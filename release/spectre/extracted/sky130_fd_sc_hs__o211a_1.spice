* Extracted by Quantus, converted by sky130cad/quantus.py
*
*
*
*                       LINUX           Wed Nov 18 08:53:40 2026
*
*
*
*  PROGRAM  advgen
*
*  Name           : advgen - Quantus - (64-bit)
*  Version        : 25.1.0-p047
*  Build Date     : Thu Dec 11 23:20:30 PST 2025
*
*  HSPICE LIBRARY
*
*  OPERATING_TEMPERATURE 150
*  QRC_TECH_DIR <path>/tech
*
*
*

*
.SUBCKT sky130_fd_sc_hs__o211a_1 VNB VPB VGND VPWR X A2 A1 B1 C1
*
*
*  caps2d version: 10
*
*
*       TRANSISTOR CARDS
*
*
XM9 X#3 a_83_264##3 VGND#5 VNB sky130_fd_pr__nfet_01v8_lvt l=0.15 w=0.74 ad=0.2109 as=0.2627 pd=2.05 ps=2.19
XM2 a_257_136##2 A1#3 VGND#1 VNB sky130_fd_pr__nfet_01v8_lvt l=0.15 w=0.64 ad=0.2112 as=0.3264 pd=1.94 ps=2.3
XM7 VGND#1 A2#2 a_257_136# VNB sky130_fd_pr__nfet_01v8_lvt l=0.15 w=0.64 ad=0.3264 as=0.4704 pd=2.3 ps=2.75
XM5 a_257_136# B1#1 a_662_136# VNB sky130_fd_pr__nfet_01v8_lvt l=0.15 w=0.64 ad=0.4704 as=0.208 pd=2.75 ps=1.93
XM3 a_662_136# C1#3 a_83_264##8 VNB sky130_fd_pr__nfet_01v8_lvt l=0.15 w=0.64 ad=0.208 as=0.2112 pd=1.93 ps=1.94
XM0 X#1 a_83_264##4 VPWR#7 VPB sky130_fd_pr__pfet_01v8 l=0.15 w=1.12 ad=0.3304 as=1.2918 pd=2.83 ps=4.76
XM4 VPWR#7 A1#1 a_398_392# VPB sky130_fd_pr__pfet_01v8 l=0.15 w=1 ad=1.2918 as=0.27 pd=4.76 ps=2.54
XM1 a_398_392# A2#3 a_83_264##9 VPB sky130_fd_pr__pfet_01v8 l=0.15 w=1 ad=0.27 as=0.3 pd=2.54 ps=2.6
XM6 a_83_264##9 B1#3 VPWR#6 VPB sky130_fd_pr__pfet_01v8 l=0.15 w=1 ad=0.3 as=0.88 pd=2.6 ps=3.76
XM8 VPWR#6 C1#1 a_83_264##5 VPB sky130_fd_pr__pfet_01v8 l=0.15 w=1 ad=0.88 as=0.295 pd=3.76 ps=2.59
*
*
*       RESISTOR AND CAP/DIODE CARDS
*
Rg1	a_83_264#	a_83_264##2	32.582375
Rg2	a_83_264##2	a_83_264##3	380.339874
Rg3	a_83_264##2	a_83_264##4	462.979767
Rg4	A1#1	A1#2	428.684692
Rg5	A1#2	A1#3	290.414215
Rg6	A2#1	A2#2	274.231628
Rg7	A2#2	A2#3	776.819763
Rg8	B1#1	B1#2	323.107452
Rg9	B1#2	B1#3	464.823853
Rg10	C1#1	C1#2	400.207520
Rg11	C1#2	C1#3	302.199066
Rf1	X	X#2	0.181173
Rf2	X#2	X	13.225628
Rf3	X	X#3	86.767128
Rf4	X#1	X#2	5.000000
Rf5	A1#2	A1	80.510071
Rf6	a_257_136#	a_257_136##2	137.192108
Rf7	B1	B1#2	162.321564
Rf8	A2	A2#1	165.329987
Rf9	C1	C1#2	171.929825
Rf10	a_83_264##5	a_83_264##6	117.722748
Rf11	a_83_264##6	a_83_264#	236.611511
Rf12	a_83_264##6	a_83_264##8	151.441040
Rf13	a_83_264##6	a_83_264##9	21.038494
Rf15	VPWR#2	VPWR#3	83.451019
Rf16	VPWR#3	VPWR#4	68.512184
Rf18	VPWR#2	VPWR#6	14.329996
Rf19	VPWR#4	VPWR#7	9.460706
Rf20	VGND#1	VGND#2	43.317902
Rf21	VGND#2	VGND#3	103.670647
Rf23	VGND#3	VGND#5	33.306259
Re1	VPWR#3	VPWR	1.091357
Re2	VGND	VGND#2	1.091398
*
*       CAPACITOR CARDS
*
*
C1	VGND	VNB	8.25954e-17
C2	VPWR	VNB	5.83609e-17
C3	X	VNB	4.87359e-17
C4	A2	VNB	3.92519e-17
C5	A1	VNB	1.18853e-19
C6	B1	VNB	9.8701e-22
C7	C1	VNB	2.10645e-17
C8	a_83_264#	VNB	1.06207e-17
C9	VGND	X	8.9408e-19
C10	A1#2	VNB	3.55887e-17
C11	A2#1	VNB	5.22403e-17
C12	B1#2	VNB	3.62187e-17
C13	VGND	A2	3.9768e-17
C14	C1#2	VNB	4.08066e-17
C15	VGND#2	VNB	2.95537e-16
C16	VPWR	X	1.76916e-17
C17	VPWR#3	VNB	2.04089e-16
C18	VGND	A1	3.22054e-18
C19	a_83_264##4	VNB	4.25069e-17
C20	A1#1	VNB	2.76552e-17
C21	VGND	B1	1.80689e-18
C22	A2#3	VNB	3.94768e-17
C23	B1#3	VNB	3.636e-17
C24	C1#1	VNB	3.55244e-17
C25	VGND	C1	3.04829e-18
C26	VPWR	A1	3.01013e-18
C27	a_83_264##3	VNB	3.6153e-17
C28	A1#3	VNB	3.48704e-17
C29	A2#2	VNB	2.81082e-17
C30	B1#1	VNB	2.5629e-17
C31	VPWR	B1	1.8944e-18
C32	C1#3	VNB	2.98135e-17
C33	X#1	VNB	1.98603e-17
C34	VPWR	C1	1.65108e-18
C35	a_83_264##9	VNB	2.20964e-18
C36	a_83_264##8	a_257_136#	1.284e-17
C37	a_83_264##5	VNB	5.22344e-17
C38	X#3	VNB	5.23682e-17
C39	VGND#5	VNB	1.54029e-17
C40	a_83_264##6	a_83_264##5	1.2246e-19
C41	a_257_136##2	VNB	1.26558e-17
C42	VGND#1	VNB	1.01428e-17
C43	VGND	a_83_264#	7.01939e-18
C44	a_83_264##8	VNB	3.85776e-17
C45	VGND	A2#1	1.18625e-17
C46	a_83_264##6	VNB	3.89014e-18
C47	VGND	C1#2	1.1531e-18
C48	VGND	VGND#2	9.4012e-17
C49	VPWR	a_83_264#	8.14575e-18
C50	VGND#5	a_83_264##2	1.25706e-17
C51	X	a_83_264#	3.77604e-17
C52	VPWR	C1#2	1.17663e-18
C53	X	A1#2	1.74837e-19
C54	VPWR	VPWR#3	1.54949e-17
C55	VGND	a_83_264##3	2.30472e-18
C56	VGND	A1#3	5.04373e-18
C57	VPWR	a_83_264##4	3.77486e-18
C58	VPWR	A1#1	6.75225e-19
C59	VGND	C1#3	1.82864e-18
C60	VPWR	A2#3	2.85078e-19
C61	A2	A2#1	1.44379e-17
C62	VPWR	B1#3	1.62303e-19
C63	a_83_264#	A1	4.75169e-17
C64	VPWR	C1#1	7.92805e-19
C65	A2	B1#2	1.36943e-18
C66	A1	A1#2	2.70917e-17
C67	X	a_83_264##4	2.09959e-17
C68	VGND#2	A2	9.49786e-17
C69	VGND	X#3	1.93554e-17
C70	X	A1#1	6.23855e-19
C71	VGND	VGND#5	2.21581e-17
C72	VGND	a_257_136##2	1.43605e-17
C73	A1	B1#2	1.65414e-18
C74	VGND	a_257_136#	1.01968e-17
C75	VGND	a_83_264##8	1.72783e-17
C76	B1	B1#2	1.57026e-17
C77	a_83_264##2	VNB	6.74598e-17
C78	VPWR	a_83_264##9	1.69237e-17
C79	B1	C1#2	2.10941e-17
C80	VGND	a_83_264##6	5.1765e-18
C81	VPWR	a_83_264##5	1.77794e-17
C82	A1	a_83_264##4	2.96466e-19
C83	X	X#1	3.16086e-18
C84	C1	C1#2	9.41928e-18
C85	A1	A2#3	3.6229e-18
C86	VGND#2	C1	8.03029e-19
C87	A2	B1#1	1.281e-17
C88	A2	C1#3	1.43244e-17
C89	X#3	X	3.9497e-18
C90	VPWR	a_83_264##6	1.00899e-17
C91	a_257_136##2	a_83_264##2	5.06795e-19
C92	A1	A2#2	3.75598e-18
C93	a_83_264#	a_83_264##2	3.38806e-17
C94	a_83_264#	A1#2	7.9969e-18
C95	A1	VPWR#7	6.79722e-18
C96	a_83_264##6	VGND#1	7.47382e-20
C97	A2	a_257_136#	5.76913e-17
C98	a_83_264#	B1#2	2.41181e-20
C99	A2	a_83_264##8	1.78734e-17
C100	A1	a_257_136##2	6.10828e-17
C101	A1	VGND#1	2.86957e-18
C102	a_83_264##6	a_257_136#	8.03844e-17
C103	B1	VPWR#6	5.21647e-18
C104	a_257_136#	A1	2.83177e-18
C105	A1#1	a_398_392#	2.43769e-17
C106	VGND#2	A1#2	9.78975e-20
C107	A2#3	a_398_392#	2.43769e-17
C108	VGND#2	A2#1	3.91852e-17
C109	B1#2	C1#2	2.21782e-17
C110	a_83_264#	a_83_264##4	4.81354e-18
C111	C1	a_83_264##5	2.6882e-17
C112	a_83_264#	A1#1	1.84952e-19
C113	VGND#2	B1#2	8.12971e-20
C114	A1	a_83_264##6	4.64512e-17
C115	a_83_264##2	A1#2	1.91021e-17
C116	a_83_264##4	A1#2	9.01925e-19
C117	a_83_264##8	B1	2.47257e-17
C118	a_83_264#	A2#3	8.79857e-20
C119	VGND#2	C1#2	7.41339e-20
C120	B1#1	a_662_136#	1.33985e-17
C121	a_83_264#	B1#3	6.53387e-20
C122	C1#3	a_662_136#	1.37034e-17
C123	A1#2	A2#3	1.21561e-17
C124	a_83_264##8	a_83_264##6	2.82359e-18
C125	a_83_264##8	C1	2.90441e-17
C126	a_83_264##6	B1	7.57471e-17
C127	a_83_264##2	A1#3	3.47465e-18
C128	VGND	a_83_264##2	1.61138e-18
C129	A2#3	B1#2	7.60641e-18
C130	a_83_264#	A1#3	1.83048e-18
C131	a_83_264#	A2#2	4.13164e-19
C132	a_83_264#	B1#1	2.55652e-19
C133	a_83_264##3	A2#1	8.52981e-19
C134	B1#3	C1#2	1.20502e-18
C135	A1#2	A2#2	1.36551e-17
C136	VPWR#3	A1#1	2.83307e-18
C137	A1#3	A2#1	3.31757e-18
C138	a_83_264#	VPWR#7	9.45903e-18
C139	VPWR#3	A2#3	5.69795e-18
C140	A2#1	A2#2	1.67836e-18
C141	A2#1	B1#1	3.21029e-18
C142	a_83_264##8	a_662_136#	6.39835e-18
C143	a_83_264##4	A1#1	2.861e-18
C144	A2#2	B1#2	1.17838e-17
C145	VGND#2	a_83_264##3	8.61024e-19
C146	A1#1	A2#3	5.45999e-17
C147	X#3	a_83_264#	2.32457e-17
C148	VGND#2	A1#3	4.98722e-19
C149	a_83_264#	VGND#5	4.40722e-17
C150	a_257_136##2	a_83_264#	4.72271e-18
C151	VGND#2	B1#1	9.52984e-19
C152	A2#3	B1#3	4.51333e-17
C153	VGND#2	C1#3	1.88532e-18
C154	a_257_136##2	A1#2	7.55586e-18
C155	a_83_264##6	a_398_392#	7.92593e-18
C156	X#3	A2#1	3.3929e-19
C157	VGND#1	A1#2	1.29487e-18
C158	VGND#5	A2#1	1.85024e-18
C159	B1#3	C1#1	4.62122e-18
C160	a_257_136#	A1#2	1.11628e-18
C161	C1#2	VPWR#6	4.7774e-19
C162	VGND#1	A2#1	3.89201e-17
C163	X	a_83_264##2	4.26194e-18
C164	C1#2	a_83_264##5	3.01757e-17
C165	A2#1	a_257_136#	1.98045e-17
C166	a_83_264##9	VPWR#3	9.00145e-18
C167	a_83_264#	a_83_264##6	3.15503e-18
C168	X#1	a_83_264##4	2.46596e-17
C169	B1#2	a_257_136#	2.50833e-18
C170	a_83_264##4	VPWR#7	3.70373e-17
C171	X#1	A1#1	1.09196e-18
C172	VGND#5	VGND#2	1.64105e-18
C173	a_83_264##6	A1#2	4.16943e-18
C174	A1#1	VPWR#7	3.00833e-17
C175	VGND#2	a_257_136##2	5.3344e-18
C176	X#1	A2#3	3.00995e-19
C177	a_83_264##9	a_83_264##4	5.56356e-19
C178	a_83_264##3	A1#3	2.98683e-18
C179	a_83_264##8	C1#2	3.30396e-17
C180	VGND#2	a_257_136#	2.90832e-19
C181	a_83_264##6	A2#1	2.67614e-19
C182	a_83_264##9	A1#1	7.04287e-18
C183	VGND#2	a_83_264##8	9.41349e-18
C184	a_83_264##9	A2#3	4.61065e-17
C185	A1#3	A2#2	1.30851e-17
C186	a_83_264##6	B1#2	2.67454e-17
C187	a_83_264##9	B1#3	5.04204e-17
C188	B1#3	VPWR#6	2.35941e-17
C189	a_83_264##6	C1#2	1.12878e-18
C190	A2#2	B1#1	5.69323e-18
C191	a_83_264##9	C1#1	7.76583e-19
C192	a_83_264##5	B1#3	7.15229e-19
C193	C1#1	VPWR#6	1.78896e-17
C194	A1	a_83_264##2	4.50478e-18
C195	a_83_264##5	C1#1	5.72526e-17
C196	B1#1	C1#3	2.38813e-17
C197	a_83_264##6	VPWR#3	1.66024e-18
C198	X#3	a_83_264##3	3.81505e-17
C199	a_83_264##3	VGND#5	3.66163e-17
C200	a_83_264##6	a_83_264##4	4.65664e-19
C201	X#3	A1#3	8.872e-19
C202	a_257_136##2	a_83_264##3	1.68478e-18
C203	VGND#5	A1#3	2.3204e-18
C204	X#3	A2#2	5.90577e-20
C205	VGND#1	a_83_264##3	1.48661e-18
C206	a_83_264##6	A1#1	1.87378e-17
C207	a_257_136##2	A1#3	3.13718e-17
C208	VGND#5	A2#2	5.09414e-20
C209	a_257_136#	a_83_264##3	1.53307e-19
C210	A1#3	VGND#1	3.40276e-17
C211	a_83_264##6	A2#3	2.47197e-17
C212	a_257_136##2	A2#2	1.05789e-18
C213	a_257_136#	A1#3	1.30141e-18
C214	A2#2	VGND#1	2.05352e-17
C215	a_83_264##6	B1#3	2.45432e-17
C216	a_257_136#	A2#2	5.25091e-17
C217	VGND#1	B1#1	1.20515e-18
C218	a_83_264##6	C1#1	9.31972e-19
C219	a_257_136#	B1#1	2.88446e-17
C220	VGND#1	C1#3	6.28414e-19
C221	a_83_264##8	A2#2	9.6876e-19
C222	a_83_264##9	a_83_264##5	1.33266e-18
C223	a_257_136#	C1#3	2.38098e-18
C224	a_83_264##8	B1#1	2.49e-17
C225	a_83_264##5	VPWR#6	3.64234e-18
C226	a_83_264##8	C1#3	3.7336e-17
C227	a_83_264##6	A1#3	7.03451e-19
C228	a_83_264##6	A2#2	5.79951e-18
C229	X#3	VGND#5	6.83464e-17
C230	a_83_264##6	B1#1	1.0889e-19
C231	X#3	a_257_136##2	3.88551e-18
C232	a_83_264##6	a_83_264##2	5.61049e-19
C233	a_83_264##6	C1#3	4.34241e-20
C234	X#3	VGND#1	1.46232e-20
C235	VGND#5	a_257_136##2	2.89567e-17
C236	VGND#5	VGND#1	6.71131e-18
C237	a_83_264##8	a_83_264##5	5.21692e-18
C238	a_257_136##2	VGND#1	4.59035e-17
C239	a_83_264##6	VPWR#7	1.92385e-18
C240	a_257_136##2	a_257_136#	3.24846e-18
C241	a_257_136#	VGND#1	3.9248e-17
C242	X#3	a_83_264##2	5.11521e-18
C243	a_83_264##6	a_83_264##9	2.04842e-19
C244	a_83_264##6	VPWR#6	5.11518e-18
C245	VGND#1	a_83_264##8	1.42027e-20
C246	VGND#3	a_83_264##2	2.673e-19
C247	VPWR#4	a_83_264##2	4.14993e-18
C248	VPWR#2	A2#3	1.28001e-18
C249	VGND#2	VGND#3	5.90637e-17
C250	a_83_264##6	VPWR#4	2.37103e-17
C251	a_83_264#	VPWR#4	6.86891e-17
C252	VPWR#2	VPWR#6	2.81334e-17
C253	VPWR#2	VNB	7.02357e-17
C254	VPWR#2	C1#1	2.48885e-17
C255	VPWR#4	VNB	7.76233e-17
C256	VPWR#4	A1#1	3.86633e-17
C257	VGND#3	VNB	5.44534e-17
C258	VPWR#2	B1#2	3.07214e-18
C259	VPWR#4	B1#3	5.01941e-19
C260	VPWR#4	VPWR#2	1.37967e-18
C261	X	VPWR#4	5.38728e-17
C262	VPWR#4	VPWR#7	3.36064e-17
C263	VPWR#3	VPWR#4	8.46442e-17
C264	VGND#3	X#3	2.23318e-17
C265	VGND	VGND#3	3.91183e-17
C266	VPWR#2	A1#1	5.73813e-19
C267	a_83_264##9	VPWR#2	7.13392e-17
C268	VGND#3	A1#2	4.6735e-20
C269	VPWR#4	a_83_264##9	2.52496e-17
C270	VPWR#2	B1#3	2.18222e-17
C271	VPWR#4	a_83_264##4	2.62204e-17
C272	a_83_264##5	VPWR#2	1.09791e-16
C273	VGND#3	a_83_264##3	4.70245e-18
C274	a_83_264##6	VPWR#2	4.52734e-17
C275	VPWR#4	A1#2	2.65113e-18
C276	VPWR	VPWR#2	9.83457e-17
C277	VGND#3	a_257_136##2	2.19492e-18
C278	VPWR#4	A2#3	4.81485e-18
C279	VPWR#2	C1#2	5.19202e-19
C280	VPWR	VPWR#4	1.2795e-16
C281	X#1	VPWR#4	3.34537e-17
C282	VPWR#4	C1#1	3.36606e-19
C283	VPWR#3	VPWR#2	7.5238e-17
C284	VGND#3	a_83_264#	1.29111e-18
*
*
.ENDS sky130_fd_sc_hs__o211a_1
*
