* Extracted by Quantus, converted by sky130cad/quantus.py
*
*
*
*                       LINUX           Wed Nov 18 08:17:40 2026
*
*
*
*  PROGRAM  advgen
*
*  Name           : advgen - Quantus - (64-bit)
*  Version        : 25.1.0-p047
*  Build Date     : Thu Dec 11 23:20:30 PST 2025
*
*  HSPICE LIBRARY
*
*  OPERATING_TEMPERATURE 150
*  QRC_TECH_DIR <path>/tech
*
*
*

*
.SUBCKT sky130_fd_sc_hs__and3b_1 VPB VNB VGND VPWR X A_N B C
*
*
*  caps2d version: 10
*
*
*       TRANSISTOR CARDS
*
*
XM9 VGND#4 A_N#3 a_114_74##7 VNB sky130_fd_pr__nfet_01v8_lvt l=0.15 w=0.55 ad=0.15675 as=0.19525 pd=1.67 ps=1.81
XM4 a_266_94##6 a_114_74##4 a_353_94# VNB sky130_fd_pr__nfet_01v8_lvt l=0.15 w=0.64 ad=0.1824 as=0.1536 pd=1.85 ps=1.76
XM3 a_353_94# B#3 a_431_94# VNB sky130_fd_pr__nfet_01v8_lvt l=0.15 w=0.64 ad=0.1536 as=0.2496 pd=1.76 ps=2.06
XM0 a_431_94# C#3 VGND#5 VNB sky130_fd_pr__nfet_01v8_lvt l=0.15 w=0.64 ad=0.2496 as=0.3971 pd=2.06 ps=2.61
XM6 VGND#5 a_266_94# X#1 VNB sky130_fd_pr__nfet_01v8_lvt l=0.15 w=0.74 ad=0.3971 as=0.2109 pd=2.61 ps=2.05
XM5 VPWR#4 A_N#1 a_114_74##5 VPB sky130_fd_pr__pfet_01v8 l=0.15 w=0.84 ad=0.252 as=0.2856 pd=2.28 ps=2.36
XM7 a_266_94##8 a_114_74# VPWR#6 VPB sky130_fd_pr__pfet_01v8 l=0.15 w=0.84 ad=0.2478 as=0.3318 pd=2.27 ps=2.47
XM8 VPWR#6 B#1 a_266_94##9 VPB sky130_fd_pr__pfet_01v8 l=0.15 w=0.84 ad=0.3318 as=0.2562 pd=2.47 ps=2.29
XM1 a_266_94##9 C#1 VPWR#5 VPB sky130_fd_pr__pfet_01v8 l=0.15 w=0.84 ad=0.2562 as=0.462 pd=2.29 ps=3.11
XM2 VPWR#5 a_266_94##3 X#2 VPB sky130_fd_pr__pfet_01v8 l=0.15 w=1.12 ad=0.462 as=0.3304 pd=3.11 ps=2.83
*
*
*       RESISTOR AND CAP/DIODE CARDS
*
Rg1	A_N#1	A_N#2	520.122009
Rg2	A_N#2	A_N#3	357.635284
Rg3	a_114_74#	a_114_74##2	499.548096
Rg4	a_114_74##2	a_114_74##3	372.025024
Rg5	a_114_74##2	a_114_74##4	251.111053
Rg6	B#1	B#2	354.298584
Rg7	B#2	B#3	353.846649
Rg8	C#1	C#2	354.298584
Rg9	C#2	C#3	353.846649
Rg10	a_266_94#	a_266_94##2	353.846649
Rg11	a_266_94##2	a_266_94##3	456.846832
Rf1	A_N	A_N#4	1.640446
Rf2	A_N#5	A_N#2	81.756851
Rf3	A_N#4	A_N#5	4.435209
Rf4	A_N	A_N#7	1.640446
Rf5	A_N#5	A_N#7	6.504973
Rf6	a_114_74##5	a_114_74##3	72.472260
Rf7	a_114_74##3	a_114_74##7	51.618347
Rf8	B	B#2	166.137894
Rf9	C#4	C#2	161.407532
Rf10	C	C#6	1.174731
Rf11	C#4	C#6	5.583287
Rf12	a_266_94##2	a_266_94##5	286.264099
Rf13	a_266_94##5	a_266_94##6	21.065739
Rf14	a_266_94##5	a_266_94##7	35.398605
Rf15	a_266_94##7	a_266_94##8	16.341667
Rf16	a_266_94##7	a_266_94##9	77.444305
Rf17	X#1	X	86.597252
Rf18	X	X#3	11.676959
Rf19	X#3	X	0.159958
Rf20	X#2	X#3	5.000000
Rf22	VGND#2	VGND#3	73.018906
Rf23	VGND#3	VGND#4	154.769409
Rf24	VGND#2	VGND#5	16.738564
Rf26	VPWR#2	VPWR#3	81.207619
Rf27	VPWR#3	VPWR#4	153.781219
Rf28	VPWR#2	VPWR#5	43.738586
Rf29	VPWR#3	VPWR#6	49.618740
Re1	VPWR#3	VPWR	1.227783
Re2	VGND	VGND#3	1.227829
*
*       CAPACITOR CARDS
*
*
C1	VGND	VNB	6.70409e-17
C2	VPWR	VNB	7.4823e-17
C3	A_N	VNB	1.24456e-17
C4	B	VNB	1.71662e-18
C5	C	VNB	1.19799e-18
C6	VGND	B	2.36044e-18
C7	VPWR	A_N	5.04508e-18
C8	A_N#2	VNB	6.87728e-17
C9	VPWR	B	1.92768e-18
C10	a_114_74##3	VNB	7.08663e-17
C11	B#2	VNB	2.85244e-17
C12	VPWR	C	2.82488e-18
C13	C#2	VNB	2.9731e-17
C14	a_266_94##2	VNB	4.64189e-17
C15	VGND#3	VNB	2.14562e-16
C16	VPWR#3	VNB	2.25367e-16
C17	a_266_94##7	a_266_94##8	5.20976e-18
C18	A_N#1	VNB	5.58988e-17
C19	VGND	a_114_74##3	7.98422e-18
C20	a_114_74#	VNB	5.21297e-17
C21	B#1	VNB	3.14943e-17
C22	C#1	VNB	3.25997e-17
C23	a_266_94##3	VNB	4.45755e-17
C24	VGND	a_266_94##2	9.34287e-18
C25	A_N#3	VNB	4.38177e-17
C26	B	C	1.42529e-17
C27	VGND	VGND#3	3.30817e-17
C28	a_114_74##4	VNB	2.99409e-17
C29	B#3	VNB	2.49674e-17
C30	VPWR	a_114_74##3	6.78764e-18
C31	C#3	VNB	2.74563e-17
C32	a_266_94#	VNB	3.23258e-17
C33	VPWR#4	VNB	8.38266e-17
C34	a_114_74##5	VNB	2.0952e-17
C35	VPWR#6	VNB	8.54378e-18
C36	VPWR	a_266_94##2	3.65664e-18
C37	a_266_94##9	VNB	3.14682e-18
C38	VPWR#5	VNB	3.96692e-18
C39	X#2	VNB	7.26169e-17
C40	VGND#4	VNB	7.18751e-17
C41	VPWR	VPWR#3	6.17233e-17
C42	a_114_74##7	VNB	1.41964e-17
C43	VGND	A_N#3	1.70879e-18
C44	A_N	A_N#2	1.55099e-17
C45	VGND	a_114_74##4	1.01039e-17
C46	VPWR	A_N#1	2.0311e-18
C47	A_N	a_114_74##3	2.40701e-17
C48	VGND	B#3	9.39056e-18
C49	X#1	VNB	5.27363e-17
C50	VPWR	a_114_74#	6.73808e-18
C51	VGND	C#3	2.17514e-18
C52	A_N#4	VNB	1.15252e-17
C53	A_N#5	VNB	6.16334e-18
C54	VGND	a_266_94#	1.82606e-18
C55	VPWR	B#1	6.43355e-18
C56	VPWR	C#1	6.78547e-18
C57	a_266_94##7	VPWR#6	6.0074e-17
C58	VPWR	a_266_94##3	2.9991e-18
C59	C#4	VNB	5.72002e-19
C60	B	B#2	1.47178e-17
C61	a_266_94##5	VNB	1.62278e-17
C62	a_266_94##7	VNB	1.37891e-17
C63	VGND	X#2	1.75665e-18
C64	B	C#2	3.6837e-18
C65	VGND	VGND#4	4.83464e-17
C66	a_266_94##5	a_266_94##9	1.61834e-18
C67	VGND	a_114_74##7	2.08652e-17
C68	C	B#2	1.02822e-18
C69	VPWR	VPWR#4	4.97788e-17
C70	C	C#2	6.12129e-18
C71	VPWR	a_114_74##5	1.69243e-17
C72	VGND	X#1	1.9682e-17
C73	A_N	a_114_74#	1.34317e-19
C74	VGND	A_N#4	5.06882e-18
C75	C	a_266_94##2	6.27945e-18
C76	VPWR	a_266_94##9	1.3817e-17
C77	VPWR	X#2	2.13143e-17
C78	VGND	C#4	3.19072e-18
C79	a_266_94##7	a_266_94##9	2.63689e-18
C80	B	a_114_74#	2.19524e-18
C81	B	B#1	2.00981e-18
C82	VGND	a_266_94##5	2.28691e-17
C83	B	C#1	4.45001e-19
C84	C	B#1	7.55662e-19
C85	A_N	VPWR#4	2.54004e-17
C86	C	C#1	3.78639e-18
C87	C	a_266_94##3	1.63907e-18
C88	A_N#2	a_114_74##3	4.72309e-17
C89	a_114_74##2	a_266_94##6	1.42995e-18
C90	a_266_94##2	a_431_94#	1.82615e-18
C91	a_114_74##3	a_114_74##2	4.51472e-18
C92	VPWR	a_266_94##7	1.47098e-17
C93	B	a_266_94##9	3.39481e-17
C94	B#2	C#2	3.50387e-17
C95	VGND#3	a_114_74##3	3.36403e-18
C96	a_266_94##2	B#2	3.71199e-19
C97	a_114_74##2	VNB	2.34924e-17
C98	C	a_266_94##9	2.57527e-17
C99	a_114_74##3	VPWR#3	1.85165e-18
C100	C	VPWR#5	1.38097e-17
C101	VGND#3	B#2	1.23106e-19
C102	C#2	a_266_94##2	3.72875e-17
C103	C	X#2	4.08024e-18
C104	a_114_74##4	a_353_94#	1.46959e-17
C105	A_N#2	a_114_74#	1.09957e-18
C106	B#3	a_353_94#	1.46959e-17
C107	a_114_74##3	A_N#1	3.51135e-19
C108	a_114_74##3	a_114_74#	4.9683e-18
C109	a_114_74##7	a_266_94##5	3.02055e-17
C110	B#3	a_431_94#	1.89333e-17
C111	a_114_74##2	B#2	2.41847e-17
C112	a_114_74#	B#2	1.11833e-17
C113	B	C#4	1.56173e-17
C114	C#3	a_431_94#	1.89333e-17
C115	a_266_94##5	B	4.53633e-17
C116	a_266_94##7	B	9.64718e-18
C117	a_266_94##5	a_266_94##6	7.15055e-18
C118	A_N#3	a_114_74##3	9.36779e-18
C119	a_266_94##5	a_114_74##2	2.54939e-17
C120	a_114_74##3	a_114_74##4	4.57697e-18
C121	a_114_74##2	B#3	3.85293e-18
C122	VPWR#3	A_N#1	1.25856e-18
C123	C#2	a_266_94##3	6.77018e-19
C124	VPWR#3	a_114_74#	1.67326e-18
C125	VPWR#4	A_N#2	5.30043e-18
C126	VPWR#3	B#1	1.60641e-18
C127	VPWR#4	a_114_74##3	5.89144e-20
C128	A_N#1	a_114_74#	4.2603e-18
C129	VPWR#3	a_266_94##3	1.45294e-18
C130	VGND#3	a_114_74##4	4.67478e-18
C131	a_114_74#	B#1	2.47888e-17
C132	a_266_94##2	C#3	2.01235e-17
C133	VGND#4	A_N#2	6.28159e-18
C134	VGND#3	B#3	7.05215e-18
C135	B#2	VPWR#6	1.51637e-18
C136	a_266_94##2	a_266_94#	2.98395e-18
C137	a_266_94##7	a_114_74##2	8.24457e-20
C138	VGND#3	C#3	9.782e-20
C139	a_266_94##9	B#2	3.95271e-18
C140	B#1	C#1	3.46751e-17
C141	VGND#4	a_114_74##3	2.76304e-19
C142	a_114_74##3	a_114_74##7	4.75708e-19
C143	a_266_94##5	a_353_94#	2.78945e-18
C144	C#2	a_266_94##9	1.42067e-18
C145	a_114_74##3	a_266_94##6	2.7499e-19
C146	C#2	VPWR#5	2.0847e-18
C147	C#1	a_266_94##3	2.37244e-17
C148	A_N#4	A_N#2	1.63905e-17
C149	a_266_94##2	a_114_74##2	1.90164e-19
C150	VPWR#3	VPWR#4	4.42479e-17
C151	X#2	C#2	1.37532e-19
C152	a_266_94##2	a_266_94##9	4.07171e-18
C153	A_N#5	A_N#2	9.15845e-18
C154	a_114_74##5	VPWR#3	3.05956e-18
C155	a_266_94##5	a_431_94#	2.74426e-18
C156	a_266_94##2	VPWR#5	1.46534e-17
C157	a_266_94##2	X#2	3.59706e-17
C158	A_N#4	a_114_74##3	2.92856e-17
C159	A_N#5	a_114_74##3	1.54754e-17
C160	VPWR#4	A_N#1	4.67129e-17
C161	a_266_94##9	VPWR#3	3.88509e-18
C162	a_114_74##5	A_N#1	2.7786e-17
C163	VPWR#4	a_114_74#	7.76902e-19
C164	VGND#3	VGND#4	4.1734e-17
C165	VPWR#3	VPWR#5	1.02725e-18
C166	VGND#3	a_114_74##7	4.29658e-18
C167	a_114_74##5	a_114_74#	4.73841e-18
C168	X#1	C#2	1.94995e-21
C169	VPWR#6	A_N#1	1.13912e-18
C170	a_114_74#	a_266_94##8	2.58104e-17
C171	VGND#3	a_114_74##2	2.24268e-19
C172	a_266_94##2	VGND#5	5.63541e-20
C173	A_N#3	a_114_74##4	3.65799e-18
C174	a_266_94##7	A_N#2	3.44477e-19
C175	a_114_74##5	B#1	2.97842e-19
C176	a_114_74#	VPWR#6	2.9571e-17
C177	a_266_94##2	X#1	4.45871e-17
C178	C#4	B#2	2.59661e-18
C179	a_266_94##9	a_114_74#	7.60241e-19
C180	a_266_94##5	a_114_74##3	7.30375e-17
C181	B#1	VPWR#6	2.59642e-17
C182	a_114_74##4	B#3	4.40806e-17
C183	a_114_74##3	a_266_94##7	2.8496e-17
C184	VPWR#5	a_114_74#	3.5943e-19
C185	a_266_94##9	B#1	5.08634e-17
C186	X#2	a_114_74#	2.21841e-19
C187	VPWR#6	C#1	1.39992e-18
C188	C#4	C#2	8.71136e-18
C189	a_266_94##5	B#2	4.7712e-18
C190	VPWR#5	B#1	7.48597e-19
C191	a_266_94##9	C#1	4.77008e-17
C192	a_266_94##7	B#2	1.01645e-18
C193	B#3	C#3	2.55973e-17
C194	X#2	B#1	2.40723e-19
C195	VPWR#6	a_266_94##3	1.34251e-18
C196	C#1	VPWR#5	3.06885e-17
C197	VPWR#3	a_114_74##2	9.40636e-20
C198	a_266_94##2	C#4	5.91879e-17
C199	a_266_94##9	a_266_94##3	1.13898e-18
C200	a_266_94##5	C#2	9.40904e-20
C201	X#2	C#1	9.62125e-19
C202	a_266_94##3	VPWR#5	3.07982e-17
C203	C#3	a_266_94#	1.31799e-17
C204	X#2	a_266_94##3	5.12746e-17
C205	a_266_94##5	a_266_94##2	1.18539e-18
C206	B	a_114_74##2	2.80557e-18
C207	VGND#3	a_266_94##5	1.70753e-17
C208	VGND#4	A_N#3	3.5313e-17
C209	VPWR#4	a_114_74##5	9.81102e-17
C210	A_N#3	a_114_74##7	2.55475e-17
C211	a_266_94##7	VPWR#3	7.32241e-18
C212	VGND#4	a_114_74##4	1.13161e-18
C213	a_114_74##7	a_114_74##4	4.1606e-18
C214	VGND#4	B#3	1.70577e-19
C215	a_114_74##4	a_266_94##6	8.3893e-18
C216	a_114_74##5	VPWR#6	5.13885e-18
C217	a_114_74##7	B#3	2.88805e-19
C218	VGND#4	C#3	2.25928e-19
C219	a_114_74##7	C#3	2.18193e-19
C220	a_266_94##7	A_N#1	6.47773e-18
C221	a_266_94##5	a_266_94##7	6.77925e-18
C222	VGND#4	VPWR#4	2.37427e-19
C223	a_266_94##9	VPWR#6	5.30397e-17
C224	a_266_94##7	a_114_74#	5.36513e-17
C225	X#1	a_114_74##4	3.33398e-19
C226	VPWR#6	VPWR#5	5.84322e-18
C227	X#1	B#3	3.33777e-19
C228	a_266_94##7	B#1	1.34051e-18
C229	a_114_74##7	a_114_74##5	1.70117e-18
C230	C#3	VGND#5	1.83036e-17
C231	a_266_94##9	VPWR#5	5.65579e-17
C232	X#1	C#3	2.37763e-18
C233	a_266_94#	VGND#5	6.34954e-18
C234	a_266_94##7	C#1	2.38896e-19
C235	X#1	a_266_94#	3.41348e-17
C236	VPWR#5	X#2	8.95602e-17
C237	a_266_94##7	a_266_94##3	1.94059e-19
C238	a_266_94##5	A_N#3	2.3029e-18
C239	VGND#4	a_114_74##7	6.92434e-17
C240	a_266_94##5	a_114_74##4	2.64091e-17
C241	a_266_94##5	B#3	2.64659e-17
C242	a_266_94##5	C#3	1.92588e-18
C243	X#1	X#2	4.03994e-18
C244	a_266_94##5	a_266_94#	3.82256e-19
C245	A_N#4	VGND#4	4.10815e-17
C246	a_114_74##5	a_266_94##7	4.08911e-17
C247	VGND#2	A_N#3	1.2867e-18
C248	VGND#2	a_266_94##5	1.18531e-17
C249	VPWR	VPWR#2	6.07226e-17
C250	VGND#2	a_114_74##4	2.15572e-18
C251	VGND#2	B#3	5.13797e-18
C252	X#2	VPWR#2	2.72045e-17
C253	VPWR#3	VPWR#2	6.07617e-17
C254	VGND#2	B#2	1.15719e-19
C255	VGND#2	VGND#5	8.80276e-18
C256	VPWR#2	C#1	4.67141e-18
C257	VGND#2	C#3	3.34012e-17
C258	VGND#2	VNB	6.3538e-17
C259	VGND#2	C#2	1.14702e-18
C260	VGND#2	X#1	7.88155e-17
C261	VGND#2	a_266_94#	2.53713e-17
C262	VGND	VGND#2	8.24675e-17
C263	VPWR#2	a_266_94##3	1.23319e-17
C264	VGND#2	a_266_94##2	5.93639e-17
C265	VPWR#2	VNB	5.53749e-17
C266	VPWR#2	C#2	3.24476e-20
C267	VGND#3	VGND#2	6.51617e-17
C268	a_114_74##7	VGND#2	2.00764e-18
C269	C	VPWR#2	4.35605e-19
C270	a_266_94##9	VPWR#2	2.91782e-18
C271	a_266_94##2	VPWR#2	3.21014e-19
*
*
.ENDS sky130_fd_sc_hs__and3b_1
*
