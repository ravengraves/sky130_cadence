* Extracted by Quantus, converted by sky130cad/quantus.py
*
*
*
*                       LINUX           Wed Nov 18 09:11:26 2026
*
*
*
*  PROGRAM  advgen
*
*  Name           : advgen - Quantus - (64-bit)
*  Version        : 25.1.0-p047
*  Build Date     : Thu Dec 11 23:20:30 PST 2025
*
*  HSPICE LIBRARY
*
*  OPERATING_TEMPERATURE 150
*  QRC_TECH_DIR <path>/tech
*
*
*

*
.SUBCKT sky130_fd_sc_hs__sdfxtp_1 VNB VPB VGND VPWR Q SCE CLK D SCD
*
*
*  caps2d version: 10
*
*
*       TRANSISTOR CARDS
*
*
XM3 a_35_74##8 SCE#4 VGND#15 VNB sky130_fd_pr__nfet_01v8_lvt l=0.15 w=0.42 ad=0.1197 as=0.1491 pd=1.41 ps=1.55
XM27 VGND#15 a_35_74# a_223_74# VNB sky130_fd_pr__nfet_01v8_lvt l=0.15 w=0.42 ad=0.1491 as=0.1008 pd=1.55 ps=1.32
XM25 a_223_74# D#3 a_301_74##6 VNB sky130_fd_pr__nfet_01v8_lvt l=0.15 w=0.42 ad=0.1008 as=0.2499 pd=1.32 ps=2.03
XM6 a_301_74##6 SCE#6 a_450_74# VNB sky130_fd_pr__nfet_01v8_lvt l=0.15 w=0.42 ad=0.2499 as=0.1008 pd=2.03 ps=1.32
XM15 a_450_74# SCD#1 VGND#14 VNB sky130_fd_pr__nfet_01v8_lvt l=0.15 w=0.42 ad=0.1008 as=0.2424 pd=1.32 ps=2.2
XM19 VGND#14 CLK#3 a_630_74##14 VNB sky130_fd_pr__nfet_01v8_lvt l=0.15 w=0.74 ad=0.2424 as=0.2109 pd=2.2 ps=2.05
XM28 VGND#13 a_630_74##8 a_828_74##13 VNB sky130_fd_pr__nfet_01v8_lvt l=0.15 w=0.74 ad=0.2109 as=0.1961 pd=2.05 ps=2.01
XM9 a_301_74##5 a_630_74##6 a_1018_100##6 VNB sky130_fd_pr__nfet_01v8_lvt l=0.15 w=0.42 ad=0.1113 as=0.2226 pd=1.37 ps=1.9
XM20 a_1018_100##6 a_828_74##4 a_1154_100# VNB sky130_fd_pr__nfet_01v8_lvt l=0.15 w=0.42 ad=0.2226 as=0.1785 pd=1.9 ps=1.69
XM30 a_1154_100# a_1239_74##2 VGND#12 VNB sky130_fd_pr__nfet_01v8_lvt l=0.15 w=0.42 ad=0.1785 as=0.40275 pd=1.69 ps=2.76
XM29 VGND#12 a_1018_100# a_1239_74##4 VNB sky130_fd_pr__nfet_01v8_lvt l=0.15 w=0.55 ad=0.40275 as=0.15675 pd=2.76 ps=1.67
XM21 a_1239_74##4 a_828_74##5 a_1520_74##7 VNB sky130_fd_pr__nfet_01v8_lvt l=0.15 w=0.55 ad=0.15675 as=0.3223 pd=1.67 ps=2.48
XM7 a_1520_74##7 a_630_74##9 a_1688_100# VNB sky130_fd_pr__nfet_01v8_lvt l=0.15 w=0.42 ad=0.3223 as=0.1008 pd=2.48 ps=1.32
XM31 a_1688_100# a_1736_74##3 VGND#11 VNB sky130_fd_pr__nfet_01v8_lvt l=0.15 w=0.42 ad=0.1008 as=0.3244 pd=1.32 ps=2.49
XM13 VGND#11 a_1520_74# a_1736_74##12 VNB sky130_fd_pr__nfet_01v8_lvt l=0.15 w=0.55 ad=0.3244 as=0.14575 pd=2.49 ps=1.63
XM8 VGND#4 a_1736_74##5 Q#3 VNB sky130_fd_pr__nfet_01v8_lvt l=0.15 w=0.74 ad=0.1998 as=0.2035 pd=2.02 ps=2.03
XM5 a_35_74##9 SCE#5 VPWR#14 VPB sky130_fd_pr__pfet_01v8 l=0.15 w=0.64 ad=0.1888 as=0.224 pd=1.87 ps=1.98
XM11 VPWR#14 SCE#1 a_238_464# VPB sky130_fd_pr__pfet_01v8 l=0.15 w=0.64 ad=0.224 as=0.1728 pd=1.98 ps=1.82
XM16 a_238_464# D#1 a_301_74##4 VPB sky130_fd_pr__pfet_01v8 l=0.15 w=0.64 ad=0.1728 as=0.192 pd=1.82 ps=1.88
XM1 a_301_74##4 a_35_74##3 a_412_464# VPB sky130_fd_pr__pfet_01v8 l=0.15 w=0.64 ad=0.192 as=0.2496 pd=1.88 ps=2.06
XM10 a_412_464# SCD#3 VPWR#12 VPB sky130_fd_pr__pfet_01v8 l=0.15 w=0.64 ad=0.2496 as=0.4856 pd=2.06 ps=3.36
XM18 VPWR#12 CLK#1 a_630_74##12 VPB sky130_fd_pr__pfet_01v8 l=0.15 w=1.12 ad=0.4856 as=0.3304 pd=3.36 ps=2.83
XM2 VPWR#9 a_630_74##7 a_828_74##16 VPB sky130_fd_pr__pfet_01v8 l=0.15 w=1.12 ad=0.532 as=0.3304 pd=3.19 ps=2.83
XM22 a_301_74# a_828_74# a_1018_100##7 VPB sky130_fd_pr__pfet_01v8 l=0.15 w=0.42 ad=0.1239 as=0.147 pd=1.43 ps=1.54
XM0 a_1018_100##7 a_630_74# a_1202_508# VPB sky130_fd_pr__pfet_01v8 l=0.15 w=0.42 ad=0.147 as=0.105 pd=1.54 ps=1.34
XM24 a_1202_508# a_1239_74##3 VPWR#7 VPB sky130_fd_pr__pfet_01v8 l=0.15 w=0.42 ad=0.105 as=0.3696 pd=1.34 ps=3.04
XM12 VPWR#7 a_1018_100##3 a_1239_74##7 VPB sky130_fd_pr__pfet_01v8 l=0.15 w=0.84 ad=0.3696 as=0.4662 pd=3.04 ps=2.79
XM17 a_1239_74##7 a_630_74##11 a_1520_74##6 VPB sky130_fd_pr__pfet_01v8 l=0.15 w=0.84 ad=0.4662 as=0.3927 pd=2.79 ps=2.79
XM14 a_1520_74##6 a_828_74##8 a_1688_508# VPB sky130_fd_pr__pfet_01v8 l=0.15 w=0.42 ad=0.3927 as=0.1134 pd=2.79 ps=1.38
XM4 a_1688_508# a_1736_74# VPWR#5 VPB sky130_fd_pr__pfet_01v8 l=0.15 w=0.42 ad=0.1134 as=0.3612 pd=1.38 ps=2.87
XM23 VPWR#5 a_1520_74##3 a_1736_74##9 VPB sky130_fd_pr__pfet_01v8 l=0.15 w=0.84 ad=0.3612 as=0.2478 pd=2.87 ps=2.27
XM26 VPWR#4 a_1736_74##8 Q#1 VPB sky130_fd_pr__pfet_01v8 l=0.15 w=1.12 ad=0.3304 as=0.3248 pd=2.83 ps=2.82
*
*
*       RESISTOR AND CAP/DIODE CARDS
*
Rg1	a_35_74#	a_35_74##2	847.608582
Rg2	SCE#1	SCE#2	484.685455
Rg3	SCE#2	SCE#3	842.316772
Rg4	SCE#3	SCE#4	242.169754
Rg5	SCE#2	SCE#5	234.008942
Rg6	D#1	D#2	473.017548
Rg7	D#2	D#3	585.753723
Rg8	a_35_74##3	a_35_74##4	339.263733
Rg9	SCE#6	SCE#7	216.119781
Rg10	SCD#1	SCD#2	576.689392
Rg11	SCD#2	SCD#3	339.263733
Rg12	CLK#1	CLK#2	473.627625
Rg13	CLK#2	CLK#3	350.123901
Rg14	CLK#2	CLK#4	34.575123
Rg15	a_828_74#	a_828_74##2	460.703613
Rg16	a_828_74##3	a_828_74##4	212.440369
Rg17	a_630_74#	a_630_74##2	321.137604
Rg18	a_630_74##2	a_630_74##3	544.425049
Rg19	a_630_74##3	a_630_74##4	280.929016
Rg20	a_630_74##4	a_630_74##5	171.848099
Rg21	a_630_74##3	a_630_74##6	466.780426
Rg22	a_630_74##4	a_630_74##7	427.807281
Rg23	a_630_74##5	a_630_74##8	346.792999
Rg24	a_1239_74#	a_1239_74##2	216.119781
Rg25	a_1239_74#	a_1239_74##3	813.434021
Rg26	a_1018_100#	a_1018_100##2	625.600464
Rg27	a_1018_100##2	a_1018_100##3	357.390686
Rg28	a_828_74##5	a_828_74##6	413.653595
Rg29	a_630_74##9	a_630_74##10	686.110962
Rg30	a_630_74##10	a_630_74##11	362.110718
Rg31	a_828_74##7	a_828_74##8	427.335480
Rg32	a_1736_74#	a_1736_74##2	802.725037
Rg33	a_1736_74##2	a_1736_74##3	273.287537
Rg34	a_1736_74##2	a_1736_74##4	36.987911
Rg35	a_1520_74#	a_1520_74##2	573.181152
Rg36	a_1520_74##2	a_1520_74##3	360.282135
Rg37	a_1736_74##5	a_1736_74##6	368.862610
Rg38	a_1736_74##6	a_1736_74##7	72.924507
Rg39	a_1736_74##6	a_1736_74##8	462.979767
Rf1	D#2	D	171.649307
Rf2	a_35_74##4	a_35_74##6	177.293732
Rf3	a_35_74##6	a_35_74##2	6.509647
Rf4	a_35_74##2	a_35_74##8	88.855370
Rf5	a_35_74##6	a_35_74##9	25.406616
Rf6	SCE#3	SCE	183.495468
Rf7	SCE	SCE#7	189.832184
Rf8	SCD#4	SCD	0.695947
Rf9	SCD#2	SCD#6	80.812347
Rf10	SCD#4	SCD#6	5.433131
Rf11	CLK#5	CLK#4	161.592804
Rf12	CLK	CLK#7	1.360000
Rf13	CLK#5	CLK#7	6.530186
Rf14	a_630_74##12	a_630_74##13	61.362694
Rf15	a_630_74##13	a_630_74##14	92.496208
Rf16	a_301_74#	a_301_74##2	81.939468
Rf17	a_301_74##2	a_301_74##3	76.787468
Rf18	a_301_74##3	a_301_74##4	101.115776
Rf19	a_301_74##2	a_301_74##5	146.344620
Rf20	a_301_74##3	a_301_74##6	190.445084
Rf21	a_1018_100##2	a_1018_100##5	245.614960
Rf22	a_1018_100##5	a_1018_100##6	77.190964
Rf23	a_1018_100##5	a_1018_100##7	84.893318
Rf24	a_1239_74##4	a_1239_74##5	48.653843
Rf25	a_1239_74##5	a_1239_74#	191.156799
Rf26	a_1239_74##5	a_1239_74##7	87.064873
Rf27	a_630_74##10	a_630_74##2	520.034180
Rf28	a_828_74##7	a_828_74##6	144.173828
Rf29	a_828_74##6	a_828_74##11	204.511124
Rf30	a_828_74##11	a_828_74##12	75.433121
Rf31	a_828_74##12	a_828_74##13	82.616409
Rf32	a_828_74##11	a_828_74##3	182.228943
Rf33	a_828_74##12	a_828_74##2	128.137512
Rf34	a_828_74##2	a_828_74##16	37.462502
Rf35	a_1520_74##2	a_1520_74##5	181.313980
Rf36	a_1520_74##5	a_1520_74##6	107.821869
Rf37	a_1520_74##5	a_1520_74##7	108.046028
Rf38	a_1736_74##9	a_1736_74##10	91.297073
Rf39	a_1736_74##10	a_1736_74##4	190.960175
Rf40	a_1736_74##10	a_1736_74##12	59.853207
Rf41	a_1736_74##10	a_1736_74##7	175.213272
Rf42	Q	Q#2	0.194040
Rf43	Q#2	Q	14.164948
Rf44	Q	Q#4	6.403333
Rf45	Q#4	Q	7.955656
Rf46	Q#1	Q#2	5.000000
Rf47	Q#3	Q#4	7.500000
Rf49	VGND#2	VGND#3	108.147552
Rf50	VGND#2	VGND#4	42.062149
Rf51	VGND#3	VGND#5	173.162491
Rf52	VGND#5	VGND#6	194.322601
Rf53	VGND#6	VGND#7	35.770210
Rf54	VGND#7	VGND#8	36.623291
Rf55	VGND#8	VGND#9	154.210052
Rf57	VGND#3	VGND#11	20.274899
Rf58	VGND#5	VGND#12	28.841251
Rf59	VGND#6	VGND#13	32.342297
Rf60	VGND#8	VGND#14	55.529682
Rf61	VGND#9	VGND#15	33.916985
Rf63	VPWR#2	VPWR#3	105.882980
Rf64	VPWR#2	VPWR#4	48.259808
Rf65	VPWR#3	VPWR#5	26.941650
Rf66	VPWR#3	VPWR#6	163.243317
Rf67	VPWR#6	VPWR#7	23.681496
Rf68	VPWR#6	VPWR#8	185.097458
Rf69	VPWR#8	VPWR#9	26.159485
Rf70	VPWR#8	VPWR#10	54.726856
Rf71	VPWR#10	VPWR#11	31.897644
Rf72	VPWR#11	VPWR#12	26.266380
Rf73	VPWR#11	VPWR#13	148.388657
Rf74	VPWR#13	VPWR#14	31.337896
Rf83	a_630_74##5	a_630_74##13	160.232803
Re1	VPWR#3	VPWR	2.377092
Re2	VPWR	VPWR#10	1.528131
Re3	VGND#3	VGND	2.377092
Re4	VGND	VGND#7	1.528131
*
*       CAPACITOR CARDS
*
*
C1	VPWR#6	VPWR#7	1.22214e-17
C2	a_1018_100##5	a_630_74##7	1.02284e-19
C3	VGND#13	SCD#1	2.59789e-19
C4	a_828_74##2	a_630_74##3	5.50866e-17
C5	VGND#3	a_1520_74#	2.23952e-17
C6	a_828_74##6	a_1520_74##6	6.76751e-18
C7	VPWR#3	a_630_74##9	7.31063e-20
C8	VGND#6	CLK#2	2.64763e-19
C9	a_301_74##2	a_828_74#	1.74732e-18
C10	CLK#3	VGND#14	1.51561e-17
C11	a_301_74##4	a_301_74##3	1.33573e-18
C12	a_630_74##11	a_828_74##8	1.47268e-17
C13	a_301_74##3	a_35_74##2	3.87547e-20
C14	VGND#6	a_630_74##8	5.21082e-18
C15	a_828_74##6	a_1239_74##7	8.93882e-20
C16	VGND#3	a_1736_74##3	2.94695e-17
C17	VGND#14	a_630_74##14	3.60427e-17
C18	a_630_74##14	SCD#1	1.851e-18
C19	a_301_74##6	a_630_74##8	1.536e-19
C20	CLK#5	a_630_74##12	1.3582e-17
C21	a_630_74##5	a_301_74##5	9.79478e-18
C22	VGND#5	a_630_74##3	7.78706e-20
C23	a_35_74##6	SCE#2	3.61893e-17
C24	VGND#3	a_630_74##9	2.0666e-17
C25	a_301_74##3	a_630_74##7	3.95775e-19
C26	a_630_74##5	a_828_74##13	2.04769e-17
C27	VPWR#12	CLK#2	2.27953e-19
C28	VGND#8	CLK#3	5.19752e-18
C29	a_35_74##6	a_35_74##4	2.23548e-18
C30	SCD#1	VGND#14	1.2228e-17
C31	a_630_74##5	VGND#13	8.46423e-19
C32	a_1239_74##7	a_1018_100##2	2.55421e-17
C33	VGND#3	a_828_74##5	4.18513e-18
C34	a_1520_74##6	a_630_74##9	5.64599e-19
C35	a_1018_100##3	a_630_74##11	1.66954e-17
C36	a_301_74##2	a_630_74##7	4.36222e-17
C37	a_301_74##6	CLK#3	2.72578e-18
C38	a_630_74##14	a_630_74##5	2.87835e-18
C39	a_630_74##5	a_630_74##4	4.68927e-19
C40	a_1018_100##2	VPWR#7	2.5292e-18
C41	VGND#3	a_1018_100#	1.79483e-18
C42	a_1018_100##7	VPWR#8	1.12605e-18
C43	a_630_74##5	a_630_74##3	2.66891e-18
C44	VGND#3	VGND#5	5.45696e-17
C45	a_301_74##3	CLK#1	3.03328e-17
C46	VGND#14	SCE#6	6.08905e-19
C47	a_301_74##4	VPWR#12	8.90628e-18
C48	CLK#2	a_630_74##5	3.46126e-17
C49	a_35_74##6	D#2	3.14114e-18
C50	VGND#6	a_828_74##12	3.34676e-17
C51	a_828_74##11	a_630_74##9	1.18527e-19
C52	a_301_74##6	a_630_74##14	8.53024e-18
C53	a_301_74##6	SCD#1	2.34478e-17
C54	a_1239_74##3	a_1018_100##3	2.82711e-17
C55	a_301_74##6	a_630_74##5	1.21093e-18
C56	VGND#8	SCD#1	6.20698e-18
C57	a_301_74##2	CLK#1	1.23136e-18
C58	a_1018_100##7	VPWR#6	2.57871e-17
C59	VGND#15	CLK#3	3.83134e-19
C60	a_630_74##2	a_1239_74##7	1.0657e-17
C61	VGND#14	D#3	2.72401e-19
C62	VGND#4	a_1736_74##6	2.01372e-18
C63	a_630_74##2	VPWR#7	1.06772e-18
C64	a_301_74##3	SCD#3	2.77689e-17
C65	a_301_74#	VPWR#8	3.14958e-17
C66	a_35_74##6	a_35_74##2	2.92166e-17
C67	a_301_74##6	VGND#14	3.9355e-17
C68	a_301_74##6	SCE#6	4.31317e-17
C69	a_630_74#	a_1239_74##3	4.33916e-17
C70	VGND#5	a_828_74##12	3.00854e-17
C71	a_828_74##11	a_828_74##5	7.21705e-19
C72	VPWR#14	VPWR#12	3.50998e-19
C73	VGND#15	SCD#1	3.27594e-19
C74	a_301_74##2	SCD#3	6.21137e-20
C75	a_1018_100##5	a_1239_74##5	3.10152e-19
C76	a_1018_100##7	a_630_74##2	7.08383e-17
C77	VGND#8	SCE#6	6.57127e-18
C78	VPWR#3	a_1736_74##10	2.87788e-18
C79	VGND#14	a_35_74#	1.61487e-19
C80	a_1520_74##7	a_1520_74##6	1.80647e-19
C81	a_301_74##6	D#3	3.10596e-17
C82	a_1736_74##10	VPWR#4	3.14862e-17
C83	a_301_74##6	SCD#2	1.8301e-17
C84	a_35_74##6	SCE#3	8.42893e-17
C85	a_1520_74##5	VPWR#3	1.91407e-17
C86	a_301_74##3	a_35_74##3	6.78737e-19
C87	a_1239_74##5	a_630_74##3	8.21887e-20
C88	a_828_74#	a_630_74#	1.83272e-17
C89	a_828_74##16	a_630_74##2	9.42793e-20
C90	VGND#15	SCE#6	6.5949e-19
C91	a_828_74##11	a_1018_100#	1.8068e-17
C92	a_630_74##9	a_828_74##7	2.04585e-17
C93	VGND#5	a_828_74##11	4.8622e-17
C94	VGND#7	CLK#3	2.22429e-18
C95	VPWR#14	a_301_74##4	2.31043e-17
C96	a_301_74##6	a_35_74#	2.38116e-18
C97	SCE#7	a_301_74##6	1.03253e-16
C98	VGND#3	a_1736_74##10	3.79919e-18
C99	VGND#8	D#3	2.89162e-19
C100	VPWR#11	VPWR#9	8.96044e-19
C101	a_301_74##5	a_301_74##2	1.34061e-18
C102	VGND#15	D#3	2.73289e-18
C103	a_630_74##7	a_828_74#	4.32504e-18
C104	a_1018_100##7	a_828_74##2	4.39748e-17
C105	a_1736_74##10	a_1736_74##9	2.06117e-18
C106	a_301_74##3	D#1	3.44628e-19
C107	a_828_74##6	a_1520_74#	3.69496e-19
C108	VGND#3	a_1520_74##5	3.35305e-18
C109	a_828_74##2	a_301_74#	2.48594e-17
C110	a_828_74##6	a_1736_74##3	3.39319e-19
C111	SCD#2	CLK#2	1.72411e-17
C112	a_301_74##6	SCE#4	1.11577e-18
C113	VPWR#3	a_1736_74##8	7.0058e-18
C114	a_301_74##6	a_35_74##4	4.84342e-19
C115	a_828_74##16	a_828_74##2	1.46533e-17
C116	a_828_74##11	a_1239_74##2	2.71959e-17
C117	a_828_74##6	a_630_74##9	3.09762e-17
C118	a_35_74#	VGND#15	1.03658e-17
C119	a_1018_100##5	a_630_74##3	1.3745e-17
C120	a_1520_74##5	a_1736_74##9	9.45699e-18
C121	CLK#1	a_630_74##7	4.06581e-18
C122	a_1239_74##5	a_630_74##9	2.92367e-20
C123	VPWR#3	a_1520_74##3	1.97953e-17
C124	a_301_74##2	a_828_74##13	1.2021e-17
C125	VGND#8	a_35_74#	1.60127e-19
C126	a_828_74##6	a_828_74##5	1.76362e-17
C127	a_828_74##12	a_828_74##4	1.54442e-18
C128	a_301_74##3	VPWR#11	1.31182e-18
C129	a_301_74##3	SCE#1	1.03718e-18
C130	VPWR#3	a_1736_74##2	1.20865e-18
C131	a_35_74##8	a_35_74#	4.91833e-19
C132	VPWR#3	a_1736_74#	3.15226e-17
C133	VGND#15	a_301_74##6	1.24091e-17
C134	a_301_74##6	D#2	1.54712e-18
C135	a_828_74##6	a_1018_100#	2.61788e-17
C136	a_630_74##5	VPWR#9	6.05872e-18
C137	VGND#15	SCE#4	2.41769e-17
C138	a_35_74##9	VPWR#14	6.23779e-17
C139	VPWR#3	a_828_74##8	1.40837e-17
C140	a_828_74##6	a_1239_74##2	1.19289e-19
C141	a_828_74##11	a_828_74##4	1.79548e-17
C142	VPWR#4	a_1736_74##6	1.6178e-18
C143	SCD#3	CLK#1	1.21722e-17
C144	a_630_74##12	a_630_74##5	4.19335e-18
C145	VGND#3	a_1736_74#	5.08505e-19
C146	a_1239_74##5	a_828_74##5	3.19795e-19
C147	VGND#3	a_828_74##11	9.46919e-18
C148	VPWR#3	a_630_74##11	2.45767e-18
C149	a_35_74##8	SCE#4	1.42245e-17
C150	a_301_74##3	VPWR#8	2.24714e-20
C151	a_301_74##6	a_35_74##2	3.25529e-19
C152	a_630_74##14	a_301_74##3	2.51945e-18
C153	a_35_74##8	SCE#2	4.5306e-19
C154	a_828_74##12	a_630_74##6	3.9571e-17
C155	a_1736_74##2	VGND#11	2.11932e-20
C156	VPWR#3	a_1018_100##3	1.10191e-18
C157	a_1239_74#	a_1018_100#	6.04136e-18
C158	a_35_74##3	SCD#3	2.18009e-17
C159	VGND#15	a_35_74##2	5.2629e-19
C160	VGND#3	a_1736_74##6	7.00198e-19
C161	a_1520_74##5	a_1736_74##10	2.48484e-18
C162	a_828_74##11	a_630_74##6	5.16868e-19
C163	VGND#3	a_1736_74##2	1.10718e-17
C164	a_1239_74##5	a_1018_100#	1.63117e-17
C165	a_1520_74##2	a_1736_74##8	2.98247e-18
C166	a_630_74##12	SCD#2	6.59095e-19
C167	a_630_74##10	VPWR#6	1.22225e-17
C168	a_301_74##3	a_630_74##4	7.65813e-20
C169	VGND#14	a_301_74##3	7.49563e-18
C170	a_1736_74##10	a_1736_74##7	2.53062e-17
C171	a_828_74##12	a_630_74##8	5.76608e-19
C172	SCD#2	VPWR#12	1.74319e-18
C173	D#1	a_35_74##3	2.88343e-17
C174	SCE#3	VGND#15	4.14022e-17
C175	a_301_74##2	VPWR#8	1.42471e-17
C176	VPWR#14	SCE#2	3.08727e-18
C177	a_35_74##8	SCE#3	2.37278e-17
C178	a_1520_74##5	a_1736_74##7	2.12823e-19
C179	a_35_74##8	VGND#15	3.67934e-17
C180	a_1736_74#	a_1520_74##2	7.79814e-18
C181	SCD#2	a_301_74##4	8.39097e-18
C182	a_1239_74##5	a_1239_74##2	1.70774e-19
C183	a_35_74##4	SCE#2	1.03441e-19
C184	a_1520_74#	a_1736_74##5	6.81566e-18
C185	a_1736_74##8	Q#1	1.18617e-17
C186	SCE#1	D#1	5.10755e-17
C187	VGND#3	a_1239_74##5	1.37275e-18
C188	a_1520_74##6	a_1520_74##5	4.38514e-18
C189	a_1736_74##10	a_1520_74##2	5.91082e-17
C190	VPWR#6	a_828_74##6	1.46664e-19
C191	SCE#7	a_301_74##4	4.30253e-18
C192	a_630_74##6	a_828_74##3	4.0663e-18
C193	a_35_74##9	SCD#2	4.14955e-21
C194	a_1736_74##8	VPWR#4	2.35594e-17
C195	a_828_74##7	a_1736_74#	1.77897e-17
C196	VPWR#6	a_1736_74#	2.39266e-19
C197	a_301_74##3	a_301_74##2	1.45637e-18
C198	a_1520_74##5	a_1520_74##2	6.6459e-19
C199	a_301_74##2	a_630_74##4	7.42641e-18
C200	a_35_74##6	D#1	4.16238e-19
C201	SCE#5	SCE#1	2.33254e-17
C202	a_301_74##4	VPWR#11	5.95941e-18
C203	VPWR#10	CLK#1	1.4318e-18
C204	a_1239_74##5	a_828_74##4	4.3278e-20
C205	a_1736_74##9	a_1736_74##8	3.2198e-18
C206	a_35_74##9	SCE#2	1.12799e-17
C207	a_35_74##4	a_301_74##4	6.27063e-17
C208	a_35_74##6	VPWR#14	3.78512e-17
C209	a_301_74##3	CLK#2	1.59166e-17
C210	a_301_74##6	a_301_74##3	1.70353e-18
C211	a_1736_74##12	VGND#4	4.67938e-17
C212	a_630_74##11	a_828_74##7	7.03419e-18
C213	a_1736_74##3	a_1520_74#	5.80376e-18
C214	VPWR#4	a_1520_74##3	2.42922e-18
C215	a_1520_74#	a_1736_74##6	2.34672e-19
C216	a_630_74##10	a_828_74##8	5.73834e-19
C217	a_828_74##11	a_1154_100#	4.02876e-18
C218	VPWR#6	a_1018_100##2	7.93234e-19
C219	a_630_74##5	a_630_74##6	2.21685e-19
C220	a_1520_74##7	a_1736_74##2	1.49457e-17
C221	SCE#2	D#2	5.91796e-19
C222	VPWR#10	CLK#2	1.88008e-19
C223	a_630_74##10	a_630_74##11	2.12082e-17
C224	a_35_74##9	a_35_74##4	9.07022e-21
C225	a_1520_74##5	a_1736_74##4	1.40937e-17
C226	a_1736_74##9	a_1520_74##3	5.8267e-17
C227	a_301_74##2	a_630_74##3	4.14192e-19
C228	a_35_74##6	SCE#1	1.12175e-17
C229	a_1736_74##10	a_1736_74##6	6.1502e-19
C230	a_630_74##5	a_630_74##8	7.65224e-18
C231	VPWR#6	a_828_74##8	6.27386e-19
C232	a_1736_74##2	a_1520_74#	2.03317e-17
C233	a_630_74##10	a_1018_100##3	1.32826e-17
C234	VPWR#4	a_1736_74#	1.72321e-19
C235	a_630_74##5	CLK#3	9.15626e-19
C236	a_1736_74##2	a_1736_74#	7.43652e-19
C237	a_630_74##14	CLK#5	2.15429e-17
C238	a_301_74##3	VPWR#10	6.28416e-18
C239	a_630_74##4	a_630_74##3	1.74982e-18
C240	a_1520_74##3	VPWR#5	1.03635e-17
C241	a_630_74##10	a_1239_74##3	1.97677e-19
C242	a_630_74##5	SCD#1	1.27834e-19
C243	a_1736_74##10	VGND#4	3.18528e-17
C244	VGND#5	a_828_74##6	4.4382e-17
C245	a_630_74##9	a_1736_74##3	3.41206e-17
C246	a_828_74##5	a_1520_74#	1.50032e-19
C247	a_1736_74##9	a_1736_74#	2.85832e-18
C248	a_1018_100##5	a_630_74##6	3.70335e-20
C249	a_1520_74##7	a_1688_100#	1.17753e-18
C250	a_301_74##2	CLK#2	3.74401e-21
C251	VPWR#6	a_1239_74#	2.7113e-19
C252	a_828_74##7	a_1520_74##5	8.50399e-17
C253	a_1520_74##6	a_1202_508#	5.91216e-21
C254	a_1736_74##10	a_1736_74##2	4.88385e-19
C255	a_1736_74#	VPWR#5	1.26521e-17
C256	VPWR#6	a_630_74##11	7.3118e-18
C257	SCD#2	CLK#3	1.09851e-18
C258	a_1239_74##3	a_1018_100##2	2.45188e-18
C259	a_1520_74##6	a_1520_74##3	2.02987e-19
C260	a_1736_74##9	a_828_74##8	1.90393e-19
C261	SCE#2	a_35_74##2	2.73114e-17
C262	VGND#7	CLK#2	3.21002e-19
C263	VPWR#14	VPWR#11	4.46108e-20
C264	a_301_74##5	a_828_74##16	1.89669e-17
C265	a_630_74##2	a_630_74##11	1.4119e-19
C266	VGND#5	a_1018_100##2	3.485e-20
C267	a_828_74##5	a_630_74##9	6.50718e-18
C268	a_630_74##2	a_1018_100##3	2.31655e-17
C269	CLK#2	a_630_74##4	2.39176e-20
C270	a_1520_74##6	a_1736_74#	1.89602e-18
C271	SCE#7	SCD#1	1.81443e-17
C272	a_630_74##10	a_1520_74##5	5.25427e-19
C273	a_1736_74##9	a_630_74##11	1.44594e-19
C274	a_630_74##2	VPWR#6	4.88916e-17
C275	a_630_74##2	a_1239_74##3	5.49049e-17
C276	a_1736_74##9	VPWR#4	7.15424e-17
C277	VGND#8	a_301_74##3	8.38096e-19
C278	VPWR#3	a_1736_74##7	1.152e-18
C279	a_630_74##2	a_630_74#	5.88582e-18
C280	VPWR#6	a_1018_100##3	1.65004e-17
C281	D#3	SCE#7	7.71383e-18
C282	SCD	CLK#2	6.6109e-19
C283	VGND#3	a_1736_74##7	2.18732e-18
C284	a_1520_74##2	VPWR#3	1.90742e-17
C285	a_1520_74##5	a_1736_74##2	2.04251e-17
C286	a_1520_74##6	a_828_74##8	3.10367e-17
C287	a_301_74##3	CLK#5	3.63967e-17
C288	a_301_74##3	a_630_74##8	6.71238e-19
C289	a_1018_100#	a_828_74##5	2.85935e-17
C290	a_1520_74##7	a_1736_74##12	1.8268e-18
C291	a_1736_74##5	Q#3	7.47752e-18
C292	VGND#3	a_1520_74##2	4.23656e-18
C293	a_630_74##7	a_630_74##2	7.11549e-19
C294	SCE#3	SCE#2	1.7256e-18
C295	a_828_74##2	a_630_74#	5.34489e-18
C296	VGND#3	a_1736_74##4	3.58952e-17
C297	a_630_74##9	a_1736_74##2	9.12796e-18
C298	a_1520_74##2	a_1736_74##6	3.79682e-19
C299	VPWR#3	a_828_74##7	4.95091e-18
C300	VGND#8	VGND#6	8.6597e-19
C301	a_630_74##11	a_1520_74##6	2.62513e-17
C302	a_1736_74##5	VGND#4	1.97002e-17
C303	a_1736_74##10	a_1736_74##8	1.46282e-18
C304	a_301_74##4	a_412_464#	4.57456e-18
C305	VPWR#6	a_1239_74##3	1.70027e-17
C306	VGND#3	a_828_74##7	3.86971e-18
C307	a_1736_74##2	a_1520_74##2	3.63729e-17
C308	a_35_74#	D#2	5.50773e-18
C309	a_630_74##10	VPWR#3	2.10093e-17
C310	a_630_74##7	a_828_74##2	1.29036e-17
C311	a_301_74##3	CLK#3	1.22471e-17
C312	a_630_74##11	a_1239_74##7	2.85642e-17
C313	a_1520_74##2	a_1736_74##7	2.79414e-17
C314	a_1239_74##2	a_1018_100#	7.08551e-18
C315	VGND#3	a_630_74##10	3.88042e-18
C316	VGND#5	a_630_74##2	1.58793e-19
C317	a_1520_74##5	a_1736_74##8	6.94634e-20
C318	VPWR#3	a_828_74##6	1.2197e-18
C319	a_1736_74##12	a_1736_74##5	1.03227e-18
C320	a_1520_74##6	a_1018_100##3	2.08431e-18
C321	a_630_74##5	a_630_74##7	3.23684e-18
C322	VGND#6	a_828_74##13	4.27892e-17
C323	VPWR#8	a_828_74##2	6.04398e-19
C324	VGND#4	a_1520_74#	2.38806e-18
C325	VGND#3	a_828_74##6	5.06423e-17
C326	a_1239_74##5	a_828_74##7	7.90084e-19
C327	VPWR#3	a_1018_100##2	2.97272e-18
C328	a_630_74##5	CLK#1	5.90142e-19
C329	a_1736_74##4	a_1520_74##2	2.91735e-17
C330	a_1239_74##7	a_1018_100##3	3.56261e-17
C331	VGND#8	VGND#13	5.88886e-19
C332	a_828_74##11	a_828_74##6	2.26403e-18
C333	a_1736_74##10	a_1520_74##3	4.32107e-20
C334	SCE#3	a_35_74#	2.29771e-17
C335	VGND#3	a_1018_100##2	2.30459e-18
C336	VPWR#6	a_630_74#	7.15114e-18
C337	a_1520_74##6	a_1239_74##3	7.36118e-19
C338	a_1520_74##7	a_1736_74##10	3.15538e-19
C339	VGND#3	VGND#4	2.2535e-18
C340	a_1736_74##12	a_1520_74#	3.75371e-17
C341	a_1018_100##3	VPWR#7	1.61887e-17
C342	VGND#3	a_1239_74#	1.25317e-18
C343	a_828_74##4	a_1239_74##2	1.33933e-17
C344	a_630_74##14	a_630_74##12	3.14605e-18
C345	VPWR#3	a_630_74##2	4.79535e-18
C346	a_1520_74##5	a_1520_74##3	2.26072e-18
C347	a_1520_74##6	a_1736_74##9	1.74627e-18
C348	VGND#5	a_828_74##3	4.51261e-19
C349	a_1018_100##7	a_630_74##11	4.04484e-19
C350	SCD#2	CLK#1	1.53889e-17
C351	VGND#3	a_1736_74##12	7.18748e-17
C352	a_1239_74##7	a_1239_74##3	2.13833e-18
C353	a_1736_74##4	a_1736_74##2	1.58297e-17
C354	VPWR#8	a_630_74##4	8.62528e-20
C355	a_1239_74##5	a_630_74##10	1.24373e-17
C356	a_1520_74#	VGND#11	4.29752e-18
C357	a_1520_74##6	a_630_74#	2.77427e-19
C358	VPWR#8	a_828_74#	3.02802e-18
C359	VGND#3	VGND#11	8.49907e-18
C360	a_828_74##11	a_1018_100##2	3.73564e-18
C361	a_1239_74##3	VPWR#7	1.00327e-17
C362	a_1736_74##10	a_1736_74#	9.02944e-20
C363	a_1520_74##7	a_1520_74##5	1.28311e-18
C364	CLK	CLK#2	4.7359e-18
C365	a_630_74##10	a_828_74##7	6.17457e-17
C366	a_1736_74##12	a_1736_74##3	1.01606e-18
C367	a_1018_100##7	a_1018_100##3	1.41378e-18
C368	VPWR#6	a_828_74#	2.36281e-18
C369	a_630_74##6	a_828_74##4	9.33217e-18
C370	a_1520_74##5	a_1736_74#	2.93509e-17
C371	VGND#3	a_1520_74##7	6.32233e-17
C372	a_1736_74##3	VGND#11	1.33727e-17
C373	a_828_74##6	a_1239_74##5	5.31802e-17
C374	a_1736_74##3	a_1688_100#	5.87385e-18
C375	a_828_74##6	a_630_74##10	7.29665e-17
C376	a_630_74##9	a_1688_100#	7.56458e-18
C377	VPWR#8	a_630_74##3	2.02867e-19
C378	VGND#6	a_630_74##14	7.27119e-19
C379	a_1018_100##7	a_1239_74##3	3.55377e-18
C380	a_1736_74#	a_1688_508#	1.06762e-17
C381	a_1736_74##12	a_630_74##9	1.43723e-19
C382	VGND#3	a_1239_74##4	7.72121e-18
C383	a_1018_100##2	a_630_74##10	1.84056e-17
C384	a_1520_74##7	a_1520_74#	5.661e-19
C385	a_35_74##4	D#1	2.18472e-17
C386	a_828_74##11	a_1239_74#	5.87159e-17
C387	a_828_74##8	a_1688_508#	1.06762e-17
C388	VPWR#8	a_630_74##7	9.48183e-19
C389	a_828_74##7	a_1736_74##2	3.39273e-17
C390	a_1018_100##2	a_828_74##6	1.10134e-17
C391	VGND#3	VGND#12	2.85185e-20
C392	a_1239_74##5	a_1239_74##7	2.93246e-18
C393	VGND#6	a_630_74##5	6.06224e-21
C394	VPWR#6	a_630_74##7	4.79674e-19
C395	a_1018_100##7	a_630_74#	3.39443e-17
C396	a_630_74##8	a_630_74##6	5.9267e-18
C397	a_630_74##2	a_630_74##10	1.14519e-18
C398	CLK#5	CLK#2	1.70888e-17
C399	a_1239_74##5	a_1018_100##2	5.0665e-17
C400	a_828_74##12	a_630_74##2	7.05962e-20
C401	a_1736_74##12	a_828_74##5	3.8018e-20
C402	a_1018_100##2	a_1239_74#	1.26325e-16
C403	a_1520_74##7	a_1736_74##3	1.19618e-17
C404	VGND#4	a_1736_74##7	8.31479e-18
C405	a_828_74##12	a_828_74##11	3.09956e-18
C406	a_1018_100##5	a_1018_100##2	1.68423e-18
C407	a_301_74#	a_630_74#	7.80359e-19
C408	a_35_74##2	SCE#1	5.91136e-18
C409	a_828_74##11	a_630_74##2	1.04607e-18
C410	a_1239_74##3	a_1202_508#	7.82598e-18
C411	a_1018_100##2	a_630_74##2	3.76712e-17
C412	VPWR#9	a_1239_74##3	2.11019e-19
C413	a_301_74##6	a_450_74#	5.44793e-18
C414	a_1018_100##7	a_828_74#	1.66126e-17
C415	a_630_74#	a_1202_508#	6.07892e-18
C416	SCE#3	SCE#1	9.3088e-20
C417	a_630_74##2	a_1239_74#	2.63621e-17
C418	CLK#3	a_630_74##8	4.41123e-18
C419	a_301_74#	a_828_74#	1.99857e-17
C420	a_828_74##3	a_1239_74#	5.9204e-17
C421	a_1520_74##5	a_630_74##11	2.72261e-19
C422	a_1520_74##7	a_630_74##9	3.93963e-17
C423	a_1239_74##5	a_1239_74#	2.7412e-19
C424	VPWR#9	a_630_74#	3.61465e-19
C425	a_630_74##10	a_1736_74##2	1.16413e-18
C426	a_828_74##12	a_828_74##3	4.68929e-19
C427	a_1018_100##7	a_630_74##7	9.83791e-19
C428	a_828_74##3	a_630_74##2	2.08546e-17
C429	a_1239_74##2	a_1154_100#	4.32329e-18
C430	a_828_74##2	a_1239_74#	1.11207e-19
C431	a_1018_100##5	a_1239_74#	5.00697e-19
C432	a_301_74##5	a_630_74##4	1.0193e-17
C433	SCD	a_301_74##3	2.54533e-17
C434	a_828_74##4	a_1154_100#	1.0691e-17
C435	Q	a_1736_74##6	1.9747e-17
C436	VPWR#11	SCD#3	8.30696e-18
C437	a_828_74##11	a_828_74##3	8.33772e-20
C438	VPWR#11	SCE#7	6.78057e-20
C439	a_630_74##2	a_828_74##2	1.22214e-17
C440	a_1239_74##4	a_630_74##9	9.30257e-21
C441	SCD#3	a_412_464#	1.83683e-17
C442	a_828_74##2	a_828_74##3	3.72453e-19
C443	VPWR#9	a_828_74#	1.18359e-18
C444	a_828_74##5	a_1520_74##7	1.04584e-17
C445	a_35_74##3	a_412_464#	1.83683e-17
C446	VGND#8	a_301_74##6	2.84549e-17
C447	VGND#8	SCD#2	4.86673e-20
C448	a_301_74##6	a_301_74##4	1.84868e-18
C449	SCD#1	CLK#3	2.50022e-17
C450	a_1239_74##5	a_630_74##2	4.87045e-19
C451	a_630_74##7	a_828_74##16	1.66695e-17
C452	a_301_74##5	a_630_74##3	1.04092e-17
C453	a_828_74##12	a_828_74##2	1.07662e-18
C454	a_828_74##2	a_630_74##5	1.83826e-19
C455	a_1018_100##5	a_630_74##2	6.95937e-17
C456	D#1	a_238_464#	1.62684e-17
C457	a_1239_74##4	a_828_74##5	2.39614e-17
C458	VPWR#9	a_630_74##7	5.51529e-17
C459	SCE#1	a_238_464#	1.62684e-17
C460	VPWR#11	a_35_74##3	5.51057e-18
C461	VPWR#11	a_35_74##4	4.12922e-19
C462	a_828_74##13	a_630_74##4	4.38315e-18
C463	VGND#12	a_828_74##5	3.18612e-19
C464	SCE#6	SCD#1	3.11657e-17
C465	a_630_74##5	SCD#2	4.15284e-19
C466	VGND#8	SCE#7	3.73401e-19
C467	VPWR#9	CLK#1	5.6815e-18
C468	a_35_74##6	D	4.24135e-17
C469	a_1520_74##7	a_1736_74##4	2.02207e-17
C470	VPWR	a_630_74##3	5.37536e-19
C471	VPWR	SCE#2	1.51767e-22
C472	a_1239_74##4	a_1018_100#	1.89063e-17
C473	VPWR#12	a_630_74##7	2.49619e-18
C474	a_1018_100##5	a_828_74##3	5.68811e-17
C475	VGND#7	a_630_74##14	1.80322e-17
C476	a_828_74##12	a_630_74##5	2.65285e-20
C477	a_1018_100##5	a_1018_100##7	2.76768e-18
C478	a_630_74##12	CLK#1	4.03804e-17
C479	a_301_74##6	SCD	2.97664e-17
C480	a_828_74##11	a_1239_74##4	2.71145e-17
C481	a_828_74##13	a_630_74##3	3.15061e-20
C482	SCE#7	SCD#2	1.11629e-17
C483	VPWR#3	VPWR#4	2.38006e-18
C484	a_1018_100#	VGND#12	9.83514e-18
C485	a_35_74##8	a_35_74##6	5.0118e-18
C486	a_828_74##12	a_630_74##3	1.83022e-18
C487	VPWR#12	CLK#1	3.83407e-17
C488	a_35_74##4	SCD#2	8.59596e-17
C489	SCD#1	a_450_74#	7.43995e-18
C490	a_1520_74##7	a_828_74##7	3.43531e-17
C491	D#3	SCE#6	8.45988e-18
C492	SCE#6	a_450_74#	6.36549e-18
C493	a_1239_74##4	a_1239_74##2	2.13173e-19
C494	VPWR#3	a_1736_74##9	6.24696e-17
C495	SCE#7	a_35_74##4	7.20558e-17
C496	D#2	SCD#2	4.76747e-19
C497	VGND#8	a_35_74##4	5.08947e-20
C498	a_828_74##2	a_1018_100##5	6.78258e-17
C499	D#2	SCE#7	1.41137e-17
C500	VPWR#3	VPWR#5	9.54994e-18
C501	a_630_74##2	a_1202_508#	2.60949e-18
C502	VGND#3	VPWR#4	2.07845e-18
C503	SCD#3	VPWR#12	2.52916e-17
C504	a_35_74##4	D#2	1.10677e-16
C505	a_1239_74##2	VGND#12	1.73174e-17
C506	a_1736_74##10	Q	2.28858e-17
C507	a_828_74##11	VGND#12	7.62056e-17
C508	a_301_74##4	CLK#1	7.88644e-19
C509	VGND	a_630_74##3	3.4449e-18
C510	VGND	CLK#2	5.78284e-19
C511	a_35_74##4	a_35_74##2	2.93064e-19
C512	SCE	a_35_74##6	3.92351e-18
C513	a_630_74##14	CLK	1.3991e-17
C514	a_1239_74##4	a_828_74##4	1.36016e-20
C515	a_35_74#	D#3	4.79275e-17
C516	a_35_74##2	D#2	3.14233e-17
C517	a_301_74##2	a_828_74##2	8.38073e-18
C518	a_630_74##7	a_630_74##3	6.20103e-18
C519	a_1239_74##4	a_630_74##10	1.68481e-18
C520	VPWR	VPWR#11	8.88562e-17
C521	D#3	a_223_74#	9.87534e-18
C522	a_1520_74##6	VPWR#3	5.0776e-17
C523	VPWR#12	a_35_74##3	3.57627e-18
C524	VPWR	VPWR#8	1.01376e-16
C525	VPWR	VPWR#6	8.28973e-17
C526	a_301_74#	a_630_74##3	1.08359e-18
C527	a_35_74#	a_223_74#	8.35249e-18
C528	a_301_74##4	SCD#3	2.40485e-18
C529	a_301_74##2	a_1018_100##7	1.03846e-17
C530	SCE#3	a_35_74##2	4.04293e-17
C531	VGND#12	a_828_74##4	1.27733e-18
C532	VPWR#3	a_1239_74##7	4.2287e-18
C533	a_828_74##6	a_1520_74##7	6.7663e-17
C534	a_301_74##3	a_630_74##5	8.1314e-18
C535	VPWR#12	D#1	2.86745e-19
C536	a_301_74##6	SCE	1.24149e-17
C537	Q	Q#3	3.74163e-18
C538	a_35_74##4	a_412_464#	9.7907e-19
C539	a_301_74##4	a_35_74##3	4.85217e-17
C540	a_828_74##12	a_1018_100##6	7.3242e-17
C541	a_828_74##6	a_1239_74##4	6.23398e-17
C542	VGND#4	Q	7.23134e-17
C543	a_35_74##8	SCE	3.29893e-18
C544	a_301_74#	a_1018_100##7	3.16224e-17
C545	a_301_74##2	a_630_74##5	8.99906e-17
C546	SCE#4	a_35_74#	1.90198e-17
C547	CLK	a_630_74##12	1.19359e-17
C548	VPWR#14	SCD#3	1.75377e-19
C549	a_630_74##4	a_828_74##16	2.49823e-18
C550	VPWR	a_1018_100##5	1.99009e-18
C551	CLK#1	a_630_74##4	1.81774e-19
C552	VPWR	a_301_74##3	1.76755e-17
C553	VPWR	a_301_74##2	1.83632e-17
C554	VPWR#12	SCE#1	1.63859e-19
C555	VPWR	CLK#5	2.31227e-18
C556	a_828_74##3	a_1154_100#	6.17578e-19
C557	VGND#5	a_828_74##5	4.46401e-18
C558	a_35_74##9	SCD#3	1.84655e-19
C559	a_1018_100##6	a_828_74##4	6.32303e-18
C560	VGND	VGND#8	8.53766e-17
C561	a_630_74##3	a_1239_74#	7.1904e-19
C562	a_301_74##4	D#1	3.74926e-17
C563	VGND	VGND#6	9.11309e-17
C564	VGND	VGND#5	7.95198e-17
C565	VPWR#4	a_1736_74##7	9.04899e-18
C566	a_1736_74##10	a_1736_74##5	1.44017e-18
C567	VPWR	a_35_74##6	5.46052e-18
C568	VPWR#14	a_35_74##3	3.3984e-19
C569	a_630_74##8	a_630_74##3	3.25326e-20
C570	Q	Q#1	5.8329e-18
C571	a_1018_100##6	a_828_74##11	3.42154e-17
C572	VPWR#4	Q	8.71621e-17
C573	a_630_74##3	a_828_74##16	2.5603e-18
C574	CLK	a_630_74##8	5.83499e-19
C575	VGND	a_828_74##12	2.83814e-17
C576	VGND	a_828_74##11	2.11522e-17
C577	a_828_74##12	a_301_74##5	5.73118e-17
C578	a_828_74##13	a_301_74##5	6.61863e-17
C579	a_35_74##9	a_35_74##3	2.69083e-19
C580	VPWR	a_301_74##5	1.94395e-18
C581	SCD	CLK#1	7.36528e-20
C582	a_301_74##4	SCE#1	5.76247e-18
C583	VGND	a_1018_100##5	1.69026e-18
C584	VGND	a_301_74##3	2.95014e-18
C585	CLK#2	a_630_74##8	2.73056e-19
C586	VGND	a_301_74##2	1.9548e-18
C587	VPWR#14	D#1	5.33846e-18
C588	a_301_74#	a_828_74##16	5.23784e-18
C589	a_630_74##6	a_1018_100##6	1.48607e-17
C590	a_301_74##2	a_828_74##16	5.78443e-17
C591	VGND	CLK#5	2.34918e-18
C592	VPWR#4	a_1520_74##2	4.40109e-19
C593	a_828_74##11	a_1239_74##5	1.65313e-17
C594	a_828_74##12	a_1018_100##5	3.91245e-18
C595	SCE	SCD#1	1.34508e-19
C596	VGND	a_35_74##6	5.22613e-18
C597	Q	a_1736_74##5	2.60567e-17
C598	SCE	SCE#6	6.38027e-19
C599	VGND#5	a_1018_100#	4.46603e-18
C600	Q	a_1520_74#	6.47563e-19
C601	SCE	D#3	1.7294e-17
C602	CLK#2	a_630_74##14	8.36543e-18
C603	a_1520_74##2	a_1736_74##9	4.07582e-18
C604	a_35_74##9	D#1	4.50118e-19
C605	SCE	a_35_74#	2.72175e-17
C606	SCD#2	a_301_74##3	7.59253e-17
C607	a_1736_74##10	a_1520_74#	1.64636e-17
C608	SCE	SCE#4	1.4342e-18
C609	a_630_74##4	VPWR#9	1.33802e-19
C610	D	SCE#1	2.79329e-18
C611	VPWR	a_1018_100##7	2.09995e-17
C612	VPWR	a_301_74#	2.2061e-17
C613	VGND	VGND#12	1.47176e-17
C614	a_630_74##6	a_301_74##5	2.56234e-17
C615	VPWR	a_828_74##16	2.66438e-18
C616	a_1239_74#	VGND#12	2.72521e-18
C617	a_1736_74##6	VNB	3.56282e-17
C618	VGND	a_1018_100##6	7.41413e-18
C619	VPWR	VPWR#9	2.84372e-17
C620	VPWR#14	SCE#1	4.43617e-17
C621	a_1736_74##2	VNB	6.06137e-17
C622	a_630_74##4	VNB	2.24086e-17
C623	VGND	a_301_74##5	8.71413e-18
C624	VPWR	a_630_74##12	3.95212e-18
C625	a_301_74##2	SCD#2	3.13278e-20
C626	a_630_74##3	VNB	5.28128e-17
C627	CLK#2	VNB	5.45968e-17
C628	VGND	a_828_74##13	2.18396e-17
C629	SCE#2	VNB	6.19963e-17
C630	VPWR	VPWR#12	2.53535e-17
C631	VGND	VGND#13	1.59655e-17
C632	a_1520_74##2	VPWR#5	1.81786e-18
C633	VGND	a_630_74##14	2.29361e-17
C634	a_828_74##13	a_828_74##12	2.7361e-18
C635	VPWR	a_301_74##4	2.42097e-17
C636	VGND	a_301_74##6	3.82416e-17
C637	VPWR	VPWR#14	2.22618e-17
C638	VPWR	a_35_74##9	2.40626e-17
C639	VGND	VGND#15	1.85072e-17
C640	VGND	a_35_74##8	1.64033e-17
C641	a_35_74##9	SCE#1	1.67211e-18
C642	Q	a_1736_74##8	3.61597e-17
C643	a_301_74##2	VPWR#9	8.39903e-17
C644	a_828_74##13	a_630_74##6	1.93202e-18
C645	VPWR#11	VPWR#8	2.83364e-19
C646	VPWR#14	SCE#5	1.89692e-17
C647	a_828_74##11	a_1018_100##5	1.98093e-18
C648	VGND#4	VPWR#4	5.46508e-18
C649	SCE	SCE#1	1.54634e-18
C650	VGND	a_630_74##12	4.14377e-18
C651	VGND#13	a_828_74##13	3.22772e-17
C652	a_301_74##5	a_630_74##8	1.67936e-18
C653	a_301_74##3	a_630_74##12	6.35777e-17
C654	VPWR#11	VNB	4.44533e-17
C655	VPWR#8	VNB	5.56191e-17
C656	VGND#5	a_1239_74##2	3.87792e-18
C657	VPWR#6	VNB	7.672e-17
C658	VPWR#6	a_1520_74##6	4.20973e-18
C659	a_1736_74##10	a_1736_74##3	9.80773e-20
C660	SCD	SCD#2	1.16463e-17
C661	VGND#8	VNB	4.11946e-17
C662	VGND#6	VNB	5.25875e-17
C663	VGND#5	VNB	7.86352e-17
C664	CLK#5	SCD#2	4.36586e-19
C665	a_1520_74##3	a_1736_74##8	5.46186e-18
C666	a_35_74##9	SCE#5	3.21632e-17
C667	VGND#13	a_630_74##6	2.24757e-19
C668	VGND	a_1239_74##2	9.47182e-18
C669	a_35_74##4	SCD	2.12418e-17
C670	a_1736_74##10	VNB	1.46466e-17
C671	a_1520_74##5	VNB	1.41909e-18
C672	VPWR	a_1239_74##3	8.13949e-19
C673	VGND	a_630_74##8	4.17738e-18
C674	VPWR	a_630_74#	1.69973e-18
C675	VPWR#3	Q	2.11672e-17
C676	a_828_74##12	VNB	1.16629e-17
C677	a_828_74##11	VNB	8.04801e-18
C678	VGND	CLK#3	3.01798e-18
C679	VPWR	a_828_74#	1.58168e-18
C680	VGND#3	Q	2.0589e-17
C681	VGND	SCD#1	2.87209e-19
C682	VPWR	a_630_74##7	5.60235e-19
C683	VGND	SCE#6	3.78014e-19
C684	VPWR	CLK#1	8.23299e-19
C685	a_1239_74##5	VNB	1.35119e-18
C686	VGND	D#3	1.39851e-18
C687	a_1018_100##5	VNB	7.44813e-18
C688	VPWR	SCD#3	1.0624e-18
C689	CLK	a_630_74##5	4.11368e-17
C690	D	a_35_74##4	3.4312e-18
C691	a_301_74##3	VNB	1.11218e-17
C692	a_828_74##13	a_630_74##8	1.87778e-17
C693	a_301_74##2	VNB	1.37962e-17
C694	VGND	SCE#4	1.11314e-18
C695	VPWR	a_35_74##3	2.26767e-19
C696	VGND#6	a_630_74##4	7.92965e-20
C697	VPWR	D#1	1.78662e-18
C698	Q	a_1520_74##2	3.39373e-19
C699	D	D#2	6.37243e-18
C700	CLK#5	VNB	3.84736e-18
C701	VPWR	SCE#1	8.9694e-19
C702	D	a_35_74##2	1.18961e-17
C703	a_630_74##12	a_301_74##2	1.72947e-17
C704	VPWR	SCE#5	6.1051e-19
C705	a_35_74##6	VNB	4.13775e-17
C706	D	SCE#3	7.34043e-19
C707	VPWR#3	VPWR#6	7.69279e-17
C708	VGND#4	VNB	9.98321e-18
C709	a_630_74##14	a_828_74##13	1.94714e-17
C710	a_1736_74##12	VNB	9.06778e-18
C711	VPWR	VPWR#10	2.52286e-17
C712	a_1520_74##7	VNB	5.80045e-18
C713	a_630_74##14	a_630_74##6	7.22645e-20
C714	a_1239_74##4	VNB	8.36336e-21
C715	VGND#12	VNB	3.45902e-18
C716	a_1018_100##6	VNB	5.41836e-18
C717	a_301_74##5	VNB	1.23932e-17
C718	a_828_74##13	VNB	1.31848e-17
C719	VGND#13	VNB	3.66436e-18
C720	a_630_74##14	VNB	9.21537e-18
C721	VGND#14	VNB	1.40908e-18
C722	a_301_74##6	VNB	6.10568e-18
C723	a_301_74##3	VPWR#12	6.5305e-17
C724	VGND#15	VNB	3.36039e-18
C725	a_35_74##8	VNB	3.84273e-17
C726	SCE	D#2	3.3258e-17
C727	a_301_74##3	a_35_74##4	1.65274e-19
C728	VPWR#4	VNB	1.36952e-17
C729	a_1736_74##9	VNB	1.34212e-17
C730	SCE	a_35_74##2	9.83323e-18
C731	VGND#13	a_630_74##8	3.55148e-17
C732	a_630_74##3	a_828_74##3	3.238e-18
C733	VPWR	a_1018_100##2	3.44341e-18
C734	a_1520_74##6	VNB	1.43765e-17
C735	a_1239_74##7	VNB	3.9094e-18
C736	SCE	SCE#3	2.09052e-19
C737	a_1736_74#	a_1520_74##3	2.44856e-17
C738	a_1018_100##7	VNB	5.8568e-18
C739	VPWR	a_630_74##2	1.677e-17
C740	a_301_74#	VNB	8.88448e-18
C741	VGND	VGND#7	2.4983e-17
C742	a_828_74##16	VNB	3.71229e-18
C743	VPWR#9	VNB	4.8392e-18
C744	a_630_74##12	VNB	6.3495e-18
C745	VPWR#12	VNB	1.63723e-18
C746	VPWR	a_828_74##2	6.99873e-18
C747	VGND#5	a_828_74##4	3.10741e-18
C748	a_1736_74##10	a_630_74##9	2.59406e-20
C749	a_301_74##4	VNB	7.67518e-18
C750	VPWR	a_630_74##5	1.65565e-18
C751	VPWR#14	VNB	2.2032e-18
C752	a_35_74##9	VNB	4.06011e-17
C753	a_1736_74##5	VNB	3.91979e-17
C754	a_1520_74#	VNB	4.63359e-17
C755	VPWR	SCD#2	3.92402e-18
C756	a_1736_74##3	VNB	2.13145e-17
C757	a_828_74##13	CLK#3	3.06189e-19
C758	a_630_74##9	VNB	5.13926e-17
C759	a_828_74##5	VNB	2.99785e-17
C760	VGND	a_1018_100##2	2.81923e-18
C761	a_1018_100#	VNB	3.58131e-17
C762	a_828_74##7	a_1520_74##6	2.93655e-17
C763	a_1239_74##2	VNB	2.78365e-17
C764	VGND	a_1239_74#	3.6972e-18
C765	a_1018_100##6	a_828_74##3	1.9944e-17
C766	VPWR	a_35_74##4	8.41905e-18
C767	a_828_74##4	VNB	2.29742e-17
C768	a_630_74##6	VNB	4.36521e-17
C769	VGND	a_630_74##2	4.24311e-20
C770	a_630_74##8	VNB	3.83143e-17
C771	VPWR	D#2	1.19828e-18
C772	CLK#3	VNB	3.14153e-17
C773	VGND	a_828_74##3	2.16987e-20
C774	SCD#1	VNB	3.39048e-17
C775	SCE#6	VNB	2.20749e-17
C776	D#3	VNB	2.98669e-17
C777	a_35_74#	VNB	3.56439e-17
C778	VGND	a_630_74##5	3.84163e-19
C779	SCE#4	VNB	2.79977e-17
C780	a_630_74##14	VGND#13	5.70161e-17
C781	a_1736_74##8	VNB	4.29112e-17
C782	a_1520_74##3	VNB	3.60248e-17
C783	a_1736_74#	VNB	5.41531e-17
C784	a_828_74##8	VNB	3.02953e-17
C785	VGND	SCE#7	7.10524e-18
C786	a_630_74##14	a_630_74##8	9.13302e-18
C787	a_630_74##11	VNB	3.11083e-17
C788	a_1018_100##3	VNB	3.28231e-17
C789	VGND	a_35_74##4	3.81762e-18
C790	VPWR#12	a_301_74##2	1.93882e-18
C791	a_1239_74##3	VNB	5.34167e-17
C792	a_630_74#	VNB	2.64191e-17
C793	VGND	D#2	1.31109e-18
C794	a_828_74#	VNB	2.13463e-17
C795	a_630_74##7	VNB	3.49784e-17
C796	CLK#1	VNB	4.19933e-17
C797	SCD#3	VNB	2.90103e-17
C798	VGND	SCE#3	5.2385e-18
C799	a_35_74##3	VNB	2.26501e-17
C800	VGND#6	a_630_74##3	3.83101e-20
C801	D#1	VNB	2.88997e-17
C802	SCE#1	VNB	3.77491e-17
C803	SCE#5	VNB	2.85333e-17
C804	VPWR#3	VNB	2.73305e-16
C805	VGND#3	VNB	2.94368e-16
C806	VPWR#10	VNB	1.41659e-17
C807	a_1520_74##5	a_630_74##9	7.84384e-20
C808	VGND#7	VNB	1.4622e-17
C809	a_1736_74##7	VNB	4.75676e-17
C810	a_35_74##6	SCD#2	5.39441e-20
C811	VGND#6	a_630_74##6	3.128e-18
C812	a_1520_74##2	VNB	5.42596e-17
C813	VGND#13	CLK#3	2.37442e-18
C814	a_1736_74##4	VNB	4.82891e-18
C815	a_828_74##7	VNB	6.73494e-17
C816	a_630_74##10	VNB	6.67982e-17
C817	a_828_74##6	VNB	3.6035e-17
C818	a_301_74##2	a_630_74#	1.67629e-19
C819	VPWR#12	VPWR#9	8.99105e-18
C820	a_1018_100##2	VNB	6.41286e-17
C821	a_1239_74#	VNB	5.71101e-17
C822	a_630_74##2	VNB	6.212e-17
C823	a_828_74##3	VNB	2.88216e-17
C824	a_828_74##2	VNB	4.91074e-17
C825	D#2	a_301_74##3	1.43672e-18
C826	a_630_74##12	CLK#2	3.72929e-18
C827	a_630_74##5	VNB	3.61626e-17
C828	SCD#2	VNB	7.23282e-17
C829	SCE#7	VNB	3.48812e-17
C830	SCE	D	2.61739e-17
C831	a_35_74##4	VNB	5.45156e-17
C832	a_828_74##8	a_1736_74#	4.14029e-17
C833	D#2	VNB	5.83304e-17
C834	a_630_74##10	a_1520_74##6	6.8267e-17
C835	a_35_74##2	VNB	4.83983e-17
C836	SCE#3	VNB	8.08932e-17
C837	VGND#14	a_630_74##8	2.00598e-19
C838	VPWR	D	1.53674e-18
C839	VGND	SCD	2.69864e-18
C840	VPWR	CLK	1.70824e-18
C841	VGND	D	1.47511e-18
C842	VGND	CLK	1.8507e-18
C843	VGND	SCE	1.24754e-17
C844	VGND#14	VGND#13	8.6834e-19
C845	SCD	VNB	2.31327e-18
C846	D	VNB	6.27646e-19
C847	a_630_74##10	a_1239_74##7	9.11542e-17
C848	VGND#3	a_1736_74##5	1.07614e-17
C849	CLK	VNB	1.97684e-18
C850	a_630_74##14	CLK#3	4.83581e-17
C851	SCE	VNB	3.65538e-18
C852	Q	VNB	1.11855e-16
C853	VPWR	VNB	2.95918e-16
C854	a_828_74##2	a_630_74##4	1.13969e-19
C855	VGND	VNB	3.02367e-16
C856	a_301_74##5	a_828_74##2	2.31464e-17
C857	VGND#8	a_630_74##8	6.10242e-19
C858	VGND#9	SCE#1	9.80773e-20
C859	VPWR#13	SCE#1	4.05997e-18
C860	Q	VPWR#2	2.11441e-17
C861	VPWR#2	a_1736_74#	4.73838e-20
C862	VGND#9	D#3	5.10142e-18
C863	VGND#2	VNB	5.00262e-17
C864	VGND#2	a_1520_74#	1.31573e-18
C865	a_1736_74##10	VPWR#2	3.3799e-19
C866	a_35_74##6	VPWR#13	1.29906e-18
C867	VGND#9	SCE#6	1.30294e-19
C868	VGND#9	SCE#3	1.81025e-18
C869	VGND#2	a_1736_74##5	7.87353e-18
C870	VPWR#13	SCE#2	5.45939e-19
C871	VPWR#2	a_1520_74##3	8.51551e-19
C872	VGND#9	VNB	6.88228e-17
C873	VPWR	VPWR#13	1.19704e-16
C874	VGND#2	Q	1.96159e-17
C875	VGND#9	a_301_74##6	1.44917e-17
C876	VPWR#13	D#1	7.55692e-18
C877	VGND#9	SCD#1	2.6551e-20
C878	a_1736_74##9	VPWR#2	8.45657e-18
C879	VPWR#2	VNB	4.91811e-17
C880	VPWR#13	D#2	1.80397e-19
C881	VGND#9	a_35_74##6	7.84264e-20
C882	VPWR#2	a_1736_74##8	7.75046e-18
C883	VGND#9	CLK#3	1.62664e-20
C884	VGND#9	D#2	6.27157e-20
C885	VGND	VGND#9	1.20442e-16
C886	VGND#9	SCE#2	5.80955e-20
C887	VPWR#3	VPWR#2	9.61786e-17
C888	VPWR#13	VNB	6.75628e-17
C889	a_301_74##4	VPWR#13	1.356e-17
C890	a_35_74##4	VPWR#13	1.14755e-18
C891	VGND#2	a_1736_74##12	8.54239e-18
C892	VGND#2	a_1736_74##7	1.75358e-19
C893	VPWR#13	SCE#5	2.55179e-18
C894	VGND#9	SCE	6.0526e-18
C895	VGND#2	a_1736_74##10	3.02819e-19
C896	VGND#9	SCE#4	6.41865e-18
C897	VPWR#2	a_1736_74##7	1.63423e-19
C898	a_35_74##9	VPWR#13	2.77916e-17
C899	VGND#3	VGND#2	9.65325e-17
C900	VGND#9	a_35_74##8	2.05884e-17
C901	VGND#9	a_35_74#	8.08081e-18
C902	VPWR#13	VPWR#11	2.09836e-19
*
*
.ENDS sky130_fd_sc_hs__sdfxtp_1
*
