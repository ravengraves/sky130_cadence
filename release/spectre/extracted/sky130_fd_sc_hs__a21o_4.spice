* Extracted by Quantus, converted by sky130cad/quantus.py
*
*
*
*                       LINUX           Wed Nov 18 08:05:50 2026
*
*
*
*  PROGRAM  advgen
*
*  Name           : advgen - Quantus - (64-bit)
*  Version        : 25.1.0-p047
*  Build Date     : Thu Dec 11 23:20:30 PST 2025
*
*  HSPICE LIBRARY
*
*  OPERATING_TEMPERATURE 150
*  QRC_TECH_DIR <path>/tech
*
*
*

*
.SUBCKT sky130_fd_sc_hs__a21o_4 VPB VNB VGND VPWR X A2 B1 A1
*
*
*  caps2d version: 10
*
*
*       TRANSISTOR CARDS
*
*
XM12 X#5 a_91_48##10 VGND#6 VNB sky130_fd_pr__nfet_01v8_lvt l=0.15 w=0.74 ad=0.2072 as=0.2109 pd=2.04 ps=2.05
XM9 X#5 a_91_48##7 VGND#10 VNB sky130_fd_pr__nfet_01v8_lvt l=0.15 w=0.74 ad=0.2072 as=0.2072 pd=2.04 ps=2.04
XM10 VGND#10 a_91_48##5 X#6 VNB sky130_fd_pr__nfet_01v8_lvt l=0.15 w=0.74 ad=0.2072 as=0.2072 pd=2.04 ps=2.04
XM14 VGND#9 a_91_48##4 X#6 VNB sky130_fd_pr__nfet_01v8_lvt l=0.15 w=0.74 ad=0.2441 as=0.2072 pd=2.16 ps=2.04
XM19 VGND#9 B1#6 a_91_48##18 VNB sky130_fd_pr__nfet_01v8_lvt l=0.15 w=0.64 ad=0.2441 as=0.1792 pd=2.16 ps=1.84
XM2 a_91_48##18 B1#5 VGND#8 VNB sky130_fd_pr__nfet_01v8_lvt l=0.15 w=0.64 ad=0.1792 as=0.1696 pd=1.84 ps=1.81
XM7 a_91_48##13 A1#6 a_700_74##4 VNB sky130_fd_pr__nfet_01v8_lvt l=0.15 w=0.64 ad=0.1792 as=0.1696 pd=1.84 ps=1.81
XM11 a_700_74##2 A1#1 a_91_48##13 VNB sky130_fd_pr__nfet_01v8_lvt l=0.15 w=0.64 ad=0.1792 as=0.1792 pd=1.84 ps=1.84
XM13 a_700_74##2 A2#5 VGND#7 VNB sky130_fd_pr__nfet_01v8_lvt l=0.15 w=0.64 ad=0.1792 as=0.1792 pd=1.84 ps=1.84
XM4 VGND#7 A2#1 a_700_74# VNB sky130_fd_pr__nfet_01v8_lvt l=0.15 w=0.64 ad=0.1792 as=0.1696 pd=1.84 ps=1.81
XM0 VPWR#7 a_91_48##12 X#3 VPB sky130_fd_pr__pfet_01v8 l=0.15 w=1.12 ad=0.308 as=0.336 pd=2.79 ps=2.84
XM16 X#3 a_91_48##11 VPWR#11 VPB sky130_fd_pr__pfet_01v8 l=0.15 w=1.12 ad=0.336 as=0.336 pd=2.84 ps=2.84
XM18 X#1 a_91_48##8 VPWR#11 VPB sky130_fd_pr__pfet_01v8 l=0.15 w=1.12 ad=0.336 as=0.336 pd=2.84 ps=2.84
XM5 VPWR#10 a_91_48# X#1 VPB sky130_fd_pr__pfet_01v8 l=0.15 w=1.12 ad=0.308 as=0.336 pd=2.79 ps=2.84
XM1 a_503_392##5 B1#4 a_91_48##17 VPB sky130_fd_pr__pfet_01v8 l=0.15 w=1 ad=0.275 as=0.3 pd=2.55 ps=2.6
XM15 a_91_48##17 B1#1 a_503_392##3 VPB sky130_fd_pr__pfet_01v8 l=0.15 w=1 ad=0.3 as=0.3 pd=2.6 ps=2.6
XM3 a_503_392##3 A1#4 VPWR#9 VPB sky130_fd_pr__pfet_01v8 l=0.15 w=1 ad=0.3 as=0.3 pd=2.6 ps=2.6
XM17 VPWR#9 A1#5 a_503_392##6 VPB sky130_fd_pr__pfet_01v8 l=0.15 w=1 ad=0.3 as=0.3 pd=2.6 ps=2.6
XM8 VPWR#8 A2#6 a_503_392##6 VPB sky130_fd_pr__pfet_01v8 l=0.15 w=1 ad=0.3 as=0.3 pd=2.6 ps=2.6
XM6 a_503_392# A2#4 VPWR#8 VPB sky130_fd_pr__pfet_01v8 l=0.15 w=1 ad=0.275 as=0.3 pd=2.55 ps=2.6
*
*
*       RESISTOR AND CAP/DIODE CARDS
*
Rg1	a_91_48#	a_91_48##2	478.122101
Rg2	a_91_48##2	a_91_48##3	90.016602
Rg3	a_91_48##2	a_91_48##4	398.296814
Rg4	a_91_48##3	a_91_48##5	375.516602
Rg5	a_91_48##3	a_91_48##6	57.428749
Rg6	a_91_48##6	a_91_48##7	366.801178
Rg7	a_91_48##3	a_91_48##8	451.334412
Rg8	a_91_48##6	a_91_48##9	66.386436
Rg9	a_91_48##9	a_91_48##10	368.862610
Rg10	a_91_48##6	a_91_48##11	470.810913
Rg11	a_91_48##9	a_91_48##12	471.862823
Rg12	B1#1	B1#2	483.939453
Rg13	B1#2	B1#3	44.136082
Rg14	B1#2	B1#4	400.668427
Rg15	B1#3	B1#5	406.798431
Rg16	B1#3	B1#6	454.803741
Rg17	A1#1	A1#2	487.133331
Rg18	A1#2	A1#3	71.444176
Rg19	A1#3	A1#4	426.054413
Rg20	A1#2	A1#5	425.023010
Rg21	A1#3	A1#6	509.267059
Rg22	A2#1	A2#2	374.601257
Rg23	A2#2	A2#3	56.190357
Rg24	A2#2	A2#4	507.445770
Rg25	A2#3	A2#5	378.102448
Rg26	A2#3	A2#6	505.638885
Rf1	X#1	X#2	84.135681
Rf2	X#2	X	45.856140
Rf3	X#2	X#3	37.494125
Rf4	X	X#4	45.451653
Rf5	X#4	X#5	24.653522
Rf6	X#4	X#6	77.755951
Rf7	B1#3	B1#8	161.176208
Rf8	B1#9	B1	0.943401
Rf9	B1#8	B1#9	2.558873
Rf10	A1	A1#7	9.448145
Rf11	A1#7	A1	9.448145
Rf12	a_91_48##13	a_91_48##14	103.448738
Rf13	a_91_48##14	a_91_48##15	43.962425
Rf14	a_91_48##15	a_91_48##3	101.713455
Rf15	a_91_48##14	a_91_48##17	49.545258
Rf16	a_91_48##15	a_91_48##18	23.131947
Rf17	A2#7	A2#3	162.522263
Rf18	A2	A2#9	2.289460
Rf19	A2#7	A2#9	6.873179
Rf20	a_503_392#	a_503_392##2	92.659187
Rf21	a_503_392##2	a_503_392##4	89.504387
Rf22	a_503_392##4	a_503_392##5	128.767700
Rf23	a_503_392##2	a_503_392##6	22.678455
Rf24	a_503_392##3	a_503_392##4	5.000000
Rf25	a_700_74#	a_700_74##3	101.969528
Rf26	a_700_74##3	a_700_74##4	98.167801
Rf27	a_700_74##2	a_700_74##3	7.500000
Rf29	VGND#2	VGND#3	150.386444
Rf30	VGND#3	VGND#4	65.339958
Rf31	VGND#4	VGND#5	62.889057
Rf32	VGND#5	VGND#6	94.446609
Rf33	VGND#2	VGND#7	34.704330
Rf34	VGND#3	VGND#8	45.091507
Rf35	VGND#4	VGND#9	46.748199
Rf36	VGND#5	VGND#10	42.655182
Rf38	VPWR#2	VPWR#3	68.675751
Rf39	VPWR#3	VPWR#4	78.196846
Rf40	VPWR#4	VPWR#5	52.629173
Rf41	VPWR#5	VPWR#6	71.655113
Rf42	VPWR#6	VPWR#7	97.198662
Rf43	VPWR#2	VPWR#8	31.534731
Rf44	VPWR#3	VPWR#9	38.736572
Rf45	VPWR#5	VPWR#10	44.934231
Rf46	VPWR#6	VPWR#11	42.573776
Rf48	A1#3	A1#7	160.232803
Re1	VPWR#4	VPWR	0.818510
Re2	VGND	VGND#3	0.818540
*
*       CAPACITOR CARDS
*
*
C1	a_700_74##2	a_700_74#	2.27239e-18
C2	a_91_48##15	a_91_48##9	6.62114e-20
C3	a_91_48##17	A1#2	1.57755e-19
C4	a_503_392##2	VPWR#8	2.87786e-17
C5	a_91_48##14	A1#2	8.36591e-20
C6	a_700_74##2	VGND#7	5.64036e-17
C7	X#1	VPWR#6	8.78682e-18
C8	a_91_48##15	a_91_48##6	2.70061e-19
C9	a_503_392##2	a_503_392##6	7.6557e-19
C10	X#1	VPWR#5	8.44616e-18
C11	a_91_48##15	a_91_48##2	1.6766e-17
C12	a_700_74##2	a_91_48##13	5.17549e-17
C13	a_503_392##2	VPWR#9	2.22994e-17
C14	a_700_74##4	a_700_74##2	2.67476e-18
C15	X#3	VPWR#6	1.0518e-17
C16	a_503_392##3	a_503_392##2	1.46438e-18
C17	a_700_74##4	a_91_48##13	6.05877e-17
C18	a_91_48##14	a_91_48##2	1.44681e-18
C19	X#4	VGND#10	1.69292e-17
C20	VPWR#7	VPWR#6	1.41623e-19
C21	VPWR#6	VPWR#5	7.06045e-19
C22	X#4	X#5	5.7327e-19
C23	VGND#8	a_700_74##4	3.23175e-17
C24	a_91_48##18	a_91_48##13	1.40966e-18
C25	X#4	VGND#6	4.6751e-18
C26	a_91_48##18	a_700_74##4	2.12536e-18
C27	VPWR#5	VPWR#3	2.05843e-19
C28	a_91_48##18	VGND#8	4.11333e-17
C29	a_91_48##14	a_503_392##3	2.70056e-18
C30	VGND#9	VGND#8	2.43124e-18
C31	a_91_48##9	a_91_48##6	4.29707e-18
C32	a_700_74#	a_503_392#	1.24235e-17
C33	a_91_48##15	a_503_392##5	1.06421e-19
C34	VGND#9	a_91_48##18	3.14562e-17
C35	X#1	a_91_48##6	1.48808e-18
C36	a_91_48##14	a_503_392##5	6.09695e-19
C37	X#1	a_91_48##2	1.4516e-18
C38	X#6	a_91_48##18	4.22964e-18
C39	a_91_48##15	VPWR#10	1.67724e-17
C40	X#6	VGND#9	5.13947e-17
C41	a_91_48##15	X#1	5.99917e-18
C42	B1#8	a_91_48##17	1.06177e-18
C43	VPWR#11	a_91_48##6	1.28599e-18
C44	X#6	VGND#10	4.26648e-17
C45	VGND#4	A1#6	7.83347e-20
C46	X#5	X#6	2.61235e-18
C47	a_91_48##6	a_91_48##2	4.34915e-18
C48	B1#8	a_91_48##2	1.01828e-18
C49	X#5	VGND#10	3.54348e-17
C50	VGND#4	B1#5	5.59762e-19
C51	X#4	a_91_48##9	1.97713e-18
C52	VGND#6	VGND#10	1.15684e-18
C53	X#4	a_91_48##6	2.68864e-18
C54	VGND#4	B1#6	6.43545e-18
C55	X#2	X#1	2.52173e-18
C56	VGND#6	X#5	3.76784e-17
C57	VGND#5	a_91_48##4	5.31921e-19
C58	a_700_74#	A2#2	1.23772e-18
C59	A2#3	A2#2	9.21408e-18
C60	VGND#4	a_91_48##4	9.10412e-18
C61	X#2	VPWR#11	2.26688e-17
C62	X#2	a_91_48##9	1.4791e-18
C63	A1#2	A2#3	3.37049e-17
C64	VGND#5	VGND#4	1.73975e-18
C65	VGND#5	a_91_48##5	5.83518e-18
C66	X#2	X#3	5.63436e-18
C67	X#2	a_91_48##6	3.86308e-18
C68	VGND#4	a_91_48##5	9.34807e-19
C69	VGND#5	a_91_48##7	5.56548e-18
C70	X#2	VPWR#7	4.76928e-18
C71	a_503_392#	VPWR#8	5.63454e-17
C72	VGND#7	A2#2	2.2725e-19
C73	VGND#4	a_91_48##7	3.0519e-19
C74	A1#3	A1#2	8.83876e-18
C75	a_503_392##6	a_503_392#	8.66244e-19
C76	a_91_48##15	B1#5	1.08547e-17
C77	VGND#5	a_91_48##10	2.07516e-18
C78	a_503_392##2	VPWR#3	3.13618e-19
C79	a_700_74#	A2#1	3.74092e-17
C80	a_91_48##14	B1#5	8.71133e-18
C81	VPWR#6	a_91_48##9	4.57114e-20
C82	a_503_392##6	VPWR#8	5.15009e-17
C83	a_91_48##15	B1#6	1.7234e-17
C84	VGND#7	A2#1	2.66885e-17
C85	a_700_74#	A2#5	8.56418e-19
C86	VPWR#9	VPWR#8	2.35578e-18
C87	a_91_48##14	B1#6	1.82074e-19
C88	a_700_74##2	A2#1	8.17166e-19
C89	VPWR#6	a_91_48##6	9.4253e-20
C90	VGND#7	A2#5	2.46631e-17
C91	a_91_48##15	a_91_48##4	2.82487e-18
C92	VPWR#9	a_503_392##6	5.06135e-17
C93	a_91_48##13	A2#1	3.34151e-19
C94	a_700_74#	A1#1	1.89459e-19
C95	VPWR#3	A2#6	5.16438e-19
C96	a_700_74##2	A2#5	2.3507e-17
C97	a_503_392##3	a_503_392##6	9.60252e-19
C98	VGND#7	A1#1	9.76907e-19
C99	a_91_48##2	B1#3	2.40175e-17
C100	a_91_48##15	a_91_48##5	2.38873e-19
C101	a_91_48##13	A2#5	1.35449e-18
C102	a_700_74##2	A1#1	3.33977e-17
C103	a_503_392##3	VPWR#9	5.74942e-17
C104	a_700_74##4	A2#5	2.16679e-19
C105	VPWR#3	A1#5	5.32351e-18
C106	VGND#7	A1#6	1.36676e-20
C107	a_91_48##13	A1#1	3.22277e-17
C108	a_91_48##15	a_91_48##7	1.81005e-20
C109	a_91_48##13	A2#2	5.18652e-19
C110	a_700_74##2	A1#6	6.42939e-19
C111	a_700_74##4	A1#1	1.23819e-18
C112	VPWR#5	A1#4	2.46852e-20
C113	a_91_48##13	A1#6	2.54953e-17
C114	a_91_48##3	a_91_48##9	8.47436e-18
C115	a_91_48##17	a_503_392##3	6.09629e-17
C116	VPWR#3	A1#4	7.59032e-18
C117	a_91_48##13	A1#2	8.81869e-18
C118	a_503_392##2	A2#4	4.94446e-19
C119	a_91_48##3	a_91_48##6	3.43607e-17
C120	a_91_48##15	a_91_48##10	1.36318e-20
C121	a_91_48##15	VPWR#5	3.2636e-19
C122	a_91_48##3	a_91_48##2	3.26681e-18
C123	a_700_74##4	A1#6	5.43082e-17
C124	VPWR#5	a_91_48##2	4.25241e-20
C125	a_503_392##5	a_503_392##3	2.14025e-18
C126	a_91_48##18	A1#1	1.3092e-19
C127	a_91_48##13	B1#5	4.2442e-19
C128	VPWR#5	B1#1	8.76356e-20
C129	VGND#8	A1#6	2.30479e-18
C130	VPWR#3	B1#1	3.91024e-19
C131	a_503_392##2	A2#6	1.53812e-17
C132	a_700_74##4	B1#5	3.03097e-18
C133	a_503_392##5	a_91_48##17	9.17234e-17
C134	a_91_48##18	A1#6	4.5173e-19
C135	a_91_48##13	B1#6	1.30782e-19
C136	VPWR#6	B1#4	1.98622e-20
C137	VGND#8	B1#5	4.37576e-17
C138	X#4	a_91_48##7	1.69418e-17
C139	VPWR#5	B1#4	9.61117e-19
C140	a_700_74##4	B1#6	1.59029e-19
C141	a_503_392##2	A1#5	2.18508e-17
C142	B1#5	a_91_48##18	1.19724e-17
C143	VPWR#3	B1#4	1.04129e-19
C144	a_700_74##4	A1#2	2.56499e-19
C145	VPWR#10	a_503_392##5	9.09617e-17
C146	VGND#8	B1#6	1.96615e-18
C147	X#1	a_91_48##17	4.62666e-18
C148	VGND#9	B1#5	6.07483e-19
C149	X#4	a_91_48##10	2.11872e-17
C150	VPWR#6	a_91_48#	5.23024e-19
C151	a_700_74##4	a_91_48##4	1.08319e-19
C152	a_91_48##18	B1#6	3.10843e-17
C153	VPWR#5	a_91_48#	7.87558e-18
C154	a_503_392##2	A1#4	4.91161e-18
C155	VGND#8	a_91_48##4	2.37442e-19
C156	VPWR#3	a_91_48#	3.36696e-20
C157	B1#6	VGND#9	1.35742e-17
C158	X#1	VPWR#10	7.78741e-17
C159	a_91_48##18	a_91_48##4	3.11905e-18
C160	X#6	B1#6	7.43693e-19
C161	VPWR#6	a_91_48##8	7.54858e-18
C162	VGND#9	a_91_48##4	3.00233e-17
C163	a_503_392##2	B1#1	1.19793e-19
C164	VPWR#5	a_91_48##8	5.45681e-19
C165	VPWR#11	VPWR#10	2.00319e-18
C166	a_91_48##18	a_91_48##5	2.80037e-19
C167	X#6	a_91_48##4	1.32128e-17
C168	X#1	VPWR#11	6.43447e-17
C169	VGND#9	a_91_48##5	1.02223e-18
C170	VGND#4	a_91_48##15	6.42285e-19
C171	VGND#10	a_91_48##4	1.52743e-19
C172	VPWR#6	a_91_48##11	4.89538e-18
C173	X#6	a_91_48##5	4.79377e-17
C174	VPWR#5	a_91_48##11	8.74044e-20
C175	a_91_48##5	VGND#10	1.42294e-17
C176	X#3	VPWR#11	6.00153e-17
C177	X#6	a_91_48##7	1.37094e-18
C178	a_91_48##2	B1#6	5.38555e-18
C179	a_91_48##14	B1#1	9.53458e-18
C180	X#5	a_91_48##5	7.44334e-19
C181	VPWR#6	a_91_48##12	6.52765e-19
C182	VGND#10	a_91_48##7	2.7334e-17
C183	VPWR#7	VPWR#11	2.66815e-18
C184	X#6	a_91_48##10	2.06596e-19
C185	VGND#5	a_91_48##9	6.18967e-20
C186	a_91_48##7	X#5	1.4553e-17
C187	VPWR#7	X#3	6.10219e-17
C188	VGND#10	a_91_48##10	1.13802e-18
C189	VGND#6	a_91_48##7	2.26025e-18
C190	X#2	VPWR#6	2.5317e-19
C191	a_91_48##10	X#5	1.90029e-17
C192	VGND#5	a_91_48##6	5.50119e-20
C193	VGND#6	a_91_48##10	3.10639e-17
C194	VPWR#4	VPWR#6	4.13877e-17
C195	VPWR#4	VPWR#5	3.48676e-17
C196	VPWR#4	VPWR#3	4.02843e-17
C197	A2#5	A2#1	3.57361e-17
C198	a_503_392#	A2#4	3.73769e-17
C199	VGND#4	a_91_48##6	6.02662e-20
C200	VPWR#8	A2#4	4.47943e-17
C201	A1#1	A2#5	3.6554e-17
C202	a_503_392#	A2#6	7.88066e-19
C203	A1	A1#2	1.1064e-17
C204	a_503_392##6	A2#4	3.24227e-19
C205	VGND#5	X#4	5.56889e-19
C206	X#2	a_91_48##8	7.16684e-19
C207	VGND#3	VGND#5	4.06202e-17
C208	VPWR#8	A2#6	4.36494e-17
C209	VGND#3	VGND#4	3.88337e-17
C210	a_503_392#	A1#5	1.8144e-19
C211	A1#6	A1#1	3.87342e-17
C212	VGND#4	a_91_48##2	8.2529e-21
C213	A2#6	a_503_392##6	1.48632e-17
C214	VPWR#8	A1#5	2.79067e-18
C215	X#2	a_91_48##11	1.4749e-17
C216	VPWR#9	A2#6	3.62753e-19
C217	a_91_48##17	A2#4	5.47466e-19
C218	a_91_48##2	VGND#9	8.65042e-19
C219	a_503_392##6	A1#5	4.1091e-17
C220	B1#5	A1#6	3.80583e-18
C221	VPWR#8	A1#4	3.06214e-19
C222	A1#5	VPWR#9	1.94502e-17
C223	a_91_48##17	A2#6	6.06964e-19
C224	X#2	a_91_48##12	1.97582e-17
C225	a_503_392##6	A1#4	1.40391e-18
C226	a_503_392##3	A1#5	3.66711e-19
C227	VPWR#9	A1#4	3.95853e-17
C228	B1	a_91_48##9	1.12935e-19
C229	a_91_48##17	A1#5	4.89585e-19
C230	B1	a_91_48##6	3.28261e-19
C231	B1#6	B1#5	3.80132e-17
C232	a_91_48##4	A1#6	1.05392e-19
C233	B1	a_91_48##2	8.75587e-19
C234	a_503_392##2	A2#3	1.71708e-18
C235	a_503_392##6	B1#1	7.85528e-20
C236	a_503_392##3	A1#4	5.10636e-17
C237	X#6	a_91_48##6	3.45884e-18
C238	VPWR#5	B1#3	3.04614e-19
C239	VGND#3	a_91_48##15	5.31334e-19
C240	a_91_48##14	A2#7	1.49702e-18
C241	VPWR#9	B1#1	1.3398e-18
C242	VGND#3	a_91_48##14	2.62282e-18
C243	a_91_48##17	A1#4	2.31524e-18
C244	A2#7	A2#3	2.06894e-17
C245	a_503_392##3	B1#1	2.66522e-17
C246	a_503_392##5	A1#4	1.83236e-19
C247	X#6	a_91_48##2	2.63618e-19
C248	a_91_48##4	B1#6	2.90134e-17
C249	A1#3	a_503_392##2	9.08092e-18
C250	a_91_48##17	B1#1	4.99993e-17
C251	VGND#4	B1#3	4.02965e-21
C252	a_503_392##3	B1#4	3.79489e-19
C253	a_503_392##5	B1#1	5.76827e-18
C254	A2#7	A1#3	3.48391e-19
C255	a_91_48##17	B1#4	4.20175e-17
C256	A2	A2#2	2.75094e-18
C257	A2	A1#2	5.90503e-18
C258	a_91_48##5	a_91_48##4	3.92369e-17
C259	a_503_392##3	a_91_48#	5.97228e-20
C260	a_503_392##5	B1#4	4.06682e-17
C261	a_91_48##15	A1#3	8.29077e-20
C262	VGND#4	a_91_48##3	3.87015e-19
C263	a_91_48##15	a_91_48##14	4.31204e-18
C264	VGND#10	a_91_48##6	8.45877e-19
C265	a_91_48##14	A1#3	3.03626e-18
C266	VGND#3	VGND#7	2.54119e-20
C267	a_91_48##17	a_91_48#	4.53017e-19
C268	VPWR#10	B1#4	1.7682e-18
C269	a_503_392##5	a_91_48#	1.86076e-18
C270	A2#7	B1#3	9.09478e-20
C271	X#1	B1#4	7.42139e-19
C272	a_91_48##7	a_91_48##5	3.62226e-17
C273	a_700_74#	A2#3	1.01995e-18
C274	a_91_48#	VPWR#10	3.96828e-17
C275	VPWR#11	B1#4	6.46576e-20
C276	VGND#3	a_700_74##4	4.20092e-17
C277	a_91_48##15	B1#3	1.32471e-17
C278	VGND#7	A2#3	5.68058e-19
C279	a_91_48##14	B1#3	1.33797e-17
C280	X#1	a_91_48#	6.77309e-17
C281	a_700_74##2	A2#3	1.30017e-18
C282	VGND#3	a_91_48##18	6.21557e-18
C283	VPWR#10	a_91_48##8	3.71489e-19
C284	VPWR#11	a_91_48#	6.46452e-19
C285	a_91_48##10	a_91_48##7	4.00771e-17
C286	a_91_48##13	A2#3	2.68974e-18
C287	a_503_392##2	A2#2	3.10698e-19
C288	X#1	a_91_48##8	6.65551e-17
C289	B1#8	B1#3	1.23706e-17
C290	VPWR#10	a_91_48##11	1.72497e-19
C291	a_91_48##8	VPWR#11	2.09722e-17
C292	X	a_91_48##9	1.74955e-17
C293	X	a_91_48##6	7.87354e-19
C294	X	a_91_48##2	1.29392e-19
C295	a_91_48##13	A1#3	2.3303e-17
C296	X#1	a_91_48##11	2.04001e-18
C297	a_700_74##4	A1#3	4.74732e-19
C298	VGND#3	VGND#6	2.61962e-17
C299	a_700_74#	a_503_392##2	1.81655e-18
C300	VPWR#11	a_91_48##11	4.59325e-17
C301	a_503_392##2	A1#2	1.06193e-18
C302	a_91_48##11	X#3	1.98046e-17
C303	X#1	a_91_48##12	2.11095e-19
C304	X#4	a_91_48##3	4.95416e-17
C305	a_503_392##3	VPWR#4	8.31343e-18
C306	a_91_48##3	X#2	5.90522e-17
C307	VPWR#11	a_91_48##12	2.21038e-18
C308	VPWR#7	a_91_48##11	2.87913e-18
C309	a_91_48##12	X#3	2.69964e-17
C310	VGND#8	B1#3	1.65589e-18
C311	a_503_392##5	VPWR#4	5.10432e-17
C312	VPWR#8	A2#3	8.25712e-19
C313	VPWR#7	a_91_48##12	4.93178e-17
C314	VGND#4	VGND#8	2.86762e-19
C315	A2#6	A2#4	4.70379e-17
C316	a_91_48##15	B1#8	4.64175e-17
C317	VPWR	a_91_48##6	4.70016e-21
C318	A1#2	A2#6	5.32418e-18
C319	a_700_74##2	a_503_392##2	4.87009e-18
C320	A1#5	A2#6	4.25455e-17
C321	A1#3	VPWR#9	4.10982e-19
C322	VGND#4	a_91_48##18	2.24177e-18
C323	a_91_48##3	X#6	4.61559e-17
C324	VPWR#4	VPWR#7	2.92371e-17
C325	B1#8	a_91_48##14	1.74343e-17
C326	a_91_48##3	VGND#10	2.68727e-18
C327	A1#3	a_503_392##3	4.61507e-18
C328	a_91_48##3	X#5	2.51339e-18
C329	a_91_48##17	A1#3	1.78136e-18
C330	A1#4	A1#5	4.27338e-17
C331	a_91_48##13	a_503_392##2	1.05764e-18
C332	a_91_48##17	B1#3	1.07207e-17
C333	VGND#3	A2#5	2.19974e-20
C334	B1#3	a_503_392##5	7.08464e-18
C335	B1	VPWR#5	6.98548e-19
C336	A1	a_503_392##2	2.96182e-17
C337	VGND#3	A1#1	6.33908e-20
C338	B1#1	A1#4	4.25173e-17
C339	VPWR#8	A2#2	6.35163e-20
C340	VPWR#10	B1#3	4.21975e-18
C341	VGND#5	X#6	5.68531e-18
C342	VGND#3	A1#6	5.55075e-18
C343	A1	A2#7	7.54624e-18
C344	X#1	B1#3	2.65138e-19
C345	VGND	a_91_48##9	4.97058e-20
C346	VGND	a_91_48##6	1.34022e-19
C347	VGND#3	B1#5	2.13376e-18
C348	VGND	a_91_48##2	4.89694e-20
C349	A1#1	A2#3	5.04474e-18
C350	B1#4	B1#1	4.23507e-17
C351	a_91_48##14	A1	3.61871e-17
C352	VGND#4	X#6	8.95158e-18
C353	a_91_48##3	X#1	4.19292e-17
C354	VGND#3	a_91_48##4	9.66138e-19
C355	a_700_74##2	A2#7	4.19113e-17
C356	a_91_48##3	VPWR#11	2.68727e-18
C357	a_91_48##3	X#3	2.35532e-18
C358	a_91_48#	B1#4	6.69724e-18
C359	B1#5	A1#3	1.95926e-19
C360	a_91_48##13	A1	2.64462e-17
C361	a_91_48##8	a_91_48#	4.70064e-17
C362	a_91_48##13	A2#7	4.68065e-18
C363	VGND#10	VGND#4	9.84487e-19
C364	A2	a_503_392##2	5.67797e-17
C365	B1#6	B1#3	1.78016e-18
C366	VGND#5	X#5	1.04945e-17
C367	A2#2	VNB	5.05519e-17
C368	A1#2	VNB	3.44927e-17
C369	a_91_48##11	a_91_48##8	4.8161e-17
C370	a_91_48##9	VNB	3.70843e-17
C371	a_91_48##6	VNB	6.63177e-17
C372	a_91_48##2	VNB	2.30451e-17
C373	VPWR#4	B1#1	4.47986e-18
C374	VPWR#4	B1#4	4.4286e-18
C375	VGND#3	B1#1	3.13967e-19
C376	a_91_48##12	a_91_48##11	4.89221e-17
C377	A2#7	A1#2	5.51859e-18
C378	A1	VPWR#9	2.29209e-18
C379	VPWR	VPWR#6	3.92979e-17
C380	A1	a_503_392##3	2.42719e-17
C381	VPWR	VPWR#5	3.45771e-17
C382	X	a_91_48##15	9.62863e-19
C383	VGND#6	VGND#5	2.08327e-18
C384	VPWR	VPWR#3	3.96762e-17
C385	a_91_48##17	A1	1.23848e-17
C386	VPWR#3	VPWR#8	2.85251e-19
C387	B1#1	A1#3	2.44527e-17
C388	X#4	X	6.76796e-19
C389	VPWR	a_503_392##2	4.22952e-18
C390	B1#3	B1#1	1.69318e-18
C391	B1	a_91_48##17	1.95837e-17
C392	B1	a_503_392##5	2.79568e-17
C393	VPWR	a_91_48##15	3.58611e-18
C394	a_91_48#	B1#3	2.3366e-18
C395	a_503_392##6	VPWR#3	6.52276e-18
C396	VGND	VGND#5	3.76708e-17
C397	VGND	VGND#4	3.73433e-17
C398	VPWR	X#2	2.85265e-18
C399	X	VGND#6	2.96412e-17
C400	X#4	X#2	3.96782e-18
C401	VPWR#9	A1#2	3.74528e-19
C402	VGND	A2#7	3.94665e-18
C403	a_700_74##4	a_91_48##14	3.15135e-17
C404	VGND	a_91_48##15	5.03867e-18
C405	VGND	a_91_48##14	8.99774e-18
C406	VGND#3	A1#3	1.74552e-20
C407	VPWR#4	B1#3	5.59982e-20
C408	VGND	B1#8	2.21073e-18
C409	VGND#3	B1#3	6.00419e-20
C410	VGND	X#4	2.42113e-18
C411	VPWR#6	VNB	3.10208e-17
C412	VPWR	a_503_392#	1.51048e-17
C413	VPWR#5	VNB	2.69354e-17
C414	VGND	X#2	3.28807e-18
C415	VPWR#3	VNB	2.93948e-17
C416	A1	A2#6	5.14614e-19
C417	VGND	a_700_74#	1.57458e-17
C418	VPWR	VPWR#8	2.17625e-17
C419	VPWR	a_503_392##6	1.3707e-17
C420	VGND#5	VNB	3.1198e-17
C421	VGND	a_700_74##2	1.67329e-17
C422	X	VPWR#7	3.22592e-17
C423	VGND#4	VNB	2.92622e-17
C424	VGND	a_91_48##13	7.11311e-18
C425	VPWR	a_503_392##3	1.59775e-17
C426	VGND	a_700_74##4	2.39193e-17
C427	VPWR	a_91_48##17	8.1016e-18
C428	B1#3	A1#3	5.59178e-19
C429	VGND	a_91_48##18	1.22263e-17
C430	VPWR	a_503_392##5	2.63316e-17
C431	a_503_392##2	VNB	2.59631e-18
C432	A1	B1#1	1.01977e-17
C433	VGND	X#6	1.39616e-17
C434	A2#7	VNB	8.243e-18
C435	VPWR	X#1	1.75722e-17
C436	a_91_48##14	VGND#8	3.0209e-17
C437	VGND	X#5	1.08596e-17
C438	a_91_48##15	VNB	3.08947e-18
C439	a_91_48##14	VNB	1.40982e-17
C440	VGND	VGND#6	3.97618e-17
C441	VPWR	X#3	1.13023e-17
C442	VGND	a_503_392#	3.56509e-18
C443	VPWR	VPWR#7	4.38729e-17
C444	X	a_91_48##4	7.92869e-21
C445	A2	A2#4	1.99665e-18
C446	a_91_48##15	a_91_48##18	1.27376e-19
C447	B1#8	VNB	2.60206e-18
C448	X	a_91_48##5	1.30445e-20
C449	A2	A2#6	2.07416e-18
C450	X#4	VNB	7.0233e-19
C451	X#2	VNB	1.39309e-18
C452	X	a_91_48##7	5.67486e-20
C453	a_700_74#	VNB	4.65565e-17
C454	VGND#7	VNB	2.37559e-18
C455	X	a_91_48##10	2.15114e-19
C456	B1	a_91_48#	8.97153e-19
C457	a_700_74##2	VNB	5.58705e-18
C458	B1	a_91_48##8	4.84393e-19
C459	a_700_74##4	VNB	1.41996e-17
C460	VGND#8	VNB	6.12952e-18
C461	VGND	X#1	2.56911e-18
C462	a_91_48##18	VNB	2.50446e-18
C463	B1	a_91_48##11	2.94301e-19
C464	VGND#9	VNB	4.49876e-20
C465	X#6	VNB	2.46336e-18
C466	VGND#10	VNB	1.94671e-19
C467	B1	a_91_48##12	2.69504e-19
C468	X#5	VNB	4.81648e-18
C469	VGND	A2#1	1.48648e-18
C470	a_503_392##3	VPWR#3	2.13317e-17
C471	VGND#6	VNB	5.16035e-17
C472	VGND	A2#5	8.04723e-19
C473	a_503_392#	VNB	5.46251e-17
C474	VPWR#8	VNB	2.36977e-18
C475	VGND	A1#1	2.58117e-18
C476	a_503_392##6	VNB	2.24265e-18
C477	A1	A2#3	2.32899e-18
C478	VGND	A1#6	1.6506e-18
C479	VPWR#9	VNB	4.09278e-19
C480	VPWR	A2#4	1.97038e-18
C481	VGND	B1#5	4.11639e-18
C482	a_503_392##3	VNB	4.05342e-18
C483	VPWR	A2#6	1.00933e-18
C484	a_91_48##17	VNB	1.3053e-18
C485	VGND	B1#6	9.56279e-18
C486	X	a_91_48#	2.1481e-19
C487	A1	A1#3	9.43098e-18
C488	a_503_392##5	VNB	1.88663e-17
C489	VGND	a_91_48##4	3.42377e-19
C490	VPWR	A1#5	7.5391e-19
C491	VPWR#10	VNB	1.1607e-17
C492	X	a_91_48##8	3.94563e-19
C493	VGND	a_91_48##5	4.39991e-19
C494	X#1	VNB	2.67592e-18
C495	VPWR	A1#4	2.36051e-18
C496	a_91_48##15	VGND#9	2.32331e-17
C497	VPWR#11	VNB	4.09278e-19
C498	VGND	a_91_48##7	6.27544e-19
C499	X	a_91_48##11	6.75386e-19
C500	VPWR	B1#1	1.55736e-18
C501	X#3	VNB	4.65214e-18
C502	VGND	a_91_48##10	6.25836e-19
C503	VPWR#7	VNB	6.98245e-17
C504	X	a_91_48##12	3.38699e-18
C505	VPWR	B1#4	1.73435e-18
C506	A2#1	VNB	2.82322e-17
C507	A2#5	VNB	2.26692e-17
C508	VPWR	a_91_48#	2.52942e-18
C509	B1	B1#3	9.45397e-18
C510	A2	A2#3	9.08659e-18
C511	A1#1	VNB	3.26197e-17
C512	VPWR	a_91_48##8	3.11734e-19
C513	A1#6	VNB	3.59847e-17
C514	B1#5	VNB	3.23175e-17
C515	VPWR	a_91_48##11	1.18538e-18
C516	B1#6	VNB	3.18026e-17
C517	a_91_48##4	VNB	2.9046e-17
C518	VPWR	a_91_48##12	6.31608e-19
C519	a_91_48##5	VNB	2.63704e-17
C520	a_91_48##7	VNB	2.49628e-17
C521	a_91_48##10	VNB	3.46715e-17
C522	VPWR	VPWR#4	1.6098e-17
C523	A2#4	VNB	4.39052e-17
C524	X	B1#3	1.15524e-18
C525	A2#6	VNB	3.17538e-17
C526	A1#5	VNB	2.89169e-17
C527	X	a_91_48##3	2.25554e-17
C528	A1#4	VNB	2.85927e-17
C529	VPWR	A1#3	5.09191e-19
C530	B1#1	VNB	5.33942e-17
C531	B1#4	VNB	3.60441e-17
C532	VPWR	B1#3	1.49738e-18
C533	a_91_48#	VNB	3.56067e-17
C534	VGND	VGND#3	5.61187e-17
C535	VPWR	a_91_48##3	5.61221e-18
C536	a_91_48##8	VNB	3.38159e-17
C537	VGND	A2#3	2.14129e-20
C538	a_91_48##11	VNB	2.96594e-17
C539	VGND	A1#3	4.94635e-19
C540	a_91_48##12	VNB	4.53087e-17
C541	A1	A2	1.52625e-17
C542	X#6	a_91_48##15	1.35494e-17
C543	a_700_74#	VGND#7	4.9765e-17
C544	VPWR#4	VNB	2.59658e-16
C545	VGND	a_91_48##3	6.83879e-18
C546	VGND#3	VNB	2.84402e-16
C547	A2#3	VNB	3.60264e-17
C548	A1#3	VNB	3.60584e-17
C549	B1#3	VNB	6.82005e-17
C550	VPWR	A1	2.60447e-18
C551	a_91_48##3	VNB	8.16553e-19
C552	VPWR	B1	3.14011e-18
C553	VPWR#5	a_503_392##5	8.64785e-18
C554	VGND	A1	2.97249e-18
C555	VPWR	A2	3.39199e-18
C556	a_503_392##2	a_503_392#	1.32102e-18
C557	VPWR	X	2.03238e-18
C558	A1	VNB	2.37649e-18
C559	B1	VNB	3.80091e-18
C560	VGND	X	2.8976e-18
C561	A2	VNB	4.18499e-18
C562	X	VNB	5.66625e-17
C563	VPWR	VNB	7.76403e-17
C564	VGND	VNB	7.79032e-17
C565	VPWR#2	A2#6	1.83835e-18
C566	VPWR#3	VPWR#2	9.86498e-19
C567	VGND#2	A2#5	4.22213e-18
C568	VGND#2	a_700_74##2	2.89233e-17
C569	a_503_392#	VPWR#2	1.78835e-17
C570	a_503_392##6	VPWR#2	7.18333e-18
C571	VGND#2	A1#3	2.69692e-21
C572	VGND#2	A1#1	5.22717e-18
C573	VGND	VGND#2	6.48037e-17
C574	a_503_392##2	VPWR#2	3.13618e-19
C575	VPWR#4	VPWR#2	5.81464e-17
C576	VGND#2	A1#6	2.54532e-19
C577	VGND#2	VNB	6.86592e-17
C578	VGND#2	a_700_74##4	1.81488e-17
C579	VGND#2	A1#2	2.52277e-20
C580	VGND#2	a_700_74#	1.78782e-17
C581	VPWR	VPWR#2	3.86865e-17
C582	VPWR#2	VNB	5.34517e-17
C583	VGND#3	VGND#2	7.73102e-17
C584	VGND#2	A2#1	3.9436e-18
C585	VPWR#2	A2#4	1.83835e-18
*
*
.ENDS sky130_fd_sc_hs__a21o_4
*
