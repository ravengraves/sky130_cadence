* Extracted by Quantus, converted by sky130cad/quantus.py
*
*
*
*                       LINUX           Wed Nov 18 08:36:40 2026
*
*
*
*  PROGRAM  advgen
*
*  Name           : advgen - Quantus - (64-bit)
*  Version        : 25.1.0-p047
*  Build Date     : Thu Dec 11 23:20:30 PST 2025
*
*  HSPICE LIBRARY
*
*  OPERATING_TEMPERATURE 150
*  QRC_TECH_DIR <path>/tech
*
*
*

*
.SUBCKT sky130_fd_sc_hs__einvn_2 VPB VNB VGND VPWR Z A TE_B
*
*
*  caps2d version: 10
*
*
*       TRANSISTOR CARDS
*
*
XM7 VGND#3 TE_B#6 a_115_464##7 VNB sky130_fd_pr__nfet_01v8_lvt l=0.15 w=0.42 ad=0.1197 as=0.1197 pd=1.41 ps=1.41
XM3 VGND#4 a_115_464##4 a_231_74##4 VNB sky130_fd_pr__nfet_01v8_lvt l=0.15 w=0.74 ad=0.2072 as=0.2109 pd=2.04 ps=2.05
XM0 a_231_74##2 a_115_464# VGND#4 VNB sky130_fd_pr__nfet_01v8_lvt l=0.15 w=0.74 ad=0.2072 as=0.2072 pd=2.04 ps=2.04
XM4 Z#3 A#4 a_231_74##2 VNB sky130_fd_pr__nfet_01v8_lvt l=0.15 w=0.74 ad=0.2109 as=0.2072 pd=2.05 ps=2.04
XM5 a_231_74# A#5 Z#3 VNB sky130_fd_pr__nfet_01v8_lvt l=0.15 w=0.74 ad=0.1995 as=0.2109 pd=2.08 ps=2.05
XM9 VPWR#3 TE_B#3 a_115_464##8 VPB sky130_fd_pr__pfet_01v8 l=0.15 w=0.64 ad=0.1856 as=0.1856 pd=1.86 ps=1.86
XM1 VPWR#4 TE_B#5 a_227_368##4 VPB sky130_fd_pr__pfet_01v8 l=0.15 w=1.12 ad=0.336 as=0.3304 pd=2.84 ps=2.83
XM6 a_227_368##2 TE_B#1 VPWR#4 VPB sky130_fd_pr__pfet_01v8 l=0.15 w=1.12 ad=0.336 as=0.336 pd=2.84 ps=2.84
XM8 a_227_368##2 A#7 Z#1 VPB sky130_fd_pr__pfet_01v8 l=0.15 w=1.12 ad=0.336 as=0.336 pd=2.84 ps=2.84
XM2 Z#1 A#1 a_227_368# VPB sky130_fd_pr__pfet_01v8 l=0.15 w=1.12 ad=0.336 as=0.3304 pd=2.84 ps=2.83
*
*
*       RESISTOR AND CAP/DIODE CARDS
*
Rg1	a_115_464#	a_115_464##2	550.679565
Rg2	a_115_464##2	a_115_464##3	218.072006
Rg3	a_115_464##2	a_115_464##4	340.173401
Rg4	TE_B#1	TE_B#2	593.719238
Rg5	TE_B#2	TE_B#3	773.366577
Rg6	TE_B#3	TE_B#4	367.796478
Rg7	TE_B#2	TE_B#5	371.735809
Rg8	TE_B#4	TE_B#6	398.044769
Rg9	A#1	A#2	506.911102
Rg10	A#2	A#3	169.131683
Rg11	A#3	A#4	296.922485
Rg12	A#2	A#5	322.988434
Rg13	A#2	A#6	41.678959
Rg14	A#3	A#7	560.102661
Rf1	TE_B	TE_B#7	0.964345
Rf2	TE_B#8	TE_B#4	54.375278
Rf3	TE_B#7	TE_B#8	10.198974
Rf4	TE_B	TE_B#10	0.964345
Rf5	TE_B#8	TE_B#10	1.236239
Rf6	a_115_464##3	a_115_464##6	164.386047
Rf7	a_115_464##6	a_115_464##7	76.224579
Rf8	a_115_464##6	a_115_464##8	83.282051
Rf9	Z#2	Z	10.825999
Rf10	Z	Z#3	15.590509
Rf11	Z#1	Z#2	5.000000
Rf12	a_231_74#	a_231_74##3	72.974609
Rf13	a_231_74##3	a_231_74##4	103.503044
Rf14	a_231_74##2	a_231_74##3	7.500000
Rf15	a_227_368#	a_227_368##3	116.821999
Rf16	a_227_368##3	a_227_368##4	103.798134
Rf17	a_227_368##2	a_227_368##3	5.000000
Rf18	A	A#6	163.775864
Rf20	VGND#2	VGND#3	145.474976
Rf21	VGND#2	VGND#4	39.186417
Rf23	VPWR#2	VPWR#3	144.759277
Rf24	VPWR#2	VPWR#4	49.031483
Re1	VPWR#2	VPWR	1.403190
Re2	VGND	VGND#2	1.403242
*
*       CAPACITOR CARDS
*
*
C1	a_115_464#	A#3	2.0611e-17
C2	a_115_464##2	a_115_464#	2.38254e-18
C3	A#7	A#2	4.17489e-18
C4	a_115_464##6	A#3	1.28493e-18
C5	a_115_464##2	TE_B#1	1.10434e-19
C6	a_115_464##6	TE_B#2	1.07958e-18
C7	a_115_464##6	a_115_464##2	3.97226e-19
C8	a_115_464##2	TE_B#5	1.71367e-17
C9	TE_B#7	a_115_464##2	1.04773e-19
C10	a_231_74#	A#3	1.77779e-19
C11	TE_B#8	a_115_464##6	1.61262e-17
C12	A#2	a_231_74#	2.42147e-18
C13	TE_B#7	a_115_464##6	3.60791e-17
C14	Z#3	A#3	1.57127e-17
C15	a_115_464##3	A#3	4.24642e-19
C16	a_115_464##6	Z#3	7.31852e-18
C17	Z#3	A#2	1.31433e-17
C18	a_115_464##3	TE_B#2	1.11749e-18
C19	Z#3	a_115_464##2	8.03859e-20
C20	a_231_74##2	A#3	1.52779e-19
C21	a_115_464##6	a_231_74##4	2.18129e-17
C22	TE_B#4	a_115_464##2	3.13048e-19
C23	a_231_74##2	TE_B#2	5.27892e-20
C24	a_231_74#	Z#3	2.31226e-17
C25	a_231_74##2	a_115_464##2	2.98049e-18
C26	a_231_74##2	Z#3	4.40613e-17
C27	VGND#4	a_115_464##2	8.69536e-19
C28	a_231_74##2	VGND#4	5.30181e-17
C29	VGND#3	TE_B#7	2.17061e-17
C30	a_231_74##4	a_231_74##2	2.71796e-18
C31	a_115_464##6	a_227_368##4	3.38188e-17
C32	a_231_74##4	VGND#4	5.18607e-17
C33	a_231_74##4	TE_B#2	2.83536e-19
C34	a_231_74##4	a_115_464##2	4.5408e-18
C35	Z#3	a_227_368#	1.06572e-16
C36	a_115_464##7	a_231_74##4	4.54596e-17
C37	VGND#3	VGND#4	1.11788e-18
C38	a_227_368##2	Z#3	8.7603e-17
C39	a_115_464##6	A#5	1.0884e-20
C40	VGND#3	a_115_464##7	4.8892e-17
C41	a_231_74##2	a_227_368##2	1.48564e-17
C42	a_115_464##6	A#4	1.49659e-20
C43	a_231_74##4	a_227_368##2	4.50882e-19
C44	a_115_464##6	a_115_464#	1.69696e-19
C45	a_115_464##6	a_115_464##4	8.75053e-19
C46	a_227_368#	Z#1	3.81133e-19
C47	a_231_74##4	a_227_368##4	1.50547e-17
C48	a_231_74#	A#5	3.29382e-17
C49	a_227_368##2	a_227_368#	2.4622e-18
C50	Z#3	A#5	2.79643e-17
C51	a_227_368#	A#3	5.60548e-20
C52	a_231_74##2	A#5	8.75352e-19
C53	a_115_464##7	a_115_464##8	4.88115e-19
C54	Z#3	A#4	2.87819e-17
C55	VGND#4	A#5	6.3647e-19
C56	a_227_368#	A#2	5.41307e-18
C57	a_231_74##2	A#4	4.3824e-17
C58	TE_B#7	a_115_464##4	4.28617e-19
C59	Z#3	a_115_464#	2.53318e-18
C60	a_227_368##2	VPWR#4	7.99289e-17
C61	VGND#4	A#4	1.62714e-18
C62	a_231_74##2	a_115_464#	3.15409e-17
C63	Z#3	a_115_464##4	1.45141e-19
C64	a_231_74##4	A#4	2.26608e-19
C65	a_227_368##4	a_227_368##2	2.71114e-18
C66	VGND#4	a_115_464#	2.73497e-17
C67	a_115_464##6	A#7	7.08596e-19
C68	a_231_74##2	a_115_464##4	4.80168e-19
C69	a_227_368##4	VPWR#4	8.203e-17
C70	a_231_74##4	a_115_464#	5.18539e-19
C71	VGND#4	a_115_464##4	2.82376e-17
C72	a_115_464##6	TE_B#1	1.74002e-19
C73	a_231_74##2	TE_B#6	6.76279e-20
C74	A	A#2	2.66297e-17
C75	a_231_74##4	a_115_464##4	3.19017e-17
C76	VGND#4	TE_B#6	7.15735e-19
C77	a_115_464##8	a_227_368##4	6.54031e-17
C78	VPWR#3	VPWR#4	1.07044e-18
C79	a_115_464##7	a_115_464##4	1.42918e-18
C80	a_115_464##6	TE_B#5	1.46857e-18
C81	a_231_74##4	TE_B#6	1.30251e-18
C82	A#3	A#2	1.06261e-17
C83	Z#3	A#1	2.47239e-17
C84	VGND#3	a_115_464##4	9.13003e-19
C85	a_115_464##7	TE_B#6	3.6046e-17
C86	a_115_464##6	TE_B#3	4.60895e-20
C87	VPWR#3	a_115_464##8	6.16672e-17
C88	VGND#3	TE_B#6	2.30334e-17
C89	Z#3	A#7	2.74289e-17
C90	a_227_368##2	a_115_464#	2.23985e-18
C91	Z#3	TE_B#1	1.942e-18
C92	a_231_74##2	TE_B#1	4.7144e-18
C93	Z#3	TE_B#5	4.83037e-19
C94	a_227_368##2	TE_B#2	4.97738e-20
C95	a_227_368#	A#1	4.37991e-17
C96	A#4	A#5	3.65753e-17
C97	A#1	Z#1	2.40733e-17
C98	a_227_368##2	a_115_464##2	2.43755e-18
C99	a_227_368#	A#7	6.62282e-18
C100	a_227_368##2	A#1	8.78501e-19
C101	a_231_74##4	TE_B#5	2.54305e-18
C102	A#7	Z#1	2.34143e-17
C103	a_227_368#	TE_B#1	1.95706e-19
C104	a_115_464#	A#4	3.76527e-17
C105	a_227_368##2	A#7	2.64985e-17
C106	VPWR	A#2	6.15463e-19
C107	VPWR	TE_B#2	9.01703e-18
C108	VPWR	a_115_464##2	8.12405e-19
C109	a_227_368##2	TE_B#1	7.38842e-17
C110	a_115_464##4	a_115_464#	3.93016e-17
C111	VPWR#4	TE_B#1	2.53877e-17
C112	a_115_464##6	a_115_464##3	3.43881e-17
C113	VPWR#4	TE_B#2	5.34552e-18
C114	a_227_368##2	TE_B#5	1.87166e-18
C115	a_227_368##4	TE_B#1	1.6401e-18
C116	TE_B#5	VPWR#4	3.23852e-17
C117	VPWR#4	a_115_464##2	8.32248e-19
C118	TE_B#6	a_115_464##4	3.75851e-18
C119	a_227_368##4	TE_B#5	3.36395e-17
C120	a_115_464##6	TE_B#4	1.69288e-17
C121	TE_B#8	a_115_464##3	1.66914e-18
C122	VPWR#3	TE_B#1	3.39998e-20
C123	VPWR#4	TE_B#3	1.1468e-19
C124	a_115_464##8	TE_B#5	1.40009e-18
C125	TE_B#7	a_115_464##3	2.29895e-18
C126	a_227_368##4	TE_B#3	1.47829e-18
C127	VPWR#3	TE_B#5	1.06293e-19
C128	a_115_464##8	TE_B#3	5.13465e-17
C129	Z#3	a_115_464##3	7.08077e-19
C130	TE_B#8	TE_B#4	9.18483e-18
C131	VGND	A#2	6.86297e-19
C132	VGND	a_115_464##2	1.5368e-18
C133	TE_B#7	TE_B#4	2.19414e-17
C134	VPWR#3	TE_B#3	3.35908e-17
C135	a_115_464#	TE_B#1	1.50758e-17
C136	Z#3	TE_B#4	5.35224e-19
C137	a_231_74##4	a_115_464##3	6.29316e-18
C138	a_227_368##4	TE_B#2	6.28012e-18
C139	a_227_368##4	a_115_464##2	6.03244e-18
C140	a_231_74##4	TE_B#4	1.05462e-18
C141	A#7	A#1	4.86465e-17
C142	a_115_464##7	TE_B#4	2.0293e-18
C143	VGND#3	TE_B#4	8.91378e-18
C144	TE_B#1	A#7	6.18748e-17
C145	a_227_368##4	a_115_464##3	6.1992e-18
C146	a_227_368##2	TE_B#4	8.21441e-20
C147	A#3	VNB	1.98532e-17
C148	A#2	VNB	6.34267e-17
C149	TE_B#2	VNB	5.08246e-17
C150	a_115_464##2	VNB	3.11839e-17
C151	TE_B#5	TE_B#1	4.80437e-17
C152	a_227_368##4	TE_B#4	1.59511e-18
C153	a_115_464##8	TE_B#4	3.67063e-18
C154	TE_B	a_115_464##6	3.47277e-17
C155	VPWR#3	TE_B#4	7.04118e-18
C156	a_115_464##2	TE_B#2	4.11846e-19
C157	TE_B#3	TE_B#5	3.80751e-18
C158	TE_B#4	a_115_464##4	1.57439e-18
C159	a_115_464##3	A#7	6.88608e-19
C160	A	a_231_74#	3.33638e-17
C161	Z#3	A	6.93887e-17
C162	TE_B#4	A#7	1.04885e-19
C163	a_115_464##3	TE_B#3	5.85492e-19
C164	TE_B#4	TE_B#5	4.08879e-18
C165	A	a_227_368#	1.86977e-17
C166	TE_B	a_115_464##8	1.274e-17
C167	VPWR	a_115_464##6	2.88682e-18
C168	TE_B	VPWR#3	3.39494e-17
C169	VPWR	Z#3	9.13389e-18
C170	A	A#5	9.32606e-18
C171	VGND	a_115_464##6	3.67119e-18
C172	TE_B#4	a_115_464##3	2.59548e-17
C173	VPWR	a_227_368#	2.71038e-17
C174	VGND	TE_B#7	5.9552e-18
C175	TE_B	A#7	3.93269e-20
C176	VGND	a_231_74#	1.97547e-17
C177	VPWR	a_227_368##2	1.85517e-17
C178	VGND	Z#3	6.62764e-18
C179	VGND	a_231_74##2	1.89057e-17
C180	VPWR	a_227_368##4	1.53142e-17
C181	TE_B	TE_B#5	7.90746e-19
C182	VGND	a_231_74##4	1.531e-17
C183	VPWR	a_115_464##8	1.76022e-17
C184	VGND	a_115_464##7	2.04417e-17
C185	VPWR	VPWR#3	4.2696e-17
C186	VGND	VGND#3	4.05444e-17
C187	a_115_464##6	VNB	1.33718e-17
C188	VGND	a_227_368#	2.84287e-18
C189	VGND	a_227_368##2	3.56475e-18
C190	TE_B#8	VNB	6.02574e-18
C191	VPWR	a_115_464#	7.45132e-19
C192	TE_B#7	VNB	1.74509e-17
C193	a_231_74#	VNB	2.17605e-17
C194	VGND	a_227_368##4	3.13863e-18
C195	Z#3	VNB	8.53508e-18
C196	a_231_74##2	VNB	7.1768e-18
C197	VGND#4	VNB	4.36297e-20
C198	a_231_74##4	VNB	1.11486e-17
C199	VGND	A#5	1.87152e-18
C200	VPWR	A#1	2.21453e-18
C201	a_115_464##7	VNB	1.4008e-17
C202	VGND	A#4	1.24718e-18
C203	TE_B	a_115_464##3	7.10056e-19
C204	VGND#3	VNB	6.24795e-17
C205	VPWR	A#7	2.0547e-18
C206	a_227_368#	VNB	6.01642e-17
C207	VGND	a_115_464#	2.21024e-18
C208	VPWR	TE_B#1	5.22413e-18
C209	VGND	a_115_464##4	2.10037e-18
C210	TE_B	TE_B#4	2.91251e-17
C211	a_227_368##2	VNB	5.6234e-18
C212	VGND	TE_B#6	1.26516e-18
C213	a_227_368##4	VNB	1.22976e-17
C214	VPWR	TE_B#3	6.03357e-18
C215	a_115_464##8	VNB	1.46214e-17
C216	VPWR#3	VNB	7.10116e-17
C217	A#5	VNB	3.91077e-17
C218	A#4	VNB	2.73601e-17
C219	VGND	TE_B#1	1.34438e-18
C220	a_115_464#	VNB	3.20417e-17
C221	VGND	TE_B#5	1.87588e-18
C222	a_115_464##4	VNB	2.97083e-17
C223	TE_B#6	VNB	3.72355e-17
C224	VPWR	a_115_464##3	1.24637e-18
C225	A#1	VNB	4.22195e-17
C226	A#7	VNB	4.20748e-17
C227	TE_B#1	VNB	4.99808e-17
C228	TE_B#5	VNB	2.915e-17
C229	TE_B#3	VNB	5.98844e-17
C230	VGND	a_115_464##3	3.76549e-18
C231	VGND	TE_B#4	2.51498e-19
C232	a_115_464##3	VNB	5.25508e-17
C233	VPWR	TE_B	6.13361e-18
C234	TE_B#4	VNB	1.34522e-16
C235	VPWR	A	3.2424e-18
C236	VGND	A	7.69078e-18
C237	TE_B	VNB	1.8621e-17
C238	A	VNB	3.77514e-17
C239	VPWR	VNB	6.0942e-17
C240	VGND	VNB	7.14524e-17
C241	VGND#2	A#5	5.71365e-18
C242	VPWR#2	TE_B#2	2.01694e-17
C243	VGND#2	a_115_464##6	9.08458e-19
C244	A	VPWR#2	2.79715e-19
C245	a_227_368#	VPWR#2	6.41698e-17
C246	VGND#2	A#3	9.04638e-20
C247	VPWR#2	TE_B#3	2.19707e-18
C248	a_115_464##8	VPWR#2	7.4045e-18
C249	VPWR#2	A#3	2.04257e-20
C250	VGND	VGND#2	8.48836e-17
C251	VPWR#2	a_115_464##3	1.33996e-18
C252	VPWR#2	TE_B#1	6.58576e-18
C253	VGND#2	a_115_464##4	4.57286e-18
C254	VGND#2	VGND#3	3.48708e-17
C255	VPWR#2	a_115_464##2	7.0239e-20
C256	VGND#2	A#4	6.02335e-18
C257	VGND#2	a_115_464##2	4.01705e-20
C258	VPWR#2	A#1	4.70638e-18
C259	VGND#2	a_231_74##4	1.79017e-17
C260	VGND#2	A#2	6.29885e-19
C261	VPWR#2	VPWR#3	3.59591e-17
C262	VPWR#2	A#2	4.91366e-19
C263	VGND#2	a_231_74##2	2.32026e-17
C264	VGND#2	VNB	2.45044e-16
C265	VGND#2	a_115_464##3	4.89968e-19
C266	a_115_464##6	VPWR#2	5.15213e-19
C267	VGND#2	a_231_74#	3.20927e-17
C268	VPWR#2	VNB	2.37196e-16
C269	a_227_368##4	VPWR#2	1.66025e-17
C270	VGND#2	TE_B#6	5.37456e-19
C271	VGND#2	A	2.04806e-18
C272	VPWR#2	A#7	4.89885e-18
C273	VGND#2	a_115_464#	4.32543e-18
C274	VPWR	VPWR#2	7.74982e-17
C275	a_227_368##2	VPWR#2	3.34294e-17
C276	VGND#2	a_115_464##7	1.02572e-17
*
*
.ENDS sky130_fd_sc_hs__einvn_2
*
