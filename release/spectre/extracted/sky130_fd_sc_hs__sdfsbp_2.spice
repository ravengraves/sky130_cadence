* Extracted by Quantus, converted by sky130cad/quantus.py
*
*
*
*                       LINUX           Wed Nov 18 09:10:25 2026
*
*
*
*  PROGRAM  advgen
*
*  Name           : advgen - Quantus - (64-bit)
*  Version        : 25.1.0-p047
*  Build Date     : Thu Dec 11 23:20:30 PST 2025
*
*  HSPICE LIBRARY
*
*  OPERATING_TEMPERATURE 150
*  QRC_TECH_DIR <path>/tech
*
*
*

*
.SUBCKT sky130_fd_sc_hs__sdfsbp_2 VNB VPB VGND SET_B VPWR Q_N Q D SCE SCD CLK
*
*
*  caps2d version: 10
*
*
*       TRANSISTOR CARDS
*
*
XM47 a_27_74##8 SCE#4 VGND#24 VNB sky130_fd_pr__nfet_01v8_lvt l=0.15 w=0.42 ad=0.1197 as=0.1785 pd=1.41 ps=1.69
XM5 VGND#24 a_27_74# a_229_74# VNB sky130_fd_pr__nfet_01v8_lvt l=0.15 w=0.42 ad=0.1785 as=0.1008 pd=1.69 ps=1.32
XM2 a_229_74# D#3 a_304_464##6 VNB sky130_fd_pr__nfet_01v8_lvt l=0.15 w=0.42 ad=0.1008 as=0.3318 pd=1.32 ps=2.42
XM45 a_304_464##6 SCE#6 a_495_74# VNB sky130_fd_pr__nfet_01v8_lvt l=0.15 w=0.42 ad=0.3318 as=0.1008 pd=2.42 ps=1.32
XM40 a_495_74# SCD#4 VGND#23 VNB sky130_fd_pr__nfet_01v8_lvt l=0.15 w=0.42 ad=0.1008 as=0.1197 pd=1.32 ps=1.41
XM29 a_619_368##19 CLK#1 VGND#22 VNB sky130_fd_pr__nfet_01v8_lvt l=0.15 w=0.74 ad=0.2109 as=0.259 pd=2.05 ps=2.18
XM16 VGND#22 a_619_368##6 a_871_74##10 VNB sky130_fd_pr__nfet_01v8_lvt l=0.15 w=0.74 ad=0.259 as=0.2109 pd=2.18 ps=2.05
XM18 a_304_464# a_619_368##8 a_1069_81##14 VNB sky130_fd_pr__nfet_01v8_lvt l=0.15 w=0.42 ad=0.1197 as=0.3675 pd=1.41 ps=2.59
XM34 a_1069_81##14 a_871_74# a_1274_81# VNB sky130_fd_pr__nfet_01v8_lvt l=0.15 w=0.42 ad=0.3675 as=0.1008 pd=2.59 ps=1.32
XM31 a_1274_81# a_1252_376# VGND#21 VNB sky130_fd_pr__nfet_01v8_lvt l=0.15 w=0.42 ad=0.1008 as=0.1554 pd=1.32 ps=1.58
XM14 a_1252_376##5 a_1069_81# a_1567_74# VNB sky130_fd_pr__nfet_01v8_lvt l=0.15 w=0.42 ad=0.1197 as=0.1008 pd=1.41 ps=1.32
XM9 a_1567_74# SET_B#1 VGND#20 VNB sky130_fd_pr__nfet_01v8_lvt l=0.15 w=0.42 ad=0.1008 as=0.189 pd=1.32 ps=1.74
XM10 VGND#19 a_1069_81##11 a_1794_74##4 VNB sky130_fd_pr__nfet_01v8_lvt l=0.15 w=0.64 ad=0.192 as=0.2144 pd=1.88 ps=1.95
XM27 a_1794_74##2 a_1069_81##4 VGND#19 VNB sky130_fd_pr__nfet_01v8_lvt l=0.15 w=0.64 ad=0.1792 as=0.192 pd=1.84 ps=1.88
XM21 a_2067_74##24 a_871_74##7 a_1794_74##2 VNB sky130_fd_pr__nfet_01v8_lvt l=0.15 w=0.64 ad=0.224 as=0.1792 pd=1.98 ps=1.84
XM35 a_1794_74# a_871_74##8 a_2067_74##24 VNB sky130_fd_pr__nfet_01v8_lvt l=0.15 w=0.64 ad=0.2272 as=0.224 pd=1.99 ps=1.98
XM38 a_2067_74##18 a_619_368##10 a_2501_74# VNB sky130_fd_pr__nfet_01v8_lvt l=0.15 w=0.42 ad=0.3759 as=0.1008 pd=2.63 ps=1.32
XM15 a_2501_74# a_2513_258# a_2579_74# VNB sky130_fd_pr__nfet_01v8_lvt l=0.15 w=0.42 ad=0.1008 as=0.1008 pd=1.32 ps=1.32
XM11 a_2579_74# SET_B#4 VGND#18 VNB sky130_fd_pr__nfet_01v8_lvt l=0.15 w=0.42 ad=0.1008 as=0.1512 pd=1.32 ps=1.56
XM41 VGND#18 a_2067_74##6 a_2513_258##7 VNB sky130_fd_pr__nfet_01v8_lvt l=0.15 w=0.42 ad=0.1512 as=0.1197 pd=1.56 ps=1.41
XM22 VGND#17 a_2067_74##10 Q_N#1 VNB sky130_fd_pr__nfet_01v8_lvt l=0.15 w=0.74 ad=0.2479 as=0.222 pd=2.15 ps=2.08
XM36 Q_N#1 a_2067_74##8 VGND#16 VNB sky130_fd_pr__nfet_01v8_lvt l=0.15 w=0.74 ad=0.222 as=0.2442 pd=2.08 ps=2.14
XM28 a_3177_368##10 a_2067_74# VGND#4 VNB sky130_fd_pr__nfet_01v8_lvt l=0.15 w=0.64 ad=0.1824 as=0.2941 pd=1.85 ps=2.31
XM46 Q#2 a_3177_368##5 VGND#4 VNB sky130_fd_pr__nfet_01v8_lvt l=0.15 w=0.74 ad=0.2072 as=0.2941 pd=2.04 ps=2.31
XM1 VGND#1 a_3177_368# Q#2 VNB sky130_fd_pr__nfet_01v8_lvt l=0.15 w=0.74 ad=0.2109 as=0.2072 pd=2.05 ps=2.04
XM25 a_27_74##9 SCE#5 VPWR#23 VPB sky130_fd_pr__pfet_01v8 l=0.15 w=0.64 ad=0.1888 as=0.224 pd=1.87 ps=1.98
XM44 VPWR#23 SCE#1 a_220_464# VPB sky130_fd_pr__pfet_01v8 l=0.15 w=0.64 ad=0.224 as=0.1728 pd=1.98 ps=1.82
XM0 a_220_464# D#1 a_304_464##4 VPB sky130_fd_pr__pfet_01v8 l=0.15 w=0.64 ad=0.1728 as=0.2688 pd=1.82 ps=2.12
XM3 a_304_464##4 a_27_74##3 a_418_464# VPB sky130_fd_pr__pfet_01v8 l=0.15 w=0.64 ad=0.2688 as=0.1728 pd=2.12 ps=1.82
XM39 a_418_464# SCD#3 VPWR#21 VPB sky130_fd_pr__pfet_01v8 l=0.15 w=0.64 ad=0.1728 as=0.2016 pd=1.82 ps=1.91
XM12 a_619_368##18 CLK#3 VPWR#18 VPB sky130_fd_pr__pfet_01v8 l=0.15 w=1.12 ad=0.3304 as=0.7616 pd=2.83 ps=3.6
XM20 VPWR#18 a_619_368##9 a_871_74##13 VPB sky130_fd_pr__pfet_01v8 l=0.15 w=1.12 ad=0.7616 as=0.3696 pd=3.6 ps=2.9
XM13 a_304_464##5 a_871_74##4 a_1069_81##16 VPB sky130_fd_pr__pfet_01v8 l=0.15 w=0.42 ad=0.1239 as=0.147 pd=1.43 ps=1.54
XM24 a_1069_81##16 a_619_368##7 a_1201_463# VPB sky130_fd_pr__pfet_01v8 l=0.15 w=0.42 ad=0.147 as=0.1134 pd=1.54 ps=1.38
XM30 a_1201_463# a_1252_376##4 VPWR#16 VPB sky130_fd_pr__pfet_01v8 l=0.15 w=0.42 ad=0.1134 as=0.3927 pd=1.38 ps=2.71
XM48 VPWR#16 a_1069_81##3 a_1252_376##7 VPB sky130_fd_pr__pfet_01v8 l=0.15 w=0.42 ad=0.3927 as=0.168 pd=2.71 ps=1.64
XM42 a_1252_376##7 SET_B#3 VPWR#14 VPB sky130_fd_pr__pfet_01v8 l=0.15 w=0.42 ad=0.168 as=0.2457 pd=1.64 ps=2.01
XM17 VPWR#12 a_1069_81##10 a_1789_424##4 VPB sky130_fd_pr__pfet_01v8 l=0.15 w=0.84 ad=0.252 as=0.2898 pd=2.28 ps=2.37
XM43 a_1789_424##2 a_1069_81##9 VPWR#12 VPB sky130_fd_pr__pfet_01v8 l=0.15 w=0.84 ad=0.252 as=0.252 pd=2.28 ps=2.28
XM33 a_1789_424##2 a_619_368##13 a_2067_74##22 VPB sky130_fd_pr__pfet_01v8 l=0.15 w=0.84 ad=0.252 as=0.252 pd=2.28 ps=2.28
XM7 a_2067_74##22 a_619_368##15 a_1789_424# VPB sky130_fd_pr__pfet_01v8 l=0.15 w=0.84 ad=0.252 as=0.2478 pd=2.28 ps=2.27
XM8 a_2277_455##2 a_871_74##5 a_2067_74##21 VPB sky130_fd_pr__pfet_01v8 l=0.15 w=0.42 ad=0.126 as=0.1239 pd=1.44 ps=1.43
XM4 a_2277_455# a_2513_258##3 VPWR#9 VPB sky130_fd_pr__pfet_01v8 l=0.15 w=0.42 ad=0.1239 as=0.126 pd=1.43 ps=1.44
XM32 VPWR#9 SET_B#6 a_2067_74##20 VPB sky130_fd_pr__pfet_01v8 l=0.15 w=0.42 ad=0.126 as=0.1239 pd=1.44 ps=1.43
XM37 a_2513_258##4 a_2067_74##13 VPWR#7 VPB sky130_fd_pr__pfet_01v8 l=0.15 w=0.42 ad=0.1239 as=0.3682 pd=1.43 ps=3.01
XM6 VPWR#7 a_2067_74##11 Q_N#3 VPB sky130_fd_pr__pfet_01v8 l=0.15 w=1.12 ad=0.3682 as=0.336 pd=3.01 ps=2.84
XM23 Q_N#3 a_2067_74##9 VPWR#5 VPB sky130_fd_pr__pfet_01v8 l=0.15 w=1.12 ad=0.336 as=0.3304 pd=2.84 ps=2.83
XM26 a_3177_368##9 a_2067_74##7 VPWR#4 VPB sky130_fd_pr__pfet_01v8 l=0.15 w=1 ad=0.295 as=0.4354 pd=2.59 ps=3.04
XM19 VPWR#4 a_3177_368##6 Q#1 VPB sky130_fd_pr__pfet_01v8 l=0.15 w=1.12 ad=0.4354 as=0.336 pd=3.04 ps=2.84
XM49 Q#1 a_3177_368##4 VPWR#1 VPB sky130_fd_pr__pfet_01v8 l=0.15 w=1.12 ad=0.336 as=0.3304 pd=2.84 ps=2.83
*
*
*       RESISTOR AND CAP/DIODE CARDS
*
Rg1	SCE#1	SCE#2	491.945435
Rg2	SCE#2	SCE#3	26.676205
Rg3	SCE#3	SCE#4	556.513550
Rg4	SCE#3	SCE#5	468.870789
Rg5	a_27_74#	a_27_74##2	216.119781
Rg6	D#1	D#2	738.959290
Rg7	D#2	D#3	216.119781
Rg8	a_27_74##3	a_27_74##4	305.795410
Rg9	SCE#6	SCE#7	248.399948
Rg10	SCD#1	SCD#2	9.268713
Rg11	SCD#2	SCD#3	743.076294
Rg12	SCD#2	SCD#4	322.291779
Rg13	CLK#1	CLK#2	306.145477
Rg14	CLK#2	CLK#3	548.562378
Rg15	a_871_74#	a_871_74##2	255.352188
Rg16	a_871_74##2	a_871_74##3	347.302063
Rg17	a_871_74##3	a_871_74##4	361.131256
Rg18	a_1252_376#	a_1252_376##2	274.421326
Rg19	a_1252_376##2	a_1252_376##3	303.572998
Rg20	a_1252_376##3	a_1252_376##4	425.917267
Rg21	a_1069_81#	a_1069_81##2	388.514160
Rg22	a_1069_81##2	a_1069_81##3	497.509583
Rg23	SET_B#1	SET_B#2	589.130066
Rg24	SET_B#2	SET_B#3	354.286407
Rg25	a_619_368#	a_619_368##2	2282.037109
Rg26	a_619_368##2	a_619_368##3	1441.336182
Rg27	a_619_368##3	a_619_368##4	43.393650
Rg28	a_619_368##4	a_619_368##5	33.566738
Rg29	a_619_368##5	a_619_368##6	397.555725
Rg30	a_619_368##2	a_619_368##7	283.919525
Rg31	a_619_368##3	a_619_368##8	608.914368
Rg32	a_619_368##5	a_619_368##9	449.655212
Rg33	a_1069_81##4	a_1069_81##5	334.831238
Rg34	a_1069_81##5	a_1069_81##6	175.141129
Rg35	a_1069_81##6	a_1069_81##7	42.970783
Rg36	a_1069_81##7	a_1069_81##8	279.650482
Rg37	a_1069_81##5	a_1069_81##9	594.897278
Rg38	a_1069_81##6	a_1069_81##10	593.715149
Rg39	a_1069_81##7	a_1069_81##11	248.751953
Rg40	a_871_74##5	a_871_74##6	712.459839
Rg41	a_871_74##6	a_871_74##7	446.319153
Rg42	a_871_74##6	a_871_74##8	339.384125
Rg43	a_619_368##10	a_619_368##11	254.867722
Rg44	a_619_368##11	a_619_368##12	2503.402344
Rg45	a_619_368##12	a_619_368##13	512.259338
Rg46	a_619_368##11	a_619_368##14	77.142242
Rg47	a_619_368##12	a_619_368##15	291.395142
Rg48	a_2513_258#	a_2513_258##2	473.394257
Rg49	a_2513_258##2	a_2513_258##3	450.833282
Rg50	SET_B#4	SET_B#5	479.132874
Rg51	SET_B#5	SET_B#6	446.483002
Rg52	a_2067_74#	a_2067_74##2	314.746094
Rg53	a_2067_74##2	a_2067_74##3	513.543213
Rg54	a_2067_74##3	a_2067_74##4	210.226303
Rg55	a_2067_74##4	a_2067_74##5	463.990967
Rg56	a_2067_74##5	a_2067_74##6	427.323700
Rg57	a_2067_74##2	a_2067_74##7	490.722809
Rg58	a_2067_74##3	a_2067_74##8	341.968231
Rg59	a_2067_74##3	a_2067_74##9	523.683533
Rg60	a_2067_74##4	a_2067_74##10	341.968231
Rg61	a_2067_74##4	a_2067_74##11	523.683533
Rg62	a_2067_74##5	a_2067_74##12	84.032776
Rg63	a_2067_74##12	a_2067_74##13	457.894226
Rg64	a_3177_368#	a_3177_368##2	423.145813
Rg65	a_3177_368##2	a_3177_368##3	81.843414
Rg66	a_3177_368##2	a_3177_368##4	526.145996
Rg67	a_3177_368##3	a_3177_368##5	347.966095
Rg68	a_3177_368##3	a_3177_368##6	450.541138
Rf1	D#4	D	1.100284
Rf2	D#5	D	1.100284
Rf3	D#4	D#5	11.836917
Rf4	D#2	D#7	161.333084
Rf5	D#5	D#7	4.478834
Rf6	a_27_74##4	a_27_74##6	266.217865
Rf7	a_27_74##6	a_27_74##7	68.058617
Rf8	a_27_74##7	a_27_74##8	33.589100
Rf9	a_27_74##6	a_27_74##9	28.241632
Rf10	a_27_74##7	a_27_74##2	181.952438
Rf11	SCE#7	SCE	82.478439
Rf12	SCE	SCE#2	172.136627
Rf13	SCD	SCD#1	83.099030
Rf14	CLK#4	CLK#2	161.469666
Rf15	CLK	CLK#6	1.236861
Rf16	CLK#4	CLK#6	8.824575
Rf17	a_619_368##4	a_619_368##17	248.253784
Rf18	a_619_368##17	a_619_368##18	23.796638
Rf19	a_619_368##17	a_619_368##19	85.407753
Rf20	a_304_464#	a_304_464##2	120.913559
Rf21	a_304_464##2	a_304_464##3	184.431335
Rf22	a_304_464##3	a_304_464##4	65.765518
Rf23	a_304_464##2	a_304_464##5	20.600924
Rf24	a_304_464##3	a_304_464##6	158.120178
Rf25	a_871_74##3	a_871_74##10	246.560486
Rf26	a_1252_376##5	a_1252_376##2	218.292847
Rf27	a_1252_376##7	a_1252_376##3	251.184189
Rf28	SET_B#7	SET_B#8	0.839094
Rf29	SET_B#9	SET_B#2	161.071899
Rf30	SET_B#8	SET_B#9	5.511418
Rf31	a_1069_81##8	a_1069_81##13	235.974869
Rf32	a_1069_81##13	a_1069_81##15	144.392639
Rf33	a_1069_81##15	a_1069_81##16	147.416107
Rf34	a_1069_81##14	a_1069_81##15	15.000000
Rf35	a_1789_424#	a_1789_424##3	100.639153
Rf36	a_1789_424##3	a_1789_424##4	91.649277
Rf37	a_1789_424##2	a_1789_424##3	7.500000
Rf38	a_1794_74#	a_1794_74##3	97.791458
Rf39	a_1794_74##3	a_1794_74##4	105.379494
Rf40	a_1794_74##2	a_1794_74##3	7.500000
Rf41	a_871_74##2	a_871_74##12	131.811249
Rf42	a_871_74##12	a_871_74##13	184.869476
Rf43	a_871_74##12	a_871_74##6	512.516418
Rf44	a_619_368##14	a_619_368#	555.549561
Rf45	a_2277_455#	a_2277_455##2	126.439880
Rf46	SET_B	SET_B#5	91.286072
Rf47	a_2067_74##12	a_2067_74##15	87.410622
Rf48	a_2067_74##15	a_2067_74##16	87.170387
Rf49	a_2067_74##16	a_2067_74##17	4.716347
Rf50	a_2067_74##17	a_2067_74##19	111.496994
Rf51	a_2067_74##15	a_2067_74##20	32.342297
Rf52	a_2067_74##16	a_2067_74##21	24.071678
Rf53	a_2067_74##17	a_2067_74##22	132.186066
Rf54	a_2067_74##19	a_2067_74##23	24.014034
Rf55	a_2067_74##23	a_2067_74##24	99.340744
Rf56	a_2067_74##18	a_2067_74##19	15.000000
Rf57	a_2067_74##18	a_2067_74##23	15.000000
Rf58	a_2513_258##4	a_2513_258##5	149.235168
Rf59	a_2513_258##5	a_2513_258##2	184.409302
Rf60	a_2513_258##5	a_2513_258##7	29.980259
Rf61	Q_N	Q_N#2	6.286522
Rf62	Q_N#2	Q_N	6.286522
Rf63	Q_N#2	Q_N#3	90.612137
Rf64	Q_N#1	Q_N#2	7.500000
Rf65	a_3177_368##3	a_3177_368##8	181.300735
Rf66	a_3177_368##8	a_3177_368##9	39.049488
Rf67	a_3177_368##8	a_3177_368##10	32.245514
Rf68	Q	Q#1	90.818436
Rf69	Q	Q#3	7.078941
Rf70	Q#3	Q	7.078941
Rf71	Q#2	Q#3	7.500000
Rf72	VPWR#1	VPWR#2	118.564102
Rf73	VPWR#2	VPWR#3	68.700279
Rf74	VPWR#2	VPWR#4	48.259808
Rf75	VPWR#3	VPWR#5	41.783939
Rf76	VPWR#3	VPWR#6	77.495041
Rf77	VPWR#6	VPWR#7	67.810089
Rf78	VPWR#6	VPWR#8	113.059097
Rf79	VPWR#8	VPWR#9	52.242409
Rf80	VPWR#8	VPWR#10	215.231750
Rf81	VPWR#10	VPWR#11	38.749577
Rf82	VPWR#11	VPWR#12	41.631927
Rf83	VPWR#11	VPWR#13	76.711304
Rf84	VPWR#13	VPWR#14	41.593605
Rf85	VPWR#13	VPWR#15	131.609848
Rf86	VPWR#15	VPWR#16	30.126051
Rf87	VPWR#15	VPWR#17	206.374039
Rf88	VPWR#17	VPWR#18	15.759814
Rf89	VPWR#17	VPWR#19	37.483906
Rf90	VPWR#19	VPWR#20	50.369324
Rf91	VPWR#20	VPWR#21	31.024939
Rf92	VPWR#20	VPWR#22	136.544373
Rf93	VPWR#22	VPWR#23	31.141060
Rf95	VGND#1	VGND#2	108.421173
Rf96	VGND#2	VGND#3	71.622299
Rf97	VGND#2	VGND#4	41.038895
Rf98	VGND#3	VGND#5	80.659737
Rf99	VGND#5	VGND#6	79.575981
Rf100	VGND#6	VGND#7	244.329376
Rf101	VGND#7	VGND#8	33.943947
Rf102	VGND#8	VGND#9	91.264053
Rf103	VGND#9	VGND#10	100.940346
Rf104	VGND#10	VGND#11	218.186386
Rf105	VGND#11	VGND#12	46.362534
Rf106	VGND#12	VGND#13	25.908394
Rf107	VGND#13	VGND#14	159.716293
Rf109	VGND#3	VGND#16	45.656124
Rf110	VGND#5	VGND#17	36.279022
Rf111	VGND#6	VGND#18	34.113823
Rf112	VGND#8	VGND#19	34.901169
Rf113	VGND#9	VGND#20	31.948624
Rf114	VGND#10	VGND#21	32.484024
Rf115	VGND#11	VGND#22	30.747387
Rf116	VGND#13	VGND#23	33.916985
Rf117	VGND#14	VGND#24	28.936274
Rf131	a_1069_81##2	a_1069_81##13	160.232803
Re2	SET_B	SET_B#7	18.638260
Re3	VPWR#3	VPWR#26	3.206809
Re4	VPWR#26	VPWR	0.460954
Re5	VPWR	VPWR#19	2.818802
Re6	VGND#3	VGND#26	3.206809
Re7	VGND#26	VGND	0.460954
Re8	VGND	VGND#12	2.818802
Re12	VPWR#10	VPWR#26	0.698413
Re15	VGND#7	VGND#26	0.698413
*
*       CAPACITOR CARDS
*
*
C1	a_871_74##6	a_619_368##13	3.44669e-18
C2	a_3177_368##9	a_3177_368##3	7.45444e-20
C3	SET_B#7	a_1789_424##2	1.01624e-17
C4	VPWR#21	SCE#1	1.47856e-19
C5	VGND#16	a_3177_368##5	4.49432e-19
C6	VGND#4	VGND#1	2.12594e-18
C7	a_1252_376#	VGND#21	1.78045e-17
C8	a_1789_424#	VPWR#10	6.28249e-17
C9	a_304_464##4	D#1	4.29468e-17
C10	VPWR#19	SCD#3	2.83251e-18
C11	a_304_464##2	CLK#2	1.40975e-18
C12	a_871_74##3	a_619_368##2	1.30908e-18
C13	a_2513_258##4	Q_N#3	1.09261e-18
C14	VGND#9	a_619_368#	4.78133e-19
C15	VPWR#23	a_27_74##3	3.57353e-19
C16	Q_N#3	a_2067_74##13	1.43326e-18
C17	a_1794_74##4	a_1069_81##8	3.68408e-17
C18	a_871_74##6	a_1069_81##9	5.50748e-19
C19	a_1069_81##14	a_1069_81#	3.24544e-19
C20	CLK#2	a_619_368##6	5.44289e-18
C21	a_27_74##6	SCE#3	3.13617e-17
C22	SET_B#7	VPWR#12	3.25145e-18
C23	a_2513_258##4	a_2067_74##11	1.74062e-18
C24	SET_B#4	a_2067_74##6	2.10583e-17
C25	a_3177_368##10	a_2067_74#	2.48834e-17
C26	VPWR#19	a_27_74##3	7.26898e-19
C27	VGND#8	a_619_368#	1.30854e-19
C28	a_2067_74##22	VPWR#10	8.67037e-20
C29	a_619_368#	a_619_368##13	4.96914e-18
C30	a_619_368##19	VGND#22	5.5234e-17
C31	VGND#12	SCD#3	6.6322e-19
C32	a_1069_81##8	VGND#20	2.8096e-17
C33	a_2067_74##12	a_2067_74##5	1.23149e-17
C34	a_619_368##18	a_304_464##2	3.21204e-17
C35	VPWR#5	SET_B#6	9.10471e-20
C36	CLK#3	a_619_368##5	2.2895e-18
C37	a_871_74##6	a_1069_81##10	1.00096e-18
C38	VPWR#16	a_619_368##2	2.82895e-19
C39	a_2513_258##5	a_2067_74##15	4.22794e-18
C40	a_304_464##4	VPWR#20	1.27945e-17
C41	a_1794_74##2	a_1794_74#	2.52447e-18
C42	VGND#11	a_619_368##8	4.14478e-18
C43	a_2067_74##17	a_2067_74##12	1.31165e-18
C44	a_2067_74##13	VPWR#7	1.88969e-17
C45	SET_B#7	a_1789_424##4	7.53509e-18
C46	a_619_368#	a_1069_81##9	1.59898e-17
C47	VGND#24	a_27_74##7	2.80694e-18
C48	VPWR#19	D#1	1.52242e-18
C49	VGND#4	a_2067_74##8	5.01738e-19
C50	a_1789_424##2	VPWR#10	3.18687e-17
C51	a_304_464##4	SCE#1	5.95444e-18
C52	VPWR#2	a_2067_74##7	9.68136e-18
C53	a_2067_74##12	a_2067_74##4	1.10141e-18
C54	a_2067_74##20	a_2067_74##11	2.97703e-19
C55	a_871_74##6	SET_B#3	6.69661e-18
C56	VPWR#23	D#1	5.76048e-18
C57	a_1069_81##16	a_1069_81##14	3.68073e-19
C58	a_2513_258##5	a_2513_258#	7.99088e-20
C59	VPWR#8	a_619_368##14	2.75186e-19
C60	a_3177_368##6	a_3177_368##4	4.66375e-17
C61	a_2513_258##4	VPWR#7	9.18067e-17
C62	a_304_464##3	VPWR#21	4.10202e-17
C63	VGND#21	a_871_74#	2.16093e-18
C64	a_304_464##3	SCD#1	2.19464e-17
C65	a_619_368#	a_1069_81##10	6.36131e-17
C66	a_2513_258##5	SET_B#5	7.24378e-18
C67	VGND#16	a_2067_74#	3.06922e-18
C68	SET_B#7	VPWR#14	6.24505e-18
C69	VGND#12	SCD#2	2.17438e-19
C70	a_871_74##12	a_1069_81##3	1.72977e-17
C71	VPWR#19	SCE#1	8.57146e-19
C72	a_871_74##6	a_1069_81##3	1.6721e-18
C73	a_2513_258##4	a_2067_74##13	4.65918e-17
C74	VGND#13	VGND#11	8.99632e-19
C75	a_1069_81##14	a_1252_376#	1.47694e-17
C76	a_619_368##5	a_619_368##4	4.98457e-18
C77	SET_B#3	a_619_368#	1.92233e-17
C78	a_2067_74##15	a_2067_74##12	1.32173e-17
C79	VGND#17	a_3177_368##5	7.84576e-20
C80	VPWR#9	a_2067_74##11	8.43454e-20
C81	VGND#23	VGND#22	1.45087e-18
C82	a_3177_368##10	a_2067_74##8	1.84532e-18
C83	a_1252_376##7	SET_B#7	3.85633e-17
C84	VPWR#19	SCE#5	7.31637e-19
C85	a_304_464##2	a_619_368##5	2.16953e-20
C86	Q_N#3	a_2067_74##12	5.37315e-19
C87	VPWR#7	SET_B#6	4.91336e-19
C88	VPWR#23	SCE#1	4.26966e-17
C89	VGND#9	a_1069_81##8	5.4828e-18
C90	a_1794_74##2	a_2067_74##24	6.39818e-17
C91	a_2513_258#	SET_B#4	4.58156e-17
C92	VPWR#6	a_2067_74##9	5.12008e-19
C93	a_871_74##6	VPWR#13	2.22773e-19
C94	a_2067_74##20	a_2067_74##13	2.22459e-18
C95	Q_N#1	a_2067_74#	2.55977e-19
C96	SCD#2	CLK#3	7.48666e-18
C97	a_2067_74##20	VPWR#7	3.20484e-18
C98	VPWR#7	a_2067_74##12	4.08768e-19
C99	VGND#8	a_1069_81##8	2.61175e-19
C100	SCE#7	SCD#4	5.36487e-19
C101	VGND#21	a_619_368##8	6.86185e-19
C102	a_27_74##9	SCE#1	1.38898e-18
C103	a_2067_74##17	SET_B#5	9.83744e-20
C104	a_2067_74##7	a_3177_368##6	3.07393e-17
C105	a_619_368##4	SCD#2	2.89953e-19
C106	a_2513_258##4	SET_B#6	8.44239e-19
C107	a_2067_74##8	VGND#16	2.78229e-17
C108	a_2067_74##12	a_2513_258##4	3.23512e-17
C109	VGND#11	a_619_368##6	7.9598e-18
C110	a_2067_74##12	a_619_368##11	5.5715e-20
C111	a_1069_81##14	a_871_74#	4.04096e-17
C112	VPWR#9	a_2067_74##13	3.56735e-19
C113	VPWR#2	a_2067_74##9	1.58202e-19
C114	a_304_464##3	SCE#7	6.72721e-18
C115	a_2513_258##5	a_619_368##11	1.18506e-19
C116	VGND#10	VGND#20	2.3323e-20
C117	a_2277_455#	a_619_368##12	2.2581e-18
C118	a_2277_455#	VPWR#8	5.64587e-17
C119	VPWR#23	SCE#5	1.87666e-17
C120	SET_B#5	a_2067_74##5	2.70951e-17
C121	VGND#23	a_619_368##19	3.70128e-17
C122	a_871_74##12	a_1252_376##4	2.64116e-17
C123	a_2513_258##2	a_2513_258##5	1.39513e-18
C124	VPWR#7	a_2513_258##3	8.02823e-20
C125	a_3177_368##8	a_2067_74##7	4.47485e-18
C126	VGND#17	a_2067_74#	9.09079e-20
C127	a_871_74##10	a_1252_376#	5.00235e-19
C128	SET_B#7	VPWR#10	1.30899e-18
C129	a_619_368##11	a_2513_258##3	2.94942e-17
C130	a_1069_81##3	SET_B#2	5.14401e-18
C131	a_2067_74##20	SET_B#6	3.18144e-17
C132	a_2067_74##9	a_3177_368##6	3.32924e-19
C133	VPWR#8	a_2067_74##11	2.24738e-19
C134	a_1069_81##14	a_619_368##7	1.82639e-19
C135	a_2067_74##15	SET_B#5	1.37154e-17
C136	SCD#2	a_619_368##5	3.27296e-19
C137	a_2067_74##20	a_2513_258##4	3.27068e-17
C138	VPWR#9	VPWR#7	5.8248e-19
C139	a_27_74##9	SCE#5	3.03459e-17
C140	a_619_368##8	a_619_368##2	1.65796e-19
C141	VGND#8	a_1794_74##4	1.46762e-17
C142	Q_N#1	a_2067_74##8	4.57295e-17
C143	VPWR#15	a_619_368#	4.38218e-20
C144	a_304_464##4	a_418_464#	1.27955e-18
C145	SET_B#7	VGND#7	9.7907e-19
C146	VPWR#3	a_3177_368##3	3.55419e-18
C147	a_1069_81##16	a_871_74##13	1.96053e-17
C148	a_619_368##10	a_2513_258#	3.52047e-17
C149	CLK#2	a_619_368##5	2.56199e-17
C150	a_2513_258##5	Q_N#3	3.80252e-18
C151	a_1252_376##5	a_1069_81##2	6.15021e-17
C152	VGND#9	SET_B#2	2.08516e-19
C153	SET_B#6	VPWR#9	9.49753e-18
C154	VGND#13	CLK#1	6.83172e-19
C155	a_2277_455#	a_619_368##11	2.56002e-17
C156	a_2067_74##9	a_2067_74##7	6.296e-18
C157	VPWR#6	a_2067_74##11	7.22252e-18
C158	VPWR#13	a_619_368#	3.78973e-17
C159	a_619_368##8	a_1069_81##14	3.93616e-18
C160	VGND#16	a_2067_74##10	6.08833e-19
C161	VGND#3	a_3177_368##3	6.16985e-18
C162	a_3177_368##10	VGND#4	4.55599e-17
C163	a_871_74##12	a_1789_424##4	1.61806e-18
C164	VPWR#3	a_2067_74##12	5.2855e-18
C165	D#2	SCE#6	9.71202e-20
C166	a_2067_74##17	a_2513_258##2	8.2791e-17
C167	a_304_464##3	SCD#2	2.62019e-17
C168	a_2067_74##20	a_2513_258##3	1.36309e-18
C169	a_871_74##10	a_871_74#	2.37225e-18
C170	VPWR#11	a_619_368#	1.55906e-18
C171	a_27_74##4	a_304_464##3	1.99748e-17
C172	VGND#17	a_2067_74##8	6.55076e-19
C173	a_3177_368##8	VPWR#2	2.17145e-19
C174	a_2277_455#	SET_B#6	1.00009e-18
C175	VGND#3	a_2067_74##12	4.30409e-18
C176	Q_N#1	a_3177_368##8	1.32457e-17
C177	a_871_74##12	a_619_368##7	1.33308e-17
C178	VGND#11	CLK#1	4.10448e-18
C179	a_1794_74##2	VGND#19	6.3582e-17
C180	a_619_368##12	a_871_74##5	4.2076e-17
C181	SCD#2	CLK#2	2.63481e-17
C182	CLK	a_619_368##5	8.68577e-18
C183	a_304_464#	a_619_368##8	3.98884e-17
C184	a_3177_368##8	a_2067_74##9	9.26558e-19
C185	a_304_464##2	a_619_368##2	2.2774e-18
C186	Q_N#1	a_2067_74##10	3.73267e-17
C187	a_2513_258##3	VPWR#9	1.1202e-17
C188	a_1069_81##14	a_1069_81##2	1.7612e-18
C189	a_1252_376##3	a_1069_81##3	1.06185e-17
C190	a_2067_74##15	a_2513_258##2	1.14593e-17
C191	a_2067_74##21	a_619_368##12	1.74707e-18
C192	D#4	a_304_464##6	3.22822e-17
C193	a_1069_81##16	a_619_368##2	8.71596e-19
C194	a_304_464##3	VPWR#19	2.44002e-17
C195	a_2067_74##21	SET_B#6	4.54917e-19
C196	a_2513_258##2	a_2067_74##5	1.23448e-19
C197	a_2067_74##11	a_2067_74##9	5.18784e-17
C198	a_304_464##6	a_619_368##19	3.86355e-18
C199	VGND#20	VGND#8	3.14132e-20
C200	a_871_74##5	a_619_368##11	3.90513e-17
C201	VGND#10	a_1069_81##2	4.00241e-19
C202	VGND#16	a_2067_74##6	9.04875e-20
C203	VGND#2	a_3177_368#	2.55181e-18
C204	a_871_74##8	a_619_368##10	8.16856e-19
C205	a_1252_376##2	VGND#21	4.26337e-17
C206	VGND#16	VGND#4	4.61086e-18
C207	a_871_74##10	a_619_368##8	1.92776e-17
C208	VPWR#9	a_2067_74##20	3.5745e-17
C209	VPWR#19	a_304_464##2	2.01611e-17
C210	VGND#19	a_1069_81##7	4.42783e-19
C211	a_2277_455#	a_2513_258##3	2.6547e-17
C212	a_2513_258##2	a_2067_74##4	5.29254e-20
C213	VPWR#6	a_2067_74##13	3.46587e-18
C214	a_871_74##12	a_619_368##2	4.15727e-17
C215	VGND#9	a_1069_81##2	3.66969e-18
C216	VPWR#13	a_1069_81##8	1.48045e-21
C217	a_2067_74##10	VGND#17	1.15805e-17
C218	a_619_368##19	SCD#2	3.33669e-18
C219	VGND#13	SCD#4	8.04953e-18
C220	a_304_464##3	SCE#3	7.641e-19
C221	SCE#4	a_27_74##2	1.61291e-17
C222	a_2067_74##17	a_2067_74##15	2.62974e-19
C223	a_871_74##12	VPWR#14	5.50758e-17
C224	a_304_464##2	a_619_368##8	1.12452e-18
C225	a_304_464##3	D#2	8.06607e-19
C226	a_1794_74##2	a_1069_81##5	7.36278e-18
C227	a_619_368##14	a_2067_74##17	1.21947e-16
C228	a_1794_74##4	a_1794_74##2	2.3763e-18
C229	a_871_74##4	a_1252_376##3	1.98434e-19
C230	a_304_464#	a_619_368##6	1.40914e-18
C231	Q_N#1	a_2067_74##7	2.74813e-20
C232	a_27_74##7	SCE#7	1.37796e-19
C233	a_2277_455#	a_2513_258##2	8.99845e-19
C234	VPWR#11	a_1069_81##8	6.11673e-22
C235	VGND#3	VGND#1	5.37613e-17
C236	VPWR#19	a_1069_81##16	1.03883e-17
C237	a_2067_74##21	a_619_368##11	1.52425e-17
C238	a_1069_81##14	a_1252_376##2	4.69414e-17
C239	a_2067_74##2	a_3177_368##10	5.87445e-19
C240	a_871_74##2	a_619_368##7	2.09506e-18
C241	a_2067_74##21	a_2513_258##3	1.47853e-18
C242	a_871_74##12	a_871_74##4	3.0882e-19
C243	Q_N#1	a_2067_74##6	5.33393e-19
C244	VGND#5	a_3177_368##5	4.08392e-20
C245	a_2277_455##2	VPWR#8	2.02183e-17
C246	a_1789_424#	SET_B#6	2.86479e-19
C247	a_304_464##6	VGND#23	2.32282e-17
C248	a_3177_368##8	a_2067_74##11	2.47448e-19
C249	a_2067_74##13	a_2067_74##11	2.89383e-17
C250	VGND#3	a_3177_368#	4.34161e-18
C251	VGND#10	a_1252_376##5	1.56104e-17
C252	a_2513_258##7	a_2067_74##10	1.43902e-18
C253	Q_N#1	a_2067_74##5	6.55467e-19
C254	a_2277_455#	a_871_74##5	4.38436e-19
C255	a_304_464##3	a_495_74#	1.33625e-19
C256	a_1069_81##14	a_1274_81#	1.68424e-18
C257	a_871_74##10	a_619_368##6	4.67575e-17
C258	VPWR#8	SET_B#6	6.2086e-18
C259	a_2277_455##2	a_2513_258##3	1.76871e-19
C260	VGND#16	a_3177_368##10	5.89735e-17
C261	SCD#1	SCD#2	1.96681e-17
C262	a_619_368##15	a_619_368##12	3.3173e-17
C263	SCD	a_619_368##5	1.38433e-19
C264	VPWR#19	a_871_74##13	4.13887e-17
C265	VGND#3	a_3177_368##5	1.8049e-18
C266	a_871_74##7	a_871_74##8	2.55517e-17
C267	VGND#16	a_2067_74##3	1.03471e-17
C268	VGND#17	a_2067_74##6	1.63214e-18
C269	VPWR#3	Q_N#1	2.05034e-18
C270	a_2277_455#	a_619_368##14	1.16864e-19
C271	a_1794_74##4	VGND#19	5.90158e-17
C272	a_619_368##11	a_2513_258##2	8.00515e-17
C273	a_304_464#	CLK#1	1.44971e-19
C274	SET_B#6	a_2067_74##11	2.14142e-19
C275	SCD	SCD#2	1.34283e-17
C276	a_1069_81##5	a_871_74##5	6.73628e-20
C277	VGND#2	a_3177_368##5	7.34611e-18
C278	VPWR#20	VPWR#17	8.98194e-19
C279	VGND#10	a_1252_376##2	1.33696e-18
C280	a_2067_74##21	a_871_74##5	1.69891e-17
C281	a_2513_258##5	a_2513_258##4	1.70771e-18
C282	a_2277_455##2	a_619_368##12	2.18415e-17
C283	SET_B#7	a_871_74##6	8.72589e-17
C284	Q_N#1	a_2067_74##9	5.92857e-18
C285	a_1069_81##14	a_1252_376##3	3.09102e-19
C286	a_1252_376##7	a_871_74##12	1.20131e-16
C287	VPWR#6	SET_B#6	1.96738e-19
C288	VGND#18	a_2067_74##10	4.97969e-19
C289	a_1789_424#	a_2513_258##3	2.57669e-19
C290	a_619_368##6	VGND#22	1.82037e-17
C291	VGND#3	a_2067_74#	1.11811e-17
C292	VGND#3	a_3177_368##10	2.70949e-17
C293	a_871_74##13	a_619_368##18	1.9807e-19
C294	a_2067_74##17	a_871_74##6	2.4278e-18
C295	a_619_368##4	a_871_74##4	1.9754e-17
C296	VGND#13	SCE#6	5.56585e-18
C297	a_2277_455#	VPWR#9	3.79419e-17
C298	a_2067_74##21	a_2067_74##20	1.13532e-18
C299	a_1794_74##4	a_1069_81##7	1.64254e-17
C300	SET_B#7	a_619_368#	6.30119e-17
C301	a_2067_74##17	a_619_368##12	2.82017e-17
C302	a_27_74##6	a_27_74##4	1.97471e-18
C303	VGND#9	a_1252_376##5	2.01026e-18
C304	SET_B#6	a_2067_74##13	4.45557e-18
C305	VGND#24	D#4	1.3006e-17
C306	a_871_74##12	a_619_368##9	9.02756e-20
C307	a_871_74##5	a_2277_455##2	1.43309e-17
C308	VPWR#19	a_619_368##18	7.46886e-18
C309	VGND#23	SCD#2	6.90501e-18
C310	a_2513_258##7	a_2067_74##6	3.21419e-17
C311	a_871_74##10	CLK#1	1.38156e-18
C312	Q_N#1	a_2067_74##4	1.53632e-17
C313	a_619_368##11	a_2513_258#	1.11611e-17
C314	a_2277_455##2	a_619_368##14	2.87792e-20
C315	a_619_368##4	a_619_368##9	3.80256e-17
C316	VPWR#2	a_3177_368##2	4.5102e-20
C317	VGND#3	a_2067_74##8	8.11859e-18
C318	VGND#3	VGND#6	3.60952e-17
C319	VGND#7	a_871_74##6	8.33478e-19
C320	VGND#19	a_1069_81##5	7.52686e-19
C321	a_619_368##12	a_619_368##11	1.15445e-18
C322	a_619_368##19	a_619_368##6	2.50588e-19
C323	Q_N#1	a_3177_368##10	2.05979e-18
C324	SET_B#7	a_1069_81##8	7.99635e-18
C325	a_619_368##4	CLK#3	4.95075e-19
C326	a_2067_74##21	a_619_368##15	1.16247e-19
C327	VPWR#19	VPWR#21	1.96467e-17
C328	a_2277_455##2	a_619_368##11	4.17514e-19
C329	SET_B#4	a_2579_74#	9.87534e-18
C330	SET_B#5	a_2067_74##12	4.85029e-17
C331	Q#1	a_3177_368##2	6.40961e-18
C332	VGND#17	SET_B#4	1.46117e-19
C333	VGND#20	VGND#19	1.88974e-18
C334	VGND#3	a_2067_74##10	6.10506e-18
C335	a_619_368##18	VPWR#18	2.44434e-18
C336	a_1789_424#	a_871_74##5	1.06858e-18
C337	SCD#2	CLK#1	4.84215e-18
C338	VGND#3	Q_N#1	3.09645e-17
C339	VGND#3	VGND#5	7.92887e-17
C340	a_304_464#	a_304_464##2	2.637e-18
C341	VPWR#8	a_2513_258##3	7.33488e-18
C342	a_2513_258#	a_2579_74#	9.87534e-18
C343	a_1069_81##14	a_871_74##2	1.28242e-16
C344	a_1069_81##4	a_871_74##7	3.58688e-17
C345	VGND#22	CLK#1	4.09685e-17
C346	SET_B#7	SET_B#2	2.91136e-17
C347	Q_N#1	a_2067_74##11	1.91378e-19
C348	a_619_368##14	a_2067_74##22	3.80841e-17
C349	VGND#18	a_2067_74##6	1.12758e-17
C350	a_2067_74##12	a_2513_258##2	7.05239e-20
C351	VGND#12	a_619_368##18	5.7559e-18
C352	a_304_464##3	a_304_464##2	3.30783e-18
C353	SCE#2	a_304_464##3	3.42337e-18
C354	a_2277_455##2	a_619_368##15	1.11417e-18
C355	a_304_464#	a_871_74##2	2.84711e-19
C356	a_27_74##7	D#2	1.71884e-19
C357	VGND#3	a_2067_74##6	4.19045e-19
C358	VPWR#15	a_1069_81##2	7.70191e-20
C359	a_2277_455##2	a_871_74##6	2.86585e-19
C360	a_619_368##14	a_619_368##12	1.52494e-17
C361	VGND#3	VGND#2	8.66725e-17
C362	VGND#10	VGND#9	4.91435e-19
C363	a_871_74##12	VPWR#16	1.42368e-16
C364	VGND#2	a_2067_74#	4.78472e-18
C365	SCE#7	SCD#2	3.96287e-17
C366	a_2513_258##3	SET_B#6	3.16083e-17
C367	VGND#10	a_1252_376##3	2.26604e-19
C368	a_2067_74##22	a_871_74##5	1.70679e-19
C369	VGND#2	VGND#1	1.25309e-18
C370	a_2513_258##5	a_2067_74##11	2.33686e-18
C371	a_1069_81##2	SET_B#7	4.53441e-17
C372	a_2513_258##2	SET_B#5	8.66412e-17
C373	VPWR#19	a_304_464##4	2.3847e-17
C374	VPWR#6	a_2513_258##3	1.84787e-20
C375	a_27_74##8	D#4	1.1516e-18
C376	VPWR#6	a_2067_74##4	4.93645e-19
C377	a_2513_258##7	SET_B#4	1.27149e-18
C378	Q_N#1	a_2067_74##3	1.52784e-17
C379	SCE#3	D#1	1.57936e-17
C380	VPWR#13	a_1069_81##2	4.74298e-19
C381	a_2067_74##21	a_619_368##13	6.27029e-20
C382	a_619_368##14	a_619_368##11	7.18676e-18
C383	CLK#1	a_619_368##19	1.55838e-17
C384	a_871_74##13	a_619_368##2	2.44701e-17
C385	SCE	SCE#3	1.47912e-19
C386	VGND#3	a_2513_258##7	1.74415e-17
C387	a_2067_74##17	a_619_368##11	3.12681e-17
C388	a_619_368##12	a_1789_424#	2.11718e-17
C389	a_1789_424#	a_619_368##15	4.60481e-17
C390	VGND#13	D#3	7.16538e-20
C391	Q_N#1	VGND#16	6.94566e-17
C392	VGND#20	a_1794_74##4	1.32439e-17
C393	a_619_368##19	a_619_368##18	2.78798e-18
C394	a_2067_74##21	a_2277_455#	4.88784e-17
C395	a_2067_74##22	a_871_74##6	1.74719e-18
C396	a_871_74##3	a_1069_81##14	1.01725e-16
C397	VGND#22	SCD#4	6.4102e-19
C398	VGND#3	VGND#18	1.13533e-17
C399	a_2513_258##5	Q_N#1	2.61839e-17
C400	VGND#5	a_2067_74##8	7.3888e-19
C401	VPWR#19	VPWR#23	2.22675e-17
C402	SET_B#7	a_1252_376##3	2.0016e-18
C403	VGND#18	SET_B#4	2.96584e-17
C404	VPWR#11	a_619_368##12	3.03279e-19
C405	a_27_74##7	a_27_74##6	3.6908e-18
C406	a_304_464#	a_871_74##3	7.02088e-17
C407	VGND#23	CLK#1	1.86166e-18
C408	a_2067_74##22	a_619_368##15	2.38553e-17
C409	VGND#17	a_2067_74##4	6.99368e-18
C410	SCE#7	SCD#3	9.58391e-18
C411	VPWR#19	a_1069_81##2	2.45657e-18
C412	a_2513_258#	a_2501_74#	9.87534e-18
C413	a_1069_81##11	a_1069_81##4	2.94929e-17
C414	a_1794_74##4	a_1069_81##5	6.79731e-19
C415	VPWR#8	a_871_74##5	1.26172e-18
C416	VPWR#19	a_27_74##6	3.08657e-18
C417	a_619_368#	a_1789_424#	1.08736e-19
C418	a_619_368##10	a_2501_74#	9.87534e-18
C419	a_871_74##10	a_871_74##3	4.75412e-18
C420	VPWR#19	a_27_74##9	1.96275e-17
C421	a_1789_424#	a_619_368##11	1.46109e-19
C422	a_871_74##2	SET_B#7	4.51031e-18
C423	a_1789_424#	a_619_368##13	7.54961e-18
C424	a_2513_258##7	a_2513_258#	1.29722e-19
C425	a_619_368##14	a_1069_81##5	2.77013e-19
C426	a_619_368##19	SCD#4	1.81022e-18
C427	VGND#12	a_1069_81##2	3.79255e-19
C428	Q_N#1	a_2067_74##2	5.28388e-19
C429	VPWR#19	a_1252_376##2	1.97679e-19
C430	a_1789_424##2	VPWR#11	5.88609e-18
C431	a_27_74##4	SCD#3	3.00449e-17
C432	VPWR#15	a_1252_376##2	4.64632e-20
C433	a_1789_424##2	a_619_368##15	5.37267e-19
C434	a_619_368##14	a_871_74##6	1.15651e-16
C435	a_619_368#	a_2067_74##22	3.22908e-17
C436	SET_B#7	VGND#9	5.43772e-18
C437	a_2277_455##2	a_2277_455#	2.09155e-18
C438	a_2513_258##5	a_2067_74##13	2.92463e-19
C439	VGND#2	a_2067_74##8	1.30732e-19
C440	VGND#17	VGND#16	1.74139e-18
C441	a_871_74##6	a_1789_424##4	7.5929e-18
C442	a_304_464##2	a_1252_376##4	1.78276e-19
C443	VGND#10	a_871_74##2	5.38384e-19
C444	VGND#6	a_2067_74##10	1.9909e-19
C445	a_1069_81##14	a_619_368##4	9.59249e-20
C446	VPWR#3	VPWR#8	2.37099e-17
C447	VPWR#19	a_1252_376##3	1.07528e-18
C448	VGND#24	a_304_464##6	2.42714e-18
C449	a_2067_74##22	a_619_368##13	3.88518e-17
C450	a_619_368#	a_1789_424##2	3.53342e-17
C451	a_871_74##6	a_619_368##12	4.24014e-17
C452	SET_B#7	VGND#8	1.58767e-18
C453	a_2067_74##18	a_2067_74##6	1.33202e-19
C454	a_27_74##4	D#1	5.40648e-17
C455	VGND#23	SCD#4	3.0266e-17
C456	a_871_74##6	VPWR#14	2.87982e-17
C457	a_304_464#	a_619_368##4	3.27958e-17
C458	VGND#12	a_27_74##7	6.32686e-19
C459	VGND#18	a_2513_258#	4.10103e-18
C460	VGND#13	a_27_74#	1.67365e-20
C461	VGND#12	a_1252_376##3	1.44673e-18
C462	SCE#3	SCE#1	2.96963e-19
C463	D#4	a_229_74#	8.61107e-21
C464	VPWR#13	VPWR#12	7.9257e-19
C465	VPWR#11	a_619_368##15	2.0358e-19
C466	a_27_74##4	SCE#3	6.05746e-19
C467	VPWR#19	a_871_74##2	1.17129e-18
C468	VPWR#12	a_619_368#	2.39552e-19
C469	VPWR#3	VPWR#6	7.96236e-17
C470	a_871_74##6	a_619_368#	1.80671e-16
C471	VPWR#3	a_2067_74##5	6.13905e-19
C472	a_1789_424#	a_1069_81##9	2.8353e-19
C473	a_871_74##6	a_619_368##11	6.79905e-18
C474	a_304_464##6	CLK#1	2.83256e-19
C475	a_871_74##10	a_619_368##4	2.9853e-17
C476	a_1252_376##7	a_871_74##6	2.1485e-17
C477	a_2067_74##22	a_619_368##12	1.27157e-17
C478	VGND#1	VPWR#1	1.03343e-17
C479	a_619_368##19	SCE#6	1.42882e-19
C480	a_1789_424##2	a_619_368##13	2.42862e-17
C481	a_27_74##7	SCE#2	3.8852e-17
C482	SET_B#1	a_1069_81##11	2.37182e-18
C483	a_304_464##6	SCD#3	3.56676e-19
C484	a_304_464##3	VPWR#20	4.33502e-18
C485	VGND#5	a_2067_74##10	7.50164e-18
C486	a_2277_455##2	a_2067_74##21	3.46955e-17
C487	a_619_368##18	a_619_368##5	8.06874e-19
C488	VGND#12	a_871_74##2	8.1278e-18
C489	a_871_74##12	a_1201_463#	9.47454e-18
C490	a_2513_258##7	a_619_368##10	1.66217e-19
C491	a_619_368#	a_1789_424##4	7.11533e-17
C492	a_1069_81##8	a_871_74##6	6.00712e-17
C493	VPWR#19	a_871_74##3	5.62008e-18
C494	a_871_74##6	a_1069_81##7	2.33154e-17
C495	VPWR#3	VPWR#2	8.39683e-17
C496	VPWR#3	a_2067_74##4	9.18743e-19
C497	a_27_74##6	SCE#2	7.51776e-17
C498	VGND#10	a_1069_81##14	2.85199e-17
C499	a_2067_74##22	a_1069_81##9	2.62953e-18
C500	a_1252_376##5	a_1794_74##4	2.94704e-18
C501	a_304_464##6	SCD#2	7.84232e-18
C502	VGND#17	Q_N#1	4.6733e-17
C503	a_1069_81##16	a_871_74##12	1.05461e-16
C504	a_619_368##19	a_619_368##4	1.42251e-19
C505	a_871_74##12	a_619_368#	1.0279e-17
C506	VPWR#8	a_619_368##12	9.20385e-18
C507	VPWR#14	a_619_368#	1.38336e-17
C508	VGND#12	a_871_74##3	4.97674e-18
C509	a_1069_81##8	a_619_368#	1.43188e-17
C510	a_304_464##6	a_495_74#	1.85051e-18
C511	a_871_74##6	SET_B#2	6.8846e-17
C512	a_2067_74##15	a_2067_74##11	4.22463e-20
C513	VPWR#19	a_619_368##4	5.49371e-18
C514	a_304_464##2	a_619_368##7	1.27555e-18
C515	VGND#23	SCE#6	3.34427e-18
C516	VGND#11	a_871_74##3	1.01422e-19
C517	VPWR#3	a_2067_74##3	1.27002e-18
C518	a_2067_74##18	SET_B#4	1.20976e-18
C519	a_2067_74##15	a_2513_258##4	3.99008e-17
C520	a_1252_376##7	a_619_368#	1.87269e-19
C521	SET_B#2	a_619_368#	1.19729e-17
C522	a_1069_81##2	a_871_74##6	1.16161e-17
C523	VGND#18	a_619_368##10	2.08215e-18
C524	VGND#9	VGND#8	6.06097e-19
C525	VGND#12	a_619_368##4	6.20604e-18
C526	a_871_74##6	a_1069_81##5	1.90574e-17
C527	a_304_464##6	SCD#4	7.45995e-18
C528	a_1789_424##2	a_1069_81##9	5.52974e-17
C529	a_619_368##13	a_619_368##15	3.49314e-17
C530	VGND#10	a_871_74##3	5.09604e-19
C531	SCE#2	D#1	1.63236e-18
C532	a_1069_81##9	a_871_74##5	1.01921e-19
C533	VGND#6	a_2067_74##6	4.83529e-18
C534	VPWR#19	CLK#2	2.12457e-18
C535	Q	a_3177_368##2	1.61082e-17
C536	a_3177_368##9	a_3177_368##2	3.92147e-20
C537	a_1789_424#	a_2067_74##21	6.37205e-19
C538	VPWR#3	a_2067_74##2	1.96779e-18
C539	a_1069_81##8	SET_B#2	1.28604e-17
C540	VPWR#16	a_619_368#	7.62823e-20
C541	Q	a_2067_74##2	1.72022e-19
C542	a_304_464##4	VPWR#21	1.1917e-17
C543	CLK#2	VGND#22	2.20941e-17
C544	VGND#12	CLK#2	4.54388e-18
C545	a_2067_74##22	a_1069_81##10	8.12261e-19
C546	a_1789_424##4	VPWR#13	6.97848e-18
C547	a_1252_376##4	a_1201_463#	8.27123e-18
C548	VPWR#11	a_619_368##13	4.71289e-19
C549	VPWR#14	a_1069_81##8	3.49184e-19
C550	VPWR#19	SCD#1	2.75917e-18
C551	VGND#3	a_3177_368##2	3.06952e-19
C552	a_304_464##3	VPWR#17	2.06885e-17
C553	D#2	SCD#2	8.593e-19
C554	a_1069_81##9	VPWR#12	1.63025e-17
C555	a_1069_81#	SET_B#1	4.20114e-17
C556	a_2067_74##17	VPWR#8	7.1796e-19
C557	a_1794_74#	SET_B#4	3.5478e-19
C558	a_619_368#	a_619_368##12	2.56107e-18
C559	a_1069_81##2	a_1069_81##8	1.52336e-18
C560	a_1252_376##5	VGND#20	1.26144e-17
C561	a_619_368##19	CLK#2	2.33936e-17
C562	VPWR#3	a_3177_368##8	1.81731e-18
C563	a_2513_258##7	Q_N#1	1.53839e-18
C564	VGND#12	SCD#1	1.75679e-18
C565	VPWR#11	a_1069_81##7	3.58441e-20
C566	SCE#3	D#2	1.73065e-17
C567	VGND#23	D#3	5.69681e-19
C568	VGND#5	a_2067_74##6	9.6402e-19
C569	SET_B#1	a_1567_74#	9.87534e-18
C570	VPWR#19	SCE#7	6.45386e-19
C571	a_1069_81##2	SET_B#2	5.45447e-17
C572	a_1789_424##2	a_1069_81##10	1.60717e-18
C573	VGND#3	a_2067_74##5	2.04915e-18
C574	VPWR#20	a_619_368##2	1.75643e-20
C575	VGND#6	a_2067_74##5	8.1e-20
C576	a_2067_74##15	a_619_368##11	2.73716e-19
C577	a_1069_81#	a_1567_74#	9.87534e-18
C578	a_2067_74##18	a_2513_258#	3.0133e-18
C579	a_304_464##6	SCE#6	3.80885e-17
C580	a_1789_424#	a_2277_455##2	4.07734e-17
C581	a_2067_74##22	a_2067_74##21	6.40884e-19
C582	VGND#12	D#4	1.80179e-17
C583	a_1789_424##4	a_1069_81##9	4.50208e-19
C584	a_304_464##2	a_871_74##4	2.59384e-17
C585	VGND#12	SCE#7	1.23267e-18
C586	a_1069_81##9	a_619_368##13	5.04573e-17
C587	VPWR#8	a_619_368##11	1.17098e-17
C588	a_2067_74##15	a_2067_74##13	8.88103e-19
C589	VGND#7	a_871_74##8	4.4773e-18
C590	a_1252_376##2	SET_B#2	9.00472e-21
C591	VPWR#19	a_27_74##4	9.2304e-18
C592	a_619_368#	a_1069_81##7	1.40817e-17
C593	SCD	a_304_464##3	1.98866e-18
C594	VGND#24	SCD#4	3.80865e-19
C595	a_1789_424##4	VPWR#11	1.1594e-17
C596	VGND#3	a_2067_74##4	6.19767e-18
C597	VGND#11	a_619_368##4	4.13363e-19
C598	VPWR#12	a_1069_81##10	3.17785e-17
C599	VPWR#15	VPWR#13	2.54036e-19
C600	SET_B#7	a_1794_74#	1.62641e-20
C601	VGND#12	a_27_74##4	3.1515e-18
C602	a_1069_81##2	a_1252_376##2	8.51007e-17
C603	a_27_74##8	VGND#24	3.20655e-17
C604	VGND#7	a_871_74##7	4.42789e-18
C605	VGND#2	a_3177_368##10	4.4434e-18
C606	a_1252_376##7	SET_B#2	4.13571e-18
C607	a_619_368##18	SCD#2	1.21546e-17
C608	VGND#6	SET_B#4	8.16112e-18
C609	VGND#21	VGND#20	1.39681e-18
C610	VGND#11	a_871_74##10	8.61517e-17
C611	a_1794_74#	a_2513_258#	5.04872e-19
C612	a_3177_368##8	a_3177_368##2	1.99374e-19
C613	VGND#3	a_2067_74##3	4.83732e-18
C614	a_1789_424#	a_871_74##7	1.97058e-20
C615	VGND#23	a_27_74#	2.77712e-19
C616	a_1069_81##2	a_1252_376##3	9.73456e-17
C617	a_871_74##2	SET_B#2	2.50137e-20
C618	SET_B#7	a_2067_74##24	7.14283e-19
C619	VGND#12	D#2	1.778e-20
C620	a_2513_258##7	VGND#17	3.67229e-17
C621	a_1252_376#	a_1069_81#	3.42932e-18
C622	a_619_368#	a_1069_81##5	7.01246e-18
C623	a_304_464##3	a_619_368##9	2.57613e-19
C624	SCD#1	VGND#23	1.63696e-17
C625	SCD#3	a_418_464#	1.53392e-17
C626	VPWR#2	a_2067_74##2	1.6849e-20
C627	VPWR#23	VPWR#21	3.49519e-19
C628	a_1789_424##4	a_1069_81##10	5.05356e-17
C629	VGND#7	a_1069_81##4	9.83623e-20
C630	VPWR#11	a_1069_81##9	5.02691e-18
C631	VPWR#19	a_27_74##2	5.15387e-21
C632	VGND#5	VGND#16	3.14574e-19
C633	VGND#18	a_2513_258##5	3.13001e-17
C634	D#3	a_304_464##6	1.57073e-17
C635	a_304_464##2	VPWR#17	3.58707e-17
C636	a_2067_74##18	a_619_368##10	4.08872e-17
C637	a_27_74##3	a_418_464#	1.53392e-17
C638	a_1252_376##2	a_1252_376##3	3.55776e-18
C639	a_871_74##2	a_1069_81##2	3.40112e-17
C640	VGND#3	a_3177_368##8	1.86202e-18
C641	VGND#3	a_2067_74##2	2.16144e-18
C642	a_1069_81##10	a_1069_81##9	5.0537e-17
C643	VGND#12	a_27_74##2	5.78195e-18
C644	SET_B#7	a_1794_74##2	5.48011e-18
C645	VGND#24	SCE#6	8.44724e-19
C646	VGND#13	VGND#22	4.49522e-20
C647	SET_B#7	VPWR#13	2.86814e-18
C648	a_871_74##13	a_871_74##12	1.08186e-18
C649	a_304_464##2	a_619_368##9	2.87796e-17
C650	VPWR#19	SCE#2	5.0208e-18
C651	VGND#5	SET_B#4	1.04459e-19
C652	a_2067_74##17	a_2277_455#	3.01576e-17
C653	a_871_74##2	a_1252_376##2	2.42806e-17
C654	a_304_464##6	SCD#1	4.83895e-17
C655	VPWR#14	a_1069_81##10	9.20969e-19
C656	a_1252_376#	a_1274_81#	7.44515e-18
C657	a_2067_74##22	a_871_74##7	2.82921e-19
C658	a_1252_376##7	a_1069_81##2	3.49425e-17
C659	VPWR#20	SCD#2	1.26613e-19
C660	SCE	a_304_464##3	1.44703e-17
C661	a_871_74#	a_1274_81#	7.00001e-18
C662	a_2067_74##15	SET_B#6	9.06081e-18
C663	VGND#12	SCE#2	7.56695e-18
C664	VPWR#17	a_871_74##3	1.52344e-19
C665	SCE#3	a_27_74##2	3.21497e-17
C666	SET_B#7	VGND#19	3.45672e-18
C667	a_619_368##19	SCE#7	2.06366e-19
C668	a_871_74##2	a_1252_376##3	2.38908e-17
C669	VPWR#21	a_619_368##2	7.99422e-21
C670	VGND#10	a_871_74##10	1.38278e-17
C671	SET_B#7	VPWR#11	1.47862e-18
C672	D#1	a_220_464#	1.62684e-17
C673	a_2067_74##15	VPWR#9	2.21065e-17
C674	a_1789_424##4	SET_B#3	1.18002e-18
C675	a_1794_74#	a_619_368##10	2.35967e-18
C676	a_1789_424#	a_2067_74##22	7.25341e-17
C677	VPWR#17	a_619_368##2	1.50712e-17
C678	VPWR#15	a_871_74##3	1.35885e-19
C679	VGND#5	a_2067_74##5	3.52515e-19
C680	a_2067_74##17	a_2513_258##3	7.70155e-18
C681	SCE#1	a_220_464#	1.62684e-17
C682	a_871_74##3	a_1252_376##3	4.68944e-18
C683	VPWR#13	a_1069_81##10	9.30868e-19
C684	a_304_464##6	a_27_74#	2.76255e-19
C685	VGND#18	VGND#17	1.86305e-18
C686	VGND#11	CLK#2	6.86047e-19
C687	SET_B#7	a_1794_74##4	4.46797e-18
C688	VGND#2	Q	1.62822e-17
C689	CLK	a_304_464#	6.12829e-18
C690	a_1789_424##2	a_871_74##7	2.56176e-19
C691	a_304_464##6	a_304_464##3	8.1172e-19
C692	a_304_464##3	CLK#3	3.11682e-17
C693	a_871_74#	a_1252_376#	3.23964e-17
C694	a_2067_74##18	a_871_74##8	1.56968e-18
C695	a_304_464##3	a_418_464#	1.79899e-18
C696	VGND#24	D#3	4.21187e-18
C697	VGND#2	a_3177_368##2	5.87174e-20
C698	VGND#6	a_2513_258#	8.95701e-18
C699	a_871_74##3	a_871_74##2	6.2834e-18
C700	VGND#7	a_2067_74##18	1.57607e-17
C701	SET_B#3	VPWR#14	1.002e-17
C702	VGND#22	CLK	2.03921e-17
C703	a_3177_368##3	VGND#4	4.16204e-17
C704	a_304_464##6	SCE#7	1.53213e-17
C705	SET_B#7	VGND#20	2.88048e-18
C706	VPWR#23	a_304_464##4	2.32346e-17
C707	VPWR#11	a_1069_81##10	5.22524e-18
C708	a_2067_74##24	a_619_368##10	7.27517e-20
C709	VPWR#21	SCD#2	1.98005e-18
C710	a_3177_368##8	a_3177_368#	8.27757e-21
C711	a_619_368##4	a_871_74##2	5.64644e-19
C712	VGND#5	Q_N#1	1.00855e-17
C713	a_2067_74##15	VPWR#8	1.7421e-18
C714	VGND#12	VGND#13	8.01735e-17
C715	a_2513_258##2	a_2067_74##10	1.08964e-20
C716	a_1069_81##5	a_871_74##7	1.82932e-17
C717	VGND#7	a_1794_74#	5.43113e-17
C718	a_304_464##2	CLK#3	4.57697e-18
C719	a_1789_424##2	a_1789_424#	3.48911e-18
C720	a_3177_368##8	Q	5.96312e-19
C721	VGND#3	a_2513_258##5	7.84674e-18
C722	a_1069_81##2	a_871_74##12	6.09074e-18
C723	a_1252_376##7	SET_B#3	9.20866e-18
C724	VGND#21	a_1252_376##5	2.89578e-17
C725	a_619_368##4	a_871_74##3	3.67843e-17
C726	a_2067_74##17	a_2067_74##21	3.27148e-19
C727	a_27_74##8	D#3	4.28089e-19
C728	a_1794_74#	a_871_74##8	3.61384e-17
C729	VGND#12	VGND#11	1.0195e-16
C730	a_2067_74##15	a_2513_258##3	4.61316e-18
C731	a_1069_81##7	a_1069_81##4	2.95987e-18
C732	VGND#18	a_2513_258##7	3.89872e-17
C733	VPWR#17	a_619_368##4	4.71773e-19
C734	a_1069_81##3	SET_B#3	1.84509e-17
C735	VPWR	a_619_368##12	1.81083e-20
C736	VGND#24	a_27_74#	3.1956e-17
C737	VGND#24	SCE#3	1.10987e-18
C738	SCE#2	SCD#2	3.88029e-19
C739	a_2513_258##7	a_619_368##11	2.30856e-20
C740	a_2513_258##2	SET_B#4	8.65405e-18
C741	a_2067_74##17	a_871_74##5	2.18175e-17
C742	VGND#12	VGND#10	7.4528e-17
C743	a_619_368##4	CLK#2	9.90133e-19
C744	VPWR#3	a_2067_74##15	7.10723e-18
C745	SCD	a_619_368##19	3.56896e-17
C746	VGND#7	a_1794_74##2	4.32817e-17
C747	VPWR	a_619_368##2	8.23343e-18
C748	SCE#2	SCE#3	3.37407e-17
C749	VGND#5	a_2067_74##4	5.88124e-20
C750	VPWR#16	a_1252_376##3	1.73796e-18
C751	SCD	VGND#23	1.73151e-17
C752	a_304_464##3	SCD#3	3.16964e-17
C753	VPWR#13	VPWR#11	1.75469e-18
C754	a_619_368##8	a_871_74#	2.89337e-18
C755	a_1789_424##2	a_1069_81##5	2.30593e-19
C756	a_27_74##7	D	4.41446e-19
C757	VPWR#13	SET_B#3	9.70222e-19
C758	a_1789_424##2	a_2067_74##22	4.84497e-17
C759	a_27_74##6	VPWR#23	4.00395e-17
C760	a_2067_74##24	a_871_74##8	3.73292e-17
C761	a_1252_376##7	a_1069_81##3	3.37849e-17
C762	VPWR#12	a_1069_81##7	2.43007e-19
C763	a_2513_258##2	a_2513_258#	6.53098e-18
C764	a_3177_368##8	a_2067_74##4	3.9812e-19
C765	VPWR#15	a_619_368##2	6.40323e-17
C766	VGND#2	a_3177_368##8	2.51915e-19
C767	VPWR#3	a_3177_368##4	3.9287e-18
C768	VGND#12	a_1252_376#	8.33995e-18
C769	a_27_74##8	a_27_74#	1.96633e-18
C770	VGND#6	a_619_368##10	6.39185e-18
C771	VGND#11	a_619_368##19	1.67731e-18
C772	VPWR#5	a_2067_74##3	7.48733e-18
C773	a_304_464##2	SCD#3	5.32185e-19
C774	VPWR#2	VPWR#1	7.06672e-19
C775	a_3177_368##8	a_3177_368##5	1.37252e-20
C776	a_1794_74#	a_871_74##7	4.24687e-19
C777	SET_B#2	a_1069_81##7	1.36199e-18
C778	a_2067_74##15	VPWR#6	5.56674e-19
C779	a_1069_81##16	a_1252_376##3	7.08067e-19
C780	a_1069_81##3	VPWR#16	2.74359e-18
C781	VGND#12	a_871_74#	1.31539e-17
C782	a_1252_376##4	a_1069_81##3	3.70149e-18
C783	a_871_74##12	a_1252_376##2	3.98312e-19
C784	VPWR#3	a_3177_368##6	2.46039e-18
C785	SCE#4	VGND#24	1.68744e-17
C786	a_2067_74##17	a_2277_455##2	2.63721e-17
C787	a_1794_74##2	a_871_74##8	1.97511e-18
C788	D#2	a_304_464##6	9.63863e-19
C789	SCD#1	SCE#7	4.43222e-18
C790	Q#1	VPWR#1	1.08097e-16
C791	a_1252_376##7	a_1252_376##4	3.83732e-19
C792	VGND#12	a_619_368##8	2.17862e-18
C793	a_1069_81##7	a_1069_81##5	1.63083e-17
C794	VPWR#15	a_1069_81##3	1.0859e-18
C795	Q_N#1	a_2067_74##12	5.27546e-19
C796	SCD#4	a_495_74#	4.13345e-18
C797	VGND#6	a_2513_258##7	1.02088e-17
C798	VPWR#3	a_2067_74##7	1.08563e-17
C799	SCE	a_304_464##6	8.26507e-17
C800	a_2067_74##21	a_2067_74##15	1.828e-18
C801	SCE#6	a_495_74#	7.53088e-18
C802	VPWR#17	CLK#2	1.09852e-18
C803	a_871_74##7	a_2067_74##24	1.41565e-17
C804	VGND#8	a_871_74##8	2.98797e-19
C805	a_27_74##9	VPWR#23	5.80678e-17
C806	VPWR#19	VPWR#20	8.29759e-17
C807	a_2067_74##17	a_619_368##15	1.016e-19
C808	a_619_368##6	a_619_368##8	3.10217e-18
C809	a_304_464##3	a_27_74##3	1.05191e-19
C810	a_27_74##8	SCE#4	2.17199e-17
C811	a_27_74##6	a_27_74##9	5.04052e-21
C812	a_1069_81##16	a_871_74##2	1.85378e-17
C813	VGND#12	a_619_368##6	1.53159e-18
C814	a_1069_81##14	a_1252_376##5	2.77231e-18
C815	SCE#7	a_27_74##4	1.6378e-17
C816	SCD#1	D#2	9.45017e-20
C817	VPWR#16	a_1252_376##4	2.75344e-17
C818	CLK	a_619_368##18	3.69391e-18
C819	VGND#13	SCE#7	7.52837e-19
C820	VPWR#3	a_2067_74##9	5.54172e-18
C821	VGND#5	a_2067_74##3	1.20425e-20
C822	a_871_74##8	a_619_368##14	2.45459e-18
C823	VGND#1	Q	7.51017e-17
C824	a_619_368##7	a_1252_376##4	3.67434e-17
C825	SET_B#3	a_619_368##2	5.91418e-18
C826	VPWR#19	VPWR#17	1.47624e-16
C827	a_3177_368##8	a_2067_74##3	1.99371e-18
C828	Q	Q#2	2.42853e-19
C829	D#2	SCE#7	3.28816e-17
C830	VGND#4	Q	6.37352e-17
C831	a_3177_368##10	Q	4.86259e-20
C832	VGND#12	CLK#1	1.10277e-18
C833	a_1789_424##2	VPWR#12	5.24783e-17
C834	VGND#6	VGND#5	1.13184e-18
C835	VPWR	VPWR#15	6.72607e-17
C836	VPWR#12	a_1069_81##5	2.15808e-19
C837	a_2067_74##18	a_2513_258##5	4.17714e-19
C838	a_619_368##14	a_871_74##7	1.59605e-19
C839	a_1794_74##2	a_871_74##7	5.49117e-17
C840	VPWR	VPWR#13	9.42858e-17
C841	VPWR#4	VPWR#1	2.00319e-18
C842	a_27_74##4	D#2	1.73692e-18
C843	VPWR#3	a_2067_74##11	4.99277e-18
C844	VPWR	VPWR#11	5.64259e-17
C845	a_3177_368##8	a_2067_74#	1.00967e-19
C846	VPWR	VPWR#8	1.13811e-16
C847	Q#1	VPWR#2	1.64371e-17
C848	VPWR#19	VPWR#15	1.10528e-16
C849	VPWR#13	a_619_368##2	5.74273e-18
C850	a_1789_424##4	a_1069_81##7	5.56677e-19
C851	a_871_74##12	a_1252_376##3	9.51111e-17
C852	D	a_304_464##6	3.94571e-18
C853	a_871_74##4	a_1252_376##4	1.01525e-18
C854	VGND#12	SCD#4	3.47575e-18
C855	a_27_74##7	D#3	7.75279e-20
C856	a_27_74##4	a_27_74##2	1.42748e-18
C857	a_871_74##3	a_1069_81##16	4.18258e-17
C858	VGND#5	a_2513_258##7	7.42021e-18
C859	SCD	a_619_368##18	4.49747e-17
C860	a_27_74##8	D	1.28595e-18
C861	VPWR#16	a_619_368##7	1.087e-18
C862	VPWR#3	a_2067_74##13	1.15376e-17
C863	VPWR#3	VPWR#1	5.47542e-17
C864	a_27_74##2	VGND#24	3.56019e-17
C865	a_1069_81##2	a_1069_81##7	3.39867e-19
C866	a_27_74##2	D#2	5.0072e-17
C867	SCE#2	a_27_74##4	1.23249e-17
C868	a_1069_81##16	a_1252_376##4	1.33103e-18
C869	a_1069_81##14	VGND#21	3.01009e-17
C870	VPWR	a_2067_74##17	8.28858e-18
C871	D#3	a_229_74#	7.57269e-18
C872	VGND#12	SCE#6	2.80524e-18
C873	VPWR	a_2067_74##15	1.68881e-18
C874	CLK#1	a_619_368##6	2.84912e-17
C875	a_871_74##6	a_871_74##7	1.35951e-17
C876	VGND#19	a_871_74##7	1.0876e-18
C877	VPWR#15	a_1252_376##4	4.18261e-19
C878	a_304_464##3	D#1	1.83564e-19
C879	a_871_74##4	a_619_368##7	2.67967e-17
C880	a_27_74#	a_229_74#	1.54461e-18
C881	SCE#2	D#2	1.7817e-17
C882	SET_B#7	a_1069_81##7	9.30688e-19
C883	a_1789_424##4	a_1789_424##2	2.70417e-18
C884	a_1069_81##14	a_871_74##12	4.02153e-19
C885	a_2067_74##17	a_619_368##13	6.41989e-20
C886	VPWR	a_871_74##12	3.88953e-17
C887	a_871_74##3	a_871_74##13	3.65042e-18
C888	VPWR#3	Q#1	2.01198e-17
C889	VGND#8	a_871_74##7	6.4298e-19
C890	VPWR#4	Q#1	8.59254e-17
C891	a_27_74##2	SCE#2	5.78498e-17
C892	VGND#12	D#3	9.82572e-19
C893	VGND#3	a_2067_74##13	5.77189e-19
C894	a_1794_74##2	a_1069_81##4	1.78752e-17
C895	a_2067_74##5	a_2067_74##4	5.45684e-19
C896	a_1069_81##16	a_619_368##4	1.13036e-19
C897	a_2067_74##18	a_2513_258##7	6.78299e-19
C898	a_3177_368##8	a_2067_74##2	5.49719e-17
C899	VGND#16	VPWR#5	8.91572e-18
C900	VGND#12	a_27_74#	2.90474e-19
C901	a_619_368#	a_871_74##7	2.84139e-18
C902	SCE	a_304_464##4	2.78807e-18
C903	a_1794_74##4	a_871_74##7	1.91698e-19
C904	a_1069_81##16	a_619_368##7	3.36447e-17
C905	VGND#2	a_3177_368##3	8.88682e-19
C906	VGND#18	SET_B#5	9.32412e-19
C907	VPWR#7	a_2067_74##4	6.27008e-18
C908	VGND#3	VPWR#1	4.93889e-18
C909	Q	Q#1	3.04969e-18
C910	a_27_74##7	a_27_74#	1.99454e-19
C911	a_871_74##13	a_1252_376##4	4.52836e-20
C912	CLK	a_619_368##6	2.32623e-19
C913	a_871_74##12	a_871_74##2	1.179e-19
C914	SET_B#7	a_1069_81##5	1.50437e-18
C915	a_3177_368##8	a_2067_74##8	2.57146e-20
C916	a_1069_81##3	a_619_368##2	1.91998e-17
C917	a_1789_424##4	VPWR#12	6.4158e-17
C918	a_619_368##4	a_871_74##13	1.28943e-17
C919	a_3177_368##9	VPWR#3	2.51223e-17
C920	VGND#6	a_2513_258##5	3.16169e-19
C921	VGND#12	SCE#4	6.94893e-19
C922	a_1794_74##2	a_619_368##13	3.65457e-19
C923	a_2067_74##22	a_2067_74##17	7.82287e-19
C924	VGND#19	a_1069_81##4	3.06853e-17
C925	VGND#3	Q#1	1.51368e-18
C926	a_1789_424##4	a_1069_81##5	2.12414e-20
C927	VPWR#10	a_619_368##12	1.36925e-17
C928	VGND#18	VGND#5	6.37042e-19
C929	SCD#4	CLK#1	3.15515e-18
C930	VPWR#1	a_3177_368##4	3.26206e-17
C931	a_3177_368##9	Q#1	5.04822e-19
C932	a_304_464##3	SCE#1	8.36153e-20
C933	a_1069_81##2	a_619_368##2	1.4233e-18
C934	VPWR#20	SCE#7	1.83981e-19
C935	VPWR#3	VPWR#5	2.0905e-17
C936	a_871_74##12	VPWR#15	1.02579e-16
C937	VGND#8	a_1069_81##7	2.30279e-19
C938	a_1794_74##2	a_1069_81##11	7.21296e-19
C939	a_1069_81##16	a_871_74##4	9.64086e-18
C940	SCD	CLK#1	4.38536e-19
C941	a_619_368##18	a_619_368##4	3.52513e-18
C942	VGND#3	VPWR#4	3.23039e-18
C943	a_2067_74##18	VGND#18	1.21698e-17
C944	VGND#13	a_304_464##6	2.42998e-17
C945	a_871_74##13	a_619_368##7	2.26334e-19
C946	a_3177_368##5	a_3177_368#	3.92842e-17
C947	a_2513_258##4	a_2067_74##5	4.35392e-19
C948	a_1794_74##4	a_1069_81##4	4.65997e-19
C949	VGND#6	a_619_368##11	3.34133e-19
C950	VPWR#14	VPWR#12	2.17142e-19
C951	VGND#8	a_1069_81##4	3.92086e-18
C952	Q#1	a_3177_368##4	5.94382e-17
C953	Q_N#3	VPWR#3	2.49358e-17
C954	CLK#3	a_619_368##9	1.16506e-17
C955	a_871_74##10	VGND#21	3.54519e-18
C956	a_871_74##4	a_304_464##5	3.79969e-18
C957	a_1069_81##8	a_1069_81##11	5.89476e-18
C958	a_27_74##7	SCE#4	1.96129e-17
C959	SET_B#7	a_619_368##2	9.68088e-19
C960	D#4	SCE#6	5.34828e-19
C961	VGND	VGND#10	7.51105e-17
C962	VGND	VGND#9	8.26981e-17
C963	VGND	VGND#8	7.01506e-17
C964	VGND	VGND#6	1.03397e-16
C965	VGND#19	a_1069_81##11	2.68383e-17
C966	a_3177_368##9	VPWR#4	7.19812e-17
C967	VPWR#1	a_3177_368##6	1.23306e-18
C968	VGND#13	SCD#3	3.21187e-20
C969	a_2067_74##17	VPWR#10	1.1728e-18
C970	a_871_74##12	a_871_74##3	3.99449e-19
C971	a_3177_368##8	Q#1	4.84782e-19
C972	a_1069_81##8	SET_B#1	2.08457e-17
C973	a_619_368##18	CLK#2	5.73406e-17
C974	VGND#3	VPWR#5	4.70953e-18
C975	a_3177_368##9	VPWR#2	3.97543e-18
C976	VPWR#4	a_3177_368##4	7.37579e-19
C977	VPWR#17	a_871_74##13	1.09226e-16
C978	VGND#2	a_2067_74##2	4.08974e-20
C979	Q	a_3177_368#	2.48775e-17
C980	a_871_74##13	a_871_74##4	6.49152e-18
C981	VGND#12	a_1069_81##14	3.38088e-17
C982	SCE#6	SCD#4	3.36478e-17
C983	VGND#5	a_2513_258##5	2.73449e-18
C984	Q	a_3177_368##5	2.3355e-17
C985	Q	a_2067_74#	1.20495e-18
C986	a_1794_74##2	SET_B#1	3.66756e-20
C987	a_304_464##3	SCE#5	8.77409e-20
C988	a_2067_74##18	a_2067_74##17	4.58504e-19
C989	VGND	a_2513_258##5	8.68552e-19
C990	VPWR#14	a_1789_424##4	3.9749e-17
C991	VPWR#3	a_2513_258##4	2.024e-17
C992	a_1252_376##4	a_619_368##2	1.6787e-17
C993	Q#1	a_3177_368##6	5.65915e-17
C994	SCD#3	CLK#3	5.18936e-18
C995	a_1794_74##4	a_1069_81##11	1.77217e-17
C996	a_871_74##12	VPWR#13	4.5146e-17
C997	a_2067_74##18	a_2513_258##2	4.53424e-17
C998	VGND#12	a_304_464#	8.32822e-18
C999	a_27_74##6	SCD#3	7.57506e-20
C1000	D	SCE#6	1.27571e-18
C1001	VPWR#6	VPWR#5	2.83085e-19
C1002	VPWR	a_2067_74##20	5.78325e-18
C1003	D	D#3	3.27076e-18
C1004	VPWR#20	a_27_74##4	1.4667e-19
C1005	a_3177_368##9	a_3177_368##4	7.40723e-20
C1006	D	a_27_74#	1.21871e-18
C1007	VPWR	a_2277_455#	3.48153e-17
C1008	VPWR#15	a_871_74##4	7.48023e-19
C1009	a_2067_74##7	a_3177_368##3	3.65388e-18
C1010	VPWR	a_2067_74##21	5.2121e-18
C1011	D	SCE#4	6.34224e-19
C1012	VPWR#3	a_2067_74##20	1.18516e-17
C1013	VPWR	a_2277_455##2	2.21239e-17
C1014	VPWR#5	VPWR#4	5.40923e-18
C1015	VPWR	a_1789_424#	3.3651e-17
C1016	a_1252_376##2	a_619_368##2	3.50661e-19
C1017	a_2067_74#	a_3177_368##5	2.27303e-17
C1018	VGND#3	VPWR#7	3.42856e-18
C1019	VPWR	a_2067_74##22	8.47506e-18
C1020	VGND#12	a_871_74##10	4.78246e-17
C1021	a_871_74##13	VPWR#15	2.39226e-17
C1022	D#4	D#3	1.31417e-17
C1023	VGND#19	SET_B#1	5.84586e-19
C1024	VPWR	a_1789_424##2	2.2564e-17
C1025	a_619_368##9	a_871_74##13	2.73671e-17
C1026	VPWR	a_1789_424##4	2.10169e-17
C1027	a_3177_368##6	VPWR#4	2.66947e-17
C1028	VGND#8	a_1069_81##11	3.89412e-18
C1029	VPWR	a_1252_376##7	8.38602e-18
C1030	VPWR#8	VPWR#6	2.78026e-19
C1031	VGND#20	a_1069_81##11	2.87115e-18
C1032	VPWR#10	a_619_368##15	4.43061e-18
C1033	a_304_464##2	a_1252_376##3	1.36671e-19
C1034	VGND#12	VGND#22	2.26136e-17
C1035	VGND#13	SCD#2	5.29959e-20
C1036	a_871_74##12	a_619_368##4	1.61678e-19
C1037	VGND#10	SET_B#1	3.24655e-19
C1038	a_2067_74##18	a_619_368##12	1.5843e-20
C1039	a_1069_81##2	SET_B#1	2.23707e-17
C1040	D#3	SCE#6	4.42303e-18
C1041	a_27_74##3	SCD#3	3.63559e-17
C1042	a_619_368##9	VPWR#18	1.60055e-17
C1043	Q#1	a_2067_74##7	1.93326e-18
C1044	a_2513_258##5	a_2067_74##5	4.10686e-17
C1045	VPWR#5	VPWR#2	3.28216e-19
C1046	a_1794_74##4	SET_B#1	3.04775e-18
C1047	VPWR#10	a_619_368##13	4.42805e-18
C1048	a_2067_74##8	a_3177_368##5	1.99393e-19
C1049	a_3177_368##9	a_3177_368##6	1.63853e-18
C1050	SET_B#7	a_871_74##12	3.56428e-18
C1051	VGND	VGND#18	5.68853e-18
C1052	VPWR#19	CLK	2.1115e-18
C1053	VPWR#17	VPWR#18	1.40434e-17
C1054	a_1069_81##2	a_1069_81#	2.21827e-18
C1055	a_619_368##14	a_2067_74##18	1.13293e-16
C1056	VGND#12	a_619_368##19	3.05646e-17
C1057	a_871_74##10	a_1069_81##14	8.90478e-18
C1058	VGND	a_2067_74##18	4.44268e-17
C1059	VGND#12	CLK	1.18712e-18
C1060	VGND	a_1794_74#	2.74769e-17
C1061	a_304_464##2	a_1069_81##16	4.85004e-17
C1062	a_871_74##13	CLK#3	1.86037e-18
C1063	VGND	a_2067_74##24	4.44243e-18
C1064	a_27_74##6	a_27_74##3	3.01461e-20
C1065	VPWR#5	a_3177_368##9	7.73893e-17
C1066	VGND	a_1794_74##2	2.69297e-17
C1067	VPWR#17	a_619_368##9	2.289e-17
C1068	VPWR#1	a_2067_74##9	1.67551e-19
C1069	VGND	a_1794_74##4	1.78808e-17
C1070	VGND	VGND#20	1.44219e-17
C1071	a_619_368##18	a_619_368##9	3.94106e-19
C1072	VGND	a_1252_376##5	1.67494e-17
C1073	a_2067_74##4	a_2067_74##3	7.6004e-18
C1074	VPWR#10	a_1069_81##9	1.33394e-18
C1075	VGND#9	SET_B#1	5.44852e-18
C1076	a_3177_368##3	VPWR#2	3.71664e-19
C1077	a_2067_74##7	VPWR#4	3.30171e-17
C1078	a_1252_376##2	SET_B#1	1.09858e-19
C1079	VPWR#19	SCD	2.25048e-18
C1080	VGND#12	VGND#23	1.83822e-17
C1081	a_2067_74##12	a_2067_74##11	5.05294e-18
C1082	VGND#12	SCD	1.86669e-18
C1083	D#4	a_27_74#	3.9407e-18
C1084	VGND#7	a_619_368##13	2.48709e-20
C1085	VGND#1	a_3177_368#	2.67119e-17
C1086	Q_N#3	VPWR#6	6.75191e-18
C1087	VPWR#5	a_3177_368##6	6.92063e-19
C1088	CLK#3	VPWR#18	2.93326e-17
C1089	VPWR#23	SCE#3	1.02292e-18
C1090	VGND#20	SET_B#1	3.30781e-17
C1091	VPWR#15	a_619_368##9	5.10535e-20
C1092	a_619_368##2	a_619_368##7	6.06216e-19
C1093	a_3177_368##2	VNB	3.91671e-17
C1094	a_1252_376##2	a_1069_81#	1.91462e-18
C1095	D#1	a_27_74##3	1.68746e-17
C1096	a_2067_74##5	VNB	4.91886e-17
C1097	a_2067_74##4	VNB	3.11554e-17
C1098	a_2067_74##3	VNB	4.66529e-17
C1099	a_2067_74##2	VNB	3.36657e-17
C1100	a_2067_74##8	a_2067_74#	4.84482e-18
C1101	a_619_368##12	VNB	1.44879e-16
C1102	VGND#6	a_2513_258##2	7.14875e-18
C1103	a_619_368##11	VNB	1.20311e-16
C1104	a_304_464##4	SCE#7	1.03417e-18
C1105	a_1069_81##7	VNB	4.33836e-17
C1106	VPWR#19	SCE	6.06309e-18
C1107	a_1069_81##5	VNB	3.22394e-17
C1108	a_619_368##5	VNB	1.91916e-17
C1109	VGND#17	VPWR#7	7.98247e-18
C1110	a_2067_74##18	a_619_368##11	2.03634e-17
C1111	a_619_368##2	VNB	2.11056e-16
C1112	VGND#12	SCE	9.25314e-18
C1113	SCD#2	VNB	9.24144e-17
C1114	SCE#3	VNB	9.65706e-17
C1115	a_2067_74##5	a_2067_74##13	2.15645e-18
C1116	VGND#6	a_2067_74##18	2.9741e-17
C1117	a_1252_376##5	a_1069_81##11	4.53415e-19
C1118	a_871_74##13	SCD#3	2.78531e-19
C1119	a_3177_368##9	a_2067_74##7	7.38377e-17
C1120	a_1252_376##2	a_1252_376#	2.13144e-18
C1121	a_304_464#	a_619_368##5	2.98678e-19
C1122	a_27_74#	D#3	3.24072e-17
C1123	a_1794_74##2	a_619_368##14	3.52305e-18
C1124	VGND#8	SET_B#1	1.60259e-19
C1125	a_1794_74##4	a_1069_81#	5.92689e-19
C1126	a_619_368##18	CLK#3	4.12011e-17
C1127	Q_N#3	a_3177_368##9	2.21432e-18
C1128	a_1252_376##3	a_619_368##2	3.45839e-18
C1129	a_871_74##10	a_304_464#	6.23844e-17
C1130	VPWR#8	VPWR#7	3.74528e-19
C1131	a_2067_74##18	a_871_74##6	3.43363e-17
C1132	VGND#12	a_304_464##6	2.45843e-17
C1133	SET_B#6	a_2067_74##12	5.21827e-18
C1134	VGND	a_1252_376##7	1.76064e-18
C1135	VPWR#8	a_2067_74##12	1.37873e-18
C1136	VGND#3	Q	1.91128e-17
C1137	CLK	a_619_368##4	3.26519e-17
C1138	a_3177_368#	Q#2	1.54402e-17
C1139	VGND#10	a_1069_81#	1.31615e-18
C1140	a_2513_258##5	a_2067_74##4	2.0489e-18
C1141	VGND#13	VNB	4.24267e-17
C1142	VGND#11	VNB	5.83039e-17
C1143	a_2513_258##5	a_2067_74##10	4.27716e-18
C1144	VPWR#4	a_2067_74##9	6.14357e-19
C1145	VGND#10	VNB	7.31187e-17
C1146	CLK	CLK#2	5.96117e-18
C1147	a_1794_74#	a_2579_74#	1.03754e-21
C1148	VGND#9	VNB	4.15024e-17
C1149	VGND#8	VNB	2.85678e-17
C1150	a_27_74##6	D#1	3.13409e-19
C1151	VGND#6	VNB	7.37977e-17
C1152	VGND#5	VNB	3.61964e-17
C1153	VGND#2	VNB	3.62204e-17
C1154	a_2067_74##4	a_2067_74##13	1.60357e-18
C1155	a_304_464##2	a_304_464##5	3.3177e-18
C1156	VPWR#20	VNB	4.32486e-17
C1157	VPWR#17	VNB	5.78146e-17
C1158	VPWR#15	VNB	5.69799e-17
C1159	a_871_74##6	a_1794_74#	6.39526e-18
C1160	a_3177_368##8	a_3177_368##3	3.58093e-19
C1161	VPWR#13	VNB	3.33643e-17
C1162	a_3177_368##2	Q#2	1.71222e-19
C1163	VPWR#11	VNB	2.40495e-17
C1164	VPWR	a_1069_81##10	3.62908e-19
C1165	VPWR#8	VNB	6.5333e-17
C1166	VPWR#6	VNB	3.68621e-17
C1167	VPWR#21	CLK#3	6.34662e-18
C1168	VPWR#5	a_2067_74##7	3.54868e-18
C1169	VPWR#6	a_2067_74##12	7.28358e-19
C1170	VPWR#2	VNB	3.49895e-17
C1171	a_27_74##4	a_304_464##4	6.42351e-17
C1172	SCE#1	D#1	4.82821e-17
C1173	a_3177_368##8	VNB	2.4845e-18
C1174	a_619_368##18	D#2	9.40096e-20
C1175	SCD	CLK#2	5.36743e-18
C1176	a_2513_258##5	VNB	1.47299e-17
C1177	a_3177_368##3	Q	3.38599e-17
C1178	a_2067_74##17	VNB	3.08357e-18
C1179	D#4	SCE#4	4.19448e-19
C1180	a_2067_74##15	VNB	1.12535e-17
C1181	VGND#1	a_3177_368##5	1.34033e-18
C1182	VGND#20	a_1069_81#	5.44151e-18
C1183	VGND	a_619_368##10	9.41086e-19
C1184	VPWR#17	CLK#3	1.53097e-17
C1185	a_871_74##12	VNB	3.41671e-17
C1186	a_871_74##6	a_2067_74##24	7.08582e-17
C1187	a_619_368##18	SCD#3	1.87992e-18
C1188	VGND#12	VGND#24	2.03341e-17
C1189	VGND	a_1069_81#	3.58131e-19
C1190	a_3177_368##9	a_2067_74##9	3.07988e-18
C1191	a_304_464##3	VNB	9.83316e-18
C1192	a_304_464##2	VNB	2.50775e-18
C1193	VGND#9	a_1069_81#	4.67276e-18
C1194	a_1252_376##5	SET_B#1	6.38547e-18
C1195	SCE	SCE#7	3.42102e-17
C1196	VGND#4	a_3177_368#	7.92936e-19
C1197	Q_N#3	VPWR#5	9.17887e-17
C1198	a_2513_258##3	SET_B#5	1.85554e-19
C1199	SCE	a_27_74##4	4.00937e-17
C1200	a_27_74##7	VNB	3.53145e-17
C1201	a_2067_74##18	a_1794_74#	4.31084e-17
C1202	a_27_74##6	VNB	3.33951e-17
C1203	Q_N#3	a_2067_74##7	5.6184e-19
C1204	SCE	D#2	6.98051e-17
C1205	a_1794_74##2	a_871_74##6	5.26976e-17
C1206	D#4	VNB	5.52713e-20
C1207	SET_B#7	VPWR	4.94138e-17
C1208	VGND#1	VNB	6.8587e-17
C1209	VGND#4	VNB	7.56654e-18
C1210	VPWR	VPWR#10	9.44085e-17
C1211	a_2067_74##5	a_2067_74##10	9.07832e-19
C1212	a_304_464##2	a_871_74##3	6.46657e-17
C1213	a_2067_74##10	a_2067_74##8	3.48601e-17
C1214	a_3177_368##10	VNB	1.21121e-17
C1215	SCE#4	a_27_74#	1.41883e-17
C1216	VGND#16	VNB	1.0297e-17
C1217	Q_N#1	VNB	3.97108e-18
C1218	VGND#17	VNB	7.76347e-18
C1219	VGND#12	a_27_74##8	1.88683e-17
C1220	D	SCE#7	1.95224e-18
C1221	a_2513_258##7	VNB	7.99621e-18
C1222	VGND#18	VNB	6.67118e-19
C1223	a_871_74##2	a_1252_376#	4.83333e-19
C1224	a_2067_74##18	VNB	1.06928e-17
C1225	VPWR#21	SCD#3	4.0782e-17
C1226	a_304_464##4	D#2	5.33254e-19
C1227	a_1794_74#	VNB	1.12242e-17
C1228	VGND#6	a_619_368##14	9.51523e-19
C1229	a_2067_74##24	VNB	7.17455e-19
C1230	a_1794_74##2	VNB	4.59249e-18
C1231	VGND#19	VNB	6.05806e-20
C1232	D	D#2	7.46343e-18
C1233	a_1794_74##4	VNB	5.22955e-18
C1234	VGND#20	VNB	1.42539e-18
C1235	a_1252_376##5	VNB	8.01172e-18
C1236	VGND#21	VNB	5.46885e-18
C1237	a_27_74##2	D	1.33477e-17
C1238	SCE#5	SCE#1	2.90833e-17
C1239	a_304_464##4	CLK#3	4.54939e-19
C1240	a_1069_81##14	VNB	1.01706e-17
C1241	a_3177_368##5	Q#2	1.49333e-17
C1242	a_304_464#	VNB	3.32651e-18
C1243	VPWR	a_2513_258##2	2.52217e-18
C1244	VPWR#5	a_2067_74##9	7.1968e-17
C1245	a_871_74##10	VNB	1.45578e-17
C1246	VGND#22	VNB	1.08047e-18
C1247	a_619_368##19	VNB	1.08288e-17
C1248	VPWR	a_619_368##14	4.76368e-18
C1249	VGND#23	VNB	5.28518e-18
C1250	a_619_368##2	a_871_74##4	1.37142e-17
C1251	VPWR	a_871_74##6	3.87809e-18
C1252	VGND#24	VNB	1.79015e-18
C1253	a_27_74##8	VNB	2.36472e-17
C1254	VPWR	a_619_368#	5.90097e-18
C1255	a_27_74##6	SCE#1	1.0956e-17
C1256	VPWR#1	VNB	7.99346e-17
C1257	Q#1	VNB	7.78173e-18
C1258	VPWR#2	a_3177_368##4	2.30691e-18
C1259	VPWR#4	VNB	5.0889e-18
C1260	a_3177_368##9	VNB	1.5612e-17
C1261	VPWR#5	VNB	1.48269e-17
C1262	VGND#21	SET_B#1	4.28399e-19
C1263	Q_N#3	VNB	3.30831e-18
C1264	VPWR	SET_B#2	9.99681e-19
C1265	VPWR#7	VNB	3.34906e-18
C1266	VPWR#8	SET_B#5	4.71674e-20
C1267	a_2513_258##4	VNB	1.15903e-17
C1268	a_2067_74##20	VNB	8.11199e-18
C1269	VPWR	a_1069_81##2	3.69039e-18
C1270	a_871_74##7	a_619_368##13	5.11061e-18
C1271	a_304_464##2	a_871_74##13	1.15494e-16
C1272	VPWR#9	VNB	3.05029e-18
C1273	a_2277_455#	VNB	8.02914e-18
C1274	a_2277_455##2	VNB	1.28717e-17
C1275	a_1789_424#	VNB	5.03452e-18
C1276	a_2067_74##22	VNB	1.3762e-18
C1277	VPWR	a_1252_376##3	2.80786e-18
C1278	a_2513_258##5	a_2067_74##6	1.34953e-17
C1279	VGND#20	a_1252_376#	4.27374e-19
C1280	a_3177_368##10	a_3177_368#	8.27757e-21
C1281	a_1789_424##2	VNB	3.01229e-18
C1282	a_1794_74##4	a_871_74##6	5.52511e-17
C1283	VPWR#12	VNB	2.45567e-19
C1284	a_1789_424##4	VNB	1.08467e-17
C1285	VPWR#20	SCD#3	5.05378e-18
C1286	VPWR#14	VNB	1.08605e-17
C1287	a_1252_376##7	VNB	2.61815e-18
C1288	a_3177_368##9	a_2067_74##11	3.64827e-19
C1289	VPWR#16	VNB	4.39847e-18
C1290	a_619_368##8	a_871_74##2	2.66445e-18
C1291	a_1069_81##16	VNB	8.27656e-18
C1292	VGND#1	a_2067_74#	2.27179e-19
C1293	VGND#10	a_1252_376#	3.15155e-18
C1294	VPWR#19	a_1252_376##4	3.0759e-18
C1295	a_871_74##13	VNB	1.85908e-17
C1296	a_619_368##18	VNB	5.78121e-18
C1297	VPWR#21	VNB	2.81028e-18
C1298	VGND	SET_B#7	4.84646e-17
C1299	a_871_74##2	a_619_368##2	4.82598e-19
C1300	a_304_464##4	VNB	5.33461e-18
C1301	VPWR#7	VPWR#5	2.28687e-18
C1302	VPWR#23	VNB	3.50822e-18
C1303	VGND	VGND#7	9.69345e-17
C1304	a_3177_368##3	a_3177_368##2	2.86777e-18
C1305	a_27_74##9	VNB	3.24919e-17
C1306	a_3177_368#	VNB	3.37413e-17
C1307	Q_N#3	a_2067_74##9	2.19445e-17
C1308	a_3177_368##5	VNB	3.07621e-17
C1309	a_1252_376##5	a_1069_81#	2.72559e-17
C1310	a_2067_74#	VNB	3.89391e-17
C1311	a_2067_74##8	VNB	3.09956e-17
C1312	a_2067_74##10	VNB	3.33336e-17
C1313	a_2067_74##6	VNB	3.625e-17
C1314	VPWR#21	VPWR#17	1.04241e-17
C1315	SET_B#4	VNB	2.79461e-17
C1316	VPWR#21	a_27_74##3	3.10925e-18
C1317	a_2513_258#	VNB	2.50281e-17
C1318	a_871_74##12	a_1069_81##10	1.12056e-19
C1319	a_619_368##10	VNB	2.17707e-17
C1320	a_871_74##8	VNB	3.24329e-17
C1321	a_871_74##7	VNB	4.84927e-17
C1322	VGND	a_2513_258##2	8.56543e-18
C1323	VGND#22	a_871_74##10	6.71274e-17
C1324	a_1069_81##4	VNB	2.31162e-17
C1325	a_619_368##19	a_304_464#	1.04682e-18
C1326	a_1069_81##11	VNB	2.22832e-17
C1327	VGND	a_619_368##14	4.78189e-18
C1328	SET_B#1	VNB	3.3021e-17
C1329	a_2067_74##24	a_2067_74##18	2.78907e-18
C1330	a_304_464##3	VPWR#18	8.68403e-19
C1331	a_3177_368##5	VGND#4	2.01716e-17
C1332	a_1069_81#	VNB	2.70389e-17
C1333	VGND	a_871_74##6	8.1032e-18
C1334	a_1252_376#	VNB	3.07042e-17
C1335	a_304_464##4	SCD#3	4.45508e-18
C1336	a_871_74##3	a_871_74#	3.2803e-19
C1337	a_871_74#	VNB	2.74699e-17
C1338	VGND	a_619_368#	1.86995e-18
C1339	a_27_74##7	SCE#3	1.53573e-17
C1340	a_619_368##8	VNB	5.03186e-17
C1341	VGND#9	a_871_74##6	6.27613e-19
C1342	a_619_368##6	VNB	3.29608e-17
C1343	VGND	a_1069_81##8	1.33832e-17
C1344	CLK#1	VNB	2.91993e-17
C1345	VPWR#17	SCD#3	2.13781e-18
C1346	SCD#4	VNB	2.41684e-17
C1347	VGND	SET_B#2	8.14638e-19
C1348	SCE#6	VNB	2.13466e-17
C1349	D#3	VNB	2.2378e-17
C1350	VGND	a_1069_81##2	1.10153e-17
C1351	a_27_74#	VNB	2.50546e-17
C1352	SCE#4	VNB	4.38796e-17
C1353	VGND	a_1252_376##2	5.37763e-18
C1354	a_3177_368##4	VNB	4.18366e-17
C1355	VGND	a_1252_376##3	3.10183e-18
C1356	a_3177_368##6	VNB	3.56351e-17
C1357	a_2067_74##7	VNB	4.87802e-17
C1358	a_2067_74##9	VNB	4.15331e-17
C1359	VPWR#5	a_2067_74##11	3.27616e-18
C1360	a_2067_74##11	VNB	4.18672e-17
C1361	a_2067_74##13	VNB	5.27673e-17
C1362	SET_B#6	VNB	3.71605e-17
C1363	a_2513_258##3	VNB	3.5296e-17
C1364	a_619_368##14	a_871_74##5	1.74921e-17
C1365	a_871_74##5	VNB	5.38036e-17
C1366	a_619_368##15	VNB	2.91578e-17
C1367	a_619_368##13	VNB	4.014e-17
C1368	a_304_464##2	a_619_368##4	1.46087e-16
C1369	a_1252_376##7	a_619_368##2	1.66058e-18
C1370	a_1069_81##9	VNB	3.98401e-17
C1371	a_619_368##8	a_871_74##3	2.43533e-17
C1372	a_1069_81##10	VNB	3.81065e-17
C1373	SET_B#3	VNB	2.85681e-17
C1374	a_1069_81##3	VNB	3.58019e-17
C1375	a_2513_258##4	VPWR#6	1.73123e-17
C1376	a_1252_376##4	VNB	2.93466e-17
C1377	a_619_368##7	VNB	2.91012e-17
C1378	VGND#8	a_871_74##6	1.88284e-19
C1379	a_871_74##4	VNB	2.82333e-17
C1380	a_619_368##9	VNB	3.52058e-17
C1381	VPWR#7	a_2067_74##9	6.42426e-19
C1382	CLK#3	VNB	5.52305e-17
C1383	SCD#3	VNB	4.73036e-17
C1384	a_27_74##3	VNB	2.32588e-17
C1385	D#1	VNB	4.18511e-17
C1386	a_2067_74##6	a_2067_74##10	4.00521e-18
C1387	SCE#1	VNB	2.92248e-17
C1388	VPWR#19	a_619_368##2	2.17953e-17
C1389	SCE#5	VNB	4.36871e-17
C1390	VPWR#3	VNB	2.63737e-16
C1391	VGND#21	a_1069_81#	1.7632e-18
C1392	VGND#3	VNB	2.4781e-16
C1393	D	a_229_74#	1.40648e-21
C1394	SET_B#7	VNB	6.32742e-18
C1395	VPWR#10	VNB	4.99824e-17
C1396	VGND#12	a_619_368##7	6.37347e-19
C1397	VGND#7	VNB	5.81395e-17
C1398	VPWR#19	VNB	3.13121e-16
C1399	a_871_74##3	a_619_368##6	1.65884e-19
C1400	VGND#12	VNB	3.28455e-16
C1401	a_3177_368##3	VNB	4.49073e-17
C1402	a_27_74##6	SCE#5	1.31475e-17
C1403	a_2067_74##12	VNB	4.8454e-17
C1404	SET_B#5	VNB	7.01598e-17
C1405	a_2513_258##2	VNB	6.16341e-17
C1406	a_619_368##14	VNB	3.54783e-17
C1407	a_871_74##6	VNB	1.44974e-16
C1408	a_1794_74##4	a_619_368#	4.80075e-19
C1409	a_619_368#	VNB	1.4731e-16
C1410	a_1069_81##8	VNB	5.12791e-17
C1411	SET_B#7	a_1789_424#	3.45477e-19
C1412	VPWR#21	D#1	3.61595e-19
C1413	VPWR#7	Q_N#3	9.063e-17
C1414	SET_B#2	VNB	5.54488e-17
C1415	VGND#6	a_871_74##6	2.5384e-21
C1416	a_1069_81##2	VNB	9.02441e-17
C1417	a_1252_376##2	VNB	5.57147e-17
C1418	a_1252_376##3	VNB	6.3163e-17
C1419	D	SCE	1.55889e-17
C1420	a_3177_368##10	a_3177_368##5	1.09376e-18
C1421	a_3177_368##3	Q#1	1.66924e-17
C1422	a_871_74##2	VNB	6.47452e-17
C1423	Q_N#3	a_2067_74##11	5.55205e-17
C1424	a_871_74##3	VNB	5.17323e-17
C1425	a_619_368##4	VNB	1.12762e-16
C1426	CLK#2	VNB	4.88145e-17
C1427	a_304_464##4	a_27_74##3	5.26599e-17
C1428	a_304_464##2	VPWR#18	7.04814e-18
C1429	SCD#1	VNB	1.02628e-18
C1430	SCE#7	VNB	6.36432e-17
C1431	a_871_74##13	a_619_368##8	1.40914e-19
C1432	VPWR#19	a_619_368##9	7.77257e-19
C1433	a_27_74##4	VNB	5.0888e-17
C1434	VPWR#19	SCD#2	1.23515e-19
C1435	D#2	VNB	5.88381e-17
C1436	a_27_74##2	VNB	2.79269e-17
C1437	VGND#1	a_2067_74##8	1.50669e-19
C1438	SCE#2	VNB	1.0954e-17
C1439	a_1252_376##5	a_1252_376#	1.68798e-18
C1440	a_304_464#	SCD#2	1.20219e-19
C1441	VPWR#2	a_3177_368##6	7.82188e-18
C1442	a_2067_74##3	a_2067_74##2	1.05026e-18
C1443	VPWR#23	SCD#3	3.11922e-19
C1444	a_2067_74##20	VPWR#8	2.02816e-17
C1445	VPWR#19	a_871_74##12	2.41699e-17
C1446	VPWR#8	a_2513_258##2	5.56887e-20
C1447	a_2513_258##5	SET_B#4	2.77058e-18
C1448	a_2067_74##20	a_619_368##11	3.76299e-20
C1449	Q_N#3	a_3177_368##8	1.59824e-18
C1450	a_1794_74#	a_2067_74##24	5.03166e-17
C1451	SET_B#7	a_2067_74##22	4.50636e-18
C1452	a_1794_74##2	a_1069_81##8	2.45035e-19
C1453	a_3177_368##3	VPWR#4	3.41411e-17
C1454	a_871_74##6	a_619_368##15	4.40529e-20
C1455	VPWR#5	a_2067_74##13	2.52692e-19
C1456	VPWR#20	a_27_74##3	5.51057e-18
C1457	a_619_368##9	a_619_368##2	9.56752e-18
C1458	a_2067_74#	VGND#4	2.39669e-17
C1459	CLK	VNB	1.64325e-18
C1460	a_2513_258##5	a_2067_74##12	8.26457e-17
C1461	SCD	VNB	4.48305e-18
C1462	a_2277_455##2	VPWR#10	1.27074e-17
C1463	SCE	VNB	7.41497e-18
C1464	VPWR#19	CLK#3	5.71543e-18
C1465	D	VNB	6.11566e-19
C1466	a_619_368##6	a_619_368##4	1.1858e-17
C1467	Q	VNB	1.29988e-17
C1468	VPWR	VNB	2.19468e-16
C1469	a_2067_74##2	a_3177_368##3	3.20871e-17
C1470	VGND	VNB	2.26081e-16
C1471	VGND#10	a_871_74#	5.84509e-18
C1472	a_304_464##3	a_619_368##18	7.07982e-17
C1473	a_871_74##12	SET_B#3	1.9095e-17
C1474	VGND#8	a_1794_74##2	2.64003e-19
C1475	a_304_464##3	CLK#2	2.19823e-19
C1476	a_2067_74##11	VPWR#7	2.04862e-17
C1477	VPWR#22	D#2	5.18432e-20
C1478	VGND#14	D#2	4.11567e-19
C1479	SET_B	a_2067_74##5	5.27408e-18
C1480	SET_B	a_619_368##14	8.33354e-17
C1481	VPWR#22	VPWR#21	1.48605e-20
C1482	SET_B	a_871_74##5	9.02672e-19
C1483	SET_B	VPWR#10	2.71528e-18
C1484	SET_B	a_2067_74##18	7.99342e-18
C1485	VGND#14	SCE#4	2.71976e-18
C1486	a_304_464##4	VPWR#22	1.15022e-17
C1487	a_2513_258##2	SET_B	1.10847e-16
C1488	SET_B	a_2067_74##22	6.6771e-18
C1489	VPWR#22	D#1	7.62454e-18
C1490	SET_B	VNB	6.27093e-18
C1491	VGND#14	a_27_74##2	1.13628e-18
C1492	a_2513_258##5	SET_B	2.60034e-17
C1493	VGND#14	SCE	8.17756e-19
C1494	SET_B	SET_B#5	2.51343e-17
C1495	SET_B	a_619_368##11	1.44266e-18
C1496	VPWR#22	SCE#5	2.57092e-18
C1497	VPWR#22	VPWR#20	2.17335e-19
C1498	SET_B	a_1789_424#	1.85058e-18
C1499	a_27_74##6	VPWR#22	5.98582e-19
C1500	SET_B	a_2067_74##12	6.00157e-17
C1501	VGND#14	VNB	7.43204e-17
C1502	SET_B	Q_N#3	1.22149e-18
C1503	a_27_74##4	VPWR#22	2.1986e-18
C1504	SET_B	a_619_368##12	5.76041e-21
C1505	VGND#14	a_27_74##8	2.22826e-17
C1506	SET_B	VPWR#8	4.82365e-18
C1507	SET_B	a_2277_455##2	1.80283e-18
C1508	SET_B	VGND#18	1.60498e-18
C1509	VGND#3	SET_B	1.20123e-18
C1510	VGND	SET_B	4.61781e-17
C1511	VPWR#22	a_27_74##2	1.64778e-19
C1512	VGND#14	D#4	1.49074e-17
C1513	VGND#14	SCE#2	1.45379e-18
C1514	SET_B	a_2067_74##15	4.0799e-17
C1515	VGND#12	VGND#14	1.27046e-16
C1516	VGND#14	D#3	6.10794e-18
C1517	VPWR#19	VPWR#22	1.12263e-16
C1518	VPWR#3	SET_B	1.1666e-18
C1519	VGND#14	a_27_74##4	4.10109e-19
C1520	SET_B	a_619_368#	2.71606e-18
C1521	a_27_74##9	VPWR#22	2.32735e-17
C1522	SET_B	a_2277_455#	4.11657e-18
C1523	VPWR#22	SCE#1	4.03814e-18
C1524	VPWR	SET_B	4.88269e-17
C1525	SET_B	a_2067_74##24	1.26679e-18
C1526	SET_B	VGND#6	8.48155e-18
C1527	a_2067_74##17	SET_B	5.30871e-17
C1528	VGND#14	a_27_74#	3.67927e-18
C1529	SET_B	a_871_74##6	2.1513e-17
C1530	VPWR#22	VNB	6.36861e-17
C1531	SET_B	VPWR#9	3.13304e-18
C1532	SET_B	Q_N#1	1.27206e-18
C1533	VGND#14	a_27_74##7	2.72067e-19
C1534	SET_B	VGND#7	2.15235e-18
C1535	SET_B	a_1794_74#	1.1032e-18
*
*
.ENDS sky130_fd_sc_hs__sdfsbp_2
*
