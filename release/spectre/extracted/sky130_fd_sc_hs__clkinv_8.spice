* Extracted by Quantus, converted by sky130cad/quantus.py
*
*
*
*                       LINUX           Wed Nov 18 08:25:11 2026
*
*
*
*  PROGRAM  advgen
*
*  Name           : advgen - Quantus - (64-bit)
*  Version        : 25.1.0-p047
*  Build Date     : Thu Dec 11 23:20:30 PST 2025
*
*  HSPICE LIBRARY
*
*  OPERATING_TEMPERATURE 150
*  QRC_TECH_DIR <path>/tech
*
*
*

*
.SUBCKT sky130_fd_sc_hs__clkinv_8 VPB VNB VGND VPWR Y A
*
*
*  caps2d version: 10
*
*
*       TRANSISTOR CARDS
*
*
XM2 Y#14 A#32 VGND#7 VNB sky130_fd_pr__nfet_01v8_lvt l=0.15 w=0.42 ad=0.8442 as=0.1281 pd=4.86 ps=1.45
XM18 VGND#8 A#25 Y#14 VNB sky130_fd_pr__nfet_01v8_lvt l=0.15 w=0.42 ad=0.1764 as=0.8442 pd=1.68 ps=4.86
XM3 Y#16 A#22 VGND#8 VNB sky130_fd_pr__nfet_01v8_lvt l=0.15 w=0.42 ad=0.1176 as=0.1764 pd=1.4 ps=1.68
XM7 VGND#6 A#20 Y#16 VNB sky130_fd_pr__nfet_01v8_lvt l=0.15 w=0.42 ad=0.1764 as=0.1176 pd=1.68 ps=1.4
XM8 VGND#6 A#18 Y#18 VNB sky130_fd_pr__nfet_01v8_lvt l=0.15 w=0.42 ad=0.1764 as=0.1176 pd=1.68 ps=1.4
XM11 Y#18 A#16 VGND#5 VNB sky130_fd_pr__nfet_01v8_lvt l=0.15 w=0.42 ad=0.1176 as=0.1764 pd=1.4 ps=1.68
XM17 VGND#5 A#13 Y#20 VNB sky130_fd_pr__nfet_01v8_lvt l=0.15 w=0.42 ad=0.1764 as=0.147 pd=1.68 ps=1.54
XM13 Y#20 A#1 VGND#1 VNB sky130_fd_pr__nfet_01v8_lvt l=0.15 w=0.42 ad=0.147 as=0.1197 pd=1.54 ps=1.41
XM1 VPWR#7 A#37 Y#8 VPB sky130_fd_pr__pfet_01v8 l=0.15 w=1.12 ad=0.3584 as=0.336 pd=2.88 ps=2.84
XM4 VPWR#12 A#36 Y#8 VPB sky130_fd_pr__pfet_01v8 l=0.15 w=1.12 ad=0.392 as=0.336 pd=2.94 ps=2.84
XM5 Y#12 A#35 VPWR#12 VPB sky130_fd_pr__pfet_01v8 l=0.15 w=1.12 ad=0.336 as=0.392 pd=2.84 ps=2.94
XM6 Y#12 A#34 VPWR#11 VPB sky130_fd_pr__pfet_01v8 l=0.15 w=1.12 ad=0.336 as=0.392 pd=2.84 ps=2.94
XM9 VPWR#11 A#33 Y#11 VPB sky130_fd_pr__pfet_01v8 l=0.15 w=1.12 ad=0.392 as=0.336 pd=2.94 ps=2.84
XM10 Y#11 A#26 VPWR#10 VPB sky130_fd_pr__pfet_01v8 l=0.15 w=1.12 ad=0.336 as=0.392 pd=2.84 ps=2.94
XM12 Y#10 A#21 VPWR#10 VPB sky130_fd_pr__pfet_01v8 l=0.15 w=1.12 ad=0.336 as=0.392 pd=2.84 ps=2.94
XM14 VPWR#9 A#19 Y#10 VPB sky130_fd_pr__pfet_01v8 l=0.15 w=1.12 ad=0.392 as=0.336 pd=2.94 ps=2.84
XM15 VPWR#9 A#17 Y#9 VPB sky130_fd_pr__pfet_01v8 l=0.15 w=1.12 ad=0.392 as=0.336 pd=2.94 ps=2.84
XM16 Y#9 A#15 VPWR#8 VPB sky130_fd_pr__pfet_01v8 l=0.15 w=1.12 ad=0.336 as=0.392 pd=2.84 ps=2.94
XM19 VPWR#8 A#14 Y#1 VPB sky130_fd_pr__pfet_01v8 l=0.15 w=1.12 ad=0.392 as=0.336 pd=2.94 ps=2.84
XM0 Y#1 A#12 VPWR#1 VPB sky130_fd_pr__pfet_01v8 l=0.15 w=1.12 ad=0.336 as=0.3304 pd=2.84 ps=2.83
*
*
*       RESISTOR AND CAP/DIODE CARDS
*
Rg1	A#1	A#2	472.157806
Rg2	A#2	A#3	66.369736
Rg3	A#3	A#4	90.026909
Rg4	A#4	A#5	21.001062
Rg5	A#5	A#6	50.285873
Rg6	A#6	A#7	26.115089
Rg7	A#7	A#8	66.487305
Rg8	A#8	A#9	25.654016
Rg9	A#9	A#10	47.298008
Rg10	A#10	A#11	35.713127
Rg11	A#2	A#12	449.655212
Rg12	A#3	A#13	470.096344
Rg13	A#3	A#14	448.603302
Rg14	A#4	A#15	419.554810
Rg15	A#5	A#16	470.803711
Rg16	A#6	A#17	419.000305
Rg17	A#7	A#18	500.783112
Rg18	A#8	A#19	388.798737
Rg19	A#9	A#20	446.464355
Rg20	A#10	A#21	390.783234
Rg21	A#11	A#22	457.158020
Rg22	A#11	A#23	53.269764
Rg23	A#23	A#24	33.425358
Rg24	A#24	A#25	445.354126
Rg25	A#23	A#26	419.554810
Rg26	A#24	A#27	41.300251
Rg27	A#27	A#28	90.789742
Rg28	A#28	A#29	80.946121
Rg29	A#29	A#30	90.789742
Rg30	A#30	A#31	67.149261
Rg31	A#31	A#32	472.157806
Rg32	A#27	A#33	419.554810
Rg33	A#28	A#34	419.554810
Rg34	A#29	A#35	419.554810
Rg35	A#30	A#36	419.554810
Rg36	A#31	A#37	449.655212
Rf1	A	A#11	11.083414
Rf2	Y#1	Y#2	17.026701
Rf3	Y#2	Y#3	69.348907
Rf4	Y#3	Y#4	69.348907
Rf5	Y#4	Y#5	69.348907
Rf6	Y#5	Y#6	69.348907
Rf7	Y#6	Y#7	69.348907
Rf8	Y#7	Y#8	17.027714
Rf9	Y#3	Y#9	17.027714
Rf10	Y#4	Y#10	17.027714
Rf11	Y#5	Y#11	17.027714
Rf12	Y#6	Y#12	17.027714
Rf13	Y#7	Y#13	181.483795
Rf14	Y#13	Y#14	5.598006
Rf15	Y#13	Y#15	137.318802
Rf16	Y#15	Y#16	30.767605
Rf17	Y#15	Y#17	73.001427
Rf18	Y#17	Y#18	30.767605
Rf19	Y#17	Y#19	73.001427
Rf20	Y#19	Y#20	30.767605
Rf21	Y#19	Y	45.357964
Rf22	Y	Y#21	52.601803
Rf23	Y#21	Y#2	20.667021
Rf24	VGND#1	VGND#2	105.058044
Rf25	VGND#2	VGND#3	73.001427
Rf26	VGND#3	VGND#4	61.337883
Rf27	VGND#2	VGND#5	35.688515
Rf28	VGND#3	VGND#6	35.688515
Rf29	VGND#4	VGND#7	243.426285
Rf30	VGND#4	VGND#8	39.186417
Rf31	VPWR#1	VPWR#2	106.849358
Rf32	VPWR#2	VPWR#3	69.463600
Rf33	VPWR#3	VPWR#4	72.352806
Rf34	VPWR#4	VPWR#5	68.335030
Rf35	VPWR#5	VPWR#6	69.463600
Rf36	VPWR#6	VPWR#7	107.969482
Rf37	VPWR#2	VPWR#8	38.736572
Rf38	VPWR#3	VPWR#9	38.736572
Rf39	VPWR#4	VPWR#10	43.353802
Rf40	VPWR#5	VPWR#11	38.736572
Rf41	VPWR#6	VPWR#12	38.736572
Re1	VPWR#4	VPWR	0.755546
Re2	VGND	VGND#4	0.755573
*
*       CAPACITOR CARDS
*
*
C1	VGND#5	A#5	1.21398e-18
C2	Y#17	A#5	1.43221e-17
C3	VGND	VNB	5.84204e-17
C4	VPWR	VNB	7.15546e-17
C5	Y	VNB	3.6013e-17
C6	A	VNB	7.54305e-17
C7	A#5	A#3	6.08706e-18
C8	VGND	Y	3.99849e-18
C9	VGND#4	VNB	3.19897e-16
C10	VGND	A	2.84837e-17
C11	VPWR#4	VNB	2.77202e-16
C12	A#28	VPWR#11	8.6347e-19
C13	A#37	VNB	4.23972e-17
C14	VPWR	A	2.63137e-17
C15	VGND#2	A#13	2.80314e-18
C16	Y#4	VPWR#3	3.13618e-19
C17	A#36	VNB	3.25859e-17
C18	VGND	VGND#4	7.30101e-17
C19	A#35	VNB	3.13143e-17
C20	A#34	VNB	3.28528e-17
C21	A	Y	2.81545e-17
C22	Y#19	A#3	1.53956e-17
C23	A#33	VNB	3.1601e-17
C24	A#26	VNB	3.32245e-17
C25	A#21	VNB	3.13647e-17
C26	A#19	VNB	3.26171e-17
C27	VPWR	VPWR#4	3.47754e-17
C28	A#17	VNB	3.13895e-17
C29	A#15	VNB	3.307e-17
C30	A#14	VNB	3.12764e-17
C31	A#12	VNB	4.28606e-17
C32	VPWR	A#37	7.57113e-19
C33	A#32	VNB	4.98709e-17
C34	VPWR	A#36	7.67472e-19
C35	A#25	VNB	3.62643e-17
C36	A#22	VNB	3.25466e-17
C37	Y#15	Y#17	1.26156e-18
C38	Y#7	Y#8	1.16353e-18
C39	VPWR	A#35	2.70197e-19
C40	A#20	VNB	3.25411e-17
C41	A#18	VNB	3.26811e-17
C42	Y#19	A#1	5.84532e-18
C43	VPWR	A#34	8.4008e-19
C44	A#16	VNB	3.28607e-17
C45	A#13	VNB	3.39174e-17
C46	VPWR	A#33	2.70197e-19
C47	A#1	VNB	3.40638e-17
C48	VPWR#7	VNB	6.18988e-17
C49	Y#13	A#23	2.60614e-18
C50	Y#8	VNB	4.50184e-18
C51	VPWR	A#26	8.4008e-19
C52	VPWR#12	VNB	3.0111e-18
C53	Y#12	VNB	2.1429e-18
C54	VPWR	A#21	2.93561e-19
C55	A	A#37	1.60501e-18
C56	VPWR#11	VNB	3.0111e-18
C57	VGND	A#32	4.66979e-18
C58	Y#11	VNB	2.1429e-18
C59	VPWR	A#19	8.71966e-19
C60	A	A#36	2.05396e-18
C61	VPWR#10	VNB	3.0111e-18
C62	VGND	A#25	7.93101e-18
C63	Y#10	VNB	2.1429e-18
C64	VPWR	A#17	2.93561e-19
C65	VGND	A#22	8.39405e-18
C66	VPWR#9	VNB	3.0111e-18
C67	Y#6	VPWR#12	1.44232e-17
C68	A	A#35	2.06618e-18
C69	Y#9	VNB	2.1429e-18
C70	VPWR	A#15	8.40079e-19
C71	VGND	A#20	7.93101e-18
C72	VPWR#8	VNB	3.0111e-18
C73	VGND	A#18	8.39405e-18
C74	VPWR	A#14	1.88546e-19
C75	Y#1	VNB	4.4788e-18
C76	A	A#34	2.06618e-18
C77	VPWR#1	VNB	5.98176e-17
C78	VGND	A#16	8.39405e-18
C79	VGND#7	VNB	8.3044e-17
C80	VPWR	A#12	1.60094e-18
C81	VGND	A#13	8.39405e-18
C82	A	A#33	2.06618e-18
C83	VGND#8	VNB	4.14064e-18
C84	VGND	A#1	4.23535e-18
C85	Y#16	VNB	3.01253e-20
C86	VGND#6	VNB	3.8746e-18
C87	A	A#26	2.06618e-18
C88	Y#18	VNB	3.01253e-20
C89	Y#15	A#9	1.38862e-17
C90	VGND#5	VNB	3.8746e-18
C91	Y#20	VNB	1.198e-18
C92	VGND#1	VNB	5.26563e-17
C93	VGND#7	Y#14	1.46202e-18
C94	Y#2	VNB	2.56917e-17
C95	Y#7	VPWR#12	1.16841e-17
C96	VGND#2	A#2	4.69316e-20
C97	Y#7	VNB	2.19588e-17
C98	Y#13	VNB	5.11983e-17
C99	A	A#15	2.06618e-18
C100	Y#15	VNB	3.01773e-18
C101	Y#17	VNB	3.01904e-18
C102	VPWR	VPWR#7	3.2383e-17
C103	A	A#14	2.05476e-18
C104	Y#19	VNB	3.50928e-18
C105	VGND#2	VNB	3.90755e-17
C106	Y#17	A#7	1.4943e-17
C107	VGND#3	VNB	3.06884e-17
C108	VPWR	Y#8	1.32506e-17
C109	VGND	VGND#7	5.81838e-17
C110	VPWR#2	VNB	3.33227e-17
C111	A	A#12	1.33766e-18
C112	VPWR#3	VNB	2.81499e-17
C113	VPWR#5	VNB	2.8093e-17
C114	Y#6	Y#12	1.34628e-18
C115	VPWR#6	VNB	3.37115e-17
C116	VPWR	Y#12	1.5835e-17
C117	VGND	Y#16	1.39342e-17
C118	A#27	Y#11	6.9441e-19
C119	VPWR#4	A#34	8.34499e-20
C120	VPWR	Y#11	1.5835e-17
C121	VGND	Y#18	1.39342e-17
C122	Y#5	VPWR#5	1.6661e-19
C123	A#37	A#36	4.57045e-17
C124	VGND	Y#20	1.4178e-17
C125	Y	A#1	3.96135e-18
C126	VPWR	Y#10	1.5835e-17
C127	VPWR#4	A#33	2.99535e-19
C128	VGND	VGND#1	3.95087e-17
C129	Y#19	A#5	1.06825e-18
C130	Y#5	VPWR#11	1.44232e-17
C131	VPWR	Y#9	1.5835e-17
C132	VPWR#4	A#26	5.32783e-18
C133	VPWR	Y#1	1.58676e-17
C134	VPWR	VPWR#1	3.35617e-17
C135	VPWR#4	A#21	4.53211e-18
C136	A#36	A#35	3.77743e-17
C137	Y#17	Y#19	1.26156e-18
C138	VGND#2	A#3	5.60447e-20
C139	VGND	Y#13	6.59403e-17
C140	VPWR#4	A#19	3.40035e-19
C141	VGND	Y#15	2.72553e-18
C142	Y#13	A#27	2.01576e-17
C143	VGND	Y#17	2.72553e-18
C144	VGND	Y#19	2.4272e-18
C145	VPWR#4	A#17	9.12873e-20
C146	VGND	VGND#2	4.8152e-17
C147	VGND#8	Y#14	1.22992e-18
C148	VGND	VGND#3	4.22708e-17
C149	Y#6	VPWR#11	1.16841e-17
C150	A#35	A#34	4.58334e-17
C151	Y#7	A#30	2.50395e-18
C152	VGND#4	A#32	7.27914e-21
C153	Y#6	VPWR#5	3.13618e-19
C154	Y#5	Y#11	1.34628e-18
C155	VPWR	Y#2	5.1431e-18
C156	Y#15	A#23	1.66032e-17
C157	VPWR	Y#3	2.2595e-18
C158	VGND#4	A#25	2.85948e-18
C159	VPWR	Y#4	2.2595e-18
C160	A#23	VPWR#10	1.70122e-18
C161	A#34	A#33	3.77855e-17
C162	VPWR	Y#5	2.2595e-18
C163	Y#7	VPWR#11	5.71807e-21
C164	VGND#4	A#22	2.80314e-18
C165	VPWR	Y#6	2.2595e-18
C166	VGND#3	Y#15	2.26944e-19
C167	VPWR	Y#7	3.62222e-18
C168	Y#4	VPWR#10	1.45196e-17
C169	VGND#2	Y#17	2.26944e-19
C170	Y#13	A#28	8.71545e-18
C171	Y#17	A#9	1.1827e-18
C172	VGND#1	Y	2.28656e-17
C173	A#33	A#26	4.58334e-17
C174	Y#7	A#31	5.93501e-18
C175	VPWR	VPWR#2	3.83869e-17
C176	VPWR	VPWR#3	3.47285e-17
C177	VPWR	VPWR#5	3.48017e-17
C178	Y#2	VPWR#9	1.26559e-21
C179	Y	Y#2	9.29444e-20
C180	Y#6	VPWR#6	1.6661e-19
C181	Y#5	VPWR#10	1.16841e-17
C182	VPWR	VPWR#6	3.88801e-17
C183	VGND#4	A#1	3.63957e-20
C184	VGND#8	Y#16	3.16608e-17
C185	A#26	A#21	3.85839e-17
C186	Y#4	Y#10	1.34628e-18
C187	A#2	VNB	4.37392e-17
C188	A#3	VNB	3.6588e-17
C189	VGND#3	Y#17	2.26944e-19
C190	A#5	VNB	3.96704e-17
C191	VGND#2	Y#19	2.26944e-19
C192	Y#13	A#29	8.71545e-18
C193	A#7	VNB	3.65037e-17
C194	A#9	Y#10	5.53701e-19
C195	VGND#2	A#5	1.66151e-20
C196	VPWR#7	VPWR#6	7.08704e-19
C197	A#9	VNB	3.96364e-17
C198	Y#3	VPWR#9	1.44232e-17
C199	A#23	VNB	5.80526e-17
C200	VPWR#4	VPWR#7	2.73313e-17
C201	A#27	VNB	4.87419e-17
C202	A#28	VNB	3.4161e-17
C203	A#29	VNB	3.4161e-17
C204	A#30	VNB	3.41612e-17
C205	A#31	VNB	5.12089e-17
C206	A#21	A#19	4.67431e-17
C207	A	Y#2	7.72835e-17
C208	VGND#8	VGND#6	4.54777e-18
C209	A	Y#3	8.0916e-17
C210	A	Y#4	8.0916e-17
C211	Y#7	VPWR#6	3.13618e-19
C212	A	Y#5	8.0916e-17
C213	A	Y#6	8.0916e-17
C214	Y#4	VPWR#9	1.16975e-17
C215	Y#7	A	7.49262e-17
C216	VGND#1	VPWR#1	8.72428e-20
C217	Y#13	A	2.28574e-16
C218	A#19	A#17	3.85839e-17
C219	Y#11	VPWR#4	7.69774e-18
C220	Y#13	A#30	8.71545e-18
C221	Y#3	Y#9	1.34628e-18
C222	Y#15	A	8.49175e-17
C223	Y#17	A	8.48337e-17
C224	Y#8	VPWR#6	1.57575e-17
C225	A#37	VPWR#7	2.77099e-17
C226	Y#19	A	6.63993e-17
C227	Y#16	VGND#6	3.16407e-17
C228	Y#2	VPWR#8	1.44232e-17
C229	Y#10	VPWR#4	9.23085e-18
C230	A#7	VPWR#9	1.15453e-18
C231	Y#8	A#37	4.70086e-17
C232	VGND#4	VGND#7	6.1812e-17
C233	A#17	A#15	4.67431e-17
C234	VPWR#12	A#37	7.14071e-19
C235	VPWR#7	A#36	1.24819e-18
C236	VPWR#2	A#2	2.01982e-20
C237	VGND#4	Y#16	7.18092e-18
C238	Y#3	VPWR#8	1.16841e-17
C239	Y#8	A#36	5.31706e-17
C240	Y#13	A#31	2.27101e-17
C241	Y#16	Y#18	3.05636e-18
C242	VPWR#4	VPWR#1	2.55859e-17
C243	VGND#3	VGND#2	1.38123e-18
C244	A#36	VPWR#12	3.1819e-17
C245	Y#2	Y#1	9.73268e-19
C246	VGND#2	A#7	1.88912e-20
C247	A#15	A#14	3.77823e-17
C248	VPWR#7	A#35	2.6379e-19
C249	Y#12	A#36	1.49612e-18
C250	Y#8	A#35	1.93064e-18
C251	A#5	Y#9	4.62331e-19
C252	VPWR#11	A#36	1.71283e-19
C253	A#9	VPWR#9	4.96495e-19
C254	VGND#4	VGND#1	2.78711e-17
C255	A#35	VPWR#12	2.81567e-17
C256	VGND#6	Y#18	3.16608e-17
C257	VPWR#2	A#3	2.04712e-20
C258	Y#12	VPWR#5	7.69774e-18
C259	Y#12	A#35	4.61514e-17
C260	A#14	A#12	4.567e-17
C261	Y#2	VPWR#1	3.11871e-17
C262	VPWR#11	A#35	3.70183e-19
C263	VPWR#12	A#34	4.09291e-19
C264	A#27	A#23	6.26295e-18
C265	Y#12	VPWR#6	9.23085e-18
C266	Y#12	A#34	5.3027e-17
C267	VGND#6	VGND#5	4.55192e-18
C268	A#3	VPWR#8	8.21251e-19
C269	A#34	VPWR#11	3.18165e-17
C270	VPWR#12	A#33	1.78501e-19
C271	A#7	Y#9	8.22328e-20
C272	VGND#4	Y#13	4.0075e-17
C273	Y#11	A#34	1.49612e-18
C274	VGND#4	Y#15	2.26944e-19
C275	Y#12	A#33	1.59399e-18
C276	VPWR#10	A#34	1.71283e-19
C277	Y#4	VPWR#4	1.6661e-19
C278	A#33	VPWR#11	2.81567e-17
C279	Y#18	VGND#5	3.16407e-17
C280	Y#5	VPWR#4	3.13618e-19
C281	VGND#4	VGND#2	4.75819e-17
C282	Y#11	A#33	4.61514e-17
C283	VGND#4	VGND#3	3.90603e-17
C284	VGND#3	A#7	3.64167e-20
C285	Y#2	A#2	5.34791e-18
C286	VPWR#10	A#33	3.70183e-19
C287	VPWR#11	A#26	4.09291e-19
C288	A#5	VPWR#8	8.6347e-19
C289	VPWR#2	A#5	1.584e-20
C290	A#7	A#5	1.00562e-17
C291	Y#11	VPWR#5	9.23085e-18
C292	Y#11	A#26	5.3027e-17
C293	A#32	A#25	7.3762e-19
C294	Y#18	Y#20	3.05636e-18
C295	A#2	Y#1	2.70455e-19
C296	A#26	VPWR#10	3.18165e-17
C297	VPWR#11	A#21	1.78501e-19
C298	Y#10	A#26	1.49612e-18
C299	Y#2	A#3	2.43182e-18
C300	Y#11	A#21	1.59399e-18
C301	VPWR#4	VPWR#2	4.49989e-17
C302	VPWR#9	A#26	1.71283e-19
C303	VPWR#4	VPWR#3	3.88204e-17
C304	A#25	A#22	1.92605e-17
C305	A#21	VPWR#10	2.81567e-17
C306	VGND#5	Y#20	3.16608e-17
C307	A#3	Y#1	2.74109e-19
C308	VPWR#4	VPWR#5	3.88204e-17
C309	VPWR#4	VPWR#6	4.52998e-17
C310	Y#10	A#21	4.61514e-17
C311	VPWR#3	VPWR#2	7.4289e-19
C312	A#26	A#23	1.85656e-19
C313	VPWR#9	A#21	3.70183e-19
C314	VPWR#10	A#19	4.09291e-19
C315	Y#7	A#37	2.36447e-17
C316	Y#10	VPWR#3	7.69774e-18
C317	VGND#3	A#9	5.2349e-21
C318	VGND#5	VGND#1	4.45495e-18
C319	A#22	A#20	3.44412e-17
C320	Y#10	A#19	5.3027e-17
C321	Y	A#2	1.83466e-17
C322	A#19	VPWR#9	3.18165e-17
C323	VPWR#10	A#17	1.78501e-19
C324	Y	A#3	2.82321e-19
C325	Y	A#5	1.60772e-19
C326	Y#6	A#36	4.93999e-21
C327	VPWR#3	A#5	1.78536e-20
C328	Y#9	A#19	1.49612e-18
C329	Y#10	A#17	1.59399e-18
C330	Y	A#7	7.88767e-20
C331	Y#7	A#36	1.82936e-17
C332	Y#20	VGND#1	3.16608e-17
C333	A#20	A#18	1.91398e-17
C334	VPWR#8	A#19	1.71283e-19
C335	A#17	VPWR#9	2.81567e-17
C336	Y#9	A#17	4.61514e-17
C337	VGND#7	Y#13	8.15911e-17
C338	Y#9	VPWR#2	7.69774e-18
C339	Y#6	A#35	1.70377e-17
C340	VPWR#8	A#17	3.70183e-19
C341	VPWR#9	A#15	4.09291e-19
C342	VPWR#6	A#37	2.1503e-18
C343	Y#7	A#35	2.63565e-19
C344	A#18	A#16	3.44434e-17
C345	Y#9	A#15	5.30095e-17
C346	Y#9	VPWR#3	9.23085e-18
C347	VGND#3	A#23	4.55209e-22
C348	Y#5	A#34	4.93999e-21
C349	VPWR#9	A#14	1.78501e-19
C350	A#15	VPWR#8	3.18165e-17
C351	Y#13	Y#14	3.87043e-17
C352	Y#6	A#34	1.77822e-17
C353	VPWR#5	A#36	8.34499e-20
C354	Y#9	A#14	1.58905e-18
C355	Y#1	A#15	1.82447e-18
C356	A	A#2	1.19648e-17
C357	A#16	A#13	1.90329e-17
C358	Y#7	A#34	1.29001e-19
C359	VPWR#3	A#7	6.14135e-21
C360	A	A#3	1.91754e-17
C361	VPWR#6	A#36	5.3291e-18
C362	VPWR#1	A#15	2.54733e-19
C363	A#14	VPWR#8	2.81567e-17
C364	A	A#5	2.11966e-17
C365	Y#3	A#5	3.30981e-18
C366	Y#5	A#33	1.70377e-17
C367	A	A#7	2.08893e-17
C368	Y#1	A#14	4.62673e-17
C369	Y#13	VGND#8	4.71824e-17
C370	A	A#9	2.26311e-17
C371	Y#6	A#33	4.93999e-21
C372	Y#1	VPWR#2	1.66935e-17
C373	A	A#23	3.17282e-17
C374	VPWR#8	A#12	7.81638e-19
C375	VPWR#1	A#14	1.22325e-18
C376	A#13	A#1	2.49066e-17
C377	Y#7	A#33	8.28613e-20
C378	VPWR#5	A#35	2.99535e-19
C379	A	A#27	2.36036e-17
C380	A	A#28	1.74534e-17
C381	Y#4	A#26	4.93999e-21
C382	VPWR#6	VPWR#5	7.4289e-19
C383	A	A#29	1.74534e-17
C384	VPWR#6	A#35	4.55094e-18
C385	Y#1	A#12	4.84162e-17
C386	A	A#30	1.74504e-17
C387	VGND#8	Y#15	1.37976e-17
C388	A	A#31	9.4603e-18
C389	Y#5	A#26	1.77822e-17
C390	A#28	A#27	7.05493e-19
C391	Y#13	Y#16	3.81299e-18
C392	A#12	VPWR#1	2.82605e-17
C393	VPWR#2	VPWR#1	7.43786e-19
C394	Y#4	A#21	1.70377e-17
C395	VPWR#5	A#34	5.32783e-18
C396	Y#3	A#7	1.52755e-18
C397	VPWR#3	A#9	1.55761e-20
C398	VPWR#6	A#34	3.40035e-19
C399	Y#5	A#21	4.93999e-21
C400	Y#2	A#19	2.17927e-19
C401	Y#3	A#19	4.93999e-21
C402	Y#4	A#19	1.77822e-17
C403	VPWR#7	Y#8	5.79728e-17
C404	VPWR#5	A#33	4.55094e-18
C405	Y#2	A#17	1.85336e-19
C406	VGND#6	Y#15	1.35771e-17
C407	VGND#7	A#32	2.66896e-17
C408	VPWR#6	A#33	9.12873e-20
C409	VPWR#7	VPWR#12	2.02265e-18
C410	Y#3	A#17	1.70377e-17
C411	A#32	Y#14	1.75734e-17
C412	Y#4	A#17	4.93999e-21
C413	Y#8	VPWR#12	5.29637e-17
C414	VPWR#3	A#26	8.34499e-20
C415	Y#2	A#15	2.55409e-19
C416	VGND#6	Y#17	1.37976e-17
C417	VPWR#5	A#26	3.40035e-19
C418	Y#3	A#15	1.77822e-17
C419	A#25	Y#14	1.52816e-17
C420	Y#8	Y#12	2.75876e-18
C421	Y#4	A#7	5.03971e-19
C422	A#25	VGND#8	2.14912e-17
C423	Y#3	Y#2	2.75876e-20
C424	Y#2	A#14	1.74018e-17
C425	VPWR#12	Y#12	6.12484e-17
C426	VPWR#3	A#21	2.99535e-19
C427	Y#16	A#25	9.69483e-19
C428	Y#3	A#14	4.93999e-21
C429	VPWR#5	A#21	9.12873e-20
C430	VGND#3	Y#16	3.6015e-18
C431	A#9	A#7	6.30985e-18
C432	VPWR#12	VPWR#11	2.09124e-18
C433	A#22	VGND#8	1.64931e-17
C434	VGND#6	A#25	7.05463e-19
C435	A#7	A#15	2.31942e-19
C436	Y#2	A#12	2.56179e-17
C437	VPWR#2	A#19	8.34499e-20
C438	Y#16	A#22	2.33678e-17
C439	VGND#5	Y#17	1.35771e-17
C440	VPWR#3	A#19	5.30167e-18
C441	Y#12	VPWR#11	5.29637e-17
C442	VGND#8	A#20	2.0493e-18
C443	Y#4	A#9	3.09634e-18
C444	VGND#6	A#22	1.12832e-18
C445	VGND#2	Y#18	5.96328e-18
C446	A#29	A#28	8.81379e-19
C447	Y#12	Y#11	2.75876e-18
C448	Y#4	Y#3	2.75876e-20
C449	Y#16	A#20	2.7106e-17
C450	VGND#5	Y#19	1.37976e-17
C451	VPWR#2	A#17	2.99535e-19
C452	VGND#8	A#18	5.16115e-19
C453	A#20	VGND#6	1.86102e-17
C454	VPWR#3	A#17	4.53544e-18
C455	VPWR#11	Y#11	6.12484e-17
C456	VGND#3	Y#18	4.81915e-18
C457	Y#16	A#18	6.29336e-19
C458	Y#18	A#20	6.29336e-19
C459	VPWR#11	VPWR#10	2.09124e-18
C460	VPWR#2	A#15	5.33959e-18
C461	A#18	VGND#6	1.61778e-17
C462	VGND#5	A#20	5.16115e-19
C463	Y#4	A#23	1.16056e-18
C464	VPWR#3	A#15	3.40035e-19
C465	VGND#4	A#23	6.62328e-20
C466	Y#18	A#18	2.33678e-17
C467	Y#11	VPWR#10	5.29637e-17
C468	Y#5	Y#4	2.75876e-20
C469	VGND#4	A#27	1.61811e-19
C470	VGND#2	Y#20	1.25786e-17
C471	VGND#6	A#16	1.12832e-18
C472	VGND#4	A#28	2.14471e-19
C473	VGND#5	A#18	1.12832e-18
C474	VGND#1	Y#19	2.79172e-18
C475	VGND#4	A#29	1.1904e-19
C476	VGND#7	VPWR#7	2.80099e-18
C477	VPWR#2	A#14	4.55598e-18
C478	Y#11	Y#10	2.75876e-18
C479	VPWR#5	A#27	2.37602e-20
C480	Y#18	A#16	2.7106e-17
C481	A#31	A#27	1.36963e-19
C482	VPWR#3	A#14	9.12873e-20
C483	VGND#6	A#13	5.16115e-19
C484	A#16	VGND#5	1.86102e-17
C485	VPWR#10	Y#10	6.12484e-17
C486	VGND#2	VGND#1	1.38629e-18
C487	VGND#7	A#29	9.49868e-20
C488	Y#13	A#32	2.37214e-17
C489	Y#18	A#13	6.29336e-19
C490	VPWR#2	A#12	2.23523e-18
C491	Y#20	A#16	9.45506e-19
C492	VPWR#5	A#28	1.6104e-20
C493	A#3	A#2	7.70867e-18
C494	VPWR#10	VPWR#9	2.09124e-18
C495	Y#6	Y#5	2.75876e-20
C496	A#13	VGND#5	1.61778e-17
C497	VGND#7	A#30	2.14471e-19
C498	VPWR#4	A#9	2.41562e-20
C499	VGND#1	A#16	5.16115e-19
C500	Y#5	A#23	1.26006e-18
C501	Y#13	A#25	3.9313e-17
C502	Y#10	VPWR#9	5.29637e-17
C503	A#30	Y#8	2.70455e-19
C504	Y#20	A#13	2.56585e-17
C505	VPWR#4	A#27	2.61362e-20
C506	VGND#7	A#31	4.80805e-20
C507	Y#15	A#25	3.92651e-19
C508	VGND#5	A#1	1.84774e-18
C509	VGND#1	A#13	2.73856e-18
C510	A#31	Y#8	2.74109e-19
C511	Y#10	Y#9	2.75876e-18
C512	A#1	Y#20	1.16809e-17
C513	Y#13	A#22	1.15804e-18
C514	A#30	A#29	7.05493e-19
C515	Y#19	Y#2	1.78453e-18
C516	VGND#8	A#23	2.12455e-18
C517	VPWR#9	Y#9	6.12484e-17
C518	Y#15	A#22	1.16898e-17
C519	VGND#1	A#1	2.92806e-17
C520	Y#7	Y#6	2.75876e-20
C521	Y#5	A#27	4.17039e-18
C522	VPWR#6	A#28	3.82129e-21
C523	VPWR#9	VPWR#8	2.09124e-18
C524	A#29	VPWR#12	8.21251e-19
C525	Y#15	A#20	1.16878e-17
C526	Y#9	VPWR#8	5.29637e-17
C527	A#30	VPWR#12	8.6347e-19
C528	Y#17	A#20	2.59769e-19
C529	VPWR#6	A#29	2.04712e-20
C530	VGND#6	A#7	3.85617e-19
C531	Y#9	Y#1	2.73117e-18
C532	Y#13	Y#7	2.09957e-18
C533	Y#15	A#18	2.59769e-19
C534	Y#2	VPWR#2	1.6661e-19
C535	Y#17	A#18	1.16898e-17
C536	VPWR#8	Y#1	6.12484e-17
C537	VPWR#6	A#30	2.01982e-20
C538	VGND#3	A#20	2.82539e-18
C539	A#28	Y#12	2.70455e-19
C540	A#23	A#9	1.03345e-17
C541	VPWR#8	VPWR#1	2.09124e-18
C542	VGND#6	A#9	1.28552e-18
C543	A#29	Y#12	2.74109e-19
C544	Y#3	VPWR#2	3.13618e-19
C545	Y#17	A#16	1.16878e-17
C546	VGND#5	A#3	4.26066e-19
C547	VGND#3	A#18	2.80314e-18
C548	Y#6	A#28	2.49969e-18
C549	VPWR#6	A#31	2.04712e-20
C550	Y#13	Y#15	1.57387e-18
C551	Y#1	VPWR#1	5.29637e-17
C552	Y#19	A#16	3.8294e-19
C553	Y#3	VPWR#3	1.6661e-19
C554	VGND#2	A#16	2.80314e-18
C555	Y#17	A#13	2.59769e-19
C556	Y#19	A#2	1.11815e-17
C557	A#27	VPWR#11	8.21251e-19
C558	Y#6	A#29	2.45224e-18
C559	A#31	A#30	8.81118e-19
C560	Y#7	VPWR#7	2.67416e-17
C561	Y#19	A#13	1.23782e-17
*
*
.ENDS sky130_fd_sc_hs__clkinv_8
*
