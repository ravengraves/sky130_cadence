* Extracted by Quantus, converted by sky130cad/quantus.py
*
*
*
*                       LINUX           Wed Nov 18 08:28:44 2026
*
*
*
*  PROGRAM  advgen
*
*  Name           : advgen - Quantus - (64-bit)
*  Version        : 25.1.0-p047
*  Build Date     : Thu Dec 11 23:20:30 PST 2025
*
*  HSPICE LIBRARY
*
*  OPERATING_TEMPERATURE 150
*  QRC_TECH_DIR <path>/tech
*
*
*

*
.SUBCKT sky130_fd_sc_hs__dfxbp_1 VPB VNB VGND VPWR Q Q_N D CLK
*
*
*  caps2d version: 10
*
*
*       TRANSISTOR CARDS
*
*
XM27 a_27_74##16 CLK#3 VGND#16 VNB sky130_fd_pr__nfet_01v8_lvt l=0.15 w=0.74 ad=0.2109 as=0.4034 pd=2.05 ps=2.7
XM13 VGND#16 a_27_74# a_205_368##14 VNB sky130_fd_pr__nfet_01v8_lvt l=0.15 w=0.74 ad=0.4034 as=0.3252 pd=2.7 ps=2.59
XM0 VGND#15 D#3 a_420_503# VNB sky130_fd_pr__nfet_01v8_lvt l=0.15 w=0.42 ad=0.368725 as=0.1176 pd=2.64 ps=1.4
XM15 a_420_503# a_27_74##6 a_543_447##8 VNB sky130_fd_pr__nfet_01v8_lvt l=0.15 w=0.42 ad=0.1176 as=0.151375 pd=1.4 ps=1.66
XM5 a_543_447##8 a_205_368# a_713_102# VNB sky130_fd_pr__nfet_01v8_lvt l=0.15 w=0.42 ad=0.151375 as=0.0882 pd=1.66 ps=1.26
XM6 a_713_102# a_701_463##3 VGND#14 VNB sky130_fd_pr__nfet_01v8_lvt l=0.15 w=0.42 ad=0.0882 as=0.29025 pd=1.26 ps=2.38
XM26 VGND#14 a_543_447# a_701_463##7 VNB sky130_fd_pr__nfet_01v8_lvt l=0.15 w=0.55 ad=0.29025 as=0.2365 pd=2.38 ps=2.26
XM24 a_701_463##7 a_205_368##4 a_1005_120##6 VNB sky130_fd_pr__nfet_01v8_lvt l=0.15 w=0.55 ad=0.2365 as=0.2593 pd=2.26 ps=2.18
XM16 a_1005_120##6 a_27_74##8 a_1143_146# VNB sky130_fd_pr__nfet_01v8_lvt l=0.15 w=0.42 ad=0.2593 as=0.1008 pd=2.18 ps=1.32
XM18 a_1143_146# a_1191_120##3 VGND#13 VNB sky130_fd_pr__nfet_01v8_lvt l=0.15 w=0.42 ad=0.1008 as=0.1197 pd=1.32 ps=1.41
XM21 a_1191_120##14 a_1005_120##3 VGND#12 VNB sky130_fd_pr__nfet_01v8_lvt l=0.15 w=0.64 ad=0.1824 as=0.2938 pd=1.85 ps=2.32
XM19 VGND#12 a_1191_120##7 Q#4 VNB sky130_fd_pr__nfet_01v8_lvt l=0.15 w=0.74 ad=0.2938 as=0.2109 pd=2.32 ps=2.05
XM25 a_1644_94##6 a_1191_120##8 VGND#11 VNB sky130_fd_pr__nfet_01v8_lvt l=0.15 w=0.64 ad=0.1824 as=0.2589 pd=1.85 ps=2.2
XM2 VGND#11 a_1644_94##3 Q_N#3 VNB sky130_fd_pr__nfet_01v8_lvt l=0.15 w=0.74 ad=0.2589 as=0.2109 pd=2.2 ps=2.05
XM7 a_27_74##14 CLK#1 VPWR#16 VPB sky130_fd_pr__pfet_01v8 l=0.15 w=1.12 ad=0.3248 as=0.336 pd=2.82 ps=2.84
XM22 VPWR#16 a_27_74##3 a_205_368##11 VPB sky130_fd_pr__pfet_01v8 l=0.15 w=1.12 ad=0.336 as=0.3192 pd=2.84 ps=2.81
XM3 VPWR#15 D#1 a_420_503##2 VPB sky130_fd_pr__pfet_01v8 l=0.15 w=0.42 ad=0.2282 as=0.29275 pd=2.1 ps=2.67
XM20 a_420_503##2 a_205_368##3 a_543_447##6 VPB sky130_fd_pr__pfet_01v8 l=0.15 w=0.42 ad=0.29275 as=0.215075 pd=2.67 ps=2.22
XM10 a_543_447##6 a_27_74##4 a_650_508# VPB sky130_fd_pr__pfet_01v8 l=0.15 w=0.42 ad=0.215075 as=0.1134 pd=2.22 ps=1.38
XM17 a_650_508# a_701_463##2 VPWR#14 VPB sky130_fd_pr__pfet_01v8 l=0.15 w=0.42 ad=0.1134 as=0.46515 pd=1.38 ps=3.43
XM1 VPWR#14 a_543_447##4 a_701_463##4 VPB sky130_fd_pr__pfet_01v8 l=0.15 w=0.84 ad=0.46515 as=0.5082 pd=3.43 ps=2.89
XM14 a_701_463##4 a_27_74##9 a_1005_120##7 VPB sky130_fd_pr__pfet_01v8 l=0.15 w=0.84 ad=0.5082 as=0.2817 pd=2.89 ps=2.45
XM23 a_1005_120##7 a_205_368##6 a_1158_482# VPB sky130_fd_pr__pfet_01v8 l=0.15 w=0.42 ad=0.2817 as=0.1008 pd=2.45 ps=1.32
XM4 a_1158_482# a_1191_120# VPWR#13 VPB sky130_fd_pr__pfet_01v8 l=0.15 w=0.42 ad=0.1008 as=0.1197 pd=1.32 ps=1.41
XM11 a_1191_120##10 a_1005_120# VPWR#12 VPB sky130_fd_pr__pfet_01v8 l=0.15 w=1 ad=0.29 as=0.3868 pd=2.58 ps=2.95
XM12 VPWR#12 a_1191_120##9 Q#1 VPB sky130_fd_pr__pfet_01v8 l=0.15 w=1.12 ad=0.3868 as=0.3192 pd=2.95 ps=2.81
XM8 a_1644_94##7 a_1191_120##4 VPWR#11 VPB sky130_fd_pr__pfet_01v8 l=0.15 w=0.84 ad=0.2394 as=0.3724 pd=2.25 ps=2.95
XM9 VPWR#11 a_1644_94# Q_N#1 VPB sky130_fd_pr__pfet_01v8 l=0.15 w=1.12 ad=0.3724 as=0.3248 pd=2.95 ps=2.82
*
*
*       RESISTOR AND CAP/DIODE CARDS
*
Rg1	CLK#1	CLK#2	484.027802
Rg2	CLK#2	CLK#3	299.905945
Rg3	a_27_74#	a_27_74##2	327.776306
Rg4	a_27_74##2	a_27_74##3	502.421692
Rg5	D#1	D#2	226.096359
Rg6	D#3	D#4	345.927887
Rg7	a_27_74##4	a_27_74##5	359.238403
Rg8	a_27_74##5	a_27_74##6	617.791809
Rg9	a_205_368#	a_205_368##2	1990.957886
Rg10	a_205_368##2	a_205_368##3	803.138977
Rg11	a_701_463#	a_701_463##2	847.192810
Rg12	a_701_463#	a_701_463##3	210.074844
Rg13	a_543_447#	a_543_447##2	607.015320
Rg14	a_543_447##2	a_543_447##3	29.612585
Rg15	a_543_447##2	a_543_447##4	369.314545
Rg16	a_205_368##4	a_205_368##5	307.937683
Rg17	a_27_74##7	a_27_74##8	216.119781
Rg18	a_27_74##8	a_27_74##9	965.725586
Rg19	a_205_368##6	a_205_368##7	363.657745
Rg20	a_1191_120#	a_1191_120##2	317.176758
Rg21	a_1191_120##2	a_1191_120##3	491.001862
Rg22	a_1005_120#	a_1005_120##2	470.485138
Rg23	a_1005_120##2	a_1005_120##3	316.209290
Rg24	a_1191_120##4	a_1191_120##5	423.597717
Rg25	a_1191_120##5	a_1191_120##6	180.798630
Rg26	a_1191_120##6	a_1191_120##7	390.517181
Rg27	a_1191_120##5	a_1191_120##8	423.145813
Rg28	a_1191_120##6	a_1191_120##9	444.766602
Rg29	a_1644_94#	a_1644_94##2	465.025360
Rg30	a_1644_94##2	a_1644_94##3	366.265259
Rf1	CLK	CLK#4	1.568163
Rf2	CLK#5	CLK#2	161.800964
Rf3	CLK#4	CLK#5	3.353338
Rf4	D#4	D	160.537720
Rf5	D	D#2	196.641434
Rf6	a_420_503#	a_420_503##2	143.405518
Rf7	a_543_447##3	a_543_447##7	272.359619
Rf8	a_543_447##7	a_543_447##8	131.358551
Rf9	a_543_447##6	a_543_447##7	15.000000
Rf10	a_701_463##4	a_701_463##5	99.645470
Rf11	a_701_463##5	a_701_463#	182.472321
Rf12	a_701_463##5	a_701_463##7	27.441675
Rf13	a_27_74##5	a_27_74##11	255.955902
Rf14	a_27_74##11	a_27_74##12	240.692841
Rf15	a_27_74##12	a_27_74##13	15.177165
Rf16	a_27_74##13	a_27_74##14	91.665573
Rf17	a_27_74##11	a_27_74##7	238.752136
Rf18	a_27_74##12	a_27_74##16	50.045601
Rf19	a_205_368##7	a_205_368##9	299.741638
Rf20	a_205_368##9	a_205_368##10	271.191589
Rf21	a_205_368##10	a_205_368##11	7.767661
Rf22	a_205_368##9	a_205_368##5	256.732758
Rf23	a_205_368##10	a_205_368##13	12.568270
Rf24	a_205_368##13	a_205_368##14	32.572445
Rf25	a_1005_120##2	a_1005_120##5	257.700928
Rf26	a_1005_120##5	a_1005_120##6	28.549639
Rf27	a_1005_120##5	a_1005_120##7	98.180252
Rf28	a_1191_120##10	a_1191_120##11	11.875902
Rf29	a_1191_120##11	a_1191_120##2	92.559120
Rf30	a_1191_120##11	a_1191_120##13	45.606003
Rf31	a_1191_120##13	a_1191_120##14	96.583809
Rf32	Q#2	Q	1.294829
Rf33	Q	Q#3	6.797851
Rf34	Q#3	Q#4	97.374283
Rf35	Q#1	Q#2	15.000000
Rf36	Q#1	Q#3	15.000000
Rf37	a_1644_94##2	a_1644_94##5	181.117142
Rf38	a_1644_94##5	a_1644_94##6	47.930981
Rf39	a_1644_94##5	a_1644_94##7	62.563320
Rf40	Q_N	Q_N#2	0.183608
Rf41	Q_N#2	Q_N	13.403392
Rf42	Q_N	Q_N#3	86.518295
Rf43	Q_N#1	Q_N#2	5.000000
Rf45	VPWR#2	VPWR#3	48.188797
Rf46	VPWR#3	VPWR#4	58.107960
Rf47	VPWR#4	VPWR#5	75.615547
Rf48	VPWR#5	VPWR#6	174.878860
Rf49	VPWR#6	VPWR#7	41.951500
Rf50	VPWR#7	VPWR#8	119.778282
Rf51	VPWR#8	VPWR#9	75.615547
Rf53	VPWR#2	VPWR#11	46.297459
Rf54	VPWR#4	VPWR#12	48.457489
Rf55	VPWR#5	VPWR#13	39.625240
Rf56	VPWR#6	VPWR#14	22.904993
Rf57	VPWR#8	VPWR#15	22.697315
Rf58	VPWR#9	VPWR#16	44.620285
Rf60	VGND#2	VGND#3	49.341900
Rf61	VGND#3	VGND#4	62.433640
Rf62	VGND#4	VGND#5	77.384460
Rf63	VGND#5	VGND#6	153.356979
Rf64	VGND#6	VGND#7	57.320107
Rf65	VGND#7	VGND#8	97.121643
Rf66	VGND#8	VGND#9	88.671906
Rf68	VGND#2	VGND#11	41.038895
Rf69	VGND#4	VGND#12	31.948624
Rf70	VGND#5	VGND#13	46.120842
Rf71	VGND#6	VGND#14	24.468842
Rf72	VGND#8	VGND#15	29.536062
Rf73	VGND#9	VGND#16	25.684818
Rf80	a_27_74##2	a_27_74##13	160.232803
Rf84	a_205_368##2	a_205_368##13	160.232803
Rf87	a_1191_120##6	a_1191_120##13	160.232803
Re1	VPWR#3	VPWR	2.920302
Re2	VPWR	VPWR#7	1.251558
Re3	VGND#3	VGND	2.920302
Re4	VGND	VGND#7	1.251558
*
*       CAPACITOR CARDS
*
*
C1	a_27_74##7	a_1005_120##5	1.85025e-18
C2	a_1005_120##5	a_543_447#	1.74029e-19
C3	a_27_74##16	VGND#16	2.05175e-17
C4	VGND#3	a_1191_120##14	1.37596e-17
C5	VGND#8	D#4	2.71164e-19
C6	a_205_368##7	a_205_368##9	2.72351e-18
C7	a_1005_120##7	a_27_74##9	3.02364e-17
C8	a_701_463##3	a_543_447#	1.65812e-17
C9	a_205_368##9	a_27_74##8	1.13813e-18
C10	a_27_74##9	a_701_463##4	3.01157e-17
C11	a_205_368##5	a_1005_120##5	3.79228e-17
C12	a_205_368#	a_543_447#	1.64935e-18
C13	Q_N#3	a_1644_94##2	3.23818e-17
C14	a_1644_94##2	VGND#11	3.50775e-17
C15	a_543_447##4	a_701_463##4	1.36721e-17
C16	a_205_368#	a_701_463##3	4.19791e-17
C17	a_543_447##4	VPWR#14	1.55061e-17
C18	Q#1	VPWR#4	6.13742e-18
C19	a_1005_120##5	a_543_447##3	3.83887e-20
C20	a_701_463##4	a_701_463##2	6.72436e-19
C21	a_205_368##5	a_205_368##9	3.43817e-18
C22	a_701_463##2	VPWR#14	6.78665e-18
C23	a_205_368#	a_27_74##6	3.92399e-17
C24	a_27_74##11	a_27_74##7	2.44041e-18
C25	VGND#8	a_205_368##2	1.40083e-17
C26	a_543_447##6	a_543_447##4	3.81108e-19
C27	a_701_463##4	a_27_74##4	1.09038e-19
C28	Q#4	a_1191_120##6	9.00272e-17
C29	VPWR#4	a_1644_94#	4.03726e-19
C30	VPWR#11	Q_N#1	4.18093e-17
C31	a_205_368#	D#3	1.91969e-17
C32	VPWR#8	D#2	1.02409e-18
C33	a_1191_120##6	VGND#12	1.69166e-17
C34	a_543_447##6	a_701_463##2	1.67938e-17
C35	a_543_447##3	a_205_368##9	5.26922e-17
C36	a_27_74##11	a_27_74##8	1.16887e-19
C37	a_1644_94##5	VPWR#11	6.32192e-18
C38	a_27_74##7	a_701_463##5	4.51556e-17
C39	a_701_463##4	a_205_368##3	7.58272e-20
C40	a_1191_120##14	a_1191_120##6	2.31009e-18
C41	D#3	a_27_74##6	3.63723e-17
C42	Q#4	a_1005_120##2	3.82687e-19
C43	a_1191_120##5	a_1644_94##2	3.24915e-17
C44	a_205_368##11	a_543_447##4	5.76994e-19
C45	a_1644_94##5	a_1191_120##5	4.44895e-17
C46	a_543_447##6	a_27_74##4	2.38777e-17
C47	VGND#12	a_1005_120##2	3.98258e-19
C48	VPWR#8	a_205_368##2	8.64724e-19
C49	a_420_503##2	a_27_74##4	2.28612e-19
C50	a_27_74##11	a_205_368##4	2.16333e-19
C51	a_1005_120##2	a_1191_120##14	5.2876e-17
C52	a_701_463#	a_205_368##9	5.73452e-19
C53	a_1644_94##7	VPWR#3	1.53477e-17
C54	a_701_463##5	a_205_368##5	5.64961e-17
C55	a_1644_94##7	VPWR#11	6.56949e-17
C56	a_205_368##11	a_701_463##2	2.41491e-18
C57	a_205_368##3	a_543_447##6	1.70128e-17
C58	a_27_74##11	a_543_447##3	1.28816e-18
C59	VGND#13	a_1005_120##2	2.87012e-17
C60	a_205_368##9	a_205_368#	2.32988e-19
C61	Q#1	VPWR#3	3.74759e-17
C62	VGND#3	VPWR#11	3.79103e-18
C63	VPWR#5	a_1191_120##9	8.58357e-19
C64	a_1191_120##5	a_1644_94#	1.09062e-18
C65	Q_N#3	a_1644_94##3	3.52676e-17
C66	a_420_503##2	a_205_368##3	4.24151e-17
C67	a_701_463##5	a_27_74##8	1.05929e-18
C68	a_1191_120##3	a_1191_120#	1.8619e-18
C69	a_27_74##11	a_1005_120##6	2.18067e-18
C70	a_205_368##11	a_27_74##4	2.97411e-17
C71	Q#1	VPWR#11	7.76507e-18
C72	a_1005_120##6	a_1005_120##2	1.04935e-19
C73	a_543_447##6	D#1	6.52046e-19
C74	VPWR#4	a_1191_120##9	9.64427e-18
C75	a_1644_94##5	a_1644_94#	1.88814e-19
C76	a_27_74##11	a_543_447#	1.3704e-18
C77	a_701_463##5	a_543_447##3	3.00898e-17
C78	a_1005_120##5	a_205_368##9	9.70971e-19
C79	a_205_368##9	a_27_74##5	7.20605e-19
C80	VPWR#8	a_27_74##2	8.17939e-20
C81	a_1644_94##3	VGND#11	2.18487e-17
C82	a_1191_120##6	a_1191_120##5	6.12464e-19
C83	a_27_74##11	a_701_463#	4.60531e-17
C84	CLK#3	a_27_74#	1.64952e-17
C85	D#1	a_420_503##2	1.14822e-17
C86	Q#1	a_1644_94##5	1.0802e-17
C87	a_205_368##11	a_205_368##3	1.19099e-17
C88	VGND#6	a_27_74##9	5.29302e-20
C89	Q_N#3	a_1191_120##8	2.04612e-18
C90	a_543_447##6	a_27_74##3	6.59439e-20
C91	Q#1	a_1644_94##7	6.87076e-17
C92	a_701_463##5	a_205_368##4	1.37483e-17
C93	D#1	VPWR#15	5.71131e-18
C94	a_1644_94##6	a_1644_94##3	7.24951e-19
C95	VGND#5	a_27_74##9	2.64651e-21
C96	a_420_503##2	a_27_74##3	8.75271e-20
C97	VPWR#5	VPWR#4	1.51079e-18
C98	a_701_463##5	a_701_463#	5.08769e-19
C99	a_27_74##11	a_701_463##3	2.54555e-17
C100	a_205_368##11	D#1	3.15618e-17
C101	a_1644_94##5	a_1191_120##4	6.94809e-20
C102	VPWR#4	a_1005_120#	9.50795e-18
C103	a_1191_120##8	VGND#11	2.50178e-17
C104	a_27_74##11	a_27_74##5	1.6304e-18
C105	VGND#12	a_27_74##7	8.50566e-19
C106	VPWR#16	D#1	7.56645e-19
C107	Q#4	a_1644_94##3	1.172e-18
C108	a_27_74##12	a_205_368#	5.50463e-19
C109	a_1191_120##14	a_27_74##7	3.02163e-19
C110	a_701_463##5	a_543_447#	1.61138e-17
C111	a_1644_94##2	VPWR#11	3.47653e-17
C112	a_205_368##11	a_27_74##3	6.38292e-17
C113	a_1644_94##6	a_1191_120##8	3.7891e-17
C114	a_27_74##11	VGND#14	3.80803e-19
C115	VPWR#5	a_1191_120#	3.58059e-18
C116	a_27_74##7	VGND#13	1.76192e-17
C117	a_27_74##5	a_701_463##5	3.83538e-18
C118	a_27_74##11	a_205_368#	6.15106e-17
C119	a_543_447##8	a_543_447##6	3.94739e-18
C120	VGND#11	a_1191_120##7	1.44104e-18
C121	VGND#12	a_1644_94##3	4.91366e-19
C122	a_27_74##12	D#4	6.89187e-18
C123	a_27_74##3	VPWR#16	2.1781e-17
C124	VPWR#12	Q#1	7.81407e-17
C125	a_1644_94##5	a_1191_120##9	3.66486e-21
C126	a_701_463##5	a_1005_120##6	1.70082e-17
C127	a_205_368##11	CLK#1	3.4406e-18
C128	Q#4	a_1191_120##8	5.86299e-18
C129	a_27_74##7	a_1005_120##6	5.62517e-17
C130	a_27_74##14	a_27_74##3	8.08127e-19
C131	a_27_74##12	a_27_74##6	5.87762e-19
C132	a_701_463##5	a_701_463##3	5.23271e-19
C133	a_1644_94##6	a_1191_120##7	6.81255e-19
C134	VGND#11	Q_N#3	6.40784e-17
C135	VPWR#16	CLK#1	4.88524e-17
C136	a_420_503#	a_543_447##6	2.3586e-17
C137	a_27_74##7	a_701_463##7	1.89033e-18
C138	VGND#12	a_1191_120##8	3.1201e-19
C139	VGND#11	a_1005_120##3	2.29453e-19
C140	a_27_74##7	VGND#14	2.88087e-18
C141	a_27_74##11	a_27_74##6	9.72646e-18
C142	a_1191_120##6	Q#1	5.28731e-17
C143	a_27_74##14	CLK#1	4.22673e-17
C144	VGND#4	Q#4	6.8753e-18
C145	a_27_74##12	D#2	1.71719e-18
C146	VPWR#5	a_205_368##6	2.97517e-18
C147	a_1191_120##4	a_1644_94#	3.09e-17
C148	Q#4	a_1191_120##7	5.24837e-17
C149	a_701_463##5	a_701_463##7	1.23171e-18
C150	a_1005_120##6	a_205_368##5	5.42033e-18
C151	a_1191_120##6	VPWR#12	3.4182e-17
C152	VGND#5	VGND#12	3.08307e-18
C153	a_27_74##12	D#3	9.21197e-18
C154	a_205_368##5	a_701_463##7	3.95187e-19
C155	a_1191_120##9	a_1644_94#	7.19907e-19
C156	VPWR#6	VPWR#14	9.01788e-18
C157	a_27_74##11	a_543_447##8	9.11902e-17
C158	a_1191_120##7	VGND#12	1.89681e-17
C159	VPWR#6	a_27_74##9	2.12778e-18
C160	a_1191_120##11	a_1191_120##4	7.94584e-20
C161	a_27_74##12	a_420_503#	4.28228e-17
C162	a_27_74##11	D#3	8.90959e-18
C163	a_205_368#	a_701_463##2	5.9989e-19
C164	a_27_74##12	a_205_368##2	4.40478e-17
C165	Q#4	a_1005_120##3	9.49509e-19
C166	a_1191_120##9	a_1191_120##4	5.41517e-18
C167	VPWR#13	VPWR#12	3.54278e-18
C168	VPWR#5	a_27_74##9	3.7093e-18
C169	a_27_74##11	a_205_368##2	1.68783e-18
C170	a_1191_120##14	a_1191_120##7	5.46317e-19
C171	a_1644_94##6	VGND#11	3.9533e-17
C172	a_27_74##12	a_27_74#	1.60736e-17
C173	a_1005_120##2	VPWR#13	6.84539e-19
C174	a_1005_120##3	VGND#12	2.52032e-17
C175	VPWR#4	a_27_74##9	1.42814e-19
C176	VGND#5	a_1191_120##14	5.63137e-18
C177	a_1191_120##11	Q#1	7.17427e-19
C178	a_27_74##11	a_420_503#	3.2702e-17
C179	a_205_368##11	VPWR#7	2.51133e-17
C180	VGND#13	a_1191_120##7	7.78965e-20
C181	a_27_74##12	VGND#15	4.62278e-17
C182	a_1191_120##11	a_1191_120##9	1.5496e-18
C183	a_27_74##11	a_27_74#	3.791e-19
C184	a_1005_120#	a_1191_120##9	3.63738e-17
C185	VPWR#6	a_543_447##4	9.69049e-18
C186	a_420_503#	a_205_368##11	9.99504e-19
C187	a_205_368#	a_205_368##3	3.36984e-19
C188	VGND#8	a_205_368##3	1.73166e-19
C189	VGND#3	a_1644_94##3	2.30721e-18
C190	a_1191_120##14	a_1005_120##3	4.60678e-17
C191	Q#4	VGND#11	8.40609e-18
C192	a_1191_120##2	VPWR#13	2.86706e-17
C193	a_701_463#	VGND#14	1.25253e-18
C194	VPWR#5	a_543_447##4	8.14627e-20
C195	a_27_74##12	CLK#3	1.24626e-17
C196	VGND#3	a_1191_120##8	9.57682e-18
C197	VGND#4	a_1191_120##14	7.39172e-18
C198	a_27_74##11	VGND#15	3.25418e-17
C199	VGND#13	a_1005_120##3	1.39658e-18
C200	a_1191_120##11	VPWR#12	6.39643e-17
C201	VPWR#8	a_701_463##2	7.0809e-19
C202	VGND#3	a_1191_120##7	1.72306e-18
C203	D#3	a_205_368##3	5.54452e-18
C204	a_1191_120#	a_1005_120#	8.12912e-18
C205	a_543_447##8	a_701_463#	1.49082e-18
C206	a_1005_120##7	a_1191_120##2	2.52878e-19
C207	a_27_74##12	a_205_368##14	4.65406e-17
C208	a_27_74##11	CLK#3	3.17238e-19
C209	a_205_368##7	VPWR#13	3.63768e-17
C210	a_1191_120##11	a_1005_120#	4.99628e-17
C211	a_1191_120##14	a_1191_120##3	9.76962e-19
C212	a_1005_120##6	a_1191_120##7	2.1335e-19
C213	Q#4	a_1644_94##6	3.82867e-17
C214	VGND#3	a_1005_120##3	3.87695e-19
C215	VGND#12	VGND#11	1.3641e-18
C216	VPWR#6	a_701_463##2	1.47447e-17
C217	VGND#5	a_1005_120##5	1.73276e-18
C218	a_1005_120##7	a_205_368##7	6.64055e-17
C219	VGND#13	a_1191_120##3	4.02922e-17
C220	a_543_447##8	a_27_74##5	6.55536e-17
C221	a_205_368##6	a_1191_120#	4.29878e-17
C222	a_27_74##9	a_1005_120#	9.42821e-20
C223	a_1191_120##11	a_1191_120##10	5.40538e-18
C224	a_1005_120##6	a_1005_120##3	2.25429e-19
C225	a_420_503#	a_27_74##5	3.80473e-19
C226	a_27_74##12	VGND#16	5.03191e-17
C227	VPWR#8	a_27_74##4	1.74904e-18
C228	a_1191_120##11	a_1191_120#	4.04611e-18
C229	a_1191_120##8	a_1644_94##2	9.33174e-19
C230	a_205_368##9	a_1158_482#	2.02767e-18
C231	VPWR#6	a_27_74##4	2.68625e-18
C232	VGND#13	a_27_74##8	2.15298e-18
C233	a_543_447##8	D#4	3.03825e-20
C234	a_1005_120##5	a_1191_120#	1.88946e-18
C235	a_27_74##9	a_205_368##6	2.40888e-17
C236	a_205_368##9	a_1191_120##9	5.28947e-19
C237	a_27_74##11	VGND#16	1.04443e-19
C238	a_420_503#	D#4	9.94003e-18
C239	a_1005_120##6	a_1191_120##3	4.30093e-18
C240	VPWR#8	VPWR#15	8.57951e-18
C241	a_1191_120##6	a_1191_120##8	3.04805e-20
C242	VGND#12	Q#4	3.75263e-17
C243	a_27_74##16	a_27_74##12	4.25153e-18
C244	VGND#15	D#4	7.31824e-19
C245	a_205_368##5	a_1005_120##7	3.954e-17
C246	VPWR#13	a_1191_120##11	3.85451e-17
C247	a_205_368##14	D#4	1.80023e-18
C248	a_1191_120##6	a_1191_120##7	6.63225e-18
C249	a_205_368##5	a_701_463##4	4.5891e-17
C250	VPWR#8	a_205_368##3	8.07911e-19
C251	VGND#13	a_205_368##4	1.67497e-19
C252	a_205_368##9	a_650_508#	3.11904e-18
C253	a_543_447##4	a_27_74##9	1.13833e-17
C254	a_1191_120##6	a_1005_120##3	1.12463e-18
C255	a_1005_120##6	a_27_74##8	2.66521e-17
C256	a_1005_120##5	VPWR#13	2.242e-18
C257	a_701_463##5	a_1005_120##5	6.63966e-18
C258	a_205_368##9	a_1005_120#	6.64972e-20
C259	a_1005_120##2	a_1191_120##7	4.86407e-18
C260	a_1191_120##6	a_1191_120##3	3.58627e-19
C261	a_1191_120##14	Q#4	2.71972e-18
C262	a_701_463##4	a_543_447##3	4.57283e-17
C263	a_205_368##11	VPWR#8	7.85925e-17
C264	a_27_74##16	a_27_74##14	1.3394e-18
C265	a_1191_120##6	a_27_74##8	3.38294e-19
C266	a_543_447##3	VPWR#14	2.50458e-18
C267	VGND#13	a_543_447#	6.97357e-20
C268	VGND#7	a_205_368#	1.93236e-17
C269	a_701_463##2	a_543_447##4	1.47568e-17
C270	a_420_503#	a_205_368##2	1.83898e-19
C271	a_1005_120##2	a_1191_120##3	2.03552e-17
C272	VPWR#8	D#1	1.31648e-17
C273	a_205_368##4	a_1005_120##6	1.41312e-17
C274	VGND#15	a_205_368##2	1.53086e-17
C275	VGND#7	a_27_74##6	1.91306e-18
C276	a_543_447##6	a_543_447##3	1.43006e-18
C277	a_1005_120##2	a_27_74##8	3.07004e-19
C278	a_1191_120##14	VGND#12	4.07333e-17
C279	a_1005_120##5	a_27_74##9	3.18248e-18
C280	a_205_368##2	a_205_368##14	8.85219e-18
C281	a_205_368##9	a_1191_120#	3.96643e-18
C282	VPWR#3	a_1644_94#	4.06477e-18
C283	VPWR#6	D#1	1.59559e-18
C284	VGND#16	a_205_368##2	3.59057e-18
C285	a_205_368##4	a_701_463##7	7.57174e-18
C286	a_27_74##4	a_701_463##2	3.75432e-17
C287	VPWR#3	a_1191_120##4	4.18556e-18
C288	VGND#6	VGND#14	7.10233e-18
C289	a_27_74##16	a_205_368##2	4.73035e-19
C290	a_27_74##8	a_1191_120##2	1.48424e-18
C291	VPWR#16	VPWR#8	2.1985e-18
C292	a_1005_120##6	a_543_447#	8.76948e-19
C293	a_543_447##6	a_701_463#	1.49303e-19
C294	VPWR#3	a_1191_120##9	2.19815e-18
C295	a_1191_120##3	a_205_368##7	1.01735e-17
C296	a_27_74##2	a_205_368##14	3.14642e-17
C297	VGND#13	VGND#12	1.057e-18
C298	VPWR#8	a_27_74##3	2.45538e-18
C299	a_27_74##2	VGND#16	3.53674e-18
C300	a_27_74##8	a_205_368##7	1.32735e-17
C301	a_27_74##7	a_1005_120##3	1.95675e-18
C302	a_205_368##9	a_205_368##6	9.37552e-18
C303	a_543_447#	a_701_463##7	1.11956e-17
C304	VPWR#3	a_1005_120#	8.98951e-18
C305	a_205_368##3	a_27_74##4	1.6214e-17
C306	a_543_447##6	a_27_74##5	1.06924e-16
C307	a_1644_94##5	Q_N#3	6.58462e-19
C308	a_27_74##7	a_1191_120##3	1.1174e-17
C309	a_1005_120##6	a_701_463##3	4.41308e-19
C310	a_420_503##2	a_27_74##5	2.76215e-18
C311	D#1	a_27_74##4	1.91632e-18
C312	a_27_74##7	a_27_74##8	4.31984e-18
C313	a_543_447#	VGND#14	1.33166e-17
C314	VGND#13	a_1191_120##14	4.41113e-17
C315	VGND#5	a_1191_120##7	4.66923e-19
C316	a_27_74##7	a_205_368##4	3.33689e-17
C317	a_543_447##6	D#4	4.8507e-19
C318	a_205_368##11	a_27_74##5	2.55696e-19
C319	CLK#2	a_27_74##16	2.25533e-17
C320	D#1	a_205_368##3	9.91678e-18
C321	a_27_74##3	a_27_74##4	2.02846e-20
C322	a_543_447##6	a_701_463##4	1.10724e-18
C323	a_420_503##2	D#4	5.10141e-19
C324	a_205_368##9	a_27_74##9	3.95294e-17
C325	VPWR#8	CLK#1	6.86632e-19
C326	a_27_74##7	a_543_447#	3.1592e-17
C327	a_205_368##5	a_27_74##8	2.42969e-17
C328	a_27_74##3	a_205_368##3	3.34016e-19
C329	a_27_74##7	a_701_463##3	5.10191e-19
C330	VGND#4	a_1191_120##7	4.70848e-18
C331	a_1644_94##5	VGND#11	5.50087e-18
C332	a_701_463##3	VGND#14	1.08623e-17
C333	a_205_368##9	VPWR#13	2.10779e-17
C334	a_543_447##6	D#2	3.41357e-19
C335	a_543_447#	a_205_368##5	8.49762e-19
C336	a_1191_120##6	a_1191_120##4	1.88933e-19
C337	a_27_74##3	D#1	3.17321e-18
C338	D#2	a_420_503##2	4.24539e-17
C339	D#2	VPWR#15	2.76631e-18
C340	a_1191_120##6	a_1191_120##9	5.69102e-18
C341	VGND#5	a_1005_120##3	2.63384e-18
C342	a_205_368##9	a_543_447##4	3.96349e-17
C343	a_543_447##6	a_205_368##2	1.79773e-19
C344	a_205_368##11	D#2	6.77266e-17
C345	a_1191_120##6	a_1005_120#	5.61167e-18
C346	a_420_503##2	a_205_368##2	4.07418e-18
C347	CLK#1	a_27_74##3	5.01118e-17
C348	VPWR#7	a_701_463##2	3.86596e-18
C349	Q_N#3	a_1191_120##5	6.25505e-21
C350	VGND#4	a_1005_120##3	2.98106e-18
C351	VGND#3	VGND#5	6.44391e-18
C352	a_701_463#	a_543_447#	2.00705e-17
C353	a_205_368##2	a_205_368##11	1.05778e-17
C354	a_701_463##5	a_205_368##9	1.32052e-18
C355	VPWR#7	a_27_74##4	6.37125e-18
C356	VGND#3	VGND#4	6.16106e-17
C357	a_205_368##9	a_701_463##2	3.28925e-17
C358	a_1191_120##2	a_1005_120#	1.13756e-17
C359	a_1005_120##6	VGND#13	1.01866e-17
C360	a_205_368#	a_701_463#	9.58433e-18
C361	VPWR#7	a_205_368##3	1.79637e-18
C362	a_1191_120##11	VPWR#5	6.00745e-18
C363	a_205_368#	a_543_447##8	1.08693e-17
C364	a_1191_120##5	a_1644_94##7	5.34241e-19
C365	VGND#5	a_1191_120##3	1.87022e-18
C366	a_27_74##2	a_205_368##11	2.73382e-17
C367	a_27_74##6	a_701_463#	4.63589e-18
C368	a_1191_120##2	a_1191_120#	4.48722e-18
C369	a_205_368##9	a_1005_120##7	6.7958e-17
C370	a_420_503##2	a_543_447##6	7.38663e-17
C371	a_27_74##2	VPWR#16	2.10985e-17
C372	a_205_368##7	a_1005_120#	9.24584e-20
C373	a_205_368##11	VPWR#14	1.55098e-19
C374	Q#4	a_1644_94##5	3.46416e-17
C375	a_205_368#	a_27_74##5	4.336e-18
C376	a_1191_120##2	a_205_368##6	5.61502e-19
C377	a_420_503#	a_205_368#	2.26157e-18
C378	a_205_368##7	a_1191_120#	9.11863e-18
C379	a_27_74##5	a_27_74##6	1.52614e-19
C380	a_27_74##9	a_1191_120##2	7.02858e-19
C381	a_543_447##8	a_27_74##6	2.71322e-17
C382	a_205_368##7	a_205_368##6	8.07244e-18
C383	VPWR#3	VPWR#5	1.14029e-17
C384	a_205_368##9	a_27_74##4	4.10133e-19
C385	a_205_368#	D#4	1.86744e-18
C386	VGND#15	a_205_368#	5.12007e-18
C387	a_1191_120##11	VPWR#4	5.94444e-18
C388	CLK#2	a_27_74##14	2.46331e-17
C389	a_27_74##11	a_713_102#	2.79135e-19
C390	a_701_463##5	a_27_74##9	7.86775e-20
C391	a_27_74##9	a_205_368##7	3.97848e-17
C392	D#4	a_27_74##6	6.65445e-19
C393	a_205_368##9	a_701_463##4	6.75146e-17
C394	VPWR#3	VPWR#4	7.14456e-17
C395	VGND#5	a_27_74##8	1.22846e-19
C396	a_27_74##6	a_420_503#	1.32612e-17
C397	a_543_447##8	D#3	1.2229e-18
C398	a_27_74##7	a_27_74##9	5.06092e-19
C399	a_205_368##11	a_543_447##6	5.83494e-17
C400	a_205_368##5	a_205_368##6	7.61133e-20
C401	Q#1	a_1191_120##5	3.39853e-20
C402	VGND#8	a_27_74##12	5.00853e-18
C403	VGND#5	VGND#4	8.48256e-19
C404	VGND#6	a_205_368##4	2.47852e-18
C405	a_205_368##2	a_205_368#	1.95018e-19
C406	a_205_368##5	a_27_74##9	3.14433e-17
C407	a_420_503#	D#3	2.51573e-17
C408	a_205_368##11	a_420_503##2	2.60281e-17
C409	a_205_368##5	a_543_447##4	2.74825e-19
C410	a_205_368##9	VPWR#14	5.36755e-18
C411	VPWR#3	a_1644_94##2	3.46484e-18
C412	a_205_368##2	D#3	7.41031e-18
C413	a_543_447##3	a_27_74##9	5.29684e-18
C414	D#3	VGND#15	1.08697e-17
C415	a_205_368##11	a_650_508#	4.10691e-19
C416	VGND#3	a_1644_94##2	4.49731e-18
C417	VPWR#3	a_1191_120##6	4.30498e-18
C418	a_27_74#	a_205_368##2	2.65265e-17
C419	a_543_447##3	a_543_447##4	7.8584e-18
C420	Q_N	a_1191_120##5	3.98775e-19
C421	VPWR#13	a_1191_120##3	6.86697e-19
C422	a_205_368##11	VPWR#15	1.40414e-18
C423	a_420_503#	a_27_74#	2.92127e-19
C424	VGND#16	VGND#8	3.26598e-19
C425	a_543_447##3	a_701_463##2	2.80121e-17
C426	VGND#3	a_1191_120##6	6.35268e-18
C427	VPWR#3	a_1644_94##5	1.10826e-18
C428	VPWR#3	a_1005_120##2	2.37412e-18
C429	VGND#8	a_27_74##11	2.62401e-17
C430	a_27_74##2	a_27_74#	2.85281e-18
C431	VGND#6	a_543_447#	1.0014e-17
C432	VGND#3	a_1005_120##2	3.55799e-18
C433	a_27_74##2	CLK#3	2.28422e-18
C434	VGND#15	a_27_74#	2.10502e-18
C435	a_1644_94##5	a_1644_94##3	8.72758e-20
C436	a_543_447##3	a_205_368##3	1.47772e-19
C437	a_27_74##5	a_543_447##4	2.94893e-19
C438	VGND#16	D#3	3.8534e-19
C439	a_27_74##5	a_701_463##2	2.77924e-17
C440	VGND#5	a_543_447#	9.09644e-19
C441	a_27_74##11	a_205_368##3	9.46531e-20
C442	a_27_74#	a_205_368##14	1.39081e-17
C443	VGND#6	a_27_74##11	2.41563e-17
C444	VPWR#16	a_205_368##11	7.11258e-17
C445	VGND#3	a_1644_94##5	7.09619e-19
C446	a_27_74##16	D#3	3.88622e-19
C447	VGND#15	CLK#3	8.81491e-19
C448	a_205_368##3	a_27_74##5	4.19646e-17
C449	a_27_74##11	a_701_463##5	1.90921e-18
C450	a_543_447##6	a_205_368##9	2.82881e-17
C451	a_27_74#	VGND#16	2.82291e-17
C452	a_1005_120##2	a_1191_120##6	7.31708e-17
C453	VGND#6	a_701_463##3	7.22558e-18
C454	a_1644_94##5	a_1191_120##8	2.76657e-18
C455	VPWR#5	a_1191_120##3	5.16465e-19
C456	a_1005_120##7	a_27_74##8	1.48254e-18
C457	D#4	a_205_368##3	2.25098e-18
C458	Q#4	a_1191_120##5	1.02042e-19
C459	VGND#4	a_1191_120##6	4.47768e-19
C460	a_27_74##14	a_205_368##11	2.66103e-18
C461	a_1191_120##2	a_1191_120##6	2.95748e-18
C462	a_27_74##16	a_27_74#	2.02692e-18
C463	D#2	a_205_368##3	1.18037e-17
C464	VPWR#3	a_1191_120##11	1.72597e-17
C465	a_1191_120##2	a_1005_120##2	4.61343e-17
C466	CLK#3	VGND#16	2.4274e-17
C467	VGND#8	a_205_368#	1.19397e-17
C468	a_27_74##14	VPWR#16	7.33224e-17
C469	a_27_74##3	D#2	5.77992e-18
C470	a_1191_120##3	a_1143_146#	8.35249e-18
C471	a_27_74##8	a_1143_146#	8.35249e-18
C472	a_205_368##7	a_1191_120##2	8.25976e-17
C473	a_27_74##16	CLK#3	3.55302e-17
C474	a_1644_94##5	a_1191_120##7	1.47195e-19
C475	VGND#5	a_1005_120##2	1.24641e-18
C476	VPWR#5	a_27_74##8	1.0059e-19
C477	VGND#6	a_205_368#	4.22612e-18
C478	a_27_74##3	a_205_368##2	5.58287e-18
C479	a_1191_120#	a_1158_482#	1.97434e-18
C480	VPWR#7	a_27_74##5	2.97536e-19
C481	VGND#4	a_1005_120##2	1.53979e-19
C482	a_205_368##2	CLK#1	4.13005e-19
C483	a_205_368##6	a_1158_482#	3.8943e-18
C484	a_205_368##9	VPWR#6	1.27711e-16
C485	VGND#7	a_27_74##5	2.13045e-19
C486	VGND#3	a_1191_120##11	3.00441e-18
C487	a_27_74##2	a_27_74##3	6.00544e-18
C488	a_205_368##5	a_205_368##7	8.66731e-20
C489	a_701_463##5	a_701_463##4	2.68856e-18
C490	a_27_74##7	a_205_368##5	6.05725e-18
C491	VGND#5	a_1191_120##2	2.15167e-19
C492	a_701_463##2	a_650_508#	6.01881e-18
C493	a_27_74##7	a_543_447##3	4.73882e-19
C494	a_27_74##12	D	2.76046e-17
C495	a_205_368##9	VPWR#5	6.96679e-17
C496	a_1644_94##5	Q_N	1.08691e-18
C497	a_1191_120##6	VPWR#4	3.73153e-19
C498	a_27_74##4	a_650_508#	8.30752e-18
C499	a_543_447##3	a_205_368##5	3.44012e-17
C500	a_27_74##7	a_701_463#	1.54803e-17
C501	a_205_368##11	a_205_368##9	4.11207e-18
C502	a_1644_94##5	a_1644_94##2	4.81989e-19
C503	a_27_74##11	a_543_447##6	3.24224e-19
C504	Q_N#1	a_1644_94#	2.43703e-17
C505	a_701_463##3	a_713_102#	2.56827e-18
C506	a_1191_120##8	a_1644_94##3	2.79891e-17
C507	a_701_463#	a_543_447##3	7.67428e-17
C508	a_205_368#	a_713_102#	6.40586e-18
C509	VGND#8	D#3	7.47767e-19
C510	a_1191_120##14	a_1191_120##11	1.33332e-18
C511	a_1005_120##6	a_27_74##9	3.30399e-19
C512	a_27_74##12	a_420_503##2	1.42246e-18
C513	a_27_74##5	a_543_447##3	2.72126e-17
C514	VPWR#5	a_1005_120##2	8.93207e-20
C515	VPWR#11	a_1644_94#	2.11077e-17
C516	VGND#5	a_205_368##7	3.12274e-19
C517	a_27_74##5	a_701_463#	4.09905e-17
C518	a_27_74##16	CLK	1.5751e-17
C519	VPWR#4	a_1005_120##2	5.10852e-20
C520	a_1191_120##7	a_1644_94##3	3.18681e-19
C521	Q_N#1	a_1191_120##4	9.2923e-19
C522	a_1644_94##5	a_1191_120##6	9.61898e-20
C523	D#4	a_27_74##5	1.37156e-18
C524	D	a_420_503#	3.31682e-17
C525	Q_N#3	Q_N	3.61786e-18
C526	Q#4	Q#1	2.46755e-18
C527	VPWR#11	a_1191_120##4	4.78209e-17
C528	a_205_368##14	D	1.51369e-17
C529	a_420_503#	a_543_447##8	5.3085e-17
C530	a_1191_120##7	a_1191_120##8	5.00933e-18
C531	Q#1	a_1644_94#	1.81456e-18
C532	VPWR	VPWR#8	9.31927e-17
C533	VPWR	VPWR#6	1.0199e-16
C534	VPWR	VPWR#5	1.07355e-16
C535	VGND#6	a_27_74##7	8.3189e-17
C536	a_205_368##2	a_27_74##5	6.54078e-19
C537	a_205_368##9	VPWR#7	5.57229e-18
C538	a_1191_120##2	VPWR#5	6.85893e-19
C539	a_205_368##7	a_1158_482#	1.01094e-17
C540	a_1191_120##4	a_1644_94##7	1.60119e-17
C541	a_205_368##2	D#4	5.16112e-17
C542	a_543_447##6	a_205_368#	1.47535e-18
C543	VGND#5	a_27_74##7	4.66552e-17
C544	VPWR#12	a_1644_94#	1.44421e-19
C545	VPWR#11	a_1191_120##9	8.75064e-19
C546	a_205_368##2	D#2	4.11469e-17
C547	CLK	a_27_74##14	1.45833e-17
C548	VPWR	a_1191_120##11	1.33524e-19
C549	VGND#13	a_1005_120##5	1.14442e-17
C550	Q#1	a_1191_120##4	3.80749e-18
C551	a_1191_120##5	VNB	4.23091e-17
C552	Q_N	Q_N#1	3.13679e-18
C553	VPWR#11	Q_N	5.38201e-17
C554	VPWR	a_205_368##9	7.74794e-17
C555	a_420_503##2	a_205_368#	1.45677e-19
C556	D	a_420_503##2	3.01652e-17
C557	a_27_74##12	a_205_368##11	3.96738e-18
C558	VGND	VGND#8	7.84683e-17
C559	VGND	VGND#6	9.67477e-17
C560	a_27_74##2	a_205_368##2	4.6877e-17
C561	a_1644_94##7	a_1191_120##9	1.06655e-18
C562	VGND	VGND#5	1.12219e-16
C563	a_1005_120##3	a_1191_120##7	1.96534e-17
C564	a_205_368##11	D	7.67078e-18
C565	a_205_368##2	CLK#2	2.17974e-19
C566	VPWR#5	a_205_368##7	3.6966e-20
C567	CLK#2	a_27_74##2	7.62654e-17
C568	VGND#6	a_205_368##5	5.93925e-20
C569	Q#1	a_1191_120##9	6.81866e-17
C570	VGND	a_1191_120##11	2.45412e-19
C571	VGND	a_1005_120##5	6.50505e-18
C572	a_1005_120##5	a_1191_120##6	1.6018e-19
C573	D	a_205_368#	6.08668e-19
C574	a_1191_120##9	VPWR#12	2.7028e-17
C575	VGND	a_27_74##12	2.5083e-17
C576	VPWR	a_543_447##8	2.97442e-18
C577	VGND	a_27_74##11	4.96783e-17
C578	D	a_27_74#	1.63408e-19
C579	VGND	a_701_463##5	7.36901e-18
C580	Q#1	a_1005_120#	1.62252e-18
C581	a_1191_120##3	a_1005_120##3	3.10629e-18
C582	VGND#8	VNB	3.41511e-17
C583	VGND#6	VNB	4.88106e-17
C584	a_205_368##14	a_420_503#	1.24829e-18
C585	VGND#5	VNB	5.71069e-17
C586	VGND#4	VNB	3.1535e-17
C587	VPWR#8	VNB	4.78452e-17
C588	VPWR#6	VNB	5.00062e-17
C589	VPWR#5	VNB	5.722e-17
C590	VPWR#4	VNB	2.94274e-17
C591	a_1005_120##2	a_1191_120##11	4.84295e-17
C592	VGND	a_1191_120##14	3.49911e-18
C593	a_1005_120#	VPWR#12	3.24298e-17
C594	a_1644_94##5	VNB	1.9468e-18
C595	VPWR	a_1005_120##7	7.32983e-18
C596	VGND#6	a_543_447##3	4.48979e-19
C597	VPWR	a_701_463##4	7.07842e-18
C598	VGND	a_1005_120##6	7.90939e-18
C599	Q_N	a_1644_94#	2.33899e-17
C600	a_1191_120##11	VNB	1.19039e-17
C601	VPWR	a_543_447##6	8.7923e-18
C602	Q_N	a_1191_120##4	1.09374e-18
C603	VGND#7	a_27_74##11	6.35636e-17
C604	a_1005_120##5	VNB	9.43624e-18
C605	VPWR#13	a_1191_120##9	5.14984e-19
C606	a_1005_120##5	a_1005_120##2	1.94981e-18
C607	VGND	a_543_447##8	8.10792e-18
C608	VPWR	a_420_503##2	6.64643e-18
C609	Q_N	a_1191_120##9	2.08195e-19
C610	a_1005_120##5	a_1191_120##3	1.63811e-17
C611	VGND	a_420_503#	8.98365e-18
C612	VGND	VGND#15	1.80543e-17
C613	VPWR#3	a_1191_120##5	2.56818e-18
C614	VPWR	a_205_368##11	6.17195e-17
C615	a_27_74##12	a_27_74##14	5.35262e-19
C616	a_205_368##9	VNB	1.8649e-17
C617	VGND	a_205_368##14	5.12467e-18
C618	D	a_205_368##3	1.33805e-19
C619	VGND	VGND#16	2.42125e-17
C620	VGND	a_27_74##16	1.75099e-17
C621	VPWR	a_27_74##14	1.64955e-17
C622	a_27_74##11	VNB	1.92774e-17
C623	a_1005_120#	a_1191_120##10	2.21685e-17
C624	D	a_27_74##3	7.49867e-20
C625	a_701_463##5	VNB	5.30222e-20
C626	VPWR	a_1191_120##3	6.87009e-19
C627	a_27_74##8	a_1191_120##3	3.67843e-17
C628	Q_N#3	VNB	5.25104e-17
C629	VPWR#12	a_1191_120#	5.09625e-19
C630	VGND	a_701_463##4	6.78137e-19
C631	VGND#11	VNB	8.27079e-18
C632	Q#4	VNB	1.50651e-17
C633	VPWR	a_205_368#	2.83514e-19
C634	VGND#12	VNB	4.24523e-18
C635	VGND	a_543_447##6	2.53766e-18
C636	a_1191_120##14	VNB	8.81156e-18
C637	VGND#13	VNB	9.18896e-18
C638	VPWR#6	a_205_368##5	7.15908e-20
C639	VPWR#13	a_1005_120#	2.85562e-18
C640	a_1005_120##6	VNB	9.16795e-20
C641	VGND	a_205_368##11	3.14895e-18
C642	VGND	a_27_74##14	4.90429e-18
C643	VPWR#3	Q_N	2.0781e-17
C644	a_543_447##8	VNB	4.48474e-18
C645	a_420_503#	VNB	5.30235e-18
C646	VGND#3	Q_N	1.63423e-18
C647	VGND#15	VNB	2.29967e-18
C648	a_205_368##14	VNB	5.84592e-18
C649	VGND#16	VNB	4.5749e-18
C650	a_27_74##16	VNB	3.50339e-17
C651	VGND	a_1191_120##3	3.56386e-18
C652	Q_N#1	VNB	1.97803e-17
C653	VGND#16	VGND#15	4.47347e-18
C654	VPWR#11	VNB	2.31359e-18
C655	VGND	a_27_74##8	1.2033e-20
C656	a_1644_94##7	VNB	5.4663e-18
C657	VPWR	a_1191_120#	4.93e-18
C658	a_1644_94##2	Q_N	3.19504e-17
C659	Q#1	VNB	1.99017e-17
C660	VGND	a_543_447#	5.09991e-18
C661	VPWR#12	VNB	2.57865e-18
C662	a_1005_120##5	a_1191_120##2	3.31121e-18
C663	VGND	a_701_463##3	8.40855e-18
C664	Q_N	a_1191_120##6	2.51453e-20
C665	VGND#6	a_701_463#	9.78376e-19
C666	VPWR	a_27_74##9	5.00895e-18
C667	a_1005_120##5	a_27_74##8	2.29765e-17
C668	VPWR#13	VNB	7.04683e-18
C669	VGND	a_205_368#	1.64522e-17
C670	VPWR	a_543_447##4	1.12665e-18
C671	a_1005_120##7	VNB	2.57356e-18
C672	a_701_463##4	VNB	4.34779e-18
C673	VGND	D#3	3.85426e-19
C674	VPWR	a_701_463##2	7.59056e-19
C675	VGND	a_27_74#	3.72927e-18
C676	VPWR	a_27_74##4	2.27246e-18
C677	VGND	CLK#3	1.21537e-18
C678	a_543_447##6	VNB	7.0162e-18
C679	VPWR	a_205_368##3	1.66857e-21
C680	a_420_503##2	VNB	3.09466e-18
C681	VPWR	D#1	7.59807e-18
C682	a_420_503#	a_205_368##3	2.51856e-18
C683	D	a_27_74##5	1.76357e-19
C684	a_205_368##11	VNB	2.17318e-17
C685	VPWR	a_27_74##3	3.2959e-18
C686	VPWR#16	VNB	2.63324e-18
C687	VPWR#13	a_1191_120#	4.76241e-17
C688	a_27_74##14	VNB	5.99873e-17
C689	D	D#4	1.81083e-17
C690	VPWR	CLK#1	2.2814e-18
C691	a_1644_94##3	VNB	3.40758e-17
C692	a_1191_120##8	VNB	4.35128e-17
C693	a_1191_120##7	VNB	3.6136e-17
C694	CLK	CLK#2	1.10486e-17
C695	a_1005_120##3	VNB	3.33463e-17
C696	a_1191_120##3	VNB	4.06763e-17
C697	D	a_205_368##2	5.59688e-17
C698	a_27_74##8	VNB	3.72781e-17
C699	a_205_368##4	VNB	2.68144e-17
C700	VPWR	VPWR#7	6.22238e-17
C701	a_543_447#	VNB	3.74832e-17
C702	D	a_27_74##2	4.11242e-19
C703	a_205_368##4	a_27_74##8	1.3948e-17
C704	a_701_463##3	VNB	2.61598e-17
C705	a_205_368#	VNB	1.25772e-16
C706	VGND	a_205_368##3	6.24021e-19
C707	a_27_74##6	VNB	3.17581e-17
C708	VGND#3	Q_N#3	2.07885e-17
C709	D#3	VNB	2.94034e-17
C710	a_27_74#	VNB	2.96159e-17
C711	CLK#3	VNB	3.6411e-17
C712	VPWR	a_1191_120##2	3.99486e-18
C713	a_1644_94#	VNB	3.90907e-17
C714	a_1191_120##4	VNB	3.04101e-17
C715	VPWR	a_205_368##7	1.6942e-18
C716	a_1191_120##9	VNB	4.08372e-17
C717	VGND#3	a_1191_120##5	3.11396e-18
C718	VPWR#6	a_543_447##3	7.736e-19
C719	a_1005_120#	VNB	4.45134e-17
C720	a_205_368##7	a_1191_120##11	2.3409e-18
C721	a_1191_120#	VNB	5.60495e-17
C722	VPWR	a_205_368##5	1.95436e-18
C723	a_205_368##6	VNB	3.6898e-17
C724	VGND	VGND#7	5.52658e-17
C725	VPWR#12	a_27_74##9	7.08414e-20
C726	a_27_74##9	VNB	6.18957e-17
C727	VPWR	a_543_447##3	7.41596e-18
C728	a_543_447##4	VNB	3.28222e-17
C729	a_701_463##2	VNB	5.99478e-17
C730	a_27_74##4	VNB	3.19909e-17
C731	VGND	a_1005_120##2	3.6135e-18
C732	VPWR	a_27_74##5	5.6866e-18
C733	a_205_368##3	VNB	6.18957e-17
C734	VGND	a_1191_120##2	3.12713e-18
C735	D#1	VNB	3.25526e-17
C736	VPWR#13	a_205_368##6	1.10333e-18
C737	a_27_74##3	VNB	4.32788e-17
C738	VGND	a_205_368##7	4.40819e-18
C739	VPWR	D#2	5.60511e-18
C740	CLK#1	VNB	4.02713e-17
C741	VGND	a_27_74##7	5.57574e-17
C742	VPWR	a_205_368##2	4.06407e-18
C743	a_1005_120##5	a_205_368##7	4.77101e-17
C744	VGND	a_205_368##5	5.65596e-18
C745	VPWR#3	VNB	1.8695e-16
C746	a_1005_120##5	a_205_368##4	1.57552e-19
C747	VGND#3	VNB	1.79873e-16
C748	VGND	a_543_447##3	3.79225e-18
C749	VPWR	a_27_74##2	4.09535e-18
C750	VPWR#7	VNB	3.17477e-17
C751	VGND	a_701_463#	5.91398e-18
C752	VPWR	CLK#2	1.42921e-18
C753	VGND#7	VNB	2.54643e-17
C754	a_1005_120##7	a_1191_120#	2.6081e-18
C755	VGND	a_27_74##5	3.37927e-18
C756	a_1644_94##2	VNB	4.87158e-17
C757	a_1191_120##6	VNB	5.60191e-17
C758	VGND	D#4	2.55635e-18
C759	a_1005_120##2	VNB	5.72882e-17
C760	a_1191_120##2	VNB	5.41495e-17
C761	VGND#3	a_1644_94##6	1.67659e-17
C762	VGND	a_205_368##2	4.04116e-18
C763	a_205_368##7	VNB	5.2934e-17
C764	a_27_74##7	VNB	4.36002e-17
C765	VGND	a_27_74##2	1.45603e-19
C766	a_205_368##5	VNB	4.23196e-17
C767	VGND	CLK#2	1.42527e-18
C768	a_543_447##3	VNB	5.9954e-17
C769	a_701_463#	VNB	6.07912e-17
C770	a_27_74##5	VNB	7.4482e-17
C771	D#4	VNB	2.97676e-17
C772	D#2	VNB	2.49767e-17
C773	a_205_368##2	VNB	1.50737e-16
C774	a_27_74##2	VNB	4.29361e-17
C775	CLK#2	VNB	5.34435e-17
C776	VGND#3	Q#4	3.85747e-17
C777	a_543_447#	a_205_368##4	2.54425e-17
C778	VPWR#13	a_27_74##9	1.15518e-19
C779	VPWR	CLK	1.27341e-18
C780	VPWR	D	1.90474e-18
C781	VGND	CLK	1.46421e-18
C782	VGND	D	5.81573e-18
C783	a_205_368##6	a_1005_120##7	1.53232e-17
C784	CLK	VNB	1.92537e-17
C785	D	VNB	2.64577e-18
C786	Q_N	VNB	4.86928e-17
C787	VGND#3	VGND#12	1.82455e-17
C788	VPWR#6	a_701_463#	2.81291e-19
C789	VPWR	VNB	3.014e-16
C790	VGND	VNB	2.97706e-16
C791	a_1644_94##2	VPWR#2	2.64219e-19
C792	a_1644_94##5	VPWR#2	1.67516e-19
C793	a_205_368##11	VPWR#9	8.86619e-18
C794	VGND#9	a_27_74##16	2.12346e-17
C795	VPWR#9	VNB	4.50914e-17
C796	VGND#2	a_1191_120##8	3.02217e-18
C797	VPWR#4	VPWR#2	5.87943e-19
C798	a_1644_94##7	VPWR#2	5.50627e-19
C799	VGND#9	a_27_74#	5.73496e-18
C800	a_27_74##2	VPWR#9	2.91804e-19
C801	VGND#2	a_1644_94##6	9.25247e-19
C802	VPWR#2	a_1191_120##4	1.09851e-18
C803	VGND#9	a_27_74##12	4.61709e-18
C804	VGND#2	VNB	4.58107e-17
C805	VGND#9	CLK#3	2.96605e-18
C806	VPWR#2	Q_N	2.44172e-17
C807	VGND#2	a_1191_120##7	4.25077e-19
C808	VGND#2	a_1644_94##5	1.94461e-19
C809	VGND	VGND#9	8.78619e-17
C810	VGND#4	VGND#2	3.59688e-19
C811	VGND#9	a_27_74##14	3.8839e-19
C812	VPWR#9	CLK#2	1.4576e-19
C813	VPWR#9	VPWR#8	7.76529e-19
C814	VPWR#3	VPWR#2	9.56665e-17
C815	VPWR#9	a_27_74##3	6.74417e-18
C816	Q#1	VPWR#2	8.48389e-19
C817	VPWR	VPWR#9	9.26404e-17
C818	VGND#9	VNB	5.29928e-17
C819	VGND#2	a_1005_120##3	5.97509e-20
C820	VGND#2	a_1644_94##2	4.85132e-19
C821	a_27_74##14	VPWR#9	1.78179e-17
C822	VPWR#2	a_1191_120##9	1.37281e-18
C823	VGND#12	VGND#2	1.46352e-19
C824	VGND#2	Q_N#3	2.30726e-17
C825	VPWR#9	CLK#1	4.67365e-18
C826	VPWR#2	VNB	4.84188e-17
C827	VPWR#2	a_1644_94#	1.16472e-17
C828	VGND#2	a_1644_94##3	7.9655e-18
C829	VPWR#12	VPWR#2	5.08961e-19
C830	VGND#3	VGND#2	9.20993e-17
C831	VGND#9	CLK#2	2.53477e-19
*
*
.ENDS sky130_fd_sc_hs__dfxbp_1
*
