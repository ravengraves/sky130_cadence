* Extracted by Quantus, converted by sky130cad/quantus.py
*
*
*
*                       LINUX           Wed Nov 18 08:39:52 2026
*
*
*
*  PROGRAM  advgen
*
*  Name           : advgen - Quantus - (64-bit)
*  Version        : 25.1.0-p047
*  Build Date     : Thu Dec 11 23:20:30 PST 2025
*
*  HSPICE LIBRARY
*
*  OPERATING_TEMPERATURE 150
*  QRC_TECH_DIR <path>/tech
*
*
*

*
.SUBCKT sky130_fd_sc_hs__fahcon_1 VPB VNB VGND VPWR COUT_N SUM B CI A
*
*
*  caps2d version: 10
*
*
*       TRANSISTOR CARDS
*
*
XM12 a_27_100##6 A#3 VGND#12 VNB sky130_fd_pr__nfet_01v8_lvt l=0.15 w=0.74 ad=0.2109 as=0.4923 pd=2.05 ps=2.92
XM28 VGND#12 a_27_100# a_241_368##6 VNB sky130_fd_pr__nfet_01v8_lvt l=0.15 w=0.64 ad=0.4923 as=0.1792 pd=2.92 ps=1.84
XM5 a_241_368##6 a_336_263##4 a_374_120##9 VNB sky130_fd_pr__nfet_01v8_lvt l=0.15 w=0.64 ad=0.1792 as=0.30045 pd=1.84 ps=2.29
XM30 a_374_120##9 B#11 a_27_100##8 VNB sky130_fd_pr__nfet_01v8_lvt l=0.15 w=0.64 ad=0.30045 as=0.1856 pd=2.29 ps=1.86
XM11 a_27_100##8 a_336_263##2 a_369_365##10 VNB sky130_fd_pr__nfet_01v8_lvt l=0.15 w=0.64 ad=0.1856 as=0.2912 pd=1.86 ps=2.19
XM3 a_369_365##10 B#10 a_241_368# VNB sky130_fd_pr__nfet_01v8_lvt l=0.15 w=0.64 ad=0.2912 as=0.1824 pd=2.19 ps=1.85
XM15 a_336_263##10 B#6 VGND#11 VNB sky130_fd_pr__nfet_01v8_lvt l=0.15 w=0.74 ad=0.4662 as=0.233 pd=2.74 ps=2.13
XM8 VGND#11 B#1 a_1023_389# VNB sky130_fd_pr__nfet_01v8_lvt l=0.15 w=0.64 ad=0.233 as=0.4992 pd=2.13 ps=2.84
XM29 a_1023_389# a_369_365##3 COUT_N#1 VNB sky130_fd_pr__nfet_01v8_lvt l=0.15 w=0.64 ad=0.4992 as=0.3584 pd=2.84 ps=2.4
XM31 COUT_N#1 a_374_120##3 a_1261_421##2 VNB sky130_fd_pr__nfet_01v8_lvt l=0.15 w=0.64 ad=0.3584 as=0.352 pd=2.4 ps=2.38
XM9 a_1261_421##2 CI#7 VGND#10 VNB sky130_fd_pr__nfet_01v8_lvt l=0.15 w=0.64 ad=0.352 as=0.2554 pd=2.38 ps=2.2
XM22 VGND#10 CI#1 a_1606_368##9 VNB sky130_fd_pr__nfet_01v8_lvt l=0.15 w=0.74 ad=0.2554 as=0.2589 pd=2.2 ps=2.2
XM19 a_1606_368##9 a_369_365##7 a_1744_94##5 VNB sky130_fd_pr__nfet_01v8_lvt l=0.15 w=0.64 ad=0.2589 as=0.4224 pd=2.2 ps=2.6
XM13 a_1744_94##5 a_374_120##7 a_1719_368# VNB sky130_fd_pr__nfet_01v8_lvt l=0.15 w=0.64 ad=0.4224 as=0.3264 pd=2.6 ps=2.3
XM27 a_1719_368# a_1606_368##3 VGND#9 VNB sky130_fd_pr__nfet_01v8_lvt l=0.15 w=0.64 ad=0.3264 as=0.5983 pd=2.3 ps=3.38
XM23 VGND#9 a_1744_94# SUM#3 VNB sky130_fd_pr__nfet_01v8_lvt l=0.15 w=0.74 ad=0.5983 as=0.2109 pd=3.38 ps=2.05
XM1 a_27_100##4 A#1 VPWR#12 VPB sky130_fd_pr__pfet_01v8 l=0.15 w=1.12 ad=0.3304 as=0.4764 pd=2.83 ps=3.11
XM24 VPWR#12 a_27_100##3 a_241_368##4 VPB sky130_fd_pr__pfet_01v8 l=0.15 w=1 ad=0.4764 as=0.45985 pd=3.11 ps=3.01
XM14 a_241_368##4 a_336_263##5 a_369_365##9 VPB sky130_fd_pr__pfet_01v8 l=0.15 w=0.84 ad=0.45985 as=0.3528 pd=3.01 ps=2.52
XM0 a_369_365##9 B#5 a_27_100##10 VPB sky130_fd_pr__pfet_01v8 l=0.15 w=0.84 ad=0.3528 as=0.252 pd=2.52 ps=2.28
XM20 a_27_100##10 a_336_263# a_374_120##8 VPB sky130_fd_pr__pfet_01v8 l=0.15 w=0.84 ad=0.252 as=0.4228 pd=2.28 ps=2.86
XM25 a_374_120##8 B#9 a_241_368##2 VPB sky130_fd_pr__pfet_01v8 l=0.15 w=0.84 ad=0.4228 as=0.2436 pd=2.86 ps=2.26
XM16 a_336_263##7 B#8 VPWR#11 VPB sky130_fd_pr__pfet_01v8 l=0.15 w=1.12 ad=0.3304 as=0.4964 pd=2.83 ps=3.15
XM10 VPWR#11 B#7 a_1023_389##2 VPB sky130_fd_pr__pfet_01v8 l=0.15 w=1 ad=0.4964 as=0.3706 pd=3.15 ps=2.77
XM2 a_1023_389##2 a_374_120# COUT_N#3 VPB sky130_fd_pr__pfet_01v8 l=0.15 w=0.84 ad=0.3706 as=0.4242 pd=2.77 ps=2.69
XM4 COUT_N#3 a_369_365##4 a_1261_421# VPB sky130_fd_pr__pfet_01v8 l=0.15 w=0.84 ad=0.4242 as=0.9412 pd=2.69 ps=4.14
XM17 a_1261_421# CI#5 VPWR#10 VPB sky130_fd_pr__pfet_01v8 l=0.15 w=1 ad=0.9412 as=0.3868 pd=4.14 ps=2.95
XM7 VPWR#10 CI#6 a_1606_368##7 VPB sky130_fd_pr__pfet_01v8 l=0.15 w=1.12 ad=0.3868 as=0.3304 pd=2.95 ps=2.83
XM6 a_1719_368##4 a_369_365##5 a_1744_94##7 VPB sky130_fd_pr__pfet_01v8 l=0.15 w=0.84 ad=0.4033 as=0.252 pd=3.02 ps=2.28
XM21 a_1744_94##7 a_374_120##5 a_1606_368##5 VPB sky130_fd_pr__pfet_01v8 l=0.15 w=0.84 ad=0.252 as=0.2478 pd=2.28 ps=2.27
XM26 a_1719_368##2 a_1606_368# VPWR#9 VPB sky130_fd_pr__pfet_01v8 l=0.15 w=1 ad=0.295 as=0.3868 pd=2.59 ps=2.95
XM18 VPWR#9 a_1744_94##3 SUM#1 VPB sky130_fd_pr__pfet_01v8 l=0.15 w=1.12 ad=0.3868 as=0.3304 pd=2.95 ps=2.83
*
*
*       RESISTOR AND CAP/DIODE CARDS
*
Rg1	A#1	A#2	442.817719
Rg2	A#2	A#3	320.356293
Rg3	a_27_100#	a_27_100##2	317.046326
Rg4	a_27_100##2	a_27_100##3	396.905884
Rg5	a_336_263#	a_336_263##2	670.042297
Rg6	a_336_263##2	a_336_263##3	274.549927
Rg7	a_336_263##3	a_336_263##4	962.752014
Rg8	a_336_263##4	a_336_263##5	700.896606
Rg9	a_336_263##3	a_336_263##6	24.851269
Rg10	B#1	B#2	419.904022
Rg11	B#2	B#3	177.186752
Rg12	B#3	B#4	1361.292725
Rg13	B#4	B#5	966.456299
Rg14	B#2	B#6	297.986908
Rg15	B#2	B#7	493.354645
Rg16	B#3	B#8	456.494629
Rg17	B#4	B#9	315.962036
Rg18	B#9	B#10	701.754150
Rg19	B#5	B#11	679.400024
Rg20	a_374_120#	a_374_120##2	433.032990
Rg21	a_369_365#	a_369_365##2	24.707481
Rg22	a_369_365##2	a_369_365##3	541.021240
Rg23	a_369_365##2	a_369_365##4	398.184448
Rg24	a_374_120##3	a_374_120##4	318.451508
Rg25	CI#1	CI#2	372.509399
Rg26	CI#2	CI#3	19.064896
Rg27	CI#3	CI#4	41.705215
Rg28	CI#4	CI#5	610.246094
Rg29	CI#2	CI#6	487.937256
Rg30	CI#4	CI#7	321.576782
Rg31	a_369_365##5	a_369_365##6	501.795197
Rg32	a_369_365##6	a_369_365##7	331.927338
Rg33	a_374_120##5	a_374_120##6	390.592865
Rg34	a_374_120##6	a_374_120##7	298.519653
Rg35	a_1606_368#	a_1606_368##2	606.241577
Rg36	a_1606_368##2	a_1606_368##3	308.972870
Rg37	a_1744_94#	a_1744_94##2	366.265259
Rg38	a_1744_94##2	a_1744_94##3	465.025360
Rf1	A#2	A#5	162.813492
Rf2	A#6	A	2.580688
Rf3	A#5	A#6	5.500849
Rf4	a_27_100##4	a_27_100##5	89.423225
Rf5	a_27_100##5	a_27_100##6	19.627558
Rf6	a_27_100##5	a_27_100##7	40.427048
Rf7	a_27_100##7	a_27_100##9	189.045715
Rf8	a_27_100##9	a_27_100##10	53.370243
Rf9	a_27_100##7	a_27_100##2	192.275665
Rf10	a_27_100##8	a_27_100##9	7.500000
Rf11	a_374_120##8	a_374_120##10	228.424011
Rf12	a_374_120##10	a_374_120##11	0.837493
Rf13	a_374_120##9	a_374_120##10	7.500000
Rf14	a_369_365##8	a_369_365##9	102.704178
Rf15	a_369_365##8	a_369_365##10	34.466579
Rf16	a_241_368#	a_241_368##3	54.399612
Rf17	a_241_368##3	a_241_368##5	205.379272
Rf18	a_241_368##5	a_241_368##6	79.490822
Rf19	a_241_368##2	a_241_368##3	7.500000
Rf20	a_241_368##4	a_241_368##5	5.000000
Rf21	a_336_263##7	a_336_263##8	94.987740
Rf22	a_336_263##8	a_336_263##6	248.332520
Rf23	a_336_263##8	a_336_263##10	13.809429
Rf24	B	B#12	0.972658
Rf25	B#13	B#2	161.205460
Rf26	B#12	B#13	12.001423
Rf27	a_374_120##12	a_374_120##2	228.196854
Rf28	a_1023_389#	a_1023_389##2	148.870148
Rf29	a_369_365##11	a_369_365##12	10.466710
Rf30	a_369_365#	a_369_365##14	160.921738
Rf31	a_369_365##11	a_369_365##14	2.422064
Rf32	COUT_N	COUT_N#2	5.314581
Rf33	COUT_N#2	COUT_N#3	124.410904
Rf34	COUT_N#1	COUT_N#2	7.500000
Rf35	a_374_120##14	a_374_120##4	113.973618
Rf36	a_1261_421#	a_1261_421##2	119.474052
Rf37	CI#8	CI	1.411932
Rf38	CI#3	CI#10	161.644730
Rf39	CI#8	CI#10	3.543054
Rf40	a_369_365##15	a_369_365##6	178.629395
Rf41	a_374_120##6	a_374_120##17	200.909088
Rf42	a_1606_368##2	a_1606_368##6	204.641296
Rf43	a_1606_368##6	a_1606_368##8	94.294609
Rf44	a_1606_368##8	a_1606_368##9	101.964325
Rf45	a_1606_368##5	a_1606_368##6	7.500000
Rf46	a_1606_368##7	a_1606_368##8	5.000000
Rf47	a_1719_368#	a_1719_368##3	150.646591
Rf48	a_1719_368##3	a_1719_368##4	143.738831
Rf49	a_1719_368##2	a_1719_368##3	5.000000
Rf50	a_1744_94##2	a_1744_94##6	379.490265
Rf51	a_1744_94##6	a_1744_94##7	96.813347
Rf52	a_1744_94##5	a_1744_94##6	7.500000
Rf53	SUM	SUM#2	0.181173
Rf54	SUM#2	SUM	13.225628
Rf55	SUM	SUM#3	88.968201
Rf56	SUM#1	SUM#2	5.000000
Rf58	VPWR#2	VPWR#3	120.931381
Rf59	VPWR#3	VPWR#4	101.638229
Rf60	VPWR#4	VPWR#5	220.686005
Rf61	VPWR#5	VPWR#6	98.593636
Rf62	VPWR#6	VPWR#7	185.523712
Rf64	VPWR#2	VPWR#9	43.597031
Rf65	VPWR#4	VPWR#10	63.427055
Rf66	VPWR#5	VPWR#11	38.876549
Rf67	VPWR#7	VPWR#12	35.727165
Rf69	VGND#2	VGND#3	114.998817
Rf70	VGND#3	VGND#4	91.345932
Rf71	VGND#4	VGND#5	207.529037
Rf72	VGND#5	VGND#6	122.027145
Rf73	VGND#6	VGND#7	199.525894
Rf75	VGND#2	VGND#9	22.879200
Rf76	VGND#4	VGND#10	37.457504
Rf77	VGND#5	VGND#11	44.190063
Rf78	VGND#7	VGND#12	50.916069
Re1	a_369_365##15	a_369_365##12	13.698293
Re2	a_369_365##12	a_369_365##8	15.344948
Re3	a_374_120##17	a_374_120##14	13.698293
Re4	a_374_120##14	a_374_120##12	1.450526
Re5	a_374_120##12	a_374_120##11	16.168276
Re6	VPWR#3	VPWR	2.268450
Re7	VPWR	VPWR#6	1.620321
Re8	VGND#3	VGND	2.268450
Re9	VGND	VGND#6	1.620321
*
*       CAPACITOR CARDS
*
*
C1	VPWR#6	A#5	3.08099e-18
C2	A#3	a_336_263##4	6.71861e-19
C3	a_1261_421#	VPWR#10	9.81266e-17
C4	a_369_365##15	a_1606_368##5	1.84586e-18
C5	a_241_368##6	a_241_368##4	7.59959e-19
C6	VGND#6	a_27_100##5	1.6116e-17
C7	a_241_368##2	a_336_263##5	4.33107e-19
C8	a_1606_368##9	CI#7	1.55495e-18
C9	a_27_100##10	B#5	2.78154e-17
C10	a_374_120##12	VGND#11	2.20347e-17
C11	VPWR#5	B#7	7.77988e-18
C12	a_241_368##4	a_336_263#	3.96767e-19
C13	a_374_120##17	a_1606_368##7	2.1762e-19
C14	a_369_365##15	a_1744_94##7	7.90238e-18
C15	a_1261_421##2	CI#1	1.54196e-18
C16	a_1719_368##2	VPWR#3	4.39855e-17
C17	a_374_120##8	a_336_263##5	1.36054e-17
C18	A#3	a_27_100#	7.38748e-18
C19	CI#10	CI#3	8.89437e-18
C20	a_1606_368##7	CI#4	2.73854e-19
C21	a_27_100##7	a_241_368##6	8.57684e-17
C22	a_369_365##9	B#5	2.4923e-17
C23	a_1261_421##2	VGND#10	5.56146e-17
C24	a_369_365##8	B#4	1.55899e-18
C25	CI#7	VGND#10	1.92882e-17
C26	a_374_120##2	VPWR#5	1.22503e-18
C27	CI#8	CI#3	5.57085e-18
C28	VGND#5	B#2	5.12051e-19
C29	a_369_365##15	a_1719_368##4	1.25635e-18
C30	VPWR#3	a_1606_368##5	1.83139e-17
C31	a_27_100##10	a_336_263##5	1.45278e-18
C32	VGND#6	A#5	1.79089e-18
C33	a_241_368##4	B#5	2.03379e-17
C34	a_369_365##8	B#3	5.73186e-18
C35	a_1606_368##9	a_374_120##3	1.10953e-19
C36	a_369_365##15	a_1606_368##7	4.62153e-17
C37	VPWR#3	a_1744_94##7	1.91778e-18
C38	a_374_120##8	a_27_100##3	8.14906e-19
C39	a_336_263##5	a_369_365##9	2.51608e-17
C40	a_1261_421##2	CI#7	4.57932e-17
C41	a_1261_421##2	CI#4	1.16975e-17
C42	VGND#5	a_336_263##8	5.29358e-17
C43	VPWR#12	B#5	4.33078e-19
C44	a_369_365##15	VPWR#10	7.40253e-18
C45	COUT_N#3	a_1261_421#	7.88214e-17
C46	VPWR#5	B#8	5.64364e-18
C47	a_1719_368##4	VPWR#3	1.04198e-16
C48	a_27_100##7	VGND#12	7.36419e-17
C49	VGND#10	a_374_120##3	8.84387e-19
C50	CI#10	a_374_120##4	4.94597e-20
C51	a_336_263##5	a_241_368##4	4.42484e-17
C52	a_27_100##7	B#11	2.65107e-19
C53	a_369_365##8	a_241_368#	1.11669e-17
C54	CI#8	a_374_120##4	4.17849e-19
C55	a_1606_368##7	VPWR#3	2.58713e-17
C56	a_369_365##14	a_1261_421#	2.39278e-17
C57	B#2	VPWR#5	6.20058e-19
C58	VGND#5	a_336_263##6	3.25206e-19
C59	VGND#3	a_1719_368##2	2.07187e-18
C60	a_1744_94##2	SUM#3	7.37831e-17
C61	a_374_120##3	a_1261_421##2	1.60021e-17
C62	a_27_100##8	a_369_365##8	4.33202e-18
C63	a_241_368##4	a_27_100##3	6.12327e-17
C64	VPWR#10	CI#4	3.06014e-18
C65	a_27_100##5	VGND#12	4.08824e-17
C66	VGND#3	a_1606_368##5	3.09666e-18
C67	a_1744_94##2	VGND#9	7.13264e-18
C68	VGND#10	a_369_365##3	3.62665e-19
C69	a_374_120##11	a_241_368#	3.88911e-17
C70	VPWR#3	a_1261_421#	3.57845e-17
C71	a_369_365##8	a_374_120##9	1.67426e-18
C72	a_374_120##14	a_1606_368##7	2.90623e-18
C73	a_27_100##7	a_336_263##4	1.30166e-17
C74	a_1719_368#	a_1744_94##2	1.04328e-16
C75	a_27_100##3	VPWR#12	2.83538e-17
C76	a_369_365##14	a_374_120##4	8.80566e-18
C77	a_374_120##11	B#3	3.94703e-18
C78	a_374_120##3	COUT_N#1	5.12154e-18
C79	a_374_120##11	a_369_365##10	3.82713e-17
C80	a_369_365##8	a_241_368##6	2.7026e-19
C81	a_1023_389##2	COUT_N#3	4.67166e-17
C82	a_374_120##14	VPWR#10	3.58789e-18
C83	VPWR#11	a_1261_421#	1.127e-18
C84	a_1744_94##5	a_1744_94##2	1.59149e-18
C85	COUT_N#3	a_369_365##14	2.04726e-17
C86	a_241_368##4	A#1	4.10816e-18
C87	a_369_365##11	a_374_120##4	1.06144e-17
C88	a_27_100##4	a_27_100##3	2.01795e-19
C89	a_1261_421##2	a_369_365##3	1.57755e-18
C90	a_374_120##11	a_27_100##8	4.50416e-17
C91	a_374_120##14	a_1261_421#	3.55904e-18
C92	a_374_120#	a_369_365##2	7.49031e-19
C93	a_27_100##5	a_27_100##6	8.22258e-18
C94	a_1606_368##2	VGND#9	5.53262e-19
C95	VGND#3	a_1606_368##7	8.01373e-19
C96	A#1	VPWR#12	4.36939e-17
C97	a_1023_389#	a_374_120##3	6.83815e-19
C98	VGND#6	a_1023_389#	2.39361e-17
C99	a_374_120##11	a_374_120##9	4.29443e-17
C100	a_1606_368#	a_1744_94##3	4.25324e-17
C101	a_1606_368##2	a_1719_368#	6.33663e-17
C102	a_27_100##7	a_27_100#	1.72135e-17
C103	VGND#3	VPWR#10	4.21754e-19
C104	a_369_365##3	COUT_N#1	9.68694e-18
C105	a_374_120##11	a_241_368##6	5.39885e-18
C106	a_27_100##4	A#1	5.06705e-17
C107	VGND#11	a_374_120##3	9.50919e-20
C108	a_1261_421#	CI#4	4.79978e-18
C109	a_27_100##5	a_27_100#	9.98907e-19
C110	VGND#6	a_241_368#	8.66077e-18
C111	VPWR#6	a_374_120##9	1.46734e-18
C112	a_1023_389#	a_369_365##3	3.16509e-17
C113	VGND#4	CI#1	7.5329e-18
C114	VPWR#6	B#4	3.52666e-17
C115	VPWR#11	a_1023_389##2	7.83397e-17
C116	a_369_365##12	VPWR#10	6.54034e-18
C117	a_374_120##5	a_1606_368#	6.08054e-18
C118	VGND#6	a_369_365##10	5.51235e-18
C119	VPWR#6	a_241_368##6	1.4381e-18
C120	a_374_120##6	a_1719_368#	1.04554e-18
C121	a_27_100##7	A#3	3.8261e-18
C122	a_369_365##12	a_1261_421#	5.03913e-17
C123	a_1744_94##5	a_374_120##6	3.06692e-17
C124	VGND#6	a_27_100##8	8.08889e-17
C125	VGND#11	a_369_365##3	3.00252e-19
C126	a_1606_368##9	a_374_120##6	2.19045e-19
C127	a_369_365##12	COUT_N#3	1.38822e-17
C128	a_336_263##7	a_1023_389##2	4.81748e-19
C129	VGND#6	a_374_120##9	9.71801e-18
C130	a_27_100##5	A#3	3.38848e-17
C131	a_1023_389#	B#1	4.9131e-17
C132	VGND#6	a_241_368##6	1.06506e-17
C133	a_369_365##12	a_1023_389##2	4.15647e-17
C134	a_374_120##17	a_1744_94#	4.7355e-20
C135	a_369_365##5	a_374_120##5	4.13137e-17
C136	VGND#4	CI#7	4.58275e-18
C137	a_369_365##14	CI#5	9.73932e-19
C138	a_1261_421#	a_369_365##2	6.75622e-18
C139	VGND#6	VGND#12	5.37991e-18
C140	a_369_365##12	VPWR#11	6.92823e-18
C141	B#1	VGND#11	1.54986e-17
C142	a_1744_94##5	a_369_365##6	4.36312e-17
C143	a_374_120##17	a_1606_368##3	9.57819e-19
C144	a_336_263##7	VPWR#11	1.00437e-16
C145	a_374_120##12	COUT_N#3	4.42603e-19
C146	a_1606_368##9	a_369_365##6	3.57577e-17
C147	VGND#11	a_1023_389#	5.35397e-17
C148	a_1023_389#	B#6	2.65041e-18
C149	a_1023_389##2	a_374_120##12	4.40397e-18
C150	a_374_120##17	a_374_120##7	1.1708e-17
C151	VGND#5	a_374_120##3	2.10875e-19
C152	VGND#6	B#3	1.44643e-19
C153	a_374_120##12	VPWR#11	4.51178e-18
C154	CI#6	a_369_365##5	4.50725e-18
C155	a_336_263##8	a_374_120##2	7.1893e-20
C156	a_374_120##17	a_369_365##7	2.50162e-18
C157	a_241_368##2	VPWR#11	3.50021e-18
C158	B#6	VGND#11	2.11332e-17
C159	a_1744_94##5	CI#3	3.6223e-19
C160	CI#10	a_1606_368##9	1.72418e-17
C161	a_374_120##12	a_336_263##7	1.63439e-18
C162	a_374_120##17	CI#1	4.67367e-19
C163	VGND#4	a_374_120##3	8.87879e-18
C164	a_1606_368##9	CI#3	1.0332e-17
C165	a_1023_389#	B#10	2.36113e-19
C166	CI#3	VGND#10	5.68551e-18
C167	a_369_365##8	VPWR#11	1.53114e-17
C168	B#6	a_336_263##10	8.19416e-19
C169	a_241_368##2	a_336_263##7	8.69388e-17
C170	a_1744_94##2	VPWR#9	1.1479e-17
C171	CI#5	CI#6	4.36868e-17
C172	B#4	B#8	2.64845e-17
C173	COUT_N#3	a_369_365##2	5.46829e-18
C174	a_369_365##8	a_336_263##7	2.52404e-17
C175	VGND#11	B#10	2.00544e-19
C176	a_336_263##8	B#2	2.95005e-18
C177	a_1719_368##2	a_1744_94##2	2.12206e-17
C178	a_336_263##5	B#11	9.36619e-19
C179	VGND#5	a_369_365##3	5.41558e-18
C180	CI#8	a_1606_368##9	2.00038e-17
C181	VPWR#6	a_1261_421#	1.52739e-17
C182	a_241_368#	B#6	5.06006e-19
C183	a_369_365##8	a_241_368##2	1.10938e-16
C184	B#3	B#8	1.91709e-17
C185	a_1606_368##9	a_374_120##4	3.63764e-19
C186	VGND#3	a_1744_94#	8.16123e-19
C187	VPWR#6	COUT_N#3	2.05161e-17
C188	a_369_365##8	a_374_120##8	5.47068e-17
C189	a_336_263##8	B#3	2.9876e-17
C190	VGND#4	a_369_365##3	6.43468e-20
C191	a_374_120##4	a_1261_421##2	4.54957e-17
C192	VPWR#6	a_1023_389##2	1.92585e-17
C193	VGND#3	a_1606_368##3	1.39476e-20
C194	a_369_365##4	CI#5	3.55817e-18
C195	a_1719_368##2	a_1606_368##2	4.5821e-17
C196	a_27_100##10	a_369_365##8	5.78466e-17
C197	a_336_263##6	a_336_263##8	4.21622e-18
C198	VPWR#6	VPWR#11	1.63734e-17
C199	a_241_368#	B#10	4.70248e-17
C200	a_374_120##8	a_241_368##2	8.75393e-17
C201	VGND#3	a_374_120##7	3.38955e-18
C202	a_369_365##9	a_369_365##8	2.16208e-18
C203	a_374_120##14	CI#1	1.38963e-18
C204	a_374_120##11	a_374_120##8	2.7446e-18
C205	VGND#10	CI#8	2.41315e-17
C206	VPWR#6	a_336_263##7	1.97494e-17
C207	a_1744_94##7	a_1606_368##2	3.20775e-18
C208	VGND#5	B#1	6.60067e-18
C209	VGND#3	a_369_365##7	1.43056e-17
C210	a_369_365##8	a_241_368##4	7.19236e-19
C211	a_374_120##14	CI#7	4.72882e-18
C212	a_1261_421##2	CI#10	1.28421e-17
C213	a_336_263##8	a_1023_389##2	1.58857e-19
C214	a_1719_368##2	a_374_120##6	1.83823e-19
C215	a_241_368##2	VPWR#6	1.43184e-16
C216	B#10	a_369_365##10	1.89429e-17
C217	B#9	B#4	1.24663e-17
C218	a_374_120#	a_369_365##4	1.77055e-17
C219	a_1023_389##2	a_369_365##2	8.48946e-19
C220	VGND#3	CI#1	1.66711e-18
C221	a_374_120##11	a_369_365##9	6.19461e-18
C222	a_374_120##14	a_374_120##3	9.50963e-18
C223	a_374_120##6	a_1606_368##5	2.25688e-17
C224	VPWR#6	a_374_120##8	1.86684e-17
C225	a_241_368#	a_336_263##2	5.71263e-19
C226	VGND#3	CI#7	9.90381e-19
C227	B#9	B#3	2.4014e-17
C228	a_1744_94##7	a_374_120##6	1.26352e-17
C229	a_374_120##14	a_369_365##3	2.64964e-19
C230	VPWR#6	a_27_100##10	4.74672e-18
C231	a_27_100##8	B#10	2.67396e-19
C232	a_27_100##7	a_336_263##6	1.27182e-19
C233	a_374_120##17	VGND#4	1.36559e-18
C234	a_1719_368##4	a_374_120##6	7.73644e-20
C235	a_1261_421##2	CI#8	1.7434e-17
C236	a_374_120##8	a_27_100##10	4.96455e-19
C237	VPWR#6	a_369_365##9	6.8045e-18
C238	a_336_263##2	a_369_365##10	2.25441e-17
C239	B#7	a_374_120#	2.96249e-17
C240	a_369_365##6	a_1606_368##5	8.39566e-19
C241	VGND#5	B#6	8.78972e-18
C242	a_241_368##4	VPWR#6	6.15048e-17
C243	a_241_368#	B#11	1.8944e-19
C244	a_1744_94##7	a_369_365##6	2.10933e-17
C245	a_1023_389#	a_374_120##2	1.83445e-18
C246	a_27_100##8	a_336_263##2	3.69605e-17
C247	VPWR#6	VPWR#12	2.14587e-17
C248	a_369_365##6	a_1719_368##4	1.37885e-18
C249	a_374_120##8	a_369_365##9	6.47498e-17
C250	a_1023_389##2	B#3	2.44761e-19
C251	a_27_100##7	a_27_100##2	1.30161e-18
C252	VPWR#6	a_27_100##4	2.20093e-17
C253	a_27_100##5	a_27_100##2	1.18618e-18
C254	a_1606_368##7	a_369_365##6	3.50126e-17
C255	B#8	B#7	2.82355e-17
C256	VGND#6	a_241_368##4	1.1162e-18
C257	a_336_263#	B#4	1.54089e-17
C258	a_1719_368#	a_1719_368##2	3.01586e-18
C259	a_369_365##15	VGND#4	2.48084e-19
C260	a_336_263##8	a_336_263##7	1.95033e-18
C261	a_369_365##10	a_241_368#	5.22592e-17
C262	a_369_365##9	a_27_100##10	4.05729e-17
C263	a_374_120##8	a_241_368##4	9.23269e-17
C264	a_1023_389#	B#2	7.56366e-18
C265	a_1261_421#	a_369_365##6	1.07135e-19
C266	a_27_100##8	B#11	3.66783e-17
C267	a_374_120##12	a_369_365##3	8.92192e-18
C268	B#2	VGND#11	1.67319e-17
C269	a_1606_368##7	CI#3	3.88425e-18
C270	a_27_100##7	A#2	1.54185e-18
C271	a_374_120##12	B#1	3.8758e-18
C272	VPWR#11	B#4	1.80717e-18
C273	a_27_100##5	A#2	9.3953e-18
C274	VPWR#10	CI#3	3.87132e-19
C275	B#11	a_374_120##9	2.065e-17
C276	a_241_368#	B#2	2.95916e-19
C277	a_374_120##12	B#6	5.91533e-19
C278	a_27_100##8	a_241_368#	1.86239e-18
C279	a_1261_421#	CI#3	5.21967e-19
C280	a_241_368##2	a_336_263##8	2.60533e-18
C281	a_27_100##8	a_336_263##4	2.14577e-17
C282	a_369_365##15	a_1606_368#	4.88067e-21
C283	A#5	A#2	1.01275e-17
C284	a_1744_94##2	a_1744_94#	1.95776e-17
C285	VPWR#11	B#3	6.01587e-19
C286	VGND#11	a_336_263##6	5.82206e-20
C287	a_241_368##6	B#11	1.9731e-20
C288	VPWR#3	a_1744_94##3	3.87041e-18
C289	a_336_263#	B#9	2.29723e-17
C290	a_1744_94##2	a_1606_368##3	1.74183e-17
C291	a_1744_94##5	a_1606_368##5	2.76198e-18
C292	B#5	B#4	1.15762e-18
C293	a_336_263##4	a_374_120##9	2.67014e-17
C294	B#10	B#3	8.42623e-18
C295	a_336_263##6	a_241_368#	1.20283e-17
C296	a_374_120##4	a_1261_421#	5.22675e-17
C297	VPWR#3	a_1606_368#	1.5192e-18
C298	a_369_365##8	B#10	1.65406e-18
C299	a_27_100##8	a_369_365##10	5.47143e-17
C300	a_1744_94##2	a_374_120##7	1.19307e-18
C301	VGND#4	CI#4	8.06716e-20
C302	a_336_263##6	a_369_365##10	3.952e-17
C303	a_369_365##15	a_369_365##5	3.50717e-18
C304	a_27_100##8	a_27_100#	1.58512e-19
C305	a_369_365##15	VPWR#4	1.97279e-18
C306	a_369_365##8	a_336_263##2	3.25445e-18
C307	VPWR#3	a_374_120##5	1.09508e-18
C308	a_1744_94##2	a_369_365##7	1.32009e-19
C309	a_27_100##8	a_336_263##6	5.31395e-17
C310	a_241_368##6	a_336_263##4	4.61856e-17
C311	a_1606_368##2	a_1606_368##3	2.11048e-18
C312	a_369_365##15	CI#6	3.55242e-18
C313	B#5	a_336_263#	4.95557e-17
C314	a_374_120##9	a_336_263##6	1.43522e-18
C315	a_374_120##11	B#10	1.34486e-18
C316	a_336_263##7	B#4	1.29603e-17
C317	VPWR#3	a_369_365##5	1.09062e-18
C318	VGND#4	a_374_120##14	9.56863e-18
C319	a_374_120##6	a_1744_94#	2.36775e-20
C320	VGND#6	a_369_365##3	1.97754e-19
C321	a_374_120##11	a_336_263##2	3.01113e-18
C322	VGND#5	a_369_365##2	3.87831e-20
C323	VGND#12	a_336_263##4	3.87009e-19
C324	a_241_368#	B#3	5.5442e-18
C325	VPWR#3	CI#6	2.77067e-18
C326	a_27_100##8	A#3	1.60315e-19
C327	a_374_120##6	a_1606_368##3	8.7511e-19
C328	VPWR#12	a_241_368##4	8.4845e-17
C329	VGND#6	B#1	5.74521e-19
C330	a_336_263##8	B#9	6.08067e-20
C331	a_374_120##11	B#11	9.61559e-19
C332	a_241_368##6	a_27_100#	3.06484e-17
C333	a_374_120##6	a_374_120##7	7.41195e-20
C334	a_336_263##7	B#3	1.09508e-17
C335	VPWR#3	CI#5	1.05529e-18
C336	a_336_263##5	B#5	3.22673e-17
C337	a_374_120##9	a_27_100##2	1.65026e-18
C338	VGND#6	B#6	5.7926e-19
C339	CI#4	CI#3	2.85958e-18
C340	VPWR#3	VPWR#4	1.12981e-16
C341	a_369_365##7	a_374_120##6	1.26715e-18
C342	a_241_368##6	a_27_100##2	3.4459e-17
C343	a_374_120##2	COUT_N#3	1.72956e-17
C344	VGND#6	B#10	9.94484e-19
C345	a_27_100##8	a_374_120##9	1.04661e-16
C346	a_27_100##3	B#5	1.04517e-18
C347	a_27_100#	VGND#12	2.9213e-18
C348	a_27_100##4	a_241_368##4	2.00361e-18
C349	a_27_100##2	VGND#12	3.11212e-19
C350	a_1023_389##2	a_374_120##2	5.53844e-17
C351	a_241_368##6	A#3	1.3355e-18
C352	VPWR#11	a_374_120##2	5.0114e-19
C353	VGND#3	VGND#4	1.18338e-16
C354	a_27_100##3	a_336_263##5	1.98849e-17
C355	A#1	B#5	2.90607e-19
C356	a_336_263##7	a_374_120##2	4.38132e-20
C357	a_27_100##5	a_27_100##7	3.50493e-18
C358	a_241_368##6	A#2	8.7498e-22
C359	a_27_100##4	VPWR#12	9.00675e-17
C360	a_241_368##2	B#4	5.78368e-17
C361	VGND#6	a_336_263##4	6.99419e-18
C362	VGND#12	A#3	3.77642e-17
C363	VGND#12	A#2	6.63011e-19
C364	a_1023_389##2	B#2	5.02715e-17
C365	VGND#4	a_369_365##2	6.98096e-20
C366	B#2	VPWR#11	1.16794e-17
C367	CI#3	a_369_365##7	3.21932e-18
C368	CI#10	CI#4	5.34672e-18
C369	A#1	a_27_100##3	2.68351e-17
C370	a_336_263##7	B#2	2.62223e-19
C371	a_1023_389##2	a_369_365##3	5.81989e-20
C372	VGND#6	A#3	4.79891e-18
C373	a_369_365##12	VGND#5	2.30845e-19
C374	A#3	a_27_100##6	2.07954e-18
C375	a_241_368##2	B#3	1.16764e-17
C376	a_374_120##4	CI#4	3.86807e-17
C377	a_1606_368##9	a_1606_368##7	1.12985e-18
C378	a_241_368##6	a_374_120##9	8.61079e-17
C379	a_369_365##12	VGND#4	6.66683e-19
C380	VGND#5	B#3	7.83646e-20
C381	a_369_365##2	a_374_120##4	3.42221e-17
C382	a_374_120##4	CI#7	7.64468e-19
C383	a_374_120##8	a_336_263##6	1.70856e-19
C384	CI#8	CI#1	1.37425e-18
C385	a_374_120##8	B#4	3.56962e-18
C386	a_369_365##3	a_374_120##4	4.31677e-18
C387	a_374_120##12	VGND#5	3.92598e-18
C388	a_1606_368#	a_1744_94##2	1.20777e-18
C389	a_369_365##9	a_336_263##6	4.891e-19
C390	CI#8	CI#4	4.36643e-18
C391	VPWR#6	a_369_365##4	6.94741e-18
C392	a_369_365##8	B#8	4.11972e-18
C393	a_1606_368##2	a_1606_368#	2.81166e-20
C394	a_369_365##12	VPWR#5	5.31653e-18
C395	a_1606_368##3	a_1744_94#	6.71869e-18
C396	a_374_120##17	a_369_365##15	3.46183e-17
C397	VPWR#6	a_374_120#	1.05538e-17
C398	a_369_365##8	B#9	1.68171e-17
C399	a_1261_421#	a_1606_368##9	1.21622e-19
C400	a_1744_94##3	SUM#1	1.20052e-17
C401	a_369_365##15	CI#10	1.22341e-17
C402	a_369_365##12	VPWR#4	5.474e-18
C403	a_241_368##4	a_27_100##2	1.56659e-17
C404	a_374_120##6	a_1606_368#	1.09557e-19
C405	a_1606_368##2	a_369_365##5	1.16458e-19
C406	VPWR#6	B#7	1.10706e-17
C407	a_369_365##8	a_336_263#	2.13374e-17
C408	a_374_120##2	a_369_365##3	6.58033e-20
C409	a_27_100##2	VPWR#12	3.70532e-18
C410	a_369_365##8	VGND#5	1.31483e-19
C411	VPWR#6	B#8	9.03843e-18
C412	a_1744_94##3	VPWR#9	2.86254e-17
C413	a_369_365##8	B#5	4.04918e-19
C414	a_1261_421##2	VPWR#10	1.467e-19
C415	a_369_365##15	VPWR#3	2.57828e-17
C416	a_369_365##5	a_374_120##6	2.96242e-18
C417	a_241_368##4	A#2	9.74745e-20
C418	a_1606_368##7	VPWR#4	1.77644e-17
C419	a_369_365##8	a_336_263##5	1.89013e-19
C420	B#2	a_369_365##3	1.03383e-18
C421	a_374_120##14	a_369_365##15	1.67915e-17
C422	A#2	VPWR#12	1.76103e-18
C423	VGND#3	a_374_120##17	6.38181e-17
C424	a_1719_368##2	a_1744_94##3	3.85788e-18
C425	a_374_120##7	a_1606_368##3	1.45198e-17
C426	B	B#3	1.08384e-17
C427	a_27_100##5	A#5	5.38392e-17
C428	a_369_365##6	a_369_365##5	2.73018e-18
C429	VPWR#3	CI#10	2.69038e-18
C430	a_27_100##4	A#2	2.90579e-18
C431	B#6	B#2	4.22208e-19
C432	a_1606_368#	VPWR#9	3.17242e-17
C433	a_369_365##15	VGND#3	6.8611e-19
C434	VPWR#6	B#5	1.70241e-17
C435	a_369_365##6	CI#6	2.36915e-19
C436	B#10	B#2	7.3749e-19
C437	CI#3	a_369_365##5	2.4082e-19
C438	a_1719_368##2	a_1606_368#	8.28315e-17
C439	a_336_263##6	B#6	1.07946e-18
C440	VPWR#6	a_27_100##3	3.08741e-18
C441	VGND#3	a_374_120##14	6.81085e-17
C442	a_369_365##12	VPWR#3	1.61072e-17
C443	a_336_263##6	B#10	2.17301e-17
C444	a_374_120##2	a_369_365##2	3.10252e-17
C445	VPWR#6	A#1	2.9013e-18
C446	a_27_100##7	a_241_368##4	2.41276e-18
C447	a_1606_368##5	a_1606_368#	1.9215e-18
C448	a_369_365##7	a_374_120##7	7.89538e-18
C449	a_369_365##8	VPWR#5	1.81294e-18
C450	a_374_120##14	a_369_365##12	4.74139e-17
C451	a_336_263##6	B#11	1.52308e-17
C452	a_374_120##4	CI#5	9.86792e-18
C453	a_1719_368##2	a_374_120##5	2.07667e-18
C454	a_336_263##4	a_336_263##6	1.35503e-18
C455	a_374_120##14	CI#8	6.73397e-18
C456	a_1744_94##7	a_1606_368#	4.76595e-20
C457	a_1606_368##5	a_374_120##5	6.80877e-17
C458	a_27_100##2	a_336_263##4	1.09927e-17
C459	a_374_120##12	a_369_365##12	6.54767e-17
C460	a_27_100##7	VPWR#12	3.17243e-18
C461	a_1719_368##4	a_1606_368#	1.72896e-19
C462	a_1261_421#	VPWR#4	5.75606e-17
C463	a_27_100##2	a_27_100#	1.26709e-19
C464	a_1719_368##2	a_369_365##5	1.73916e-19
C465	a_27_100##10	a_336_263##2	3.00889e-18
C466	a_374_120##17	a_1744_94##2	7.17762e-19
C467	CI#1	a_369_365##7	2.68664e-17
C468	a_374_120##5	a_1744_94##7	1.97561e-17
C469	VGND#3	CI#8	6.80139e-19
C470	a_1606_368##7	a_1606_368#	2.02777e-19
C471	a_336_263##8	a_1023_389#	2.50526e-18
C472	VGND#4	a_1606_368##9	1.79557e-17
C473	a_1606_368##5	a_369_365##5	3.83379e-17
C474	COUT_N#3	VPWR#5	2.04413e-17
C475	A#2	a_27_100#	3.44045e-19
C476	a_374_120##12	a_369_365##8	2.5598e-17
C477	B#2	a_369_365##2	1.83128e-18
C478	VGND#6	a_374_120##14	6.39495e-18
C479	a_1719_368##4	a_374_120##5	9.34419e-18
C480	VPWR#3	a_1744_94##2	3.34651e-18
C481	a_27_100##10	B#11	2.23671e-18
C482	B#7	a_374_120##2	7.46758e-18
C483	a_369_365##15	a_1606_368##2	1.59176e-18
C484	a_369_365##12	VPWR#6	3.2231e-17
C485	a_374_120##14	a_369_365##11	4.70958e-19
C486	a_1744_94##7	a_369_365##5	2.58815e-17
C487	B#3	B#2	2.32574e-18
C488	a_369_365##15	CI#4	5.64181e-19
C489	VPWR#3	a_1606_368##2	1.43702e-18
C490	a_241_368##4	B#4	4.36476e-19
C491	VGND#6	VGND#5	1.39431e-16
C492	a_369_365##15	a_374_120##6	1.73627e-18
C493	a_374_120##11	a_369_365##8	4.09814e-17
C494	a_1606_368##7	a_374_120##5	9.05794e-19
C495	a_369_365##12	CI#10	2.92949e-18
C496	COUT_N	a_369_365##2	1.66802e-17
C497	a_374_120##17	a_369_365##6	7.15003e-18
C498	VGND#3	a_1744_94##2	1.87345e-17
C499	a_1606_368##5	CI#6	5.53212e-19
C500	VGND#6	VGND#4	1.21937e-17
C501	CI#7	CI#1	2.57739e-17
C502	VPWR#3	a_374_120##6	2.3063e-18
C503	B#8	B#2	1.86654e-18
C504	a_27_100##10	a_336_263##4	2.26316e-20
C505	a_369_365##5	a_1719_368##4	2.2907e-17
C506	a_369_365##8	VPWR#6	3.62323e-17
C507	a_336_263##8	VGND#11	5.40355e-17
C508	VGND#6	a_374_120##12	9.58525e-17
C509	VPWR#6	VPWR#5	1.33633e-16
C510	a_369_365##15	a_369_365##6	2.98902e-17
C511	A#5	A#1	4.63474e-18
C512	a_27_100##5	a_27_100##4	2.94579e-18
C513	VGND#3	a_1606_368##2	7.2753e-18
C514	VPWR#3	a_369_365##6	3.19083e-18
C515	a_1744_94##7	CI#6	1.1116e-18
C516	VPWR#6	VPWR#4	2.29267e-17
C517	a_1023_389##2	VPWR#5	1.95481e-17
C518	a_369_365##15	CI#3	4.2385e-18
C519	VGND#3	a_374_120##6	1.86797e-18
C520	a_1606_368##7	a_369_365##5	5.19975e-18
C521	B	VPWR#5	2.56273e-19
C522	a_369_365##9	a_336_263##4	1.35613e-19
C523	VGND#6	a_374_120##11	8.88133e-17
C524	VGND#11	a_1023_389##2	1.45561e-18
C525	a_27_100##7	A	1.31041e-17
C526	a_1719_368##4	CI#6	3.49768e-18
C527	a_27_100##5	A	3.20798e-18
C528	VGND#3	a_369_365##6	4.63317e-18
C529	VPWR#3	a_374_120##4	1.72172e-18
C530	VPWR#4	CI#4	7.2036e-20
C531	a_336_263##8	a_336_263##10	2.00157e-17
C532	VGND#3	CI#3	1.41029e-20
C533	a_374_120##3	CI#7	1.18516e-17
C534	a_374_120##14	a_374_120##4	1.19279e-18
C535	a_1606_368##7	CI#6	7.66944e-17
C536	a_369_365##12	a_369_365##14	9.7396e-18
C537	VPWR#3	CI#4	4.63984e-19
C538	a_1261_421#	a_369_365##5	2.19009e-20
C539	VGND#3	a_374_120##4	2.8274e-19
C540	a_1719_368##2	VPWR#9	7.62111e-17
C541	a_1719_368##4	CI#5	4.38156e-19
C542	a_27_100##2	a_336_263##5	1.40878e-17
C543	a_374_120##9	B#9	4.11846e-20
C544	VGND#4	a_1261_421##2	2.06092e-17
C545	a_369_365##12	a_374_120##4	2.96782e-17
C546	a_369_365##12	a_369_365##11	7.44862e-18
C547	CI#6	VPWR#10	2.65202e-17
C548	a_374_120##12	a_374_120##4	1.14115e-19
C549	a_1606_368##2	a_1744_94##2	2.96015e-17
C550	a_1606_368##7	CI#5	3.27679e-18
C551	a_27_100##4	A#5	1.80813e-17
C552	a_336_263##8	a_241_368#	7.75976e-17
C553	a_1261_421#	CI#6	3.34377e-18
C554	a_336_263##8	B	5.67879e-17
C555	a_369_365##12	a_374_120##2	2.92734e-17
C556	a_369_365##3	a_374_120##3	1.26147e-17
C557	a_374_120##9	a_336_263#	2.48307e-19
C558	A	VGND#12	1.16975e-18
C559	CI#5	VPWR#10	2.83697e-17
C560	a_374_120##6	a_1606_368##2	5.88759e-17
C561	a_374_120##12	a_374_120##2	2.78091e-18
C562	a_369_365##12	B#2	1.83834e-17
C563	VGND#5	COUT_N	1.11083e-17
C564	a_1606_368##2	a_369_365##6	4.54742e-20
C565	a_374_120##12	a_369_365##11	4.84163e-19
C566	VGND#4	COUT_N	1.40452e-17
C567	a_374_120##12	B#2	9.04876e-18
C568	a_336_263##7	VPWR#5	1.68118e-17
C569	a_1261_421#	CI#5	7.81775e-17
C570	VPWR#5	B#4	1.20151e-18
C571	a_369_365##6	a_374_120##6	1.9733e-17
C572	a_369_365##8	B#2	3.19541e-18
C573	a_1606_368##5	a_1719_368##2	1.22035e-16
C574	a_374_120##17	a_1719_368#	3.76837e-17
C575	VPWR#6	a_374_120##2	4.56845e-18
C576	VPWR#10	a_369_365##4	4.87643e-19
C577	a_374_120##14	CI#4	8.62912e-20
C578	a_374_120##9	B#5	5.86454e-18
C579	a_336_263##6	a_369_365##8	6.42777e-19
C580	COUT_N#3	CI#5	1.85508e-19
C581	VGND#6	a_374_120##2	4.73378e-19
C582	VGND#5	a_1023_389#	3.47315e-17
C583	VPWR#6	B#2	2.17888e-18
C584	a_374_120##17	a_1744_94##5	9.72316e-17
C585	B#1	a_369_365##3	6.90466e-18
C586	CI#3	a_369_365##6	1.89413e-17
C587	VPWR#4	a_369_365##2	1.21305e-19
C588	a_374_120##11	a_336_263##6	8.55712e-18
C589	a_369_365##8	a_27_100##2	5.87795e-19
C590	a_369_365##4	a_1261_421#	4.58324e-17
C591	VGND#6	B#2	7.97403e-19
C592	SUM#3	a_1744_94#	2.15181e-17
C593	a_241_368##6	B#5	2.13219e-19
C594	a_374_120##17	a_1606_368##9	3.52045e-17
C595	VGND#6	a_336_263##6	1.07675e-16
C596	VPWR#10	a_374_120#	2.7109e-19
C597	a_1719_368#	VGND#9	2.04195e-18
C598	SUM#3	SUM	2.50516e-18
C599	A	a_241_368##4	3.66358e-18
C600	VPWR#6	a_27_100##2	3.77405e-18
C601	A	VPWR#12	1.74382e-17
C602	COUT_N	a_369_365##11	3.41841e-17
C603	a_374_120##9	a_336_263##5	3.10697e-17
C604	COUT_N#3	a_369_365##4	5.93208e-17
C605	a_369_365##14	a_369_365##2	9.42745e-18
C606	a_27_100##8	a_336_263##8	1.08965e-18
C607	VGND#6	a_27_100##2	2.51634e-20
C608	VPWR#5	B#3	1.25286e-19
C609	CI#10	VPWR#4	4.51934e-19
C610	a_1744_94#	VGND#9	1.74598e-17
C611	a_1261_421#	a_374_120#	4.18668e-19
C612	a_369_365##15	a_1744_94##5	8.26082e-18
C613	a_241_368##6	a_336_263##5	1.02495e-18
C614	a_1023_389##2	a_369_365##4	1.46418e-18
C615	SUM#3	a_1606_368##3	7.65003e-19
C616	a_1606_368##5	a_1744_94##7	5.33375e-17
C617	B#6	B#1	3.16379e-17
C618	a_1719_368##4	a_1719_368##2	1.28858e-18
C619	a_374_120##12	a_336_263##8	4.4076e-17
C620	a_369_365##15	a_1606_368##9	3.6987e-18
C621	COUT_N#3	a_374_120#	1.68817e-17
C622	B	VPWR#11	1.2108e-17
C623	a_374_120##9	a_27_100##3	8.85723e-19
C624	a_1719_368#	a_1744_94#	3.8449e-18
C625	a_336_263##8	B#1	1.88458e-18
C626	SUM	SUM#1	5.75544e-18
C627	VPWR#11	a_369_365##4	7.69544e-19
C628	VPWR#9	SUM	7.53241e-17
C629	a_369_365##15	VGND#10	3.78275e-18
C630	a_1719_368##2	SUM	1.42558e-17
C631	VGND#4	a_369_365##6	6.48442e-20
C632	a_1261_421#	B#7	1.48265e-19
C633	CI#4	VNB	3.3035e-17
C634	a_369_365##2	VNB	6.21789e-17
C635	COUT_N	a_1261_421##2	1.35378e-17
C636	B#4	VNB	1.20123e-16
C637	a_1606_368##3	VGND#9	1.47662e-17
C638	B#3	VNB	6.45736e-17
C639	COUT_N	COUT_N#1	1.70344e-17
C640	a_1023_389##2	a_374_120#	2.02361e-17
C641	B#2	a_374_120##2	1.19049e-17
C642	a_1023_389#	COUT_N	2.67349e-17
C643	VGND#11	COUT_N	5.23658e-19
C644	a_1606_368##5	a_1719_368##4	3.66877e-17
C645	COUT_N#3	B#7	3.13569e-18
C646	a_369_365##8	a_336_263##8	2.04945e-17
C647	VPWR#11	a_374_120#	1.35211e-18
C648	B#10	B#6	2.08448e-18
C649	VPWR#6	a_369_365##14	7.47075e-19
C650	a_1744_94##5	a_1719_368#	2.64427e-17
C651	a_1261_421#	B#8	1.04463e-19
C652	a_1719_368#	a_1606_368##3	2.90321e-17
C653	a_369_365##11	a_369_365##2	4.57076e-18
C654	a_336_263##8	B#6	2.69563e-17
C655	a_1023_389##2	B#7	5.61129e-17
C656	B	B#10	3.37079e-19
C657	a_1606_368##7	a_1606_368##5	3.0804e-18
C658	VGND#3	SUM#3	1.82077e-17
C659	COUT_N	a_1261_421#	1.02472e-18
C660	VPWR#4	CI#6	7.79667e-18
C661	B#7	VPWR#11	2.95762e-17
C662	A#2	a_27_100##2	2.53604e-17
C663	a_1744_94##5	a_1606_368##3	9.07664e-18
C664	VGND#5	VNB	7.51466e-17
C665	A	a_336_263##5	2.79211e-19
C666	VGND#4	VNB	6.54239e-17
C667	a_1023_389##2	B#8	1.69401e-18
C668	a_374_120##11	a_336_263##8	1.60026e-17
C669	a_374_120##9	a_241_368##2	3.2574e-19
C670	A	a_27_100##3	1.14434e-18
C671	a_374_120##7	a_1719_368#	2.29415e-17
C672	VPWR#5	VNB	6.89629e-17
C673	VGND#3	a_1719_368#	1.18059e-17
C674	A	A#1	6.20876e-20
C675	a_369_365##12	CI#4	2.15937e-18
C676	VPWR#4	VNB	6.79891e-17
C677	a_336_263##2	B#10	2.11285e-17
C678	a_374_120##14	VGND#10	2.62404e-17
C679	a_1606_368##7	a_1744_94##7	8.71508e-18
C680	COUT_N	CI#7	1.74492e-18
C681	a_336_263##8	B#10	3.8193e-18
C682	COUT_N	a_374_120##3	1.15724e-17
C683	SUM	a_1744_94##3	3.51297e-17
C684	COUT_N	a_369_365##3	2.3351e-17
C685	B#8	VPWR#11	3.69265e-17
C686	VGND#3	a_1744_94##5	1.26517e-16
C687	COUT_N	B#1	9.78216e-19
C688	SUM	a_1606_368#	4.16008e-18
C689	CI#10	VNB	1.762e-18
C690	CI#8	VNB	1.93927e-18
C691	COUT_N	B#6	2.72369e-19
C692	a_374_120##14	a_1261_421##2	5.80118e-17
C693	a_241_368##2	B#7	2.53685e-19
C694	a_369_365##14	VNB	4.02581e-18
C695	a_369_365##11	VNB	4.30965e-18
C696	a_1744_94##5	a_374_120##7	5.41461e-17
C697	a_369_365##12	a_369_365##2	4.0156e-18
C698	a_336_263##8	VNB	2.34206e-17
C699	VGND#3	a_1606_368##9	1.65931e-17
C700	a_336_263##7	B#8	6.58873e-17
C701	VPWR#4	CI#5	5.19261e-18
C702	a_374_120##9	a_374_120##8	2.44386e-18
C703	a_374_120##14	COUT_N#1	4.29044e-18
C704	a_27_100##7	VNB	1.23472e-17
C705	a_27_100##5	VNB	6.15238e-17
C706	a_1606_368##9	a_1744_94##5	4.56304e-17
C707	a_1606_368##7	a_1719_368##4	6.60021e-17
C708	CI#4	CI#6	1.33063e-18
C709	VGND#4	a_374_120##4	7.12438e-19
C710	a_1719_368#	a_369_365##7	6.27002e-19
C711	CI#10	VPWR#10	4.94245e-18
C712	A#5	VNB	1.94696e-18
C713	VPWR#6	A	1.56749e-18
C714	SUM#3	VNB	5.07642e-17
C715	a_1719_368#	VNB	4.6328e-18
C716	VGND#6	A	1.55072e-18
C717	a_1744_94##5	VNB	2.72958e-17
C718	VPWR#4	CI#3	1.60589e-19
C719	a_1606_368##9	VNB	4.72167e-18
C720	VGND#10	VNB	3.49701e-18
C721	a_1261_421##2	VNB	7.38992e-18
C722	a_1023_389#	VNB	1.06255e-18
C723	B#11	a_336_263##2	4.12073e-17
C724	VGND#11	VNB	1.11334e-18
C725	a_241_368##2	B#8	2.23607e-18
C726	a_241_368#	VNB	6.22907e-18
C727	a_1606_368##9	a_374_120##7	9.07857e-19
C728	a_369_365##10	VNB	3.32585e-18
C729	a_336_263##8	a_336_263##2	8.98594e-20
C730	a_27_100##8	VNB	7.78306e-18
C731	a_374_120##9	VNB	9.88913e-18
C732	a_374_120##12	B	5.81441e-18
C733	a_241_368##6	VNB	5.60903e-19
C734	VGND#3	a_1261_421##2	1.6036e-17
C735	VGND#12	VNB	8.29276e-18
C736	a_369_365##8	B	9.66761e-18
C737	VPWR#3	SUM	2.09802e-17
C738	VPWR#9	VNB	3.64628e-18
C739	a_1719_368##2	VNB	8.67582e-18
C740	a_336_263##7	B#9	1.34735e-18
C741	a_1606_368##5	VNB	1.26783e-17
C742	a_1744_94##7	VNB	9.80533e-19
C743	VGND#3	SUM	2.19617e-18
C744	VPWR#6	B	1.81071e-18
C745	a_1719_368##4	VNB	2.11715e-17
C746	a_1744_94##5	a_369_365##7	2.06439e-17
C747	a_1606_368##7	VNB	1.38045e-17
C748	VPWR#10	VNB	3.62186e-18
C749	VPWR#5	a_369_365##4	5.35528e-19
C750	a_1261_421#	VNB	1.27264e-17
C751	a_1606_368##9	CI#4	3.33284e-19
C752	a_374_120##9	a_27_100##10	2.17776e-17
C753	COUT_N#3	VNB	6.79396e-18
C754	VPWR#10	a_1719_368##4	1.70448e-18
C755	a_1023_389##2	VNB	1.11154e-17
C756	VPWR#11	VNB	8.49527e-18
C757	a_336_263##7	VNB	2.95113e-18
C758	a_374_120##11	a_27_100##7	2.55073e-18
C759	a_241_368##2	VNB	7.65554e-18
C760	a_374_120##8	VNB	3.25886e-18
C761	a_27_100##10	VNB	1.4333e-18
C762	a_374_120##14	COUT_N	3.99867e-17
C763	VGND#10	a_1744_94##5	2.6415e-18
C764	a_241_368##4	VNB	1.94032e-17
C765	VPWR#12	VNB	4.9179e-18
C766	VGND#10	a_374_120##7	1.14305e-19
C767	a_27_100##4	VNB	5.65723e-17
C768	a_241_368##2	B#9	3.81119e-17
C769	a_1744_94#	VNB	3.48977e-17
C770	a_369_365##12	COUT_N	2.36952e-17
C771	a_1606_368##3	VNB	3.01801e-17
C772	a_1744_94##2	SUM	2.93508e-17
C773	A	a_27_100##2	3.69334e-17
C774	a_374_120##7	VNB	2.95941e-17
C775	a_374_120##12	COUT_N	6.19948e-17
C776	a_369_365##7	VNB	3.76374e-17
C777	SUM	a_1606_368##2	6.00924e-20
C778	CI#1	VNB	3.44781e-17
C779	a_374_120##11	a_27_100##5	1.40648e-18
C780	A	A#2	4.5737e-18
C781	CI#7	VNB	2.88201e-17
C782	VGND#6	a_336_263##8	9.04446e-17
C783	VPWR#4	a_369_365##4	4.06327e-18
C784	a_374_120##3	VNB	2.90008e-17
C785	a_369_365##3	VNB	3.29999e-17
C786	a_1261_421#	CI#10	3.36926e-18
C787	B#1	VNB	3.06149e-17
C788	B#6	VNB	3.15838e-17
C789	B#10	VNB	4.31204e-17
C790	VGND#6	COUT_N	1.66137e-17
C791	a_1606_368##9	a_369_365##7	1.78163e-17
C792	a_336_263##2	VNB	2.86436e-17
C793	B	B#2	2.3741e-18
C794	B#11	VNB	3.22281e-17
C795	a_336_263##4	VNB	6.93116e-17
C796	a_27_100#	VNB	2.41319e-17
C797	a_369_365##12	a_1261_421##2	1.39623e-18
C798	a_336_263##4	B#11	2.37456e-17
C799	A#3	VNB	4.00311e-17
C800	VPWR#4	a_374_120##4	1.46824e-19
C801	B#9	a_374_120##8	1.1236e-17
C802	a_336_263##8	B#11	1.45291e-19
C803	a_1744_94##3	VNB	3.77135e-17
C804	a_1606_368#	VNB	4.70269e-17
C805	a_374_120##5	VNB	2.97018e-17
C806	a_369_365##5	VNB	4.94555e-17
C807	VPWR#10	a_1606_368##7	7.84842e-17
C808	CI#6	VNB	4.34969e-17
C809	CI#5	VNB	4.36654e-17
C810	COUT_N	a_374_120##4	3.7122e-17
C811	a_374_120##9	a_369_365##9	5.19743e-17
C812	a_27_100##7	a_27_100##8	1.24642e-18
C813	a_369_365##4	VNB	3.35246e-17
C814	a_1744_94##5	CI#1	3.76085e-18
C815	a_374_120#	VNB	3.54219e-17
C816	B#7	VNB	4.61436e-17
C817	B#8	VNB	4.39423e-17
C818	a_374_120##2	COUT_N	3.70547e-17
C819	B#9	VNB	3.02174e-17
C820	a_241_368##2	a_336_263#	7.10752e-18
C821	a_336_263#	VNB	3.52916e-17
C822	COUT_N	B#2	8.78597e-19
C823	B#5	VNB	7.68704e-17
C824	a_336_263##5	VNB	4.50426e-17
C825	a_27_100##3	VNB	3.72822e-17
C826	A#1	VNB	4.27918e-17
C827	VGND#10	a_1606_368##9	5.14413e-17
C828	a_369_365##15	VNB	2.1182e-18
C829	VGND#10	a_369_365##7	6.28834e-19
C830	VPWR#3	VNB	2.72201e-16
C831	a_374_120##14	VNB	6.8228e-19
C832	VGND#3	VNB	2.65634e-16
C833	VPWR#5	a_374_120#	4.61931e-18
C834	a_369_365##12	VNB	9.15492e-18
C835	a_374_120##12	VNB	3.20137e-18
C836	a_369_365##12	a_1023_389#	3.41849e-19
C837	a_369_365##8	VNB	1.07263e-17
C838	a_374_120##11	VNB	2.71031e-18
C839	VPWR#6	VNB	3.42295e-16
C840	VGND#6	VNB	3.44888e-16
C841	a_374_120##8	a_336_263#	3.34416e-17
C842	a_1744_94##2	VNB	4.20847e-17
C843	a_1606_368##2	VNB	4.39563e-17
C844	a_374_120##6	VNB	3.69844e-17
C845	a_369_365##6	VNB	5.51939e-17
C846	a_1606_368##9	CI#1	4.0171e-17
C847	CI#3	VNB	3.0535e-17
C848	a_374_120##4	VNB	6.42458e-17
C849	a_369_365##9	B#9	1.60821e-19
C850	a_1261_421#	a_1606_368##7	7.39069e-18
C851	a_374_120##17	a_1606_368##5	1.89661e-18
C852	a_374_120##2	VNB	4.05714e-17
C853	B#2	VNB	5.60616e-17
C854	a_369_365##12	VGND#11	5.02714e-18
C855	a_336_263##6	VNB	8.08658e-17
C856	CI#10	a_369_365##6	5.1117e-19
C857	a_27_100##2	VNB	3.03979e-17
C858	A#2	VNB	3.42481e-17
C859	a_241_368##2	B#5	1.44082e-17
C860	VPWR#4	a_374_120#	2.18101e-19
C861	a_374_120##9	a_241_368##4	6.98068e-17
C862	VGND#5	a_374_120##2	2.10621e-19
C863	a_27_100#	a_336_263##4	4.01518e-17
C864	a_1744_94##5	CI#7	3.42379e-19
C865	a_27_100##10	a_336_263#	3.33484e-17
C866	CI#4	VGND#10	1.95318e-19
C867	a_27_100##7	a_374_120##9	1.98065e-19
C868	a_374_120##12	COUT_N#1	2.43467e-19
C869	CI#4	CI#1	2.07202e-18
C870	A	VNB	7.59047e-19
C871	a_369_365##15	a_1719_368##2	1.62849e-18
C872	B	VNB	7.21744e-18
C873	a_369_365##2	CI#5	1.75636e-18
C874	a_1261_421##2	a_1606_368##9	3.86306e-18
C875	SUM	VNB	7.00776e-17
C876	COUT_N	VNB	1.3426e-17
C877	a_374_120##8	B#5	1.64293e-17
C878	CI#1	VGND#10	1.82973e-17
C879	VGND#6	a_27_100##7	2.91269e-17
C880	a_374_120##12	a_1023_389#	1.17268e-16
C881	a_369_365##9	a_336_263#	6.36541e-18
C882	a_27_100##4	VPWR#7	2.43199e-17
C883	VPWR#2	a_1606_368#	7.83967e-18
C884	SUM	VPWR#2	2.23585e-17
C885	VGND#7	VNB	7.44501e-17
C886	A#5	VPWR#7	4.12144e-19
C887	VGND#3	VGND#2	1.14921e-16
C888	a_27_100##2	VPWR#7	6.75119e-19
C889	VGND#6	VGND#7	1.32012e-16
C890	VPWR#7	B#5	2.41369e-19
C891	a_1719_368##2	VPWR#2	3.38139e-17
C892	VPWR#7	A#2	2.55052e-20
C893	VPWR#6	VPWR#7	1.28899e-16
C894	VGND#2	a_1744_94##2	7.47707e-17
C895	VGND#7	A#3	9.57202e-19
C896	VPWR#7	a_336_263##5	9.91e-19
C897	VGND#2	a_1606_368##2	7.02008e-19
C898	VGND#7	a_27_100#	1.15916e-18
C899	VGND#7	a_336_263##4	8.21361e-18
C900	VPWR#3	VPWR#2	1.16984e-16
C901	VPWR#7	a_27_100##3	5.70615e-18
C902	VGND#2	a_1744_94#	1.48008e-17
C903	VGND#7	a_27_100##5	1.26682e-17
C904	VPWR#7	A#1	7.7905e-18
C905	VGND#2	a_1606_368##3	5.83042e-18
C906	VGND#7	a_27_100##7	5.51901e-17
C907	VPWR#2	VNB	5.96021e-17
C908	a_1744_94##2	VPWR#2	2.64219e-19
C909	VPWR#7	VNB	7.46699e-17
C910	VPWR#2	a_1606_368##2	1.53663e-19
C911	VGND#7	VGND#12	4.41435e-18
C912	VGND#2	SUM#3	2.51472e-17
C913	VGND#2	VGND#9	7.77798e-18
C914	VGND#2	a_1744_94##5	2.16109e-17
C915	VGND#7	a_27_100##2	2.29862e-19
C916	VGND#7	a_27_100##8	1.55976e-17
C917	a_241_368##4	VPWR#7	7.14142e-17
C918	VGND#2	VNB	6.33142e-17
C919	VPWR#2	a_1744_94##3	7.32729e-18
*
*
.ENDS sky130_fd_sc_hs__fahcon_1
*
