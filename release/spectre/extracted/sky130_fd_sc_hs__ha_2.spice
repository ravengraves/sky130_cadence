* Extracted by Quantus, converted by sky130cad/quantus.py
*
*
*
*                       LINUX           Wed Nov 18 08:41:05 2026
*
*
*
*  PROGRAM  advgen
*
*  Name           : advgen - Quantus - (64-bit)
*  Version        : 25.1.0-p047
*  Build Date     : Thu Dec 11 23:20:30 PST 2025
*
*  HSPICE LIBRARY
*
*  OPERATING_TEMPERATURE 150
*  QRC_TECH_DIR <path>/tech
*
*
*

*
.SUBCKT sky130_fd_sc_hs__ha_2 VPB VNB VGND VPWR SUM COUT B A
*
*
*  caps2d version: 10
*
*
*       TRANSISTOR CARDS
*
*
XM16 a_27_74##14 B#3 a_114_74# VNB sky130_fd_pr__nfet_01v8_lvt l=0.15 w=0.74 ad=0.2109 as=0.1776 pd=2.05 ps=1.96
XM17 a_114_74# A#5 VGND#11 VNB sky130_fd_pr__nfet_01v8_lvt l=0.15 w=0.74 ad=0.1776 as=0.2072 pd=1.96 ps=2.04
XM14 VGND#11 A#6 a_278_74##2 VNB sky130_fd_pr__nfet_01v8_lvt l=0.15 w=0.74 ad=0.2072 as=0.2072 pd=2.04 ps=2.04
XM1 a_278_74##2 B#6 VGND#10 VNB sky130_fd_pr__nfet_01v8_lvt l=0.15 w=0.74 ad=0.2072 as=0.19515 pd=2.04 ps=2.05
XM2 a_391_388##9 a_27_74##4 a_278_74# VNB sky130_fd_pr__nfet_01v8_lvt l=0.15 w=0.74 ad=0.201625 as=0.2011 pd=2.05 ps=2.05
XM13 SUM#1 a_391_388##5 VGND#9 VNB sky130_fd_pr__nfet_01v8_lvt l=0.15 w=0.74 ad=0.2442 as=0.1962 pd=2.14 ps=2.05
XM15 VGND#8 a_391_388# SUM#1 VNB sky130_fd_pr__nfet_01v8_lvt l=0.15 w=0.74 ad=0.2072 as=0.2442 pd=2.04 ps=2.14
XM3 VGND#8 a_27_74##10 COUT#2 VNB sky130_fd_pr__nfet_01v8_lvt l=0.15 w=0.74 ad=0.2072 as=0.2072 pd=2.04 ps=2.04
XM8 COUT#2 a_27_74##5 VGND#1 VNB sky130_fd_pr__nfet_01v8_lvt l=0.15 w=0.74 ad=0.2072 as=0.2109 pd=2.04 ps=2.05
XM10 VPWR#6 B#1 a_27_74##16 VPB sky130_fd_pr__pfet_01v8 l=0.15 w=1 ad=0.295 as=0.3 pd=2.59 ps=2.6
XM5 a_27_74##16 A#7 VPWR#9 VPB sky130_fd_pr__pfet_01v8 l=0.15 w=1 ad=0.3 as=0.3585 pd=2.6 ps=2.75
XM4 VPWR#9 A#1 a_307_388# VPB sky130_fd_pr__pfet_01v8 l=0.15 w=1 ad=0.3585 as=0.27 pd=2.75 ps=2.54
XM12 a_307_388# B#4 a_391_388##10 VPB sky130_fd_pr__pfet_01v8 l=0.15 w=1 ad=0.27 as=0.99 pd=2.54 ps=3.98
XM0 a_391_388##10 a_27_74# VPWR#8 VPB sky130_fd_pr__pfet_01v8 l=0.15 w=1 ad=0.99 as=0.7737 pd=3.98 ps=3.71
XM11 SUM#2 a_391_388##6 VPWR#8 VPB sky130_fd_pr__pfet_01v8 l=0.15 w=1.12 ad=0.336 as=0.7737 pd=2.84 ps=3.71
XM6 VPWR#7 a_391_388##4 SUM#2 VPB sky130_fd_pr__pfet_01v8 l=0.15 w=1.12 ad=0.336 as=0.336 pd=2.84 ps=2.84
XM9 COUT#1 a_27_74##8 VPWR#7 VPB sky130_fd_pr__pfet_01v8 l=0.15 w=1.12 ad=0.336 as=0.336 pd=2.84 ps=2.84
XM7 VPWR#1 a_27_74##9 COUT#1 VPB sky130_fd_pr__pfet_01v8 l=0.15 w=1.12 ad=0.3304 as=0.336 pd=2.83 ps=2.84
*
*
*       RESISTOR AND CAP/DIODE CARDS
*
Rg1	B#1	B#2	475.221954
Rg2	B#2	B#3	351.636841
Rg3	A#1	A#2	477.210968
Rg4	A#2	A#3	2.736583
Rg5	A#3	A#4	46.754292
Rg6	A#4	A#5	441.595306
Rg7	A#2	A#6	465.196472
Rg8	A#4	A#7	422.461670
Rg9	B#4	B#5	400.207520
Rg10	B#5	B#6	428.579132
Rg11	a_27_74#	a_27_74##2	510.628357
Rg12	a_27_74##2	a_27_74##3	37.061756
Rg13	a_27_74##2	a_27_74##4	386.010681
Rg14	a_391_388#	a_391_388##2	324.550201
Rg15	a_391_388##2	a_391_388##3	96.781052
Rg16	a_391_388##2	a_391_388##4	507.522552
Rg17	a_391_388##3	a_391_388##5	288.753235
Rg18	a_391_388##3	a_391_388##6	472.761688
Rg19	a_27_74##5	a_27_74##6	344.184753
Rg20	a_27_74##6	a_27_74##7	90.033310
Rg21	a_27_74##7	a_27_74##8	529.775757
Rg22	a_27_74##6	a_27_74##9	447.184967
Rg23	a_27_74##7	a_27_74##10	428.306824
Rf1	A#3	A	162.988510
Rf2	B#5	B	202.975296
Rf3	B	B#2	229.869019
Rf4	a_278_74#	a_278_74##2	179.689209
Rf5	a_391_388##3	a_391_388##8	66.618652
Rf6	a_391_388##8	a_391_388##9	94.569939
Rf7	a_391_388##8	a_391_388##10	89.049919
Rf8	SUM#1	SUM	121.017509
Rf9	SUM	SUM#3	16.104858
Rf10	SUM#3	SUM	1.861096
Rf11	SUM#2	SUM#3	15.000000
Rf12	COUT	COUT#1	83.249962
Rf13	COUT	COUT#3	7.282945
Rf14	COUT#3	COUT	7.282945
Rf15	COUT#2	COUT#3	7.500000
Rf16	a_27_74##6	a_27_74##12	512.932678
Rf17	a_27_74##12	a_27_74##13	129.560318
Rf18	a_27_74##13	a_27_74##14	52.713596
Rf19	a_27_74##12	a_27_74##3	89.585243
Rf20	a_27_74##13	a_27_74##16	71.737152
Rf21	VPWR#1	VPWR#2	94.997292
Rf22	VPWR#2	VPWR#3	81.727859
Rf23	VPWR#3	VPWR#4	42.670376
Rf24	VPWR#4	VPWR#5	122.126167
Rf25	VPWR#5	VPWR#6	99.127090
Rf26	VPWR#2	VPWR#7	32.932804
Rf27	VPWR#3	VPWR#8	15.020425
Rf28	VPWR#5	VPWR#9	30.988905
Rf29	VGND#1	VGND#2	108.421173
Rf30	VGND#2	VGND#3	63.562214
Rf31	VGND#3	VGND#4	60.607380
Rf32	VGND#4	VGND#5	67.181923
Rf33	VGND#5	VGND#6	62.774361
Rf35	VGND#2	VGND#8	37.794724
Rf36	VGND#3	VGND#9	32.539131
Rf37	VGND#5	VGND#10	31.948624
Rf38	VGND#6	VGND#11	31.948624
Re1	VPWR#4	VPWR	0.818510
Re2	VGND	VGND#4	0.818540
*
*       CAPACITOR CARDS
*
*
C1	VGND#8	VGND#1	1.95357e-18
C2	VPWR#2	VPWR#1	1.46454e-18
C3	VPWR#3	VPWR#7	1.09018e-17
C4	SUM#1	VGND#8	2.89667e-17
C5	VGND#9	VGND#8	1.27029e-17
C6	VPWR#3	VPWR#8	7.23522e-18
C7	VGND#4	a_27_74##7	2.84961e-21
C8	a_391_388##9	VGND#8	5.34597e-21
C9	a_391_388##8	a_27_74##7	1.44439e-19
C10	a_27_74##12	SUM#2	9.0699e-20
C11	a_278_74#	VGND#9	3.52817e-17
C12	a_391_388##8	a_391_388##2	1.58389e-19
C13	a_27_74##12	VPWR#8	3.14883e-18
C14	VPWR#9	VPWR#3	3.8504e-18
C15	A#4	VPWR#9	1.95039e-19
C16	a_27_74##7	a_27_74##6	3.93596e-18
C17	a_27_74##12	a_391_388##10	1.27141e-16
C18	a_27_74##6	a_391_388##2	2.08006e-19
C19	a_278_74#	a_391_388##9	5.71533e-17
C20	VGND#10	VGND#9	8.00173e-20
C21	VGND#2	a_27_74##5	2.7172e-18
C22	VGND#10	a_278_74#	3.34773e-17
C23	VPWR#6	VPWR#5	1.78525e-18
C24	VGND#1	VPWR#1	1.52758e-18
C25	a_391_388##8	VPWR#8	2.67691e-18
C26	a_27_74##16	A#4	4.01244e-18
C27	VGND#2	a_27_74##10	6.73571e-18
C28	a_391_388##3	a_27_74##7	1.44084e-18
C29	a_391_388##3	a_391_388##2	1.91995e-17
C30	a_27_74##13	a_27_74##16	1.24955e-18
C31	a_278_74##2	a_391_388##9	2.64913e-17
C32	a_391_388##8	a_391_388##10	3.53594e-18
C33	VGND#2	a_391_388#	6.92583e-18
C34	a_278_74##2	VGND#10	3.7412e-17
C35	VGND#3	a_391_388##5	3.72694e-18
C36	VGND#11	VGND#10	1.02189e-17
C37	VGND#2	a_391_388##5	6.17806e-19
C38	VGND#5	B#6	3.674e-18
C39	a_27_74##14	a_278_74##2	7.37908e-18
C40	a_27_74##14	VGND#11	9.90525e-18
C41	B#5	A#4	5.76638e-20
C42	VPWR#5	B#6	8.44655e-20
C43	a_391_388##2	a_27_74##10	1.77149e-18
C44	a_27_74##12	a_391_388##5	9.88465e-20
C45	a_391_388##8	a_27_74##10	4.56293e-20
C46	a_27_74##13	a_27_74##4	9.16294e-19
C47	a_27_74##12	a_27_74##4	1.63624e-19
C48	a_391_388##8	a_391_388#	8.45933e-20
C49	a_27_74##13	B#6	1.5046e-18
C50	A#3	A#4	1.05436e-17
C51	a_391_388##9	a_391_388##10	1.13224e-18
C52	a_27_74##12	B#6	1.97527e-17
C53	a_391_388##8	a_391_388##5	3.50567e-18
C54	VGND#1	a_27_74##5	2.65472e-17
C55	a_27_74##13	A#6	1.1137e-17
C56	a_27_74##5	COUT#2	1.54402e-17
C57	a_391_388##8	a_27_74##4	1.24655e-18
C58	VGND#1	a_27_74##10	1.34033e-18
C59	VGND#8	a_27_74##5	7.06672e-19
C60	VGND#5	VGND#3	2.77386e-19
C61	VPWR#7	VPWR#1	9.85396e-18
C62	a_27_74##13	A#5	1.91176e-17
C63	a_27_74##10	COUT#2	1.49333e-17
C64	a_27_74##7	COUT#2	1.36978e-19
C65	B#2	A#4	3.21973e-17
C66	VGND#1	a_391_388#	2.73732e-19
C67	a_391_388##8	B#6	2.97182e-19
C68	a_27_74##10	VGND#8	1.23343e-17
C69	a_27_74##13	B#3	8.83645e-18
C70	SUM#1	a_27_74##10	5.72461e-18
C71	VGND#8	a_391_388#	2.8747e-17
C72	VGND#3	VGND#2	1.31084e-18
C73	SUM#1	a_391_388#	4.14282e-17
C74	VGND#8	a_391_388##5	2.61876e-18
C75	a_278_74#	a_27_74##10	1.76283e-19
C76	VGND#9	a_391_388#	3.31598e-18
C77	SUM#1	a_391_388##5	3.41357e-17
C78	a_391_388##9	a_27_74##10	2.22676e-19
C79	VPWR#2	a_27_74##8	3.97415e-18
C80	a_278_74#	a_391_388#	2.95511e-19
C81	VGND#9	a_391_388##5	4.46687e-17
C82	a_391_388##9	a_391_388#	2.39161e-19
C83	VPWR#3	a_391_388##4	4.51418e-18
C84	SUM#1	a_27_74##4	9.5468e-19
C85	a_278_74#	a_391_388##5	2.58168e-18
C86	VPWR#2	a_391_388##4	3.97815e-18
C87	VGND#9	a_27_74##4	1.78647e-18
C88	a_27_74##14	VPWR#6	1.51584e-19
C89	a_391_388##9	a_391_388##5	6.64309e-19
C90	a_391_388##10	VPWR#8	1.13398e-18
C91	SUM#1	a_27_74##7	1.66589e-18
C92	VPWR#3	a_391_388##6	2.44711e-17
C93	a_278_74#	a_27_74##4	5.71502e-17
C94	VGND#10	a_391_388##5	4.12873e-20
C95	VGND#9	B#6	5.36896e-20
C96	a_391_388##9	a_27_74##4	3.27696e-17
C97	a_27_74##12	a_391_388##4	1.60698e-19
C98	VPWR#5	a_27_74#	2.97482e-19
C99	a_278_74#	B#6	1.7365e-18
C100	SUM#1	a_391_388##2	2.71613e-18
C101	VPWR#3	a_27_74#	2.34374e-17
C102	VGND#10	a_27_74##4	1.01268e-18
C103	a_391_388##9	B#6	2.52286e-18
C104	a_391_388##8	a_27_74##8	2.00809e-20
C105	a_278_74##2	a_27_74##4	1.26725e-18
C106	a_27_74##12	a_391_388##6	1.58807e-17
C107	a_278_74#	A#6	2.84599e-19
C108	VPWR#5	B#4	9.11219e-18
C109	VGND#10	B#6	3.5764e-17
C110	VPWR#3	B#4	2.6527e-18
C111	a_391_388##9	A#6	6.87433e-19
C112	a_391_388##8	a_391_388##4	1.18792e-19
C113	a_278_74##2	B#6	4.04983e-17
C114	a_278_74#	A#5	1.67888e-19
C115	a_27_74##12	a_27_74#	1.17149e-17
C116	VGND#10	A#6	2.70421e-18
C117	VPWR#5	A#1	8.64587e-18
C118	VGND#11	B#6	4.1923e-18
C119	a_391_388##9	A#5	4.9192e-19
C120	a_278_74##2	A#6	3.12233e-17
C121	VPWR#3	A#1	1.07886e-18
C122	a_391_388##8	a_391_388##6	6.87168e-18
C123	a_278_74#	B#3	1.41227e-19
C124	a_27_74##12	B#4	4.14682e-18
C125	VGND#11	A#6	3.34809e-17
C126	a_391_388##9	B#3	4.52371e-19
C127	VPWR#5	VPWR#3	4.57038e-19
C128	VPWR#5	A#7	4.024e-18
C129	a_278_74##2	A#5	1.69391e-18
C130	a_27_74##14	B#6	4.54499e-19
C131	a_391_388##8	a_27_74#	2.99165e-18
C132	VPWR#3	A#7	2.88259e-19
C133	VPWR#6	VPWR#9	1.07968e-17
C134	VGND#11	A#5	3.08806e-17
C135	a_27_74##14	A#6	9.66104e-19
C136	a_278_74##2	B#3	7.51323e-19
C137	VPWR#5	B#1	1.98391e-18
C138	VGND#11	B#3	4.93533e-18
C139	a_27_74##14	A#5	5.66469e-18
C140	VPWR#3	VPWR#2	1.5262e-18
C141	a_27_74##14	B#3	4.01707e-17
C142	VGND#4	VGND#5	3.74924e-17
C143	VPWR#4	VPWR#5	6.14638e-17
C144	a_27_74##10	a_27_74##5	3.92823e-17
C145	VGND#4	VGND#3	3.66853e-17
C146	VPWR#4	VPWR#3	4.54307e-17
C147	VGND#4	VGND#2	4.26381e-17
C148	VPWR#4	VPWR#2	4.18893e-17
C149	VPWR#1	a_27_74##9	2.89319e-17
C150	a_391_388#	a_27_74##10	3.70848e-17
C151	COUT#1	a_27_74##9	3.72679e-17
C152	a_27_74##12	VPWR#4	9.3595e-18
C153	VGND#2	a_27_74##6	5.87174e-20
C154	VPWR#1	a_27_74##8	4.69354e-18
C155	VPWR#7	a_27_74##9	5.03831e-18
C156	a_27_74##12	VPWR#3	8.25455e-17
C157	COUT#1	a_27_74##8	3.70704e-17
C158	VGND#3	a_391_388##8	3.117e-18
C159	VGND#3	a_391_388##3	1.12684e-18
C160	a_391_388##5	a_391_388#	2.92515e-17
C161	a_27_74##6	VPWR#3	2.24724e-18
C162	VPWR#7	a_27_74##8	3.20363e-17
C163	a_27_74##6	VPWR#2	6.38846e-18
C164	COUT#1	a_391_388##4	7.53337e-19
C165	VPWR#7	a_391_388##4	3.72033e-17
C166	VGND#5	a_27_74##3	4.85438e-20
C167	VGND#3	a_391_388##2	9.30638e-20
C168	VPWR#3	a_391_388##3	1.46076e-18
C169	a_27_74##4	a_391_388##5	4.17704e-18
C170	a_391_388##4	SUM#2	2.58222e-17
C171	VPWR#7	a_391_388##6	4.21265e-18
C172	a_391_388##6	SUM#2	2.58222e-17
C173	B#6	a_27_74##4	3.46099e-18
C174	a_391_388##3	a_27_74##12	1.4757e-17
C175	VGND#2	a_27_74##7	3.53696e-20
C176	a_391_388##6	VPWR#8	2.51079e-17
C177	a_27_74##13	a_27_74##12	1.22822e-18
C178	VGND#4	VGND#1	2.53487e-17
C179	a_27_74##13	a_27_74##3	7.29282e-20
C180	VPWR#5	B#5	2.6771e-20
C181	a_27_74#	VPWR#8	3.08675e-17
C182	VGND#5	A#3	3.18035e-20
C183	a_27_74##12	a_27_74##3	3.76253e-17
C184	A#6	B#6	4.29576e-17
C185	a_391_388##8	a_391_388##3	1.56935e-17
C186	VGND#2	a_391_388##2	2.84666e-19
C187	a_391_388##10	a_27_74#	6.39802e-17
C188	a_27_74##6	VGND#1	4.49213e-17
C189	a_27_74##13	B#5	2.16374e-19
C190	a_27_74##6	COUT#2	5.4791e-20
C191	B#4	a_391_388##10	3.64267e-17
C192	B	A#4	3.22973e-19
C193	VPWR#9	a_27_74#	1.4549e-18
C194	a_27_74##12	B#5	1.03451e-16
C195	A#5	A#6	4.17657e-17
C196	a_391_388##8	a_27_74##3	6.01971e-18
C197	VGND#8	a_27_74##6	1.25125e-18
C198	VGND#4	a_278_74#	5.67463e-17
C199	VPWR#9	B#4	5.29003e-18
C200	a_27_74##13	A#3	6.35878e-17
C201	a_391_388##8	B#5	7.44739e-19
C202	a_27_74##16	B#4	7.7102e-19
C203	B#3	A#5	5.22721e-17
C204	a_27_74##12	A#3	3.91422e-19
C205	VPWR#9	A#1	3.59653e-17
C206	a_391_388##3	SUM#1	4.62673e-17
C207	a_391_388##3	VGND#9	2.26522e-17
C208	VPWR#4	VPWR#1	2.70905e-17
C209	a_27_74##16	A#1	2.18385e-18
C210	B#2	a_27_74##13	3.42737e-17
C211	VPWR#9	A#7	3.96685e-17
C212	COUT	a_27_74##7	4.10337e-18
C213	VPWR#6	A#1	6.83704e-19
C214	COUT	a_391_388##2	1.64221e-18
C215	a_391_388##4	a_27_74##7	1.81895e-18
C216	a_27_74##16	A#7	3.37005e-17
C217	VGND#2	VGND#1	1.25309e-18
C218	VGND#11	A#4	1.14143e-18
C219	VPWR#9	B#1	5.00485e-18
C220	VPWR#6	A#7	4.3819e-18
C221	a_278_74#	a_27_74##3	1.2642e-18
C222	a_27_74##16	B#1	3.13829e-17
C223	a_391_388##9	a_27_74##3	6.83278e-18
C224	a_27_74##6	VPWR#1	5.2075e-17
C225	VPWR#6	B#1	2.95567e-17
C226	COUT#1	a_27_74##6	9.87138e-17
C227	a_278_74##2	a_27_74##3	1.17622e-18
C228	a_27_74##12	a_391_388##8	5.38685e-17
C229	a_27_74##6	VPWR#7	4.41494e-17
C230	a_27_74##8	a_27_74##9	5.01465e-17
C231	a_27_74##6	SUM#2	3.99614e-18
C232	VGND#10	B#5	7.08324e-19
C233	a_27_74##6	VPWR#8	1.29668e-20
C234	a_278_74##2	B#5	7.27601e-19
C235	SUM	a_27_74##7	5.86043e-18
C236	SUM	a_391_388##2	7.99817e-18
C237	VPWR#4	VPWR#6	2.68297e-17
C238	a_391_388##4	a_27_74##8	4.803e-17
C239	VGND#3	SUM#1	2.53968e-18
C240	a_278_74##2	A#3	4.2142e-19
C241	VGND#11	A#3	4.57427e-19
C242	a_391_388##6	a_391_388##4	5.23229e-17
C243	VGND#2	SUM#1	2.09189e-18
C244	a_391_388##10	a_27_74##3	4.0615e-18
C245	VGND#5	a_278_74#	1.423e-17
C246	a_27_74#	a_391_388##6	9.13199e-18
C247	B#2	a_27_74##14	4.65403e-17
C248	B#5	a_391_388##10	2.13615e-18
C249	VGND#4	a_27_74##4	4.43427e-18
C250	VGND#9	VGND#2	6.42628e-20
C251	a_27_74##13	a_114_74#	3.09316e-18
C252	VGND#3	a_278_74#	6.09369e-18
C253	B#4	a_27_74#	5.66315e-18
C254	a_27_74##16	B#5	6.56812e-18
C255	VPWR#2	a_27_74##7	5.81313e-20
C256	A#3	VPWR#9	1.08548e-18
C257	a_27_74##4	a_391_388##3	2.09216e-19
C258	a_27_74##16	A#3	1.4121e-17
C259	A#1	B#4	5.1986e-17
C260	B#6	a_27_74##3	3.99652e-18
C261	B#2	a_27_74##16	1.10171e-17
C262	VPWR#2	a_391_388##2	5.39028e-20
C263	B#2	VPWR#6	1.42393e-18
C264	A#7	A#1	3.94354e-17
C265	a_27_74##6	a_27_74##9	2.22479e-17
C266	VGND	a_391_388##2	2.96658e-19
C267	a_27_74##6	a_27_74##8	1.28441e-17
C268	VPWR#4	a_27_74#	4.11646e-18
C269	a_278_74#	a_114_74#	3.25135e-21
C270	VGND#10	VGND#3	2.83938e-20
C271	a_27_74##6	a_391_388##4	1.61802e-17
C272	B#1	A#7	4.73955e-17
C273	A#3	B#6	7.38905e-18
C274	COUT#1	a_27_74##7	8.9156e-18
C275	VGND#5	a_278_74##2	2.73104e-18
C276	B	VPWR#5	1.08553e-17
C277	a_27_74##6	a_391_388##6	1.1517e-17
C278	a_278_74##2	a_114_74#	8.34042e-21
C279	a_27_74##13	B	5.13248e-18
C280	a_27_74##12	B	4.15338e-17
C281	COUT#1	a_391_388##2	5.8838e-19
C282	B#2	A#5	2.63553e-18
C283	a_27_74##3	a_391_388##6	1.43071e-18
C284	VGND#2	COUT	1.67763e-17
C285	B#5	a_27_74#	1.26054e-18
C286	a_27_74##7	VNB	2.4117e-17
C287	a_391_388##2	VNB	2.80728e-17
C288	B#5	B#4	5.82248e-18
C289	A#4	VNB	2.72958e-17
C290	A#1	B#5	3.41989e-18
C291	B#5	A#7	6.47856e-19
C292	VGND#4	a_27_74##6	1.13984e-21
C293	COUT	VGND#1	6.35451e-17
C294	COUT	COUT#2	2.15857e-19
C295	A#7	A#3	1.55068e-19
C296	VGND#8	COUT	3.69803e-17
C297	VPWR#4	a_27_74##3	4.42211e-19
C298	SUM#1	COUT	3.11147e-17
C299	a_27_74##14	B	5.45799e-20
C300	a_391_388##8	SUM	1.67014e-17
C301	a_278_74#	COUT	1.51469e-18
C302	a_391_388##3	a_27_74##6	1.18888e-18
C303	VGND#4	a_27_74##3	1.19797e-19
C304	B#2	A#7	5.99746e-19
C305	VPWR#4	B#5	3.82726e-20
C306	B#2	B#1	5.12364e-18
C307	A#5	a_114_74#	1.63029e-17
C308	VPWR	VPWR#5	6.383e-17
C309	B	VPWR#8	4.11709e-19
C310	B#4	a_307_388#	2.04991e-17
C311	VPWR	VPWR#3	6.74183e-17
C312	VPWR	VPWR#2	2.99681e-17
C313	B#3	a_114_74#	1.70186e-17
C314	B	a_391_388##10	7.78808e-18
C315	a_27_74##3	a_391_388##3	2.46509e-17
C316	A#1	a_307_388#	1.29519e-17
C317	SUM#1	SUM	1.91746e-18
C318	VPWR	a_27_74##12	2.45617e-17
C319	B	VPWR#9	4.48556e-17
C320	COUT	COUT#1	1.95813e-18
C321	B	a_27_74##16	5.22333e-17
C322	B	VPWR#6	4.35096e-17
C323	VPWR	a_391_388##8	1.96438e-18
C324	B#5	a_27_74##3	2.09521e-17
C325	a_278_74#	a_27_74##12	2.80771e-18
C326	VGND	VGND#5	2.21679e-17
C327	VGND	VGND#3	2.54043e-17
C328	VGND	VGND#2	4.05674e-17
C329	SUM	COUT#1	5.9799e-17
C330	SUM	VPWR#7	1.57276e-19
C331	A#3	B#5	4.73177e-17
C332	B	B#6	1.91393e-18
C333	COUT	a_27_74##5	2.79596e-17
C334	VGND	a_27_74##13	9.33208e-18
C335	SUM	SUM#2	2.28602e-19
C336	VGND	a_27_74##12	9.75057e-18
C337	COUT	a_27_74##10	2.42902e-17
C338	COUT	a_391_388#	3.17878e-18
C339	VGND	a_391_388##8	6.81563e-18
C340	COUT	a_391_388##5	7.85528e-19
C341	COUT	a_27_74##4	4.48525e-19
C342	B#2	A#3	2.89942e-18
C343	a_27_74##12	a_391_388##9	4.65644e-17
C344	VPWR	VPWR#1	3.53546e-17
C345	VGND	VGND#1	3.45827e-17
C346	VPWR	COUT#1	2.86804e-18
C347	VPWR	VPWR#7	1.60247e-17
C348	VGND#5	VNB	3.0206e-17
C349	VGND	SUM#1	1.04293e-17
C350	VGND#3	VNB	3.07776e-17
C351	VGND	VGND#9	1.81943e-17
C352	VGND#2	VNB	3.46018e-17
C353	a_391_388##8	SUM#1	9.41417e-18
C354	VGND	a_278_74#	3.57658e-17
C355	VPWR	a_391_388##10	4.14535e-18
C356	B	a_391_388##6	2.53352e-19
C357	VPWR#5	VNB	5.24315e-17
C358	VGND	a_391_388##9	6.32956e-18
C359	VPWR#3	VNB	3.83693e-17
C360	VGND	VGND#10	1.5896e-17
C361	B	a_27_74#	2.24154e-18
C362	VPWR#2	VNB	3.5193e-17
C363	VGND	a_278_74##2	1.06179e-17
C364	a_27_74##13	A#4	1.57828e-17
C365	a_27_74##13	VNB	3.95941e-18
C366	VPWR	a_27_74##16	2.3969e-18
C367	VGND	VGND#11	1.58081e-17
C368	B	B#4	1.67975e-17
C369	a_27_74##12	VNB	2.03503e-17
C370	VPWR	VPWR#6	3.56061e-17
C371	VGND	a_27_74##14	1.66077e-17
C372	B	A#1	2.90271e-17
C373	a_391_388##8	VNB	1.25447e-17
C374	VGND	COUT#1	8.6443e-19
C375	B	A#7	2.66906e-17
C376	B	B#1	1.9373e-17
C377	VGND#1	VNB	6.75705e-17
C378	a_27_74##12	VGND#10	9.21153e-19
C379	VGND	a_391_388##10	3.80368e-18
C380	SUM	a_27_74##8	7.16017e-18
C381	VGND#8	VNB	3.55486e-19
C382	SUM#1	VNB	3.03721e-18
C383	SUM	a_391_388##4	2.34937e-17
C384	B	VPWR#4	1.57415e-18
C385	VGND#9	VNB	4.58669e-18
C386	a_278_74#	VNB	1.88081e-17
C387	SUM	a_391_388##6	1.12e-17
C388	a_391_388##9	VNB	2.21099e-20
C389	a_278_74##2	a_27_74##13	2.55318e-17
C390	VGND#10	VNB	3.35533e-18
C391	SUM	a_27_74#	2.46924e-18
C392	VGND	a_27_74##5	1.81155e-18
C393	a_278_74##2	VNB	8.38055e-18
C394	VGND#9	a_391_388##8	2.27427e-18
C395	VGND#11	VNB	8.24376e-20
C396	VGND	a_27_74##10	4.96676e-18
C397	VPWR	a_27_74##9	2.89795e-19
C398	VGND	a_391_388#	3.65821e-19
C399	a_27_74##14	VNB	4.02732e-17
C400	VGND	a_391_388##5	2.78304e-19
C401	VPWR	a_27_74##8	2.98464e-19
C402	VPWR#1	VNB	4.68292e-17
C403	COUT#1	VNB	8.62223e-19
C404	VGND	a_27_74##4	1.86566e-18
C405	VPWR	a_391_388##4	3.67169e-19
C406	VGND	B#6	1.06352e-18
C407	VPWR	a_391_388##6	3.96341e-19
C408	VGND	A#6	4.66604e-19
C409	COUT	a_27_74##6	1.72892e-17
C410	VPWR	a_27_74#	4.2946e-18
C411	a_391_388##10	VNB	4.27334e-18
C412	VGND	A#5	8.27432e-19
C413	VGND	B#3	1.77655e-18
C414	VPWR	B#4	9.62881e-18
C415	A#3	B	1.18155e-17
C416	a_27_74##16	VNB	4.11178e-19
C417	VPWR	A#1	4.04416e-18
C418	VPWR#6	VNB	4.60518e-17
C419	VPWR	A#7	4.19607e-18
C420	a_27_74##5	VNB	3.29449e-17
C421	B#2	B	5.91329e-18
C422	a_27_74##10	VNB	2.84901e-17
C423	SUM	a_27_74##6	7.20293e-17
C424	VPWR	B#1	4.2082e-18
C425	a_391_388#	VNB	2.35594e-17
C426	a_391_388##5	VNB	2.89102e-17
C427	a_391_388##3	SUM	4.72609e-17
C428	a_278_74##2	a_27_74##12	7.24695e-17
C429	a_27_74##4	VNB	3.6902e-17
C430	VPWR	VPWR#4	2.51131e-17
C431	B#6	VNB	3.5779e-17
C432	SUM	a_27_74##3	1.79531e-19
C433	B	a_307_388#	5.50534e-18
C434	A#6	VNB	2.49316e-17
C435	A#5	VNB	2.49333e-17
C436	B#3	VNB	3.19328e-17
C437	VPWR	a_27_74##6	2.12257e-17
C438	VGND#11	a_27_74##13	1.60205e-17
C439	a_391_388##8	a_278_74#	2.08243e-17
C440	VPWR	a_391_388##3	5.04646e-18
C441	a_27_74##9	VNB	3.42818e-17
C442	a_27_74##8	VNB	2.94579e-17
C443	a_391_388##4	VNB	3.25477e-17
C444	a_391_388##6	VNB	3.63886e-17
C445	VPWR	B#5	8.14935e-23
C446	VGND	VGND#4	1.3951e-17
C447	a_27_74#	VNB	4.24748e-17
C448	VPWR	A#3	3.25393e-18
C449	B#4	VNB	2.95368e-17
C450	VGND	a_27_74##6	5.45695e-18
C451	A#1	VNB	3.28092e-17
C452	VGND	a_391_388##3	6.40754e-18
C453	VPWR	B#2	1.75442e-18
C454	A#7	VNB	2.92822e-17
C455	VGND	a_27_74##3	3.98675e-19
C456	B#1	A#4	5.40098e-18
C457	B#1	VNB	4.35056e-17
C458	VGND	B#5	2.94601e-18
C459	VPWR#4	VNB	2.64746e-16
C460	VGND	A#3	1.96837e-18
C461	VGND#4	VNB	2.59e-16
C462	VGND	B#2	3.93717e-18
C463	a_27_74##6	VNB	9.53595e-17
C464	a_391_388##3	VNB	5.99236e-17
C465	a_27_74##3	VNB	6.45864e-17
C466	B#5	VNB	3.38221e-17
C467	A#3	VNB	3.77101e-17
C468	B#2	VNB	8.12402e-17
C469	SUM	COUT	4.23574e-18
C470	VPWR	B	3.00703e-17
C471	a_391_388##2	a_27_74##7	2.48272e-17
C472	VPWR	SUM	6.01383e-18
C473	VGND	COUT	1.55186e-17
C474	B	VNB	2.49227e-17
C475	VGND	SUM	2.60092e-18
C476	COUT	VNB	4.21732e-18
C477	SUM	VNB	6.9965e-18
C478	VPWR	VNB	5.88734e-17
C479	VGND	VNB	6.80018e-17
C480	VGND#6	A#6	3.6723e-18
C481	VGND#4	VGND#6	6.54039e-17
C482	VGND#6	B#3	6.6764e-18
C483	VGND#6	a_278_74##2	2.77523e-18
C484	VGND#6	VGND#5	1.35859e-18
C485	VGND#6	VNB	5.8445e-17
C486	VGND#6	B#2	1.59163e-19
C487	VGND#6	a_27_74##13	3.10679e-18
C488	VGND#6	A#5	4.34507e-18
C489	VGND	VGND#6	4.31323e-17
C490	VGND#6	A#3	2.70668e-20
C491	VGND#6	a_27_74##14	2.13015e-17
*
*
.ENDS sky130_fd_sc_hs__ha_2
*
