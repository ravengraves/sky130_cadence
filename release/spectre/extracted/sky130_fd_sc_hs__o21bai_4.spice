* Extracted by Quantus, converted by sky130cad/quantus.py
*
*
*
*                       LINUX           Wed Nov 18 08:56:57 2026
*
*
*
*  PROGRAM  advgen
*
*  Name           : advgen - Quantus - (64-bit)
*  Version        : 25.1.0-p047
*  Build Date     : Thu Dec 11 23:20:30 PST 2025
*
*  HSPICE LIBRARY
*
*  OPERATING_TEMPERATURE 150
*  QRC_TECH_DIR <path>/tech
*
*
*

*
.SUBCKT sky130_fd_sc_hs__o21bai_4 VNB VPB VGND VPWR Y A1 A2 B1_N
*
*
*  caps2d version: 10
*
*
*       TRANSISTOR CARDS
*
*
XM11 VGND#11 A1#10 a_27_74##12 VNB sky130_fd_pr__nfet_01v8_lvt l=0.15 w=0.74 ad=0.2442 as=0.2109 pd=2.14 ps=2.05
XM23 a_27_74##11 A1#8 VGND#11 VNB sky130_fd_pr__nfet_01v8_lvt l=0.15 w=0.74 ad=0.2072 as=0.2442 pd=2.04 ps=2.14
XM5 a_27_74##11 A1#6 VGND#10 VNB sky130_fd_pr__nfet_01v8_lvt l=0.15 w=0.74 ad=0.2072 as=0.2072 pd=2.04 ps=2.04
XM6 VGND#10 A1#5 a_27_74##9 VNB sky130_fd_pr__nfet_01v8_lvt l=0.15 w=0.74 ad=0.2072 as=0.2072 pd=2.04 ps=2.04
XM7 a_27_74##9 A2#6 VGND#9 VNB sky130_fd_pr__nfet_01v8_lvt l=0.15 w=0.74 ad=0.2072 as=0.2072 pd=2.04 ps=2.04
XM16 VGND#9 A2#10 a_27_74##6 VNB sky130_fd_pr__nfet_01v8_lvt l=0.15 w=0.74 ad=0.2072 as=0.2072 pd=2.04 ps=2.04
XM18 VGND#8 A2#8 a_27_74##6 VNB sky130_fd_pr__nfet_01v8_lvt l=0.15 w=0.74 ad=0.3778 as=0.2072 pd=2.72 ps=2.04
XM22 a_27_74##3 A2#1 VGND#8 VNB sky130_fd_pr__nfet_01v8_lvt l=0.15 w=0.74 ad=0.259 as=0.3778 pd=2.18 ps=2.72
XM9 a_27_74##3 a_828_48##10 Y#8 VNB sky130_fd_pr__nfet_01v8_lvt l=0.15 w=0.74 ad=0.259 as=0.2072 pd=2.18 ps=2.04
XM14 Y#8 a_828_48##8 a_27_74##5 VNB sky130_fd_pr__nfet_01v8_lvt l=0.15 w=0.74 ad=0.2072 as=0.259 pd=2.04 ps=2.18
XM19 Y#10 a_828_48##5 a_27_74##5 VNB sky130_fd_pr__nfet_01v8_lvt l=0.15 w=0.74 ad=0.259 as=0.259 pd=2.18 ps=2.18
XM20 a_27_74# a_828_48# Y#10 VNB sky130_fd_pr__nfet_01v8_lvt l=0.15 w=0.74 ad=0.2627 as=0.259 pd=2.19 ps=2.18
XM15 a_828_48##11 B1_N#1 VGND#1 VNB sky130_fd_pr__nfet_01v8_lvt l=0.15 w=0.74 ad=0.2109 as=0.2109 pd=2.05 ps=2.05
XM10 VPWR#12 A1#12 a_28_368##6 VPB sky130_fd_pr__pfet_01v8 l=0.15 w=1.12 ad=0.336 as=0.3304 pd=2.84 ps=2.83
XM24 a_28_368##8 A1#11 VPWR#12 VPB sky130_fd_pr__pfet_01v8 l=0.15 w=1.12 ad=0.336 as=0.336 pd=2.84 ps=2.84
XM12 VPWR#11 A1#7 a_28_368##8 VPB sky130_fd_pr__pfet_01v8 l=0.15 w=1.12 ad=0.336 as=0.336 pd=2.84 ps=2.84
XM21 a_28_368##3 A1#1 VPWR#11 VPB sky130_fd_pr__pfet_01v8 l=0.15 w=1.12 ad=0.336 as=0.336 pd=2.84 ps=2.84
XM1 a_28_368##3 A2#12 Y#5 VPB sky130_fd_pr__pfet_01v8 l=0.15 w=1.12 ad=0.336 as=0.336 pd=2.84 ps=2.84
XM3 a_28_368##7 A2#11 Y#5 VPB sky130_fd_pr__pfet_01v8 l=0.15 w=1.12 ad=0.336 as=0.336 pd=2.84 ps=2.84
XM8 Y#9 A2#9 a_28_368##7 VPB sky130_fd_pr__pfet_01v8 l=0.15 w=1.12 ad=0.392 as=0.336 pd=2.94 ps=2.84
XM17 Y#9 A2#7 a_28_368# VPB sky130_fd_pr__pfet_01v8 l=0.15 w=1.12 ad=0.392 as=0.3864 pd=2.94 ps=2.93
XM2 Y#6 a_828_48##9 VPWR#10 VPB sky130_fd_pr__pfet_01v8 l=0.15 w=1.12 ad=0.3304 as=0.3528 pd=2.83 ps=2.87
XM4 VPWR#10 a_828_48##4 Y#1 VPB sky130_fd_pr__pfet_01v8 l=0.15 w=1.12 ad=0.3528 as=0.3304 pd=2.87 ps=2.83
XM0 VPWR#9 B1_N#3 a_828_48##14 VPB sky130_fd_pr__pfet_01v8 l=0.15 w=0.84 ad=0.2478 as=0.252 pd=2.27 ps=2.28
XM13 a_828_48##14 B1_N#4 VPWR#1 VPB sky130_fd_pr__pfet_01v8 l=0.15 w=0.84 ad=0.252 as=0.2478 pd=2.28 ps=2.27
*
*
*       RESISTOR AND CAP/DIODE CARDS
*
Rg1	A1#1	A1#2	503.850128
Rg2	A1#2	A1#3	177.452377
Rg3	A1#3	A1#4	84.618660
Rg4	A1#2	A1#5	373.313751
Rg5	A1#3	A1#6	415.274414
Rg6	A1#3	A1#7	429.620972
Rg7	A1#4	A1#8	380.313354
Rg8	A1#4	A1#9	64.081955
Rg9	A1#9	A1#10	397.555725
Rg10	A1#4	A1#11	429.126801
Rg11	A1#9	A1#12	449.655212
Rg12	A2#1	A2#2	451.838898
Rg13	A2#2	A2#3	91.687035
Rg14	A2#3	A2#4	66.484207
Rg15	A2#4	A2#5	158.054306
Rg16	A2#5	A2#6	370.950104
Rg17	A2#2	A2#7	503.938385
Rg18	A2#3	A2#8	376.234039
Rg19	A2#3	A2#9	428.333527
Rg20	A2#4	A2#10	453.979462
Rg21	A2#4	A2#11	468.326019
Rg22	A2#5	A2#12	504.425171
Rg23	a_828_48#	a_828_48##2	445.804535
Rg24	a_828_48##2	a_828_48##3	30.241665
Rg25	a_828_48##2	a_828_48##4	419.554810
Rg26	a_828_48##3	a_828_48##5	419.137726
Rg27	a_828_48##3	a_828_48##6	50.316681
Rg28	a_828_48##6	a_828_48##7	22.529716
Rg29	a_828_48##7	a_828_48##8	381.948395
Rg30	a_828_48##6	a_828_48##9	419.554810
Rg31	a_828_48##7	a_828_48##10	458.118439
Rg32	B1_N#1	B1_N#2	372.453491
Rg33	B1_N#2	B1_N#3	486.966278
Rg34	B1_N#2	B1_N#4	450.433960
Rf1	A1	A1#13	8.404075
Rf2	A1#13	A1	6.264856
Rf3	A2	A2#13	14.516130
Rf4	A2#13	A2	0.152801
Rf5	a_28_368#	a_28_368##2	89.094078
Rf6	a_28_368##2	a_28_368##4	104.057144
Rf7	a_28_368##4	a_28_368##5	91.518852
Rf8	a_28_368##5	a_28_368##6	85.383591
Rf9	a_28_368##2	a_28_368##7	18.149860
Rf10	a_28_368##5	a_28_368##8	20.631947
Rf11	a_28_368##3	a_28_368##4	5.000000
Rf12	Y#1	Y#2	83.464752
Rf13	Y#2	Y#3	33.727058
Rf14	Y#3	Y#4	43.489880
Rf15	Y#4	Y#5	88.133362
Rf16	Y#2	Y#6	16.634041
Rf17	Y#3	Y	15.791745
Rf18	Y	Y#7	31.240978
Rf19	Y#7	Y#8	22.500479
Rf20	Y#4	Y#9	14.705224
Rf21	Y#7	Y#10	90.735825
Rf22	a_27_74#	a_27_74##2	87.125717
Rf23	a_27_74##2	a_27_74##4	76.523178
Rf24	a_27_74##2	a_27_74##5	23.287825
Rf25	a_27_74##4	a_27_74##7	73.977898
Rf26	a_27_74##7	a_27_74##8	78.714645
Rf27	a_27_74##8	a_27_74##9	28.306047
Rf28	a_27_74##8	a_27_74##10	63.019512
Rf29	a_27_74##10	a_27_74##11	28.306047
Rf30	a_27_74##10	a_27_74##12	89.810654
Rf31	a_27_74##3	a_27_74##4	15.000000
Rf32	a_27_74##6	a_27_74##7	7.500000
Rf33	a_828_48##11	a_828_48##12	77.691948
Rf34	a_828_48##12	a_828_48##3	69.604355
Rf35	a_828_48##12	a_828_48##14	101.364975
Rf36	B1_N	B1_N#5	16.927925
Rf37	B1_N#5	B1_N	1.968364
Rf38	VPWR#1	VPWR#2	38.740540
Rf39	VPWR#2	VPWR#3	73.119835
Rf40	VPWR#3	VPWR#4	72.085594
Rf41	VPWR#4	VPWR#5	119.535606
Rf42	VPWR#5	VPWR#6	125.987572
Rf43	VPWR#6	VPWR#7	68.675751
Rf45	VPWR#3	VPWR#9	38.736572
Rf46	VPWR#4	VPWR#10	56.795742
Rf47	VPWR#6	VPWR#11	31.534731
Rf48	VPWR#7	VPWR#12	38.736572
Rf49	VGND#1	VGND#2	42.677269
Rf50	VGND#2	VGND#3	266.122955
Rf51	VGND#3	VGND#4	65.026932
Rf52	VGND#4	VGND#5	62.774361
Rf53	VGND#5	VGND#6	66.426888
Rf55	VGND#3	VGND#8	28.360416
Rf56	VGND#4	VGND#9	38.247387
Rf57	VGND#5	VGND#10	38.247387
Rf58	VGND#6	VGND#11	38.247387
Rf62	B1_N#2	B1_N#5	160.232803
Rf59	A1#4	A1#13	53.410934
Rf60	A2#3	A2#13	53.410934
Re1	VPWR#2	VPWR	11.068454
Re2	VPWR	VPWR#5	0.790604
Re3	VGND#2	VGND	11.068454
Re4	VGND	VGND#3	0.790604
*
*       CAPACITOR CARDS
*
*
C1	a_828_48##12	a_828_48##10	1.37466e-19
C2	Y#7	a_828_48#	3.2711e-19
C3	a_27_74##8	A1#3	5.43052e-20
C4	VGND#4	A2#6	5.32103e-18
C5	a_28_368##6	a_28_368##5	1.01481e-18
C6	a_27_74##2	a_828_48##5	3.14403e-17
C7	a_27_74##3	Y#9	1.2013e-18
C8	VGND#5	A1#5	5.48621e-18
C9	Y#7	a_828_48##5	1.36652e-18
C10	a_27_74##8	A1#2	1.00465e-18
C11	VGND#4	A1#5	6.3656e-19
C12	Y#7	a_828_48##7	6.83932e-18
C13	a_27_74##2	a_828_48##8	2.19316e-17
C14	a_28_368##2	VPWR#6	1.69954e-17
C15	Y#7	a_828_48##8	3.09047e-17
C16	VGND#5	A1#6	5.34211e-18
C17	A2#2	a_828_48##10	1.87463e-17
C18	a_828_48##14	VPWR#1	6.69958e-17
C19	a_27_74##2	a_828_48##10	4.60354e-19
C20	VGND#10	A1#3	4.27257e-19
C21	VPWR#9	VPWR#1	2.35578e-18
C22	Y#7	a_828_48##10	2.39228e-17
C23	a_27_74##8	A2#8	3.90164e-20
C24	VGND#5	A1#8	6.53982e-19
C25	Y#3	a_828_48##12	3.83315e-19
C26	VGND#10	A1#2	3.49295e-19
C27	a_27_74##2	A2#1	2.01668e-19
C28	a_828_48##14	VPWR#9	5.84079e-17
C29	VGND#1	B1_N#1	3.59991e-17
C30	Y#7	A2#1	4.81687e-18
C31	VGND#2	a_828_48##7	5.78334e-20
C32	Y#3	a_828_48##10	6.90904e-19
C33	a_27_74##8	A2#10	9.24914e-20
C34	Y#1	a_828_48##14	2.63578e-18
C35	VGND#5	A1#10	2.94194e-19
C36	Y#2	a_828_48##10	6.06303e-19
C37	B1_N#1	a_828_48##11	2.49902e-17
C38	a_27_74##10	A2#6	3.90164e-20
C39	VGND#1	a_828_48#	1.75679e-18
C40	Y#1	VPWR#9	5.10824e-17
C41	Y#7	A2#8	1.10013e-18
C42	a_27_74#	B1_N#1	2.97859e-18
C43	a_27_74##8	A2#6	2.06088e-17
C44	a_828_48##11	a_828_48#	1.58708e-18
C45	Y#10	B1_N#1	6.17278e-19
C46	VPWR#10	VPWR#9	1.99722e-18
C47	a_27_74##10	A1#5	1.63871e-19
C48	a_27_74#	a_828_48#	4.26999e-17
C49	VGND#11	A1#9	3.10091e-19
C50	Y#7	A2#10	6.23275e-20
C51	a_27_74##2	Y#7	5.59207e-17
C52	a_27_74##8	A1#5	1.94338e-17
C53	Y#1	VPWR#10	5.54691e-17
C54	A1#3	A1#2	8.3639e-18
C55	Y#10	a_828_48#	3.99625e-17
C56	VPWR#5	A2#5	1.23625e-21
C57	a_27_74##10	A1#6	1.70521e-17
C58	a_27_74#	a_828_48##5	4.24687e-19
C59	Y#7	A2#6	3.99942e-20
C60	Y#6	Y#1	1.44813e-19
C61	VPWR#5	A2#4	5.09954e-21
C62	VPWR#5	A2#2	1.48383e-20
C63	a_27_74##8	A1#6	9.24914e-20
C64	Y#10	a_828_48##5	3.20583e-17
C65	Y#6	VPWR#10	5.76466e-17
C66	Y#2	a_828_48##7	1.05743e-17
C67	a_27_74##10	A1#8	2.27847e-17
C68	a_828_48##5	a_27_74##5	1.66135e-17
C69	a_27_74##12	A1#9	1.79381e-19
C70	Y#10	a_828_48##8	4.24687e-19
C71	a_27_74##8	A1#8	3.90164e-20
C72	VGND#3	a_828_48##7	8.62074e-20
C73	a_28_368#	VPWR#10	2.68207e-18
C74	VGND#8	a_828_48#	4.46743e-20
C75	a_828_48##8	a_27_74##5	7.52576e-18
C76	a_27_74##10	A1#10	1.71832e-19
C77	a_27_74##3	a_828_48##5	2.01668e-19
C78	a_28_368#	Y#6	5.27291e-17
C79	VPWR#3	B1_N#4	5.39717e-19
C80	Y#7	Y#3	4.7779e-19
C81	a_828_48##8	Y#8	1.44708e-17
C82	VGND#8	a_828_48##5	6.66502e-20
C83	Y#9	Y#6	2.6159e-18
C84	a_27_74##3	a_828_48##8	4.60354e-19
C85	VPWR#4	B1_N#3	2.68042e-19
C86	a_828_48##10	Y#8	1.44708e-17
C87	Y#7	Y#2	1.85161e-18
C88	VPWR#3	B1_N#3	5.65228e-18
C89	VGND#8	a_828_48##8	1.86568e-19
C90	a_28_368#	Y#9	5.59369e-17
C91	a_828_48##7	B1_N#2	1.34476e-19
C92	a_27_74##3	a_828_48##10	2.85868e-17
C93	VGND#4	VGND#8	1.91775e-18
C94	VPWR#4	a_828_48##4	7.59766e-18
C95	a_27_74##12	a_28_368##6	1.6024e-19
C96	a_28_368##7	a_28_368#	4.30643e-18
C97	VGND#8	a_828_48##10	4.4773e-19
C98	VPWR#3	a_828_48##4	8.11617e-19
C99	a_27_74##3	A2#1	5.66148e-17
C100	a_27_74##6	a_828_48##10	6.37147e-19
C101	Y#9	a_28_368##7	6.27243e-17
C102	A2#1	VGND#8	2.4033e-17
C103	VGND#4	a_27_74##6	7.51645e-18
C104	Y#3	Y#2	2.91336e-18
C105	VPWR#4	a_828_48##9	5.39781e-18
C106	a_27_74##3	A2#8	9.22072e-19
C107	Y#5	Y#9	2.3755e-18
C108	Y#1	a_828_48##7	3.51886e-18
C109	a_28_368##3	a_28_368#	3.61483e-21
C110	a_27_74##6	A2#1	2.77074e-18
C111	VPWR#3	a_828_48##9	7.9813e-20
C112	a_828_48##3	a_828_48##7	4.68524e-17
C113	A2#8	VGND#8	2.53736e-17
C114	a_828_48##12	a_828_48##4	2.51988e-18
C115	Y#5	a_28_368##7	4.3912e-17
C116	a_27_74#	a_828_48##12	3.2046e-17
C117	VGND#9	A2#1	1.20934e-19
C118	VPWR#4	A2#7	3.10302e-19
C119	a_27_74##6	A2#8	5.93845e-17
C120	a_28_368##3	a_28_368##7	4.19053e-18
C121	VGND#8	A2#10	9.9183e-19
C122	VGND#5	a_27_74##9	5.24871e-18
C123	VGND#9	A2#8	1.22921e-18
C124	a_828_48##12	a_828_48##9	2.58061e-19
C125	Y#10	a_828_48##12	9.53725e-18
C126	a_27_74##6	A2#10	2.8345e-17
C127	a_28_368##3	Y#5	6.21044e-17
C128	a_27_74##9	A2#8	1.28671e-19
C129	VPWR#4	A2#9	5.87561e-20
C130	VGND#4	a_27_74##9	5.19931e-18
C131	VPWR#10	a_828_48##7	1.24008e-18
C132	VGND#9	A2#10	3.03564e-17
C133	Y#1	a_828_48#	2.73328e-18
C134	a_27_74##6	A2#6	8.48022e-19
C135	a_828_48##12	A2#7	1.27558e-19
C136	a_27_74##9	A2#10	3.05025e-19
C137	VGND#9	A2#6	2.81866e-17
C138	a_28_368##3	VPWR#11	6.57274e-17
C139	A2#4	A2#3	4.0818e-18
C140	VPWR#4	A2#11	3.8051e-20
C141	A2#3	A2#2	2.76755e-18
C142	a_27_74##6	A1#5	1.87602e-19
C143	a_28_368##5	A1#9	4.16739e-19
C144	Y#3	a_828_48##4	1.12594e-19
C145	A2#6	a_27_74##9	1.38198e-17
C146	a_28_368##8	a_28_368##3	1.25897e-18
C147	VGND#5	a_27_74##11	6.4343e-18
C148	VGND#9	A1#5	1.21722e-18
C149	Y#2	a_828_48##4	7.75448e-19
C150	VGND#10	A2#6	1.21722e-18
C151	VPWR#6	A2#12	4.461e-18
C152	A1#5	a_27_74##9	1.72195e-17
C153	a_28_368##8	VPWR#11	5.30395e-17
C154	a_28_368##5	A1#3	1.34485e-18
C155	a_27_74##11	A2#6	1.28671e-19
C156	Y#3	a_828_48##9	4.19636e-19
C157	VGND#10	A1#5	3.27157e-17
C158	a_28_368##2	A2#5	6.55021e-20
C159	Y#2	a_828_48##9	2.09296e-17
C160	VPWR#12	VPWR#11	2.35578e-18
C161	a_28_368##3	a_28_368##6	4.6216e-21
C162	a_27_74##2	a_27_74#	2.5966e-18
C163	a_27_74##9	A1#6	3.05025e-19
C164	VPWR#6	A1#1	1.84638e-18
C165	a_27_74##11	A1#5	5.40425e-19
C166	a_28_368##5	A1#2	3.21736e-19
C167	Y#3	A2#7	1.34509e-18
C168	VPWR#12	a_28_368##8	5.21257e-17
C169	VGND#10	A1#6	2.82105e-17
C170	A1#9	A1#4	3.56881e-18
C171	a_28_368##2	A2#4	1.31004e-20
C172	A1#4	A1#3	4.0818e-18
C173	Y#2	A2#7	1.32619e-19
C174	a_27_74##9	A1#8	1.28671e-19
C175	A1#6	a_27_74##11	1.39055e-17
C176	a_28_368#	a_828_48##10	7.72497e-19
C177	a_27_74##2	Y#10	5.60909e-17
C178	a_28_368##6	a_28_368##8	1.48508e-18
C179	VGND#10	A1#8	1.22471e-18
C180	VPWR#6	A1#7	1.82442e-18
C181	VGND#11	A1#6	2.30452e-18
C182	Y#3	A2#9	3.8102e-19
C183	a_28_368##6	VPWR#12	5.42684e-17
C184	a_28_368##2	A2#2	2.74702e-20
C185	A1#8	a_27_74##11	1.77102e-17
C186	a_27_74##12	A1#6	1.77288e-19
C187	Y#7	Y#10	2.5966e-18
C188	a_27_74##2	a_27_74##5	3.67401e-18
C189	VGND#10	A1#10	1.68038e-19
C190	A1#8	VGND#11	1.71371e-17
C191	Y#3	A2#11	2.5558e-19
C192	a_27_74##11	A1#10	1.20149e-18
C193	a_27_74##12	A1#8	7.47633e-19
C194	a_28_368##2	A2#9	2.08876e-17
C195	VGND#11	A1#10	3.26103e-17
C196	Y#7	a_27_74##5	4.22137e-19
C197	a_27_74##2	Y#8	4.11595e-19
C198	VGND#5	VGND#4	1.68991e-18
C199	a_27_74##12	A1#10	3.36731e-17
C200	Y#3	A2#12	1.56311e-19
C201	a_27_74##8	a_27_74##6	5.2354e-19
C202	VGND#4	A2#4	1.58688e-20
C203	a_28_368##2	A2#11	2.10313e-17
C204	a_828_48#	B1_N#1	5.05025e-18
C205	a_28_368##5	A2#12	7.36537e-20
C206	a_27_74##3	a_27_74##2	2.55444e-18
C207	Y#3	A1#1	1.25132e-19
C208	a_28_368##2	A2#12	1.10704e-17
C209	a_27_74##8	VGND#9	2.14502e-17
C210	a_28_368#	A2#2	8.46999e-20
C211	Y#7	a_27_74##3	6.35731e-17
C212	a_828_48##5	a_828_48#	2.51035e-17
C213	a_28_368##5	A1#1	1.6466e-19
C214	VGND#5	A1#3	3.46846e-20
C215	VPWR#1	B1_N#4	3.91769e-17
C216	a_828_48##14	B1_N#4	2.17646e-17
C217	a_27_74##8	a_27_74##9	1.24483e-18
C218	VPWR#1	B1_N#3	3.38448e-18
C219	a_28_368##5	A1#7	1.40747e-17
C220	VPWR#9	B1_N#4	6.98698e-19
C221	a_828_48##8	a_828_48##5	2.50345e-17
C222	a_27_74##10	VGND#10	1.46745e-17
C223	a_828_48##14	B1_N#3	6.96824e-17
C224	VPWR#3	VPWR#2	1.00203e-18
C225	a_27_74##3	Y#3	1.38703e-18
C226	VPWR#1	a_828_48##4	1.5105e-19
C227	B1_N#3	VPWR#9	4.4303e-17
C228	VPWR#3	VPWR#1	2.74878e-19
C229	a_27_74##8	VGND#10	1.45929e-17
C230	A2#2	Y#9	1.86793e-18
C231	a_28_368##5	A1#11	1.78625e-17
C232	a_27_74##6	Y#7	8.59326e-18
C233	a_828_48##14	a_828_48##4	3.26939e-19
C234	Y#1	B1_N#3	2.52892e-18
C235	a_828_48##10	a_828_48##8	3.84254e-17
C236	a_27_74##10	a_27_74##11	1.24483e-18
C237	VPWR#9	a_828_48##4	2.10105e-18
C238	VPWR#10	B1_N#3	3.1139e-19
C239	VPWR#4	a_828_48##7	8.87878e-20
C240	Y#1	a_828_48##4	7.85447e-17
C241	a_27_74#	a_828_48##7	2.82574e-19
C242	a_828_48##14	VPWR#3	6.82444e-18
C243	a_28_368##5	A1#12	4.04988e-19
C244	a_828_48##11	VGND#1	6.45545e-17
C245	A2#1	a_828_48##10	3.00047e-17
C246	VPWR#9	a_828_48##9	1.67339e-19
C247	a_828_48##4	VPWR#10	2.54886e-17
C248	a_27_74##10	VGND#11	2.13304e-17
C249	VGND#2	a_828_48##12	7.25094e-19
C250	Y#1	a_828_48##9	2.1839e-18
C251	Y#6	a_828_48##4	1.3962e-18
C252	a_27_74#	VGND#1	6.43699e-18
C253	a_828_48##9	VPWR#10	3.01111e-17
C254	a_28_368#	a_828_48##4	3.38633e-19
C255	VPWR#6	A2#5	2.39524e-20
C256	A2#8	A2#1	2.33171e-17
C257	Y#6	a_828_48##9	6.72999e-17
C258	a_27_74##12	a_27_74##10	4.84924e-19
C259	Y#1	VPWR#4	9.14899e-18
C260	VPWR#10	A2#7	2.99113e-19
C261	a_28_368#	a_828_48##9	3.00443e-18
C262	VGND#2	a_27_74##2	1.82127e-17
C263	a_27_74#	a_828_48##11	3.36481e-17
C264	VPWR#3	a_828_48##7	2.70219e-20
C265	Y#6	A2#7	2.05509e-18
C266	Y#5	A2#5	1.25293e-18
C267	Y#9	a_828_48##9	3.27021e-19
C268	Y#10	a_828_48##7	6.30202e-18
C269	A2#10	A2#8	3.91613e-17
C270	Y#1	VPWR#3	8.79554e-18
C271	a_28_368#	A2#7	4.04301e-17
C272	a_28_368##7	a_828_48##9	1.09084e-19
C273	Y#5	A2#4	8.18998e-20
C274	B1_N	a_828_48##7	2.73604e-20
C275	Y#9	A2#7	6.83859e-17
C276	Y#10	a_828_48##11	2.64494e-18
C277	a_828_48##12	a_828_48##14	3.76938e-18
C278	a_28_368#	A2#9	7.23601e-19
C279	a_28_368##7	A2#7	2.01137e-18
C280	VPWR#3	B1_N#2	1.04416e-20
C281	A2#6	A2#10	3.97361e-17
C282	Y#9	A2#9	3.63475e-17
C283	Y#5	A2#7	1.82138e-19
C284	Y#3	VPWR#5	2.23705e-19
C285	a_27_74#	Y#10	4.79327e-17
C286	a_28_368##7	A2#9	4.45518e-17
C287	a_28_368##3	A2#7	1.87679e-19
C288	Y#6	VPWR#4	1.75377e-17
C289	VGND#3	a_27_74##2	5.33896e-17
C290	a_828_48##12	B1_N#2	1.232e-17
C291	a_828_48##12	VPWR#9	1.89578e-17
C292	Y#9	A2#11	4.6642e-19
C293	Y#5	A2#9	4.08201e-19
C294	VPWR#11	A2#7	4.44084e-20
C295	A1#5	A2#6	4.09634e-17
C296	a_828_48##3	VPWR#3	3.26197e-19
C297	VGND#2	a_828_48##11	9.51491e-18
C298	a_28_368##7	A2#11	3.95746e-17
C299	a_28_368##2	VPWR#5	6.54758e-17
C300	a_28_368##3	A2#9	5.37739e-19
C301	VGND#4	A2#3	3.80851e-20
C302	VGND#2	a_27_74#	5.1903e-17
C303	Y#9	A2#12	2.00227e-19
C304	Y#5	A2#11	3.53149e-17
C305	VPWR#11	A2#9	7.33399e-20
C306	A2	a_828_48##7	1.90842e-20
C307	a_28_368#	VPWR#4	6.59644e-19
C308	a_28_368##7	A2#12	1.75878e-18
C309	a_28_368##3	A2#11	1.5788e-18
C310	A1#6	A1#5	3.97309e-17
C311	Y#1	a_828_48##12	3.69763e-17
C312	A2	A2#5	4.15198e-18
C313	A2	A2#4	1.4994e-17
C314	Y#5	A2#12	4.74216e-17
C315	A2	A2#2	1.75462e-17
C316	VPWR#11	A2#11	2.65252e-19
C317	Y#3	B1_N#2	5.43492e-20
C318	VGND#5	A1#4	1.20149e-20
C319	A2	A1#2	1.67883e-18
C320	a_28_368##3	A2#12	2.6122e-17
C321	a_28_368##7	A1#1	3.5079e-19
C322	VPWR#6	A1#3	1.81511e-20
C323	A1#8	A1#6	4.10678e-17
C324	Y#5	A1#1	1.56401e-18
C325	VPWR#11	A2#12	2.01865e-18
C326	Y#7	a_828_48##3	4.92582e-17
C327	VPWR#6	A1#4	1.26921e-20
C328	a_28_368##3	A1#1	4.43132e-17
C329	a_28_368##8	A2#12	1.07786e-19
C330	VPWR#11	A1#1	4.95844e-17
C331	a_828_48##3	Y#2	6.36388e-17
C332	A1#10	A1#8	2.77306e-17
C333	a_28_368##8	A1#1	2.40966e-19
C334	a_28_368##3	A1#7	1.33915e-18
C335	VPWR#2	VPWR#1	2.14351e-17
C336	a_828_48##11	B1_N#2	1.36512e-17
C337	VPWR#4	VPWR#3	7.25921e-19
C338	a_828_48##14	VPWR#2	7.18333e-18
C339	VPWR#11	A1#7	4.62144e-17
C340	VGND#3	a_27_74##3	4.80056e-17
C341	A1	A2#5	6.38115e-18
C342	a_27_74##10	A1#4	4.22385e-18
C343	A1	A2#4	2.24764e-19
C344	VGND#5	a_27_74##10	2.91756e-19
C345	A1#7	a_28_368##8	1.78245e-17
C346	a_28_368##3	A1#11	6.99828e-19
C347	A1	A1#9	2.10326e-17
C348	A1	A1#3	2.0022e-17
C349	VGND#3	a_27_74##6	7.04797e-18
C350	A1	A1#2	1.26547e-17
C351	VPWR#12	A1#7	6.51081e-19
C352	VPWR#11	A1#11	2.44702e-18
C353	A2#2	a_828_48##7	1.26459e-19
C354	a_28_368##8	A1#11	4.41638e-17
C355	a_28_368##3	A1#12	2.19936e-19
C356	a_27_74#	a_828_48##3	1.7912e-18
C357	a_28_368##2	A2#3	1.14459e-19
C358	A2#4	A2#9	2.31942e-19
C359	Y#10	a_828_48##3	5.84918e-17
C360	A1#11	VPWR#12	2.25557e-17
C361	VPWR#11	A1#12	4.77448e-19
C362	a_28_368##6	A1#11	7.46456e-19
C363	VGND#5	a_27_74##8	2.91756e-19
C364	a_28_368##8	A1#12	1.78975e-18
C365	a_27_74##3	a_828_48##7	2.11154e-19
C366	VPWR#11	A1#3	2.82103e-19
C367	a_28_368##5	A1#4	2.74265e-18
C368	a_27_74##3	Y#8	2.59293e-19
C369	VPWR#12	A1#12	4.41308e-17
C370	a_28_368##3	VPWR#6	2.19254e-17
C371	a_28_368##6	A1#12	3.75314e-17
C372	Y	a_828_48##7	8.85184e-19
C373	B1_N#3	B1_N#4	4.05668e-17
C374	VPWR#11	A1#2	3.64564e-19
C375	Y	A2#5	1.07257e-19
C376	Y	A2#4	1.67151e-19
C377	Y	A2#2	8.57474e-18
C378	VGND#4	a_27_74##8	2.91803e-19
C379	a_28_368#	VPWR#5	4.95584e-17
C380	a_27_74##3	A2#3	3.72286e-19
C381	VGND#8	A2#3	7.24028e-19
C382	a_828_48##4	B1_N#3	6.08074e-18
C383	a_828_48##14	B1_N#2	2.88185e-18
C384	a_27_74##6	A2#3	3.83997e-18
C385	Y#1	B1_N#2	2.06418e-19
C386	a_27_74##3	VGND#8	4.2564e-17
C387	a_828_48##12	a_828_48##7	5.15338e-19
C388	a_828_48##9	a_828_48##4	4.39359e-17
C389	A1#3	a_28_368##8	2.43044e-19
C390	a_828_48##3	Y#1	4.98535e-17
C391	VGND#2	B1_N#1	4.70797e-18
C392	a_28_368##8	VPWR#6	7.18333e-18
C393	a_828_48##3	VPWR#10	2.61106e-18
C394	Y#2	Y#1	2.39401e-18
C395	a_27_74##6	a_27_74##3	2.50837e-18
C396	VGND#2	a_828_48#	5.39009e-18
C397	A2#7	a_828_48##9	5.40117e-18
C398	a_828_48##3	Y#6	3.48707e-18
C399	VGND#2	a_828_48##5	1.89449e-18
C400	VGND#11	A1#4	8.39499e-19
C401	VGND#2	a_828_48##8	4.5881e-20
C402	A2#5	A2#4	9.83653e-18
C403	a_27_74##6	VGND#8	3.27146e-17
C404	A2#9	A2#7	3.36495e-17
C405	Y#2	VPWR#10	1.60376e-17
C406	A1#9	VPWR#12	2.86194e-19
C407	A2#12	A2#4	6.34251e-18
C408	A2#3	Y#9	3.46523e-18
C409	a_828_48##12	B1_N	1.76316e-17
C410	VPWR#5	a_828_48##10	4.75788e-20
C411	VGND#3	a_828_48##5	2.58666e-18
C412	A2#3	a_28_368##7	1.49738e-18
C413	a_27_74##8	Y#5	4.25757e-18
C414	VGND#1	VPWR#1	3.61737e-19
C415	A2#11	A2#9	4.70649e-17
C416	Y#5	A2#3	6.70406e-19
C417	VGND#3	a_828_48##8	4.43427e-18
C418	a_27_74##3	A2#2	1.51778e-18
C419	VGND#9	VGND#8	1.45565e-18
C420	a_828_48#	B1_N#2	8.55424e-18
C421	VGND#3	a_828_48##10	4.49056e-18
C422	VGND#3	A2#1	2.62909e-18
C423	Y#2	Y#6	2.22879e-18
C424	VGND#3	A2#8	2.89336e-18
C425	A2#12	A2#11	4.4975e-17
C426	a_828_48##3	a_828_48#	1.47822e-17
C427	Y#3	a_28_368#	3.76176e-17
C428	a_27_74##6	VGND#9	5.11787e-17
C429	a_27_74##8	A2	1.03911e-17
C430	a_27_74##8	a_28_368##3	1.35516e-17
C431	A1#4	a_28_368##8	3.0152e-19
C432	VPWR#2	B1_N#4	5.4065e-18
C433	VGND#1	B1_N	3.87027e-17
C434	A1#1	A2#12	5.18916e-17
C435	A1#4	VPWR#12	9.49831e-19
C436	B1_N	a_828_48##11	3.02422e-17
C437	a_828_48##11	a_828_48##14	4.58931e-18
C438	a_27_74##9	a_27_74##6	1.72657e-18
C439	A1#7	A1#1	4.75011e-17
C440	a_27_74##10	A1	8.17379e-17
C441	a_27_74##8	A1	2.11951e-17
C442	VGND#8	A2#2	6.98808e-19
C443	A1#11	A1#7	4.77298e-17
C444	a_27_74##9	VGND#9	4.16102e-17
C445	a_828_48##7	a_828_48#	2.54773e-18
C446	A1	a_28_368##5	9.40006e-17
C447	A1#3	A1#1	4.36548e-18
C448	a_27_74##3	A2	1.00518e-17
C449	VPWR#5	A2#7	4.4526e-18
C450	B1_N	VPWR#1	2.05737e-17
C451	B1_N#3	B1_N#2	1.60898e-18
C452	a_27_74##6	A2	6.03989e-17
C453	Y	a_828_48##12	1.36756e-18
C454	B1_N	a_828_48##14	2.69404e-17
C455	A1#12	A1#11	4.68342e-17
C456	VPWR#5	A2#9	4.47374e-18
C457	a_828_48##4	B1_N#2	2.05583e-18
C458	VPWR#5	A2#11	4.43317e-18
C459	a_828_48##12	A2#2	1.34643e-20
C460	VGND#10	VGND#9	1.66094e-18
C461	a_27_74##6	A2#4	6.62183e-19
C462	VPWR	VPWR#6	8.0354e-17
C463	VPWR	VPWR#4	8.63375e-17
C464	VPWR	VPWR#3	7.20278e-17
C465	VPWR	a_828_48##12	8.0974e-19
C466	VPWR#3	a_828_48#	2.38003e-19
C467	VGND#10	a_27_74##9	4.15829e-17
C468	a_27_74##12	A1	4.5474e-17
C469	A2	Y#9	6.89587e-17
C470	a_28_368##2	Y#9	1.96342e-17
C471	A2	Y#5	4.07643e-17
C472	VPWR	Y#3	5.80476e-18
C473	B1_N	a_828_48#	3.06471e-18
C474	VPWR	Y#2	1.92839e-18
C475	VPWR	a_28_368##5	3.85866e-18
C476	VGND	VGND#5	7.34701e-17
C477	VGND	VGND#4	7.48778e-17
C478	VPWR	a_28_368##2	3.3157e-17
C479	VGND#9	A2#5	6.93135e-19
C480	a_27_74##11	a_27_74##9	1.67195e-18
C481	a_828_48##7	VNB	8.30189e-17
C482	VGND	a_828_48##12	5.07976e-18
C483	A1	a_28_368##3	1.10244e-17
C484	A2#5	VNB	2.1627e-17
C485	VGND	a_27_74##10	3.95043e-18
C486	A2#4	VNB	2.06422e-17
C487	a_828_48##12	B1_N#1	9.78925e-20
C488	A2#2	VNB	2.46702e-17
C489	VGND	a_27_74##8	4.31733e-18
C490	A1#9	VNB	3.64318e-17
C491	A1#3	VNB	2.80668e-17
C492	A1#2	VNB	2.22763e-17
C493	VPWR#2	B1_N#2	3.40098e-20
C494	a_28_368##2	a_28_368##7	4.35239e-20
C495	VGND	a_27_74##2	2.93426e-17
C496	A2	a_828_48##10	4.55863e-18
C497	VGND	Y#7	1.25599e-17
C498	a_27_74##8	A2#5	3.30721e-18
C499	A1	a_28_368##6	4.02716e-17
C500	VGND#2	B1_N#2	3.41009e-19
C501	VGND#9	A2#4	8.42275e-20
C502	a_27_74##11	VGND#10	4.16102e-17
C503	VPWR	a_828_48##14	1.61488e-17
C504	VGND	a_828_48##11	1.44724e-17
C505	VGND	a_27_74#	2.50316e-17
C506	VGND	Y#10	9.59674e-18
C507	VPWR	Y#1	1.91397e-17
C508	a_28_368##5	a_28_368##3	8.60298e-19
C509	VPWR	Y#6	1.77938e-17
C510	VGND	a_27_74##3	2.73708e-17
C511	B1_N	a_828_48##4	1.15202e-19
C512	VGND#4	A2#1	2.08993e-19
C513	VPWR	a_28_368#	2.52801e-17
C514	VPWR#5	A2#3	4.44053e-20
C515	VGND	VGND#8	2.21244e-17
C516	Y	a_828_48#	2.18228e-19
C517	VGND	a_27_74##6	1.83114e-17
C518	VPWR	Y#9	1.16334e-17
C519	Y	a_828_48##5	6.22787e-20
C520	a_28_368##2	Y#5	2.7576e-17
C521	VGND	a_27_74##9	1.23287e-17
C522	a_828_48##12	a_828_48#	5.01334e-18
C523	VPWR	Y#5	9.15312e-18
C524	Y	a_828_48##8	3.14158e-19
C525	VGND#3	A2#3	1.76824e-20
C526	VPWR	a_28_368##3	1.27711e-17
C527	VGND	a_27_74##11	1.18512e-17
C528	Y	a_828_48##10	1.41297e-17
C529	VPWR	VPWR#11	2.15913e-17
C530	Y	A2#1	4.3642e-19
C531	a_27_74##8	A2#4	2.13342e-19
C532	VGND	a_27_74##12	1.57109e-17
C533	a_27_74##10	A1#9	7.78295e-19
C534	VGND#11	VGND#10	1.51928e-18
C535	VPWR	a_28_368##8	1.48603e-17
C536	Y	A2#8	1.69185e-19
C537	A2	a_828_48##9	8.03545e-20
C538	Y	A2#10	7.64928e-20
C539	VPWR	a_28_368##6	1.58628e-17
C540	Y	A2#6	4.90838e-20
C541	A2	A2#7	1.53342e-18
C542	VPWR	a_828_48#	1.54803e-18
C543	A2	A2#9	2.09803e-18
C544	A1#11	A1#3	2.31942e-19
C545	VPWR	a_828_48##10	1.38491e-21
C546	a_28_368##5	VPWR#11	2.66331e-17
C547	A2	A2#12	1.73343e-18
C548	VPWR#4	a_828_48##10	1.64709e-19
C549	VGND	a_28_368##3	3.6647e-18
C550	A2	A1#1	5.24204e-19
C551	VGND#5	VNB	2.70374e-17
C552	VGND#4	VNB	2.7683e-17
C553	VPWR#6	VNB	4.28175e-17
C554	VPWR#4	VNB	4.06309e-17
C555	VPWR#3	VNB	3.02746e-17
C556	VGND	B1_N#1	3.35008e-18
C557	Y	a_828_48##4	1.59676e-19
C558	VGND#11	a_27_74##11	3.34994e-17
C559	A1	A2#12	1.26896e-18
C560	B1_N	VPWR#2	3.25623e-18
C561	VGND	a_828_48#	2.55284e-18
C562	a_828_48##12	VNB	1.59107e-17
C563	Y	a_828_48##9	1.10677e-18
C564	VGND#4	A2#8	6.64435e-19
C565	a_27_74##10	VNB	1.52887e-18
C566	VGND	a_828_48##5	1.57845e-18
C567	a_27_74##8	VNB	3.15192e-18
C568	A1	A1#1	4.53288e-18
C569	VGND	a_828_48##8	1.58774e-18
C570	Y	A2#7	1.26758e-18
C571	VGND#2	B1_N	2.73765e-18
C572	a_828_48##12	a_828_48##5	1.12908e-19
C573	a_27_74##2	VNB	5.37264e-18
C574	VGND	a_828_48##10	1.48815e-18
C575	Y#7	VNB	8.53623e-19
C576	a_27_74##10	a_27_74##8	5.06977e-19
C577	VGND	A2#1	5.63782e-19
C578	Y#3	VNB	4.26741e-18
C579	VPWR	B1_N#4	5.14259e-19
C580	Y#2	VNB	2.26635e-18
C581	VGND	A2#8	2.24562e-19
C582	Y	A2#11	1.72997e-20
C583	A1	A1#11	2.04678e-18
C584	VPWR	B1_N#3	7.84058e-19
C585	VGND	A2#10	6.62025e-19
C586	a_27_74##10	A1#3	2.53345e-18
C587	a_28_368##2	VNB	6.09412e-18
C588	Y	A2#12	1.03497e-20
C589	A1	A1#12	3.3974e-18
C590	VGND	A2#6	1.01425e-18
C591	VPWR	a_828_48##4	3.98902e-19
C592	VGND#1	VNB	4.45333e-17
C593	VGND	A1#5	6.99989e-19
C594	VPWR	a_828_48##9	1.03129e-18
C595	a_828_48##11	VNB	1.26605e-17
C596	B1_N	B1_N#2	2.79161e-17
C597	a_27_74#	VNB	1.33444e-17
C598	VGND	A1#6	6.42711e-19
C599	Y#10	VNB	6.06154e-19
C600	VPWR	A2#7	1.55612e-18
C601	VGND	A1#8	1.3322e-18
C602	VPWR	A2#9	1.64547e-18
C603	a_27_74##3	VNB	3.27238e-18
C604	VGND	A1#10	1.6266e-18
C605	A1#2	A2#5	3.27583e-17
C606	VGND#8	VNB	5.44582e-18
C607	a_27_74##6	VNB	2.18616e-18
C608	VPWR	A2#11	1.54355e-18
C609	VGND#9	VNB	3.01253e-20
C610	a_27_74##9	VNB	4.55126e-18
C611	VPWR	A2#12	1.45627e-18
C612	VGND#10	VNB	3.01253e-20
C613	a_28_368##5	a_28_368##8	2.20942e-18
C614	a_27_74##11	VNB	4.55126e-18
C615	Y#3	VPWR#4	8.45909e-19
C616	VGND#11	VNB	1.67769e-18
C617	VPWR	A1#1	1.28273e-18
C618	a_27_74##12	VNB	4.69124e-17
C619	VPWR#1	VNB	4.43262e-17
C620	VPWR	A1#7	1.02377e-18
C621	a_27_74##2	B1_N#1	1.19872e-19
C622	a_27_74##12	a_27_74##11	1.59922e-18
C623	a_828_48##14	VNB	7.05319e-18
C624	VPWR#9	VNB	8.99476e-18
C625	Y#1	VNB	1.2662e-17
C626	VPWR	A1#11	6.5795e-19
C627	A2	A2#3	2.51464e-17
C628	VPWR#10	VNB	2.94216e-18
C629	Y#6	VNB	9.84239e-18
C630	VPWR	A1#12	2.08509e-18
C631	a_28_368#	VNB	1.16774e-17
C632	a_28_368##3	VNB	5.12764e-18
C633	VPWR	VPWR#2	1.28976e-17
C634	VPWR#11	VNB	1.38316e-19
C635	a_28_368##8	VNB	2.24265e-18
C636	Y	B1_N#2	1.77949e-19
C637	VPWR#12	VNB	2.60465e-18
C638	a_28_368##6	VNB	4.97631e-17
C639	A1	A1#4	2.00489e-17
C640	B1_N#1	VNB	3.31564e-17
C641	Y	a_828_48##3	3.29789e-17
C642	VPWR	VPWR#5	8.6367e-17
C643	a_828_48#	VNB	6.00527e-17
C644	a_828_48##5	VNB	2.9747e-17
C645	a_828_48##8	VNB	2.93985e-17
C646	Y	A2#3	3.83919e-19
C647	a_828_48##10	VNB	5.14845e-17
C648	A2#1	VNB	2.85939e-17
C649	a_828_48##12	a_828_48##8	6.66801e-20
C650	VPWR	B1_N#2	9.26327e-20
C651	A2#8	VNB	2.8961e-17
C652	VGND#4	A2#10	5.50191e-18
C653	A2#10	VNB	2.52892e-17
C654	A2#6	VNB	2.5321e-17
C655	VGND	VGND#2	8.15046e-17
C656	VPWR	a_828_48##3	9.2579e-18
C657	A1#5	VNB	2.54873e-17
C658	A1#6	VNB	2.54034e-17
C659	A1#8	VNB	2.64697e-17
C660	A1#10	VNB	3.42454e-17
C661	VGND	VGND#3	1.15524e-16
C662	B1_N#4	VNB	4.10767e-17
C663	VGND	B1_N#2	3.08336e-19
C664	B1_N#3	VNB	3.50906e-17
C665	a_828_48##4	VNB	4.49836e-17
C666	VGND	a_828_48##3	8.37794e-18
C667	a_828_48##9	VNB	3.68419e-17
C668	a_27_74##12	VGND#11	5.12961e-17
C669	A2#7	VNB	3.83123e-17
C670	a_27_74##2	a_828_48##7	1.46966e-18
C671	A2#9	VNB	3.26575e-17
C672	A2#11	VNB	3.16994e-17
C673	A1	A2	1.40999e-17
C674	A2#12	VNB	3.56673e-17
C675	A1#1	VNB	3.35734e-17
C676	a_28_368##5	VPWR#12	2.41447e-17
C677	A1#7	VNB	2.78179e-17
C678	A1#11	VNB	3.05182e-17
C679	A2	Y	2.92305e-17
C680	A1#12	VNB	3.87107e-17
C681	VPWR	B1_N	2.75289e-18
C682	VPWR#2	VNB	9.34341e-17
C683	VGND#2	VNB	1.36492e-16
C684	VPWR	A2	8.14055e-18
C685	VPWR#5	VNB	5.10011e-17
C686	a_27_74##2	a_828_48#	1.33456e-18
C687	VGND#3	VNB	6.70503e-17
C688	VGND	B1_N	2.80008e-18
C689	VPWR	A1	1.11786e-17
C690	B1_N#2	VNB	8.64556e-17
C691	Y#2	VPWR#4	4.52495e-19
C692	a_828_48##3	VNB	1.50121e-17
C693	VGND	A2	8.27052e-18
C694	A2#3	VNB	3.11309e-17
C695	a_828_48##10	a_828_48##7	3.18172e-18
C696	A1#4	VNB	3.23057e-17
C697	VGND	A1	9.97462e-18
C698	VGND#5	A2#6	6.3656e-19
C699	a_28_368##5	VPWR#6	3.13618e-19
C700	B1_N	VNB	2.18785e-17
C701	A2	VNB	1.31183e-17
C702	A1	VNB	4.18595e-17
C703	Y	VNB	1.09904e-18
C704	VPWR	VNB	3.07954e-16
C705	VGND	VNB	3.03197e-16
C706	VGND#6	A1#10	5.4152e-18
C707	VGND#6	VNB	4.72884e-17
C708	a_28_368##5	VPWR#7	3.13618e-19
C709	VGND#6	A1#4	2.49367e-20
C710	VPWR#7	A1#7	5.16438e-19
C711	VPWR	VPWR#7	9.1136e-17
C712	VPWR#7	A1#4	9.55321e-21
C713	VGND#6	A1#6	8.87759e-19
C714	VPWR#7	VPWR#11	2.85135e-19
C715	VPWR#7	A1#12	4.48432e-18
C716	VGND	VGND#6	9.81413e-17
C717	VPWR#7	VPWR#6	9.84578e-19
C718	VGND#6	VGND#5	1.67868e-18
C719	VGND#6	a_27_74##12	1.7841e-17
C720	VGND#6	a_27_74##11	4.01372e-18
C721	VGND#6	A1#8	5.59514e-18
C722	VPWR#7	A1#11	5.33525e-18
C723	a_28_368##8	VPWR#7	6.52276e-18
C724	VPWR#7	VNB	4.44795e-17
C725	VGND#6	a_27_74##10	6.23298e-19
C726	a_28_368##6	VPWR#7	1.78825e-17
*
*
.ENDS sky130_fd_sc_hs__o21bai_4
*
