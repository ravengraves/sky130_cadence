* Extracted by Quantus, converted by sky130cad/quantus.py
*
*
*
*                       LINUX           Wed Nov 18 08:38:59 2026
*
*
*
*  PROGRAM  advgen
*
*  Name           : advgen - Quantus - (64-bit)
*  Version        : 25.1.0-p047
*  Build Date     : Thu Dec 11 23:20:30 PST 2025
*
*  HSPICE LIBRARY
*
*  OPERATING_TEMPERATURE 150
*  QRC_TECH_DIR <path>/tech
*
*
*

*
.SUBCKT sky130_fd_sc_hs__fah_1 VPB VNB VGND VPWR COUT SUM B CI A
*
*
*  caps2d version: 10
*
*
*       TRANSISTOR CARDS
*
*
XM17 SUM#3 a_83_21##2 VGND#14 VNB sky130_fd_pr__nfet_01v8_lvt l=0.15 w=0.74 ad=0.2072 as=0.3848 pd=2.04 ps=2.82
XM29 VGND#14 CI#3 a_231_132##9 VNB sky130_fd_pr__nfet_01v8_lvt l=0.15 w=0.64 ad=0.3848 as=0.2016 pd=2.82 ps=1.91
XM30 COUT#2 a_410_58##3 VGND#13 VNB sky130_fd_pr__nfet_01v8_lvt l=0.15 w=0.74 ad=0.2072 as=0.5853 pd=2.04 ps=3.22
XM11 VGND#13 a_231_132##3 a_644_104##4 VNB sky130_fd_pr__nfet_01v8_lvt l=0.15 w=0.64 ad=0.5853 as=0.23505 pd=3.22 ps=2.02
XM13 a_879_55##11 a_811_379##4 a_410_58##5 VNB sky130_fd_pr__nfet_01v8_lvt l=0.15 w=0.64 ad=0.28315 as=0.26395 pd=3.17 ps=2.41
XM8 a_410_58##5 a_1023_379##6 a_231_132##5 VNB sky130_fd_pr__nfet_01v8_lvt l=0.15 w=0.64 ad=0.26395 as=0.1792 pd=2.41 ps=1.84
XM4 a_231_132##5 a_811_379##3 a_83_21##4 VNB sky130_fd_pr__nfet_01v8_lvt l=0.15 w=0.64 ad=0.1792 as=0.2375 pd=1.84 ps=2.16
XM20 a_83_21##4 a_1023_379# a_644_104##5 VNB sky130_fd_pr__nfet_01v8_lvt l=0.15 w=0.64 ad=0.2375 as=0.1824 pd=2.16 ps=1.85
XM3 a_879_55##9 B#7 VGND#12 VNB sky130_fd_pr__nfet_01v8_lvt l=0.15 w=0.74 ad=0.2109 as=0.3136 pd=2.05 ps=2.51
XM5 a_1660_374##6 a_879_55# a_1023_379##11 VNB sky130_fd_pr__nfet_01v8_lvt l=0.15 w=0.64 ad=0.2568 as=0.4965 pd=2.17 ps=2.98
XM6 a_1023_379##11 B#8 a_1849_374##4 VNB sky130_fd_pr__nfet_01v8_lvt l=0.15 w=0.64 ad=0.4965 as=0.3048 pd=2.98 ps=2.32
XM2 a_1849_374##4 a_879_55##6 a_811_379##8 VNB sky130_fd_pr__nfet_01v8_lvt l=0.15 w=0.64 ad=0.3048 as=0.6528 pd=2.32 ps=3.32
XM18 a_811_379##8 B#1 a_1660_374# VNB sky130_fd_pr__nfet_01v8_lvt l=0.15 w=0.64 ad=0.6528 as=0.2589 pd=3.32 ps=2.2
XM24 a_1660_374# a_2342_48##3 VGND#11 VNB sky130_fd_pr__nfet_01v8_lvt l=0.15 w=0.74 ad=0.2589 as=0.2875 pd=2.2 ps=2.33
XM7 a_1849_374##5 A#5 VGND#10 VNB sky130_fd_pr__nfet_01v8_lvt l=0.15 w=0.64 ad=0.208 as=0.2432 pd=1.93 ps=2.04
XM12 VGND#10 A#1 a_2342_48##8 VNB sky130_fd_pr__nfet_01v8_lvt l=0.15 w=0.64 ad=0.2432 as=0.1824 pd=2.04 ps=1.85
XM0 SUM#1 a_83_21##3 VPWR#12 VPB sky130_fd_pr__pfet_01v8 l=0.15 w=1.12 ad=0.3304 as=0.5645 pd=2.83 ps=3.3
XM27 VPWR#12 CI#1 a_231_132##7 VPB sky130_fd_pr__pfet_01v8 l=0.15 w=1 ad=0.5645 as=0.295 pd=3.3 ps=2.59
XM1 COUT#1 a_410_58# VPWR#10 VPB sky130_fd_pr__pfet_01v8 l=0.15 w=1.12 ad=0.46765 as=0.611325 pd=3.29 ps=3.7
XM21 VPWR#10 a_231_132# a_644_104# VPB sky130_fd_pr__pfet_01v8 l=0.15 w=1 ad=0.611325 as=0.558725 pd=3.7 ps=3.27
XM10 a_644_104# a_811_379##5 a_83_21##6 VPB sky130_fd_pr__pfet_01v8 l=0.15 w=0.84 ad=0.558725 as=0.7644 pd=3.27 ps=3.5
XM16 a_83_21##6 a_1023_379##4 a_231_132##10 VPB sky130_fd_pr__pfet_01v8 l=0.15 w=0.84 ad=0.7644 as=0.813225 pd=3.5 ps=4.02
XM19 a_231_132##10 a_811_379# a_410_58##7 VPB sky130_fd_pr__pfet_01v8 l=0.15 w=0.84 ad=0.813225 as=0.5082 pd=4.02 ps=2.89
XM15 a_410_58##7 a_1023_379##3 a_879_55##13 VPB sky130_fd_pr__pfet_01v8 l=0.15 w=0.84 ad=0.5082 as=0.4036 pd=2.89 ps=3.01
XM28 a_879_55##13 B#9 VPWR#9 VPB sky130_fd_pr__pfet_01v8 l=0.15 w=1.12 ad=0.4036 as=0.3864 pd=3.01 ps=2.93
XM25 a_1660_374##4 a_879_55##3 a_811_379##9 VPB sky130_fd_pr__pfet_01v8 l=0.15 w=0.84 ad=0.2478 as=0.294 pd=2.27 ps=2.38
XM31 a_811_379##9 B#4 a_1849_374# VPB sky130_fd_pr__pfet_01v8 l=0.15 w=0.84 ad=0.294 as=1.32135 pd=2.38 ps=4.79
XM9 a_1849_374# a_879_55##4 a_1023_379##9 VPB sky130_fd_pr__pfet_01v8 l=0.15 w=0.84 ad=1.32135 as=0.252 pd=4.79 ps=2.28
XM23 a_1023_379##9 B#2 a_1660_374##2 VPB sky130_fd_pr__pfet_01v8 l=0.15 w=0.84 ad=0.252 as=0.3724 pd=2.28 ps=2.95
XM26 a_1660_374##2 a_2342_48##4 VPWR#8 VPB sky130_fd_pr__pfet_01v8 l=0.15 w=1.12 ad=0.3724 as=0.4851 pd=2.95 ps=3.31
XM14 a_1849_374##7 A#7 VPWR#7 VPB sky130_fd_pr__pfet_01v8 l=0.15 w=1 ad=0.295 as=0.35 pd=2.59 ps=2.7
XM22 VPWR#7 A#6 a_2342_48##5 VPB sky130_fd_pr__pfet_01v8 l=0.15 w=1 ad=0.35 as=0.3 pd=2.7 ps=2.6
*
*
*       RESISTOR AND CAP/DIODE CARDS
*
Rg1	CI#1	CI#2	400.207520
Rg2	CI#2	CI#3	279.244598
Rg3	a_83_21#	a_83_21##2	1991.679565
Rg4	a_83_21##2	a_83_21##3	794.359497
Rg5	a_410_58#	a_410_58##2	454.976013
Rg6	a_410_58##2	a_410_58##3	539.090881
Rg7	a_231_132#	a_231_132##2	403.693939
Rg8	a_231_132##2	a_231_132##3	382.967102
Rg9	a_231_132##2	a_231_132##4	79.819237
Rg10	a_811_379#	a_811_379##2	510.216370
Rg11	a_811_379##2	a_811_379##3	279.244598
Rg12	a_811_379##3	a_811_379##4	1427.425415
Rg13	a_811_379##4	a_811_379##5	971.464172
Rg14	a_1023_379#	a_1023_379##2	504.914154
Rg15	a_1023_379##2	a_1023_379##3	489.439728
Rg16	a_1023_379##3	a_1023_379##4	1719.743896
Rg17	a_1023_379##2	a_1023_379##5	50.268917
Rg18	a_1023_379##4	a_1023_379##6	913.030640
Rg19	a_879_55#	a_879_55##2	420.462036
Rg20	a_879_55##2	a_879_55##3	357.417023
Rg21	a_879_55##4	a_879_55##5	604.651794
Rg22	a_879_55##5	a_879_55##6	316.658020
Rg23	B#1	B#2	788.468567
Rg24	B#2	B#3	1603.723999
Rg25	B#3	B#4	415.306152
Rg26	B#4	B#5	441.733459
Rg27	B#3	B#6	1626.244263
Rg28	B#6	B#7	516.798889
Rg29	B#5	B#8	316.658020
Rg30	B#6	B#9	392.853271
Rg31	a_2342_48#	a_2342_48##2	103.456429
Rg32	a_2342_48##2	a_2342_48##3	322.953644
Rg33	a_2342_48##2	a_2342_48##4	507.075531
Rg34	A#1	A#2	495.112274
Rg35	A#2	A#3	32.565670
Rg36	A#3	A#4	30.613651
Rg37	A#4	A#5	495.112274
Rg38	A#2	A#6	415.223511
Rg39	A#4	A#7	415.223511
Rf1	SUM	SUM#2	0.194040
Rf2	SUM#2	SUM	14.164948
Rf3	SUM	SUM#3	21.664948
Rf4	SUM#1	SUM#2	5.000000
Rf5	CI#2	CI	163.775864
Rf6	COUT#1	COUT	351.703522
Rf7	COUT	COUT#2	24.054472
Rf8	a_644_104#	a_644_104##2	40.540192
Rf9	a_644_104##2	a_644_104##3	7.703831
Rf10	a_644_104##2	a_644_104##4	54.722656
Rf11	a_811_379##2	a_811_379##7	192.228394
Rf12	a_83_21##4	a_83_21#	404.013641
Rf13	a_83_21#	a_83_21##6	180.035889
Rf14	a_644_104##5	a_644_104##6	71.548492
Rf15	a_410_58##2	a_410_58##6	386.875885
Rf16	a_410_58##6	a_410_58##7	182.356400
Rf17	a_410_58##5	a_410_58##6	15.000000
Rf18	a_231_132##5	a_231_132##6	340.651031
Rf19	a_231_132##6	a_231_132##8	299.566345
Rf20	a_231_132##8	a_231_132##9	106.653343
Rf21	a_231_132##6	a_231_132##11	0.860370
Rf22	a_231_132##11	a_231_132##4	204.527008
Rf23	a_231_132##7	a_231_132##8	7.500000
Rf24	a_231_132##10	a_231_132##11	7.500000
Rf25	a_1023_379##5	a_1023_379##8	110.845375
Rf26	B#10	B	0.882458
Rf27	B#5	B#12	161.115265
Rf28	B#10	B#12	3.543054
Rf29	a_879_55##5	a_879_55##8	297.571533
Rf30	a_879_55##8	a_879_55##10	104.798630
Rf31	a_879_55##10	a_879_55##11	227.375000
Rf32	a_879_55##8	a_879_55##2	218.390854
Rf33	a_879_55##10	a_879_55##13	102.370636
Rf34	a_879_55##9	a_879_55##10	7.500000
Rf35	a_1849_374##2	a_1849_374##3	1.183454
Rf36	a_1849_374##3	a_1849_374##4	49.426346
Rf37	a_1849_374#	a_1849_374##2	2.500000
Rf38	a_811_379##8	a_811_379##10	275.803711
Rf39	a_811_379##10	a_811_379##11	11.318090
Rf40	a_811_379##9	a_811_379##10	7.500000
Rf41	a_1023_379##9	a_1023_379##10	49.472240
Rf42	a_1023_379##10	a_1023_379##11	244.088684
Rf43	a_1660_374#	a_1660_374##3	64.643906
Rf44	a_1660_374##3	a_1660_374##5	262.429962
Rf45	a_1660_374##5	a_1660_374##6	96.336403
Rf46	a_1660_374##2	a_1660_374##3	7.500000
Rf47	a_1660_374##4	a_1660_374##5	7.500000
Rf48	a_1849_374##5	a_1849_374##6	152.937225
Rf49	a_1849_374##6	a_1849_374##7	20.980471
Rf50	A#3	A	81.887932
Rf51	a_2342_48##5	a_2342_48##6	82.821419
Rf52	a_2342_48##6	a_2342_48#	241.358826
Rf53	a_2342_48##6	a_2342_48##8	27.392002
Rf54	VGND#1	VGND#2	39.422733
Rf55	VGND#2	VGND#3	77.384460
Rf56	VGND#3	VGND#4	146.076462
Rf57	VGND#4	VGND#5	158.495041
Rf58	VGND#5	VGND#6	332.355225
Rf59	VGND#6	VGND#7	74.609550
Rf60	VGND#7	VGND#8	113.667030
Rf62	VGND#2	VGND#10	31.337896
Rf63	VGND#3	VGND#11	29.586588
Rf64	VGND#5	VGND#12	26.043533
Rf65	VGND#7	VGND#13	51.146652
Rf66	VGND#8	VGND#14	30.373932
Rf67	VPWR#1	VPWR#2	36.923317
Rf68	VPWR#2	VPWR#3	77.070869
Rf69	VPWR#3	VPWR#4	148.992798
Rf70	VPWR#4	VPWR#5	163.973831
Rf71	VPWR#5	VPWR#6	326.876434
Rf72	VPWR#2	VPWR#7	44.422604
Rf73	VPWR#3	VPWR#8	29.126753
Rf74	VPWR#5	VPWR#9	40.451241
Rf75	VPWR#6	VPWR#10	25.431526
Rf76	VPWR#6	VPWR#11	195.325500
Rf77	VPWR#11	VPWR#12	53.143215
Re1	a_644_104##6	a_644_104##3	25.122730
Re2	a_811_379##11	a_811_379##7	25.199917
Re3	a_1023_379##10	a_1023_379##8	26.460640
Re4	a_1849_374##3	a_1849_374##6	18.390244
Re5	VPWR#1	VPWR#15	11.160645
Re6	VPWR#15	VPWR	1.198481
Re7	VPWR	VPWR#6	2.081275
Re8	VGND#1	VGND#16	11.160645
Re9	VGND#16	VGND	1.198481
Re10	VGND	VGND#6	2.081275
Re20	VPWR#4	VPWR#15	0.698413
Re23	VGND#4	VGND#16	0.698413
*
*       CAPACITOR CARDS
*
*
C1	a_879_55##13	VPWR#9	1.00716e-16
C2	VPWR#9	B#3	8.20427e-18
C3	a_879_55##9	B#7	6.95432e-17
C4	a_644_104##6	a_83_21##4	3.1883e-18
C5	CI#1	a_231_132##7	3.12284e-17
C6	a_1023_379##2	B#7	1.66182e-17
C7	a_1023_379##10	a_1849_374#	5.77025e-17
C8	a_83_21##4	a_231_132##2	3.52838e-20
C9	a_644_104##6	a_231_132##5	9.755e-17
C10	a_811_379##7	a_879_55##9	1.37171e-18
C11	a_1849_374##3	a_1660_374##2	3.76519e-18
C12	COUT#1	a_83_21##3	4.0269e-18
C13	a_879_55##8	B#5	4.56988e-18
C14	CI#1	VPWR#12	2.89867e-17
C15	a_83_21##4	a_644_104##5	2.1163e-17
C16	a_879_55##9	a_231_132##5	1.63623e-18
C17	a_644_104##5	B#7	4.99773e-19
C18	VPWR#3	VPWR#2	7.56243e-19
C19	a_644_104##6	a_410_58##5	2.85772e-17
C20	a_1849_374##3	a_1023_379##9	2.67174e-17
C21	a_231_132##7	a_83_21##3	1.95784e-20
C22	VGND#5	a_879_55##11	3.25375e-17
C23	a_811_379##7	a_1023_379##2	1.95007e-18
C24	a_879_55##9	a_1023_379#	1.76436e-17
C25	a_811_379##7	a_83_21##4	7.39257e-20
C26	a_1023_379#	a_1023_379##3	2.37094e-19
C27	a_644_104##6	a_879_55##11	1.14281e-18
C28	a_1023_379##10	a_1660_374##4	1.4928e-18
C29	VGND#5	a_811_379##2	3.67057e-20
C30	a_1849_374##3	a_1849_374#	6.06087e-17
C31	B#12	B#5	2.19586e-17
C32	a_879_55##13	B#6	5.54824e-18
C33	a_811_379##11	a_1660_374##2	5.17446e-17
C34	a_83_21##3	VPWR#12	1.92614e-17
C35	a_83_21##4	B#7	6.36442e-19
C36	a_811_379##7	a_231_132##5	4.2613e-17
C37	VGND#12	a_811_379##3	2.92458e-19
C38	a_231_132##5	a_1023_379##2	2.26572e-18
C39	B#10	B#5	1.03705e-17
C40	A#7	A#6	3.4138e-17
C41	a_231_132##5	a_644_104##5	2.16753e-17
C42	a_644_104##5	a_1023_379#	1.04741e-17
C43	a_879_55##8	a_879_55##2	3.091e-18
C44	a_410_58##5	a_811_379##7	2.94785e-17
C45	a_83_21##3	SUM#1	1.20508e-17
C46	a_1023_379#	a_811_379#	1.16578e-17
C47	a_1849_374##3	a_1660_374##4	4.52849e-19
C48	a_811_379##11	a_1849_374#	1.74612e-16
C49	a_879_55##9	a_811_379##3	2.77463e-19
C50	a_644_104##3	a_83_21##4	3.00928e-18
C51	a_1660_374##2	VPWR#4	7.07336e-17
C52	a_1023_379#	a_1023_379##2	1.59746e-17
C53	a_879_55##8	a_1849_374##4	1.77796e-17
C54	a_83_21##4	a_1023_379#	2.75496e-17
C55	a_811_379##11	a_811_379##9	4.62597e-18
C56	a_879_55##2	B#12	2.68593e-17
C57	VGND#2	A#1	2.23162e-18
C58	a_83_21##4	a_231_132##5	6.89216e-17
C59	a_2342_48##4	A#7	4.92756e-18
C60	a_644_104##5	a_811_379##3	3.97919e-19
C61	a_879_55##2	B#10	1.53099e-17
C62	a_644_104##3	a_410_58##5	1.51029e-17
C63	a_811_379##11	a_1660_374##4	2.08878e-16
C64	a_879_55##13	a_1023_379##2	5.78104e-19
C65	a_811_379##3	a_1023_379##4	1.09525e-20
C66	VGND#10	a_2342_48#	1.30391e-17
C67	a_231_132##5	a_1023_379#	1.48618e-17
C68	a_644_104##3	a_879_55##11	6.83849e-19
C69	a_879_55##9	a_1023_379##6	3.08191e-19
C70	a_410_58##7	a_231_132##10	9.67544e-18
C71	a_811_379##11	VPWR#9	3.61807e-17
C72	a_1849_374##5	a_2342_48#	8.73e-17
C73	a_83_21##4	a_811_379##3	2.73428e-17
C74	a_644_104##4	a_644_104##3	3.76462e-18
C75	VPWR#6	a_231_132##5	2.09291e-18
C76	a_644_104##3	a_231_132##2	1.58671e-17
C77	VGND#6	a_879_55##9	2.14162e-17
C78	a_811_379##11	a_879_55##13	2.07272e-17
C79	a_2342_48#	VGND#11	1.1611e-18
C80	a_879_55##8	a_1023_379##11	8.48098e-17
C81	a_83_21##4	a_410_58##5	9.91267e-17
C82	a_1660_374##4	VPWR#4	6.73726e-17
C83	a_644_104##5	a_879_55##11	2.92752e-20
C84	a_410_58##5	a_1023_379#	2.04902e-19
C85	VGND#7	a_410_58##2	1.33275e-19
C86	VPWR#6	a_410_58##5	4.3312e-18
C87	a_644_104##5	a_1023_379##6	1.3376e-19
C88	VGND#6	a_644_104##5	6.27926e-18
C89	B#2	a_2342_48##4	4.56812e-17
C90	a_811_379##4	a_1023_379##4	1.31588e-17
C91	VGND#2	A#5	4.59563e-18
C92	a_231_132##5	a_811_379##3	3.20193e-17
C93	a_231_132##6	VPWR#9	5.26996e-18
C94	VGND#6	a_83_21##4	1.03992e-16
C95	a_644_104##3	a_231_132##9	4.72166e-19
C96	a_879_55##11	a_1023_379#	4.84844e-19
C97	a_83_21##4	a_1023_379##6	2.49303e-17
C98	VGND#1	A#1	3.45973e-18
C99	VGND#6	a_231_132##5	4.30906e-18
C100	a_1023_379##8	a_1660_374##4	4.79377e-17
C101	VGND#3	a_2342_48##3	8.17888e-18
C102	a_410_58##5	a_231_132##5	2.49832e-17
C103	a_83_21##4	a_879_55##11	1.65416e-16
C104	a_410_58##5	a_811_379##3	4.97602e-19
C105	VGND#6	a_410_58##5	4.28796e-18
C106	a_2342_48##6	A#1	1.68188e-17
C107	a_644_104##5	a_811_379##4	8.49008e-20
C108	a_1023_379##8	VPWR#9	1.9677e-17
C109	a_879_55##8	a_1660_374##6	5.92456e-17
C110	a_1660_374#	a_879_55##5	8.39247e-19
C111	a_879_55##4	B#2	6.18337e-17
C112	a_410_58##7	a_1023_379##2	1.81078e-19
C113	VGND#6	a_879_55##11	1.39445e-16
C114	a_231_132##5	a_1023_379##6	2.82694e-17
C115	VGND#7	a_83_21#	2.71938e-17
C116	a_231_132#	a_811_379##4	1.2989e-18
C117	a_1023_379##5	a_231_132##6	2.58616e-18
C118	a_879_55##5	a_811_379##8	1.17774e-16
C119	a_1023_379##8	a_879_55##13	4.13102e-17
C120	a_231_132##6	a_879_55##13	7.93554e-17
C121	VGND#6	a_644_104##4	2.99466e-18
C122	a_879_55##11	a_811_379##3	2.65924e-17
C123	a_83_21##4	a_811_379##4	2.85521e-17
C124	a_879_55##5	a_1849_374##4	7.55626e-17
C125	B#4	B#2	3.51772e-19
C126	B#12	a_1849_374##4	1.41428e-17
C127	a_1023_379##6	a_410_58##5	1.60569e-17
C128	a_1023_379##11	a_879_55##5	4.35576e-17
C129	VGND#3	B#1	2.79672e-18
C130	B#4	a_879_55##4	2.90946e-18
C131	a_231_132##5	a_811_379##4	2.38571e-18
C132	a_2342_48##6	A#5	8.91774e-19
C133	VGND#6	a_231_132##9	6.19691e-18
C134	a_1023_379##10	A#5	1.70156e-19
C135	a_811_379##8	B#5	4.97269e-20
C136	a_879_55##11	a_1023_379##6	8.51152e-18
C137	a_83_21##6	a_644_104#	4.89184e-17
C138	a_83_21##4	a_231_132##3	1.33555e-18
C139	a_231_132##6	a_811_379##2	8.25487e-19
C140	a_231_132##6	a_410_58##7	1.18207e-16
C141	VGND#6	VGND#14	1.61341e-17
C142	a_1849_374##4	B#5	6.96128e-18
C143	B#10	a_1849_374##4	1.53957e-17
C144	a_410_58##5	a_879_55##11	2.85035e-18
C145	a_1023_379##10	a_2342_48##3	3.46814e-18
C146	a_410_58##5	a_811_379##4	5.68039e-17
C147	B#5	a_1023_379##11	2.23878e-18
C148	VGND#6	SUM#3	1.63985e-17
C149	a_1023_379##10	B#1	1.80311e-17
C150	VGND#14	VGND#7	5.08103e-19
C151	a_879_55##3	B#4	3.21545e-17
C152	a_83_21##6	VPWR#10	1.66927e-18
C153	a_644_104##6	a_410_58##7	1.88656e-18
C154	VGND#6	a_1023_379##2	3.00726e-18
C155	a_879_55##11	a_811_379##4	3.37883e-17
C156	a_83_21##4	a_410_58##3	1.14656e-19
C157	a_879_55##9	a_879_55##8	1.26092e-18
C158	a_1023_379##10	a_879_55##6	1.79756e-18
C159	a_2342_48##6	a_2342_48##3	2.85811e-19
C160	VGND#6	a_231_132##2	2.06706e-19
C161	a_231_132##4	a_231_132##6	1.83337e-18
C162	a_644_104##4	a_410_58##5	2.85614e-17
C163	a_879_55##2	a_1849_374##4	2.43168e-18
C164	VPWR#3	VPWR#7	1.72272e-18
C165	a_410_58##5	a_231_132##3	2.28486e-18
C166	a_231_132##6	a_231_132##10	1.2854e-17
C167	a_811_379##7	a_879_55##13	9.74489e-18
C168	a_1023_379##10	B#8	3.79867e-19
C169	a_644_104##4	a_811_379##4	2.72999e-19
C170	a_811_379##7	a_410_58##7	4.34714e-17
C171	a_879_55##2	a_1660_374##6	5.04065e-17
C172	a_231_132##6	B#9	2.06805e-18
C173	a_879_55##11	a_231_132##3	3.73304e-19
C174	a_811_379##7	a_231_132##10	3.02788e-18
C175	a_644_104##6	VPWR#10	1.42124e-18
C176	a_644_104##4	a_231_132##2	1.59048e-17
C177	a_879_55##9	a_879_55##2	8.02626e-19
C178	a_811_379##7	a_83_21##6	2.13035e-18
C179	a_83_21##6	a_231_132##7	3.71897e-18
C180	VGND#10	A#4	2.05557e-18
C181	a_231_132##6	a_83_21##6	1.70948e-16
C182	a_231_132##3	a_644_104##4	1.66065e-17
C183	a_811_379##7	a_644_104#	3.23966e-18
C184	a_231_132##2	a_811_379##4	2.68123e-19
C185	a_1849_374##7	VPWR#3	8.46822e-18
C186	a_1023_379##3	B#9	3.81865e-17
C187	VPWR#1	VPWR#2	4.24309e-18
C188	a_811_379##7	VPWR#10	4.31803e-19
C189	a_231_132##6	a_1023_379##3	5.35855e-17
C190	VGND#5	a_879_55#	5.93465e-18
C191	a_644_104##3	a_83_21##6	5.33734e-17
C192	a_231_132##3	VGND#13	2.31414e-17
C193	COUT#1	VPWR#10	6.69453e-17
C194	a_811_379##8	a_1660_374##2	2.15633e-17
C195	VPWR#6	a_410_58##7	1.23023e-17
C196	a_879_55##9	a_1023_379##5	7.13181e-17
C197	a_644_104##3	a_644_104#	1.51067e-17
C198	VPWR#8	a_2342_48#	6.96409e-19
C199	a_83_21##6	a_231_132##2	1.71529e-19
C200	a_2342_48#	A#4	3.24439e-17
C201	a_644_104##5	a_1023_379##5	4.49736e-17
C202	a_1849_374##7	VPWR#2	9.18043e-18
C203	a_231_132##6	a_644_104#	5.01224e-18
C204	a_1660_374#	B#2	2.90396e-20
C205	a_644_104##3	VPWR#10	7.68348e-18
C206	a_811_379#	a_1023_379##3	2.07615e-17
C207	VPWR#6	a_83_21##6	1.07726e-17
C208	a_231_132##7	VPWR#10	2.24234e-17
C209	a_410_58##3	VGND#13	1.64065e-17
C210	VPWR#3	VPWR#8	1.30336e-18
C211	VPWR#6	a_644_104#	1.24196e-18
C212	a_231_132##6	a_811_379#	1.62468e-17
C213	a_811_379##8	B#2	2.36324e-18
C214	a_811_379##8	a_1023_379##9	6.91441e-17
C215	a_1023_379##4	a_1023_379##3	1.91323e-19
C216	a_879_55##9	a_811_379##2	3.67042e-20
C217	a_644_104##3	a_231_132##7	1.6286e-18
C218	VPWR#1	A#6	4.64902e-18
C219	VGND#5	B#7	2.57639e-18
C220	VPWR#6	VPWR#10	2.10108e-16
C221	VGND#4	a_879_55##6	3.41441e-18
C222	a_1660_374##2	a_879_55##5	9.63231e-19
C223	a_231_132##7	COUT#1	1.72697e-16
C224	a_410_58##3	COUT#2	8.73458e-18
C225	a_811_379#	a_1023_379##4	1.20997e-17
C226	a_83_21##4	a_811_379##2	8.06889e-19
C227	VPWR#6	COUT#1	5.67712e-17
C228	a_231_132##6	VPWR#10	1.87687e-16
C229	VGND#4	B#8	3.41441e-18
C230	VGND#6	a_644_104#	5.03318e-19
C231	a_231_132##5	a_811_379##2	8.872e-17
C232	VPWR#6	a_231_132##7	2.92477e-17
C233	a_879_55##5	a_1849_374#	3.10156e-17
C234	a_1849_374##6	VPWR#3	4.52137e-18
C235	a_410_58##5	a_811_379##2	3.06547e-17
C236	a_811_379##8	a_879_55##4	3.19997e-17
C237	a_231_132##9	a_410_58##3	1.1191e-18
C238	a_811_379##8	a_1849_374#	6.34127e-17
C239	a_2342_48##2	A#4	5.49834e-19
C240	a_231_132##6	a_1023_379##4	6.18542e-17
C241	COUT#1	VPWR#12	7.37017e-17
C242	a_644_104#	a_231_132##2	7.17604e-19
C243	a_879_55##11	a_811_379##2	3.8694e-19
C244	a_1660_374##2	VPWR#3	5.7881e-17
C245	a_1849_374##6	A#6	1.50877e-18
C246	VPWR#5	B#3	2.53481e-17
C247	a_811_379##5	a_1023_379##4	5.16547e-18
C248	a_83_21##4	a_231_132##4	6.26549e-18
C249	VGND#5	a_1023_379#	2.7786e-18
C250	VGND#14	a_410_58##3	6.7698e-19
C251	a_1849_374##6	A#7	2.77182e-17
C252	VGND#13	a_83_21##2	3.15111e-19
C253	a_1849_374#	B#5	9.562e-18
C254	COUT#1	a_231_132##6	3.07019e-18
C255	a_879_55##8	B#6	8.81401e-19
C256	a_410_58##5	a_231_132##4	1.21968e-16
C257	a_231_132##9	CI#3	1.77451e-17
C258	a_811_379##8	B#4	4.44246e-19
C259	a_1849_374##6	a_2342_48##4	1.0832e-17
C260	a_1660_374##4	B#5	6.22419e-19
C261	a_644_104##6	a_1023_379#	8.34441e-18
C262	a_231_132##6	a_811_379##5	3.1288e-17
C263	a_231_132#	a_811_379##5	1.59678e-17
C264	a_879_55##5	B#3	1.55324e-18
C265	VGND#1	VGND#2	4.37859e-18
C266	a_1849_374##5	a_2342_48##2	4.13117e-18
C267	a_83_21##4	a_410_58##2	4.92128e-17
C268	a_1849_374##6	B#2	1.56412e-18
C269	CI#3	VGND#14	2.10896e-17
C270	a_879_55##2	a_1849_374#	1.8209e-18
C271	a_1023_379##10	a_2342_48##4	1.75694e-19
C272	a_410_58#	a_811_379##5	2.5985e-19
C273	a_231_132##9	a_83_21##2	2.68196e-18
C274	VGND#5	a_811_379##3	6.90464e-18
C275	a_410_58##2	a_410_58##5	3.89283e-18
C276	a_644_104##6	a_1023_379##6	2.87868e-18
C277	a_1023_379##10	B#2	1.27727e-17
C278	a_1660_374##4	a_879_55##2	3.21691e-17
C279	SUM#3	CI#3	2.24628e-18
C280	VPWR#10	a_231_132##2	5.7105e-20
C281	a_644_104##6	a_811_379##4	1.73186e-19
C282	a_410_58#	a_231_132#	2.14178e-17
C283	a_410_58##2	a_644_104##4	7.30184e-17
C284	a_1023_379##10	a_879_55##4	5.0672e-18
C285	a_231_132##6	a_231_132#	1.7675e-17
C286	VGND#14	a_83_21##2	2.61369e-17
C287	a_83_21#	a_83_21##4	1.23522e-18
C288	a_410_58##2	VGND#13	7.33541e-18
C289	a_1849_374##3	B#2	3.63691e-18
C290	VGND#1	a_2342_48##6	8.05607e-19
C291	VGND#14	VGND#13	1.58854e-18
C292	a_1849_374##3	VPWR#3	6.45632e-19
C293	a_1023_379##10	B#4	1.32047e-18
C294	a_1849_374##3	a_879_55##4	1.10727e-18
C295	SUM#3	a_83_21##2	3.54068e-17
C296	VGND#10	a_2342_48##8	5.38483e-17
C297	a_811_379##11	B#2	8.75126e-19
C298	CI#1	a_410_58#	1.80166e-18
C299	a_2342_48#	A#5	2.52191e-17
C300	B#5	B#3	9.4048e-19
C301	a_811_379##11	a_879_55##4	2.54519e-19
C302	a_2342_48##2	VGND#11	1.9172e-18
C303	a_2342_48#	a_2342_48##3	1.97764e-19
C304	a_83_21#	VGND#13	6.9912e-17
C305	a_644_104##3	a_811_379##4	2.33905e-19
C306	a_2342_48##5	A#4	1.72959e-18
C307	a_2342_48##6	a_2342_48##5	2.81505e-18
C308	a_231_132##6	a_410_58#	1.21078e-18
C309	VPWR#4	B#2	1.35003e-17
C310	VGND#3	a_1023_379##10	1.10414e-17
C311	a_644_104##3	a_231_132##3	3.43274e-18
C312	a_811_379##11	VPWR#5	2.5252e-18
C313	a_811_379##11	B#4	4.80254e-17
C314	a_1849_374##6	a_2342_48##6	3.35222e-19
C315	a_231_132##9	a_83_21#	8.42304e-17
C316	a_879_55##8	B#10	1.49476e-17
C317	a_879_55##8	a_879_55##6	6.16358e-19
C318	VPWR#4	a_879_55##4	1.21312e-18
C319	a_83_21##3	CI#1	2.02597e-17
C320	VGND#14	a_83_21#	3.53857e-18
C321	VGND#6	a_811_379##3	7.91572e-18
C322	a_811_379##11	a_879_55##3	1.5645e-17
C323	SUM#3	a_83_21#	2.03911e-19
C324	a_811_379##2	a_410_58##7	5.3292e-18
C325	a_879_55##5	B#1	1.00065e-17
C326	VGND#6	a_1023_379##6	1.73578e-18
C327	a_410_58##7	a_1023_379#	1.02734e-19
C328	a_811_379##11	B#9	3.62439e-18
C329	A	A#4	2.94745e-17
C330	a_1660_374##6	a_1660_374##4	1.76613e-18
C331	a_879_55##5	a_879_55##6	1.69301e-17
C332	VGND#6	a_811_379##4	1.3146e-17
C333	A	a_2342_48##2	2.04431e-19
C334	a_231_132##9	CI#2	7.12742e-18
C335	a_879_55##9	a_231_132##6	4.2879e-19
C336	a_879_55##5	B#8	7.48167e-19
C337	VGND#6	a_231_132##3	2.91216e-18
C338	a_1660_374##4	VPWR#5	5.7747e-17
C339	B#6	a_879_55##2	1.62246e-17
C340	a_879_55##8	B#8	2.96442e-17
C341	a_1849_374##5	VGND#10	5.43745e-17
C342	A#5	A#1	2.7356e-17
C343	a_410_58##7	a_811_379##3	3.26868e-20
C344	a_879_55##5	a_879_55#	1.31679e-19
C345	VGND#6	a_410_58##3	9.75046e-18
C346	a_879_55##2	B#3	1.30295e-18
C347	a_2342_48##5	A#6	4.45168e-17
C348	a_1660_374#	a_2342_48##2	8.00732e-18
C349	a_1023_379##8	B#9	4.94336e-19
C350	VGND#6	CI#3	4.35037e-18
C351	VPWR#7	A#4	3.91215e-18
C352	a_231_132##4	a_83_21##6	1.40246e-17
C353	VGND#3	VGND#2	4.45773e-19
C354	a_231_132##4	a_644_104#	4.07857e-17
C355	a_879_55#	B#5	5.40707e-18
C356	VGND#6	a_83_21##2	1.69274e-17
C357	a_1023_379##8	a_1023_379##3	8.44131e-18
C358	A#6	VPWR#7	2.75305e-17
C359	a_879_55##2	a_879_55##6	1.42487e-19
C360	VPWR#10	a_231_132##4	6.75298e-20
C361	a_1023_379##8	a_811_379#	1.59403e-18
C362	a_879_55##9	a_1660_374##4	7.48047e-19
C363	SUM#3	VGND#14	1.04605e-17
C364	VGND#11	VGND#10	1.74692e-18
C365	a_2342_48##5	A#7	2.96778e-18
C366	a_879_55##2	B#8	7.98836e-19
C367	a_879_55##8	a_879_55#	1.98863e-17
C368	a_1849_374##7	A#6	1.17781e-18
C369	a_879_55##2	a_879_55#	2.57383e-18
C370	a_410_58##2	a_644_104#	3.75464e-19
C371	a_1023_379##8	VPWR#5	9.17075e-19
C372	a_2342_48##3	A#5	3.88014e-18
C373	VGND#7	a_410_58##3	4.55283e-18
C374	B#7	a_879_55##2	5.90969e-19
C375	VPWR#10	a_410_58##2	7.89888e-20
C376	A#7	VPWR#7	3.18729e-17
C377	a_644_104##6	a_1023_379##3	1.88804e-18
C378	COUT#1	a_410_58##2	5.63979e-19
C379	VPWR#8	A#6	7.08636e-20
C380	a_231_132##5	B#9	5.37506e-20
C381	a_1023_379##5	B#6	2.23795e-19
C382	a_2342_48##5	a_2342_48##4	1.53987e-19
C383	a_83_21##6	a_83_21#	4.2434e-20
C384	a_644_104##6	a_811_379#	6.74636e-18
C385	a_879_55##9	VPWR#9	4.91435e-18
C386	a_231_132##7	a_410_58##2	7.96418e-19
C387	a_1849_374##5	VGND#11	5.65697e-17
C388	a_811_379##7	a_1023_379##3	2.49183e-18
C389	a_83_21#	a_644_104#	1.69492e-20
C390	a_1849_374##7	A#7	4.91868e-17
C391	a_1023_379##5	B#7	1.53704e-18
C392	a_644_104##6	a_1023_379##4	2.18191e-18
C393	a_83_21#	VPWR#10	3.4751e-18
C394	a_1023_379##5	a_1023_379##2	2.76552e-17
C395	a_879_55##9	a_811_379#	1.52977e-19
C396	a_879_55##8	B#7	7.07817e-19
C397	a_1023_379##5	a_1023_379#	9.85833e-19
C398	a_811_379##7	a_811_379#	8.93499e-19
C399	VPWR#7	a_2342_48##4	3.80058e-19
C400	a_83_21#	COUT#1	6.63519e-18
C401	a_879_55##13	VPWR#5	1.45152e-17
C402	VPWR#8	A#7	1.47558e-18
C403	a_231_132##7	a_83_21#	1.94756e-16
C404	a_811_379##7	a_1023_379##4	1.26584e-17
C405	B#1	a_2342_48##3	2.61809e-17
C406	B#12	B#3	2.18571e-20
C407	a_811_379##4	a_83_21##6	3.83835e-18
C408	a_231_132##5	a_1023_379##3	1.05394e-18
C409	a_1023_379##10	a_1849_374##6	2.71264e-18
C410	a_879_55##9	a_879_55##13	6.64937e-19
C411	a_1849_374##7	a_2342_48##4	1.00074e-18
C412	a_1023_379##10	a_879_55##8	2.18998e-18
C413	a_1849_374##6	A#4	5.51108e-18
C414	a_231_132##5	a_231_132##6	5.68765e-19
C415	a_811_379##2	a_1023_379#	7.97948e-18
C416	a_811_379##7	a_811_379##5	8.5424e-19
C417	a_1660_374#	a_1849_374##5	4.71054e-17
C418	a_1660_374##2	A#7	3.84824e-19
C419	a_811_379##3	a_811_379##2	1.21831e-18
C420	a_83_21##4	a_811_379#	1.85781e-19
C421	a_410_58##5	a_1023_379##3	1.46602e-19
C422	a_811_379##7	a_231_132#	1.98127e-19
C423	a_1023_379##8	VGND#5	3.4369e-18
C424	a_231_132##7	CI#2	1.57691e-18
C425	a_811_379##2	a_1023_379##6	2.76335e-17
C426	a_644_104##3	a_811_379##5	1.57138e-18
C427	a_2342_48##4	VPWR#8	2.04687e-17
C428	a_83_21##6	a_231_132##3	3.04188e-19
C429	a_1023_379##10	a_1849_374##3	1.53826e-16
C430	CI#2	VPWR#12	3.14895e-19
C431	a_879_55##5	B#2	5.75176e-18
C432	a_811_379##2	a_811_379##4	7.45837e-19
C433	B#10	a_879_55#	1.31411e-19
C434	a_1849_374##6	a_2342_48##2	9.26523e-18
C435	a_231_132##5	a_811_379#	2.76373e-17
C436	a_644_104##3	a_231_132#	1.81995e-17
C437	VGND#6	a_811_379#	1.21145e-19
C438	VPWR#6	a_811_379##5	8.53698e-19
C439	VPWR#10	a_811_379##4	1.03267e-19
C440	a_1023_379##10	a_811_379##11	2.08533e-17
C441	a_1660_374##2	a_2342_48##4	6.88686e-17
C442	a_879_55##6	B#1	3.33915e-18
C443	a_231_132##4	a_1023_379##6	6.25462e-19
C444	a_644_104##3	a_410_58#	6.4084e-18
C445	a_1023_379##10	B#12	1.54283e-17
C446	VGND#7	a_83_21##2	6.17111e-18
C447	a_1660_374#	VGND#11	2.58924e-17
C448	a_410_58##5	a_231_132##6	6.93988e-17
C449	VPWR#6	a_231_132#	2.54745e-18
C450	a_410_58##5	a_811_379#	5.77729e-19
C451	a_83_21##4	a_1023_379##4	1.15798e-19
C452	a_811_379##2	a_1023_379##2	9.78812e-19
C453	a_231_132##4	a_811_379##4	4.07689e-17
C454	VGND#3	a_1849_374##5	9.01027e-18
C455	a_811_379##11	a_1849_374##3	1.26555e-17
C456	VGND#6	a_811_379##5	8.67058e-20
C457	B#5	a_879_55##4	3.62819e-19
C458	VPWR#7	a_2342_48##5	8.6597e-17
C459	VPWR#6	a_410_58#	1.31555e-18
C460	a_1023_379##9	a_2342_48##4	8.56647e-19
C461	VPWR#3	A#6	5.02065e-19
C462	VPWR#10	a_231_132##3	3.04232e-19
C463	a_231_132##5	a_1023_379##4	1.75515e-18
C464	a_2342_48##4	A#4	1.35328e-18
C465	a_1660_374##2	B#2	7.84829e-17
C466	a_410_58##2	a_811_379##4	3.25148e-19
C467	a_879_55##2	a_879_55##4	5.17387e-20
C468	VGND#4	a_1023_379##10	2.85248e-17
C469	a_410_58##2	a_231_132##3	4.74581e-17
C470	VPWR#6	a_83_21##3	5.93278e-18
C471	VPWR#2	A#6	4.80742e-18
C472	a_410_58##5	a_1023_379##4	3.50864e-17
C473	a_879_55##2	B#4	3.65073e-18
C474	a_83_21##4	a_811_379##5	3.07416e-19
C475	a_231_132##5	a_879_55##13	1.34439e-18
C476	a_410_58##2	a_410_58##3	1.93785e-18
C477	VGND#2	a_1849_374##5	1.05663e-17
C478	B#2	a_1023_379##9	1.79619e-17
C479	B#8	a_879_55##6	1.79538e-17
C480	a_879_55##8	a_811_379##11	1.06682e-18
C481	a_1023_379##8	a_811_379##11	1.59602e-16
C482	VPWR#10	a_410_58##3	3.48283e-20
C483	a_83_21##4	a_410_58##7	1.65488e-19
C484	a_811_379##7	VPWR#5	1.4262e-18
C485	a_83_21#	a_811_379##4	1.61041e-19
C486	a_879_55##11	a_1023_379##4	8.98702e-20
C487	a_1660_374##2	a_879_55##4	7.95719e-18
C488	a_83_21#	a_231_132##3	2.90579e-17
C489	a_1023_379##10	a_2342_48##2	8.84236e-19
C490	a_2342_48##8	A#1	2.72099e-17
C491	A	VPWR#2	6.60045e-19
C492	VGND#5	B#6	9.96057e-20
C493	VGND#2	a_2342_48##6	4.19048e-19
C494	a_231_132##7	a_231_132##3	1.60446e-19
C495	a_1849_374#	B#2	3.32674e-19
C496	a_83_21#	a_410_58##3	9.44822e-17
C497	a_2342_48##6	a_2342_48##8	1.57428e-19
C498	VPWR#3	A#7	1.65778e-18
C499	COUT#1	a_410_58##3	6.37601e-20
C500	a_644_104##6	VGND#5	1.3469e-18
C501	VPWR#8	a_2342_48##2	4.21774e-19
C502	CI#3	a_83_21#	2.40215e-17
C503	a_410_58##5	a_811_379##5	9.69107e-19
C504	a_879_55##4	a_1023_379##9	2.10278e-17
C505	a_1849_374##7	VPWR#7	5.5404e-17
C506	a_231_132##5	a_410_58##7	4.81166e-17
C507	a_83_21##2	a_83_21#	2.12319e-18
C508	a_1660_374##2	A#4	3.22351e-19
C509	a_1023_379##5	a_1023_379##3	2.26607e-19
C510	VGND#3	a_2342_48##2	1.14992e-19
C511	A#1	VGND#10	2.28702e-17
C512	B#12	a_811_379##11	1.28245e-18
C513	a_231_132##4	a_231_132##2	9.22456e-19
C514	VPWR#2	A#7	7.63367e-18
C515	a_2342_48##6	A	7.01114e-17
C516	a_879_55##11	a_811_379##5	1.57377e-19
C517	a_231_132##7	a_410_58##3	1.9093e-19
C518	VGND#11	VGND#2	3.85893e-19
C519	a_879_55#	B#8	1.05303e-17
C520	a_879_55##4	a_1849_374#	3.47756e-17
C521	a_644_104##6	a_1023_379##8	5.5297e-17
C522	a_2342_48##8	A#5	1.45697e-18
C523	a_1023_379##2	B#6	9.01463e-18
C524	a_83_21##2	CI#2	8.07046e-18
C525	VGND#3	a_1660_374#	1.78482e-17
C526	VPWR#8	VPWR#7	4.2189e-19
C527	a_1023_379##8	a_811_379##7	5.63007e-17
C528	a_1849_374##5	A#1	2.38577e-19
C529	a_231_132##5	a_231_132##10	2.57895e-18
C530	VGND#10	a_2342_48##6	2.84592e-17
C531	VGND#1	a_2342_48##8	4.40704e-17
C532	VPWR#3	a_2342_48##4	1.33274e-17
C533	a_811_379##2	a_1023_379##4	1.96016e-17
C534	a_1849_374##6	a_2342_48#	8.18359e-17
C535	A#5	VGND#10	2.691e-17
C536	B#4	a_1849_374#	1.39014e-17
C537	a_644_104##6	a_811_379##7	1.39219e-16
C538	a_231_132##4	a_1023_379##4	1.32564e-18
C539	B#2	a_2342_48##2	7.96338e-18
C540	VGND#11	A#1	5.62618e-19
C541	a_1023_379##8	a_879_55##8	1.01027e-18
C542	VPWR#2	a_2342_48##4	2.98503e-19
C543	VPWR#8	a_1849_374##7	4.96982e-17
C544	B#7	a_879_55#	4.32304e-18
C545	a_231_132##4	a_811_379##5	2.7809e-17
C546	a_1660_374##2	a_2342_48##2	7.33533e-18
C547	a_231_132##7	a_83_21##2	2.21709e-19
C548	B#4	a_811_379##9	1.95222e-17
C549	a_1023_379##10	a_879_55##5	2.33307e-17
C550	A#5	a_1849_374##5	2.12396e-17
C551	a_231_132##4	a_231_132#	6.72023e-20
C552	VPWR#6	VPWR#5	7.02683e-17
C553	a_1849_374##3	a_879_55##5	1.7314e-18
C554	a_644_104##6	VPWR#6	9.32481e-18
C555	VGND#5	a_1023_379##2	1.14123e-18
C556	a_410_58##2	a_231_132##2	1.04017e-17
C557	a_1023_379##10	B#5	3.01071e-18
C558	a_1849_374##5	a_2342_48##6	9.76628e-19
C559	VGND#10	a_2342_48##3	9.87108e-19
C560	a_1660_374##4	B#4	3.03498e-18
C561	VPWR#12	a_83_21##2	1.25888e-18
C562	a_811_379##11	a_879_55##5	1.66041e-18
C563	a_410_58##2	a_231_132#	1.82884e-19
C564	a_811_379##7	VPWR#6	3.55488e-17
C565	VPWR#3	B#2	1.06757e-17
C566	VGND#6	a_644_104##6	3.16436e-17
C567	VGND#11	A#5	2.30477e-18
C568	B#3	B#2	4.94397e-20
C569	a_879_55##3	a_811_379##9	2.77225e-19
C570	a_410_58##5	a_83_21##6	2.46992e-18
C571	a_83_21#	a_811_379##5	2.46554e-20
C572	a_644_104##3	VPWR#6	3.24056e-17
C573	a_811_379##11	B#5	7.47722e-19
C574	a_1849_374##5	a_1849_374##6	5.98642e-18
C575	a_83_21#	a_231_132#	5.61524e-19
C576	a_1660_374##6	B#6	1.29671e-18
C577	VPWR#2	B#2	2.51007e-20
C578	a_231_132##6	a_1023_379#	6.74249e-20
C579	a_1849_374##5	a_2342_48##3	9.33635e-18
C580	a_1023_379##11	a_811_379##8	2.31238e-17
C581	a_1023_379#	B#7	1.11611e-18
C582	VGND#6	a_644_104##3	3.12665e-17
C583	a_83_21#	a_410_58#	4.39308e-17
C584	a_879_55##2	a_811_379##11	2.94489e-17
C585	a_1660_374##4	a_879_55##3	4.74281e-17
C586	VGND#4	a_879_55##5	2.74266e-19
C587	a_1849_374##6	VGND#11	3.80767e-18
C588	CI#1	a_83_21#	1.75265e-17
C589	a_1660_374#	A#5	4.06076e-19
C590	a_1660_374##2	VPWR#8	6.53341e-17
C591	a_1660_374##2	B#3	8.73962e-18
C592	VGND#4	B#5	2.27343e-19
C593	a_1660_374#	a_1849_374##6	1.44018e-17
C594	a_1023_379##8	a_879_55##2	3.15317e-17
C595	a_2342_48##3	VGND#11	2.3768e-17
C596	VGND#5	a_1023_379##11	1.18135e-17
C597	a_811_379##3	B#7	3.99457e-19
C598	B#1	a_2342_48##2	1.12766e-17
C599	a_811_379##11	B#6	1.97679e-18
C600	a_83_21##3	CI#2	6.70017e-18
C601	a_1660_374##6	B#3	2.9297e-20
C602	a_1023_379##8	a_1023_379##5	2.91444e-18
C603	a_1660_374##4	B#9	3.81142e-19
C604	a_83_21#	a_231_132##2	9.76165e-19
C605	a_811_379##11	B#3	6.34944e-18
C606	a_1023_379##10	VGND#11	3.65471e-18
C607	a_1023_379##8	a_811_379##2	2.32762e-19
C608	a_811_379##3	a_1023_379#	2.95685e-17
C609	a_1660_374#	a_2342_48##3	4.47848e-17
C610	A	a_2342_48##5	1.09588e-17
C611	a_644_104##6	a_1023_379##5	1.18644e-17
C612	B#9	VPWR#9	3.38196e-17
C613	A	VPWR#7	4.22496e-17
C614	a_1023_379##10	a_1660_374#	7.13687e-17
C615	a_811_379##7	a_1023_379##5	3.55308e-18
C616	a_1023_379##8	a_231_132##6	2.78471e-17
C617	VGND#11	B#1	5.99546e-19
C618	a_644_104##6	a_811_379##2	2.55902e-17
C619	a_1660_374##4	a_1023_379##3	1.92143e-19
C620	VGND#6	VGND#7	8.46346e-17
C621	VGND#12	B#6	9.9158e-19
C622	a_1660_374##6	a_1023_379##2	1.19316e-18
C623	a_879_55##13	B#9	6.32397e-17
C624	a_811_379##7	a_811_379##2	6.24382e-18
C625	a_1023_379##10	a_811_379##8	1.64013e-16
C626	a_231_132##9	CI	4.56739e-17
C627	a_644_104##6	a_231_132##4	2.03774e-17
C628	a_1023_379##9	a_1660_374##2	7.36259e-17
C629	VGND#7	COUT	1.7789e-17
C630	a_644_104##4	a_644_104#	7.8331e-19
C631	VGND#6	VGND#5	6.09983e-17
C632	VGND	a_2342_48##2	1.4366e-19
C633	VPWR#9	a_1023_379##3	1.51749e-18
C634	VGND	B#6	4.38e-20
C635	a_811_379##7	a_231_132##4	1.16432e-18
C636	VGND	a_1023_379##2	2.48275e-19
C637	VGND#6	a_1023_379##5	2.22602e-18
C638	a_1660_374#	B#1	2.28462e-17
C639	VPWR#6	a_811_379##2	7.42519e-19
C640	a_644_104##3	a_231_132##4	7.0947e-17
C641	a_2342_48##6	A#4	2.49572e-17
C642	a_811_379##3	a_1023_379##6	4.49349e-17
C643	B#5	a_879_55##5	9.39657e-18
C644	VGND#6	a_811_379##2	2.31557e-18
C645	a_879_55##13	a_1023_379##3	2.12274e-17
C646	VPWR#6	a_231_132##4	1.70811e-18
C647	VGND#11	a_879_55##6	5.86125e-20
C648	a_1023_379##10	a_1023_379##11	1.85573e-18
C649	a_410_58##2	a_644_104##3	4.57129e-17
C650	a_879_55##2	a_879_55##5	2.52106e-20
C651	VGND#6	a_231_132##4	5.32431e-18
C652	VPWR#6	a_410_58##2	4.66861e-18
C653	a_1849_374##3	a_811_379##8	2.23994e-17
C654	a_879_55##2	B#5	4.01671e-17
C655	B#1	a_811_379##8	2.96316e-18
C656	VPWR#5	a_879_55##3	1.1407e-18
C657	a_83_21#	a_644_104##3	2.97494e-17
C658	VPWR#4	B#3	3.25916e-17
C659	a_811_379##4	a_811_379##3	9.87538e-19
C660	a_1023_379##3	a_410_58##7	3.55668e-17
C661	VGND#6	a_410_58##2	1.74007e-17
C662	VPWR	VPWR#5	1.35294e-16
C663	VPWR	VPWR#3	1.06449e-16
C664	VPWR#6	a_83_21#	1.33461e-17
C665	VPWR	VPWR#2	6.10252e-17
C666	a_231_132##6	a_811_379##4	1.26111e-17
C667	a_644_104##3	CI#2	4.89816e-21
C668	a_1660_374#	a_879_55##6	5.57787e-19
C669	a_2342_48##6	a_2342_48##4	4.72875e-20
C670	a_879_55##8	a_1849_374#	6.10553e-19
C671	VPWR#3	a_2342_48#	2.1826e-19
C672	a_879_55##13	a_811_379#	4.04199e-19
C673	VGND#6	a_83_21#	9.70954e-17
C674	CI	COUT#1	6.92588e-19
C675	B#3	B#4	2.85968e-19
C676	CI	a_231_132##7	1.96736e-17
C677	a_811_379##4	a_1023_379##6	3.47812e-17
C678	a_879_55##9	B#6	1.29991e-17
C679	a_644_104##6	a_231_132##6	2.49517e-18
C680	SUM	SUM#3	3.33789e-20
C681	a_410_58##7	a_811_379#	5.19642e-17
C682	a_811_379##8	a_811_379##11	1.84086e-18
C683	VGND#12	a_1023_379##11	5.18494e-18
C684	a_879_55##6	a_811_379##8	2.3445e-17
C685	A#4	VNB	7.74325e-17
C686	a_2342_48##2	VNB	2.58837e-17
C687	VPWR	B#12	2.11251e-18
C688	B#6	VNB	9.49552e-17
C689	B#3	VNB	1.9021e-16
C690	a_1023_379##2	VNB	8.77341e-17
C691	a_231_132##2	VNB	2.673e-17
C692	a_1849_374#	B#3	3.65892e-18
C693	a_811_379#	a_231_132##10	2.43327e-17
C694	VPWR	a_231_132##6	1.19694e-17
C695	VPWR#5	B#9	1.51694e-18
C696	a_231_132##6	a_231_132##3	7.69396e-20
C697	VGND#5	a_879_55##8	1.25026e-17
C698	COUT	VGND#13	2.82336e-17
C699	VGND#5	a_879_55##9	1.12471e-16
C700	COUT	COUT#2	2.67852e-18
C701	COUT	a_231_132##9	6.3062e-17
C702	a_879_55##6	a_1849_374##4	1.88212e-17
C703	a_410_58##7	a_1023_379##4	4.43221e-18
C704	a_1023_379##8	B#6	2.82841e-18
C705	COUT	VGND#14	4.56116e-17
C706	A	a_2342_48##4	1.45308e-19
C707	VGND	VGND#5	1.22639e-16
C708	SUM#3	COUT	4.12709e-17
C709	VGND	VGND#3	8.77066e-17
C710	VGND	VGND#2	4.9217e-17
C711	a_410_58##2	a_231_132##4	2.86531e-18
C712	a_231_132##3	a_811_379##4	1.45035e-18
C713	VGND	a_2342_48##6	1.54377e-18
C714	SUM	COUT#1	2.84521e-18
C715	VPWR	a_811_379##8	1.37424e-18
C716	CI	a_83_21##2	7.07301e-19
C717	B#6	a_879_55##3	2.37993e-17
C718	VGND#3	a_2342_48#	4.24942e-19
C719	a_811_379##7	a_231_132##6	2.76293e-17
C720	a_811_379##11	a_1660_374##6	2.35126e-19
C721	SUM	VPWR#12	5.66428e-17
C722	SUM	SUM#1	5.91619e-18
C723	a_1023_379##4	a_231_132##10	2.47945e-17
C724	a_231_132##6	B#3	6.87721e-19
C725	VGND	a_879_55##8	2.33846e-17
C726	a_83_21#	a_410_58##2	1.91416e-16
C727	VGND#2	a_2342_48#	4.79699e-19
C728	a_1023_379##11	a_879_55##6	1.22034e-17
C729	VGND	B#10	3.3436e-18
C730	a_1023_379##8	a_1023_379##2	8.66209e-18
C731	B#3	a_879_55##3	1.71263e-17
C732	a_1023_379##4	a_83_21##6	3.09866e-17
C733	CI#2	a_83_21#	2.1502e-17
C734	B#8	a_1849_374##4	2.15402e-17
C735	a_2342_48##5	VPWR#1	4.29322e-17
C736	COUT	a_231_132##7	2.33941e-17
C737	a_879_55##9	a_1023_379##2	2.3834e-17
C738	a_811_379##11	a_879_55##9	1.46597e-18
C739	COUT	VPWR#12	2.24604e-17
C740	VPWR#5	a_1023_379##3	2.42987e-17
C741	VPWR	a_1849_374##7	1.76566e-17
C742	B#12	a_1849_374#	1.88337e-17
C743	VGND	VGND#10	2.22566e-17
C744	VGND	a_1849_374##5	2.1851e-17
C745	VPWR	a_1660_374##2	5.75353e-17
C746	VGND	VGND#11	1.88827e-17
C747	VPWR	a_1023_379##9	9.47171e-19
C748	VPWR#5	VNB	9.30565e-17
C749	VGND	a_1660_374#	2.1148e-17
C750	VPWR#3	VNB	4.80004e-17
C751	a_879_55##9	a_1660_374##6	2.00167e-17
C752	VPWR	a_1849_374#	9.96576e-18
C753	VPWR#2	VNB	2.38927e-17
C754	VGND	a_811_379##8	5.72462e-18
C755	VGND	a_1849_374##4	5.44416e-18
C756	SUM	CI#3	1.30054e-19
C757	VGND	a_1023_379##11	5.91645e-17
C758	VPWR	a_1660_374##4	6.2152e-17
C759	A	VPWR#1	1.34158e-18
C760	VGND#7	VNB	4.00908e-17
C761	a_2342_48#	a_2342_48##6	1.88371e-18
C762	a_410_58##3	a_231_132##3	4.30417e-18
C763	VGND#5	VNB	1.07979e-16
C764	VGND	a_1660_374##6	6.11873e-18
C765	SUM	a_83_21##2	1.01e-17
C766	VGND#3	VNB	4.91409e-17
C767	VGND	VGND#12	1.7192e-17
C768	a_644_104##3	a_231_132##6	3.26757e-18
C769	VGND#2	VNB	2.69345e-17
C770	VPWR	a_879_55##13	1.69853e-17
C771	VGND#1	A	6.80427e-19
C772	a_1660_374##4	a_1849_374#	1.91411e-18
C773	VGND	a_879_55##9	3.98964e-17
C774	a_2342_48##6	VNB	4.20312e-17
C775	a_1849_374##6	A	2.59404e-17
C776	a_231_132##7	COUT#2	2.40685e-19
C777	CI	a_83_21##3	3.1509e-19
C778	a_1023_379##10	A	1.6818e-18
C779	a_1023_379##11	B#8	1.87838e-17
C780	a_231_132##6	a_1023_379##2	2.31628e-18
C781	a_83_21##6	a_811_379##5	5.88099e-17
C782	a_879_55##8	VNB	2.28735e-18
C783	B#12	VNB	6.74487e-19
C784	COUT	a_231_132##3	3.55428e-19
C785	VPWR#10	a_1023_379##4	1.27405e-17
C786	B#10	VNB	2.49057e-18
C787	COUT	a_410_58##3	1.71954e-17
C788	COUT	CI#3	3.60624e-17
C789	a_231_132##6	VNB	3.54436e-17
C790	COUT	a_83_21##2	2.43504e-17
C791	a_1849_374##4	a_879_55#	1.44852e-18
C792	a_1023_379##8	a_1023_379##11	2.32306e-19
C793	VGND	a_1849_374#	2.75797e-18
C794	a_811_379##5	a_644_104#	2.93101e-17
C795	VGND	a_1660_374##4	4.34003e-19
C796	a_2342_48##8	VNB	3.05423e-17
C797	VGND	VPWR#9	5.08689e-18
C798	VGND#10	VNB	3.95068e-18
C799	a_1849_374##5	VNB	9.64387e-18
C800	B#9	B#6	2.2153e-17
C801	a_879_55##9	VGND#12	6.27903e-17
C802	VGND#11	VNB	5.03546e-18
C803	a_1660_374#	VNB	5.49165e-18
C804	a_811_379##8	VNB	5.41431e-18
C805	a_231_132##9	a_231_132##7	2.24424e-18
C806	a_1849_374##4	VNB	4.58121e-18
C807	a_1023_379##8	a_1660_374##6	2.41443e-18
C808	a_1023_379##11	VNB	2.00131e-17
C809	SUM	CI#1	1.00275e-18
C810	a_1660_374##6	VNB	7.13822e-18
C811	VGND#12	VNB	4.95893e-18
C812	a_83_21##6	a_231_132#	1.89728e-17
C813	a_879_55##9	VNB	2.92002e-17
C814	SUM	a_83_21##3	4.45035e-17
C815	VPWR#5	a_811_379#	1.18859e-18
C816	a_644_104##5	VNB	6.47739e-19
C817	a_83_21##4	VNB	2.12863e-17
C818	a_231_132##5	VNB	2.90159e-18
C819	VPWR#5	a_879_55##2	4.13539e-19
C820	a_410_58##5	VNB	1.51303e-17
C821	a_879_55##11	VNB	1.75592e-17
C822	VPWR#6	a_231_132##6	1.21888e-16
C823	VPWR#10	a_811_379##5	5.42768e-18
C824	a_644_104##4	VNB	2.51065e-18
C825	VGND	A#5	7.20167e-19
C826	VGND#13	VNB	1.43171e-18
C827	VPWR	A#6	2.22264e-19
C828	VGND	a_2342_48##3	5.22539e-18
C829	a_879_55#	a_1023_379##11	2.70911e-17
C830	VPWR	A#7	2.69548e-18
C831	a_2342_48#	A	2.96517e-17
C832	VGND	B#1	5.88529e-18
C833	a_1023_379##8	VGND#12	7.52058e-19
C834	VGND#14	VNB	8.48456e-18
C835	VPWR#6	CI	2.68704e-18
C836	VPWR	a_2342_48##4	2.34947e-18
C837	SUM#3	VNB	3.52212e-17
C838	B#9	B#3	1.23756e-17
C839	a_1849_374##6	a_2342_48##5	5.08987e-18
C840	a_2342_48##5	VNB	5.22644e-17
C841	VPWR#7	VNB	3.25964e-18
C842	VGND#6	CI	3.33677e-18
C843	a_1660_374##4	B#6	3.39808e-17
C844	a_231_132##6	a_231_132##2	1.07256e-19
C845	VGND	a_879_55#	8.10106e-18
C846	a_1849_374##7	VNB	1.00478e-17
C847	COUT	CI#1	9.50004e-18
C848	VGND	B#7	1.70128e-19
C849	VPWR#8	VNB	7.83613e-18
C850	a_1660_374##2	VNB	2.67431e-17
C851	COUT	a_83_21##3	9.22039e-18
C852	a_231_132#	a_644_104#	2.47048e-17
C853	a_1023_379##9	VNB	1.07833e-18
C854	a_1849_374#	VNB	9.2718e-18
C855	VPWR	B#9	4.25301e-18
C856	VGND#12	B#8	3.90861e-19
C857	a_1660_374##4	VNB	1.54233e-17
C858	VPWR#9	VNB	1.64049e-17
C859	VGND#4	a_1023_379##11	1.19045e-16
C860	a_879_55##13	VNB	2.79936e-18
C861	a_644_104##5	a_1023_379##2	8.27327e-18
C862	a_1023_379##8	a_879_55##9	1.75497e-17
C863	COUT#1	a_811_379##5	9.96646e-20
C864	a_644_104#	VNB	2.03957e-18
C865	a_1849_374##6	VPWR#7	2.28534e-17
C866	VPWR#10	VNB	1.18004e-16
C867	COUT#1	VNB	2.17601e-17
C868	a_83_21##6	a_410_58#	1.76969e-18
C869	a_231_132##7	VNB	1.26715e-17
C870	VPWR#12	VNB	1.86738e-18
C871	A#1	VNB	3.53649e-17
C872	VPWR#6	SUM	1.9296e-17
C873	a_879_55#	a_1660_374##6	2.70217e-17
C874	A#5	VNB	3.55378e-17
C875	a_231_132#	VPWR#10	2.98609e-17
C876	a_2342_48##3	VNB	3.95284e-17
C877	B#1	VNB	4.55561e-17
C878	a_879_55##6	VNB	2.91093e-17
C879	B#8	VNB	2.94675e-17
C880	a_879_55#	VNB	3.70743e-17
C881	a_1849_374##6	VPWR	3.08341e-17
C882	B#7	VNB	4.14621e-17
C883	a_231_132##7	a_811_379##5	2.58149e-19
C884	a_1023_379#	VNB	4.50636e-17
C885	a_1023_379##10	VPWR	1.21996e-17
C886	a_811_379##3	VNB	7.66206e-17
C887	a_1849_374##6	a_1849_374##7	1.45688e-18
C888	a_1023_379##6	VNB	3.43012e-17
C889	a_1849_374##3	VPWR	3.72452e-17
C890	a_811_379##4	VNB	1.05447e-16
C891	CI	a_83_21#	1.82176e-18
C892	a_811_379##11	VPWR	6.24409e-17
C893	a_1660_374##4	B#3	6.0016e-17
C894	a_231_132##3	VNB	4.8814e-17
C895	VPWR#6	COUT	3.15914e-18
C896	a_879_55##9	B#8	2.71988e-19
C897	a_410_58##3	VNB	4.23294e-17
C898	VPWR	VPWR#4	1.2223e-16
C899	CI#3	VNB	2.42567e-17
C900	VGND#6	COUT	3.60163e-17
C901	CI	CI#2	2.11837e-17
C902	a_1023_379##11	B#7	1.90904e-18
C903	a_83_21##2	VNB	1.28971e-16
C904	a_83_21##2	CI#3	2.99326e-17
C905	A#6	VNB	3.64853e-17
C906	A#7	VNB	4.05966e-17
C907	COUT#1	a_231_132#	1.23671e-18
C908	a_2342_48##4	VNB	4.4929e-17
C909	B#2	VNB	1.22707e-16
C910	a_811_379##7	VPWR	9.30022e-18
C911	a_879_55##4	VNB	4.26092e-17
C912	VPWR#5	a_1023_379##4	1.41898e-17
C913	VGND	a_1849_374##6	3.01737e-18
C914	B#4	VNB	3.16161e-17
C915	VPWR#9	a_1660_374##4	1.16636e-16
C916	VGND	a_1023_379##10	5.86024e-17
C917	a_879_55##3	VNB	2.42885e-17
C918	a_1849_374##6	VPWR#8	6.86274e-17
C919	B#9	VNB	3.94249e-17
C920	a_1023_379##3	VNB	1.04242e-16
C921	VGND	a_811_379##11	1.12094e-18
C922	VGND#12	a_879_55#	2.56603e-18
C923	a_83_21##6	CI#1	2.35158e-19
C924	a_811_379#	VNB	4.069e-17
C925	a_1023_379##4	VNB	1.25274e-16
C926	VGND#5	a_879_55##2	8.08296e-20
C927	a_811_379##5	VNB	6.4935e-17
C928	VGND	a_1023_379##8	3.72111e-17
C929	VPWR	a_2342_48#	1.37256e-19
C930	SUM	CI#2	7.92193e-19
C931	a_231_132#	VNB	3.80875e-17
C932	VGND	VGND#4	1.01663e-16
C933	a_410_58#	VPWR#10	3.52371e-17
C934	a_410_58#	VNB	4.46904e-17
C935	CI#1	VNB	3.87897e-17
C936	a_83_21##3	VNB	5.45088e-17
C937	VPWR	a_879_55##2	3.36281e-19
C938	VPWR#1	VNB	8.90996e-17
C939	COUT	a_83_21#	7.64524e-17
C940	VGND#1	VNB	8.95448e-17
C941	a_879_55##9	a_644_104##5	1.60415e-17
C942	a_231_132##7	a_231_132#	1.31295e-18
C943	a_1023_379##3	B#6	5.06774e-18
C944	a_1849_374##6	VNB	1.33936e-17
C945	COUT	CI#2	7.72585e-18
C946	a_1023_379##10	VNB	2.57885e-17
C947	a_1849_374##6	a_1660_374##2	1.06836e-16
C948	a_1660_374##6	B#7	4.50079e-18
C949	VGND	a_2342_48#	6.12968e-18
C950	a_811_379##11	VNB	7.59885e-18
C951	VPWR#4	VNB	5.26177e-17
C952	VGND	a_879_55##5	1.18032e-17
C953	a_1023_379##8	VNB	6.95072e-18
C954	VGND#4	VNB	6.29714e-17
C955	VGND	a_879_55##2	1.35276e-18
C956	a_644_104##6	VNB	3.67837e-18
C957	a_811_379##7	VNB	6.50744e-18
C958	VGND	a_1023_379##5	6.69256e-18
C959	a_644_104##3	VNB	5.71701e-18
C960	VPWR#6	VNB	2.90357e-16
C961	a_410_58#	COUT#1	2.41791e-17
C962	VGND#6	VNB	3.65919e-16
C963	a_2342_48#	VNB	6.09355e-17
C964	a_879_55##9	a_879_55#	2.40041e-18
C965	a_879_55##5	VNB	6.09383e-17
C966	a_644_104##6	a_1023_379##2	8.14656e-18
C967	B#5	VNB	5.13066e-17
C968	a_879_55##2	VNB	3.61178e-17
C969	a_879_55##13	a_1660_374##4	1.61829e-18
C970	a_1023_379##5	VNB	6.22018e-18
C971	a_811_379##2	VNB	4.07897e-17
C972	a_1023_379##3	B#3	1.11619e-18
C973	a_231_132##4	VNB	8.47602e-17
C974	a_410_58##2	VNB	4.17629e-17
C975	a_879_55##8	a_879_55##5	1.30547e-18
C976	VPWR#9	B#6	2.48285e-17
C977	a_83_21#	VNB	1.76035e-16
C978	CI#2	VNB	2.25853e-17
C979	VPWR#10	CI#1	1.30987e-19
C980	COUT	CI	6.06505e-17
C981	B#7	VGND#12	3.10413e-17
C982	a_231_132##7	a_410_58#	3.22437e-17
C983	VPWR	A	3.04448e-18
C984	a_83_21##4	a_1023_379##2	9.74255e-19
C985	a_644_104##6	a_879_55##9	1.61025e-18
C986	a_231_132##6	VPWR#5	9.75532e-17
C987	SUM	COUT	5.6191e-17
C988	VGND	A	3.29059e-18
C989	A	VNB	5.62662e-18
C990	a_1023_379##10	a_1660_374##2	3.63085e-17
C991	CI	VNB	1.39026e-18
C992	a_1023_379##2	a_1023_379##3	5.57655e-19
C993	a_879_55##9	a_83_21##4	2.21212e-17
C994	SUM	VNB	7.02924e-17
C995	COUT	VNB	1.18574e-17
C996	COUT#1	CI#1	3.6768e-17
C997	VPWR	VNB	2.26797e-16
C998	VGND	VNB	2.27402e-16
C999	VGND#5	a_811_379#	1.08162e-20
C1000	VPWR#12	a_410_58#	3.28372e-20
C1001	VPWR#11	a_83_21#	5.22328e-19
C1002	VPWR#11	a_410_58#	2.09485e-19
C1003	VGND#8	a_83_21##2	3.20243e-17
C1004	VPWR#11	a_83_21##3	8.10597e-18
C1005	VGND#6	VGND#8	1.04336e-16
C1006	VGND#8	SUM#3	1.12923e-17
C1007	SUM	VPWR#11	2.11402e-17
C1008	VPWR#6	VPWR#11	1.22001e-16
C1009	VPWR#11	VNB	6.87894e-17
C1010	VGND#8	CI#3	3.67108e-18
C1011	VGND#8	VGND#7	1.35929e-19
C1012	VPWR#11	COUT#1	6.75589e-17
C1013	VPWR#11	CI#2	1.56644e-20
C1014	VPWR#11	CI#1	3.79854e-18
C1015	VGND#8	CI#2	2.41754e-19
C1016	VGND#8	COUT	9.04074e-18
C1017	COUT	VPWR#11	2.61593e-19
C1018	VGND#8	VNB	5.30052e-17
*
*
.ENDS sky130_fd_sc_hs__fah_1
*
