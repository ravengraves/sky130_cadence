* Extracted by Quantus, converted by sky130cad/quantus.py
*
*
*
*                       LINUX           Wed Nov 18 08:17:29 2026
*
*
*
*  PROGRAM  advgen
*
*  Name           : advgen - Quantus - (64-bit)
*  Version        : 25.1.0-p047
*  Build Date     : Thu Dec 11 23:20:30 PST 2025
*
*  HSPICE LIBRARY
*
*  OPERATING_TEMPERATURE 150
*  QRC_TECH_DIR <path>/tech
*
*
*

*
.SUBCKT sky130_fd_sc_hs__and3_4 VPB VNB VGND VPWR X B C A
*
*
*  caps2d version: 10
*
*
*       TRANSISTOR CARDS
*
*
XM10 X#4 a_83_260##10 VGND#5 VNB sky130_fd_pr__nfet_01v8_lvt l=0.15 w=0.74 ad=0.2072 as=0.2109 pd=2.04 ps=2.05
XM13 VGND#8 a_83_260##7 X#4 VNB sky130_fd_pr__nfet_01v8_lvt l=0.15 w=0.74 ad=0.259 as=0.2072 pd=2.18 ps=2.04
XM16 VGND#8 a_83_260##5 X#8 VNB sky130_fd_pr__nfet_01v8_lvt l=0.15 w=0.74 ad=0.259 as=0.2072 pd=2.18 ps=2.04
XM19 X#8 a_83_260##4 VGND#7 VNB sky130_fd_pr__nfet_01v8_lvt l=0.15 w=0.74 ad=0.2072 as=0.249 pd=2.04 ps=2.18
XM4 VGND#7 C#4 a_489_74##2 VNB sky130_fd_pr__nfet_01v8_lvt l=0.15 w=0.64 ad=0.249 as=0.1792 pd=2.18 ps=1.84
XM11 a_489_74##2 C#5 VGND#6 VNB sky130_fd_pr__nfet_01v8_lvt l=0.15 w=0.64 ad=0.1792 as=0.1824 pd=1.84 ps=1.85
XM5 a_686_74##3 B#7 a_489_74# VNB sky130_fd_pr__nfet_01v8_lvt l=0.15 w=0.64 ad=0.1824 as=0.2048 pd=1.85 ps=1.92
XM12 a_489_74# B#1 a_686_74##4 VNB sky130_fd_pr__nfet_01v8_lvt l=0.15 w=0.64 ad=0.2048 as=0.1792 pd=1.92 ps=1.84
XM7 a_83_260##18 A#5 a_686_74##4 VNB sky130_fd_pr__nfet_01v8_lvt l=0.15 w=0.64 ad=0.2368 as=0.1792 pd=2.02 ps=1.84
XM18 a_686_74# A#1 a_83_260##18 VNB sky130_fd_pr__nfet_01v8_lvt l=0.15 w=0.64 ad=0.2144 as=0.2368 pd=1.95 ps=2.02
XM0 VPWR#7 a_83_260##12 X#6 VPB sky130_fd_pr__pfet_01v8 l=0.15 w=1.12 ad=0.3304 as=0.336 pd=2.83 ps=2.84
XM2 X#6 a_83_260##11 VPWR#11 VPB sky130_fd_pr__pfet_01v8 l=0.15 w=1.12 ad=0.336 as=0.448 pd=2.84 ps=3.04
XM8 VPWR#11 a_83_260##8 X#1 VPB sky130_fd_pr__pfet_01v8 l=0.15 w=1.12 ad=0.448 as=0.336 pd=3.04 ps=2.84
XM15 X#1 a_83_260# VPWR#10 VPB sky130_fd_pr__pfet_01v8 l=0.15 w=1.12 ad=0.336 as=0.4102 pd=2.84 ps=3.04
XM3 a_83_260##20 C#6 VPWR#10 VPB sky130_fd_pr__pfet_01v8 l=0.15 w=0.84 ad=0.252 as=0.4102 pd=2.28 ps=3.04
XM17 VPWR#9 C#1 a_83_260##20 VPB sky130_fd_pr__pfet_01v8 l=0.15 w=0.84 ad=0.546 as=0.252 pd=2.98 ps=2.28
XM1 VPWR#9 B#5 a_83_260##19 VPB sky130_fd_pr__pfet_01v8 l=0.15 w=0.84 ad=0.546 as=0.2856 pd=2.98 ps=2.36
XM14 a_83_260##19 B#6 VPWR#8 VPB sky130_fd_pr__pfet_01v8 l=0.15 w=0.84 ad=0.2856 as=0.3024 pd=2.36 ps=2.4
XM6 VPWR#8 A#7 a_83_260##13 VPB sky130_fd_pr__pfet_01v8 l=0.15 w=0.84 ad=0.3024 as=0.252 pd=2.4 ps=2.28
XM9 a_83_260##13 A#6 VPWR#1 VPB sky130_fd_pr__pfet_01v8 l=0.15 w=0.84 ad=0.252 as=0.2898 pd=2.28 ps=2.37
*
*
*       RESISTOR AND CAP/DIODE CARDS
*
Rg1	a_83_260#	a_83_260##2	463.544769
Rg2	a_83_260##2	a_83_260##3	55.764629
Rg3	a_83_260##2	a_83_260##4	397.487915
Rg4	a_83_260##3	a_83_260##5	387.478790
Rg5	a_83_260##3	a_83_260##6	106.408203
Rg6	a_83_260##6	a_83_260##7	365.868195
Rg7	a_83_260##3	a_83_260##8	451.334412
Rg8	a_83_260##6	a_83_260##9	66.386436
Rg9	a_83_260##9	a_83_260##10	368.862610
Rg10	a_83_260##6	a_83_260##11	468.868408
Rg11	a_83_260##9	a_83_260##12	471.862823
Rg12	C#1	C#2	418.787384
Rg13	C#2	C#3	63.515358
Rg14	C#3	C#4	520.309875
Rg15	C#2	C#5	453.936310
Rg16	C#3	C#6	415.038177
Rg17	B#1	B#2	411.902283
Rg18	B#2	B#3	30.596949
Rg19	B#3	B#4	30.613651
Rg20	B#4	B#5	504.876801
Rg21	B#2	B#6	502.864136
Rg22	B#4	B#7	416.506470
Rg23	A#1	A#2	528.853760
Rg24	A#2	A#3	26.624105
Rg25	A#3	A#4	20.120399
Rg26	A#4	A#5	532.815430
Rg27	A#2	A#6	376.971954
Rg28	A#4	A#7	387.613678
Rf1	X#1	X#2	83.154045
Rf2	X#2	X	9.798555
Rf3	X	X#3	11.622770
Rf4	X#3	X	4.898489
Rf5	X	X#5	7.282945
Rf6	X#2	X	6.005465
Rf7	X	X#7	14.164948
Rf8	X#7	X	0.194040
Rf9	X#3	X#8	74.532959
Rf10	X#5	X	7.282945
Rf11	X#4	X#5	7.500000
Rf12	X#6	X#7	5.000000
Rf13	C	C#7	10.235491
Rf14	C#7	C	8.660800
Rf15	a_489_74#	a_489_74##2	157.477005
Rf16	B#8	B	1.378649
Rf17	B#3	B#10	81.495049
Rf18	B#8	B#10	11.576647
Rf19	B#11	B	1.378649
Rf20	B#10	B#11	2.315329
Rf21	A#3	A#9	80.613510
Rf22	A#10	A	0.497105
Rf23	A#9	A#10	3.543054
Rf24	a_83_260##13	a_83_260##14	24.053936
Rf25	a_83_260##14	a_83_260##15	73.001427
Rf26	a_83_260##15	a_83_260##16	91.264053
Rf27	a_83_260##16	a_83_260##3	150.103485
Rf28	a_83_260##14	a_83_260##18	159.575867
Rf29	a_83_260##15	a_83_260##19	24.054951
Rf30	a_83_260##16	a_83_260##20	24.054951
Rf31	a_686_74#	a_686_74##2	87.125717
Rf32	a_686_74##2	a_686_74##3	86.383324
Rf33	a_686_74##2	a_686_74##4	17.953024
Rf34	VPWR#1	VPWR#2	100.904266
Rf35	VPWR#2	VPWR#3	82.120544
Rf36	VPWR#3	VPWR#4	34.662258
Rf37	VPWR#4	VPWR#5	47.458290
Rf38	VPWR#5	VPWR#6	73.001427
Rf39	VPWR#6	VPWR#7	120.594025
Rf40	VPWR#2	VPWR#8	31.534731
Rf41	VPWR#3	VPWR#9	17.719683
Rf42	VPWR#5	VPWR#10	31.534731
Rf43	VPWR#6	VPWR#11	34.487274
Rf45	VGND#2	VGND#3	58.050610
Rf46	VGND#3	VGND#4	65.023224
Rf47	VGND#4	VGND#5	109.924255
Rf48	VGND#2	VGND#6	40.761108
Rf49	VGND#3	VGND#7	31.337896
Rf50	VGND#4	VGND#8	42.655182
Rf51	C#2	C#7	80.116402
Re1	VPWR#4	VPWR	0.818510
Re2	VGND	VGND#2	0.818540
*
*       CAPACITOR CARDS
*
*
C1	a_83_260##19	VPWR#3	8.48902e-18
C2	a_83_260#	C#3	8.19925e-18
C3	a_686_74#	a_83_260##18	8.0754e-17
C4	a_83_260##19	VPWR#2	9.16153e-18
C5	a_83_260##14	VPWR#1	9.88722e-17
C6	a_686_74##4	a_686_74#	4.30643e-18
C7	a_83_260##20	VPWR#5	1.8126e-18
C8	a_83_260##14	a_83_260##13	6.70828e-19
C9	a_686_74##4	a_83_260##18	4.05596e-17
C10	a_83_260##15	VPWR#8	1.66377e-17
C11	B#10	B#4	1.14864e-17
C12	a_83_260##14	VPWR#8	8.02927e-17
C13	a_489_74#	a_83_260##18	4.3777e-18
C14	X#1	VPWR#6	8.63016e-18
C15	VPWR#10	VPWR#3	3.32607e-19
C16	a_83_260##16	VPWR#9	3.03027e-17
C17	a_489_74#	a_686_74##4	3.1921e-17
C18	X#1	VPWR#5	8.44616e-18
C19	a_83_260##19	a_83_260##14	4.30228e-18
C20	a_83_260##15	VPWR#9	3.02693e-17
C21	a_686_74##3	a_686_74##4	5.04014e-18
C22	a_489_74#	a_686_74##3	6.61732e-17
C23	a_83_260##16	VPWR#10	3.66411e-17
C24	VPWR#10	C#3	5.27716e-19
C25	VPWR#7	VPWR#6	8.82913e-19
C26	VGND#4	VGND#3	1.11424e-18
C27	X#1	a_83_260##16	1.70459e-17
C28	VGND#6	a_686_74##3	3.95444e-17
C29	a_489_74##2	a_489_74#	1.14447e-18
C30	X#1	C#3	3.14806e-19
C31	a_489_74##2	VGND#6	7.54549e-17
C32	VGND#7	VGND#6	1.82757e-18
C33	a_686_74#	VPWR#1	2.7205e-19
C34	VGND#7	a_489_74##2	6.69879e-17
C35	X#8	a_489_74##2	3.47524e-18
C36	a_686_74##2	A#5	2.27466e-17
C37	VPWR#11	a_83_260##6	6.98042e-19
C38	X#8	VGND#7	5.80662e-17
C39	a_686_74##2	B#1	2.17644e-17
C40	VGND#8	VGND#7	1.02654e-18
C41	VGND#3	C#4	5.07635e-18
C42	a_83_260##9	a_83_260##6	3.54153e-18
C43	a_83_260##9	X#6	1.1473e-19
C44	VGND#4	a_83_260##4	5.49638e-19
C45	X#8	VGND#8	4.4883e-17
C46	VGND#3	a_83_260##4	3.78885e-18
C47	VPWR#6	VPWR#5	9.53351e-19
C48	a_83_260##6	X#6	1.132e-19
C49	VGND#4	a_83_260##5	5.76947e-18
C50	VGND#5	VGND#8	8.61868e-19
C51	VGND#4	a_83_260##7	6.11973e-18
C52	VPWR#5	VPWR#3	9.8235e-19
C53	VGND#4	a_83_260##10	3.07936e-18
C54	a_686_74#	A#4	2.99839e-19
C55	VPWR#3	VPWR#2	9.8235e-19
C56	B#4	A#5	3.39028e-18
C57	a_83_260##18	A#4	2.22021e-17
C58	a_686_74#	A#1	3.18639e-17
C59	VPWR#8	VPWR#1	1.69608e-18
C60	a_83_260##18	A#1	4.19331e-17
C61	a_686_74#	A#5	1.28373e-18
C62	C#2	B#4	1.34548e-17
C63	a_686_74##4	A#1	2.56766e-18
C64	a_83_260##16	VPWR#5	9.16354e-19
C65	C#3	C#2	1.48386e-17
C66	A#5	a_83_260##18	1.85614e-17
C67	a_83_260##18	B#4	3.06608e-18
C68	a_489_74#	A#1	7.90207e-19
C69	a_686_74##4	A#5	3.31901e-17
C70	a_83_260##18	B#1	1.12212e-18
C71	a_83_260##19	VPWR#8	6.22318e-17
C72	a_489_74#	A#5	9.18167e-19
C73	a_686_74##4	B#1	3.1694e-17
C74	VPWR#9	VPWR#8	1.70876e-18
C75	VGND#4	a_83_260##9	5.01069e-20
C76	a_83_260##18	B#7	4.99481e-19
C77	a_83_260##3	B#4	9.95303e-19
C78	B#1	a_489_74#	1.7436e-17
C79	VPWR#2	A#7	2.59681e-18
C80	a_83_260##15	VPWR#3	9.16354e-19
C81	a_686_74##4	B#7	2.14807e-18
C82	a_83_260##3	C#3	4.21382e-17
C83	VPWR#9	a_83_260##19	6.40357e-17
C84	a_686_74##3	B#1	1.32122e-18
C85	a_83_260##3	a_83_260##9	3.35742e-20
C86	a_83_260##18	C#5	2.59276e-19
C87	a_83_260##3	a_83_260##6	1.51953e-17
C88	VGND#3	C#3	5.47272e-21
C89	a_489_74#	B#7	3.12908e-17
C90	VGND#4	a_83_260##6	4.36225e-20
C91	a_83_260##14	A#6	3.42431e-17
C92	a_83_260##20	a_83_260##19	3.15535e-18
C93	a_83_260##15	VPWR#2	8.52387e-19
C94	VPWR#2	B#6	4.34671e-18
C95	a_686_74##3	B#7	5.32075e-17
C96	a_489_74##2	B#1	1.07061e-19
C97	a_489_74#	C#5	3.26909e-19
C98	a_83_260##20	VPWR#9	6.40004e-17
C99	VGND#6	B#7	9.58613e-19
C100	VPWR#3	B#5	4.50997e-18
C101	a_83_260##14	A#7	3.22155e-17
C102	VGND#5	VPWR#7	9.71428e-18
C103	a_686_74##3	C#5	1.09096e-18
C104	a_83_260##14	VPWR#2	1.50995e-17
C105	VPWR#10	VPWR#9	1.66274e-18
C106	a_489_74##2	B#7	3.54004e-19
C107	a_489_74#	C#4	9.08347e-20
C108	C#5	B#4	9.52075e-19
C109	a_83_260##15	B#6	1.43476e-17
C110	VGND#6	C#5	3.70467e-17
C111	a_489_74#	B#4	4.53578e-18
C112	VPWR#10	a_83_260##20	6.22435e-17
C113	a_83_260##14	B#6	2.69363e-18
C114	a_489_74##2	C#5	3.1962e-17
C115	VGND#6	C#4	1.25599e-18
C116	X#1	a_83_260##20	4.38718e-18
C117	VGND#7	C#5	1.15945e-18
C118	a_83_260##15	B#5	2.27513e-17
C119	VPWR#5	C#6	4.50609e-18
C120	a_489_74##2	C#4	4.15204e-17
C121	a_83_260##14	B#5	6.19751e-19
C122	X#1	VPWR#10	6.76347e-17
C123	VGND#6	a_83_260##4	1.43377e-19
C124	a_83_260##16	C#1	1.92471e-17
C125	VGND#7	C#4	1.55653e-17
C126	a_489_74##2	a_83_260##4	1.4235e-18
C127	VPWR#11	VPWR#10	1.69573e-18
C128	VPWR#5	a_83_260#	4.6495e-18
C129	X#8	C#4	6.55434e-19
C130	a_686_74##3	B#4	1.4809e-19
C131	VGND#7	a_83_260##4	4.18462e-17
C132	X#1	VPWR#11	7.94215e-17
C133	a_83_260##16	C#6	2.74594e-17
C134	a_489_74##2	a_83_260##5	1.94048e-19
C135	X#8	a_83_260##4	1.32617e-17
C136	VPWR#6	a_83_260##8	2.59945e-18
C137	VGND#7	a_83_260##5	2.19833e-18
C138	VGND#8	a_83_260##4	1.57044e-19
C139	X#8	a_83_260##5	4.9469e-17
C140	VPWR#6	a_83_260##9	4.57114e-20
C141	a_83_260##16	a_83_260#	1.85296e-18
C142	a_686_74##2	A#9	2.51053e-18
C143	VGND#7	a_83_260##7	3.1607e-19
C144	VPWR#6	a_83_260##11	2.59554e-18
C145	a_83_260##5	VGND#8	1.84468e-17
C146	X#8	a_83_260##7	1.41396e-18
C147	VPWR#7	VPWR#11	1.47906e-18
C148	a_83_260##7	VGND#8	2.09152e-17
C149	VPWR#3	B#4	3.42157e-20
C150	VPWR#6	a_83_260##6	4.5102e-20
C151	VPWR#2	A#4	1.14605e-19
C152	VGND#5	a_83_260##5	2.69223e-19
C153	VPWR#6	a_83_260##12	2.19585e-18
C154	a_83_260##7	X#4	1.49316e-17
C155	VGND#8	a_83_260##10	3.11767e-19
C156	VGND#5	a_83_260##7	1.34033e-18
C157	a_83_260##10	X#4	1.54384e-17
C158	VGND#5	a_83_260##10	2.69002e-17
C159	VPWR#2	B#4	3.03928e-20
C160	A#5	A#1	2.63892e-17
C161	a_686_74##2	A#4	3.18506e-19
C162	VPWR#4	VPWR#6	4.76069e-17
C163	A#9	a_83_260##14	3.88851e-17
C164	VPWR#4	VPWR#5	3.4667e-17
C165	VPWR#4	VPWR#3	3.97264e-17
C166	A#6	VPWR#1	2.6485e-17
C167	B#1	A#5	3.6981e-17
C168	VPWR#4	VPWR#2	4.54001e-17
C169	A	A#4	1.31093e-17
C170	a_489_74##2	C#3	2.55477e-18
C171	A#6	a_83_260##13	1.83097e-17
C172	VPWR#1	A#7	1.34947e-18
C173	a_83_260##16	VPWR#4	1.00456e-18
C174	VPWR#8	A#6	1.4381e-18
C175	B#7	B#1	3.08213e-17
C176	A#7	a_83_260##13	1.78044e-17
C177	a_686_74##2	B#4	5.03618e-19
C178	VPWR#1	B#6	2.83289e-19
C179	A#7	VPWR#8	2.02812e-17
C180	B#10	a_83_260##15	1.97867e-17
C181	a_83_260##19	A#7	1.18228e-18
C182	C#5	B#7	3.70018e-18
C183	VPWR#8	B#6	4.31219e-17
C184	B#6	a_83_260##19	1.62269e-17
C185	C	B#4	3.22506e-18
C186	VPWR#8	B#5	2.30247e-18
C187	C	C#3	8.09029e-18
C188	VPWR#9	B#6	7.78572e-19
C189	C#4	C#5	3.98442e-17
C190	a_83_260##19	B#5	4.46028e-17
C191	VPWR#8	C#1	1.80216e-19
C192	B#5	VPWR#9	3.07202e-17
C193	a_83_260##19	C#1	8.87363e-19
C194	a_83_260##20	B#5	8.87363e-19
C195	a_83_260##4	C#4	2.9236e-17
C196	C#1	VPWR#9	3.61084e-17
C197	VPWR#10	B#5	1.80216e-19
C198	VGND#4	a_83_260##3	2.61597e-20
C199	a_83_260##20	C#1	5.01389e-17
C200	VGND#3	a_83_260##3	6.03656e-19
C201	B	A#4	8.07291e-18
C202	VPWR#9	C#6	8.3754e-19
C203	VPWR#10	C#1	1.2717e-18
C204	B	B#4	3.84944e-17
C205	VPWR#6	a_83_260##3	4.57114e-20
C206	a_83_260##5	a_83_260##4	3.92364e-17
C207	a_83_260##16	C#2	1.2958e-17
C208	B	C#3	3.74873e-19
C209	a_83_260##3	VPWR#5	2.96467e-19
C210	a_83_260##20	C#6	4.21883e-17
C211	VPWR#9	a_83_260#	3.34129e-19
C212	C#6	VPWR#10	2.50848e-17
C213	a_83_260##20	a_83_260#	1.28136e-18
C214	X#1	C#6	8.71804e-19
C215	a_83_260##7	a_83_260##5	2.81281e-17
C216	a_83_260#	VPWR#10	3.08296e-17
C217	VPWR#11	C#6	2.8528e-19
C218	X#1	a_83_260#	6.34048e-17
C219	VPWR#10	a_83_260##8	7.67963e-19
C220	VPWR#11	a_83_260#	7.67963e-19
C221	a_83_260##10	a_83_260##7	3.92661e-17
C222	X#1	a_83_260##8	6.71452e-17
C223	VPWR#10	a_83_260##11	2.8528e-19
C224	a_83_260##8	VPWR#11	3.16592e-17
C225	X	C#3	9.28495e-20
C226	a_686_74##2	a_83_260##18	1.69022e-17
C227	X	a_83_260##9	1.91638e-17
C228	X	a_83_260##6	1.50836e-17
C229	X#1	a_83_260##11	7.09787e-19
C230	VPWR#4	VPWR#1	2.95983e-17
C231	a_83_260##16	C#3	8.66135e-19
C232	a_83_260##11	VPWR#11	3.68466e-17
C233	VPWR#7	a_83_260##8	2.57768e-19
C234	a_83_260##15	B#4	4.02454e-18
C235	a_83_260##14	A#4	3.80086e-17
C236	VGND#3	a_489_74##2	4.25858e-18
C237	a_83_260##11	X#6	2.37335e-17
C238	a_83_260##18	C#2	1.19127e-19
C239	VGND#8	a_83_260##6	1.25463e-18
C240	VPWR#11	a_83_260##12	1.46384e-18
C241	VPWR#7	a_83_260##11	1.23062e-18
C242	a_686_74##2	a_686_74##4	3.45007e-20
C243	VGND#4	VGND#7	7.52417e-19
C244	a_83_260##12	X#6	2.44069e-17
C245	a_83_260##20	VPWR#4	1.50071e-17
C246	VGND#6	C#2	1.46775e-18
C247	VPWR#7	a_83_260##12	3.2577e-17
C248	a_489_74##2	C#2	4.50047e-18
C249	A#7	A#6	3.59658e-17
C250	VPWR	A#4	5.70227e-20
C251	a_686_74##2	a_489_74#	1.07122e-17
C252	VGND#4	X#8	5.86038e-18
C253	a_83_260##9	X#4	1.94052e-19
C254	B#6	A#7	2.76845e-17
C255	a_83_260##3	VGND#7	2.63936e-17
C256	VPWR#4	VPWR#7	2.54254e-17
C257	a_83_260##14	B#4	4.49502e-19
C258	a_83_260##3	X#8	4.95827e-17
C259	VGND#3	X#8	6.92636e-18
C260	a_83_260##3	VGND#8	4.45027e-18
C261	a_83_260##6	X#4	1.68939e-19
C262	B#5	B#6	3.54364e-17
C263	a_83_260##18	a_83_260##14	2.19841e-18
C264	a_686_74##4	a_83_260##15	3.24342e-18
C265	a_489_74#	a_83_260##16	7.25191e-19
C266	VPWR#9	C#2	8.92743e-19
C267	B#6	A#4	5.64351e-18
C268	C#1	B#5	1.01849e-17
C269	A	a_83_260##14	4.79161e-17
C270	a_686_74##4	a_83_260##14	2.76952e-18
C271	VGND	a_83_260##6	3.88443e-19
C272	a_489_74#	a_83_260##15	2.96983e-18
C273	C#6	C#1	3.94776e-17
C274	a_83_260##3	VPWR#10	2.44075e-18
C275	C	a_83_260##16	6.93064e-17
C276	a_83_260##3	X#1	6.84388e-17
C277	a_83_260##3	VPWR#11	4.60202e-18
C278	a_83_260#	C#6	2.85367e-17
C279	A#4	a_83_260##13	1.08639e-18
C280	a_686_74##2	B	4.32211e-18
C281	a_83_260##18	A	3.35454e-17
C282	VGND#5	VGND#4	1.59677e-18
C283	a_83_260##18	A#9	2.40754e-17
C284	a_83_260##8	a_83_260#	4.69099e-17
C285	B#4	A#4	3.18938e-17
C286	B	a_83_260##15	6.34642e-17
C287	VGND#4	X	1.61795e-17
C288	B	A#9	2.20745e-17
C289	A#4	VNB	1.04648e-16
C290	B#4	VNB	7.80697e-17
C291	X	VPWR#6	1.70517e-17
C292	a_83_260##11	a_83_260##8	3.12661e-17
C293	C#3	VNB	3.67563e-17
C294	a_83_260##3	C#4	1.04959e-18
C295	a_83_260##9	VNB	3.95718e-17
C296	a_83_260##6	VNB	3.43083e-17
C297	VPWR#4	C#1	5.02011e-18
C298	a_686_74##4	A#9	2.78442e-18
C299	a_489_74##2	a_83_260##16	6.00227e-18
C300	a_489_74##2	C	3.91885e-17
C301	a_83_260##12	a_83_260##11	4.74277e-17
C302	B	a_83_260##18	3.37095e-18
C303	a_686_74##4	B	7.43616e-18
C304	A#9	A#4	2.08154e-17
C305	a_489_74#	B	3.98487e-17
C306	VPWR	VPWR#6	2.73071e-17
C307	VPWR	VPWR#5	2.37535e-17
C308	VPWR	VPWR#3	2.77639e-17
C309	VPWR	VPWR#2	2.76227e-17
C310	C#2	B#5	1.54579e-18
C311	VPWR	a_83_260##16	9.20672e-18
C312	a_83_260##3	B#6	1.19313e-19
C313	VPWR	a_83_260##15	6.92498e-18
C314	VPWR	a_83_260##14	2.03942e-17
C315	a_83_260##3	B#5	1.51385e-19
C316	VPWR	A#9	1.67018e-18
C317	VPWR	B#10	1.26633e-18
C318	VGND	VGND#4	4.03348e-17
C319	VGND	VGND#3	2.13639e-17
C320	X	X#8	4.24367e-18
C321	a_83_260##3	a_83_260#	2.31616e-18
C322	X	VGND#8	5.3382e-17
C323	VGND	a_686_74##2	2.90037e-17
C324	VGND#5	X	7.17327e-17
C325	VGND	A#9	2.83697e-18
C326	VPWR#4	C#2	4.58499e-20
C327	VGND	B#10	1.4012e-18
C328	A#9	B#4	4.80446e-18
C329	X	X#1	3.56767e-18
C330	VGND#4	VNB	3.51629e-17
C331	X	VPWR#11	1.0248e-16
C332	VGND#3	VNB	2.83788e-17
C333	VPWR	VPWR#1	4.04034e-17
C334	X	X#6	8.92041e-19
C335	VGND	a_686_74#	2.27895e-17
C336	VPWR#6	VNB	3.63317e-17
C337	VPWR#5	VNB	2.60472e-17
C338	VGND	a_83_260##18	1.11077e-17
C339	VPWR#7	X	8.99752e-17
C340	VPWR	VPWR#8	2.13928e-17
C341	VPWR#3	VNB	3.12718e-17
C342	VPWR#2	VNB	3.50495e-17
C343	VPWR	a_83_260##19	1.60524e-17
C344	VGND	a_489_74#	8.70769e-18
C345	a_686_74##2	VNB	5.17003e-18
C346	VGND	a_686_74##3	2.03551e-17
C347	VPWR	VPWR#9	3.50438e-17
C348	a_83_260##16	VNB	5.69636e-18
C349	VPWR	a_83_260##20	1.5835e-17
C350	a_83_260##15	VNB	7.62837e-18
C351	VGND	a_489_74##2	1.68261e-17
C352	a_489_74#	B#10	2.05258e-17
C353	a_83_260##14	VNB	3.63672e-17
C354	VPWR	VPWR#10	2.14732e-17
C355	VGND	VGND#7	2.16506e-17
C356	VPWR	X#1	1.66231e-17
C357	VGND	X#8	1.38928e-17
C358	A#9	VNB	2.86297e-18
C359	X	C#5	1.94036e-19
C360	VPWR	VPWR#11	2.08959e-17
C361	X	C#4	1.82704e-19
C362	B#10	VNB	2.43768e-18
C363	VGND	VGND#5	3.15292e-17
C364	VPWR	VPWR#7	3.29064e-17
C365	X	a_83_260##4	2.01131e-19
C366	a_83_260##3	C#2	1.80084e-18
C367	X	a_83_260##5	1.86291e-18
C368	X	a_83_260##7	4.31988e-17
C369	a_686_74#	VNB	3.84356e-17
C370	X	a_83_260##10	2.39113e-17
C371	C	a_83_260#	4.93023e-19
C372	a_83_260##18	VNB	3.06526e-17
C373	a_686_74##4	VNB	5.99648e-18
C374	a_489_74#	VNB	6.07928e-18
C375	a_686_74##3	VNB	9.8563e-18
C376	VGND	X#1	2.60426e-18
C377	VGND#6	VNB	5.14892e-18
C378	a_489_74##2	VNB	6.97378e-18
C379	VGND#7	VNB	1.16921e-18
C380	X#8	VNB	2.30362e-18
C381	VGND	VPWR#7	3.12218e-18
C382	VGND#8	VNB	1.53901e-18
C383	VPWR#2	VPWR#1	9.5684e-19
C384	VGND	A#1	2.32999e-18
C385	VGND	A#5	1.58281e-18
C386	VGND#5	VNB	6.87966e-17
C387	VPWR#1	VNB	6.7837e-17
C388	VGND	B#1	1.50092e-18
C389	VGND	B#7	2.00339e-18
C390	VPWR#8	VNB	1.11978e-18
C391	VPWR	A#6	1.43534e-19
C392	VGND	C#5	6.73849e-19
C393	a_83_260##19	VNB	2.77131e-18
C394	VPWR	A#7	1.45344e-19
C395	VPWR#9	VNB	4.36205e-18
C396	VGND	C#4	4.78409e-18
C397	a_83_260##20	VNB	2.1429e-18
C398	VGND	a_83_260##4	3.10612e-19
C399	VPWR	B#6	8.47148e-19
C400	VPWR#10	VNB	3.94218e-18
C401	X	a_83_260##8	7.11292e-19
C402	VGND	a_83_260##5	2.65251e-19
C403	X#1	VNB	2.65706e-18
C404	VPWR	B#5	1.34851e-18
C405	VPWR#11	VNB	3.74405e-18
C406	VGND	a_83_260##7	3.85852e-19
C407	X	a_83_260##11	5.42751e-17
C408	VPWR	C#1	1.74302e-18
C409	VGND	a_83_260##10	4.89117e-18
C410	VPWR#7	VNB	8.08507e-17
C411	X	a_83_260##12	3.29396e-17
C412	VPWR	C#6	1.56553e-18
C413	A#1	VNB	3.50692e-17
C414	A#5	VNB	3.33621e-17
C415	VPWR	a_83_260#	3.28093e-18
C416	C	C#2	2.55073e-17
C417	B#1	VNB	2.97819e-17
C418	VPWR	a_83_260##8	2.59562e-19
C419	B#7	VNB	3.30958e-17
C420	a_83_260##3	C	2.44481e-17
C421	C#5	VNB	3.06511e-17
C422	VPWR	a_83_260##11	1.91744e-19
C423	C#4	VNB	3.23818e-17
C424	a_83_260##4	VNB	2.76039e-17
C425	VPWR	a_83_260##12	5.06286e-18
C426	B	C#2	6.17693e-18
C427	a_83_260##5	VNB	2.77378e-17
C428	a_83_260##7	VNB	2.8649e-17
C429	a_83_260##3	B	3.30812e-18
C430	a_83_260##10	VNB	3.38131e-17
C431	VPWR	VPWR#4	1.09778e-17
C432	A#6	VNB	3.31005e-17
C433	X	C#2	1.78513e-19
C434	A#7	VNB	2.48837e-17
C435	B#6	VNB	3.38432e-17
C436	X	a_83_260##3	8.08152e-17
C437	B#5	VNB	3.80407e-17
C438	C#1	VNB	3.4956e-17
C439	C#6	VNB	3.46447e-17
C440	a_83_260#	VNB	3.62655e-17
C441	VPWR	a_83_260##3	5.35008e-18
C442	a_83_260##8	VNB	3.30305e-17
C443	a_83_260##11	VNB	3.27002e-17
C444	a_83_260##12	VNB	4.13216e-17
C445	VPWR#4	VNB	2.44612e-16
C446	VGND	a_83_260##3	9.18978e-18
C447	C	B	2.68276e-17
C448	VPWR#3	VPWR#8	3.32607e-19
C449	C#2	VNB	6.75124e-17
C450	VPWR	A	1.1139e-18
C451	a_83_260##3	VNB	6.92441e-17
C452	VPWR	C	3.07111e-18
C453	VGND	A	1.30776e-18
C454	VPWR	B	3.72475e-18
C455	VGND	C	5.08292e-18
C456	VPWR	X	1.81662e-17
C457	VGND	B	5.2514e-18
C458	A	VNB	7.73456e-18
C459	C	VNB	1.32601e-17
C460	VGND	X	1.98079e-17
C461	B	VNB	4.76827e-18
C462	X	VNB	2.41192e-17
C463	VPWR	VNB	6.09165e-17
C464	VGND	VNB	7.6621e-17
C465	VGND#2	B#1	4.61647e-18
C466	VGND#2	a_686_74##3	4.76845e-17
C467	VGND#2	VNB	3.45555e-16
C468	VGND#2	A#4	5.647e-20
C469	VGND#2	a_686_74##2	6.91154e-17
C470	VGND#2	C#5	5.23441e-18
C471	VGND#2	a_83_260##9	4.03694e-21
C472	VGND#2	a_489_74##2	9.37033e-18
C473	VGND#2	VGND#5	2.59944e-17
C474	VGND#2	B#4	5.34138e-20
C475	VGND#2	A#5	4.48988e-18
C476	VGND#2	a_83_260##4	1.72693e-19
C477	VGND#2	a_489_74#	9.06886e-19
C478	VGND#2	VGND#3	3.75169e-17
C479	VGND	VGND#2	8.93928e-17
C480	VGND#2	B#7	5.39936e-18
C481	VGND#2	a_686_74#	5.44175e-17
C482	VGND#2	C#3	3.79963e-20
C483	VGND#2	C#2	6.15057e-21
C484	VGND#2	A#1	4.47119e-18
C485	VGND#2	C#4	8.84451e-19
C486	VGND#2	VGND#4	4.30416e-17
C487	VGND#2	a_83_260##6	3.51452e-21
C488	VGND#7	VGND#2	7.02477e-20
*
*
.ENDS sky130_fd_sc_hs__and3_4
*
