* Extracted by Quantus, converted by sky130cad/quantus.py
*
*
*
*                       LINUX           Wed Nov 18 08:25:14 2026
*
*
*
*  PROGRAM  advgen
*
*  Name           : advgen - Quantus - (64-bit)
*  Version        : 25.1.0-p047
*  Build Date     : Thu Dec 11 23:20:30 PST 2025
*
*  HSPICE LIBRARY
*
*  OPERATING_TEMPERATURE 150
*  QRC_TECH_DIR <path>/tech
*
*
*

*
.SUBCKT sky130_fd_sc_hs__decap_4 VPB VNB VGND VPWR
*
*
*  caps2d version: 10
*
*
*       TRANSISTOR CARDS
*
*
XM1 VGND#5 VPWR#2 VGND#3 VNB sky130_fd_pr__nfet_01v8_lvt l=1 w=0.42 ad=0.1113 as=0.1197 pd=1.37 ps=1.41
XM0 VPWR#6 VGND#2 VPWR#3 VPB sky130_fd_pr__pfet_01v8 l=1 w=1 ad=0.275 as=0.285 pd=2.55 ps=2.57
*
*
*       RESISTOR AND CAP/DIODE CARDS
*
Rg1	VGND#1	VGND#2	146.904678
Rg2	VPWR#1	VPWR#2	120.722801
Rf1	VGND#3	VGND#4	81.061172
Rf2	VGND#4	VGND#6	41.538513
Rf3	VGND#6	VGND#1	178.384674
Rf4	VGND#5	VGND#6	15.000000
Rf5	VPWR#4	VPWR#5	42.288494
Rf6	VPWR#5	VPWR#6	84.766808
Rf7	VPWR#4	VPWR#1	184.551651
Rf8	VPWR#3	VPWR#4	5.000000
Re1	VPWR#5	VPWR	2.455682
Re2	VGND	VGND#4	2.455774
*
*       CAPACITOR CARDS
*
*
C1	VGND	VNB	5.21825e-17
C2	VPWR	VNB	4.95298e-17
C3	VGND#1	VNB	8.64419e-17
C4	VPWR#1	VNB	8.84382e-17
C5	VGND#4	VNB	1.56281e-16
C6	VPWR#5	VNB	1.54665e-16
C7	VGND	VGND#1	3.31065e-19
C8	VGND	VPWR#1	1.09787e-17
C9	VGND#2	VNB	1.93208e-16
C10	VGND	VGND#4	4.05026e-17
C11	VPWR	VGND#1	7.1379e-18
C12	VPWR#2	VNB	1.56762e-16
C13	VPWR#6	VNB	7.51998e-17
C14	VPWR	VPWR#1	4.73023e-21
C15	VPWR#3	VNB	5.6014e-17
C16	VGND#5	VNB	3.12798e-17
C17	VGND	VGND#2	1.67211e-18
C18	VGND#3	VNB	4.98658e-17
C19	VPWR	VPWR#5	3.42544e-17
C20	VGND	VPWR#2	1.5577e-17
C21	VGND#1	VPWR#1	5.66374e-17
C22	VGND	VPWR#6	4.33004e-18
C23	VPWR	VGND#2	2.17855e-17
C24	VGND	VGND#5	3.53222e-17
C25	VGND#4	VGND#1	1.4522e-20
C26	VGND	VGND#3	3.72638e-17
C27	VPWR	VPWR#2	1.11508e-18
C28	VGND#1	VPWR#5	7.14173e-19
C29	VPWR	VPWR#6	3.70175e-17
C30	VGND#4	VPWR#1	1.80609e-18
C31	VPWR	VPWR#3	4.12927e-17
C32	VPWR#1	VGND#2	1.87612e-17
C33	VGND#1	VPWR#2	3.30218e-17
C34	VGND#1	VPWR#6	2.68482e-17
C35	VGND#4	VGND#2	2.34946e-18
C36	VPWR#3	VGND#1	3.56501e-19
C37	VPWR#5	VGND#2	1.52828e-17
C38	VGND#4	VPWR#2	1.70427e-17
C39	VGND#3	VPWR#1	2.19399e-17
C40	VPWR#5	VPWR#6	2.48259e-17
C41	VGND#4	VGND#3	2.39648e-17
C42	VPWR#2	VGND#2	7.38916e-18
C43	VPWR#6	VGND#2	7.54159e-17
C44	VPWR#3	VGND#2	1.17472e-16
C45	VGND#5	VPWR#2	6.97979e-17
C46	VPWR#6	VPWR#3	2.18781e-17
C47	VGND#3	VPWR#2	4.06299e-17
C48	VGND#5	VGND#3	1.13472e-17
*
*
.ENDS sky130_fd_sc_hs__decap_4
*
