* Extracted by Quantus, converted by sky130cad/quantus.py
*
*
*
*                       LINUX           Wed Nov 18 09:02:00 2026
*
*
*
*  PROGRAM  advgen
*
*  Name           : advgen - Quantus - (64-bit)
*  Version        : 25.1.0-p047
*  Build Date     : Thu Dec 11 23:20:30 PST 2025
*
*  HSPICE LIBRARY
*
*  OPERATING_TEMPERATURE 150
*  QRC_TECH_DIR <path>/tech
*
*
*

*
.SUBCKT sky130_fd_sc_hs__o31a_4 VNB VPB VGND VPWR X A3 A1 A2 B1
*
*
*  caps2d version: 10
*
*
*       TRANSISTOR CARDS
*
*
XM7 VGND#8 a_86_260##12 X#4 VNB sky130_fd_pr__nfet_01v8_lvt l=0.15 w=0.74 ad=0.2109 as=0.2072 pd=2.05 ps=2.04
XM13 X#4 a_86_260##10 VGND#13 VNB sky130_fd_pr__nfet_01v8_lvt l=0.15 w=0.74 ad=0.2072 as=0.2183 pd=2.04 ps=2.07
XM15 VGND#13 a_86_260##8 X#8 VNB sky130_fd_pr__nfet_01v8_lvt l=0.15 w=0.74 ad=0.2183 as=0.2072 pd=2.07 ps=2.04
XM17 X#8 a_86_260##7 VGND#12 VNB sky130_fd_pr__nfet_01v8_lvt l=0.15 w=0.74 ad=0.2072 as=0.2109 pd=2.04 ps=2.05
XM4 a_86_260##18 B1#5 a_492_125##6 VNB sky130_fd_pr__nfet_01v8_lvt l=0.15 w=0.64 ad=0.2112 as=0.1952 pd=1.94 ps=1.89
XM8 a_492_125##4 B1#1 a_86_260##18 VNB sky130_fd_pr__nfet_01v8_lvt l=0.15 w=0.64 ad=0.2816 as=0.2112 pd=2.16 ps=1.94
XM20 a_492_125##4 A3#7 VGND#11 VNB sky130_fd_pr__nfet_01v8_lvt l=0.15 w=0.64 ad=0.2816 as=0.1792 pd=2.16 ps=1.84
XM2 VGND#11 A3#1 a_492_125##8 VNB sky130_fd_pr__nfet_01v8_lvt l=0.15 w=0.64 ad=0.1792 as=0.1792 pd=1.84 ps=1.84
XM0 a_492_125##8 A2#4 VGND#10 VNB sky130_fd_pr__nfet_01v8_lvt l=0.15 w=0.64 ad=0.1792 as=0.1792 pd=1.84 ps=1.84
XM6 a_492_125##7 A1#4 VGND#10 VNB sky130_fd_pr__nfet_01v8_lvt l=0.15 w=0.64 ad=0.224 as=0.1792 pd=1.98 ps=1.84
XM23 VGND#9 A1#5 a_492_125##7 VNB sky130_fd_pr__nfet_01v8_lvt l=0.15 w=0.64 ad=0.224 as=0.224 pd=1.98 ps=1.98
XM9 VGND#9 A2#3 a_492_125# VNB sky130_fd_pr__nfet_01v8_lvt l=0.15 w=0.64 ad=0.224 as=0.1824 pd=1.98 ps=1.85
XM3 X#6 a_86_260##6 VPWR#7 VPB sky130_fd_pr__pfet_01v8 l=0.15 w=1.12 ad=0.336 as=0.3304 pd=2.84 ps=2.83
XM5 X#6 a_86_260##11 VPWR#11 VPB sky130_fd_pr__pfet_01v8 l=0.15 w=1.12 ad=0.336 as=0.336 pd=2.84 ps=2.84
XM10 VPWR#11 a_86_260##9 X#1 VPB sky130_fd_pr__pfet_01v8 l=0.15 w=1.12 ad=0.336 as=0.336 pd=2.84 ps=2.84
XM18 VPWR#10 a_86_260# X#1 VPB sky130_fd_pr__pfet_01v8 l=0.15 w=1.12 ad=0.4204 as=0.336 pd=3.01 ps=2.84
XM22 VPWR#10 B1#4 a_86_260##14 VPB sky130_fd_pr__pfet_01v8 l=0.15 w=1 ad=0.4204 as=0.3 pd=3.01 ps=2.6
XM11 a_86_260##14 B1#6 VPWR#9 VPB sky130_fd_pr__pfet_01v8 l=0.15 w=1 ad=0.3 as=0.295 pd=2.6 ps=2.59
XM1 a_86_260##13 A3#5 a_699_392##3 VPB sky130_fd_pr__pfet_01v8 l=0.15 w=1 ad=0.3 as=0.295 pd=2.6 ps=2.59
XM14 a_699_392##4 A3#6 a_86_260##13 VPB sky130_fd_pr__pfet_01v8 l=0.15 w=1 ad=0.3 as=0.3 pd=2.6 ps=2.6
XM12 a_968_392##2 A2#5 a_699_392##4 VPB sky130_fd_pr__pfet_01v8 l=0.15 w=1 ad=0.3 as=0.3 pd=2.6 ps=2.6
XM19 a_968_392##2 A1#6 VPWR#8 VPB sky130_fd_pr__pfet_01v8 l=0.15 w=1 ad=0.3 as=0.35 pd=2.6 ps=2.7
XM21 VPWR#8 A1#1 a_968_392# VPB sky130_fd_pr__pfet_01v8 l=0.15 w=1 ad=0.35 as=0.34 pd=2.7 ps=2.68
XM16 a_699_392# A2#1 a_968_392# VPB sky130_fd_pr__pfet_01v8 l=0.15 w=1 ad=0.305 as=0.34 pd=2.61 ps=2.68
*
*
*       RESISTOR AND CAP/DIODE CARDS
*
Rg1	a_86_260#	a_86_260##2	474.407288
Rg2	a_86_260##2	a_86_260##3	47.724842
Rg3	a_86_260##3	a_86_260##4	94.193329
Rg4	a_86_260##4	a_86_260##5	89.090996
Rg5	a_86_260##5	a_86_260##6	498.703766
Rg6	a_86_260##2	a_86_260##7	370.182983
Rg7	a_86_260##3	a_86_260##8	347.003357
Rg8	a_86_260##3	a_86_260##9	450.161743
Rg9	a_86_260##4	a_86_260##10	397.730652
Rg10	a_86_260##4	a_86_260##11	440.770294
Rg11	a_86_260##5	a_86_260##12	356.140625
Rg12	B1#1	B1#2	369.349915
Rg13	B1#2	B1#3	40.445728
Rg14	B1#3	B1#4	673.005615
Rg15	B1#3	B1#5	345.783051
Rg16	B1#3	B1#6	412.229095
Rg17	A3#1	A3#2	337.127960
Rg18	A3#2	A3#3	46.351898
Rg19	A3#3	A3#4	22.738758
Rg20	A3#4	A3#5	424.409760
Rg21	A3#2	A3#6	419.841095
Rg22	A3#4	A3#7	344.886322
Rg23	A1#1	A1#2	416.987610
Rg24	A1#2	A1#3	76.992004
Rg25	A1#3	A1#4	340.169525
Rg26	A1#2	A1#5	342.643860
Rg27	A1#3	A1#6	421.885773
Rg28	A2#1	A2#2	406.869812
Rg29	A2#2	A2#3	325.153564
Rg30	A2#3	A2#4	1597.649780
Rg31	A2#4	A2#5	797.020508
Rf1	X#1	X#2	80.469910
Rf2	X#2	X	10.847330
Rf3	X	X#3	12.308095
Rf4	X#3	X	4.953798
Rf5	X	X#5	7.282945
Rf6	X#2	X	7.395233
Rf7	X	X#7	18.000221
Rf8	X#7	X	0.246578
Rf9	X#3	X#8	70.442986
Rf10	X#5	X	7.282945
Rf11	X#4	X#5	7.500000
Rf12	X#6	X#7	5.000000
Rf13	B1	B1#2	161.413818
Rf14	a_86_260##13	a_86_260##15	109.869408
Rf15	a_86_260##15	a_86_260##16	51.980942
Rf16	a_86_260##16	a_86_260##3	91.027374
Rf17	a_86_260##16	a_86_260##18	56.952602
Rf18	a_86_260##14	a_86_260##15	5.000000
Rf19	A3	A3#8	0.393673
Rf20	A3#8	A3	18.502617
Rf21	A1#7	A1	0.631129
Rf22	A1#2	A1#9	160.863937
Rf23	A1#7	A1#9	7.479781
Rf24	a_968_392#	a_968_392##2	94.680191
Rf25	a_492_125#	a_492_125##2	81.448502
Rf26	a_492_125##2	a_492_125##3	68.002594
Rf27	a_492_125##3	a_492_125##5	69.275467
Rf28	a_492_125##5	a_492_125##6	115.609055
Rf29	a_492_125##2	a_492_125##7	16.224981
Rf30	a_492_125##3	a_492_125##8	16.224981
Rf31	a_492_125##4	a_492_125##5	7.500000
Rf32	A2#2	A2#7	160.851227
Rf33	A2#8	A2	0.618430
Rf34	A2#7	A2#8	7.873454
Rf35	a_699_392#	a_699_392##2	153.167603
Rf36	a_699_392##2	a_699_392##3	61.626808
Rf37	a_699_392##2	a_699_392##4	22.185177
Rf39	VGND#2	VGND#3	67.887894
Rf40	VGND#3	VGND#4	65.753731
Rf41	VGND#4	VGND#5	52.994427
Rf42	VGND#5	VGND#6	96.036865
Rf43	VGND#6	VGND#7	63.992695
Rf44	VGND#7	VGND#8	107.213768
Rf45	VGND#2	VGND#9	42.184113
Rf46	VGND#3	VGND#10	42.184113
Rf47	VGND#4	VGND#11	50.329590
Rf48	VGND#6	VGND#12	33.306259
Rf49	VGND#7	VGND#13	51.511902
Rf51	VPWR#2	VPWR#3	151.920502
Rf52	VPWR#3	VPWR#4	20.429605
Rf53	VPWR#4	VPWR#5	69.041000
Rf54	VPWR#5	VPWR#6	71.655113
Rf55	VPWR#6	VPWR#7	114.223145
Rf56	VPWR#2	VPWR#8	32.539131
Rf57	VPWR#4	VPWR#9	32.342297
Rf58	VPWR#5	VPWR#10	48.259808
Rf59	VPWR#6	VPWR#11	42.573776
Rf62	A3#3	A3#8	80.116402
Re1	VPWR#3	VPWR	0.701577
Re2	VGND	VGND#5	0.701602
*
*       CAPACITOR CARDS
*
*
C1	VGND#8	VGND#13	1.44809e-18
C2	a_492_125##2	A1#4	1.62885e-17
C3	A3#4	A2#4	1.66768e-17
C4	a_492_125##3	A3#4	2.15939e-18
C5	B1#3	A3#4	1.76787e-17
C6	a_492_125##3	A2#4	1.29711e-17
C7	B1#3	a_492_125##6	2.91466e-18
C8	VGND#7	a_86_260##7	6.57747e-19
C9	a_492_125##2	A2#4	3.79568e-19
C10	VPWR#3	A3#4	6.0148e-20
C11	VGND#6	a_86_260##7	3.78885e-18
C12	a_492_125##2	A1#3	4.54953e-18
C13	a_492_125##4	a_86_260##13	2.19847e-18
C14	VPWR#3	B1#3	1.02389e-19
C15	VGND#4	a_86_260##7	3.29869e-19
C16	a_492_125##3	A3#1	1.69909e-17
C17	VGND#7	a_86_260##8	7.56538e-18
C18	a_492_125##4	a_699_392##3	3.29839e-19
C19	VGND#7	a_86_260##10	5.20194e-18
C20	a_699_392#	a_968_392#	1.07103e-16
C21	VGND#5	B1#3	4.23453e-20
C22	VGND#5	a_86_260##5	4.39314e-21
C23	VGND#5	a_86_260##4	3.15831e-21
C24	VGND#7	a_86_260##12	2.81563e-18
C25	a_86_260##16	A2#4	2.45158e-19
C26	a_86_260##18	a_86_260##14	2.76159e-18
C27	VGND#12	a_86_260##2	2.46611e-18
C28	a_968_392#	VPWR#8	5.54485e-17
C29	a_492_125#	A2#3	4.72776e-17
C30	a_492_125##2	A1#9	2.12645e-17
C31	A2#3	VGND#9	2.3343e-17
C32	a_968_392##2	a_968_392#	2.41843e-18
C33	a_699_392##4	a_699_392#	9.98708e-20
C34	a_492_125#	A1#5	1.74155e-18
C35	a_492_125##7	A2#3	2.40446e-18
C36	B1#1	A3#4	3.66976e-19
C37	a_968_392##2	VPWR#8	4.03156e-17
C38	VGND#9	A1#5	3.12198e-17
C39	VGND#10	A2#3	1.01397e-18
C40	a_492_125#	A1#4	2.52739e-19
C41	a_86_260##16	B1#1	2.14987e-20
C42	A1#5	a_492_125##7	1.53849e-17
C43	A1#3	A1#2	2.77368e-18
C44	B1#3	B1#1	1.38843e-19
C45	VGND#9	A1#4	2.05806e-18
C46	VGND#10	A1#5	1.50111e-18
C47	a_699_392##4	a_968_392##2	5.43385e-17
C48	A1#4	a_492_125##7	1.84161e-17
C49	a_86_260##16	B1#5	7.50311e-18
C50	a_492_125##8	A1#5	2.36491e-19
C51	VGND#9	A2#4	1.31488e-18
C52	VGND#13	a_86_260##4	4.60886e-19
C53	VGND#10	A1#4	3.07539e-17
C54	a_492_125##7	A2#4	5.51978e-18
C55	a_699_392##2	A2#1	2.72932e-19
C56	a_86_260##16	a_86_260##7	1.1426e-18
C57	a_492_125##8	A1#4	5.41336e-19
C58	a_86_260##13	a_699_392##4	5.09121e-17
C59	VGND#10	A2#4	2.7762e-17
C60	a_86_260##5	X#4	2.11174e-19
C61	a_492_125##7	A3#1	2.39622e-19
C62	A2#4	a_492_125##8	1.12989e-17
C63	a_86_260##16	a_86_260##8	4.18921e-19
C64	a_699_392##2	A1#1	1.74329e-19
C65	VGND#10	A3#1	1.72017e-18
C66	VGND#11	A2#4	1.9358e-18
C67	a_86_260##4	X#4	1.51817e-19
C68	a_86_260##13	a_699_392##3	5.4764e-17
C69	a_86_260##5	a_86_260##4	5.65363e-18
C70	a_492_125##8	A3#1	2.74092e-17
C71	a_86_260##2	B1#3	1.31365e-17
C72	a_86_260##2	B1#5	1.37461e-18
C73	a_86_260##16	a_86_260##10	2.61056e-19
C74	VGND#3	a_492_125##7	2.62761e-18
C75	a_492_125##4	A2#4	1.13103e-18
C76	VGND#10	A3#7	4.0652e-19
C77	a_699_392##2	A1#6	1.75816e-17
C78	VPWR#9	a_86_260##13	8.16649e-18
C79	a_86_260##14	a_699_392##4	6.29501e-22
C80	VGND#4	VGND#10	1.10447e-18
C81	A3#1	VGND#11	1.5689e-17
C82	a_492_125##8	A3#7	1.35016e-18
C83	VGND#8	VPWR#7	9.71428e-18
C84	a_492_125##4	A3#1	5.38019e-19
C85	a_86_260##14	a_86_260##13	1.30862e-18
C86	a_86_260##16	a_86_260##12	2.82072e-19
C87	VGND#11	A3#7	2.86204e-17
C88	VPWR#5	B1#6	4.90208e-19
C89	a_699_392##2	A2#5	1.76229e-17
C90	a_86_260##18	A3#1	4.92697e-19
C91	VGND#4	a_492_125##8	2.67388e-18
C92	a_492_125##8	B1#1	2.69667e-19
C93	a_86_260##14	a_699_392##3	2.06534e-18
C94	VPWR#4	B1#6	1.78412e-18
C95	a_492_125##4	A3#7	2.69331e-17
C96	a_699_392#	A2#3	3.54067e-19
C97	a_86_260##14	VPWR#9	5.54644e-17
C98	VPWR#6	B1#4	8.43591e-20
C99	a_86_260##18	A3#7	1.00528e-18
C100	a_968_392#	A1#3	1.99269e-19
C101	VGND#3	a_492_125##8	3.28031e-18
C102	a_699_392##2	A3#6	1.8774e-17
C103	VPWR#5	B1#4	7.72275e-18
C104	B1#1	a_492_125##4	3.29287e-17
C105	VPWR#6	VPWR#5	7.06045e-19
C106	a_968_392#	A2#3	2.94563e-19
C107	a_492_125##6	A3#7	2.11071e-19
C108	VPWR#10	VPWR#9	2.34061e-18
C109	a_86_260##18	B1#1	4.48479e-17
C110	a_492_125##4	B1#5	4.13764e-19
C111	a_86_260##3	a_86_260##5	3.21481e-19
C112	VPWR#6	a_86_260#	3.00302e-19
C113	VPWR#10	a_86_260##14	7.10568e-17
C114	a_492_125##6	B1#1	1.08458e-18
C115	a_699_392##2	A3#5	8.88541e-20
C116	a_86_260##3	a_86_260##4	1.51921e-17
C117	VGND#11	a_86_260##7	7.92454e-20
C118	VPWR#5	a_86_260#	7.45539e-18
C119	a_86_260##3	a_86_260##2	2.40663e-17
C120	VGND#4	a_492_125##4	1.98034e-17
C121	a_86_260##18	B1#5	2.30039e-17
C122	VGND#12	B1#1	3.36293e-19
C123	a_86_260##16	A3#4	6.82842e-19
C124	a_492_125##6	B1#5	3.68757e-17
C125	VPWR#8	A1#3	3.46601e-19
C126	a_86_260##18	a_86_260##7	3.23076e-19
C127	VPWR#6	a_86_260##9	7.54858e-18
C128	X#1	VPWR#10	8.62732e-17
C129	a_699_392##2	B1#6	3.27109e-20
C130	VGND#12	B1#5	2.68879e-18
C131	VPWR#5	a_86_260##9	3.00302e-19
C132	VPWR#5	VPWR#4	1.05144e-18
C133	a_492_125##6	a_86_260##7	2.26359e-18
C134	VPWR#11	VPWR#10	2.00319e-18
C135	VGND#6	a_492_125##6	2.33901e-17
C136	VGND#12	a_86_260##7	4.82017e-17
C137	VGND#7	VGND#12	5.58403e-20
C138	a_699_392##2	B1#4	2.48419e-20
C139	a_968_392##2	A2#4	2.37326e-19
C140	X#1	VPWR#11	6.42909e-17
C141	VPWR#6	a_86_260##11	5.48072e-18
C142	a_86_260##16	B1#3	2.89546e-17
C143	X#8	a_86_260##7	1.36581e-17
C144	VPWR#5	a_86_260##11	8.74044e-20
C145	VGND#12	a_86_260##8	2.69217e-18
C146	VGND#13	a_86_260##7	4.1872e-19
C147	a_968_392##2	A1#3	1.23008e-19
C148	VPWR#6	a_86_260##5	4.54236e-20
C149	a_492_125##2	VGND#9	1.54656e-17
C150	X#8	a_86_260##8	4.94776e-17
C151	VGND#7	X#8	5.40833e-18
C152	a_86_260##16	a_86_260##5	7.9716e-20
C153	VGND#12	a_86_260##10	3.19809e-19
C154	VPWR#6	a_86_260##6	3.74116e-18
C155	a_86_260##8	VGND#13	1.66055e-17
C156	X#8	a_86_260##10	1.61703e-18
C157	VPWR#5	B1#3	1.8248e-20
C158	VGND#6	X#8	7.54368e-18
C159	VPWR#7	VPWR#11	2.2895e-18
C160	a_492_125##2	a_492_125##7	6.20844e-19
C161	a_86_260##16	a_86_260##4	1.15078e-19
C162	VPWR#6	a_86_260##4	3.66142e-20
C163	a_492_125##3	VGND#10	1.4191e-17
C164	a_86_260##10	VGND#13	1.9045e-17
C165	VGND#8	a_86_260##8	2.72506e-19
C166	a_86_260##10	X#4	1.49316e-17
C167	a_86_260##16	B1#6	1.97956e-18
C168	VGND#13	a_86_260##12	5.13768e-19
C169	a_492_125##2	VGND#10	1.6392e-17
C170	VGND#8	a_86_260##10	1.34033e-18
C171	a_86_260##16	a_86_260##2	4.84129e-19
C172	a_492_125##3	a_492_125##8	3.22492e-19
C173	a_86_260##12	X#4	1.54384e-17
C174	VPWR#3	VPWR#6	4.45976e-17
C175	VGND#8	a_86_260##12	2.69002e-17
C176	VPWR#4	B1#3	6.54122e-20
C177	a_86_260##16	B1#4	8.5076e-18
C178	VPWR#3	VPWR#5	3.77766e-17
C179	a_492_125##3	VGND#11	1.14272e-17
C180	VPWR#3	VPWR#4	2.69432e-17
C181	VGND#8	VGND#7	1.23091e-18
C182	A2#3	A1#5	4.19978e-17
C183	a_86_260##16	a_86_260#	1.49585e-19
C184	a_86_260##13	A3#4	8.00844e-19
C185	a_699_392#	A2#1	5.32181e-17
C186	A1#4	A1#5	2.52929e-17
C187	A2#4	A2#3	6.11582e-19
C188	A2#1	a_968_392#	2.31924e-17
C189	VGND#5	VGND#7	4.03175e-17
C190	a_699_392#	A1#1	1.63554e-17
C191	VGND#5	VGND#6	4.73801e-17
C192	VPWR#8	A2#1	1.48639e-18
C193	a_699_392##2	VPWR#3	5.8527e-19
C194	VGND#5	VGND#4	3.27504e-17
C195	a_968_392#	A1#1	5.61044e-17
C196	A2#4	A1#4	5.3977e-17
C197	a_86_260##13	B1#3	1.94375e-18
C198	VGND#5	VGND#3	3.76942e-17
C199	a_699_392#	A1#6	2.2035e-19
C200	A1#1	VPWR#8	2.57079e-17
C201	a_699_392##4	A2#1	3.57658e-20
C202	a_968_392#	A1#6	1.07762e-18
C203	a_968_392##2	A1#1	3.97021e-19
C204	a_699_392##3	A3#4	1.83864e-18
C205	a_86_260##16	a_86_260##6	2.98899e-20
C206	a_699_392#	A2#5	1.26201e-19
C207	VPWR#8	A1#6	3.82712e-17
C208	A3#1	A2#4	4.13106e-17
C209	a_699_392##4	A1#1	2.23126e-20
C210	a_968_392#	A2#5	2.00227e-19
C211	a_968_392##2	A1#6	3.19515e-17
C212	a_699_392#	A3#6	8.7313e-20
C213	VPWR#8	A2#5	2.12736e-18
C214	a_699_392##4	A1#6	1.09733e-19
C215	VGND#7	VGND#6	1.03041e-18
C216	A3#7	A3#1	3.5228e-17
C217	a_968_392##2	A2#5	4.04243e-17
C218	VPWR#8	A3#6	7.38616e-19
C219	A2#5	a_699_392##4	1.83536e-17
C220	B1	A1#3	1.42064e-19
C221	a_968_392##2	A3#6	1.24128e-18
C222	a_86_260##13	A2#5	1.16593e-18
C223	B1	A3#4	1.36876e-18
C224	VPWR#9	A1#6	2.16143e-19
C225	B1#1	A3#7	1.84346e-17
C226	a_699_392##2	A1#2	1.16402e-18
C227	B1	B1#3	1.8977e-17
C228	VPWR#8	A3#5	4.2871e-19
C229	A3#6	a_699_392##4	2.32518e-17
C230	a_699_392##2	a_699_392#	8.10142e-19
C231	a_86_260##13	A3#6	4.56843e-17
C232	VPWR#9	A2#5	3.25616e-19
C233	A2#5	A1#3	1.30553e-17
C234	A1#9	A2#2	2.65108e-17
C235	a_699_392##4	A3#5	1.86294e-19
C236	a_86_260##14	A2#5	6.8958e-20
C237	A3#4	A2#5	1.30577e-17
C238	B1#5	B1#1	2.69582e-17
C239	a_86_260##13	A3#5	5.46886e-17
C240	VPWR#9	A3#6	5.90508e-19
C241	B1#3	VPWR#9	1.73991e-18
C242	a_699_392##2	a_968_392#	1.23518e-17
C243	VPWR#6	a_86_260##3	4.57114e-20
C244	a_492_125##2	A1#2	4.04082e-18
C245	VGND#7	a_86_260##5	5.3306e-20
C246	a_699_392##4	B1#6	7.26264e-20
C247	a_86_260##3	VPWR#5	3.75625e-19
C248	a_699_392##3	A3#5	4.30507e-17
C249	VPWR#5	VPWR#9	2.29393e-19
C250	a_86_260##14	A3#6	6.89704e-20
C251	A1#9	A1#2	1.28043e-17
C252	a_86_260##13	B1#6	1.57311e-18
C253	VPWR#9	A3#5	5.76071e-18
C254	a_86_260##7	B1#5	3.86883e-18
C255	a_699_392##4	B1#4	4.76243e-20
C256	a_699_392##3	B1#6	1.80763e-18
C257	VGND#4	A3#4	1.95552e-20
C258	a_86_260##14	A3#5	6.9742e-19
C259	VGND#7	a_86_260##3	3.38958e-20
C260	VGND#6	B1#3	3.48004e-19
C261	a_699_392##2	VPWR#8	1.47974e-18
C262	a_492_125#	VGND#9	5.06326e-17
C263	VGND#6	a_86_260##3	6.61867e-19
C264	a_86_260##13	B1#4	1.18737e-19
C265	VPWR#9	B1#6	4.80709e-17
C266	VGND#7	a_86_260##4	3.83227e-20
C267	a_86_260##14	VPWR#5	6.40831e-18
C268	a_699_392##3	B1#4	2.53443e-19
C269	a_86_260##14	B1#6	3.39291e-17
C270	a_86_260##8	a_86_260##7	3.93378e-17
C271	a_86_260##16	a_492_125##6	2.90755e-17
C272	VPWR#9	B1#4	2.11424e-18
C273	VGND#3	A1#3	2.73772e-19
C274	VPWR#10	B1#6	6.07259e-19
C275	a_492_125##7	a_492_125#	3.11662e-18
C276	a_86_260##14	B1#3	3.20864e-18
C277	A2#2	a_492_125#	3.37586e-17
C278	a_86_260##14	VPWR#4	7.95713e-18
C279	a_86_260##14	B1#4	4.65464e-17
C280	a_699_392##2	a_968_392##2	4.73229e-17
C281	VGND#4	VGND#3	2.84035e-18
C282	VPWR#9	a_86_260#	3.12271e-19
C283	B1#4	VPWR#10	2.57833e-17
C284	a_86_260##10	a_86_260##8	3.67068e-17
C285	VGND#5	a_492_125##4	3.60702e-17
C286	A1	A1#3	4.47607e-18
C287	a_86_260##14	a_86_260#	1.35149e-18
C288	X#1	B1#4	1.67453e-18
C289	a_492_125##7	VGND#9	3.04029e-17
C290	a_86_260#	VPWR#10	3.13833e-17
C291	VGND#5	a_492_125##6	3.10179e-17
C292	VPWR#11	B1#4	1.73929e-19
C293	VGND#9	A1#2	6.00673e-19
C294	a_492_125##2	a_699_392#	8.40617e-19
C295	X#1	VPWR#6	8.77092e-18
C296	a_699_392##2	a_699_392##4	2.19556e-18
C297	a_86_260##12	a_86_260##10	3.92697e-17
C298	X#1	a_86_260#	6.65145e-17
C299	VPWR#10	a_86_260##9	3.71489e-19
C300	VPWR#11	a_86_260#	3.71489e-19
C301	VGND#10	VGND#9	7.27687e-18
C302	X#1	VPWR#5	8.44616e-18
C303	X#1	a_86_260##9	6.72832e-17
C304	a_86_260##16	a_86_260##3	1.86715e-19
C305	a_86_260##9	VPWR#11	2.09722e-17
C306	VPWR#10	a_86_260##11	1.72497e-19
C307	VGND#5	VGND#8	2.65998e-17
C308	a_699_392##2	a_86_260##13	1.56113e-17
C309	VGND#10	a_492_125##7	3.19707e-17
C310	B1#3	A3#5	4.2008e-20
C311	X#1	a_86_260##11	2.23002e-18
C312	A1#9	a_699_392#	2.82786e-17
C313	A3	A1#3	1.56102e-17
C314	VPWR#11	a_86_260##11	4.59058e-17
C315	A3	A3#4	3.76962e-17
C316	A3	B1#3	1.15064e-17
C317	a_86_260##13	VPWR#3	2.62828e-17
C318	a_86_260##11	X#6	2.83644e-18
C319	X#1	a_86_260##6	2.85102e-19
C320	A2#2	a_699_392#	3.31182e-17
C321	a_492_125##8	a_492_125##7	2.97487e-18
C322	VPWR#7	a_86_260##11	1.16752e-18
C323	VPWR#11	a_86_260##6	2.26644e-18
C324	A1#9	a_968_392#	1.58075e-19
C325	a_86_260##6	X#6	2.43476e-17
C326	A1#1	A2#1	3.55116e-17
C327	a_86_260##14	VPWR#3	8.32972e-19
C328	a_699_392#	A1#2	1.40243e-18
C329	VPWR#7	a_86_260##6	3.16783e-17
C330	a_968_392#	A1#2	6.80407e-19
C331	a_492_125##8	VGND#10	3.04029e-17
C332	VPWR#8	A1#2	3.3421e-19
C333	A1#6	A1#1	3.3469e-17
C334	VPWR#7	VPWR#6	9.47412e-19
C335	VGND#11	VGND#10	6.01326e-18
C336	VPWR#3	VPWR#7	2.50241e-17
C337	X	a_86_260##5	1.81616e-17
C338	a_86_260##3	VGND#12	3.97473e-17
C339	X	a_86_260##4	1.47165e-17
C340	X	a_86_260##2	2.12297e-19
C341	a_86_260##3	X#8	5.56822e-17
C342	A2#5	A1#6	4.24696e-17
C343	a_86_260##3	VGND#13	3.52421e-18
C344	a_699_392##2	a_86_260##14	1.6477e-22
C345	VGND#11	a_492_125##8	2.98988e-17
C346	A3#6	A2#5	4.36648e-17
C347	a_699_392##2	A1#3	2.01836e-18
C348	B1#4	B1#3	1.05153e-17
C349	a_492_125##4	a_492_125##8	3.4412e-18
C350	A3#5	A3#6	4.14786e-17
C351	A2#3	A1#2	7.14863e-19
C352	VGND#5	A3#7	3.17029e-20
C353	VPWR	B1#3	7.27166e-21
C354	a_699_392##2	A3#4	1.34379e-18
C355	VGND#5	B1#1	1.11821e-18
C356	VPWR#11	a_86_260##4	3.14935e-19
C357	a_492_125##4	VGND#11	5.69174e-17
C358	B1#6	A3#5	3.57555e-18
C359	VGND#5	B1#5	1.11953e-18
C360	a_86_260##2	B1#4	3.49828e-18
C361	A2#4	A1#2	7.40561e-20
C362	a_86_260##3	VPWR#10	2.27726e-17
C363	a_86_260##3	X#1	5.28297e-17
C364	a_86_260##16	B1	4.23663e-17
C365	a_86_260##3	VPWR#11	2.82247e-18
C366	B1#4	B1#6	4.21668e-17
C367	A1	a_699_392##2	1.88509e-17
C368	a_86_260#	B1#4	3.79005e-17
C369	a_492_125##4	a_86_260##18	6.72314e-17
C370	VGND	B1#3	4.20742e-19
C371	VGND	a_86_260##4	5.45672e-19
C372	a_492_125##2	A1	2.5917e-17
C373	VGND#4	a_492_125##3	2.61567e-19
C374	VGND	a_86_260##2	1.89619e-20
C375	a_86_260##9	a_86_260#	4.69813e-17
C376	B1	a_86_260##18	3.58018e-17
C377	A2	a_492_125#	1.87505e-17
C378	VPWR#3	A3#6	4.58083e-18
C379	A3	a_699_392##2	9.80759e-17
C380	a_492_125##6	a_492_125##4	2.55986e-18
C381	VPWR#3	A3#5	5.54102e-18
C382	a_86_260##11	a_86_260##9	4.7224e-17
C383	X	VPWR#6	1.44522e-17
C384	a_492_125##3	A3	7.57457e-17
C385	VGND#11	A3#4	1.24406e-18
C386	a_492_125##2	A3	2.11071e-17
C387	VGND#3	a_492_125##3	2.41016e-19
C388	a_492_125#	a_699_392#	5.06792e-18
C389	VGND#7	X	1.71211e-17
C390	VGND#3	A2#3	2.16542e-19
C391	a_86_260##6	a_86_260##11	4.74963e-17
C392	a_492_125##6	a_86_260##18	5.84549e-17
C393	a_86_260##16	A3	1.16935e-18
C394	B1	a_699_392##3	1.94596e-17
C395	A2	a_699_392#	2.04335e-17
C396	B1	VPWR#9	1.06518e-18
C397	a_86_260##14	B1	3.87072e-17
C398	VPWR	VPWR#6	4.09815e-17
C399	a_86_260##4	a_86_260##9	1.71475e-18
C400	VPWR	VPWR#5	3.80688e-17
C401	VGND#12	a_86_260##18	3.06529e-18
C402	VGND#3	a_492_125##2	2.01306e-19
C403	VPWR	VPWR#4	1.82337e-17
C404	a_86_260##16	VPWR#5	1.7165e-19
C405	X	a_86_260##16	2.91049e-19
C406	A3	VGND#11	2.84535e-18
C407	A1	a_699_392#	5.37416e-18
C408	A3	a_492_125##4	5.24179e-17
C409	A1	VPWR#8	2.51339e-18
C410	VPWR	a_699_392##2	6.97025e-18
C411	VGND#12	a_492_125##6	5.17638e-17
C412	a_492_125##4	A3#4	2.75035e-18
C413	VPWR	A1#9	1.16366e-18
C414	VPWR	a_86_260##16	8.36647e-19
C415	VGND#3	A1#4	6.43858e-19
C416	X	a_492_125##6	9.08882e-20
C417	VGND	VGND#7	3.43008e-17
C418	VGND	VGND#6	2.87715e-17
C419	A3	a_86_260##13	3.08407e-18
C420	VGND	VGND#4	3.58599e-17
C421	X	X#8	4.60708e-18
C422	VGND	VGND#3	4.46984e-17
C423	A3	a_699_392##3	5.04918e-17
C424	X	VGND#13	5.31899e-17
C425	A1	A2#3	4.89473e-20
C426	a_86_260##16	a_86_260##14	8.35432e-19
C427	A1#2	A2#2	2.88437e-17
C428	VGND#8	X	7.16662e-17
C429	A1#3	VNB	3.07266e-17
C430	A3#4	VNB	6.53004e-17
C431	B1#3	VNB	6.89505e-17
C432	VGND	a_492_125##3	2.39957e-18
C433	A1	A2#4	1.01612e-19
C434	a_86_260##5	VNB	3.72829e-17
C435	a_86_260##4	VNB	2.72581e-17
C436	VGND	a_492_125##2	2.50158e-18
C437	VGND#4	A2#4	3.25905e-18
C438	a_86_260##2	VNB	2.83353e-17
C439	VGND	A1#9	1.25611e-18
C440	VGND	a_86_260##16	5.97676e-18
C441	B1	A1#6	1.62312e-19
C442	X#8	VGND#12	6.48324e-17
C443	B1	A2#5	4.30309e-19
C444	A3	A2#4	1.31081e-17
C445	X	X#1	3.54096e-18
C446	VGND#3	A2#4	2.25924e-17
C447	VPWR	a_699_392#	1.954e-17
C448	B1	A3#6	4.06736e-19
C449	X	VPWR#11	8.68351e-17
C450	VPWR	a_968_392#	1.74365e-17
C451	VGND	a_492_125#	1.41552e-17
C452	VPWR	VPWR#8	1.78545e-17
C453	X	X#6	4.27084e-18
C454	B1	A3#5	1.72322e-18
C455	a_86_260##16	VPWR#10	1.79593e-17
C456	VGND	a_492_125##7	1.10949e-17
C457	VPWR	a_968_392##2	1.47269e-17
C458	VPWR#7	X	8.86838e-17
C459	VPWR	a_699_392##4	1.23818e-17
C460	B1	B1#6	6.72196e-18
C461	VGND	a_492_125##8	1.07475e-17
C462	VPWR	a_86_260##13	2.44856e-17
C463	VGND	a_492_125##4	2.28759e-17
C464	VPWR	a_699_392##3	3.6393e-18
C465	B1	B1#4	1.01706e-18
C466	VGND	a_86_260##18	8.09102e-18
C467	VPWR	VPWR#9	1.56753e-17
C468	VGND	a_492_125##6	2.52522e-17
C469	VPWR	a_86_260##14	1.9973e-17
C470	VGND	VGND#12	2.21622e-17
C471	VGND	X#8	1.38163e-17
C472	VPWR	X#1	1.75397e-17
C473	a_492_125##2	a_699_392##2	5.59676e-18
C474	VGND#4	A3#1	2.02848e-18
C475	VGND#13	VGND#12	1.66901e-18
C476	VGND	VGND#8	3.21427e-17
C477	X	B1#5	8.61639e-20
C478	VPWR	VPWR#7	3.12729e-17
C479	X	a_86_260##7	4.0652e-20
C480	X	a_86_260##8	1.68324e-18
C481	X	a_86_260##10	4.14327e-17
C482	A3	A2#5	1.36809e-17
C483	X	a_86_260##12	2.38723e-17
C484	X#1	a_86_260##16	1.22688e-18
C485	VPWR#6	VNB	3.31889e-17
C486	VGND	VPWR#10	2.76965e-18
C487	VPWR#5	VNB	2.83101e-17
C488	VPWR#4	VNB	2.15691e-17
C489	VGND	X#1	2.56619e-18
C490	VGND#7	VNB	3.20873e-17
C491	VGND#6	VNB	3.97227e-17
C492	VGND#4	VNB	2.783e-17
C493	VGND#3	VNB	2.53747e-17
C494	VGND	VPWR#7	3.12218e-18
C495	VGND	A2#3	6.48154e-18
C496	X#8	VGND#13	3.58957e-17
C497	a_699_392##2	VNB	3.67473e-18
C498	VGND	A1#5	2.58553e-18
C499	VGND	A1#4	2.58553e-18
C500	a_492_125##3	VNB	2.25759e-18
C501	VGND	A2#4	4.91132e-18
C502	A2	A2#2	9.80901e-18
C503	a_492_125##2	VNB	1.50432e-18
C504	VGND	A3#1	6.61724e-18
C505	a_699_392##2	A2#4	3.39209e-19
C506	VPWR	A2#1	1.23329e-18
C507	A1#9	VNB	1.47523e-19
C508	a_86_260##6	a_86_260##4	3.48594e-18
C509	a_492_125##2	A2#3	2.30603e-19
C510	VGND	A3#7	2.27145e-18
C511	X	B1#4	4.25763e-20
C512	a_86_260##16	VNB	7.49017e-18
C513	VPWR	A1#6	1.07805e-18
C514	VGND	a_86_260##7	1.52998e-18
C515	VPWR	A2#5	1.93016e-18
C516	VGND#4	A3#7	7.32903e-19
C517	VGND	a_86_260##8	4.03346e-20
C518	X	a_86_260##9	5.53802e-19
C519	VPWR	A3#6	1.83495e-18
C520	a_492_125#	VNB	4.15281e-17
C521	VGND	a_86_260##10	4.33892e-19
C522	A1	A1#2	4.94382e-18
C523	VGND#9	VNB	5.23687e-18
C524	VPWR	A3#5	8.3425e-19
C525	X	a_86_260##11	2.57497e-17
C526	a_492_125##7	VNB	3.14244e-18
C527	VGND	a_86_260##12	4.89856e-18
C528	VGND#10	VNB	2.13964e-18
C529	VPWR	B1#6	7.48676e-19
C530	a_492_125##8	VNB	3.04795e-18
C531	X	a_86_260##6	3.29437e-17
C532	VGND#11	VNB	1.66813e-18
C533	a_492_125##4	VNB	1.9658e-17
C534	VPWR	B1#4	3.84959e-18
C535	a_86_260##18	VNB	3.22197e-19
C536	a_492_125##6	VNB	1.83156e-17
C537	VPWR	a_86_260#	2.61005e-18
C538	VGND#12	VNB	1.0002e-17
C539	X#8	VNB	2.37431e-18
C540	VGND#13	VNB	2.2045e-18
C541	VPWR	a_86_260##9	3.94344e-19
C542	VGND#8	VNB	6.94842e-17
C543	VPWR	a_86_260##11	7.29237e-19
C544	a_699_392#	VNB	5.75137e-17
C545	a_86_260##18	B1#3	4.47775e-18
C546	a_968_392#	VNB	2.70185e-18
C547	VPWR#8	VNB	2.16341e-18
C548	VPWR	a_86_260##6	5.01335e-18
C549	a_968_392##2	VNB	2.18851e-18
C550	a_699_392##4	VNB	4.80095e-18
C551	a_86_260##13	VNB	6.78113e-18
C552	a_699_392##3	VNB	3.59118e-18
C553	VPWR#9	VNB	3.34134e-18
C554	VPWR	VPWR#3	2.88796e-17
C555	a_86_260##14	VNB	4.69788e-18
C556	VPWR#10	VNB	5.48117e-18
C557	X#1	VNB	2.55849e-18
C558	VPWR#11	VNB	4.09278e-19
C559	VGND#6	a_86_260##16	1.3976e-18
C560	VPWR	A2#2	1.11622e-18
C561	VPWR#7	VNB	8.01608e-17
C562	A2#3	VNB	8.56106e-17
C563	X	a_86_260##3	8.32699e-17
C564	A1#5	VNB	2.19551e-17
C565	A1#4	VNB	2.08154e-17
C566	A2#4	VNB	9.04646e-17
C567	A3#1	VNB	2.87892e-17
C568	A3#7	VNB	2.62011e-17
C569	B1#1	VNB	2.96554e-17
C570	VGND	VGND#5	1.60125e-17
C571	a_492_125##2	A1#5	1.77681e-17
C572	B1#5	VNB	2.66378e-17
C573	a_86_260##7	VNB	3.18161e-17
C574	VGND	A2#2	1.28027e-18
C575	VPWR	a_86_260##3	6.46173e-18
C576	a_86_260##8	VNB	3.0151e-17
C577	A1#9	A2#3	1.22615e-19
C578	a_86_260##10	VNB	2.72966e-17
C579	a_86_260##12	VNB	3.37005e-17
C580	A2#1	VNB	3.77215e-17
C581	B1	A3	2.14246e-17
C582	A1#1	VNB	2.89216e-17
C583	A1#6	VNB	2.70632e-17
C584	A2#5	VNB	4.18937e-17
C585	VGND	a_86_260##3	7.76883e-18
C586	A3#6	VNB	2.95575e-17
C587	A3#5	VNB	4.21878e-17
C588	B1#6	VNB	2.98618e-17
C589	B1#4	VNB	4.52489e-17
C590	A3	A1	2.28508e-17
C591	a_86_260#	VNB	3.82817e-17
C592	a_86_260##9	VNB	3.46798e-17
C593	a_86_260##11	VNB	2.8004e-17
C594	VPWR	B1	3.84196e-18
C595	a_86_260##6	VNB	4.5125e-17
C596	VPWR	A2	1.1857e-18
C597	VPWR#3	VNB	3.0131e-16
C598	VGND#5	VNB	2.952e-16
C599	A2#2	VNB	5.0767e-17
C600	VGND	B1	2.9228e-18
C601	VPWR	A1	1.19066e-18
C602	A1#2	VNB	3.23828e-17
C603	A2#4	A1#3	1.3253e-17
C604	VGND	A2	2.31481e-18
C605	VPWR	A3	6.66103e-18
C606	a_86_260##3	VNB	4.53995e-17
C607	VGND	A1	1.188e-18
C608	VPWR	X	1.92869e-17
C609	VGND	A3	7.07963e-18
C610	VGND	X	1.89783e-17
C611	B1	VNB	3.29221e-18
C612	A2	VNB	1.89817e-17
C613	A1	VNB	7.67288e-19
C614	A3	VNB	6.47624e-19
C615	X	VNB	2.3746e-17
C616	VPWR	VNB	7.69718e-17
C617	VGND	VNB	7.87815e-17
C618	a_699_392##4	VPWR#2	1.87924e-17
C619	VPWR#2	A2#2	4.94341e-20
C620	VPWR#2	VNB	8.10612e-17
C621	VGND#2	A2	5.7942e-19
C622	VGND#2	A1#3	2.25552e-20
C623	VPWR#2	A3#6	1.70686e-19
C624	VPWR#3	VPWR#2	9.82702e-17
C625	VGND#2	A1#5	8.33228e-19
C626	a_699_392#	VPWR#2	2.38113e-17
C627	VGND#2	a_492_125#	9.33405e-18
C628	VPWR#2	A1#6	1.79258e-18
C629	VGND#5	VGND#2	5.48705e-17
C630	VPWR#2	A2#1	5.73755e-18
C631	VGND	VGND#2	5.78937e-17
C632	a_699_392##2	VPWR#2	5.86286e-19
C633	VPWR#2	A1#2	2.50403e-20
C634	VGND#2	A2#4	1.29365e-18
C635	VGND#2	a_492_125##7	2.44168e-18
C636	VGND#2	A2#3	2.44948e-17
C637	VGND#2	A1#2	1.57887e-19
C638	a_968_392##2	VPWR#2	1.68924e-17
C639	a_968_392#	VPWR#2	2.09285e-17
C640	VPWR#2	A2#5	4.836e-18
C641	VGND#2	VNB	4.80103e-17
C642	VGND#2	a_492_125##2	2.60513e-19
C643	VPWR	VPWR#2	5.98755e-17
C644	VPWR#2	A1#1	2.55059e-18
C645	VGND#3	VGND#2	3.18173e-18
C646	VGND#2	A2#2	9.02983e-20
*
*
.ENDS sky130_fd_sc_hs__o31a_4
*
