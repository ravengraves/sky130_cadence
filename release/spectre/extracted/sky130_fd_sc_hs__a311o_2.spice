* Extracted by Quantus, converted by sky130cad/quantus.py
*
*
*
*                       LINUX           Wed Nov 18 08:11:15 2026
*
*
*
*  PROGRAM  advgen
*
*  Name           : advgen - Quantus - (64-bit)
*  Version        : 25.1.0-p047
*  Build Date     : Thu Dec 11 23:20:30 PST 2025
*
*  HSPICE LIBRARY
*
*  OPERATING_TEMPERATURE 150
*  QRC_TECH_DIR <path>/tech
*
*
*

*
.SUBCKT sky130_fd_sc_hs__a311o_2 VPB VNB VGND VPWR X A3 B1 C1 A2 A1
*
*
*  caps2d version: 10
*
*
*       TRANSISTOR CARDS
*
*
XM8 X#3 a_21_270##6 VGND#9 VNB sky130_fd_pr__nfet_01v8_lvt l=0.15 w=0.74 ad=0.2072 as=0.1961 pd=2.04 ps=2.01
XM10 VGND#8 a_21_270# X#3 VNB sky130_fd_pr__nfet_01v8_lvt l=0.15 w=0.74 ad=0.3108 as=0.2072 pd=2.32 ps=2.04
XM0 VGND#8 A3#1 a_351_74# VNB sky130_fd_pr__nfet_01v8_lvt l=0.15 w=0.74 ad=0.3108 as=0.1554 pd=2.32 ps=1.9
XM3 a_351_74# A2#3 a_423_74# VNB sky130_fd_pr__nfet_01v8_lvt l=0.15 w=0.74 ad=0.1554 as=0.2886 pd=1.9 ps=2.26
XM11 a_423_74# A1#3 a_21_270##12 VNB sky130_fd_pr__nfet_01v8_lvt l=0.15 w=0.74 ad=0.2886 as=0.2886 pd=2.26 ps=2.26
XM5 a_21_270##12 B1#3 VGND#7 VNB sky130_fd_pr__nfet_01v8_lvt l=0.15 w=0.74 ad=0.2886 as=0.2886 pd=2.26 ps=2.26
XM6 VGND#7 C1#1 a_21_270##8 VNB sky130_fd_pr__nfet_01v8_lvt l=0.15 w=0.74 ad=0.2886 as=0.1961 pd=2.26 ps=2.01
XM12 VPWR#6 a_21_270##7 X#1 VPB sky130_fd_pr__pfet_01v8 l=0.15 w=1.12 ad=0.308 as=0.336 pd=2.79 ps=2.84
XM13 X#1 a_21_270##5 VPWR#5 VPB sky130_fd_pr__pfet_01v8 l=0.15 w=1.12 ad=0.336 as=0.403 pd=2.84 ps=2.98
XM9 VPWR#5 A3#3 a_330_392##2 VPB sky130_fd_pr__pfet_01v8 l=0.15 w=1 ad=0.403 as=0.33 pd=2.98 ps=2.66
XM7 a_330_392##2 A2#1 VPWR#3 VPB sky130_fd_pr__pfet_01v8 l=0.15 w=1 ad=0.33 as=0.54 pd=2.66 ps=3.08
XM2 VPWR#3 A1#1 a_330_392# VPB sky130_fd_pr__pfet_01v8 l=0.15 w=1 ad=0.54 as=0.33 pd=3.08 ps=2.66
XM1 a_330_392# B1#1 a_660_392# VPB sky130_fd_pr__pfet_01v8 l=0.15 w=1 ad=0.33 as=0.27 pd=2.66 ps=2.54
XM4 a_660_392# C1#3 a_21_270##13 VPB sky130_fd_pr__pfet_01v8 l=0.15 w=1 ad=0.27 as=0.275 pd=2.54 ps=2.55
*
*
*       RESISTOR AND CAP/DIODE CARDS
*
Rg1	a_21_270#	a_21_270##2	370.620300
Rg2	a_21_270##2	a_21_270##3	160.862473
Rg3	a_21_270##3	a_21_270##4	61.366196
Rg4	a_21_270##2	a_21_270##5	505.227142
Rg5	a_21_270##3	a_21_270##6	413.013641
Rg6	a_21_270##3	a_21_270##7	452.720551
Rg7	A3#1	A3#2	330.892151
Rg8	A3#2	A3#3	492.429810
Rg9	A2#1	A2#2	409.090576
Rg10	A2#2	A2#3	439.925934
Rg11	A1#1	A1#2	409.090576
Rg12	A1#2	A1#3	439.925934
Rg13	B1#1	B1#2	492.429810
Rg14	B1#2	B1#3	330.892151
Rg15	C1#1	C1#2	503.486481
Rg16	C1#2	C1#3	482.831268
Rg17	C1#2	C1#4	62.096523
Rf1	X	X#2	2.937730
Rf2	X#2	X#4	61.145699
Rf3	X#1	X#2	15.000000
Rf4	X#3	X#4	7.500000
Rf5	A3#2	A3#5	161.377533
Rf6	A3#6	A3	1.144730
Rf7	A3#5	A3#6	10.679173
Rf8	A2#2	A2	162.201172
Rf9	A1#2	A1	162.201172
Rf10	a_330_392#	a_330_392##2	61.391598
Rf11	B1#4	B1	2.254818
Rf12	B1#2	B1#6	162.487625
Rf13	B1#4	B1#6	2.289460
Rf14	B1#7	B1	2.254818
Rf15	B1#6	B1#7	9.920992
Rf16	a_21_270##8	a_21_270##9	89.126366
Rf17	a_21_270##9	a_21_270##10	184.855637
Rf18	a_21_270##10	a_21_270##4	272.563293
Rf19	a_21_270##9	a_21_270##12	14.578120
Rf20	a_21_270##10	a_21_270##13	201.651901
Rf21	C1#4	C1	162.594833
Rf23	VGND#2	VGND#3	87.250465
Rf24	VGND#3	VGND#4	53.271152
Rf25	VGND#4	VGND#5	73.392853
Rf27	VGND#2	VGND#7	32.667610
Rf28	VGND#4	VGND#8	31.396503
Rf29	VGND#5	VGND#9	41.038895
Rf31	VPWR#2	VPWR#3	27.679647
Rf32	VPWR#2	VPWR#4	64.259903
Rf33	VPWR#4	VPWR#5	35.098007
Rf34	VPWR#4	VPWR#6	99.653198
Re1	VPWR#2	VPWR	1.091357
Re2	VGND	VGND#3	1.091398
*
*       CAPACITOR CARDS
*
*
C1	a_21_270##9	a_21_270##8	2.4757e-18
C2	VGND#4	X#3	8.64201e-18
C3	a_21_270##9	VGND#7	5.58432e-17
C4	VGND#9	a_21_270##3	1.50434e-18
C5	VGND#3	a_21_270##3	2.96665e-21
C6	VGND#4	a_21_270##2	3.7593e-20
C7	a_21_270##9	a_21_270##12	9.18763e-18
C8	VGND#3	a_21_270##2	2.84799e-20
C9	a_21_270##13	C1#2	5.2289e-19
C10	a_21_270##10	VGND#8	4.02048e-17
C11	a_21_270##9	VGND#8	2.20395e-17
C12	X#3	a_21_270##10	2.84569e-17
C13	a_330_392##2	VPWR#4	6.49954e-18
C14	B1#2	C1#2	3.30572e-17
C15	X#3	a_21_270##9	3.07603e-19
C16	a_21_270##10	VGND#9	2.33101e-19
C17	a_21_270##9	a_21_270##13	3.7403e-18
C18	VPWR#6	VPWR#4	9.56424e-19
C19	a_21_270##10	a_330_392#	1.80053e-17
C20	a_21_270##10	VPWR#3	2.74712e-18
C21	a_21_270##8	VGND#7	5.52494e-17
C22	a_21_270##10	a_330_392##2	7.2815e-17
C23	A3#5	VGND#8	6.50583e-19
C24	a_21_270##10	VPWR#5	3.85291e-17
C25	a_21_270##10	X#1	4.24148e-18
C26	a_21_270##2	A3#2	2.68404e-17
C27	a_21_270##10	VPWR#6	5.77554e-19
C28	a_21_270##10	a_21_270##3	1.497e-19
C29	VGND#8	VGND#7	4.88273e-19
C30	a_21_270##10	a_21_270##2	6.16024e-18
C31	a_21_270##4	a_21_270##3	4.2984e-19
C32	a_21_270##9	C1#1	8.92168e-19
C33	VGND#4	A3#1	3.71996e-18
C34	a_21_270##10	B1#3	5.1005e-20
C35	a_21_270##8	a_21_270##13	4.24569e-18
C36	a_21_270##9	B1#3	2.58624e-17
C37	VGND#4	a_21_270#	2.97317e-18
C38	a_21_270##10	A1#3	2.99693e-19
C39	a_21_270##9	A1#3	4.36861e-17
C40	a_21_270##10	A2#3	4.59733e-19
C41	X#3	VGND#8	3.60913e-17
C42	a_21_270##9	A2#3	2.87537e-17
C43	VGND#9	VGND#8	2.26484e-18
C44	a_21_270##10	A3#1	3.68978e-19
C45	a_21_270##9	A3#1	1.67429e-17
C46	VGND#9	X#3	6.99477e-17
C47	a_21_270##10	a_21_270#	7.55184e-18
C48	a_21_270##9	a_21_270#	5.12707e-20
C49	a_21_270##10	a_21_270##6	8.00034e-19
C50	VPWR#4	A1#1	5.52772e-20
C51	a_21_270##9	a_21_270##6	4.51231e-20
C52	VPWR#4	A2#1	2.99503e-19
C53	A3#5	A1#3	3.61712e-19
C54	a_21_270##8	C1#1	4.64681e-17
C55	a_21_270##13	a_330_392#	6.93293e-17
C56	C1#1	VGND#7	2.11303e-17
C57	VPWR#4	A3#3	7.08037e-18
C58	A3#5	A2#3	1.88891e-18
C59	a_21_270##8	B1#3	8.96646e-19
C60	a_21_270##10	B1#1	3.59967e-19
C61	VGND#7	B1#3	3.37551e-17
C62	a_21_270##8	A1#3	1.93866e-19
C63	VPWR#4	a_21_270##5	7.10645e-18
C64	B1#3	a_21_270##12	4.64299e-18
C65	VGND#7	A1#3	1.67548e-18
C66	a_21_270##10	A1#1	3.59033e-19
C67	a_330_392#	VPWR#3	2.02953e-18
C68	A1#3	a_21_270##12	1.80976e-17
C69	VPWR#4	a_21_270##7	3.38712e-18
C70	VGND#7	A2#3	2.32593e-19
C71	a_330_392##2	a_330_392#	1.91662e-18
C72	a_21_270##10	A2#1	1.5489e-17
C73	VGND#8	B1#3	1.82456e-19
C74	VGND#7	A3#1	1.24562e-19
C75	a_330_392##2	VPWR#3	1.77093e-18
C76	a_21_270##10	A3#3	2.16754e-17
C77	VGND#8	A1#3	1.81244e-18
C78	X#3	A1#3	4.45455e-20
C79	VPWR#5	a_330_392##2	3.48544e-17
C80	VGND#8	A2#3	3.7397e-18
C81	a_21_270##10	a_21_270##5	1.82756e-17
C82	X#3	A2#3	5.21541e-20
C83	VGND#8	A3#1	4.3129e-17
C84	a_21_270##10	a_21_270##7	8.48441e-18
C85	X#3	A3#1	8.34111e-19
C86	a_21_270#	VGND#8	2.18157e-17
C87	VGND#9	A3#1	1.79951e-19
C88	VPWR#6	VPWR#5	1.48771e-17
C89	X#3	a_21_270#	3.01404e-17
C90	VGND#3	VGND#4	3.93911e-17
C91	VGND#8	a_21_270##6	1.54255e-18
C92	VGND#9	a_21_270#	7.37627e-19
C93	A3#6	A3#3	2.09585e-18
C94	X#3	a_21_270##6	3.90008e-17
C95	VGND#9	a_21_270##6	2.1029e-17
C96	A3#6	a_21_270##5	5.01455e-19
C97	VGND#3	a_21_270##9	1.23412e-17
C98	B1#3	C1#1	2.06522e-17
C99	a_21_270##13	C1#3	5.44007e-17
C100	A3#6	a_21_270##2	9.47109e-20
C101	a_21_270##13	B1#1	2.69046e-17
C102	A1#3	B1#3	2.40899e-17
C103	a_330_392#	C1#3	7.66353e-18
C104	a_21_270##10	B1#2	1.39791e-19
C105	a_21_270##13	A1#1	1.53147e-17
C106	a_21_270##9	B1#2	1.89215e-17
C107	a_330_392#	B1#1	4.99762e-17
C108	VPWR#4	A3#2	8.77929e-20
C109	A2#3	A1#3	2.98936e-17
C110	a_21_270##10	A1#2	5.06917e-18
C111	a_21_270##13	A2#1	2.89675e-19
C112	a_330_392#	A1#1	5.25396e-17
C113	a_21_270##9	A1#2	3.0463e-18
C114	a_330_392##2	B1#1	1.58589e-19
C115	a_21_270##10	VPWR#4	3.53983e-18
C116	A1#1	VPWR#3	2.35179e-17
C117	a_21_270##13	A3#3	2.88544e-19
C118	a_330_392#	A2#1	5.25128e-19
C119	A3#1	A2#3	5.90118e-17
C120	a_21_270##10	A2#2	2.74121e-18
C121	a_330_392##2	A1#1	5.25128e-19
C122	a_21_270##9	A2#2	2.56379e-18
C123	A2#1	VPWR#3	2.51414e-17
C124	VPWR#5	A1#1	1.52519e-19
C125	a_330_392#	A3#3	1.58589e-19
C126	a_330_392##2	A2#1	4.32293e-17
C127	a_21_270#	A3#1	2.12927e-17
C128	a_21_270##10	A3#2	1.29272e-17
C129	A3#5	B1#2	4.27637e-19
C130	VPWR#5	A2#1	3.75694e-19
C131	a_21_270##8	C1#4	5.90865e-18
C132	a_330_392##2	A3#3	4.54211e-17
C133	A3#5	a_21_270##2	2.86776e-18
C134	B1	C1#2	2.20534e-17
C135	A3#3	VPWR#5	1.64512e-17
C136	a_21_270##4	a_21_270##10	2.831e-18
C137	A3#5	A1#2	3.75492e-19
C138	a_330_392##2	a_21_270##5	2.80758e-18
C139	a_21_270##6	a_21_270#	3.94648e-17
C140	a_21_270##8	B1#2	3.20302e-18
C141	A3#6	A2#2	2.83102e-18
C142	B1#2	VGND#7	2.76966e-18
C143	VPWR#5	a_21_270##5	3.84073e-17
C144	a_330_392##2	a_21_270##7	1.08421e-18
C145	a_21_270##5	X#1	2.66639e-17
C146	A3#5	A2#2	3.93725e-18
C147	VPWR#5	a_21_270##7	5.25588e-18
C148	A3#6	A3#2	6.08776e-18
C149	VPWR#6	a_21_270##5	5.63003e-18
C150	a_21_270##7	X#1	2.73897e-17
C151	VGND#4	a_21_270##9	1.17091e-18
C152	A3#5	A3#2	1.01395e-17
C153	VPWR#6	a_21_270##7	3.36851e-17
C154	C1#4	a_21_270##13	7.67114e-18
C155	B1#2	a_21_270##13	1.98023e-17
C156	B1#1	C1#3	5.45194e-17
C157	a_330_392#	B1#2	3.74593e-19
C158	B1#1	C1#2	4.63249e-18
C159	A1#1	B1#1	3.72702e-17
C160	VGND#8	A3#2	1.07828e-18
C161	a_330_392#	A1#2	1.51796e-18
C162	a_21_270##9	a_423_74#	9.37302e-18
C163	X	a_21_270##3	1.74878e-17
C164	X	a_21_270##2	1.46635e-17
C165	VGND#3	A1#3	5.52403e-18
C166	A2#1	A1#1	1.66745e-17
C167	a_21_270##8	C1#2	3.87112e-19
C168	VGND#3	A2#3	8.38614e-18
C169	B1#2	C1#1	6.22433e-18
C170	VGND#9	a_21_270##4	2.59286e-17
C171	a_330_392##2	A2#2	6.38288e-19
C172	a_21_270##9	a_351_74#	5.80693e-18
C173	A3#3	A2#1	3.66013e-17
C174	A1#3	B1#2	3.49819e-18
C175	a_330_392##2	A3#2	5.2968e-19
C176	a_21_270##5	A3#3	3.77066e-17
C177	a_21_270##13	a_660_392#	4.08698e-18
C178	A1	a_21_270##10	1.56264e-17
C179	a_21_270##9	A1	1.99028e-17
C180	a_21_270##4	VPWR#6	4.96916e-17
C181	a_21_270##7	a_21_270##5	4.94238e-17
C182	a_21_270##9	a_21_270##10	8.06158e-18
C183	A3#2	A2#3	6.66659e-18
C184	B1#2	B1#1	1.83015e-18
C185	A2	a_21_270##10	4.1138e-17
C186	a_21_270##9	A2	1.89611e-17
C187	a_21_270#	A3#2	1.10939e-18
C188	A1#2	B1#1	4.81447e-18
C189	VGND	a_21_270##3	5.81252e-19
C190	A3#6	A2	1.99289e-17
C191	A3#5	A2	9.90058e-18
C192	A3#3	A2#2	4.85588e-18
C193	a_21_270##9	B1	1.20596e-17
C194	A1#3	a_423_74#	2.12051e-17
C195	A1	a_21_270##13	2.54289e-17
C196	A2#3	a_423_74#	2.12051e-17
C197	a_21_270##5	A3#2	5.88962e-18
C198	C1#3	a_660_392#	2.52006e-17
C199	a_21_270##3	a_21_270##2	9.59425e-18
C200	a_21_270##4	A3#3	1.86466e-19
C201	a_21_270##8	C1	1.31701e-17
C202	B1#1	a_660_392#	2.43792e-17
C203	A1	VPWR#3	1.56118e-18
C204	a_21_270##4	a_21_270##5	7.28557e-19
C205	A2#3	a_351_74#	1.44693e-17
C206	a_21_270##4	a_21_270##7	1.20806e-17
C207	A3#1	a_351_74#	1.44693e-17
C208	C1#2	VNB	2.43322e-17
C209	A3#5	B1	2.85546e-18
C210	VGND#3	A2#2	1.85576e-19
C211	a_21_270##3	VNB	2.24004e-17
C212	a_21_270##2	VNB	1.9108e-17
C213	A1#2	B1#2	2.72555e-17
C214	A2	VPWR#3	1.42267e-18
C215	a_21_270##8	B1	3.26868e-17
C216	C1	a_21_270##13	2.66668e-17
C217	VGND#3	a_21_270##4	1.752e-21
C218	X	a_21_270##10	1.08855e-16
C219	A2#2	A1#2	3.15678e-17
C220	VPWR	VPWR#4	4.81533e-17
C221	B1	a_21_270##13	5.37601e-17
C222	A3#2	A2#2	3.00092e-17
C223	a_21_270##3	a_21_270##5	6.33407e-18
C224	A1	B1#1	4.29182e-19
C225	VPWR	a_21_270##10	1.62638e-17
C226	B1	C1#1	5.96437e-18
C227	B1	A1#3	1.63659e-18
C228	VPWR	A3#6	2.28649e-18
C229	VGND	VGND#4	2.57656e-17
C230	B1	A2#3	3.45241e-19
C231	A2	A3#3	4.34004e-19
C232	VGND	a_21_270##10	2.94271e-18
C233	VGND	a_21_270##9	3.06533e-17
C234	VPWR#4	a_21_270##3	1.06945e-20
C235	B1	B1#1	4.27343e-19
C236	VPWR	a_21_270##13	2.48871e-17
C237	A1	B1#2	2.8075e-18
C238	a_21_270##10	A3#6	5.52881e-17
C239	VGND	A3#5	2.67156e-18
C240	VPWR#4	VNB	3.48761e-17
C241	VPWR	a_330_392#	1.86837e-17
C242	A1	A1#2	1.87285e-17
C243	VGND#4	VNB	3.16958e-17
C244	VGND	a_21_270##8	1.7304e-17
C245	VPWR	a_330_392##2	1.8662e-17
C246	VGND	VGND#7	1.97397e-17
C247	A1	A2#2	2.82401e-18
C248	X	a_21_270#	2.16181e-19
C249	a_21_270##10	VNB	1.54561e-17
C250	VPWR	VPWR#6	4.25324e-17
C251	X	a_21_270##6	4.75227e-19
C252	A2	A1#2	3.55141e-18
C253	VGND	VGND#8	2.20786e-17
C254	a_21_270##9	VNB	2.96475e-18
C255	C1	C1#4	2.04408e-17
C256	VGND	X#3	1.67295e-17
C257	A2	A2#2	1.78075e-17
C258	A2	A3#2	2.79533e-18
C259	A3#6	VNB	1.16994e-19
C260	VPWR#4	a_21_270##2	5.27593e-20
C261	A3#5	VNB	1.13858e-19
C262	B1	B1#2	9.08466e-18
C263	X	A3#3	5.26359e-19
C264	a_21_270##8	VNB	3.92949e-17
C265	VGND#7	VNB	1.6907e-18
C266	X	a_21_270##5	1.09198e-17
C267	B1	A1#2	6.70406e-18
C268	VPWR	C1#3	1.23288e-18
C269	VGND	C1#1	6.89007e-19
C270	X	a_21_270##7	7.93843e-18
C271	VGND	B1#3	6.54888e-19
C272	VPWR	B1#1	1.72074e-18
C273	B1	A2#2	3.58393e-19
C274	VGND#8	VNB	1.07593e-18
C275	VGND	A1#3	1.25982e-19
C276	VPWR	A1#1	1.5579e-19
C277	X#3	VNB	4.50679e-18
C278	VGND	A2#3	1.28611e-18
C279	VGND#9	VNB	3.87239e-17
C280	VPWR	A2#1	8.05755e-20
C281	VGND	A3#1	4.20706e-19
C282	a_21_270##13	VNB	5.50523e-17
C283	VPWR	A3#3	1.8155e-18
C284	VGND	a_21_270#	4.20394e-18
C285	a_330_392#	VNB	2.70472e-18
C286	VPWR	a_21_270##5	4.34401e-19
C287	a_330_392##2	VNB	2.69778e-18
C288	VPWR	a_21_270##7	9.5165e-19
C289	VPWR#5	VNB	8.1597e-19
C290	VPWR#6	VNB	5.41627e-17
C291	C1#1	VNB	3.64212e-17
C292	B1#3	VNB	2.43611e-17
C293	A1#3	VNB	3.02513e-17
C294	A2#3	VNB	2.83673e-17
C295	X	A3#2	3.70132e-19
C296	A3#1	VNB	2.48113e-17
C297	VPWR	B1#2	1.16184e-18
C298	A2	A1	2.36052e-17
C299	a_21_270#	VNB	2.75383e-17
C300	a_21_270##4	X	6.04609e-17
C301	a_21_270##6	VNB	3.60747e-17
C302	a_21_270##10	A3#5	3.08548e-17
C303	C1#3	VNB	3.19363e-17
C304	B1#1	VNB	3.30808e-17
C305	VGND	VGND#3	2.31032e-17
C306	A1#1	VNB	2.76441e-17
C307	VGND	C1#4	2.2547e-18
C308	A2#1	VNB	2.83748e-17
C309	VPWR	a_21_270##4	4.79508e-18
C310	VGND	B1#2	1.43793e-18
C311	A1	B1	3.13653e-17
C312	A3#3	VNB	3.62843e-17
C313	a_21_270##5	VNB	3.49278e-17
C314	a_21_270##7	VNB	3.91406e-17
C315	VGND#3	VNB	2.1432e-16
C316	VGND	a_21_270##4	8.71391e-18
C317	B1	C1	3.1727e-17
C318	C1#4	VNB	4.91838e-17
C319	B1#2	VNB	3.07757e-17
C320	A1#2	VNB	3.15993e-17
C321	A2#2	VNB	3.3349e-17
C322	A3#2	VNB	3.28555e-17
C323	VPWR	A1	1.67939e-18
C324	a_21_270##4	VNB	9.81763e-17
C325	VPWR	A2	1.6832e-18
C326	VPWR	C1	5.30092e-18
C327	VGND	A1	2.68801e-18
C328	a_21_270##9	A3#5	2.62486e-17
C329	VGND	A2	2.68801e-18
C330	VPWR	B1	3.27391e-18
C331	VGND	C1	5.76813e-18
C332	A1	VNB	1.88073e-18
C333	VGND	B1	3.5933e-18
C334	A2	VNB	1.86246e-18
C335	VPWR	X	4.36302e-18
C336	C1	VNB	2.22985e-17
C337	B1	VNB	9.70257e-18
C338	VGND	X	1.82738e-18
C339	X	VNB	4.83389e-18
C340	VPWR	VNB	6.1322e-17
C341	VGND	VNB	6.47313e-17
C342	VGND#2	A3#1	1.11127e-20
C343	VGND#5	A3#1	9.07924e-20
C344	VPWR#2	VNB	2.81578e-16
C345	VGND#2	A2#3	6.34814e-20
C346	VGND#4	VGND#2	2.99477e-19
C347	VGND#2	A1#3	5.54542e-19
C348	VGND#2	VNB	6.23923e-17
C349	C1	VPWR#2	1.37089e-18
C350	VPWR#2	VPWR#3	1.52926e-17
C351	VGND#2	B1#3	3.66858e-18
C352	VPWR#2	C1#2	4.14111e-21
C353	VGND	VGND#2	4.53456e-17
C354	VGND#2	C1#1	4.74588e-18
C355	a_21_270##13	VPWR#2	2.56799e-17
C356	VGND#5	X#3	7.13533e-18
C357	VGND#5	VGND#4	1.18169e-18
C358	VPWR#2	A1#2	7.50432e-19
C359	VGND#5	VGND#8	1.15712e-19
C360	VGND#5	VNB	3.92086e-17
C361	VGND#2	C1	1.14959e-18
C362	VPWR#2	A2#1	1.23998e-17
C363	VPWR#2	C1#3	6.52498e-18
C364	VGND	VGND#5	4.30842e-17
C365	VGND#2	C1#2	4.56753e-21
C366	VPWR	VPWR#2	8.97388e-17
C367	VPWR#2	VPWR#6	3.00396e-17
C368	VPWR#2	VPWR#4	4.4975e-17
C369	a_330_392##2	VPWR#2	6.30172e-17
C370	VGND#8	VGND#2	3.59778e-21
C371	VGND#5	a_21_270##4	1.3226e-18
C372	VGND#5	X	4.33866e-19
C373	VPWR#2	A2#2	5.14686e-19
C374	VGND#2	a_21_270##8	2.1034e-17
C375	VPWR#2	C1#4	4.99496e-19
C376	VGND#2	A1#2	6.065e-20
C377	VPWR#2	A3#3	1.94541e-18
C378	VPWR#2	B1#1	9.58823e-18
C379	VGND#2	C1#4	3.93617e-19
C380	VGND#3	VGND#2	6.8693e-17
C381	VPWR#5	VPWR#2	2.35969e-18
C382	a_330_392#	VPWR#2	7.19734e-17
C383	VGND#5	a_21_270##2	2.64046e-20
C384	VGND#5	a_21_270##6	8.20559e-18
C385	VPWR#2	B1#2	5.63632e-20
C386	VGND#2	a_21_270##9	1.5703e-17
C387	VGND#5	a_21_270##3	6.46561e-21
C388	VPWR#2	a_21_270##5	3.23077e-19
C389	VGND#5	a_21_270#	5.99544e-19
C390	VPWR#2	A1#1	1.25379e-17
C391	VGND#3	VGND#5	3.95749e-17
*
*
.ENDS sky130_fd_sc_hs__a311o_2
*
