* Extracted by Quantus, converted by sky130cad/quantus.py
*
*
*
*                       LINUX           Wed Nov 18 09:10:28 2026
*
*
*
*  PROGRAM  advgen
*
*  Name           : advgen - Quantus - (64-bit)
*  Version        : 25.1.0-p047
*  Build Date     : Thu Dec 11 23:20:30 PST 2025
*
*  HSPICE LIBRARY
*
*  OPERATING_TEMPERATURE 150
*  QRC_TECH_DIR <path>/tech
*
*
*

*
.SUBCKT sky130_fd_sc_hs__sdfstp_1 VNB VPB VGND SET_B VPWR Q SCD CLK SCE D
*
*
*  caps2d version: 10
*
*
*       TRANSISTOR CARDS
*
*
XM37 a_27_464##9 SCE#5 VGND#19 VNB sky130_fd_pr__nfet_01v8_lvt l=0.15 w=0.42 ad=0.1197 as=0.1638 pd=1.41 ps=1.62
XM23 VGND#19 a_27_464# a_238_74# VNB sky130_fd_pr__nfet_01v8_lvt l=0.15 w=0.42 ad=0.1638 as=0.1008 pd=1.62 ps=1.32
XM8 a_238_74# D#1 a_289_464##6 VNB sky130_fd_pr__nfet_01v8_lvt l=0.15 w=0.42 ad=0.1008 as=0.1176 pd=1.32 ps=1.4
XM19 a_289_464##6 SCE#6 a_402_74# VNB sky130_fd_pr__nfet_01v8_lvt l=0.15 w=0.42 ad=0.1176 as=0.1008 pd=1.4 ps=1.32
XM15 a_402_74# SCD#3 VGND#18 VNB sky130_fd_pr__nfet_01v8_lvt l=0.15 w=0.42 ad=0.1008 as=0.1197 pd=1.32 ps=1.41
XM4 a_599_74##13 CLK#3 VGND#17 VNB sky130_fd_pr__nfet_01v8_lvt l=0.15 w=0.74 ad=0.2109 as=0.3108 pd=2.05 ps=2.32
XM36 VGND#17 a_599_74##6 a_800_74##9 VNB sky130_fd_pr__nfet_01v8_lvt l=0.15 w=0.74 ad=0.3108 as=0.2109 pd=2.32 ps=2.05
XM20 a_289_464# a_599_74##8 a_998_81##7 VNB sky130_fd_pr__nfet_01v8_lvt l=0.15 w=0.42 ad=0.1197 as=0.2562 pd=1.41 ps=2.06
XM9 a_998_81##7 a_800_74# a_1150_81# VNB sky130_fd_pr__nfet_01v8_lvt l=0.15 w=0.42 ad=0.2562 as=0.1008 pd=2.06 ps=1.32
XM24 a_1150_81# a_1198_55##4 VGND#16 VNB sky130_fd_pr__nfet_01v8_lvt l=0.15 w=0.42 ad=0.1008 as=0.1197 pd=1.32 ps=1.41
XM35 a_1198_55##5 a_998_81# a_1426_118# VNB sky130_fd_pr__nfet_01v8_lvt l=0.15 w=0.42 ad=0.1197 as=0.1008 pd=1.41 ps=1.32
XM13 a_1426_118# SET_B#1 VGND#14 VNB sky130_fd_pr__nfet_01v8_lvt l=0.15 w=0.42 ad=0.1008 as=0.4699 pd=1.32 ps=2.8
XM10 VGND#14 a_998_81##4 a_1686_74# VNB sky130_fd_pr__nfet_01v8_lvt l=0.15 w=0.64 ad=0.4699 as=0.1536 pd=2.8 ps=1.76
XM7 a_1686_74# a_800_74##7 a_1764_74##11 VNB sky130_fd_pr__nfet_01v8_lvt l=0.15 w=0.64 ad=0.1536 as=0.3547 pd=1.76 ps=2.44
XM32 a_1764_74##11 a_599_74# a_1910_74# VNB sky130_fd_pr__nfet_01v8_lvt l=0.15 w=0.42 ad=0.3547 as=0.1008 pd=2.44 ps=1.32
XM12 a_1910_74# a_1958_48# a_1988_74# VNB sky130_fd_pr__nfet_01v8_lvt l=0.15 w=0.42 ad=0.1008 as=0.3192 pd=1.32 ps=2.36
XM14 a_1988_74# SET_B#6 VGND#13 VNB sky130_fd_pr__nfet_01v8_lvt l=0.15 w=0.42 ad=0.3192 as=0.1764 pd=2.36 ps=1.68
XM28 VGND#13 a_1764_74##5 a_1958_48##4 VNB sky130_fd_pr__nfet_01v8_lvt l=0.15 w=0.42 ad=0.1764 as=0.1197 pd=1.68 ps=1.41
XM2 a_2395_94##6 a_1764_74##6 VGND#12 VNB sky130_fd_pr__nfet_01v8_lvt l=0.15 w=0.64 ad=0.448 as=0.3107 pd=2.68 ps=2.34
XM5 VGND#12 a_2395_94##3 Q#3 VNB sky130_fd_pr__nfet_01v8_lvt l=0.15 w=0.74 ad=0.3107 as=0.2109 pd=2.34 ps=2.05
XM38 a_27_464##7 SCE#3 VPWR#20 VPB sky130_fd_pr__pfet_01v8 l=0.15 w=0.64 ad=0.1856 as=0.192 pd=1.86 ps=1.88
XM21 VPWR#20 SCE#1 a_205_464# VPB sky130_fd_pr__pfet_01v8 l=0.15 w=0.64 ad=0.192 as=0.1728 pd=1.88 ps=1.82
XM27 a_205_464# D#3 a_289_464##4 VPB sky130_fd_pr__pfet_01v8 l=0.15 w=0.64 ad=0.1728 as=0.3072 pd=1.82 ps=2.24
XM25 a_289_464##4 a_27_464##3 a_415_464# VPB sky130_fd_pr__pfet_01v8 l=0.15 w=0.64 ad=0.3072 as=0.1728 pd=2.24 ps=1.82
XM33 a_415_464# SCD#1 VPWR#19 VPB sky130_fd_pr__pfet_01v8 l=0.15 w=0.64 ad=0.1728 as=0.2954 pd=1.82 ps=2.4
XM39 a_599_74##11 CLK#1 VPWR#18 VPB sky130_fd_pr__pfet_01v8 l=0.15 w=1.12 ad=0.3304 as=0.336 pd=2.83 ps=2.84
XM17 VPWR#18 a_599_74##9 a_800_74##13 VPB sky130_fd_pr__pfet_01v8 l=0.15 w=1.12 ad=0.336 as=0.3076 pd=2.84 ps=2.83
XM31 a_289_464##5 a_800_74##4 a_998_81##9 VPB sky130_fd_pr__pfet_01v8 l=0.15 w=0.42 ad=0.1239 as=0.147 pd=1.43 ps=1.54
XM18 a_998_81##9 a_599_74##7 a_1128_457# VPB sky130_fd_pr__pfet_01v8 l=0.15 w=0.42 ad=0.147 as=0.1533 pd=1.54 ps=1.57
XM3 a_1128_457# a_1198_55# VPWR#17 VPB sky130_fd_pr__pfet_01v8 l=0.15 w=0.42 ad=0.1533 as=0.3298 pd=1.57 ps=2.59
XM34 VPWR#17 a_998_81##3 a_1198_55##7 VPB sky130_fd_pr__pfet_01v8 l=0.15 w=0.42 ad=0.3298 as=0.1386 pd=2.59 ps=1.5
XM29 a_1198_55##7 SET_B#3 VPWR#16 VPB sky130_fd_pr__pfet_01v8 l=0.15 w=0.42 ad=0.1386 as=0.3763 pd=1.5 ps=3.06
XM0 VPWR#16 a_998_81##6 a_1610_341##2 VPB sky130_fd_pr__pfet_01v8 l=0.15 w=1 ad=0.3763 as=0.285 pd=3.06 ps=2.57
XM30 a_1721_374##2 a_800_74##5 a_1764_74##13 VPB sky130_fd_pr__pfet_01v8 l=0.15 w=0.42 ad=0.2584 as=0.3259 pd=3.07 ps=2.82
XM6 a_1764_74##13 a_599_74##2 a_1610_341# VPB sky130_fd_pr__pfet_01v8 l=0.15 w=1 ad=0.3259 as=0.28 pd=2.82 ps=2.56
XM1 a_1721_374# a_1958_48##3 VPWR#15 VPB sky130_fd_pr__pfet_01v8 l=0.15 w=0.42 ad=0.1197 as=0.126 pd=1.41 ps=1.44
XM26 VPWR#15 SET_B#4 a_1764_74##12 VPB sky130_fd_pr__pfet_01v8 l=0.15 w=0.42 ad=0.126 as=0.1197 pd=1.44 ps=1.41
XM16 a_1958_48##7 a_1764_74##7 VPWR#14 VPB sky130_fd_pr__pfet_01v8 l=0.15 w=0.42 ad=0.1197 as=0.1197 pd=1.41 ps=1.41
XM22 a_2395_94##7 a_1764_74# VPWR#13 VPB sky130_fd_pr__pfet_01v8 l=0.15 w=0.84 ad=0.2394 as=0.3724 pd=2.25 ps=2.95
XM11 VPWR#13 a_2395_94# Q#1 VPB sky130_fd_pr__pfet_01v8 l=0.15 w=1.12 ad=0.3724 as=0.3192 pd=2.95 ps=2.81
*
*
*       RESISTOR AND CAP/DIODE CARDS
*
Rg1	SCE#1	SCE#2	510.222534
Rg2	SCE#2	SCE#3	378.485382
Rg3	SCE#2	SCE#4	50.077541
Rg4	SCE#4	SCE#5	480.074249
Rg5	a_27_464#	a_27_464##2	239.074265
Rg6	D#1	D#2	744.072815
Rg7	D#2	D#3	301.353882
Rg8	a_27_464##3	a_27_464##4	296.912354
Rg9	SCE#6	SCE#7	422.710083
Rg10	SCD#1	SCD#2	341.228149
Rg11	SCD#2	SCD#3	365.568817
Rg12	SCD#2	SCD#4	63.050129
Rg13	CLK#1	CLK#2	492.059540
Rg14	CLK#2	CLK#3	307.937683
Rg15	a_800_74#	a_800_74##2	600.833496
Rg16	a_800_74##2	a_800_74##3	216.388794
Rg17	a_800_74##3	a_800_74##4	269.276367
Rg18	a_1198_55#	a_1198_55##2	250.751389
Rg19	a_1198_55##2	a_1198_55##3	390.455688
Rg20	a_1198_55##3	a_1198_55##4	274.421326
Rg21	a_998_81#	a_998_81##2	470.938721
Rg22	a_998_81##2	a_998_81##3	368.990295
Rg23	SET_B#1	SET_B#2	450.469696
Rg24	SET_B#2	SET_B#3	366.141235
Rg25	a_998_81##4	a_998_81##5	316.801727
Rg26	a_998_81##5	a_998_81##6	452.691040
Rg27	a_800_74##5	a_800_74##6	364.724884
Rg28	a_800_74##6	a_800_74##7	306.097992
Rg29	a_599_74#	a_599_74##2	964.208679
Rg30	a_599_74##2	a_599_74##3	2607.387451
Rg31	a_599_74##3	a_599_74##4	1380.889526
Rg32	a_599_74##4	a_599_74##5	59.537186
Rg33	a_599_74##5	a_599_74##6	378.360626
Rg34	a_599_74##3	a_599_74##7	296.970245
Rg35	a_599_74##4	a_599_74##8	631.868835
Rg36	a_599_74##5	a_599_74##9	428.333527
Rg37	a_1958_48#	a_1958_48##2	227.787109
Rg38	a_1958_48##2	a_1958_48##3	899.627014
Rg39	SET_B#4	SET_B#5	428.038086
Rg40	SET_B#5	SET_B#6	549.879028
Rg41	a_1764_74#	a_1764_74##2	352.697205
Rg42	a_1764_74##2	a_1764_74##3	433.616516
Rg43	a_1764_74##3	a_1764_74##4	106.198441
Rg44	a_1764_74##4	a_1764_74##5	532.324341
Rg45	a_1764_74##2	a_1764_74##6	581.195435
Rg46	a_1764_74##3	a_1764_74##7	396.462189
Rg47	a_2395_94#	a_2395_94##2	510.359009
Rg48	a_2395_94##2	a_2395_94##3	336.001343
Rf1	D#4	D	0.667014
Rf2	D#2	D#6	160.899811
Rf3	D#4	D#6	8.463963
Rf4	a_27_464##4	a_27_464##6	292.145081
Rf5	a_27_464##6	a_27_464##7	18.486889
Rf6	a_27_464##6	a_27_464##8	100.015388
Rf7	a_27_464##8	a_27_464##9	28.907539
Rf8	a_27_464##8	a_27_464##2	197.725952
Rf9	SCE#7	SCE	243.336685
Rf10	SCE	SCE#4	84.434143
Rf11	SCD	SCD#4	1.023254
Rf12	SCD#4	SCD	17.906948
Rf13	CLK#4	CLK#2	161.706955
Rf14	CLK	CLK#6	1.474148
Rf15	CLK#4	CLK#6	5.647728
Rf16	a_599_74##5	a_599_74##12	210.425186
Rf17	a_599_74##12	a_599_74##13	97.610039
Rf18	a_599_74##11	a_599_74##12	15.000000
Rf19	a_289_464#	a_289_464##2	141.313721
Rf20	a_289_464##2	a_289_464##3	168.844849
Rf21	a_289_464##3	a_289_464##4	56.555588
Rf22	a_289_464##2	a_289_464##5	24.029247
Rf23	a_289_464##3	a_289_464##6	177.582687
Rf24	a_800_74##3	a_800_74##9	269.803375
Rf25	a_1198_55##5	a_1198_55##3	198.087448
Rf26	a_1198_55##7	a_1198_55##2	258.693817
Rf27	SET_B#7	SET_B#2	166.643845
Rf28	a_998_81##7	a_998_81##8	48.792969
Rf29	a_998_81##8	a_998_81##9	105.852089
Rf30	a_998_81##8	a_998_81##10	89.596268
Rf31	a_998_81##10	a_998_81##5	177.561829
Rf32	a_800_74##6	a_800_74##11	498.987854
Rf33	a_800_74##11	a_800_74##2	203.742432
Rf34	a_800_74##11	a_800_74##13	175.048050
Rf35	a_1610_341#	a_1610_341##2	108.248581
Rf36	a_1721_374#	a_1721_374##2	135.903915
Rf37	SET_B	SET_B#5	91.186661
Rf38	a_1764_74##4	a_1764_74##9	111.335327
Rf39	a_1764_74##9	a_1764_74##10	160.079605
Rf40	a_1764_74##10	a_1764_74##11	75.821701
Rf41	a_1764_74##9	a_1764_74##12	31.323109
Rf42	a_1764_74##10	a_1764_74##13	30.051189
Rf43	a_1958_48##4	a_1958_48##5	28.956652
Rf44	a_1958_48##5	a_1958_48##2	157.249268
Rf45	a_1958_48##5	a_1958_48##7	130.066101
Rf46	a_2395_94##2	a_2395_94##5	181.117142
Rf47	a_2395_94##5	a_2395_94##6	60.152725
Rf48	a_2395_94##5	a_2395_94##7	72.243423
Rf49	Q	Q#2	0.255814
Rf50	Q#2	Q	18.674389
Rf51	Q	Q#4	6.799999
Rf52	Q#4	Q	4.382222
Rf53	Q#1	Q#2	5.000000
Rf54	Q#3	Q#4	7.500000
Rf55	VPWR#1	VPWR#2	35.404957
Rf56	VPWR#2	VPWR#3	73.058777
Rf57	VPWR#3	VPWR#4	108.245590
Rf58	VPWR#4	VPWR#5	46.485107
Rf59	VPWR#5	VPWR#6	167.318451
Rf60	VPWR#6	VPWR#7	105.258347
Rf61	VPWR#7	VPWR#8	190.670074
Rf62	VPWR#8	VPWR#9	27.734655
Rf63	VPWR#9	VPWR#10	45.997280
Rf64	VPWR#10	VPWR#11	146.417175
Rf66	VPWR#2	VPWR#13	39.408188
Rf67	VPWR#3	VPWR#14	39.329605
Rf68	VPWR#4	VPWR#15	50.781399
Rf69	VPWR#6	VPWR#16	52.376095
Rf70	VPWR#7	VPWR#17	35.236591
Rf71	VPWR#8	VPWR#18	33.326477
Rf72	VPWR#10	VPWR#19	24.862514
Rf73	VPWR#11	VPWR#20	33.326477
Rf74	VGND#1	VGND#2	46.362534
Rf75	VGND#2	VGND#3	150.069702
Rf76	VGND#3	VGND#4	66.451416
Rf77	VGND#4	VGND#5	160.938324
Rf78	VGND#5	VGND#6	117.083488
Rf79	VGND#6	VGND#7	192.804245
Rf80	VGND#7	VGND#8	20.429605
Rf81	VGND#8	VGND#9	59.876873
Rf82	VGND#9	VGND#10	122.675766
Rf84	VGND#2	VGND#12	31.731567
Rf85	VGND#3	VGND#13	34.507496
Rf86	VGND#5	VGND#15	6.783111
Rf87	VGND#15	VGND#14	10.178518
Rf88	VGND#6	VGND#16	34.310661
Rf89	VGND#7	VGND#17	31.141060
Rf90	VGND#9	VGND#18	33.326477
Rf91	VGND#10	VGND#19	33.720150
Rf92	VGND#14	VGND#15	7.500000
Rf105	a_998_81##2	a_998_81##10	160.232803
Re2	SET_B	SET_B#7	15.344948
Re3	VPWR#1	VPWR#22	11.160645
Re4	VPWR#22	VPWR	1.198481
Re5	VPWR	VPWR#9	2.081275
Re6	VGND#1	VGND#21	11.160645
Re7	VGND#21	VGND	1.198481
Re8	VGND	VGND#8	2.081275
Re12	VPWR#5	VPWR#22	0.698413
Re15	VGND#4	VGND#21	0.698413
*
*       CAPACITOR CARDS
*
*
C1	a_599_74##6	a_599_74##8	4.14722e-18
C2	SCE#2	SCE#1	4.90366e-18
C3	VPWR#14	VPWR#13	4.55307e-18
C4	CLK#3	VGND#17	2.82393e-17
C5	a_1958_48##7	VPWR#3	2.08306e-17
C6	a_27_464##6	SCE#2	1.16948e-17
C7	a_2395_94##5	VPWR#2	5.32805e-20
C8	a_27_464##4	a_289_464##4	5.56819e-17
C9	a_2395_94##2	VGND#12	4.43233e-17
C10	VPWR#8	a_599_74##5	2.75482e-20
C11	VGND#3	a_1764_74##3	3.86144e-19
C12	a_800_74##11	a_1198_55##3	3.63663e-19
C13	VPWR#18	a_599_74##3	7.96855e-19
C14	a_998_81##8	a_998_81##2	7.40312e-18
C15	VGND#18	a_599_74##6	3.62104e-19
C16	VGND#6	a_800_74##9	2.49423e-17
C17	SCE#3	SCE#1	3.42876e-17
C18	a_1958_48##5	a_2395_94##6	1.54392e-17
C19	a_1764_74##12	VPWR#4	2.26671e-17
C20	VGND#3	SET_B#6	6.39163e-18
C21	a_599_74##13	CLK#3	5.0689e-17
C22	a_998_81##9	a_599_74##7	2.89431e-17
C23	a_998_81##8	a_800_74#	6.99433e-18
C24	VGND#1	VGND#2	9.5324e-19
C25	a_1958_48##3	SET_B#5	1.89789e-17
C26	a_800_74##13	a_1198_55#	4.01824e-20
C27	VPWR#9	a_1198_55#	4.23988e-18
C28	VPWR#14	a_2395_94##7	3.24529e-17
C29	VGND#17	SCD#3	4.43875e-19
C30	a_289_464##2	a_599_74##7	8.38371e-19
C31	SET_B#2	a_599_74##3	7.61574e-19
C32	CLK#3	a_599_74##6	2.19975e-17
C33	a_998_81##7	a_1198_55##5	1.67119e-18
C34	VGND#18	CLK#3	2.64139e-18
C35	VGND#9	a_599_74##13	1.79949e-18
C36	VPWR#19	VPWR#18	5.88882e-18
C37	a_1958_48##2	a_1958_48##3	5.06145e-19
C38	VGND#5	a_1958_48#	4.29042e-19
C39	a_998_81##9	a_800_74##4	7.00702e-18
C40	a_800_74##13	a_800_74##11	9.70085e-19
C41	a_998_81##8	a_1198_55##3	1.95765e-17
C42	a_800_74##11	a_1198_55##2	7.41834e-17
C43	a_800_74##3	a_800_74#	1.29868e-18
C44	a_599_74##13	SCD#3	1.92333e-18
C45	a_800_74##13	a_599_74##7	1.7742e-19
C46	D#2	a_289_464##4	2.53211e-18
C47	a_599_74##2	a_1958_48##2	6.85742e-18
C48	a_1958_48##7	a_2395_94##7	1.91906e-17
C49	a_2395_94##5	a_2395_94##7	3.67898e-18
C50	a_800_74##3	a_599_74##8	4.26425e-17
C51	a_800_74##4	a_289_464##5	5.23718e-18
C52	a_998_81##8	a_599_74##8	1.07867e-18
C53	VGND#3	a_1958_48#	4.84252e-19
C54	VGND#2	a_1764_74##3	2.12821e-19
C55	VPWR#9	a_599_74##9	1.23217e-18
C56	a_998_81##8	a_998_81##9	3.91339e-18
C57	a_800_74##3	a_599_74##6	5.32107e-19
C58	a_800_74##6	a_599_74##2	1.34504e-17
C59	a_289_464##2	a_800_74##4	2.12975e-17
C60	VGND#18	SCD#3	3.62212e-17
C61	a_998_81##7	VGND#16	1.35905e-17
C62	a_998_81#	a_599_74##3	3.92592e-19
C63	a_800_74##13	a_800_74##4	4.75667e-18
C64	VPWR#9	CLK#1	2.23108e-18
C65	SCD#3	CLK#3	3.93199e-18
C66	a_289_464##6	CLK#3	1.25893e-18
C67	a_800_74##6	a_800_74##5	5.12831e-18
C68	a_599_74##13	SCE#6	1.68511e-19
C69	a_1958_48##5	a_1764_74##3	1.54973e-17
C70	a_1958_48##7	VPWR#14	3.80507e-17
C71	a_998_81##5	a_599_74##2	1.10907e-18
C72	VGND#5	a_599_74#	9.1982e-19
C73	VPWR#3	a_2395_94#	5.78749e-19
C74	SET_B#7	VGND#5	1.60659e-17
C75	a_998_81##8	a_1198_55##2	1.57063e-17
C76	a_800_74##2	a_800_74##11	3.92432e-18
C77	VGND#8	a_1198_55##5	5.07105e-18
C78	a_599_74##11	SCD#2	1.2066e-17
C79	a_800_74##6	a_998_81##6	4.06137e-17
C80	a_289_464##3	a_599_74##9	7.44305e-19
C81	VGND#6	a_998_81##8	3.11201e-18
C82	a_998_81##2	a_599_74##3	9.48712e-19
C83	Q#3	a_2395_94##3	2.23653e-17
C84	VGND#13	a_1958_48##5	2.83006e-17
C85	VPWR#1	VPWR#2	4.98108e-18
C86	VGND#18	SCE#6	4.40652e-18
C87	VPWR#9	a_27_464##3	1.62748e-18
C88	a_599_74##9	a_800_74##13	1.88797e-17
C89	a_800_74##6	SET_B#3	1.45629e-17
C90	a_1721_374#	VPWR#4	6.95173e-18
C91	VPWR#2	a_2395_94#	5.54004e-18
C92	VGND#13	SET_B#5	1.09975e-18
C93	a_289_464##2	a_599_74##9	1.95602e-17
C94	CLK#2	a_599_74##6	4.52526e-18
C95	VGND#9	SCE#7	3.72454e-19
C96	VGND#3	a_599_74#	5.20173e-20
C97	a_289_464##6	SCD#3	1.21504e-17
C98	VGND#2	a_1764_74##2	1.71711e-19
C99	a_800_74##6	a_998_81##3	8.72171e-19
C100	VPWR#9	D#3	1.69739e-18
C101	a_2395_94##3	VGND#12	2.75356e-17
C102	VPWR#18	a_599_74##9	4.03097e-17
C103	a_289_464##3	a_599_74##4	1.64137e-19
C104	SCE#6	SCD#3	4.05696e-17
C105	a_1958_48##5	a_1764_74##2	1.37808e-18
C106	VPWR#19	a_599_74##3	5.05176e-20
C107	SET_B#2	a_998_81##6	1.51841e-17
C108	VPWR#9	SCE#1	7.70628e-19
C109	VGND#8	a_998_81##7	1.45495e-17
C110	a_998_81##8	a_800_74##2	9.39593e-17
C111	a_800_74##11	a_800_74##3	3.24203e-19
C112	VPWR#10	a_27_464##4	1.28377e-19
C113	a_289_464##3	CLK#1	1.21697e-17
C114	VGND#18	D#1	3.52697e-19
C115	VGND#5	a_800_74##7	1.48314e-17
C116	a_800_74##9	VGND#16	2.52144e-18
C117	a_289_464#	a_599_74##4	2.62374e-17
C118	a_1764_74##9	VPWR#4	1.45541e-18
C119	VPWR#9	SCE#3	1.84486e-18
C120	VGND#8	a_289_464#	1.05416e-17
C121	a_289_464##6	SCE#6	3.77631e-17
C122	a_1764_74##12	a_1958_48##7	4.33763e-17
C123	VPWR#15	VPWR#14	7.72132e-19
C124	VGND#13	a_1958_48##2	8.91168e-18
C125	a_998_81##2	a_998_81##6	2.60487e-19
C126	VPWR#18	CLK#1	3.70048e-17
C127	a_1958_48##7	a_2395_94##5	2.56624e-19
C128	a_289_464#	a_289_464##2	1.29245e-18
C129	a_289_464##2	CLK#1	8.78279e-18
C130	a_289_464##2	a_1198_55##2	6.04511e-20
C131	VPWR#19	SCD#2	1.70811e-18
C132	VGND#19	SCD#3	3.43555e-19
C133	VPWR#2	a_1764_74#	3.92052e-18
C134	a_1198_55##3	a_599_74##3	3.6934e-19
C135	a_1764_74##6	VGND#12	2.74523e-17
C136	VGND#8	a_800_74##9	4.68507e-17
C137	VGND#3	a_800_74##7	4.04865e-20
C138	VPWR#4	a_1764_74##7	4.96918e-19
C139	D#1	SCE#6	3.20167e-17
C140	a_599_74##11	CLK#1	4.13307e-17
C141	VGND#6	a_998_81##4	6.76455e-20
C142	VGND#12	Q#3	4.20872e-17
C143	VGND#18	a_27_464#	1.70418e-19
C144	a_1958_48##4	a_2395_94##3	7.78895e-19
C145	VGND#8	VGND#17	2.10375e-17
C146	a_998_81##8	a_800_74##11	5.70068e-18
C147	VPWR#18	SCD#1	1.28839e-18
C148	a_998_81##8	a_800_74##3	8.54368e-17
C149	a_289_464##3	SCD#1	3.68371e-17
C150	a_289_464##6	D#1	3.41866e-17
C151	VPWR#19	CLK#1	4.55242e-18
C152	a_1764_74##6	a_2395_94##6	1.81273e-17
C153	VPWR#3	a_1764_74##7	6.55377e-18
C154	a_1764_74##11	a_1958_48##2	1.89208e-17
C155	a_1198_55##2	a_998_81##6	9.37054e-21
C156	a_289_464##2	a_599_74##4	5.06853e-17
C157	VGND#8	a_599_74##13	3.34505e-17
C158	VGND#19	SCE#6	3.30303e-19
C159	VGND#5	a_998_81##4	3.86628e-17
C160	a_2395_94##5	a_2395_94#	1.93815e-18
C161	a_1764_74##9	VPWR#3	5.63925e-19
C162	VGND#9	a_289_464##6	1.23274e-17
C163	a_800_74##9	a_289_464##2	1.61106e-18
C164	a_800_74##9	a_800_74##13	1.6401e-20
C165	a_289_464##2	a_599_74##8	4.92106e-19
C166	a_289_464##2	SCD#1	1.61909e-19
C167	VGND#12	a_1764_74##5	1.27489e-18
C168	VGND#13	a_2395_94##3	5.08774e-19
C169	VPWR#20	VPWR#19	8.97128e-19
C170	VGND#8	VGND#18	1.54187e-17
C171	SET_B#7	VPWR#6	3.90342e-18
C172	VGND#18	SCE#5	3.01691e-19
C173	VPWR#2	a_1764_74##7	4.93721e-19
C174	a_289_464##3	SCD#2	2.11943e-17
C175	a_1198_55##2	a_998_81##3	9.19209e-18
C176	a_27_464#	D#1	3.5446e-17
C177	a_800_74##9	a_599_74##4	5.38931e-18
C178	a_1958_48##4	a_1764_74##6	1.91633e-18
C179	SCD#1	VPWR#19	2.36397e-17
C180	VPWR#15	a_1764_74##12	3.30953e-17
C181	a_800_74##9	a_998_81##7	1.00396e-17
C182	a_1764_74##9	a_1764_74##3	4.78823e-19
C183	a_289_464##6	a_27_464#	3.7182e-18
C184	a_289_464#	SCD#2	1.59797e-19
C185	VPWR#4	SET_B#4	5.91082e-18
C186	D#1	SCE#7	1.72491e-17
C187	VGND#1	a_2395_94##2	6.77499e-19
C188	a_2395_94##5	a_2395_94##3	3.30122e-19
C189	a_2395_94##6	a_1764_74##5	1.49091e-18
C190	a_1198_55##2	a_599_74##3	1.67196e-18
C191	a_289_464##3	a_27_464##3	1.6832e-17
C192	VGND#19	D#1	4.1355e-18
C193	a_800_74##6	a_1764_74##11	4.94593e-17
C194	VGND#12	a_1764_74##2	8.94309e-19
C195	VPWR#6	a_1721_374##2	3.24197e-17
C196	VGND#8	a_289_464##6	2.44443e-17
C197	a_289_464##2	a_599_74##3	1.47662e-18
C198	a_599_74##7	a_1198_55##2	2.59155e-18
C199	VPWR#3	SET_B#4	2.65037e-19
C200	VGND#13	a_1764_74##6	3.97787e-19
C201	VGND#12	SET_B#6	3.42534e-19
C202	a_289_464##2	a_998_81##9	5.37748e-17
C203	VPWR#19	a_27_464##3	9.69135e-19
C204	a_289_464##2	a_800_74##3	8.44644e-17
C205	VGND#5	SET_B#1	2.79652e-17
C206	a_27_464##9	D#1	1.24228e-19
C207	a_1958_48##5	a_1958_48##7	2.23106e-18
C208	a_800_74##9	a_289_464#	8.35113e-17
C209	a_289_464##6	SCE#5	2.14952e-18
C210	a_1958_48##4	a_1764_74##5	3.16942e-17
C211	a_800_74##2	a_599_74##7	1.56756e-17
C212	a_800_74##11	VPWR#7	7.65028e-17
C213	D#4	SCE#2	7.81659e-18
C214	a_289_464##3	SCE#2	1.08534e-19
C215	a_2395_94##6	a_1764_74##3	5.52885e-18
C216	SCE#5	a_27_464#	1.67444e-17
C217	VPWR#20	a_289_464##4	9.31887e-18
C218	a_2395_94##6	VPWR#14	5.51038e-18
C219	VGND#8	VGND#9	8.20896e-17
C220	VGND#8	VGND#19	1.82928e-17
C221	a_27_464#	VGND#19	1.86825e-17
C222	a_27_464##2	D#1	3.81747e-17
C223	a_1764_74##11	a_998_81##5	1.00168e-19
C224	VPWR#4	a_1958_48##3	7.52302e-18
C225	VPWR#19	D#3	4.47202e-19
C226	a_2395_94##5	a_1764_74##6	3.98154e-17
C227	a_599_74##8	a_599_74##3	2.8557e-20
C228	a_289_464##3	D#3	2.6133e-19
C229	a_800_74##3	a_599_74##7	1.41796e-18
C230	VGND#8	VGND#7	8.52043e-17
C231	SET_B#7	a_1610_341#	2.10941e-18
C232	VGND#8	a_27_464##9	2.13027e-17
C233	VGND#6	a_998_81#	3.93739e-19
C234	a_289_464##4	a_27_464##3	2.87676e-17
C235	a_289_464##2	SCD#2	2.7328e-19
C236	a_1721_374#	VPWR#15	3.60183e-17
C237	VGND#13	a_1764_74##5	1.21773e-17
C238	a_1610_341#	a_1764_74##12	1.01165e-18
C239	a_1610_341##2	VPWR#6	6.65395e-18
C240	SCE#5	a_27_464##2	1.4402e-17
C241	a_599_74##4	a_800_74##2	8.47902e-19
C242	a_27_464##9	a_27_464#	1.58344e-18
C243	VPWR#20	SCD#1	5.06351e-19
C244	a_1764_74##11	a_1764_74##10	9.89109e-19
C245	a_800_74##9	SCD#2	2.82675e-21
C246	a_289_464##2	a_289_464##5	2.72743e-18
C247	VGND#8	VGND#6	1.26784e-16
C248	SCE#4	D#1	7.41186e-19
C249	VPWR#3	a_1958_48##3	4.78216e-20
C250	a_1958_48##4	VGND#12	4.95434e-18
C251	a_599_74##5	a_289_464##2	8.31392e-17
C252	a_1721_374#	VPWR#5	6.44676e-17
C253	a_998_81##5	VGND#14	7.32275e-18
C254	a_1958_48##4	SET_B#6	1.42612e-18
C255	a_289_464##3	VGND#18	3.84081e-20
C256	a_800_74##2	a_599_74##3	7.17006e-19
C257	SCE#5	VGND#19	2.04979e-17
C258	a_2395_94##6	a_1764_74##2	3.96357e-18
C259	VPWR#19	SCE#1	2.08897e-19
C260	VGND#5	a_998_81#	1.1116e-17
C261	VPWR#6	a_599_74##2	4.71378e-17
C262	a_800_74##11	VPWR#6	4.31575e-17
C263	SET_B#7	a_1721_374##2	2.70388e-18
C264	a_289_464##4	D#3	3.20574e-17
C265	VPWR#5	a_1958_48##2	2.29639e-19
C266	SET_B#7	a_800_74##6	8.43164e-17
C267	VPWR#20	a_27_464##3	5.3358e-19
C268	a_599_74##5	a_599_74##9	1.16256e-17
C269	a_599_74##6	a_599_74##4	7.77155e-18
C270	a_1764_74##9	a_1958_48##7	4.26978e-17
C271	a_289_464##3	SCE#1	1.16072e-19
C272	a_27_464##9	SCE#5	2.40727e-17
C273	VGND#13	SET_B#6	3.3927e-17
C274	SET_B#7	a_1610_341##2	1.45321e-17
C275	VPWR#9	VPWR#10	7.65515e-17
C276	a_1198_55##7	a_998_81#	2.59549e-18
C277	VGND#4	a_1958_48##2	1.0589e-17
C278	VPWR#4	a_599_74##2	8.79075e-19
C279	a_2395_94##5	a_1764_74##5	4.6134e-19
C280	CLK#1	a_599_74##5	3.93252e-18
C281	VGND#17	a_800_74##9	6.61759e-17
C282	a_599_74##13	a_289_464#	5.38153e-19
C283	SET_B#7	a_998_81##5	2.27724e-17
C284	a_289_464##3	CLK#2	4.19795e-19
C285	a_599_74##13	a_599_74##11	4.05947e-18
C286	VGND#6	a_1198_55##4	4.23891e-18
C287	a_1958_48##4	a_2395_94##6	3.02065e-17
C288	a_289_464##2	a_800_74##13	9.98825e-17
C289	a_1958_48##4	a_1958_48#	5.25743e-20
C290	a_289_464##4	SCE#1	1.93858e-18
C291	VPWR#9	VPWR#8	9.45841e-17
C292	SET_B#7	VPWR#16	4.32744e-18
C293	a_1721_374##2	VPWR#5	3.7008e-17
C294	a_1958_48##5	a_2395_94##5	3.02104e-17
C295	a_2395_94##2	VPWR#13	2.28086e-17
C296	VPWR#20	D#3	4.20405e-18
C297	SET_B#7	SET_B#2	3.32206e-17
C298	a_1610_341#	a_1721_374#	4.78037e-17
C299	SET_B#3	a_599_74##3	1.63357e-17
C300	a_289_464##3	VPWR#18	1.27602e-17
C301	VPWR#9	VPWR#7	1.05002e-16
C302	a_599_74##13	a_599_74##4	1.02601e-19
C303	a_599_74##4	a_800_74##3	5.54543e-17
C304	a_1958_48##5	a_1764_74##6	2.62535e-18
C305	VGND#5	a_1198_55##4	1.69198e-18
C306	SET_B#7	a_998_81##2	8.05602e-18
C307	VGND#13	a_1958_48#	3.47007e-18
C308	SET_B#5	a_1764_74##4	5.53916e-17
C309	a_1764_74##11	a_1764_74##5	3.98003e-19
C310	a_599_74##13	a_800_74##9	2.57444e-18
C311	a_800_74##3	a_599_74##3	2.02944e-18
C312	a_289_464##3	SCE#3	1.1919e-19
C313	VPWR#20	SCE#1	3.06472e-17
C314	SET_B#6	a_1988_74#	1.69121e-17
C315	a_1958_48##2	a_1764_74##4	7.2048e-19
C316	a_1958_48##4	a_599_74#	6.32985e-20
C317	SET_B#7	a_1764_74##10	7.84565e-18
C318	a_289_464##2	VPWR#18	3.95722e-17
C319	a_1958_48#	a_1988_74#	1.69121e-17
C320	VGND#2	a_2395_94##2	4.95742e-19
C321	VGND#6	a_800_74#	5.3405e-18
C322	a_289_464##6	a_289_464##3	8.9071e-19
C323	SET_B#7	a_1198_55##2	4.76528e-19
C324	a_1958_48##2	SET_B#5	4.14476e-17
C325	a_27_464##4	SCD#1	2.41402e-18
C326	a_1764_74#	a_2395_94#	3.14997e-17
C327	VPWR#9	a_998_81##2	2.77716e-18
C328	VGND#18	VPWR#19	3.95805e-20
C329	a_1198_55##5	a_998_81##2	4.02437e-17
C330	a_289_464##3	a_599_74##11	4.1875e-17
C331	a_27_464##6	SCD#1	8.639e-20
C332	VGND#3	a_2395_94##6	2.16926e-18
C333	VPWR#20	SCE#3	2.78057e-17
C334	a_599_74##13	VGND#17	5.78664e-17
C335	a_27_464##4	a_27_464##3	8.1159e-18
C336	a_1764_74##9	a_1764_74##7	6.89311e-19
C337	a_1764_74##11	SET_B#6	1.58976e-18
C338	VGND#13	a_599_74#	1.0506e-18
C339	SET_B#7	a_800_74##2	3.47699e-18
C340	a_1958_48##5	a_1764_74##5	1.95465e-17
C341	VGND#8	a_998_81##2	3.32414e-18
C342	VGND#16	a_998_81##2	2.50343e-18
C343	VPWR#6	a_998_81##6	1.60052e-18
C344	VPWR#9	a_1198_55##3	1.79457e-19
C345	a_27_464##4	D#3	1.92542e-17
C346	a_1610_341#	a_1764_74##13	4.67771e-17
C347	a_1721_374##2	a_1721_374#	1.62245e-18
C348	a_1764_74##7	a_2395_94#	3.19501e-19
C349	VGND#13	a_1958_48##4	3.05638e-17
C350	a_1764_74##4	a_1958_48##7	1.78138e-17
C351	SCE#3	a_27_464##7	1.79496e-18
C352	a_1958_48##2	a_800_74##6	1.81975e-18
C353	a_1764_74##9	VPWR#15	2.61352e-17
C354	VGND#7	a_599_74##8	2.64149e-18
C355	a_998_81##3	a_599_74##3	1.63309e-17
C356	a_27_464##4	a_289_464##3	7.54214e-17
C357	a_27_464##4	SCE#1	5.335e-20
C358	VGND#8	a_1198_55##3	4.23147e-18
C359	a_599_74##5	a_599_74##4	6.40728e-18
C360	VPWR#9	a_1198_55##2	4.34364e-18
C361	a_599_74##13	SCD#2	4.78433e-18
C362	a_599_74##11	a_289_464##2	1.89233e-17
C363	VGND#3	a_1764_74##4	1.24061e-19
C364	a_27_464##4	SCE#3	1.16845e-19
C365	a_1764_74##10	a_1721_374#	9.14745e-19
C366	a_1764_74##7	a_1764_74#	4.56813e-18
C367	VPWR#13	a_2395_94#	5.35265e-17
C368	SCD#2	CLK#3	3.43925e-18
C369	a_1958_48#	a_1910_74#	9.87534e-18
C370	VGND#8	a_1198_55##2	2.82974e-18
C371	VGND#18	VGND#17	1.36628e-18
C372	VGND#2	a_2395_94##6	1.28989e-17
C373	VPWR#9	a_800_74##2	3.22849e-18
C374	a_27_464##6	a_27_464##3	8.47929e-20
C375	VPWR#17	VPWR#6	1.70826e-20
C376	a_1764_74##11	a_1958_48#	5.81295e-18
C377	VPWR#8	a_599_74##4	2.25625e-19
C378	a_289_464##3	VPWR#19	4.72097e-17
C379	a_599_74#	a_1910_74#	9.87534e-18
C380	a_998_81##5	a_800_74##6	1.13272e-16
C381	VGND#6	a_599_74##8	1.37833e-18
C382	VGND#13	a_800_74##7	8.99405e-19
C383	a_1610_341#	a_1721_374##2	2.41334e-17
C384	a_599_74##5	SCD#2	4.96572e-19
C385	a_1198_55##3	VGND#16	2.85167e-17
C386	CLK	a_599_74##4	1.07242e-18
C387	a_1958_48##7	SET_B#5	1.07827e-19
C388	VGND#8	a_800_74##2	2.96612e-18
C389	a_1764_74##9	SET_B#4	1.87624e-17
C390	VGND#3	a_1958_48##4	2.29088e-17
C391	VPWR#9	a_800_74##3	3.63165e-18
C392	a_1764_74##6	a_2395_94##3	2.0702e-17
C393	a_1958_48##5	SET_B#6	4.88628e-18
C394	SCE#1	D#2	1.30224e-17
C395	a_800_74##6	SET_B#2	5.28125e-17
C396	a_2395_94##7	a_2395_94#	2.05092e-18
C397	VPWR#20	SCE#2	5.85479e-19
C398	VPWR#9	VPWR#17	1.15427e-17
C399	VPWR#6	SET_B#3	7.51609e-19
C400	VGND#8	a_800_74##3	4.87687e-18
C401	SCE#7	a_289_464##3	1.54166e-17
C402	a_1764_74##9	a_1721_374#	3.63957e-17
C403	a_998_81##5	SET_B#2	5.36242e-17
C404	VPWR#9	a_599_74##5	4.96349e-18
C405	a_998_81##2	a_800_74##6	2.24906e-18
C406	VPWR#13	a_1764_74#	2.03568e-17
C407	a_998_81##7	a_1198_55##3	4.87623e-18
C408	VGND#18	a_599_74##13	2.81408e-17
C409	VGND#7	a_599_74##6	4.07028e-18
C410	VPWR#15	SET_B#5	1.14884e-18
C411	SET_B#4	a_1764_74##7	3.54045e-18
C412	a_1610_341##2	a_1610_341#	2.90073e-18
C413	VGND#4	a_1764_74##10	1.15603e-18
C414	VPWR#7	a_998_81#	9.64749e-20
C415	VPWR#14	a_2395_94#	8.47076e-19
C416	VGND#8	a_599_74##5	6.86638e-18
C417	a_1764_74##10	a_1958_48##3	3.84042e-18
C418	a_998_81##2	a_998_81##5	1.46962e-18
C419	a_1764_74##11	a_599_74#	2.35213e-17
C420	a_1764_74##5	a_2395_94##3	1.35666e-19
C421	a_27_464##6	D#3	1.46444e-19
C422	VPWR#9	CLK#2	1.92559e-18
C423	a_1764_74##10	a_1610_341#	3.40227e-17
C424	VGND#16	a_1198_55##2	9.36193e-19
C425	a_1198_55#	a_599_74##3	1.61394e-17
C426	VPWR#9	a_998_81##9	8.39317e-18
C427	a_2395_94##7	a_1764_74#	6.01453e-17
C428	a_998_81##2	SET_B#2	8.06448e-17
C429	a_1198_55#	a_1128_457#	2.71447e-18
C430	VGND#8	CLK#2	5.03735e-18
C431	a_1198_55##3	a_998_81##5	1.78262e-18
C432	VGND#18	SCD#2	3.85418e-18
C433	VPWR#7	a_998_81##3	6.5763e-19
C434	a_1198_55##2	a_800_74##6	7.3775e-19
C435	VPWR#8	a_599_74##3	1.5814e-17
C436	a_800_74##7	a_1686_74#	1.50481e-17
C437	a_1764_74##9	a_1958_48##3	3.26862e-17
C438	a_599_74##7	a_1128_457#	5.12093e-18
C439	VPWR#6	a_998_81#	1.09955e-19
C440	VPWR#13	a_1764_74##7	7.82437e-19
C441	VPWR#7	VPWR#6	2.9382e-19
C442	a_998_81##4	a_1686_74#	1.50481e-17
C443	a_1764_74##5	a_1764_74##6	2.66002e-18
C444	a_1610_341##2	a_1764_74##13	7.22226e-18
C445	D#2	a_289_464##3	2.26538e-18
C446	VPWR#9	a_27_464##4	1.24262e-17
C447	VPWR#14	a_1764_74#	2.57752e-18
C448	a_2395_94##2	VPWR#2	1.8589e-19
C449	SCD#2	CLK#2	1.4567e-17
C450	VGND#1	a_2395_94##3	1.90722e-18
C451	a_1610_341#	a_1764_74##9	3.60042e-17
C452	SCD	a_599_74##4	1.71386e-19
C453	a_998_81##2	a_1198_55##3	5.72631e-17
C454	a_1198_55##2	SET_B#2	1.73733e-20
C455	VGND#9	VGND#7	7.87344e-19
C456	a_1958_48##3	SET_B#4	3.34207e-17
C457	VPWR#9	a_800_74##13	3.27661e-17
C458	a_1764_74##11	a_800_74##7	4.51303e-17
C459	SCD	SCD#2	4.27461e-17
C460	VGND#8	a_27_464##4	3.15383e-18
C461	a_1721_374#	a_1958_48##2	1.89007e-18
C462	a_27_464##6	SCE#1	1.98572e-17
C463	a_2395_94##7	a_1764_74##7	2.94887e-18
C464	VPWR#9	SCE#7	4.75099e-18
C465	a_1764_74##10	a_599_74##2	2.53698e-17
C466	a_998_81##2	a_1198_55##2	8.17699e-17
C467	a_1764_74##13	a_1764_74##10	2.44389e-18
C468	a_1958_48##7	a_1764_74#	1.91133e-18
C469	VPWR#9	VPWR#18	1.83126e-17
C470	VGND#3	a_1958_48##2	2.145e-18
C471	a_1610_341#	a_1958_48##2	1.33392e-18
C472	VGND#8	SCE#7	8.04301e-18
C473	SET_B#1	a_1426_118#	9.87534e-18
C474	VPWR#4	a_1764_74##4	1.33805e-19
C475	a_800_74##13	a_599_74##8	1.33284e-20
C476	a_1610_341##2	a_1721_374##2	4.07347e-17
C477	a_27_464##6	a_27_464##4	7.6825e-19
C478	VPWR#9	D#2	1.95046e-18
C479	a_1198_55##3	a_1198_55##2	3.70961e-18
C480	a_800_74##2	a_998_81##2	7.21612e-18
C481	a_998_81#	a_1426_118#	9.87534e-18
C482	a_289_464##6	a_599_74##13	9.08226e-18
C483	VPWR#14	a_1764_74##7	1.07913e-17
C484	VPWR#7	a_1198_55#	3.10629e-18
C485	VPWR#9	a_599_74##11	6.43405e-18
C486	a_1764_74##9	a_599_74##2	6.88031e-19
C487	VGND#8	D#2	1.90305e-18
C488	SCD#1	a_415_464#	1.26251e-17
C489	VPWR#3	a_1764_74##4	3.48913e-19
C490	a_800_74##2	a_1198_55##3	7.81581e-18
C491	a_1958_48##5	a_599_74#	1.60365e-19
C492	VPWR#9	a_27_464##2	4.34744e-19
C493	a_599_74##3	a_599_74##7	9.05982e-19
C494	a_289_464#	a_800_74##2	1.18456e-19
C495	a_27_464##3	a_415_464#	5.89735e-18
C496	a_1764_74##11	a_998_81##4	7.70356e-18
C497	VGND#9	SCD#3	3.76872e-18
C498	a_599_74##2	a_1958_48##3	1.03118e-17
C499	SET_B#6	a_1764_74##5	1.85195e-17
C500	VPWR#9	VPWR#19	2.20968e-17
C501	VPWR#7	a_599_74##3	4.62408e-17
C502	VPWR#9	a_599_74##3	1.88058e-17
C503	a_800_74##2	a_1198_55##2	6.55684e-17
C504	VGND#8	a_27_464##2	5.43614e-18
C505	a_27_464##6	SCE#3	2.68874e-17
C506	a_1958_48##7	a_1764_74##7	4.10514e-17
C507	a_800_74##6	a_1610_341#	8.02897e-19
C508	a_2395_94##5	a_2395_94##2	6.38642e-19
C509	VPWR#9	SCE#4	6.46867e-18
C510	SCE#6	SCD#2	6.97395e-18
C511	VPWR#16	a_1721_374##2	4.80951e-18
C512	a_27_464##8	SCE#7	1.1055e-19
C513	a_1764_74##11	VGND#13	7.1969e-18
C514	a_800_74##3	a_1198_55##2	1.34579e-18
C515	VGND#5	a_800_74##6	2.30113e-18
C516	VPWR#15	a_1764_74#	8.53303e-20
C517	VGND#8	a_599_74##11	2.89183e-18
C518	a_1764_74##10	a_800_74##5	3.71304e-18
C519	VGND#8	SCE#4	6.79637e-18
C520	VPWR#14	SET_B#4	2.38431e-19
C521	a_1764_74##10	a_599_74#	1.2332e-18
C522	a_800_74##6	a_1764_74##13	8.11591e-19
C523	D#4	a_27_464##4	9.21474e-18
C524	a_289_464##6	VGND#18	2.00933e-17
C525	a_800_74##3	a_998_81##7	5.30522e-17
C526	Q	a_1764_74##2	3.92236e-18
C527	D#3	a_205_464#	1.52812e-17
C528	a_800_74##3	a_800_74##2	1.52037e-17
C529	a_1958_48##5	a_1764_74##9	2.18402e-18
C530	a_1764_74##12	a_1764_74##7	8.54615e-19
C531	a_800_74##13	VPWR#8	6.38668e-17
C532	SCE#1	a_205_464#	1.52812e-17
C533	a_800_74##11	a_599_74##4	1.37217e-19
C534	D#4	SCE#1	4.41668e-18
C535	VPWR#9	a_289_464##4	1.63807e-17
C536	VPWR#9	SCE#2	1.9711e-18
C537	a_289_464#	a_800_74##3	7.85271e-17
C538	a_1721_374##2	a_800_74##6	1.76485e-19
C539	a_1198_55##4	a_1150_81#	9.87534e-18
C540	a_1764_74##11	SET_B#1	6.73637e-20
C541	VPWR#9	a_800_74##11	3.77056e-17
C542	a_1958_48##7	SET_B#4	1.29858e-18
C543	a_800_74##5	a_599_74##2	2.39317e-17
C544	SCE#4	a_289_464##3	1.84118e-18
C545	a_800_74#	a_1150_81#	9.87534e-18
C546	VPWR#16	a_1610_341##2	3.40986e-17
C547	a_800_74##9	a_800_74##3	6.58582e-18
C548	a_599_74##4	a_800_74##4	1.96631e-17
C549	a_800_74##6	a_1610_341##2	6.44823e-17
C550	VPWR#15	a_1764_74##7	2.19981e-19
C551	a_998_81##4	VGND#14	1.8686e-17
C552	VPWR#8	a_599_74##8	1.91245e-20
C553	VPWR#14	a_1958_48##3	7.63631e-20
C554	VPWR#3	a_1764_74##3	6.58745e-20
C555	a_1958_48#	SET_B#6	7.89387e-18
C556	VGND#9	SCE#6	5.51589e-18
C557	VGND#8	a_599_74##4	2.01412e-18
C558	a_800_74##6	VPWR#16	6.36222e-17
C559	a_2395_94##5	a_1764_74##4	2.71376e-18
C560	a_800_74##13	VPWR#7	5.29447e-18
C561	VGND#2	a_2395_94##5	4.95916e-18
C562	a_1764_74##12	SET_B#4	3.09055e-17
C563	VPWR#9	VPWR#20	1.62175e-17
C564	a_998_81##6	a_599_74##2	1.8835e-17
C565	SCE#7	D#4	3.51029e-18
C566	a_1198_55##5	a_800_74##7	3.31189e-19
C567	a_599_74##3	a_800_74##4	1.21914e-17
C568	VGND#9	SCD	7.67907e-19
C569	a_27_464##6	D#2	3.01881e-20
C570	a_1764_74##11	a_1610_341#	4.45529e-19
C571	a_1764_74##10	a_998_81##6	9.31155e-20
C572	VGND#5	a_1764_74##11	4.11861e-17
C573	a_289_464##6	SCD#2	1.67714e-17
C574	VGND#5	a_998_81##5	9.40585e-17
C575	a_599_74##5	a_289_464#	1.11188e-17
C576	CLK#2	a_599_74##5	2.95738e-17
C577	a_800_74##11	a_599_74##2	2.12851e-19
C578	VPWR#6	a_599_74##3	1.03344e-17
C579	a_1198_55##7	a_800_74##6	5.60748e-17
C580	VPWR#8	a_800_74##4	3.60554e-19
C581	D#4	SCE#3	8.57517e-19
C582	a_1764_74##11	a_998_81#	8.16912e-20
C583	a_1610_341##2	a_998_81##5	1.2972e-18
C584	a_800_74##11	a_599_74##3	4.12536e-17
C585	a_289_464##3	VPWR#10	1.67963e-17
C586	a_998_81##6	a_800_74##5	6.2925e-18
C587	a_800_74##9	a_599_74##5	3.0886e-17
C588	SET_B#4	VPWR#15	1.07429e-17
C589	VGND#8	SCD#2	2.88224e-18
C590	SET_B#1	VGND#14	1.36937e-17
C591	a_27_464##4	SCD#2	3.40485e-17
C592	VPWR	a_1764_74##3	5.74374e-18
C593	VPWR#16	a_998_81##5	4.39318e-19
C594	VPWR#7	a_800_74##4	4.21386e-19
C595	VPWR	a_1764_74##2	2.39633e-18
C596	VGND#17	a_599_74##5	3.082e-18
C597	VGND#19	VGND#18	3.99396e-19
C598	a_1764_74##12	a_1958_48##3	1.02494e-18
C599	a_27_464##8	D#1	1.07093e-19
C600	VPWR	a_599_74##3	4.72728e-18
C601	VPWR#9	a_998_81##8	4.16371e-18
C602	a_27_464##8	a_27_464##2	4.10364e-18
C603	a_1198_55##5	a_998_81##4	4.86689e-19
C604	a_1958_48##5	a_1764_74##4	1.07059e-16
C605	SCE#2	D#1	1.17782e-18
C606	a_1721_374#	SET_B#4	1.15644e-18
C607	D#4	D#2	5.50773e-18
C608	VPWR#3	a_1764_74##2	5.18425e-19
C609	a_599_74#	a_1958_48#	3.42842e-17
C610	a_27_464##6	a_27_464##2	1.13561e-18
C611	a_289_464#	CLK#2	4.72045e-19
C612	a_1198_55##7	a_599_74##3	1.31633e-18
C613	a_1764_74##2	a_2395_94##2	1.40084e-17
C614	a_599_74##9	a_599_74##4	3.42489e-17
C615	a_1764_74##10	a_1764_74##4	2.10917e-20
C616	a_1958_48##3	VPWR#15	1.25601e-17
C617	a_800_74##6	VPWR#6	5.49101e-19
C618	SET_B#3	a_998_81##6	1.27696e-17
C619	VGND#4	a_1958_48#	8.42395e-18
C620	a_1610_341#	SET_B#4	3.06623e-19
C621	VGND#5	SET_B#2	3.4305e-19
C622	VPWR#8	a_599_74##9	4.0059e-18
C623	VGND#16	a_998_81##4	6.52945e-19
C624	a_1764_74##12	a_599_74##2	1.10185e-19
C625	a_1764_74##9	a_1764_74##4	4.17999e-18
C626	VGND#2	Q	1.79748e-18
C627	CLK#2	VGND#17	1.71136e-17
C628	a_599_74##9	a_599_74##3	9.41194e-18
C629	SCE#7	a_27_464##4	4.81395e-17
C630	SET_B#2	a_1198_55##7	5.78983e-18
C631	a_1721_374#	a_1958_48##3	3.64077e-17
C632	VGND#4	a_599_74#	5.70955e-18
C633	a_27_464##8	a_27_464#	3.28377e-19
C634	a_1198_55##5	SET_B#1	4.64583e-18
C635	a_599_74##13	CLK#2	2.55251e-17
C636	a_289_464##3	SCD	6.89651e-17
C637	a_27_464##8	SCE#4	6.26957e-17
C638	SCD	a_289_464##2	1.41433e-18
C639	D#2	a_27_464##4	9.26998e-17
C640	D#4	a_27_464##2	1.12755e-18
C641	VGND#8	a_998_81##8	1.06931e-17
C642	a_27_464##6	SCE#4	4.48841e-17
C643	a_1958_48##5	SET_B#5	6.98944e-18
C644	SCE#7	D#2	7.68867e-17
C645	a_800_74##11	a_1128_457#	9.10597e-18
C646	a_2395_94##5	Q	5.83861e-18
C647	a_27_464##4	a_27_464##2	1.88646e-19
C648	VPWR#4	VPWR#3	2.79316e-19
C649	SCD#3	a_402_74#	9.87534e-18
C650	a_1610_341#	a_1958_48##3	1.8207e-18
C651	SCE#7	SCD#2	3.63705e-17
C652	a_800_74##7	a_599_74#	1.11081e-17
C653	a_1764_74##6	a_2395_94##2	1.65621e-17
C654	SCE#6	a_402_74#	9.87534e-18
C655	a_998_81##3	SET_B#3	2.47094e-17
C656	a_27_464##2	SCE#7	3.03775e-18
C657	VGND#19	a_289_464##6	1.45184e-17
C658	a_1764_74##10	SET_B#5	2.29081e-18
C659	VGND#16	SET_B#1	3.47451e-19
C660	a_1198_55##7	a_998_81##2	2.14137e-17
C661	VGND#6	a_998_81##2	9.16201e-20
C662	a_800_74##11	a_998_81##6	6.56708e-19
C663	SCE#7	SCE#2	9.10174e-19
C664	a_1721_374#	a_599_74##2	1.68469e-17
C665	a_289_464##3	VPWR#9	3.91172e-17
C666	CLK	a_289_464#	4.365e-18
C667	VPWR#6	a_998_81##5	3.88849e-19
C668	SCE#4	SCE#7	1.66573e-18
C669	VGND#3	a_1958_48##5	2.4068e-18
C670	VPWR#2	a_1764_74##2	3.9521e-20
C671	VGND#17	CLK	2.13627e-17
C672	a_1764_74##13	a_1958_48##3	4.37548e-19
C673	VGND#6	VGND#5	7.94208e-19
C674	a_1198_55##5	a_998_81#	3.8957e-17
C675	a_599_74##4	a_599_74##3	3.27107e-20
C676	a_1764_74##9	SET_B#5	6.82818e-18
C677	VGND#5	VGND#14	1.12167e-17
C678	a_289_464##2	VPWR#8	8.72105e-19
C679	VPWR#17	a_599_74##3	1.73013e-17
C680	VGND#5	a_998_81##2	1.71041e-18
C681	a_27_464##8	SCE#5	2.33852e-17
C682	SCE#4	D#2	3.56636e-18
C683	a_1764_74##4	a_1764_74##2	1.59796e-18
C684	a_289_464##2	VPWR#9	2.01426e-17
C685	SCE#4	D#4	2.46352e-17
C686	a_1764_74##4	a_1764_74##6	1.34025e-18
C687	a_1610_341#	a_599_74##2	6.57097e-17
C688	VPWR#19	VPWR#8	1.56727e-18
C689	a_27_464##2	SCE#4	4.22374e-17
C690	VPWR	VPWR#7	1.78043e-17
C691	VPWR	VPWR#6	1.20069e-16
C692	VPWR	VPWR#4	6.75782e-17
C693	VPWR	VPWR#3	8.27335e-17
C694	a_27_464##8	a_27_464##6	2.15399e-18
C695	VPWR	VPWR#2	6.55467e-17
C696	a_1721_374##2	a_1958_48##3	1.8359e-19
C697	a_27_464##9	a_289_464##6	9.83062e-19
C698	a_1198_55#	a_998_81##3	7.11723e-18
C699	a_1958_48##2	a_1958_48##5	2.78385e-18
C700	VGND#16	a_998_81#	2.42124e-18
C701	VPWR	a_2395_94##5	7.46766e-19
C702	VPWR#17	a_1198_55##3	1.58558e-19
C703	a_599_74##2	a_1764_74##13	2.80572e-17
C704	D#1	a_238_74#	9.87534e-18
C705	VPWR	a_1764_74##10	2.24499e-18
C706	a_998_81##4	a_800_74##7	4.69179e-17
C707	VPWR	a_1764_74##9	9.12113e-18
C708	a_27_464#	a_238_74#	9.87534e-18
C709	VPWR#10	SCD#1	5.23873e-18
C710	a_1764_74##10	a_1958_48##2	3.61259e-17
C711	a_800_74##11	SET_B#3	8.96182e-18
C712	SCD	a_599_74##13	2.51487e-17
C713	a_1198_55##5	a_1198_55##4	1.46298e-18
C714	VGND#18	SCD	9.80431e-18
C715	VPWR	a_800_74##11	2.65255e-17
C716	Q	Q#3	8.83205e-19
C717	SCD#2	CLK#1	8.02837e-18
C718	a_27_464##8	a_289_464##6	1.54239e-18
C719	VGND#12	Q	1.99032e-17
C720	a_1610_341#	a_800_74##5	1.30454e-17
C721	VGND#6	a_1198_55##3	2.06178e-18
C722	a_289_464##6	SCD	3.37497e-17
C723	a_27_464##4	a_205_464#	1.21786e-18
C724	D#2	SCD#2	2.62507e-18
C725	a_1958_48##2	a_1764_74##9	3.11369e-18
C726	VGND	a_1764_74##3	1.38238e-19
C727	a_1721_374##2	a_599_74##2	3.81823e-17
C728	a_1721_374#	a_998_81##6	2.7265e-19
C729	SCE#2	D#2	2.36142e-17
C730	SET_B#5	a_1764_74##3	7.0219e-19
C731	a_599_74##7	a_1198_55#	2.00038e-17
C732	VPWR#17	a_1198_55##2	6.38892e-19
C733	VGND#16	a_1198_55##4	3.06228e-17
C734	VGND#19	SCE#2	5.45305e-19
C735	a_800_74##5	a_1764_74##13	1.65809e-17
C736	a_289_464##6	a_27_464##4	9.47551e-19
C737	CLK	a_599_74##11	1.02598e-17
C738	VGND#6	a_1198_55##5	7.50365e-18
C739	a_1610_341##2	a_599_74##2	9.81262e-18
C740	a_998_81##7	a_998_81#	2.24577e-19
C741	a_1610_341#	a_998_81##6	5.40932e-19
C742	a_1198_55##5	a_800_74#	1.92567e-19
C743	VPWR#3	VPWR#2	1.25466e-18
C744	VGND#8	a_1198_55##4	4.26956e-18
C745	a_800_74##5	a_1721_374##2	8.1241e-18
C746	SET_B#1	a_998_81##4	4.85815e-18
C747	a_998_81##9	a_1198_55##2	5.80146e-19
C748	a_800_74##6	a_1764_74##10	3.67856e-17
C749	a_800_74##11	a_998_81##3	2.36845e-17
C750	Q	Q#1	1.52385e-17
C751	a_289_464##4	VPWR#10	9.03102e-18
C752	VPWR#13	Q	7.26921e-17
C753	VPWR#10	a_27_464##3	6.19516e-18
C754	VPWR#1	a_2395_94#	6.08088e-18
C755	a_1958_48##2	SET_B#6	3.15025e-17
C756	a_2395_94##7	Q	2.95175e-19
C757	a_27_464##9	VGND#19	3.97997e-17
C758	a_289_464##3	a_415_464#	2.57433e-18
C759	VPWR#16	a_599_74##2	2.52356e-19
C760	SCD	a_599_74##11	6.1303e-17
C761	a_1764_74##13	a_998_81##6	1.27228e-18
C762	SCD	VPWR#19	3.79966e-18
C763	a_800_74##4	a_599_74##7	2.36367e-17
C764	VGND#8	a_800_74#	1.2319e-17
C765	VGND#6	a_1198_55##2	3.83521e-19
C766	a_800_74##11	VPWR#16	2.09646e-17
C767	VGND#16	a_800_74#	4.98868e-18
C768	a_289_464##6	SCE#7	7.73656e-17
C769	a_1610_341##2	a_800_74##5	1.47281e-17
C770	a_998_81##9	a_599_74##4	1.6871e-19
C771	VGND#5	a_1198_55##5	1.79491e-17
C772	a_1764_74##2	a_2395_94#	1.91158e-17
C773	VGND	VGND#6	1.10857e-17
C774	VGND	VGND#5	1.77391e-16
C775	VGND	VGND#3	1.11056e-16
C776	a_998_81##7	a_1198_55##4	4.48708e-18
C777	VGND#8	a_599_74##8	4.304e-19
C778	VGND	VGND#2	8.55868e-17
C779	CLK	a_599_74##6	1.79731e-19
C780	a_998_81##9	a_800_74##2	2.28105e-17
C781	a_1721_374##2	a_998_81##6	2.53069e-18
C782	a_599_74#	a_1958_48##2	3.82312e-17
C783	a_27_464##2	SCD#2	2.13426e-19
C784	VPWR#16	a_800_74##5	9.40342e-20
C785	VPWR	a_2395_94##7	1.67838e-17
C786	SCE#2	a_27_464##2	1.7582e-17
C787	VGND#8	a_599_74##6	3.92632e-18
C788	VGND	a_2395_94##5	7.40612e-18
C789	VGND#19	a_27_464##8	3.07419e-18
C790	VPWR	a_1958_48##7	1.93361e-17
C791	a_998_81##8	a_599_74##4	3.83104e-19
C792	a_1958_48##2	a_800_74##7	2.04601e-19
C793	VPWR	a_1764_74##12	2.07587e-17
C794	VGND	a_1958_48##5	8.24246e-18
C795	VGND	a_1764_74##10	7.11881e-18
C796	VPWR	a_1721_374#	3.73447e-17
C797	a_800_74##11	a_1198_55#	2.59174e-17
C798	a_998_81#	SET_B#1	4.82904e-17
C799	VPWR	a_1610_341#	1.02817e-17
C800	a_1764_74##10	a_998_81##5	9.8136e-20
C801	a_998_81##6	a_1610_341##2	2.88434e-17
C802	VPWR	a_1764_74##13	2.70385e-18
C803	Q	a_2395_94##3	1.16673e-17
C804	VPWR	a_1721_374##2	3.3559e-17
C805	a_998_81##9	a_599_74##3	9.62358e-19
C806	a_289_464##3	a_289_464##2	2.02032e-18
C807	VGND#16	a_998_81##8	2.43991e-18
C808	VGND#16	a_599_74##8	5.96733e-19
C809	VPWR	a_1610_341##2	1.6739e-17
C810	Q	a_1764_74##6	1.06109e-18
C811	SCD	CLK#3	1.53012e-19
C812	VGND#8	CLK#3	9.6744e-18
C813	a_800_74##6	a_599_74#	9.58839e-18
C814	VPWR	a_1198_55##7	6.83882e-18
C815	a_800_74##3	a_998_81##9	2.85317e-17
C816	a_1198_55##7	a_800_74##11	6.36801e-17
C817	a_998_81##7	a_800_74#	3.4681e-17
C818	VGND#6	a_800_74##2	4.56518e-20
C819	VGND#8	SCD#3	2.71559e-18
C820	VPWR#16	a_998_81##6	3.64796e-17
C821	a_1764_74##3	a_1764_74#	2.19216e-18
C822	a_800_74##9	a_1198_55##4	3.83004e-19
C823	VGND#16	VGND#5	5.81825e-18
C824	a_800_74##11	a_998_81#	1.09976e-19
C825	VGND	VGND#12	2.20968e-17
C826	a_2395_94##7	a_1764_74##3	3.52447e-18
C827	VGND	a_2395_94##6	1.87404e-17
C828	VGND	a_1958_48##4	1.98425e-17
C829	a_1610_341##2	SET_B#3	6.03091e-19
C830	a_800_74##13	a_800_74##3	2.98787e-19
C831	a_998_81##4	a_800_74##6	1.4176e-18
C832	VPWR#9	a_27_464##6	2.33146e-17
C833	VGND#8	SCE#6	1.99237e-20
C834	CLK#1	a_599_74##9	4.6318e-17
C835	VGND	a_1764_74##11	2.92305e-17
C836	a_27_464##2	a_289_464##6	1.94374e-17
C837	a_289_464#	a_800_74#	3.32307e-20
C838	a_998_81##8	a_599_74##3	9.5016e-19
C839	VGND	a_1198_55##5	7.93014e-18
C840	Q	a_2395_94#	3.04976e-17
C841	a_2395_94##5	VGND#12	4.80422e-17
C842	VPWR#3	VPWR#13	2.74004e-19
C843	a_800_74##11	a_599_74##7	1.11991e-17
C844	SCD	a_599_74##9	2.89532e-19
C845	VGND#8	D#1	1.29952e-18
C846	SCD	CLK#1	1.3048e-18
C847	a_1198_55##4	a_998_81#	2.77158e-18
C848	SCE#4	SCD#2	3.75404e-19
C849	a_599_74##8	a_998_81##7	1.92884e-18
C850	SET_B#3	VPWR#16	1.53203e-17
C851	a_1764_74##3	VNB	3.96879e-17
C852	a_27_464##2	VGND#19	3.53839e-17
C853	a_1764_74##2	VNB	4.52169e-17
C854	a_599_74##4	VNB	8.48109e-17
C855	VGND#3	a_2395_94##3	1.14261e-19
C856	a_599_74##3	VNB	1.94586e-16
C857	SCD#2	VNB	1.11254e-16
C858	SCE#2	VNB	9.76752e-17
C859	SCE#4	SCE#2	4.41485e-17
C860	a_800_74##11	VPWR#17	8.46597e-17
C861	VGND#8	a_27_464##8	4.84988e-19
C862	VPWR#9	CLK	1.75164e-18
C863	a_599_74##5	a_800_74##13	9.03486e-19
C864	VPWR	a_2395_94#	3.3658e-20
C865	a_800_74##9	a_800_74#	2.67533e-18
C866	VGND#8	a_27_464#	5.9632e-19
C867	a_2395_94##7	a_1764_74##2	1.37151e-17
C868	VPWR	a_1764_74#	8.67253e-18
C869	VGND#8	CLK	1.62356e-18
C870	VPWR	a_1764_74##7	2.18845e-18
C871	VPWR	a_1958_48##3	1.99411e-19
C872	a_998_81##5	SET_B#1	2.18364e-17
C873	SET_B#3	a_1198_55##7	1.24375e-17
C874	SCD#1	CLK#1	3.78616e-18
C875	VGND#6	a_800_74##3	1.51802e-19
C876	a_599_74##5	VPWR#18	1.02565e-18
C877	VPWR	a_998_81##6	2.08225e-18
C878	a_289_464#	a_599_74##8	2.1218e-17
C879	VPWR#9	SCD	5.31053e-18
C880	VGND#8	SCE#5	1.09927e-18
C881	VGND#8	SCD	5.91639e-18
C882	Q	VPWR#1	3.56794e-17
C883	VGND#1	Q	4.57998e-17
C884	VGND#9	VNB	4.42963e-17
C885	VGND#7	VNB	4.83898e-17
C886	VGND#2	a_2395_94##3	3.33196e-18
C887	a_998_81##5	a_998_81#	4.45191e-19
C888	VGND#6	VNB	6.53289e-17
C889	VGND	a_2395_94##3	1.77572e-18
C890	a_599_74##11	a_599_74##5	5.16749e-18
C891	VGND#5	VNB	7.64831e-17
C892	VGND#3	VNB	4.96008e-17
C893	VGND	a_1764_74##6	9.2149e-18
C894	VGND#2	VNB	4.54798e-17
C895	VGND	a_1764_74##5	8.53307e-19
C896	a_27_464##6	VPWR#20	6.44134e-17
C897	VPWR#10	VNB	4.02967e-17
C898	VPWR#8	VNB	4.61177e-17
C899	VPWR#7	VNB	4.99222e-17
C900	VPWR#6	VNB	4.89004e-17
C901	VPWR#4	VNB	3.1417e-17
C902	VGND	a_599_74#	2.30294e-18
C903	VPWR#3	VNB	4.0709e-17
C904	VPWR#2	VNB	2.69423e-17
C905	SET_B#7	a_1764_74##11	4.45088e-18
C906	VPWR#9	D#4	1.76418e-18
C907	a_27_464##6	a_205_464#	3.38417e-18
C908	a_2395_94##5	VNB	6.7176e-18
C909	VGND	SET_B#1	2.15425e-18
C910	a_2395_94##5	a_2395_94##6	3.72393e-18
C911	VGND	a_998_81#	9.24608e-18
C912	a_1958_48##5	VNB	2.2101e-17
C913	a_800_74##11	a_800_74##4	2.36193e-19
C914	a_1764_74##10	VNB	1.61546e-17
C915	a_2395_94##2	Q	5.18461e-17
C916	a_1764_74##9	VNB	1.9006e-17
C917	CLK	a_599_74##5	3.39152e-17
C918	SET_B#7	a_599_74##2	1.6731e-19
C919	a_2395_94##7	VPWR#3	5.86469e-18
C920	a_27_464##6	D#4	1.58343e-17
C921	a_800_74##11	VNB	2.46593e-17
C922	CLK	CLK#2	7.12345e-18
C923	a_800_74#	a_1198_55##4	3.65101e-17
C924	VPWR#14	a_1764_74##3	6.25783e-18
C925	a_998_81##8	VNB	1.51048e-17
C926	VGND#6	a_998_81##7	1.20837e-17
C927	a_800_74##9	a_599_74##8	1.77574e-17
C928	SET_B#7	VPWR	3.24359e-17
C929	VPWR#5	a_1958_48##3	1.57317e-19
C930	a_800_74##6	a_599_74##3	3.35199e-19
C931	a_289_464##3	VNB	8.85277e-18
C932	a_1198_55##7	a_998_81##3	1.42044e-17
C933	VPWR	VPWR#5	7.86519e-17
C934	VGND#7	a_599_74##4	4.8192e-19
C935	a_27_464##3	SCD#1	3.47353e-17
C936	a_27_464##8	VNB	3.93138e-17
C937	a_27_464##6	VNB	6.17992e-17
C938	SCD	CLK#2	9.21386e-19
C939	a_998_81#	SET_B#2	1.04598e-18
C940	VPWR	a_2395_94##2	3.22481e-18
C941	VPWR#7	a_800_74##2	7.92406e-20
C942	a_800_74##13	a_599_74##4	2.87132e-18
C943	D#4	VNB	1.01348e-19
C944	VPWR	a_1764_74##4	3.88472e-18
C945	Q#3	VNB	2.35649e-17
C946	SET_B#7	a_800_74##5	1.23416e-18
C947	SET_B#2	a_800_74##11	1.44344e-18
C948	VGND#12	VNB	6.86852e-18
C949	a_2395_94##6	VNB	8.15832e-18
C950	a_1958_48##4	VNB	7.08863e-18
C951	a_289_464#	a_599_74##6	1.60177e-18
C952	VGND#13	VNB	2.85568e-18
C953	a_599_74##11	CLK#2	3.84442e-17
C954	a_1764_74##11	VNB	1.02786e-17
C955	VPWR	a_800_74##6	6.81373e-18
C956	VPWR#5	a_599_74##2	1.57583e-17
C957	VGND#7	a_599_74##5	7.59302e-19
C958	a_1198_55##5	VNB	6.91758e-18
C959	VGND#16	VNB	6.4356e-18
C960	a_998_81##7	VNB	3.64823e-18
C961	VPWR	SET_B#2	2.34876e-18
C962	a_289_464#	VNB	3.7958e-18
C963	a_800_74##9	VNB	1.07484e-17
C964	VGND#17	VNB	4.12486e-18
C965	VPWR	a_998_81##2	1.52258e-18
C966	a_599_74##13	VNB	1.01714e-17
C967	VGND#18	VNB	5.44122e-18
C968	a_998_81##8	a_599_74##7	8.2208e-19
C969	a_998_81##3	VPWR#17	1.42299e-17
C970	a_289_464##6	VNB	4.96553e-18
C971	VGND#19	VNB	3.90084e-18
C972	VPWR	a_1198_55##2	4.54751e-20
C973	a_27_464##9	VNB	2.67475e-17
C974	a_1198_55##5	a_599_74##3	3.99561e-21
C975	VPWR#13	VNB	4.65698e-18
C976	a_2395_94##7	VNB	6.55765e-18
C977	VPWR#14	VNB	5.84234e-18
C978	a_1958_48##7	VNB	1.17701e-17
C979	a_1764_74##12	VNB	8.92661e-18
C980	VPWR#15	VNB	2.33907e-18
C981	a_1721_374#	VNB	1.13714e-17
C982	a_1610_341#	VNB	6.49979e-18
C983	a_27_464##6	a_27_464##7	6.98397e-18
C984	a_1764_74##13	VNB	3.44658e-19
C985	a_1721_374##2	VNB	1.76301e-17
C986	a_1610_341##2	VNB	1.27307e-17
C987	a_2395_94##7	VPWR#2	6.44752e-18
C988	VPWR#16	VNB	2.66962e-18
C989	a_1198_55##7	VNB	3.58466e-18
C990	VPWR#17	VNB	2.60809e-18
C991	VGND	SET_B#7	3.13154e-17
C992	a_998_81##9	VNB	4.47473e-18
C993	a_27_464##8	SCE#2	1.51504e-17
C994	VGND#8	D#4	1.76098e-18
C995	a_1198_55##7	a_1198_55#	2.77263e-20
C996	a_998_81##2	a_998_81#	1.26293e-17
C997	a_800_74##13	VNB	1.04744e-17
C998	VGND	VGND#4	7.99598e-17
C999	a_599_74##11	VNB	5.58954e-18
C1000	VPWR#19	VNB	5.54407e-18
C1001	a_800_74##9	a_599_74##6	5.15293e-17
C1002	VGND	a_2395_94##2	4.54342e-18
C1003	a_2395_94##5	a_1764_74##2	3.09865e-17
C1004	VGND#2	a_1764_74##6	2.85829e-18
C1005	VPWR#20	VNB	2.01947e-18
C1006	VGND	a_1764_74##4	4.6951e-18
C1007	a_2395_94##3	VNB	3.21289e-17
C1008	a_1764_74##6	VNB	4.89738e-17
C1009	a_800_74##13	a_599_74##3	2.31701e-17
C1010	a_1764_74##5	VNB	4.82835e-17
C1011	SET_B#6	VNB	3.33108e-17
C1012	VGND	a_1958_48##2	2.15887e-17
C1013	a_1958_48#	VNB	1.81094e-17
C1014	a_599_74#	VNB	4.44538e-17
C1015	VGND	a_800_74##6	6.39382e-18
C1016	a_800_74##7	VNB	2.39121e-17
C1017	a_998_81##4	VNB	2.45954e-17
C1018	VGND	a_998_81##5	8.0397e-18
C1019	a_800_74##11	a_599_74##9	9.64722e-20
C1020	D#3	a_27_464##3	1.47839e-17
C1021	SET_B#1	VNB	2.57933e-17
C1022	a_998_81#	VNB	5.4831e-17
C1023	VGND	SET_B#2	2.16952e-18
C1024	a_1198_55##4	VNB	2.43335e-17
C1025	a_800_74#	VNB	3.92594e-17
C1026	VGND	a_998_81##2	6.44534e-18
C1027	a_599_74##8	VNB	4.38084e-17
C1028	a_599_74##6	VNB	3.19601e-17
C1029	VPWR#16	a_599_74##7	4.56386e-20
C1030	CLK#3	VNB	3.49796e-17
C1031	SCD#3	VNB	2.56037e-17
C1032	a_1198_55##3	SET_B#1	1.18911e-19
C1033	SCE#6	VNB	2.48373e-17
C1034	a_599_74##8	a_800_74#	1.17671e-17
C1035	D#1	VNB	3.79693e-17
C1036	a_27_464#	VNB	2.11372e-17
C1037	VGND#9	SCD#2	9.5449e-19
C1038	SCE#5	VNB	4.37461e-17
C1039	a_2395_94#	VNB	4.48834e-17
C1040	a_289_464#	CLK#3	6.88353e-20
C1041	a_1764_74#	VNB	3.76286e-17
C1042	a_1764_74##7	VNB	3.515e-17
C1043	VPWR#8	a_800_74##3	3.19029e-19
C1044	SET_B#4	VNB	3.52744e-17
C1045	a_1958_48##3	VNB	6.03435e-17
C1046	a_599_74##2	VNB	1.9529e-16
C1047	a_1198_55#	VPWR#17	1.30382e-17
C1048	a_800_74##5	VNB	4.19159e-17
C1049	a_998_81##6	VNB	3.89813e-17
C1050	SET_B#3	VNB	3.07995e-17
C1051	a_998_81##3	VNB	2.6027e-17
C1052	a_1198_55#	VNB	2.01427e-17
C1053	a_599_74##7	VNB	2.93035e-17
C1054	a_800_74##4	VNB	1.98763e-17
C1055	a_998_81##9	a_800_74##11	7.53519e-17
C1056	a_599_74##9	VNB	3.52991e-17
C1057	CLK#1	VNB	3.88791e-17
C1058	VPWR#18	a_800_74##13	3.62468e-17
C1059	SCD#1	VNB	2.80963e-17
C1060	a_27_464##3	VNB	2.62224e-17
C1061	a_1198_55##3	a_998_81#	2.66433e-17
C1062	D#3	VNB	2.37128e-17
C1063	SCE#1	VNB	3.08531e-17
C1064	a_800_74##11	a_998_81##2	4.55122e-19
C1065	SCE#3	VNB	3.34887e-17
C1066	SET_B#4	a_1764_74##3	6.76855e-19
C1067	a_599_74##6	VGND#17	2.35254e-17
C1068	VPWR#1	VNB	8.9267e-17
C1069	VGND#1	VNB	9.24759e-17
C1070	VPWR#7	a_800_74##3	8.01567e-20
C1071	SET_B#7	VNB	2.16379e-18
C1072	a_2395_94##7	VPWR#13	7.65536e-17
C1073	VPWR#5	VNB	4.20145e-17
C1074	VGND#4	VNB	4.16001e-17
C1075	VPWR#9	VNB	3.03288e-16
C1076	VGND#3	a_1764_74##5	7.35321e-18
C1077	a_1198_55##7	a_599_74##7	8.20739e-21
C1078	VGND#8	VNB	3.37276e-16
C1079	a_2395_94##2	VNB	5.08413e-17
C1080	a_1764_74##4	VNB	6.75106e-17
C1081	SET_B#5	VNB	5.82975e-17
C1082	a_1958_48##2	VNB	1.10082e-16
C1083	a_800_74##6	VNB	6.03299e-17
C1084	VGND#16	a_1198_55##5	1.19766e-17
C1085	a_998_81##5	VNB	5.76151e-17
C1086	SET_B#2	VNB	5.37518e-17
C1087	a_1958_48##7	a_1764_74##3	1.4121e-17
C1088	a_998_81##2	VNB	5.3804e-17
C1089	a_1198_55##3	VNB	5.41275e-17
C1090	VGND#4	a_1764_74##11	1.4816e-17
C1091	a_1198_55##2	VNB	5.05022e-17
C1092	a_998_81##5	a_599_74##3	5.65714e-20
C1093	a_800_74##2	VNB	5.86747e-17
C1094	a_1198_55##3	a_1198_55##4	3.46298e-18
C1095	a_800_74##3	VNB	8.28198e-17
C1096	a_599_74##5	VNB	3.87215e-17
C1097	CLK#2	VNB	3.89628e-17
C1098	VGND#7	a_800_74##9	7.35351e-17
C1099	a_27_464##4	VNB	2.1474e-17
C1100	SCE#7	VNB	4.55963e-17
C1101	a_800_74##9	CLK#3	1.16386e-18
C1102	D#2	VNB	5.20384e-17
C1103	a_27_464##2	VNB	3.59546e-17
C1104	SCE#4	VNB	1.14442e-17
C1105	SCE#1	D#3	3.55712e-17
C1106	VPWR#18	a_599_74##4	5.98484e-19
C1107	a_800_74#	a_1198_55##3	1.92879e-17
C1108	VPWR#17	a_599_74##7	1.25351e-18
C1109	a_599_74##13	a_599_74##6	3.87369e-19
C1110	VGND	Q	2.95571e-18
C1111	CLK	VNB	8.44987e-19
C1112	Q#3	a_2395_94##2	1.15929e-17
C1113	SCD	VNB	3.44725e-18
C1114	Q	VNB	1.00588e-16
C1115	VPWR	VNB	2.42317e-16
C1116	VGND#9	VGND#17	2.04585e-19
C1117	a_998_81##9	a_1198_55#	5.65352e-19
C1118	VGND	VNB	2.47458e-16
C1119	SET_B	a_1764_74##11	8.16792e-20
C1120	a_1764_74##9	SET_B	4.55073e-17
C1121	VGND#10	SCE#7	1.12998e-18
C1122	SET_B	a_1764_74##4	7.00163e-17
C1123	VGND#8	VGND#10	1.13004e-16
C1124	VGND#10	SCE#2	1.26639e-19
C1125	VGND#10	SCE#4	2.04822e-19
C1126	VPWR#11	D#3	7.58497e-18
C1127	VGND#10	a_27_464#	4.81182e-18
C1128	VPWR#11	VPWR#19	3.13163e-19
C1129	a_1764_74##10	SET_B	9.97686e-17
C1130	VPWR#11	a_27_464##2	1.32827e-19
C1131	a_27_464##6	VPWR#11	2.17263e-17
C1132	SET_B	a_1721_374##2	6.1571e-19
C1133	VGND#10	VGND#18	1.95116e-20
C1134	VPWR#11	SCE#3	1.77539e-18
C1135	SET_B	VNB	1.05726e-17
C1136	a_289_464##4	VPWR#11	1.11634e-17
C1137	a_1958_48##5	SET_B	2.85902e-17
C1138	VGND#10	VNB	6.44394e-17
C1139	VGND#10	D#2	4.82948e-19
C1140	SET_B	a_599_74##2	3.83908e-18
C1141	SET_B	VGND#13	1.98478e-18
C1142	VGND#10	a_27_464##8	2.52469e-19
C1143	a_27_464##4	VPWR#11	2.12754e-18
C1144	SET_B	a_1610_341#	1.10795e-17
C1145	SET_B	VPWR#4	1.02354e-18
C1146	VGND#10	SCE#5	2.71859e-18
C1147	VGND	SET_B	3.74762e-17
C1148	SET_B	a_1958_48##3	3.16249e-18
C1149	SET_B	VGND#4	8.23058e-18
C1150	SET_B	VGND#3	1.96844e-18
C1151	VPWR#11	D#2	1.51734e-19
C1152	SET_B	a_1721_374#	3.49868e-18
C1153	SET_B	a_800_74##6	3.75425e-19
C1154	VPWR#11	SCE#1	3.94819e-18
C1155	SET_B	a_2395_94##5	2.70722e-18
C1156	SET_B	VPWR#5	1.7538e-18
C1157	SET_B	VGND#5	1.21452e-19
C1158	VGND#10	a_27_464##2	1.72331e-18
C1159	SET_B	VPWR#15	2.15258e-18
C1160	a_1958_48##2	SET_B	5.96981e-17
C1161	VGND#10	D#1	7.55801e-18
C1162	VPWR#9	VPWR#11	1.16117e-16
C1163	VPWR	SET_B	3.29001e-17
C1164	VPWR#11	VNB	6.49566e-17
C1165	SET_B	SET_B#5	2.67239e-17
C1166	VGND#10	VGND#9	3.9511e-19
C1167	VGND#10	a_289_464##6	7.49116e-18
C1168	VGND#10	a_27_464##9	2.6207e-17
*
*
.ENDS sky130_fd_sc_hs__sdfstp_1
*
