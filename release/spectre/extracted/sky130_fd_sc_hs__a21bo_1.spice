* Extracted by Quantus, converted by sky130cad/quantus.py
*
*
*
*                       LINUX           Wed Nov 18 08:04:18 2026
*
*
*
*  PROGRAM  advgen
*
*  Name           : advgen - Quantus - (64-bit)
*  Version        : 25.1.0-p047
*  Build Date     : Thu Dec 11 23:20:30 PST 2025
*
*  HSPICE LIBRARY
*
*  OPERATING_TEMPERATURE 150
*  QRC_TECH_DIR <path>/tech
*
*
*

*
.SUBCKT sky130_fd_sc_hs__a21bo_1 VPB VNB VGND VPWR X A2 B1_N A1
*
*
*  caps2d version: 10
*
*
*       TRANSISTOR CARDS
*
*
XM8 VGND#9 A2#2 a_122_136# VNB sky130_fd_pr__nfet_01v8_lvt l=0.15 w=0.64 ad=0.1696 as=0.1344 pd=1.81 ps=1.7
XM4 a_122_136# A1#3 a_194_136##7 VNB sky130_fd_pr__nfet_01v8_lvt l=0.15 w=0.64 ad=0.1344 as=0.2496 pd=1.7 ps=2.06
XM3 a_194_136##7 a_272_110##3 VGND#8 VNB sky130_fd_pr__nfet_01v8_lvt l=0.15 w=0.64 ad=0.2496 as=0.1696 pd=2.06 ps=1.81
XM9 a_272_110##5 B1_N#1 VGND#7 VNB sky130_fd_pr__nfet_01v8_lvt l=0.15 w=0.55 ad=0.15675 as=0.22625 pd=1.67 ps=2.13
XM2 VGND#7 a_194_136##3 X#3 VNB sky130_fd_pr__nfet_01v8_lvt l=0.15 w=0.74 ad=0.22625 as=0.1961 pd=2.13 ps=2.01
XM5 a_34_392##2 A2#1 VPWR#7 VPB sky130_fd_pr__pfet_01v8 l=0.15 w=1 ad=0.275 as=0.33 pd=2.55 ps=2.66
XM7 VPWR#7 A1#1 a_34_392# VPB sky130_fd_pr__pfet_01v8 l=0.15 w=1 ad=0.33 as=0.3 pd=2.66 ps=2.6
XM1 a_34_392# a_272_110# a_194_136##5 VPB sky130_fd_pr__pfet_01v8 l=0.15 w=1 ad=0.3 as=0.275 pd=2.6 ps=2.55
XM6 a_272_110##7 B1_N#3 VPWR#6 VPB sky130_fd_pr__pfet_01v8 l=0.15 w=0.84 ad=0.231 as=0.406 pd=2.23 ps=3.01
XM0 VPWR#6 a_194_136# X#1 VPB sky130_fd_pr__pfet_01v8 l=0.15 w=1.12 ad=0.406 as=0.308 pd=3.01 ps=2.79
*
*
*       RESISTOR AND CAP/DIODE CARDS
*
Rg1	A2#1	A2#2	774.737183
Rg2	A2#2	A2#3	317.786102
Rg3	A1#1	A1#2	409.090576
Rg4	A1#2	A1#3	290.721832
Rg5	a_272_110#	a_272_110##2	501.598419
Rg6	a_272_110##2	a_272_110##3	248.751953
Rg7	a_272_110##2	a_272_110##4	319.406708
Rg8	B1_N#1	B1_N#2	362.454590
Rg9	B1_N#2	B1_N#3	411.718903
Rg10	a_194_136#	a_194_136##2	456.142303
Rg11	a_194_136##2	a_194_136##3	377.742493
Rf1	A2#3	A2	166.137894
Rf2	A1#2	A1#5	160.737244
Rf3	A1#6	A1	0.504448
Rf4	A1#5	A1#6	8.463963
Rf5	a_34_392#	a_34_392##2	98.072578
Rf6	a_272_110##5	a_272_110##4	60.412472
Rf7	a_272_110##4	a_272_110##7	57.439507
Rf8	B1_N	B1_N#4	0.705966
Rf9	B1_N#5	B1_N#2	160.938766
Rf10	B1_N#4	B1_N#5	3.543054
Rf11	a_194_136##2	a_194_136##6	324.822723
Rf12	a_194_136##6	a_194_136##7	132.473312
Rf13	a_194_136##5	a_194_136##6	5.000000
Rf14	X	X#2	0.199714
Rf15	X#2	X	14.579127
Rf16	X	X#3	84.280487
Rf17	X#1	X#2	5.000000
Rf19	VPWR#2	VPWR#3	83.618286
Rf20	VPWR#3	VPWR#4	84.812981
Rf22	VPWR#2	VPWR#6	34.704330
Rf23	VPWR#4	VPWR#7	46.248783
Rf25	VGND#2	VGND#3	79.504341
Rf26	VGND#3	VGND#4	19.699100
Rf27	VGND#4	VGND#5	70.201988
Rf29	VGND#2	VGND#7	49.163322
Rf30	VGND#4	VGND#8	44.546150
Rf31	VGND#5	VGND#9	89.795288
Re1	VPWR#3	VPWR	1.227783
Re2	VGND	VGND#3	1.227829
*
*       CAPACITOR CARDS
*
*
C1	VPWR#3	a_272_110##2	6.71022e-20
C2	VGND#4	VGND#7	4.54202e-19
C3	VGND#4	a_272_110##5	3.33907e-18
C4	VGND#4	a_194_136##7	4.2484e-18
C5	a_272_110##2	a_272_110##4	4.87456e-18
C6	B1_N#4	X#3	5.11417e-18
C7	a_272_110##2	VGND#8	2.03024e-18
C8	a_272_110##5	B1_N#4	1.61057e-17
C9	A1#2	a_272_110##2	2.47226e-17
C10	a_194_136##7	a_272_110##2	9.17074e-18
C11	VGND#4	a_194_136##3	3.38298e-19
C12	VGND#7	X#3	4.54042e-17
C13	a_272_110##5	X#3	3.58653e-18
C14	VGND#4	B1_N#1	1.21206e-18
C15	a_272_110##5	VGND#7	5.15428e-17
C16	B1_N#5	a_272_110##7	1.26985e-17
C17	VGND#4	a_272_110##3	4.96302e-19
C18	B1_N#5	a_194_136##5	4.83223e-19
C19	VGND#8	a_272_110##5	4.32418e-17
C20	a_194_136##7	a_272_110##5	3.84311e-18
C21	a_194_136##7	VGND#8	5.33873e-17
C22	VGND#9	VGND#8	2.60758e-18
C23	VGND#9	a_194_136##7	4.84369e-17
C24	B1_N#4	a_194_136##3	1.69401e-18
C25	a_272_110##5	a_272_110##7	4.348e-18
C26	VPWR#6	X#1	5.1248e-18
C27	X#3	a_194_136##3	3.71409e-17
C28	a_194_136##7	a_34_392#	2.08303e-18
C29	a_194_136##3	VGND#7	1.80864e-17
C30	X#3	B1_N#1	2.42923e-18
C31	a_272_110##5	a_194_136##3	2.70594e-18
C32	a_194_136##5	X#1	9.53847e-19
C33	B1_N#1	VGND#7	1.68511e-17
C34	X#3	a_272_110##3	2.86285e-19
C35	a_194_136##5	VPWR#6	8.95977e-18
C36	a_272_110##5	B1_N#1	4.56494e-17
C37	VGND#8	B1_N#1	6.35364e-19
C38	a_194_136##5	a_272_110##7	7.65617e-17
C39	a_272_110##5	a_272_110##3	2.72856e-18
C40	VGND#9	a_34_392##2	1.15409e-17
C41	a_194_136##5	a_272_110##2	1.94822e-18
C42	a_194_136##7	B1_N#1	2.57962e-19
C43	VGND#8	a_272_110##3	3.04417e-17
C44	a_272_110##5	A1#3	2.58918e-19
C45	a_194_136##7	a_272_110##3	3.74946e-17
C46	A1	a_272_110##2	7.75363e-18
C47	a_34_392#	a_194_136##5	8.32479e-17
C48	VGND#3	VGND#4	2.80083e-17
C49	VGND#8	A1#3	9.85392e-19
C50	VGND#9	B1_N#1	1.5575e-20
C51	a_194_136##7	A1#3	4.04505e-17
C52	VGND#9	a_272_110##3	7.49876e-19
C53	a_34_392#	VPWR#7	6.22464e-17
C54	a_194_136##7	A2#2	5.41552e-18
C55	VGND#9	A1#3	1.20567e-17
C56	a_34_392##2	a_34_392#	2.89198e-18
C57	a_34_392##2	VPWR#7	6.42603e-17
C58	VGND#9	A2#2	3.80214e-17
C59	a_194_136#	X#1	9.48605e-18
C60	VGND#4	A1#2	4.5674e-20
C61	B1_N#1	a_194_136##3	2.86194e-17
C62	VPWR#6	a_194_136#	4.49311e-17
C63	X#1	B1_N#3	1.04388e-18
C64	B1_N#5	a_194_136##2	2.09225e-17
C65	a_272_110##7	a_194_136#	1.93588e-18
C66	B1_N#3	VPWR#6	1.80469e-17
C67	B1_N#4	a_194_136##2	4.23552e-18
C68	X#1	a_272_110#	3.31992e-19
C69	a_194_136##5	a_194_136#	2.09611e-18
C70	a_272_110##3	B1_N#1	1.777e-18
C71	VGND#4	A2#3	2.27272e-18
C72	a_272_110##7	B1_N#3	5.0509e-17
C73	VPWR#6	a_272_110#	1.886e-18
C74	B1_N#5	B1_N#2	1.26436e-17
C75	a_34_392#	a_194_136#	1.93753e-19
C76	a_194_136##5	B1_N#3	1.67617e-17
C77	B1_N#4	B1_N#2	1.17747e-17
C78	a_272_110##7	a_272_110#	1.19387e-18
C79	VPWR#6	A1#1	1.73427e-19
C80	a_34_392#	B1_N#3	6.18915e-19
C81	A1#3	a_272_110##3	1.93807e-17
C82	a_194_136##5	a_272_110#	2.42011e-17
C83	a_272_110##4	B1_N#5	1.60616e-17
C84	a_272_110##4	B1_N#4	1.15795e-17
C85	VGND#3	a_272_110##5	1.96638e-17
C86	a_34_392#	a_272_110#	5.70094e-17
C87	a_194_136##2	X#3	5.09867e-17
C88	a_194_136##5	A1#1	6.1878e-19
C89	VPWR#7	a_272_110#	8.67813e-19
C90	a_194_136##2	VGND#7	8.31061e-18
C91	A2#2	A1#3	4.69916e-17
C92	a_34_392#	A1#1	6.25869e-17
C93	a_194_136##5	A2#1	5.60672e-19
C94	X#3	B1_N#2	1.90879e-18
C95	A1#1	VPWR#7	2.39388e-17
C96	a_34_392#	A2#1	2.05218e-18
C97	a_34_392##2	A1#1	2.01028e-18
C98	a_272_110##5	B1_N#2	3.83516e-18
C99	A2#1	VPWR#7	3.02652e-17
C100	a_272_110##4	X#3	2.59871e-18
C101	a_34_392##2	A2#1	5.47348e-17
C102	a_194_136##5	VPWR#3	2.47743e-17
C103	a_194_136##7	B1_N#2	4.91798e-20
C104	a_194_136##2	X#1	2.24392e-17
C105	a_34_392#	VPWR#3	5.06338e-18
C106	a_272_110##4	VGND#8	2.11937e-19
C107	a_194_136##2	VPWR#6	4.07485e-17
C108	a_194_136##7	a_272_110##4	5.34693e-17
C109	a_272_110##7	a_194_136##2	1.24483e-17
C110	a_194_136##5	a_194_136##2	1.2684e-18
C111	B1_N#3	a_194_136#	2.78581e-17
C112	A1#2	a_194_136##7	2.02554e-17
C113	a_272_110##7	B1_N#2	2.13632e-18
C114	a_272_110##5	A2#3	5.875e-19
C115	a_272_110#	a_194_136#	3.87856e-19
C116	a_194_136##5	B1_N#2	5.27966e-19
C117	VGND#8	A2#3	2.00757e-18
C118	VGND#9	A1#2	1.34421e-17
C119	a_272_110#	B1_N#3	3.49572e-18
C120	a_194_136##5	a_272_110##4	2.37425e-17
C121	VGND#3	a_272_110##3	3.05557e-20
C122	VGND#9	A2#3	6.85458e-18
C123	A1#1	a_272_110#	4.18833e-17
C124	B1_N#2	a_194_136##3	5.74064e-18
C125	a_194_136##5	A1#2	1.02712e-18
C126	A1#2	a_34_392#	2.85716e-17
C127	a_272_110##4	a_194_136##3	1.22011e-19
C128	A1#2	VPWR#7	9.59398e-19
C129	a_272_110##3	B1_N#2	1.29099e-19
C130	A2#1	A1#1	3.74401e-17
C131	A1#2	a_34_392##2	1.71e-17
C132	a_272_110##3	a_272_110##4	9.57955e-18
C133	VPWR#3	a_272_110#	5.39999e-18
C134	a_194_136##2	a_194_136#	1.51773e-17
C135	a_34_392##2	A2#3	1.72877e-18
C136	a_194_136##2	B1_N#3	2.37694e-17
C137	A2#3	B1_N#1	1.53834e-19
C138	a_194_136##2	a_272_110#	2.48763e-19
C139	A2#2	A1#2	2.3659e-17
C140	a_272_110##4	a_194_136#	2.22759e-19
C141	A2#3	A1#3	8.75896e-18
C142	a_272_110##2	VNB	1.86331e-17
C143	a_272_110##4	B1_N#3	6.41668e-18
C144	a_272_110#	a_272_110##4	3.04522e-18
C145	VGND#9	a_122_136#	3.02956e-18
C146	A1#2	a_272_110#	8.22799e-18
C147	A1	a_194_136##7	3.31354e-17
C148	A2#1	A1#2	2.08676e-17
C149	VPWR#3	a_272_110##4	5.59557e-19
C150	B1_N#2	a_194_136##2	3.24287e-17
C151	A1#3	a_272_110##2	1.04464e-18
C152	VGND#3	a_272_110##4	2.47429e-18
C153	A1	a_194_136##5	1.01123e-17
C154	A1	a_34_392#	2.21601e-17
C155	a_272_110##4	a_194_136##2	6.38903e-18
C156	a_272_110##4	B1_N#2	3.45912e-17
C157	A1#3	a_122_136#	4.58831e-18
C158	A2#2	a_122_136#	1.07137e-17
C159	A2	VGND#9	4.97784e-17
C160	X#3	X	4.28749e-18
C161	VPWR	B1_N#5	2.7534e-18
C162	VGND	VGND#4	3.90628e-17
C163	X	X#1	8.47968e-18
C164	A2	a_34_392##2	3.98923e-19
C165	VPWR#6	X	2.73139e-17
C166	A1	B1_N#3	8.88149e-20
C167	A1	a_272_110#	2.02013e-18
C168	VGND	B1_N#4	5.4602e-18
C169	A2	A2#2	3.14612e-18
C170	VGND#4	VNB	2.81565e-17
C171	VPWR	a_272_110##7	5.37207e-18
C172	VGND	X#3	2.26217e-17
C173	VPWR	a_194_136##5	2.38167e-17
C174	VGND	a_272_110##5	2.6884e-17
C175	VPWR	a_34_392#	1.70494e-17
C176	VGND	a_194_136##7	1.72113e-17
C177	VPWR	a_34_392##2	1.75937e-17
C178	VGND	VGND#9	5.4936e-18
C179	B1_N#5	VNB	9.9488e-19
C180	X	a_194_136#	1.75655e-17
C181	B1_N#4	VNB	2.77015e-19
C182	A1	a_272_110##4	4.9445e-19
C183	VGND	a_272_110##7	2.72195e-18
C184	A1	A1#2	5.05128e-18
C185	X#3	VNB	6.40015e-17
C186	VGND#7	VNB	1.31812e-18
C187	VGND	a_34_392##2	3.84219e-18
C188	a_272_110##5	VNB	2.43403e-17
C189	VPWR	a_194_136#	4.40636e-18
C190	VGND#8	VNB	9.65747e-18
C191	VGND	a_194_136##3	2.42653e-18
C192	VPWR	B1_N#3	6.54029e-18
C193	a_194_136##7	VNB	6.33764e-18
C194	VGND	B1_N#1	1.31495e-18
C195	VPWR	a_272_110#	6.63774e-18
C196	VGND	a_272_110##3	3.69932e-18
C197	VGND#9	VNB	3.17625e-17
C198	X#1	VNB	1.8694e-17
C199	VGND	A1#3	7.31457e-18
C200	VPWR	A1#1	1.00717e-18
C201	VPWR#6	VNB	7.76743e-18
C202	VGND	A2#2	5.1569e-20
C203	VPWR	A2#1	1.8045e-18
C204	a_272_110##7	VNB	7.19356e-18
C205	a_194_136##2	X	4.70113e-17
C206	a_194_136##5	VNB	2.6351e-17
C207	a_34_392#	VNB	4.26816e-18
C208	VPWR#7	VNB	4.95283e-18
C209	VPWR	VPWR#3	2.64766e-17
C210	A2	A2#3	2.71464e-17
C211	a_34_392##2	VNB	5.27758e-17
C212	a_194_136##3	VNB	3.38245e-17
C213	B1_N#1	VNB	4.0584e-17
C214	VPWR	a_194_136##2	7.08794e-18
C215	a_272_110##3	VNB	3.05522e-17
C216	A1#3	VNB	2.73002e-17
C217	A2#2	VNB	4.35052e-17
C218	VPWR	a_272_110##4	1.57078e-18
C219	a_194_136#	VNB	3.77055e-17
C220	VGND	VGND#3	1.27467e-17
C221	VPWR	A1#2	2.06817e-18
C222	B1_N#3	VNB	4.11142e-17
C223	VGND	a_194_136##2	3.95607e-18
C224	a_272_110#	VNB	4.2324e-17
C225	A1#1	VNB	2.9245e-17
C226	VGND	B1_N#2	3.32079e-19
C227	A2#1	VNB	5.92613e-17
C228	VGND	a_272_110##4	7.62441e-18
C229	VGND	A1#2	2.96102e-18
C230	VPWR#3	VNB	2.07408e-16
C231	VGND#3	VNB	1.90084e-16
C232	VGND	A2#3	4.14219e-18
C233	a_194_136##2	VNB	4.87667e-17
C234	B1_N#2	VNB	4.14063e-17
C235	a_272_110##4	VNB	7.1115e-17
C236	A1#2	VNB	3.46805e-17
C237	A2#3	VNB	6.76225e-17
C238	VPWR	A1	1.21348e-18
C239	VGND	A1	1.28579e-18
C240	VPWR	X	1.90114e-17
C241	VGND	A2	1.4998e-17
C242	VGND	X	1.54493e-18
C243	A2	VNB	2.39611e-17
C244	X	VNB	4.73999e-17
C245	VPWR	VNB	7.27741e-17
C246	VGND	VNB	7.40677e-17
C247	VGND#2	B1_N#4	1.08315e-18
C248	VGND	VGND#5	4.65815e-17
C249	VGND#2	B1_N#2	1.58794e-19
C250	VPWR#4	A1#1	5.02627e-18
C251	VPWR#2	a_194_136#	6.20051e-18
C252	a_34_392#	VPWR#4	1.4752e-17
C253	VPWR#3	VPWR#2	5.92498e-17
C254	VGND#2	a_272_110##5	1.33583e-17
C255	VGND#5	A1#2	4.28706e-19
C256	VPWR#4	a_272_110#	4.5529e-19
C257	VGND#2	B1_N#1	1.15349e-17
C258	VGND#3	VGND#5	4.92607e-17
C259	VGND#2	a_194_136##2	5.29367e-19
C260	VGND#5	a_194_136##7	3.45061e-18
C261	VGND#5	VGND#4	3.60022e-18
C262	VPWR#2	VNB	5.42358e-17
C263	VGND#5	B1_N#1	2.35485e-19
C264	VGND#2	a_194_136##3	9.0451e-18
C265	VPWR#4	VNB	5.18308e-17
C266	VGND#3	VGND#2	5.96125e-17
C267	VPWR#3	VPWR#4	5.76849e-17
C268	a_194_136##5	VPWR#2	2.474e-18
C269	VPWR#2	A1#1	2.81916e-20
C270	VGND#5	VGND#8	3.54853e-18
C271	VGND#2	X#3	2.72704e-17
C272	VGND#2	VNB	5.60362e-17
C273	VPWR#2	B1_N#2	1.30779e-19
C274	VPWR	VPWR#2	5.91918e-17
C275	VPWR#2	a_272_110#	1.93684e-19
C276	a_34_392##2	VPWR#4	2.11181e-17
C277	VGND#5	VNB	4.919e-17
C278	VGND#5	VGND#9	9.20945e-19
C279	VPWR	VPWR#4	5.1703e-17
C280	VGND#5	A2	5.33279e-17
C281	a_194_136##2	VPWR#2	1.46473e-18
C282	VGND	VGND#2	5.25477e-17
C283	X	VPWR#2	2.13484e-17
C284	VPWR#4	A2#1	5.56759e-18
C285	VPWR#2	B1_N#3	4.56976e-18
C286	VGND#5	A1#3	2.77585e-18
C287	VGND#4	VGND#2	9.47785e-19
C288	VGND#5	A2#3	1.73988e-17
*
*
.ENDS sky130_fd_sc_hs__a21bo_1
*
