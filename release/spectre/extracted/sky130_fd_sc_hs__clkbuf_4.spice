* Extracted by Quantus, converted by sky130cad/quantus.py
*
*
*
*                       LINUX           Wed Nov 18 08:22:26 2026
*
*
*
*  PROGRAM  advgen
*
*  Name           : advgen - Quantus - (64-bit)
*  Version        : 25.1.0-p047
*  Build Date     : Thu Dec 11 23:20:30 PST 2025
*
*  HSPICE LIBRARY
*
*  OPERATING_TEMPERATURE 150
*  QRC_TECH_DIR <path>/tech
*
*
*

*
.SUBCKT sky130_fd_sc_hs__clkbuf_4 VPB VNB VGND VPWR X A
*
*
*  caps2d version: 10
*
*
*       TRANSISTOR CARDS
*
*
XM4 VGND#5 a_83_270##12 X#4 VNB sky130_fd_pr__nfet_01v8_lvt l=0.15 w=0.42 ad=0.1197 as=0.1176 pd=1.41 ps=1.4
XM3 X#4 a_83_270##10 VGND#7 VNB sky130_fd_pr__nfet_01v8_lvt l=0.15 w=0.42 ad=0.1176 as=0.1176 pd=1.4 ps=1.4
XM7 VGND#7 a_83_270##8 X#7 VNB sky130_fd_pr__nfet_01v8_lvt l=0.15 w=0.42 ad=0.1176 as=0.1344 pd=1.4 ps=1.48
XM8 X#7 a_83_270##7 VGND#6 VNB sky130_fd_pr__nfet_01v8_lvt l=0.15 w=0.42 ad=0.1344 as=0.1596 pd=1.48 ps=1.6
XM2 VGND#6 A#1 a_83_270##13 VNB sky130_fd_pr__nfet_01v8_lvt l=0.15 w=0.42 ad=0.1596 as=0.126 pd=1.6 ps=1.44
XM0 VPWR#5 a_83_270##6 X#6 VPB sky130_fd_pr__pfet_01v8 l=0.15 w=1.12 ad=0.3304 as=0.336 pd=2.83 ps=2.84
XM1 VPWR#7 a_83_270##11 X#6 VPB sky130_fd_pr__pfet_01v8 l=0.15 w=1.12 ad=0.336 as=0.336 pd=2.84 ps=2.84
XM5 X#1 a_83_270##9 VPWR#7 VPB sky130_fd_pr__pfet_01v8 l=0.15 w=1.12 ad=0.336 as=0.336 pd=2.84 ps=2.84
XM6 X#1 a_83_270# VPWR#6 VPB sky130_fd_pr__pfet_01v8 l=0.15 w=1.12 ad=0.336 as=0.392 pd=2.84 ps=2.94
XM9 VPWR#6 A#3 a_83_270##16 VPB sky130_fd_pr__pfet_01v8 l=0.15 w=1.12 ad=0.392 as=0.3304 pd=2.94 ps=2.83
*
*
*       RESISTOR AND CAP/DIODE CARDS
*
Rg1	a_83_270#	a_83_270##2	449.655212
Rg2	a_83_270##2	a_83_270##3	72.035599
Rg3	a_83_270##3	a_83_270##4	76.244972
Rg4	a_83_270##4	a_83_270##5	66.386436
Rg5	a_83_270##5	a_83_270##6	449.655212
Rg6	a_83_270##2	a_83_270##7	489.373627
Rg7	a_83_270##3	a_83_270##8	486.376709
Rg8	a_83_270##3	a_83_270##9	446.658295
Rg9	a_83_270##4	a_83_270##10	486.379211
Rg10	a_83_270##4	a_83_270##11	446.660797
Rg11	a_83_270##5	a_83_270##12	489.373627
Rg12	A#1	A#2	331.833557
Rg13	A#2	A#3	561.141479
Rf1	X#1	X#2	77.775970
Rf2	X#2	X#3	67.930099
Rf3	X#3	X	6.000568
Rf4	X	X#5	13.581708
Rf5	X#5	X	0.984182
Rf6	X#2	X#6	26.029509
Rf7	X#3	X#7	81.739563
Rf8	X#4	X#5	15.000000
Rf9	A#4	A	0.818971
Rf10	A#2	A#6	161.051773
Rf11	A#4	A#6	6.298763
Rf12	a_83_270##13	a_83_270##14	80.535858
Rf13	a_83_270##14	a_83_270##3	116.674637
Rf14	a_83_270##14	a_83_270##16	30.903008
Rf16	VGND#2	VGND#3	47.093037
Rf17	VGND#3	VGND#4	20.917435
Rf18	VGND#4	VGND#5	106.381432
Rf19	VGND#2	VGND#6	34.507496
Rf20	VGND#4	VGND#7	52.242409
Rf22	VPWR#2	VPWR#3	49.707153
Rf23	VPWR#3	VPWR#4	21.947966
Rf24	VPWR#4	VPWR#5	114.076828
Rf25	VPWR#2	VPWR#6	45.701672
Rf26	VPWR#4	VPWR#7	39.504013
Re1	VPWR#3	VPWR	1.637070
Re2	VGND	VGND#3	1.637131
*
*       CAPACITOR CARDS
*
*
C1	VGND	VNB	5.47278e-17
C2	VPWR	VNB	5.64616e-17
C3	X	VNB	2.32727e-18
C4	A	VNB	1.72369e-18
C5	VGND	X	1.61605e-17
C6	a_83_270##3	VNB	4.32272e-17
C7	VGND	A	1.92851e-18
C8	A#2	VNB	5.56175e-17
C9	VGND#3	VNB	1.51168e-16
C10	a_83_270##2	X#1	1.52783e-18
C11	VPWR#3	VNB	1.50923e-16
C12	VGND	a_83_270##3	8.12845e-18
C13	a_83_270##6	VNB	3.91946e-17
C14	a_83_270##11	VNB	2.8754e-17
C15	a_83_270##9	VNB	3.28376e-17
C16	VGND	VGND#3	9.0344e-18
C17	a_83_270#	VNB	3.72485e-17
C18	A#3	VNB	4.59136e-17
C19	VPWR	a_83_270##3	6.67711e-18
C20	a_83_270##12	VNB	4.12416e-17
C21	a_83_270##10	VNB	2.93608e-17
C22	a_83_270##8	VNB	3.16718e-17
C23	a_83_270##7	VNB	3.56366e-17
C24	VPWR	VPWR#3	1.01288e-17
C25	A#1	VNB	3.46031e-17
C26	VPWR#5	VNB	8.09192e-17
C27	X#6	VNB	2.24388e-18
C28	VPWR#7	VNB	4.09278e-19
C29	a_83_270##3	A	1.56097e-17
C30	VPWR	a_83_270##6	4.15359e-18
C31	X#1	VNB	2.14836e-18
C32	VPWR#6	VNB	2.99545e-18
C33	VGND	a_83_270##12	3.85855e-18
C34	VPWR	a_83_270##11	7.54331e-19
C35	A	A#2	4.87312e-18
C36	a_83_270##16	VNB	4.55637e-17
C37	VGND#5	VNB	5.70005e-17
C38	VGND	a_83_270##10	4.34155e-19
C39	VPWR	a_83_270##9	2.21603e-19
C40	VGND#7	VNB	5.18547e-18
C41	VGND	a_83_270##8	2.03239e-20
C42	X#7	VNB	4.11483e-18
C43	VPWR	a_83_270#	2.70058e-18
C44	VGND	a_83_270##7	6.17126e-19
C45	VGND#6	VNB	8.99153e-18
C46	VPWR	A#3	1.13425e-18
C47	VGND	A#1	1.84085e-18
C48	a_83_270##13	VNB	3.56056e-17
C49	X#2	VNB	7.05051e-18
C50	VGND	VPWR#5	3.56272e-18
C51	X#3	VNB	1.86512e-17
C52	A#6	VNB	9.76916e-19
C53	a_83_270##14	VNB	3.99903e-17
C54	a_83_270##3	A#2	2.58567e-18
C55	VGND	VGND#5	2.869e-17
C56	VGND#4	VNB	2.59131e-17
C57	VGND#3	a_83_270##3	5.56893e-20
C58	VPWR	VPWR#5	3.06552e-17
C59	X	a_83_270##12	1.47705e-17
C60	VPWR#4	VNB	2.33265e-17
C61	VGND	X#7	1.65836e-17
C62	VPWR	X#6	1.4886e-17
C63	X	a_83_270##10	1.89501e-17
C64	VGND	a_83_270##13	1.67381e-17
C65	VPWR#3	a_83_270##3	2.04712e-20
C66	X	a_83_270##8	9.74796e-19
C67	VGND	X#2	5.37626e-19
C68	VPWR	X#1	1.70204e-17
C69	a_83_270##5	a_83_270##4	1.05804e-17
C70	VGND	X#3	1.51982e-18
C71	VPWR	a_83_270##16	2.11628e-17
C72	VGND	A#6	2.00142e-18
C73	VGND	a_83_270##14	3.1621e-18
C74	VGND	VGND#4	3.03703e-17
C75	VPWR	X#2	1.71305e-18
C76	VGND#5	X	3.8252e-17
C77	X	X#4	2.65877e-19
C78	X	VGND#7	3.75808e-17
C79	X	X#7	3.1637e-19
C80	a_83_270##14	a_83_270##2	4.87981e-19
C81	VPWR	a_83_270##14	1.10736e-18
C82	VPWR#3	a_83_270##9	5.70081e-18
C83	VPWR	VPWR#4	3.31692e-17
C84	X#7	A	6.46388e-18
C85	a_83_270##6	a_83_270##11	4.64644e-17
C86	VGND#6	A	1.35067e-17
C87	X#3	A	1.46893e-18
C88	a_83_270##7	A#2	5.01642e-18
C89	VGND#4	X	1.68068e-17
C90	a_83_270##11	a_83_270##9	4.6775e-17
C91	VGND#3	a_83_270##8	3.27253e-18
C92	a_83_270##3	VPWR#7	7.27127e-19
C93	a_83_270##3	X#1	5.72353e-17
C94	A	a_83_270##14	1.72595e-17
C95	a_83_270##9	a_83_270#	4.55998e-17
C96	a_83_270##2	VNB	3.15806e-17
C97	a_83_270##4	VNB	3.15796e-17
C98	a_83_270##5	VNB	5.1973e-17
C99	VPWR#6	A#2	6.90533e-19
C100	VGND#7	a_83_270##3	3.12676e-19
C101	VPWR#3	VPWR#5	2.44223e-17
C102	X#7	a_83_270##3	5.14807e-17
C103	a_83_270#	A#3	3.83185e-17
C104	VGND#6	a_83_270##3	6.12044e-19
C105	a_83_270##13	a_83_270##3	1.20245e-20
C106	X#2	a_83_270##3	5.36919e-17
C107	X#1	VPWR#3	1.5126e-17
C108	X#7	A#2	3.20272e-18
C109	VGND#3	VGND#5	2.46828e-17
C110	X#3	a_83_270##3	4.89535e-17
C111	VPWR#5	a_83_270##6	3.10921e-17
C112	VGND#6	A#2	4.16473e-18
C113	a_83_270##13	A#2	5.47452e-18
C114	X#6	a_83_270##6	4.48917e-17
C115	VGND#3	X#7	1.41458e-17
C116	VPWR#5	a_83_270##11	1.16752e-18
C117	VPWR#7	a_83_270##6	2.11079e-18
C118	X#3	A#2	1.70385e-19
C119	a_83_270##3	a_83_270##14	2.58924e-18
C120	a_83_270##11	X#6	1.57082e-17
C121	X#1	a_83_270##6	2.09026e-19
C122	VPWR#7	a_83_270##11	4.33531e-17
C123	A#6	A#2	1.13971e-17
C124	X#6	a_83_270##9	1.30999e-19
C125	a_83_270##12	a_83_270##10	3.37556e-17
C126	X#1	a_83_270##11	1.84101e-18
C127	a_83_270##14	A#2	1.65114e-17
C128	a_83_270##9	VPWR#7	2.18779e-17
C129	VPWR#6	a_83_270##11	1.72497e-19
C130	X#1	a_83_270##9	6.86764e-17
C131	VPWR#7	a_83_270#	3.71489e-19
C132	a_83_270##10	a_83_270##8	3.53521e-17
C133	VPWR#6	a_83_270##9	6.87375e-19
C134	X#1	a_83_270#	6.56997e-17
C135	VPWR#7	A#3	2.56016e-19
C136	a_83_270#	VPWR#6	3.37597e-17
C137	X#1	A#3	1.74392e-18
C138	a_83_270##8	a_83_270##7	2.86095e-17
C139	a_83_270##16	a_83_270#	1.43067e-18
C140	VGND#3	VGND#4	3.13379e-17
C141	X#2	a_83_270##6	9.84934e-18
C142	A#3	VPWR#6	3.06259e-17
C143	a_83_270##16	A#3	4.10542e-17
C144	a_83_270##7	A#1	1.97975e-17
C145	X#2	a_83_270##11	1.76885e-17
C146	a_83_270##2	A#3	4.66307e-18
C147	X#2	a_83_270##9	4.43872e-19
C148	VPWR#3	VPWR#4	3.1758e-17
C149	a_83_270##14	a_83_270##6	8.81753e-20
C150	VGND#5	a_83_270##12	1.91752e-17
C151	X#2	a_83_270#	9.54195e-20
C152	a_83_270##12	X#4	8.76435e-18
C153	a_83_270##14	a_83_270##11	7.399e-20
C154	VPWR#5	X#6	6.41126e-17
C155	VGND#5	a_83_270##10	1.34033e-18
C156	VGND#7	a_83_270##12	4.74247e-19
C157	X#2	A#3	8.29692e-20
C158	a_83_270##10	X#4	8.47661e-18
C159	VPWR#5	VPWR#7	2.2895e-18
C160	VGND#5	a_83_270##8	2.73732e-19
C161	a_83_270##14	a_83_270##9	1.21359e-19
C162	a_83_270##10	VGND#7	1.21813e-17
C163	VPWR#4	a_83_270##6	3.36615e-18
C164	X#6	VPWR#7	5.31026e-17
C165	X#7	a_83_270##10	1.65759e-18
C166	a_83_270##8	VGND#7	9.9463e-18
C167	X#6	X#1	8.36788e-19
C168	a_83_270##14	a_83_270#	3.53087e-19
C169	VGND#6	a_83_270##10	2.03624e-19
C170	VGND#7	a_83_270##4	4.64129e-19
C171	X#7	a_83_270##8	3.72108e-17
C172	VPWR#4	a_83_270##11	5.62736e-18
C173	X#1	VPWR#7	5.98309e-17
C174	VGND#7	a_83_270##7	2.22495e-19
C175	X#3	a_83_270##12	7.70074e-18
C176	VGND#4	a_83_270##4	3.35512e-20
C177	VGND#6	a_83_270##8	1.55141e-18
C178	a_83_270##14	A#3	1.59282e-17
C179	VGND#5	VPWR#5	6.49499e-18
C180	X#7	a_83_270##7	1.27792e-17
C181	VPWR#7	VPWR#6	2.00319e-18
C182	a_83_270##13	a_83_270##8	2.56523e-19
C183	VGND#7	A#1	1.41565e-19
C184	X#3	a_83_270##10	1.20365e-17
C185	VPWR#4	a_83_270##9	1.81023e-18
C186	a_83_270##7	VGND#6	1.70893e-17
C187	X#1	VPWR#6	7.91772e-17
C188	VGND#4	a_83_270##5	3.85385e-20
C189	X#7	A#1	1.39548e-18
C190	A	a_83_270##2	6.98862e-18
C191	A	a_83_270##4	1.41726e-19
C192	a_83_270##13	a_83_270##7	1.83317e-18
C193	A	a_83_270##5	9.3134e-20
C194	X#3	a_83_270##8	7.50285e-19
C195	A#1	VGND#6	1.67288e-17
C196	X#7	a_83_270##2	4.1936e-18
C197	VPWR#4	a_83_270#	3.00302e-19
C198	a_83_270##13	A#1	2.38037e-17
C199	VPWR#6	a_83_270##16	8.36788e-17
C200	VPWR#4	A#3	1.31769e-19
C201	VPWR#5	X#2	4.15607e-17
C202	VGND#4	a_83_270##12	3.10327e-18
C203	X#2	X#6	1.06008e-18
C204	VGND#4	a_83_270##10	5.26622e-18
C205	X#2	VPWR#7	2.12254e-17
C206	VGND#5	VGND#7	1.3367e-18
C207	VGND#4	a_83_270##8	4.4166e-18
C208	X#2	X#1	1.76369e-18
C209	VGND#4	a_83_270##7	4.02482e-19
C210	VGND#7	X#7	3.9266e-17
C211	VGND#4	A#1	1.84639e-19
C212	VGND#7	VGND#6	1.39509e-18
C213	VPWR#4	a_83_270##4	2.01982e-20
C214	X#7	VGND#6	4.26946e-17
C215	X#7	a_83_270##13	3.95354e-18
C216	VPWR#4	a_83_270##5	2.04712e-20
C217	a_83_270##3	a_83_270##2	3.08408e-17
C218	a_83_270##3	a_83_270##4	2.94825e-17
C219	a_83_270##14	VPWR#6	3.55782e-17
C220	VPWR#5	VPWR#4	9.47412e-19
C221	a_83_270##3	a_83_270##5	9.89537e-19
C222	VGND#7	X#3	1.61725e-17
C223	VGND#6	a_83_270##13	3.00302e-17
C224	a_83_270##14	a_83_270##16	8.36726e-19
C225	X#3	X#7	2.87896e-18
C226	X#2	a_83_270##4	1.99619e-18
C227	X#6	VPWR#4	1.49621e-17
C228	X#2	a_83_270##5	9.81065e-18
C229	a_83_270##2	A#2	3.57982e-17
C230	X#3	a_83_270##2	1.13016e-19
C231	X#3	X#2	2.58262e-18
C232	X#3	a_83_270##4	1.33635e-17
C233	VGND#6	A#6	5.82685e-18
C234	VGND#5	VGND#4	1.23091e-18
C235	X#3	a_83_270##5	1.77277e-17
C236	a_83_270##13	A#6	1.93335e-17
C237	VGND#6	a_83_270##14	2.66939e-18
C238	VGND#3	a_83_270##2	3.35512e-20
C239	VGND#3	a_83_270##5	2.54513e-20
C240	a_83_270##13	a_83_270##14	3.21338e-18
C241	VGND#4	X#7	1.73909e-20
C242	VPWR#3	a_83_270##2	2.01982e-20
C243	VGND#4	VGND#6	9.0681e-19
C244	a_83_270##5	X#6	1.59832e-19
C245	A#6	a_83_270##14	3.94069e-17
C246	VGND#4	X#3	3.0608e-19
C247	a_83_270##4	VPWR#7	5.71005e-19
C248	X#2	VPWR#4	3.00284e-19
C249	X#1	VPWR#2	2.01066e-18
C250	VPWR#2	a_83_270#	9.80146e-18
C251	VGND#2	A#6	6.10794e-19
C252	VPWR#2	VNB	4.36292e-17
C253	VGND#2	a_83_270##3	9.02287e-19
C254	a_83_270##3	VPWR#2	4.50068e-19
C255	VGND#2	a_83_270##8	5.83499e-19
C256	VPWR#2	a_83_270##9	5.45681e-19
C257	VPWR#3	VPWR#2	4.85167e-17
C258	a_83_270##16	VPWR#2	2.33586e-17
C259	VGND#3	VGND#2	5.03302e-17
C260	VGND	VGND#2	5.81698e-17
C261	VGND#2	A#1	7.33419e-18
C262	VPWR#2	a_83_270##11	8.74044e-20
C263	VPWR	VPWR#2	4.80984e-17
C264	VGND#2	a_83_270##10	8.4955e-20
C265	VGND#2	X#7	2.35844e-18
C266	VPWR#2	A#3	4.99025e-18
C267	VGND#4	VGND#2	1.27745e-18
C268	a_83_270##14	VPWR#2	9.89692e-20
C269	VGND#2	VNB	4.66851e-17
C270	VGND#2	a_83_270##7	7.64447e-18
C271	VPWR#4	VPWR#2	7.06672e-19
C272	VGND#2	a_83_270##13	1.45737e-17
*
*
.ENDS sky130_fd_sc_hs__clkbuf_4
*
