* Extracted by Quantus, converted by sky130cad/quantus.py
*
*
*
*                       LINUX           Wed Nov 18 09:01:47 2026
*
*
*
*  PROGRAM  advgen
*
*  Name           : advgen - Quantus - (64-bit)
*  Version        : 25.1.0-p047
*  Build Date     : Thu Dec 11 23:20:30 PST 2025
*
*  HSPICE LIBRARY
*
*  OPERATING_TEMPERATURE 150
*  QRC_TECH_DIR <path>/tech
*
*
*

*
.SUBCKT sky130_fd_sc_hs__o31a_2 VNB VPB VGND VPWR X A3 B1 A1 A2
*
*
*  caps2d version: 10
*
*
*       TRANSISTOR CARDS
*
*
XM7 VGND#5 a_55_264##5 X#1 VNB sky130_fd_pr__nfet_01v8_lvt l=0.15 w=0.74 ad=0.2627 as=0.2072 pd=2.19 ps=2.04
XM8 X#1 a_55_264##4 VGND#7 VNB sky130_fd_pr__nfet_01v8_lvt l=0.15 w=0.74 ad=0.2072 as=0.3108 pd=2.04 ps=2.32
XM2 VGND#7 A1#3 a_328_74##2 VNB sky130_fd_pr__nfet_01v8_lvt l=0.15 w=0.74 ad=0.3108 as=0.2553 pd=2.32 ps=2.17
XM10 a_328_74##2 A2#3 VGND#6 VNB sky130_fd_pr__nfet_01v8_lvt l=0.15 w=0.74 ad=0.2553 as=0.3108 pd=2.17 ps=2.32
XM9 VGND#6 A3#3 a_328_74# VNB sky130_fd_pr__nfet_01v8_lvt l=0.15 w=0.74 ad=0.3108 as=0.3663 pd=2.32 ps=2.47
XM11 a_328_74# B1#4 a_55_264##7 VNB sky130_fd_pr__nfet_01v8_lvt l=0.15 w=0.74 ad=0.3663 as=0.2627 pd=2.47 ps=2.19
XM0 VPWR#4 a_55_264##6 X#2 VPB sky130_fd_pr__pfet_01v8 l=0.15 w=1.12 ad=0.3304 as=0.3976 pd=2.83 ps=2.95
XM3 X#2 a_55_264# VPWR#5 VPB sky130_fd_pr__pfet_01v8 l=0.15 w=1.12 ad=0.3976 as=0.5268 pd=2.95 ps=3.23
XM5 VPWR#5 A1#1 a_346_392# VPB sky130_fd_pr__pfet_01v8 l=0.15 w=1 ad=0.5268 as=0.27 pd=3.23 ps=2.54
XM1 a_346_392# A2#1 a_430_392# VPB sky130_fd_pr__pfet_01v8 l=0.15 w=1 ad=0.27 as=0.42 pd=2.54 ps=2.84
XM4 a_430_392# A3#1 a_55_264##8 VPB sky130_fd_pr__pfet_01v8 l=0.15 w=1 ad=0.42 as=0.39 pd=2.84 ps=2.78
XM6 a_55_264##8 B1#3 VPWR#1 VPB sky130_fd_pr__pfet_01v8 l=0.15 w=1 ad=0.39 as=0.445 pd=2.78 ps=2.89
*
*
*       RESISTOR AND CAP/DIODE CARDS
*
Rg1	a_55_264#	a_55_264##2	516.454041
Rg2	a_55_264##2	a_55_264##3	202.970047
Rg3	a_55_264##2	a_55_264##4	354.916412
Rg4	a_55_264##3	a_55_264##5	357.225159
Rg5	a_55_264##3	a_55_264##6	439.865051
Rg6	A1#1	A1#2	453.277618
Rg7	A1#2	A1#3	382.539734
Rg8	A2#1	A2#2	400.207520
Rg9	A2#2	A2#3	451.403168
Rg10	A3#1	A3#2	509.830780
Rg11	A3#2	A3#3	307.937683
Rg12	B1#1	B1#2	47.292805
Rg13	B1#2	B1#3	520.404358
Rg14	B1#2	B1#4	387.022156
Rf1	X#1	X#3	83.438316
Rf2	X#3	X	1.699060
Rf3	X#2	X#3	15.000000
Rf4	A1	A1#2	165.394180
Rf5	A2	A2#2	161.413818
Rf6	A3	A3#4	1.411932
Rf7	A3#5	A3#2	161.644730
Rf8	A3#4	A3#5	3.261114
Rf9	a_328_74#	a_328_74##2	92.837486
Rf10	B1#1	B1#6	160.782516
Rf11	B1#7	B1	0.549716
Rf12	B1#6	B1#7	7.873454
Rf13	a_55_264##7	a_55_264##9	123.188980
Rf14	a_55_264##9	a_55_264##3	407.106049
Rf15	a_55_264##8	a_55_264##9	5.000000
Rf16	VPWR#1	VPWR#2	151.873550
Rf17	VPWR#2	VPWR#3	42.859596
Rf18	VPWR#3	VPWR#4	108.054779
Rf19	VPWR#3	VPWR#5	25.850632
Rf21	VGND#2	VGND#3	28.618141
Rf22	VGND#3	VGND#4	46.727783
Rf23	VGND#4	VGND#5	104.232445
Rf24	VGND#2	VGND#6	29.274549
Rf25	VGND#4	VGND#7	33.306259
Re1	VPWR#2	VPWR	1.227783
Re2	VGND	VGND#3	1.227829
*
*       CAPACITOR CARDS
*
*
C1	A3#4	a_55_264##2	6.32687e-20
C2	a_55_264##7	B1#2	1.61799e-17
C3	B1#2	a_328_74#	1.10737e-18
C4	VGND#4	a_328_74##2	1.94492e-18
C5	a_55_264##7	B1#7	3.71126e-18
C6	VGND#4	X#1	1.49575e-17
C7	A3#2	B1#2	3.00627e-17
C8	VGND#5	VGND#4	9.5684e-19
C9	B1#6	a_55_264##7	5.8152e-17
C10	A3#5	a_55_264##7	1.91143e-17
C11	A3#4	a_55_264##7	1.43291e-17
C12	X#1	a_55_264##2	5.33033e-18
C13	a_328_74#	A3#4	2.49305e-17
C14	a_55_264##8	VPWR#3	4.58915e-17
C15	a_55_264##2	A1#2	1.99957e-17
C16	B1#7	VPWR#1	2.67523e-17
C17	a_55_264##8	B1#7	2.08036e-17
C18	X#1	A3#5	8.49447e-20
C19	a_55_264##7	a_328_74#	5.77566e-17
C20	VPWR#1	B1#2	7.13087e-18
C21	X#1	A3#4	2.32341e-18
C22	VPWR#3	VPWR#5	3.83934e-18
C23	a_55_264##3	a_55_264##2	1.22887e-17
C24	VGND#6	a_55_264##7	3.68326e-18
C25	a_328_74#	VGND#6	4.14762e-17
C26	a_328_74##2	a_55_264##7	5.40992e-18
C27	A3#5	a_55_264##8	1.14658e-17
C28	a_328_74##2	a_328_74#	2.49151e-18
C29	VPWR#4	VPWR#3	1.04897e-17
C30	a_55_264##8	B1#2	4.78179e-18
C31	a_328_74##2	VGND#6	4.4003e-17
C32	VGND#7	VGND#6	2.39306e-18
C33	VGND#7	a_328_74##2	6.91642e-17
C34	a_55_264##7	VPWR#1	5.36224e-19
C35	VGND#4	A1#3	4.70848e-18
C36	VGND#4	a_55_264##4	4.9143e-18
C37	X#1	VGND#7	7.52794e-17
C38	a_328_74#	a_55_264##8	4.61105e-18
C39	VGND#5	VGND#7	1.84033e-18
C40	VGND#5	X#1	7.00474e-17
C41	a_328_74##2	a_55_264##8	4.17064e-18
C42	A3#4	B1#4	1.14463e-18
C43	VGND#7	a_55_264##8	3.08687e-18
C44	A3#4	A2#3	2.7119e-18
C45	a_55_264##8	VPWR#1	1.19475e-16
C46	a_55_264##7	B1#4	3.2285e-17
C47	VPWR#3	B1#3	1.41607e-18
C48	A3#4	A1#3	3.3385e-19
C49	a_328_74#	B1#4	3.80574e-17
C50	a_55_264##7	A3#3	6.66601e-18
C51	VPWR#3	A3#1	2.04435e-18
C52	A3#4	a_55_264##4	1.76564e-19
C53	VGND#6	B1#4	1.8653e-18
C54	a_328_74#	A3#3	4.97379e-17
C55	a_55_264##7	A2#3	1.40579e-18
C56	a_328_74##2	B1#4	4.17028e-19
C57	A3#3	VGND#6	2.12042e-17
C58	VPWR#3	A2#1	3.95112e-18
C59	a_328_74#	A2#3	5.99381e-19
C60	a_55_264##7	A1#3	5.59046e-19
C61	a_328_74##2	A3#3	1.71396e-18
C62	a_55_264##8	VPWR#5	3.3761e-18
C63	VGND#6	A2#3	2.99871e-17
C64	VGND#5	VPWR#4	1.89666e-18
C65	a_328_74#	A1#3	2.25015e-19
C66	VGND#4	a_55_264##2	4.01705e-20
C67	VPWR#3	A1#1	2.31249e-17
C68	a_55_264##7	a_55_264##4	1.41432e-19
C69	a_328_74##2	A2#3	3.55478e-17
C70	VGND#6	A1#3	1.27756e-18
C71	X#1	A3#3	7.02991e-20
C72	VGND#7	A2#3	6.86557e-19
C73	a_328_74##2	A1#3	4.48329e-17
C74	VPWR#3	a_55_264#	2.12962e-17
C75	VGND#6	a_55_264##4	2.03103e-19
C76	X#1	A2#3	3.57189e-19
C77	A2	B1#2	6.85011e-19
C78	A1#3	VGND#7	2.27564e-17
C79	VPWR#3	a_55_264##6	5.49038e-18
C80	X#1	A1#3	8.32423e-19
C81	a_55_264##4	VGND#7	2.75797e-17
C82	VGND#5	A1#3	2.90158e-19
C83	X#1	a_55_264##4	4.59714e-17
C84	VGND#7	a_55_264##5	1.465e-18
C85	VGND#5	a_55_264##4	1.37281e-18
C86	X#1	a_55_264##5	4.08426e-17
C87	VGND#3	VGND#4	4.00148e-17
C88	VPWR#2	VPWR#3	4.51186e-17
C89	VGND#5	a_55_264##5	2.83311e-17
C90	A1	a_55_264##2	1.03688e-18
C91	A3#3	B1#4	1.61363e-17
C92	VPWR#1	B1#3	2.57573e-17
C93	a_55_264##8	B1#3	6.47838e-17
C94	VPWR#1	A3#1	1.12541e-18
C95	A2#3	A3#3	1.75935e-17
C96	a_55_264##8	A3#1	4.98712e-17
C97	VPWR#3	a_55_264##2	5.0888e-20
C98	VPWR#1	A2#1	4.22703e-19
C99	a_55_264##8	A2#1	2.7024e-17
C100	A1#3	A2#3	2.95438e-17
C101	VPWR#1	A1#1	2.27289e-19
C102	VGND#4	A1#2	4.13988e-19
C103	a_55_264##8	A1#1	1.80255e-17
C104	a_55_264##4	A1#3	2.27679e-17
C105	VPWR#3	A1#2	4.92636e-19
C106	a_55_264##8	a_55_264#	5.426e-19
C107	A3#5	A3#2	1.24618e-17
C108	VGND#4	a_55_264##3	4.0679e-20
C109	A3#4	A3#2	1.00185e-17
C110	A1#1	VPWR#5	2.63958e-17
C111	a_55_264##3	VPWR#3	2.66235e-17
C112	a_55_264##5	a_55_264##4	3.88741e-17
C113	A3#5	A2#2	3.01209e-18
C114	VGND#3	a_328_74##2	1.65338e-17
C115	a_55_264#	VPWR#5	2.17945e-17
C116	A3#4	A2#2	6.81451e-19
C117	a_55_264##7	A3#2	4.37259e-18
C118	a_55_264#	X#2	2.8609e-17
C119	VPWR#2	VPWR#1	4.40428e-17
C120	A1#2	A3#5	3.59507e-18
C121	A3#2	a_328_74#	3.54898e-18
C122	VPWR#4	a_55_264#	4.69793e-18
C123	VGND#3	VGND#5	2.98284e-17
C124	a_55_264##8	VPWR#2	1.68476e-17
C125	A3#4	A1#2	1.45905e-19
C126	a_55_264##6	X#2	2.91399e-17
C127	X	a_55_264##2	7.78301e-18
C128	a_55_264##7	A2#2	1.49222e-19
C129	VPWR#4	a_55_264##6	3.21076e-17
C130	a_55_264##2	A1#3	5.00674e-19
C131	VGND#6	A2#2	6.52946e-19
C132	X#1	A3#2	2.47121e-19
C133	a_328_74##2	A2#2	1.82213e-18
C134	VPWR#1	A3#2	7.25933e-20
C135	VPWR#2	VPWR#4	2.80334e-17
C136	A3#1	B1#3	3.33111e-17
C137	a_328_74##2	A1#2	2.38596e-17
C138	a_55_264##8	A3#2	4.3857e-18
C139	VGND#7	A1#2	1.22278e-17
C140	B1#7	B1#2	1.04707e-17
C141	X#1	A1#2	1.79262e-18
C142	VPWR	B1#2	3.32043e-19
C143	a_55_264##8	A2#2	1.26743e-18
C144	A2#1	A3#1	2.89299e-17
C145	VGND#7	a_55_264##3	3.92708e-18
C146	X#1	a_55_264##3	1.31463e-17
C147	a_55_264##8	A1#2	4.91786e-19
C148	VGND#3	A2#3	1.29992e-18
C149	a_55_264##3	VGND#5	4.48565e-17
C150	A1#1	A2#1	5.29455e-17
C151	A3#2	B1#4	7.66535e-19
C152	a_55_264#	A1#1	2.20195e-17
C153	A2#3	A3#2	2.87453e-18
C154	a_55_264##3	VPWR#5	1.55081e-18
C155	VPWR#2	A3#1	5.66707e-18
C156	VGND	B1#2	5.68857e-19
C157	a_55_264##3	X#2	5.17123e-18
C158	a_55_264##6	a_55_264#	3.78511e-17
C159	VPWR#2	A2#1	8.3946e-18
C160	a_55_264##3	VPWR#4	4.93697e-17
C161	a_55_264##8	a_430_392#	1.08834e-17
C162	A1#2	A2#3	2.58953e-18
C163	VPWR#2	A1#1	2.49736e-18
C164	A2	A3#5	8.79997e-18
C165	a_55_264##8	a_346_392#	6.18537e-18
C166	A2#2	A3#1	7.20747e-18
C167	A2	a_55_264##7	1.4095e-18
C168	a_328_74##2	A2	1.08867e-17
C169	A1#1	A2#2	3.19905e-18
C170	B1#6	B1#2	1.62432e-17
C171	a_55_264##3	A2#1	1.79412e-19
C172	a_55_264#	A1#2	6.16657e-18
C173	A2	a_55_264##8	5.02147e-17
C174	VPWR#2	A3#2	2.15197e-20
C175	a_55_264##3	A1#1	3.64694e-19
C176	a_55_264##3	a_55_264#	1.75721e-17
C177	VPWR#2	A2#2	1.36919e-19
C178	A3#1	a_430_392#	2.30336e-17
C179	a_55_264##3	a_55_264##6	2.10939e-17
C180	A1	a_55_264##8	4.44637e-17
C181	A2#1	a_430_392#	2.68785e-17
C182	VGND#3	A1#2	5.28856e-20
C183	A2#1	a_346_392#	2.1966e-17
C184	A2#2	A3#2	2.31587e-17
C185	A1#1	a_346_392#	2.19541e-17
C186	A1#2	A3#2	6.11316e-19
C187	VPWR	VPWR#3	5.63093e-17
C188	A1#2	A2#2	3.43105e-17
C189	B1#2	VNB	7.15563e-17
C190	a_55_264##2	VNB	1.9616e-17
C191	VPWR	B1#7	2.83167e-18
C192	A2	B1#3	1.00335e-18
C193	A2	A3#1	4.2105e-18
C194	VPWR	A3#5	3.06589e-18
C195	X#1	X	4.81505e-18
C196	A2	A2#1	9.19424e-18
C197	VGND	VGND#4	2.48844e-17
C198	A2	A1#1	2.50206e-18
C199	A2#2	a_430_392#	5.04222e-19
C200	A1	A2#1	2.7627e-18
C201	A1	A1#1	1.27887e-17
C202	VGND	B1#6	2.93915e-18
C203	X	X#2	6.54377e-19
C204	A1	a_55_264#	4.37552e-18
C205	VGND	A3#4	2.93342e-18
C206	VPWR	VPWR#1	4.95632e-17
C207	VPWR	a_55_264##8	3.98082e-17
C208	VGND	a_55_264##7	2.02122e-17
C209	VGND	a_328_74#	2.13158e-17
C210	A2	A3#2	3.91568e-18
C211	VGND	a_328_74##2	1.85642e-17
C212	VPWR	VPWR#4	3.59698e-17
C213	VGND	VGND#7	1.87716e-17
C214	VGND	X#1	1.69967e-17
C215	A2	A2#2	2.15276e-17
C216	VGND	VGND#5	4.17846e-17
C217	A1#2	A2	1.10074e-17
C218	VGND	a_55_264##8	2.21461e-18
C219	A3#5	B1#2	3.05117e-18
C220	A1	A2#2	3.21164e-18
C221	A3#1	B1#2	2.39221e-18
C222	X	A1#1	2.03613e-18
C223	A1	A1#2	1.1165e-17
C224	X	a_55_264#	1.30478e-17
C225	VPWR	B1#3	1.48085e-18
C226	VGND	B1#4	3.28021e-18
C227	X	a_55_264##6	1.03876e-17
C228	VGND	A3#3	1.20305e-19
C229	VPWR	A3#1	1.17904e-18
C230	VGND	A2#3	7.08396e-19
C231	VPWR	A2#1	1.05673e-18
C232	VGND	A1#3	1.2732e-18
C233	VGND#4	VNB	3.13612e-17
C234	VPWR	A1#1	5.34011e-19
C235	A2	a_346_392#	3.71538e-19
C236	VGND	a_55_264##4	4.85589e-18
C237	VPWR	a_55_264#	3.45651e-19
C238	VPWR#3	VNB	3.69592e-17
C239	VGND	a_55_264##5	1.30713e-18
C240	VPWR	a_55_264##6	3.09364e-19
C241	B1#7	VNB	1.13768e-17
C242	A1	a_346_392#	9.4192e-19
C243	B1#6	VNB	1.0102e-17
C244	A3#5	VNB	1.46126e-18
C245	VPWR	VPWR#2	3.16061e-17
C246	A3#4	VNB	6.2249e-19
C247	X	A1#2	8.25165e-18
C248	a_55_264##7	VNB	4.40286e-17
C249	VGND#6	VNB	2.89406e-18
C250	X	a_55_264##3	1.11264e-16
C251	a_328_74##2	VNB	8.68021e-18
C252	VGND#7	VNB	1.61407e-17
C253	X#1	VNB	4.61204e-18
C254	A1	A2	4.76874e-17
C255	VGND#5	VNB	7.22473e-17
C256	VPWR#1	VNB	9.07932e-17
C257	a_55_264##8	VNB	9.23407e-18
C258	VGND	VGND#3	8.6558e-18
C259	VPWR	a_55_264##3	1.37563e-17
C260	VGND	A3#2	3.32079e-19
C261	VPWR#4	VNB	4.75561e-17
C262	B1#4	VNB	3.28726e-17
C263	A3#3	VNB	2.54214e-17
C264	A2#3	VNB	3.04897e-17
C265	VGND	A1#2	4.52574e-18
C266	A1#3	VNB	3.18373e-17
C267	a_55_264##4	VNB	3.13165e-17
C268	VGND	a_55_264##3	6.2266e-18
C269	a_55_264##5	VNB	3.35685e-17
C270	B1#3	VNB	4.24069e-17
C271	A3#1	VNB	3.38631e-17
C272	A2#1	VNB	2.75049e-17
C273	X	A1	2.23992e-17
C274	A1#1	VNB	3.28817e-17
C275	a_55_264#	VNB	3.30506e-17
C276	VPWR	A2	3.44693e-18
C277	a_55_264##6	VNB	3.82604e-17
C278	VPWR	A1	4.3595e-18
C279	VPWR#2	VNB	2.0619e-16
C280	VGND#3	VNB	1.82979e-16
C281	VGND	A2	4.31617e-18
C282	A3#2	VNB	3.50473e-17
C283	A2#2	VNB	2.51509e-17
C284	A1#2	VNB	4.11447e-17
C285	a_55_264##3	VNB	9.31678e-17
C286	VPWR	X	3.03391e-18
C287	VGND	X	6.21924e-19
C288	A2	VNB	2.60598e-18
C289	A1	VNB	1.61873e-18
C290	X	VNB	5.86088e-19
C291	VPWR	VNB	5.37859e-17
C292	A3#4	B1#2	1.436e-18
C293	VGND	VNB	6.23977e-17
C294	VGND#4	VGND#2	9.64642e-19
C295	VGND#2	a_55_264##7	2.54259e-17
C296	VGND#2	B1#4	5.58729e-18
C297	VGND#2	a_328_74#	1.83916e-17
C298	VGND#2	B1#2	2.95762e-19
C299	VGND#2	A3#3	5.05035e-18
C300	VGND#3	VGND#2	7.59637e-17
C301	VGND#2	A2#3	3.13523e-18
C302	VGND#2	A1#3	6.6335e-19
C303	VGND#7	VGND#2	4.95622e-20
C304	VGND#2	A3#2	1.74671e-19
C305	VGND#2	a_55_264##4	9.74995e-20
C306	VGND	VGND#2	6.48724e-17
C307	VGND#2	VNB	6.61008e-17
*
*
.ENDS sky130_fd_sc_hs__o31a_2
*
