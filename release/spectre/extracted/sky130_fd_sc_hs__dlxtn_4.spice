* Extracted by Quantus, converted by sky130cad/quantus.py
*
*
*
*                       LINUX           Wed Nov 18 08:33:59 2026
*
*
*
*  PROGRAM  advgen
*
*  Name           : advgen - Quantus - (64-bit)
*  Version        : 25.1.0-p047
*  Build Date     : Thu Dec 11 23:20:30 PST 2025
*
*  HSPICE LIBRARY
*
*  OPERATING_TEMPERATURE 150
*  QRC_TECH_DIR <path>/tech
*
*
*

*
.SUBCKT sky130_fd_sc_hs__dlxtn_4 VPB VNB VGND VPWR Q D GATE_N
*
*
*  caps2d version: 10
*
*
*       TRANSISTOR CARDS
*
*
XM0 a_27_115##6 D#4 VGND#14 VNB sky130_fd_pr__nfet_01v8_lvt l=0.15 w=0.55 ad=0.15675 as=0.403175 pd=1.67 ps=3.14
XM6 VGND#14 GATE_N#1 a_230_424##12 VNB sky130_fd_pr__nfet_01v8_lvt l=0.15 w=0.74 ad=0.403175 as=0.2109 pd=3.14 ps=2.05
XM17 a_369_392##9 a_230_424# VGND#13 VNB sky130_fd_pr__nfet_01v8_lvt l=0.15 w=0.74 ad=0.2109 as=0.4794 pd=2.05 ps=2.9
XM23 VGND#13 a_27_115# a_658_79# VNB sky130_fd_pr__nfet_01v8_lvt l=0.15 w=0.64 ad=0.4794 as=0.1536 pd=2.9 ps=1.76
XM20 a_658_79# a_230_424##7 a_675_392##8 VNB sky130_fd_pr__nfet_01v8_lvt l=0.15 w=0.64 ad=0.1536 as=0.3259 pd=1.76 ps=2.57
XM7 a_675_392##8 a_369_392##3 a_895_123# VNB sky130_fd_pr__nfet_01v8_lvt l=0.15 w=0.42 ad=0.3259 as=0.0882 pd=2.57 ps=1.26
XM8 a_895_123# a_840_395# VGND#12 VNB sky130_fd_pr__nfet_01v8_lvt l=0.15 w=0.42 ad=0.0882 as=0.2062 pd=1.26 ps=2
XM9 VGND#12 a_675_392##6 a_840_395##20 VNB sky130_fd_pr__nfet_01v8_lvt l=0.15 w=0.64 ad=0.2062 as=0.1792 pd=2 ps=1.84
XM12 a_840_395##20 a_675_392##5 VGND#11 VNB sky130_fd_pr__nfet_01v8_lvt l=0.15 w=0.64 ad=0.1792 as=0.2586 pd=1.84 ps=2.21
XM10 VGND#11 a_840_395##9 Q#4 VNB sky130_fd_pr__nfet_01v8_lvt l=0.15 w=0.74 ad=0.2586 as=0.2738 pd=2.21 ps=2.22
XM11 Q#4 a_840_395##13 VGND#10 VNB sky130_fd_pr__nfet_01v8_lvt l=0.15 w=0.74 ad=0.2738 as=0.2072 pd=2.22 ps=2.04
XM19 Q#6 a_840_395##11 VGND#10 VNB sky130_fd_pr__nfet_01v8_lvt l=0.15 w=0.74 ad=0.2405 as=0.2072 pd=2.13 ps=2.04
XM22 VGND#1 a_840_395##10 Q#6 VNB sky130_fd_pr__nfet_01v8_lvt l=0.15 w=0.74 ad=0.2294 as=0.2405 pd=2.1 ps=2.13
XM15 a_27_115##7 D#1 VPWR#14 VPB sky130_fd_pr__pfet_01v8 l=0.15 w=0.84 ad=0.2478 as=0.336 pd=2.27 ps=2.48
XM2 VPWR#14 GATE_N#3 a_230_424##13 VPB sky130_fd_pr__pfet_01v8 l=0.15 w=0.84 ad=0.336 as=0.2478 pd=2.48 ps=2.27
XM21 a_369_392##8 a_230_424##4 VPWR#13 VPB sky130_fd_pr__pfet_01v8 l=0.15 w=0.84 ad=0.2478 as=0.5006 pd=2.27 ps=3.03
XM3 VPWR#13 a_27_115##3 a_591_392# VPB sky130_fd_pr__pfet_01v8 l=0.15 w=1 ad=0.5006 as=0.27 pd=3.03 ps=2.54
XM5 a_591_392# a_369_392# a_675_392##10 VPB sky130_fd_pr__pfet_01v8 l=0.15 w=1 ad=0.27 as=0.3475 pd=2.54 ps=2.84
XM24 a_675_392##10 a_230_424##8 a_789_508# VPB sky130_fd_pr__pfet_01v8 l=0.15 w=0.42 ad=0.3475 as=0.1134 pd=2.84 ps=1.38
XM16 a_789_508# a_840_395##3 VPWR#12 VPB sky130_fd_pr__pfet_01v8 l=0.15 w=0.42 ad=0.1134 as=0.4389 pd=1.38 ps=3.24
XM13 a_840_395##21 a_675_392##4 VPWR#12 VPB sky130_fd_pr__pfet_01v8 l=0.15 w=0.84 ad=0.2982 as=0.4389 pd=2.39 ps=3.24
XM25 VPWR#11 a_675_392# a_840_395##21 VPB sky130_fd_pr__pfet_01v8 l=0.15 w=0.84 ad=0.3724 as=0.2982 pd=2.95 ps=2.39
XM14 VPWR#11 a_840_395##15 Q#5 VPB sky130_fd_pr__pfet_01v8 l=0.15 w=1.12 ad=0.3724 as=0.42 pd=2.95 ps=2.99
XM18 VPWR#10 a_840_395##14 Q#5 VPB sky130_fd_pr__pfet_01v8 l=0.15 w=1.12 ad=0.336 as=0.42 pd=2.84 ps=2.99
XM4 Q#1 a_840_395##12 VPWR#10 VPB sky130_fd_pr__pfet_01v8 l=0.15 w=1.12 ad=0.336 as=0.336 pd=2.84 ps=2.84
XM1 Q#1 a_840_395##4 VPWR#1 VPB sky130_fd_pr__pfet_01v8 l=0.15 w=1.12 ad=0.336 as=0.3304 pd=2.84 ps=2.83
*
*
*       RESISTOR AND CAP/DIODE CARDS
*
Rg1	D#1	D#2	515.159607
Rg2	D#2	D#3	28.628223
Rg3	D#2	D#4	308.688934
Rg4	GATE_N#1	GATE_N#2	353.846649
Rg5	GATE_N#2	GATE_N#3	411.718903
Rg6	a_230_424#	a_230_424##2	348.495087
Rg7	a_230_424##2	a_230_424##3	97.741379
Rg8	a_230_424##2	a_230_424##4	357.254944
Rg9	a_27_115#	a_27_115##2	397.496460
Rg10	a_27_115##2	a_27_115##3	517.017944
Rg11	a_369_392#	a_369_392##2	560.440308
Rg12	a_230_424##5	a_230_424##6	50.300888
Rg13	a_230_424##6	a_230_424##7	479.274719
Rg14	a_230_424##6	a_230_424##8	530.261414
Rg15	a_369_392##3	a_369_392##4	212.914124
Rg16	a_840_395#	a_840_395##2	696.565308
Rg17	a_840_395##2	a_840_395##3	308.090637
Rg18	a_675_392#	a_675_392##2	515.859558
Rg19	a_675_392##2	a_675_392##3	55.599739
Rg20	a_675_392##3	a_675_392##4	487.796906
Rg21	a_675_392##2	a_675_392##5	402.955383
Rg22	a_675_392##3	a_675_392##6	374.158020
Rg23	a_840_395##4	a_840_395##5	517.262939
Rg24	a_840_395##5	a_840_395##6	67.705811
Rg25	a_840_395##6	a_840_395##7	62.041195
Rg26	a_840_395##7	a_840_395##8	92.538956
Rg27	a_840_395##8	a_840_395##9	380.339874
Rg28	a_840_395##5	a_840_395##10	434.623047
Rg29	a_840_395##6	a_840_395##11	418.669952
Rg30	a_840_395##6	a_840_395##12	450.232361
Rg31	a_840_395##7	a_840_395##13	360.864685
Rg32	a_840_395##7	a_840_395##14	443.735718
Rg33	a_840_395##8	a_840_395##15	462.979767
Rf1	D#5	D#3	160.919952
Rf2	D	D#7	0.687145
Rf3	D#5	D#7	7.873454
Rf4	GATE_N	GATE_N#2	162.201172
Rf5	a_27_115##2	a_27_115##5	393.024292
Rf6	a_27_115##5	a_27_115##6	27.108574
Rf7	a_27_115##5	a_27_115##7	116.718224
Rf8	a_230_424##5	a_230_424##10	469.849609
Rf9	a_230_424##10	a_230_424##3	51.753590
Rf10	a_230_424##3	a_230_424##12	28.809029
Rf11	a_230_424##10	a_230_424##13	12.063261
Rf12	a_369_392##4	a_369_392##2	286.830139
Rf13	a_369_392##2	a_369_392##7	80.191208
Rf14	a_369_392##7	a_369_392##8	33.594978
Rf15	a_369_392##7	a_369_392##9	63.856564
Rf16	a_675_392##3	a_675_392##9	242.237671
Rf17	a_675_392##9	a_675_392##10	109.290665
Rf18	a_675_392##8	a_675_392##9	7.500000
Rf19	a_840_395##7	a_840_395##17	78.854645
Rf20	a_840_395##17	a_840_395##18	45.178970
Rf21	a_840_395##18	a_840_395##2	197.811066
Rf22	a_840_395##17	a_840_395##20	67.867081
Rf23	a_840_395##18	a_840_395##21	17.881943
Rf24	Q#1	Q#2	20.791882
Rf25	Q#2	Q	20.277977
Rf26	Q	Q#3	43.915066
Rf27	Q#3	Q#4	84.323151
Rf28	Q#2	Q#5	87.110100
Rf29	Q#3	Q#6	19.806370
Rf30	VPWR#1	VPWR#2	61.004704
Rf31	VPWR#2	VPWR#3	33.578697
Rf32	VPWR#3	VPWR#4	73.001427
Rf33	VPWR#4	VPWR#5	88.656273
Rf34	VPWR#5	VPWR#6	102.925652
Rf35	VPWR#6	VPWR#7	56.183540
Rf36	VPWR#7	VPWR#8	130.670517
Rf38	VPWR#3	VPWR#10	35.274624
Rf39	VPWR#4	VPWR#11	34.093605
Rf40	VPWR#5	VPWR#12	16.179535
Rf41	VPWR#7	VPWR#13	27.329292
Rf42	VPWR#8	VPWR#14	31.534731
Rf43	VGND#1	VGND#2	64.567978
Rf44	VGND#2	VGND#3	35.770210
Rf45	VGND#3	VGND#4	75.558197
Rf46	VGND#4	VGND#5	65.753731
Rf47	VGND#5	VGND#6	120.931381
Rf48	VGND#6	VGND#7	27.734655
Rf49	VGND#7	VGND#8	159.931519
Rf51	VGND#3	VGND#10	36.082184
Rf52	VGND#4	VGND#11	34.901169
Rf53	VGND#5	VGND#12	52.887722
Rf54	VGND#7	VGND#13	32.223660
Rf55	VGND#8	VGND#14	24.468842
Re1	VPWR#2	VPWR	4.549932
Re2	VPWR	VPWR#6	0.974985
Re3	VGND#2	VGND	4.549932
Re4	VGND	VGND#6	0.974985
*
*       CAPACITOR CARDS
*
*
C1	a_230_424##13	VPWR#13	9.35332e-17
C2	VGND#13	a_27_115#	5.3983e-17
C3	Q#5	VPWR#4	9.21769e-18
C4	a_230_424##13	a_369_392##8	8.69593e-17
C5	VPWR#14	VPWR#13	7.64718e-19
C6	Q#2	VPWR#3	1.50545e-19
C7	a_840_395##18	VPWR#5	9.85578e-18
C8	a_230_424#	VGND#13	4.9052e-18
C9	VPWR#5	VPWR#11	1.94729e-18
C10	Q#2	Q#1	1.88425e-18
C11	Q#5	VPWR#3	9.30654e-18
C12	a_369_392##9	a_230_424#	2.97223e-17
C13	Q#6	VGND#1	4.20063e-17
C14	VPWR#14	a_230_424##13	7.03833e-17
C15	a_840_395##18	VPWR#4	1.40228e-19
C16	VPWR#5	a_840_395##21	4.75689e-17
C17	a_27_115##6	a_27_115#	1.01311e-19
C18	a_369_392##9	GATE_N#1	1.03962e-18
C19	Q#2	VPWR#10	3.2747e-17
C20	a_27_115##7	a_230_424##13	1.09135e-17
C21	a_230_424##12	GATE_N#1	2.69764e-17
C22	VGND#10	VGND#1	2.23985e-18
C23	a_840_395##21	VPWR#4	9.1682e-18
C24	a_27_115##6	a_230_424#	1.42619e-18
C25	Q#3	Q#2	4.75425e-18
C26	a_27_115##7	VPWR#14	8.5164e-17
C27	a_369_392##7	a_27_115##3	3.04641e-18
C28	GATE_N#1	VGND#14	7.39464e-18
C29	VPWR#5	VPWR#12	1.71786e-17
C30	Q#5	Q#2	2.75366e-18
C31	a_230_424##12	D#4	1.64379e-18
C32	VGND#10	Q#6	3.99018e-17
C33	a_27_115##6	GATE_N#1	3.41194e-17
C34	D#4	VGND#14	1.45157e-17
C35	a_369_392##7	a_230_424##4	4.56034e-18
C36	VGND#2	VGND#3	5.73154e-17
C37	a_27_115##6	D#4	4.45554e-17
C38	Q#4	Q#6	2.23638e-18
C39	a_675_392##8	a_675_392##2	4.73673e-20
C40	a_840_395##18	Q#5	1.16935e-17
C41	VPWR#2	VPWR#3	3.75173e-17
C42	Q#4	VGND#10	5.49404e-17
C43	a_840_395##11	a_840_395##10	3.23796e-17
C44	a_675_392##8	a_230_424##6	1.39995e-17
C45	a_840_395##18	VPWR#11	2.35424e-17
C46	Q#2	VPWR#2	2.94176e-18
C47	a_675_392##10	a_230_424##7	1.79762e-18
C48	VGND#11	VGND#10	1.93829e-18
C49	VPWR#1	a_840_395##4	3.725e-17
C50	a_840_395##17	VPWR#11	3.92606e-18
C51	a_840_395##13	a_840_395##11	3.92316e-17
C52	VGND#2	Q#3	2.68059e-18
C53	a_840_395##4	Q#1	2.64982e-17
C54	a_840_395##18	a_840_395##21	1.59077e-18
C55	VGND#11	Q#4	3.97619e-17
C56	VGND#2	Q#2	1.28033e-18
C57	VPWR#1	a_840_395##12	2.47203e-18
C58	VPWR#10	a_840_395##4	2.92288e-18
C59	VGND#4	a_840_395##7	4.92568e-19
C60	a_840_395##12	Q#1	2.30956e-17
C61	Q#5	a_840_395##4	3.03824e-19
C62	VPWR#13	VPWR#5	1.2016e-20
C63	a_840_395##9	a_840_395##13	2.48448e-17
C64	VGND#3	a_840_395##7	5.69832e-20
C65	a_840_395##20	Q#4	1.1377e-17
C66	VPWR#10	a_840_395##12	5.61412e-17
C67	a_840_395##18	VPWR#12	2.82646e-19
C68	VGND#5	a_675_392##3	6.45697e-19
C69	Q#5	a_840_395##12	4.62904e-19
C70	a_369_392#	a_230_424##6	7.4051e-18
C71	VGND#4	a_675_392##3	6.27113e-20
C72	a_230_424##13	a_27_115#	5.7808e-19
C73	VPWR#10	a_840_395##14	4.85705e-17
C74	a_840_395##20	VGND#11	4.80499e-17
C75	a_675_392##5	a_840_395##9	2.83006e-17
C76	Q#5	a_840_395##14	6.93545e-17
C77	a_840_395##7	VPWR#4	2.66235e-19
C78	a_230_424##13	VPWR#7	1.43665e-17
C79	VPWR#10	a_840_395##15	1.98497e-18
C80	VPWR#3	a_840_395##7	4.14287e-20
C81	VPWR#11	a_840_395##14	7.95111e-19
C82	VGND#5	a_840_395##2	1.25559e-19
C83	a_840_395##15	Q#5	4.78836e-17
C84	Q#3	a_840_395##7	5.18104e-17
C85	a_675_392##6	a_675_392##5	3.60684e-17
C86	VPWR#5	a_675_392##3	3.69166e-20
C87	VPWR#10	a_675_392#	2.69569e-19
C88	a_840_395##15	VPWR#11	2.65235e-17
C89	a_840_395##7	Q#2	5.75358e-17
C90	VPWR#4	a_675_392##3	2.22867e-20
C91	VGND#12	a_840_395##20	5.21792e-17
C92	VGND#7	a_369_392##4	1.15149e-18
C93	Q#5	a_675_392#	6.9534e-19
C94	a_840_395##21	a_840_395##15	8.80464e-19
C95	VGND#5	a_369_392##4	4.08704e-17
C96	a_675_392#	VPWR#11	2.9702e-17
C97	VGND#3	a_840_395##10	7.8966e-19
C98	VGND#4	a_369_392##4	1.01017e-19
C99	a_840_395#	a_675_392##6	2.2762e-17
C100	a_840_395##17	a_840_395##7	3.55418e-19
C101	a_840_395##2	VPWR#5	4.9582e-17
C102	Q#5	a_675_392##4	1.04301e-19
C103	VGND#4	a_840_395##8	6.01935e-20
C104	a_675_392#	a_840_395##21	1.62616e-17
C105	VPWR#11	a_675_392##4	2.00647e-18
C106	a_675_392##3	a_840_395##18	4.97673e-17
C107	a_675_392##8	a_840_395##20	3.27953e-18
C108	a_675_392##4	a_840_395##21	2.62405e-17
C109	VGND#3	a_840_395##11	4.94076e-18
C110	a_675_392##3	a_840_395##17	3.81595e-17
C111	a_369_392##3	a_840_395#	4.14522e-17
C112	a_675_392##2	a_840_395##9	1.11054e-18
C113	VPWR#11	a_840_395##3	8.32601e-20
C114	a_675_392##4	VPWR#12	1.07852e-17
C115	D#5	a_27_115##6	5.86424e-17
C116	VGND#4	a_840_395##13	2.96442e-19
C117	a_840_395##21	a_840_395##3	8.7389e-19
C118	VGND#2	VGND#1	2.4564e-17
C119	a_675_392##8	VGND#12	3.30748e-17
C120	a_840_395##18	a_840_395##2	1.72547e-18
C121	a_840_395##3	VPWR#12	8.31705e-18
C122	VGND#2	Q#6	2.99937e-17
C123	a_840_395##17	a_840_395##2	1.70384e-19
C124	a_230_424##7	a_369_392##3	4.59219e-18
C125	VGND#3	a_840_395##8	3.15681e-20
C126	VGND#3	a_840_395##13	4.40289e-18
C127	VGND#5	a_840_395##9	4.27786e-19
C128	a_230_424##5	VPWR#5	7.65714e-17
C129	VGND#2	Q#4	1.20555e-18
C130	VGND#4	a_840_395##9	7.35088e-18
C131	a_675_392##10	a_840_395##3	2.44847e-18
C132	VGND#7	a_27_115##2	4.68558e-17
C133	a_27_115#	a_230_424##7	5.08798e-17
C134	VGND#1	VPWR#1	1.54575e-19
C135	VGND#3	a_840_395##9	4.72164e-19
C136	VGND#5	a_675_392##5	7.53534e-19
C137	a_675_392##10	a_230_424##8	3.23718e-17
C138	VPWR#13	a_840_395##3	7.39725e-20
C139	VGND#4	a_675_392##2	8.07442e-22
C140	a_230_424##5	a_840_395##18	2.67764e-18
C141	VGND#4	a_675_392##5	1.18023e-18
C142	a_230_424#	a_27_115#	7.15098e-18
C143	a_675_392##10	a_369_392#	4.27205e-17
C144	a_230_424##5	a_840_395##17	1.33469e-18
C145	VGND#7	a_230_424##3	1.88047e-19
C146	VPWR#13	a_230_424##8	1.25468e-19
C147	a_230_424##13	a_840_395##3	1.35286e-19
C148	VGND#3	a_675_392##5	1.59846e-19
C149	VGND#5	a_675_392##6	9.8309e-18
C150	Q#3	a_840_395##10	1.92005e-17
C151	a_840_395##7	Q#6	2.98762e-18
C152	a_675_392##10	a_27_115##3	3.4738e-18
C153	VPWR#13	a_369_392#	1.54986e-18
C154	a_840_395##7	VGND#10	4.34594e-18
C155	a_230_424##13	a_230_424##8	4.16269e-19
C156	GATE_N#1	a_230_424#	1.47526e-18
C157	a_840_395##7	Q#4	6.58528e-17
C158	a_369_392##8	a_369_392#	5.7906e-19
C159	VGND#3	VGND#1	8.1211e-19
C160	VPWR#7	a_230_424##3	1.68788e-19
C161	a_675_392##10	a_230_424##4	1.41598e-18
C162	VGND#11	a_840_395##7	5.13184e-18
C163	VPWR#13	a_27_115##3	4.4648e-17
C164	VPWR#2	VPWR#1	2.95848e-17
C165	a_230_424##13	a_369_392#	1.78279e-17
C166	Q#3	a_840_395##11	1.74983e-17
C167	VGND#5	a_840_395#	2.31951e-18
C168	Q#1	VPWR#2	2.80469e-17
C169	a_369_392##8	a_27_115##3	1.99316e-18
C170	D#4	GATE_N#1	1.80522e-17
C171	a_369_392##7	a_369_392##2	2.06065e-18
C172	a_230_424##4	VPWR#13	3.19517e-17
C173	VPWR#2	VPWR#10	2.15678e-17
C174	a_230_424##13	a_27_115##3	2.92498e-17
C175	a_230_424##13	a_369_392##7	2.60908e-17
C176	VPWR#2	Q#5	5.60862e-19
C177	a_369_392##8	a_230_424##4	2.66513e-17
C178	a_840_395##20	a_675_392##3	2.30803e-17
C179	VPWR#14	a_27_115##3	4.57785e-19
C180	Q#3	a_840_395##13	7.1171e-20
C181	VPWR#13	GATE_N#3	1.47964e-18
C182	VGND#12	a_675_392##3	2.10893e-17
C183	a_230_424##13	a_230_424##4	1.97314e-17
C184	a_840_395##17	a_840_395##10	7.07539e-20
C185	a_27_115##2	a_369_392##7	5.30021e-17
C186	a_369_392##8	GATE_N#3	6.51077e-19
C187	a_230_424##6	a_840_395#	1.60692e-18
C188	a_675_392##8	a_675_392##3	5.07506e-18
C189	VPWR#13	D#1	3.42002e-19
C190	a_230_424##13	GATE_N#3	6.13783e-17
C191	a_27_115##7	a_230_424##4	5.38567e-19
C192	VPWR#2	a_840_395##6	1.29892e-20
C193	Q#3	a_840_395##9	1.59075e-20
C194	GATE_N#3	VPWR#14	2.85892e-17
C195	VGND#4	Q#4	8.60466e-18
C196	a_840_395##17	a_840_395##11	7.72183e-20
C197	VGND#11	a_369_392##4	1.33067e-19
C198	a_369_392##7	a_230_424##3	5.99609e-17
C199	a_230_424##13	D#1	1.70764e-18
C200	VPWR#2	a_840_395##5	2.77558e-20
C201	a_27_115##7	GATE_N#3	3.79163e-18
C202	a_675_392##8	a_840_395##2	4.19713e-18
C203	a_840_395##20	a_369_392##4	7.81885e-20
C204	VGND#5	VGND#11	2.96888e-18
C205	D#1	VPWR#14	3.30254e-17
C206	a_369_392##4	VGND#12	7.07201e-18
C207	a_27_115##7	D#1	5.76216e-17
C208	a_840_395##7	Q#1	2.1182e-18
C209	a_840_395##12	a_840_395##4	4.72416e-17
C210	VGND#3	Q#4	1.02506e-17
C211	a_369_392##4	a_675_392##8	6.20534e-17
C212	a_840_395##17	a_840_395##13	1.55297e-19
C213	a_840_395##7	VPWR#10	3.15471e-18
C214	a_369_392##7	GATE_N#2	2.79667e-20
C215	a_230_424##6	a_369_392##3	5.11755e-18
C216	a_840_395##7	Q#5	5.70368e-17
C217	VGND#5	a_840_395##20	9.27632e-18
C218	VGND#13	a_369_392##4	3.95619e-17
C219	a_840_395##7	VPWR#11	7.52157e-18
C220	VGND#5	VGND#4	1.57622e-18
C221	a_840_395##14	a_840_395##12	4.61537e-17
C222	VGND#2	a_840_395##6	5.4843e-20
C223	a_675_392##8	a_230_424##5	3.6537e-17
C224	VGND#7	a_230_424#	4.41432e-18
C225	VGND#11	VGND#3	3.392e-19
C226	VGND#2	a_840_395##5	5.43079e-20
C227	a_840_395##17	a_840_395##9	3.59776e-19
C228	a_369_392##2	VGND#12	1.01722e-19
C229	VGND#4	a_840_395##20	6.88158e-18
C230	a_27_115##6	a_369_392##9	5.12573e-18
C231	a_840_395##15	a_840_395##14	3.44048e-17
C232	a_230_424##13	VPWR#6	2.12584e-17
C233	Q#5	a_840_395##8	2.17805e-18
C234	a_369_392##2	a_675_392##8	7.05579e-17
C235	VGND#5	VGND#12	1.68842e-19
C236	VGND#2	a_840_395##10	9.26018e-19
C237	VGND#13	a_369_392##2	3.41573e-17
C238	a_27_115##6	a_230_424##12	4.5195e-17
C239	VGND#2	a_840_395##11	8.03141e-19
C240	D#5	GATE_N#2	3.77875e-19
C241	a_840_395##21	a_840_395##2	1.63754e-19
C242	a_675_392#	a_840_395##15	3.76203e-17
C243	a_675_392##8	a_27_115##2	1.01519e-19
C244	VGND#2	a_840_395##13	6.17789e-19
C245	a_840_395##2	VPWR#12	1.45701e-18
C246	VPWR#4	a_840_395##8	2.73457e-20
C247	VPWR#7	a_27_115#	2.47745e-22
C248	a_27_115##2	VGND#13	1.12141e-16
C249	a_27_115##6	VGND#14	6.23838e-18
C250	VGND#4	VGND#3	8.66408e-19
C251	a_675_392##10	a_840_395##2	3.50598e-18
C252	a_27_115##2	a_369_392##9	8.48526e-17
C253	D#5	D#3	1.66654e-17
C254	a_675_392##4	a_675_392#	3.44653e-17
C255	Q#3	VGND#1	4.13753e-18
C256	a_230_424##5	a_840_395##21	3.45964e-18
C257	a_369_392##4	a_675_392##10	1.22935e-18
C258	a_27_115##6	a_27_115##2	1.43754e-18
C259	Q#5	a_675_392##2	2.54487e-19
C260	a_369_392##9	a_230_424##3	7.07417e-17
C261	VGND#5	a_675_392##8	3.82915e-18
C262	a_840_395##3	a_675_392##4	5.4947e-18
C263	a_840_395##17	a_840_395#	2.49292e-19
C264	a_230_424##5	a_675_392##10	1.44868e-16
C265	a_27_115##6	a_230_424##3	4.66552e-17
C266	Q#3	Q#6	1.2758e-18
C267	VPWR#3	a_840_395##8	3.14475e-21
C268	GATE_N#2	a_230_424##12	2.33425e-17
C269	VPWR#6	a_230_424##7	5.57426e-20
C270	a_230_424##8	a_840_395##3	2.73312e-17
C271	a_369_392##2	a_675_392##10	6.08228e-17
C272	VPWR#6	a_27_115#	4.00108e-20
C273	a_27_115##6	GATE_N#2	1.75884e-17
C274	a_230_424##13	a_230_424##5	1.66642e-18
C275	VGND#6	a_230_424##7	4.15511e-18
C276	VGND#6	a_230_424##6	1.70318e-19
C277	Q#3	VGND#10	1.6721e-17
C278	a_230_424##12	D#3	1.50194e-18
C279	a_369_392#	a_230_424##8	2.27289e-17
C280	VGND#6	a_27_115#	9.9979e-19
C281	VPWR#2	a_840_395##4	2.77679e-18
C282	a_675_392##3	a_840_395#	2.88363e-17
C283	Q#1	VPWR#1	5.84992e-17
C284	a_369_392##2	a_230_424##13	1.41749e-17
C285	a_27_115##6	D#3	1.30699e-17
C286	VPWR#2	a_840_395##12	6.36188e-19
C287	VPWR#13	a_27_115##2	3.10448e-19
C288	VPWR#4	a_675_392##2	3.14475e-21
C289	a_369_392##4	a_840_395##9	1.97148e-19
C290	a_840_395##7	a_840_395##8	2.20661e-17
C291	VPWR#2	a_840_395##14	5.44159e-19
C292	a_27_115##3	a_369_392#	5.14169e-17
C293	a_675_392##8	a_789_508#	1.96723e-19
C294	a_840_395##7	a_840_395##6	1.84945e-17
C295	a_230_424##13	a_27_115##2	1.0264e-18
C296	a_369_392##3	a_840_395##2	3.63459e-18
C297	VPWR#10	VPWR#1	2.06271e-18
C298	a_369_392##4	a_675_392##6	4.48314e-18
C299	Q#4	Q#3	2.05505e-19
C300	VPWR#13	a_230_424##3	3.32771e-19
C301	a_840_395##7	a_840_395##5	8.13785e-18
C302	a_369_392##4	a_840_395#	1.16386e-17
C303	a_230_424##3	a_369_392##8	6.82846e-18
C304	a_230_424##4	a_27_115##3	1.82776e-17
C305	a_840_395##6	a_840_395##5	4.01076e-18
C306	a_675_392##2	a_840_395##8	1.9005e-17
C307	a_369_392##4	a_369_392##3	6.13541e-19
C308	a_230_424##13	a_230_424##3	7.50377e-18
C309	VPWR#10	Q#1	6.51594e-17
C310	a_840_395##10	VGND#1	2.52445e-17
C311	a_369_392##4	a_230_424##7	2.99225e-17
C312	a_230_424##5	a_840_395#	5.58799e-18
C313	GATE_N#3	a_27_115##3	2.34791e-19
C314	a_369_392##8	GATE_N#2	8.21856e-20
C315	a_369_392##4	a_27_115#	7.3393e-18
C316	a_369_392##3	a_230_424##5	8.22372e-18
C317	a_369_392##2	a_675_392##6	8.67426e-21
C318	GATE_N#2	a_230_424##13	2.55884e-17
C319	GATE_N#3	a_230_424##4	3.75784e-18
C320	a_230_424#	a_369_392##4	2.55258e-19
C321	a_230_424##5	a_230_424##7	1.59299e-19
C322	a_369_392##2	a_840_395#	1.12922e-20
C323	a_840_395##10	Q#6	1.83556e-17
C324	a_27_115##7	GATE_N#2	2.7402e-17
C325	a_369_392##2	a_369_392##3	4.58518e-20
C326	VGND#1	a_840_395##11	2.0062e-18
C327	a_230_424##13	D#3	2.11037e-19
C328	a_230_424##7	a_369_392##2	1.43888e-17
C329	D#1	GATE_N#3	2.63057e-17
C330	Q	a_840_395##8	1.38085e-19
C331	VGND#10	a_840_395##10	1.50686e-18
C332	Q	a_840_395##6	4.44258e-19
C333	a_27_115#	a_369_392##2	2.21541e-17
C334	Q	a_840_395##5	1.60431e-17
C335	VPWR#6	a_230_424##8	2.88607e-18
C336	Q	a_675_392##2	2.46465e-19
C337	a_27_115##7	D#3	1.09993e-17
C338	Q#5	VPWR#10	7.73393e-17
C339	a_840_395##11	Q#6	1.98223e-17
C340	a_369_392##2	a_230_424#	8.73681e-20
C341	a_675_392##8	a_895_123#	1.62033e-18
C342	a_27_115##2	a_230_424##7	1.03679e-18
C343	VPWR#6	a_369_392#	4.41812e-18
C344	a_675_392##3	a_675_392##2	1.10205e-17
C345	a_27_115##2	a_27_115#	1.06165e-18
C346	Q#4	a_840_395##10	3.03022e-19
C347	a_675_392##3	a_230_424##6	1.11551e-18
C348	a_27_115##2	a_230_424#	3.32557e-17
C349	VGND#10	a_840_395##11	3.25896e-17
C350	VPWR#11	VPWR#10	1.76158e-18
C351	a_27_115##2	GATE_N#1	2.4912e-19
C352	a_840_395##2	a_675_392##4	1.88921e-17
C353	Q#3	a_840_395##6	1.98681e-18
C354	Q#6	a_840_395##13	7.74508e-19
C355	a_230_424##3	a_230_424#	1.4003e-17
C356	Q#4	a_840_395##11	4.63117e-19
C357	GATE_N#1	a_230_424##3	2.14797e-17
C358	a_230_424##8	a_840_395##2	1.44116e-17
C359	VPWR#11	Q#5	7.32712e-17
C360	a_230_424##13	a_591_392#	1.21259e-17
C361	a_230_424##3	D#4	1.22891e-19
C362	a_230_424##5	a_675_392#	2.70029e-19
C363	VGND#10	a_840_395##13	2.81895e-17
C364	VGND#7	a_27_115##6	9.22016e-18
C365	a_230_424##5	a_675_392##4	8.87961e-19
C366	Q#6	a_840_395##9	1.73111e-19
C367	a_230_424##5	a_840_395##3	2.2359e-17
C368	Q#3	a_840_395##5	2.21924e-18
C369	Q#4	a_840_395##13	3.08156e-17
C370	VPWR#3	a_840_395##12	1.06419e-18
C371	a_230_424##5	a_230_424##8	1.68981e-17
C372	D#3	GATE_N#1	5.74138e-18
C373	a_230_424##6	a_840_395##2	1.27098e-17
C374	VGND#11	a_840_395##17	3.80453e-18
C375	VGND#10	a_840_395##9	1.12055e-18
C376	Q#2	a_840_395##4	1.36616e-17
C377	a_230_424##5	a_369_392#	6.72796e-18
C378	a_840_395##20	a_840_395##18	4.61176e-18
C379	VPWR#2	a_840_395##7	5.19715e-18
C380	VGND#11	a_840_395##13	3.95928e-19
C381	a_230_424##5	a_27_115##3	1.2159e-19
C382	a_369_392##2	a_369_392#	6.08214e-18
C383	a_840_395##21	VPWR#11	5.61697e-17
C384	Q#2	a_840_395##6	9.36124e-19
C385	VGND#2	a_840_395##7	4.44269e-18
C386	Q#4	a_840_395##9	4.58552e-17
C387	a_369_392##2	a_27_115##3	2.72073e-17
C388	VPWR#3	a_840_395##14	9.87778e-19
C389	VGND#10	a_675_392##5	1.61869e-19
C390	a_840_395##18	a_840_395##4	1.78201e-20
C391	a_840_395##6	a_840_395##4	1.07265e-18
C392	a_230_424##12	a_230_424##13	4.66677e-18
C393	VPWR#7	VPWR#5	1.14183e-19
C394	Q#2	a_840_395##12	1.58337e-17
C395	VPWR#5	a_840_395##15	3.26097e-19
C396	a_840_395##9	VGND#11	1.5172e-17
C397	a_230_424##3	a_27_115##3	4.04267e-18
C398	Q#4	a_675_392##5	2.46706e-18
C399	a_27_115##6	a_369_392##8	1.2996e-18
C400	VPWR#4	a_840_395##15	4.96428e-18
C401	Q#2	a_840_395##5	2.2778e-18
C402	a_840_395#	a_895_123#	6.42889e-18
C403	a_840_395##20	a_840_395##9	3.00864e-18
C404	Q#4	a_840_395##8	3.2545e-18
C405	a_369_392##3	a_895_123#	6.42889e-18
C406	a_369_392##4	a_230_424##6	6.956e-19
C407	VGND#6	a_369_392##4	6.63354e-17
C408	GATE_N#2	a_230_424##4	6.75961e-19
C409	a_230_424##5	VPWR#6	3.91128e-17
C410	VGND#11	a_675_392##5	3.59064e-17
C411	a_675_392##3	a_840_395##2	5.81082e-17
C412	Q#2	a_840_395##14	5.79797e-19
C413	VGND#6	a_230_424##5	2.02937e-20
C414	VPWR#6	a_369_392##2	2.77928e-20
C415	VPWR#5	a_675_392#	1.55757e-18
C416	Q#4	a_675_392##6	2.02853e-19
C417	VGND#3	Q#3	3.61731e-19
C418	a_840_395##3	a_789_508#	8.28504e-18
C419	D#1	GATE_N#2	3.0161e-18
C420	VGND#6	a_369_392##2	2.83501e-19
C421	a_230_424##8	a_789_508#	1.07866e-18
C422	a_840_395##20	a_675_392##5	2.40685e-17
C423	Q#3	Q	1.70136e-18
C424	a_230_424##5	a_675_392##3	3.28225e-17
C425	VPWR#4	a_675_392#	9.83935e-19
C426	a_675_392##10	a_230_424##6	1.4489e-17
C427	VGND#11	a_675_392##6	1.875e-18
C428	a_230_424##7	a_658_79#	7.15278e-18
C429	a_230_424##5	a_840_395##2	8.02067e-17
C430	a_27_115##6	VPWR#14	2.40631e-18
C431	a_27_115#	a_658_79#	2.97145e-18
C432	a_840_395##18	a_840_395##14	7.98033e-19
C433	a_369_392#	a_591_392#	1.30196e-17
C434	a_369_392##4	a_230_424##5	2.52393e-18
C435	a_27_115##3	a_591_392#	1.66595e-17
C436	a_840_395##8	VNB	3.27147e-17
C437	a_840_395##6	VNB	2.49721e-17
C438	Q#2	a_840_395##15	2.61824e-19
C439	a_840_395##5	VNB	3.59308e-17
C440	VPWR#5	VPWR#4	9.97514e-19
C441	a_675_392##2	VNB	2.99e-17
C442	a_230_424##6	VNB	4.54396e-17
C443	a_840_395##20	a_675_392##6	3.75749e-17
C444	VPWR	VPWR#7	8.24642e-17
C445	VPWR#5	a_675_392##4	2.12942e-17
C446	VPWR	VPWR#5	1.37887e-16
C447	VPWR	VPWR#4	6.06327e-17
C448	VPWR	VPWR#3	1.01262e-17
C449	a_230_424##5	a_675_392##2	2.67638e-19
C450	a_369_392##2	a_230_424##5	4.36361e-19
C451	a_27_115##2	a_369_392##4	1.51892e-19
C452	Q	VGND#1	3.09984e-17
C453	a_27_115##6	a_27_115##7	1.85378e-18
C454	VPWR	a_840_395##18	2.70001e-18
C455	a_230_424##5	a_230_424##6	4.30089e-18
C456	D	a_27_115##6	4.35797e-18
C457	VPWR	a_840_395##17	7.43543e-19
C458	a_675_392##6	VGND#12	1.4738e-17
C459	VPWR	a_369_392##7	4.00905e-18
C460	a_27_115##2	a_369_392##2	6.51296e-17
C461	a_840_395##18	a_840_395##15	3.09538e-18
C462	a_675_392##8	a_840_395##17	4.54552e-19
C463	a_840_395##20	a_840_395#	1.82934e-18
C464	VGND	VGND#7	7.65933e-17
C465	a_369_392##2	a_230_424##3	1.98042e-19
C466	VGND	VGND#5	9.49177e-17
C467	a_840_395##18	a_840_395##6	2.23451e-20
C468	VGND	VGND#4	8.17674e-17
C469	VGND	VGND#3	1.23721e-17
C470	a_230_424##3	a_27_115##2	3.28709e-17
C471	VPWR#5	a_840_395##3	1.85768e-17
C472	Q	VPWR#1	3.38779e-17
C473	a_840_395#	VGND#12	1.6256e-17
C474	VGND	a_840_395##18	1.23479e-18
C475	D	a_27_115##7	3.98266e-17
C476	a_840_395##14	a_840_395##6	1.14316e-18
C477	VGND	a_840_395##17	8.38995e-19
C478	GATE_N#2	a_230_424##3	5.50593e-17
C479	a_675_392##8	a_675_392##6	9.92243e-19
C480	VGND	a_369_392##7	1.60864e-18
C481	a_230_424##5	a_789_508#	1.03214e-18
C482	a_230_424##3	D#3	1.54856e-19
C483	a_840_395##18	a_675_392#	1.06868e-17
C484	a_840_395##17	a_840_395##8	7.96715e-19
C485	D#3	GATE_N#2	1.88602e-17
C486	a_840_395##18	a_840_395##5	2.97001e-21
C487	VGND	D#5	2.79359e-18
C488	VGND#7	VNB	4.27655e-17
C489	VGND#5	VNB	4.02273e-17
C490	VPWR	Q#5	1.81643e-17
C491	Q	a_840_395##10	8.32215e-19
C492	D#5	GATE_N#1	3.45946e-19
C493	VPWR#4	VPWR#3	9.53351e-19
C494	VGND#4	VNB	3.19456e-17
C495	VPWR	VPWR#11	1.80492e-17
C496	VGND#3	VNB	2.4934e-17
C497	Q	a_840_395##11	1.70719e-19
C498	VGND#12	a_369_392##3	6.29246e-19
C499	VPWR	a_840_395##21	1.82823e-17
C500	VGND	Q#4	1.77251e-17
C501	Q	a_840_395##13	9.75255e-20
C502	VPWR#5	a_230_424##8	1.79044e-18
C503	VPWR#7	VNB	4.43267e-17
C504	VPWR#5	VNB	5.27616e-17
C505	Q	a_840_395##9	6.02683e-20
C506	VGND	a_840_395##20	1.6672e-17
C507	a_369_392##2	a_230_424##6	2.84616e-17
C508	VPWR#4	VNB	3.07115e-17
C509	VPWR#3	VNB	2.40222e-17
C510	VPWR	a_675_392##10	1.2747e-17
C511	Q#3	VNB	8.79544e-19
C512	a_675_392##8	a_840_395#	1.86402e-17
C513	VGND	a_675_392##8	2.32394e-17
C514	Q#2	VNB	7.10329e-19
C515	VPWR	VPWR#13	2.4747e-17
C516	a_840_395##18	VNB	2.60266e-18
C517	VGND	VGND#13	1.83469e-17
C518	VPWR	a_369_392##8	5.12312e-18
C519	a_840_395##17	VNB	3.84567e-18
C520	VGND	a_369_392##9	8.18385e-18
C521	VPWR	a_230_424##13	6.02028e-17
C522	VGND	a_230_424##12	2.93399e-18
C523	VPWR	VPWR#14	1.93818e-17
C524	a_369_392##7	VNB	9.18216e-18
C525	VPWR	a_27_115##7	2.08778e-17
C526	VGND	a_27_115##6	5.38082e-17
C527	a_369_392##4	a_658_79#	4.82479e-18
C528	a_840_395##18	a_675_392##4	2.02894e-17
C529	a_840_395##17	a_840_395##6	1.79916e-19
C530	Q	a_840_395##4	1.0902e-17
C531	a_369_392##2	a_658_79#	9.28385e-18
C532	D#5	VNB	9.73152e-18
C533	VGND#1	VNB	2.82006e-17
C534	VGND#12	a_230_424##7	2.99579e-19
C535	Q#6	VNB	5.1464e-18
C536	VPWR	a_369_392##3	2.56458e-20
C537	VGND#10	VNB	4.1552e-20
C538	Q	a_840_395##14	2.7503e-20
C539	a_840_395##18	a_675_392##2	4.30144e-18
C540	Q#4	VNB	3.38849e-18
C541	VGND#11	VNB	7.40983e-19
C542	Q	a_840_395##15	1.67439e-20
C543	VGND	a_369_392##8	9.75535e-19
C544	a_840_395##20	VNB	1.95963e-18
C545	VGND#12	VNB	5.55411e-18
C546	a_675_392##8	a_369_392##3	4.33613e-17
C547	a_675_392##8	VNB	2.42412e-18
C548	VGND#13	VNB	2.07672e-18
C549	a_369_392##9	VNB	4.12159e-19
C550	a_230_424##12	VNB	3.02646e-18
C551	VPWR#5	a_369_392#	1.02128e-19
C552	a_27_115##6	VNB	5.75596e-17
C553	VGND	a_840_395##9	1.5881e-18
C554	VPWR#1	VNB	3.66647e-17
C555	VGND	a_675_392##5	5.07707e-18
C556	Q#1	VNB	5.15633e-18
C557	VGND	a_675_392##6	9.31675e-18
C558	VPWR#10	VNB	1.1667e-19
C559	Q#5	VNB	5.91519e-18
C560	VGND	a_840_395#	8.21677e-18
C561	VPWR	a_840_395##15	4.02901e-18
C562	VPWR#11	VNB	3.66049e-18
C563	VGND	a_369_392##3	9.71076e-19
C564	a_840_395##21	VNB	5.42222e-18
C565	VPWR	a_675_392#	2.34452e-19
C566	VGND	a_230_424##7	3.07481e-18
C567	VGND	a_27_115#	4.41213e-18
C568	VPWR#3	VPWR#1	1.79214e-18
C569	VGND	a_230_424#	5.95151e-18
C570	VPWR	a_840_395##3	5.99214e-19
C571	VGND	GATE_N#1	3.19324e-18
C572	VPWR#13	VNB	3.99997e-18
C573	VPWR	a_230_424##8	1.50579e-18
C574	a_369_392##8	VNB	2.37225e-18
C575	VGND	D#4	9.02917e-18
C576	VPWR#2	Q	3.96969e-18
C577	VPWR	a_369_392#	1.35752e-18
C578	a_230_424##13	VNB	3.08463e-17
C579	a_369_392##8	a_675_392##10	6.04322e-18
C580	VPWR#14	VNB	4.57468e-18
C581	VGND#2	Q	5.00896e-18
C582	VPWR	a_27_115##3	5.55994e-19
C583	VGND#12	a_27_115#	1.34444e-19
C584	a_27_115##7	VNB	5.37435e-17
C585	a_840_395##10	VNB	3.17025e-17
C586	VPWR	a_230_424##4	8.08209e-18
C587	a_840_395##11	VNB	2.56398e-17
C588	VPWR	GATE_N#3	2.62094e-18
C589	a_840_395##17	a_840_395##5	1.65914e-19
C590	a_840_395##13	VNB	2.49939e-17
C591	a_840_395##9	VNB	3.10223e-17
C592	VPWR	D#1	1.01421e-18
C593	a_675_392##5	VNB	2.93484e-17
C594	a_840_395##7	Q	2.11155e-17
C595	a_675_392##6	VNB	3.32327e-17
C596	a_675_392##8	a_230_424##7	3.78582e-17
C597	a_840_395#	VNB	4.45224e-17
C598	a_369_392##3	VNB	2.02617e-17
C599	a_230_424##7	VNB	3.34908e-17
C600	a_840_395##18	a_230_424##6	3.36998e-19
C601	VPWR#7	a_27_115##3	9.49615e-19
C602	a_27_115#	VNB	4.07718e-17
C603	a_230_424#	VNB	3.75542e-17
C604	VPWR	VPWR#6	4.58397e-17
C605	GATE_N#1	VNB	2.99873e-17
C606	a_27_115##2	a_230_424##6	1.47476e-18
C607	D#4	VNB	3.85666e-17
C608	a_675_392##2	a_840_395##15	5.63039e-18
C609	VPWR	a_840_395##7	4.75327e-18
C610	a_840_395##4	VNB	3.50822e-17
C611	a_840_395##12	VNB	2.77942e-17
C612	VPWR	a_675_392##3	7.15272e-18
C613	D	D#3	1.19481e-17
C614	a_840_395##14	VNB	2.95249e-17
C615	VPWR	a_840_395##2	7.43696e-18
C616	a_840_395##15	VNB	3.48131e-17
C617	a_675_392#	VNB	3.41335e-17
C618	a_675_392##4	VNB	3.38885e-17
C619	a_230_424##13	a_675_392##10	3.04107e-17
C620	a_840_395##3	VNB	2.96278e-17
C621	VPWR	a_230_424##5	3.36696e-17
C622	VPWR#5	a_27_115##3	2.92681e-20
C623	a_230_424##8	VNB	3.83457e-17
C624	VGND	VGND#6	4.90421e-17
C625	VPWR	a_369_392##2	6.29876e-18
C626	a_369_392#	VNB	3.07961e-17
C627	VGND	a_840_395##7	4.80604e-18
C628	a_27_115##3	VNB	3.51412e-17
C629	VPWR	a_27_115##2	3.84015e-18
C630	a_230_424##4	VNB	4.41967e-17
C631	VGND	a_675_392##3	5.29094e-18
C632	GATE_N#3	VNB	4.03959e-17
C633	VGND	a_840_395##2	3.6725e-19
C634	D#1	VNB	4.56438e-17
C635	VGND	a_369_392##4	4.80545e-17
C636	VPWR	GATE_N#2	4.61305e-18
C637	VPWR#2	VNB	1.28669e-16
C638	VGND	a_230_424##5	4.24027e-18
C639	a_840_395##20	a_675_392##2	2.36603e-19
C640	VGND#2	VNB	1.29079e-16
C641	VGND	a_369_392##2	2.77797e-18
C642	VPWR#6	VNB	2.67029e-17
C643	VGND	a_27_115##2	2.77937e-17
C644	VGND#6	VNB	2.95377e-17
C645	a_840_395##7	VNB	5.01392e-17
C646	VGND	a_230_424##3	1.0835e-17
C647	a_675_392##8	a_27_115#	1.74216e-18
C648	a_675_392##3	VNB	5.6233e-17
C649	VGND	GATE_N#2	3.32654e-18
C650	a_840_395##2	VNB	7.6239e-17
C651	a_369_392##4	VNB	6.82579e-17
C652	a_230_424##5	VNB	3.71719e-17
C653	a_369_392##2	VNB	2.8682e-17
C654	a_840_395##17	a_675_392##2	1.85859e-17
C655	a_27_115##2	VNB	4.87118e-17
C656	a_230_424##3	VNB	1.29396e-16
C657	VGND#13	a_230_424##7	1.54274e-18
C658	GATE_N#2	VNB	3.9378e-17
C659	D#3	VNB	7.53583e-17
C660	a_369_392##8	a_230_424##6	6.69751e-20
C661	VPWR#7	a_230_424##4	5.95255e-18
C662	VPWR	D	4.46943e-18
C663	D	VNB	1.07874e-17
C664	Q	VNB	5.89287e-17
C665	VPWR	VNB	2.98589e-16
C666	VGND	VNB	3.03517e-16
C667	VPWR#8	VNB	6.14371e-17
C668	VPWR	VPWR#8	1.07224e-16
C669	D	VPWR#8	4.94776e-19
C670	VPWR#8	VPWR#7	1.43377e-19
C671	VPWR#8	D#3	4.32648e-19
C672	GATE_N#2	VPWR#8	8.89311e-19
C673	VPWR#8	a_230_424##3	7.68939e-20
C674	a_27_115##7	VPWR#8	2.09733e-17
C675	a_230_424##13	VPWR#8	2.69208e-17
C676	VPWR#8	VPWR#13	1.45689e-19
C677	VPWR#8	D#1	2.57626e-18
C678	VPWR#8	GATE_N#3	7.69843e-18
C679	VGND#8	GATE_N#1	5.6428e-18
C680	VGND#8	GATE_N#2	2.93588e-20
C681	VGND#8	a_230_424#	6.27871e-19
C682	VGND#8	a_230_424##3	1.04783e-18
C683	VGND#8	VNB	8.12258e-17
C684	VGND#8	a_27_115##6	1.26822e-16
C685	VGND	VGND#8	1.26616e-16
C686	VGND#8	VGND#14	6.30784e-18
C687	VGND#8	D#4	8.2294e-18
C688	VGND#8	D#3	2.46214e-19
*
*
.ENDS sky130_fd_sc_hs__dlxtn_4
*
