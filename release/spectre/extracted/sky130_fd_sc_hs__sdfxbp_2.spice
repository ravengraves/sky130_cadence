* Extracted by Quantus, converted by sky130cad/quantus.py
*
*
*
*                       LINUX           Wed Nov 18 09:11:06 2026
*
*
*
*  PROGRAM  advgen
*
*  Name           : advgen - Quantus - (64-bit)
*  Version        : 25.1.0-p047
*  Build Date     : Thu Dec 11 23:20:30 PST 2025
*
*  HSPICE LIBRARY
*
*  OPERATING_TEMPERATURE 150
*  QRC_TECH_DIR <path>/tech
*
*
*

*
.SUBCKT sky130_fd_sc_hs__sdfxbp_2 VNB VPB VGND VPWR Q Q_N SCE CLK D SCD
*
*
*  caps2d version: 10
*
*
*       TRANSISTOR CARDS
*
*
XM3 a_36_74##8 SCE#4 VGND#21 VNB sky130_fd_pr__nfet_01v8_lvt l=0.15 w=0.42 ad=0.1197 as=0.147 pd=1.41 ps=1.54
XM36 VGND#21 a_36_74# a_223_74# VNB sky130_fd_pr__nfet_01v8_lvt l=0.15 w=0.42 ad=0.147 as=0.1008 pd=1.54 ps=1.32
XM34 a_223_74# D#3 a_301_74##4 VNB sky130_fd_pr__nfet_01v8_lvt l=0.15 w=0.42 ad=0.1008 as=0.2499 pd=1.32 ps=2.03
XM10 a_301_74##4 SCE#6 a_450_74# VNB sky130_fd_pr__nfet_01v8_lvt l=0.15 w=0.42 ad=0.2499 as=0.1008 pd=2.03 ps=1.32
XM23 a_450_74# SCD#1 VGND#20 VNB sky130_fd_pr__nfet_01v8_lvt l=0.15 w=0.42 ad=0.1008 as=0.2424 pd=1.32 ps=2.2
XM29 VGND#20 CLK#3 a_630_74##14 VNB sky130_fd_pr__nfet_01v8_lvt l=0.15 w=0.74 ad=0.2424 as=0.2109 pd=2.2 ps=2.05
XM37 VGND#19 a_630_74##8 a_828_74##13 VNB sky130_fd_pr__nfet_01v8_lvt l=0.15 w=0.74 ad=0.2109 as=0.1998 pd=2.05 ps=2.02
XM4 a_301_74# a_630_74##6 a_1021_97##6 VNB sky130_fd_pr__nfet_01v8_lvt l=0.15 w=0.42 ad=0.1155 as=0.2562 pd=1.39 ps=2.06
XM20 a_1021_97##6 a_828_74##3 a_1173_97# VNB sky130_fd_pr__nfet_01v8_lvt l=0.15 w=0.42 ad=0.2562 as=0.16425 pd=2.06 ps=1.77
XM21 a_1173_97# a_1243_48##3 VGND#18 VNB sky130_fd_pr__nfet_01v8_lvt l=0.15 w=0.42 ad=0.16425 as=0.2887 pd=1.77 ps=2.32
XM11 VGND#18 a_1021_97##3 a_1243_48##4 VNB sky130_fd_pr__nfet_01v8_lvt l=0.15 w=0.55 ad=0.2887 as=0.154 pd=2.32 ps=1.66
XM22 a_1243_48##4 a_828_74##6 a_1511_74##6 VNB sky130_fd_pr__nfet_01v8_lvt l=0.15 w=0.55 ad=0.154 as=0.2887 pd=1.66 ps=2.32
XM24 a_1511_74##6 a_630_74##9 a_1663_74# VNB sky130_fd_pr__nfet_01v8_lvt l=0.15 w=0.42 ad=0.2887 as=0.1008 pd=2.32 ps=1.32
XM19 a_1663_74# a_1711_48##3 VGND#17 VNB sky130_fd_pr__nfet_01v8_lvt l=0.15 w=0.42 ad=0.1008 as=0.3866 pd=1.32 ps=2.94
XM35 VGND#17 a_1511_74##3 a_1711_48##19 VNB sky130_fd_pr__nfet_01v8_lvt l=0.15 w=0.74 ad=0.3866 as=0.2109 pd=2.94 ps=2.05
XM27 VGND#16 a_1711_48##12 Q#1 VNB sky130_fd_pr__nfet_01v8_lvt l=0.15 w=0.74 ad=0.2627 as=0.2072 pd=2.19 ps=2.04
XM39 Q#1 a_1711_48##10 VGND#8 VNB sky130_fd_pr__nfet_01v8_lvt l=0.15 w=0.74 ad=0.2072 as=0.2109 pd=2.04 ps=2.05
XM13 a_2322_368##10 a_1711_48##4 VGND#5 VNB sky130_fd_pr__nfet_01v8_lvt l=0.15 w=0.64 ad=0.1824 as=0.2589 pd=1.85 ps=2.2
XM17 VGND#5 a_2322_368##5 Q_N#2 VNB sky130_fd_pr__nfet_01v8_lvt l=0.15 w=0.74 ad=0.2589 as=0.2183 pd=2.2 ps=2.07
XM14 Q_N#2 a_2322_368##4 VGND#1 VNB sky130_fd_pr__nfet_01v8_lvt l=0.15 w=0.74 ad=0.2183 as=0.1962 pd=2.07 ps=2.05
XM30 a_36_74##9 SCE#5 VPWR#18 VPB sky130_fd_pr__pfet_01v8 l=0.15 w=0.64 ad=0.2432 as=0.192 pd=2.04 ps=1.88
XM9 VPWR#18 SCE#1 a_238_453# VPB sky130_fd_pr__pfet_01v8 l=0.15 w=0.64 ad=0.192 as=0.1728 pd=1.88 ps=1.82
XM15 a_238_453# D#1 a_301_74##6 VPB sky130_fd_pr__pfet_01v8 l=0.15 w=0.64 ad=0.1728 as=0.2272 pd=1.82 ps=1.99
XM16 a_301_74##6 a_36_74##3 a_423_453# VPB sky130_fd_pr__pfet_01v8 l=0.15 w=0.64 ad=0.2272 as=0.2144 pd=1.99 ps=1.95
XM7 a_423_453# SCD#3 VPWR#16 VPB sky130_fd_pr__pfet_01v8 l=0.15 w=0.64 ad=0.2144 as=0.519675 pd=1.95 ps=3.48
XM28 VPWR#16 CLK#1 a_630_74##12 VPB sky130_fd_pr__pfet_01v8 l=0.15 w=1.12 ad=0.519675 as=0.5656 pd=3.48 ps=3.25
XM26 VPWR#13 a_630_74##7 a_828_74##16 VPB sky130_fd_pr__pfet_01v8 l=0.15 w=1.12 ad=0.3304 as=0.3304 pd=2.83 ps=2.83
XM8 a_301_74##5 a_828_74# a_1021_97##7 VPB sky130_fd_pr__pfet_01v8 l=0.15 w=0.42 ad=0.1239 as=0.1617 pd=1.43 ps=1.61
XM5 a_1021_97##7 a_630_74# a_1217_499# VPB sky130_fd_pr__pfet_01v8 l=0.15 w=0.42 ad=0.1617 as=0.1134 pd=1.61 ps=1.38
XM32 a_1217_499# a_1243_48# VPWR#11 VPB sky130_fd_pr__pfet_01v8 l=0.15 w=0.42 ad=0.1134 as=0.379125 pd=1.38 ps=3.07
XM2 VPWR#11 a_1021_97# a_1243_48##7 VPB sky130_fd_pr__pfet_01v8 l=0.15 w=0.84 ad=0.379125 as=0.5418 pd=3.07 ps=2.97
XM38 a_1243_48##7 a_630_74##11 a_1511_74##7 VPB sky130_fd_pr__pfet_01v8 l=0.15 w=0.84 ad=0.5418 as=0.2856 pd=2.97 ps=2.45
XM18 a_1511_74##7 a_828_74##8 a_1691_508# VPB sky130_fd_pr__pfet_01v8 l=0.15 w=0.42 ad=0.2856 as=0.1134 pd=2.45 ps=1.38
XM25 a_1691_508# a_1711_48# VPWR#9 VPB sky130_fd_pr__pfet_01v8 l=0.15 w=0.42 ad=0.1134 as=0.4015 pd=1.38 ps=3.18
XM0 VPWR#9 a_1511_74# a_1711_48##16 VPB sky130_fd_pr__pfet_01v8 l=0.15 w=1 ad=0.4015 as=0.285 pd=3.18 ps=2.57
XM6 VPWR#7 a_1711_48##13 Q#3 VPB sky130_fd_pr__pfet_01v8 l=0.15 w=1.12 ad=0.3192 as=0.336 pd=2.81 ps=2.84
XM31 Q#3 a_1711_48##11 VPWR#6 VPB sky130_fd_pr__pfet_01v8 l=0.15 w=1.12 ad=0.336 as=0.3192 pd=2.84 ps=2.81
XM1 a_2322_368##9 a_1711_48##9 VPWR#5 VPB sky130_fd_pr__pfet_01v8 l=0.15 w=1 ad=0.285 as=0.4092 pd=2.57 ps=2.99
XM33 VPWR#5 a_2322_368##6 Q_N#1 VPB sky130_fd_pr__pfet_01v8 l=0.15 w=1.12 ad=0.4092 as=0.336 pd=2.99 ps=2.84
XM12 Q_N#1 a_2322_368# VPWR#1 VPB sky130_fd_pr__pfet_01v8 l=0.15 w=1.12 ad=0.336 as=0.3192 pd=2.84 ps=2.81
*
*
*       RESISTOR AND CAP/DIODE CARDS
*
Rg1	a_36_74#	a_36_74##2	746.917175
Rg2	SCE#1	SCE#2	455.992371
Rg3	SCE#2	SCE#3	740.259949
Rg4	SCE#3	SCE#4	214.327560
Rg5	SCE#2	SCE#5	234.008942
Rg6	D#1	D#2	442.565857
Rg7	D#2	D#3	594.361633
Rg8	a_36_74##3	a_36_74##4	319.119995
Rg9	SCE#6	SCE#7	254.661270
Rg10	SCD#1	SCD#2	730.667603
Rg11	SCD#2	SCD#3	305.090881
Rg12	CLK#1	CLK#2	416.207306
Rg13	CLK#2	CLK#3	424.725952
Rg14	CLK#2	CLK#4	37.528206
Rg15	a_828_74#	a_828_74##2	454.965027
Rg16	a_828_74##3	a_828_74##4	233.335632
Rg17	a_630_74#	a_630_74##2	281.939758
Rg18	a_630_74##2	a_630_74##3	530.059509
Rg19	a_630_74##3	a_630_74##4	287.966156
Rg20	a_630_74##4	a_630_74##5	221.679138
Rg21	a_630_74##3	a_630_74##6	535.286499
Rg22	a_630_74##4	a_630_74##7	371.735809
Rg23	a_630_74##5	a_630_74##8	382.539734
Rg24	a_1243_48#	a_1243_48##2	658.126221
Rg25	a_1243_48##2	a_1243_48##3	348.372070
Rg26	a_1021_97#	a_1021_97##2	353.619843
Rg27	a_1021_97##2	a_1021_97##3	581.789062
Rg28	a_828_74##5	a_828_74##6	409.071228
Rg29	a_630_74##9	a_630_74##10	675.433655
Rg30	a_630_74##10	a_630_74##11	359.194885
Rg31	a_828_74##7	a_828_74##8	648.614563
Rg32	a_1711_48#	a_1711_48##2	233.787552
Rg33	a_1711_48##2	a_1711_48##3	960.649414
Rg34	a_1511_74#	a_1511_74##2	507.620972
Rg35	a_1511_74##2	a_1511_74##3	305.727875
Rg36	a_1711_48##4	a_1711_48##5	303.082855
Rg37	a_1711_48##5	a_1711_48##6	502.221588
Rg38	a_1711_48##6	a_1711_48##7	188.173859
Rg39	a_1711_48##7	a_1711_48##8	45.616405
Rg40	a_1711_48##5	a_1711_48##9	490.655548
Rg41	a_1711_48##6	a_1711_48##10	342.008240
Rg42	a_1711_48##6	a_1711_48##11	523.915405
Rg43	a_1711_48##7	a_1711_48##12	367.764618
Rg44	a_1711_48##7	a_1711_48##13	471.250305
Rg45	a_2322_368#	a_2322_368##2	462.979767
Rg46	a_2322_368##2	a_2322_368##3	56.190357
Rg47	a_2322_368##2	a_2322_368##4	368.862610
Rg48	a_2322_368##3	a_2322_368##5	372.453491
Rg49	a_2322_368##3	a_2322_368##6	464.927643
Rf1	D#2	D	171.649307
Rf2	SCE#3	SCE	202.828873
Rf3	SCE	SCE#7	167.422516
Rf4	a_36_74##4	a_36_74##2	268.180573
Rf5	a_36_74##2	a_36_74##7	10.438768
Rf6	a_36_74##7	a_36_74##8	81.225296
Rf7	a_36_74##7	a_36_74##9	37.241928
Rf8	SCD#2	SCD#5	161.452484
Rf9	SCD#6	SCD	1.219682
Rf10	SCD#5	SCD#6	3.536082
Rf11	CLK#4	CLK#6	162.577271
Rf12	CLK#7	CLK	2.344470
Rf13	CLK#6	CLK#7	5.195247
Rf14	a_630_74##12	a_630_74##13	65.709595
Rf15	a_630_74##13	a_630_74##14	86.089279
Rf16	a_301_74#	a_301_74##2	136.717438
Rf17	a_301_74##2	a_301_74##3	98.083748
Rf18	a_301_74##3	a_301_74##4	213.506393
Rf19	a_301_74##2	a_301_74##5	71.254333
Rf20	a_301_74##3	a_301_74##6	86.406464
Rf21	a_1021_97##2	a_1021_97##5	247.752869
Rf22	a_1021_97##5	a_1021_97##6	81.024231
Rf23	a_1021_97##5	a_1021_97##7	87.038002
Rf24	a_1243_48##4	a_1243_48##5	50.975616
Rf25	a_1243_48##5	a_1243_48##2	193.750305
Rf26	a_1243_48##5	a_1243_48##7	85.102531
Rf27	a_630_74##10	a_630_74##2	524.666870
Rf28	a_828_74##7	a_828_74##5	221.064148
Rf29	a_828_74##5	a_828_74##11	195.052994
Rf30	a_828_74##11	a_828_74##12	94.415939
Rf31	a_828_74##12	a_828_74##13	83.712166
Rf32	a_828_74##11	a_828_74##4	183.591599
Rf33	a_828_74##12	a_828_74##2	126.560333
Rf34	a_828_74##2	a_828_74##16	37.626495
Rf35	a_1511_74##2	a_1511_74##5	195.024704
Rf36	a_1511_74##5	a_1511_74##6	102.249504
Rf37	a_1511_74##5	a_1511_74##7	145.751175
Rf38	a_1711_48##8	a_1711_48##15	92.930450
Rf39	a_1711_48##15	a_1711_48##17	54.969967
Rf40	a_1711_48##17	a_1711_48##2	191.788269
Rf41	a_1711_48##15	a_1711_48##19	70.268784
Rf42	a_1711_48##16	a_1711_48##17	5.000000
Rf43	Q#2	Q	7.282945
Rf44	Q	Q#3	95.256004
Rf45	Q#2	Q	7.282945
Rf46	Q#1	Q#2	7.500000
Rf47	a_2322_368##3	a_2322_368##8	186.464737
Rf48	a_2322_368##8	a_2322_368##9	38.233078
Rf49	a_2322_368##8	a_2322_368##10	31.033260
Rf50	Q_N#1	Q_N	38.867634
Rf51	Q_N	Q_N#2	48.530689
Rf52	VPWR#1	VPWR#2	97.562767
Rf53	VPWR#2	VPWR#3	74.885040
Rf54	VPWR#3	VPWR#4	84.421844
Rf55	VPWR#2	VPWR#5	48.259808
Rf56	VPWR#3	VPWR#6	38.286041
Rf57	VPWR#4	VPWR#7	52.877037
Rf58	VPWR#4	VPWR#8	68.260757
Rf59	VPWR#8	VPWR#9	25.018780
Rf60	VPWR#8	VPWR#10	175.620453
Rf61	VPWR#10	VPWR#11	23.090988
Rf62	VPWR#10	VPWR#12	182.577164
Rf63	VPWR#12	VPWR#13	32.342297
Rf64	VPWR#12	VPWR#14	64.259903
Rf65	VPWR#14	VPWR#15	35.003517
Rf66	VPWR#15	VPWR#16	26.582312
Rf67	VPWR#15	VPWR#17	145.285233
Rf68	VPWR#17	VPWR#18	33.503098
Rf70	VGND#1	VGND#2	93.564705
Rf71	VGND#2	VGND#3	75.250298
Rf72	VGND#3	VGND#4	88.570015
Rf73	VGND#2	VGND#6	18.326479
Rf75	VGND#3	VGND#8	41.038895
Rf76	VGND#4	VGND#9	76.397560
Rf77	VGND#9	VGND#10	184.853012
Rf78	VGND#10	VGND#11	193.899994
Rf79	VGND#11	VGND#12	35.770210
Rf80	VGND#12	VGND#13	39.480083
Rf81	VGND#13	VGND#14	145.744019
Rf83	VGND#4	VGND#16	36.804161
Rf84	VGND#9	VGND#17	15.965190
Rf85	VGND#10	VGND#18	31.948624
Rf86	VGND#11	VGND#19	35.098007
Rf87	VGND#13	VGND#20	41.038895
Rf88	VGND#14	VGND#21	32.932804
Rf89	VGND#5	VGND#6	7.500000
Rf97	a_630_74##5	a_630_74##13	160.232803
Re1	VPWR#4	VPWR	1.989084
Re2	VPWR	VPWR#14	1.989084
Re3	VGND#4	VGND	1.989084
Re4	VGND	VGND#12	1.989084
*
*       CAPACITOR CARDS
*
*
C1	a_1711_48##3	a_1711_48##2	1.31353e-18
C2	a_301_74##4	SCE#7	8.52629e-17
C3	a_1511_74##3	a_1711_48##12	4.26395e-18
C4	a_630_74##14	a_828_74##13	2.43825e-18
C5	a_630_74##10	VPWR#10	1.73153e-17
C6	a_1711_48##19	a_1711_48##3	1.14273e-18
C7	a_301_74##2	VPWR#13	4.30664e-17
C8	a_1511_74##5	a_1511_74##2	1.96912e-17
C9	VPWR#10	a_630_74##11	4.3604e-18
C10	a_301_74##4	a_301_74##6	7.04469e-18
C11	Q#3	a_1711_48##11	3.19338e-17
C12	VPWR#10	a_1511_74##7	3.22797e-18
C13	a_301_74##3	VPWR#14	2.59678e-17
C14	VGND#8	VPWR#6	8.51651e-18
C15	VGND#13	a_301_74##4	2.32568e-17
C16	VGND#11	a_630_74##6	3.27172e-18
C17	a_1711_48##5	a_2322_368##3	1.74661e-17
C18	VGND#12	CLK#3	4.72367e-18
C19	a_630_74##10	VPWR#8	4.57977e-19
C20	a_630_74#	a_1243_48#	3.31348e-17
C21	a_1021_97##7	a_828_74##2	2.58856e-17
C22	a_301_74##3	a_630_74##12	6.11588e-17
C23	VPWR#6	a_1711_48##13	1.47207e-18
C24	VPWR#8	a_630_74##11	4.27001e-18
C25	a_301_74##2	VPWR#14	1.80867e-17
C26	a_1711_48##3	a_828_74##7	3.19568e-17
C27	VGND#12	a_1021_97##5	2.50447e-18
C28	a_301_74##3	a_238_453#	1.52544e-20
C29	VGND#12	SCD#1	1.83103e-18
C30	a_1711_48##15	a_1711_48##2	7.86428e-19
C31	a_1711_48##3	VGND#17	1.35409e-17
C32	VPWR#7	a_1711_48##11	6.1097e-19
C33	a_828_74##2	a_301_74##5	3.90918e-17
C34	a_1511_74##5	a_1711_48##13	3.75404e-19
C35	a_1711_48##15	VGND#16	5.56876e-17
C36	D#2	a_301_74##4	1.00612e-17
C37	VGND#11	a_630_74##4	1.45727e-19
C38	a_828_74##7	a_630_74##9	1.53526e-17
C39	a_630_74##14	VGND#19	4.24409e-17
C40	a_1511_74##7	VPWR#8	3.16326e-17
C41	a_1511_74##6	a_1511_74##3	1.86527e-19
C42	a_828_74##16	a_828_74##2	1.0029e-17
C43	Q#3	a_1711_48##13	5.57296e-17
C44	VGND#12	SCE#6	3.0627e-18
C45	a_1711_48##15	a_1511_74#	2.11588e-19
C46	a_1711_48##19	a_630_74##9	2.72847e-19
C47	VGND#13	a_630_74##8	3.25022e-19
C48	a_630_74##14	a_301_74##3	1.949e-18
C49	VPWR#4	a_2322_368#	4.67557e-19
C50	a_301_74##2	a_630_74##12	6.665e-17
C51	a_1711_48##3	a_1511_74##3	1.57499e-17
C52	a_2322_368##10	VGND#5	3.15691e-17
C53	a_828_74#	a_630_74#	1.57117e-17
C54	a_1511_74##5	a_1711_48##2	5.43678e-17
C55	VGND#12	a_301_74##3	5.40136e-18
C56	VGND#12	D#3	1.23823e-18
C57	VPWR#10	a_828_74##5	1.54244e-19
C58	a_1711_48##15	a_1711_48##10	1.14539e-20
C59	VPWR#10	a_1021_97#	1.52725e-17
C60	a_1711_48##13	VPWR#7	2.07714e-17
C61	VPWR#4	a_2322_368##6	2.41773e-18
C62	a_301_74##3	VPWR#16	5.51065e-17
C63	VGND#11	a_630_74##8	6.94501e-18
C64	VGND#12	a_301_74##2	1.34419e-18
C65	a_1711_48##8	a_1711_48##6	1.18883e-17
C66	VGND#12	a_36_74#	4.0772e-19
C67	a_1711_48##15	Q#3	9.84707e-18
C68	a_301_74##4	a_36_74##2	7.28729e-19
C69	Q#3	a_1511_74#	2.13963e-20
C70	VGND#20	VGND#19	2.21116e-18
C71	VPWR#8	a_1021_97#	3.78976e-19
C72	a_828_74##5	a_1711_48##3	5.8028e-19
C73	a_301_74##3	SCD#5	3.23465e-17
C74	a_1511_74##6	a_1711_48##3	2.99135e-18
C75	VPWR#4	a_1711_48##9	8.74535e-18
C76	a_630_74##5	VPWR#13	1.42362e-18
C77	a_1711_48##16	a_1711_48##13	1.75856e-18
C78	a_1511_74##5	a_1511_74#	1.66612e-18
C79	D#2	CLK#2	3.23248e-19
C80	Q#1	Q#3	2.91113e-18
C81	VGND#12	SCE#4	1.59063e-18
C82	a_1711_48##15	a_1711_48##19	3.63242e-19
C83	a_828_74##5	a_630_74##9	3.15198e-17
C84	VGND#21	a_36_74##2	5.26539e-19
C85	a_630_74##7	a_828_74#	5.89915e-18
C86	a_630_74##5	a_630_74##12	1.67553e-18
C87	SCE#2	D#2	6.98305e-19
C88	a_1243_48##5	a_1511_74##5	4.76761e-19
C89	VGND#8	VGND#5	8.01401e-18
C90	VGND#11	a_630_74##3	2.26903e-20
C91	VPWR#7	a_1511_74#	2.64139e-18
C92	VGND#20	a_301_74##3	2.27017e-17
C93	VPWR#4	a_1711_48##11	3.87215e-18
C94	a_301_74##2	VPWR#16	7.82403e-20
C95	VPWR#14	SCD#6	3.54009e-18
C96	a_828_74##5	a_828_74##6	2.07696e-17
C97	VGND#13	CLK#3	4.50111e-18
C98	VGND#10	a_630_74##2	2.09965e-20
C99	a_630_74##9	a_1711_48##3	4.48274e-17
C100	a_828_74##7	a_1511_74##5	7.7817e-17
C101	a_301_74##4	SCE#3	3.79894e-19
C102	a_1711_48##15	a_1711_48##12	1.843e-19
C103	VPWR#10	a_1021_97##2	6.84457e-19
C104	VPWR#4	a_1711_48##13	1.01186e-17
C105	VPWR#10	a_1243_48#	1.2186e-17
C106	VGND#20	a_630_74##14	6.5991e-17
C107	a_828_74##5	a_1021_97##3	2.41598e-17
C108	a_1711_48##16	a_1511_74#	9.05352e-17
C109	VPWR#10	VPWR#11	8.09282e-18
C110	a_1511_74##6	a_630_74##9	5.30277e-17
C111	a_301_74#	a_630_74##4	7.68513e-18
C112	CLK#4	a_630_74##12	1.90391e-17
C113	a_1711_48##15	VPWR#7	2.83268e-17
C114	SCE#3	VGND#21	4.93957e-17
C115	CLK#1	a_630_74##7	3.82455e-18
C116	VGND#11	CLK#3	8.67553e-19
C117	VPWR#4	a_1511_74#	8.24638e-19
C118	VPWR#7	a_1711_48#	1.32428e-19
C119	Q_N#2	a_2322_368##2	9.79581e-19
C120	VGND#18	a_1711_48##3	3.61882e-20
C121	a_36_74##8	SCE#3	4.85273e-17
C122	a_1511_74#	VPWR#9	1.23409e-17
C123	VGND#8	a_2322_368##10	5.26966e-17
C124	VPWR#4	a_1711_48#	1.01933e-18
C125	a_1711_48##16	a_1711_48#	1.58738e-18
C126	a_630_74##12	SCD#2	6.9042e-19
C127	VGND#11	CLK#2	1.57422e-19
C128	a_630_74##10	a_1511_74##5	2.54611e-18
C129	a_828_74##6	a_630_74##9	1.0942e-17
C130	VPWR#4	a_828_74##8	2.37299e-18
C131	a_828_74##6	a_1511_74##6	1.69465e-17
C132	a_301_74#	a_630_74##3	1.16257e-17
C133	VGND#10	a_828_74##4	1.39483e-19
C134	VGND#13	SCD#1	8.14373e-18
C135	a_1711_48##15	a_1511_74##3	1.33231e-18
C136	SCD#3	CLK#1	1.39426e-17
C137	a_1511_74##5	a_1711_48##12	2.53504e-19
C138	SCD#2	VPWR#16	1.00762e-18
C139	a_1243_48##5	a_630_74##3	8.17664e-20
C140	a_1711_48##9	a_2322_368##3	4.38046e-18
C141	a_36_74##2	SCE#2	3.92167e-17
C142	VPWR#10	a_1243_48##2	8.1677e-20
C143	a_1243_48##2	a_1021_97##3	8.53839e-18
C144	VPWR#10	a_630_74#	7.65857e-18
C145	VGND#10	a_630_74##3	5.62028e-20
C146	a_1511_74##5	a_1711_48##19	2.39494e-18
C147	a_1711_48#	VPWR#9	1.26097e-17
C148	VGND#18	a_630_74##9	8.22969e-20
C149	VGND#12	SCD#5	3.11216e-18
C150	VPWR#4	a_630_74##11	1.70169e-18
C151	a_1511_74##5	VPWR#8	9.31795e-19
C152	a_1511_74##7	a_1511_74#	3.38605e-19
C153	VGND#2	a_2322_368##2	4.24677e-20
C154	Q#1	a_2322_368##10	2.26563e-18
C155	a_1711_48##16	a_828_74##8	3.42566e-19
C156	VGND#11	SCD#1	1.21106e-19
C157	a_828_74##6	a_1243_48##4	1.21011e-17
C158	a_301_74##4	a_630_74##14	3.4498e-18
C159	VGND#12	a_36_74##7	2.41944e-18
C160	VPWR#4	a_1021_97#	5.26762e-19
C161	a_828_74##3	a_1243_48##2	1.32713e-18
C162	VGND#4	VGND#1	6.09106e-17
C163	a_828_74##13	a_630_74##4	5.30693e-18
C164	a_36_74##3	SCD#3	2.66183e-17
C165	a_1711_48##8	a_1711_48##11	4.16436e-18
C166	VPWR#12	a_828_74#	4.63631e-18
C167	VGND#4	Q_N#2	8.35481e-18
C168	a_828_74##5	a_1511_74##5	7.41992e-19
C169	a_1021_97##3	a_828_74##6	3.01537e-17
C170	a_1511_74##7	a_1711_48#	3.86587e-18
C171	VGND#18	a_828_74##6	3.53777e-19
C172	VPWR#18	SCE#2	2.24353e-18
C173	a_36_74##4	a_301_74##6	5.6841e-17
C174	SCD#1	CLK#2	2.12692e-18
C175	a_1511_74##5	a_1511_74##3	1.07236e-18
C176	a_36_74##9	SCD#2	4.4541e-20
C177	a_1711_48##16	a_630_74##11	1.55207e-19
C178	a_1021_97##7	a_1243_48##7	4.35083e-19
C179	VGND#3	a_1711_48##6	1.56703e-19
C180	VGND#13	SCE#6	6.22951e-18
C181	Q#1	VGND#8	4.6433e-17
C182	a_630_74##2	VPWR#10	5.7552e-17
C183	VGND#4	VGND#5	1.99361e-17
C184	VPWR#10	a_828_74#	3.55255e-18
C185	a_301_74##4	VGND#20	4.25027e-17
C186	a_1021_97##3	a_1243_48##4	1.3391e-17
C187	a_1021_97##7	VPWR#10	2.08296e-17
C188	D#1	a_36_74##3	2.4435e-17
C189	a_828_74##13	a_630_74##3	9.33259e-21
C190	a_1711_48##19	a_1711_48##16	2.07828e-18
C191	a_1511_74##2	a_1711_48##13	1.58684e-19
C192	a_1021_97##5	a_630_74##3	2.09461e-17
C193	VGND#4	a_2322_368##10	1.63733e-17
C194	SCE#3	SCE#2	2.12604e-18
C195	a_1511_74##7	a_828_74##8	2.0997e-17
C196	a_301_74##6	SCE#7	1.51323e-18
C197	a_1511_74##5	a_1711_48##16	3.10394e-18
C198	a_36_74##9	a_36_74##4	5.74346e-20
C199	VPWR#14	a_1243_48#	8.62213e-18
C200	VGND#2	VGND#1	1.6655e-18
C201	a_1021_97##3	VGND#18	1.83843e-17
C202	a_301_74##5	VPWR#12	1.94605e-17
C203	a_630_74##6	a_828_74##4	4.78511e-18
C204	a_1243_48##5	a_828_74##7	4.54644e-18
C205	VPWR#14	a_630_74#	9.76079e-18
C206	a_828_74##11	a_1173_97#	1.03592e-17
C207	a_1243_48##3	a_1021_97##3	8.20822e-18
C208	VPWR#12	a_630_74##7	9.52345e-19
C209	VGND#16	VGND#8	2.22288e-18
C210	SCE#1	D#1	5.05517e-17
C211	VGND#11	a_630_74##5	9.40838e-21
C212	a_1511_74##5	a_1711_48##3	3.25449e-17
C213	a_1711_48##15	a_1711_48##6	1.44017e-18
C214	a_1711_48##2	a_1511_74#	2.0736e-17
C215	a_828_74##11	a_828_74##5	3.06427e-18
C216	VPWR#14	a_828_74#	9.43537e-18
C217	VGND#3	a_1711_48##5	5.65628e-19
C218	a_1511_74##7	a_630_74##11	4.54415e-17
C219	a_828_74##2	a_630_74##6	9.57386e-19
C220	VPWR#10	a_630_74##7	1.09604e-18
C221	VGND#13	D#3	1.86211e-19
C222	VGND#4	VGND#16	2.2138e-17
C223	a_36_74##9	SCE#2	2.36297e-17
C224	a_828_74##2	a_630_74##8	1.0003e-20
C225	VPWR#14	a_630_74##7	1.81893e-18
C226	VGND#18	a_1243_48##3	2.20139e-17
C227	a_630_74##11	a_1243_48##7	9.72336e-18
C228	a_828_74##8	a_1711_48##2	3.16762e-17
C229	VPWR#15	CLK#1	2.72118e-18
C230	SCE#5	SCE#1	2.97239e-17
C231	VGND#4	a_1711_48##19	3.47215e-17
C232	a_1243_48##5	a_630_74##10	1.59829e-17
C233	a_630_74##5	a_630_74##6	9.20654e-19
C234	VGND#16	Q#1	4.78949e-17
C235	VPWR#14	CLK#1	6.53214e-18
C236	VGND#2	Q_N#2	2.84304e-18
C237	a_1511_74##7	a_1021_97#	2.66074e-18
C238	a_828_74##3	a_1243_48##3	2.03947e-17
C239	a_1711_48##2	a_630_74##11	1.31428e-18
C240	a_630_74##5	a_630_74##8	8.90487e-18
C241	a_1511_74##5	a_630_74##9	2.70131e-19
C242	VPWR#14	SCD#3	8.18353e-18
C243	a_36_74##2	VPWR#18	3.56763e-17
C244	VPWR#12	a_828_74##2	8.40574e-19
C245	a_1711_48##5	a_2322_368##5	4.10793e-19
C246	VGND#3	VGND#5	9.33098e-20
C247	a_828_74##11	a_1021_97##2	1.92875e-18
C248	VGND#13	a_301_74##3	9.44857e-19
C249	a_1243_48##7	a_1021_97#	4.19263e-17
C250	a_36_74##9	a_36_74##2	8.86956e-18
C251	VGND#18	a_828_74##3	1.40547e-18
C252	a_630_74##11	a_828_74##7	3.11525e-18
C253	a_630_74##5	SCD#1	9.32285e-20
C254	VPWR#14	a_36_74##3	1.02649e-17
C255	a_2322_368##3	Q_N#2	3.09473e-17
C256	a_828_74##11	a_1243_48##5	1.3459e-17
C257	VGND#13	a_36_74#	5.55007e-20
C258	SCD#6	a_301_74##6	8.75214e-18
C259	a_828_74##12	a_1021_97##5	8.46821e-20
C260	a_1511_74##7	a_1243_48#	6.39743e-19
C261	a_1021_97##6	a_1243_48##3	5.96255e-19
C262	a_301_74##5	a_1021_97##7	4.65877e-17
C263	VGND#4	a_1511_74##6	1.75571e-17
C264	a_1021_97#	VPWR#11	1.73216e-17
C265	VGND#2	a_1711_48##5	9.76373e-20
C266	a_828_74##5	a_1243_48##5	5.52309e-17
C267	VPWR#14	D#1	1.0415e-17
C268	a_630_74##10	a_630_74##11	1.17298e-17
C269	a_1021_97##7	a_630_74##11	5.75388e-19
C270	VPWR#15	SCD#3	7.72449e-18
C271	a_1243_48##7	a_1243_48#	2.99562e-18
C272	a_630_74##6	a_828_74##3	7.39137e-18
C273	a_630_74##8	a_1243_48##3	7.45113e-20
C274	VGND#4	a_1243_48##4	7.44672e-18
C275	a_630_74##10	a_1021_97#	1.89876e-17
C276	VPWR#14	SCE#1	4.68716e-18
C277	a_2322_368##10	a_1711_48##6	9.12237e-20
C278	a_1711_48##6	a_1711_48##4	4.82048e-20
C279	VGND#21	a_301_74##4	1.2191e-17
C280	VGND#13	SCD#2	4.84334e-20
C281	a_1511_74##7	a_630_74#	3.41071e-19
C282	a_828_74##11	a_1243_48##2	6.64883e-17
C283	VPWR#12	a_630_74##5	1.21306e-19
C284	a_630_74##10	a_1243_48#	1.42182e-19
C285	a_1243_48#	VPWR#11	1.13227e-17
C286	VGND#3	a_2322_368##10	4.9581e-18
C287	a_1021_97##6	a_828_74##3	2.31499e-17
C288	VPWR#14	SCE#5	4.47089e-18
C289	a_1021_97##7	a_1021_97#	1.05125e-18
C290	a_1711_48##19	VGND#16	6.32802e-17
C291	a_828_74##11	a_1021_97##5	1.56436e-18
C292	a_1021_97##2	a_630_74##11	9.81131e-20
C293	a_630_74##10	a_630_74#	5.96729e-20
C294	a_1243_48##7	a_630_74#	3.35379e-19
C295	a_1243_48##5	a_1021_97##2	5.0466e-17
C296	a_301_74##5	a_828_74##16	1.30669e-17
C297	a_1711_48##5	a_2322_368##10	7.57566e-19
C298	a_630_74##8	a_630_74##6	5.93588e-18
C299	VPWR#15	a_36_74##3	5.04163e-18
C300	a_1021_97##5	a_1021_97##2	1.71136e-18
C301	a_828_74##12	a_630_74##2	1.12992e-19
C302	a_301_74##2	a_630_74##4	7.97356e-18
C303	a_1243_48#	a_1021_97##2	2.7701e-18
C304	a_1021_97##7	a_1243_48#	1.83756e-18
C305	a_630_74##14	CLK#2	8.87875e-18
C306	a_630_74##6	a_1021_97##6	1.58499e-17
C307	VGND#2	a_2322_368##10	4.71877e-18
C308	a_828_74##11	a_630_74##2	4.07673e-21
C309	SCE#7	SCD#1	2.43686e-17
C310	a_630_74##2	a_630_74##11	2.59679e-19
C311	a_301_74##3	CLK#2	2.37647e-17
C312	Q#1	a_1711_48##8	1.93511e-18
C313	VPWR#13	a_301_74##5	6.91246e-18
C314	SCE#7	SCE#6	2.57982e-18
C315	a_630_74##2	a_1021_97#	1.92971e-17
C316	VGND#8	a_1711_48##6	7.71925e-18
C317	VPWR#4	a_2322_368##3	4.29162e-18
C318	a_630_74##6	a_301_74#	2.7005e-17
C319	a_1243_48##5	a_1243_48##2	4.2363e-19
C320	a_1021_97##7	a_630_74#	1.04776e-17
C321	a_301_74##6	a_423_453#	5.87822e-18
C322	D#3	SCE#7	1.65787e-17
C323	VGND#16	a_1711_48##8	7.86335e-18
C324	D#2	SCD#1	2.91893e-19
C325	a_630_74##2	a_1243_48#	5.90411e-17
C326	VGND#12	VGND#18	1.60223e-17
C327	VGND#4	a_2322_368##3	3.05694e-18
C328	VPWR#4	a_1711_48##8	1.22618e-18
C329	a_1021_97##5	a_1243_48##2	2.92736e-18
C330	CLK#3	a_630_74##8	4.73594e-18
C331	a_828_74##12	a_828_74##4	4.36826e-19
C332	VPWR#14	a_301_74#	2.45002e-18
C333	a_630_74##2	a_630_74#	1.13588e-17
C334	VGND#9	VGND#16	1.98715e-18
C335	a_828_74##13	a_630_74##6	2.00011e-18
C336	a_36_74##9	a_423_453#	1.77892e-20
C337	VGND#4	a_1711_48##8	2.38538e-18
C338	VPWR#13	a_1243_48#	4.36941e-19
C339	a_828_74##11	a_828_74##4	2.05014e-18
C340	VPWR#16	VPWR#12	4.89924e-19
C341	VPWR#4	a_1511_74##2	3.06313e-18
C342	Q#1	a_1511_74##2	2.59674e-19
C343	a_630_74##2	a_828_74#	6.45356e-19
C344	a_1021_97##7	a_828_74#	2.75155e-17
C345	a_36_74##8	VGND#21	3.43966e-17
C346	a_36_74#	D#2	1.22988e-18
C347	a_301_74#	a_630_74##8	1.97916e-18
C348	a_301_74##4	SCD#5	1.01549e-17
C349	VGND#12	a_1021_97##6	7.71138e-18
C350	VGND#4	a_1511_74##2	5.48174e-18
C351	a_630_74##7	a_630_74##2	5.87293e-19
C352	VPWR#4	a_1711_48##2	7.01014e-18
C353	VGND#13	SCE#7	3.78973e-19
C354	a_1243_48##5	a_630_74##2	3.59402e-19
C355	a_828_74#	a_301_74##5	1.33725e-17
C356	a_828_74##11	a_828_74##6	1.15062e-18
C357	VGND#12	a_301_74#	9.09913e-18
C358	a_828_74##2	a_630_74#	3.33942e-18
C359	VPWR#13	a_630_74#	5.28069e-19
C360	a_1511_74##2	a_1711_48##19	1.20246e-17
C361	VPWR#4	a_828_74##7	3.43902e-18
C362	a_1021_97##5	a_630_74##2	7.79273e-17
C363	SCD#1	CLK#3	3.03469e-17
C364	a_828_74##13	a_630_74##8	1.74102e-17
C365	a_1021_97##7	a_630_74##7	1.00983e-18
C366	VPWR#15	VPWR#12	9.53834e-20
C367	a_828_74##12	a_828_74##2	1.79595e-18
C368	VGND#12	a_828_74##13	2.29069e-17
C369	Q#1	a_1711_48##6	1.58772e-17
C370	a_630_74##14	a_630_74##6	7.17798e-20
C371	a_1511_74##2	VGND#17	1.74514e-18
C372	VGND#4	a_828_74##7	3.90683e-18
C373	VPWR#4	a_630_74##10	2.12109e-17
C374	a_630_74##7	a_828_74##2	1.09461e-17
C375	VGND#9	a_1711_48##19	4.31352e-17
C376	SCE#3	a_36_74#	3.69391e-17
C377	a_630_74##12	VPWR#13	1.95385e-18
C378	a_301_74##5	a_630_74##7	3.28845e-18
C379	VGND#19	a_630_74##8	3.98634e-17
C380	VPWR#15	a_36_74##4	2.16739e-19
C381	VGND#4	a_630_74##10	3.14187e-18
C382	VPWR#13	a_828_74#	2.80369e-18
C383	VPWR#4	a_828_74##5	7.96e-19
C384	a_301_74##2	a_630_74##2	1.51641e-20
C385	VPWR#4	VPWR#1	6.54355e-17
C386	a_828_74##4	a_1243_48##5	1.97195e-19
C387	a_630_74##5	a_630_74##7	1.46491e-18
C388	a_1511_74##2	a_1711_48##8	2.42307e-17
C389	VGND#12	a_630_74##14	3.53785e-17
C390	a_828_74##13	CLK#3	3.06189e-19
C391	a_630_74##7	a_828_74##16	2.26702e-17
C392	a_828_74##11	a_1021_97##3	2.32368e-17
C393	VGND#4	a_828_74##5	2.76705e-17
C394	a_1511_74##6	a_1711_48##19	2.16576e-18
C395	VGND#16	VGND#3	3.6697e-19
C396	VPWR#4	a_1021_97##2	2.76501e-18
C397	VPWR#14	a_301_74##4	3.66258e-18
C398	CLK	CLK#2	5.22015e-18
C399	SCE#6	SCD#1	3.2222e-17
C400	CLK#1	a_630_74##5	1.5279e-18
C401	a_1021_97##5	a_828_74##4	5.21785e-17
C402	a_301_74##6	VPWR#15	9.21409e-18
C403	a_630_74##14	a_630_74##8	2.0103e-18
C404	VPWR#4	Q_N#1	1.6049e-17
C405	Q#1	a_1711_48##5	4.37828e-19
C406	VPWR#16	VPWR#13	5.51062e-18
C407	VPWR#13	a_630_74##7	5.50542e-17
C408	VGND#4	a_1021_97##2	1.60977e-18
C409	VGND#19	CLK#3	1.87177e-18
C410	a_1711_48##2	a_1511_74##2	2.27202e-17
C411	CLK#4	CLK#1	1.94401e-18
C412	a_828_74##12	a_1243_48##3	1.72202e-19
C413	a_828_74##11	a_1243_48##4	3.04959e-17
C414	VPWR#14	a_1021_97##2	2.99953e-18
C415	VGND#20	a_630_74##8	5.19508e-19
C416	VGND#4	a_1243_48##2	5.3094e-19
C417	a_630_74##12	a_630_74##7	1.82402e-18
C418	VGND#9	VGND#17	1.02424e-17
C419	VPWR#4	a_630_74##2	3.67132e-18
C420	VGND#13	VGND#11	1.16054e-18
C421	VPWR#15	SCE#7	6.51851e-20
C422	VPWR#4	a_2322_368##9	1.74043e-17
C423	VGND#12	a_301_74##4	3.29993e-17
C424	SCD#2	CLK#1	1.42871e-17
C425	VGND#12	a_1021_97##2	2.37883e-18
C426	VGND#4	Q_N#1	1.1343e-18
C427	a_630_74##14	CLK#3	5.60535e-17
C428	VPWR#13	CLK#1	4.09637e-18
C429	a_828_74##7	a_1711_48##2	2.91164e-17
C430	a_828_74##11	a_1243_48##3	2.20331e-17
C431	D#3	SCE#6	9.34785e-18
C432	VPWR#16	a_630_74##7	1.89178e-18
C433	a_828_74##2	a_1021_97##5	8.57228e-17
C434	VGND#12	a_1243_48##2	2.95272e-18
C435	VGND#19	SCD#1	1.7829e-19
C436	a_36_74##4	CLK#1	2.39175e-19
C437	VPWR#14	a_630_74##2	1.89263e-17
C438	a_36_74##3	SCD#2	1.16935e-18
C439	a_630_74##10	a_1711_48##2	8.38231e-20
C440	a_630_74##12	CLK#1	3.50427e-17
C441	CLK#3	VGND#20	1.8989e-17
C442	VGND#12	VGND#21	1.81643e-17
C443	Q#3	VPWR#4	2.40971e-17
C444	VGND#4	VGND#10	4.70443e-17
C445	a_828_74##12	a_828_74##3	3.7228e-18
C446	Q_N#1	VPWR#1	6.12168e-17
C447	a_828_74##11	VGND#18	8.82241e-17
C448	a_828_74##7	a_630_74##10	5.118e-17
C449	VPWR#13	SCD#3	9.13666e-19
C450	a_1511_74##6	a_828_74##7	3.40746e-17
C451	a_630_74##3	a_1243_48##2	9.64895e-19
C452	a_630_74##14	SCD#1	1.7787e-18
C453	CLK#1	VPWR#16	2.87686e-17
C454	VGND#2	a_2322_368##8	1.8975e-19
C455	a_1711_48##3	a_1663_74#	9.87534e-18
C456	VGND#12	a_36_74##8	2.10108e-17
C457	VGND#12	a_828_74##4	1.55284e-18
C458	a_301_74##2	a_828_74##2	4.97374e-18
C459	VGND#4	VGND#9	1.63377e-16
C460	a_36_74##4	D#1	1.83542e-17
C461	VPWR#14	a_828_74##2	5.36956e-18
C462	a_630_74##9	a_1663_74#	9.87534e-18
C463	a_301_74##4	CLK#2	2.44712e-19
C464	VGND#4	VPWR#6	2.84376e-18
C465	a_1511_74##5	a_1711_48##15	5.33311e-18
C466	a_630_74##12	SCD#3	1.31888e-19
C467	a_36_74#	D#3	4.93756e-17
C468	a_1711_48#	a_1691_508#	1.06762e-17
C469	a_828_74##11	a_828_74##3	1.18852e-17
C470	a_828_74##5	a_630_74##10	6.95093e-17
C471	a_1711_48##16	VPWR#4	3.3538e-17
C472	a_828_74##7	a_1021_97##2	3.29079e-19
C473	SCD#1	VGND#20	2.18363e-17
C474	VGND#4	Q#3	1.52618e-18
C475	a_828_74##8	a_1691_508#	1.06762e-17
C476	a_36_74##8	a_36_74##7	2.86812e-18
C477	VPWR#5	VPWR#1	2.35578e-18
C478	SCD#3	VPWR#16	2.73085e-17
C479	a_301_74##4	a_450_74#	1.98286e-18
C480	VGND#12	a_630_74##5	5.33132e-18
C481	a_1021_97##2	a_630_74##10	1.72528e-17
C482	a_301_74##4	CLK#3	1.21961e-18
C483	VGND#2	a_2322_368##4	2.08508e-18
C484	a_1511_74##6	a_630_74##10	1.37206e-18
C485	a_301_74##6	CLK#1	8.4284e-19
C486	VGND#4	VGND#3	7.22465e-17
C487	VPWR#14	CLK#4	2.33642e-18
C488	VGND#4	VPWR#7	3.06276e-18
C489	a_301_74##3	a_630_74##5	3.60808e-18
C490	a_828_74##12	a_630_74##6	3.97457e-17
C491	a_1021_97##5	a_1243_48##5	2.98274e-19
C492	a_1021_97##2	a_828_74##5	7.80774e-18
C493	a_301_74##6	VPWR#16	6.52866e-18
C494	VGND#12	CLK#4	1.85274e-18
C495	VGND#4	VGND#2	7.09328e-17
C496	VPWR#14	SCD#2	1.2626e-19
C497	a_630_74##5	a_301_74##2	5.06965e-17
C498	VGND#4	a_1711_48##16	1.59179e-18
C499	a_828_74##12	a_1021_97##6	8.66768e-17
C500	Q_N	a_2322_368##2	1.45367e-17
C501	a_630_74##2	a_630_74##10	1.18259e-18
C502	VPWR#16	a_36_74##3	3.4986e-18
C503	VGND#20	SCE#6	2.73366e-18
C504	SCE#4	a_36_74#	1.87988e-17
C505	Q_N	a_1711_48##5	1.16773e-19
C506	VPWR#5	Q_N#1	8.60547e-17
C507	a_301_74##6	SCD#3	1.2216e-17
C508	a_36_74##2	SCE#1	2.51134e-17
C509	VPWR#14	a_36_74##4	9.27322e-18
C510	a_2322_368##3	Q_N#1	3.05257e-17
C511	VPWR#4	a_1511_74##7	2.04142e-17
C512	VGND#9	a_1511_74##6	3.37731e-17
C513	a_828_74##11	a_630_74##6	4.55506e-19
C514	a_1243_48#	a_1217_499#	5.91938e-18
C515	a_301_74##4	SCD#1	1.25288e-17
C516	a_1021_97##2	a_1243_48##2	1.27813e-16
C517	a_1243_48##5	a_1021_97##3	1.13029e-17
C518	a_828_74##5	a_1511_74##6	7.55947e-17
C519	VGND#12	VGND#13	9.53675e-17
C520	a_630_74#	a_1217_499#	8.29536e-18
C521	VGND#12	a_36_74##4	4.96248e-18
C522	a_1021_97##5	a_630_74##7	2.06719e-19
C523	VGND#21	CLK#3	4.15577e-19
C524	a_2322_368##3	VPWR#5	2.71704e-17
C525	SCE#3	SCE#1	6.47633e-19
C526	a_1021_97##2	a_630_74##2	2.49218e-17
C527	VPWR#4	a_1243_48##7	4.84711e-18
C528	a_828_74##4	a_828_74##5	2.14959e-20
C529	a_828_74##5	a_1243_48##4	5.03552e-17
C530	a_301_74##3	CLK#4	3.97668e-17
C531	VPWR#4	VPWR#10	7.35006e-17
C532	a_301_74##2	a_828_74#	8.29751e-19
C533	VPWR#16	D#1	4.05464e-19
C534	VGND#2	a_2322_368##5	3.62043e-18
C535	VGND#12	VGND#11	1.11084e-16
C536	VGND#12	SCE#7	7.88688e-18
C537	a_1021_97##6	a_828_74##11	3.15038e-17
C538	a_301_74##6	a_36_74##3	4.80433e-17
C539	a_828_74##12	a_630_74##8	4.00484e-19
C540	a_630_74##2	a_1243_48##2	2.86865e-17
C541	a_2322_368##9	a_2322_368##3	3.88813e-20
C542	VPWR#14	D#2	1.20365e-18
C543	VGND#20	D#3	5.57329e-19
C544	VPWR#18	SCD#3	2.45251e-19
C545	VGND#4	a_1511_74##7	3.06615e-18
C546	a_1243_48##3	a_1173_97#	2.18564e-18
C547	VPWR#4	VPWR#8	1.39619e-16
C548	a_828_74##12	a_301_74#	6.124e-17
C549	VGND#12	VGND#10	8.66035e-17
C550	a_1021_97##5	VPWR#12	5.93262e-19
C551	VGND#12	D#2	1.5693e-18
C552	VPWR#18	VPWR#16	1.17109e-18
C553	a_828_74##4	a_1243_48##2	6.13673e-17
C554	a_301_74##4	SCE#6	4.01197e-17
C555	a_828_74##3	a_1173_97#	4.31583e-18
C556	VPWR#14	a_36_74##2	7.02433e-18
C557	a_36_74##9	SCD#3	2.70985e-19
C558	a_301_74##3	a_630_74##7	5.81346e-19
C559	VGND#21	SCD#1	3.8288e-19
C560	a_828_74##4	a_630_74##2	2.6287e-17
C561	a_828_74##2	a_1243_48##2	1.42454e-19
C562	VPWR#16	SCE#1	2.43528e-19
C563	VPWR#4	VPWR#3	8.2279e-17
C564	VGND#12	a_36_74##2	3.37245e-18
C565	D#1	a_301_74##6	1.79921e-17
C566	SCD#3	a_423_453#	1.49362e-17
C567	VPWR#14	SCE#3	6.46975e-21
C568	VPWR#18	a_36_74##3	1.94441e-18
C569	a_828_74##2	a_630_74##2	1.51339e-17
C570	a_2322_368##9	VPWR#5	8.00445e-17
C571	a_36_74##3	a_423_453#	1.49362e-17
C572	VGND#20	a_36_74#	2.8175e-19
C573	VPWR#4	VPWR#2	8.04544e-17
C574	a_301_74##2	a_630_74##7	3.4393e-17
C575	a_301_74##3	SCD#2	2.32954e-17
C576	VGND#12	SCE#3	7.26987e-18
C577	a_1511_74##7	a_630_74##9	3.5885e-19
C578	a_828_74##2	a_828_74##4	4.04985e-19
C579	VGND#1	a_2322_368##4	3.56729e-17
C580	a_630_74##3	a_828_74##4	2.12667e-18
C581	a_301_74##4	D#3	2.92111e-17
C582	VPWR#12	a_630_74##4	5.09706e-20
C583	a_36_74##9	a_36_74##3	4.70463e-19
C584	VPWR#2	VPWR#1	9.54295e-19
C585	VGND#2	a_1711_48##4	2.74687e-18
C586	a_301_74##5	a_630_74##3	7.05292e-19
C587	a_301_74##6	SCE#1	5.24268e-18
C588	VGND#21	SCE#6	1.23295e-18
C589	a_828_74##13	a_828_74##12	2.68059e-18
C590	VPWR#18	D#1	5.79833e-18
C591	D#1	a_238_453#	1.62684e-17
C592	Q#3	a_1711_48##8	2.02593e-18
C593	Q_N#1	a_2322_368##2	5.06442e-19
C594	a_828_74##2	a_630_74##5	1.94551e-19
C595	VPWR#18	a_301_74##6	1.96391e-17
C596	a_301_74##3	CLK#1	4.38228e-17
C597	SCE#1	a_238_453#	1.62684e-17
C598	VPWR#4	a_2322_368##8	1.62649e-18
C599	VPWR#6	VPWR#5	1.08195e-18
C600	VPWR#14	VPWR#15	7.82592e-17
C601	a_301_74##3	VPWR#15	2.1846e-18
C602	Q_N#2	a_2322_368##4	3.80653e-17
C603	VPWR#7	a_1711_48##8	6.11996e-18
C604	a_36_74##9	D#1	8.48933e-19
C605	a_36_74##8	SCE#6	4.37544e-20
C606	VGND#3	a_1711_48##10	5.28524e-18
C607	VGND#18	a_1243_48##2	1.35355e-18
C608	a_301_74##4	a_36_74#	2.06982e-18
C609	VGND#9	a_1711_48##12	5.83518e-19
C610	a_301_74##2	CLK#1	1.52003e-18
C611	a_36_74##4	a_301_74##3	3.1186e-18
C612	VPWR#14	VPWR#12	1.04997e-16
C613	VGND#1	a_2322_368##5	5.347e-18
C614	VPWR#18	SCE#1	4.38498e-17
C615	VGND#21	D#3	3.92213e-18
C616	VPWR#14	a_1021_97##7	1.74543e-17
C617	Q#3	a_1511_74##2	1.33133e-19
C618	a_2322_368##6	a_2322_368#	4.72281e-17
C619	a_828_74##16	a_630_74##4	5.49862e-18
C620	a_630_74##5	SCD#2	3.50512e-19
C621	SCD#6	SCD#2	8.78342e-18
C622	VPWR#14	VPWR#10	7.6981e-17
C623	VGND#5	a_2322_368##4	6.70663e-18
C624	VPWR#12	a_630_74##3	4.25601e-19
C625	a_828_74##12	a_828_74##16	6.32242e-19
C626	Q_N#1	VPWR#2	1.30268e-17
C627	a_36_74##9	SCE#1	6.40868e-19
C628	VPWR#6	a_2322_368##9	8.30454e-17
C629	a_1021_97##6	a_1243_48##2	1.05888e-19
C630	a_2322_368##8	Q_N	7.1531e-19
C631	a_1711_48##6	a_1711_48##5	1.06479e-18
C632	CLK#4	SCD#2	5.47411e-19
C633	VPWR#14	a_301_74##5	1.71828e-17
C634	VPWR#2	a_2322_368#	5.32686e-19
C635	a_301_74##3	SCD#3	2.01324e-17
C636	a_36_74##8	D#3	6.16401e-20
C637	Q_N#2	a_2322_368##5	3.53112e-17
C638	VPWR#18	SCE#5	3.71115e-17
C639	a_828_74##2	a_630_74##3	5.19763e-17
C640	a_301_74##4	SCE#4	3.21882e-20
C641	a_301_74#	a_828_74##16	2.59022e-17
C642	SCD#5	SCD#2	1.11329e-17
C643	VPWR#3	VPWR#5	4.61456e-18
C644	VGND#4	a_2322_368##8	1.00048e-18
C645	a_1511_74##2	a_1711_48##16	1.44045e-17
C646	VGND#2	a_2322_368##3	4.29701e-19
C647	VPWR#2	a_2322_368##2	3.69166e-21
C648	VPWR#14	a_828_74##16	2.9617e-18
C649	SCD#1	a_450_74#	4.351e-19
C650	a_828_74##16	a_630_74##3	6.38099e-18
C651	VGND#21	a_36_74#	3.10987e-17
C652	a_36_74##4	SCD#2	3.17193e-17
C653	SCE#6	a_450_74#	7.46612e-18
C654	a_301_74##2	SCD#3	5.54836e-19
C655	a_36_74##9	SCE#5	1.79881e-17
C656	a_828_74##12	a_630_74##3	1.21724e-18
C657	VGND#3	a_1711_48##12	5.66447e-19
C658	VGND#3	Q	8.19825e-18
C659	Q#3	a_2322_368##9	2.32095e-18
C660	a_1711_48##9	a_2322_368##6	3.35424e-17
C661	VGND#9	a_1511_74##3	1.95647e-17
C662	VPWR#14	VPWR#13	1.54908e-17
C663	a_1021_97##5	a_630_74##6	3.60582e-19
C664	VGND#5	a_2322_368##5	3.76322e-17
C665	a_630_74##14	CLK	1.39068e-17
C666	a_1021_97##6	a_630_74##2	1.10515e-18
C667	VGND#9	a_1511_74##5	3.94432e-17
C668	a_36_74##4	SCD#6	1.25675e-17
C669	VPWR#3	a_2322_368##6	6.43637e-19
C670	a_1711_48##15	VPWR#4	4.99657e-18
C671	SCE#7	a_36_74##4	2.90024e-17
C672	D#2	SCD#2	5.12623e-18
C673	a_36_74##8	a_36_74#	1.28438e-18
C674	a_36_74##9	VPWR#18	4.80653e-17
C675	VPWR#14	a_630_74##12	7.31056e-18
C676	a_1711_48##16	a_1711_48##2	6.33763e-19
C677	VPWR#3	a_1711_48##6	2.28326e-19
C678	Q_N#2	a_1711_48##4	7.10197e-19
C679	a_36_74##4	D#2	6.70689e-17
C680	a_1711_48##11	a_2322_368##6	3.56967e-19
C681	a_301_74##3	a_36_74##3	9.53206e-19
C682	a_630_74##2	a_1217_499#	2.99983e-18
C683	SCE#4	VGND#21	1.49757e-17
C684	a_36_74##8	SCE#2	5.22829e-20
C685	a_36_74##4	SCD#5	1.94559e-17
C686	VPWR#2	a_2322_368##6	7.69971e-18
C687	D#2	SCE#7	9.458e-18
C688	a_36_74##2	a_36_74##4	1.93961e-18
C689	a_630_74##4	VPWR#13	5.46948e-19
C690	a_1711_48##2	VPWR#9	3.51482e-18
C691	VPWR#14	VPWR#16	2.63014e-17
C692	a_2322_368##10	a_2322_368##5	9.29734e-19
C693	VGND#1	a_1711_48##10	3.60558e-20
C694	Q#3	VPWR#6	9.02201e-17
C695	SCD#6	CLK#1	2.04532e-19
C696	a_301_74##2	VPWR#12	8.73736e-18
C697	VPWR#10	a_630_74##3	1.53579e-20
C698	a_2322_368##9	VPWR#3	5.99419e-18
C699	VPWR#4	a_1511_74##5	4.51471e-18
C700	D#2	a_301_74##3	2.15284e-18
C701	Q_N	VGND#1	2.94201e-17
C702	D#3	a_223_74#	9.87534e-18
C703	a_1711_48##11	a_1711_48##9	6.66692e-18
C704	a_1021_97##6	a_828_74##4	2.00025e-17
C705	Q_N#2	Q_N	2.96188e-18
C706	VPWR#4	a_1711_48##6	9.51114e-19
C707	VGND#1	VPWR#1	1.64531e-19
C708	a_1711_48##4	VGND#5	1.50873e-17
C709	a_36_74#	a_223_74#	9.87534e-18
C710	a_36_74##8	SCE#4	2.33505e-17
C711	a_301_74##4	SCE	2.72315e-17
C712	a_36_74##2	D#2	4.02986e-17
C713	a_1711_48##16	a_828_74##7	2.74093e-19
C714	a_630_74##5	a_630_74##3	2.99014e-18
C715	VGND#3	a_1511_74##3	2.28242e-20
C716	a_36_74##8	SCE	1.27543e-18
C717	VGND#9	a_1511_74##2	1.60666e-17
C718	a_1511_74##7	a_1711_48##2	1.82594e-17
C719	VGND#9	a_1711_48##3	2.89682e-17
C720	VGND#8	a_2322_368##5	9.21293e-19
C721	VGND#4	a_1711_48##15	6.88074e-18
C722	VPWR#4	a_1711_48##5	9.42056e-19
C723	VPWR#3	a_1711_48##9	1.52262e-18
C724	VPWR#14	a_301_74##6	2.38391e-17
C725	CLK#2	a_630_74##5	2.96676e-17
C726	VPWR	VPWR#10	4.72459e-18
C727	SCE#3	a_36_74##2	8.2714e-17
C728	a_301_74##3	D#1	5.15303e-19
C729	SCD#5	CLK#1	5.28254e-19
C730	CLK	a_630_74##12	1.74986e-17
C731	a_2322_368##9	VPWR#2	5.75212e-18
C732	VPWR#3	a_1711_48##5	8.32704e-19
C733	a_2322_368##10	a_1711_48##4	2.31288e-17
C734	a_2322_368##9	a_2322_368##2	3.12468e-20
C735	a_36_74##4	a_423_453#	1.05063e-19
C736	VPWR#3	VPWR#2	1.19336e-18
C737	VPWR#2	a_1711_48##9	7.04651e-18
C738	a_828_74##2	a_1021_97##6	2.1497e-19
C739	a_1711_48##16	a_630_74##10	2.51756e-21
C740	a_1711_48##13	a_1711_48##11	4.77679e-17
C741	a_2322_368##8	VPWR#5	8.98121e-18
C742	VGND#5	a_1711_48##10	1.34696e-18
C743	a_1511_74##7	a_828_74##7	5.13647e-17
C744	VGND#4	a_1511_74##5	8.97694e-18
C745	VPWR#3	VPWR#6	2.40042e-19
C746	a_301_74##3	a_301_74##2	1.42526e-18
C747	Q	VGND#8	1.87995e-17
C748	a_301_74#	a_828_74##2	3.7406e-17
C749	VGND#4	a_2322_368##4	5.10933e-18
C750	Q	Q#1	1.23759e-19
C751	Q_N	VPWR#1	3.52424e-17
C752	VGND#16	Q	2.01226e-17
C753	a_2322_368##9	Q_N	2.19372e-19
C754	VGND#11	a_828_74##13	4.53679e-17
C755	VGND#8	a_1711_48##4	3.75502e-18
C756	VPWR#7	Q#3	8.42963e-17
C757	a_2322_368##8	a_2322_368##4	3.5278e-20
C758	VPWR#14	a_36_74##9	2.19405e-17
C759	VGND#4	a_2322_368##5	4.8788e-18
C760	VGND	VGND#10	3.30549e-18
C761	a_1021_97##5	a_1021_97##7	2.39731e-18
C762	a_2322_368##3	VPWR#2	3.72385e-19
C763	VGND#16	a_2322_368##5	9.72175e-20
C764	VPWR#3	a_1711_48##11	1.07044e-17
C765	a_2322_368##10	a_1711_48##10	1.91451e-18
C766	VGND#9	a_630_74##9	1.06209e-17
C767	a_301_74##3	SCE#1	7.49056e-19
C768	VGND#4	a_1711_48##6	4.0321e-18
C769	Q#1	a_2322_368##8	1.12922e-17
C770	a_828_74##4	a_1173_97#	2.97146e-19
C771	a_1511_74##7	a_630_74##10	1.02417e-16
C772	Q_N#2	Q_N#1	4.14404e-18
C773	VGND#4	a_1711_48##4	8.29943e-18
C774	a_2322_368##8	a_1711_48##9	7.94529e-18
C775	a_36_74##7	D#2	1.05758e-18
C776	a_2322_368##5	a_2322_368##4	3.80296e-17
C777	a_1511_74#	a_1711_48##13	7.35983e-18
C778	a_1021_97##6	a_1021_97##5	2.81058e-18
C779	Q#1	a_1711_48##4	3.26212e-19
C780	a_630_74##5	a_301_74#	9.83981e-18
C781	a_2322_368##8	a_2322_368##2	1.64408e-19
C782	VGND#4	a_1711_48##5	1.10282e-18
C783	a_1711_48##16	Q#3	5.30835e-19
C784	VGND#11	a_828_74##12	3.11363e-17
C785	a_630_74##10	a_1243_48##7	1.14795e-16
C786	VPWR#2	a_1711_48##11	1.78873e-19
C787	CLK#4	CLK#2	1.26191e-17
C788	VGND#4	a_1711_48##10	5.12076e-18
C789	VPWR#1	a_2322_368#	3.9947e-17
C790	VGND	a_828_74##11	6.05938e-19
C791	a_1711_48##10	VGND#8	2.88515e-17
C792	a_630_74##5	a_828_74##13	2.55215e-17
C793	a_2322_368##8	a_2322_368##3	2.11191e-19
C794	Q_N	a_2322_368##4	6.80258e-18
C795	Q#3	VPWR#3	1.46021e-17
C796	VPWR#2	a_1711_48##5	4.81822e-20
C797	Q_N	a_2322_368##5	7.33545e-20
C798	a_630_74##14	a_630_74##12	5.5116e-19
C799	VGND#10	a_828_74##6	4.4184e-18
C800	VPWR#8	a_1711_48##13	9.04778e-19
C801	a_630_74##5	VGND#19	2.78052e-17
C802	VPWR#3	a_1711_48##8	1.914e-20
C803	VGND#4	a_1711_48##12	6.26724e-18
C804	a_828_74##5	a_1511_74##7	4.59054e-18
C805	SCE	D#3	1.90794e-17
C806	a_2322_368##8	a_2322_368##5	4.61867e-20
C807	SCE	a_36_74#	5.02359e-19
C808	Q_N#1	a_2322_368#	2.82858e-17
C809	SCE	SCE#4	2.71654e-19
C810	CLK#2	a_630_74##12	4.47676e-18
C811	VPWR#8	VPWR#7	2.43311e-18
C812	a_1711_48#	a_1511_74#	9.46835e-18
C813	VGND#4	a_828_74##11	7.3931e-18
C814	a_828_74##5	a_1243_48##7	4.20124e-19
C815	a_1711_48##16	VPWR#7	9.67064e-17
C816	VPWR#3	a_1711_48##13	1.55492e-18
C817	Q#1	a_1711_48##10	3.44253e-17
C818	a_36_74##7	a_36_74##2	1.3783e-17
C819	VGND#4	a_1511_74##3	1.06601e-18
C820	SCD#6	D#1	5.8038e-19
C821	VGND#9	a_828_74##7	8.49581e-19
C822	VGND#9	a_828_74##6	5.3745e-19
C823	Q	a_2322_368##5	4.92953e-20
C824	VPWR#1	a_2322_368##6	2.61586e-18
C825	D	SCE#1	3.04613e-18
C826	Q	a_1711_48##4	2.20536e-19
C827	a_2322_368##8	a_1711_48##11	1.07154e-18
C828	Q	a_1711_48##10	1.11262e-17
C829	Q	a_1711_48##12	9.05855e-18
C830	a_1711_48##4	a_2322_368##5	2.75393e-17
C831	VPWR#5	a_2322_368#	6.75994e-19
C832	VGND#8	a_1711_48##12	7.02575e-19
C833	VGND#4	a_1711_48##3	5.22521e-19
C834	VGND#10	a_828_74##12	4.17096e-17
C835	a_1511_74##7	a_1021_97##2	3.05162e-20
C836	Q_N	a_2322_368#	1.62936e-17
C837	Q_N	a_2322_368##6	5.08689e-20
C838	VPWR#14	D	1.52847e-18
C839	a_2322_368##2	VNB	2.87763e-17
C840	Q_N	a_1711_48##9	1.06019e-19
C841	a_1711_48##6	VNB	4.37677e-17
C842	a_1711_48##5	VNB	3.51932e-17
C843	VGND#12	D	1.75221e-18
C844	a_630_74##4	VNB	2.4872e-17
C845	VPWR#8	a_1511_74##2	1.00244e-18
C846	a_630_74##3	VNB	5.56162e-17
C847	CLK#2	VNB	5.42319e-17
C848	SCE#2	VNB	5.38183e-17
C849	VGND#16	a_1711_48##10	1.29819e-18
C850	Q_N#1	a_2322_368##6	5.60915e-17
C851	a_301_74##4	a_630_74##5	4.32813e-19
C852	VPWR#7	VPWR#3	2.35578e-18
C853	a_1021_97##2	a_1243_48##7	2.16551e-17
C854	VGND#4	a_630_74##9	1.84759e-19
C855	a_630_74##14	CLK#4	3.00616e-17
C856	VPWR#8	a_1511_74#	1.61031e-17
C857	a_2322_368##9	a_2322_368#	2.34351e-20
C858	VGND#10	a_1021_97##3	4.41949e-18
C859	VPWR#14	CLK	1.69422e-18
C860	a_301_74##2	a_1021_97##7	3.90809e-18
C861	a_828_74##8	a_1711_48#	2.86874e-17
C862	a_1711_48##10	a_2322_368##5	5.35591e-19
C863	VGND#12	CLK	1.44776e-18
C864	SCE	SCE#1	3.86741e-19
C865	SCD#2	CLK#2	1.39912e-17
C866	Q#1	a_1711_48##12	2.89496e-17
C867	VPWR#4	a_1243_48##5	7.34587e-19
C868	a_1021_97##2	VPWR#11	2.68727e-18
C869	a_36_74##7	SCE#3	5.26915e-17
C870	SCD#6	SCE#1	5.0443e-19
C871	VGND#4	a_828_74##6	4.08564e-18
C872	VGND#11	a_630_74##14	5.1562e-19
C873	VPWR#6	a_1711_48##6	7.72502e-18
C874	a_2322_368##6	VPWR#5	2.6079e-17
C875	a_1711_48##16	VPWR#8	4.85123e-17
C876	VGND#12	SCE	8.66661e-18
C877	VPWR#3	a_1511_74#	8.46543e-20
C878	VGND#13	VNB	3.95214e-17
C879	VGND#11	VNB	5.20005e-17
C880	VGND#8	a_1511_74##3	8.38964e-20
C881	VGND#10	VNB	7.89873e-17
C882	VGND#9	VNB	6.66135e-17
C883	VGND#3	VNB	3.2781e-17
C884	VGND#1	Q_N#2	9.29312e-18
C885	VGND#2	VNB	3.7483e-17
C886	VGND#9	a_630_74##10	3.62263e-20
C887	VPWR#15	VNB	4.0751e-17
C888	VPWR#12	VNB	5.65184e-17
C889	VGND#9	a_1021_97##3	6.30446e-20
C890	a_828_74##13	a_301_74#	5.57339e-17
C891	VGND#4	a_1021_97##3	1.60394e-18
C892	VPWR#10	VNB	8.04175e-17
C893	VPWR#4	Q_N	4.77212e-18
C894	Q_N#1	a_1711_48##9	1.74546e-18
C895	VPWR#8	VNB	5.86436e-17
C896	VPWR#3	VNB	3.53791e-17
C897	VPWR#2	VNB	3.29161e-17
C898	VGND#4	Q_N	6.05718e-18
C899	a_2322_368##8	VNB	1.47186e-18
C900	a_1711_48##16	VPWR#9	4.02833e-19
C901	a_1711_48##10	a_1711_48##4	5.17839e-18
C902	VPWR#16	CLK#2	2.0897e-19
C903	a_1711_48##15	VNB	1.01154e-17
C904	a_1711_48##12	VGND#16	2.11926e-17
C905	VPWR#14	a_630_74##3	4.24214e-19
C906	VPWR#10	a_1711_48#	2.88187e-19
C907	a_1511_74##5	VNB	9.62515e-18
C908	a_2322_368##3	Q_N	1.92331e-17
C909	a_2322_368##9	a_2322_368##6	1.51885e-18
C910	a_2322_368##8	a_1711_48##6	1.65348e-18
C911	a_828_74##12	VNB	1.19822e-17
C912	D	a_36_74##4	6.31624e-18
C913	a_828_74##11	VNB	1.21469e-17
C914	CLK	a_630_74##5	4.64793e-17
C915	VGND#10	a_828_74##11	4.34174e-17
C916	a_2322_368##8	VPWR#2	2.52668e-19
C917	a_1243_48##5	VNB	4.43481e-18
C918	a_1021_97##5	VNB	9.53486e-18
C919	a_630_74##11	a_828_74##8	2.96823e-17
C920	VPWR#1	a_1711_48##11	1.42554e-19
C921	a_301_74##3	VNB	9.80818e-18
C922	D	D#2	6.0092e-18
C923	Q#3	a_2322_368##8	3.12771e-18
C924	a_301_74##2	VNB	7.78055e-18
C925	VGND#4	Q	2.70416e-17
C926	a_1711_48##2	VPWR#8	3.58347e-17
C927	VGND#20	SCD#2	6.57589e-19
C928	D	a_36_74##2	6.29826e-17
C929	SCD#6	VNB	2.79564e-18
C930	SCD#5	VNB	1.4902e-18
C931	a_36_74##7	VNB	3.35536e-17
C932	VGND#12	a_828_74##12	3.21728e-17
C933	SCE#3	D	8.20748e-18
C934	VPWR#14	CLK#2	1.01285e-19
C935	a_1711_48##9	VPWR#5	3.27506e-17
C936	VGND#1	VNB	4.9569e-17
C937	Q_N#2	VNB	9.99201e-19
C938	VGND#5	VNB	2.8654e-18
C939	a_2322_368##10	VNB	8.29986e-18
C940	VPWR#8	a_1711_48#	2.53492e-17
C941	VGND#8	VNB	9.67641e-18
C942	Q#1	VNB	3.97272e-19
C943	VGND#16	VNB	1.04937e-17
C944	VGND#4	a_1243_48##5	1.48553e-18
C945	a_1711_48##19	VNB	1.08215e-17
C946	SCE	a_36_74##4	1.79911e-18
C947	a_1511_74##6	VNB	7.81813e-18
C948	VPWR#6	a_2322_368##6	8.80437e-20
C949	a_1243_48##4	VNB	1.13702e-18
C950	VGND#18	VNB	9.86703e-19
C951	SCE	SCE#7	5.86944e-18
C952	VGND#10	a_1243_48##3	3.65084e-18
C953	a_1021_97##6	VNB	5.61161e-18
C954	a_1711_48##19	a_1711_48##12	1.0472e-18
C955	a_630_74##2	a_1243_48##7	1.05409e-17
C956	a_301_74#	VNB	1.62715e-17
C957	a_828_74##13	VNB	1.63472e-17
C958	VGND#19	VNB	6.1265e-18
C959	SCE	D#2	3.34058e-17
C960	a_36_74##7	SCE#2	1.3249e-17
C961	a_630_74##14	VNB	1.29477e-17
C962	VGND#20	VNB	1.07922e-17
C963	VGND#12	a_828_74##11	1.74501e-17
C964	a_1711_48##15	a_1711_48##8	3.70918e-17
C965	VPWR#14	SCE#2	9.22679e-20
C966	a_301_74##4	VNB	1.08123e-17
C967	VGND#21	VNB	1.2961e-18
C968	a_36_74##8	VNB	3.49768e-17
C969	a_301_74##4	SCD#2	1.1085e-17
C970	VPWR#1	VNB	6.07199e-17
C971	VGND#5	VGND#1	1.47238e-17
C972	Q_N#1	VNB	2.92379e-18
C973	VPWR#5	VNB	7.17609e-18
C974	a_2322_368##9	VNB	1.49035e-17
C975	VPWR#6	VNB	1.10429e-17
C976	Q#3	VNB	2.66018e-18
C977	VGND#10	a_828_74##5	4.30232e-17
C978	VPWR#7	VNB	1.09546e-17
C979	a_1711_48##16	VNB	1.72756e-17
C980	a_2322_368##9	a_1711_48##9	7.39137e-17
C981	VPWR#8	VPWR#9	9.57952e-18
C982	a_630_74##2	VPWR#11	4.12362e-18
C983	a_1511_74##7	VNB	5.36118e-18
C984	a_1243_48##7	VNB	4.66716e-18
C985	VGND#16	a_1511_74##3	3.10303e-18
C986	a_1021_97##7	VNB	4.84706e-18
C987	a_301_74##5	VNB	9.7e-18
C988	VPWR	a_1021_97##2	1.18889e-18
C989	a_828_74##16	VNB	3.86204e-18
C990	VPWR#13	VNB	3.72666e-18
C991	a_630_74##12	VNB	2.71195e-18
C992	VPWR#16	VNB	7.021e-18
C993	VPWR	a_630_74##2	8.5805e-19
C994	a_36_74##4	CLK#2	3.63304e-19
C995	a_1711_48##15	a_1711_48##11	4.10522e-19
C996	a_301_74##6	VNB	2.98825e-18
C997	VPWR#18	VNB	4.3687e-18
C998	a_36_74##9	VNB	4.60222e-17
C999	a_1021_97#	a_630_74##11	1.22593e-17
C1000	a_2322_368##4	VNB	2.26873e-17
C1001	a_2322_368##5	VNB	2.98084e-17
C1002	VGND#9	a_828_74##5	1.28942e-17
C1003	a_1711_48##4	VNB	3.6581e-17
C1004	a_1711_48##10	VNB	2.92225e-17
C1005	a_1711_48##12	VNB	2.85592e-17
C1006	a_1511_74##3	VNB	3.24038e-17
C1007	VPWR#5	a_1711_48##11	6.45715e-19
C1008	a_1711_48##3	VNB	5.56344e-17
C1009	a_1511_74##2	a_1711_48##12	4.8846e-19
C1010	a_630_74##9	VNB	4.04274e-17
C1011	a_301_74#	a_301_74##2	2.24045e-18
C1012	a_828_74##6	VNB	2.56269e-17
C1013	a_1711_48##12	a_1711_48##10	3.94447e-17
C1014	a_1021_97##3	VNB	4.07054e-17
C1015	Q#3	a_1711_48##6	2.79049e-19
C1016	a_1243_48##3	VNB	2.61818e-17
C1017	a_828_74##3	VNB	2.46102e-17
C1018	VGND	a_1021_97##2	3.00184e-19
C1019	a_630_74##6	VNB	4.89771e-17
C1020	a_36_74##4	SCE#2	1.30999e-19
C1021	VGND#3	VGND#2	1.04085e-18
C1022	VPWR#10	a_828_74##8	3.16225e-19
C1023	a_630_74##8	VNB	3.8705e-17
C1024	VGND	a_1243_48##2	3.25126e-19
C1025	CLK#3	VNB	3.47548e-17
C1026	a_2322_368##8	a_1711_48##5	5.52783e-17
C1027	SCD#1	VNB	4.58297e-17
C1028	SCE#6	VNB	2.27566e-17
C1029	D#3	VNB	3.2005e-17
C1030	a_36_74#	VNB	2.94134e-17
C1031	a_1511_74##5	a_1711_48##8	5.01368e-19
C1032	VPWR#6	a_1711_48##9	2.05024e-18
C1033	SCE#4	VNB	2.85115e-17
C1034	VGND#12	a_1243_48##3	5.71899e-19
C1035	a_2322_368#	VNB	3.43279e-17
C1036	a_2322_368##6	VNB	3.50471e-17
C1037	a_1711_48##9	VNB	4.66646e-17
C1038	a_1711_48##11	VNB	3.9596e-17
C1039	a_1021_97##7	a_630_74##2	5.42465e-17
C1040	a_1711_48##13	VNB	4.02167e-17
C1041	a_301_74##2	a_828_74##16	5.63069e-17
C1042	a_1511_74#	VNB	4.51724e-17
C1043	a_1711_48#	VNB	1.98851e-17
C1044	a_828_74##8	VNB	4.27476e-17
C1045	a_1511_74##7	a_1711_48##16	3.82463e-18
C1046	a_630_74##11	VNB	2.77614e-17
C1047	a_1511_74##2	a_1511_74##3	6.62973e-18
C1048	a_1021_97#	VNB	3.55358e-17
C1049	a_1243_48#	VNB	4.97794e-17
C1050	VPWR#8	a_828_74##7	4.84528e-19
C1051	a_630_74#	VNB	2.84076e-17
C1052	a_828_74#	VNB	2.80049e-17
C1053	a_1711_48##19	a_1511_74##3	4.80879e-17
C1054	a_630_74##7	VNB	4.05724e-17
C1055	CLK#1	VNB	5.18505e-17
C1056	SCD#3	VNB	3.04654e-17
C1057	a_301_74##4	a_36_74##4	3.96025e-18
C1058	a_36_74##3	VNB	2.63411e-17
C1059	VGND#19	a_828_74##13	4.96022e-17
C1060	D#1	VNB	2.9677e-17
C1061	SCE#1	VNB	3.34445e-17
C1062	SCE#5	VNB	3.21685e-17
C1063	a_2322_368##9	a_1711_48##11	2.99433e-18
C1064	VPWR#4	VNB	3.29704e-16
C1065	VGND#4	VNB	3.3317e-16
C1066	VGND#12	a_630_74##3	1.12083e-19
C1067	VPWR#14	VNB	3.25705e-16
C1068	VGND#12	a_828_74##3	1.47629e-20
C1069	VGND#12	VNB	3.12403e-16
C1070	a_2322_368##3	a_2322_368##2	2.969e-18
C1071	a_2322_368##3	VNB	3.89553e-17
C1072	VPWR#8	a_828_74##8	1.28112e-17
C1073	VGND#5	Q_N#2	4.57676e-18
C1074	a_1711_48##8	VNB	7.39811e-17
C1075	a_1511_74##2	VNB	4.11569e-17
C1076	a_1711_48##2	VNB	5.98674e-17
C1077	a_630_74##14	SCE#7	5.86145e-19
C1078	a_828_74##7	VNB	5.67224e-17
C1079	a_630_74##10	VNB	5.32865e-17
C1080	a_828_74##5	VNB	3.62556e-17
C1081	a_1021_97##2	VNB	5.69512e-17
C1082	a_1711_48##3	a_1511_74##2	1.50418e-17
C1083	a_1243_48##2	VNB	6.66298e-17
C1084	Q#3	a_1711_48##9	8.45653e-19
C1085	a_630_74##2	VNB	5.73798e-17
C1086	SCE	D	1.52049e-17
C1087	a_828_74##4	VNB	2.79889e-17
C1088	a_828_74##2	VNB	4.17722e-17
C1089	a_630_74##5	VNB	4.46705e-17
C1090	VGND#16	a_1711_48##3	1.85386e-19
C1091	a_1511_74##2	a_1711_48##15	5.32248e-17
C1092	CLK#4	VNB	5.43273e-18
C1093	SCD#2	VNB	5.79646e-17
C1094	a_36_74##4	VNB	3.74346e-17
C1095	VGND#10	a_828_74##3	3.23156e-18
C1096	SCE#7	VNB	4.93459e-17
C1097	D#2	VNB	5.70582e-17
C1098	VPWR#14	a_1021_97##5	4.49275e-18
C1099	a_36_74##2	VNB	5.61988e-17
C1100	a_828_74##16	a_630_74##2	2.21148e-19
C1101	a_1243_48#	a_1021_97#	2.87496e-17
C1102	SCE#3	VNB	7.28529e-17
C1103	VGND#20	SCE#7	1.55439e-18
C1104	Q#3	a_1711_48##5	7.85316e-20
C1105	VGND#12	CLK#2	1.72544e-19
C1106	a_1711_48##15	Q#1	3.43663e-17
C1107	SCD#6	a_301_74##3	3.78265e-17
C1108	VPWR#6	a_1711_48##11	5.35449e-17
C1109	a_828_74##12	a_828_74##11	2.42053e-18
C1110	VGND#10	a_1021_97##2	3.10107e-20
C1111	a_1511_74##3	VGND#17	7.30799e-18
C1112	a_1711_48##15	a_1711_48##13	1.25753e-18
C1113	D	VNB	1.26362e-18
C1114	CLK	VNB	2.2007e-18
C1115	SCE	VNB	9.13145e-18
C1116	a_301_74##2	a_828_74##13	9.51877e-18
C1117	Q_N	VNB	6.12394e-17
C1118	Q	VNB	2.09654e-18
C1119	VPWR	VNB	1.78298e-18
C1120	VGND	VNB	1.8959e-18
C1121	VGND#12	a_630_74##8	1.68482e-18
C1122	VGND#14	SCE	2.99709e-18
C1123	VGND#6	a_2322_368##8	6.96925e-18
C1124	VGND#6	Q_N#2	1.90954e-17
C1125	VPWR#17	SCE#1	7.69474e-18
C1126	VGND#14	D#2	6.21037e-20
C1127	VGND#14	a_36_74#	3.73196e-18
C1128	VPWR#17	D#1	1.62583e-17
C1129	VGND#14	SCE#1	1.11719e-19
C1130	VPWR#17	VNB	6.92371e-17
C1131	VPWR#17	SCE#3	9.27248e-20
C1132	VPWR#17	VPWR#15	3.60202e-20
C1133	a_36_74##2	VPWR#17	1.4386e-18
C1134	VGND#14	SCE#3	1.88721e-18
C1135	a_36_74##9	VPWR#17	2.22883e-17
C1136	VPWR#17	D#2	1.82119e-19
C1137	VGND#6	VNB	4.45793e-18
C1138	VGND#14	SCE#7	3.32686e-19
C1139	VPWR#14	VPWR#17	1.42036e-16
C1140	VGND#14	D#3	7.47673e-18
C1141	a_2322_368##10	VGND#6	1.9121e-17
C1142	VPWR#17	SCE#7	8.28334e-20
C1143	VPWR#17	SCE#2	4.51326e-19
C1144	VGND#6	a_1711_48##4	4.68457e-18
C1145	a_36_74##4	VPWR#17	1.66666e-18
C1146	a_301_74##6	VPWR#17	9.53245e-18
C1147	VGND#14	VNB	6.91763e-17
C1148	VGND#14	SCE#4	4.64579e-18
C1149	VGND#6	VGND#5	6.11205e-18
C1150	VGND#14	a_36_74##8	2.42876e-17
C1151	VGND#6	a_2322_368##5	4.5432e-18
C1152	VGND#14	a_301_74##4	1.49005e-17
C1153	VGND#6	a_2322_368##3	2.91815e-17
C1154	VGND#12	VGND#14	1.2192e-16
C1155	VPWR#17	VPWR#16	2.58691e-19
C1156	VPWR#17	SCE#5	3.74742e-18
*
*
.ENDS sky130_fd_sc_hs__sdfxbp_2
*
