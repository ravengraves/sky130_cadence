* Extracted by Quantus, converted by sky130cad/quantus.py
*
*
*
*                       LINUX           Wed Nov 18 08:57:31 2026
*
*
*
*  PROGRAM  advgen
*
*  Name           : advgen - Quantus - (64-bit)
*  Version        : 25.1.0-p047
*  Build Date     : Thu Dec 11 23:20:30 PST 2025
*
*  HSPICE LIBRARY
*
*  OPERATING_TEMPERATURE 150
*  QRC_TECH_DIR <path>/tech
*
*
*

*
.SUBCKT sky130_fd_sc_hs__o221a_4 VNB VPB VGND VPWR X A1 C1 B2 B1 A2
*
*
*  caps2d version: 10
*
*
*       TRANSISTOR CARDS
*
*
XM20 a_27_125##4 C1#4 a_114_125##17 VNB sky130_fd_pr__nfet_01v8_lvt l=0.15 w=0.64 ad=0.1824 as=0.1792 pd=1.85 ps=1.84
XM25 a_114_125##17 C1#5 a_27_125##6 VNB sky130_fd_pr__nfet_01v8_lvt l=0.15 w=0.64 ad=0.1792 as=0.224 pd=1.84 ps=1.98
XM16 a_300_125##5 B1#4 a_27_125##6 VNB sky130_fd_pr__nfet_01v8_lvt l=0.15 w=0.64 ad=0.2016 as=0.224 pd=1.91 ps=1.98
XM18 a_300_125##5 B2#5 a_27_125##5 VNB sky130_fd_pr__nfet_01v8_lvt l=0.15 w=0.64 ad=0.2016 as=0.2016 pd=1.91 ps=1.91
XM6 a_27_125##5 B2#3 a_300_125##3 VNB sky130_fd_pr__nfet_01v8_lvt l=0.15 w=0.64 ad=0.2016 as=0.1824 pd=1.91 ps=1.85
XM2 a_27_125# B1#6 a_300_125##3 VNB sky130_fd_pr__nfet_01v8_lvt l=0.15 w=0.64 ad=0.1824 as=0.1824 pd=1.85 ps=1.85
XM1 a_300_125##6 A1#4 VGND#10 VNB sky130_fd_pr__nfet_01v8_lvt l=0.15 w=0.64 ad=0.1824 as=0.1824 pd=1.85 ps=1.85
XM11 VGND#9 A2#5 a_300_125##6 VNB sky130_fd_pr__nfet_01v8_lvt l=0.15 w=0.64 ad=0.1792 as=0.1824 pd=1.84 ps=1.85
XM3 a_300_125# A2#3 VGND#9 VNB sky130_fd_pr__nfet_01v8_lvt l=0.15 w=0.64 ad=0.1792 as=0.1792 pd=1.84 ps=1.84
XM23 VGND#8 A1#3 a_300_125# VNB sky130_fd_pr__nfet_01v8_lvt l=0.15 w=0.64 ad=0.307 as=0.1792 pd=2.33 ps=1.84
XM5 X#3 a_114_125##6 VGND#8 VNB sky130_fd_pr__nfet_01v8_lvt l=0.15 w=0.74 ad=0.2109 as=0.307 pd=2.05 ps=2.33
XM24 VGND#7 a_114_125##10 X#3 VNB sky130_fd_pr__nfet_01v8_lvt l=0.15 w=0.74 ad=0.3108 as=0.2109 pd=2.32 ps=2.05
XM21 X#6 a_114_125##8 VGND#7 VNB sky130_fd_pr__nfet_01v8_lvt l=0.15 w=0.74 ad=0.2072 as=0.3108 pd=2.04 ps=2.32
XM12 VGND#1 a_114_125##7 X#6 VNB sky130_fd_pr__nfet_01v8_lvt l=0.15 w=0.74 ad=0.2627 as=0.2072 pd=2.19 ps=2.04
XM0 VPWR#7 C1#6 a_114_125##20 VPB sky130_fd_pr__pfet_01v8 l=0.15 w=1 ad=0.295 as=0.3 pd=2.59 ps=2.6
XM17 a_114_125##20 C1#1 VPWR#11 VPB sky130_fd_pr__pfet_01v8 l=0.15 w=1 ad=0.3 as=0.305 pd=2.6 ps=2.61
XM13 a_297_387##2 B1#5 VPWR#11 VPB sky130_fd_pr__pfet_01v8 l=0.15 w=1 ad=0.345 as=0.305 pd=2.69 ps=2.61
XM26 a_114_125##19 B2#6 a_297_387##2 VPB sky130_fd_pr__pfet_01v8 l=0.15 w=1 ad=0.3 as=0.345 pd=2.6 ps=2.69
XM9 a_297_387# B2#1 a_114_125##19 VPB sky130_fd_pr__pfet_01v8 l=0.15 w=1 ad=0.3 as=0.3 pd=2.6 ps=2.6
XM27 VPWR#10 B1#1 a_297_387# VPB sky130_fd_pr__pfet_01v8 l=0.15 w=1 ad=0.785 as=0.3 pd=3.57 ps=2.6
XM7 a_763_387##2 A1#5 VPWR#10 VPB sky130_fd_pr__pfet_01v8 l=0.15 w=1 ad=0.325 as=0.785 pd=2.65 ps=3.57
XM10 a_763_387##2 A2#6 a_114_125##18 VPB sky130_fd_pr__pfet_01v8 l=0.15 w=1 ad=0.325 as=0.325 pd=2.65 ps=2.65
XM14 a_114_125##18 A2#1 a_763_387# VPB sky130_fd_pr__pfet_01v8 l=0.15 w=1 ad=0.325 as=0.35 pd=2.65 ps=2.7
XM22 VPWR#9 A1#1 a_763_387# VPB sky130_fd_pr__pfet_01v8 l=0.15 w=1 ad=0.3868 as=0.35 pd=2.95 ps=2.7
XM4 VPWR#9 a_114_125##12 X#5 VPB sky130_fd_pr__pfet_01v8 l=0.15 w=1.12 ad=0.3868 as=0.42 pd=2.95 ps=2.99
XM15 X#5 a_114_125##11 VPWR#8 VPB sky130_fd_pr__pfet_01v8 l=0.15 w=1.12 ad=0.42 as=0.336 pd=2.99 ps=2.84
XM19 X#7 a_114_125##9 VPWR#8 VPB sky130_fd_pr__pfet_01v8 l=0.15 w=1.12 ad=0.3976 as=0.336 pd=2.95 ps=2.84
XM8 VPWR#1 a_114_125# X#7 VPB sky130_fd_pr__pfet_01v8 l=0.15 w=1.12 ad=0.3304 as=0.3976 pd=2.83 ps=2.95
*
*
*       RESISTOR AND CAP/DIODE CARDS
*
Rg1	C1#1	C1#2	416.643372
Rg2	C1#2	C1#3	55.599739
Rg3	C1#3	C1#4	304.732208
Rg4	C1#2	C1#5	337.382050
Rg5	C1#3	C1#6	385.524780
Rg6	B2#1	B2#2	417.171356
Rg7	B2#2	B2#3	338.021790
Rg8	B2#2	B2#4	56.207058
Rg9	B2#4	B2#5	334.430908
Rg10	B2#4	B2#6	415.223511
Rg11	B1#1	B1#2	468.971619
Rg12	B1#2	B1#3	157.078491
Rg13	B1#3	B1#4	2172.204590
Rg14	B1#4	B1#5	787.787903
Rg15	B1#2	B1#6	309.007477
Rg16	A2#1	A2#2	417.171356
Rg17	A2#2	A2#3	356.880676
Rg18	A2#2	A2#4	44.394718
Rg19	A2#4	A2#5	354.597900
Rg20	A2#4	A2#6	416.643372
Rg21	A1#1	A1#2	453.711121
Rg22	A1#2	A1#3	368.419769
Rg23	A1#3	A1#4	1579.366821
Rg24	A1#4	A1#5	788.512146
Rg25	a_114_125#	a_114_125##2	470.060944
Rg26	a_114_125##2	a_114_125##3	115.606453
Rg27	a_114_125##3	a_114_125##4	71.656403
Rg28	a_114_125##4	a_114_125##5	58.569523
Rg29	a_114_125##5	a_114_125##6	325.822968
Rg30	a_114_125##2	a_114_125##7	334.109375
Rg31	a_114_125##3	a_114_125##8	307.510040
Rg32	a_114_125##3	a_114_125##9	458.922638
Rg33	a_114_125##4	a_114_125##10	302.708252
Rg34	a_114_125##4	a_114_125##11	426.540497
Rg35	a_114_125##5	a_114_125##12	449.655212
Rf1	C1	C1#7	6.403333
Rf2	C1#7	C1	12.224544
Rf3	a_297_387#	a_297_387##2	97.731689
Rf4	B2	B2#7	13.970907
Rf5	B2#7	B2	4.656969
Rf6	a_27_125#	a_27_125##2	86.649002
Rf7	a_27_125##2	a_27_125##3	72.721329
Rf8	a_27_125##3	a_27_125##4	98.058792
Rf9	a_27_125##2	a_27_125##5	27.421387
Rf10	a_27_125##3	a_27_125##6	28.208733
Rf11	B1	B1#7	12.806664
Rf12	B1#7	B1	5.821211
Rf13	A2#2	A2	162.398010
Rf14	a_300_125#	a_300_125##2	77.152855
Rf15	a_300_125##2	a_300_125##4	106.059006
Rf16	a_300_125##4	a_300_125##5	46.988091
Rf17	a_300_125##2	a_300_125##6	15.634649
Rf18	a_300_125##3	a_300_125##4	7.500000
Rf19	a_763_387#	a_763_387##2	105.036736
Rf20	A1#6	A1#2	161.990021
Rf21	A1	A1#8	1.757216
Rf22	A1#6	A1#8	4.973462
Rf23	a_114_125##4	a_114_125##14	181.774689
Rf24	a_114_125##14	a_114_125##15	170.646423
Rf25	a_114_125##15	a_114_125##16	72.150826
Rf26	a_114_125##16	a_114_125##17	101.478760
Rf27	a_114_125##14	a_114_125##18	17.460934
Rf28	a_114_125##15	a_114_125##19	24.836149
Rf29	a_114_125##16	a_114_125##20	45.209969
Rf30	X	X#1	20.499596
Rf31	X#1	X#2	25.532482
Rf32	X#2	X#3	83.593361
Rf33	X#1	X#4	10.773849
Rf34	X#4	X#5	79.136818
Rf35	X#2	X#6	18.188906
Rf36	X#4	X#7	23.289812
Rf37	VPWR#1	VPWR#2	61.148346
Rf38	VPWR#2	VPWR#3	52.263920
Rf39	VPWR#3	VPWR#4	74.519791
Rf40	VPWR#4	VPWR#5	155.719116
Rf41	VPWR#5	VPWR#6	159.611633
Rf42	VPWR#6	VPWR#7	117.106918
Rf43	VPWR#3	VPWR#8	41.294708
Rf44	VPWR#4	VPWR#9	32.814171
Rf45	VPWR#5	VPWR#10	16.944290
Rf46	VPWR#6	VPWR#11	39.248199
Rf47	VGND#1	VGND#2	41.693089
Rf48	VGND#2	VGND#3	60.941452
Rf49	VGND#3	VGND#4	70.413483
Rf50	VGND#4	VGND#5	68.618401
Rf51	VGND#5	VGND#6	83.253036
Rf52	VGND#3	VGND#7	33.198242
Rf53	VGND#4	VGND#8	37.538242
Rf54	VGND#5	VGND#9	41.003098
Rf55	VGND#6	VGND#10	44.894669
Rf56	C1#3	C1#7	80.116402
Rf57	B2#2	B2#7	160.232803
Rf58	B1#3	B1#7	160.232803
Re1	VPWR#2	VPWR	6.179563
Re2	VPWR	VPWR#5	0.882795
Re3	VGND#2	VGND	6.179563
Re4	VGND	VGND#6	0.882795
*
*       CAPACITOR CARDS
*
*
C1	VGND	VNB	2.83211e-16
C2	VPWR	VNB	3.02939e-16
C3	X	VNB	1.88712e-17
C4	X#5	X#1	1.04175e-18
C5	A1	VNB	1.68647e-18
C6	C1	VNB	1.97033e-17
C7	a_114_125##18	A2#1	4.38909e-17
C8	B2	VNB	3.38882e-18
C9	B1	VNB	6.72284e-18
C10	a_114_125##8	VGND#7	2.19507e-17
C11	A2	VNB	1.31816e-18
C12	C1#3	VNB	5.58747e-17
C13	B2#2	VNB	2.69757e-17
C14	VGND#4	VGND#7	5.56471e-19
C15	B1#3	VNB	1.15328e-16
C16	A1#2	VNB	2.29252e-17
C17	VGND	C1	4.25808e-18
C18	a_114_125##4	VPWR#4	5.29162e-19
C19	a_27_125##2	a_27_125#	1.88298e-19
C20	a_114_125##4	VNB	4.49383e-17
C21	VGND#6	VNB	1.20057e-16
C22	VGND	B2	3.16511e-18
C23	VPWR	A1	3.41854e-18
C24	VGND#2	VNB	1.20229e-16
C25	VPWR#2	VNB	1.15491e-16
C26	X#5	VPWR#8	6.06111e-17
C27	VGND	B1	5.04246e-18
C28	A1#4	A2#4	1.42847e-17
C29	C1#6	VNB	3.853e-17
C30	VPWR	C1	4.53487e-18
C31	C1#1	VNB	3.3383e-17
C32	B1#5	VNB	4.38285e-17
C33	VGND	A2	2.63784e-18
C34	B2#6	VNB	2.81683e-17
C35	B2#1	VNB	2.81054e-17
C36	VPWR	B2	2.75779e-18
C37	VGND#1	a_114_125##10	3.84536e-19
C38	B1#1	VNB	3.47392e-17
C39	A1#5	VNB	4.19288e-17
C40	a_300_125##2	A2#5	1.89043e-17
C41	A2#6	VNB	2.84199e-17
C42	a_763_387##2	A1#1	1.98955e-19
C43	A2#1	VNB	2.82964e-17
C44	VPWR	B1	5.12129e-18
C45	A1#1	VNB	2.93723e-17
C46	a_114_125##12	VNB	3.41644e-17
C47	A1#6	A1#4	5.33139e-19
C48	a_114_125##11	VNB	3.31832e-17
C49	a_114_125##9	VNB	2.93969e-17
C50	VPWR	A2	1.82084e-18
C51	a_114_125#	VNB	4.26065e-17
C52	C1#4	VNB	3.06992e-17
C53	a_763_387#	A2#1	2.78708e-17
C54	C1#5	VNB	2.3981e-17
C55	B1#4	VNB	1.52138e-16
C56	B2#5	VNB	2.45943e-17
C57	B2#3	VNB	2.10416e-17
C58	B1#6	VNB	2.03957e-17
C59	A1#4	VNB	8.24951e-17
C60	A2#5	VNB	2.12626e-17
C61	A2#3	VNB	2.04858e-17
C62	A1#3	VNB	7.90365e-17
C63	a_114_125##6	VNB	3.07823e-17
C64	a_114_125##10	VNB	2.55757e-17
C65	VGND	B2#2	5.08572e-19
C66	a_114_125##8	VNB	2.85458e-17
C67	a_114_125##7	VNB	3.28092e-17
C68	VGND#8	VGND#7	5.45089e-18
C69	VPWR#7	VNB	7.4057e-17
C70	VGND	B1#3	7.03841e-18
C71	a_114_125##20	VNB	2.28691e-18
C72	VPWR#11	VNB	4.87256e-19
C73	a_297_387##2	VNB	4.94297e-18
C74	A2	A1	1.25162e-17
C75	a_114_125##19	VNB	7.88739e-20
C76	VPWR#10	a_114_125##12	1.50048e-19
C77	a_297_387#	VNB	4.49218e-18
C78	VPWR#10	VNB	7.68887e-17
C79	a_763_387#	VPWR#4	5.1192e-17
C80	a_763_387##2	VNB	4.8955e-18
C81	a_114_125##8	X#6	1.3825e-17
C82	a_114_125##18	VNB	1.62361e-19
C83	VGND#3	a_114_125##4	6.22865e-20
C84	a_763_387#	VNB	4.5198e-18
C85	VGND	a_114_125##4	8.29757e-18
C86	VPWR#9	VNB	1.34798e-18
C87	X#5	VNB	2.83893e-18
C88	A2#4	A1#1	2.25791e-18
C89	a_300_125##2	a_114_125##14	3.45239e-18
C90	VGND	VGND#6	2.58391e-16
C91	VPWR#8	VNB	4.09278e-19
C92	X#7	VNB	2.96518e-18
C93	VPWR#1	VNB	4.64119e-17
C94	a_27_125##4	VNB	5.53066e-17
C95	B2	B1	2.30511e-17
C96	VPWR	B2#2	4.63562e-19
C97	a_114_125##18	A1#1	1.89774e-18
C98	a_114_125##17	VNB	2.72433e-18
C99	a_27_125##6	VNB	4.9378e-19
C100	a_300_125##5	VNB	3.89106e-18
C101	a_27_125##5	VNB	4.79072e-19
C102	a_300_125##3	VNB	2.25786e-18
C103	a_27_125#	VNB	5.25572e-18
C104	VGND#10	VNB	7.73333e-19
C105	a_300_125##6	VNB	2.41531e-18
C106	VGND#9	VNB	2.53042e-18
C107	a_300_125#	VNB	1.14835e-18
C108	VGND#8	VNB	6.94475e-18
C109	X#3	VNB	2.63676e-18
C110	VGND#7	VNB	4.54692e-18
C111	VGND#1	VNB	4.78074e-17
C112	VGND#4	a_114_125##4	4.22587e-19
C113	VPWR	a_114_125##4	9.33606e-18
C114	a_27_125##2	VNB	1.24818e-17
C115	B1	A2	2.88674e-17
C116	a_27_125##3	VNB	9.40358e-18
C117	a_300_125##2	VNB	3.76311e-18
C118	X#5	X#7	1.69115e-18
C119	VGND#7	a_114_125##7	1.64798e-18
C120	A1#6	VNB	2.24934e-18
C121	a_114_125##15	VNB	1.865e-20
C122	a_114_125##16	VNB	9.20999e-18
C123	X#1	VNB	5.0401e-18
C124	VPWR#9	VPWR#3	4.28143e-20
C125	X#2	VNB	6.29068e-18
C126	VPWR#3	VNB	2.71797e-17
C127	VPWR#4	VNB	4.66104e-17
C128	VPWR#6	VNB	4.96764e-17
C129	X#1	VPWR#8	2.28937e-17
C130	VGND#3	VNB	3.2073e-17
C131	a_763_387#	A1#1	5.33664e-17
C132	VGND#4	VNB	2.86772e-17
C133	VGND#5	VNB	2.22384e-17
C134	VPWR	C1#6	8.98328e-18
C135	X#5	A2#1	2.40039e-19
C136	VPWR	C1#1	9.14998e-18
C137	A1#4	A2#5	5.39459e-17
C138	C1	C1#3	3.26375e-17
C139	VGND#1	a_114_125##8	1.50296e-18
C140	VPWR	B1#5	3.50268e-18
C141	VGND#2	X	1.81328e-18
C142	A1	A1#2	8.78241e-18
C143	a_300_125##2	A2#3	9.26822e-19
C144	VGND	C1#4	1.51167e-20
C145	VPWR#2	X	1.1328e-18
C146	A1	a_114_125##4	3.07525e-17
C147	VPWR	B1#1	3.31895e-18
C148	VGND#2	a_114_125##2	2.60245e-20
C149	VGND	B1#4	1.64128e-17
C150	VPWR	A1#5	3.45324e-18
C151	a_114_125##18	a_114_125##12	2.6391e-19
C152	X#3	VGND#7	4.09765e-17
C153	B2	B2#2	1.36632e-17
C154	A1#1	VPWR#9	2.26212e-17
C155	VGND	A1#4	4.51692e-18
C156	VPWR	A1#1	3.40205e-18
C157	VGND	A2#5	2.79341e-18
C158	a_114_125##7	X#6	1.54402e-17
C159	VPWR	a_114_125##12	3.63595e-18
C160	B2	B1#3	1.36778e-18
C161	VGND	A2#3	3.07608e-18
C162	VGND	A1#3	7.21582e-18
C163	VPWR	a_114_125##11	1.93157e-19
C164	VGND	a_114_125##6	9.44691e-18
C165	VPWR	a_114_125##9	1.85751e-20
C166	VGND	a_114_125##10	4.81216e-18
C167	VPWR#8	X#7	6.7795e-17
C168	VGND	a_114_125##8	1.99427e-18
C169	B1	B1#3	2.33748e-17
C170	a_763_387#	a_114_125##12	1.56489e-18
C171	a_300_125##5	B2#4	1.01438e-18
C172	a_114_125##2	X#6	2.6879e-19
C173	X#5	A1#1	4.99527e-19
C174	C1#2	VNB	2.34384e-17
C175	B2#4	VNB	2.19331e-17
C176	B1#2	VNB	1.82297e-17
C177	A2#4	VNB	4.40109e-17
C178	a_114_125##2	VNB	3.58173e-17
C179	a_114_125##5	VNB	1.69298e-17
C180	a_114_125##18	a_114_125##11	1.46911e-19
C181	VGND#1	a_114_125##7	2.3797e-17
C182	X#5	VPWR#3	8.8056e-18
C183	C1	B1#5	7.66622e-19
C184	A2	A1#2	2.73189e-18
C185	X#1	X#7	1.09414e-18
C186	VPWR#9	a_114_125##12	5.47851e-17
C187	A1#4	A1#3	6.37211e-19
C188	VGND	a_27_125##4	1.86691e-17
C189	A2#5	A2#3	3.61118e-17
C190	VGND	a_114_125##17	9.51477e-18
C191	VGND#6	VGND#5	3.79151e-18
C192	a_300_125##2	A1#3	6.4416e-19
C193	VGND	a_300_125##5	1.07295e-17
C194	VPWR	VPWR#7	5.83398e-17
C195	A1	a_114_125##12	4.14102e-19
C196	VGND	a_300_125##3	1.31648e-17
C197	VPWR	a_114_125##20	1.66975e-17
C198	VPWR#8	VPWR#1	2.11371e-18
C199	VGND	a_27_125#	1.89671e-17
C200	a_114_125##14	A1#4	1.3851e-19
C201	a_300_125##3	a_300_125##2	2.26347e-19
C202	VPWR	a_297_387##2	2.41754e-17
C203	VGND	a_300_125##6	9.77413e-18
C204	B2	B1#5	1.29677e-18
C205	VGND#2	X#1	1.21291e-18
C206	VPWR	a_114_125##19	6.14543e-18
C207	VGND	a_300_125#	1.3191e-17
C208	VPWR	a_297_387#	2.46866e-17
C209	a_114_125##12	X#5	1.98458e-17
C210	VPWR	VPWR#10	1.82155e-16
C211	VGND	X#3	1.41572e-17
C212	VPWR	a_763_387##2	2.56552e-17
C213	VPWR	a_114_125##18	8.93241e-18
C214	B2	B1#1	3.95157e-18
C215	VPWR	a_763_387#	2.62616e-17
C216	VGND#2	X#2	2.5322e-17
C217	VPWR	VPWR#9	2.09889e-17
C218	VGND	a_27_125##2	2.73026e-17
C219	VPWR	X#5	1.94421e-17
C220	B2	A1#5	1.22017e-19
C221	VGND	a_27_125##3	3.49677e-17
C222	X#5	VPWR#4	9.21614e-18
C223	VPWR#9	a_114_125##11	2.10533e-18
C224	VGND	a_300_125##2	4.26788e-18
C225	VGND	A1#6	3.92187e-18
C226	VPWR#8	a_114_125##12	3.77294e-19
C227	B1	B1#1	1.53212e-18
C228	X#7	VPWR#1	6.31768e-17
C229	VPWR#10	B1#2	1.94707e-19
C230	B1	A1#5	1.53403e-17
C231	VGND	X#1	2.90902e-19
C232	VGND	X#2	1.95747e-18
C233	X#1	VPWR#1	1.48441e-17
C234	C1	B1#4	6.91406e-19
C235	a_300_125##2	a_114_125##6	3.40786e-19
C236	X#5	a_114_125##11	7.91749e-17
C237	A1#3	A2#3	5.23985e-17
C238	VGND#4	VGND#3	1.63038e-18
C239	A1#6	A1#3	3.0208e-19
C240	VPWR#2	a_114_125##2	5.68246e-20
C241	VGND	VGND#3	7.50257e-17
C242	VGND	VGND#4	7.98639e-17
C243	VGND	VGND#5	7.67957e-17
C244	VGND#4	a_114_125##5	2.32782e-20
C245	X#1	VPWR#2	2.04112e-18
C246	VPWR#9	a_114_125##9	2.7201e-19
C247	X	VPWR#1	2.35918e-17
C248	a_114_125##11	VPWR#8	2.13471e-17
C249	B2	B1#4	1.88911e-18
C250	a_27_125##5	B2#4	1.70003e-19
C251	a_297_387##2	B1#4	3.73575e-19
C252	VPWR#10	A2#4	2.34174e-20
C253	VGND#1	a_114_125##2	3.0188e-18
C254	X#5	a_114_125##9	2.19408e-18
C255	VGND#6	C1#3	8.41402e-20
C256	VGND#2	VGND#3	1.05229e-17
C257	VGND#7	VGND#1	5.53962e-18
C258	X#7	a_114_125##11	2.72003e-19
C259	C1	VPWR#7	3.30594e-17
C260	VPWR	a_114_125##14	8.20626e-18
C261	VPWR	a_114_125##15	6.97261e-18
C262	C1	a_114_125##20	2.90695e-17
C263	VPWR	a_114_125##16	5.8782e-18
C264	a_300_125##2	a_114_125##10	2.39198e-19
C265	VPWR	X#1	1.08112e-18
C266	X#7	VPWR#3	4.90489e-18
C267	VPWR#2	VPWR#3	1.04606e-17
C268	A1#3	a_114_125##6	2.37769e-17
C269	VPWR	VPWR#3	5.91174e-17
C270	a_114_125##15	B2#4	2.7409e-19
C271	VPWR#8	a_114_125##9	5.2657e-17
C272	a_300_125##2	VGND#10	3.26013e-17
C273	VPWR	VPWR#4	8.8312e-17
C274	VPWR	VPWR#6	1.07919e-16
C275	VGND#1	X	1.81459e-17
C276	a_114_125##14	A2#4	4.92649e-18
C277	VGND#6	B1#3	1.8953e-17
C278	B1	A1#4	1.29621e-17
C279	a_114_125##17	a_114_125##16	2.08045e-18
C280	X#5	a_114_125#	3.57788e-19
C281	a_297_387#	B1#4	3.97107e-19
C282	a_114_125##4	A1#2	5.54883e-18
C283	a_114_125##9	X#7	1.89452e-17
C284	A2	A1#4	3.14082e-20
C285	VPWR#8	a_114_125#	1.88154e-18
C286	C1	a_27_125##4	3.39064e-17
C287	VPWR#1	a_114_125##9	7.28874e-19
C288	C1	a_114_125##17	3.48403e-17
C289	a_114_125##16	C1#2	9.38368e-18
C290	A2	A1#3	1.63016e-19
C291	a_300_125##2	a_300_125##6	1.25839e-18
C292	a_114_125##16	C1#6	8.0004e-19
C293	a_114_125##15	B1#2	9.43119e-19
C294	VPWR#3	VPWR#1	1.33815e-20
C295	a_114_125##6	a_114_125##10	3.67787e-17
C296	a_114_125##14	A1#3	2.88387e-19
C297	X#7	a_114_125#	5.21371e-17
C298	VGND#5	VGND#4	1.70232e-18
C299	a_27_125##6	a_114_125##16	1.61538e-18
C300	VGND#2	a_114_125##4	3.22093e-19
C301	a_763_387##2	A2#4	2.28322e-19
C302	VGND	B1#2	9.23621e-19
C303	VPWR#2	a_114_125##4	3.53105e-20
C304	a_300_125##5	a_114_125##15	1.09603e-17
C305	a_114_125#	VPWR#1	2.78625e-17
C306	a_27_125##4	a_114_125##17	5.98069e-17
C307	B2#2	B1#1	4.01958e-18
C308	a_300_125##5	B2	9.72633e-18
C309	A1	a_114_125##14	2.97401e-17
C310	A1#3	A2#4	4.31754e-19
C311	a_114_125##16	B2#4	1.9559e-18
C312	a_300_125##2	VGND#9	1.57879e-17
C313	a_300_125##3	B2	4.66658e-17
C314	a_114_125##16	C1#1	1.55312e-17
C315	B1#1	B1#3	5.4008e-18
C316	a_300_125##3	B1#2	1.75255e-18
C317	a_114_125##10	a_114_125##8	2.06143e-17
C318	X#2	A2#3	5.41421e-20
C319	B1#3	A1#5	1.65079e-17
C320	a_300_125##5	a_114_125##16	4.7276e-18
C321	a_27_125##4	a_27_125##6	2.29413e-18
C322	VPWR#6	C1#6	3.1217e-18
C323	a_300_125##3	B1	3.45529e-17
C324	C1	a_114_125##16	3.06389e-17
C325	a_114_125##16	B1#5	2.77272e-17
C326	a_114_125##17	a_27_125##6	5.6767e-17
C327	X#2	A1#3	1.10201e-19
C328	a_114_125##8	a_114_125##7	3.66693e-17
C329	a_114_125##4	A1#5	3.33017e-19
C330	A2#4	a_114_125##18	6.5363e-19
C331	C1	VPWR#6	5.0578e-20
C332	a_27_125##4	C1#4	2.5244e-17
C333	a_114_125##4	A2#6	2.43412e-19
C334	VGND#5	A1#4	1.48419e-17
C335	a_300_125##3	a_114_125##15	5.66266e-18
C336	a_114_125##4	A2#1	4.67611e-19
C337	A1#2	a_114_125##12	2.94527e-18
C338	a_114_125##15	B2#6	1.73394e-17
C339	VPWR#6	C1#1	6.68824e-18
C340	a_763_387##2	A1#4	2.64738e-19
C341	a_114_125##17	C1#4	3.4327e-17
C342	B2	a_114_125##15	5.5829e-17
C343	a_114_125##17	a_300_125##5	1.90743e-17
C344	B1#4	B2#2	8.42331e-19
C345	C1#6	C1#1	4.06463e-17
C346	a_114_125##4	A1#1	1.31019e-17
C347	a_114_125##16	B2	7.56345e-18
C348	a_300_125#	A2	1.42874e-17
C349	a_27_125#	B1#2	2.52568e-19
C350	a_114_125##16	B2#6	5.90608e-19
C351	a_27_125##4	C1#5	7.3557e-19
C352	a_114_125##4	a_114_125##12	9.00438e-18
C353	a_300_125##2	B1	7.83418e-17
C354	X#2	a_114_125##6	4.27355e-19
C355	a_27_125##6	C1#4	1.51492e-18
C356	B1#4	B1#3	1.81126e-19
C357	a_114_125##4	a_114_125##11	8.73455e-19
C358	C1#3	C1#2	2.62523e-18
C359	C1#1	B1#5	4.15525e-17
C360	a_300_125#	A1#6	2.72641e-17
C361	a_114_125##17	C1#5	2.83298e-17
C362	a_114_125##4	a_114_125##9	1.40222e-19
C363	a_27_125##6	a_300_125##5	3.70792e-17
C364	VGND#5	A2#5	5.98591e-19
C365	a_300_125##5	C1#4	3.04208e-19
C366	a_114_125##15	B2#1	1.5733e-17
C367	B1	a_114_125##14	8.52482e-17
C368	a_114_125##4	a_114_125#	1.02656e-18
C369	VPWR#6	B1#5	7.33039e-18
C370	B1	a_114_125##15	2.99216e-17
C371	B1#3	B1#6	3.35162e-17
C372	a_27_125##6	C1#5	2.70916e-17
C373	B1#5	B2#6	3.44688e-17
C374	B1#3	A1#4	5.8139e-17
C375	a_114_125##16	B2#1	3.40243e-19
C376	a_300_125##2	A2	1.01986e-17
C377	a_763_387#	A2#4	1.16523e-19
C378	X#2	a_114_125##10	1.10421e-18
C379	a_114_125##17	B1#4	7.07629e-18
C380	a_27_125##6	a_27_125##5	1.87372e-18
C381	A2	A1#6	1.10444e-17
C382	a_300_125##5	C1#5	1.8299e-18
C383	C1#3	VPWR#7	5.31057e-18
C384	A1#6	VGND#8	2.59863e-17
C385	VPWR#7	a_114_125##20	7.6393e-17
C386	C1#2	B1#5	1.17301e-17
C387	C1#3	a_114_125##20	3.19913e-18
C388	VGND#6	C1#4	1.11579e-18
C389	B2#6	B2#1	4.23767e-17
C390	VGND#5	A2#3	8.39168e-19
C391	B1#4	a_27_125##6	1.2913e-17
C392	A2	a_114_125##14	4.44523e-17
C393	a_114_125##15	B1#1	2.72556e-17
C394	VGND#3	A1#3	5.88776e-19
C395	B1#5	B2#4	1.2701e-17
C396	a_27_125##5	C1#5	1.53614e-19
C397	VGND#6	C1#5	1.11953e-18
C398	VPWR#6	B2#6	4.22542e-18
C399	a_114_125##17	B2#5	4.14285e-19
C400	VPWR#7	VPWR#11	2.32803e-18
C401	a_114_125##16	B1#1	4.32386e-19
C402	a_300_125##5	a_27_125##5	4.19296e-17
C403	VGND#6	B1#4	3.03955e-17
C404	VPWR#2	a_114_125##9	1.07032e-18
C405	a_300_125##5	B1#4	4.20882e-17
C406	X#2	a_114_125##8	3.70545e-17
C407	VGND#4	A1#3	1.20653e-17
C408	B2#1	B1#1	4.17591e-17
C409	VGND#6	B2#5	2.17134e-18
C410	VPWR#2	a_114_125#	8.26127e-18
C411	a_114_125##14	A1#5	2.53219e-17
C412	B2#4	B2#2	2.48974e-18
C413	A2#3	A1#2	2.52237e-18
C414	a_27_125##6	B2#5	3.60015e-19
C415	a_297_387##2	B2#2	9.36909e-20
C416	VGND#6	B2#3	1.51215e-18
C417	B2#2	B1#2	2.02715e-17
C418	a_27_125##5	B1#4	7.97656e-19
C419	a_114_125##20	VPWR#11	5.1156e-17
C420	B2#2	a_114_125##19	5.02361e-19
C421	a_114_125##17	B2#3	2.30226e-19
C422	a_763_387#	A1#3	4.04461e-19
C423	a_114_125##15	A1#5	7.49374e-20
C424	VGND#5	a_300_125##2	3.04985e-19
C425	VGND#6	B1#6	2.11502e-18
C426	VGND#5	A1#3	1.95434e-17
C427	a_300_125##5	a_300_125##3	2.42654e-18
C428	X#1	a_114_125##2	2.03947e-17
C429	a_297_387#	B2#2	1.16523e-19
C430	a_300_125##5	B2#5	3.37729e-17
C431	B1#1	A1#5	8.15322e-18
C432	VGND#6	A1#4	1.16686e-17
C433	a_300_125##3	B1#4	2.59614e-18
C434	VPWR#10	B2#2	1.19509e-20
C435	a_27_125##6	B2#3	1.64034e-19
C436	A1	A2#4	3.9117e-18
C437	X#2	a_114_125##7	2.31139e-17
C438	B2#5	a_27_125##5	2.11254e-17
C439	A1	a_114_125##5	8.28787e-19
C440	VGND#4	a_114_125##6	3.78253e-18
C441	a_114_125##14	A2#6	1.76842e-17
C442	a_114_125##17	B1#6	1.26056e-19
C443	a_27_125#	B1#4	2.13947e-18
C444	a_300_125##3	a_27_125##5	3.70306e-17
C445	A1#5	A2#6	3.5076e-17
C446	a_27_125##3	a_27_125##2	1.7119e-18
C447	a_300_125##5	B2#3	9.30708e-19
C448	VGND#6	A1#3	2.75714e-20
C449	B1#3	VPWR#10	4.41237e-18
C450	a_300_125#	a_114_125##14	5.20185e-18
C451	a_114_125##15	A2#6	3.58413e-20
C452	a_114_125##20	a_114_125##19	1.33559e-18
C453	VPWR#11	a_297_387##2	6.55124e-17
C454	a_300_125##3	B2#5	6.82619e-19
C455	VGND#3	a_114_125##10	9.70727e-19
C456	VGND#10	B1#4	1.31405e-19
C457	a_27_125##4	C1#3	5.85203e-18
C458	VGND#4	A1#6	4.40523e-19
C459	a_27_125##5	B2#3	2.69732e-17
C460	a_114_125##17	C1#3	3.94994e-18
C461	A2#6	A2#1	3.45015e-17
C462	a_27_125##5	a_27_125#	3.29522e-18
C463	a_114_125##14	A2#1	1.81371e-17
C464	a_300_125##5	B1#6	2.01717e-19
C465	B1#3	B1#2	8.54764e-18
C466	a_300_125##3	B2#3	3.54151e-17
C467	VGND#2	A1#3	8.14049e-20
C468	X#2	a_114_125##2	2.63993e-18
C469	a_114_125##17	B2#2	9.53794e-20
C470	a_27_125##5	B1#6	1.02788e-18
C471	C1	C1#2	8.50605e-18
C472	X#1	a_114_125##5	3.17364e-20
C473	a_297_387##2	a_114_125##19	4.41979e-17
C474	VGND#3	a_114_125##8	2.31154e-18
C475	A2#1	A1#1	3.06479e-17
C476	a_27_125#	B2#3	1.05971e-18
C477	a_300_125##3	a_27_125#	4.81346e-17
C478	a_300_125##5	B2#2	1.24015e-18
C479	a_114_125##16	VPWR#11	3.40234e-17
C480	a_300_125##3	B1#6	3.16159e-17
C481	a_114_125##14	A1#1	8.76295e-18
C482	a_27_125##5	B2#2	4.6308e-19
C483	a_114_125##14	VPWR#4	3.2017e-19
C484	VGND#2	a_114_125##8	6.17994e-18
C485	VGND#10	B2#3	2.96654e-19
C486	X#2	X#1	2.61998e-18
C487	a_300_125##3	B2#2	1.50945e-17
C488	a_763_387#	A1#2	4.78144e-19
C489	a_114_125##17	B1#3	2.61425e-19
C490	a_297_387##2	a_297_387#	3.01982e-18
C491	a_114_125##15	a_297_387##2	2.15007e-17
C492	VGND#2	a_114_125##7	1.17699e-17
C493	A1#1	a_114_125##12	3.98439e-17
C494	a_27_125#	B1#6	2.05171e-17
C495	a_300_125##3	VGND#10	2.1118e-18
C496	a_300_125##6	B2#3	6.40103e-20
C497	a_300_125##3	A1#4	4.43118e-19
C498	a_297_387#	a_114_125##19	4.48116e-17
C499	a_114_125##16	a_297_387##2	2.00303e-17
C500	VGND#10	B1#6	1.26836e-18
C501	C1#2	B1#4	1.16635e-17
C502	a_300_125##3	B1#3	2.22685e-17
C503	VGND#9	A2#4	5.76288e-19
C504	a_114_125##4	VPWR#9	4.11002e-17
C505	a_114_125##12	a_114_125##11	3.26999e-17
C506	a_27_125#	B1#3	1.85786e-17
C507	a_27_125#	A1#4	1.12148e-18
C508	VPWR#7	VPWR#6	1.2188e-18
C509	a_300_125##3	a_300_125##6	7.77899e-19
C510	a_114_125##15	a_114_125##19	2.76671e-18
C511	a_114_125##4	X#5	9.16632e-17
C512	a_27_125#	VGND#10	3.29631e-17
C513	VGND#10	B1#3	1.30035e-17
C514	B2	C1#2	1.67773e-18
C515	B1#4	B2#4	1.22328e-17
C516	a_300_125##6	B1#6	1.13152e-19
C517	VGND#1	VPWR#1	4.26911e-19
C518	B2	B2#4	7.34179e-18
C519	a_300_125##3	A2#5	1.93216e-19
C520	a_114_125##4	VPWR#8	3.14908e-18
C521	VPWR#4	A2#1	4.13025e-18
C522	B2	B1#2	1.18382e-17
C523	a_300_125##6	B1#3	4.70484e-19
C524	X#5	a_114_125##5	3.85629e-19
C525	VGND#10	A1#4	2.92414e-17
C526	a_27_125##3	C1#3	4.14625e-19
C527	a_114_125##11	a_114_125##9	4.64613e-17
C528	a_114_125##19	a_763_387##2	2.39087e-20
C529	C1#2	a_114_125##20	2.5965e-19
C530	a_297_387#	VPWR#10	1.19033e-16
C531	a_27_125##3	C1#4	4.38172e-18
C532	X#1	a_114_125##12	2.3081e-19
C533	X#1	VPWR#3	1.6556e-19
C534	A1#4	a_300_125##6	1.99285e-17
C535	C1#6	VPWR#7	3.51347e-17
C536	a_114_125##15	a_297_387#	3.80056e-17
C537	a_114_125##20	VPWR#6	1.51443e-17
C538	VGND#10	A2#5	1.73469e-18
C539	a_300_125##2	A2#4	1.18892e-18
C540	a_114_125##20	C1#6	5.07043e-17
C541	VPWR#4	A1#1	4.01928e-18
C542	a_27_125##2	C1#5	2.21205e-19
C543	a_114_125##14	VPWR#10	4.45998e-17
C544	VGND#9	A1#4	2.90034e-18
C545	a_114_125##9	a_114_125#	3.57767e-17
C546	VPWR#6	C1#2	3.34957e-21
C547	VPWR#11	C1#6	8.02546e-19
C548	VPWR#7	C1#1	1.36732e-18
C549	VGND#10	a_300_125##6	3.06826e-17
C550	VGND#6	a_27_125##4	3.66364e-17
C551	a_300_125#	A2#4	1.26432e-18
C552	A2#5	a_300_125##6	1.15911e-17
C553	a_27_125##3	C1#5	5.09076e-18
C554	A2#4	A1#2	3.20356e-17
C555	a_114_125##20	C1#1	5.50096e-17
C556	X#1	a_114_125##11	5.93652e-19
C557	a_114_125##16	VPWR#6	6.69812e-19
C558	a_300_125#	A1#4	3.11081e-19
C559	VPWR#3	a_114_125##12	3.00326e-19
C560	a_114_125##18	a_297_387#	1.35473e-20
C561	a_114_125##15	VPWR#10	4.04671e-17
C562	VPWR#10	a_763_387##2	1.23536e-16
C563	VPWR#7	B1#5	3.42943e-19
C564	B1	B1#2	1.3004e-18
C565	C1#1	VPWR#11	1.99705e-17
C566	VGND#9	A2#5	2.56856e-17
C567	a_27_125##2	B1#4	1.91222e-17
C568	B1	A2#4	1.5864e-17
C569	a_27_125##3	B1#3	2.51432e-20
C570	VPWR#4	a_114_125##12	3.46471e-18
C571	VGND#10	VGND#9	7.89608e-18
C572	a_114_125##16	C1#3	1.92415e-19
C573	VGND#8	A1#4	1.17654e-19
C574	a_114_125##14	a_763_387##2	3.80788e-17
C575	X#3	X#2	3.02041e-18
C576	a_114_125##20	B1#5	1.71327e-18
C577	A1#2	a_114_125##5	2.21902e-17
C578	VGND#8	A1#2	3.75591e-18
C579	a_300_125##6	A2#3	6.6254e-19
C580	VPWR#6	B2#4	2.34174e-21
C581	a_27_125##3	B1#4	2.83875e-17
C582	a_300_125#	A2#5	7.11928e-19
C583	a_114_125##19	C1#1	1.60166e-19
C584	VPWR#11	B1#5	4.51774e-17
C585	VGND#6	a_300_125##3	1.00229e-18
C586	a_27_125##4	VPWR#7	4.18018e-19
C587	VPWR#4	A2#4	1.19509e-20
C588	VGND#10	A1#3	1.06095e-19
C589	a_300_125##2	B1#3	1.2426e-17
C590	X#1	a_114_125##9	1.78536e-17
C591	VGND#6	a_27_125#	3.60383e-17
C592	a_114_125##20	B2#6	2.20152e-19
C593	VGND#9	A2#3	2.84549e-17
C594	a_114_125##15	a_763_387##2	5.65328e-21
C595	B1#5	a_297_387##2	2.22714e-17
C596	VPWR#3	a_114_125##11	7.53905e-18
C597	a_27_125##2	B2#5	3.60921e-18
C598	VPWR#6	a_297_387##2	5.02879e-17
C599	a_300_125##6	VGND#9	2.3272e-17
C600	B2#2	a_114_125##15	1.50604e-17
C601	X#7	VPWR#2	3.20741e-17
C602	A1#6	B1#3	2.61171e-19
C603	VGND#8	a_114_125##4	2.84676e-17
C604	a_763_387##2	a_114_125##18	5.8236e-17
C605	a_300_125##6	A1#3	2.8016e-19
C606	A1#5	A2#4	1.11238e-17
C607	VPWR#11	B2#6	1.04332e-18
C608	a_114_125##19	B1#5	7.52793e-19
C609	a_114_125##14	a_114_125##18	2.10425e-18
C610	VPWR#6	C1#3	4.0695e-20
C611	a_114_125##16	B2#2	8.18305e-20
C612	VGND#6	a_300_125##6	2.00298e-18
C613	X#2	VGND#7	5.37186e-17
C614	VPWR#2	VPWR#1	1.49217e-17
C615	a_114_125##4	X#3	6.17423e-17
C616	a_300_125#	A2#3	3.23018e-17
C617	a_27_125##3	B2#5	4.24304e-19
C618	a_114_125##20	B2#1	1.23305e-19
C619	a_297_387##2	B2#6	5.44301e-17
C620	VGND#6	VGND#9	1.29572e-19
C621	a_114_125##4	A2#4	4.96557e-19
C622	a_114_125##4	VGND#7	7.27223e-18
C623	VGND#9	A1#3	3.26487e-18
C624	VGND#5	a_300_125##6	1.98456e-18
C625	a_27_125##4	a_27_125##3	4.31837e-19
C626	VPWR#10	VPWR#9	4.62777e-20
C627	X#1	a_114_125#	2.06774e-17
C628	B2#6	a_114_125##19	2.38938e-17
C629	a_114_125##4	a_114_125##2	1.91206e-18
C630	a_763_387##2	a_763_387#	2.54657e-18
C631	C1#4	C1#5	3.4075e-17
C632	a_114_125##4	X#6	4.87731e-19
C633	a_300_125##6	a_300_125#	3.739e-18
C634	a_27_125##2	B2#3	3.25417e-18
C635	a_114_125##14	B1#3	3.81487e-18
C636	VGND#8	A2#3	8.43951e-19
C637	a_114_125##17	a_114_125##20	1.13075e-19
C638	VPWR#3	a_114_125##9	4.19472e-18
C639	A1#6	B1#2	7.08865e-20
C640	A2	A2#4	2.18937e-17
C641	a_114_125##15	B1#3	3.6282e-18
C642	a_297_387##2	B2#1	1.37698e-18
C643	a_297_387#	B2#6	1.37698e-18
C644	a_300_125#	A1#3	4.71478e-17
C645	a_114_125##14	a_763_387#	3.7857e-17
C646	a_114_125##4	a_114_125##5	1.47904e-17
C647	VPWR#6	B2#2	9.6092e-21
C648	a_27_125##3	B2#3	1.93325e-19
C649	X#2	X#6	8.01171e-19
C650	B2#1	a_114_125##19	2.00931e-17
C651	a_763_387#	a_114_125##18	5.75074e-17
C652	VGND#9	a_114_125##6	6.91104e-19
C653	VGND#1	X#1	3.07703e-18
C654	a_300_125#	VGND#9	3.92071e-17
C655	a_27_125##3	a_114_125##17	2.22e-17
C656	C1#5	B1#4	2.92576e-17
C657	A1#3	VGND#8	2.7678e-17
C658	a_297_387#	B2#1	4.62743e-17
C659	a_27_125##2	B1#6	3.18334e-20
C660	a_27_125##6	a_27_125##2	2.24846e-19
C661	VGND#3	X#2	3.28407e-18
C662	A1#6	A2#4	4.66907e-18
C663	a_297_387##2	B2#4	2.28322e-20
C664	VPWR#4	VPWR#3	9.95172e-19
C665	a_114_125##19	B1#1	8.8e-19
C666	VPWR#3	a_114_125#	6.53344e-19
C667	A1#6	A1#2	1.13882e-17
C668	VPWR#10	B2#1	4.11601e-18
C669	VGND#4	a_300_125#	2.58287e-18
C670	a_297_387#	B1#1	4.92343e-17
C671	X#2	VGND#1	7.08827e-17
C672	VGND#9	VGND#8	7.28874e-18
C673	a_114_125##17	C1#2	5.52951e-19
C674	a_114_125##6	VGND#8	2.27292e-17
C675	B1#4	B2#5	4.34655e-17
C676	VGND#6	a_27_125##2	6.28955e-17
C677	a_114_125##19	A1#5	3.16923e-19
C678	VPWR#10	VPWR#4	2.34474e-19
C679	B1#1	VPWR#10	4.55085e-17
C680	a_114_125##18	B2#1	2.28002e-19
C681	a_27_125##2	a_300_125##5	1.40406e-17
C682	a_114_125##18	X#5	1.69272e-18
C683	VGND#7	A1#3	1.02675e-18
C684	a_763_387#	VPWR#9	6.5172e-17
C685	VGND#6	a_27_125##3	7.44292e-17
C686	VPWR#4	a_114_125##5	5.45898e-21
C687	a_114_125##14	A1#2	1.45372e-18
C688	VGND#5	a_300_125#	2.95158e-18
C689	A1#6	a_114_125##4	2.21167e-17
C690	B1#4	B2#3	1.62718e-17
C691	X#3	a_114_125##6	3.81085e-17
C692	VGND#7	VGND#2	5.69732e-19
C693	a_114_125##17	B2#4	4.97142e-19
C694	a_114_125##19	A2#6	1.51579e-19
C695	VPWR#6	VPWR#10	3.28791e-19
C696	a_300_125#	VGND#8	5.02155e-17
C697	A1#5	VPWR#10	4.00262e-17
C698	a_114_125##18	B1#1	4.59047e-19
C699	VGND#8	a_114_125##10	8.10533e-19
C700	VGND#3	X#3	4.86952e-18
C701	a_27_125##3	a_300_125##5	1.39322e-17
C702	B1#4	B1#6	6.78592e-18
C703	B2#5	B2#3	2.96668e-17
C704	VGND#6	a_300_125##2	3.61425e-19
C705	VGND#7	a_114_125##6	1.75081e-18
C706	a_763_387##2	A1#5	4.45167e-17
C707	a_300_125##2	B1#6	2.18798e-20
C708	VGND#1	A1#3	1.31285e-19
C709	B2#4	a_114_125##19	5.41579e-20
C710	X#3	a_114_125##10	3.1081e-17
C711	VPWR#10	A2#6	4.11616e-18
C712	a_114_125##17	B1#2	5.22231e-20
C713	a_114_125##18	A1#5	1.93959e-18
C714	a_114_125##15	B1#4	4.76151e-19
C715	VGND#5	VGND#8	1.48589e-18
C716	VPWR#9	X#5	5.38766e-17
C717	a_763_387##2	A2#6	2.9332e-17
C718	VGND#4	X#3	4.27466e-18
C719	a_763_387#	A1#5	1.91936e-19
C720	VPWR#4	A1#2	1.8189e-20
C721	B2#3	B1#6	3.52995e-17
C722	VGND#7	a_114_125##10	3.66023e-17
C723	a_114_125##16	B1#4	2.85327e-18
C724	a_27_125##2	a_300_125##3	1.70766e-17
C725	X#1	a_114_125##4	6.43733e-17
C726	a_300_125##2	A1#4	1.59921e-17
C727	A2#6	a_114_125##18	3.37395e-17
C728	A1#6	B1#6	2.19993e-19
C729	a_27_125##3	a_114_125##16	7.09447e-19
C730	X#3	a_114_125##8	6.02384e-19
C731	X#2	a_114_125##4	3.62603e-17
C732	VPWR#9	VPWR#8	2.09714e-18
C733	A1#6	a_114_125##5	2.79376e-18
C734	X#3	a_114_125##5	8.9664e-19
C735	a_763_387##2	A2#1	1.15681e-18
C736	VGND#8	X#3	6.20666e-17
C737	a_763_387#	A2#6	4.44518e-19
C738	VPWR#3	a_114_125##4	4.5196e-20
*
*
.ENDS sky130_fd_sc_hs__o221a_4
*
