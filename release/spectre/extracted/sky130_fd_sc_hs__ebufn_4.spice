* Extracted by Quantus, converted by sky130cad/quantus.py
*
*
*
*                       LINUX           Wed Nov 18 08:35:58 2026
*
*
*
*  PROGRAM  advgen
*
*  Name           : advgen - Quantus - (64-bit)
*  Version        : 25.1.0-p047
*  Build Date     : Thu Dec 11 23:20:30 PST 2025
*
*  HSPICE LIBRARY
*
*  OPERATING_TEMPERATURE 150
*  QRC_TECH_DIR <path>/tech
*
*
*

*
.SUBCKT sky130_fd_sc_hs__ebufn_4 VPB VNB VGND VPWR Z TE_B A
*
*
*  caps2d version: 10
*
*
*       TRANSISTOR CARDS
*
*
XM9 a_27_368##16 A#1 VGND#9 VNB sky130_fd_pr__nfet_01v8_lvt l=0.15 w=0.74 ad=0.2109 as=0.2072 pd=2.05 ps=2.04
XM7 VGND#9 TE_B#7 a_208_74##11 VNB sky130_fd_pr__nfet_01v8_lvt l=0.15 w=0.74 ad=0.2072 as=0.2109 pd=2.04 ps=2.05
XM1 a_378_74##6 a_208_74##8 VGND#8 VNB sky130_fd_pr__nfet_01v8_lvt l=0.15 w=0.74 ad=0.2072 as=0.2072 pd=2.04 ps=2.04
XM4 VGND#8 a_208_74##7 a_378_74##8 VNB sky130_fd_pr__nfet_01v8_lvt l=0.15 w=0.74 ad=0.2072 as=0.2072 pd=2.04 ps=2.04
XM16 a_378_74##8 a_208_74##6 VGND#7 VNB sky130_fd_pr__nfet_01v8_lvt l=0.15 w=0.74 ad=0.2072 as=0.2072 pd=2.04 ps=2.04
XM18 VGND#7 a_208_74# a_378_74##3 VNB sky130_fd_pr__nfet_01v8_lvt l=0.15 w=0.74 ad=0.2072 as=0.2072 pd=2.04 ps=2.04
XM3 Z#1 a_27_368##12 a_378_74##3 VNB sky130_fd_pr__nfet_01v8_lvt l=0.15 w=0.74 ad=0.2072 as=0.2072 pd=2.04 ps=2.04
XM10 a_378_74##7 a_27_368##10 Z#1 VNB sky130_fd_pr__nfet_01v8_lvt l=0.15 w=0.74 ad=0.2072 as=0.2072 pd=2.04 ps=2.04
XM13 Z#5 a_27_368##8 a_378_74##7 VNB sky130_fd_pr__nfet_01v8_lvt l=0.15 w=0.74 ad=0.222 as=0.2072 pd=2.08 ps=2.04
XM17 a_378_74# a_27_368# Z#5 VNB sky130_fd_pr__nfet_01v8_lvt l=0.15 w=0.74 ad=0.2035 as=0.222 pd=2.03 ps=2.08
XM0 a_27_368##14 A#3 VPWR#9 VPB sky130_fd_pr__pfet_01v8 l=0.15 w=1.12 ad=0.3304 as=0.364 pd=2.83 ps=2.89
XM8 VPWR#9 TE_B#11 a_208_74##9 VPB sky130_fd_pr__pfet_01v8 l=0.15 w=1.12 ad=0.364 as=0.3304 pd=2.89 ps=2.83
XM11 a_348_368##8 TE_B#10 VPWR#8 VPB sky130_fd_pr__pfet_01v8 l=0.15 w=1.12 ad=0.3304 as=0.336 pd=2.83 ps=2.84
XM12 VPWR#8 TE_B#9 a_348_368##5 VPB sky130_fd_pr__pfet_01v8 l=0.15 w=1.12 ad=0.336 as=0.336 pd=2.84 ps=2.84
XM14 VPWR#7 TE_B#8 a_348_368##5 VPB sky130_fd_pr__pfet_01v8 l=0.15 w=1.12 ad=0.336 as=0.336 pd=2.84 ps=2.84
XM19 a_348_368##3 TE_B#1 VPWR#7 VPB sky130_fd_pr__pfet_01v8 l=0.15 w=1.12 ad=0.336 as=0.336 pd=2.84 ps=2.84
XM5 a_348_368##3 a_27_368##6 Z#4 VPB sky130_fd_pr__pfet_01v8 l=0.15 w=1.12 ad=0.336 as=0.336 pd=2.84 ps=2.84
XM6 Z#4 a_27_368##11 a_348_368##7 VPB sky130_fd_pr__pfet_01v8 l=0.15 w=1.12 ad=0.336 as=0.336 pd=2.84 ps=2.84
XM15 Z#6 a_27_368##9 a_348_368##7 VPB sky130_fd_pr__pfet_01v8 l=0.15 w=1.12 ad=0.336 as=0.336 pd=2.84 ps=2.84
XM2 a_348_368# a_27_368##7 Z#6 VPB sky130_fd_pr__pfet_01v8 l=0.15 w=1.12 ad=0.3248 as=0.336 pd=2.82 ps=2.84
*
*
*       RESISTOR AND CAP/DIODE CARDS
*
Rg1	A#1	A#2	366.265259
Rg2	A#2	A#3	465.025360
Rg3	TE_B#1	TE_B#2	599.066956
Rg4	TE_B#2	TE_B#3	214.351181
Rg5	TE_B#3	TE_B#4	214.351181
Rg6	TE_B#4	TE_B#5	496.082092
Rg7	TE_B#5	TE_B#6	47.932892
Rg8	TE_B#6	TE_B#7	332.803345
Rg9	TE_B#2	TE_B#8	385.612793
Rg10	TE_B#3	TE_B#9	385.612793
Rg11	TE_B#4	TE_B#10	385.612793
Rg12	TE_B#5	TE_B#11	413.695587
Rg13	a_208_74#	a_208_74##2	473.208221
Rg14	a_208_74##2	a_208_74##3	210.494781
Rg15	a_208_74##3	a_208_74##4	210.494781
Rg16	a_208_74##4	a_208_74##5	410.554993
Rg17	a_208_74##2	a_208_74##6	262.702026
Rg18	a_208_74##3	a_208_74##7	262.702026
Rg19	a_208_74##4	a_208_74##8	262.702026
Rg20	a_27_368#	a_27_368##2	380.339874
Rg21	a_27_368##2	a_27_368##3	66.369736
Rg22	a_27_368##3	a_27_368##4	86.720970
Rg23	a_27_368##4	a_27_368##5	58.569527
Rg24	a_27_368##5	a_27_368##6	467.025726
Rg25	a_27_368##2	a_27_368##7	462.979767
Rg26	a_27_368##3	a_27_368##8	377.345459
Rg27	a_27_368##3	a_27_368##9	459.985352
Rg28	a_27_368##4	a_27_368##10	364.143097
Rg29	a_27_368##4	a_27_368##11	446.171570
Rg30	a_27_368##5	a_27_368##12	394.071777
Rf1	A#2	A#5	163.673721
Rf2	A#6	A	3.440917
Rf3	A#5	A#6	5.634589
Rf4	TE_B#12	TE_B#6	162.112686
Rf5	TE_B	TE_B#14	1.879877
Rf6	TE_B#12	TE_B#14	4.412288
Rf7	a_208_74##9	a_208_74##5	87.838860
Rf8	a_208_74##5	a_208_74##11	15.745702
Rf9	a_27_368##4	a_27_368##15	377.115417
Rf10	a_27_368##15	a_27_368##16	111.021149
Rf11	a_27_368##14	a_27_368##15	5.000000
Rf12	Z#1	Z#2	71.715492
Rf13	Z#2	Z#3	59.679474
Rf14	Z#3	Z#4	71.433052
Rf15	Z#2	Z#5	23.672878
Rf16	Z#3	Z	5.647644
Rf17	Z	Z#7	10.672221
Rf18	Z#7	Z	3.686767
Rf19	Z#6	Z#7	5.000000
Rf20	a_348_368#	a_348_368##2	98.263313
Rf21	a_348_368##2	a_348_368##4	93.554710
Rf22	a_348_368##4	a_348_368##6	113.905884
Rf23	a_348_368##2	a_348_368##7	26.057018
Rf24	a_348_368##6	a_348_368##8	77.814148
Rf26	a_348_368##3	a_348_368##4	5.000000
Rf27	a_348_368##5	a_348_368##6	5.000000
Rf28	a_378_74#	a_378_74##2	89.630066
Rf29	a_378_74##2	a_378_74##4	80.960449
Rf30	a_378_74##4	a_378_74##5	72.422668
Rf31	a_378_74##5	a_378_74##6	102.522240
Rf32	a_378_74##2	a_378_74##7	27.405241
Rf33	a_378_74##5	a_378_74##8	27.348812
Rf34	a_378_74##3	a_378_74##4	7.500000
Rf36	VGND#2	VGND#3	29.253016
Rf37	VGND#3	VGND#4	30.656675
Rf38	VGND#4	VGND#5	124.867279
Rf40	VGND#2	VGND#7	43.678436
Rf41	VGND#4	VGND#8	31.141060
Rf42	VGND#5	VGND#9	31.534733
Rf44	VPWR#2	VPWR#3	23.043722
Rf45	VPWR#3	VPWR#4	39.787987
Rf46	VPWR#4	VPWR#5	116.270370
Rf48	VPWR#2	VPWR#7	42.062149
Rf49	VPWR#4	VPWR#8	31.554951
Rf50	VPWR#5	VPWR#9	30.809536
Re1	VPWR#3	VPWR	0.818510
Re2	VGND	VGND#3	0.818540
*
*       CAPACITOR CARDS
*
*
C1	a_378_74##7	a_378_74#	2.91501e-18
C2	a_348_368##3	TE_B#2	1.4566e-18
C3	a_348_368##2	a_348_368##7	1.79159e-18
C4	Z#3	a_348_368#	3.0325e-17
C5	a_208_74##11	TE_B#14	4.26727e-17
C6	a_208_74##3	TE_B#3	1.74284e-17
C7	Z#3	Z#6	2.27602e-19
C8	a_348_368##2	Z#4	3.16904e-17
C9	a_27_368##14	VPWR#4	2.5094e-18
C10	Z#1	a_378_74##7	2.91877e-17
C11	Z#3	a_348_368##7	1.91759e-17
C12	VPWR#7	TE_B#2	6.60708e-19
C13	a_378_74##3	a_378_74##7	3.00757e-18
C14	TE_B#14	TE_B#5	5.8566e-18
C15	Z#4	Z#3	1.98655e-18
C16	a_208_74##3	TE_B#2	5.59431e-18
C17	a_378_74##3	Z#1	5.15676e-17
C18	a_348_368##5	TE_B#3	1.63522e-18
C19	A#6	VGND#9	1.36005e-17
C20	a_348_368##5	TE_B#2	1.90652e-18
C21	a_378_74##3	VGND#7	4.64101e-17
C22	VGND#9	A#5	3.21269e-18
C23	VPWR#8	TE_B#4	1.62398e-19
C24	a_208_74##2	TE_B#2	2.1853e-17
C25	a_208_74##9	a_27_368##5	7.43447e-20
C26	a_378_74##8	a_378_74##3	2.35749e-18
C27	TE_B#3	VPWR#8	3.82135e-19
C28	a_27_368##16	A#5	1.43034e-17
C29	A#3	TE_B#5	1.24732e-18
C30	a_378_74##8	VGND#7	3.69713e-17
C31	VGND#8	VGND#7	8.48348e-19
C32	TE_B#4	a_348_368##8	9.37905e-19
C33	a_378_74#	a_348_368#	9.93747e-18
C34	VGND#8	a_378_74##8	4.48041e-17
C35	VPWR#4	TE_B#5	3.5247e-20
C36	a_208_74##9	TE_B#5	2.16775e-17
C37	VPWR#4	TE_B#4	1.44588e-19
C38	a_378_74##6	VGND#8	6.3497e-17
C39	A#6	TE_B#5	9.31721e-18
C40	a_208_74##9	TE_B#4	1.20461e-17
C41	VGND#4	a_378_74##5	9.2345e-20
C42	a_378_74##2	a_27_368##8	1.4802e-17
C43	a_208_74##11	VGND#8	2.52597e-18
C44	a_378_74##2	a_27_368##10	1.46296e-17
C45	a_208_74##11	a_378_74##6	8.65296e-17
C46	VGND#9	VGND#8	1.51826e-20
C47	VPWR#3	TE_B#3	1.91147e-20
C48	VPWR#3	TE_B#2	1.80692e-20
C49	a_27_368##14	a_208_74##4	1.7606e-18
C50	TE_B#14	a_208_74##9	2.17613e-17
C51	a_378_74##5	a_208_74#	3.20042e-20
C52	VGND#4	a_208_74##7	4.82721e-19
C53	VGND#9	a_208_74##11	6.1447e-17
C54	VGND#3	a_208_74##3	7.33329e-20
C55	Z#2	a_27_368#	1.62312e-17
C56	VGND#3	a_208_74##2	7.24163e-20
C57	a_378_74#	a_27_368##2	1.74964e-19
C58	a_378_74##5	a_208_74##6	7.56374e-18
C59	a_27_368##16	a_208_74##11	2.16452e-18
C60	Z#2	a_27_368##8	2.62009e-17
C61	a_27_368##14	TE_B#5	4.14108e-18
C62	VGND#4	a_208_74##8	1.2494e-18
C63	A#6	a_208_74##9	9.58649e-18
C64	a_27_368##4	a_27_368##5	2.50116e-17
C65	a_27_368##16	VGND#9	5.66518e-17
C66	a_27_368##4	a_27_368##3	1.9711e-17
C67	a_27_368##14	TE_B#4	5.3173e-18
C68	a_378_74##5	a_208_74##7	5.89333e-18
C69	Z#2	a_27_368##10	1.03181e-18
C70	a_27_368##4	a_208_74##4	2.26474e-18
C71	a_27_368##4	a_208_74##3	4.31682e-18
C72	a_27_368##4	a_208_74##2	6.16881e-18
C73	a_27_368##2	Z#5	1.64694e-19
C74	a_27_368##4	TE_B#5	1.11701e-18
C75	a_378_74##5	a_208_74##8	3.72569e-19
C76	A#6	a_27_368##14	6.61502e-18
C77	a_27_368##4	TE_B#3	1.90969e-17
C78	VGND#4	a_208_74##4	5.43397e-19
C79	a_27_368##4	TE_B#2	1.15241e-17
C80	Z#2	a_208_74#	4.49517e-19
C81	a_27_368##14	A#5	3.7665e-17
C82	a_378_74##7	a_27_368##3	4.59493e-19
C83	a_348_368#	Z#6	6.04967e-17
C84	TE_B#5	a_208_74##5	2.39769e-17
C85	a_348_368##7	a_348_368#	3.8026e-18
C86	a_208_74##5	TE_B#4	1.33383e-17
C87	a_378_74#	a_27_368#	3.8349e-17
C88	a_348_368##7	Z#6	4.97014e-17
C89	a_27_368#	Z#5	1.57903e-17
C90	a_378_74#	a_27_368##8	1.08317e-18
C91	Z#4	Z#6	1.0081e-18
C92	Z#1	a_27_368##3	3.22307e-19
C93	a_378_74##7	a_27_368#	1.07048e-18
C94	a_27_368##8	Z#5	1.536e-17
C95	Z#4	a_348_368##7	5.63633e-17
C96	TE_B#6	TE_B#5	1.21755e-17
C97	a_378_74#	a_27_368##10	2.45042e-19
C98	a_27_368##8	a_378_74##7	1.53827e-17
C99	a_348_368##3	a_348_368##7	3.8026e-18
C100	VGND#4	TE_B#4	5.31151e-19
C101	Z#1	a_27_368##8	1.03181e-18
C102	a_378_74##3	a_27_368##5	1.55698e-18
C103	a_208_74##11	a_208_74##9	2.68854e-18
C104	a_27_368##10	a_378_74##7	1.7424e-17
C105	a_348_368##3	Z#4	6.98363e-17
C106	a_378_74##3	a_27_368##8	2.50755e-19
C107	Z#1	a_27_368##10	4.36168e-17
C108	a_378_74##5	a_27_368##5	1.84652e-19
C109	a_378_74##7	a_27_368##12	5.31334e-19
C110	a_378_74##6	a_27_368##14	8.50659e-18
C111	a_378_74##3	a_27_368##10	5.73793e-19
C112	a_208_74#	a_27_368##5	1.33715e-17
C113	A#2	TE_B#5	3.49119e-17
C114	Z#1	a_27_368##12	3.2409e-17
C115	a_348_368##3	VPWR#7	8.03772e-17
C116	a_378_74##7	a_208_74#	2.24137e-19
C117	a_378_74##5	a_27_368##3	8.13421e-20
C118	a_378_74##3	a_27_368##12	2.89977e-17
C119	VGND#9	a_27_368##14	1.64268e-18
C120	a_348_368##5	a_348_368##3	2.44864e-18
C121	Z#1	a_208_74#	1.18269e-18
C122	a_348_368##2	a_27_368##9	1.54879e-17
C123	Z#3	a_27_368##7	8.89767e-18
C124	a_27_368##16	a_27_368##14	1.25802e-18
C125	a_378_74##3	a_208_74#	5.22962e-17
C126	a_348_368##5	VPWR#7	5.74345e-17
C127	VPWR#4	TE_B#9	3.95647e-18
C128	a_208_74#	VGND#7	1.39178e-17
C129	a_348_368##2	a_27_368##11	1.54567e-17
C130	VPWR#8	VPWR#7	2.66815e-18
C131	Z#3	a_27_368##9	1.81422e-17
C132	a_378_74##3	a_208_74##6	1.55923e-18
C133	a_378_74##5	TE_B#1	3.32377e-19
C134	a_378_74##8	a_208_74#	3.48281e-19
C135	a_348_368##5	VPWR#8	1.98368e-17
C136	VGND#7	a_208_74##6	2.75165e-17
C137	a_378_74##5	a_208_74##4	9.25921e-19
C138	VPWR#4	TE_B#10	1.7832e-18
C139	a_378_74##3	a_208_74##7	2.03573e-19
C140	a_348_368##2	a_27_368##6	8.7534e-18
C141	Z#3	a_27_368##11	3.9367e-19
C142	a_208_74##6	a_378_74##8	1.21117e-17
C143	a_348_368##8	a_348_368##5	2.07158e-18
C144	VGND#7	a_208_74##7	9.89367e-19
C145	VGND#8	a_208_74##6	2.37826e-18
C146	a_348_368##8	VPWR#8	2.49222e-17
C147	a_378_74##5	a_208_74##3	8.47391e-18
C148	a_208_74##7	a_378_74##8	1.55885e-17
C149	Z#3	a_27_368##6	3.01481e-20
C150	a_378_74##6	a_208_74##6	1.69348e-19
C151	a_378_74##2	Z#2	1.72482e-17
C152	VGND#8	a_208_74##7	4.12862e-17
C153	VGND#7	a_208_74##2	6.15002e-19
C154	a_378_74##6	a_208_74##7	4.01452e-19
C155	a_378_74##5	a_208_74##2	1.65971e-17
C156	VPWR#9	VPWR#8	3.32596e-18
C157	Z#3	TE_B#1	1.42007e-19
C158	a_27_368##14	a_348_368##5	3.82073e-17
C159	VGND#8	a_208_74##8	3.57018e-17
C160	a_378_74##2	a_27_368##3	1.5935e-19
C161	a_378_74##6	a_208_74##8	1.75483e-17
C162	VPWR#9	a_348_368##8	5.13785e-18
C163	a_27_368##14	VPWR#8	4.48545e-19
C164	VGND#8	TE_B#7	2.63167e-19
C165	Z#3	a_348_368##2	1.45149e-18
C166	a_208_74##11	a_208_74##8	2.77977e-18
C167	a_208_74##3	a_378_74##8	4.96868e-19
C168	a_27_368##14	a_348_368##8	7.04698e-17
C169	a_378_74##2	a_27_368##2	3.33746e-20
C170	VGND#9	a_208_74##8	3.93962e-19
C171	TE_B#7	a_208_74##11	1.69248e-17
C172	a_27_368##14	a_208_74##9	9.2171e-17
C173	a_208_74##2	a_378_74##8	4.90657e-19
C174	VGND#9	TE_B#7	4.99969e-17
C175	a_348_368##3	a_208_74#	4.55455e-19
C176	a_27_368##14	VPWR#9	6.53714e-17
C177	a_208_74##11	A#1	1.12592e-19
C178	a_27_368##16	TE_B#7	1.14449e-18
C179	a_208_74##4	VGND#8	1.65461e-18
C180	VPWR#3	VPWR#4	4.41964e-17
C181	VGND#9	A#1	4.06999e-17
C182	a_378_74##5	TE_B#3	2.56039e-18
C183	a_27_368##16	A#1	2.04504e-17
C184	a_208_74##3	VGND#8	1.62547e-18
C185	a_378_74##5	TE_B#2	3.30105e-18
C186	a_27_368##8	a_27_368#	3.52927e-17
C187	a_378_74##6	a_208_74##4	1.67101e-17
C188	a_208_74##11	a_27_368##5	1.38424e-18
C189	Z#2	Z#3	3.69716e-18
C190	a_348_368#	a_27_368##7	4.48952e-17
C191	a_378_74##3	TE_B#1	1.44988e-18
C192	VGND#3	VGND#4	4.4555e-17
C193	Z#6	a_27_368##7	4.01293e-17
C194	a_27_368##10	a_27_368##8	3.96639e-17
C195	a_348_368#	a_27_368##9	1.31036e-18
C196	a_348_368##7	a_27_368##7	1.48559e-18
C197	a_348_368##2	a_27_368##5	2.0182e-20
C198	VGND#3	a_378_74##5	2.59492e-19
C199	Z#6	a_27_368##9	3.86556e-17
C200	a_348_368#	a_27_368##11	3.02705e-19
C201	a_27_368##12	a_27_368##10	3.78626e-17
C202	a_27_368##9	a_348_368##7	2.47335e-17
C203	Z#6	a_27_368##11	1.13156e-18
C204	Z#4	a_27_368##9	1.46973e-18
C205	a_348_368##2	a_27_368##3	8.33049e-20
C206	a_378_74##5	a_27_368##4	6.78962e-17
C207	a_27_368##11	a_348_368##7	2.88226e-17
C208	a_348_368##3	a_27_368##9	3.02705e-19
C209	a_27_368##3	a_27_368##2	3.37327e-18
C210	VGND#4	a_208_74##5	4.80198e-18
C211	a_208_74#	a_27_368##12	3.93748e-17
C212	Z#4	a_27_368##11	6.24493e-17
C213	a_378_74##2	a_27_368##4	4.01561e-19
C214	A#5	A#3	4.98751e-18
C215	a_378_74##6	TE_B#4	6.77016e-18
C216	a_348_368##7	a_27_368##6	7.36633e-19
C217	a_348_368##3	a_27_368##11	6.78335e-19
C218	a_348_368##2	a_27_368##2	1.83271e-20
C219	Z#4	a_27_368##6	4.78056e-17
C220	a_378_74##5	a_208_74##5	3.57779e-19
C221	a_27_368##4	a_348_368##2	7.18254e-19
C222	a_208_74##6	a_208_74#	3.50968e-17
C223	a_348_368##7	TE_B#1	3.06914e-19
C224	a_348_368##3	a_27_368##6	2.65658e-17
C225	a_378_74##6	TE_B#3	3.52706e-19
C226	A#1	TE_B#5	1.22468e-18
C227	Z#4	TE_B#1	1.60734e-18
C228	a_27_368##4	Z#3	4.22983e-17
C229	Z#2	a_27_368##4	3.36623e-17
C230	a_348_368##3	TE_B#1	6.60167e-17
C231	TE_B#5	a_208_74##11	1.13057e-17
C232	a_208_74##7	a_208_74##6	3.77676e-17
C233	TE_B#1	VPWR#7	2.0631e-17
C234	a_348_368##3	TE_B#8	2.09145e-18
C235	a_348_368##5	TE_B#1	3.70342e-19
C236	VPWR#7	TE_B#8	4.56093e-17
C237	a_208_74##8	a_208_74##7	3.65724e-17
C238	a_348_368##3	TE_B#9	2.0031e-19
C239	a_348_368##5	TE_B#8	4.17338e-17
C240	VPWR#7	TE_B#9	1.85163e-18
C241	VPWR#8	TE_B#8	1.91076e-18
C242	a_378_74##2	Z#5	1.71966e-19
C243	TE_B#14	a_208_74##5	3.86102e-18
C244	a_348_368##5	TE_B#9	3.06476e-17
C245	a_348_368##8	TE_B#8	1.63694e-19
C246	TE_B#7	a_208_74##8	3.71636e-19
C247	VPWR#8	TE_B#9	3.75167e-17
C248	a_348_368##5	TE_B#10	1.30678e-18
C249	a_348_368##8	TE_B#9	7.57591e-19
C250	a_27_368##4	a_378_74##7	2.78826e-18
C251	a_378_74##2	a_378_74##7	2.79369e-19
C252	VGND#3	a_378_74##8	1.05051e-17
C253	VPWR#8	TE_B#10	3.17834e-17
C254	a_208_74##9	TE_B#9	7.57536e-19
C255	A#1	TE_B#7	3.88782e-17
C256	a_27_368##4	Z#1	6.51044e-17
C257	a_27_368##14	TE_B#8	5.24726e-19
C258	a_27_368##4	a_378_74##3	3.67251e-17
C259	a_348_368##8	TE_B#10	5.62211e-17
C260	a_348_368##5	TE_B#11	2.00512e-19
C261	a_378_74##5	a_378_74##3	2.16634e-19
C262	A#6	TE_B#6	2.49715e-17
C263	VPWR#8	TE_B#11	1.18652e-18
C264	a_208_74##9	TE_B#10	4.45141e-18
C265	a_27_368##14	TE_B#9	8.1132e-18
C266	Z#3	a_27_368##5	1.11979e-19
C267	a_348_368##8	TE_B#11	2.53533e-18
C268	VPWR#9	TE_B#10	1.42895e-18
C269	a_378_74##2	Z#1	2.64109e-17
C270	a_348_368#	a_27_368##2	6.27563e-20
C271	a_378_74##6	a_27_368##4	6.58226e-18
C272	a_208_74##9	TE_B#11	3.93505e-17
C273	a_27_368##14	TE_B#10	2.83499e-17
C274	a_208_74#	TE_B#1	1.13097e-17
C275	A#6	A#2	5.64288e-18
C276	VPWR#9	TE_B#11	4.03799e-17
C277	a_348_368##8	A#3	5.76998e-19
C278	a_378_74##5	VGND#7	1.78387e-17
C279	a_27_368##16	TE_B#5	3.54902e-19
C280	VGND#8	a_208_74##5	1.86044e-18
C281	Z#3	a_27_368##3	2.85765e-18
C282	A#5	A#2	1.08817e-17
C283	a_208_74##9	A#3	5.27412e-18
C284	a_27_368##14	TE_B#11	3.49992e-17
C285	VGND#4	a_378_74##6	1.07441e-17
C286	a_378_74##6	a_208_74##5	1.05149e-17
C287	VPWR#9	A#3	3.85122e-17
C288	a_208_74##11	a_208_74##5	4.83774e-17
C289	a_348_368##5	VPWR#3	3.23468e-19
C290	a_27_368##14	A#3	4.93551e-17
C291	VGND#9	a_208_74##5	1.37399e-18
C292	a_27_368##9	a_27_368##7	4.62311e-17
C293	a_27_368##4	a_348_368##7	2.69919e-18
C294	a_27_368##16	a_208_74##5	3.74528e-19
C295	a_378_74##5	a_378_74##8	1.71099e-18
C296	Z#3	a_27_368##2	9.07355e-18
C297	a_27_368##4	Z#4	5.86863e-17
C298	a_208_74##11	TE_B#6	1.23979e-17
C299	a_27_368##4	a_348_368##3	5.31265e-17
C300	VPWR	TE_B#2	8.73907e-21
C301	VGND#4	a_208_74##11	1.01551e-17
C302	Z#2	a_27_368##5	1.44008e-19
C303	a_27_368##11	a_27_368##9	4.75576e-17
C304	a_27_368##16	TE_B#6	4.74966e-18
C305	a_27_368##4	a_348_368##5	6.3221e-17
C306	a_27_368##2	Z#6	1.64591e-19
C307	a_378_74#	Z#2	5.67433e-17
C308	VGND#8	a_378_74##5	2.71966e-17
C309	VGND#9	A#2	1.88679e-18
C310	a_27_368##16	A#2	7.35027e-18
C311	a_27_368##6	a_27_368##11	4.65535e-17
C312	Z#2	a_27_368##3	3.15063e-18
C313	a_208_74##9	a_27_368##4	1.37681e-17
C314	VGND#9	VGND#4	4.19475e-20
C315	TE_B#1	a_27_368##6	4.73154e-17
C316	a_378_74##6	a_378_74##5	2.63887e-18
C317	VGND	a_208_74##4	5.12535e-19
C318	Z#2	a_27_368##2	9.45451e-18
C319	a_348_368##7	a_27_368##3	3.39289e-19
C320	VGND	TE_B#5	2.01706e-20
C321	VGND	TE_B#4	1.56677e-18
C322	a_27_368##14	a_208_74##5	5.34355e-19
C323	VGND	TE_B#3	9.68188e-20
C324	TE_B#6	a_208_74##9	1.03106e-17
C325	TE_B#8	TE_B#1	4.76011e-17
C326	VGND#3	a_208_74##6	4.788e-19
C327	TE_B#6	a_27_368##14	1.46795e-18
C328	VGND#3	a_208_74##7	7.38279e-19
C329	a_27_368##4	a_208_74#	9.76238e-18
C330	Z#2	a_378_74##7	2.92806e-17
C331	a_208_74##9	A#2	7.6578e-19
C332	A#2	VPWR#9	3.68909e-19
C333	TE_B#9	TE_B#8	4.82991e-17
C334	a_27_368##14	A#2	9.85357e-18
C335	Z#4	a_27_368##5	3.75264e-19
C336	TE_B#10	TE_B#9	4.7654e-17
C337	Z#1	Z#2	2.67051e-18
C338	a_208_74##5	a_208_74##8	2.67625e-17
C339	TE_B#7	a_208_74##5	2.57896e-17
C340	a_27_368##5	VNB	2.66954e-17
C341	a_27_368##3	VNB	2.8086e-17
C342	a_27_368##2	VNB	3.8778e-17
C343	a_208_74##4	VNB	1.65089e-17
C344	a_208_74##3	VNB	1.17465e-17
C345	a_208_74##2	VNB	1.7132e-17
C346	TE_B#5	VNB	5.48527e-17
C347	TE_B#11	TE_B#10	5.48238e-18
C348	TE_B#4	VNB	2.29656e-17
C349	TE_B#3	VNB	1.54671e-17
C350	TE_B#2	VNB	2.09886e-17
C351	TE_B#6	A#1	2.72601e-19
C352	a_27_368##4	a_27_368##11	1.2831e-20
C353	VPWR#3	TE_B#8	2.31822e-18
C354	VPWR	VPWR#4	2.73571e-17
C355	A#3	TE_B#11	4.45834e-17
C356	a_27_368##4	a_27_368##6	1.84997e-20
C357	TE_B#1	a_27_368##5	9.99896e-18
C358	a_27_368##4	TE_B#1	9.52226e-18
C359	a_27_368##4	TE_B#8	2.85989e-19
C360	a_27_368##4	TE_B#9	3.90612e-18
C361	VPWR	a_348_368##2	2.98638e-17
C362	a_27_368##4	TE_B#10	3.11347e-18
C363	VPWR	Z#3	1.62476e-18
C364	a_27_368##4	TE_B#11	2.10784e-19
C365	VPWR	TE_B#14	8.41478e-19
C366	VGND	VGND#4	2.56727e-17
C367	VPWR	A#6	2.42222e-18
C368	VGND	a_378_74##5	3.12363e-18
C369	VPWR	A#5	2.19035e-18
C370	VGND	a_378_74##2	2.57776e-17
C371	a_208_74##2	TE_B#1	3.44265e-18
C372	VGND	Z#3	8.42788e-19
C373	VGND	Z#2	1.01065e-17
C374	VGND#3	a_208_74##5	1.752e-21
C375	VGND	TE_B#14	1.34715e-18
C376	VPWR#4	VNB	3.5366e-17
C377	VGND	A#6	2.03751e-18
C378	a_348_368##5	VPWR#4	6.88066e-19
C379	VPWR	a_348_368#	2.1963e-17
C380	VGND#4	VNB	3.44135e-17
C381	VGND	A#5	3.03132e-18
C382	VGND	a_378_74#	2.17814e-17
C383	VPWR	Z#6	9.34452e-18
C384	a_378_74##5	VNB	1.52867e-18
C385	VPWR	Z#4	8.93751e-18
C386	VGND	Z#1	8.05248e-18
C387	a_378_74##2	VNB	5.42104e-18
C388	VPWR	a_348_368##3	1.72439e-17
C389	VGND	a_378_74##3	1.85789e-17
C390	a_348_368##2	VNB	5.75222e-18
C391	VGND	a_378_74##8	1.14093e-17
C392	VPWR	a_348_368##5	4.3366e-18
C393	VGND	VGND#8	2.19608e-17
C394	VPWR	VPWR#8	1.59396e-17
C395	Z#3	VNB	8.77055e-18
C396	VGND	a_378_74##6	1.28216e-17
C397	Z#2	VNB	8.65515e-18
C398	VPWR	a_348_368##8	1.08834e-17
C399	VGND	a_208_74##11	2.89161e-17
C400	VGND	VGND#9	2.15326e-17
C401	VPWR	a_208_74##9	6.40863e-18
C402	VGND	a_27_368##16	1.65383e-17
C403	TE_B#14	VNB	2.94368e-18
C404	VGND	a_348_368#	3.01695e-18
C405	VPWR	a_27_368##14	3.98687e-17
C406	TE_B#6	A#2	3.26177e-18
C407	A#6	VNB	3.22604e-18
C408	a_208_74##4	TE_B#4	2.7992e-17
C409	A#5	VNB	1.71125e-18
C410	a_378_74#	VNB	5.1795e-17
C411	Z#1	VNB	4.87364e-19
C412	a_378_74##3	VNB	2.81295e-18
C413	VGND#7	VNB	1.60815e-19
C414	a_378_74##8	VNB	4.58357e-18
C415	VGND	a_208_74##9	1.91574e-18
C416	VGND#8	VNB	4.95102e-20
C417	a_378_74##6	VNB	4.6108e-18
C418	a_208_74##11	VNB	1.18704e-17
C419	VGND#9	VNB	2.69088e-18
C420	VGND	a_27_368#	2.29639e-18
C421	a_27_368##16	VNB	5.0523e-17
C422	VGND	a_27_368##8	1.67353e-18
C423	a_348_368#	VNB	6.10795e-17
C424	VGND	a_27_368##10	1.58722e-18
C425	VGND	a_27_368##12	1.50895e-18
C426	Z#4	VNB	2.62159e-19
C427	VPWR	a_27_368##7	2.30002e-18
C428	VGND	a_208_74#	4.43285e-19
C429	a_348_368##3	VNB	4.336e-18
C430	VPWR	a_27_368##9	1.67359e-18
C431	VPWR#7	VNB	4.09278e-19
C432	VGND	a_208_74##6	6.56283e-19
C433	a_348_368##5	VNB	3.4583e-20
C434	VGND	a_208_74##7	7.8638e-19
C435	VPWR	a_27_368##11	1.59645e-18
C436	VPWR#8	VNB	4.09544e-19
C437	VGND	a_208_74##8	9.00496e-19
C438	VPWR	a_27_368##6	1.55514e-18
C439	a_208_74##9	VNB	6.27811e-18
C440	VGND	TE_B#7	2.4271e-18
C441	VPWR	TE_B#1	9.38639e-19
C442	VPWR#9	VNB	2.28013e-18
C443	VGND	A#1	1.33111e-18
C444	a_27_368##14	VNB	8.70933e-17
C445	VPWR	TE_B#8	1.51405e-18
C446	a_27_368#	VNB	3.18472e-17
C447	a_27_368##8	VNB	2.76479e-17
C448	VPWR	TE_B#9	2.43482e-19
C449	a_27_368##10	VNB	2.87067e-17
C450	VPWR	TE_B#10	8.70313e-19
C451	a_27_368##12	VNB	2.87833e-17
C452	a_208_74#	VNB	3.96466e-17
C453	VPWR	TE_B#11	5.25515e-19
C454	a_208_74##6	VNB	2.19114e-17
C455	a_208_74##7	VNB	2.19003e-17
C456	VPWR	A#3	1.76807e-18
C457	a_208_74##8	VNB	2.25664e-17
C458	TE_B#7	VNB	2.67302e-17
C459	A#1	VNB	3.33106e-17
C460	VPWR	VPWR#3	7.63481e-18
C461	a_27_368##7	VNB	3.77197e-17
C462	a_27_368##9	VNB	3.26109e-17
C463	a_348_368##8	VPWR#4	8.51568e-18
C464	VPWR	a_27_368##4	8.51439e-18
C465	a_27_368##11	VNB	3.30312e-17
C466	a_27_368##6	VNB	3.31511e-17
C467	TE_B#1	VNB	4.22229e-17
C468	TE_B#8	VNB	2.98202e-17
C469	VPWR	TE_B#6	1.29152e-18
C470	TE_B#9	VNB	3.13644e-17
C471	VGND	VGND#3	6.28937e-18
C472	TE_B#10	VNB	3.26066e-17
C473	VGND	a_27_368##4	1.21294e-17
C474	TE_B#11	VNB	3.25356e-17
C475	VGND	a_208_74##5	5.992e-18
C476	A#3	VNB	3.5392e-17
C477	a_378_74#	Z#5	1.52331e-19
C478	VGND	TE_B#6	3.25599e-18
C479	VPWR#3	VNB	2.44759e-16
C480	VGND	A#2	7.10856e-19
C481	VGND#3	VNB	2.44651e-16
C482	a_27_368##4	VNB	4.48543e-17
C483	a_208_74##5	VNB	8.01501e-17
C484	TE_B#6	VNB	3.48403e-19
C485	A#2	VNB	4.08312e-17
C486	a_208_74##4	TE_B#3	6.44085e-18
C487	VPWR	VNB	7.23422e-17
C488	VGND	VNB	7.42361e-17
C489	a_348_368##2	Z#6	1.87552e-17
C490	VGND#2	a_378_74##3	4.31738e-17
C491	VGND#2	a_27_368##8	4.55198e-18
C492	VPWR#8	a_348_368##6	1.61126e-17
C493	VGND#5	TE_B#7	3.98534e-18
C494	a_348_368##2	VPWR#2	7.89511e-17
C495	VGND#2	a_27_368##3	4.22701e-20
C496	a_348_368##6	TE_B#8	3.62324e-18
C497	VPWR#2	TE_B#9	6.31563e-19
C498	VGND#2	a_27_368##12	4.96146e-18
C499	VPWR#2	TE_B#1	4.88257e-18
C500	a_348_368##6	VPWR#3	1.05168e-17
C501	VPWR#2	a_27_368##11	4.65185e-18
C502	VGND#2	a_27_368##4	5.80915e-20
C503	VPWR#2	a_27_368##7	4.50215e-18
C504	VPWR#4	VPWR#2	1.10884e-18
C505	VGND#3	VGND#5	6.84307e-17
C506	VGND#2	VNB	9.34563e-17
C507	VPWR#3	VPWR#5	6.56094e-17
C508	VGND#5	A#5	8.80355e-19
C509	VPWR#5	VPWR#4	3.33344e-19
C510	VGND#5	a_208_74##5	3.15705e-18
C511	VGND#2	a_208_74##6	5.29651e-18
C512	VPWR#5	A#3	4.62666e-18
C513	VPWR#8	VPWR#2	6.61587e-20
C514	VGND#5	VNB	5.98717e-17
C515	VGND#5	VGND#4	2.49355e-19
C516	a_348_368##6	a_348_368##5	5.51192e-18
C517	VGND#5	A#2	7.3222e-20
C518	VPWR#2	a_27_368##3	2.26025e-20
C519	VPWR#5	TE_B#5	1.58642e-19
C520	VPWR#5	TE_B#10	3.12879e-19
C521	VGND#2	a_27_368#	4.53049e-18
C522	VGND#4	VGND#2	1.33675e-18
C523	VPWR#2	VNB	9.33847e-17
C524	VPWR	VPWR#2	7.67065e-17
C525	VPWR#5	A#2	4.87589e-20
C526	VGND#5	TE_B#5	2.739e-19
C527	VGND#2	a_27_368##5	1.89766e-20
C528	VPWR#5	VNB	5.97843e-17
C529	VGND#2	a_27_368##10	4.67617e-18
C530	VPWR	a_348_368##6	1.12735e-17
C531	VPWR#2	a_27_368##4	3.0794e-20
C532	VPWR#3	VPWR#2	1.13618e-16
C533	VGND#3	VGND#2	1.12582e-16
C534	VGND#5	A#1	3.82436e-18
C535	VGND	VGND#2	7.45836e-17
C536	VPWR	VPWR#5	6.10643e-17
C537	VGND#5	a_208_74##11	3.05001e-17
C538	VGND#2	a_378_74#	4.97218e-17
C539	VPWR#2	TE_B#8	3.033e-18
C540	VGND#8	VGND#2	1.34707e-18
C541	VPWR#2	a_27_368##6	4.89811e-18
C542	a_27_368##14	VPWR#5	2.70867e-17
C543	VGND#2	a_27_368##2	2.41066e-20
C544	VPWR#2	a_27_368##9	4.52345e-18
C545	a_348_368##6	VPWR#7	1.58468e-17
C546	VGND#2	a_208_74#	5.26612e-18
C547	VGND#5	a_27_368##16	2.10313e-17
C548	VGND#2	a_378_74##5	1.80866e-19
C549	VPWR#2	a_208_74#	3.60523e-20
C550	VGND	VGND#5	4.18641e-17
C551	a_348_368##6	TE_B#9	3.62324e-18
C552	VPWR#5	VPWR#8	1.84542e-20
C553	VGND#5	TE_B#6	1.22661e-18
C554	a_348_368##3	VPWR#2	3.14878e-17
C555	VPWR#5	TE_B#11	7.0584e-18
C556	VGND#2	a_208_74##7	7.51287e-19
C557	VPWR#2	a_27_368##2	1.10737e-20
C558	a_348_368#	VPWR#2	4.93961e-17
C559	VPWR#2	a_27_368##5	2.88688e-21
C560	VGND#2	a_378_74##2	6.90576e-17
C561	a_348_368##6	VNB	4.64787e-18
*
*
.ENDS sky130_fd_sc_hs__ebufn_4
*
