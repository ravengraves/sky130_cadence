* Extracted by Quantus, converted by sky130cad/quantus.py
*
*
*
*                       LINUX           Wed Nov 18 08:24:20 2026
*
*
*
*  PROGRAM  advgen
*
*  Name           : advgen - Quantus - (64-bit)
*  Version        : 25.1.0-p047
*  Build Date     : Thu Dec 11 23:20:30 PST 2025
*
*  HSPICE LIBRARY
*
*  OPERATING_TEMPERATURE 150
*  QRC_TECH_DIR <path>/tech
*
*
*

*
.SUBCKT sky130_fd_sc_hs__clkinv_2 VPB VNB VGND VPWR Y A
*
*
*  caps2d version: 10
*
*
*       TRANSISTOR CARDS
*
*
XM0 VGND#3 A#6 Y#4 VNB sky130_fd_pr__nfet_01v8_lvt l=0.15 w=0.42 ad=0.1197 as=0.3276 pd=1.41 ps=2.4
XM2 Y#4 A#1 VGND#1 VNB sky130_fd_pr__nfet_01v8_lvt l=0.15 w=0.42 ad=0.3276 as=0.1197 pd=2.4 ps=1.41
XM3 Y#3 A#9 VPWR#5 VPB sky130_fd_pr__pfet_01v8 l=0.15 w=1.12 ad=0.3304 as=0.336 pd=2.83 ps=2.84
XM4 Y#1 A#8 VPWR#5 VPB sky130_fd_pr__pfet_01v8 l=0.15 w=1.12 ad=0.336 as=0.336 pd=2.84 ps=2.84
XM1 VPWR#1 A#7 Y#1 VPB sky130_fd_pr__pfet_01v8 l=0.15 w=1.12 ad=0.3304 as=0.336 pd=2.83 ps=2.84
*
*
*       RESISTOR AND CAP/DIODE CARDS
*
Rg1	A#1	A#2	472.157806
Rg2	A#2	A#3	67.132561
Rg3	A#3	A#4	36.535618
Rg4	A#4	A#5	30.613651
Rg5	A#5	A#6	472.157806
Rg6	A#2	A#7	449.655212
Rg7	A#3	A#8	419.554810
Rg8	A#5	A#9	449.655212
Rf1	A	A#10	13.599322
Rf2	A#10	A	1.069610
Rf3	Y#1	Y#2	18.601391
Rf4	Y#2	Y#3	81.107391
Rf5	Y#2	Y	71.935623
Rf6	Y	Y#4	59.217712
Rf7	VGND#1	VGND#2	81.706421
Rf8	VGND#2	VGND#3	83.263077
Rf9	VPWR#1	VPWR#2	89.649673
Rf10	VPWR#2	VPWR#3	16.534405
Rf12	VPWR#3	VPWR#5	53.143215
Rf13	A#4	A#10	80.116402
Re1	VPWR#2	VPWR	2.455682
Re2	VGND	VGND#2	2.455774
*
*       CAPACITOR CARDS
*
*
C1	VGND	VNB	4.58276e-17
C2	VPWR	VNB	5.38675e-17
C3	Y	VNB	3.84714e-17
C4	A	VNB	4.10021e-17
C5	VGND	Y	4.48554e-18
C6	VGND#2	VNB	1.37068e-16
C7	VGND	A	9.51496e-18
C8	VPWR#2	VNB	1.2434e-16
C9	A#9	VNB	4.38538e-17
C10	VPWR	A	6.99421e-18
C11	A#8	VNB	3.41548e-17
C12	VGND	VGND#2	2.4565e-17
C13	A#7	VNB	4.25958e-17
C14	A	Y	2.59142e-17
C15	A#6	VNB	4.5626e-17
C16	A#1	VNB	3.26441e-17
C17	Y#3	VNB	4.94057e-17
C18	VPWR#5	VNB	2.82484e-18
C19	Y#1	VNB	4.01791e-18
C20	VPWR	VPWR#2	1.38556e-17
C21	VPWR#1	VNB	5.75518e-17
C22	VGND#3	VNB	5.67049e-17
C23	VGND#2	Y	2.13594e-19
C24	Y#4	VNB	1.4303e-17
C25	VPWR	A#9	1.22293e-18
C26	VGND#1	VNB	5.40701e-17
C27	VGND	A#6	4.24527e-18
C28	VGND	A#1	4.21751e-18
C29	VPWR	A#8	2.43008e-19
C30	Y#2	VNB	2.10238e-17
C31	VGND#2	A	5.84482e-19
C32	VPWR	A#7	7.59575e-19
C33	VGND	VGND#3	3.86665e-17
C34	VGND	Y#4	2.33383e-17
C35	A	A#9	2.9741e-18
C36	VGND	VGND#1	3.8659e-17
C37	VPWR	Y#3	1.76333e-17
C38	A	A#8	2.04601e-18
C39	VPWR	Y#1	1.58676e-17
C40	VPWR	VPWR#1	3.00714e-17
C41	A	A#7	1.74554e-18
C42	Y	A#1	5.05252e-18
C43	VPWR	Y#2	5.65973e-18
C44	A	Y#3	4.47687e-17
C45	VGND#1	Y	3.27846e-17
C46	Y	Y#2	1.65441e-18
C47	VPWR#2	A#8	5.68243e-18
C48	VGND#3	A	1.15766e-17
C49	Y#4	A	7.23515e-17
C50	VPWR#2	A#7	3.09602e-18
C51	VGND#2	A#6	4.51872e-18
C52	VGND#2	A#1	1.81611e-18
C53	A#9	A#8	4.73903e-17
C54	A	Y#2	6.18667e-17
C55	A#8	A#7	4.56992e-17
C56	VGND#2	VGND#3	2.30672e-17
C57	Y#1	VPWR#2	1.66935e-17
C58	VGND#2	Y#4	2.16183e-17
C59	VPWR#2	VPWR#1	2.16726e-17
C60	Y#3	A#9	5.81998e-17
C61	VGND#2	VGND#1	2.30269e-17
C62	A#9	VPWR#5	3.08474e-17
C63	Y#3	A#8	2.12167e-18
C64	Y#1	A#9	2.01754e-18
C65	A#8	VPWR#5	2.52415e-17
C66	A#2	VNB	4.53779e-17
C67	VPWR#1	A#9	6.3557e-19
C68	A#5	VNB	8.63051e-17
C69	Y#1	A#8	4.60609e-17
C70	Y#2	VPWR#2	5.83134e-19
C71	VPWR#5	A#7	7.28027e-19
C72	A#6	A#1	5.75114e-18
C73	VPWR#1	A#8	1.23306e-18
C74	Y#1	A#7	4.77823e-17
C75	A#7	VPWR#1	2.54635e-17
C76	Y#2	A#9	5.51748e-19
C77	Y#2	A#8	1.81613e-17
C78	Y#3	VPWR#5	5.2514e-17
C79	VGND#3	A#6	3.25293e-17
C80	Y#3	Y#1	2.33888e-18
C81	Y#2	A#7	2.8532e-17
C82	A#6	Y#4	2.88972e-17
C83	VGND#3	A#1	2.76401e-18
C84	VPWR#5	Y#1	5.21059e-17
C85	VGND	A#5	1.42342e-19
C86	VGND#1	A#6	2.76401e-18
C87	Y#4	A#1	2.28987e-17
C88	VGND#3	Y#3	1.11278e-19
C89	VPWR#5	VPWR#1	1.94092e-18
C90	VGND#1	A#1	2.77514e-17
C91	Y#1	VPWR#1	5.29637e-17
C92	Y#3	Y#2	6.51334e-19
C93	Y#2	VPWR#5	1.84296e-17
C94	VGND#1	VPWR#1	9.19337e-20
C95	VGND#3	Y#4	3.2915e-17
C96	Y#2	Y#1	1.1803e-18
C97	VGND#3	VGND#1	4.67173e-18
C98	Y#2	VPWR#1	3.08012e-17
C99	Y#4	VGND#1	3.29367e-17
C100	Y#4	Y#2	1.90419e-18
C101	A#5	VPWR#5	1.24432e-18
C102	Y	A#2	2.20192e-17
C103	Y	A#5	3.83262e-19
C104	A#2	Y#1	2.70455e-19
C105	A#5	Y#1	2.74109e-19
C106	A	A#2	9.5965e-18
C107	A	A#5	3.90545e-17
C108	Y#4	A#2	6.16941e-18
C109	Y#4	A#5	1.88515e-17
C110	VGND#2	A#2	5.62783e-20
C111	VGND#2	A#5	3.28917e-19
C112	VPWR#2	A#2	2.01982e-20
C113	VPWR#2	A#5	2.04712e-20
C114	A#5	A#2	2.90669e-18
C115	Y#2	A#2	1.86091e-18
C116	Y#2	A#5	3.00672e-18
C117	VPWR#3	A#9	7.70872e-18
C118	VPWR#3	VPWR#1	6.99578e-19
C119	VPWR	VPWR#3	3.5495e-17
C120	VPWR#3	A#8	1.8148e-18
C121	Y#3	VPWR#3	2.11316e-17
C122	VPWR#3	A#7	5.62579e-19
C123	VPWR#2	VPWR#3	3.76218e-17
C124	VPWR#3	VNB	3.55423e-17
*
*
.ENDS sky130_fd_sc_hs__clkinv_2
*
