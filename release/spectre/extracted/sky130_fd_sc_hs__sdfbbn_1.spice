* Extracted by Quantus, converted by sky130cad/quantus.py
*
*
*
*                       LINUX           Wed Nov 18 09:08:42 2026
*
*
*
*  PROGRAM  advgen
*
*  Name           : advgen - Quantus - (64-bit)
*  Version        : 25.1.0-p047
*  Build Date     : Thu Dec 11 23:20:30 PST 2025
*
*  HSPICE LIBRARY
*
*  OPERATING_TEMPERATURE 150
*  QRC_TECH_DIR <path>/tech
*
*
*

*
.SUBCKT sky130_fd_sc_hs__sdfbbn_1 VNB VPB VGND SET_B VPWR Q_N Q RESET_B SCD SCE CLK_N D
*
*
*  caps2d version: 10
*
*
*       TRANSISTOR CARDS
*
*
XM21 VGND#12 SCD#3 a_119_119# VNB sky130_fd_pr__nfet_01v8_lvt l=0.15 w=0.42 ad=0.1197 as=0.1008 pd=1.41 ps=1.32
XM47 a_119_119# SCE#3 a_197_119##5 VNB sky130_fd_pr__nfet_01v8_lvt l=0.15 w=0.42 ad=0.1008 as=0.1638 pd=1.32 ps=1.62
XM43 a_197_119##5 D#4 a_305_119# VNB sky130_fd_pr__nfet_01v8_lvt l=0.15 w=0.42 ad=0.1638 as=0.1008 pd=1.62 ps=1.32
XM19 a_305_119# a_353_93##3 VGND#19 VNB sky130_fd_pr__nfet_01v8_lvt l=0.15 w=0.42 ad=0.1008 as=0.2898 pd=1.32 ps=2.22
XM22 VGND#19 SCE#2 a_353_93##7 VNB sky130_fd_pr__nfet_01v8_lvt l=0.15 w=0.42 ad=0.2898 as=0.1197 pd=2.22 ps=1.41
XM20 a_662_82##11 CLK_N#3 VGND#18 VNB sky130_fd_pr__nfet_01v8_lvt l=0.15 w=0.74 ad=0.2109 as=0.3923 pd=2.05 ps=2.82
XM28 VGND#18 a_662_82##4 a_867_82##11 VNB sky130_fd_pr__nfet_01v8_lvt l=0.15 w=0.74 ad=0.3923 as=0.3219 pd=2.82 ps=2.35
XM26 VGND#17 a_977_243# a_1151_119# VNB sky130_fd_pr__nfet_01v8_lvt l=0.15 w=0.42 ad=0.1197 as=0.0882 pd=1.41 ps=1.26
XM5 a_1151_119# a_662_82##2 a_1159_497##5 VNB sky130_fd_pr__nfet_01v8_lvt l=0.15 w=0.42 ad=0.0882 as=0.1176 pd=1.26 ps=1.4
XM1 a_1159_497##5 a_867_82##3 a_197_119##2 VNB sky130_fd_pr__nfet_01v8_lvt l=0.15 w=0.42 ad=0.1176 as=0.1491 pd=1.4 ps=1.55
XM10 a_1434_78##2 a_1159_497# a_977_243##13 VNB sky130_fd_pr__nfet_01v8_lvt l=0.15 w=0.55 ad=0.2602 as=0.209 pd=2.24 ps=1.86
XM2 a_977_243##13 a_1579_258# a_1434_78# VNB sky130_fd_pr__nfet_01v8_lvt l=0.15 w=0.55 ad=0.209 as=0.25025 pd=1.86 ps=2.01
XM42 a_1434_78# SET_B#1 VGND#16 VNB sky130_fd_pr__nfet_01v8_lvt l=0.15 w=0.55 ad=0.25025 as=0.2255 pd=2.01 ps=1.92
XM46 VGND#16 a_977_243##6 a_1876_119# VNB sky130_fd_pr__nfet_01v8_lvt l=0.15 w=0.55 ad=0.2255 as=0.132 pd=1.92 ps=1.58
XM25 a_1876_119# a_662_82##5 a_1954_119##5 VNB sky130_fd_pr__nfet_01v8_lvt l=0.15 w=0.55 ad=0.132 as=0.4807 pd=1.58 ps=2.9
XM30 a_1954_119##5 a_867_82##8 a_2164_119# VNB sky130_fd_pr__nfet_01v8_lvt l=0.15 w=0.42 ad=0.4807 as=0.1638 pd=2.9 ps=1.62
XM23 a_2164_119# a_2133_410# VGND#15 VNB sky130_fd_pr__nfet_01v8_lvt l=0.15 w=0.42 ad=0.1638 as=0.354125 pd=1.62 ps=2.76
XM40 VGND#15 SET_B#4 a_2392_74##2 VNB sky130_fd_pr__nfet_01v8_lvt l=0.15 w=0.74 ad=0.354125 as=0.2072 pd=2.76 ps=2.04
XM35 a_2392_74##2 a_1579_258##6 a_2133_410##10 VNB sky130_fd_pr__nfet_01v8_lvt l=0.15 w=0.74 ad=0.2072 as=0.2812 pd=2.04 ps=2.24
XM3 a_2133_410##10 a_1954_119##3 a_2392_74# VNB sky130_fd_pr__nfet_01v8_lvt l=0.15 w=0.74 ad=0.2812 as=0.2875 pd=2.24 ps=2.33
XM4 a_1579_258##11 RESET_B#1 VGND#14 VNB sky130_fd_pr__nfet_01v8_lvt l=0.15 w=0.42 ad=0.1197 as=0.3656 pd=1.41 ps=2.68
XM14 VGND#14 a_2133_410##9 Q_N#1 VNB sky130_fd_pr__nfet_01v8_lvt l=0.15 w=0.74 ad=0.3656 as=0.2109 pd=2.68 ps=2.05
XM31 a_3078_384##7 a_2133_410##4 VGND#13 VNB sky130_fd_pr__nfet_01v8_lvt l=0.15 w=0.55 ad=0.15675 as=0.25215 pd=1.67 ps=2.2
XM8 VGND#13 a_3078_384##3 Q#3 VNB sky130_fd_pr__nfet_01v8_lvt l=0.15 w=0.74 ad=0.25215 as=0.2109 pd=2.2 ps=2.05
XM38 a_27_464##2 SCD#1 VPWR#25 VPB sky130_fd_pr__pfet_01v8 l=0.15 w=0.64 ad=0.1888 as=0.2112 pd=1.87 ps=1.94
XM41 VPWR#25 SCE#5 a_212_464# VPB sky130_fd_pr__pfet_01v8 l=0.15 w=0.64 ad=0.2112 as=0.1728 pd=1.94 ps=1.82
XM45 a_212_464# D#3 a_197_119##6 VPB sky130_fd_pr__pfet_01v8 l=0.15 w=0.64 ad=0.1728 as=0.192 pd=1.82 ps=1.88
XM18 a_197_119##6 a_353_93##4 a_27_464# VPB sky130_fd_pr__pfet_01v8 l=0.15 w=0.64 ad=0.192 as=0.1856 pd=1.88 ps=1.86
XM33 VPWR#24 SCE#1 a_353_93##5 VPB sky130_fd_pr__pfet_01v8 l=0.15 w=0.64 ad=0.1888 as=0.1888 pd=1.87 ps=1.87
XM0 a_662_82##12 CLK_N#1 VPWR#23 VPB sky130_fd_pr__pfet_01v8 l=0.15 w=1.12 ad=0.3304 as=0.336 pd=2.83 ps=2.84
XM24 VPWR#23 a_662_82##8 a_867_82##9 VPB sky130_fd_pr__pfet_01v8 l=0.15 w=1.12 ad=0.336 as=0.3304 pd=2.84 ps=2.83
XM6 VPWR#22 a_977_243##3 a_1081_497# VPB sky130_fd_pr__pfet_01v8 l=0.15 w=0.42 ad=0.1239 as=0.1008 pd=1.43 ps=1.32
XM39 a_1081_497# a_867_82# a_1159_497##7 VPB sky130_fd_pr__pfet_01v8 l=0.15 w=0.42 ad=0.1008 as=0.2266 pd=1.32 ps=2.05
XM12 a_1159_497##7 a_662_82# a_197_119# VPB sky130_fd_pr__pfet_01v8 l=0.15 w=0.64 ad=0.2266 as=0.2208 pd=2.05 ps=1.97
XM32 a_977_243##10 a_1159_497##4 a_1528_424# VPB sky130_fd_pr__pfet_01v8 l=0.15 w=0.84 ad=0.3906 as=0.2268 pd=2.61 ps=2.22
XM15 a_1528_424# a_1579_258##3 VPWR#21 VPB sky130_fd_pr__pfet_01v8 l=0.15 w=0.84 ad=0.2268 as=0.252 pd=2.22 ps=2.28
XM44 VPWR#21 SET_B#3 a_977_243##12 VPB sky130_fd_pr__pfet_01v8 l=0.15 w=0.84 ad=0.252 as=0.2436 pd=2.28 ps=2.26
XM7 VPWR#20 a_977_243##4 a_1903_424# VPB sky130_fd_pr__pfet_01v8 l=0.15 w=0.84 ad=0.2478 as=0.2016 pd=2.27 ps=2.16
XM16 a_1903_424# a_867_82##5 a_1954_119##7 VPB sky130_fd_pr__pfet_01v8 l=0.15 w=0.84 ad=0.2016 as=0.2856 pd=2.16 ps=2.45
XM9 a_1954_119##7 a_662_82##6 a_2088_508# VPB sky130_fd_pr__pfet_01v8 l=0.15 w=0.42 ad=0.2856 as=0.1008 pd=2.45 ps=1.32
XM17 a_2088_508# a_2133_410##3 VPWR#19 VPB sky130_fd_pr__pfet_01v8 l=0.15 w=0.42 ad=0.1008 as=0.22775 pd=1.32 ps=2.07
XM36 a_2133_410##14 SET_B#6 VPWR#18 VPB sky130_fd_pr__pfet_01v8 l=0.15 w=1 ad=0.295 as=0.53815 pd=2.59 ps=3.41
XM27 VPWR#18 a_1579_258##4 a_2509_392# VPB sky130_fd_pr__pfet_01v8 l=0.15 w=1 ad=0.53815 as=0.27 pd=3.41 ps=2.54
XM11 a_2509_392# a_1954_119##4 a_2133_410##12 VPB sky130_fd_pr__pfet_01v8 l=0.15 w=1 ad=0.27 as=0.295 pd=2.54 ps=2.59
XM37 a_1579_258##7 RESET_B#3 VPWR#17 VPB sky130_fd_pr__pfet_01v8 l=0.15 w=0.64 ad=0.3625 as=0.5496 pd=3.71 ps=3.56
XM13 VPWR#17 a_2133_410##7 Q_N#2 VPB sky130_fd_pr__pfet_01v8 l=0.15 w=1.12 ad=0.5496 as=0.3304 pd=3.56 ps=2.83
XM34 a_3078_384##6 a_2133_410##8 VPWR#16 VPB sky130_fd_pr__pfet_01v8 l=0.15 w=0.84 ad=0.2478 as=0.406 pd=2.27 ps=3.01
XM29 VPWR#16 a_3078_384# Q#1 VPB sky130_fd_pr__pfet_01v8 l=0.15 w=1.12 ad=0.406 as=0.3304 pd=3.01 ps=2.83
*
*
*       RESISTOR AND CAP/DIODE CARDS
*
Rg1	SCD#1	SCD#2	445.926178
Rg2	SCD#2	SCD#3	286.193420
Rg3	D#1	D#2	30.613651
Rg4	D#2	D#3	525.458557
Rg5	D#2	D#4	450.460754
Rg6	a_353_93#	a_353_93##2	252.861252
Rg7	a_353_93##2	a_353_93##3	499.880585
Rg8	a_353_93##2	a_353_93##4	564.018677
Rg9	SCE#1	SCE#2	1265.154663
Rg10	SCE#2	SCE#3	1625.407715
Rg11	SCE#3	SCE#4	295.497040
Rg12	SCE#4	SCE#5	455.229767
Rg13	CLK_N#1	CLK_N#2	460.646515
Rg14	CLK_N#2	CLK_N#3	359.467133
Rg15	a_977_243#	a_977_243##2	934.814270
Rg16	a_977_243##2	a_977_243##3	286.440094
Rg17	a_867_82#	a_867_82##2	594.561584
Rg18	a_867_82##3	a_867_82##4	414.102173
Rg19	a_1159_497#	a_1159_497##2	241.831177
Rg20	a_1159_497##2	a_1159_497##3	289.878845
Rg21	a_1159_497##2	a_1159_497##4	587.218689
Rg22	a_1579_258#	a_1579_258##2	266.141907
Rg23	a_1579_258##2	a_1579_258##3	540.671143
Rg24	SET_B#1	SET_B#2	463.106628
Rg25	SET_B#2	SET_B#3	430.994873
Rg26	a_977_243##4	a_977_243##5	354.298584
Rg27	a_977_243##5	a_977_243##6	468.619049
Rg28	a_867_82##5	a_867_82##6	363.181610
Rg29	a_662_82#	a_662_82##2	1049.081543
Rg30	a_662_82##2	a_662_82##3	341.909027
Rg31	a_662_82##3	a_662_82##4	1325.393188
Rg32	a_662_82##3	a_662_82##5	2421.469482
Rg33	a_662_82##5	a_662_82##6	1321.260742
Rg34	a_662_82##4	a_662_82##7	353.846649
Rg35	a_662_82##7	a_662_82##8	439.080750
Rg36	a_867_82##7	a_867_82##8	284.983215
Rg37	a_2133_410#	a_2133_410##2	897.061584
Rg38	a_2133_410##2	a_2133_410##3	228.275131
Rg39	SET_B#4	SET_B#5	451.403168
Rg40	SET_B#5	SET_B#6	400.207520
Rg41	a_1579_258##4	a_1579_258##5	514.736511
Rg42	a_1579_258##5	a_1579_258##6	314.711456
Rg43	a_1954_119#	a_1954_119##2	24.707481
Rg44	a_1954_119##2	a_1954_119##3	463.819916
Rg45	a_1954_119##2	a_1954_119##4	414.828278
Rg46	RESET_B#1	RESET_B#2	240.880203
Rg47	RESET_B#2	RESET_B#3	750.885498
Rg48	a_2133_410##4	a_2133_410##5	414.889038
Rg49	a_2133_410##5	a_2133_410##6	216.303528
Rg50	a_2133_410##6	a_2133_410##7	467.381500
Rg51	a_2133_410##5	a_2133_410##8	444.345856
Rg52	a_2133_410##6	a_2133_410##9	373.964142
Rg53	a_3078_384#	a_3078_384##2	500.238068
Rg54	a_3078_384##2	a_3078_384##3	320.356293
Rf1	SCD#4	SCD	1.931624
Rf2	SCD#2	SCD#6	82.048027
Rf3	SCD#4	SCD#6	2.883209
Rf4	SCE#4	SCE#7	81.736473
Rf5	SCE#8	SCE	1.620071
Rf6	SCE#7	SCE#8	4.573365
Rf7	D#1	D	161.413818
Rf8	a_27_464#	a_27_464##2	226.121307
Rf9	a_353_93##5	a_353_93#	63.059940
Rf10	a_353_93#	a_353_93##7	45.154495
Rf11	CLK_N#4	CLK_N#2	160.767609
Rf12	CLK_N	CLK_N#6	0.534805
Rf13	CLK_N#4	CLK_N#6	5.905091
Rf14	a_662_82##7	a_662_82##10	167.929108
Rf15	a_662_82##10	a_662_82##11	73.928200
Rf16	a_662_82##10	a_662_82##12	88.453224
Rf17	a_867_82##9	a_867_82##10	42.781178
Rf18	a_867_82##10	a_867_82##11	51.968452
Rf19	a_867_82##10	a_867_82##12	53.730549
Rf20	a_867_82##12	a_867_82##2	2.570513
Rf21	a_867_82##2	a_867_82##4	205.858231
Rf22	a_1159_497##5	a_1159_497##3	95.756744
Rf23	a_1159_497##3	a_1159_497##7	119.194618
Rf24	a_197_119#	a_197_119##3	236.407959
Rf25	a_197_119##3	a_197_119##4	517.791077
Rf26	a_197_119##4	a_197_119##5	87.364487
Rf27	a_197_119##4	a_197_119##6	123.259407
Rf28	a_197_119##2	a_197_119##3	15.000000
Rf29	a_1434_78#	a_1434_78##2	125.513420
Rf30	SET_B#2	SET_B#8	184.416946
Rf31	a_977_243##5	a_977_243##8	221.153915
Rf32	a_977_243##8	a_977_243##9	45.694588
Rf33	a_977_243##9	a_977_243##11	58.669254
Rf34	a_977_243##8	a_977_243##12	17.804613
Rf35	a_977_243##9	a_977_243##13	122.902626
Rf36	a_977_243##11	a_977_243##2	352.547607
Rf37	a_977_243##10	a_977_243##11	15.000000
Rf38	a_867_82##7	a_867_82##16	205.614288
Rf39	a_867_82##16	a_867_82##6	164.383774
Rf40	SET_B#5	SET_B	185.757492
Rf41	a_2392_74#	a_2392_74##2	101.801819
Rf42	a_1954_119##5	a_1954_119##6	129.074539
Rf43	a_1954_119##6	a_1954_119##7	115.868134
Rf44	a_1954_119##6	a_1954_119#	272.475464
Rf45	a_1579_258##7	a_1579_258##8	70.526123
Rf46	a_1579_258##8	a_1579_258##9	93.000908
Rf47	a_1579_258##9	a_1579_258##2	549.031494
Rf48	a_1579_258##8	a_1579_258##11	36.912125
Rf49	a_1579_258##9	a_1579_258##5	163.599716
Rf50	RESET_B	RESET_B#4	1.268211
Rf51	RESET_B#5	RESET_B#2	161.501007
Rf52	RESET_B#4	RESET_B#5	3.818136
Rf53	a_2133_410##10	a_2133_410##11	235.355316
Rf54	a_2133_410##11	a_2133_410##13	162.774841
Rf55	a_2133_410##13	a_2133_410##15	102.871078
Rf56	a_2133_410##15	a_2133_410##2	225.538422
Rf57	a_2133_410##12	a_2133_410##13	7.500000
Rf58	a_2133_410##14	a_2133_410##15	15.000000
Rf59	Q_N#1	Q_N	83.118790
Rf60	Q_N	Q_N#3	12.403138
Rf61	Q_N#3	Q_N	0.169906
Rf62	Q_N#2	Q_N#3	5.000000
Rf63	a_3078_384##2	a_3078_384##5	180.065399
Rf64	a_3078_384##5	a_3078_384##6	55.798756
Rf65	a_3078_384##5	a_3078_384##7	49.654335
Rf66	Q	Q#2	0.181173
Rf67	Q#2	Q	13.225628
Rf68	Q	Q#3	90.898705
Rf69	Q#1	Q#2	5.000000
Rf71	VPWR#2	VPWR#3	66.508766
Rf72	VPWR#3	VPWR#4	56.655075
Rf73	VPWR#4	VPWR#5	159.631744
Rf74	VPWR#5	VPWR#6	79.941223
Rf75	VPWR#6	VPWR#7	71.930206
Rf76	VPWR#7	VPWR#8	63.164146
Rf77	VPWR#8	VPWR#9	73.489258
Rf78	VPWR#9	VPWR#10	224.030624
Rf79	VPWR#10	VPWR#11	79.690674
Rf80	VPWR#11	VPWR#12	50.802910
Rf81	VPWR#12	VPWR#13	55.916443
Rf82	VPWR#13	VPWR#14	136.247452
Rf84	VPWR#2	VPWR#16	46.213299
Rf85	VPWR#4	VPWR#17	18.330051
Rf86	VPWR#5	VPWR#18	22.500479
Rf87	VPWR#6	VPWR#19	22.500479
Rf88	VPWR#8	VPWR#20	39.034733
Rf89	VPWR#9	VPWR#21	47.494125
Rf90	VPWR#10	VPWR#22	43.166809
Rf91	VPWR#11	VPWR#23	38.736572
Rf92	VPWR#13	VPWR#24	38.480759
Rf93	VPWR#14	VPWR#25	31.337896
Rf95	VGND#2	VGND#3	66.508766
Rf96	VGND#3	VGND#4	39.794056
Rf97	VGND#4	VGND#5	218.372299
Rf98	VGND#5	VGND#6	109.910774
Rf99	VGND#6	VGND#7	81.792023
Rf100	VGND#7	VGND#8	255.262405
Rf101	VGND#8	VGND#9	109.526672
Rf102	VGND#9	VGND#10	44.171017
Rf103	VGND#10	VGND#11	95.306366
Rf104	VGND#11	VGND#12	169.317764
Rf105	VGND#2	VGND#13	38.992386
Rf106	VGND#4	VGND#14	32.451584
Rf107	VGND#5	VGND#15	24.203579
Rf108	VGND#7	VGND#16	44.939819
Rf109	VGND#8	VGND#17	43.365131
Rf110	VGND#9	VGND#18	24.468842
Rf111	VGND#11	VGND#19	41.987278
Rf131	a_2133_410##6	a_2133_410##11	160.232803
Re1	a_867_82##16	a_867_82##12	26.769386
Re3	SET_B	SET_B#8	15.344948
Re4	VPWR#3	VPWR#27	3.332833
Re5	VPWR#27	VPWR	0.645336
Re6	VPWR	VPWR#12	2.634420
Re7	VGND#3	VGND#21	3.332833
Re8	VGND#21	VGND	0.645336
Re9	VGND	VGND#10	2.634420
Re15	VPWR#7	VPWR#27	0.698413
Re18	VGND#6	VGND#21	0.698413
*
*       CAPACITOR CARDS
*
*
C1	a_1579_258##4	a_1954_119##4	5.04354e-17
C2	a_662_82##11	a_662_82##12	7.64925e-19
C3	a_1434_78##2	a_1579_258##2	4.68421e-19
C4	VGND#3	a_1579_258##11	5.89958e-18
C5	a_197_119##4	D#2	7.83652e-18
C6	VGND#4	a_2133_410##9	3.82436e-18
C7	a_353_93##7	a_662_82##4	5.33306e-19
C8	a_2392_74##2	RESET_B#1	6.91614e-20
C9	a_1579_258##11	a_1579_258##6	2.34423e-19
C10	VGND#3	a_2133_410##6	2.69433e-17
C11	a_1954_119##7	a_662_82##6	4.79239e-17
C12	VPWR#3	RESET_B#2	3.66131e-18
C13	VGND#11	D#4	4.03837e-18
C14	CLK_N#2	a_353_93##2	1.18725e-19
C15	a_1579_258##9	a_1954_119#	5.30545e-17
C16	VGND#7	SET_B#2	4.23826e-20
C17	VPWR#8	a_662_82##6	2.60722e-19
C18	a_353_93#	CLK_N#6	1.26039e-17
C19	VGND#3	a_2133_410##9	4.09911e-19
C20	a_197_119##2	a_1579_258##2	2.10656e-18
C21	VPWR#20	a_2133_410##3	1.21233e-19
C22	a_197_119##4	a_867_82##11	3.62175e-17
C23	VGND#7	a_1434_78##2	5.33628e-17
C24	a_662_82##11	CLK_N#3	3.78291e-17
C25	a_2133_410##10	a_1954_119##3	4.62231e-17
C26	a_1159_497##4	a_1579_258##2	5.75421e-18
C27	VPWR#12	a_867_82##10	2.72e-18
C28	a_1579_258##9	SET_B#4	1.94573e-17
C29	a_662_82##5	a_977_243##6	6.9698e-17
C30	a_197_119##2	a_867_82##10	1.4897e-17
C31	a_197_119##4	SCE#2	4.92096e-17
C32	VGND#3	RESET_B#2	5.61622e-19
C33	a_27_464#	a_212_464#	1.10633e-17
C34	a_1579_258##8	a_1954_119#	4.11574e-17
C35	VPWR#3	a_1954_119#	8.91704e-19
C36	a_197_119##4	SCE#4	9.40035e-20
C37	VGND#3	RESET_B#1	3.06853e-18
C38	Q_N#1	a_3078_384##5	4.48958e-17
C39	a_2133_410##14	a_1579_258##5	2.99526e-19
C40	VPWR#6	a_662_82##6	1.84489e-18
C41	VPWR#12	a_867_82##9	2.13951e-17
C42	SCE#4	D#4	7.77502e-18
C43	a_353_93##5	a_662_82##12	5.59682e-17
C44	a_2392_74#	a_1579_258##6	4.27133e-19
C45	VPWR#24	VPWR#23	1.1469e-18
C46	VPWR#12	a_662_82##10	3.881e-18
C47	VGND#3	a_2133_410##10	1.6725e-17
C48	VGND#8	a_197_119##2	1.0573e-16
C49	VPWR#3	VPWR#4	1.34566e-16
C50	a_1159_497##3	a_1159_497##4	1.79264e-17
C51	VGND#3	a_1954_119#	5.92698e-19
C52	a_1954_119##7	a_867_82##5	4.60533e-17
C53	a_353_93##7	CLK_N#3	1.93859e-18
C54	SCE#3	SCE#4	1.03784e-18
C55	a_1159_497##3	a_1434_78##2	1.20752e-18
C56	SET_B#6	a_1579_258##4	2.18885e-17
C57	a_1954_119##7	a_2133_410##14	1.40109e-18
C58	a_867_82##12	VPWR#12	2.76899e-17
C59	a_2392_74##2	a_1954_119##3	1.54058e-18
C60	a_1579_258##8	SET_B#4	7.13234e-21
C61	a_662_82##5	SET_B#1	2.0657e-17
C62	a_977_243##8	VPWR#20	4.7448e-17
C63	a_1579_258##11	SET_B#4	1.77328e-19
C64	a_867_82##10	a_662_82##4	3.58147e-19
C65	VPWR#20	a_662_82##6	1.0836e-19
C66	a_662_82#	a_1159_497##3	3.36464e-18
C67	Q_N#1	a_3078_384##7	5.58207e-17
C68	a_1954_119##6	a_1954_119#	9.36975e-19
C69	VGND#14	VGND#13	1.23021e-18
C70	a_27_464##2	a_212_464#	5.2079e-18
C71	VGND#11	VGND#9	1.98916e-19
C72	a_197_119##2	a_1159_497##3	1.19774e-16
C73	a_662_82##11	SCE#2	6.10476e-18
C74	a_1579_258##6	a_2133_410##10	1.72556e-17
C75	VGND#10	a_867_82##12	2.73045e-17
C76	a_1579_258##9	a_1579_258##5	2.38984e-17
C77	a_662_82##12	VPWR#12	3.03663e-17
C78	VGND#12	VGND#19	2.84438e-18
C79	VGND#4	RESET_B#1	2.07658e-18
C80	VPWR#3	a_2133_410##5	2.46193e-18
C81	VPWR#20	VPWR#6	4.28386e-19
C82	a_1579_258##5	a_1954_119##2	3.07336e-17
C83	CLK_N#6	VPWR#12	4.89998e-18
C84	a_197_119##4	VGND#18	2.90295e-18
C85	SET_B#5	a_2133_410##14	8.6622e-19
C86	VGND#10	a_867_82##10	1.67361e-18
C87	VPWR#8	a_867_82##5	1.32147e-18
C88	VGND#11	SCE#3	2.50905e-17
C89	a_867_82##4	a_662_82#	2.64559e-17
C90	VGND#7	a_1579_258##2	1.2236e-17
C91	a_353_93##3	D#2	4.93638e-18
C92	a_197_119##4	a_353_93##3	1.60366e-17
C93	a_1579_258##9	a_2133_410#	2.75554e-17
C94	a_1434_78#	a_977_243##13	5.15502e-17
C95	a_662_82##10	a_662_82##4	6.13111e-18
C96	SET_B#1	a_977_243##6	2.23491e-17
C97	a_662_82##5	a_1579_258#	1.91863e-17
C98	a_977_243##5	VPWR#8	1.05324e-18
C99	a_1954_119##7	a_977_243##4	6.96859e-18
C100	a_1579_258##8	a_1579_258##5	2.30291e-19
C101	a_353_93##5	VPWR#12	3.60927e-17
C102	a_353_93#	a_353_93##2	1.69121e-18
C103	a_353_93##7	SCE#2	4.31237e-17
C104	VGND#10	a_662_82##10	5.32172e-18
C105	VPWR#20	a_867_82##5	3.5753e-18
C106	SCD#4	VGND#12	1.79205e-17
C107	a_2133_410##3	SET_B#6	2.78447e-18
C108	a_2392_74##2	a_1579_258##6	4.90801e-17
C109	VPWR#6	a_867_82##5	5.1815e-19
C110	a_867_82##2	a_662_82#	3.88703e-17
C111	VGND#5	a_1954_119##3	4.7004e-18
C112	VPWR#24	a_353_93##5	6.07252e-17
C113	D	a_353_93##2	3.87848e-18
C114	a_197_119##2	a_867_82##4	1.81075e-18
C115	Q#3	a_2133_410##5	2.11871e-19
C116	a_977_243##8	a_977_243##12	3.09823e-18
C117	D	D#2	1.57814e-17
C118	a_977_243##2	a_1159_497##4	1.56345e-19
C119	a_662_82##12	a_353_93##2	1.86195e-19
C120	a_867_82##16	SET_B#5	2.43793e-18
C121	a_1954_119##6	a_1579_258##5	2.15279e-19
C122	a_1954_119##6	SET_B#4	6.486e-19
C123	a_1954_119##5	a_1954_119##6	1.30247e-18
C124	VPWR#9	a_977_243##4	2.86238e-19
C125	SCE#2	VGND#19	1.92366e-18
C126	a_27_464##2	SCE#3	4.25374e-19
C127	a_867_82##10	a_662_82#	1.89697e-19
C128	a_1159_497##5	a_867_82##4	3.61067e-17
C129	VPWR#12	a_27_464#	4.53721e-17
C130	a_1954_119##7	SET_B#3	3.17966e-19
C131	a_977_243##2	a_662_82#	2.48369e-18
C132	a_1434_78##2	a_1434_78#	2.17565e-18
C133	a_977_243##9	VPWR#21	2.66959e-17
C134	a_197_119##4	a_662_82##11	5.06074e-17
C135	a_1579_258##9	SET_B#5	4.9866e-17
C136	a_867_82##16	a_867_82##7	6.92139e-19
C137	VPWR#20	a_977_243##4	4.45437e-17
C138	VGND#8	a_1159_497##3	8.66896e-19
C139	a_353_93##7	a_353_93##3	1.59997e-19
C140	a_197_119##4	D#4	1.62337e-19
C141	VPWR#9	SET_B#2	8.59397e-20
C142	a_977_243##2	a_867_82#	3.2009e-17
C143	a_662_82##10	CLK_N#3	2.93994e-19
C144	VPWR#13	VPWR#11	3.59226e-19
C145	VPWR#3	a_3078_384##5	1.63474e-18
C146	VPWR#12	a_197_119##6	9.43768e-18
C147	a_1579_258##9	a_867_82##8	1.782e-17
C148	VPWR#8	a_977_243##4	8.92502e-18
C149	SCE#2	SCE#1	1.17401e-18
C150	a_1579_258#	SET_B#1	1.63873e-17
C151	a_662_82##6	a_2133_410##3	3.10632e-17
C152	a_977_243##2	a_977_243##3	1.07506e-17
C153	a_2392_74##2	SET_B#4	3.58419e-17
C154	VPWR#8	SET_B#2	2.60233e-19
C155	a_867_82##16	a_2133_410##2	4.51861e-20
C156	VGND#3	a_2133_410##5	2.42902e-18
C157	SET_B#5	a_1954_119##2	3.63168e-19
C158	a_197_119##2	a_867_82##2	4.34063e-18
C159	a_2133_410##14	a_2133_410##2	2.89186e-18
C160	VGND#8	a_662_82#	1.38214e-19
C161	VGND#12	a_197_119##5	1.67126e-17
C162	VGND#14	Q_N#1	3.01382e-17
C163	a_977_243##9	VPWR#9	6.68416e-18
C164	VPWR#12	SCE#8	2.69902e-18
C165	a_867_82##7	a_1954_119##7	1.9633e-17
C166	a_867_82##16	VPWR#9	1.42139e-18
C167	a_662_82##8	a_977_243##2	1.38153e-17
C168	VGND#19	a_353_93##3	3.90927e-17
C169	VPWR#21	VPWR#8	1.11518e-18
C170	VPWR#6	a_977_243##4	1.40817e-19
C171	a_977_243##8	VPWR#21	3.63308e-17
C172	a_197_119##2	a_1151_119#	1.43496e-18
C173	a_867_82##16	a_867_82##6	1.7819e-17
C174	a_2133_410##2	VPWR#19	1.40382e-18
C175	VPWR#20	SET_B#3	1.38875e-18
C176	a_867_82##16	a_2133_410#	4.38169e-20
C177	VGND#5	a_1579_258##6	4.95894e-18
C178	VPWR#12	VPWR#25	2.13737e-17
C179	a_1954_119##6	SET_B#5	2.82761e-17
C180	a_1434_78##2	a_977_243##13	2.65201e-17
C181	SCE#8	SCE#4	9.00745e-18
C182	a_1954_119##6	a_2133_410#	1.84417e-17
C183	a_197_119##5	SCE#2	2.78869e-19
C184	a_27_464#	VPWR#24	5.37727e-17
C185	a_197_119##6	a_353_93##5	1.61414e-18
C186	a_867_82##16	VPWR#8	9.92034e-20
C187	VPWR#21	a_977_243##4	2.42151e-19
C188	SET_B#4	VGND#15	4.88757e-18
C189	SET_B#8	a_867_82##6	2.50243e-18
C190	VPWR#9	SET_B#3	5.28544e-18
C191	a_197_119##4	a_353_93##7	1.12994e-16
C192	RESET_B#2	a_2133_410##6	7.77655e-17
C193	a_867_82##16	a_977_243##5	5.22684e-17
C194	a_1434_78#	a_662_82##3	6.97934e-19
C195	a_1579_258##9	a_867_82##7	7.04527e-19
C196	VPWR#12	a_27_464##2	1.92336e-17
C197	a_353_93##3	a_353_93##4	1.41731e-18
C198	a_197_119##4	SCE#3	1.01124e-18
C199	a_662_82##10	SCE#2	1.69463e-19
C200	SET_B#3	a_977_243##12	2.20985e-17
C201	VGND#6	a_2133_410##2	2.25573e-20
C202	CLK_N#1	a_662_82##7	4.89717e-19
C203	a_867_82##5	a_662_82##6	3.11786e-17
C204	VPWR#7	a_867_82##6	6.51767e-20
C205	a_2392_74##2	a_2133_410#	1.43111e-18
C206	VGND#9	VGND#8	8.92857e-19
C207	a_1954_119##7	a_2133_410##2	4.12582e-17
C208	a_197_119##2	a_977_243##2	1.46766e-17
C209	a_1579_258##9	a_662_82##5	2.66668e-18
C210	VGND#9	VGND#17	2.13337e-18
C211	a_1954_119##4	a_2509_392#	1.15846e-17
C212	SET_B#8	a_977_243##5	3.07113e-17
C213	VGND#3	a_3078_384##5	1.92518e-18
C214	a_1159_497#	a_1579_258#	1.98821e-17
C215	a_1954_119##7	a_662_82##5	1.27645e-18
C216	a_867_82##16	SET_B#2	2.42049e-17
C217	VGND#19	D#4	3.17166e-18
C218	VPWR#8	SET_B#3	1.42513e-18
C219	VPWR#20	a_1579_258##3	1.23239e-19
C220	a_867_82##16	a_662_82##5	3.28506e-17
C221	VGND#10	SCE#8	2.85312e-18
C222	a_1579_258##4	a_2509_392#	1.62026e-17
C223	a_197_119##6	VPWR#24	2.39677e-18
C224	a_1954_119##5	a_867_82##16	5.7084e-17
C225	a_197_119##5	D#2	6.33163e-18
C226	SET_B#3	VPWR#21	1.99364e-17
C227	a_1954_119#	RESET_B#2	1.04346e-18
C228	a_197_119##5	a_353_93##3	6.96643e-18
C229	a_977_243##10	VPWR#10	6.16985e-17
C230	SET_B#8	SET_B#2	1.15008e-17
C231	a_197_119##2	a_977_243##13	7.4011e-17
C232	a_1579_258##8	RESET_B#3	2.02521e-18
C233	a_977_243##8	VPWR#9	9.71361e-18
C234	a_867_82##16	a_1579_258##2	8.46149e-17
C235	SET_B#8	VPWR#9	5.47872e-19
C236	a_353_93#	a_662_82##8	6.91982e-20
C237	VGND#5	a_1579_258##9	4.82673e-17
C238	a_867_82##16	a_977_243##6	3.6399e-19
C239	SCE#1	CLK_N#2	1.04274e-17
C240	a_2133_410#	VGND#15	7.82266e-18
C241	a_867_82##7	a_1954_119##6	7.44516e-17
C242	SCE#3	D#2	5.97718e-19
C243	a_353_93#	CLK_N#1	1.32285e-18
C244	a_1579_258##2	SET_B#8	3.17187e-17
C245	a_1954_119##7	a_867_82##6	6.73827e-18
C246	SET_B#8	a_662_82##5	5.93383e-19
C247	a_197_119##4	VGND#19	9.71553e-17
C248	VGND#5	SET_B#4	1.1629e-17
C249	a_867_82##11	a_867_82##10	3.0949e-18
C250	SET_B#8	VPWR#8	1.96499e-18
C251	a_1954_119##5	SET_B#4	7.85423e-20
C252	a_977_243##4	a_867_82##5	5.33807e-17
C253	VPWR#12	SCD#4	2.05704e-18
C254	a_197_119##2	a_662_82##7	5.08395e-19
C255	a_2392_74##2	a_867_82##8	2.80252e-19
C256	VPWR#20	a_1954_119##7	1.79997e-17
C257	a_27_464#	a_197_119##6	1.004e-16
C258	a_867_82##12	VGND#8	2.51831e-18
C259	a_1579_258##9	a_2133_410##2	2.5724e-19
C260	VPWR#9	a_1579_258##3	5.55551e-18
C261	a_867_82##16	VGND#16	3.60421e-18
C262	a_353_93#	SCE#1	3.91534e-17
C263	a_1954_119#	a_1579_258##5	7.66199e-18
C264	a_867_82##11	a_977_243##2	2.52982e-18
C265	VGND#19	SCE#3	2.0855e-18
C266	a_1579_258##3	VPWR#21	2.05916e-17
C267	a_2133_410##3	a_2088_508#	7.5791e-18
C268	SET_B#8	a_1159_497##3	4.05599e-18
C269	a_977_243##10	VPWR#9	6.48824e-17
C270	SCE#4	D#2	5.12517e-17
C271	a_1579_258##9	a_977_243##6	1.59735e-19
C272	SET_B#8	a_1954_119##5	5.65412e-19
C273	a_353_93#	a_353_93##4	5.91135e-19
C274	a_197_119##5	D#4	3.66681e-17
C275	a_867_82##3	a_1159_497#	2.89171e-18
C276	a_977_243##10	SET_B#3	6.02479e-19
C277	a_867_82##12	VGND#7	5.37685e-19
C278	VGND#6	a_1579_258##2	2.04523e-17
C279	SET_B#5	a_1954_119#	1.12102e-17
C280	a_662_82##6	a_2088_508#	3.4808e-18
C281	SCE#8	a_27_464#	1.76455e-18
C282	VPWR#9	a_1159_497##3	9.76179e-20
C283	a_197_119##2	a_1434_78##2	6.92116e-17
C284	a_977_243##13	a_662_82##3	2.2436e-18
C285	a_867_82##16	a_1434_78#	3.09454e-18
C286	VPWR#11	VPWR#10	6.52048e-19
C287	VPWR#7	a_662_82##5	1.34733e-19
C288	VPWR#8	a_1579_258##3	2.80348e-19
C289	VGND#12	a_353_93##3	4.91413e-19
C290	a_977_243##5	a_1954_119##7	1.53777e-17
C291	a_977_243##8	VPWR#8	9.59183e-18
C292	SET_B#5	a_1579_258##5	2.52364e-17
C293	SCD#4	SCD#2	1.87058e-17
C294	VGND#6	a_867_82##8	1.86364e-18
C295	a_867_82##10	a_662_82##8	6.96303e-18
C296	a_662_82##10	a_867_82##11	4.36763e-17
C297	D#2	a_353_93##2	2.61922e-17
C298	a_867_82##16	a_977_243##13	1.11651e-17
C299	a_2133_410#	a_2164_119#	9.64418e-18
C300	SET_B#3	a_977_243##4	4.38179e-18
C301	a_1954_119##5	a_2133_410#	1.54796e-19
C302	a_1954_119##6	a_2133_410##2	9.5909e-17
C303	a_1954_119##6	a_662_82##5	5.73241e-19
C304	VPWR#21	a_1159_497##4	1.23241e-18
C305	a_867_82##11	a_662_82##7	6.13052e-18
C306	VGND#19	SCD#3	2.41744e-19
C307	VGND#10	SCD#4	1.43556e-18
C308	a_867_82##8	a_2164_119#	9.64418e-18
C309	a_867_82##12	a_1159_497##3	6.101e-17
C310	a_1954_119#	a_2133_410##2	2.68554e-19
C311	a_197_119#	a_977_243##9	6.34655e-17
C312	a_867_82##5	a_1903_424#	1.55184e-17
C313	a_977_243##10	a_1579_258##3	1.35288e-18
C314	VGND#6	a_662_82##5	7.54463e-18
C315	a_867_82##16	a_1434_78##2	6.68582e-19
C316	a_662_82##10	a_662_82##8	6.75088e-18
C317	a_197_119##5	SCE#3	4.34181e-17
C318	a_977_243##5	VPWR#20	2.89146e-17
C319	a_2392_74#	VGND#14	1.49186e-18
C320	a_1579_258##8	a_1579_258##7	3.06753e-18
C321	VGND#5	a_2133_410#	2.85792e-18
C322	VPWR#12	a_1159_497##3	8.08686e-19
C323	a_977_243##4	a_1903_424#	1.87573e-17
C324	a_867_82##12	a_867_82##4	2.84496e-17
C325	SCE#4	D#3	1.46553e-18
C326	a_977_243##13	a_1159_497##2	5.38016e-18
C327	VPWR#9	a_1159_497##4	4.99025e-18
C328	VPWR#25	a_27_464#	4.88492e-17
C329	VGND#12	D#4	4.75718e-19
C330	SCE#8	a_197_119##6	2.77421e-18
C331	VPWR#10	a_867_82##4	1.34161e-19
C332	a_662_82##2	a_867_82##3	3.79839e-17
C333	VGND#10	a_1159_497##3	9.41779e-19
C334	a_197_119#	a_1579_258##3	2.74497e-18
C335	a_2133_410##6	a_2133_410##4	5.64615e-20
C336	a_2133_410##2	SET_B#5	1.32916e-17
C337	VPWR#12	a_867_82##4	1.54108e-18
C338	a_977_243##9	a_1528_424#	4.57996e-18
C339	a_867_82##12	a_867_82##2	2.41986e-17
C340	a_1954_119##6	a_1954_119##4	8.97755e-20
C341	VPWR#9	a_867_82##4	1.42665e-20
C342	VGND#9	VGND#18	7.62555e-18
C343	a_1579_258##3	SET_B#3	4.46915e-17
C344	VGND#8	a_977_243##2	4.76973e-19
C345	a_977_243##10	a_1159_497##4	5.53823e-17
C346	a_867_82##10	CLK_N#1	1.35952e-18
C347	a_1954_119##5	a_867_82##8	2.6823e-17
C348	a_867_82##11	CLK_N#2	5.19855e-20
C349	VGND#10	a_867_82##4	1.99329e-18
C350	a_2133_410##6	a_2133_410##9	1.35038e-17
C351	a_662_82##10	VGND#18	2.28859e-18
C352	a_867_82##7	a_2133_410##2	9.79328e-18
C353	a_2133_410##5	a_3078_384#	1.94668e-18
C354	a_197_119##4	a_353_93##4	8.50743e-19
C355	a_1434_78##2	a_662_82##3	2.21018e-17
C356	CLK_N#6	a_662_82##8	1.35824e-19
C357	a_197_119##5	SCD#3	6.03253e-18
C358	a_867_82##12	a_977_243##2	4.90317e-17
C359	Q_N#1	a_2133_410##5	5.12388e-18
C360	VGND#10	VGND#11	1.36779e-16
C361	a_1954_119##6	a_867_82##6	5.2003e-20
C362	a_1954_119##6	a_977_243##6	7.21312e-20
C363	CLK_N#2	VGND#18	3.18842e-19
C364	a_1579_258##3	a_1528_424#	1.65923e-17
C365	a_197_119##5	a_197_119##4	2.38498e-18
C366	a_2133_410##6	RESET_B#1	2.40384e-17
C367	VPWR#10	a_662_82#	3.95611e-18
C368	a_197_119##2	a_1159_497##5	1.14346e-16
C369	a_662_82##10	CLK_N#1	8.74006e-18
C370	VGND#12	SCE#3	1.87559e-17
C371	a_197_119#	a_1159_497##4	3.02212e-17
C372	VPWR#12	a_977_243##2	2.45434e-17
C373	a_1159_497##4	a_1528_424#	6.11825e-18
C374	Q#3	a_3078_384##2	3.81271e-17
C375	CLK_N#2	a_662_82##11	3.22447e-17
C376	a_662_82##5	a_1876_119#	9.707e-18
C377	VGND#10	VGND#9	8.05254e-17
C378	a_1579_258##8	a_2133_410##12	2.04002e-18
C379	VPWR#16	Q#1	3.65888e-17
C380	a_662_82##3	a_662_82#	3.08907e-19
C381	a_977_243##6	a_1876_119#	9.90962e-18
C382	RESET_B#2	a_2133_410##9	5.60213e-19
C383	a_2133_410##6	a_1954_119##3	3.82847e-19
C384	VGND#3	RESET_B#4	3.81847e-18
C385	a_977_243##10	a_662_82#	1.85093e-17
C386	VGND#5	a_867_82##8	9.93941e-19
C387	a_3078_384##2	VGND#13	3.61381e-17
C388	a_977_243#	a_662_82##2	5.98164e-17
C389	VGND#10	VGND#8	1.39064e-16
C390	a_27_464#	D#2	3.10832e-19
C391	a_1159_497##7	a_1159_497##4	1.91065e-19
C392	a_1159_497##4	a_1579_258##3	5.29338e-17
C393	a_27_464##2	a_197_119##6	2.90725e-17
C394	VPWR#10	a_867_82##2	2.22737e-20
C395	a_197_119##4	a_662_82##10	3.59132e-17
C396	a_1954_119##5	a_662_82##5	4.79302e-17
C397	a_1954_119##6	a_1579_258##4	2.15032e-19
C398	a_1434_78##2	a_1159_497##2	4.19597e-19
C399	VGND#9	a_662_82##7	2.47974e-19
C400	VPWR#12	CLK_N#2	1.86997e-19
C401	a_662_82#	a_197_119#	2.60644e-17
C402	a_977_243##5	a_867_82##6	3.50633e-17
C403	VPWR#21	VPWR#20	9.67248e-19
C404	a_3078_384##5	a_3078_384##3	3.9181e-19
C405	a_1579_258##2	a_867_82##7	6.66309e-20
C406	CLK_N#6	CLK_N#1	3.33008e-18
C407	VGND#12	SCD#3	3.45234e-17
C408	a_867_82#	a_1081_497#	1.94907e-18
C409	a_2133_410##10	a_1579_258##11	4.01362e-17
C410	a_867_82##12	VPWR#10	8.87829e-19
C411	a_1954_119##3	RESET_B#2	5.02994e-19
C412	a_197_119##4	D	4.44609e-17
C413	VGND#10	CLK_N#2	3.61041e-18
C414	a_662_82##4	a_662_82##2	5.77338e-20
C415	VPWR#21	a_1579_258##2	7.55433e-19
C416	a_977_243##3	a_1081_497#	3.89814e-18
C417	VPWR#12	a_353_93#	6.25173e-18
C418	a_977_243##10	a_867_82#	1.94076e-19
C419	VGND#7	a_662_82##5	4.79704e-17
C420	a_662_82##10	SCE#1	2.61701e-19
C421	a_1159_497##7	a_662_82#	5.51834e-17
C422	a_662_82##10	a_353_93##2	1.41513e-19
C423	a_867_82##12	VPWR#9	4.36602e-19
C424	VPWR#10	a_867_82#	3.83171e-18
C425	VGND#10	a_353_93#	1.55153e-18
C426	a_197_119##2	a_662_82##3	4.60948e-17
C427	VPWR#3	a_3078_384#	3.28224e-18
C428	SET_B#2	a_977_243##5	5.93299e-17
C429	a_197_119##6	a_353_93##2	6.737e-18
C430	a_662_82#	a_1159_497##4	3.55788e-18
C431	VPWR#13	a_353_93##2	2.72845e-19
C432	a_1954_119##5	a_977_243##6	2.62797e-18
C433	VPWR#12	VPWR#13	9.06497e-17
C434	a_867_82##12	a_662_82##2	7.29719e-18
C435	a_662_82##4	a_977_243#	1.92631e-18
C436	a_1579_258##2	a_977_243##5	4.24915e-17
C437	VGND#5	a_662_82##5	1.3391e-18
C438	VPWR#3	a_2133_410##8	8.04522e-18
C439	VPWR#12	SCE#4	2.33781e-18
C440	VGND#16	a_662_82##5	2.8103e-18
C441	VPWR#4	VPWR#16	1.46859e-18
C442	a_1954_119##6	SET_B#6	1.88127e-17
C443	VGND#3	a_1579_258##8	2.10095e-18
C444	a_197_119#	a_1579_258##2	5.78543e-19
C445	a_977_243##2	VPWR#10	4.10058e-17
C446	a_977_243##10	a_977_243##3	1.21466e-19
C447	a_27_464##2	VPWR#25	9.65868e-17
C448	a_197_119##2	VGND#17	1.3563e-16
C449	VPWR#12	VPWR#11	6.94871e-17
C450	a_2392_74#	a_2133_410##10	8.7604e-17
C451	a_3078_384##6	VPWR#16	6.41282e-17
C452	SCE#8	D	3.78423e-17
C453	a_1579_258##11	a_2392_74##2	2.50172e-20
C454	a_867_82##12	a_977_243#	7.07095e-18
C455	a_1579_258##2	SET_B#2	6.31503e-17
C456	CLK_N#6	SCE#1	1.20318e-18
C457	a_867_82#	a_1159_497##7	1.5802e-17
C458	VGND#10	SCE#4	5.60676e-18
C459	a_197_119##6	D#2	1.16329e-17
C460	VGND#9	CLK_N#2	8.78769e-19
C461	Q_N#1	a_2133_410##6	6.73743e-17
C462	a_3078_384##5	a_2133_410##4	1.3076e-18
C463	VPWR#12	SCD#2	1.95073e-18
C464	VPWR#3	a_2133_410##7	3.96032e-18
C465	Q_N#1	Q_N#2	3.21749e-18
C466	a_1579_258##5	a_1954_119##3	7.87168e-18
C467	VPWR#12	VPWR#10	1.30144e-16
C468	a_197_119##2	a_1159_497##2	1.7932e-17
C469	a_1159_497##3	a_977_243##10	3.49106e-18
C470	a_867_82#	a_662_82#	2.35498e-17
C471	VGND#10	SCD#2	2.92128e-18
C472	SCE#8	a_27_464##2	1.64846e-17
C473	a_3078_384##6	VPWR#3	1.69429e-17
C474	a_977_243##9	a_662_82##5	1.68532e-20
C475	D#3	a_212_464#	3.43095e-18
C476	a_2133_410##6	VGND#14	7.03022e-17
C477	a_1434_78#	a_662_82##5	1.52466e-17
C478	Q_N#2	a_2133_410##5	4.06391e-18
C479	VGND#7	a_977_243##6	3.19586e-18
C480	VPWR#3	RESET_B#3	5.0418e-19
C481	a_1579_258##2	a_1579_258##9	1.84264e-18
C482	SCE#5	a_212_464#	6.42114e-18
C483	VPWR#12	VPWR#9	3.60339e-18
C484	a_1159_497##3	a_197_119#	1.06838e-16
C485	VPWR#10	a_977_243##3	6.09321e-18
C486	a_867_82##12	a_1434_78##2	4.06945e-18
C487	SCE#8	D#4	1.72104e-18
C488	Q	a_2133_410##5	7.96081e-19
C489	a_1159_497##7	a_977_243##3	1.53533e-18
C490	CLK_N#3	a_662_82##4	2.15984e-17
C491	Q_N#2	VPWR#16	6.19057e-18
C492	a_2133_410##6	a_1579_258##11	3.7833e-17
C493	a_977_243##6	VGND#16	1.38532e-17
C494	Q_N#2	VPWR#3	4.31728e-17
C495	a_197_119##2	a_867_82##11	5.2574e-17
C496	VPWR#13	D#2	1.35537e-20
C497	VGND#3	VPWR#16	3.69401e-18
C498	SET_B#4	a_1579_258##5	7.81739e-18
C499	a_2133_410##7	a_2133_410##5	6.12454e-20
C500	VPWR#22	a_867_82#	8.70486e-19
C501	a_2392_74##2	a_2392_74#	2.38259e-18
C502	VPWR#11	a_662_82##7	2.79288e-20
C503	a_1159_497##5	a_662_82##3	1.17923e-18
C504	a_977_243##8	a_662_82##5	2.91923e-20
C505	a_867_82##12	a_197_119##2	1.30366e-16
C506	a_867_82##4	a_1159_497##3	1.11261e-16
C507	a_977_243##13	a_662_82##5	3.99411e-19
C508	VGND#3	RESET_B#3	2.27141e-19
C509	a_867_82##9	VPWR#11	1.12156e-17
C510	a_977_243##10	a_867_82##4	1.70517e-18
C511	VGND#10	a_977_243#	9.30755e-19
C512	Q#1	a_3078_384#	2.4785e-17
C513	a_977_243##3	a_867_82#	3.05823e-17
C514	VGND#11	a_353_93#	1.98348e-19
C515	a_1159_497##3	a_867_82##2	2.59176e-19
C516	SCE#2	a_662_82##4	4.60129e-19
C517	a_662_82##2	a_1151_119#	6.3834e-18
C518	a_867_82##9	a_867_82#	2.36124e-19
C519	a_197_119#	a_867_82##4	2.16479e-18
C520	VGND#5	a_2392_74#	3.59364e-17
C521	a_867_82##12	a_1159_497##5	5.8835e-18
C522	a_1159_497##2	a_1579_258#	4.88684e-19
C523	a_3078_384##5	a_2133_410##9	2.65742e-19
C524	a_1579_258##2	a_1954_119##6	8.27215e-19
C525	a_2133_410##10	a_2133_410##6	3.09956e-18
C526	RESET_B#2	VGND#14	1.17569e-18
C527	VGND#10	a_662_82##4	1.24895e-17
C528	VPWR#9	VPWR#8	7.576e-19
C529	VPWR#11	a_662_82##8	7.53354e-18
C530	VPWR#3	a_1579_258##7	5.11045e-18
C531	a_1159_497##3	a_977_243##2	1.23142e-19
C532	Q_N#2	a_3078_384##6	9.02265e-17
C533	VGND#3	Q_N#2	1.68253e-18
C534	a_867_82##4	a_1159_497##7	3.42213e-17
C535	VPWR#22	a_977_243##3	3.13651e-17
C536	a_3078_384#	VPWR#16	2.85816e-17
C537	a_197_119##5	SCE#4	2.33972e-17
C538	VGND#16	SET_B#1	3.64314e-17
C539	SCE#8	SCE#3	8.62696e-19
C540	VGND#10	CLK_N#3	1.14999e-17
C541	a_867_82##9	VPWR#10	9.94312e-18
C542	a_2133_410#	SET_B#5	1.64787e-17
C543	a_867_82##4	a_977_243##2	2.50871e-19
C544	VGND#7	SET_B#1	2.04249e-18
C545	a_1954_119#	a_2509_392#	8.90424e-18
C546	a_2392_74##2	a_2133_410##10	4.14988e-17
C547	SCE#2	CLK_N#3	1.22714e-17
C548	a_977_243##9	SET_B#2	7.26691e-19
C549	a_977_243##10	VPWR#21	5.9186e-18
C550	VPWR#3	a_2133_410##12	1.01897e-17
C551	VPWR#10	a_662_82##8	1.51651e-18
C552	Q#1	a_2133_410##8	9.45994e-19
C553	a_977_243##13	a_977_243##6	9.55333e-20
C554	a_867_82##9	a_977_243##3	3.67727e-18
C555	a_867_82##12	VGND#17	1.97607e-18
C556	a_977_243##2	a_867_82##2	3.66207e-17
C557	a_867_82##4	a_662_82##7	1.30263e-19
C558	a_662_82##8	a_977_243##3	3.75513e-18
C559	VGND#10	SCE#2	9.76753e-18
C560	VGND#12	SCE#4	1.01581e-18
C561	SET_B#2	a_977_243##8	3.60367e-17
C562	a_3078_384##6	a_3078_384#	1.36247e-18
C563	a_1954_119##6	a_662_82##6	1.43124e-19
C564	VGND#4	a_2133_410##6	2.27055e-17
C565	VPWR#11	CLK_N#2	8.45697e-21
C566	a_197_119##5	D	1.52558e-17
C567	SET_B#1	a_1434_78#	1.76127e-17
C568	VGND#4	a_2392_74#	1.69141e-17
C569	VPWR#22	a_662_82##8	9.18536e-19
C570	a_1159_497##7	a_867_82##2	2.18759e-18
C571	a_662_82##3	a_1159_497#	1.91997e-17
C572	VGND#3	a_1579_258##7	2.32787e-18
C573	VPWR#4	Q_N#2	3.65479e-17
C574	VPWR#13	CLK_N#1	3.32236e-19
C575	a_867_82##7	a_2133_410#	3.26162e-17
C576	VGND#10	a_353_93##3	2.50275e-18
C577	VPWR#23	a_977_243##3	6.79559e-19
C578	a_2133_410##8	VPWR#16	2.81361e-17
C579	a_197_119##5	SCD#2	1.78122e-19
C580	a_2133_410##4	a_3078_384##3	2.59643e-17
C581	a_662_82##7	a_977_243##2	1.53389e-17
C582	a_977_243##2	a_977_243##10	1.40659e-18
C583	VGND#16	a_1579_258#	9.72472e-19
C584	a_2133_410##2	a_2509_392#	3.43069e-20
C585	Q_N#2	a_3078_384#	1.68282e-18
C586	a_867_82##9	a_662_82##8	5.47806e-17
C587	VGND#10	D#4	5.23932e-18
C588	VPWR#11	CLK_N#1	5.77259e-18
C589	VGND#10	a_197_119##2	5.39588e-17
C590	a_977_243##13	SET_B#1	2.60709e-19
C591	VPWR#9	a_1159_497##2	1.56044e-20
C592	a_2133_410##2	a_2088_508#	5.40492e-19
C593	a_867_82##16	a_1954_119##6	1.22318e-18
C594	SCD#2	VGND#12	3.36633e-17
C595	CLK_N#1	a_662_82##8	4.75113e-17
C596	SCE#2	a_353_93##3	2.74193e-17
C597	a_1434_78#	SET_B#3	1.43677e-19
C598	a_3078_384##6	a_2133_410##8	6.58656e-17
C599	a_977_243##9	a_1579_258##2	5.20252e-18
C600	a_867_82##7	a_662_82##5	3.18994e-17
C601	SET_B#8	a_1579_258##9	4.44228e-20
C602	CLK_N#2	a_662_82##7	3.48302e-17
C603	VPWR#22	CLK_N#1	5.42465e-20
C604	a_2133_410##5	a_3078_384##3	2.20188e-18
C605	a_977_243##2	a_1159_497##7	3.91573e-17
C606	VPWR#23	VPWR#10	1.23092e-18
C607	VGND#10	SCE#3	1.44163e-17
C608	VGND#10	a_1159_497##5	3.68648e-18
C609	VGND#7	a_1579_258#	1.25611e-18
C610	a_662_82##8	VPWR#23	1.81952e-17
C611	VGND#4	RESET_B#3	4.51319e-20
C612	a_1579_258#	a_1434_78#	2.51435e-17
C613	VPWR#10	CLK_N#1	2.13301e-19
C614	a_353_93#	a_662_82##7	6.66109e-20
C615	a_1579_258##2	a_977_243##8	3.03842e-18
C616	a_353_93#	VPWR#13	6.82439e-19
C617	VPWR#16	a_2133_410##7	1.22288e-18
C618	a_1954_119##6	a_2133_410##14	7.19015e-17
C619	VGND#10	SCD#3	4.50291e-18
C620	a_3078_384##5	Q	2.69312e-18
C621	a_977_243##13	a_977_243##9	8.05932e-19
C622	a_867_82##9	CLK_N#1	2.34951e-18
C623	a_1434_78##2	SET_B#1	1.75933e-19
C624	a_353_93#	CLK_N#2	1.45588e-17
C625	Q_N#2	a_2133_410##8	4.42434e-18
C626	VGND#11	a_197_119##5	1.10779e-17
C627	VGND#4	RESET_B#2	1.49906e-19
C628	a_977_243##2	VPWR#22	8.67805e-17
C629	a_2392_74#	a_1954_119##2	9.69832e-19
C630	a_662_82##12	a_662_82##8	4.00009e-19
C631	a_977_243##5	a_1903_424#	1.10486e-18
C632	a_662_82##5	a_2133_410##2	1.43212e-19
C633	VGND#4	a_2133_410##10	2.54973e-17
C634	VPWR#4	VPWR#17	6.73317e-18
C635	a_662_82##12	VPWR#11	3.40712e-18
C636	SCD#4	a_27_464##2	1.78088e-17
C637	VPWR#13	SCE#1	7.85789e-18
C638	a_662_82##3	a_1579_258##2	9.79085e-19
C639	SCE#1	CLK_N#1	1.30703e-17
C640	a_867_82##9	a_977_243##2	4.35622e-17
C641	a_197_119##2	a_197_119#	4.42867e-19
C642	a_977_243##13	a_1579_258#	4.16799e-17
C643	a_3078_384##6	a_2133_410##7	1.07339e-18
C644	a_2133_410##9	a_2133_410##4	5.02279e-18
C645	a_977_243##9	a_662_82##3	1.00381e-19
C646	VPWR#23	CLK_N#1	4.19828e-17
C647	a_867_82##16	a_662_82##6	1.84336e-18
C648	a_662_82##3	a_867_82##3	1.55797e-17
C649	VGND#11	SCE#4	5.72609e-19
C650	a_662_82##10	a_867_82##10	5.14853e-17
C651	a_977_243##10	a_1159_497##2	6.48978e-20
C652	a_1159_497##2	a_1579_258##2	3.45155e-17
C653	VGND#5	a_2392_74##2	6.38605e-17
C654	a_1579_258##9	a_2164_119#	1.02981e-18
C655	VPWR#8	VPWR#6	6.67805e-20
C656	D#4	a_353_93##3	4.37444e-17
C657	SCE#3	SCE#2	1.93437e-19
C658	a_197_119#	a_977_243##10	1.16629e-16
C659	VPWR#11	SCE#1	2.81792e-19
C660	VGND#17	a_662_82##3	6.99682e-19
C661	a_1434_78#	a_1159_497#	7.09081e-19
C662	a_867_82##12	a_662_82##3	1.81365e-19
C663	VGND#10	a_867_82##11	6.01282e-18
C664	a_867_82##9	SCE#1	2.43789e-19
C665	a_662_82##5	a_867_82##6	2.42323e-17
C666	a_353_93##5	VPWR#13	5.44362e-18
C667	a_1579_258##5	a_2133_410##10	3.74919e-18
C668	a_662_82##12	CLK_N#1	3.2561e-17
C669	a_2133_410##7	Q_N#2	2.22807e-17
C670	a_1434_78##2	a_1579_258#	5.94023e-19
C671	a_1579_258##7	a_1954_119##2	4.61779e-18
C672	a_867_82##3	a_1159_497##2	1.92628e-19
C673	a_867_82##12	a_1159_497##2	1.98807e-18
C674	VGND#7	a_1159_497#	1.08783e-18
C675	D	a_197_119##6	3.28543e-17
C676	VPWR#23	SCE#1	5.05322e-19
C677	a_2392_74##2	a_1579_258##5	4.66832e-19
C678	SCE#3	a_353_93##3	8.07482e-18
C679	a_353_93##4	SCE#1	9.05762e-18
C680	a_353_93##3	a_305_119#	5.87385e-18
C681	a_867_82##10	VPWR#10	3.88895e-19
C682	D#4	a_305_119#	7.56693e-18
C683	a_353_93##5	CLK_N#1	1.4064e-18
C684	a_977_243##13	a_1159_497#	1.07184e-17
C685	a_1434_78##2	a_1528_424#	4.65656e-21
C686	SET_B#8	a_867_82##5	3.02739e-18
C687	a_27_464##2	D#2	1.44759e-18
C688	a_197_119#	a_662_82##3	4.27507e-19
C689	a_1579_258##8	RESET_B#4	1.85047e-17
C690	VGND#10	a_662_82##11	6.40083e-18
C691	a_662_82##5	a_977_243##5	1.90426e-18
C692	a_2133_410##7	VPWR#17	2.55509e-17
C693	SCD#2	SCE#4	1.21883e-16
C694	a_977_243##10	a_1159_497##7	3.554e-17
C695	a_662_82##10	VPWR#11	3.49849e-19
C696	VPWR#7	a_662_82##6	5.47492e-18
C697	a_2133_410##12	Q_N#2	1.03216e-18
C698	VPWR#4	a_3078_384#	8.09344e-19
C699	a_197_119##2	a_1579_258#	7.98448e-19
C700	a_662_82##12	SCE#1	7.73767e-18
C701	a_977_243##9	a_1159_497##2	9.7223e-19
C702	VPWR#13	a_353_93##4	5.56293e-18
C703	VPWR#5	a_1954_119##2	3.71675e-20
C704	a_1434_78#	a_867_82##3	7.23909e-20
C705	SET_B#8	a_977_243##4	2.58801e-19
C706	RESET_B#1	a_2133_410##9	8.33013e-18
C707	a_867_82##16	a_977_243##9	2.14921e-17
C708	VPWR#24	CLK_N#1	3.05391e-19
C709	SCE#3	D#4	3.63484e-17
C710	Q_N#2	RESET_B#3	4.82574e-19
C711	VGND#10	a_353_93##7	1.09199e-17
C712	a_2133_410##10	a_1954_119##2	2.05614e-18
C713	VPWR#8	a_662_82##5	1.34768e-19
C714	VPWR#7	a_867_82##5	7.64099e-18
C715	a_977_243##2	a_1081_497#	1.14257e-17
C716	VGND#8	a_867_82##3	1.39885e-18
C717	a_662_82##3	a_1159_497##3	3.67981e-18
C718	VPWR#23	a_353_93##4	1.14357e-19
C719	a_1159_497#	a_1434_78##2	1.9129e-17
C720	a_1579_258##7	a_2133_410##7	1.39314e-18
C721	VGND#5	VGND#15	6.52891e-18
C722	Q#3	a_3078_384##3	3.33315e-17
C723	Q#3	Q	3.20386e-18
C724	VGND#6	a_1579_258##9	3.18648e-17
C725	a_2133_410##12	VPWR#5	2.30168e-17
C726	a_353_93##5	SCE#1	5.36487e-17
C727	VPWR#11	a_353_93##4	2.92511e-20
C728	a_662_82##5	SET_B#2	7.00995e-19
C729	D#3	a_353_93##4	3.71679e-17
C730	a_2133_410##6	a_2133_410##8	7.37225e-21
C731	SET_B#8	SET_B#3	9.38494e-18
C732	a_867_82##16	a_977_243##8	4.0736e-18
C733	a_1579_258##2	a_2133_410#	5.0778e-20
C734	a_197_119#	a_1159_497##2	2.35247e-19
C735	a_1159_497##3	a_1159_497##2	1.94958e-17
C736	a_1159_497##7	a_197_119#	5.19245e-17
C737	VPWR	VPWR#9	1.16862e-16
C738	a_977_243##13	a_867_82##3	3.22518e-19
C739	RESET_B#3	VPWR#17	2.13706e-17
C740	VPWR	VPWR#8	7.11253e-17
C741	CLK_N#2	a_662_82##12	5.8752e-18
C742	VPWR	VPWR#6	7.79305e-17
C743	a_197_119##2	a_977_243##9	4.94604e-18
C744	VPWR	VPWR#5	9.7993e-17
C745	VPWR	VPWR#4	1.17783e-17
C746	a_2133_410##6	VPWR#4	4.324e-17
C747	a_1954_119##3	a_2133_410##9	3.66914e-19
C748	a_1579_258##2	a_867_82##8	3.61192e-19
C749	a_2133_410##6	a_2133_410##7	1.78749e-17
C750	SET_B#8	a_1579_258##3	6.119e-18
C751	VPWR#24	SCE#1	1.37778e-17
C752	a_2133_410##12	a_2133_410##7	5.65793e-19
C753	SCE#3	a_119_119#	9.7209e-18
C754	VGND#5	a_1579_258##5	9.28638e-20
C755	a_197_119##2	a_1159_497#	1.91072e-17
C756	SCD#3	a_119_119#	1.01349e-17
C757	Q_N#2	a_1954_119##4	1.57941e-19
C758	a_1954_119##2	a_2133_410##12	8.11112e-18
C759	a_3078_384##3	VGND#13	2.10001e-17
C760	a_2133_410##12	a_2509_392#	2.62946e-18
C761	a_1579_258##2	a_662_82##5	4.47988e-17
C762	a_2133_410##6	RESET_B#3	1.32099e-17
C763	a_353_93##5	a_353_93##4	7.1791e-19
C764	a_1579_258##4	a_1954_119##2	9.60824e-18
C765	a_3078_384##5	a_3078_384##2	6.55549e-19
C766	RESET_B#3	a_1579_258##7	1.19246e-17
C767	VGND#10	a_197_119##5	1.93977e-17
C768	VPWR#4	a_2133_410##8	5.5252e-19
C769	a_2133_410##12	VPWR#4	4.49913e-17
C770	a_2133_410##9	a_2133_410##5	6.28558e-19
C771	SCD#3	SCE#3	4.20342e-17
C772	a_1434_78##2	a_867_82##3	4.36203e-19
C773	SCE#5	D#3	4.74284e-17
C774	a_27_464#	SCE#1	1.36551e-18
C775	VGND#12	VGND#11	4.41462e-19
C776	D	a_353_93##3	1.62417e-18
C777	a_977_243##9	SET_B#8	2.05698e-17
C778	RESET_B#2	a_2133_410##7	7.97939e-18
C779	a_1579_258##2	a_977_243##6	2.31635e-17
C780	VPWR	a_1579_258##9	4.36971e-18
C781	VPWR#13	D#3	1.80282e-19
C782	SCE#8	a_197_119##4	3.85748e-18
C783	Q#3	a_2133_410##4	1.69513e-18
C784	a_1159_497##7	a_662_82##3	2.65399e-19
C785	a_353_93#	a_662_82##12	9.02523e-18
C786	a_1954_119##3	RESET_B#1	2.69296e-18
C787	D	SCE#3	2.01962e-19
C788	VPWR#12	a_353_93##2	1.14634e-18
C789	VPWR	a_1954_119##6	6.39692e-18
C790	a_2133_410##6	a_1954_119##4	1.6626e-19
C791	a_2133_410##12	a_1579_258##7	5.2704e-17
C792	a_1159_497##5	a_1159_497#	2.66144e-19
C793	Q_N#2	a_3078_384##5	2.00165e-17
C794	VPWR#24	a_353_93##4	1.25072e-18
C795	a_867_82##16	a_1954_119##7	6.03402e-17
C796	a_1579_258##2	SET_B#1	2.3575e-17
C797	a_977_243##9	a_977_243##8	6.72818e-18
C798	RESET_B#2	RESET_B#3	4.37273e-18
C799	VPWR	a_977_243##9	1.15348e-17
C800	VPWR#6	VPWR#5	2.0343e-18
C801	a_977_243##8	a_867_82##5	2.90224e-19
C802	SET_B#8	a_977_243##8	4.86928e-17
C803	VPWR#4	a_1954_119##2	2.30871e-19
C804	VPWR	a_977_243##8	1.81506e-17
C805	a_2133_410##12	RESET_B#3	3.40774e-17
C806	a_197_119##6	SCE#1	3.40522e-18
C807	a_1579_258##2	a_1876_119#	1.26782e-17
C808	a_3078_384##7	a_3078_384##3	9.55907e-19
C809	Q	Q#1	3.16601e-18
C810	VPWR#16	Q	4.49176e-17
C811	a_2133_410##6	a_1579_258##4	3.2556e-20
C812	a_3078_384##6	Q	2.61378e-18
C813	VGND#9	a_662_82##3	6.39176e-19
C814	a_1954_119#	a_2133_410##7	3.69581e-20
C815	a_1579_258##8	a_1579_258##11	6.85401e-19
C816	a_867_82##3	a_197_119##2	2.41517e-17
C817	a_353_93##5	D#3	1.63786e-19
C818	a_1954_119##7	a_1954_119##6	8.15792e-19
C819	VGND#10	VGND#12	8.67423e-17
C820	a_353_93#	VPWR#24	1.57953e-17
C821	a_1579_258##2	a_1579_258#	1.10163e-19
C822	a_662_82##3	a_867_82##4	1.23173e-18
C823	a_27_464#	VPWR#13	4.34744e-17
C824	a_1954_119##4	RESET_B#2	2.93644e-19
C825	a_27_464#	a_353_93##4	5.91395e-17
C826	a_1579_258##7	a_1954_119##4	8.48643e-19
C827	a_662_82##11	VGND#18	1.06579e-19
C828	a_353_93##2	SCE#1	1.18244e-18
C829	a_353_93##7	a_867_82##11	1.63232e-19
C830	a_2133_410##4	VGND#13	2.11529e-17
C831	SCD#1	SCE#5	3.05192e-17
C832	a_662_82##3	a_977_243#	1.75861e-17
C833	a_197_119##2	a_662_82#	6.40444e-20
C834	a_1954_119#	RESET_B#3	1.17239e-19
C835	a_1579_258##2	a_1159_497#	8.69817e-20
C836	a_1434_78##2	a_662_82##2	9.76184e-20
C837	CLK_N#6	a_662_82##10	1.75305e-17
C838	RESET_B#4	a_2133_410##9	4.43854e-19
C839	VPWR#24	D#3	2.72378e-20
C840	a_662_82##5	SET_B#3	2.37305e-19
C841	VGND#5	SET_B#5	3.58642e-19
C842	a_977_243##9	a_977_243##4	1.85078e-19
C843	a_197_119##6	a_353_93#	6.96402e-18
C844	SET_B#8	a_1954_119##7	9.57551e-18
C845	a_197_119##6	a_353_93##4	2.85028e-17
C846	a_3078_384##5	a_2133_410##6	9.20216e-20
C847	a_1159_497##5	a_867_82##3	3.82613e-17
C848	a_1954_119##5	a_867_82##7	5.55523e-17
C849	a_1954_119#	a_1954_119##4	1.25561e-17
C850	VPWR#4	a_2133_410##7	2.67467e-17
C851	a_2133_410##12	a_1954_119##4	6.96095e-17
C852	VPWR#25	SCE#1	5.17284e-20
C853	a_3078_384##5	a_3078_384#	5.70413e-19
C854	a_1159_497##5	a_662_82#	1.38471e-19
C855	a_867_82##10	a_867_82##4	1.0272e-18
C856	a_197_119##4	a_353_93##5	2.52616e-18
C857	a_27_464#	D#3	2.44161e-17
C858	VPWR#13	SCE#5	2.43834e-20
C859	a_3078_384##7	a_2133_410##4	4.52541e-17
C860	a_1579_258##6	a_1954_119##3	2.0646e-17
C861	a_1159_497##3	a_1159_497#	6.80164e-19
C862	a_197_119##2	a_662_82##2	1.9593e-17
C863	a_1954_119#	a_1579_258##4	2.97899e-17
C864	a_977_243##8	a_977_243##4	2.66551e-18
C865	a_1579_258##7	a_1579_258##4	3.21912e-19
C866	a_867_82##10	a_867_82##9	2.20097e-18
C867	a_867_82##12	a_662_82#	7.19293e-18
C868	VGND#11	a_353_93##2	1.70459e-19
C869	VPWR#5	VPWR#18	6.01079e-18
C870	VGND#8	a_977_243#	6.02219e-19
C871	VGND#14	a_3078_384##3	3.35556e-19
C872	VGND	VGND#8	2.61837e-17
C873	VGND#13	a_2133_410##9	6.07276e-19
C874	a_867_82##16	VPWR#21	1.73947e-18
C875	VGND	VGND#7	1.62128e-16
C876	a_197_119##6	D#3	2.90162e-17
C877	VGND	VGND#5	1.41006e-16
C878	SET_B#8	VPWR#20	4.89093e-18
C879	D	a_353_93##4	1.73136e-18
C880	a_1954_119#	SET_B#6	1.75183e-18
C881	VGND	VGND#4	1.58514e-17
C882	a_1954_119##7	VPWR#7	1.91312e-17
C883	VPWR#25	a_353_93##4	2.35027e-19
C884	VGND#11	a_662_82##4	1.86309e-19
C885	a_2133_410##10	a_1579_258##9	5.76069e-17
C886	a_2133_410##5	a_3078_384##2	3.61582e-17
C887	a_1159_497##3	a_662_82##2	1.98639e-19
C888	VPWR#5	RESET_B#3	4.37987e-19
C889	a_2133_410##12	a_1579_258##4	2.37819e-17
C890	a_1159_497##5	a_662_82##2	1.42637e-17
C891	VGND#10	D#2	1.32624e-20
C892	a_27_464#	SCE#5	9.28558e-18
C893	Q_N#1	a_2133_410##4	1.53383e-18
C894	a_3078_384##2	VPWR#16	1.77768e-17
C895	a_1579_258##9	a_1579_258##8	1.64139e-18
C896	VGND#8	a_662_82##3	6.6252e-17
C897	a_1954_119##5	a_2133_410##2	5.32697e-19
C898	a_977_243##9	SET_B#3	3.53801e-18
C899	VGND#11	a_197_119##4	3.72811e-17
C900	a_2133_410##14	VPWR#6	2.77597e-17
C901	a_662_82##10	a_867_82##9	9.53225e-18
C902	VPWR	a_2133_410##12	2.87758e-17
C903	VGND#5	a_867_82##7	1.18802e-19
C904	a_27_464##2	a_353_93##4	1.56188e-18
C905	a_662_82##4	a_662_82##3	1.63279e-19
C906	a_197_119##2	a_977_243#	3.36408e-17
C907	VPWR	a_2133_410##14	2.36187e-17
C908	a_3078_384##7	a_2133_410##9	8.67085e-19
C909	a_197_119##6	SCE#4	1.65307e-18
C910	VGND	a_1579_258##9	4.5343e-17
C911	a_197_119##4	VPWR#24	2.93834e-18
C912	VGND	a_1579_258##8	1.53919e-18
C913	a_197_119##6	SCE#5	2.4395e-18
C914	SET_B#5	a_1579_258##4	5.14413e-18
C915	VPWR#4	RESET_B#3	2.92651e-17
C916	VGND	a_1954_119##6	4.10634e-18
C917	a_867_82##16	a_977_243##10	5.81966e-19
C918	VGND#9	a_662_82##4	2.59607e-17
C919	a_353_93##7	a_662_82##11	2.57979e-17
C920	VPWR	a_1954_119##7	2.09714e-17
C921	SET_B#8	VPWR#21	2.83848e-18
C922	a_3078_384##5	a_2133_410##8	6.87901e-19
C923	a_867_82##4	a_662_82##2	2.8607e-17
C924	VPWR#25	D#3	1.83726e-18
C925	a_977_243##8	SET_B#3	3.92907e-17
C926	a_867_82##12	a_662_82##8	4.06665e-19
C927	SET_B#4	a_1579_258##6	3.77682e-17
C928	VPWR#13	SCD#1	5.55591e-20
C929	VPWR	a_977_243##10	3.58562e-17
C930	a_2133_410##14	a_1954_119##4	3.85503e-19
C931	VPWR#12	D	1.37536e-18
C932	VGND#14	a_2133_410##4	9.40613e-19
C933	D#2	a_353_93##4	6.3446e-18
C934	VPWR	a_197_119#	7.26266e-18
C935	a_27_464#	SCD#1	1.2095e-18
C936	VPWR#12	a_977_243##3	2.71783e-18
C937	VGND#10	D	1.87362e-18
C938	a_197_119##5	SCE#8	4.24921e-17
C939	a_2133_410##12	SET_B#6	1.12175e-18
C940	VPWR#25	SCE#4	5.70455e-19
C941	a_2133_410##10	a_1579_258##8	4.52048e-17
C942	VPWR#5	VPWR#4	5.65679e-19
C943	Q	a_3078_384#	2.4817e-17
C944	a_2133_410##14	VPWR#5	4.74161e-17
C945	a_27_464##2	D#3	5.68558e-18
C946	a_1579_258##4	VPWR#18	2.19905e-17
C947	Q	a_2133_410##8	2.02499e-18
C948	VPWR#5	a_1579_258##5	2.7961e-19
C949	VGND#11	D#2	7.48178e-19
C950	Q_N#1	a_2133_410##9	1.73496e-17
C951	Q	a_2133_410##7	1.66934e-19
C952	VGND#8	a_662_82##4	1.17201e-17
C953	a_27_464##2	SCE#4	3.85964e-17
C954	a_197_119##6	SCD#2	9.83194e-19
C955	VPWR#12	a_662_82##8	2.63411e-18
C956	a_1579_258##9	a_2392_74##2	6.62006e-17
C957	a_2133_410##8	a_3078_384#	3.46607e-17
C958	a_867_82##2	a_662_82##2	4.67445e-18
C959	a_2133_410##2	a_1954_119##4	2.40126e-19
C960	VGND#17	a_662_82##2	2.86305e-18
C961	VGND	a_2392_74#	2.03099e-17
C962	VPWR#5	a_1954_119##4	7.01324e-18
C963	SCE#5	VPWR#25	1.65733e-17
C964	VGND#9	a_197_119##4	5.86069e-17
C965	VGND	a_2133_410##10	1.10496e-17
C966	a_977_243##9	a_1579_258##3	4.09103e-17
C967	a_197_119##2	a_662_82##4	8.8529e-18
C968	VGND	a_2392_74##2	2.39606e-17
C969	a_197_119##4	a_662_82##7	2.38479e-19
C970	a_662_82##10	VPWR#23	2.26984e-17
C971	VGND	a_1954_119##5	1.23352e-17
C972	a_977_243#	a_867_82##2	2.25855e-17
C973	VGND	a_1434_78#	2.54737e-17
C974	VPWR#12	CLK_N#1	9.93844e-19
C975	a_2133_410##14	a_2133_410##12	1.45473e-18
C976	VGND	a_977_243##13	8.70105e-18
C977	a_2133_410##2	a_1579_258##4	3.14292e-19
C978	VPWR#6	VPWR#19	3.49315e-18
C979	VGND	a_1434_78##2	3.2197e-17
C980	a_867_82##10	a_977_243##2	3.46894e-17
C981	VPWR	a_662_82##5	1.06906e-18
C982	VGND	a_197_119##2	1.79001e-17
C983	a_2133_410##14	a_1579_258##4	1.08829e-18
C984	a_1579_258##8	a_2133_410##9	7.49512e-19
C985	a_197_119##4	a_27_464#	1.94454e-18
C986	a_2133_410##6	a_2133_410##5	6.00811e-19
C987	Q_N#2	a_2133_410##6	8.81149e-17
C988	SET_B#8	a_197_119#	2.86492e-18
C989	a_2133_410##7	a_3078_384#	4.65352e-19
C990	VGND#5	a_2133_410##2	7.64298e-20
C991	a_27_464##2	SCE#5	1.17297e-17
C992	a_867_82##9	VPWR#22	3.68019e-17
C993	VGND#7	a_662_82##3	1.7713e-17
C994	VGND#14	a_2133_410##9	3.79773e-17
C995	a_977_243##2	a_662_82##2	5.7802e-19
C996	a_662_82##10	a_977_243##2	1.32059e-18
C997	a_27_464##2	SCD#2	4.2243e-17
C998	a_977_243##8	a_1579_258##3	1.79064e-18
C999	a_662_82##3	a_977_243##2	8.73102e-20
C1000	a_2133_410##2	SET_B#6	1.40059e-17
C1001	VPWR#4	a_1954_119##4	3.18501e-18
C1002	a_3078_384##5	a_2133_410##7	3.36471e-20
C1003	VPWR#12	SCE#1	6.69106e-19
C1004	SET_B#6	VPWR#18	2.56968e-17
C1005	VGND#9	CLK_N#3	8.849e-18
C1006	a_2133_410##6	a_1954_119##2	4.78889e-19
C1007	a_2133_410##6	VPWR#17	3.0442e-18
C1008	VGND#5	a_1954_119##2	1.85804e-20
C1009	VPWR#25	SCD#1	3.46389e-17
C1010	a_2133_410#	SET_B#4	2.04269e-17
C1011	a_977_243#	a_977_243##2	6.13409e-18
C1012	SCE#8	a_353_93##2	6.75523e-19
C1013	a_2133_410##5	VNB	4.89704e-17
C1014	a_1954_119##2	VNB	6.25397e-17
C1015	a_662_82##3	VNB	1.82428e-16
C1016	a_1159_497##2	VNB	2.44636e-17
C1017	a_353_93##2	VNB	4.5265e-17
C1018	D#2	VNB	4.73953e-17
C1019	a_2133_410##6	RESET_B#4	4.35368e-17
C1020	a_2133_410##2	a_2133_410##3	1.46222e-17
C1021	VPWR#6	a_1579_258##4	3.10824e-19
C1022	Q_N#1	RESET_B#1	5.11588e-19
C1023	VGND	a_1954_119##7	2.43121e-18
C1024	VPWR#3	Q	2.10545e-17
C1025	a_1579_258##8	a_2392_74##2	8.98054e-22
C1026	VGND#17	a_977_243#	4.62757e-17
C1027	VGND#3	Q	1.72819e-18
C1028	a_3078_384##5	Q#3	6.58856e-19
C1029	VPWR#12	a_353_93##4	1.60941e-18
C1030	a_1954_119##5	a_2164_119#	5.99758e-19
C1031	a_2133_410##7	a_2133_410##8	6.82043e-18
C1032	VPWR	a_1579_258##4	9.1439e-19
C1033	a_197_119##2	CLK_N#3	3.64032e-19
C1034	a_662_82##4	a_977_243##2	3.31962e-18
C1035	a_2133_410##6	a_1579_258##7	1.68421e-17
C1036	D	SCE#4	1.13072e-18
C1037	a_2133_410##14	SET_B#6	4.86351e-17
C1038	a_1579_258##9	VGND#15	9.17355e-18
C1039	VPWR#5	SET_B#5	4.39942e-20
C1040	VPWR	a_867_82##5	1.10205e-18
C1041	VGND#13	Q#3	5.77144e-17
C1042	a_27_464##2	SCD#1	2.7485e-17
C1043	a_662_82##6	a_2133_410##2	4.21249e-17
C1044	VPWR#23	VPWR#22	6.78048e-19
C1045	VGND#8	CLK_N#3	3.72633e-19
C1046	VGND#11	VNB	4.70938e-17
C1047	a_977_243##9	a_1159_497##4	8.82082e-18
C1048	VGND#9	VNB	3.39424e-17
C1049	a_662_82##10	a_662_82##12	3.63339e-19
C1050	VGND#8	VNB	6.07361e-17
C1051	a_1579_258##9	a_1954_119##6	7.37123e-17
C1052	a_977_243##10	a_1528_424#	7.56091e-19
C1053	VGND#7	VNB	6.22253e-17
C1054	VPWR#12	D#3	1.66687e-18
C1055	VGND#5	VNB	7.68646e-17
C1056	a_197_119##4	CLK_N#2	1.13011e-18
C1057	VGND#4	VNB	5.88855e-17
C1058	a_3078_384##2	Q	2.07788e-17
C1059	VPWR#13	VNB	4.12995e-17
C1060	VPWR#11	VNB	2.63573e-17
C1061	VPWR#5	a_1579_258##4	1.3437e-17
C1062	a_2133_410##12	a_2133_410##6	2.2598e-18
C1063	VPWR#10	VNB	6.70086e-17
C1064	VPWR#9	VNB	6.11161e-17
C1065	VPWR#8	VNB	3.22642e-17
C1066	a_867_82##10	a_662_82##7	1.02743e-17
C1067	VPWR#6	VNB	3.54888e-17
C1068	VPWR#5	VNB	5.05453e-17
C1069	VPWR#25	VPWR#13	5.04004e-20
C1070	VPWR#4	VNB	5.65761e-17
C1071	VGND	a_1954_119##3	2.73248e-18
C1072	VGND	a_1579_258##6	1.39041e-18
C1073	a_2133_410##2	a_867_82##5	1.44915e-18
C1074	VGND	SET_B#4	2.03624e-18
C1075	a_3078_384##5	VNB	3.97969e-18
C1076	VGND#11	SCE#2	3.94032e-17
C1077	a_197_119##4	a_197_119##6	3.09913e-18
C1078	VGND	a_2133_410#	8.51551e-18
C1079	a_867_82##11	a_977_243#	3.65773e-19
C1080	VGND	a_867_82##8	1.66857e-21
C1081	RESET_B#1	VGND#14	1.25187e-17
C1082	a_1579_258##8	RESET_B#1	2.76371e-18
C1083	VGND	a_977_243##6	4.38436e-18
C1084	RESET_B#4	VNB	1.8776e-18
C1085	VGND	SET_B#1	1.45305e-18
C1086	a_1579_258##9	a_1954_119##2	8.19593e-18
C1087	a_662_82##4	a_662_82##7	8.4418e-19
C1088	a_1579_258##9	VNB	3.32322e-17
C1089	VPWR#24	SCE#2	1.71117e-19
C1090	a_1579_258##8	VNB	1.12576e-17
C1091	VPWR#12	SCE#5	5.12118e-19
C1092	a_662_82##10	a_662_82##7	2.08164e-17
C1093	a_867_82##6	a_662_82##6	2.39794e-17
C1094	a_1954_119##6	VNB	8.64656e-18
C1095	a_1954_119##6	VPWR#6	2.49409e-19
C1096	VGND#7	a_1434_78#	5.42699e-17
C1097	a_977_243##8	VNB	1.3119e-17
C1098	a_197_119##4	VNB	2.53425e-17
C1099	a_867_82##16	VPWR	1.28794e-17
C1100	SET_B#8	VPWR	4.49543e-17
C1101	a_867_82##10	VNB	6.5361e-18
C1102	VGND#17	a_662_82##4	1.72162e-18
C1103	a_662_82##10	VNB	4.0572e-18
C1104	a_2392_74#	a_2133_410##9	5.39634e-19
C1105	VPWR	VPWR#7	4.92108e-17
C1106	CLK_N#3	a_662_82##7	1.20136e-19
C1107	SCE#8	D#2	1.24182e-17
C1108	CLK_N#6	VNB	4.01243e-18
C1109	a_1579_258##7	RESET_B#2	1.63926e-17
C1110	VPWR#4	a_1579_258##4	4.22279e-19
C1111	a_2133_410##14	VPWR#18	6.46694e-18
C1112	SCE#8	VNB	1.36007e-18
C1113	a_867_82##12	VPWR	1.43171e-17
C1114	a_2133_410##14	a_2133_410##3	1.34656e-18
C1115	VPWR#23	a_867_82##9	5.35492e-17
C1116	VGND#3	VGND#4	9.03144e-17
C1117	SCD#4	VNB	2.88275e-17
C1118	Q#3	VNB	5.14011e-17
C1119	VPWR#12	SCD#1	1.52295e-18
C1120	VGND#13	VNB	5.80439e-18
C1121	a_3078_384##7	VNB	2.43437e-18
C1122	Q_N#1	VNB	1.66286e-17
C1123	a_867_82##8	a_2133_410#	1.69393e-17
C1124	VGND#14	VNB	2.18278e-18
C1125	RESET_B#3	a_2133_410##7	1.9945e-17
C1126	a_662_82##5	SET_B#4	2.20805e-19
C1127	a_1579_258##11	VNB	1.42755e-19
C1128	a_2392_74#	VNB	5.40165e-18
C1129	VGND#9	SCE#2	1.10976e-18
C1130	a_2133_410##10	VNB	1.72509e-17
C1131	a_2392_74##2	VNB	3.25604e-18
C1132	RESET_B#4	RESET_B#2	6.89325e-18
C1133	a_1579_258##9	a_1954_119##3	1.39344e-17
C1134	a_1954_119##5	VNB	2.60102e-19
C1135	VPWR	a_1954_119#	1.0474e-17
C1136	VGND#16	VNB	2.16575e-18
C1137	a_1434_78#	VNB	1.12171e-17
C1138	a_977_243##5	a_662_82##6	7.7632e-20
C1139	CLK_N#6	a_662_82##7	4.45406e-19
C1140	a_977_243##13	VNB	1.49185e-18
C1141	a_1434_78##2	VNB	1.32008e-17
C1142	a_197_119##2	VNB	3.70228e-17
C1143	VPWR#6	SET_B#6	2.12585e-18
C1144	RESET_B#1	a_1579_258##11	9.29909e-18
C1145	VGND#3	Q#3	2.09055e-17
C1146	a_1579_258##8	a_2133_410##6	3.73598e-18
C1147	RESET_B#2	a_2133_410##12	2.57265e-18
C1148	VGND#17	VNB	7.25872e-18
C1149	a_3078_384##5	VGND#13	6.49599e-18
C1150	a_867_82##11	VNB	4.29324e-18
C1151	a_867_82##16	SET_B#8	1.91883e-16
C1152	a_662_82##11	VNB	9.33848e-18
C1153	a_353_93##7	VNB	3.28098e-18
C1154	VPWR	a_2133_410##2	5.63421e-18
C1155	VGND#19	VNB	5.38644e-18
C1156	a_197_119##5	VNB	2.52122e-18
C1157	a_197_119##4	a_662_82##4	3.90056e-17
C1158	VGND#12	VNB	7.81117e-17
C1159	a_1954_119##2	RESET_B#2	8.06156e-18
C1160	a_867_82##12	a_977_243##10	6.49877e-18
C1161	Q#1	VNB	1.98209e-17
C1162	VPWR	a_977_243##5	2.49239e-18
C1163	VPWR#16	VNB	5.20167e-18
C1164	a_3078_384##6	VNB	4.84327e-18
C1165	VGND#16	SET_B#2	9.45624e-19
C1166	VGND#4	a_1954_119##2	1.56418e-19
C1167	Q_N#2	VNB	2.40008e-17
C1168	VPWR	SET_B#2	1.08363e-18
C1169	a_1579_258##7	VNB	3.4303e-18
C1170	a_1954_119#	VPWR#17	3.59814e-21
C1171	a_2133_410##12	VNB	1.30113e-17
C1172	VPWR	a_1579_258##2	2.19643e-18
C1173	a_977_243##9	a_662_82#	7.1601e-20
C1174	a_867_82##11	a_662_82##4	2.55969e-17
C1175	a_2133_410##14	VNB	4.33272e-18
C1176	VPWR	a_1159_497##3	2.2395e-18
C1177	a_977_243##5	a_867_82##5	3.43792e-18
C1178	a_2133_410##3	VPWR#19	8.85346e-18
C1179	a_197_119##4	a_353_93#	3.80051e-17
C1180	a_1954_119##7	VNB	4.414e-18
C1181	VPWR#20	VNB	5.47142e-18
C1182	VPWR#21	VNB	2.91397e-18
C1183	a_867_82##10	CLK_N#2	5.29166e-20
C1184	a_977_243##10	VNB	1.82749e-17
C1185	VGND#14	a_1954_119##3	6.67192e-19
C1186	a_197_119#	VNB	5.38619e-18
C1187	VGND	a_867_82##16	4.576e-17
C1188	a_1159_497##7	VNB	1.9832e-18
C1189	VGND	SET_B#8	1.39859e-19
C1190	VPWR#22	VNB	1.84606e-18
C1191	a_867_82##9	VNB	9.87316e-18
C1192	VPWR#23	VNB	4.84045e-19
C1193	a_662_82##12	VNB	9.10225e-18
C1194	VGND	VGND#6	7.09169e-17
C1195	a_867_82##16	VPWR#7	1.3973e-18
C1196	a_353_93##5	VNB	1.4628e-17
C1197	VPWR#24	VNB	9.47815e-18
C1198	VGND	a_867_82##12	1.39934e-17
C1199	a_1434_78#	SET_B#2	1.82437e-19
C1200	a_1954_119##7	SET_B#6	2.6429e-19
C1201	a_27_464#	VNB	1.56811e-17
C1202	a_197_119##6	VNB	6.96867e-18
C1203	a_662_82##5	a_2133_410#	5.55488e-19
C1204	VPWR#25	VNB	3.16575e-18
C1205	a_662_82##12	a_867_82##9	2.64492e-18
C1206	SCE#2	CLK_N#2	2.11002e-17
C1207	a_867_82##12	a_197_119#	5.72582e-18
C1208	a_27_464##2	VNB	6.0028e-17
C1209	VPWR#5	SET_B#6	1.1118e-17
C1210	a_3078_384##3	VNB	3.22764e-17
C1211	a_2133_410##4	VNB	3.65269e-17
C1212	a_1954_119#	a_1579_258##7	3.45061e-17
C1213	CLK_N#6	a_662_82##12	2.95572e-17
C1214	a_2133_410##9	VNB	3.07738e-17
C1215	a_977_243##5	a_977_243##4	1.00501e-17
C1216	RESET_B#1	VNB	2.78946e-17
C1217	a_1954_119##3	VNB	3.81531e-17
C1218	a_2133_410##14	a_662_82##6	4.31326e-19
C1219	a_1579_258##6	VNB	2.73755e-17
C1220	VGND#17	CLK_N#3	3.54382e-19
C1221	CLK_N#2	a_662_82##10	3.3146e-17
C1222	a_1579_258##2	a_1954_119##5	6.07014e-17
C1223	a_1579_258##8	a_1954_119##3	3.67877e-20
C1224	SET_B#4	VNB	3.37179e-17
C1225	VGND	a_1954_119#	4.95355e-18
C1226	a_353_93#	a_662_82##4	2.54689e-20
C1227	a_2133_410#	VNB	5.30797e-17
C1228	a_867_82##8	VNB	2.92519e-17
C1229	VGND	a_1579_258##5	3.98495e-19
C1230	a_662_82##5	VNB	1.77222e-16
C1231	a_977_243##6	VNB	2.9278e-17
C1232	VGND	SET_B#5	3.17765e-18
C1233	SET_B#1	VNB	2.76959e-17
C1234	a_1579_258#	VNB	2.36183e-17
C1235	VGND	a_867_82##7	4.28792e-18
C1236	a_1159_497#	VNB	2.49832e-17
C1237	a_2392_74#	RESET_B#1	2.07258e-19
C1238	a_867_82##3	VNB	2.42437e-17
C1239	a_977_243##8	a_1954_119##7	3.10872e-18
C1240	a_662_82##2	VNB	3.88282e-17
C1241	a_977_243#	VNB	6.24845e-17
C1242	a_662_82##4	VNB	8.36774e-17
C1243	VGND#11	a_353_93##3	1.52943e-18
C1244	CLK_N#3	VNB	3.88963e-17
C1245	VGND	a_977_243##5	1.31407e-18
C1246	SCE#2	VNB	1.3198e-16
C1247	a_1954_119##7	VPWR#6	1.83721e-18
C1248	a_977_243##13	SET_B#2	9.33634e-19
C1249	a_353_93##3	VNB	3.40779e-17
C1250	VGND	SET_B#2	1.88852e-18
C1251	D#4	VNB	2.03951e-17
C1252	VGND#7	a_977_243##5	1.14569e-19
C1253	SCE#3	VNB	8.61344e-17
C1254	VGND	a_1579_258##2	2.95128e-17
C1255	SCD#3	VNB	2.5907e-17
C1256	VGND	a_1159_497##3	4.53192e-18
C1257	VGND#3	a_3078_384##7	2.57695e-17
C1258	SET_B#8	VPWR#7	1.57217e-18
C1259	a_3078_384#	VNB	4.42509e-17
C1260	a_867_82##10	a_662_82##2	2.12408e-19
C1261	a_867_82##16	VGND#6	1.37149e-18
C1262	a_2133_410##8	VNB	4.663e-17
C1263	a_662_82##4	VGND#18	1.09154e-17
C1264	a_2133_410##7	VNB	3.91445e-17
C1265	a_353_93#	CLK_N#3	8.87444e-20
C1266	a_977_243##5	SET_B#3	4.75485e-19
C1267	VPWR#8	a_2133_410##3	2.26109e-19
C1268	RESET_B#3	VNB	6.92155e-17
C1269	a_197_119##4	a_353_93##2	1.84287e-17
C1270	a_1954_119##4	VNB	3.14351e-17
C1271	a_1954_119#	a_2133_410##12	1.19406e-16
C1272	a_867_82##12	a_1159_497##7	1.79438e-17
C1273	a_1579_258##4	VNB	4.208e-17
C1274	SET_B#6	VNB	4.14286e-17
C1275	a_2133_410##3	VNB	2.91034e-17
C1276	a_662_82##6	VNB	5.24843e-17
C1277	a_1954_119##4	RESET_B#3	5.53949e-18
C1278	a_1579_258##9	RESET_B#2	1.73738e-19
C1279	a_867_82##5	VNB	2.70115e-17
C1280	VPWR#12	a_977_243##10	2.95542e-17
C1281	a_977_243##4	VNB	2.92637e-17
C1282	SET_B#3	VNB	4.34494e-17
C1283	a_1579_258##3	VNB	3.56733e-17
C1284	a_1159_497##4	VNB	4.41298e-17
C1285	a_662_82#	VNB	6.05325e-17
C1286	a_867_82#	VNB	3.03161e-17
C1287	a_977_243##3	VNB	2.9325e-17
C1288	a_662_82##8	VNB	4.16244e-17
C1289	CLK_N#1	VNB	3.46379e-17
C1290	VPWR#4	SET_B#6	2.66932e-19
C1291	a_1579_258##11	a_1954_119##3	1.25196e-18
C1292	SCE#1	VNB	7.31412e-17
C1293	a_353_93##4	VNB	5.38592e-17
C1294	a_3078_384##7	VGND#13	5.17128e-17
C1295	D#3	VNB	3.25069e-17
C1296	a_1579_258##8	a_1954_119##2	8.26785e-18
C1297	SCE#5	VNB	2.76526e-17
C1298	SCD#1	VNB	3.51577e-17
C1299	CLK_N#6	CLK_N#2	9.54082e-18
C1300	a_353_93#	SCE#2	3.67559e-17
C1301	VPWR#3	VNB	2.0257e-16
C1302	VGND#3	VNB	2.06548e-16
C1303	a_662_82##5	a_867_82##8	2.05211e-18
C1304	a_867_82##16	VNB	6.33903e-18
C1305	SET_B#8	VNB	9.64554e-18
C1306	VGND#16	a_1579_258##2	7.54531e-17
C1307	a_1579_258##9	a_1579_258##6	4.47497e-18
C1308	VPWR#7	VNB	2.49476e-17
C1309	VGND#6	VNB	3.93532e-17
C1310	a_867_82##11	CLK_N#3	2.72305e-20
C1311	a_867_82##12	VNB	8.20639e-18
C1312	VPWR#12	VNB	3.34234e-16
C1313	VGND#3	Q_N#1	4.37571e-17
C1314	VGND#10	VNB	3.16986e-16
C1315	a_3078_384##2	VNB	4.3029e-17
C1316	a_2133_410##6	VNB	5.80395e-17
C1317	RESET_B#2	VNB	4.30332e-17
C1318	a_662_82##12	VPWR#23	5.21257e-17
C1319	a_1579_258##8	RESET_B#2	1.81659e-17
C1320	a_1954_119#	VNB	1.26701e-17
C1321	a_867_82##10	a_867_82##12	3.78772e-18
C1322	a_1579_258##5	VNB	3.10343e-17
C1323	a_1954_119##7	a_2133_410##3	3.54128e-18
C1324	SET_B#5	VNB	4.1726e-17
C1325	VPWR#12	a_197_119#	3.51531e-18
C1326	a_197_119##4	CLK_N#3	3.11201e-17
C1327	a_867_82##7	VNB	3.88234e-17
C1328	a_2133_410##2	VNB	6.08835e-17
C1329	a_2133_410##2	VPWR#6	2.53774e-17
C1330	a_867_82##6	VNB	2.68416e-17
C1331	a_197_119##6	a_353_93##3	6.29647e-19
C1332	a_977_243##5	VNB	3.20472e-17
C1333	a_662_82##3	a_1159_497##2	4.27337e-19
C1334	VPWR#3	a_3078_384##2	3.83621e-18
C1335	SET_B#2	VNB	4.5233e-17
C1336	a_1579_258##2	VNB	7.03783e-17
C1337	VPWR#6	a_2133_410##3	1.4898e-17
C1338	a_2133_410##10	RESET_B#1	2.05314e-18
C1339	a_2133_410##14	VPWR#19	1.00931e-18
C1340	a_1159_497##3	VNB	7.11809e-17
C1341	a_867_82##4	VNB	5.35588e-17
C1342	a_867_82##2	VNB	4.3312e-17
C1343	SCE#2	a_353_93##2	1.43888e-18
C1344	VGND#8	a_1434_78##2	1.0129e-17
C1345	a_977_243##2	VNB	1.0167e-16
C1346	VGND#14	a_1579_258##6	4.66405e-20
C1347	a_1579_258##9	a_1954_119##5	8.01223e-17
C1348	a_662_82##7	VNB	3.97206e-17
C1349	a_2133_410##14	a_867_82##5	1.16466e-19
C1350	CLK_N#2	VNB	4.88973e-17
C1351	a_353_93#	VNB	4.82853e-17
C1352	a_1434_78#	a_1579_258##2	4.38607e-17
C1353	VGND#3	a_3078_384##3	2.33705e-18
C1354	SCE#4	VNB	5.79708e-17
C1355	SCD#2	VNB	9.74031e-17
C1356	a_1954_119#	VPWR#18	6.53269e-18
C1357	a_197_119##5	VGND#19	1.85937e-17
C1358	VGND#3	VGND#14	1.55583e-17
C1359	a_867_82##12	a_662_82##10	2.55026e-18
C1360	VPWR#12	a_1159_497##7	4.56577e-18
C1361	VGND#3	a_3078_384##2	4.37465e-18
C1362	a_1434_78#	VGND#16	4.99816e-17
C1363	a_2392_74#	a_1954_119##3	3.55374e-17
C1364	a_353_93#	a_662_82##10	3.93764e-18
C1365	a_977_243##13	a_1579_258##2	4.67506e-17
C1366	a_2133_410##6	VPWR#3	7.58864e-18
C1367	D	VNB	4.38366e-18
C1368	CLK_N#3	VGND#18	1.85304e-17
C1369	VGND#10	a_197_119##4	1.1468e-16
C1370	a_1954_119#	a_1954_119##2	2.96912e-17
C1371	a_867_82##16	VGND#7	3.0167e-18
C1372	a_3078_384##5	a_2133_410##5	4.89951e-17
C1373	a_1579_258##2	SET_B#3	1.02002e-17
C1374	Q	VNB	5.10778e-17
C1375	a_1579_258##8	a_1579_258##6	9.40247e-21
C1376	VPWR	VNB	2.32254e-16
C1377	VGND#9	a_197_119##2	9.97012e-19
C1378	a_1954_119#	a_2133_410##14	3.16757e-17
C1379	VPWR#5	a_2133_410##3	6.09321e-19
C1380	VGND	VNB	2.51988e-16
C1381	a_1954_119##6	SET_B	8.81447e-17
C1382	SET_B	a_2133_410##2	2.44141e-17
C1383	SET_B	VGND#5	2.24235e-18
C1384	VPWR#14	SCD#1	9.6e-19
C1385	a_27_464#	VPWR#14	4.56167e-17
C1386	VPWR#14	D#2	2.61927e-20
C1387	VGND#3	VGND#2	1.00635e-16
C1388	VPWR#14	VNB	6.16966e-17
C1389	VPWR#2	a_3078_384#	8.51278e-18
C1390	SET_B	VPWR#6	5.53604e-18
C1391	SET_B	a_867_82##7	8.54763e-18
C1392	VPWR#14	D#3	4.39478e-18
C1393	VPWR#3	VPWR#2	9.98967e-17
C1394	SET_B	VPWR#7	1.96709e-18
C1395	VGND#2	VNB	5.01179e-17
C1396	a_3078_384##6	VPWR#2	3.71749e-18
C1397	VPWR#4	VPWR#2	1.34684e-19
C1398	SET_B	a_1954_119##2	9.1023e-21
C1399	SET_B	VNB	1.03313e-17
C1400	SET_B	SET_B#5	1.54778e-19
C1401	SET_B	a_662_82##6	5.34031e-19
C1402	SET_B	a_1954_119##5	5.43478e-18
C1403	VPWR#14	VPWR#13	2.23905e-19
C1404	SET_B	a_1579_258##9	1.25518e-17
C1405	SET_B	a_1954_119##7	3.04318e-17
C1406	SET_B	a_867_82##16	3.6416e-18
C1407	VGND#14	VGND#2	2.0927e-20
C1408	VPWR#2	a_2133_410##7	3.98588e-19
C1409	VGND#2	a_2133_410##4	7.83718e-18
C1410	a_3078_384##5	VPWR#2	1.96002e-19
C1411	SET_B	a_1954_119#	1.11551e-17
C1412	SET_B	SET_B#6	1.02887e-17
C1413	SET_B	VGND#15	2.81695e-20
C1414	VGND#2	a_3078_384##7	8.69609e-18
C1415	VGND#2	a_3078_384##5	2.77032e-19
C1416	SET_B	a_1579_258##4	4.16749e-18
C1417	a_3078_384##2	VPWR#2	2.90636e-19
C1418	VGND#4	VGND#2	5.40202e-19
C1419	VPWR	SET_B	4.08535e-17
C1420	VPWR#14	SCE#5	9.66079e-19
C1421	VGND#2	a_2133_410##5	6.63103e-20
C1422	SET_B	a_2133_410##14	6.27825e-18
C1423	SET_B	a_1954_119##4	7.21824e-19
C1424	VGND#2	Q#3	2.33152e-17
C1425	VPWR#14	SCD#2	6.79621e-20
C1426	VPWR#2	a_2133_410##5	3.74349e-20
C1427	VPWR#2	a_2133_410##8	4.12184e-18
C1428	VPWR#2	VNB	4.93279e-17
C1429	VPWR#12	VPWR#14	1.03151e-16
C1430	VGND#2	a_2133_410##9	3.67633e-19
C1431	SET_B	a_2133_410##12	1.31396e-18
C1432	Q	VPWR#2	2.23608e-17
C1433	VGND#2	a_3078_384##3	7.45805e-18
C1434	a_27_464##2	VPWR#14	1.94259e-17
C1435	VGND#2	a_3078_384##2	5.44344e-19
C1436	SET_B	VPWR#5	1.51611e-18
*
*
.ENDS sky130_fd_sc_hs__sdfbbn_1
*
