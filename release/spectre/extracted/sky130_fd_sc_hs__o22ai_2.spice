* Extracted by Quantus, converted by sky130cad/quantus.py
*
*
*
*                       LINUX           Wed Nov 18 08:58:58 2026
*
*
*
*  PROGRAM  advgen
*
*  Name           : advgen - Quantus - (64-bit)
*  Version        : 25.1.0-p047
*  Build Date     : Thu Dec 11 23:20:30 PST 2025
*
*  HSPICE LIBRARY
*
*  OPERATING_TEMPERATURE 150
*  QRC_TECH_DIR <path>/tech
*
*
*

*
.SUBCKT sky130_fd_sc_hs__o22ai_2 VNB VPB VGND VPWR Y A2 B1 B2 A1
*
*
*  caps2d version: 10
*
*
*       TRANSISTOR CARDS
*
*
XM6 Y#4 B1#5 a_27_74##6 VNB sky130_fd_pr__nfet_01v8_lvt l=0.15 w=0.74 ad=0.2812 as=0.2109 pd=2.24 ps=2.05
XM14 a_27_74##8 B1#1 Y#4 VNB sky130_fd_pr__nfet_01v8_lvt l=0.15 w=0.74 ad=0.2368 as=0.2812 pd=2.12 ps=2.24
XM5 Y#6 B2#7 a_27_74##8 VNB sky130_fd_pr__nfet_01v8_lvt l=0.15 w=0.74 ad=0.259 as=0.2368 pd=2.18 ps=2.12
XM8 a_27_74##3 B2#1 Y#6 VNB sky130_fd_pr__nfet_01v8_lvt l=0.15 w=0.74 ad=0.5624 as=0.259 pd=3 ps=2.18
XM7 a_27_74##3 A2#5 VGND#6 VNB sky130_fd_pr__nfet_01v8_lvt l=0.15 w=0.74 ad=0.5624 as=0.2368 pd=3 ps=2.12
XM0 VGND#6 A2#1 a_27_74##7 VNB sky130_fd_pr__nfet_01v8_lvt l=0.15 w=0.74 ad=0.2368 as=0.2072 pd=2.12 ps=2.04
XM10 VGND#5 A1#4 a_27_74##7 VNB sky130_fd_pr__nfet_01v8_lvt l=0.15 w=0.74 ad=0.259 as=0.2072 pd=2.18 ps=2.04
XM15 a_27_74# A1#1 VGND#5 VNB sky130_fd_pr__nfet_01v8_lvt l=0.15 w=0.74 ad=0.2109 as=0.259 pd=2.05 ps=2.18
XM1 VPWR#7 B1#7 a_28_368##4 VPB sky130_fd_pr__pfet_01v8 l=0.15 w=1.12 ad=0.392 as=0.3304 pd=2.94 ps=2.83
XM12 a_28_368##2 B1#6 VPWR#7 VPB sky130_fd_pr__pfet_01v8 l=0.15 w=1.12 ad=0.336 as=0.392 pd=2.84 ps=2.94
XM9 a_28_368##2 B2#5 Y#5 VPB sky130_fd_pr__pfet_01v8 l=0.15 w=1.12 ad=0.336 as=0.336 pd=2.84 ps=2.84
XM2 Y#5 B2#6 a_28_368# VPB sky130_fd_pr__pfet_01v8 l=0.15 w=1.12 ad=0.336 as=0.3304 pd=2.84 ps=2.83
XM3 a_510_368##4 A2#6 Y#1 VPB sky130_fd_pr__pfet_01v8 l=0.15 w=1.12 ad=0.3304 as=0.336 pd=2.83 ps=2.84
XM11 Y#1 A2#4 a_510_368##2 VPB sky130_fd_pr__pfet_01v8 l=0.15 w=1.12 ad=0.336 as=0.336 pd=2.84 ps=2.84
XM13 VPWR#6 A1#6 a_510_368##2 VPB sky130_fd_pr__pfet_01v8 l=0.15 w=1.12 ad=0.336 as=0.336 pd=2.84 ps=2.84
XM4 a_510_368# A1#5 VPWR#6 VPB sky130_fd_pr__pfet_01v8 l=0.15 w=1.12 ad=0.3304 as=0.336 pd=2.83 ps=2.84
*
*
*       RESISTOR AND CAP/DIODE CARDS
*
Rg1	B1#1	B1#2	397.555725
Rg2	B1#2	B1#3	32.565670
Rg3	B1#3	B1#4	30.613651
Rg4	B1#4	B1#5	397.555725
Rg5	B1#2	B1#6	449.655212
Rg6	B1#4	B1#7	449.655212
Rg7	B2#1	B2#2	476.383667
Rg8	B2#2	B2#3	50.324913
Rg9	B2#3	B2#4	19.785671
Rg10	B2#4	B2#5	451.667847
Rg11	B2#2	B2#6	416.207306
Rg12	B2#4	B2#7	402.159912
Rg13	A2#1	A2#2	368.862610
Rg14	A2#2	A2#3	55.205994
Rg15	A2#2	A2#4	471.862823
Rg16	A2#3	A2#5	360.425598
Rg17	A2#3	A2#6	468.101959
Rg18	A1#1	A1#2	388.381256
Rg19	A1#2	A1#3	66.050674
Rg20	A1#3	A1#4	397.555725
Rg21	A1#2	A1#5	447.688812
Rg22	A1#3	A1#6	449.655212
Rf1	B1	B1#8	13.599322
Rf2	B1#8	B1	1.069610
Rf3	B2#3	B2	166.137894
Rf4	a_28_368#	a_28_368##3	95.939941
Rf5	a_28_368##3	a_28_368##4	103.917801
Rf6	a_28_368##2	a_28_368##3	5.000000
Rf7	Y#1	Y#2	97.687004
Rf8	Y#2	Y	28.846565
Rf9	Y	Y#3	33.432495
Rf10	Y#3	Y#4	94.672554
Rf11	Y#2	Y#5	54.947945
Rf12	Y#3	Y#6	24.862514
Rf13	A2	A2#3	111.823334
Rf14	a_510_368#	a_510_368##3	107.339569
Rf15	a_510_368##3	a_510_368##4	117.219872
Rf16	a_510_368##2	a_510_368##3	5.000000
Rf17	A1#7	A1	1.310145
Rf18	A1#2	A1#9	81.426544
Rf19	A1#7	A1#9	5.042445
Rf20	A1#10	A1	1.310145
Rf21	A1#9	A1#10	9.626486
Rf22	a_27_74#	a_27_74##2	87.849609
Rf23	a_27_74##2	a_27_74##4	83.730629
Rf24	a_27_74##4	a_27_74##5	74.089600
Rf25	a_27_74##5	a_27_74##6	89.731430
Rf26	a_27_74##2	a_27_74##7	18.783115
Rf27	a_27_74##5	a_27_74##8	24.862514
Rf28	a_27_74##3	a_27_74##4	5.000000
Rf30	VGND#2	VGND#3	70.809914
Rf31	VGND#3	VGND#4	52.571827
Rf32	VGND#2	VGND#5	38.247387
Rf33	VGND#3	VGND#6	36.279022
Rf35	VPWR#2	VPWR#3	117.278862
Rf36	VPWR#3	VPWR#4	121.604546
Rf38	VPWR#2	VPWR#6	38.736572
Rf39	VPWR#4	VPWR#7	31.534731
Rf40	B1#3	B1#8	80.116402
Re1	VPWR#3	VPWR	0.982218
Re2	VGND	VGND#4	0.982254
*
*       CAPACITOR CARDS
*
*
C1	a_510_368##2	VPWR#6	6.59337e-17
C2	VGND	VNB	7.50684e-17
C3	a_27_74#	A1#1	3.09423e-17
C4	VPWR	VNB	7.50381e-17
C5	Y	VNB	1.8679e-18
C6	Y#3	A2#5	3.22666e-19
C7	A2	VNB	3.05494e-18
C8	B1	VNB	3.466e-17
C9	B2	VNB	5.92959e-18
C10	A1	VNB	3.40746e-17
C11	A2#3	VNB	5.21543e-17
C12	A1#2	VNB	5.71131e-17
C13	VGND#4	VNB	2.97713e-16
C14	VGND	A2	2.43675e-18
C15	VPWR#3	VNB	2.52384e-16
C16	B1#7	VNB	3.8794e-17
C17	VGND	B1	7.51079e-18
C18	B1#6	VNB	2.89693e-17
C19	B2#5	VNB	3.31319e-17
C20	B2#6	VNB	3.97724e-17
C21	VGND	B2	2.70423e-18
C22	VPWR	A2	1.8494e-18
C23	A2#6	VNB	3.71954e-17
C24	A2#4	VNB	3.60168e-17
C25	A1#6	VNB	3.0126e-17
C26	VGND	A1	3.88269e-18
C27	A1#5	VNB	3.82355e-17
C28	VPWR	B1	6.99421e-18
C29	B1#5	VNB	3.8507e-17
C30	B1#1	VNB	2.89989e-17
C31	B2#7	VNB	2.95207e-17
C32	VPWR	B2	3.45665e-18
C33	B2#1	VNB	3.12104e-17
C34	A2#5	VNB	2.73084e-17
C35	A2#1	VNB	2.45099e-17
C36	A1#4	VNB	2.73367e-17
C37	VPWR	A1	4.94227e-18
C38	A1#1	VNB	3.06233e-17
C39	a_28_368##4	VNB	4.91749e-17
C40	VPWR#7	VNB	3.41532e-18
C41	a_28_368##2	VNB	1.8631e-18
C42	B2	Y	1.39116e-17
C43	a_28_368#	VNB	1.33284e-17
C44	a_510_368##4	VNB	1.34934e-17
C45	Y#1	VNB	4.92372e-19
C46	a_27_74##3	B2#4	6.1648e-20
C47	a_510_368##2	VNB	2.1027e-18
C48	VPWR#6	VNB	1.3526e-18
C49	a_510_368##2	a_510_368#	2.52173e-18
C50	a_510_368#	VNB	4.90263e-17
C51	a_27_74##6	VNB	4.94183e-17
C52	VGND	A2#3	4.21765e-18
C53	Y#4	VNB	1.47962e-18
C54	a_27_74##3	VNB	1.08859e-17
C55	VGND#6	VNB	4.89211e-19
C56	VGND	VGND#4	5.35245e-17
C57	a_27_74##7	VNB	2.12109e-18
C58	A2	A1	3.16988e-17
C59	VGND#5	VNB	1.66194e-18
C60	a_27_74#	VNB	4.56603e-17
C61	B1	B2	3.8976e-17
C62	Y#2	VNB	1.16171e-17
C63	Y#3	VNB	1.79646e-18
C64	VPWR	A2#3	3.60806e-18
C65	A1#9	VNB	2.47975e-19
C66	Y#3	A2#1	2.55696e-20
C67	a_27_74##2	VNB	3.53339e-18
C68	a_27_74##5	VNB	5.56359e-18
C69	VGND#3	VNB	2.76782e-17
C70	A2#4	A1#3	1.11573e-18
C71	VPWR	VPWR#3	3.08735e-17
C72	Y	A2#3	1.60027e-17
C73	VPWR	B1#7	2.08506e-18
C74	Y	A1#2	1.74617e-19
C75	VPWR	B1#6	1.72798e-19
C76	VGND	B1#5	2.36188e-18
C77	VPWR	B2#5	1.4247e-18
C78	VGND	B1#1	1.68256e-18
C79	a_510_368#	VPWR#6	7.02533e-17
C80	VGND	B2#7	1.56754e-18
C81	VPWR	B2#6	1.52589e-18
C82	A2	A2#3	1.46692e-19
C83	VGND	B2#1	1.95456e-18
C84	VPWR	A2#6	1.49413e-18
C85	a_27_74##5	B1#1	1.64698e-17
C86	VGND	A2#5	1.32248e-18
C87	A2	A1#2	4.30882e-20
C88	VPWR	A2#4	1.5273e-18
C89	VGND	A2#1	1.06222e-18
C90	VGND	A1#4	1.56187e-19
C91	VPWR	A1#6	1.28995e-18
C92	VGND	A1#1	1.49633e-18
C93	VPWR	A1#5	1.28246e-18
C94	a_28_368##2	B1#4	2.06621e-18
C95	Y#3	A1#4	1.39174e-20
C96	B2	A2#3	3.02335e-19
C97	VGND	Y#1	2.46303e-18
C98	a_27_74##5	Y#3	6.8868e-19
C99	VGND	a_27_74##6	2.32766e-17
C100	A2	B2#6	1.39517e-19
C101	B1	B1#7	3.03852e-18
C102	VGND	Y#4	8.66388e-18
C103	Y	B1#5	1.47936e-19
C104	A2	A2#6	4.27852e-19
C105	VPWR	a_28_368##4	1.48789e-17
C106	A1	A1#2	1.98741e-17
C107	VGND	Y#6	8.21592e-18
C108	B1	B1#6	2.0403e-18
C109	Y	B1#1	2.14216e-19
C110	VPWR	VPWR#7	2.23377e-17
C111	VGND	a_27_74##3	3.4135e-17
C112	A2	A2#4	2.28997e-18
C113	B1#4	VNB	7.03662e-17
C114	B2#4	VNB	5.64487e-17
C115	VPWR	a_28_368##2	2.01383e-17
C116	Y	B2#7	3.72432e-19
C117	A2#2	VNB	2.33169e-17
C118	B1	B2#5	1.06339e-18
C119	A1#3	VNB	2.29542e-17
C120	VGND	a_27_74##7	1.37986e-17
C121	A2	A1#6	1.35345e-18
C122	VPWR	Y#5	6.48705e-18
C123	Y	B2#1	1.28374e-18
C124	VPWR	a_28_368#	2.56779e-17
C125	VGND	a_27_74#	1.43014e-17
C126	A2	A1#5	1.81424e-19
C127	Y	A2#5	2.08326e-19
C128	a_27_74##5	B2#7	1.64113e-17
C129	VPWR	a_510_368##4	2.77941e-17
C130	Y	A2#1	5.84448e-20
C131	VPWR	Y#1	7.65781e-18
C132	B2	B1#6	1.45427e-19
C133	VGND	Y#2	2.17476e-18
C134	VPWR	a_510_368##2	1.18262e-17
C135	Y	A1#4	8.15162e-20
C136	VGND	Y#3	4.49945e-18
C137	B2	B2#5	5.22897e-18
C138	Y	A1#1	1.21344e-19
C139	VPWR	a_510_368#	1.75344e-17
C140	Y#3	A1#1	2.07173e-20
C141	B2	B2#6	1.46904e-18
C142	VGND#3	B1#1	3.98163e-20
C143	VGND	A1#9	1.14374e-18
C144	B2	A2#6	9.4055e-20
C145	VGND	a_27_74##2	4.84847e-18
C146	VGND	a_27_74##5	3.09686e-17
C147	Y#2	a_28_368##4	2.65942e-21
C148	VGND	VGND#3	4.1384e-17
C149	A1	A2#4	2.18293e-19
C150	VPWR	Y#2	8.15308e-18
C151	A1	A1#6	1.48405e-18
C152	a_27_74##2	A2#5	7.5381e-18
C153	VGND#6	A2#2	1.53755e-19
C154	A2	a_510_368##4	1.60713e-19
C155	VPWR	A1#9	1.08151e-18
C156	B1	a_28_368##4	4.7454e-17
C157	VGND#3	B2#7	7.14781e-20
C158	A2	a_510_368##2	2.71551e-17
C159	B1	a_28_368##2	6.22227e-17
C160	a_27_74##2	A1#9	2.01117e-18
C161	a_27_74##6	Y#4	6.71661e-17
C162	VGND#4	A2#3	3.40998e-20
C163	VPWR#3	A2#3	1.09228e-19
C164	a_27_74##2	A2#1	2.0057e-17
C165	B2	a_28_368##2	1.40966e-18
C166	B2	Y#5	3.41421e-17
C167	a_27_74##6	a_27_74##8	3.23623e-18
C168	a_27_74##6	B1	2.69729e-17
C169	B2	a_28_368#	3.38085e-19
C170	VGND#3	B2#1	5.40577e-19
C171	Y#4	B1	6.04644e-17
C172	B2#4	Y#5	4.87803e-18
C173	Y#2	A2	2.13286e-18
C174	Y#3	a_28_368##2	4.37598e-18
C175	a_27_74##2	A1#4	2.74006e-17
C176	Y#4	a_27_74##8	3.69789e-17
C177	A1	a_510_368##2	1.21733e-17
C178	a_27_74##2	A2	2.45168e-17
C179	VGND#3	A2#5	5.14444e-18
C180	A1	a_510_368#	4.18559e-17
C181	Y#3	B1	1.40428e-17
C182	Y#4	Y#6	3.18426e-18
C183	Y#3	Y#5	1.21292e-18
C184	a_27_74##2	A1#1	4.76273e-19
C185	Y#2	a_28_368#	3.31996e-17
C186	B1#4	B2#4	2.58585e-17
C187	VPWR#3	B2#6	4.4526e-18
C188	B1#7	B1#6	3.71793e-17
C189	VPWR#3	A2#6	4.46741e-18
C190	B2	Y#2	1.60797e-17
C191	a_27_74##8	Y#6	2.44207e-17
C192	VGND#3	A2#1	4.81662e-18
C193	Y#3	B2	3.72571e-17
C194	B2#4	A2#3	1.13161e-17
C195	a_27_74#	A1	2.45561e-17
C196	B1#6	B2#5	4.65906e-17
C197	A2#3	A2#2	1.27748e-17
C198	Y#2	a_510_368##4	2.26583e-17
C199	a_28_368#	B2#4	6.21657e-19
C200	A2#3	A1#3	1.41527e-18
C201	B2#1	A2#3	1.94748e-19
C202	a_27_74##8	a_27_74##3	3.513e-18
C203	VGND#4	B1#5	4.43427e-18
C204	B2#5	B2#6	4.69763e-17
C205	VGND#4	B1#1	4.48038e-18
C206	VGND#3	A1#4	7.83432e-19
C207	Y#2	Y#1	2.56171e-18
C208	VGND#4	B2#7	4.47052e-18
C209	a_27_74##3	Y#6	3.8504e-17
C210	VGND#4	B2#1	4.4412e-18
C211	B2#6	A2#6	5.49439e-18
C212	a_27_74##2	A2#2	4.63311e-19
C213	a_27_74##2	A1	2.28562e-17
C214	VGND#3	A1#1	3.32932e-19
C215	VGND#5	A1#3	3.59932e-19
C216	A2#6	A2#4	4.39051e-17
C217	a_27_74##2	A1#3	9.34098e-19
C218	A1#3	A1#2	3.41823e-18
C219	a_27_74##3	VGND#6	4.89986e-17
C220	A2#3	a_510_368##4	2.95059e-18
C221	A2#4	A1#6	4.72675e-17
C222	A2#3	Y#1	5.04156e-17
C223	a_27_74##5	B1#4	2.87749e-19
C224	a_510_368##4	A2#2	1.19697e-20
C225	a_27_74##3	a_27_74##7	2.41521e-18
C226	A1#6	A1#5	4.68389e-17
C227	VGND#4	B1#4	6.51367e-20
C228	A1#2	VPWR#6	9.08354e-19
C229	Y	B1#4	5.21146e-19
C230	VGND#6	a_27_74##7	3.21339e-17
C231	a_28_368##4	B1#7	3.80248e-17
C232	a_28_368#	VPWR#3	5.61167e-17
C233	A1#2	a_510_368#	6.56017e-18
C234	Y	B2#4	1.01465e-17
C235	Y	A2#2	1.24195e-19
C236	Y	A1#3	1.78938e-20
C237	VGND#4	B2#4	4.61814e-20
C238	a_510_368##4	VPWR#3	5.21971e-17
C239	VPWR#7	B1#7	5.08003e-17
C240	VGND#3	a_27_74##2	6.03596e-19
C241	A2#3	a_27_74##3	2.92509e-17
C242	a_28_368##4	B1#6	7.37056e-19
C243	a_28_368##2	B1#7	2.34469e-18
C244	VGND#6	VGND#5	1.36754e-18
C245	A2#3	VGND#6	4.56671e-18
C246	a_27_74##5	B2#4	3.98464e-19
C247	B1#6	VPWR#7	2.62844e-17
C248	VGND#4	a_27_74##6	5.43216e-17
C249	Y#1	A2#2	2.09933e-19
C250	a_28_368##2	B1#6	6.42766e-17
C251	VPWR#7	B2#5	5.09322e-19
C252	a_27_74##7	VGND#5	4.45083e-17
C253	a_28_368##2	B2#5	7.26179e-17
C254	B1#5	B1#1	2.57458e-17
C255	VGND#5	A1#2	8.77819e-19
C256	VGND#4	a_27_74##3	6.57244e-17
C257	VPWR#7	B2#6	2.31371e-19
C258	B2#5	Y#5	2.14106e-17
C259	a_27_74#	A1#2	4.0677e-18
C260	a_27_74##7	a_27_74#	1.24641e-18
C261	Y#2	A2#3	2.05502e-17
C262	a_28_368##2	B2#6	1.91769e-18
C263	A2	B2#4	1.04637e-19
C264	A2	A2#2	1.06129e-17
C265	a_28_368#	B2#5	1.28708e-18
C266	VPWR#3	B2#4	8.8114e-20
C267	A2	A1#3	1.0386e-17
C268	VPWR#7	A2#6	7.66033e-20
C269	Y#3	a_27_74##8	1.94954e-17
C270	Y#5	B2#6	4.75851e-17
C271	A1#9	a_510_368#	1.69933e-17
C272	a_510_368##4	B2#5	4.29821e-19
C273	a_27_74##2	a_510_368##2	3.42061e-18
C274	B1#1	B2#7	2.9189e-17
C275	a_28_368#	B2#6	6.27604e-17
C276	a_27_74#	VGND#5	4.84333e-17
C277	Y#5	A2#6	4.38268e-19
C278	a_510_368##4	B2#6	3.70682e-18
C279	Y#3	Y#6	4.53667e-19
C280	a_28_368#	A2#6	1.41651e-18
C281	a_27_74##3	Y#2	9.08967e-18
C282	B2#7	B2#1	2.49143e-17
C283	Y#1	B2#6	2.27322e-19
C284	a_510_368##4	A2#6	7.83516e-17
C285	a_27_74##2	A2#3	4.34698e-17
C286	Y#1	A2#6	3.48119e-17
C287	Y#3	a_27_74##3	3.90756e-17
C288	A1#9	A1#2	1.10853e-17
C289	B1	B1#4	4.23418e-17
C290	a_510_368##4	A2#4	1.0082e-17
C291	B1	B2#4	8.64025e-18
C292	B2#1	A2#5	6.40162e-18
C293	a_510_368##2	A2#6	3.70342e-19
C294	Y#2	VPWR#3	1.46343e-18
C295	Y#1	A2#4	5.3776e-17
C296	a_27_74##2	A1#2	2.26468e-18
C297	a_510_368##4	A1#6	2.11095e-19
C298	VGND#3	A2#3	1.2853e-20
C299	a_510_368##2	A2#4	2.5323e-17
C300	Y#1	A1#6	2.48289e-18
C301	A2#5	A2#1	2.85804e-17
C302	VPWR#6	A2#4	1.3398e-18
C303	a_510_368##2	A1#6	6.49398e-17
C304	a_510_368#	A2#4	2.11095e-19
C305	Y#1	A1#5	9.5467e-19
C306	VPWR#6	A1#6	4.22078e-17
C307	A1#3	VPWR#6	3.27671e-19
C308	A2#2	A1#3	2.61531e-17
C309	A2#1	A1#4	3.91539e-17
C310	VGND#4	a_27_74##5	7.35254e-17
C311	Y#2	B1#7	2.38199e-19
C312	a_510_368##2	A1#5	7.17196e-19
C313	B2	B1#4	1.50804e-18
C314	a_510_368#	A1#6	2.22298e-18
C315	B2	B2#4	2.28463e-17
C316	A1#5	VPWR#6	2.41894e-17
C317	VGND#4	VGND#3	3.56763e-17
C318	a_510_368#	A1#5	5.58718e-17
C319	Y#2	B1#6	2.5218e-19
C320	Y#2	B2#4	3.43594e-18
C321	A1#4	A1#1	2.47993e-17
C322	a_27_74##5	Y#4	1.74144e-17
C323	a_27_74##6	B1#4	4.09079e-19
C324	Y#2	B2#5	5.50835e-19
C325	Y#2	A2#2	6.33944e-20
C326	a_510_368#	A1#3	4.56547e-19
C327	a_27_74##5	a_27_74##8	4.00697e-19
C328	a_27_74##6	B1#5	5.28259e-17
C329	Y#2	B2#6	1.51348e-17
C330	Y#2	A1#3	6.68216e-20
C331	A1	A2#2	9.91854e-19
C332	A1	A1#3	7.73891e-18
C333	B1#5	Y#4	2.74251e-17
C334	a_28_368##4	VPWR#7	6.35866e-17
C335	Y#3	B2#4	5.07242e-18
C336	a_27_74##6	B1#1	2.15963e-18
C337	a_27_74##8	B1#5	1.02487e-18
C338	Y#2	A2#6	2.90814e-18
C339	a_27_74##5	Y#6	2.21214e-17
C340	Y#4	B1#1	2.69335e-17
C341	a_28_368##4	a_28_368##2	2.41843e-18
C342	Y#6	B1#5	3.33541e-19
C343	a_27_74##2	VGND#6	2.80126e-17
C344	Y#4	B1#4	7.13819e-18
C345	a_27_74##6	B2#7	2.41646e-19
C346	B1#1	a_27_74##8	2.45728e-17
C347	a_28_368##2	VPWR#7	9.16109e-17
C348	Y#2	A2#4	5.94979e-19
C349	Y#4	B2#7	1.05071e-18
C350	a_27_74#	A1#9	1.74016e-17
C351	Y#6	B1#1	5.41792e-19
C352	Y#3	Y#2	2.1446e-18
C353	a_27_74##8	B2#7	3.11075e-17
C354	a_27_74##2	a_27_74##7	4.59562e-19
C355	Y#4	B2#1	2.52085e-19
C356	Y#2	A1#6	8.90955e-20
C357	B2#7	Y#6	1.53975e-17
C358	a_28_368##2	Y#5	6.90298e-17
C359	a_27_74##8	B2#1	1.46469e-18
C360	A2#2	A1#4	1.35611e-18
C361	a_27_74##3	B2#7	6.23023e-19
C362	a_27_74##2	VGND#5	2.43977e-17
C363	a_28_368##2	a_28_368#	3.01982e-18
C364	Y#6	B2#1	3.06039e-17
C365	a_27_74##8	A2#5	8.72373e-20
C366	a_27_74##3	B2#1	4.3366e-17
C367	a_28_368#	Y#5	6.40778e-17
C368	VGND#3	a_27_74##3	1.07207e-17
C369	Y#6	A2#5	1.87508e-19
C370	a_27_74##2	a_27_74#	1.15144e-18
C371	VGND#6	B2#1	4.96215e-19
C372	Y#5	a_510_368##4	4.10929e-18
C373	a_27_74##3	A2#5	2.77356e-17
C374	a_27_74##7	B2#1	1.36136e-19
C375	VGND#6	A2#5	2.94165e-17
C376	a_28_368#	a_510_368##4	6.00998e-17
C377	A1#9	A1#5	3.37557e-18
C378	a_27_74##3	A2#1	4.77386e-19
C379	a_27_74##6	a_28_368##4	1.51469e-19
C380	a_27_74##7	A2#5	1.21163e-18
C381	A2#1	VGND#6	1.75771e-17
C382	a_28_368##4	B1#4	2.52013e-19
C383	VGND#5	A2#5	1.56968e-19
C384	a_27_74##3	A1#4	2.2543e-19
C385	VGND#3	a_27_74##7	5.9897e-18
C386	A2#1	a_27_74##7	1.24838e-17
C387	Y#1	a_510_368##4	7.80835e-17
C388	VGND#6	A1#4	1.24517e-18
C389	VGND#5	A2#1	4.10716e-19
C390	B2#4	A2#6	1.76283e-19
C391	a_510_368##4	a_510_368##2	2.52173e-18
C392	a_27_74##7	A1#4	3.55595e-17
C393	Y#3	B2#7	1.71106e-17
C394	VGND#6	A1#1	1.61794e-19
C395	A1#4	VGND#5	1.64164e-17
C396	Y#1	a_510_368##2	5.96528e-17
C397	a_27_74##7	A1#1	1.22243e-18
C398	Y#3	B2#1	1.69301e-17
C399	a_27_74#	A1#4	7.32174e-19
C400	B1#4	VPWR#7	1.65751e-18
C401	VGND#5	A1#1	3.37041e-17
C402	VGND#3	VGND#2	1.45359e-18
C403	VGND#2	A1#4	5.64901e-18
C404	VPWR#2	B2#6	7.75745e-20
C405	VGND#2	A2#1	8.93104e-19
C406	VGND#2	A2#5	2.65377e-19
C407	VPWR#2	A2#6	2.90229e-19
C408	VPWR#2	A2#2	4.10772e-21
C409	VGND#2	a_27_74##2	2.25448e-19
C410	VPWR#3	VPWR#4	6.81171e-17
C411	VPWR#2	VNB	6.00763e-17
C412	VPWR#2	A2#4	5.03204e-18
C413	a_28_368##4	VPWR#4	1.78825e-17
C414	VPWR#4	VNB	5.86213e-17
C415	VPWR#2	A1#6	4.48394e-18
C416	VPWR#2	A1#5	5.50442e-18
C417	VPWR#4	B1#7	1.84214e-18
C418	VPWR#2	A2#3	9.14901e-21
C419	VPWR#4	B2#4	5.67791e-21
C420	VPWR	VPWR#2	5.85654e-17
C421	a_28_368##2	VPWR#4	3.50436e-17
C422	VGND#2	a_27_74#	1.7841e-17
C423	VPWR#2	A1#2	7.4788e-20
C424	VPWR#4	B1#6	2.31287e-18
C425	VGND#4	VGND#2	5.18436e-17
C426	VGND#2	a_27_74##7	7.70491e-18
C427	VGND#2	A1#2	9.70263e-20
C428	VGND#6	VGND#2	6.2516e-19
C429	VPWR	VPWR#4	4.05359e-17
C430	a_510_368##4	VPWR#2	1.22737e-17
C431	VPWR#4	B2#5	4.4526e-18
C432	VPWR#3	VPWR#2	6.84783e-17
C433	a_28_368#	VPWR#4	4.30031e-18
C434	a_510_368##2	VPWR#2	2.58068e-17
C435	A1	VPWR#2	5.19567e-19
C436	a_510_368#	VPWR#2	2.06626e-17
C437	VGND	VGND#2	5.37876e-17
C438	VGND#2	VNB	4.83478e-17
C439	VGND#2	A1#1	5.4275e-18
*
*
.ENDS sky130_fd_sc_hs__o22ai_2
*
