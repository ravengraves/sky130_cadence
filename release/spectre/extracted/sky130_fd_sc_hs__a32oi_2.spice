* Extracted by Quantus, converted by sky130cad/quantus.py
*
*
*
*                       LINUX           Wed Nov 18 08:14:31 2026
*
*
*
*  PROGRAM  advgen
*
*  Name           : advgen - Quantus - (64-bit)
*  Version        : 25.1.0-p047
*  Build Date     : Thu Dec 11 23:20:30 PST 2025
*
*  HSPICE LIBRARY
*
*  OPERATING_TEMPERATURE 150
*  QRC_TECH_DIR <path>/tech
*
*
*

*
.SUBCKT sky130_fd_sc_hs__a32oi_2 VPB VNB VGND VPWR Y B1 A1 A3 B2 A2
*
*
*  caps2d version: 10
*
*
*       TRANSISTOR CARDS
*
*
XM4 VGND#7 B2#5 a_27_74##4 VNB sky130_fd_pr__nfet_01v8_lvt l=0.15 w=0.74 ad=0.2442 as=0.2109 pd=2.14 ps=2.05
XM19 a_27_74##2 B2#6 VGND#7 VNB sky130_fd_pr__nfet_01v8_lvt l=0.15 w=0.74 ad=0.2072 as=0.2442 pd=2.04 ps=2.14
XM2 a_27_74##2 B1#4 Y#3 VNB sky130_fd_pr__nfet_01v8_lvt l=0.15 w=0.74 ad=0.2072 as=0.2072 pd=2.04 ps=2.04
XM7 Y#3 B1#5 a_27_74# VNB sky130_fd_pr__nfet_01v8_lvt l=0.15 w=0.74 ad=0.2072 as=0.2627 pd=2.04 ps=2.19
XM0 Y#1 A1#6 a_507_74##3 VNB sky130_fd_pr__nfet_01v8_lvt l=0.15 w=0.74 ad=0.2072 as=0.2109 pd=2.04 ps=2.05
XM15 a_507_74##4 A1#5 Y#1 VNB sky130_fd_pr__nfet_01v8_lvt l=0.15 w=0.74 ad=0.2257 as=0.2072 pd=2.09 ps=2.04
XM10 a_771_74##2 A2#5 a_507_74##4 VNB sky130_fd_pr__nfet_01v8_lvt l=0.15 w=0.74 ad=0.2923 as=0.2257 pd=2.27 ps=2.09
XM11 a_507_74# A2#1 a_771_74##2 VNB sky130_fd_pr__nfet_01v8_lvt l=0.15 w=0.74 ad=0.2109 as=0.2923 pd=2.05 ps=2.27
XM6 VGND#6 A3#8 a_771_74# VNB sky130_fd_pr__nfet_01v8_lvt l=0.15 w=0.74 ad=0.2109 as=0.2072 pd=2.05 ps=2.04
XM12 a_771_74# A3#6 VGND#1 VNB sky130_fd_pr__nfet_01v8_lvt l=0.15 w=0.74 ad=0.2072 as=0.2109 pd=2.04 ps=2.05
XM5 Y#5 B2#7 a_27_368##7 VPB sky130_fd_pr__pfet_01v8 l=0.15 w=1.12 ad=0.3864 as=0.336 pd=2.93 ps=2.84
XM16 a_27_368##10 B2#1 Y#5 VPB sky130_fd_pr__pfet_01v8 l=0.15 w=1.12 ad=0.392 as=0.3864 pd=2.94 ps=2.93
XM9 a_27_368##10 B1#6 Y#6 VPB sky130_fd_pr__pfet_01v8 l=0.15 w=1.12 ad=0.392 as=0.392 pd=2.94 ps=2.94
XM13 Y#6 B1#1 a_27_368##4 VPB sky130_fd_pr__pfet_01v8 l=0.15 w=1.12 ad=0.392 as=0.392 pd=2.94 ps=2.94
XM14 VPWR#8 A1#7 a_27_368##4 VPB sky130_fd_pr__pfet_01v8 l=0.15 w=1.12 ad=0.7728 as=0.392 pd=3.62 ps=2.94
XM18 a_27_368##9 A1#1 VPWR#8 VPB sky130_fd_pr__pfet_01v8 l=0.15 w=1.12 ad=0.336 as=0.7728 pd=2.84 ps=3.62
XM3 a_27_368##9 A2#7 VPWR#7 VPB sky130_fd_pr__pfet_01v8 l=0.15 w=1.12 ad=0.336 as=0.4088 pd=2.84 ps=2.97
XM17 VPWR#7 A2#6 a_27_368##8 VPB sky130_fd_pr__pfet_01v8 l=0.15 w=1.12 ad=0.4088 as=0.532 pd=2.97 ps=3.19
XM8 VPWR#6 A3#5 a_27_368##8 VPB sky130_fd_pr__pfet_01v8 l=0.15 w=1.12 ad=0.448 as=0.532 pd=3.04 ps=3.19
XM1 a_27_368# A3#7 VPWR#6 VPB sky130_fd_pr__pfet_01v8 l=0.15 w=1.12 ad=0.3304 as=0.448 pd=2.83 ps=3.04
*
*
*       RESISTOR AND CAP/DIODE CARDS
*
Rg1	B2#1	B2#2	473.282684
Rg2	B2#2	B2#3	31.581310
Rg3	B2#3	B2#4	30.613651
Rg4	B2#4	B2#5	368.862610
Rg5	B2#2	B2#6	371.813751
Rg6	B2#4	B2#7	471.862823
Rg7	B1#1	B1#2	477.376801
Rg8	B1#2	B1#3	59.577911
Rg9	B1#3	B1#4	398.538300
Rg10	B1#2	B1#5	293.254944
Rg11	B1#3	B1#6	473.627625
Rg12	A1#1	A1#2	507.633148
Rg13	A1#2	A1#3	67.845528
Rg14	A1#3	A1#4	52.998367
Rg15	A1#2	A1#5	323.721649
Rg16	A1#3	A1#6	296.149994
Rg17	A1#4	A1#7	509.023376
Rg18	A2#1	A2#2	397.555725
Rg19	A2#2	A2#3	35.518757
Rg20	A2#3	A2#4	30.613651
Rg21	A2#4	A2#5	397.555725
Rg22	A2#2	A2#6	449.655212
Rg23	A2#4	A2#7	449.655212
Rg24	A3#1	A3#2	37.248577
Rg25	A3#2	A3#3	44.253338
Rg26	A3#3	A3#4	26.534826
Rg27	A3#4	A3#5	552.581299
Rg28	A3#2	A3#6	296.149994
Rg29	A3#3	A3#7	476.975128
Rg30	A3#4	A3#8	296.149994
Rf1	B2#3	B2	105.638702
Rf2	B1	B1#7	11.295456
Rf3	B1#7	B1	5.647728
Rf4	a_27_74#	a_27_74##3	108.678772
Rf5	a_27_74##3	a_27_74##4	104.671310
Rf6	a_27_74##2	a_27_74##3	7.500000
Rf7	A1	A1#4	163.775864
Rf8	Y#2	Y#3	116.510864
Rf9	Y#2	Y	55.257336
Rf10	Y	Y#4	108.089958
Rf11	Y#4	Y#5	87.664856
Rf12	Y#4	Y#6	18.405569
Rf13	Y#1	Y#2	15.000000
Rf14	A2#8	A2	1.129585
Rf15	A2#3	A2#10	81.245987
Rf16	A2#8	A2#10	13.446521
Rf17	A2#11	A2	1.129585
Rf18	A2#10	A2#11	1.222411
Rf19	a_507_74#	a_507_74##2	94.232048
Rf20	a_507_74##2	a_507_74##3	79.524574
Rf21	a_507_74##2	a_507_74##4	19.921387
Rf22	a_771_74#	a_771_74##2	147.593048
Rf23	a_27_368#	a_27_368##2	96.340782
Rf24	a_27_368##2	a_27_368##3	66.254974
Rf25	a_27_368##3	a_27_368##5	99.488937
Rf26	a_27_368##5	a_27_368##6	87.812820
Rf27	a_27_368##6	a_27_368##7	92.152336
Rf28	a_27_368##2	a_27_368##8	15.785553
Rf29	a_27_368##3	a_27_368##9	18.183365
Rf30	a_27_368##6	a_27_368##10	21.791332
Rf31	a_27_368##4	a_27_368##5	5.000000
Rf32	A3#9	A3	0.882458
Rf33	A3#1	A3#11	161.115265
Rf34	A3#9	A3#11	3.543054
Rf35	VGND#1	VGND#2	93.262894
Rf36	VGND#2	VGND#3	141.750778
Rf37	VGND#3	VGND#4	176.027161
Rf39	VGND#2	VGND#6	45.213318
Rf40	VGND#4	VGND#7	36.279022
Rf42	VPWR#2	VPWR#3	82.672234
Rf43	VPWR#3	VPWR#4	71.081741
Rf45	VPWR#2	VPWR#6	34.546150
Rf46	VPWR#3	VPWR#7	32.048218
Rf47	VPWR#4	VPWR#8	16.283695
Rf49	B1#2	B1#7	80.116402
Re1	VPWR#4	VPWR	0.755546
Re2	VGND	VGND#3	0.755573
*
*       CAPACITOR CARDS
*
*
C1	Y#1	a_771_74##2	2.12125e-18
C2	a_27_368##6	a_27_368##10	1.43922e-18
C3	Y#1	a_507_74##4	5.48331e-17
C4	A3#2	VGND#1	7.17276e-18
C5	VGND#2	A3#6	1.19399e-18
C6	a_771_74#	A3#4	2.94525e-17
C7	a_507_74##3	a_507_74##4	5.36247e-18
C8	a_27_368##6	Y#5	1.63307e-17
C9	Y#5	B2#4	4.58035e-18
C10	VGND#2	A3#8	7.31293e-18
C11	Y#1	a_507_74##3	5.80132e-17
C12	VGND#3	A2#4	3.77752e-20
C13	VGND#1	a_27_368#	4.26891e-19
C14	VGND#2	A2#1	5.61229e-18
C15	a_771_74#	a_27_368#	1.65843e-17
C16	VGND#3	A1#2	4.74683e-20
C17	VGND#6	A3#4	2.15743e-18
C18	a_27_74#	a_507_74##3	3.32416e-17
C19	Y#3	Y#1	1.24782e-18
C20	a_27_368##7	B2#4	1.30579e-19
C21	Y#4	a_27_368##4	3.66532e-17
C22	VGND#2	A2#5	2.0169e-19
C23	A3#1	A3#2	1.24747e-17
C24	a_27_74##2	Y#1	2.98946e-22
C25	A3#1	A2#4	3.80677e-19
C26	Y#4	Y#6	8.57811e-19
C27	a_27_74#	Y#3	7.44786e-17
C28	VGND#2	A1#5	5.10338e-20
C29	VGND#2	A3#4	5.25177e-19
C30	a_27_368##3	VPWR#3	1.6661e-19
C31	Y#4	a_27_368##10	2.40545e-17
C32	a_27_74##2	a_27_74#	2.37845e-18
C33	A2#1	A3#4	3.48705e-18
C34	VGND#2	A1#6	3.58321e-20
C35	a_27_74##2	Y#3	4.21347e-17
C36	Y#5	Y#4	4.70024e-19
C37	a_27_368##2	VPWR#3	1.24751e-17
C38	a_27_74##2	VGND#7	4.8882e-17
C39	a_507_74#	A2#4	2.51522e-19
C40	VGND#2	A2#4	3.02202e-20
C41	a_27_74##4	a_27_74##2	2.10478e-18
C42	a_507_74##2	A2#5	2.59386e-17
C43	a_27_74##4	VGND#7	5.35857e-17
C44	A1#4	A1#2	1.02117e-18
C45	a_507_74##2	A1#5	2.22555e-17
C46	a_771_74##2	A2#4	6.06894e-18
C47	VPWR#3	A3#7	9.02789e-20
C48	A1#2	A2#5	4.89636e-18
C49	VGND#1	A3#6	3.93383e-17
C50	VPWR#3	A3#5	4.08038e-19
C51	B1#3	B1#2	4.07881e-18
C52	a_27_368#	VPWR#6	1.00129e-16
C53	Y#1	A3#4	1.38674e-18
C54	a_771_74#	A3#6	1.58544e-17
C55	VGND#1	A3#8	3.25849e-18
C56	VGND#2	a_507_74##2	8.38196e-19
C57	VGND#6	A3#6	9.15126e-20
C58	VPWR#3	A2#6	4.11958e-18
C59	a_771_74#	A3#8	4.95373e-17
C60	VGND#1	A2#1	1.43745e-19
C61	A3#8	VGND#6	1.90004e-17
C62	A3#11	A3#2	1.51353e-17
C63	B2#3	B1#3	7.85367e-18
C64	a_771_74#	A2#1	4.14936e-19
C65	VPWR#7	VPWR#6	1.97656e-18
C66	VPWR#3	A2#7	4.61454e-18
C67	B2#3	B2#4	4.03088e-17
C68	a_507_74#	A3#8	1.13005e-18
C69	Y#1	A2#4	2.00887e-18
C70	VGND#6	A2#1	8.74143e-19
C71	a_771_74##2	A3#8	3.71018e-19
C72	a_771_74#	A2#5	1.21998e-19
C73	A3#11	A2#4	7.42848e-19
C74	a_507_74#	A2#1	5.50833e-17
C75	VPWR#3	A1#1	5.37902e-19
C76	A2#4	A3#4	1.25567e-17
C77	a_771_74##2	A2#1	3.38331e-17
C78	a_27_74##2	Y#5	3.58874e-18
C79	a_507_74#	A2#5	8.97486e-19
C80	a_27_368##9	VPWR#7	6.00256e-17
C81	a_27_368##2	A3#7	9.21392e-19
C82	a_507_74##4	A2#1	1.6948e-18
C83	A2#5	a_771_74##2	2.47117e-17
C84	Y#1	A2#1	1.24806e-19
C85	a_27_368##3	A3#5	1.8766e-19
C86	a_507_74#	A1#5	3.1576e-19
C87	VPWR#8	VPWR#7	2.72487e-18
C88	Y#1	A1#2	6.07832e-18
C89	A2#5	a_507_74##4	1.60096e-17
C90	a_27_368##2	A3#5	6.96901e-17
C91	a_771_74##2	A1#5	9.44644e-19
C92	VPWR#8	a_27_368##9	6.26877e-17
C93	Y#1	A2#5	2.5918e-19
C94	a_27_368##3	A2#6	6.35106e-19
C95	a_507_74##4	A1#5	3.34337e-17
C96	a_27_74##4	a_27_368##7	3.02937e-19
C97	a_771_74##2	A1#6	6.9478e-20
C98	a_27_368##4	a_27_368##9	1.65158e-18
C99	a_27_368##2	A2#6	3.18339e-17
C100	A1#5	Y#1	1.58315e-17
C101	a_507_74##4	A1#6	2.27938e-18
C102	a_27_368##4	VPWR#8	1.26674e-16
C103	a_27_368##3	a_27_368##2	2.73705e-18
C104	a_27_368##3	A2#7	2.0172e-17
C105	a_507_74##3	A1#5	1.15216e-18
C106	Y#1	A1#6	3.59185e-17
C107	a_27_368##2	A2#7	6.7415e-19
C108	a_507_74##3	A1#6	5.13416e-17
C109	a_507_74##2	a_27_368##3	9.30775e-19
C110	a_27_368##3	A1#1	2.87332e-17
C111	Y#3	A1#5	1.14941e-19
C112	Y#1	B1#5	8.17771e-19
C113	a_27_368##4	Y#6	6.31611e-17
C114	a_27_74#	A1#6	8.68765e-19
C115	a_27_368##2	A1#1	1.10221e-19
C116	a_27_74##2	A1#5	3.66702e-19
C117	a_507_74##3	B1#5	7.75057e-19
C118	Y#3	A1#6	3.96397e-19
C119	a_27_368##10	a_27_368##4	4.24095e-18
C120	Y#1	B1#4	1.71107e-19
C121	A2#10	A2#7	7.1972e-19
C122	a_27_74#	B1#5	3.75399e-17
C123	a_27_368##3	A1#7	9.58389e-19
C124	a_27_74##2	A1#6	6.13105e-19
C125	a_27_368##10	Y#6	5.41502e-17
C126	a_27_368##2	A1#7	7.78665e-20
C127	Y#3	B1#5	3.80301e-17
C128	Y#1	B2#6	2.19238e-19
C129	a_27_74#	B1#4	4.62933e-19
C130	Y#5	Y#6	2.09605e-18
C131	a_27_74##2	B1#5	1.6139e-18
C132	a_27_368##3	B1#1	2.93489e-19
C133	a_27_74#	B1#3	2.21613e-19
C134	Y#3	B1#4	3.00102e-17
C135	a_27_368##6	B1#6	2.19402e-17
C136	B2#6	B1#3	2.11554e-18
C137	a_27_74#	B2#6	2.02452e-19
C138	Y#5	a_27_368##10	6.30221e-17
C139	Y#4	A1#1	3.17328e-19
C140	a_27_74##2	B1#4	4.46642e-17
C141	Y#3	B2#6	9.51736e-19
C142	A2#10	a_27_368##3	1.93754e-17
C143	a_27_368##7	a_27_368##10	4.30435e-18
C144	VGND#7	B1#4	2.08799e-18
C145	a_27_368##2	A3#4	2.84278e-18
C146	Y#4	a_27_368##6	2.47256e-18
C147	a_27_368##6	B2#1	1.61495e-17
C148	a_27_74##2	B2#6	3.24778e-17
C149	Y#4	A1#7	1.20944e-17
C150	a_27_74##4	B1#4	1.79043e-19
C151	a_27_368##7	Y#5	8.73974e-17
C152	B2#6	VGND#7	1.76334e-17
C153	a_27_368##3	A2#4	1.57984e-18
C154	a_27_74##2	B2#5	1.7841e-18
C155	B1#3	Y#3	1.89653e-18
C156	a_27_74##4	B2#6	7.55035e-19
C157	Y#4	B1#1	1.93861e-17
C158	VGND#7	B2#5	3.22066e-17
C159	a_27_368##6	B2#4	1.29491e-19
C160	a_507_74##2	A2#10	9.84275e-19
C161	a_27_74##4	B2#5	3.30057e-17
C162	Y#4	a_27_368##3	2.67423e-18
C163	VGND#2	VGND#1	2.48745e-18
C164	Y#4	B1#6	1.93395e-17
C165	A3#8	A3#6	3.76739e-17
C166	A2	A3#4	4.73739e-18
C167	a_27_368##2	A2#4	2.3406e-18
C168	VGND#3	VGND#2	6.26152e-17
C169	VGND#2	a_771_74#	1.30474e-17
C170	Y#4	B2#1	5.38482e-19
C171	A2	A2#4	3.04875e-17
C172	a_27_368#	A3#7	6.56464e-17
C173	A2	A1#2	9.54173e-18
C174	A2#1	A3#8	4.20829e-18
C175	a_27_74##2	B2#4	1.58711e-18
C176	a_27_368##3	A1#2	2.74362e-19
C177	Y#4	B2#7	2.19625e-19
C178	A3#7	VPWR#6	3.56162e-17
C179	a_27_368#	A3#5	8.98307e-19
C180	a_27_368#	A3#4	3.93958e-18
C181	A3#5	VPWR#6	3.76081e-17
C182	A3#5	A3#4	4.42452e-18
C183	A2#5	A2#1	2.41134e-17
C184	VPWR#7	A3#7	2.36902e-19
C185	a_507_74##2	A2#4	4.08852e-19
C186	A3#5	a_27_368##8	3.03504e-17
C187	VGND#2	a_507_74#	5.36626e-17
C188	VGND#3	a_507_74##2	6.79958e-17
C189	VPWR#6	A2#6	1.2895e-18
C190	A1#2	A2#4	2.32372e-17
C191	VPWR#7	A3#5	5.08483e-19
C192	A2#6	a_27_368##8	4.60676e-18
C193	A1#5	A2#5	3.23624e-17
C194	VGND#7	B2#4	1.18515e-18
C195	a_27_368##9	A3#5	4.59946e-21
C196	a_27_368#	A3#2	1.14674e-17
C197	B2	B2#4	5.60078e-19
C198	A2#4	A3#5	5.14013e-18
C199	VPWR#7	A2#6	5.56443e-17
C200	VGND#2	a_771_74##2	1.31433e-18
C201	a_27_368##9	A2#6	9.87036e-19
C202	VPWR#6	A3#4	1.30216e-18
C203	A2#7	VPWR#7	2.5013e-17
C204	A1#6	A1#5	3.75093e-17
C205	VPWR#8	A2#6	3.76048e-19
C206	a_27_368##9	A2#7	5.02872e-17
C207	VPWR#7	A1#1	6.76302e-19
C208	VPWR#8	A2#7	2.4925e-18
C209	A1#1	a_27_368##9	2.13732e-17
C210	B1#5	A1#6	3.32565e-18
C211	a_27_368##3	A1#4	8.39844e-19
C212	a_27_368##4	A2#7	1.40992e-19
C213	a_27_74##4	B2#4	1.93731e-18
C214	a_507_74##2	A1#2	2.02315e-19
C215	VPWR#8	A1#1	6.64774e-17
C216	a_507_74##2	A1#4	3.96695e-21
C217	VGND#3	VGND#1	2.85773e-17
C218	a_27_368##6	B1#2	1.87504e-19
C219	a_27_368##9	A1#7	5.14331e-19
C220	a_27_368##4	A1#1	5.14331e-19
C221	B1#4	B1#5	3.75882e-17
C222	VPWR#8	A1#7	5.85154e-17
C223	a_27_368##9	B1#1	1.46729e-19
C224	a_27_368##4	A1#7	6.44485e-17
C225	VGND#1	A3#1	2.88231e-17
C226	VPWR#8	B1#1	6.35795e-18
C227	A1#4	Y#4	1.45861e-17
C228	Y#6	A1#7	9.79393e-19
C229	a_771_74#	a_27_368##2	9.33775e-18
C230	B2#6	B1#4	3.72856e-17
C231	a_27_368##4	B1#1	3.71191e-17
C232	a_27_368##10	A1#7	3.30616e-19
C233	VGND#3	Y#1	1.56064e-18
C234	VPWR#8	B1#6	4.73102e-18
C235	Y#6	B1#1	5.00095e-17
C236	VGND#3	a_507_74##3	4.89001e-17
C237	Y#4	B1#2	5.53418e-18
C238	a_27_368##4	B1#6	7.2148e-19
C239	a_27_368##10	B1#1	1.73473e-18
C240	VGND#3	a_27_74#	3.13195e-17
C241	B2#5	B2#6	2.68349e-17
C242	VPWR#8	B2#1	7.5636e-20
C243	B1#6	Y#6	2.06535e-17
C244	VGND#3	Y#3	1.4426e-18
C245	Y#5	B1#1	1.97004e-19
C246	a_27_368##10	B1#6	5.36686e-17
C247	VPWR#8	B2#7	5.343e-20
C248	Y#6	B2#1	3.52195e-19
C249	Y#5	B1#6	1.38781e-18
C250	A2#10	A2#4	1.01522e-17
C251	B2#1	a_27_368##10	2.26336e-17
C252	a_27_368##7	B1#6	3.30616e-19
C253	Y#5	B2#1	6.62872e-17
C254	B1	B1#3	9.78199e-18
C255	a_27_368##10	B2#7	1.34394e-18
C256	B1	B2#4	4.20494e-18
C257	Y#1	A1#4	6.11506e-17
C258	a_27_368##7	B2#1	2.59524e-18
C259	A1#1	A2#4	2.93039e-18
C260	A1#4	a_507_74##3	2.62619e-18
C261	B2#7	Y#5	2.49329e-17
C262	a_771_74##2	a_27_368##2	1.35172e-17
C263	a_27_368##7	B2#7	6.63079e-17
C264	a_507_74##4	a_27_368##3	2.27005e-18
C265	A2#4	VPWR#7	1.8201e-18
C266	A3#5	A3#7	3.14376e-17
C267	a_507_74##2	a_771_74##2	2.07987e-17
C268	B1#2	a_27_74#	3.0419e-18
C269	B1#2	Y#3	5.55807e-18
C270	Y	A3#4	8.94673e-20
C271	VPWR#3	VPWR#6	3.87146e-20
C272	Y	A2#4	1.88629e-18
C273	A2#6	A3#5	2.20894e-17
C274	Y	A1#2	7.07419e-18
C275	Y	B1#3	4.92812e-20
C276	Y	B2#4	2.39005e-19
C277	a_507_74##2	a_507_74##4	4.58253e-20
C278	a_27_74##2	B2#3	2.9119e-17
C279	A2#7	A2#6	3.4858e-17
C280	B2#3	VGND#7	3.7938e-18
C281	a_27_74##4	B2#3	2.91248e-17
C282	VPWR#8	A1#4	1.78156e-18
C283	a_27_368##4	A1#4	5.93085e-19
C284	A2	A3#11	3.77782e-18
C285	a_507_74##2	Y#1	1.10848e-17
C286	A1#1	A2#7	4.66948e-17
C287	VGND#3	A2#5	4.43427e-18
C288	VPWR#8	B1#2	1.02691e-19
C289	a_771_74##2	A2#10	1.84972e-17
C290	A2	a_27_368##3	3.09662e-17
C291	VGND#3	A1#5	4.43427e-18
C292	a_27_368##4	B1#2	4.67735e-19
C293	A2	a_27_368##2	3.52892e-17
C294	VGND#2	a_27_368#	2.25009e-20
C295	VPWR	A3#2	3.00655e-18
C296	a_507_74##2	A2	2.65805e-18
C297	VGND#3	A1#6	4.44935e-18
C298	A1#7	A1#1	1.02112e-17
C299	B1#1	A1#7	3.88346e-17
C300	B2#3	Y#5	6.00867e-17
C301	a_27_368##9	VPWR#3	7.32683e-18
C302	B2#3	a_27_368##7	5.85697e-18
C303	B1#6	B1#1	3.42397e-17
C304	B2	Y#4	3.56305e-18
C305	B2#4	B1#3	2.77672e-17
C306	A3#11	a_27_368#	2.40671e-17
C307	VGND	A3#4	2.77874e-18
C308	a_771_74##2	A2	3.35393e-17
C309	VGND	A3#2	2.21386e-20
C310	a_507_74##4	A2	2.15356e-17
C311	B2#1	B1#6	3.36334e-17
C312	VPWR#8	VPWR#3	5.89118e-20
C313	VGND	A1#2	4.2646e-19
C314	VGND	B1#3	8.85545e-20
C315	VGND	B2#4	1.47277e-20
C316	B2#7	B2#1	3.8124e-17
C317	Y#1	Y#4	6.22459e-19
C318	VPWR#8	A1#2	3.37025e-19
C319	Y#4	B1#3	2.12501e-19
C320	a_771_74#	VGND#1	5.5838e-17
C321	VPWR#8	B1#3	2.28867e-20
C322	a_27_74##4	B2	2.4212e-17
C323	A3#4	VNB	7.30443e-17
C324	A3#2	VNB	5.49213e-17
C325	A2#4	VNB	6.03931e-17
C326	Y#4	B2#4	5.95483e-19
C327	B1	Y#4	7.39504e-17
C328	VGND#6	VGND#1	3.37372e-19
C329	A1#2	VNB	2.5456e-17
C330	B2#4	B1#6	1.88132e-18
C331	B1#3	VNB	1.97013e-17
C332	B2#4	VNB	7.24203e-17
C333	Y	a_27_368##3	4.33862e-17
C334	Y	a_27_368##2	3.58127e-18
C335	VPWR	VPWR#3	4.71757e-17
C336	B2	a_27_368##7	3.07788e-17
C337	a_771_74#	VGND#6	6.92617e-17
C338	a_27_368##2	a_27_368#	3.39878e-18
C339	VPWR	A3#11	5.36414e-18
C340	VPWR	a_27_368##6	3.09545e-17
C341	Y#3	B1	8.04286e-17
C342	VGND#3	A1#4	7.26459e-19
C343	VPWR	a_27_368##3	4.1586e-18
C344	VPWR	a_27_368##2	2.29348e-17
C345	Y#3	Y#4	4.42647e-18
C346	VGND#3	B1#2	1.79797e-19
C347	VPWR	A2#10	1.23633e-18
C348	Y#1	Y	3.36046e-18
C349	VPWR	Y#4	3.79097e-18
C350	A2	A3#7	1.84491e-19
C351	A2	A3#5	1.90352e-18
C352	VGND	VGND#2	5.03239e-17
C353	a_27_368##2	VPWR#6	9.7411e-17
C354	A2	A2#6	2.13975e-18
C355	B1#2	A1#4	2.94727e-17
C356	A2	A2#7	1.3158e-18
C357	A2	A1#1	2.65662e-18
C358	a_27_74##2	Y#4	6.15488e-18
C359	VGND	a_27_368##2	5.16813e-18
C360	B2#3	A1#4	5.23859e-19
C361	a_507_74#	VGND#6	3.52875e-17
C362	a_771_74##2	a_771_74#	1.37383e-18
C363	VGND	a_507_74##2	2.91765e-17
C364	A2	A1#7	2.24461e-19
C365	VGND	A2#10	1.53496e-18
C366	Y	VPWR#8	2.90195e-18
C367	B2#3	B1#2	7.68069e-19
C368	VGND	Y#4	6.11938e-18
C369	Y	a_27_368##4	2.32061e-17
C370	VPWR#3	VNB	3.29549e-17
C371	VPWR	a_27_368#	1.78958e-17
C372	B2	B1#1	1.3081e-19
C373	VGND	VGND#1	4.19614e-17
C374	VPWR	VPWR#6	2.32927e-17
C375	a_27_368##2	a_27_368##8	1.30869e-17
C376	VGND	a_771_74#	1.6114e-17
C377	B2	B1#6	2.11072e-19
C378	VGND#2	VNB	5.17582e-17
C379	VGND	a_507_74#	2.13944e-17
C380	VGND	a_771_74##2	1.18028e-17
C381	VPWR	a_27_368##9	1.47011e-17
C382	B2	B2#1	7.86057e-19
C383	B1	B2#6	1.07281e-18
C384	A3#11	VNB	1.80679e-17
C385	VPWR	VPWR#8	9.34383e-17
C386	a_27_368##6	VNB	6.59256e-18
C387	VGND	Y#1	1.1539e-17
C388	B1	B2#5	8.08079e-19
C389	VPWR	a_27_368##4	1.97365e-17
C390	B2	B2#7	3.40697e-18
C391	VGND	a_507_74##3	1.93373e-17
C392	a_27_368##3	VPWR#7	1.75093e-17
C393	VPWR	Y#6	8.60923e-18
C394	VGND	a_27_74#	2.4024e-17
C395	a_27_368##2	VNB	7.89105e-18
C396	a_507_74##2	VNB	5.04858e-18
C397	VGND	Y#3	1.15337e-17
C398	VGND	a_27_74##2	1.71138e-17
C399	VPWR	Y#5	9.37348e-18
C400	A2#10	VNB	4.02188e-18
C401	VPWR	a_27_368##7	2.35446e-17
C402	VGND	a_27_74##4	1.49932e-17
C403	Y#4	VNB	4.74989e-18
C404	VGND	a_27_368#	5.2988e-18
C405	A2	A1#4	1.30935e-19
C406	VGND#1	VNB	6.3544e-17
C407	a_771_74#	VNB	6.98939e-18
C408	VGND#6	VNB	5.0565e-18
C409	a_507_74#	VNB	1.03705e-17
C410	Y	A3#5	1.91599e-19
C411	a_771_74##2	VNB	6.81819e-18
C412	a_27_368##2	VPWR#7	7.9373e-17
C413	a_507_74##4	VNB	3.09879e-18
C414	Y	A2#6	3.10363e-19
C415	a_507_74#	a_771_74##2	7.40964e-17
C416	Y#1	VNB	4.90044e-18
C417	VGND	Y#5	3.16088e-18
C418	a_507_74##3	VNB	7.75835e-18
C419	Y	A2#7	1.39832e-18
C420	a_27_368##6	VPWR#8	4.48859e-17
C421	a_27_74#	VNB	9.24296e-18
C422	Y#3	VNB	4.13017e-18
C423	VGND	A3#6	6.41941e-18
C424	Y	A1#1	6.27203e-18
C425	a_27_74##2	VNB	6.13474e-18
C426	VGND	A3#8	3.37573e-19
C427	VGND#7	VNB	2.36945e-18
C428	Y	A1#7	8.3877e-18
C429	VGND	A2#1	1.92361e-18
C430	a_27_74##4	VNB	4.17229e-17
C431	VPWR	A3#7	1.12233e-18
C432	a_27_368#	VNB	5.97338e-17
C433	VGND	A2#5	1.6149e-18
C434	VPWR#6	VNB	4.64333e-18
C435	VPWR	A3#5	2.78829e-19
C436	a_27_368##3	a_27_368##9	2.31718e-18
C437	VGND	A1#5	1.71179e-18
C438	VGND	A1#6	3.83696e-18
C439	VPWR	A2#6	5.05182e-19
C440	VPWR#7	VNB	8.94692e-19
C441	a_27_368##9	VNB	2.47465e-18
C442	VGND	B1#5	1.62356e-18
C443	VPWR	A2#7	9.64498e-20
C444	VPWR#8	VNB	7.25467e-17
C445	VGND	B1#4	3.63781e-18
C446	a_27_368##4	VNB	2.5634e-18
C447	VPWR	A1#1	9.34214e-19
C448	VGND	B2#6	1.03769e-18
C449	VPWR	A1#7	7.03298e-19
C450	VGND	B2#5	1.61734e-18
C451	Y#5	VNB	4.60575e-18
C452	VPWR	B1#1	1.48982e-18
C453	a_27_368##7	VNB	5.4759e-17
C454	A3#6	VNB	3.10959e-17
C455	VPWR	B1#6	1.58597e-18
C456	B1	A1#4	4.04659e-17
C457	A3#8	VNB	2.5824e-17
C458	VPWR	B2#1	1.68084e-18
C459	A2#1	VNB	3.16761e-17
C460	A2#5	VNB	3.03885e-17
C461	B1	B1#2	2.51268e-17
C462	VPWR	B2#7	2.41755e-18
C463	a_507_74##4	a_507_74#	4.29638e-18
C464	A1#5	VNB	2.73996e-17
C465	A1#6	VNB	2.81579e-17
C466	B2#3	B1	1.37997e-17
C467	B1#5	VNB	2.76129e-17
C468	B1#4	VNB	2.69338e-17
C469	Y	A1#4	5.16686e-17
C470	a_27_368##9	a_27_368##2	6.32292e-20
C471	B2#6	VNB	2.46614e-17
C472	B2#5	VNB	3.27014e-17
C473	Y	B1#2	9.67018e-20
C474	A3#7	VNB	4.00481e-17
C475	A3#5	VNB	4.13983e-17
C476	A2#6	VNB	2.96065e-17
C477	VPWR	A1#4	1.93747e-18
C478	A2#7	VNB	2.92597e-17
C479	A1#1	VNB	3.47167e-17
C480	VGND	VGND#3	4.01227e-17
C481	A1#7	VNB	3.1331e-17
C482	VPWR	B2#3	3.76568e-18
C483	B1#1	VNB	3.5597e-17
C484	VGND	A3#1	2.35139e-18
C485	a_27_368##3	VPWR#8	4.50498e-17
C486	B1#6	VNB	3.76875e-17
C487	B2#1	VNB	3.30896e-17
C488	VGND	A1#4	4.53607e-18
C489	B2#7	VNB	4.32631e-17
C490	VGND	B1#2	7.92563e-19
C491	VGND	B2#3	4.08172e-18
C492	VGND#3	VNB	3.18122e-16
C493	Y	A2	2.92329e-17
C494	A3#1	VNB	6.97223e-18
C495	a_507_74##4	a_771_74##2	5.02371e-17
C496	a_27_368##10	B1#3	2.85019e-19
C497	A1#4	VNB	5.49128e-17
C498	VPWR	A2	3.99035e-18
C499	B1#2	VNB	4.04073e-17
C500	VPWR	B2	2.25776e-18
C501	VGND	A2	5.03433e-18
C502	VGND	B2	2.0182e-18
C503	VPWR	B1	3.59716e-18
C504	A2	VNB	4.10914e-18
C505	B2	VNB	2.89093e-17
C506	VPWR	Y	3.51711e-18
C507	VGND	B1	5.31329e-18
C508	VGND	Y	1.34037e-18
C509	B1	VNB	7.17878e-18
C510	Y	VNB	5.5467e-18
C511	a_27_368##6	Y#6	3.283e-17
C512	VPWR	VNB	7.6047e-17
C513	VGND	VNB	8.85595e-17
C514	VGND#4	B2#6	4.7831e-18
C515	VPWR	VPWR#4	2.84661e-17
C516	VPWR#4	B2#1	4.46728e-18
C517	A3#11	VPWR#2	9.56811e-19
C518	a_27_368##6	VPWR#4	3.57511e-17
C519	VPWR#3	VPWR#2	6.3562e-19
C520	VGND#4	VNB	7.14398e-17
C521	VPWR#4	B2#4	8.92496e-20
C522	VGND#4	A1#6	8.12052e-20
C523	VGND#4	a_27_74#	3.14179e-17
C524	VGND#4	B1#3	5.65819e-20
C525	VPWR#4	VPWR#3	4.22905e-17
C526	VGND#4	B1#4	5.0521e-18
C527	VPWR#2	A3#7	2.59958e-18
C528	VGND#4	a_27_74##2	3.273e-17
C529	VGND#3	VGND#4	8.25559e-17
C530	VPWR#2	VNB	5.834e-17
C531	VPWR#4	B2#7	4.46741e-18
C532	VPWR	VPWR#2	4.03798e-17
C533	VGND#4	B2#5	4.59462e-18
C534	a_27_368##7	VPWR#4	5.4279e-17
C535	a_27_368##2	VPWR#2	1.16649e-17
C536	VGND#4	a_27_74##4	1.78605e-17
C537	VPWR#4	VPWR#8	9.36828e-17
C538	VGND	VGND#4	6.76711e-17
C539	a_27_368#	VPWR#2	2.09037e-17
C540	VGND#4	B1#2	6.37752e-20
C541	VPWR#4	VPWR#2	6.74752e-17
C542	VPWR#4	VNB	2.97877e-16
C543	VGND#4	B1#5	4.69561e-18
C544	VPWR#2	A3#2	1.65235e-18
C545	VPWR#2	A3#5	2.6051e-18
*
*
.ENDS sky130_fd_sc_hs__a32oi_2
*
