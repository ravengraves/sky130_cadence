* Extracted by Quantus, converted by sky130cad/quantus.py
*
*
*
*                       LINUX           Wed Nov 18 08:58:15 2026
*
*
*
*  PROGRAM  advgen
*
*  Name           : advgen - Quantus - (64-bit)
*  Version        : 25.1.0-p047
*  Build Date     : Thu Dec 11 23:20:30 PST 2025
*
*  HSPICE LIBRARY
*
*  OPERATING_TEMPERATURE 150
*  QRC_TECH_DIR <path>/tech
*
*
*

*
.SUBCKT sky130_fd_sc_hs__o221ai_4 VNB VPB VGND VPWR Y A1 B2 C1 B1 A2
*
*
*  caps2d version: 10
*
*
*       TRANSISTOR CARDS
*
*
XM3 Y#8 C1#11 a_27_84##5 VNB sky130_fd_pr__nfet_01v8_lvt l=0.15 w=0.74 ad=0.2072 as=0.2109 pd=2.04 ps=2.05
XM19 a_27_84# C1#9 Y#8 VNB sky130_fd_pr__nfet_01v8_lvt l=0.15 w=0.74 ad=0.2072 as=0.2072 pd=2.04 ps=2.04
XM27 a_27_84# C1#8 Y#15 VNB sky130_fd_pr__nfet_01v8_lvt l=0.15 w=0.74 ad=0.2072 as=0.2072 pd=2.04 ps=2.04
XM33 Y#15 C1#6 a_27_84##3 VNB sky130_fd_pr__nfet_01v8_lvt l=0.15 w=0.74 ad=0.2072 as=0.2109 pd=2.04 ps=2.05
XM10 a_483_74##16 B1#7 a_27_84##6 VNB sky130_fd_pr__nfet_01v8_lvt l=0.15 w=0.74 ad=0.2109 as=0.2072 pd=2.05 ps=2.04
XM38 a_27_84##6 B1#4 a_483_74##14 VNB sky130_fd_pr__nfet_01v8_lvt l=0.15 w=0.74 ad=0.2072 as=0.2072 pd=2.04 ps=2.04
XM6 a_483_74##14 B1#1 a_27_84##8 VNB sky130_fd_pr__nfet_01v8_lvt l=0.15 w=0.74 ad=0.2072 as=0.2072 pd=2.04 ps=2.04
XM22 a_483_74##12 B2#12 a_27_84##8 VNB sky130_fd_pr__nfet_01v8_lvt l=0.15 w=0.74 ad=0.2072 as=0.2072 pd=2.04 ps=2.04
XM37 a_27_84##10 B2#8 a_483_74##12 VNB sky130_fd_pr__nfet_01v8_lvt l=0.15 w=0.74 ad=0.2072 as=0.2072 pd=2.04 ps=2.04
XM14 a_27_84##10 B2#6 a_483_74##10 VNB sky130_fd_pr__nfet_01v8_lvt l=0.15 w=0.74 ad=0.2072 as=0.2072 pd=2.04 ps=2.04
XM7 a_483_74##10 B2#1 a_27_84##12 VNB sky130_fd_pr__nfet_01v8_lvt l=0.15 w=0.74 ad=0.2072 as=0.2072 pd=2.04 ps=2.04
XM5 a_27_84##12 B1#12 a_483_74##6 VNB sky130_fd_pr__nfet_01v8_lvt l=0.15 w=0.74 ad=0.2072 as=0.259 pd=2.04 ps=2.18
XM34 VGND#10 A1#3 a_483_74##6 VNB sky130_fd_pr__nfet_01v8_lvt l=0.15 w=0.74 ad=0.3108 as=0.259 pd=2.32 ps=2.18
XM2 VGND#10 A2#6 a_483_74##9 VNB sky130_fd_pr__nfet_01v8_lvt l=0.15 w=0.74 ad=0.3108 as=0.2072 pd=2.32 ps=2.04
XM39 a_483_74##9 A2#10 VGND#9 VNB sky130_fd_pr__nfet_01v8_lvt l=0.15 w=0.74 ad=0.2072 as=0.259 pd=2.04 ps=2.18
XM8 a_483_74##8 A2#8 VGND#9 VNB sky130_fd_pr__nfet_01v8_lvt l=0.15 w=0.74 ad=0.2072 as=0.259 pd=2.04 ps=2.18
XM1 VGND#8 A2#7 a_483_74##8 VNB sky130_fd_pr__nfet_01v8_lvt l=0.15 w=0.74 ad=0.2146 as=0.2072 pd=2.06 ps=2.04
XM24 a_483_74##2 A1#10 VGND#8 VNB sky130_fd_pr__nfet_01v8_lvt l=0.15 w=0.74 ad=0.259 as=0.2146 pd=2.18 ps=2.06
XM23 a_483_74##2 A1#8 VGND#7 VNB sky130_fd_pr__nfet_01v8_lvt l=0.15 w=0.74 ad=0.259 as=0.2072 pd=2.18 ps=2.04
XM35 VGND#7 A1#4 a_483_74# VNB sky130_fd_pr__nfet_01v8_lvt l=0.15 w=0.74 ad=0.2072 as=0.2109 pd=2.04 ps=2.05
XM4 VPWR#13 C1#13 Y#14 VPB sky130_fd_pr__pfet_01v8 l=0.15 w=1.12 ad=0.3304 as=0.336 pd=2.83 ps=2.84
XM20 Y#14 C1#12 VPWR#12 VPB sky130_fd_pr__pfet_01v8 l=0.15 w=1.12 ad=0.336 as=0.4312 pd=2.84 ps=3.01
XM0 VPWR#12 C1#7 Y#13 VPB sky130_fd_pr__pfet_01v8 l=0.15 w=1.12 ad=0.4312 as=0.364 pd=3.01 ps=2.89
XM18 Y#13 C1#1 VPWR#10 VPB sky130_fd_pr__pfet_01v8 l=0.15 w=1.12 ad=0.364 as=0.392 pd=2.89 ps=2.94
XM15 a_508_368##5 B1#9 VPWR#10 VPB sky130_fd_pr__pfet_01v8 l=0.15 w=1.12 ad=0.336 as=0.392 pd=2.84 ps=2.94
XM9 VPWR#8 B1#8 a_508_368##5 VPB sky130_fd_pr__pfet_01v8 l=0.15 w=1.12 ad=0.448 as=0.336 pd=3.04 ps=2.84
XM32 a_508_368##3 B1#5 VPWR#8 VPB sky130_fd_pr__pfet_01v8 l=0.15 w=1.12 ad=0.336 as=0.448 pd=2.84 ps=3.04
XM28 a_508_368##3 B2#14 Y#12 VPB sky130_fd_pr__pfet_01v8 l=0.15 w=1.12 ad=0.336 as=0.336 pd=2.84 ps=2.84
XM31 a_508_368##6 B2#13 Y#12 VPB sky130_fd_pr__pfet_01v8 l=0.15 w=1.12 ad=0.336 as=0.336 pd=2.84 ps=2.84
XM12 Y#11 B2#9 a_508_368##6 VPB sky130_fd_pr__pfet_01v8 l=0.15 w=1.12 ad=0.392 as=0.336 pd=2.94 ps=2.84
XM21 Y#11 B2#5 a_508_368# VPB sky130_fd_pr__pfet_01v8 l=0.15 w=1.12 ad=0.392 as=0.392 pd=2.94 ps=2.94
XM29 VPWR#7 B1#10 a_508_368# VPB sky130_fd_pr__pfet_01v8 l=0.15 w=1.12 ad=0.448 as=0.392 pd=3.04 ps=2.94
XM36 a_1288_368##5 A1#1 VPWR#7 VPB sky130_fd_pr__pfet_01v8 l=0.15 w=1.12 ad=0.3976 as=0.448 pd=2.95 ps=3.04
XM30 a_1288_368##5 A2#12 Y#9 VPB sky130_fd_pr__pfet_01v8 l=0.15 w=1.12 ad=0.3976 as=0.336 pd=2.95 ps=2.84
XM26 a_1288_368##6 A2#11 Y#9 VPB sky130_fd_pr__pfet_01v8 l=0.15 w=1.12 ad=0.336 as=0.336 pd=2.84 ps=2.84
XM13 Y#1 A2#9 a_1288_368##6 VPB sky130_fd_pr__pfet_01v8 l=0.15 w=1.12 ad=0.336 as=0.336 pd=2.84 ps=2.84
XM11 Y#1 A2#1 a_1288_368##2 VPB sky130_fd_pr__pfet_01v8 l=0.15 w=1.12 ad=0.336 as=0.336 pd=2.84 ps=2.84
XM17 a_1288_368##2 A1#12 VPWR#6 VPB sky130_fd_pr__pfet_01v8 l=0.15 w=1.12 ad=0.336 as=0.336 pd=2.84 ps=2.84
XM16 VPWR#6 A1#11 a_1288_368# VPB sky130_fd_pr__pfet_01v8 l=0.15 w=1.12 ad=0.336 as=0.336 pd=2.84 ps=2.84
XM25 VPWR#1 A1#7 a_1288_368# VPB sky130_fd_pr__pfet_01v8 l=0.15 w=1.12 ad=0.3304 as=0.336 pd=2.83 ps=2.84
*
*
*       RESISTOR AND CAP/DIODE CARDS
*
Rg1	C1#1	C1#2	481.995087
Rg2	C1#2	C1#3	50.537102
Rg3	C1#3	C1#4	25.491310
Rg4	C1#4	C1#5	79.361069
Rg5	C1#2	C1#6	338.792633
Rg6	C1#3	C1#7	390.783234
Rg7	C1#4	C1#8	348.718262
Rg8	C1#5	C1#9	356.943298
Rg9	C1#5	C1#10	60.144505
Rg10	C1#10	C1#11	367.139069
Rg11	C1#5	C1#12	429.126801
Rg12	C1#10	C1#13	449.121704
Rg13	B1#1	B1#2	311.332214
Rg14	B1#2	B1#3	34.689194
Rg15	B1#2	B1#4	266.922363
Rg16	B1#3	B1#5	448.589417
Rg17	B1#3	B1#6	46.551746
Rg18	B1#6	B1#7	375.613068
Rg19	B1#3	B1#8	429.126801
Rg20	B1#6	B1#9	479.497131
Rg21	B2#1	B2#2	320.850525
Rg22	B2#2	B2#3	51.867256
Rg23	B2#3	B2#4	42.633938
Rg24	B2#2	B2#5	506.650146
Rg25	B2#3	B2#6	317.184418
Rg26	B2#4	B2#7	32.639194
Rg27	B2#7	B2#8	304.910614
Rg28	B2#4	B2#9	486.547119
Rg29	B2#7	B2#10	34.951508
Rg30	B2#10	B2#11	17.860168
Rg31	B2#11	B2#12	438.325195
Rg32	B2#10	B2#13	415.529358
Rg33	B2#11	B2#14	559.756287
Rg34	B1#10	B1#11	434.639221
Rg35	B1#11	B1#12	382.539734
Rg36	A1#1	A1#2	474.612946
Rg37	A1#2	A1#3	330.892151
Rg38	A2#1	A2#2	503.938385
Rg39	A2#2	A2#3	63.705231
Rg40	A2#3	A2#4	72.291412
Rg41	A2#4	A2#5	72.869621
Rg42	A2#5	A2#6	397.555725
Rg43	A2#2	A2#7	451.838898
Rg44	A2#3	A2#8	418.002014
Rg45	A2#3	A2#9	432.348541
Rg46	A2#4	A2#10	381.829651
Rg47	A2#4	A2#11	433.385468
Rg48	A2#5	A2#12	449.655212
Rg49	A1#4	A1#5	345.908142
Rg50	A1#5	A1#6	73.670235
Rg51	A1#5	A1#7	489.628906
Rg52	A1#6	A1#8	336.672394
Rg53	A1#6	A1#9	64.081955
Rg54	A1#9	A1#10	345.908142
Rg55	A1#6	A1#11	469.100494
Rg56	A1#9	A1#12	489.628906
Rf1	C1	C1#14	9.168082
Rf2	C1#14	C1	5.500849
Rf3	B2	B2#15	12.682109
Rf4	B2#15	B2	4.710497
Rf5	a_27_84#	a_27_84##2	31.091238
Rf6	a_27_84##2	a_27_84##4	83.503090
Rf7	a_27_84##2	a_27_84##5	89.681892
Rf8	a_27_84##4	a_27_84##7	31.890621
Rf9	a_27_84##7	a_27_84##9	57.194447
Rf10	a_27_84##9	a_27_84##11	43.949726
Rf11	a_27_84##11	a_27_84##12	59.530800
Rf12	a_27_84##3	a_27_84##4	7.500000
Rf13	a_27_84##6	a_27_84##7	15.000000
Rf14	a_27_84##8	a_27_84##9	15.000000
Rf15	a_27_84##10	a_27_84##11	15.000000
Rf16	a_508_368#	a_508_368##2	87.125717
Rf17	a_508_368##2	a_508_368##4	72.761169
Rf18	a_508_368##4	a_508_368##5	80.411972
Rf19	a_508_368##2	a_508_368##6	17.756187
Rf20	a_508_368##3	a_508_368##4	7.500000
Rf21	B1#11	B1	163.580948
Rf22	B1	B1#3	217.332764
Rf23	A2	A2#13	3.349972
Rf24	A2#13	A2	14.516547
Rf25	Y#1	Y#2	77.595276
Rf26	Y#2	Y#3	135.711441
Rf27	Y#3	Y#4	69.471481
Rf28	Y#4	Y#5	173.944687
Rf29	Y#5	Y#6	8.701725
Rf30	Y#6	Y#7	65.344719
Rf31	Y#7	Y#8	64.759933
Rf32	Y#2	Y#10	5.468717
Rf33	Y#10	Y	1.976337
Rf34	Y#3	Y#11	12.736860
Rf35	Y#4	Y#12	18.261604
Rf36	Y#5	Y#13	18.560150
Rf37	Y#6	Y#14	79.945030
Rf38	Y#7	Y#15	17.483788
Rf39	Y#9	Y#10	7.500000
Rf40	a_1288_368#	a_1288_368##3	107.339569
Rf41	a_1288_368##3	a_1288_368##4	99.431427
Rf42	a_1288_368##4	a_1288_368##5	84.841637
Rf43	a_1288_368##4	a_1288_368##6	28.306047
Rf44	a_1288_368##2	a_1288_368##3	5.000000
Rf45	A1	A1#13	6.995571
Rf46	A1#13	A1	5.214880
Rf47	A1	A1#2	338.903625
Rf48	a_483_74#	a_483_74##3	95.038383
Rf49	a_483_74##3	a_483_74##4	70.409241
Rf50	a_483_74##4	a_483_74##5	68.002594
Rf51	a_483_74##5	a_483_74##7	67.820412
Rf52	a_483_74##4	a_483_74##8	20.911032
Rf53	a_483_74##5	a_483_74##9	20.911032
Rf54	a_483_74##7	a_483_74##11	51.607098
Rf55	a_483_74##11	a_483_74##13	43.999928
Rf56	a_483_74##13	a_483_74##15	41.941311
Rf57	a_483_74##15	a_483_74##16	56.941311
Rf58	a_483_74##2	a_483_74##3	7.500000
Rf59	a_483_74##6	a_483_74##7	7.500000
Rf60	a_483_74##10	a_483_74##11	15.000000
Rf61	a_483_74##12	a_483_74##13	15.000000
Rf62	a_483_74##14	a_483_74##15	15.000000
Rf63	VPWR#1	VPWR#2	115.238525
Rf64	VPWR#2	VPWR#3	33.270790
Rf65	VPWR#3	VPWR#4	168.722107
Rf66	VPWR#4	VPWR#5	199.403320
Rf67	VPWR#2	VPWR#6	38.736572
Rf68	VPWR#4	VPWR#7	31.141060
Rf69	VPWR#5	VPWR#8	35.446526
Rf70	VPWR#5	VPWR#9	87.891739
Rf71	VPWR#9	VPWR#10	31.141060
Rf72	VPWR#9	VPWR#11	70.079414
Rf73	VPWR#11	VPWR#12	31.534731
Rf74	VPWR#11	VPWR#13	117.268448
Rf76	VGND#2	VGND#3	72.331985
Rf77	VGND#3	VGND#4	66.707092
Rf78	VGND#4	VGND#5	67.887894
Rf79	VGND#5	VGND#6	234.467560
Rf80	VGND#2	VGND#7	33.326477
Rf81	VGND#3	VGND#8	34.103577
Rf82	VGND#4	VGND#9	31.161278
Rf83	VGND#5	VGND#10	31.161278
Rf89	A1#6	A1#13	53.410934
Rf88	A2#4	A2#13	53.410934
Rf84	C1#5	C1#14	53.410934
Rf85	B2#4	B2#15	53.410934
Re1	VPWR#3	VPWR	2.687498
Re2	VPWR	VPWR#5	1.343749
Re3	VGND#3	VGND	2.687498
Re4	VGND	VGND#6	1.343749
*
*       CAPACITOR CARDS
*
*
C1	a_1288_368#	A1#12	1.79792e-18
C2	a_1288_368##2	A1#11	3.70342e-19
C3	a_27_84##3	Y#6	1.579e-17
C4	B1#6	a_508_368##5	1.40529e-18
C5	VPWR#6	A1#12	4.24791e-17
C6	A2#6	A2#10	4.03137e-17
C7	a_27_84##3	C1#4	7.27564e-18
C8	VGND#4	a_483_74##4	6.6782e-18
C9	B1#3	B2#11	2.53263e-17
C10	a_483_74##2	VGND#7	5.5167e-17
C11	a_1288_368#	A2#1	2.11095e-19
C12	a_1288_368##2	A1#12	5.83954e-17
C13	Y#6	C1#7	2.33387e-17
C14	VPWR#6	A2#1	1.3398e-18
C15	Y#1	A1#12	1.56123e-18
C16	B1#3	B2#2	1.1335e-19
C17	B1#3	B1#6	5.87504e-17
C18	a_1288_368##2	A2#1	2.77713e-17
C19	a_1288_368#	VPWR#1	7.6922e-17
C20	a_1288_368##6	A1#12	2.68812e-19
C21	A1#3	A2#6	2.15503e-17
C22	VGND#8	VGND#7	1.92963e-18
C23	VGND#3	VGND#5	2.09152e-17
C24	a_1288_368#	A1#9	1.72513e-19
C25	Y#7	a_27_84#	3.37468e-17
C26	VPWR#3	VPWR#4	3.25945e-17
C27	VGND#3	VGND#4	5.47106e-17
C28	B1#3	C1#4	6.64866e-18
C29	Y#6	C1#12	1.20117e-18
C30	Y#1	A2#1	5.4147e-17
C31	VPWR#3	VPWR#2	7.05115e-17
C32	VPWR#4	A2#5	1.13558e-20
C33	a_1288_368##2	A2#9	6.2318e-19
C34	a_1288_368##6	A2#1	6.2318e-19
C35	VPWR#6	VPWR#1	2.00319e-18
C36	C1#4	Y#15	1.70259e-19
C37	a_1288_368#	A1#5	4.96339e-19
C38	a_483_74##2	VGND#8	3.96367e-17
C39	Y#1	A2#9	5.25727e-17
C40	B1#12	A1#3	2.77931e-17
C41	VPWR#2	A1#5	4.37872e-20
C42	Y#8	Y#7	3.2362e-18
C43	a_1288_368##5	VPWR#4	4.9886e-17
C44	B2#11	B2#2	4.07881e-18
C45	Y#7	B1#6	3.14081e-18
C46	Y#6	C1#13	3.20465e-19
C47	a_1288_368##2	A2#11	2.68812e-19
C48	A2#9	a_1288_368##6	2.39036e-17
C49	a_1288_368#	VPWR#6	7.18737e-17
C50	Y#4	B2#11	2.68149e-18
C51	B1#5	B2#11	2.31942e-19
C52	Y#1	A2#11	1.37698e-18
C53	VPWR#7	A2#1	3.64631e-20
C54	C1#10	C1#5	2.70113e-18
C55	VPWR#6	A1#9	1.50934e-19
C56	B2#1	B1#12	3.79109e-17
C57	Y#2	A2#5	1.14099e-18
C58	C1#5	C1#4	2.45616e-18
C59	A2#11	a_1288_368##6	2.73349e-17
C60	a_1288_368##5	A2#9	3.30346e-19
C61	a_1288_368##2	a_1288_368#	2.52173e-18
C62	a_483_74#	A1#4	3.14176e-17
C63	VPWR#9	VPWR#5	9.5684e-19
C64	A2#11	Y#9	2.32435e-17
C65	VPWR#7	A2#9	6.55408e-20
C66	a_27_84#	C1#4	2.47723e-19
C67	a_1288_368##4	VPWR#3	9.34919e-17
C68	VGND#3	a_483_74##5	1.72466e-17
C69	VGND#9	A2#3	1.90954e-19
C70	B1#7	B1#6	3.87043e-18
C71	a_1288_368##6	A2#12	6.21076e-19
C72	a_1288_368##5	A2#11	7.67865e-19
C73	VGND#3	a_483_74##4	2.56056e-17
C74	VGND#7	A1#4	3.15034e-17
C75	a_1288_368##2	VPWR#6	6.64543e-17
C76	B2#6	B2#1	3.83093e-17
C77	Y#6	B1#6	1.4772e-18
C78	A2#12	Y#9	2.32435e-17
C79	VPWR#7	A2#11	1.84832e-19
C80	B1#6	B2#11	3.3915e-17
C81	a_483_74#	A1#8	8.56418e-19
C82	Y#3	B2#11	1.06644e-18
C83	a_483_74##2	A1#4	8.42524e-19
C84	Y#7	C1#10	1.80144e-19
C85	a_1288_368##5	A2#12	4.10269e-17
C86	a_1288_368##6	A1#1	2.68875e-19
C87	Y#8	C1#10	9.0833e-19
C88	a_508_368#	VPWR#4	4.8637e-17
C89	VGND#9	VGND#8	2.07942e-18
C90	a_483_74##2	a_483_74##9	2.47386e-20
C91	Y#3	Y#2	1.03951e-18
C92	VGND#7	A1#8	3.02947e-17
C93	VPWR#7	A2#12	1.61452e-18
C94	B2#8	B2#6	3.83636e-17
C95	VPWR#4	B2#11	4.79447e-20
C96	a_483_74#	A1#10	1.89549e-19
C97	a_1288_368##5	A1#1	4.23426e-17
C98	C1#4	Y#13	3.35677e-19
C99	Y#1	a_1288_368##2	6.01025e-17
C100	a_483_74##2	A1#8	2.95477e-17
C101	VPWR#3	Y#2	1.12671e-17
C102	A1#1	VPWR#7	3.10908e-17
C103	C1#6	B1#6	3.34387e-19
C104	Y#7	C1#4	1.45029e-17
C105	VGND#7	A1#10	2.01871e-18
C106	a_508_368#	A1#1	7.09181e-19
C107	VGND#8	A1#8	1.2947e-18
C108	B2#12	B2#8	3.83636e-17
C109	VGND#5	a_483_74##6	3.11891e-17
C110	a_1288_368##6	a_1288_368##2	3.40187e-18
C111	VPWR#2	A1#6	4.43789e-20
C112	B1#10	VPWR#7	3.47418e-17
C113	VGND#4	A2#4	2.44833e-20
C114	a_483_74##2	A1#10	3.32459e-17
C115	a_27_84##5	C1#10	1.02472e-19
C116	a_508_368#	B1#10	5.42559e-17
C117	a_1288_368##4	Y#1	3.00876e-17
C118	Y#1	a_1288_368##6	4.10592e-17
C119	VGND#8	A1#10	2.88273e-17
C120	VPWR#7	B2#5	4.61313e-19
C121	B1#1	B2#12	3.70179e-17
C122	C1#4	VPWR#12	1.3922e-18
C123	VPWR#4	A2#4	1.1053e-20
C124	a_483_74##2	A2#7	1.96726e-18
C125	a_508_368##6	B1#10	3.30616e-19
C126	a_508_368#	B2#5	3.88117e-17
C127	Y#6	C1#4	1.12429e-17
C128	B2#5	Y#11	2.48546e-17
C129	VPWR#7	B2#9	2.05192e-19
C130	a_1288_368##4	a_1288_368##6	5.47123e-20
C131	B1#9	B1#6	3.31677e-18
C132	VGND#8	A2#7	2.63001e-17
C133	Y#4	B1#6	2.26675e-18
C134	a_508_368##6	B2#5	1.41256e-18
C135	B1#4	B1#1	3.6599e-17
C136	a_508_368#	B2#9	7.23601e-19
C137	a_483_74##2	A2#8	1.05419e-18
C138	Y#12	B2#5	2.3461e-19
C139	B2#9	Y#11	1.34458e-17
C140	C1#10	Y#14	4.79954e-19
C141	VGND#10	VGND#9	2.07044e-18
C142	a_483_74##5	A2#4	6.64307e-19
C143	VPWR#7	B2#13	6.34433e-20
C144	A2#7	a_483_74##8	6.8043e-18
C145	VPWR#4	A1#2	3.62528e-20
C146	a_483_74##4	A2#4	5.28519e-19
C147	VGND#5	a_483_74##10	2.74098e-17
C148	a_508_368##6	B2#9	4.07903e-17
C149	VGND#5	B1#11	6.90547e-20
C150	a_508_368##2	VPWR#5	4.41782e-17
C151	Y#3	B2#2	2.64017e-19
C152	C1#4	B1#9	2.97895e-18
C153	VGND#8	A2#8	1.47738e-18
C154	a_1288_368##4	Y#9	2.61894e-19
C155	B1#7	B1#4	3.69379e-17
C156	Y#12	B2#9	1.07826e-18
C157	VPWR#8	B2#5	3.89904e-20
C158	VGND#9	A2#7	7.30871e-19
C159	a_1288_368##5	a_1288_368##6	3.79135e-18
C160	A2#3	Y#1	1.3521e-18
C161	VPWR#7	B2#14	3.4801e-20
C162	Y#4	a_508_368##2	3.74908e-18
C163	a_483_74##2	A2#10	5.32387e-19
C164	a_1288_368##4	A2#4	7.03924e-20
C165	a_508_368##6	B2#13	3.66551e-17
C166	Y#7	B1#7	5.62338e-19
C167	A2#8	a_483_74##8	1.44952e-17
C168	VPWR#9	B1#6	2.01357e-20
C169	VGND#3	a_483_74#	1.5685e-17
C170	a_483_74##5	A1#2	6.6077e-17
C171	VPWR#8	B2#9	7.09397e-20
C172	VGND#3	VGND#7	1.82886e-17
C173	B2#13	Y#12	2.35973e-17
C174	VGND#8	A2#10	3.20329e-19
C175	a_1288_368##5	Y#9	3.74083e-19
C176	A2#2	Y#1	1.91788e-18
C177	C1#6	B1#7	5.26746e-18
C178	VGND#3	a_483_74##2	2.65244e-17
C179	A2#8	VGND#9	2.0444e-17
C180	a_508_368##3	B2#13	1.56315e-18
C181	a_508_368##6	B2#14	1.56075e-18
C182	VPWR#4	B2#2	1.81057e-20
C183	VPWR#11	C1#10	6.68725e-21
C184	VGND#3	VGND#8	1.65381e-17
C185	a_483_74##2	A2#6	3.67312e-19
C186	Y#3	a_508_368##2	1.93883e-17
C187	VPWR#8	B2#13	2.11221e-19
C188	B2#14	Y#12	2.62779e-17
C189	Y#7	C1#6	1.69372e-17
C190	VGND#3	VGND#9	1.59654e-17
C191	C1#4	C1#1	4.79645e-19
C192	a_483_74##4	a_483_74##2	2.34241e-18
C193	a_508_368##3	B2#14	5.64737e-17
C194	VPWR#2	A1#7	2.40272e-18
C195	a_483_74##6	A2#7	3.62075e-19
C196	VGND#6	a_27_84##2	7.54066e-17
C197	C1#8	C1#6	3.91449e-17
C198	a_1288_368##4	VPWR#4	1.22522e-17
C199	A2#7	A1#9	1.86439e-18
C200	Y#2	A2#4	2.32782e-18
C201	VGND#9	A2#10	2.97008e-17
C202	VPWR#8	B2#14	5.18866e-19
C203	VGND#3	VGND#10	3.90979e-18
C204	Y#12	B1#5	1.05563e-18
C205	A2#3	a_1288_368##6	5.12693e-20
C206	a_483_74##6	VGND#10	4.43993e-17
C207	VPWR#7	a_1288_368##5	3.93805e-17
C208	VPWR#11	C1#4	1.7009e-20
C209	a_508_368##3	B1#5	5.33483e-17
C210	A2#10	a_483_74##9	6.8043e-18
C211	a_508_368##5	VPWR#9	8.49278e-18
C212	Y#7	C1#8	2.57358e-17
C213	a_483_74##6	A2#8	5.32321e-19
C214	B1#5	VPWR#8	3.11893e-17
C215	a_27_84##2	Y#7	2.82633e-17
C216	Y#12	B1#8	6.53916e-19
C217	C1#9	C1#8	3.9727e-17
C218	VGND#9	A2#6	1.47042e-18
C219	a_483_74##4	VGND#8	3.7539e-17
C220	Y#13	B2#14	2.62764e-19
C221	A1#2	Y#2	1.89897e-17
C222	a_508_368##5	B1#5	5.24626e-19
C223	VPWR#2	A1#11	5.37254e-18
C224	VGND#10	A2#10	1.24834e-18
C225	a_508_368##3	B1#8	8.22111e-19
C226	a_27_84##2	Y#15	1.84914e-19
C227	VPWR#10	B1#5	2.8528e-19
C228	A2#5	Y#9	2.74109e-19
C229	B1#8	VPWR#8	3.32178e-17
C230	A2#6	a_483_74##9	1.44952e-17
C231	Y#12	B1#9	3.08643e-19
C232	a_483_74##6	A2#10	8.40732e-19
C233	Y#13	B1#5	2.93366e-19
C234	VGND#7	A1#6	2.79104e-19
C235	Y#2	Y#1	2.33476e-18
C236	a_508_368##5	B1#8	5.52863e-17
C237	C1#11	C1#9	3.78459e-17
C238	a_508_368#	VPWR#7	5.97774e-17
C239	VGND#9	A1#3	3.31733e-19
C240	Y#7	C1#9	1.10571e-18
C241	a_483_74##2	A1#6	3.87854e-18
C242	Y#3	B1#11	5.42754e-19
C243	A2#6	VGND#10	2.33124e-17
C244	VPWR#10	B1#8	7.67963e-19
C245	a_483_74##6	a_27_84##12	4.48274e-17
C246	a_483_74##5	a_483_74##4	2.42159e-18
C247	VPWR#8	B1#9	7.67963e-19
C248	a_483_74##4	a_483_74##8	2.36398e-18
C249	a_27_84##2	a_27_84#	6.08911e-19
C250	Y#12	C1#1	3.22036e-19
C251	a_483_74##5	A2#5	5.77504e-19
C252	A2	A2#5	1.25324e-17
C253	VPWR#9	C1#4	2.52705e-20
C254	VPWR#11	C1#5	4.62648e-20
C255	Y#13	B1#8	4.79642e-19
C256	VPWR#2	A1#12	4.18867e-18
C257	A2	A2#3	1.57348e-17
C258	a_508_368##5	B1#9	4.24449e-17
C259	a_483_74##5	VGND#9	3.70956e-17
C260	A2	A2#2	6.06882e-18
C261	Y#13	VPWR#11	7.76022e-18
C262	a_483_74##6	A2#6	2.45433e-18
C263	VGND#6	a_483_74##10	9.274e-18
C264	B1#9	VPWR#10	2.73773e-17
C265	Y#6	VPWR#11	2.15613e-19
C266	VPWR#8	C1#1	2.81672e-19
C267	VPWR#3	VPWR#1	5.88013e-17
C268	Y#2	a_1288_368##6	4.67004e-17
C269	A1#3	VGND#10	2.49114e-17
C270	Y#13	B1#9	8.72653e-19
C271	VPWR#3	a_1288_368#	1.87995e-17
C272	Y#7	C1#11	3.70885e-20
C273	VGND#6	a_483_74##12	3.6961e-17
C274	a_508_368##5	C1#1	9.80297e-19
C275	Y#13	VPWR#9	6.6769e-18
C276	a_27_84##2	Y#8	1.77616e-17
C277	a_508_368#	Y#11	2.93017e-19
C278	VPWR#10	C1#1	4.76034e-17
C279	a_1288_368##5	A2#5	8.58444e-20
C280	a_483_74##4	VGND#9	4.11413e-17
C281	VGND#9	A2#4	7.66301e-19
C282	VGND#6	a_483_74##14	3.74801e-17
C283	C1#12	C1#4	1.61014e-19
C284	a_483_74##6	A1#3	6.03209e-17
C285	a_1288_368##2	VPWR#3	4.42824e-17
C286	Y#7	B1#3	5.49311e-18
C287	VPWR#2	A2#1	6.06786e-19
C288	C1#1	Y#13	3.30714e-17
C289	a_483_74##5	a_483_74##9	2.37132e-18
C290	Y#6	B1#3	4.36356e-17
C291	VPWR#3	Y#1	9.59844e-18
C292	Y#6	VPWR#9	9.43208e-19
C293	a_27_84##12	a_483_74##10	3.7608e-17
C294	VGND#10	B1#12	1.16184e-18
C295	VGND#6	a_483_74##16	2.72901e-17
C296	VPWR#12	C1#1	1.74953e-18
C297	Y#2	Y#9	6.11841e-19
C298	a_508_368##6	a_508_368#	4.30643e-18
C299	VPWR#10	C1#7	1.89136e-18
C300	a_27_84##12	A1#3	6.91634e-19
C301	B1#3	Y#4	1.19703e-16
C302	VGND#6	a_27_84##3	4.25952e-17
C303	Y#14	C1#1	1.88123e-19
C304	a_27_84##5	VPWR#13	3.66633e-19
C305	C1#7	Y#13	3.67486e-17
C306	B1	A2#5	4.10649e-19
C307	A1#11	A1#7	4.78238e-17
C308	B2#11	a_483_74##10	7.06525e-19
C309	a_483_74##6	B1#12	3.69696e-17
C310	VPWR#3	a_1288_368##5	1.1866e-17
C311	C1#7	VPWR#12	3.21552e-17
C312	B1	B2#11	6.18705e-18
C313	VPWR#10	C1#12	2.96671e-19
C314	Y#7	C1#5	5.133e-19
C315	A1#2	VGND#10	2.82813e-18
C316	a_483_74##6	a_483_74##12	6.46853e-20
C317	VGND#10	B2#1	5.97149e-19
C318	Y#14	C1#7	5.19144e-19
C319	VPWR#2	A2#9	2.62065e-19
C320	a_483_74##5	VGND#10	4.08159e-17
C321	Y#6	C1#5	1.90709e-19
C322	B1	B2#2	1.17893e-17
C323	Y#13	C1#12	1.76599e-19
C324	a_27_84##12	B1#12	2.72042e-17
C325	a_483_74##6	A1#2	4.03512e-17
C326	VGND#6	a_27_84##5	4.9163e-17
C327	B1	B1#6	4.08412e-19
C328	Y#2	a_1288_368##5	3.84885e-17
C329	VPWR#13	C1#7	2.58493e-19
C330	Y#14	VPWR#11	1.68601e-17
C331	a_508_368##2	B2#11	3.12259e-19
C332	A1#12	A1#11	4.90967e-17
C333	C1#12	VPWR#12	3.58011e-17
C334	a_483_74##6	B2#1	1.92386e-18
C335	Y#3	VPWR#7	2.05552e-17
C336	a_483_74##4	A2#3	7.96656e-19
C337	Y#14	C1#12	7.13262e-17
C338	A1#2	a_27_84##10	1.64733e-20
C339	a_27_84##2	B1#7	1.14052e-21
C340	A2#2	A1#12	2.08748e-18
C341	a_483_74##10	a_27_84##10	3.31657e-17
C342	VPWR#13	C1#12	1.23062e-18
C343	VGND#10	B2#6	2.86408e-19
C344	VPWR#4	A2#11	1.71125e-18
C345	VPWR#12	C1#13	1.46384e-18
C346	a_27_84##12	B2#1	3.37293e-17
C347	a_483_74##6	B1#11	2.71433e-18
C348	A2#1	A1#12	4.72206e-17
C349	Y#12	a_508_368##6	2.75646e-17
C350	a_27_84##12	B2#2	1.80242e-18
C351	Y#14	C1#13	5.42778e-17
C352	a_483_74##6	a_483_74##5	2.76488e-18
C353	Y#2	VPWR#7	3.11412e-17
C354	VPWR#2	A2#11	7.21942e-20
C355	a_1288_368#	A1#6	1.07559e-18
C356	a_483_74##6	B2#6	1.07433e-18
C357	C1#13	VPWR#13	3.3245e-17
C358	B2#11	a_27_84##10	5.87575e-18
C359	VPWR#6	A1#6	5.00927e-19
C360	VPWR#13	VPWR#11	8.82913e-19
C361	a_483_74##10	B2#1	3.39427e-17
C362	Y#3	a_508_368#	8.50222e-17
C363	a_27_84##2	C1#6	2.10682e-18
C364	a_483_74##4	A2#2	5.21466e-19
C365	VGND#10	B2#8	2.23174e-19
C366	a_508_368##3	a_508_368##6	5.01824e-18
C367	A2#9	A2#1	4.69513e-17
C368	VPWR#3	A2#3	1.12044e-20
C369	a_27_84##12	B2#4	1.47973e-17
C370	a_27_84##2	C1#5	2.10119e-19
C371	VPWR#3	A2#2	1.234e-20
C372	VPWR#4	A2#12	4.46413e-18
C373	C1	C1#10	2.40107e-17
C374	a_27_84##8	B1#12	4.43023e-19
C375	C1	C1#4	1.66158e-17
C376	a_483_74##6	B2#8	6.57685e-19
C377	A2#3	A2#1	1.86509e-19
C378	a_508_368##3	VPWR#5	4.17253e-17
C379	a_483_74##10	B2#6	3.39371e-17
C380	a_27_84##10	B2#4	6.94071e-17
C381	VPWR#2	A2#12	4.15992e-20
C382	a_508_368##3	Y#12	3.38779e-17
C383	a_27_84##10	a_483_74##12	3.4907e-17
C384	Y#1	A2#4	4.52977e-19
C385	A2#11	A2#9	4.80046e-17
C386	a_1288_368##4	A2#1	5.93806e-18
C387	A2#2	A1#9	2.24704e-17
C388	Y#3	Y#11	3.48703e-18
C389	a_483_74#	VPWR#1	1.45846e-19
C390	a_27_84##2	C1#8	7.25247e-18
C391	a_27_84##8	B2#4	1.70283e-17
C392	a_508_368##5	VPWR#5	8.78455e-18
C393	A2#4	a_1288_368##6	1.11967e-18
C394	a_27_84##10	B2#6	2.93266e-17
C395	VGND#5	VGND#4	9.55651e-19
C396	A2#4	Y#9	2.70455e-19
C397	B2#2	a_483_74##10	6.64784e-19
C398	a_27_84##8	B2#1	3.35895e-19
C399	Y#4	a_508_368##6	1.41023e-17
C400	VGND#3	A1#9	4.5045e-20
C401	a_483_74##6	B2#12	4.62467e-19
C402	a_1288_368##5	A2#4	1.31628e-20
C403	A2#12	A2#11	4.60019e-17
C404	VPWR#4	A1#1	4.26566e-18
C405	B2#11	a_483_74##12	3.01992e-18
C406	a_483_74##14	a_483_74##10	8.14908e-20
C407	VGND#3	A1#4	1.44177e-18
C408	a_27_84##8	B1#3	2.80113e-17
C409	a_483_74##14	B2#1	1.6339e-19
C410	C1#4	B1#6	2.02921e-17
C411	VGND#3	A1#8	6.69776e-19
C412	a_27_84##2	C1#9	7.28151e-18
C413	a_27_84##10	B2#8	2.93266e-17
C414	Y#3	a_508_368##6	5.04787e-17
C415	a_1288_368##4	A2#9	1.58461e-17
C416	a_508_368##3	VPWR#8	5.07789e-17
C417	VGND#3	A2#3	9.74797e-21
C418	Y#3	VPWR#4	5.79561e-19
C419	a_27_84##6	B1#3	7.5718e-17
C420	a_1288_368##5	A1#2	3.15972e-19
C421	a_27_84##8	B2#6	6.23212e-19
C422	VGND#3	A1#10	1.33324e-18
C423	VGND#3	A2#2	4.15215e-20
C424	VPWR#7	A1#2	2.86165e-19
C425	A1#1	A2#12	3.38903e-17
C426	VGND#3	A2#7	1.84526e-18
C427	Y#4	Y#12	1.21298e-18
C428	a_483_74##12	a_27_84##8	3.69952e-17
C429	a_483_74##12	B2#8	3.39523e-17
C430	VGND#3	A2#8	2.1676e-20
C431	a_483_74##14	B2#6	2.38327e-19
C432	a_508_368##5	a_508_368##3	2.64007e-18
C433	Y#12	VPWR#10	1.07806e-21
C434	a_508_368#	B2#11	2.05109e-20
C435	VGND#3	A2#10	5.69751e-19
C436	VPWR#4	B1#10	4.25489e-18
C437	a_27_84##2	C1#11	1.70769e-20
C438	a_27_84##8	B2#8	1.0532e-18
C439	B1#11	VPWR#7	8.24419e-19
C440	B1#10	A1#1	3.1353e-17
C441	VGND#3	A2#6	1.11581e-19
C442	Y#12	Y#3	3.31e-18
C443	a_27_84##10	B2#2	4.2208e-20
C444	a_1288_368##4	A2#11	1.57198e-17
C445	Y#2	VPWR#4	5.79561e-19
C446	a_483_74##12	B2#12	3.39078e-17
C447	a_508_368##5	VPWR#8	4.3006e-17
C448	A1	A1#9	1.87753e-17
C449	A1	A1#5	2.43343e-17
C450	a_483_74##14	B2#8	4.01692e-19
C451	a_27_84##8	B2#11	1.52329e-17
C452	a_27_84#	C1#5	4.26947e-19
C453	Y#4	a_508_368##3	5.76418e-17
C454	A1	A2#3	8.97657e-18
C455	A1	A2#2	2.45093e-17
C456	Y#8	C1#5	3.18645e-18
C457	B2#5	B1#10	3.44472e-17
C458	a_27_84##5	C1#5	1.4491e-20
C459	a_27_84##8	B2#12	3.54879e-17
C460	VPWR#10	VPWR#8	1.69573e-18
C461	VPWR#4	B2#5	4.46319e-18
C462	a_27_84##8	a_483_74##14	3.54932e-17
C463	a_483_74##14	B2#12	7.30224e-19
C464	VGND#4	A2#8	2.72844e-18
C465	B2#9	B2#5	3.53499e-17
C466	A2#11	A2#3	2.31942e-19
C467	Y#6	a_508_368##5	4.10907e-17
C468	VPWR#5	B2#11	1.00698e-19
C469	Y#4	VPWR#8	2.13027e-18
C470	VPWR#10	a_508_368##5	5.30425e-17
C471	a_27_84##8	B1#1	2.86462e-17
C472	VGND#6	B2#6	2.6678e-18
C473	B2#13	B2#9	4.70287e-17
C474	a_27_84##6	a_27_84##8	4.39065e-18
C475	B1#3	Y#12	5.24544e-19
C476	a_508_368##2	Y#11	7.56317e-19
C477	Y#2	A2#9	1.65817e-18
C478	VGND#6	B2#8	5.3356e-18
C479	a_483_74##14	B1#1	3.44826e-17
C480	B1#3	a_508_368##3	4.22112e-19
C481	A2	Y#2	6.20248e-17
C482	VPWR#4	B2#9	4.46319e-18
C483	B1#3	VPWR#8	8.32959e-19
C484	VGND#6	B2#12	5.36401e-18
C485	a_483_74##14	B2#11	7.12005e-19
C486	VPWR#5	B1#6	1.28902e-19
C487	Y#6	VPWR#10	4.43982e-17
C488	a_27_84##8	B1#4	7.38729e-19
C489	A1#2	A2#10	8.10938e-18
C490	VGND#6	B1#1	5.30069e-18
C491	a_508_368#	B2#2	5.41682e-20
C492	VGND#4	A2#10	1.2017e-18
C493	a_27_84##6	B1#1	7.39611e-19
C494	B2#14	B2#13	4.77261e-17
C495	Y#4	a_508_368##5	1.99447e-17
C496	A1#2	A2#6	1.11702e-17
C497	VGND#6	B1#4	5.35671e-18
C498	a_27_84##3	B2#12	3.42045e-19
C499	C1	VPWR#11	6.56378e-20
C500	a_483_74##14	a_27_84##6	3.56625e-17
C501	Y#13	VPWR#10	4.57986e-17
C502	A1#2	A1#3	5.14243e-18
C503	VGND#6	B1#7	5.31202e-18
C504	VPWR#3	A1#7	2.5437e-18
C505	a_483_74##14	B1#4	3.45577e-17
C506	a_508_368##2	a_508_368##6	4.35239e-20
C507	B1#12	A1#2	3.24169e-18
C508	Y#2	A2#11	3.36645e-17
C509	VGND#6	C1#6	3.88345e-18
C510	B1	Y#4	7.41273e-18
C511	VPWR#3	A1#11	7.37075e-19
C512	B1	Y#3	1.18242e-16
C513	A1#2	B2#1	6.76194e-19
C514	B1#5	B2#14	4.74776e-17
C515	VGND#6	B2#11	3.57523e-19
C516	VGND#5	A2#6	2.69926e-18
C517	VGND#6	C1#8	3.8754e-18
C518	VPWR#3	A1#12	1.59644e-18
C519	A1#2	B2#6	3.8748e-19
C520	a_27_84##6	B1#4	2.9822e-17
C521	a_1288_368##4	A2#3	7.726e-20
C522	VPWR#12	VPWR#10	1.97611e-18
C523	C1#5	VPWR#12	4.85843e-19
C524	VGND#6	C1#9	3.8754e-18
C525	a_27_84##3	B1#1	5.19275e-19
C526	a_508_368##6	B2#11	5.75282e-19
C527	Y#6	Y#13	2.056e-18
C528	A1#2	B2#8	3.12211e-19
C529	VPWR#3	A2#1	5.93069e-18
C530	A2#3	A2#2	2.9073e-18
C531	C1#5	Y#14	3.82453e-18
C532	VGND#6	C1#11	3.8754e-18
C533	B2#4	A2#6	1.23875e-19
C534	Y#3	A2#12	1.23176e-19
C535	a_483_74##14	B1#7	3.01688e-19
C536	B1#8	B1#5	3.0167e-17
C537	VPWR#3	A2#9	5.9873e-18
C538	B2#4	A1#3	1.7482e-19
C539	Y#7	C1	4.23237e-17
C540	a_508_368##2	Y#12	1.48214e-17
C541	C1	Y#6	4.50345e-17
C542	VPWR#3	A2#11	4.3108e-18
C543	B2#4	B1#12	5.79918e-19
C544	VPWR#12	Y#13	5.65066e-17
C545	Y#2	A2#12	3.47387e-17
C546	A1#9	A1#6	3.58112e-18
C547	a_27_84##6	B1#7	3.55712e-17
C548	VPWR#3	A2#12	1.48486e-18
C549	VGND#6	B1#6	4.84173e-19
C550	a_27_84##3	B1#4	8.10816e-19
C551	B1#9	B1#8	4.56924e-17
C552	A1#6	A1#5	3.71666e-18
C553	a_483_74##4	A1#8	1.86909e-19
C554	a_27_84##6	a_483_74##16	4.36842e-17
C555	a_27_84##3	a_483_74##14	4.43001e-19
C556	VGND#5	A2#5	2.04027e-20
C557	VGND#5	A1#3	2.69926e-18
C558	a_1288_368##4	A2#2	9.32843e-20
C559	a_483_74##14	C1#6	9.76464e-20
C560	Y#6	VPWR#12	2.49646e-17
C561	a_27_84##8	B1#6	7.20449e-18
C562	VGND#6	C1#10	1.01074e-20
C563	a_483_74##16	B1#7	5.42185e-17
C564	Y#14	Y#13	5.46986e-19
C565	VPWR	C1#4	6.28518e-21
C566	A1#1	A2#5	1.78369e-18
C567	Y#3	A1#1	2.26555e-19
C568	B2#2	B1#12	3.51745e-18
C569	VGND#6	C1#4	8.26058e-20
C570	C1#1	B1#9	3.87475e-17
C571	a_483_74##6	B1	1.49142e-17
C572	a_27_84##3	B1#7	4.97704e-18
C573	a_27_84##12	B1	2.265e-17
C574	B2#4	B1#7	4.5138e-19
C575	Y#2	A1#1	3.34705e-17
C576	Y#14	VPWR#12	7.11658e-17
C577	A1	VPWR#2	2.29178e-20
C578	B2#11	Y#12	7.89595e-19
C579	C1#7	C1#1	4.13901e-17
C580	a_483_74##16	C1#6	5.64458e-19
C581	a_483_74##4	A1#10	4.27755e-19
C582	a_483_74##5	A1	5.36685e-18
C583	Y#14	Y#6	2.23174e-18
C584	a_483_74##4	A1	7.16641e-17
C585	VGND#5	B1#12	5.31202e-18
C586	A2	Y#1	4.62829e-17
C587	Y#3	B1#10	2.06824e-17
C588	VPWR#13	VPWR#12	1.47906e-18
C589	a_27_84##3	C1#6	1.9497e-17
C590	A1	a_1288_368##4	6.92661e-20
C591	C1#12	C1#7	3.34545e-17
C592	VPWR#5	B2#13	4.43427e-18
C593	a_27_84#	B1#7	5.64559e-20
C594	a_27_84##3	a_483_74##16	3.93805e-17
C595	Y#2	B1#10	1.54619e-18
C596	VPWR#5	B2#14	4.48035e-18
C597	VGND	B2#11	1.1684e-18
C598	a_508_368##2	VPWR#4	2.59537e-17
C599	C1#6	Y#15	1.44708e-17
C600	VGND#4	A2#5	2.67502e-20
C601	VGND	B2#2	6.43361e-19
C602	VPWR#5	B1#5	2.28339e-18
C603	A2#5	A2#4	2.85614e-18
C604	VGND	B1#6	1.43898e-18
C605	VPWR#13	Y#14	7.75662e-17
C606	C1#13	C1#12	4.57052e-17
C607	a_483_74##14	B1#6	1.73189e-18
C608	A2#4	A2#3	2.16813e-18
C609	VPWR#5	B1#8	2.54926e-18
C610	a_483_74##4	A2#7	1.86896e-17
C611	a_27_84##3	C1#8	4.28823e-19
C612	C1	a_27_84#	2.51339e-18
C613	a_27_84#	C1#6	7.17029e-19
C614	a_483_74#	A1#5	3.29771e-19
C615	C1	Y#8	6.11987e-17
C616	B1	VPWR#7	1.43253e-18
C617	B1#11	A1#1	1.34976e-18
C618	a_27_84##5	C1	3.38206e-17
C619	Y#3	B2#5	3.30662e-17
C620	a_483_74##6	Y#3	9.3969e-19
C621	VGND#5	B2#1	5.3356e-18
C622	B1	Y#11	2.6021e-19
C623	B1	a_508_368##6	9.06257e-19
C624	C1#8	Y#15	1.44708e-17
C625	a_483_74#	A1	4.65596e-17
C626	B2#5	B1#11	2.41353e-18
C627	A1	VGND#7	2.54221e-18
C628	Y#2	B2#5	4.71385e-19
C629	a_508_368##3	B2#11	4.36852e-20
C630	a_483_74##5	A2#8	4.04506e-19
C631	A1	a_483_74##2	8.44285e-17
C632	A1	VGND#8	2.39322e-19
C633	A1	VGND#9	5.1761e-19
C634	a_27_84##3	C1#9	1.87241e-19
C635	C1#8	a_27_84#	1.48359e-17
C636	VGND#4	A2#3	2.04027e-20
C637	VPWR	VPWR#11	6.90094e-17
C638	VPWR	VPWR#9	6.01753e-17
C639	VPWR	VPWR#4	1.12549e-16
C640	a_483_74##4	A2#8	2.78471e-17
C641	a_483_74##6	Y#2	2.98821e-18
C642	A1#2	A1#9	3.98694e-19
C643	Y#3	B2#9	2.444e-17
C644	VPWR#9	B1#9	4.51764e-18
C645	Y#8	C1#8	1.05861e-18
C646	VPWR#11	VPWR#9	1.05045e-18
C647	B1#3	B2#13	6.60725e-18
C648	VGND#5	B2#11	4.23807e-20
C649	VGND#5	B2#6	2.65001e-18
C650	a_27_84##6	B1#6	1.25356e-17
C651	Y#2	B2#9	3.31876e-19
C652	B1#3	B2#14	6.60725e-18
C653	A1#2	A2#5	4.34726e-17
C654	VPWR	Y#6	8.63243e-18
C655	C1#9	a_27_84#	1.70149e-17
C656	C1	Y#14	5.72802e-17
C657	a_27_84#	a_27_84##3	2.25695e-18
C658	VPWR	Y#4	6.55861e-18
C659	a_483_74##5	A2#10	1.92383e-17
C660	a_27_84##5	C1#8	1.91643e-19
C661	VPWR	Y#3	1.42781e-17
C662	A1	VPWR#1	3.43328e-17
C663	C1	VPWR#13	3.34287e-17
C664	B1#3	B1#5	5.37304e-18
C665	VPWR	Y#2	5.12239e-18
C666	A1	a_1288_368#	6.8775e-17
C667	B1#3	B1#8	4.92144e-18
C668	A1	a_1288_368##2	4.8941e-17
C669	VGND#7	A1#5	5.51602e-19
C670	A1	Y#1	4.88176e-18
C671	VGND	VGND#5	1.01232e-16
C672	VPWR	a_508_368##2	3.12746e-17
C673	Y#4	B2#13	1.54198e-17
C674	VGND#3	A1#6	3.45694e-20
C675	B1#3	B1#9	4.22033e-18
C676	VPWR#3	A2#4	2.1576e-20
C677	Y#8	C1#9	4.46055e-17
C678	A1#8	A1#4	3.80331e-17
C679	B1#3	C1#1	6.44334e-19
C680	VPWR#2	VPWR#1	7.06045e-19
C681	a_483_74##4	A2#10	9.20264e-19
C682	Y#3	B2#13	1.2511e-18
C683	B1#3	C1#7	3.36362e-19
C684	VGND	a_483_74##5	9.22965e-19
C685	a_27_84#	C1#11	8.45307e-19
C686	VGND#3	A1#2	4.47499e-18
C687	Y#6	B2#14	5.40539e-20
C688	a_27_84##5	C1#9	8.66415e-19
C689	VPWR#9	C1#1	1.82531e-18
C690	VGND	Y#7	1.12e-17
C691	VGND	Y#6	9.05534e-19
C692	Y#8	C1#11	3.36662e-17
C693	A1#2	B2#2	6.44871e-19
C694	a_483_74##5	A2#6	2.8859e-17
C695	A2	A2#1	1.08576e-18
C696	a_483_74##2	A1#9	1.16097e-18
C697	A1	A1#4	1.03099e-18
C698	A1	A1#8	1.26123e-18
C699	A2	A2#11	2.04856e-18
C700	Y#4	B2#14	1.34232e-17
C701	A1	A1#10	4.12428e-18
C702	A1	A2#7	8.63134e-18
C703	A2	A2#12	2.43894e-18
C704	A1#2	A2#4	7.19129e-18
C705	a_508_368##2	B2#9	2.01223e-17
C706	VGND	a_27_84##2	2.84637e-17
C707	A1#10	A1#8	2.85759e-17
C708	A1#9	VNB	1.99574e-17
C709	A1	A2#8	8.01746e-18
C710	A1#5	VNB	3.5442e-17
C711	A2#5	VNB	2.52078e-17
C712	A2	A1#1	7.54292e-19
C713	a_27_84##5	C1#11	2.96357e-17
C714	A2#3	VNB	2.31917e-17
C715	A2#2	VNB	2.59816e-17
C716	B2#11	VNB	8.98855e-17
C717	B1	A2#9	4.23811e-19
C718	A2	B1#10	1.92472e-19
C719	B2#2	VNB	2.48254e-17
C720	Y#3	B2#14	2.87581e-19
C721	B1#6	VNB	1.06113e-16
C722	a_483_74##16	B1#6	1.11787e-18
C723	a_483_74##4	A2#6	1.91698e-19
C724	C1#10	VNB	3.29759e-17
C725	C1#4	VNB	5.30055e-17
C726	B1	A2#11	5.15014e-19
C727	a_1288_368#	VPWR#2	1.70072e-17
C728	VPWR#11	C1#7	1.26427e-18
C729	VGND	VGND#10	1.20516e-17
C730	B1	A2#12	1.15967e-18
C731	B1#11	A1#2	3.79236e-17
C732	VGND	a_483_74##6	2.64338e-17
C733	Y#6	B1#5	3.13997e-19
C734	VPWR	a_1288_368##5	1.01679e-17
C735	VGND	a_27_84##12	6.73237e-18
C736	VPWR	VPWR#7	2.24961e-17
C737	B1	A1#1	4.33504e-18
C738	VGND	a_483_74##10	2.25865e-17
C739	VGND#6	C1#5	4.26194e-20
C740	VPWR	a_508_368#	2.47418e-17
C741	VGND	a_27_84##10	7.07381e-18
C742	VGND	a_483_74##12	2.27469e-17
C743	B1	B1#10	4.82168e-18
C744	B2#4	A1#2	5.456e-18
C745	VGND	a_27_84##8	8.52322e-18
C746	VGND	a_483_74##14	2.37484e-17
C747	VPWR	Y#12	6.00652e-18
C748	B1	B2#5	1.44189e-17
C749	a_508_368##3	B1#6	9.60293e-19
C750	VGND	a_27_84##6	7.94178e-18
C751	VPWR	a_508_368##3	2.37926e-17
C752	VGND	a_483_74##16	1.81264e-17
C753	VGND	a_27_84##3	2.53344e-17
C754	VPWR	VPWR#8	1.55399e-17
C755	B1	B2#9	1.65274e-17
C756	B2#4	B1#11	1.73257e-19
C757	a_483_74##2	A1#5	1.19128e-18
C758	VPWR	a_508_368##5	1.81615e-17
C759	Y#7	Y#6	2.15332e-18
C760	VPWR	VPWR#10	2.11072e-17
C761	VGND	Y#8	8.9329e-18
C762	VPWR	Y#13	1.54421e-17
C763	VGND	a_27_84##5	2.26235e-17
C764	VPWR	VPWR#12	2.09019e-17
C765	a_483_74##5	A1#3	5.31798e-19
C766	Y#8	a_27_84#	3.31756e-17
C767	VPWR	Y#14	1.80417e-17
C768	VPWR	VPWR#13	5.7724e-17
C769	Y#4	B1#5	1.29918e-17
C770	B1#3	B2#4	3.40107e-17
C771	a_508_368##2	B2#13	2.02457e-17
C772	A1	A1#7	7.57398e-18
C773	A1	A1#11	3.87191e-18
C774	A2#7	A1#10	3.67269e-17
C775	A1	A1#12	3.90573e-18
C776	A1	A2#1	6.645e-18
C777	VGND#5	VNB	6.57802e-17
C778	VGND#4	VNB	2.86874e-17
C779	VPWR#3	A2	4.99649e-18
C780	VPWR#11	VNB	3.55699e-17
C781	VPWR#9	VNB	2.96847e-17
C782	VPWR#4	VNB	7.87525e-17
C783	Y#6	B1#8	7.51416e-18
C784	VPWR#2	VNB	2.75746e-17
C785	VGND#3	A2	6.22326e-18
C786	B2#2	B1#11	2.9451e-17
C787	VPWR#11	C1#12	2.58378e-18
C788	a_483_74##5	VNB	2.08243e-18
C789	B2#11	B2#9	2.56117e-18
C790	a_483_74##4	VNB	2.08243e-18
C791	C1	C1#12	2.05901e-18
C792	a_1288_368##4	VNB	5.30866e-18
C793	a_27_84##5	a_27_84#	2.29578e-18
C794	C1	C1#13	5.88819e-18
C795	Y#7	VNB	1.70493e-18
C796	Y#6	VNB	2.1972e-18
C797	VGND	A1#3	2.40704e-19
C798	VGND	B1#12	7.47836e-19
C799	A2	A2#4	1.88869e-17
C800	a_508_368##2	VNB	5.33278e-18
C801	VGND	B2#1	7.0348e-19
C802	VGND	B2#6	7.83153e-19
C803	VGND	B2#8	7.7726e-19
C804	A1#2	A2	6.52856e-17
C805	a_27_84##2	VNB	7.4607e-18
C806	Y#2	a_1288_368##4	1.45225e-17
C807	VGND	B2#12	7.90754e-19
C808	a_483_74#	VNB	3.82215e-17
C809	VGND	B1#1	7.54777e-19
C810	VGND#7	VNB	1.80275e-18
C811	A1#7	VPWR#1	3.36367e-17
C812	a_483_74##2	VNB	5.23049e-18
C813	VGND	B1#4	7.87598e-19
C814	A2	B1#11	5.53409e-19
C815	Y#4	B1#8	6.03754e-18
C816	VGND#8	VNB	3.82071e-19
C817	VGND	B1#7	1.83074e-18
C818	a_27_84##6	Y#6	6.35937e-19
C819	a_27_84##3	B1#6	7.01521e-18
C820	VGND#9	VNB	1.15709e-18
C821	VGND	C1#6	1.58734e-20
C822	VGND#10	VNB	4.53392e-18
C823	B1	A1#2	2.54451e-17
C824	a_483_74##6	VNB	3.92899e-18
C825	VGND	C1#8	9.39209e-21
C826	VPWR	A1#1	1.7997e-18
C827	VGND#5	a_483_74##5	6.6782e-18
C828	a_483_74##10	VNB	3.92829e-18
C829	a_483_74##12	VNB	3.96732e-18
C830	VPWR	B1#10	1.70677e-18
C831	B1	B1#11	2.26786e-17
C832	a_27_84##8	VNB	1.41251e-18
C833	a_483_74##14	VNB	4.07608e-18
C834	VPWR	B2#5	1.49072e-18
C835	a_27_84##6	VNB	1.26143e-18
C836	a_483_74##16	VNB	5.96994e-18
C837	A2#8	A2#7	4.03164e-17
C838	a_27_84##3	VNB	2.00343e-17
C839	VPWR	B2#9	1.56568e-18
C840	B2#4	B1	8.26595e-17
C841	VPWR#3	A1	1.27437e-17
C842	VPWR	B2#13	1.51551e-18
C843	Y#8	VNB	4.84747e-19
C844	a_27_84##5	VNB	4.96008e-17
C845	VGND#3	A1	1.83958e-17
C846	VPWR#1	VNB	7.4258e-17
C847	VPWR	B2#14	1.41537e-18
C848	a_1288_368#	VNB	2.19739e-18
C849	VPWR#6	VNB	4.09278e-19
C850	VPWR	B1#5	3.58731e-19
C851	a_1288_368##2	VNB	2.41925e-18
C852	a_27_84##5	Y#8	6.39584e-17
C853	a_1288_368#	A1#7	5.53294e-17
C854	B1#6	VPWR#8	1.54242e-18
C855	a_1288_368##5	VNB	3.64728e-18
C856	VPWR	B1#9	1.40916e-18
C857	VPWR#7	VNB	4.35438e-18
C858	a_508_368#	VNB	3.39095e-18
C859	A1	A1#6	2.21834e-17
C860	VPWR	C1#1	9.64637e-19
C861	Y#6	B1#9	2.61817e-17
C862	Y#12	VNB	4.98604e-20
C863	VPWR	C1#7	4.87527e-19
C864	a_508_368##3	VNB	2.69589e-18
C865	A1	A2#4	3.3872e-18
C866	C1	C1#5	1.99151e-17
C867	VPWR#8	VNB	4.04362e-18
C868	a_508_368##5	VNB	2.07307e-18
C869	VPWR	C1#12	7.20823e-20
C870	VPWR#10	VNB	7.63761e-19
C871	A1	A1#2	4.05687e-19
C872	Y#13	VNB	5.07142e-18
C873	VPWR	C1#13	2.44933e-18
C874	VPWR#12	VNB	3.7162e-18
C875	a_1288_368##2	VPWR#2	2.11311e-18
C876	Y#14	VNB	2.19739e-18
C877	VPWR#13	VNB	7.29584e-17
C878	A1#4	VNB	2.83623e-17
C879	B2#4	B2#11	4.45787e-17
C880	A1#8	VNB	2.3235e-17
C881	VPWR#11	C1#13	2.23467e-18
C882	a_483_74#	VGND#7	4.48825e-17
C883	A1#10	VNB	2.39593e-17
C884	A2#7	VNB	2.39669e-17
C885	VPWR#1	A1#11	1.23306e-18
C886	a_27_84##2	C1#4	3.31222e-19
C887	A2#8	VNB	2.59424e-17
C888	B1#6	B2#12	6.60109e-19
C889	A2#10	VNB	2.40323e-17
C890	A2#6	VNB	2.72689e-17
C891	VPWR	VPWR#5	1.12315e-16
C892	VPWR#6	A1#7	6.90563e-19
C893	A1#3	VNB	2.77301e-17
C894	B1#12	VNB	3.01514e-17
C895	B2#1	VNB	2.64007e-17
C896	B2#6	VNB	2.69798e-17
C897	B2#8	VNB	2.69648e-17
C898	B2#12	VNB	2.7427e-17
C899	B1#1	VNB	2.69507e-17
C900	B1#4	VNB	2.67354e-17
C901	B1	A2	8.21892e-18
C902	B1#7	VNB	3.60612e-17
C903	C1#6	VNB	3.13494e-17
C904	VPWR	A1#2	3.71624e-18
C905	C1#8	VNB	2.52243e-17
C906	C1#9	VNB	2.60556e-17
C907	C1#11	VNB	3.42015e-17
C908	A1#7	VNB	4.35165e-17
C909	VGND	VGND#6	2.74599e-16
C910	VPWR	B2#4	5.70811e-18
C911	A1#11	VNB	3.29451e-17
C912	A1#12	VNB	3.06428e-17
C913	A2#1	VNB	3.33613e-17
C914	VPWR	B1#3	1.0796e-17
C915	A2#9	VNB	3.16588e-17
C916	A2#11	VNB	3.22492e-17
C917	A2#12	VNB	3.14099e-17
C918	VGND	A1#2	4.07535e-18
C919	a_1288_368#	A1#11	6.35842e-17
C920	A1#1	VNB	3.50376e-17
C921	B1#10	VNB	3.27718e-17
C922	B2#5	VNB	3.55601e-17
C923	A1	A2	7.80295e-17
C924	B2#9	VNB	3.55241e-17
C925	VGND	B2#4	6.45775e-18
C926	B2#13	VNB	3.20433e-17
C927	B2#14	VNB	3.23568e-17
C928	VGND	B1#3	1.05986e-17
C929	B1#5	VNB	3.03512e-17
C930	B1#8	VNB	3.11006e-17
C931	VGND#4	a_483_74##5	7.32854e-18
C932	B1#9	VNB	3.49938e-17
C933	C1#1	VNB	2.86951e-17
C934	C1#7	VNB	2.89784e-17
C935	B2#4	B2#2	6.93962e-18
C936	A2#10	A2#8	2.91661e-17
C937	C1#12	VNB	3.18112e-17
C938	C1#13	VNB	4.02369e-17
C939	VGND#5	B2#2	8.59445e-20
C940	VPWR#3	VNB	2.12425e-16
C941	a_27_84##3	Y#7	6.80425e-17
C942	VGND#3	VNB	1.97752e-16
C943	VPWR#5	VNB	6.14938e-17
C944	VPWR	B1	7.41503e-18
C945	VGND#6	VNB	1.61464e-16
C946	A1#6	VNB	2.43378e-17
C947	VPWR	C1	9.90383e-18
C948	A2#4	VNB	3.24812e-17
C949	B2#4	B1#6	6.69278e-18
C950	A1#2	VNB	3.36733e-17
C951	VPWR#1	A1#12	2.59902e-19
C952	B1#11	VNB	2.84452e-17
C953	VGND	B1	8.30177e-18
C954	B2#4	VNB	4.5987e-18
C955	A1#11	VPWR#6	2.2036e-17
C956	B1#3	VNB	9.05327e-18
C957	VGND	C1	7.96339e-18
C958	C1#5	VNB	2.84917e-17
C959	Y#6	C1#1	3.48084e-17
C960	a_483_74##2	a_483_74#	3.37345e-18
C961	A2	VNB	6.29911e-18
C962	B1	VNB	7.12933e-18
C963	C1	VNB	3.22967e-17
C964	A1	VNB	4.04366e-17
C965	VPWR	VNB	2.90939e-16
C966	VGND	VNB	3.30477e-16
C967	VGND#3	VGND#2	7.90174e-17
C968	VGND#2	a_483_74#	1.78782e-17
C969	VGND#2	A1#8	1.23999e-18
C970	VGND#2	a_483_74##2	7.26259e-18
C971	VGND#2	A1#4	1.24502e-18
C972	VGND#2	VNB	4.7439e-17
C973	VGND#2	A1#6	8.31063e-20
C974	VGND#8	VGND#2	5.19094e-19
*
*
.ENDS sky130_fd_sc_hs__o221ai_4
*
