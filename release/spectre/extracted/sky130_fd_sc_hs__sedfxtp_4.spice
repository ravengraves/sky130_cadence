* Extracted by Quantus, converted by sky130cad/quantus.py
*
*
*
*                       LINUX           Wed Nov 18 09:12:59 2026
*
*
*
*  PROGRAM  advgen
*
*  Name           : advgen - Quantus - (64-bit)
*  Version        : 25.1.0-p047
*  Build Date     : Thu Dec 11 23:20:30 PST 2025
*
*  HSPICE LIBRARY
*
*  OPERATING_TEMPERATURE 150
*  QRC_TECH_DIR <path>/tech
*
*
*

*
.SUBCKT sky130_fd_sc_hs__sedfxtp_4 VNB VPB VGND VPWR Q D SCE SCD CLK DE
*
*
*  caps2d version: 10
*
*
*       TRANSISTOR CARDS
*
*
XM12 a_37_464##6 D#3 a_135_74# VNB sky130_fd_pr__nfet_01v8_lvt l=0.15 w=0.42 ad=0.1197 as=0.1008 pd=1.41 ps=1.32
XM46 a_135_74# DE#5 VGND#25 VNB sky130_fd_pr__nfet_01v8_lvt l=0.15 w=0.42 ad=0.1008 as=0.1197 pd=1.32 ps=1.41
XM42 a_177_290##9 DE#7 VGND#24 VNB sky130_fd_pr__nfet_01v8_lvt l=0.15 w=0.42 ad=0.1197 as=0.1176 pd=1.41 ps=1.4
XM39 VGND#24 a_177_290##3 a_497_113# VNB sky130_fd_pr__nfet_01v8_lvt l=0.15 w=0.42 ad=0.1176 as=0.1008 pd=1.4 ps=1.32
XM16 a_497_113# a_545_87##3 a_37_464# VNB sky130_fd_pr__nfet_01v8_lvt l=0.15 w=0.42 ad=0.1008 as=0.1176 pd=1.32 ps=1.4
XM27 a_37_464# a_631_87##2 a_661_113##7 VNB sky130_fd_pr__nfet_01v8_lvt l=0.15 w=0.42 ad=0.1176 as=0.21 pd=1.4 ps=1.84
XM8 a_631_87##10 SCE#2 VGND#23 VNB sky130_fd_pr__nfet_01v8_lvt l=0.15 w=0.42 ad=0.1197 as=0.1176 pd=1.41 ps=1.4
XM4 VGND#23 SCD#3 a_1044_125# VNB sky130_fd_pr__nfet_01v8_lvt l=0.15 w=0.42 ad=0.1176 as=0.0882 pd=1.4 ps=1.26
XM30 a_1044_125# SCE#1 a_661_113##9 VNB sky130_fd_pr__nfet_01v8_lvt l=0.15 w=0.42 ad=0.0882 as=0.1176 pd=1.26 ps=1.4
XM40 VGND#22 CLK#3 a_1313_74##13 VNB sky130_fd_pr__nfet_01v8_lvt l=0.15 w=0.74 ad=0.2109 as=0.2072 pd=2.05 ps=2.04
XM34 VGND#21 a_1313_74##9 a_1510_74##15 VNB sky130_fd_pr__nfet_01v8_lvt l=0.15 w=0.74 ad=0.2109 as=0.2072 pd=2.05 ps=2.04
XM37 a_661_113##8 a_1313_74# a_1756_97##6 VNB sky130_fd_pr__nfet_01v8_lvt l=0.15 w=0.42 ad=0.2226 as=0.16695 pd=1.9 ps=1.74
XM26 a_1756_97##6 a_1510_74##4 a_1858_79# VNB sky130_fd_pr__nfet_01v8_lvt l=0.15 w=0.42 ad=0.16695 as=0.1785 pd=1.74 ps=1.69
XM1 a_1858_79# a_1943_53##3 VGND#20 VNB sky130_fd_pr__nfet_01v8_lvt l=0.15 w=0.42 ad=0.1785 as=0.2776 pd=1.69 ps=2.34
XM32 VGND#20 a_1756_97# a_1943_53##10 VNB sky130_fd_pr__nfet_01v8_lvt l=0.15 w=0.64 ad=0.2776 as=0.1824 pd=2.34 ps=1.85
XM31 VGND#12 a_1943_53##4 a_2331_74# VNB sky130_fd_pr__nfet_01v8_lvt l=0.15 w=0.64 ad=0.1824 as=0.1344 pd=1.85 ps=1.7
XM35 a_2331_74# a_1510_74##5 a_2403_74##18 VNB sky130_fd_pr__nfet_01v8_lvt l=0.15 w=0.64 ad=0.1344 as=0.1915 pd=1.7 ps=1.93
XM43 a_2403_74##18 a_1313_74##10 a_2498_74# VNB sky130_fd_pr__nfet_01v8_lvt l=0.15 w=0.42 ad=0.1915 as=0.1008 pd=1.93 ps=1.32
XM38 a_2498_74# a_545_87##4 VGND#10 VNB sky130_fd_pr__nfet_01v8_lvt l=0.15 w=0.42 ad=0.1008 as=0.42 pd=1.32 ps=2.84
XM20 VGND#10 a_2403_74##14 a_545_87##13 VNB sky130_fd_pr__nfet_01v8_lvt l=0.15 w=0.42 ad=0.42 as=0.1197 pd=2.84 ps=1.41
XM17 VGND#9 a_2403_74##12 Q#3 VNB sky130_fd_pr__nfet_01v8_lvt l=0.15 w=0.74 ad=0.2109 as=0.2072 pd=2.05 ps=2.04
XM24 Q#3 a_2403_74##10 VGND#8 VNB sky130_fd_pr__nfet_01v8_lvt l=0.15 w=0.74 ad=0.2072 as=0.259 pd=2.04 ps=2.18
XM7 Q#4 a_2403_74##8 VGND#8 VNB sky130_fd_pr__nfet_01v8_lvt l=0.15 w=0.74 ad=0.2183 as=0.259 pd=2.07 ps=2.18
XM2 VGND#1 a_2403_74# Q#4 VNB sky130_fd_pr__nfet_01v8_lvt l=0.15 w=0.74 ad=0.1998 as=0.2183 pd=2.02 ps=2.07
XM18 a_37_464##4 D#1 a_126_464# VPB sky130_fd_pr__pfet_01v8 l=0.15 w=0.64 ad=0.1888 as=0.1728 pd=1.87 ps=1.82
XM9 a_126_464# a_177_290##2 VPWR#24 VPB sky130_fd_pr__pfet_01v8 l=0.15 w=0.64 ad=0.1728 as=0.1888 pd=1.82 ps=1.87
XM44 a_177_290##8 DE#6 VPWR#23 VPB sky130_fd_pr__pfet_01v8 l=0.15 w=0.64 ad=0.1888 as=0.3392 pd=1.87 ps=2.34
XM22 VPWR#23 DE#1 a_572_463# VPB sky130_fd_pr__pfet_01v8 l=0.15 w=0.64 ad=0.3392 as=0.1536 pd=2.34 ps=1.76
XM36 a_572_463# a_545_87# a_37_464##5 VPB sky130_fd_pr__pfet_01v8 l=0.15 w=0.64 ad=0.1536 as=0.192 pd=1.76 ps=1.88
XM13 a_37_464##5 SCE#5 a_661_113##5 VPB sky130_fd_pr__pfet_01v8 l=0.15 w=0.64 ad=0.192 as=0.176 pd=1.88 ps=1.83
XM15 a_631_87##9 SCE#4 VPWR#22 VPB sky130_fd_pr__pfet_01v8 l=0.15 w=0.64 ad=0.1792 as=0.3392 pd=1.84 ps=2.34
XM25 VPWR#22 SCD#1 a_1071_455# VPB sky130_fd_pr__pfet_01v8 l=0.15 w=0.64 ad=0.3392 as=0.1536 pd=2.34 ps=1.76
XM10 a_1071_455# a_631_87##4 a_661_113##10 VPB sky130_fd_pr__pfet_01v8 l=0.15 w=0.64 ad=0.1536 as=0.1792 pd=1.76 ps=1.84
XM21 VPWR#21 CLK#1 a_1313_74##15 VPB sky130_fd_pr__pfet_01v8 l=0.15 w=1.12 ad=0.3136 as=0.308 pd=2.8 ps=2.79
XM0 VPWR#20 a_1313_74##8 a_1510_74##16 VPB sky130_fd_pr__pfet_01v8 l=0.15 w=1.12 ad=0.308 as=0.308 pd=2.79 ps=2.79
XM47 a_661_113# a_1510_74# a_1756_97##7 VPB sky130_fd_pr__pfet_01v8 l=0.15 w=0.42 ad=0.1155 as=0.126 pd=1.39 ps=1.44
XM23 a_1756_97##7 a_1313_74##7 a_1899_508# VPB sky130_fd_pr__pfet_01v8 l=0.15 w=0.42 ad=0.126 as=0.1386 pd=1.44 ps=1.5
XM19 a_1899_508# a_1943_53# VPWR#19 VPB sky130_fd_pr__pfet_01v8 l=0.15 w=0.42 ad=0.1386 as=0.28735 pd=1.5 ps=2.67
XM3 VPWR#19 a_1756_97##3 a_1943_53##7 VPB sky130_fd_pr__pfet_01v8 l=0.15 w=0.84 ad=0.28735 as=0.231 pd=2.67 ps=2.23
XM41 VPWR#18 a_1943_53##6 a_2292_392# VPB sky130_fd_pr__pfet_01v8 l=0.15 w=1 ad=0.275 as=0.81 pd=2.55 ps=3.62
XM5 a_2292_392# a_1313_74##12 a_2403_74##16 VPB sky130_fd_pr__pfet_01v8 l=0.15 w=1 ad=0.81 as=0.3049 pd=3.62 ps=2.72
XM28 a_2403_74##16 a_1510_74##7 a_2586_508# VPB sky130_fd_pr__pfet_01v8 l=0.15 w=0.42 ad=0.3049 as=0.1134 pd=2.72 ps=1.38
XM14 a_2586_508# a_545_87##6 VPWR#17 VPB sky130_fd_pr__pfet_01v8 l=0.15 w=0.42 ad=0.1134 as=0.2935 pd=1.38 ps=2.4
XM29 VPWR#17 a_2403_74##15 a_545_87##14 VPB sky130_fd_pr__pfet_01v8 l=0.15 w=0.64 ad=0.2935 as=0.176 pd=2.4 ps=1.83
XM6 Q#6 a_2403_74##13 VPWR#16 VPB sky130_fd_pr__pfet_01v8 l=0.15 w=1.12 ad=0.336 as=0.308 pd=2.84 ps=2.79
XM33 VPWR#15 a_2403_74##11 Q#6 VPB sky130_fd_pr__pfet_01v8 l=0.15 w=1.12 ad=0.336 as=0.336 pd=2.84 ps=2.84
XM11 Q#5 a_2403_74##9 VPWR#15 VPB sky130_fd_pr__pfet_01v8 l=0.15 w=1.12 ad=0.336 as=0.336 pd=2.84 ps=2.84
XM45 VPWR#1 a_2403_74##7 Q#5 VPB sky130_fd_pr__pfet_01v8 l=0.15 w=1.12 ad=0.3192 as=0.336 pd=2.81 ps=2.84
*
*
*       RESISTOR AND CAP/DIODE CARDS
*
Rg1	D#1	D#2	446.848755
Rg2	D#2	D#3	353.802551
Rg3	a_177_290#	a_177_290##2	424.917511
Rg4	a_177_290##3	a_177_290##4	479.849731
Rg5	DE#1	DE#2	587.980652
Rg6	DE#2	DE#3	466.463165
Rg7	DE#3	DE#4	54.238338
Rg8	DE#4	DE#5	631.179688
Rg9	DE#2	DE#6	234.008942
Rg10	DE#4	DE#7	272.515930
Rg11	a_545_87#	a_545_87##2	469.987823
Rg12	a_545_87##2	a_545_87##3	486.864502
Rg13	a_631_87#	a_631_87##2	572.829590
Rg15	SCD#1	SCD#2	458.738525
Rg16	SCD#2	SCD#3	365.323883
Rg17	SCE#1	SCE#2	1097.454712
Rg18	SCE#2	SCE#3	229.884171
Rg19	SCE#3	SCE#4	560.387146
Rg20	SCE#4	SCE#5	999.329224
Rg21	a_631_87##4	a_631_87##5	360.062225
Rg22	CLK#1	CLK#2	476.833710
Rg23	CLK#2	CLK#3	307.937683
Rg24	a_1510_74#	a_1510_74##2	469.213257
Rg25	a_1510_74##3	a_1510_74##4	372.673157
Rg26	a_1313_74#	a_1313_74##2	535.286499
Rg27	a_1313_74##2	a_1313_74##3	368.306824
Rg28	a_1313_74##3	a_1313_74##4	259.787628
Rg29	a_1313_74##4	a_1313_74##5	202.491302
Rg30	a_1313_74##2	a_1313_74##6	505.692139
Rg31	a_1313_74##6	a_1313_74##7	255.995163
Rg32	a_1313_74##3	a_1313_74##8	371.735809
Rg33	a_1313_74##4	a_1313_74##9	514.509094
Rg34	a_1943_53#	a_1943_53##2	664.199585
Rg35	a_1943_53##2	a_1943_53##3	403.355286
Rg36	a_1756_97#	a_1756_97##2	489.645569
Rg37	a_1756_97##2	a_1756_97##3	366.918610
Rg38	a_1943_53##4	a_1943_53##5	344.780762
Rg39	a_1943_53##5	a_1943_53##6	518.531250
Rg40	a_1510_74##5	a_1510_74##6	480.096283
Rg41	a_1313_74##10	a_1313_74##11	555.639709
Rg42	a_1313_74##11	a_1313_74##12	408.386017
Rg43	a_1510_74##7	a_1510_74##8	580.499084
Rg44	a_545_87##4	a_545_87##5	1143.037354
Rg45	a_545_87##5	a_545_87##6	233.787552
Rg46	a_2403_74#	a_2403_74##2	296.496552
Rg47	a_2403_74##2	a_2403_74##3	78.752373
Rg48	a_2403_74##3	a_2403_74##4	94.958275
Rg49	a_2403_74##4	a_2403_74##5	88.321602
Rg50	a_2403_74##5	a_2403_74##6	226.679398
Rg51	a_2403_74##2	a_2403_74##7	443.283264
Rg52	a_2403_74##3	a_2403_74##8	293.641815
Rg53	a_2403_74##3	a_2403_74##9	441.010864
Rg54	a_2403_74##4	a_2403_74##10	322.013794
Rg55	a_2403_74##4	a_2403_74##11	431.047577
Rg56	a_2403_74##5	a_2403_74##12	314.405243
Rg57	a_2403_74##5	a_2403_74##13	423.439026
Rg58	a_2403_74##6	a_2403_74##14	333.097656
Rg59	a_2403_74##6	a_2403_74##15	442.528625
Rf1	D#4	D	1.396637
Rf2	D#2	D#6	54.807571
Rf3	D#4	D#6	6.224183
Rf4	D#7	D	1.396637
Rf5	D#6	D#7	5.896594
Rf6	DE	DE#3	167.318909
Rf7	a_177_290##4	a_177_290##6	198.896454
Rf8	a_177_290##6	a_177_290#	55.994770
Rf9	a_177_290##6	a_177_290##8	44.937363
Rf10	a_177_290#	a_177_290##9	87.125076
Rf11	a_545_87##2	a_545_87##8	170.074615
Rf12	a_37_464#	a_37_464##2	130.570694
Rf13	a_37_464##2	a_37_464##3	277.344940
Rf14	a_37_464##3	a_37_464##4	16.588749
Rf15	a_37_464##2	a_37_464##5	21.310108
Rf16	a_37_464##3	a_37_464##6	140.304321
Rf17	SCE	SCE#6	0.956614
Rf18	SCE#7	SCE#3	161.189423
Rf19	SCE#6	SCE#7	2.362036
Rf20	SCD	SCD#4	1.936403
Rf21	SCD#5	SCD#2	162.169205
Rf22	SCD#4	SCD#5	9.012097
Rf23	a_631_87##5	a_631_87##7	193.772659
Rf24	a_631_87##7	a_631_87##8	41.957123
Rf25	a_631_87##7	a_631_87##9	46.810741
Rf26	a_631_87##8	a_631_87##10	36.461552
Rf27	CLK#4	CLK#2	161.197830
Rf28	CLK	CLK#6	0.965023
Rf29	CLK#4	CLK#6	13.413354
Rf30	a_1313_74##13	a_1313_74##5	121.816406
Rf31	a_1313_74##5	a_1313_74##15	30.622671
Rf32	a_661_113#	a_661_113##2	71.692703
Rf33	a_661_113##2	a_661_113##3	122.615028
Rf34	a_661_113##3	a_661_113##4	13.249159
Rf35	a_661_113##4	a_661_113##6	200.352585
Rf36	a_661_113##6	a_661_113##7	131.319397
Rf37	a_661_113##2	a_661_113##8	132.260529
Rf38	a_661_113##3	a_661_113##9	128.456665
Rf39	a_661_113##4	a_661_113##10	11.063752
Rf40	a_661_113##5	a_661_113##6	7.500000
Rf41	a_1756_97##2	a_1756_97##5	251.435303
Rf42	a_1756_97##5	a_1756_97##6	83.369019
Rf43	a_1756_97##5	a_1756_97##7	87.200233
Rf44	a_1943_53##7	a_1943_53##8	81.865616
Rf45	a_1943_53##8	a_1943_53##2	227.869354
Rf46	a_1943_53##8	a_1943_53##10	60.607178
Rf47	a_1943_53##8	a_1943_53##5	189.064789
Rf48	a_1313_74##11	a_1313_74##6	589.370972
Rf49	a_1510_74##8	a_1510_74##10	227.455933
Rf50	a_1510_74##10	a_1510_74##3	258.225830
Rf51	a_1510_74##3	a_1510_74##12	78.626358
Rf52	a_1510_74##12	a_1510_74##2	120.244629
Rf53	a_1510_74##10	a_1510_74##6	177.911667
Rf54	a_1510_74##12	a_1510_74##15	84.807930
Rf55	a_1510_74##2	a_1510_74##16	26.370880
Rf56	a_2403_74##16	a_2403_74##17	88.780312
Rf57	a_2403_74##17	a_2403_74##18	120.347588
Rf58	a_545_87##9	a_545_87##10	13.577485
Rf59	a_545_87##10	a_545_87##11	41.442051
Rf60	a_545_87##11	a_545_87##5	214.268341
Rf61	a_545_87##10	a_545_87##13	89.256828
Rf62	a_545_87##11	a_545_87##14	22.066036
Rf63	Q	Q#1	5.964732
Rf64	Q#1	Q#2	9.585955
Rf65	Q#2	Q#3	79.916458
Rf66	Q#1	Q#4	45.336666
Rf67	Q#1	Q#5	49.471443
Rf68	Q#2	Q#6	84.986847
Rf69	VGND#1	VGND#2	101.044479
Rf70	VGND#2	VGND#3	39.422733
Rf71	VGND#3	VGND#4	28.465160
Rf72	VGND#4	VGND#5	101.580734
Rf73	VGND#5	VGND#6	142.181107
Rf74	VGND#6	VGND#7	96.824722
Rf75	VGND#2	VGND#8	40.806259
Rf76	VGND#4	VGND#9	41.573387
Rf77	VGND#5	VGND#11	5.898635
Rf78	VGND#11	VGND#10	15.000000
Rf79	VGND#6	VGND#12	37.283096
Rf80	VGND#7	VGND#13	207.731079
Rf81	VGND#13	VGND#14	74.885040
Rf82	VGND#14	VGND#15	95.339180
Rf83	VGND#15	VGND#16	114.664749
Rf84	VGND#16	VGND#17	85.079300
Rf85	VGND#17	VGND#18	72.270927
Rf87	VGND#7	VGND#20	42.156143
Rf88	VGND#13	VGND#21	33.326477
Rf89	VGND#14	VGND#22	42.399368
Rf90	VGND#15	VGND#23	43.365131
Rf91	VGND#17	VGND#24	42.184113
Rf92	VGND#18	VGND#25	34.507496
Rf93	VGND#10	VGND#11	15.000000
Rf94	VPWR#1	VPWR#2	94.583397
Rf95	VPWR#2	VPWR#3	37.231220
Rf96	VPWR#3	VPWR#4	28.465160
Rf97	VPWR#4	VPWR#5	82.104126
Rf98	VPWR#5	VPWR#6	178.530777
Rf99	VPWR#6	VPWR#7	80.404060
Rf100	VPWR#7	VPWR#8	169.233475
Rf101	VPWR#8	VPWR#9	98.569107
Rf102	VPWR#9	VPWR#10	97.165443
Rf103	VPWR#10	VPWR#11	126.775421
Rf104	VPWR#11	VPWR#12	55.551193
Rf105	VPWR#12	VPWR#13	105.258347
Rf107	VPWR#2	VPWR#15	32.518913
Rf108	VPWR#4	VPWR#16	37.301857
Rf109	VPWR#5	VPWR#17	25.558413
Rf110	VPWR#6	VPWR#18	31.948624
Rf111	VPWR#7	VPWR#19	35.446526
Rf112	VPWR#8	VPWR#20	33.129639
Rf113	VPWR#9	VPWR#21	33.720150
Rf114	VPWR#10	VPWR#22	39.585419
Rf115	VPWR#12	VPWR#23	37.794724
Rf116	VPWR#13	VPWR#24	37.538910
Rf137	a_2403_74##6	a_2403_74##17	53.410934
Rf125	a_631_87#	a_631_87##8	32.046562
Re1	a_545_87##9	a_545_87##8	39.942635
Re2	VPWR#3	VPWR#26	3.332833
Re3	VPWR#26	VPWR	0.645336
Re4	VPWR	VPWR#11	2.634420
Re5	VGND#3	VGND#27	3.332833
Re6	VGND#27	VGND	0.645336
Re7	VGND	VGND#16	2.634420
Re11	VPWR#7	VPWR#26	0.698413
Re14	VGND#7	VGND#27	0.698413
*
*       CAPACITOR CARDS
*
*
C1	VPWR#6	a_1943_53##5	9.92184e-20
C2	a_545_87##11	VPWR#5	8.8735e-18
C3	VPWR#21	VPWR#20	4.93359e-18
C4	a_1313_74##13	a_1313_74##15	1.04098e-18
C5	VGND#17	DE#2	4.02542e-19
C6	VPWR#5	VPWR#4	9.38179e-19
C7	a_545_87##8	DE#1	1.00838e-17
C8	a_1510_74##15	a_1313_74##9	1.84766e-17
C9	VPWR#11	a_545_87#	1.58834e-17
C10	VPWR#16	VPWR#15	2.06267e-18
C11	a_1756_97##2	a_1943_53##6	2.57396e-18
C12	SCD#5	SCD#2	1.38974e-17
C13	VGND#16	SCE#5	1.7344e-19
C14	a_661_113##2	VPWR#8	1.75233e-17
C15	a_545_87##10	a_2403_74##12	2.74708e-19
C16	VGND#20	a_1943_53##2	9.91236e-19
C17	a_545_87##9	VPWR#3	2.53637e-17
C18	a_1510_74##12	a_1313_74##3	3.68348e-19
C19	a_1313_74##13	a_1313_74#	1.94313e-19
C20	VGND#14	a_661_113##9	7.69022e-18
C21	SCE#3	SCD#3	6.75436e-18
C22	VPWR#16	a_2403_74##13	7.10662e-17
C23	a_545_87##5	a_545_87##11	1.23691e-18
C24	a_177_290##6	D#1	5.34172e-19
C25	a_2403_74##14	a_2403_74##12	4.45577e-18
C26	Q#1	VPWR#1	3.42903e-17
C27	VGND#5	a_1510_74##5	3.07109e-19
C28	SCD#4	SCD#2	8.65774e-18
C29	a_2403_74##5	VPWR#16	5.46268e-18
C30	VPWR#5	a_2403_74##15	1.57023e-17
C31	VPWR#11	DE#1	4.10521e-18
C32	a_1510_74##16	a_1313_74##3	5.49899e-18
C33	DE#6	VPWR#23	2.29074e-17
C34	D#4	D#3	6.28559e-18
C35	SCE#3	a_631_87##7	1.08096e-17
C36	VGND#3	a_545_87##9	2.4433e-17
C37	VGND#12	a_2403_74##18	1.225e-17
C38	VGND#21	a_1313_74##9	3.8104e-17
C39	a_1756_97##7	VPWR#7	2.08351e-17
C40	a_1510_74##10	a_1943_53##8	1.37585e-17
C41	VPWR#11	DE#6	4.41508e-18
C42	VGND#13	a_1313_74##2	3.0302e-20
C43	VGND#5	a_1313_74##11	1.28265e-19
C44	VGND#16	DE#1	1.86147e-19
C45	a_545_87##14	a_2403_74##13	9.91853e-19
C46	DE#6	a_177_290##8	9.208e-18
C47	a_1943_53##2	a_1756_97##3	5.09205e-18
C48	VGND#17	DE#1	5.07673e-19
C49	VPWR#16	Q#6	6.46942e-17
C50	CLK#4	a_661_113##4	3.09676e-18
C51	a_545_87##9	VPWR#7	5.16641e-18
C52	a_1510_74##15	CLK#3	3.08136e-19
C53	VGND#22	a_661_113##4	9.53219e-19
C54	a_661_113##4	SCE#1	1.81698e-18
C55	a_545_87##8	a_661_113##4	4.0462e-17
C56	VGND#1	a_2403_74#	2.75917e-17
C57	a_1313_74##9	a_1313_74##2	4.35928e-19
C58	a_1313_74##6	a_1943_53##6	3.86651e-19
C59	VPWR#11	a_177_290##2	6.01109e-19
C60	VGND#6	a_1943_53##4	7.03022e-18
C61	a_661_113##9	a_1313_74##4	1.06253e-19
C62	VPWR#16	a_2403_74##15	3.4492e-18
C63	a_1510_74##16	a_1313_74##2	2.64716e-18
C64	a_1313_74##13	a_1313_74##9	1.42417e-17
C65	VPWR#24	DE#6	4.8684e-19
C66	SCE#3	SCD#5	1.32981e-17
C67	VPWR#16	a_2403_74##6	2.54682e-19
C68	a_1313_74##4	VPWR#20	7.5077e-19
C69	a_1510_74##10	a_2403_74##6	1.16939e-18
C70	a_1313_74##6	a_1756_97##3	3.1464e-17
C71	a_545_87##9	VGND#7	3.8112e-18
C72	a_2403_74##6	a_2403_74##5	7.71929e-19
C73	a_661_113##10	a_1313_74##15	6.80923e-19
C74	VPWR#11	D#1	1.70605e-18
C75	SCE#3	SCD#4	2.56904e-17
C76	D#7	D#1	4.30129e-18
C77	a_1510_74##12	a_1313_74##2	8.72487e-19
C78	a_177_290##8	a_177_290##2	4.29846e-19
C79	VGND#21	CLK#3	2.52262e-18
C80	a_1313_74##6	a_1943_53#	5.70214e-17
C81	a_545_87##4	a_2403_74##14	1.72219e-17
C82	a_545_87##11	a_1510_74##8	1.29889e-20
C83	Q#1	Q#5	1.15878e-18
C84	a_545_87##14	a_2403_74##15	4.13427e-17
C85	a_2403_74#	Q#4	1.78954e-17
C86	VGND#5	a_1943_53##4	1.68421e-19
C87	a_545_87##8	a_661_113##2	4.0344e-17
C88	VPWR#5	a_545_87##6	2.44932e-17
C89	VGND#22	a_1313_74##9	1.72655e-19
C90	VGND#6	a_1510_74##6	1.73227e-19
C91	a_1510_74##10	a_2403_74##18	4.8574e-17
C92	a_1510_74##3	a_1943_53##10	4.59588e-17
C93	a_631_87##2	a_545_87##2	8.21195e-18
C94	a_1313_74##6	a_1313_74##7	2.18256e-18
C95	VPWR#24	a_177_290##2	3.44218e-17
C96	a_631_87##7	a_631_87##9	1.74764e-17
C97	a_2403_74##9	a_2403_74##7	4.72968e-17
C98	a_37_464##3	DE#4	3.10002e-19
C99	VPWR#16	a_545_87##6	2.19798e-19
C100	VGND#1	a_2403_74##8	2.2898e-18
C101	a_1313_74##3	VPWR#20	1.1377e-18
C102	Q#2	VPWR#15	1.85855e-17
C103	a_661_113##10	VPWR#21	2.47882e-17
C104	a_1313_74##13	CLK#3	4.89529e-17
C105	a_1510_74##3	VGND#20	9.21649e-17
C106	a_2403_74##15	VPWR#17	5.81551e-18
C107	a_661_113##9	a_661_113##4	8.2324e-19
C108	a_1510_74#	a_1313_74##6	8.54061e-19
C109	VPWR#11	a_661_113##4	1.61276e-17
C110	a_631_87##10	VGND#23	3.55114e-17
C111	a_2403_74##16	a_2403_74##13	1.47196e-19
C112	VGND#8	a_2403_74#	2.41502e-18
C113	VGND#16	DE#4	1.65591e-18
C114	a_661_113##9	a_1313_74##9	8.94002e-19
C115	VPWR#10	SCE#1	1.6986e-19
C116	a_545_87##14	a_545_87##5	1.12898e-19
C117	a_1313_74##8	a_1313_74##6	7.15475e-19
C118	a_545_87##14	a_545_87##6	1.18175e-18
C119	VGND#21	SCE#1	9.28953e-20
C120	a_545_87##8	a_661_113#	1.25836e-18
C121	a_2403_74##3	a_2403_74##2	8.80869e-19
C122	Q#2	a_2403_74##7	6.14859e-21
C123	a_2403_74##6	a_2403_74##16	7.3627e-19
C124	a_545_87##14	VPWR#16	5.20071e-17
C125	VPWR#24	D#1	4.69045e-18
C126	a_1943_53##8	a_1943_53##7	1.96479e-18
C127	a_1510_74##12	a_1510_74##16	8.52024e-19
C128	a_1510_74##3	a_1756_97##6	6.00621e-17
C129	VGND#16	DE#2	5.30723e-19
C130	a_2403_74##8	Q#4	1.93168e-17
C131	CLK#3	VGND#22	1.3585e-17
C132	a_545_87##5	VPWR#17	4.56754e-19
C133	VPWR#4	VPWR#2	1.22166e-18
C134	a_545_87##9	a_2403_74##6	8.52538e-17
C135	a_631_87##7	a_545_87##2	1.17236e-19
C136	a_1313_74##10	a_545_87##4	4.57629e-17
C137	a_545_87##8	a_1510_74##16	1.347e-17
C138	Q#1	VPWR#15	1.48544e-17
C139	a_545_87##6	VPWR#17	1.23391e-17
C140	a_2403_74##11	a_2403_74##9	4.68604e-17
C141	Q#3	a_2403_74#	2.66751e-19
C142	a_1313_74##13	SCE#1	1.50333e-18
C143	a_545_87##8	CLK#4	1.50078e-17
C144	a_37_464##3	DE#2	1.57817e-18
C145	a_545_87##8	VGND#7	2.15069e-20
C146	Q#1	a_2403_74##7	2.06223e-17
C147	a_661_113##5	a_631_87##7	3.24741e-17
C148	VGND#6	a_1943_53##5	1.53877e-19
C149	a_2403_74##16	a_2403_74##15	8.84602e-19
C150	VPWR#3	a_2403_74##6	3.54778e-18
C151	VPWR#5	a_1510_74##7	7.22619e-18
C152	a_545_87##9	a_545_87##5	5.62385e-18
C153	VGND#2	VGND#1	3.73251e-18
C154	a_545_87##8	VPWR#20	3.81492e-18
C155	a_1756_97##5	a_1313_74##8	1.05885e-19
C156	a_545_87##14	a_1510_74##7	3.60833e-19
C157	a_661_113##9	CLK#3	6.14932e-18
C158	a_1313_74##8	a_1510_74##2	1.18256e-17
C159	a_631_87##7	a_661_113##4	3.38122e-17
C160	VGND#8	a_2403_74##8	3.87433e-17
C161	a_2403_74##16	a_545_87##5	2.62888e-17
C162	D#1	a_37_464##4	6.80882e-18
C163	a_661_113##4	SCE#2	1.45598e-19
C164	a_1756_97##5	a_1943_53##7	1.64055e-18
C165	Q#2	Q#6	2.28132e-18
C166	VGND#6	VGND#5	1.73722e-20
C167	VGND#15	a_631_87##10	5.80586e-18
C168	VGND#3	a_2403_74##6	8.0389e-18
C169	VPWR#3	a_545_87##5	2.66165e-18
C170	a_545_87##9	a_1510_74##8	2.36107e-17
C171	a_545_87##8	a_1313_74##15	1.78051e-17
C172	VPWR#22	VPWR#21	1.81246e-18
C173	a_1510_74##2	CLK#1	6.98624e-20
C174	a_1510_74##2	a_1756_97##6	9.14365e-18
C175	VGND#22	SCE#1	3.82535e-18
C176	VGND#2	a_2403_74##3	3.54275e-20
C177	Q#4	a_2403_74##10	1.07651e-18
C178	a_545_87##8	a_631_87##7	6.19987e-17
C179	a_545_87##8	VPWR#11	7.95981e-17
C180	a_177_290#	a_545_87##3	7.61823e-20
C181	a_1313_74##5	a_1313_74##8	2.77141e-18
C182	a_1510_74##10	a_1510_74##8	3.47281e-19
C183	Q#2	a_2403_74##9	1.45461e-20
C184	a_661_113##8	a_1510_74##2	4.49062e-17
C185	a_545_87##8	VPWR#21	3.26669e-18
C186	a_2403_74##16	a_545_87##6	5.87778e-18
C187	a_545_87##9	a_1313_74##11	4.99361e-17
C188	a_177_290#	a_177_290##3	4.15232e-20
C189	a_1313_74##13	SCD#3	6.19322e-21
C190	a_2403_74##13	a_2403_74##11	4.80417e-17
C191	Q#3	a_2403_74##8	1.28698e-18
C192	a_1313_74##5	CLK#1	1.88773e-19
C193	a_1313_74##6	VPWR#6	4.1839e-18
C194	VPWR#6	a_1313_74##12	2.77893e-18
C195	VGND#16	a_545_87##8	8.25254e-17
C196	a_1510_74##5	a_1313_74##10	3.1267e-17
C197	a_2403_74##16	a_1510_74##8	5.26048e-17
C198	a_661_113##9	SCE#1	4.39547e-17
C199	VPWR#11	CLK#4	2.53914e-18
C200	VGND#24	a_177_290##6	3.00501e-18
C201	a_661_113##2	a_1510_74#	1.23269e-18
C202	a_545_87##9	a_1510_74##6	3.32613e-17
C203	a_1510_74##10	VGND#12	6.38251e-17
C204	VPWR#22	a_661_113##10	1.21551e-17
C205	VPWR#11	a_1313_74##15	9.16588e-19
C206	Q#1	a_2403_74##9	1.67091e-17
C207	a_2403_74##10	VGND#8	2.00559e-17
C208	Q#2	a_2403_74##5	9.83938e-18
C209	a_177_290#	DE#5	1.86289e-17
C210	VGND#23	CLK#3	6.43897e-19
C211	VGND#2	Q#4	6.15213e-18
C212	VGND#22	SCD#3	2.90202e-19
C213	VPWR#5	a_1313_74##12	5.72868e-18
C214	a_661_113##4	a_1313_74##8	3.56179e-19
C215	VPWR#11	VPWR#21	5.01394e-19
C216	VGND#9	a_2403_74##8	4.08073e-19
C217	a_545_87##9	a_1943_53##5	2.53644e-17
C218	a_37_464##2	DE#2	5.90955e-18
C219	VPWR#16	Q#2	3.23724e-17
C220	a_2403_74##16	a_1510_74##7	4.63912e-17
C221	VPWR#4	a_2403_74##5	2.87128e-20
C222	a_545_87##8	SCD#5	3.70795e-17
C223	a_1313_74##5	a_661_113##8	5.01431e-18
C224	a_37_464##2	a_545_87##2	1.37015e-17
C225	VPWR#11	a_631_87##7	4.93396e-18
C226	VPWR#18	a_545_87##6	2.1639e-19
C227	a_631_87##5	CLK#1	6.79408e-18
C228	D#2	DE#5	9.55687e-18
C229	a_545_87##8	VPWR#22	1.64743e-18
C230	a_1313_74##11	a_2403_74##16	7.31043e-17
C231	a_2403_74##15	a_2403_74##13	6.2837e-18
C232	VGND#2	a_2403_74##2	5.21613e-20
C233	VPWR#11	a_661_113##10	1.93924e-17
C234	Q#3	a_2403_74##10	3.40292e-17
C235	a_545_87##9	a_1756_97##2	4.66094e-17
C236	VGND#16	a_1313_74##15	2.36385e-19
C237	a_1510_74##10	a_1313_74##11	2.7942e-17
C238	a_545_87##9	VPWR#8	1.48266e-18
C239	a_37_464##6	a_37_464##3	1.30263e-18
C240	a_661_113##9	SCD#3	4.21845e-18
C241	Q#2	a_2403_74##11	1.76499e-17
C242	VGND#13	a_1313_74#	8.43436e-19
C243	a_545_87##8	a_631_87##9	2.38691e-18
C244	a_1313_74##13	CLK#4	2.25656e-17
C245	VGND#23	SCE#1	6.1523e-18
C246	VGND#16	CLK#4	3.5666e-18
C247	VPWR#8	a_1313_74##4	1.41781e-18
C248	a_1943_53##4	a_1510_74##5	5.22144e-17
C249	VGND#8	a_2403_74##12	1.28085e-18
C250	a_631_87##5	SCD#1	1.60809e-17
C251	a_545_87##9	a_1943_53##2	1.38874e-17
C252	a_661_113##2	a_1313_74##8	3.5755e-17
C253	a_545_87##9	VPWR#6	6.71518e-18
C254	VGND#22	SCE#2	2.64319e-19
C255	VPWR#6	a_1943_53##6	3.9591e-18
C256	a_2403_74##16	a_1313_74##12	2.20834e-17
C257	a_1510_74##10	a_1943_53##10	4.98269e-17
C258	a_1313_74##11	VPWR#18	1.66248e-17
C259	CLK#4	SCD#3	1.35e-19
C260	a_1313_74##13	a_1313_74##5	1.62595e-19
C261	a_545_87##8	a_661_113##5	4.66299e-18
C262	Q#1	a_2403_74##11	2.86898e-20
C263	VGND#9	a_2403_74##10	2.43382e-18
C264	VPWR#18	a_1510_74##7	7.32786e-19
C265	Q#2	a_2403_74##4	1.91669e-17
C266	a_2403_74##6	a_545_87##5	1.21753e-16
C267	a_661_113##4	CLK#1	4.19209e-17
C268	a_545_87##9	a_1313_74##6	2.27509e-17
C269	a_37_464#	a_661_113##7	8.80675e-17
C270	a_545_87##9	VPWR#5	1.1502e-17
C271	a_2403_74##16	a_545_87##14	3.38447e-18
C272	a_1943_53##7	a_1313_74##11	7.38765e-18
C273	VPWR#11	SCD#5	1.24427e-18
C274	VPWR#7	a_1756_97##2	3.70742e-20
C275	a_177_290##4	a_37_464##2	3.84874e-17
C276	VPWR#5	a_1943_53##6	4.01712e-19
C277	a_545_87##6	a_2403_74##15	1.03465e-17
C278	VGND#14	a_1313_74##9	4.35809e-19
C279	VPWR#11	a_631_87##9	3.82367e-18
C280	VGND#16	a_631_87##7	3.05872e-18
C281	a_2403_74##12	Q#3	8.1896e-18
C282	a_661_113##9	SCE#2	1.14153e-19
C283	VGND#5	VGND#4	2.20451e-18
C284	SCE#4	SCD#2	1.80736e-18
C285	a_2403_74##6	a_1510_74##8	6.50764e-17
C286	a_661_113##9	a_1313_74##5	2.24056e-19
C287	a_661_113#	VPWR#8	2.69071e-17
C288	a_545_87##9	a_1510_74##3	2.23883e-17
C289	VGND#7	a_1756_97##2	1.27234e-20
C290	a_545_87##9	VPWR#4	1.53834e-18
C291	VGND#23	SCD#3	2.85488e-17
C292	VPWR#7	a_1943_53##2	6.96005e-20
C293	a_1510_74##10	a_1510_74##6	5.24818e-18
C294	Q#1	VGND#1	3.25266e-17
C295	a_2403_74##16	a_1943_53##6	2.85671e-18
C296	a_661_113##5	VPWR#11	9.20115e-17
C297	a_1510_74##8	a_545_87##5	4.04215e-17
C298	VGND#3	a_2403_74#	4.22761e-18
C299	a_1313_74##11	a_2403_74##6	1.28501e-18
C300	VGND#8	a_2403_74##14	2.24768e-19
C301	SCE#4	a_631_87##10	5.69248e-19
C302	VGND#5	VGND#9	7.69532e-19
C303	Q#2	a_2403_74##13	8.50168e-18
C304	VPWR#18	a_1313_74##12	2.64305e-18
C305	a_545_87##9	a_1510_74##2	1.62788e-17
C306	a_545_87##4	a_2498_74#	8.35249e-18
C307	CLK#2	a_1313_74##13	4.02947e-18
C308	a_1510_74##10	a_545_87##4	1.27145e-19
C309	VGND#9	a_545_87##9	2.38528e-17
C310	VGND#13	a_1313_74##9	4.36121e-18
C311	VPWR#8	a_1510_74##2	6.17267e-19
C312	Q#2	Q#4	2.48112e-19
C313	a_1756_97#	a_1943_53##4	3.80749e-18
C314	a_177_290##6	a_177_290##4	2.83506e-18
C315	a_661_113##2	CLK#1	1.57302e-18
C316	a_1313_74##6	VPWR#7	9.19128e-18
C317	a_545_87##8	VPWR#23	2.37453e-18
C318	a_1943_53##7	a_1510_74##6	2.867e-18
C319	a_37_464##5	VPWR#11	3.00648e-17
C320	VGND#9	a_2403_74##12	4.80765e-17
C321	a_1313_74##10	a_2498_74#	8.35249e-18
C322	a_1313_74##11	a_545_87##5	2.66624e-19
C323	VGND#3	a_2403_74##8	4.15301e-18
C324	VGND#15	CLK#3	3.98684e-19
C325	VPWR#8	a_1313_74##3	5.53787e-20
C326	a_37_464##3	DE#3	9.1588e-19
C327	a_545_87##8	a_37_464##2	5.80309e-17
C328	VGND#7	a_1313_74##6	7.50389e-20
C329	a_545_87##9	a_545_87##13	1.43493e-18
C330	a_1510_74##7	a_545_87##6	2.64124e-17
C331	a_661_113##4	a_631_87##4	1.80032e-17
C332	a_1943_53##7	a_1313_74##12	1.29806e-18
C333	Q#1	a_2403_74##13	9.53516e-21
C334	Q#2	a_2403_74##3	2.11146e-18
C335	a_1756_97##5	a_1756_97##7	6.71609e-19
C336	a_1510_74##8	a_1313_74##11	8.1336e-17
C337	a_661_113##9	CLK#2	6.30618e-18
C338	VGND#3	a_2403_74##10	1.03588e-17
C339	a_2403_74##16	a_1756_97##3	7.08717e-19
C340	CLK	a_1313_74##4	2.87122e-18
C341	VGND#3	VGND#1	5.74575e-17
C342	VPWR#18	a_1943_53##5	3.55854e-19
C343	VGND#23	SCE#2	2.92552e-17
C344	a_545_87##11	VPWR#16	4.09276e-17
C345	a_545_87##10	a_2403_74##11	2.16028e-19
C346	a_661_113##5	VPWR#22	3.78092e-17
C347	VPWR#3	VPWR#5	7.18525e-17
C348	a_37_464##2	a_497_113#	1.92003e-19
C349	VGND#7	a_1510_74##3	6.88709e-17
C350	VPWR#18	a_1943_53##6	4.38545e-17
C351	Q#4	VGND#1	3.21086e-17
C352	a_545_87##2	SCE#4	3.68294e-19
C353	a_1510_74##6	a_1510_74##8	2.15451e-18
C354	a_545_87##13	a_2403_74##12	1.06564e-18
C355	VGND#14	CLK#3	8.96937e-18
C356	VGND#16	SCD#4	5.7594e-18
C357	a_1510_74##12	a_1756_97##6	6.51927e-17
C358	VGND#3	a_2403_74##12	7.6481e-18
C359	VGND#3	Q#4	1.24564e-17
C360	a_545_87##6	a_2586_508#	1.06762e-17
C361	VPWR#12	DE#2	2.48323e-19
C362	a_1510_74##10	a_1943_53##5	7.63826e-17
C363	VPWR#11	a_37_464##3	4.95547e-17
C364	VPWR#3	VPWR#4	4.48589e-17
C365	a_1510_74##6	a_1313_74##11	7.50311e-17
C366	a_661_113##9	CLK#4	3.35646e-17
C367	a_177_290##6	DE#3	6.54203e-19
C368	VPWR#11	a_177_290##8	6.23232e-18
C369	a_2403_74##16	a_545_87##4	4.01845e-19
C370	VGND#9	a_2403_74##14	1.719e-18
C371	a_37_464##3	a_37_464##2	3.10847e-18
C372	a_1510_74##7	a_2586_508#	1.06762e-17
C373	a_631_87##10	SCE#2	9.71875e-18
C374	a_1943_53##7	a_1943_53##6	8.39431e-18
C375	a_661_113##7	SCE#5	2.98181e-19
C376	VGND#5	a_545_87##13	4.23568e-17
C377	a_1510_74##10	a_1313_74##10	1.25809e-18
C378	a_661_113##2	a_631_87##4	1.38167e-19
C379	a_1943_53##3	a_1756_97#	1.12522e-17
C380	a_631_87##2	SCE#5	8.8343e-19
C381	a_545_87##8	a_1510_74##2	1.98363e-17
C382	a_631_87##7	SCE#2	8.76163e-20
C383	SCD#4	SCE#1	1.88904e-18
C384	Q#2	VGND#8	1.68436e-17
C385	a_661_113##5	a_631_87##9	9.81405e-17
C386	a_1313_74##12	a_1510_74##7	3.2352e-17
C387	a_37_464##2	VPWR#11	2.63194e-17
C388	a_37_464##3	a_177_290#	5.87066e-17
C389	a_1943_53##5	a_1313_74##11	3.26777e-18
C390	VPWR#3	VPWR#2	5.31142e-17
C391	a_545_87##11	a_2403_74##13	5.20593e-19
C392	a_661_113##9	a_631_87##5	5.96831e-17
C393	a_545_87##2	DE#1	1.35767e-17
C394	a_545_87##10	VPWR#16	4.46376e-18
C395	DE#2	a_545_87##2	5.26629e-19
C396	a_545_87##9	a_2403_74##18	7.68027e-18
C397	VPWR#18	a_1756_97##3	4.83427e-18
C398	a_1510_74##5	a_2331_74#	1.032e-17
C399	VGND#15	SCE#1	1.62772e-17
C400	a_1943_53##8	a_1510_74##6	1.26794e-18
C401	a_661_113##4	SCD#1	2.06973e-17
C402	a_177_290##4	a_545_87#	2.70283e-19
C403	VPWR#8	a_1313_74##2	2.66661e-19
C404	VPWR#19	a_1943_53##6	2.22041e-18
C405	a_545_87##8	a_1313_74##5	2.85226e-17
C406	VPWR#9	VPWR#20	5.27044e-20
C407	VGND#3	Q#3	1.88491e-17
C408	a_1943_53##5	a_1510_74##6	4.95438e-17
C409	a_1756_97##2	a_1943_53##7	2.25187e-17
C410	a_1943_53##4	a_2331_74#	1.25891e-17
C411	a_1313_74##11	a_1756_97##2	1.60016e-19
C412	VGND#8	VGND#1	7.33099e-18
C413	a_545_87##13	a_2403_74##14	3.67706e-17
C414	a_1313_74##12	a_2292_392#	3.39195e-17
C415	a_177_290##4	DE#1	5.47948e-18
C416	a_177_290##6	DE#4	1.34281e-18
C417	a_545_87##10	a_2403_74##13	1.42351e-18
C418	a_545_87##11	a_545_87##14	2.76781e-19
C419	VGND#23	a_631_87##5	1.7352e-20
C420	VGND#24	a_37_464#	1.70167e-17
C421	VGND#9	VGND#2	2.22144e-19
C422	a_1943_53##7	a_1756_97##3	3.93799e-17
C423	VPWR#19	a_1756_97##2	2.48792e-19
C424	a_1510_74##6	a_1756_97##2	6.4339e-19
C425	a_545_87##8	CLK#2	3.17743e-18
C426	a_1943_53##6	a_2292_392#	1.94662e-17
C427	a_1510_74##12	a_661_113##8	6.66008e-17
C428	Q#1	a_2403_74##3	1.88469e-17
C429	VGND#14	SCE#1	1.97737e-18
C430	VGND#9	a_545_87##4	1.88027e-20
C431	VGND#4	VGND#2	2.83156e-18
C432	a_177_290##6	a_177_290#	2.93115e-19
C433	D#6	DE#3	8.64385e-20
C434	a_545_87##9	VGND#12	2.45361e-18
C435	VGND#4	a_545_87##13	1.06639e-17
C436	a_1756_97##2	a_1943_53##5	7.04362e-18
C437	VPWR#18	a_1943_53#	2.01185e-18
C438	a_1943_53##6	a_1313_74##12	8.02137e-18
C439	a_661_113##9	SCD#2	7.78127e-19
C440	a_545_87##8	a_631_87##5	4.17738e-17
C441	Q#1	VGND#8	1.68204e-17
C442	VPWR#11	a_177_290##6	1.51797e-18
C443	VGND#3	a_545_87##13	2.18822e-17
C444	a_2403_74##14	VGND#10	4.83202e-18
C445	D#4	DE#3	6.15325e-20
C446	a_1756_97##3	VPWR#19	2.25101e-17
C447	SCD#4	SCD#3	2.83096e-18
C448	a_37_464##3	D#2	8.3355e-18
C449	a_1943_53##7	a_1943_53##2	4.47518e-19
C450	a_1510_74##4	a_1943_53##3	1.33246e-17
C451	a_1510_74##10	a_1510_74##5	9.06516e-18
C452	VGND#5	VGND#10	1.4924e-17
C453	a_1756_97##7	a_1943_53##6	5.86545e-19
C454	VPWR#11	a_631_87##5	5.67846e-18
C455	a_631_87##2	a_661_113##7	1.77373e-17
C456	Q#2	Q#3	3.97556e-19
C457	VPWR#2	a_2403_74##3	2.02898e-20
C458	a_545_87##8	SCD#2	3.12849e-20
C459	a_545_87##11	a_2403_74##15	2.57502e-17
C460	VGND#13	SCE#1	4.09595e-20
C461	a_1943_53##7	a_1943_53#	2.59332e-18
C462	a_37_464##5	a_661_113##5	4.12939e-17
C463	a_661_113##4	SCE#4	1.22886e-17
C464	a_545_87##13	a_545_87##4	1.26955e-18
C465	a_1943_53##8	a_1943_53##5	4.5065e-18
C466	VGND#8	Q#4	3.20927e-17
C467	VGND#17	a_177_290##9	4.46812e-18
C468	a_37_464##3	a_135_74#	2.32468e-19
C469	a_177_290##9	a_37_464#	4.46851e-18
C470	D#7	a_177_290#	4.55958e-17
C471	VGND#16	a_631_87##5	3.08117e-18
C472	a_1756_97##2	a_1943_53##2	9.10481e-17
C473	a_1943_53#	a_1899_508#	9.93176e-18
C474	a_1943_53##5	a_1313_74##6	2.02981e-18
C475	DE#4	a_177_290##4	2.36548e-18
C476	a_37_464##2	a_661_113##5	6.04561e-17
C477	VGND#15	SCD#3	2.51976e-18
C478	a_1313_74##6	VPWR#18	2.88961e-17
C479	a_177_290##6	DE#2	3.17954e-17
C480	a_545_87##9	VGND#20	1.50828e-18
C481	a_545_87##9	VGND#6	3.65689e-18
C482	a_545_87##8	SCE#3	1.59523e-17
C483	a_1313_74##7	a_1899_508#	1.12772e-17
C484	a_177_290##4	DE#2	4.05786e-17
C485	VPWR#7	VPWR#6	8.86394e-19
C486	a_1756_97##2	a_1313_74##6	1.12286e-17
C487	a_1510_74##3	a_1943_53##5	1.96501e-19
C488	a_37_464#	a_631_87##2	4.56151e-17
C489	VPWR#19	a_1943_53#	2.45171e-17
C490	a_545_87##11	VPWR#17	4.44744e-19
C491	D#6	a_177_290#	1.88721e-17
C492	a_1313_74##6	a_1943_53##7	5.64268e-17
C493	a_1756_97##3	a_1943_53##6	6.38151e-18
C494	a_661_113##9	SCE#3	2.11105e-19
C495	VPWR#11	SCE#3	1.14901e-18
C496	D#1	a_177_290#	1.82332e-17
C497	VPWR#18	a_2403_74##16	6.35749e-18
C498	a_1510_74##4	a_1858_79#	1.06811e-17
C499	a_1510_74##15	a_1510_74##12	2.9616e-18
C500	a_1756_97##7	a_1756_97##3	9.49699e-19
C501	a_545_87##9	VGND#5	1.25887e-17
C502	VPWR#11	D#7	5.65569e-18
C503	Q#1	a_2403_74##2	2.19977e-17
C504	a_1313_74##6	a_1943_53##2	1.75226e-17
C505	a_545_87##4	VGND#10	1.77264e-17
C506	a_1510_74##3	a_1756_97##2	8.00178e-19
C507	D#4	a_177_290#	1.81975e-17
C508	VGND#16	SCE#3	1.87408e-18
C509	a_1313_74##6	VPWR#19	4.06706e-17
C510	SCD#4	SCE#2	4.52196e-19
C511	a_1313_74#	a_1510_74##4	1.72182e-17
C512	a_2403_74##18	a_2403_74##14	5.32407e-19
C513	a_1510_74##3	a_1943_53##2	9.33199e-17
C514	a_545_87##8	a_545_87##2	2.33479e-17
C515	a_1943_53#	a_1943_53##6	3.78108e-19
C516	VGND#23	SCE#3	1.69554e-17
C517	a_177_290##2	DE#2	4.89071e-19
C518	a_1510_74##10	a_1943_53##4	2.08812e-17
C519	VGND#4	a_545_87##9	1.49881e-18
C520	VPWR#10	VPWR#21	3.8519e-20
C521	a_545_87##13	a_1313_74##10	2.50507e-19
C522	Q#3	Q#4	3.36723e-18
C523	a_631_87##7	a_631_87##4	3.56904e-20
C524	D#7	D#2	1.39762e-17
C525	VPWR#11	a_545_87##2	2.13378e-20
C526	VGND#7	a_1943_53##4	1.62995e-19
C527	VGND#9	Q#2	2.41941e-17
C528	D#4	a_177_290##9	1.85465e-17
C529	a_1510_74##3	a_1313_74##6	1.60306e-17
C530	a_631_87##10	SCE#3	3.74785e-18
C531	VPWR#19	a_1313_74##7	3.0849e-18
C532	a_1510_74##2	a_1943_53##2	2.28127e-19
C533	a_37_464##2	a_37_464##5	2.73037e-18
C534	a_1943_53##8	a_1756_97##2	5.27871e-17
C535	VPWR#9	a_631_87##5	1.26228e-19
C536	VPWR#2	a_2403_74##2	2.00192e-20
C537	a_177_290##4	a_545_87##8	4.27514e-17
C538	a_37_464#	a_545_87##3	3.20793e-17
C539	VPWR#8	a_1510_74#	3.79106e-18
C540	a_1756_97##7	a_1313_74##6	3.09896e-17
C541	a_1756_97##7	a_1943_53#	3.41062e-18
C542	VGND#25	VGND#17	3.15194e-18
C543	VGND#16	a_545_87##2	8.55316e-20
C544	VPWR#23	a_661_113##5	1.89623e-18
C545	a_1943_53#	a_1756_97##3	3.21156e-17
C546	a_631_87##4	a_1071_455#	1.41674e-17
C547	VGND#6	a_2403_74##18	8.81588e-18
C548	a_1510_74##2	a_1313_74##6	2.67655e-17
C549	a_1313_74##4	a_1313_74##2	8.48174e-19
C550	a_1313_74##9	a_1510_74##4	3.20021e-19
C551	VPWR#11	a_177_290##4	2.98107e-18
C552	VGND#15	SCE#2	2.37624e-17
C553	a_1756_97##5	a_1756_97##2	2.14369e-18
C554	a_661_113##2	a_1756_97##7	6.48886e-18
C555	D#6	D#2	6.5496e-18
C556	VGND#7	a_1756_97#	4.15925e-18
C557	VGND#24	a_631_87##2	4.58067e-19
C558	SCD#1	a_1071_455#	1.41674e-17
C559	a_545_87##8	DE#3	7.16948e-19
C560	a_177_290##6	a_37_464##3	7.30243e-18
C561	VGND#16	a_177_290##4	3.83631e-18
C562	D#4	D#2	1.16765e-17
C563	DE#3	DE#4	7.03372e-18
C564	a_1510_74##2	a_1510_74##3	3.00774e-19
C565	a_545_87##8	VPWR#12	9.97356e-19
C566	a_177_290##9	VGND#24	4.56086e-17
C567	VGND#7	a_1943_53##3	3.50875e-18
C568	a_2403_74##18	a_545_87##4	1.91586e-17
C569	a_545_87##8	a_177_290#	2.04872e-18
C570	VPWR#19	a_1510_74#	7.06314e-19
C571	a_2403_74##6	a_2403_74##12	2.60139e-18
C572	VGND#16	DE#3	3.75591e-18
C573	Q#3	VGND#8	3.36424e-17
C574	a_1313_74##9	a_1313_74#	3.21439e-18
C575	a_545_87##9	Q#2	1.67713e-17
C576	VPWR#23	a_37_464##5	1.20038e-17
C577	a_545_87##8	VPWR#10	3.64714e-18
C578	a_1756_97##7	a_1313_74##7	2.78085e-17
C579	VPWR#11	a_177_290#	5.50365e-18
C580	a_37_464#	a_177_290##3	4.22218e-18
C581	a_631_87##7	SCD#1	9.15209e-20
C582	VGND#7	a_1510_74##4	4.10079e-18
C583	a_1510_74##10	a_1756_97#	2.39442e-18
C584	a_1313_74##7	a_1943_53#	2.12318e-17
C585	a_2403_74##6	a_2403_74##14	8.47848e-18
C586	VGND#14	CLK#2	8.09971e-20
C587	VGND#16	a_177_290#	1.59091e-18
C588	a_661_113##10	VPWR#10	1.09762e-18
C589	a_661_113##4	a_1071_455#	2.30527e-18
C590	VGND#24	a_545_87##3	3.98207e-18
C591	a_1943_53##8	a_1943_53##2	1.99281e-18
C592	a_545_87##8	VPWR#9	4.39995e-18
C593	VGND#5	a_2403_74##18	3.29344e-17
C594	VGND#23	a_631_87##7	1.4046e-18
C595	a_545_87##9	a_2403_74##5	1.39994e-17
C596	DE	a_177_290##6	2.60255e-17
C597	a_545_87#	a_572_463#	1.41968e-17
C598	a_545_87##11	a_1510_74##7	3.27319e-20
C599	VGND#7	a_1313_74#	2.41059e-18
C600	VGND#13	CLK#2	7.36676e-20
C601	VGND#16	D#4	9.90133e-18
C602	a_2403_74##6	a_545_87##4	3.42287e-17
C603	VGND#25	VGND#24	5.37246e-18
C604	a_1510_74##12	a_1510_74##3	3.59043e-18
C605	DE#1	a_572_463#	1.41968e-17
C606	VPWR#8	a_1313_74##8	3.98761e-18
C607	a_1756_97##5	a_1943_53##2	1.19878e-17
C608	VPWR#20	a_1943_53#	2.38509e-19
C609	a_177_290##6	a_37_464##2	2.07453e-18
C610	VPWR#19	a_1313_74##8	3.89546e-19
C611	a_545_87##8	VPWR#8	4.56982e-18
C612	a_1313_74##5	CLK#2	1.03915e-18
C613	a_1756_97##7	a_1510_74##2	2.10946e-17
C614	a_545_87##9	a_2403_74##4	3.48404e-19
C615	a_1756_97##7	a_1510_74#	2.57518e-17
C616	a_2403_74##18	a_1313_74##10	4.80649e-17
C617	VPWR#2	VPWR#1	1.22366e-18
C618	a_177_290##9	a_545_87##3	6.36323e-19
C619	a_2403_74##6	a_1313_74##10	3.63041e-19
C620	a_2403_74##16	a_545_87##11	1.35152e-18
C621	a_1313_74##5	a_631_87##5	3.69551e-20
C622	a_37_464#	DE#7	8.67749e-20
C623	VGND#9	VGND#8	6.1965e-18
C624	a_1510_74##2	a_661_113#	4.17416e-17
C625	a_661_113##10	VPWR#9	1.38471e-17
C626	VGND#12	a_545_87##4	1.16165e-19
C627	VPWR#11	VPWR#12	7.55875e-17
C628	a_545_87##9	a_545_87##11	6.55496e-18
C629	a_1510_74##3	a_1510_74##10	3.09956e-18
C630	a_661_113##7	a_545_87##2	8.02854e-19
C631	a_1510_74#	a_1313_74##7	2.1691e-17
C632	VPWR#10	VPWR#9	6.63787e-19
C633	VPWR#10	CLK#1	3.54373e-19
C634	CLK#3	a_1313_74##9	4.47083e-18
C635	VGND#3	VGND#5	7.4451e-17
C636	VGND#24	a_177_290##3	3.55521e-17
C637	a_545_87##4	a_545_87##5	1.26937e-18
C638	a_2403_74##6	a_1510_74##5	2.0117e-19
C639	a_631_87##5	CLK#2	7.09818e-18
C640	a_1510_74#	a_661_113#	1.3898e-17
C641	VGND#2	Q#2	4.73463e-19
C642	a_631_87##7	SCE#4	3.13995e-17
C643	a_177_290#	DE#4	1.83778e-17
C644	SCE#1	a_1044_125#	8.8457e-18
C645	Q#2	VPWR#3	3.24838e-18
C646	a_37_464##2	VPWR#23	6.48346e-17
C647	a_177_290##2	a_126_464#	1.53896e-17
C648	VGND#15	SCE	3.07842e-20
C649	a_1943_53##8	a_1510_74##5	2.06545e-19
C650	a_37_464#	a_545_87##2	1.89846e-17
C651	a_37_464##6	D#6	1.32132e-17
C652	VGND#15	a_631_87##5	4.90355e-20
C653	VPWR#20	a_1313_74##7	3.56149e-19
C654	SCD#3	a_1044_125#	8.8457e-18
C655	a_1510_74##12	a_1510_74##4	7.74511e-19
C656	VGND#25	a_177_290##9	5.99725e-17
C657	VPWR#11	VPWR#10	9.41683e-17
C658	a_37_464#	DE#4	1.7553e-18
C659	D#1	a_126_464#	1.59113e-17
C660	SCD#2	CLK#2	4.85073e-19
C661	a_545_87##9	a_545_87##10	1.89668e-17
C662	a_177_290#	DE#2	1.11545e-17
C663	a_631_87##10	a_631_87##7	1.16243e-18
C664	VGND#3	VGND#4	6.42609e-17
C665	a_1943_53##8	a_1313_74##6	4.95228e-19
C666	a_1756_97##7	a_1313_74##8	1.19028e-18
C667	VGND#17	a_545_87##3	3.37225e-18
C668	VPWR#9	CLK#1	3.72265e-18
C669	VPWR#19	VPWR#18	8.79537e-18
C670	VGND#14	a_631_87##5	1.41885e-19
C671	VPWR#3	Q#1	8.24744e-18
C672	a_1510_74##15	a_661_113##8	5.18554e-17
C673	a_37_464##3	a_177_290##8	5.02519e-17
C674	VPWR#10	SCE#3	8.94818e-20
C675	a_631_87##5	SCD#2	5.66229e-17
C676	a_1756_97##2	a_1313_74##2	3.00597e-19
C677	a_177_290##9	a_177_290##3	1.0845e-18
C678	SCD#4	a_661_113##9	1.86608e-17
C679	VPWR#11	VPWR#9	6.66036e-17
C680	a_661_113##2	a_1510_74##16	6.37442e-17
C681	a_2403_74##18	a_1510_74##5	1.64365e-17
C682	a_545_87##4	a_1510_74##8	2.69629e-17
C683	a_1756_97##5	a_1313_74##6	6.58374e-17
C684	a_1510_74##12	a_1510_74##2	7.50919e-19
C685	a_37_464#	DE#5	5.42096e-20
C686	VGND#3	VGND#2	8.19814e-17
C687	a_631_87##5	SCE#3	1.46864e-19
C688	VGND#9	Q#3	4.15892e-17
C689	a_1313_74##8	a_1510_74#	4.78504e-18
C690	VPWR#3	a_2403_74##5	3.56387e-19
C691	VGND#12	a_1313_74##10	1.12219e-18
C692	VGND#24	DE#7	3.01366e-17
C693	a_545_87##8	SCE#1	2.2923e-18
C694	VPWR#20	a_1510_74#	1.2887e-18
C695	DE#4	a_177_290##3	1.32788e-17
C696	SCE#3	SCD#2	3.2005e-17
C697	D#4	a_37_464##6	5.74071e-17
C698	Q#5	VPWR#2	1.2789e-17
C699	a_37_464#	a_177_290##4	1.31768e-18
C700	SCE#1	CLK#3	6.02449e-18
C701	a_1313_74##11	a_2292_392#	1.31607e-17
C702	a_631_87##7	SCE#5	9.97962e-19
C703	a_37_464##2	a_177_290##8	5.03139e-17
C704	VPWR#3	a_545_87##11	1.28996e-18
C705	VPWR#3	a_2403_74##4	2.13719e-20
C706	a_1510_74##16	a_1313_74##8	2.95462e-17
C707	a_1313_74##11	a_545_87##4	8.00085e-19
C708	a_1510_74##6	a_2292_392#	4.40861e-18
C709	VGND#2	Q#1	8.19215e-19
C710	VPWR#10	a_631_87##4	3.81077e-18
C711	a_1943_53##8	a_1943_53##4	1.34534e-19
C712	VGND#3	Q#2	4.77017e-18
C713	DE#7	a_177_290##9	1.16288e-17
C714	a_545_87##9	a_1313_74##2	2.32316e-18
C715	a_37_464##2	a_631_87##2	6.81396e-19
C716	a_661_113##4	a_1313_74##15	3.82952e-17
C717	a_661_113##7	a_631_87##7	1.47554e-17
C718	a_1510_74##12	a_1313_74#	4.16048e-17
C719	VGND#24	a_177_290##4	1.5101e-17
C720	VGND#15	SCD#2	8.69009e-19
C721	a_1510_74##3	a_1943_53##8	1.42143e-17
C722	a_2403_74##18	a_1943_53##4	5.69706e-18
C723	a_545_87##8	SCE#2	1.18505e-20
C724	a_37_464##3	VPWR#24	7.3187e-17
C725	a_37_464##3	D#7	5.9806e-17
C726	VPWR#20	a_1313_74##8	3.98725e-17
C727	D#2	DE#4	5.20093e-19
C728	CLK#1	a_1313_74##8	2.5523e-18
C729	a_1313_74##13	CLK	3.3549e-17
C730	VGND#17	a_177_290##3	4.58172e-18
C731	VGND#24	DE#5	1.67106e-18
C732	a_661_113##2	VPWR#20	7.38368e-17
C733	VGND#3	Q#1	9.38345e-18
C734	a_545_87##9	a_1510_74##12	1.75303e-18
C735	VPWR#9	a_631_87##4	1.33611e-18
C736	VGND#12	VGND#5	1.25123e-18
C737	VGND#12	a_1510_74##5	2.7287e-18
C738	a_1510_74##3	a_1756_97##5	2.27487e-17
C739	SCE	a_631_87##7	3.8563e-18
C740	a_1510_74##5	a_1313_74##11	3.63246e-18
C741	VGND#17	a_545_87##8	5.35348e-18
C742	a_545_87##8	a_631_87##2	4.87242e-19
C743	a_545_87##10	VGND#9	2.01869e-17
C744	DE#3	a_37_464#	4.9548e-18
C745	VGND#25	DE#7	2.47131e-18
C746	a_37_464##6	a_177_290##9	3.87632e-19
C747	a_1943_53##8	a_1313_74##2	3.01013e-19
C748	VGND#9	a_2403_74##6	6.3908e-19
C749	VGND#16	SCE#1	3.90812e-18
C750	a_1313_74##2	a_1943_53##2	3.3413e-18
C751	a_545_87##13	a_545_87##11	4.14712e-19
C752	a_545_87##8	VGND#15	5.09014e-18
C753	VPWR#3	a_2403_74##7	4.04152e-19
C754	SCE#1	SCD#3	5.92117e-17
C755	VGND#7	VGND#6	5.52543e-19
C756	a_177_290##9	DE#5	9.76697e-18
C757	a_631_87##7	a_545_87#	1.58619e-19
C758	a_545_87##13	a_2403_74##6	3.38894e-17
C759	VPWR#21	CLK#2	3.55583e-19
C760	VGND#21	a_1510_74##15	4.13953e-17
C761	a_1313_74##6	a_1899_508#	3.48387e-18
C762	VGND#16	SCD#3	2.0988e-18
C763	a_1313_74##13	a_661_113##8	1.9708e-18
C764	a_177_290##4	a_545_87##2	3.75853e-17
C765	VPWR#20	CLK#1	3.47208e-18
C766	VPWR#11	a_631_87##2	3.25378e-19
C767	a_545_87##9	a_1510_74##10	1.2878e-17
C768	VGND#3	a_2403_74##5	8.43205e-19
C769	VPWR#21	a_1313_74##8	1.74485e-18
C770	a_2403_74##18	a_1756_97#	5.00518e-19
C771	a_177_290##9	DE#3	2.8986e-17
C772	a_631_87##4	CLK#1	5.58922e-18
C773	a_1943_53##8	a_1756_97#	6.87385e-18
C774	a_545_87##8	VGND#14	3.37254e-18
C775	VPWR#3	a_2403_74##9	5.554e-19
C776	DE#3	a_545_87##2	4.48899e-19
C777	a_661_113##4	VPWR#21	4.00119e-17
C778	a_2403_74##6	VGND#10	1.58842e-18
C779	a_2403_74##3	Q#4	4.35382e-19
C780	VGND#16	SCE#2	3.37295e-18
C781	a_545_87##3	a_497_113#	9.87534e-18
C782	a_1510_74##12	a_1313_74##9	7.56454e-19
C783	VPWR#9	VPWR#8	6.36506e-19
C784	a_545_87##8	a_661_113##8	2.07707e-17
C785	VPWR#10	SCD#1	3.64923e-18
C786	VGND#23	SCD#4	2.32642e-17
C787	VGND#12	a_1943_53##4	4.32875e-17
C788	VGND#25	DE#5	3.37553e-17
C789	a_177_290##3	a_497_113#	9.87534e-18
C790	a_545_87##13	VGND#9	6.98227e-17
C791	a_177_290#	a_37_464#	1.47387e-18
C792	a_37_464##6	VGND#25	1.71083e-17
C793	DE#3	a_177_290##4	3.26287e-17
C794	SCE#2	SCE#1	2.11749e-18
C795	a_1313_74##15	a_631_87##5	1.97549e-18
C796	a_177_290#	a_545_87##2	8.04147e-20
C797	a_1313_74##15	CLK#1	3.67342e-17
C798	VGND#3	a_2403_74##4	4.12618e-20
C799	VGND#15	SCE#3	8.79921e-19
C800	VGND#1	VPWR#1	3.83252e-19
C801	a_545_87##8	VGND#13	5.44139e-18
C802	a_661_113##2	a_1313_74##15	1.70379e-17
C803	VPWR#3	a_2403_74##11	2.84108e-18
C804	a_661_113##10	a_1313_74##8	6.39687e-19
C805	a_37_464##6	DE#7	9.51622e-20
C806	VGND#16	a_631_87##2	1.32116e-17
C807	a_1756_97##5	a_1510_74##2	9.17027e-17
C808	a_177_290#	a_177_290##4	3.23005e-18
C809	a_545_87##8	a_1510_74##15	8.72579e-18
C810	VGND#17	DE#7	2.98749e-18
C811	a_1943_53##5	a_1510_74##5	1.09563e-17
C812	VPWR#12	a_545_87##2	1.11134e-19
C813	a_177_290##9	D#3	1.57688e-18
C814	a_37_464##2	a_572_463#	2.4332e-18
C815	VGND#3	a_2403_74##3	2.42136e-20
C816	a_177_290#	DE#3	4.99302e-17
C817	VPWR#21	CLK#1	3.22515e-17
C818	a_631_87##7	SCD#5	1.33846e-18
C819	a_1313_74##13	a_1510_74##15	3.27063e-17
C820	a_2403_74##4	VGND#8	1.2179e-18
C821	a_631_87##5	a_661_113##10	6.52713e-19
C822	VPWR#3	a_2403_74##13	8.80503e-18
C823	VGND#16	a_545_87##3	9.60674e-18
C824	SCE#2	SCD#3	2.88282e-17
C825	a_1943_53##10	a_1943_53##4	4.25478e-19
C826	SCD#1	a_631_87##4	4.89489e-17
C827	a_545_87##8	VGND#21	3.52461e-18
C828	a_177_290##9	a_177_290#	2.90968e-18
C829	SCE#4	CLK#1	9.9498e-20
C830	D#2	DE#3	1.34117e-18
C831	a_1756_97##7	VPWR#19	8.35623e-18
C832	VPWR#5	VPWR#16	1.96285e-18
C833	VGND#2	a_2403_74#	1.37622e-18
C834	CLK	a_1313_74##15	1.83787e-17
C835	VGND#14	CLK#4	8.76835e-19
C836	a_1510_74##10	a_2331_74#	2.9996e-18
C837	a_1313_74##15	a_631_87##4	5.86219e-19
C838	VGND#3	a_2403_74##2	1.48009e-20
C839	a_1756_97##5	a_1313_74##2	2.47043e-17
C840	VGND#25	D#3	6.13186e-18
C841	D#2	a_177_290#	4.57232e-17
C842	VGND#16	a_177_290##3	4.52468e-18
C843	a_2403_74##2	Q#4	6.46853e-19
C844	a_1756_97#	a_1943_53##5	3.26754e-18
C845	a_661_113##10	CLK#1	3.79527e-18
C846	VGND#12	a_1756_97#	5.53053e-19
C847	a_545_87##8	a_1313_74##13	5.89038e-18
C848	SCE	a_631_87##10	1.5621e-17
C849	a_37_464##3	a_37_464##4	3.12276e-18
C850	a_37_464##2	SCE#4	1.36908e-19
C851	a_661_113##4	a_661_113##10	2.1847e-18
C852	VGND#15	VGND#14	1.42945e-18
C853	a_37_464##3	D#6	1.99444e-18
C854	a_37_464##6	DE#5	6.37228e-18
C855	VPWR	VPWR#9	2.05109e-17
C856	a_2403_74##5	Q#3	6.21085e-20
C857	Q#2	Q#1	7.89101e-20
C858	VPWR	VPWR#8	1.12813e-16
C859	VPWR	VPWR#6	1.06294e-16
C860	a_661_113##8	a_1313_74##4	5.37345e-19
C861	VGND#16	DE#7	4.45161e-18
C862	VPWR	VPWR#5	6.32688e-17
C863	VGND#20	a_1943_53##4	1.68632e-21
C864	VPWR#21	a_631_87##4	2.82795e-18
C865	VPWR#12	a_661_113##5	1.97613e-18
C866	DE#5	a_135_74#	9.7209e-18
C867	a_37_464##3	a_126_464#	3.16339e-18
C868	a_661_113##2	VPWR#21	1.72803e-20
C869	D#3	a_135_74#	1.01349e-17
C870	a_545_87##8	VGND#22	5.79289e-18
C871	VPWR#10	SCE#4	1.42115e-17
C872	a_1313_74##13	VGND#21	5.91177e-17
C873	SCE#4	SCD#1	1.75224e-17
C874	VGND#13	a_1510_74##12	3.39852e-17
C875	a_177_290##9	D#2	1.11799e-18
C876	a_2403_74##3	VGND#8	1.8981e-18
C877	a_1756_97##5	VPWR#8	7.61825e-19
C878	VGND#16	DE#5	3.06714e-18
C879	a_2403_74##6	VPWR#5	1.13643e-18
C880	a_661_113##2	a_1510_74##2	2.18293e-18
C881	VGND#24	DE#2	1.76337e-18
C882	a_1756_97#	a_1943_53##10	8.6642e-18
C883	a_661_113##10	a_631_87##4	3.88853e-17
C884	VGND#17	DE#5	1.13043e-18
C885	a_545_87##8	a_661_113##9	2.16028e-17
C886	VPWR#22	SCD#2	5.04061e-19
C887	VPWR#22	CLK#1	2.84523e-19
C888	VPWR#9	SCE#4	1.06251e-19
C889	VGND#16	VGND#17	9.22018e-17
C890	a_1313_74##4	a_1313_74##8	1.18693e-17
C891	VGND#16	D#3	2.07998e-18
C892	VPWR#4	a_2403_74##6	7.26809e-20
C893	a_1510_74##3	a_1858_79#	2.6952e-18
C894	a_37_464##6	D#3	3.96426e-17
C895	a_545_87##9	a_1943_53##8	3.83302e-17
C896	a_661_113##5	VPWR#10	4.63266e-17
C897	VPWR#21	SCD#1	3.56367e-19
C898	VGND#2	a_2403_74##8	2.43386e-18
C899	Q#2	a_2403_74#	1.96553e-20
C900	a_37_464##2	SCE#5	4.44214e-18
C901	VPWR#5	a_545_87##14	4.14931e-17
C902	a_37_464##6	D#2	9.49053e-18
C903	a_1943_53##2	a_1756_97#	8.90954e-18
C904	VPWR	a_1943_53##8	3.41565e-19
C905	VGND#16	VGND#15	1.06066e-16
C906	VPWR	a_1756_97##5	4.15139e-18
C907	a_661_113##8	a_1313_74##3	1.2866e-17
C908	a_2403_74##4	Q#3	3.97495e-19
C909	a_1756_97#	VGND#20	2.14254e-17
C910	a_661_113##4	a_1313_74##5	3.60793e-19
C911	VPWR	a_661_113##4	3.19867e-18
C912	a_545_87##9	a_1756_97##5	5.32422e-17
C913	VPWR	a_661_113##2	2.53796e-17
C914	SCE#5	SCE#4	4.89192e-18
C915	CLK	a_1313_74##9	1.50699e-18
C916	a_177_290##9	DE#4	2.37763e-17
C917	a_545_87##8	VGND#23	8.26506e-18
C918	VGND#22	VGND#21	9.61735e-19
C919	VPWR#3	VPWR#1	6.51719e-17
C920	a_661_113##10	SCD#1	3.1891e-18
C921	VPWR#12	SCE#5	1.19009e-18
C922	a_37_464##3	DE#5	1.36798e-18
C923	VGND#16	VGND#14	8.01071e-17
C924	a_2403_74##18	a_1510_74##8	4.96706e-17
C925	VPWR#22	a_631_87##4	3.11377e-18
C926	a_37_464##2	VPWR#12	3.64274e-17
C927	a_1510_74##3	a_1313_74##2	5.36084e-19
C928	a_661_113##5	CLK#1	9.71667e-20
C929	a_545_87##8	a_631_87##10	3.37381e-18
C930	VPWR#21	SCE#4	2.66928e-19
C931	Q#1	a_2403_74#	1.58136e-17
C932	a_545_87#	SCE#4	3.60741e-19
C933	a_1313_74##5	a_661_113##2	7.34083e-17
C934	VPWR#3	Q#5	1.50587e-17
C935	D#4	DE#4	1.1281e-19
C936	VGND	VGND#13	1.04059e-16
C937	VGND#16	VGND#13	2.3168e-18
C938	VGND#9	a_2403_74##5	1.23465e-17
C939	VGND#16	a_1313_74##13	1.16928e-17
C940	a_545_87##3	a_631_87##2	3.25849e-17
C941	VGND	VGND#6	9.59233e-17
C942	a_1510_74##15	a_1313_74##4	9.25912e-19
C943	VGND	VGND#5	9.71417e-17
C944	a_545_87##14	VPWR#4	9.69835e-18
C945	a_631_87##9	a_631_87##4	3.79211e-20
C946	a_545_87##5	VPWR#5	2.88586e-17
C947	a_1313_74#	a_1943_53##2	5.36283e-20
C948	a_661_113#	a_1756_97##7	4.93865e-17
C949	a_545_87##9	VPWR#16	2.89239e-17
C950	a_545_87##8	a_661_113##7	3.35971e-17
C951	a_1510_74##3	a_1943_53##4	3.64071e-19
C952	CLK#4	a_1313_74##15	3.72314e-18
C953	a_661_113##8	a_1313_74##2	3.29953e-18
C954	VPWR#3	VPWR#15	2.17844e-17
C955	a_661_113##10	SCE#4	4.01328e-19
C956	a_545_87#	SCE#5	4.5621e-17
C957	VGND	a_1510_74##12	3.68384e-17
C958	VGND#20	a_1943_53##3	2.44926e-17
C959	a_37_464##2	a_545_87#	2.02481e-17
C960	VGND	a_1510_74##10	3.21246e-17
C961	VPWR#22	SCD#1	3.36852e-17
C962	VGND#22	a_1313_74##13	5.15054e-17
C963	a_177_290##6	SCE#5	9.09117e-20
C964	VGND	a_1943_53##8	1.54845e-18
C965	a_1510_74##3	a_1756_97#	3.34045e-17
C966	a_661_113##4	a_1313_74##4	7.96894e-20
C967	a_661_113##4	VPWR#10	3.40409e-18
C968	VGND	a_1756_97##5	2.97806e-18
C969	Q#2	a_2403_74##8	5.34817e-20
C970	VGND#2	a_2403_74##10	1.39783e-18
C971	a_545_87##8	a_37_464#	5.69621e-17
C972	a_661_113##4	VPWR#22	3.25763e-17
C973	a_661_113##4	CLK#2	1.02562e-18
C974	VPWR	a_661_113##8	5.48213e-19
C975	VGND	a_661_113##2	1.20066e-18
C976	a_2403_74##18	a_1313_74##11	1.132e-18
C977	Q#6	VPWR#3	2.83258e-17
C978	VPWR#5	VPWR#17	6.79845e-18
C979	VGND#16	a_661_113##9	1.68023e-17
C980	VPWR#7	a_1313_74##2	2.28525e-20
C981	CLK#1	a_1313_74##4	1.38421e-17
C982	a_1510_74##3	a_1943_53##3	3.11219e-17
C983	VPWR#7	a_1756_97##3	4.40964e-18
C984	a_631_87##9	SCD#1	9.72409e-20
C985	VGND#14	VGND#13	1.05325e-18
C986	a_1510_74##2	a_1313_74##4	1.31253e-19
C987	a_1510_74##15	a_1313_74##3	3.70396e-18
C988	VPWR#12	a_545_87#	7.8712e-19
C989	VPWR#3	VPWR#16	1.74781e-17
C990	a_1510_74##3	a_1510_74##4	2.11573e-17
C991	a_177_290##3	a_545_87##3	4.71141e-17
C992	DE#1	a_545_87#	5.21603e-17
C993	VGND#25	DE#4	4.27713e-18
C994	SCE#4	VPWR#22	2.179e-17
C995	VGND#7	a_1510_74##12	3.68563e-17
C996	a_1756_97##5	a_1313_74#	3.3539e-19
C997	VPWR#7	a_1943_53#	3.93345e-18
C998	Q#1	a_2403_74##8	1.3683e-17
C999	a_2403_74##18	a_545_87##13	2.06929e-18
C1000	a_2403_74##6	a_2403_74##13	1.73826e-18
C1001	VGND#4	a_2403_74##12	4.53887e-20
C1002	a_661_113##5	SCD#1	6.30327e-19
C1003	VGND#20	a_1510_74##4	1.87271e-18
C1004	VPWR#1	a_2403_74##7	4.15707e-17
C1005	a_1313_74#	a_1510_74##3	1.53439e-17
C1006	a_661_113##8	a_1510_74##16	2.15669e-17
C1007	VGND#13	a_1510_74##15	4.38825e-17
C1008	VPWR	a_2403_74##16	2.54163e-17
C1009	a_661_113##9	a_1313_74##13	7.31605e-18
C1010	VPWR#3	a_545_87##14	2.05736e-17
C1011	VPWR#10	a_545_87#	1.8874e-19
C1012	VGND	a_2403_74##18	2.47127e-17
C1013	VPWR	VPWR#18	2.38223e-18
C1014	a_2403_74##5	a_2403_74##4	1.16725e-18
C1015	a_1510_74##2	a_1313_74##2	5.21266e-17
C1016	a_37_464##2	DE#1	2.76316e-17
C1017	VPWR	a_1943_53##7	4.48129e-18
C1018	Q#5	VPWR#1	5.54097e-17
C1019	VPWR	VPWR#19	2.59184e-18
C1020	VGND	a_1943_53##10	4.23126e-18
C1021	VPWR#5	a_1510_74##8	4.03632e-19
C1022	a_2403_74##4	a_2403_74##9	2.31942e-19
C1023	VPWR	a_1756_97##7	2.00185e-17
C1024	a_661_113##5	a_545_87##2	9.78055e-19
C1025	VPWR#7	a_1313_74##7	4.55484e-18
C1026	SCE#4	a_631_87##9	1.46999e-17
C1027	VGND	a_1756_97##6	3.36418e-18
C1028	VPWR	a_661_113#	2.02903e-17
C1029	a_177_290##6	a_545_87#	3.78026e-19
C1030	VGND	a_661_113##8	4.0623e-18
C1031	VPWR	a_1510_74##16	2.19263e-18
C1032	a_545_87##8	DE	3.21354e-18
C1033	VGND	a_1510_74##15	2.71573e-17
C1034	VPWR	VPWR#20	1.3611e-17
C1035	VGND	VGND#21	1.25317e-17
C1036	VGND	a_1313_74##13	1.37344e-17
C1037	VPWR	a_1313_74##15	2.94145e-18
C1038	VPWR#11	DE	3.08607e-18
C1039	VGND#16	a_631_87##10	8.46633e-18
C1040	VGND#21	a_1313_74##4	9.25933e-19
C1041	a_1510_74##16	a_661_113#	3.22364e-18
C1042	a_545_87##9	a_2403_74##16	2.17767e-17
C1043	a_545_87##5	a_2403_74##13	1.6224e-19
C1044	a_661_113##4	VPWR#9	6.24729e-18
C1045	a_661_113##4	a_661_113##2	1.15135e-18
C1046	VGND#14	VGND#21	4.34887e-19
C1047	a_631_87##9	a_661_113##4	3.39375e-17
C1048	a_631_87##5	a_661_113##4	1.28797e-16
C1049	a_2403_74##7	Q#5	2.5041e-17
C1050	Q#2	a_2403_74##10	1.67835e-17
C1051	VGND#7	a_1510_74##10	5.24784e-18
C1052	VPWR#7	a_1510_74#	2.16427e-18
C1053	VGND#5	a_2403_74##14	2.12372e-17
C1054	a_1510_74##2	a_1313_74#	4.15638e-18
C1055	DE#6	DE#1	1.19331e-17
C1056	a_545_87##8	CLK	1.30786e-17
C1057	a_661_113##5	SCE#4	3.34764e-17
C1058	a_2403_74##8	a_2403_74#	3.4802e-17
C1059	VGND#16	a_661_113##7	2.7165e-17
C1060	a_2403_74##5	VNB	4.12603e-17
C1061	SCE	SCE#4	3.20694e-20
C1062	a_545_87##5	a_2403_74##15	1.50536e-17
C1063	a_2403_74##4	VNB	1.64701e-17
C1064	a_2403_74##3	VNB	1.68306e-17
C1065	a_2403_74##2	VNB	2.57061e-17
C1066	a_1313_74##4	VNB	6.76974e-17
C1067	a_1313_74##3	VNB	3.14558e-17
C1068	a_1313_74##2	VNB	4.78499e-17
C1069	DE#4	VNB	4.5476e-17
C1070	DE#2	VNB	3.99439e-17
C1071	CLK#4	CLK#2	3.09441e-17
C1072	a_37_464##3	DE#6	2.33509e-18
C1073	VGND	a_2403_74##16	6.91808e-19
C1074	VPWR#1	a_2403_74##9	2.51416e-18
C1075	a_1510_74##2	a_1313_74##9	1.63809e-19
C1076	DE#7	a_177_290##3	2.3525e-17
C1077	a_545_87##10	Q#2	8.36081e-18
C1078	a_631_87##9	SCE#5	3.26754e-18
C1079	a_1943_53##8	a_1943_53##6	2.93635e-19
C1080	VPWR#15	VPWR#1	2.06271e-18
C1081	a_661_113##9	VGND#22	4.58927e-17
C1082	VGND#5	a_2403_74##6	7.09276e-17
C1083	VGND#7	a_1313_74##2	4.04194e-20
C1084	VGND#16	a_37_464#	2.73991e-17
C1085	VGND	a_1510_74##16	1.00145e-18
C1086	VPWR#15	a_2403_74##7	2.58765e-18
C1087	VGND	a_1313_74##15	1.23088e-18
C1088	VPWR#12	DE#1	7.00939e-18
C1089	a_545_87##8	a_1510_74##12	1.19619e-18
C1090	a_545_87##9	VPWR#18	3.24999e-18
C1091	VGND#17	DE#3	4.91834e-19
C1092	a_1510_74##4	a_1756_97##6	9.87978e-18
C1093	a_1313_74##5	a_1313_74#	8.09793e-20
C1094	VPWR#12	VNB	3.56787e-17
C1095	VPWR#10	VNB	4.73257e-17
C1096	a_37_464##2	DE#6	3.36901e-17
C1097	VGND#4	a_2403_74##14	1.95272e-18
C1098	VPWR#9	VNB	4.65346e-17
C1099	VPWR#8	VNB	6.01867e-17
C1100	a_1313_74##5	a_1313_74##4	3.14704e-17
C1101	VPWR#6	VNB	5.80886e-17
C1102	VPWR#5	VNB	6.10561e-17
C1103	a_2403_74##3	Q#5	2.39747e-19
C1104	VPWR#4	VNB	2.38136e-17
C1105	VGND#6	a_545_87##4	1.00433e-19
C1106	a_1313_74##11	VPWR#6	1.17957e-17
C1107	VPWR#2	VNB	2.68576e-17
C1108	a_545_87##8	SCE	7.7294e-18
C1109	VGND#4	a_2403_74##6	1.13148e-19
C1110	VGND#17	VNB	4.03861e-17
C1111	VGND#15	VNB	4.01065e-17
C1112	VGND#14	VNB	3.76385e-17
C1113	a_1510_74##7	a_545_87##5	3.11563e-17
C1114	VGND#13	VNB	6.24765e-17
C1115	VPWR#11	SCE	1.26112e-18
C1116	a_661_113##5	SCE#5	6.39608e-17
C1117	a_2403_74##9	Q#5	2.77538e-17
C1118	VGND#6	VNB	4.71246e-17
C1119	VGND#5	VNB	6.84621e-17
C1120	a_177_290##2	DE#6	3.73468e-18
C1121	VGND#4	VNB	2.74225e-17
C1122	VGND#16	SCE	1.23263e-18
C1123	VGND#2	VNB	3.46579e-17
C1124	Q#2	VNB	1.43941e-18
C1125	CLK	a_1313_74##5	3.15708e-17
C1126	VPWR#2	a_2403_74##9	1.11847e-18
C1127	Q#1	VNB	5.64399e-17
C1128	a_1313_74##5	a_1313_74##9	2.88514e-18
C1129	a_545_87##11	VNB	6.04394e-18
C1130	a_545_87##10	VNB	3.39091e-18
C1131	a_545_87##9	a_1943_53##7	5.87726e-18
C1132	a_1510_74##12	VNB	1.50722e-17
C1133	Q#6	a_2403_74##7	1.71282e-19
C1134	a_1510_74##10	VNB	2.24224e-17
C1135	a_1313_74##11	VPWR#5	4.68197e-19
C1136	a_1943_53##8	VNB	1.02335e-17
C1137	DE	a_177_290##4	1.88045e-17
C1138	a_1756_97##5	VNB	8.50411e-18
C1139	VGND	a_1943_53##3	4.75229e-18
C1140	a_661_113##4	SCD#2	5.29495e-19
C1141	a_631_87##9	a_545_87#	3.06555e-20
C1142	a_661_113##4	VNB	1.93096e-17
C1143	VPWR#23	DE#2	4.23615e-19
C1144	DE	DE#3	8.4947e-18
C1145	a_661_113##2	VNB	1.62091e-17
C1146	VGND	a_1313_74##9	1.59039e-18
C1147	VPWR	a_1756_97##3	7.25227e-18
C1148	a_177_290#	DE	2.57573e-17
C1149	a_631_87##7	VNB	5.96653e-18
C1150	a_1313_74##5	a_1313_74##2	4.28635e-19
C1151	SCE#5	a_37_464##5	6.58839e-18
C1152	VGND#14	a_1313_74##13	9.1943e-18
C1153	SCD#5	VNB	9.9138e-19
C1154	SCD#4	VNB	2.92926e-18
C1155	VPWR#15	Q#5	5.67976e-17
C1156	Q#2	a_2403_74##12	5.44964e-18
C1157	a_37_464##3	VNB	9.28348e-17
C1158	a_545_87##9	VPWR#19	2.34344e-18
C1159	a_37_464##2	VNB	1.61807e-17
C1160	VGND#2	a_2403_74##14	1.90038e-19
C1161	VPWR#15	a_2403_74##9	5.15334e-17
C1162	a_177_290##6	VNB	1.23283e-18
C1163	VGND#12	a_1943_53##5	1.75911e-18
C1164	VGND#5	a_545_87##4	3.40614e-17
C1165	a_37_464##3	a_177_290##2	2.95355e-17
C1166	D#6	VNB	9.16767e-19
C1167	a_545_87##8	a_1313_74##4	6.58732e-18
C1168	a_2403_74##10	a_2403_74##8	2.61584e-17
C1169	CLK#4	a_631_87##5	6.86463e-19
C1170	D#4	VNB	5.77621e-18
C1171	DE#5	DE#7	3.90643e-18
C1172	VGND#1	VNB	5.79879e-17
C1173	Q#4	VNB	5.88823e-18
C1174	VGND#8	VNB	4.29235e-18
C1175	VGND#16	a_177_290##9	1.80449e-17
C1176	a_1313_74##13	a_1313_74##4	1.16717e-18
C1177	Q#3	VNB	2.91765e-18
C1178	VGND#9	VNB	1.05516e-17
C1179	a_545_87##13	VNB	1.32859e-17
C1180	CLK#2	a_1313_74##9	2.57246e-18
C1181	a_661_113##5	a_545_87#	2.10288e-18
C1182	a_2403_74##18	VNB	3.99045e-18
C1183	a_2403_74##4	VPWR#15	4.27701e-19
C1184	VGND#12	VNB	5.87908e-19
C1185	a_2403_74##2	Q#5	2.36551e-19
C1186	a_1943_53##10	VNB	1.25426e-19
C1187	a_1313_74#	a_1756_97##6	1.6885e-17
C1188	a_1313_74##12	a_1510_74##8	6.85082e-18
C1189	a_1756_97##6	VNB	5.96876e-18
C1190	SCE	SCE#3	7.56403e-18
C1191	a_2403_74##16	VPWR#5	4.11292e-17
C1192	a_661_113##8	VNB	1.80397e-17
C1193	a_545_87##8	CLK#1	2.29048e-18
C1194	a_1510_74##15	VNB	1.59693e-17
C1195	D#1	a_177_290##2	3.84079e-17
C1196	VGND#21	VNB	2.89184e-18
C1197	a_1313_74##13	VNB	1.02357e-17
C1198	a_545_87##9	VPWR	8.0101e-17
C1199	Q#5	a_2403_74##11	7.99216e-19
C1200	VGND#22	VNB	4.08242e-18
C1201	a_661_113##9	VNB	1.87682e-17
C1202	VGND#15	VGND#22	9.21401e-19
C1203	VGND#23	VNB	9.44431e-19
C1204	a_631_87##10	VNB	3.18285e-18
C1205	a_661_113##7	VNB	8.45241e-18
C1206	a_37_464#	VNB	7.99286e-18
C1207	VPWR	VPWR#7	1.03574e-16
C1208	VGND#13	a_1313_74##4	1.84549e-20
C1209	Q#2	a_2403_74##6	1.30814e-18
C1210	VGND#24	VNB	2.39089e-18
C1211	a_545_87##8	a_1313_74##3	1.24168e-18
C1212	a_177_290##9	VNB	9.80369e-18
C1213	a_1313_74##11	a_1510_74##7	9.58104e-19
C1214	a_37_464##2	a_177_290##2	1.00991e-19
C1215	VGND#25	VNB	7.30434e-18
C1216	a_661_113##8	a_661_113##2	1.01035e-18
C1217	a_545_87##8	VPWR	3.04325e-17
C1218	a_37_464##6	VNB	6.11585e-17
C1219	SCD#4	CLK#2	2.98596e-19
C1220	VPWR#1	VNB	6.05544e-17
C1221	Q#5	VNB	5.27995e-18
C1222	VPWR#15	VNB	2.19277e-19
C1223	Q#6	a_2403_74##9	4.05213e-19
C1224	Q#6	VNB	4.9807e-18
C1225	VPWR#16	VNB	9.7887e-18
C1226	a_545_87##14	VNB	9.51797e-18
C1227	a_2403_74##16	VNB	9.32474e-18
C1228	VPWR	a_545_87##5	2.4515e-18
C1229	a_631_87##7	a_631_87##5	1.40266e-18
C1230	VPWR#18	VNB	3.53583e-18
C1231	a_37_464##5	a_545_87#	2.9903e-17
C1232	a_1943_53##7	VNB	4.8697e-18
C1233	VPWR	a_1510_74##8	1.4054e-18
C1234	VPWR#19	VNB	2.22707e-18
C1235	a_661_113##2	a_1313_74##4	2.75995e-17
C1236	VPWR	a_1313_74##11	2.31939e-17
C1237	a_1756_97##7	VNB	2.50906e-18
C1238	VPWR#12	DE#6	6.14426e-18
C1239	Q#2	VPWR#2	3.17506e-19
C1240	a_661_113#	VNB	1.01756e-17
C1241	VGND#6	a_1510_74##10	3.34856e-17
C1242	a_1510_74##16	VNB	1.57226e-18
C1243	VPWR	a_1510_74##6	2.35614e-18
C1244	a_37_464##2	a_661_113##7	1.01545e-17
C1245	VPWR#20	VNB	4.29396e-18
C1246	VGND#4	a_545_87##4	6.17026e-20
C1247	SCE#1	CLK#2	4.9762e-19
C1248	a_1313_74##15	VNB	6.74389e-18
C1249	VGND	a_545_87##9	7.78726e-17
C1250	VPWR	a_1943_53##5	1.79602e-18
C1251	VPWR#21	VNB	3.88139e-18
C1252	a_661_113##10	VNB	9.7617e-18
C1253	VPWR#11	CLK#1	4.75703e-18
C1254	VPWR#23	SCE#5	4.02351e-19
C1255	VPWR	a_1756_97##2	3.40287e-18
C1256	a_545_87##9	a_1756_97##7	1.1055e-18
C1257	VPWR#22	VNB	5.33313e-19
C1258	a_1313_74##11	a_1313_74##12	2.50556e-17
C1259	a_631_87##9	VNB	8.42918e-18
C1260	VGND#6	a_1313_74##10	1.39127e-19
C1261	a_661_113##5	VNB	1.68547e-17
C1262	a_1756_97##5	a_1756_97##3	3.5072e-20
C1263	a_37_464##5	VNB	2.63233e-18
C1264	a_545_87##8	a_1313_74##2	9.23144e-19
C1265	VGND	VGND#7	1.26838e-16
C1266	VPWR	a_1313_74##6	2.59892e-17
C1267	Q#6	Q#5	2.19821e-18
C1268	DE#4	DE#2	1.33292e-18
C1269	VPWR#23	VNB	3.26483e-19
C1270	a_177_290##8	VNB	3.90666e-19
C1271	VGND	a_545_87##8	2.84778e-17
C1272	VPWR#6	a_1510_74##6	1.86535e-19
C1273	VPWR#24	VNB	1.14508e-18
C1274	VPWR#15	a_2403_74##11	4.47931e-17
C1275	VPWR	a_1510_74##2	7.02597e-19
C1276	a_1313_74#	a_661_113##8	1.79127e-17
C1277	VGND#13	a_1313_74##13	9.13842e-18
C1278	a_2403_74#	VNB	2.98763e-17
C1279	a_2403_74##8	VNB	2.45766e-17
C1280	VPWR	a_1313_74##5	9.64729e-19
C1281	a_2403_74##10	VNB	2.76837e-17
C1282	VGND	a_2403_74##6	3.47376e-18
C1283	a_2403_74##12	VNB	2.70052e-17
C1284	a_2403_74##14	VNB	4.07895e-17
C1285	a_661_113##5	DE#1	3.75866e-19
C1286	a_545_87##4	VNB	5.82449e-17
C1287	a_1313_74##10	VNB	2.99937e-17
C1288	VGND	a_1510_74##8	4.05991e-18
C1289	VGND#17	DE#4	3.80094e-19
C1290	a_1510_74##5	VNB	2.92145e-17
C1291	SCD#3	CLK#2	2.12083e-19
C1292	a_1943_53##4	VNB	2.89908e-17
C1293	VGND	a_1313_74##11	2.14484e-18
C1294	VPWR#2	a_2403_74##11	1.75999e-18
C1295	a_1756_97#	VNB	3.78556e-17
C1296	VGND#23	VGND#22	4.24384e-18
C1297	a_1943_53##3	VNB	2.69558e-17
C1298	VGND	a_1510_74##6	5.81933e-20
C1299	a_661_113##4	SCE#3	6.91322e-19
C1300	a_1510_74##4	VNB	2.35845e-17
C1301	a_1313_74#	VNB	4.71168e-17
C1302	VGND	a_1943_53##5	3.37023e-18
C1303	a_1313_74##9	VNB	4.50304e-17
C1304	CLK#3	VNB	3.67536e-17
C1305	VGND	a_1756_97##2	2.1726e-18
C1306	CLK#2	a_1313_74##4	7.49175e-18
C1307	SCE#1	VNB	7.18731e-17
C1308	SCD#3	VNB	1.86574e-17
C1309	VGND	a_1943_53##2	1.91318e-18
C1310	SCE#2	VNB	5.55094e-17
C1311	a_2403_74##5	Q#6	3.19663e-20
C1312	a_2403_74##3	VPWR#15	7.58871e-19
C1313	a_1313_74##11	a_1943_53##6	4.08769e-17
C1314	VPWR#11	a_631_87##4	1.00207e-17
C1315	a_631_87##2	VNB	5.02605e-17
C1316	a_545_87##3	VNB	2.80983e-17
C1317	a_177_290##3	VNB	2.46326e-17
C1318	VGND	a_1510_74##3	4.32864e-17
C1319	DE#7	VNB	2.43757e-17
C1320	a_545_87##9	a_661_113#	1.32368e-18
C1321	DE#5	VNB	3.87749e-17
C1322	D#3	VNB	4.21034e-17
C1323	VGND#16	a_37_464##6	2.3535e-17
C1324	a_2403_74##7	VNB	3.83546e-17
C1325	a_37_464##3	D#1	4.70654e-17
C1326	a_2403_74##9	VNB	2.82209e-17
C1327	a_2403_74##11	VNB	3.05303e-17
C1328	D#3	DE#5	4.79359e-17
C1329	Q#5	a_2403_74##13	2.65622e-19
C1330	a_2403_74##13	VNB	3.51651e-17
C1331	a_2403_74##15	VNB	4.17676e-17
C1332	a_545_87##6	VNB	1.89962e-17
C1333	a_1510_74##7	VNB	3.64831e-17
C1334	a_1313_74##12	VNB	3.11223e-17
C1335	a_1943_53##6	VNB	4.74745e-17
C1336	a_1756_97##3	VNB	3.9107e-17
C1337	CLK#4	SCD#2	1.24e-19
C1338	a_1943_53#	VNB	4.52951e-17
C1339	a_631_87##5	SCE#1	2.26934e-18
C1340	a_1313_74##7	VNB	1.87915e-17
C1341	a_1510_74#	VNB	2.40003e-17
C1342	a_1313_74##8	VNB	3.67598e-17
C1343	a_37_464##5	DE#1	2.8275e-18
C1344	CLK#1	VNB	6.58777e-17
C1345	a_631_87##4	VNB	3.55656e-17
C1346	SCD#1	VNB	3.27663e-17
C1347	VPWR#5	a_2403_74##13	9.31552e-19
C1348	SCE#4	VNB	7.27295e-17
C1349	SCD#5	a_631_87##5	5.51419e-17
C1350	a_2403_74##11	Q#6	2.41875e-17
C1351	SCE#5	VNB	6.6698e-17
C1352	a_1313_74##11	a_1756_97##3	7.46026e-19
C1353	a_661_113##2	VPWR#9	1.86845e-18
C1354	a_545_87#	VNB	3.76792e-17
C1355	DE#1	VNB	4.56388e-17
C1356	VGND#5	a_1313_74##10	8.29745e-18
C1357	DE#6	VNB	2.87301e-17
C1358	VPWR#11	SCD#1	4.37787e-18
C1359	a_2403_74##6	a_545_87##11	3.11578e-17
C1360	a_2403_74##12	a_2403_74##10	3.66917e-17
C1361	a_177_290##2	VNB	2.75038e-17
C1362	D#1	VNB	4.66917e-17
C1363	VPWR#23	a_545_87#	2.6482e-18
C1364	DE#2	a_177_290##8	1.07144e-18
C1365	a_545_87##9	VNB	1.1723e-17
C1366	a_1510_74##15	a_1313_74#	1.14584e-18
C1367	VPWR#3	VNB	1.71801e-16
C1368	VGND#3	VNB	1.75499e-16
C1369	VPWR#7	VNB	5.35726e-17
C1370	VGND#7	VNB	6.79514e-17
C1371	a_545_87##8	VNB	2.82714e-17
C1372	VPWR#11	VNB	3.18558e-16
C1373	VGND#16	VNB	3.24892e-16
C1374	VGND#9	VPWR#16	4.56235e-18
C1375	a_177_290#	VPWR#24	4.46074e-18
C1376	a_1943_53##6	a_1510_74##6	1.03572e-17
C1377	a_2403_74##6	VNB	9.05816e-17
C1378	a_545_87##5	VNB	6.15077e-17
C1379	a_1510_74##8	VNB	4.38688e-17
C1380	a_1313_74##11	VNB	4.61398e-17
C1381	a_1510_74##6	VNB	2.98752e-17
C1382	a_1943_53##5	VNB	6.72728e-17
C1383	a_2403_74##4	a_2403_74##3	8.81379e-19
C1384	SCD#4	a_631_87##5	4.0305e-18
C1385	a_1756_97##2	VNB	4.41404e-17
C1386	a_1943_53##2	VNB	6.44187e-17
C1387	a_177_290##6	a_177_290##2	1.89106e-19
C1388	Q#6	VPWR#15	5.54683e-17
C1389	a_1313_74##6	VNB	6.04511e-17
C1390	a_1510_74##3	VNB	4.38746e-17
C1391	a_1510_74##15	a_661_113##2	7.69615e-18
C1392	a_1510_74##2	VNB	5.84661e-17
C1393	a_1313_74##5	VNB	3.71406e-21
C1394	a_545_87##8	SCE#5	1.66954e-18
C1395	CLK#2	VNB	4.05008e-17
C1396	VPWR#15	a_2403_74##13	2.41273e-18
C1397	a_631_87##5	VNB	8.03658e-17
C1398	SCD#2	VNB	5.18949e-17
C1399	SCE#3	VNB	4.36306e-17
C1400	VGND#15	a_661_113##9	7.55093e-19
C1401	VGND#4	a_2403_74##5	3.73179e-20
C1402	a_545_87##10	a_2403_74##6	1.02179e-16
C1403	a_545_87##2	VNB	8.29151e-17
C1404	a_177_290##4	VNB	5.18465e-17
C1405	a_631_87##7	SCD#2	7.62893e-19
C1406	DE#3	VNB	3.05452e-17
C1407	VGND#15	SCD#4	1.58402e-18
C1408	a_177_290#	VNB	6.94243e-17
C1409	VGND#13	a_1313_74##3	1.30352e-19
C1410	D#4	DE#5	5.83023e-18
C1411	a_631_87##5	SCE#2	6.79228e-20
C1412	a_37_464#	a_37_464##2	1.28401e-18
C1413	D#2	VNB	7.21357e-17
C1414	a_661_113##8	a_1313_74##9	3.50289e-18
C1415	a_661_113##2	a_1313_74##3	8.18149e-18
C1416	SCE#1	SCD#2	6.4545e-19
C1417	VPWR#4	a_2403_74##13	6.55226e-20
C1418	VPWR#16	a_2403_74##11	2.4902e-18
C1419	VGND#23	a_661_113##9	1.6021e-17
C1420	a_2403_74##4	Q#6	2.52534e-19
C1421	a_661_113#	a_1313_74##2	3.11108e-19
C1422	VPWR	CLK	7.82705e-19
C1423	a_1510_74##12	a_1756_97##5	6.68661e-19
C1424	VGND	CLK	2.44792e-18
C1425	a_37_464##5	DE#6	3.79243e-19
C1426	a_1510_74##16	a_1313_74##4	9.9809e-19
C1427	VGND#21	a_1313_74#	1.97488e-19
C1428	Q#1	VPWR#2	3.08746e-19
C1429	CLK	VNB	9.37374e-18
C1430	VPWR#12	a_177_290##2	1.44216e-19
C1431	VPWR#11	SCE#5	1.35506e-17
C1432	SCE	VNB	2.31614e-18
C1433	VGND#6	a_1510_74##5	5.72889e-18
C1434	VPWR#23	DE#1	3.05248e-17
C1435	VPWR	VNB	2.14359e-16
C1436	VGND	VNB	2.16608e-16
C1437	a_2403_74##13	Q#6	2.01875e-17
C1438	VPWR#13	DE#3	2.29836e-20
C1439	DE#3	a_631_87#	8.51981e-20
C1440	a_631_87#	SCE#1	2.36198e-19
C1441	VGND#17	a_631_87#	2.89403e-18
C1442	a_177_290##4	a_631_87#	3.76875e-19
C1443	VPWR#13	DE#6	8.967e-19
C1444	a_631_87#	VNB	1.64241e-16
C1445	a_545_87##2	a_631_87#	7.90539e-18
C1446	VGND#24	a_631_87#	2.70343e-18
C1447	a_37_464##2	a_631_87#	6.50151e-19
C1448	VPWR#13	VNB	6.92551e-17
C1449	a_631_87#	SCE#3	5.1212e-17
C1450	a_37_464#	a_631_87#	6.62727e-18
C1451	VGND#18	D#3	8.35475e-18
C1452	VPWR#13	a_177_290##2	7.19547e-18
C1453	a_661_113##7	a_631_87#	1.06246e-16
C1454	a_631_87##5	a_631_87#	1.66928e-19
C1455	VGND#16	VGND#18	1.31259e-16
C1456	a_37_464##3	VPWR#13	6.38358e-17
C1457	VGND#18	a_177_290#	6.72307e-19
C1458	VGND#18	a_37_464##6	2.85663e-17
C1459	VPWR#11	VPWR#13	1.31392e-16
C1460	VGND#16	a_631_87#	4.70489e-17
C1461	VPWR#13	DE#4	2.54094e-20
C1462	a_631_87#	a_177_290##3	1.94428e-19
C1463	a_631_87#	SCE	3.68865e-17
C1464	a_631_87#	VGND#23	8.10439e-18
C1465	VPWR#11	a_631_87#	7.24707e-20
C1466	a_631_87#	a_545_87##3	3.21364e-19
C1467	VGND#18	D#4	3.09539e-18
C1468	a_631_87#	SCD#5	1.7268e-18
C1469	VGND#18	VNB	6.49012e-17
C1470	VPWR#13	DE#1	2.25396e-19
C1471	VGND#18	a_177_290##9	4.17491e-18
C1472	a_631_87#	SCE#5	2.08617e-18
C1473	a_545_87##8	a_631_87#	3.54222e-18
C1474	a_631_87##2	a_631_87#	1.16959e-17
C1475	VGND#18	DE#5	7.9213e-18
C1476	a_631_87#	a_661_113##9	1.65797e-18
C1477	VPWR#13	D#1	7.60742e-18
C1478	a_631_87#	SCE#4	6.89342e-18
C1479	a_631_87#	SCE#2	3.07457e-17
C1480	a_661_113##5	a_631_87#	1.10627e-17
C1481	VGND#18	VGND#17	1.41197e-18
C1482	VPWR#13	VPWR#12	5.53051e-19
C1483	VGND#18	DE#4	6.58622e-19
C1484	a_37_464##2	VPWR#13	1.02041e-18
C1485	a_631_87#	SCD#3	2.44606e-19
C1486	VGND#15	a_631_87#	2.19014e-17
C1487	VPWR#13	DE#2	3.19284e-19
C1488	a_631_87##7	a_631_87#	1.89653e-17
*
*
.ENDS sky130_fd_sc_hs__sedfxtp_4
*
