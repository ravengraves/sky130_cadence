* Extracted by Quantus, converted by sky130cad/quantus.py
*
*
*
*                       LINUX           Wed Nov 18 08:12:08 2026
*
*
*
*  PROGRAM  advgen
*
*  Name           : advgen - Quantus - (64-bit)
*  Version        : 25.1.0-p047
*  Build Date     : Thu Dec 11 23:20:30 PST 2025
*
*  HSPICE LIBRARY
*
*  OPERATING_TEMPERATURE 150
*  QRC_TECH_DIR <path>/tech
*
*
*

*
.SUBCKT sky130_fd_sc_hs__a311oi_4 VPB VNB VGND VPWR Y B1 C1 A3 A2 A1
*
*
*  caps2d version: 10
*
*
*       TRANSISTOR CARDS
*
*
XM11 VGND#11 A3#13 a_34_74##4 VNB sky130_fd_pr__nfet_01v8_lvt l=0.15 w=0.74 ad=0.2072 as=0.2109 pd=2.04 ps=2.05
XM14 a_34_74##7 A3#11 VGND#11 VNB sky130_fd_pr__nfet_01v8_lvt l=0.15 w=0.74 ad=0.2072 as=0.2072 pd=2.04 ps=2.04
XM22 a_34_74##7 A3#9 VGND#10 VNB sky130_fd_pr__nfet_01v8_lvt l=0.15 w=0.74 ad=0.2072 as=0.2072 pd=2.04 ps=2.04
XM17 VGND#10 A3#8 a_34_74# VNB sky130_fd_pr__nfet_01v8_lvt l=0.15 w=0.74 ad=0.2072 as=0.2072 pd=2.04 ps=2.04
XM33 a_34_74# A2#11 a_465_74##6 VNB sky130_fd_pr__nfet_01v8_lvt l=0.15 w=0.74 ad=0.2072 as=0.2072 pd=2.04 ps=2.04
XM27 a_34_74##5 A2#9 a_465_74##6 VNB sky130_fd_pr__nfet_01v8_lvt l=0.15 w=0.74 ad=0.2072 as=0.2072 pd=2.04 ps=2.04
XM35 a_465_74##4 A2#8 a_34_74##5 VNB sky130_fd_pr__nfet_01v8_lvt l=0.15 w=0.74 ad=0.2072 as=0.2072 pd=2.04 ps=2.04
XM31 a_465_74##4 A2#6 a_34_74##8 VNB sky130_fd_pr__nfet_01v8_lvt l=0.15 w=0.74 ad=0.2072 as=0.1961 pd=2.04 ps=2.01
XM29 a_465_74##2 A1#10 Y#8 VNB sky130_fd_pr__nfet_01v8_lvt l=0.15 w=0.74 ad=0.2072 as=0.1961 pd=2.04 ps=2.01
XM18 Y#6 A1#6 a_465_74##2 VNB sky130_fd_pr__nfet_01v8_lvt l=0.15 w=0.74 ad=0.2072 as=0.2072 pd=2.04 ps=2.04
XM9 Y#6 A1#4 a_465_74# VNB sky130_fd_pr__nfet_01v8_lvt l=0.15 w=0.74 ad=0.2072 as=0.2072 pd=2.04 ps=2.04
XM34 a_465_74# A1#1 Y#12 VNB sky130_fd_pr__nfet_01v8_lvt l=0.15 w=0.74 ad=0.2072 as=0.2072 pd=2.04 ps=2.04
XM10 VGND#9 B1#7 Y#12 VNB sky130_fd_pr__nfet_01v8_lvt l=0.15 w=0.74 ad=0.8362 as=0.2072 pd=3.74 ps=2.04
XM2 Y#11 B1#4 VGND#9 VNB sky130_fd_pr__nfet_01v8_lvt l=0.15 w=0.74 ad=0.2072 as=0.8362 pd=2.04 ps=3.74
XM6 VGND#8 C1#5 Y#11 VNB sky130_fd_pr__nfet_01v8_lvt l=0.15 w=0.74 ad=0.2072 as=0.2072 pd=2.04 ps=2.04
XM20 Y#1 C1#7 VGND#8 VNB sky130_fd_pr__nfet_01v8_lvt l=0.15 w=0.74 ad=0.2109 as=0.2072 pd=2.05 ps=2.04
XM21 VPWR#9 A3#7 a_114_368##8 VPB sky130_fd_pr__pfet_01v8 l=0.15 w=1.12 ad=0.308 as=0.336 pd=2.79 ps=2.84
XM12 VPWR#15 A3#12 a_114_368##8 VPB sky130_fd_pr__pfet_01v8 l=0.15 w=1.12 ad=0.336 as=0.336 pd=2.84 ps=2.84
XM4 a_114_368##14 A3#10 VPWR#15 VPB sky130_fd_pr__pfet_01v8 l=0.15 w=1.12 ad=0.336 as=0.336 pd=2.84 ps=2.84
XM0 a_114_368##14 A3#1 VPWR#14 VPB sky130_fd_pr__pfet_01v8 l=0.15 w=1.12 ad=0.336 as=0.336 pd=2.84 ps=2.84
XM25 VPWR#14 A2#13 a_114_368##13 VPB sky130_fd_pr__pfet_01v8 l=0.15 w=1.12 ad=0.336 as=0.336 pd=2.84 ps=2.84
XM24 VPWR#13 A2#12 a_114_368##13 VPB sky130_fd_pr__pfet_01v8 l=0.15 w=1.12 ad=0.336 as=0.336 pd=2.84 ps=2.84
XM8 a_114_368##12 A2#7 VPWR#13 VPB sky130_fd_pr__pfet_01v8 l=0.15 w=1.12 ad=0.336 as=0.336 pd=2.84 ps=2.84
XM7 a_114_368##12 A2#1 VPWR#12 VPB sky130_fd_pr__pfet_01v8 l=0.15 w=1.12 ad=0.336 as=0.336 pd=2.84 ps=2.84
XM30 VPWR#12 A1#13 a_114_368##11 VPB sky130_fd_pr__pfet_01v8 l=0.15 w=1.12 ad=0.336 as=0.336 pd=2.84 ps=2.84
XM13 VPWR#11 A1#14 a_114_368##11 VPB sky130_fd_pr__pfet_01v8 l=0.15 w=1.12 ad=0.336 as=0.336 pd=2.84 ps=2.84
XM32 a_114_368##10 A1#11 VPWR#11 VPB sky130_fd_pr__pfet_01v8 l=0.15 w=1.12 ad=0.336 as=0.336 pd=2.84 ps=2.84
XM15 a_114_368##10 A1#7 VPWR#10 VPB sky130_fd_pr__pfet_01v8 l=0.15 w=1.12 ad=0.336 as=0.308 pd=2.84 ps=2.79
XM1 a_114_368##9 B1#10 a_1213_368##5 VPB sky130_fd_pr__pfet_01v8 l=0.15 w=1.12 ad=0.336 as=0.308 pd=2.84 ps=2.79
XM16 a_1213_368##8 B1#9 a_114_368##9 VPB sky130_fd_pr__pfet_01v8 l=0.15 w=1.12 ad=0.336 as=0.336 pd=2.84 ps=2.84
XM19 a_1213_368##8 B1#8 a_114_368# VPB sky130_fd_pr__pfet_01v8 l=0.15 w=1.12 ad=0.336 as=0.336 pd=2.84 ps=2.84
XM3 a_114_368# B1#1 a_1213_368##7 VPB sky130_fd_pr__pfet_01v8 l=0.15 w=1.12 ad=0.336 as=0.336 pd=2.84 ps=2.84
XM5 Y#10 C1#9 a_1213_368##7 VPB sky130_fd_pr__pfet_01v8 l=0.15 w=1.12 ad=0.336 as=0.336 pd=2.84 ps=2.84
XM23 a_1213_368##6 C1#8 Y#10 VPB sky130_fd_pr__pfet_01v8 l=0.15 w=1.12 ad=0.336 as=0.336 pd=2.84 ps=2.84
XM26 a_1213_368##6 C1#6 Y#13 VPB sky130_fd_pr__pfet_01v8 l=0.15 w=1.12 ad=0.336 as=0.336 pd=2.84 ps=2.84
XM28 Y#13 C1#1 a_1213_368# VPB sky130_fd_pr__pfet_01v8 l=0.15 w=1.12 ad=0.336 as=0.3304 pd=2.84 ps=2.83
*
*
*       RESISTOR AND CAP/DIODE CARDS
*
Rg1	A3#1	A3#2	450.639984
Rg2	A3#2	A3#3	65.056755
Rg3	A3#3	A3#4	31.701754
Rg4	A3#4	A3#5	45.616405
Rg5	A3#5	A3#6	66.386436
Rg6	A3#6	A3#7	451.667847
Rg7	A3#2	A3#8	399.275177
Rg8	A3#3	A3#9	415.274414
Rg9	A3#3	A3#10	429.620972
Rg10	A3#5	A3#11	394.561310
Rg11	A3#5	A3#12	446.660797
Rg12	A3#6	A3#13	402.159912
Rg13	A2#1	A2#2	442.880768
Rg14	A2#2	A2#3	50.285873
Rg15	A2#3	A2#4	26.115089
Rg16	A2#4	A2#5	36.077396
Rg17	A2#2	A2#6	396.201660
Rg18	A2#3	A2#7	419.000305
Rg19	A2#4	A2#8	426.181030
Rg20	A2#5	A2#9	416.171906
Rg21	A2#5	A2#10	105.771553
Rg22	A2#10	A2#11	397.590515
Rg23	A2#5	A2#12	429.126801
Rg24	A2#10	A2#13	449.490784
Rg25	A1#1	A1#2	447.434174
Rg26	A1#2	A1#3	38.057892
Rg27	A1#2	A1#4	381.948395
Rg28	A1#3	A1#5	37.712410
Rg29	A1#5	A1#6	374.096069
Rg30	A1#3	A1#7	429.126801
Rg31	A1#5	A1#8	25.349945
Rg32	A1#8	A1#9	49.173149
Rg33	A1#9	A1#10	367.485718
Rg34	A1#8	A1#11	389.159912
Rg35	A1#9	A1#12	43.847313
Rg36	A1#12	A1#13	617.296082
Rg37	A1#12	A1#14	405.599640
Rg38	B1#1	B1#2	527.627747
Rg39	B1#2	B1#3	73.670235
Rg40	B1#2	B1#4	454.673767
Rg41	B1#3	B1#5	77.878807
Rg42	B1#5	B1#6	67.149261
Rg43	B1#6	B1#7	380.339874
Rg44	B1#3	B1#8	442.451355
Rg45	B1#5	B1#9	432.879364
Rg46	B1#6	B1#10	462.979767
Rg47	C1#1	C1#2	619.994385
Rg48	C1#2	C1#3	98.482162
Rg49	C1#3	C1#4	46.757187
Rg50	C1#4	C1#5	318.032684
Rg51	C1#2	C1#6	475.559692
Rg52	C1#3	C1#7	300.884033
Rg53	C1#3	C1#8	485.005890
Rg54	C1#4	C1#9	507.914795
Rf3	A2	A2#14	7.334466
Rf4	A2#14	A2	7.334466
Rf5	a_34_74#	a_34_74##2	26.329330
Rf6	a_34_74##2	a_34_74##3	65.529625
Rf7	a_34_74##3	a_34_74##4	83.170883
Rf8	a_34_74##2	a_34_74##6	48.395382
Rf9	a_34_74##3	a_34_74##7	21.341251
Rf10	a_34_74##6	a_34_74##8	58.170017
Rf11	a_34_74##5	a_34_74##6	15.000000
Rf12	a_465_74#	a_465_74##3	57.053680
Rf13	a_465_74##3	a_465_74##5	80.739769
Rf14	a_465_74##5	a_465_74##6	56.758797
Rf15	a_465_74##2	a_465_74##3	15.000000
Rf16	a_465_74##4	a_465_74##5	15.000000
Rf17	A1#3	A1#16	40.742592
Rf18	A1#17	A1	0.684391
Rf19	A1#16	A1#17	5.042445
Rf20	A1#18	A1	0.684391
Rf21	A1#17	A1#18	14.668931
Rf22	a_114_368#	a_114_368##2	53.430687
Rf23	a_114_368##2	a_114_368##3	101.275467
Rf24	a_114_368##3	a_114_368##4	64.001343
Rf25	a_114_368##4	a_114_368##5	66.988586
Rf26	a_114_368##5	a_114_368##6	65.941528
Rf27	a_114_368##6	a_114_368##7	65.941528
Rf28	a_114_368##7	a_114_368##8	90.417343
Rf29	a_114_368##2	a_114_368##9	17.314264
Rf30	a_114_368##3	a_114_368##10	22.678455
Rf31	a_114_368##4	a_114_368##11	27.563665
Rf32	a_114_368##5	a_114_368##12	31.284834
Rf33	a_114_368##6	a_114_368##13	31.284834
Rf34	a_114_368##7	a_114_368##14	31.284834
Rf35	B1	B1#11	8.976061
Rf36	B1#11	B1	4.488030
Rf37	C1	C1#10	10.942473
Rf38	C1#10	C1	6.000711
Rf39	a_1213_368#	a_1213_368##2	86.965652
Rf40	a_1213_368##2	a_1213_368##3	65.696381
Rf41	a_1213_368##3	a_1213_368##4	65.696381
Rf42	a_1213_368##4	a_1213_368##5	81.639030
Rf43	a_1213_368##2	a_1213_368##6	22.677097
Rf44	a_1213_368##3	a_1213_368##7	24.901169
Rf45	a_1213_368##4	a_1213_368##8	19.134041
Rf46	Y	Y#2	2.852180
Rf47	Y#2	Y#3	4.314579
Rf48	Y#3	Y#4	65.657898
Rf49	Y#4	Y#5	118.270386
Rf50	Y#5	Y#7	42.061581
Rf51	Y#7	Y#8	52.945065
Rf52	Y#3	Y#9	69.053619
Rf53	Y#9	Y#10	97.871361
Rf54	Y#4	Y#11	14.690100
Rf55	Y#5	Y#12	13.683641
Rf56	Y#9	Y#13	42.114403
Rf57	Y#1	Y#2	7.500000
Rf58	Y#6	Y#7	15.000000
Rf60	VGND#2	VGND#3	99.228203
Rf61	VGND#3	VGND#4	271.554321
Rf62	VGND#4	VGND#5	128.179077
Rf63	VGND#5	VGND#6	65.753731
Rf65	VGND#2	VGND#8	36.824379
Rf66	VGND#3	VGND#9	11.016129
Rf67	VGND#5	VGND#10	38.247387
Rf68	VGND#6	VGND#11	45.213318
Rf69	VPWR#1	VPWR#2	199.403320
Rf70	VPWR#2	VPWR#3	68.675751
Rf71	VPWR#3	VPWR#4	62.831711
Rf72	VPWR#4	VPWR#5	37.231220
Rf73	VPWR#5	VPWR#6	28.465160
Rf74	VPWR#6	VPWR#7	65.696381
Rf75	VPWR#7	VPWR#8	65.696381
Rf76	VPWR#8	VPWR#9	116.844124
Rf77	VPWR#2	VPWR#10	31.534731
Rf78	VPWR#3	VPWR#11	38.736572
Rf79	VPWR#4	VPWR#12	31.534731
Rf80	VPWR#6	VPWR#13	31.534731
Rf81	VPWR#7	VPWR#14	31.534731
Rf82	VPWR#8	VPWR#15	31.534731
Rf86	B1#3	B1#11	53.410934
Rf87	C1#3	C1#10	53.410934
Rf83	A3#4	A3	40.058201
Rf84	A2#5	A2#14	40.058201
Re1	VPWR#1	VPWR	2.687498
Re2	VPWR	VPWR#5	1.343749
Re3	VGND#2	VGND	2.687498
Re4	VGND	VGND#4	1.343749
*
*       CAPACITOR CARDS
*
*
C1	a_114_368##4	A1#13	1.81059e-17
C2	a_34_74#	a_465_74##6	3.0464e-17
C3	VGND#5	a_465_74##6	1.36616e-17
C4	VGND#3	B1#4	1.27946e-17
C5	a_114_368##7	VPWR#14	1.77481e-17
C6	a_114_368##3	A1#13	1.17829e-19
C7	Y#8	Y#5	1.59391e-18
C8	a_114_368##6	A2#1	9.78956e-20
C9	a_114_368##5	A2#1	1.69713e-17
C10	A1#16	A1#14	1.59791e-18
C11	a_114_368##6	VPWR#14	1.66328e-17
C12	a_114_368##7	A3#2	1.40714e-18
C13	VPWR#2	A1#1	1.67859e-19
C14	a_114_368##4	A2#1	4.87898e-19
C15	VPWR#8	A3#12	1.83922e-18
C16	a_114_368##4	a_114_368##13	4.6216e-21
C17	a_114_368##4	VPWR#4	3.13618e-19
C18	Y#4	C1#7	1.40476e-18
C19	VGND#5	a_34_74#	1.36753e-17
C20	VGND#3	B1#7	1.44041e-17
C21	a_114_368##7	a_114_368##14	4.40094e-18
C22	a_114_368##6	A2#7	2.26949e-19
C23	A1#17	A1#12	1.46472e-17
C24	VGND#10	a_34_74#	4.15829e-17
C25	a_1213_368#	C1#1	6.47012e-17
C26	C1#5	C1#7	3.77286e-17
C27	A1#12	a_114_368##10	8.52924e-19
C28	Y#3	C1#7	1.78659e-17
C29	Y#5	C1#5	3.44937e-19
C30	a_114_368##5	A2#7	1.42153e-17
C31	VGND#5	A2#10	6.01444e-20
C32	A2#5	A1#12	2.65463e-18
C33	A1#16	A1#13	4.27725e-19
C34	C1#1	Y#13	2.29614e-17
C35	a_114_368##4	A2#7	5.83477e-19
C36	a_114_368##4	VPWR#3	3.13618e-19
C37	a_114_368##7	A2#12	9.78956e-20
C38	Y#4	C1#5	2.32624e-17
C39	VPWR#8	A3#7	3.01968e-18
C40	Y#9	B1#2	2.29512e-19
C41	a_1213_368#	C1#6	2.92482e-18
C42	a_114_368##7	VPWR#15	2.78012e-17
C43	a_34_74##7	a_34_74#	1.31442e-18
C44	a_1213_368##6	C1#1	2.79269e-18
C45	Y#9	a_1213_368##2	2.58925e-18
C46	a_114_368##6	A2#12	1.43752e-17
C47	VGND#3	A1#1	6.24291e-18
C48	A2#10	A2#5	4.0818e-18
C49	B1#4	C1#5	3.83979e-17
C50	C1#6	Y#13	2.79045e-17
C51	a_114_368##5	A2#12	2.26949e-19
C52	Y#3	C1#5	3.83231e-19
C53	A1#16	A2#1	1.73715e-19
C54	Y#10	C1#1	2.64799e-19
C55	Y#5	B1#4	1.28553e-18
C56	a_114_368##4	A2#12	3.22978e-19
C57	a_1213_368##6	C1#6	5.13331e-17
C58	a_34_74##7	VGND#10	4.23256e-17
C59	a_114_368##7	A2#13	2.26949e-19
C60	a_114_368##3	VPWR#3	3.13618e-19
C61	Y#4	B1#4	4.42931e-17
C62	a_114_368##8	a_114_368##7	1.27996e-18
C63	Y#13	C1#8	6.13879e-19
C64	Y#4	C1#4	8.47065e-19
C65	Y#10	C1#6	6.13879e-19
C66	a_114_368##6	A2#13	1.42437e-17
C67	A1#12	VPWR#11	1.19074e-18
C68	VGND#5	a_34_74##7	7.1753e-18
C69	A1#14	A1#12	2.31942e-19
C70	VGND#3	A1#4	6.01973e-18
C71	B1#7	B1#4	2.46806e-18
C72	a_114_368##5	A2#13	9.78956e-20
C73	Y#5	B1#6	1.74588e-18
C74	a_1213_368##6	C1#8	4.47908e-17
C75	Y#3	B1#4	3.9455e-19
C76	VGND#11	VGND#10	3.37372e-19
C77	Y#5	B1#7	5.21599e-17
C78	a_114_368##4	A2#13	8.36861e-20
C79	VPWR#8	VPWR#7	1.22166e-18
C80	Y#13	C1#9	2.64799e-19
C81	Y#10	C1#8	6.08602e-17
C82	a_114_368##7	A3#1	1.81104e-17
C83	a_114_368##3	VPWR#2	4.05945e-19
C84	Y#4	B1#7	3.15261e-19
C85	a_114_368##6	A3#1	2.26949e-19
C86	a_1213_368##6	C1#9	2.09336e-18
C87	a_1213_368##7	C1#8	2.33594e-18
C88	VGND#11	a_34_74##7	3.99628e-17
C89	A1#1	B1#7	3.91413e-17
C90	VGND#3	A1#6	5.65087e-18
C91	Y#5	B1#5	5.82649e-18
C92	C1#9	Y#10	2.19933e-17
C93	Y#5	A1#1	3.0292e-17
C94	a_1213_368##7	C1#9	5.87222e-17
C95	A1#16	A1#12	4.0275e-17
C96	a_114_368##7	A3#10	1.42437e-17
C97	a_34_74##4	a_34_74##7	2.03461e-18
C98	A1#13	A1#12	1.07497e-18
C99	a_114_368##2	VPWR#2	8.38635e-19
C100	a_114_368##6	A3#10	9.78956e-20
C101	Y#10	B1#1	9.28e-19
C102	A1#4	A1#1	4.06599e-17
C103	VGND#3	A1#10	3.18864e-19
C104	a_1213_368##7	B1#1	5.06199e-17
C105	Y#5	A1#4	1.36901e-18
C106	a_34_74##4	VGND#11	4.34066e-17
C107	Y#10	B1#8	5.64493e-19
C108	a_114_368##7	A3#12	2.26949e-19
C109	a_465_74##2	A1#13	5.01114e-19
C110	B1#1	a_114_368#	2.153e-17
C111	Y#3	C1#2	2.32443e-17
C112	VPWR#7	VPWR#6	1.22166e-18
C113	VGND#5	A2#6	1.61007e-19
C114	a_1213_368##7	B1#8	2.18158e-18
C115	a_1213_368##8	B1#1	1.58892e-18
C116	A1#6	A1#4	4.10253e-17
C117	Y#10	B1#9	3.4687e-19
C118	a_114_368#	B1#8	4.73916e-17
C119	a_114_368##9	B1#1	2.94839e-19
C120	VPWR#1	Y#9	1.82797e-18
C121	Y#5	A1#12	1.66581e-18
C122	a_465_74##4	A1#13	2.45088e-18
C123	Y#5	A1#6	5.28413e-19
C124	a_114_368##7	A3#7	1.55631e-19
C125	a_1213_368##8	B1#8	4.35348e-17
C126	VGND#5	A3#5	5.62208e-20
C127	a_114_368#	B1#9	7.07274e-19
C128	Y#10	B1#10	3.02115e-19
C129	a_114_368##9	B1#8	1.18766e-18
C130	VPWR#10	B1#1	3.97099e-20
C131	A1#10	A1#6	4.09884e-17
C132	VGND#5	A2#8	2.02922e-19
C133	Y#4	B1#2	1.65799e-18
C134	a_1213_368##8	B1#9	3.85506e-17
C135	a_34_74##3	a_34_74##2	1.25873e-18
C136	a_1213_368##4	VPWR#1	8.61546e-17
C137	Y#5	A1#10	5.62111e-19
C138	a_114_368#	B1#10	2.94839e-19
C139	B1#9	a_114_368##9	2.50612e-17
C140	VPWR#10	B1#8	6.99797e-20
C141	a_1213_368##3	VPWR#1	8.75138e-17
C142	a_1213_368##8	B1#10	2.00716e-18
C143	a_1213_368##5	B1#9	1.58892e-18
C144	A2#6	A1#10	2.31134e-18
C145	a_1213_368##2	VPWR#1	8.75138e-17
C146	VPWR#6	VPWR#4	1.22166e-18
C147	VGND#5	A2#9	5.10498e-19
C148	B1#10	a_114_368##9	2.87703e-17
C149	a_1213_368#	Y#13	7.07012e-17
C150	VPWR#10	B1#9	4.22821e-19
C151	a_465_74##2	a_114_368##4	3.62289e-18
C152	a_34_74##5	A2#10	1.3752e-18
C153	a_1213_368##5	B1#10	7.49374e-17
C154	a_114_368##10	B1#9	4.20024e-20
C155	A2#8	A2#6	4.11547e-17
C156	a_114_368##9	A1#7	5.75804e-19
C157	VPWR#10	B1#10	3.45858e-18
C158	a_1213_368##6	a_1213_368#	5.01824e-18
C159	Y#9	a_1213_368#	1.24769e-17
C160	a_1213_368##5	A1#7	1.36005e-18
C161	a_114_368##10	B1#10	1.38863e-19
C162	VGND#5	A2#11	5.94659e-18
C163	Y#8	a_114_368##4	9.74674e-18
C164	a_34_74##8	a_114_368##5	3.5596e-18
C165	VPWR#10	A1#7	6.27213e-17
C166	a_114_368##9	A1#11	1.37817e-19
C167	VPWR#1	a_114_368##2	1.92301e-18
C168	a_1213_368##6	Y#13	5.09848e-17
C169	B1#2	C1#4	2.95397e-17
C170	A2#9	A2#8	3.99474e-17
C171	Y#6	A1#18	2.17764e-18
C172	A1#7	a_114_368##10	1.79581e-17
C173	VPWR#10	A1#11	2.44702e-18
C174	VPWR#11	A1#7	6.1097e-19
C175	Y#9	Y#13	1.95985e-19
C176	a_465_74##6	A2#10	5.09292e-19
C177	a_34_74##8	a_114_368##4	3.09571e-18
C178	Y#10	Y#13	3.35109e-18
C179	VPWR#4	VPWR#3	1.20296e-18
C180	VGND#5	A3#8	5.24014e-18
C181	a_114_368##10	A1#11	4.36452e-17
C182	Y#6	A1#17	2.19866e-17
C183	A2#11	A2#9	3.91241e-17
C184	Y#9	C1#3	4.08684e-19
C185	a_114_368##3	A1#1	1.1453e-19
C186	A1#11	VPWR#11	2.20708e-17
C187	VPWR#10	A1#14	3.06214e-19
C188	a_114_368##5	VPWR#5	2.98917e-19
C189	Y#10	a_1213_368##6	6.36437e-17
C190	a_114_368##11	A1#11	2.59603e-19
C191	a_114_368##10	A1#14	1.57693e-18
C192	a_114_368##2	A1#1	2.92285e-18
C193	a_465_74##4	a_114_368##4	2.58116e-18
C194	VGND#3	B1#3	2.15421e-18
C195	Y#9	a_1213_368##6	1.56281e-17
C196	Y#3	C1#3	1.57283e-17
C197	VPWR#11	A1#14	4.28625e-17
C198	a_1213_368##4	B1#5	8.21941e-20
C199	B1#6	B1#5	1.94338e-18
C200	A3#8	A2#11	4.14161e-17
C201	VGND#5	A3#9	5.35279e-18
C202	A1#14	a_114_368##11	1.98784e-17
C203	A1#18	A1#1	9.68163e-18
C204	a_114_368##10	A1#13	7.85528e-20
C205	a_1213_368##7	a_1213_368##6	5.01824e-18
C206	a_1213_368##3	C1#3	8.01357e-20
C207	VPWR#12	A1#14	2.12694e-18
C208	VPWR#11	A1#13	1.65292e-18
C209	a_1213_368##2	C1#3	7.05957e-20
C210	Y#5	B1#3	2.05797e-19
C211	Y#6	A1#16	3.28747e-17
C212	Y#4	B1#3	3.28989e-17
C213	a_114_368##12	A1#14	6.41938e-20
C214	A1#13	a_114_368##11	2.52147e-17
C215	A3#9	A3#8	3.96701e-17
C216	a_1213_368##7	Y#10	6.87218e-17
C217	Y#5	a_114_368##2	1.55677e-17
C218	VPWR#6	A2#5	1.98672e-20
C219	VPWR#12	A1#13	5.22195e-17
C220	VGND#5	A3#11	1.08306e-18
C221	VPWR#3	VPWR#2	9.86498e-19
C222	a_1213_368##4	B1#3	8.33049e-20
C223	a_114_368##12	A1#13	1.48819e-19
C224	a_114_368##11	A2#1	2.66014e-19
C225	a_1213_368##2	C1#2	6.85799e-20
C226	A3#11	A3#9	4.00374e-17
C227	VPWR#12	A2#1	4.55295e-17
C228	B1#6	B1#2	1.67306e-19
C229	VGND#5	A2#5	6.80091e-22
C230	A2#1	a_114_368##12	2.10613e-17
C231	Y#5	A1#18	2.11123e-17
C232	a_114_368##11	A2#7	1.14746e-19
C233	C1#7	Y#1	1.67372e-18
C234	VGND#5	A3#13	4.78194e-19
C235	a_114_368#	a_1213_368##7	8.04284e-17
C236	VPWR#13	A2#1	2.13205e-18
C237	VPWR#12	A2#7	2.13205e-18
C238	A3#13	A3#11	3.6907e-17
C239	a_1213_368##5	VPWR#2	2.60985e-17
C240	Y#8	A1#16	2.7937e-17
C241	a_114_368##13	A2#1	6.41938e-20
C242	A2#7	a_114_368##12	2.57546e-17
C243	VGND#8	C1#7	2.80715e-17
C244	a_1213_368##3	B1#2	7.46734e-20
C245	VPWR#13	A2#7	5.15917e-17
C246	a_1213_368#	C1#2	6.76655e-20
C247	a_1213_368##8	a_1213_368##7	5.01824e-18
C248	B1#3	a_114_368##2	2.32948e-18
C249	VPWR#3	VPWR#10	2.85251e-19
C250	A1#18	B1#3	9.55812e-20
C251	a_114_368##13	A2#7	1.48819e-19
C252	a_114_368##12	A2#12	1.48819e-19
C253	A2#10	a_114_368##13	2.74109e-19
C254	VPWR#13	A2#12	4.55295e-17
C255	VGND#8	C1#5	2.86163e-17
C256	a_114_368#	a_1213_368##8	5.32251e-17
C257	A1#12	B1#6	2.82714e-20
C258	A2#12	a_114_368##13	2.10613e-17
C259	a_114_368##12	A2#13	6.41938e-20
C260	VPWR#14	A2#12	2.13205e-18
C261	Y#4	a_1213_368##7	1.10558e-17
C262	VPWR#13	A2#13	2.13205e-18
C263	C1#2	Y#1	2.17838e-19
C264	C1#5	Y#11	4.8978e-18
C265	C1#3	Y#1	1.03333e-18
C266	A2	A1#12	2.80924e-18
C267	a_114_368##10	VPWR#3	6.51082e-18
C268	VGND#5	a_34_74##3	2.91756e-19
C269	a_114_368##14	A2#12	6.41938e-20
C270	a_114_368##6	A2#5	2.07939e-18
C271	C1#3	VGND#8	7.8596e-19
C272	a_114_368##9	a_114_368#	3.81225e-18
C273	A2#13	a_114_368##13	2.57546e-17
C274	a_1213_368##2	Y#13	9.52891e-18
C275	a_1213_368#	VPWR#1	7.69386e-17
C276	a_114_368##5	A2#5	3.33324e-18
C277	VGND#8	B1#4	2.31867e-18
C278	VGND#4	a_465_74##2	3.88979e-17
C279	A2	A2#10	1.68519e-17
C280	VPWR#14	A2#13	5.15917e-17
C281	VPWR#1	Y#13	7.39233e-18
C282	A3#5	A3#1	1.85554e-19
C283	a_114_368##2	a_1213_368##4	3.07235e-18
C284	a_114_368##10	VPWR#2	7.18333e-18
C285	a_114_368##14	A2#13	1.48819e-19
C286	a_114_368##13	A3#1	1.48819e-19
C287	C1#6	C1#1	4.9536e-17
C288	a_114_368##9	a_1213_368##8	3.80974e-17
C289	B1#4	Y#11	1.49752e-17
C290	A3#2	A2#10	2.92079e-17
C291	VPWR#1	Y#10	8.05682e-18
C292	C1#4	VGND#8	7.36895e-19
C293	VGND#4	a_465_74##4	5.47337e-17
C294	A2	A3#2	6.98217e-18
C295	VPWR#14	A3#1	4.55295e-17
C296	VGND#8	B1#7	1.64255e-19
C297	VGND#5	a_34_74##2	1.07846e-18
C298	a_1213_368##2	a_1213_368##6	4.35239e-20
C299	A3#1	a_114_368##14	2.10613e-17
C300	VGND#4	a_465_74##6	1.59087e-17
C301	B1#4	VGND#9	1.8834e-17
C302	a_114_368##13	A3#10	6.41938e-20
C303	B1#3	VGND#9	8.46812e-19
C304	VPWR#1	a_114_368#	9.28949e-18
C305	A1#16	A2#5	3.11202e-18
C306	a_1213_368##5	a_1213_368##8	5.01824e-18
C307	VPWR#9	A2#13	2.03746e-19
C308	a_114_368##7	a_114_368##6	1.23889e-18
C309	VPWR#15	A3#1	2.13205e-18
C310	C1#8	C1#6	4.80196e-17
C311	VPWR#14	A3#10	2.13205e-18
C312	a_1213_368##3	Y#10	9.54462e-18
C313	VPWR#1	a_114_368##9	3.23766e-18
C314	a_114_368##8	A3#1	1.8144e-19
C315	a_114_368##11	VPWR#4	5.25841e-18
C316	A3#10	a_114_368##14	2.57546e-17
C317	VGND#10	A3#5	4.33553e-19
C318	Y#9	C1#1	9.30547e-18
C319	a_1213_368##5	VPWR#1	1.95383e-17
C320	C1#2	C1#1	8.08309e-18
C321	VPWR#9	A3#1	5.31123e-19
C322	VPWR#15	A3#10	5.15917e-17
C323	a_1213_368##5	a_114_368##9	5.03479e-17
C324	B1#7	VGND#9	2.16383e-17
C325	A3	A2#10	6.3964e-18
C326	C1#9	C1#8	4.86835e-17
C327	a_1213_368##2	Y#10	1.17824e-17
C328	a_114_368##8	A3#10	4.05626e-19
C329	a_114_368##11	VPWR#3	5.19734e-18
C330	a_114_368##14	A3#12	1.48819e-19
C331	a_34_74##2	A2#10	5.90462e-19
C332	a_1213_368##6	C1#2	3.4855e-19
C333	A3	A3#6	1.80939e-17
C334	VPWR#9	A3#10	8.71061e-19
C335	A3	A3#5	3.81751e-17
C336	VPWR#15	A3#12	4.60106e-17
C337	a_1213_368##3	a_1213_368##7	4.35239e-20
C338	B1#7	Y#12	1.49604e-17
C339	A3	A3#2	1.4107e-17
C340	VPWR#10	a_114_368##9	1.29141e-18
C341	a_114_368##8	A3#12	3.19383e-17
C342	a_114_368##14	A3#7	1.02053e-19
C343	B1#1	C1#9	4.70537e-17
C344	a_1213_368##4	a_114_368#	1.5336e-17
C345	Y#9	C1#6	1.78273e-17
C346	VPWR#9	A3#12	2.08837e-18
C347	VPWR#15	A3#7	2.90342e-18
C348	a_465_74#	B1#7	1.00269e-18
C349	C1	C1#4	1.90026e-17
C350	VGND#10	A3#2	3.56005e-19
C351	C1	C1#2	1.11567e-17
C352	a_114_368##8	A3#7	5.19054e-17
C353	VPWR#10	a_1213_368##5	6.51093e-17
C354	C1	B1#6	7.86965e-20
C355	a_114_368##10	a_114_368##9	4.74736e-19
C356	a_114_368##6	a_114_368##5	1.23889e-18
C357	a_1213_368##6	C1#3	3.63487e-19
C358	A1#1	Y#12	5.2455e-18
C359	VPWR#12	VPWR#3	6.61283e-20
C360	C1	B1#2	6.63155e-18
C361	VPWR#9	A3#7	3.61524e-17
C362	C1#3	Y#10	1.64963e-17
C363	B1#8	B1#1	4.71758e-17
C364	a_1213_368##3	a_114_368#	1.2171e-17
C365	a_34_74##8	A2#5	4.87593e-18
C366	a_465_74#	A1#1	2.96809e-17
C367	a_1213_368##4	a_1213_368##8	4.35239e-20
C368	a_465_74##4	A2#5	1.22446e-18
C369	A3#12	A3#5	2.31942e-19
C370	a_34_74##5	A2#5	4.18769e-18
C371	a_34_74##3	A3#6	8.39338e-19
C372	A3#6	A3#5	4.03955e-18
C373	Y#10	B1#3	6.54572e-19
C374	B1#9	B1#8	4.647e-17
C375	a_465_74##6	A2#5	3.23979e-19
C376	a_114_368##12	VPWR#5	1.05092e-17
C377	VGND#11	A3#6	2.64599e-19
C378	Y#8	B1#7	1.46824e-19
C379	a_114_368##10	VPWR#10	5.15009e-17
C380	B1#3	a_114_368#	2.89501e-17
C381	a_465_74#	A1#4	3.70137e-17
C382	B1#3	a_1213_368##8	1.81114e-18
C383	Y#10	B1#6	3.46637e-19
C384	B1#10	B1#9	4.7286e-17
C385	a_34_74##2	a_34_74##5	1.83562e-19
C386	a_1213_368##4	a_114_368##9	1.31e-17
C387	B1	C1#4	6.47117e-18
C388	a_34_74##3	A3#5	6.5287e-18
C389	B1	C1#2	3.19695e-19
C390	B1	B1#6	1.08032e-18
C391	a_114_368##13	VPWR#7	5.25459e-18
C392	Y#6	A1#4	3.62291e-17
C393	VGND#11	A3#5	5.00869e-19
C394	B1	B1#5	2.01501e-17
C395	VPWR#11	VPWR#10	2.35578e-18
C396	a_34_74##2	A2#9	2.63564e-20
C397	B1	B1#2	1.77611e-17
C398	B1	A1#12	4.50701e-19
C399	a_114_368##5	a_114_368##4	5.78825e-19
C400	Y#8	A1#1	2.15296e-19
C401	A3#5	a_114_368##14	2.37561e-19
C402	a_465_74#	A1#6	9.23622e-19
C403	A1#7	B1#10	5.42709e-18
C404	Y#10	B1#5	3.97988e-19
C405	a_34_74##3	A2#11	1.04946e-19
C406	a_114_368##13	VPWR#6	5.20514e-18
C407	VPWR#11	a_114_368##10	5.06135e-17
C408	a_34_74##2	a_465_74##6	6.95413e-18
C409	a_1213_368##2	C1#6	2.20802e-17
C410	Y#6	A1#6	3.77554e-17
C411	a_34_74##2	A2#11	1.77927e-17
C412	Y#8	A1#4	3.59268e-19
C413	A1#11	A1#7	4.77665e-17
C414	a_34_74##4	VPWR#9	1.62781e-17
C415	VPWR#1	C1#2	7.34072e-20
C416	Y#10	B1#2	1.08596e-18
C417	a_465_74#	A1#10	6.25963e-19
C418	VPWR#1	B1#6	1.13771e-20
C419	a_114_368##11	a_114_368##10	9.60252e-19
C420	a_465_74##2	A1#6	3.50109e-17
C421	A3#2	a_114_368##14	3.07002e-19
C422	VGND#3	VGND#8	2.2605e-18
C423	a_34_74##3	A3#8	2.40143e-19
C424	a_34_74##8	A1#4	3.45675e-19
C425	VPWR#1	B1#5	1.76432e-20
C426	a_34_74##2	a_34_74#	1.83797e-18
C427	a_34_74##2	A3#5	6.10427e-20
C428	A1#14	A1#11	4.79202e-17
C429	VPWR#4	A1#12	2.05551e-20
C430	VPWR#1	B1#2	1.06815e-20
C431	a_34_74##3	VGND#10	1.35449e-17
C432	Y	C1#2	3.51341e-18
C433	Y#8	A1#6	8.49551e-19
C434	a_114_368##14	VPWR#8	5.25459e-18
C435	a_1213_368##2	C1#8	2.21087e-17
C436	a_465_74#	Y#6	3.65068e-17
C437	a_34_74##2	A3#8	1.82845e-17
C438	B1#5	VGND#9	4.76839e-19
C439	a_114_368##11	VPWR#11	5.11921e-17
C440	A3#5	VPWR#15	1.24432e-18
C441	a_465_74##4	A1#4	1.81176e-19
C442	a_465_74#	A2#6	3.43739e-19
C443	A3	VPWR#8	3.51086e-19
C444	A2#5	a_114_368##12	5.48219e-19
C445	a_465_74##2	A1#10	3.82173e-17
C446	a_114_368##4	a_114_368##3	6.8418e-19
C447	A2#5	VPWR#13	1.25828e-18
C448	A1#13	A1#14	4.63366e-17
C449	a_34_74##8	A1#6	5.21222e-19
C450	a_34_74##3	A3#9	1.7736e-17
C451	a_114_368##14	VPWR#7	5.20514e-18
C452	VPWR#2	B1#10	1.33651e-18
C453	A2#5	a_114_368##13	2.70455e-19
C454	a_34_74##2	VGND#10	1.47052e-17
C455	a_1213_368##3	C1#9	2.59475e-17
C456	VGND#4	A1#10	5.35671e-18
C457	VPWR#12	VPWR#11	2.66815e-18
C458	Y#8	A1#10	5.39353e-17
C459	a_34_74##3	a_34_74##7	4.71846e-19
C460	VGND#4	A2#6	5.31202e-18
C461	B1#2	VGND#9	2.43197e-20
C462	a_465_74##4	A1#6	1.95543e-19
C463	a_34_74##2	A3#9	2.9125e-19
C464	A2	a_114_368##7	9.56474e-18
C465	A2	a_114_368##6	7.39171e-17
C466	A2#1	A1#13	4.63727e-17
C467	VGND#4	A2#8	5.31202e-18
C468	B1#4	C1#4	2.65798e-18
C469	A2	a_114_368##5	6.79397e-17
C470	VGND#4	A2#9	5.31202e-18
C471	a_34_74##8	A1#10	4.11455e-18
C472	A3#6	a_114_368##8	1.46925e-18
C473	VPWR#12	a_114_368##11	5.20507e-17
C474	VPWR#1	C1#1	6.66914e-18
C475	VPWR#3	A1#7	4.94319e-19
C476	a_34_74##3	A3#11	2.06033e-17
C477	B1#2	C1#9	2.85791e-18
C478	a_34_74##7	a_34_74##2	3.89871e-19
C479	a_34_74##2	A3#2	1.12929e-18
C480	Y#8	A2#6	2.47513e-18
C481	VPWR#1	C1#6	6.10574e-18
C482	A2#7	A2#1	4.86676e-17
C483	VPWR#3	A1#12	5.26418e-20
C484	Y#6	a_465_74##2	2.01974e-17
C485	a_34_74##3	VGND#11	2.09785e-17
C486	A2	A1#16	1.22187e-17
C487	a_1213_368##3	B1#1	2.60885e-17
C488	a_465_74##4	A1#10	4.74596e-19
C489	VPWR#2	A1#7	1.83922e-18
C490	VGND#3	VGND#9	2.11337e-17
C491	VPWR#1	C1#8	6.12294e-18
C492	a_34_74##2	A3#11	1.2286e-19
C493	A3#5	a_114_368##8	1.44966e-18
C494	a_114_368##12	a_114_368##11	8.12386e-19
C495	A3	a_114_368##7	7.63059e-17
C496	VPWR#1	C1#9	6.12294e-18
C497	a_34_74##8	A2#6	4.8603e-17
C498	a_34_74##2	A2	4.02361e-17
C499	VPWR#7	A2#10	2.04712e-20
C500	A2#12	A2#7	4.74961e-17
C501	VPWR#1	B1#1	6.10783e-18
C502	C1	Y#9	3.42141e-17
C503	a_34_74##3	A3#13	2.35263e-19
C504	A3#5	A3#2	4.12819e-18
C505	a_114_368##8	VPWR#8	1.40113e-17
C506	a_1213_368##4	B1#8	1.95519e-17
C507	VPWR#1	B1#8	6.09692e-18
C508	Y#4	C1	2.51632e-17
C509	a_465_74##4	A2#6	3.9522e-17
C510	Y#3	C1	6.91365e-17
C511	a_114_368##12	VPWR#12	5.05943e-17
C512	VPWR#3	A1#11	5.20095e-18
C513	a_34_74##4	a_34_74##3	6.16945e-19
C514	VPWR#1	B1#9	6.01743e-18
C515	C1	a_1213_368##3	2.94448e-18
C516	A2#13	A2#12	4.77579e-17
C517	a_34_74##8	A2#8	1.18151e-18
C518	VPWR#1	B1#10	3.10368e-18
C519	a_114_368#	B1#2	1.38848e-18
C520	a_34_74##3	A3	8.38123e-17
C521	a_34_74##5	A2#6	1.87605e-18
C522	a_34_74##2	A3	2.88194e-17
C523	VPWR#13	VPWR#12	2.06267e-18
C524	a_34_74##8	A2	4.0397e-17
C525	A3#1	A2#13	4.65411e-17
C526	A1#18	a_114_368##3	1.33478e-17
C527	a_465_74##4	A2#8	3.50866e-17
C528	a_465_74##2	Y#8	5.83151e-17
C529	a_34_74##5	A2	7.60229e-17
C530	B1	Y#9	2.18792e-18
C531	a_465_74##6	A2#6	1.84053e-19
C532	Y#5	B1	3.30771e-17
C533	a_1213_368##4	B1#9	1.95784e-17
C534	VPWR#2	A1#12	3.31305e-20
C535	Y#4	B1	3.20774e-17
C536	VPWR#9	VPWR#8	9.86498e-19
C537	VGND#3	Y#5	9.52882e-17
C538	a_114_368##2	a_1213_368##8	1.5974e-17
C539	VPWR#13	a_114_368##12	5.05407e-17
C540	A3#10	A3#1	4.86676e-17
C541	VPWR#3	A1#14	4.8722e-18
C542	a_34_74##5	A2#8	3.86298e-17
C543	B1	a_1213_368##3	1.45766e-18
C544	a_34_74#	A2#6	2.6022e-19
C545	a_114_368##3	a_114_368##9	1.10376e-18
C546	VGND#3	a_465_74#	3.13165e-17
C547	a_465_74##4	A2#9	7.97885e-19
C548	a_1213_368##8	B1#5	1.39046e-19
C549	C1	VGND#8	1.58075e-19
C550	a_465_74##6	A2#8	4.27103e-19
C551	A1#18	a_114_368##2	2.46407e-17
C552	A3#12	A3#10	4.75011e-17
C553	A1#17	a_114_368##3	2.62271e-17
C554	B1	a_114_368##2	2.61028e-17
C555	A1#18	C1#9	3.19992e-19
C556	a_114_368##13	a_114_368##12	8.12386e-19
C557	A1#18	B1	1.15615e-17
C558	VGND#10	A2#6	1.36402e-19
C559	Y#3	Y#1	2.32817e-18
C560	VPWR#5	A2#1	5.76417e-20
C561	a_34_74##5	A2#9	3.77691e-17
C562	a_34_74##4	A3	1.38709e-17
C563	a_114_368##2	a_114_368##9	2.96224e-19
C564	VGND#4	A1#13	8.92141e-20
C565	Y#4	Y	3.93215e-18
C566	VPWR#4	A1#13	1.85197e-18
C567	a_34_74#	A2#8	3.54434e-19
C568	Y#4	VGND#8	4.38623e-17
C569	VPWR#5	A2#7	1.75792e-18
C570	A3#7	A3#12	4.67195e-17
C571	VGND#3	Y#4	8.30207e-17
C572	a_465_74##4	A2#11	1.67254e-19
C573	a_34_74##8	Y#8	2.69718e-17
C574	VPWR#3	A1#13	3.95329e-19
C575	a_114_368##13	VPWR#13	5.05943e-17
C576	a_465_74##6	A2#9	3.42156e-17
C577	VPWR	VPWR#8	6.64608e-17
C578	VGND#10	A2#8	1.55626e-19
C579	VPWR	VPWR#7	5.39545e-17
C580	VPWR#8	A3#6	2.04712e-20
C581	VPWR	VPWR#6	4.19676e-17
C582	B1	VGND#9	1.52875e-20
C583	VPWR	VPWR#4	4.61516e-17
C584	a_114_368##4	VPWR#10	5.44446e-20
C585	A1#16	a_114_368##4	1.56514e-17
C586	VPWR	VPWR#3	6.74942e-17
C587	A1#18	B1#1	2.37174e-19
C588	VPWR	VPWR#2	6.93147e-17
C589	a_34_74##5	A2#11	1.22665e-18
C590	a_114_368##4	A1#12	5.68325e-18
C591	a_465_74#	A1#12	1.02618e-18
C592	a_34_74#	A2#9	1.13003e-18
C593	C1#4	VNB	2.16635e-17
C594	VPWR#14	VPWR#13	2.06267e-18
C595	C1#2	VNB	7.3238e-17
C596	Y#3	VGND#8	1.50067e-17
C597	B1#6	VNB	2.68691e-17
C598	a_114_368##2	a_1213_368##5	2.87811e-17
C599	C1	Y#10	3.97386e-17
C600	B1#5	VNB	2.0657e-17
C601	VGND#3	B1#6	3.33918e-19
C602	VGND#4	A1#12	1.77652e-19
C603	B1#2	VNB	2.31783e-17
C604	A1#12	VNB	1.09905e-16
C605	C1	a_1213_368##7	8.26006e-18
C606	a_114_368##7	VPWR#8	3.13618e-19
C607	A2#10	VNB	2.69903e-17
C608	a_465_74##6	A2#11	2.91772e-17
C609	Y#4	Y#11	5.82101e-18
C610	A2#5	A1#13	1.88608e-17
C611	VPWR#4	A2#1	1.75807e-18
C612	VPWR	a_1213_368##4	7.71748e-19
C613	A1#1	B1#6	3.10908e-17
C614	A3#6	VNB	4.09099e-17
C615	A3#5	VNB	5.7294e-17
C616	Y	Y#1	4.15257e-18
C617	a_114_368##3	VPWR#10	3.0194e-17
C618	VGND#10	A2#9	2.90512e-19
C619	A3#2	VNB	2.3138e-17
C620	VGND#8	Y	3.14417e-17
C621	A2#5	A2#1	1.85554e-19
C622	Y#5	VGND#9	3.77277e-18
C623	A1#18	C1#4	5.37802e-21
C624	VPWR	a_114_368##7	3.92785e-18
C625	VPWR	a_114_368##6	3.06825e-18
C626	a_34_74##5	A3#8	4.69472e-19
C627	VPWR#14	a_114_368##13	5.05407e-17
C628	a_114_368##2	B1#6	2.85406e-18
C629	VPWR	a_114_368##5	3.30102e-18
C630	VPWR	a_114_368##4	3.62358e-18
C631	A3	a_114_368##8	3.9983e-17
C632	A2#11	a_34_74#	1.43762e-17
C633	VPWR	a_114_368##3	3.85395e-18
C634	A1#16	a_114_368##3	5.96484e-17
C635	A2#12	A2#5	2.31942e-19
C636	VPWR	a_114_368##2	4.04598e-18
C637	A1#18	B1#8	3.78343e-19
C638	VPWR	A1#18	2.93005e-18
C639	VGND#3	a_465_74##2	1.32852e-17
C640	VPWR	A1#17	1.9833e-18
C641	B1	a_114_368#	3.2845e-17
C642	VPWR#8	A3#5	3.79399e-20
C643	VPWR	A1#16	5.48301e-18
C644	B1	a_1213_368##8	9.72161e-19
C645	a_34_74##8	a_465_74##4	5.66207e-17
C646	C1#4	C1#3	4.79435e-18
C647	a_465_74##6	A3#8	8.9245e-19
C648	a_114_368##3	B1#9	9.76555e-20
C649	VGND	VGND#5	1.02151e-16
C650	VGND	VGND#3	1.0228e-16
C651	VGND#10	A2#11	1.43332e-18
C652	VPWR#1	C1#3	8.13558e-19
C653	a_114_368##7	VPWR#7	3.13618e-19
C654	a_114_368##14	a_114_368##13	8.12386e-19
C655	C1#3	C1#2	4.79213e-18
C656	VPWR#6	A2#7	5.76368e-20
C657	VGND#3	B1#5	1.79803e-18
C658	VGND	Y#5	1.9539e-17
C659	a_114_368##6	A2#10	1.25638e-18
C660	Y	a_1213_368#	6.49621e-18
C661	Y#4	VGND#9	4.68701e-18
C662	a_114_368##3	a_114_368##10	2.09516e-18
C663	a_114_368##2	B1#9	2.0829e-17
C664	VPWR#1	B1#3	1.95232e-18
C665	A3#8	a_34_74#	1.71873e-17
C666	a_34_74##7	A2#11	1.42094e-19
C667	a_114_368##2	B1#5	3.40556e-18
C668	Y#5	Y#12	2.1563e-18
C669	VGND	a_114_368##4	3.75564e-18
C670	a_1213_368##5	B1#6	8.33049e-20
C671	a_114_368##4	B1#10	1.34425e-19
C672	a_114_368##3	A1#12	9.88385e-18
C673	A1#18	B1#9	6.42238e-19
C674	VGND	a_114_368##2	2.17184e-18
C675	a_114_368##4	VPWR#11	1.22125e-17
C676	Y#6	A1#12	5.21145e-18
C677	a_114_368##14	VPWR#14	5.05943e-17
C678	VGND	A1#18	2.27494e-18
C679	VGND	A1#17	1.60148e-18
C680	a_34_74##5	a_34_74##8	4.33427e-18
C681	A1#12	A1#1	3.20043e-18
C682	VGND	A1#16	5.38534e-18
C683	A1#1	a_1213_368##5	1.15181e-18
C684	VGND#10	A3#8	3.25744e-17
C685	VGND	a_34_74##3	3.29243e-18
C686	VPWR#8	VNB	3.34244e-17
C687	a_114_368##3	B1#10	3.22856e-19
C688	VGND	a_34_74##2	3.74502e-18
C689	a_34_74##2	a_114_368##7	4.14311e-18
C690	VPWR#7	VNB	2.69834e-17
C691	VPWR#6	VNB	2.10033e-17
C692	B1	B1#7	2.94633e-18
C693	VPWR#4	VNB	2.23557e-17
C694	a_114_368##5	a_114_368##11	6.39754e-19
C695	VPWR#3	VNB	2.61263e-17
C696	VPWR#5	A2#5	4.06421e-20
C697	B1	A1#1	4.47914e-18
C698	VPWR#2	VNB	3.71694e-17
C699	B1	A1#4	6.20149e-19
C700	VGND#5	VNB	4.2239e-17
C701	Y#3	VGND#9	2.3058e-21
C702	VGND#3	VNB	9.72943e-17
C703	a_34_74#	A3#9	2.32213e-19
C704	B1	A1#6	4.11117e-19
C705	VGND#4	A2#5	2.12759e-19
C706	Y#9	VNB	1.02979e-17
C707	VGND	a_465_74#	1.95384e-17
C708	VPWR	a_114_368##9	4.50837e-18
C709	a_34_74##7	A3#8	3.25149e-19
C710	VPWR#15	VPWR#14	2.06267e-18
C711	VGND	Y#6	7.23619e-18
C712	Y#5	VNB	6.571e-18
C713	a_114_368##3	VPWR#11	1.30707e-17
C714	a_114_368##2	B1#10	2.30623e-17
C715	VPWR	a_1213_368##5	2.3718e-17
C716	VGND#3	B1#2	1.75844e-19
C717	Y#4	VNB	2.10009e-18
C718	VGND	a_465_74##2	3.45389e-17
C719	a_114_368##6	VPWR#7	3.13618e-19
C720	Y#3	VNB	2.22788e-17
C721	VPWR#6	A2#12	1.84457e-18
C722	VGND	Y#8	8.5189e-18
C723	VPWR	VPWR#10	2.19411e-17
C724	Y	C1#7	1.29342e-17
C725	VGND	a_34_74##8	7.02304e-18
C726	a_1213_368##4	VNB	4.45394e-18
C727	VPWR	a_114_368##10	1.47728e-17
C728	A1#18	B1#6	9.83903e-18
C729	a_1213_368##3	VNB	4.77763e-18
C730	VGND	a_465_74##4	3.55668e-17
C731	Y	C1#5	1.41792e-18
C732	a_1213_368##2	VNB	4.45184e-18
C733	VGND	a_34_74##5	6.98033e-18
C734	C1	C1#1	3.65385e-19
C735	Y	B1#4	6.31249e-19
C736	VPWR	a_114_368##11	1.22767e-17
C737	VGND	a_465_74##6	1.83729e-17
C738	VGND	a_34_74#	1.23651e-17
C739	VPWR	VPWR#12	2.17851e-17
C740	A2	A1#14	2.04635e-19
C741	a_465_74##4	a_34_74##5	3.3562e-17
C742	VPWR	a_114_368##12	1.21891e-17
C743	VGND	a_34_74##7	1.43086e-17
C744	a_114_368##4	VNB	1.5887e-18
C745	VGND#10	A3#9	2.82092e-17
C746	VPWR	VPWR#13	2.17984e-17
C747	A2	A1#13	5.00284e-18
C748	a_114_368##3	VNB	1.11652e-18
C749	a_114_368##4	A1#7	7.31366e-19
C750	A1#18	B1#10	2.72905e-18
C751	Y#5	a_465_74#	4.52146e-17
C752	a_114_368##2	VNB	2.67321e-18
C753	VPWR	a_114_368##13	1.22396e-17
C754	VGND	a_34_74##4	1.58536e-17
C755	a_114_368##4	a_114_368##11	3.02451e-18
C756	A1#18	VNB	5.22782e-18
C757	VPWR	VPWR#14	2.17984e-17
C758	A2	A2#1	3.13131e-18
C759	A1#17	VNB	2.54732e-18
C760	VPWR	a_114_368##14	1.22396e-17
C761	A1#16	VNB	1.07274e-17
C762	VPWR	VPWR#15	2.15742e-17
C763	VPWR	a_114_368##8	1.56554e-17
C764	VPWR#15	a_114_368##14	5.05407e-17
C765	B1	C1#1	5.19433e-19
C766	a_34_74##3	VNB	1.44673e-18
C767	VPWR	VPWR#9	5.36235e-17
C768	A2	A2#12	2.1032e-18
C769	a_34_74##2	VNB	2.8668e-18
C770	a_34_74#	A3#11	9.79562e-20
C771	A2	A2#13	2.07738e-18
C772	a_114_368##3	A1#7	1.77006e-17
C773	VGND#8	VNB	1.75775e-18
C774	A3#9	a_34_74##7	1.12564e-17
C775	A2	A3#1	8.5631e-19
C776	a_114_368##5	VPWR#12	1.82101e-17
C777	a_465_74#	VNB	3.26626e-18
C778	Y#6	VNB	5.44683e-19
C779	a_465_74##2	VNB	9.37105e-18
C780	Y#8	VNB	5.59455e-18
C781	a_34_74##8	VNB	8.87626e-18
C782	a_465_74##4	VNB	1.18744e-17
C783	A3	A2#13	4.15173e-19
C784	a_34_74##5	VNB	8.11279e-19
C785	VPWR#8	A3#2	2.45654e-21
C786	a_465_74##6	VNB	2.95795e-18
C787	VPWR#7	A2#13	1.84214e-18
C788	a_114_368##2	A1#7	4.44961e-19
C789	a_34_74#	VNB	4.72587e-18
C790	A3	A3#1	2.45368e-18
C791	a_114_368##11	a_114_368##3	7.56199e-19
C792	VGND#10	VNB	3.01253e-20
C793	a_465_74##6	a_465_74##4	2.78276e-19
C794	a_34_74##7	VNB	2.12109e-18
C795	a_114_368##6	VPWR#6	3.13618e-19
C796	a_34_74#	a_34_74##8	2.30928e-20
C797	VGND#10	A3#11	1.40946e-18
C798	VGND#11	VNB	4.60233e-19
C799	B1#5	B1#3	1.94338e-18
C800	a_34_74##4	VNB	4.56849e-17
C801	Y#9	C1#4	8.01883e-20
C802	A1#18	B1#5	1.6225e-19
C803	VGND	VPWR#9	6.32993e-18
C804	a_114_368##8	a_114_368##14	8.39315e-19
C805	a_1213_368#	VNB	6.14917e-17
C806	VPWR#9	VPWR#14	1.24645e-20
C807	A3	A3#12	2.10322e-18
C808	VGND#3	A1#12	1.65366e-19
C809	VGND#11	A3#9	9.10358e-20
C810	Y#10	VNB	2.69871e-18
C811	a_1213_368##7	VNB	2.76383e-18
C812	A3	A3#7	5.53042e-18
C813	a_465_74##2	A1#12	3.05143e-18
C814	Y#3	Y#9	2.34051e-18
C815	B1#3	B1#2	1.94338e-18
C816	a_114_368#	VNB	4.72301e-19
C817	VGND	A1#1	1.51477e-18
C818	VGND	A1#4	6.77789e-19
C819	a_1213_368##5	VNB	1.15352e-17
C820	a_114_368##4	A1#11	1.06686e-18
C821	VPWR#10	VNB	7.79475e-18
C822	VGND	A1#6	7.56628e-19
C823	A1#12	B1#10	9.89499e-20
C824	a_114_368##4	VPWR#12	1.88638e-17
C825	a_114_368##10	VNB	2.24265e-18
C826	VGND	A1#10	8.24341e-19
C827	VPWR#11	VNB	4.09278e-19
C828	VGND	A2#6	9.3562e-19
C829	a_114_368##11	VNB	4.60133e-18
C830	VPWR#12	VNB	2.19115e-19
C831	VGND	A2#8	8.98877e-19
C832	a_114_368##12	VNB	4.62062e-18
C833	a_34_74##7	A3#11	3.13941e-17
C834	VGND	A2#9	7.86117e-19
C835	VPWR#13	VNB	2.18738e-19
C836	VGND	A2#11	1.73006e-18
C837	a_114_368##13	VNB	4.61348e-18
C838	VPWR#14	VNB	2.18745e-19
C839	VGND	A3#8	8.39544e-19
C840	a_114_368##14	VNB	4.61348e-18
C841	VGND	A3#9	6.48986e-19
C842	VPWR#1	C1	6.35072e-18
C843	VPWR#15	VNB	1.16594e-19
C844	VGND	A3#11	2.83977e-19
C845	a_114_368##8	VNB	2.29714e-18
C846	VPWR	B1#10	1.94264e-18
C847	A1#17	A1#7	1.18626e-18
C848	a_114_368##3	A1#11	1.84071e-17
C849	VPWR#9	VNB	8.48963e-17
C850	VGND	A3#13	1.67999e-18
C851	a_114_368##8	VPWR#15	5.53668e-17
C852	VPWR	A1#7	1.01246e-18
C853	C1#7	VNB	2.915e-17
C854	C1#5	VNB	2.1774e-17
C855	VPWR	A1#11	6.91715e-19
C856	B1#4	VNB	2.84758e-17
C857	B1#7	VNB	3.02827e-17
C858	VPWR	A1#14	1.11733e-18
C859	A2	A2#5	5.63666e-17
C860	a_114_368##5	a_114_368##12	3.8601e-18
C861	A1#1	VNB	4.84472e-17
C862	VPWR	A1#13	1.13523e-18
C863	VPWR#1	B1	5.98836e-18
C864	A1#4	VNB	2.9595e-17
C865	a_34_74##5	a_465_74##6	3.10719e-17
C866	VGND#10	A3#13	2.47762e-19
C867	A1#6	VNB	2.94883e-17
C868	VPWR	A2#1	1.14687e-18
C869	A1#10	VNB	3.39703e-17
C870	C1	C1#3	1.44428e-17
C871	A2#6	VNB	3.29814e-17
C872	VPWR	A2#7	1.14785e-18
C873	A3#11	VGND#11	1.36148e-17
C874	A2#8	VNB	2.96469e-17
C875	VPWR	A2#12	1.15118e-18
C876	A2#9	VNB	2.94301e-17
C877	A2#11	VNB	2.74269e-17
C878	a_114_368##2	A1#11	4.00458e-19
C879	VPWR	A2#13	1.15118e-18
C880	A3#8	VNB	2.60148e-17
C881	A3#9	VNB	2.51875e-17
C882	VPWR	A3#1	1.15143e-18
C883	a_114_368##5	A1#14	9.62907e-20
C884	A3#11	VNB	2.66823e-17
C885	B1	C1#3	4.19857e-19
C886	VPWR	A3#10	1.16937e-18
C887	A3#13	VNB	3.39675e-17
C888	A1#18	B1#2	6.0555e-20
C889	VPWR	A3#12	1.00571e-18
C890	B1	B1#3	6.51948e-18
C891	C1#1	VNB	5.79467e-17
C892	C1#6	VNB	3.47554e-17
C893	VPWR	A3#7	4.14679e-18
C894	C1#8	VNB	3.5526e-17
C895	a_114_368##6	VPWR#13	1.5695e-17
C896	VPWR#7	A3#1	1.84209e-18
C897	C1#9	VNB	3.73687e-17
C898	Y#9	C1#2	1.23954e-17
C899	B1#1	VNB	3.27064e-17
C900	a_114_368##7	A3#5	2.90077e-18
C901	VPWR	VPWR#1	1.65543e-17
C902	a_34_74##7	A3#13	1.67264e-18
C903	VPWR#9	VPWR#15	1.7987e-18
C904	B1#8	VNB	3.22083e-17
C905	B1#9	VNB	3.23759e-17
C906	A1#16	A1#7	9.53005e-19
C907	B1#10	VNB	3.86427e-17
C908	Y#5	Y#4	1.1069e-18
C909	VPWR	VPWR#5	1.97086e-17
C910	a_34_74##4	A3#11	7.72348e-19
C911	A1#7	VNB	2.94931e-17
C912	a_114_368##4	A1#14	1.84766e-17
C913	A1#11	VNB	2.97415e-17
C914	VGND#3	C1#5	9.59968e-19
C915	A1#14	VNB	2.8356e-17
C916	A1#13	VNB	4.52378e-17
C917	A2#1	VNB	2.89452e-17
C918	A2#7	VNB	2.84909e-17
C919	A2#12	VNB	2.90829e-17
C920	A2#13	VNB	2.89119e-17
C921	A3#1	VNB	2.96397e-17
C922	A3	A2	4.29293e-17
C923	VGND	VGND#4	1.41669e-16
C924	A3#10	VNB	2.82354e-17
C925	A3#12	VNB	2.85413e-17
C926	a_34_74#	a_34_74##5	3.94003e-18
C927	A3#7	VNB	4.1823e-17
C928	a_114_368##3	A1#14	5.69774e-19
C929	VGND#11	A3#13	2.84496e-17
C930	VPWR#1	VNB	3.1038e-16
C931	VPWR#7	A3#2	2.01982e-20
C932	VPWR#5	VNB	1.04112e-17
C933	VGND#4	VNB	7.88638e-17
C934	C1#3	VNB	3.25248e-17
C935	a_114_368##5	VPWR#13	1.55987e-17
C936	VPWR#9	a_114_368##8	7.89029e-17
C937	B1#3	VNB	2.96313e-17
C938	B1	C1	1.8971e-17
C939	A2#5	VNB	8.49839e-17
C940	VPWR	A2	1.09084e-17
C941	VPWR	A3	1.00308e-17
C942	a_114_368##2	A1#14	2.79664e-19
C943	VGND	A2	1.01043e-17
C944	VGND	A3	7.81236e-18
C945	a_114_368##5	A1#13	2.23229e-19
C946	A2	VNB	1.59478e-17
C947	A1#18	A1#12	5.08465e-18
C948	a_34_74##4	A3#13	3.31932e-17
C949	A3	VNB	3.09402e-17
C950	Y#8	A1#12	8.66702e-18
C951	C1	VNB	7.81511e-18
C952	B1	VNB	7.24482e-18
C953	A1#12	VPWR#10	2.34989e-18
C954	VPWR#8	A3#10	1.82442e-18
C955	Y	VNB	5.58204e-17
C956	VPWR	VNB	2.85248e-16
C957	a_114_368##6	a_114_368##13	4.40094e-18
C958	VGND	VNB	3.16593e-16
C959	A1#12	A1#7	2.31942e-19
C960	a_114_368##5	VPWR#4	2.98917e-19
C961	VGND#2	a_1213_368##7	4.14798e-18
C962	VGND#6	VNB	4.65766e-17
C963	VGND#2	C1#2	2.93024e-18
C964	VGND#6	A3#5	1.81358e-20
C965	VGND#6	VGND#5	1.40786e-18
C966	VGND#6	A3#13	6.47109e-18
C967	VGND#2	Y#3	2.23871e-18
C968	VGND#2	C1#7	2.91333e-18
C969	VGND#2	a_114_368##2	8.97359e-19
C970	VGND#2	C1#5	1.86627e-18
C971	VGND#6	a_34_74##4	1.7841e-17
C972	VGND#2	a_1213_368#	6.3863e-18
C973	VGND#2	C1#3	1.32759e-18
C974	VGND#6	VGND#10	1.0526e-18
C975	VGND#2	VGND#8	1.61974e-17
C976	VGND#2	Y#9	1.21074e-18
C977	VGND#2	VNB	2.51765e-16
C978	VGND#6	A3#9	1.11704e-18
C979	VGND#2	B1#3	2.01356e-18
C980	VGND#2	C1	6.72187e-18
C981	VGND#6	a_34_74##7	6.50647e-18
C982	VGND	VGND#6	8.92241e-17
C983	VGND#2	Y#5	3.88446e-18
C984	VGND#2	B1	5.06423e-18
C985	VGND#6	a_34_74##3	2.91756e-19
C986	VGND#6	A3#11	6.59137e-18
C987	VGND#2	Y#10	2.8313e-18
C988	VGND#2	C1#4	1.32832e-19
C989	VGND#2	VGND#3	1.25052e-16
C990	VGND#2	Y#4	2.82785e-17
C991	VGND#2	Y	1.18879e-16
*
*
.ENDS sky130_fd_sc_hs__a311oi_4
*
