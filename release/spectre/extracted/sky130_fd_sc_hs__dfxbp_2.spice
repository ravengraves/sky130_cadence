* Extracted by Quantus, converted by sky130cad/quantus.py
*
*
*
*                       LINUX           Wed Nov 18 08:29:18 2026
*
*
*
*  PROGRAM  advgen
*
*  Name           : advgen - Quantus - (64-bit)
*  Version        : 25.1.0-p047
*  Build Date     : Thu Dec 11 23:20:30 PST 2025
*
*  HSPICE LIBRARY
*
*  OPERATING_TEMPERATURE 150
*  QRC_TECH_DIR <path>/tech
*
*
*

*
.SUBCKT sky130_fd_sc_hs__dfxbp_2 VPB VNB VGND VPWR Q_N Q D CLK
*
*
*  caps2d version: 10
*
*
*       TRANSISTOR CARDS
*
*
XM32 a_27_74##15 CLK#3 VGND#17 VNB sky130_fd_pr__nfet_01v8_lvt l=0.15 w=0.74 ad=0.2109 as=0.4077 pd=2.05 ps=2.71
XM15 VGND#17 a_27_74# a_206_368##14 VNB sky130_fd_pr__nfet_01v8_lvt l=0.15 w=0.74 ad=0.4077 as=0.3252 pd=2.71 ps=2.59
XM2 VGND#16 D#3 a_451_503##2 VNB sky130_fd_pr__nfet_01v8_lvt l=0.15 w=0.42 ad=0.35635 as=0.1176 pd=2.6 ps=1.4
XM17 a_451_503##2 a_27_74##6 a_558_445##7 VNB sky130_fd_pr__nfet_01v8_lvt l=0.15 w=0.42 ad=0.1176 as=0.166075 pd=1.4 ps=1.73
XM11 a_558_445##7 a_206_368# a_717_102# VNB sky130_fd_pr__nfet_01v8_lvt l=0.15 w=0.42 ad=0.166075 as=0.1008 pd=1.73 ps=1.32
XM31 a_717_102# a_753_284##3 VGND#15 VNB sky130_fd_pr__nfet_01v8_lvt l=0.15 w=0.42 ad=0.1008 as=0.1965 pd=1.32 ps=1.85
XM12 VGND#15 a_558_445##3 a_753_284##4 VNB sky130_fd_pr__nfet_01v8_lvt l=0.15 w=0.55 ad=0.1965 as=0.387 pd=1.85 ps=2.98
XM3 a_753_284##4 a_206_368##5 a_1000_424##5 VNB sky130_fd_pr__nfet_01v8_lvt l=0.15 w=0.55 ad=0.387 as=0.39205 pd=2.98 ps=3.36
XM7 a_1000_424##5 a_27_74##8 a_1248_128# VNB sky130_fd_pr__nfet_01v8_lvt l=0.15 w=0.42 ad=0.39205 as=0.0882 pd=3.36 ps=1.26
XM1 a_1248_128# a_1290_102##3 VGND#14 VNB sky130_fd_pr__nfet_01v8_lvt l=0.15 w=0.42 ad=0.0882 as=0.1533 pd=1.26 ps=1.57
XM28 a_1290_102##20 a_1000_424# VGND#13 VNB sky130_fd_pr__nfet_01v8_lvt l=0.15 w=0.74 ad=0.2109 as=0.2405 pd=2.05 ps=2.13
XM26 VGND#13 a_1290_102##10 Q#1 VNB sky130_fd_pr__nfet_01v8_lvt l=0.15 w=0.74 ad=0.2405 as=0.2072 pd=2.13 ps=2.04
XM30 Q#1 a_1290_102##12 VGND#12 VNB sky130_fd_pr__nfet_01v8_lvt l=0.15 w=0.74 ad=0.2072 as=0.2627 pd=2.04 ps=2.19
XM13 a_1835_368##10 a_1290_102##5 VGND#4 VNB sky130_fd_pr__nfet_01v8_lvt l=0.15 w=0.64 ad=0.1824 as=0.2877 pd=1.85 ps=2.29
XM22 VGND#4 a_1835_368##5 Q_N#3 VNB sky130_fd_pr__nfet_01v8_lvt l=0.15 w=0.74 ad=0.2877 as=0.2072 pd=2.29 ps=2.04
XM20 Q_N#3 a_1835_368# VGND#1 VNB sky130_fd_pr__nfet_01v8_lvt l=0.15 w=0.74 ad=0.2072 as=0.2109 pd=2.04 ps=2.05
XM0 a_27_74##19 CLK#1 VPWR#16 VPB sky130_fd_pr__pfet_01v8 l=0.15 w=1.12 ad=0.3304 as=0.336 pd=2.83 ps=2.84
XM25 VPWR#16 a_27_74##3 a_206_368##11 VPB sky130_fd_pr__pfet_01v8 l=0.15 w=1.12 ad=0.336 as=0.3304 pd=2.84 ps=2.83
XM18 VPWR#14 D#1 a_451_503# VPB sky130_fd_pr__pfet_01v8 l=0.15 w=0.42 ad=0.3234 as=0.21245 pd=2.38 ps=2.19
XM23 a_451_503# a_206_368##3 a_558_445##5 VPB sky130_fd_pr__pfet_01v8 l=0.15 w=0.42 ad=0.21245 as=0.2394 pd=2.19 ps=1.98
XM5 a_558_445##5 a_27_74##4 a_702_445# VPB sky130_fd_pr__pfet_01v8 l=0.15 w=0.42 ad=0.2394 as=0.1134 pd=1.98 ps=1.38
XM14 a_702_445# a_753_284##2 VPWR#11 VPB sky130_fd_pr__pfet_01v8 l=0.15 w=0.42 ad=0.1134 as=0.413075 pd=1.38 ps=3.09
XM27 VPWR#11 a_558_445# a_753_284##7 VPB sky130_fd_pr__pfet_01v8 l=0.15 w=0.84 ad=0.413075 as=0.252 pd=3.09 ps=2.28
XM8 a_753_284##7 a_27_74##10 a_1000_424##7 VPB sky130_fd_pr__pfet_01v8 l=0.15 w=0.84 ad=0.252 as=0.4851 pd=2.28 ps=3.46
XM29 a_1000_424##7 a_206_368##6 a_1208_479# VPB sky130_fd_pr__pfet_01v8 l=0.15 w=0.42 ad=0.4851 as=0.1785 pd=3.46 ps=1.69
XM16 a_1208_479# a_1290_102##4 VPWR#9 VPB sky130_fd_pr__pfet_01v8 l=0.15 w=0.42 ad=0.1785 as=0.2835 pd=1.69 ps=2.5
XM6 VPWR#9 a_1000_424##3 a_1290_102##19 VPB sky130_fd_pr__pfet_01v8 l=0.15 w=0.84 ad=0.2835 as=0.252 pd=2.5 ps=2.28
XM9 a_1290_102##19 a_1000_424##4 VPWR#7 VPB sky130_fd_pr__pfet_01v8 l=0.15 w=0.84 ad=0.252 as=0.3976 pd=2.28 ps=3.01
XM19 VPWR#7 a_1290_102##14 Q#2 VPB sky130_fd_pr__pfet_01v8 l=0.15 w=1.12 ad=0.3976 as=0.336 pd=3.01 ps=2.84
XM21 Q#2 a_1290_102##13 VPWR#5 VPB sky130_fd_pr__pfet_01v8 l=0.15 w=1.12 ad=0.336 as=0.3304 pd=2.84 ps=2.83
XM24 a_1835_368##9 a_1290_102##11 VPWR#4 VPB sky130_fd_pr__pfet_01v8 l=0.15 w=1 ad=0.295 as=0.4204 pd=2.59 ps=3.01
XM10 Q_N#1 a_1835_368##6 VPWR#4 VPB sky130_fd_pr__pfet_01v8 l=0.15 w=1.12 ad=0.336 as=0.4204 pd=2.84 ps=3.01
XM4 VPWR#1 a_1835_368##4 Q_N#1 VPB sky130_fd_pr__pfet_01v8 l=0.15 w=1.12 ad=0.336 as=0.336 pd=2.84 ps=2.84
*
*
*       RESISTOR AND CAP/DIODE CARDS
*
Rg1	CLK#1	CLK#2	490.915741
Rg2	CLK#2	CLK#3	306.793884
Rg3	a_27_74#	a_27_74##2	327.776306
Rg4	a_27_74##2	a_27_74##3	502.421692
Rg5	D#1	D#2	254.610550
Rg6	D#3	D#4	317.234772
Rg7	a_27_74##4	a_27_74##5	245.891418
Rg8	a_27_74##5	a_27_74##6	587.272339
Rg9	a_206_368#	a_206_368##2	2000.408569
Rg10	a_206_368##2	a_206_368##3	834.307129
Rg11	a_753_284#	a_753_284##2	516.702576
Rg12	a_753_284#	a_753_284##3	243.126862
Rg13	a_558_445#	a_558_445##2	346.957581
Rg14	a_558_445##2	a_558_445##3	584.658325
Rg15	a_206_368##4	a_206_368##5	295.650360
Rg16	a_206_368##6	a_206_368##7	233.787552
Rg17	a_27_74##7	a_27_74##8	264.361176
Rg18	a_27_74##8	a_27_74##9	383.455109
Rg19	a_27_74##9	a_27_74##10	860.566406
Rg20	a_1290_102#	a_1290_102##2	55.222698
Rg21	a_1290_102##2	a_1290_102##3	237.395050
Rg22	a_1290_102##2	a_1290_102##4	612.279968
Rg23	a_1000_424#	a_1000_424##2	520.707153
Rg24	a_1000_424##2	a_1000_424##3	416.581024
Rg25	a_1000_424##2	a_1000_424##4	343.261871
Rg26	a_1290_102##5	a_1290_102##6	351.646759
Rg27	a_1290_102##6	a_1290_102##7	119.189507
Rg28	a_1290_102##7	a_1290_102##8	57.428749
Rg29	a_1290_102##8	a_1290_102##9	171.636658
Rg30	a_1290_102##9	a_1290_102##10	343.439178
Rg31	a_1290_102##6	a_1290_102##11	428.548065
Rg32	a_1290_102##8	a_1290_102##12	366.801178
Rg33	a_1290_102##8	a_1290_102##13	461.927856
Rg34	a_1290_102##9	a_1290_102##14	516.454041
Rg35	a_1835_368#	a_1835_368##2	368.862610
Rg36	a_1835_368##2	a_1835_368##3	79.391464
Rg37	a_1835_368##2	a_1835_368##4	471.862823
Rg38	a_1835_368##3	a_1835_368##5	349.753082
Rg39	a_1835_368##3	a_1835_368##6	451.749359
Rf1	CLK	CLK#4	1.288721
Rf2	CLK#5	CLK#2	161.521530
Rf3	CLK#4	CLK#5	6.353694
Rf4	D	D#2	192.515228
Rf5	D	D#4	160.400620
Rf6	a_451_503#	a_451_503##2	136.947388
Rf7	a_558_445##2	a_558_445##6	279.167053
Rf8	a_558_445##6	a_558_445##7	89.814362
Rf9	a_558_445##5	a_558_445##6	15.000000
Rf10	a_753_284##5	a_753_284#	189.561417
Rf11	a_753_284##5	a_753_284##7	85.325417
Rf12	a_753_284##4	a_753_284##5	15.000000
Rf13	a_206_368##7	a_206_368##9	260.097839
Rf14	a_206_368##9	a_206_368##10	271.800690
Rf15	a_206_368##10	a_206_368##11	7.767661
Rf16	a_206_368##9	a_206_368##4	259.716400
Rf17	a_206_368##10	a_206_368##13	11.997651
Rf18	a_206_368##13	a_206_368##14	32.001827
Rf19	a_27_74##7	a_27_74##12	97.652817
Rf20	a_27_74##12	a_27_74##13	141.856476
Rf21	a_27_74##13	a_27_74##14	248.917175
Rf22	a_27_74##14	a_27_74##15	33.943306
Rf23	a_27_74##12	a_27_74##9	218.595642
Rf24	a_27_74##13	a_27_74##5	233.121399
Rf25	a_27_74##14	a_27_74##18	14.170809
Rf26	a_27_74##18	a_27_74##19	86.062019
Rf27	a_1000_424##5	a_1000_424##6	73.062958
Rf28	a_1000_424##6	a_1000_424##7	82.336548
Rf29	a_1000_424##6	a_1000_424##2	227.553741
Rf30	Q#1	Q	45.499729
Rf31	Q	Q#2	26.295456
Rf32	a_1290_102##7	a_1290_102##16	260.227234
Rf33	a_1290_102##16	a_1290_102##17	86.173981
Rf34	a_1290_102##17	a_1290_102#	179.144470
Rf35	a_1290_102##16	a_1290_102##19	37.614647
Rf36	a_1290_102##17	a_1290_102##20	30.072451
Rf37	a_1835_368##3	a_1835_368##8	180.065399
Rf38	a_1835_368##8	a_1835_368##9	49.205738
Rf39	a_1835_368##8	a_1835_368##10	44.508278
Rf40	Q_N	Q_N#2	0.178802
Rf41	Q_N#2	Q_N	13.052517
Rf42	Q_N	Q_N#3	87.164803
Rf43	Q_N#1	Q_N#2	5.000000
Rf44	VPWR#1	VPWR#2	118.929359
Rf45	VPWR#2	VPWR#3	68.335030
Rf46	VPWR#2	VPWR#4	48.259808
Rf47	VPWR#3	VPWR#5	36.824379
Rf48	VPWR#3	VPWR#6	76.568916
Rf49	VPWR#6	VPWR#7	33.326477
Rf50	VPWR#6	VPWR#8	79.941223
Rf51	VPWR#8	VPWR#9	40.215752
Rf52	VPWR#8	VPWR#10	189.882217
Rf53	VPWR#10	VPWR#11	22.697315
Rf54	VPWR#10	VPWR#12	58.781116
Rf55	VPWR#12	VPWR#13	113.528183
Rf56	VPWR#13	VPWR#14	20.599306
Rf57	VPWR#13	VPWR#15	75.574738
Rf58	VPWR#15	VPWR#16	44.620285
Rf60	VGND#1	VGND#2	108.421173
Rf61	VGND#2	VGND#3	71.622299
Rf62	VGND#2	VGND#4	41.038895
Rf63	VGND#3	VGND#5	80.038811
Rf64	VGND#5	VGND#6	72.270927
Rf65	VGND#6	VGND#7	191.337540
Rf66	VGND#7	VGND#8	61.332191
Rf67	VGND#8	VGND#9	97.497879
Rf68	VGND#9	VGND#10	88.133156
Rf70	VGND#3	VGND#12	37.591507
Rf71	VGND#5	VGND#13	34.093605
Rf72	VGND#6	VGND#14	43.561966
Rf73	VGND#7	VGND#15	31.856489
Rf74	VGND#9	VGND#16	30.373932
Rf75	VGND#10	VGND#17	25.551914
Rf83	a_206_368##2	a_206_368##13	160.232803
Rf87	a_27_74##2	a_27_74##18	160.232803
Re1	VPWR#3	VPWR	2.377092
Re2	VPWR	VPWR#12	1.528131
Re3	VGND#3	VGND	2.377092
Re4	VGND	VGND#8	1.528131
*
*       CAPACITOR CARDS
*
*
C1	a_206_368##9	a_27_74##9	2.01264e-18
C2	a_1290_102##19	VPWR#7	3.18501e-17
C3	a_1290_102##10	Q#1	3.27201e-17
C4	VPWR#3	VPWR#1	5.48763e-17
C5	a_558_445##5	a_753_284##2	9.75834e-18
C6	a_1290_102##8	VPWR#5	1.50911e-18
C7	a_451_503##2	a_206_368##11	2.27891e-18
C8	VPWR#8	a_1000_424##3	1.17814e-17
C9	Q#1	a_1835_368##8	3.9124e-18
C10	a_206_368##11	VPWR#13	7.49425e-17
C11	a_1290_102##7	a_1290_102##8	2.39253e-17
C12	VGND#12	a_1000_424#	5.65133e-19
C13	Q#1	a_1290_102##6	1.45708e-19
C14	a_27_74##13	a_558_445##2	9.27624e-19
C15	a_1290_102##20	VGND#13	6.13026e-17
C16	VGND#7	a_27_74##10	6.71056e-20
C17	a_1290_102##7	a_1290_102##6	7.26614e-20
C18	VGND#13	a_1290_102##10	1.78108e-17
C19	VPWR#9	VPWR#7	6.02806e-19
C20	VGND#9	a_206_368##2	1.424e-17
C21	a_1290_102##16	a_1290_102##13	1.01104e-17
C22	a_558_445##5	a_27_74##4	2.2798e-17
C23	VPWR#13	D#2	1.0344e-18
C24	VGND#3	VPWR#1	4.93889e-18
C25	a_206_368##9	a_206_368##4	1.42437e-18
C26	Q#1	a_1000_424#	2.02316e-18
C27	a_1835_368##9	VPWR#3	1.91714e-17
C28	VPWR#2	a_1290_102##6	1.38924e-20
C29	a_451_503#	a_27_74##4	1.57644e-19
C30	Q#1	a_1290_102#	5.13675e-19
C31	VPWR#9	a_1290_102##19	4.13643e-17
C32	a_1290_102##17	a_1290_102##16	1.12532e-18
C33	a_1290_102##17	a_1290_102##14	2.32002e-19
C34	a_1290_102##12	a_1290_102##6	5.69953e-20
C35	VPWR#3	VPWR#5	1.82824e-17
C36	CLK#3	a_27_74#	1.6207e-17
C37	VPWR#8	a_1290_102##4	3.38949e-18
C38	a_206_368##3	a_558_445##5	1.69708e-17
C39	VGND#14	VGND#13	1.36411e-19
C40	VGND#3	VPWR#4	3.24157e-18
C41	a_1000_424##7	a_1000_424##6	3.48828e-18
C42	VGND#13	a_1000_424#	4.37472e-17
C43	VPWR#16	VPWR#13	2.46936e-18
C44	a_27_74##13	a_753_284#	7.74985e-17
C45	VPWR#3	Q#2	3.62618e-18
C46	a_1000_424##2	a_1290_102##9	1.00698e-17
C47	a_451_503#	a_206_368##3	4.65905e-17
C48	a_1290_102##16	a_1290_102##14	1.88908e-17
C49	a_558_445##2	a_206_368##9	4.81939e-17
C50	a_206_368##11	a_27_74##4	1.87618e-19
C51	VPWR#13	a_206_368##2	9.29868e-19
C52	VPWR#3	VPWR#7	1.81201e-17
C53	a_1000_424#	a_1290_102##20	1.88338e-17
C54	a_1290_102#	VGND#14	4.117e-17
C55	VGND#2	a_1835_368#	2.55181e-18
C56	VGND#14	a_1290_102##20	4.54162e-17
C57	VPWR#3	a_1290_102##19	1.77651e-17
C58	D#1	a_451_503#	1.43507e-17
C59	a_206_368##11	a_206_368##3	8.42579e-18
C60	VPWR#8	a_206_368##6	3.53498e-18
C61	a_27_74##13	a_27_74##5	1.71301e-18
C62	a_1290_102##16	VGND#12	2.28691e-19
C63	a_1290_102##2	a_1000_424##2	6.84447e-18
C64	VGND#14	a_1000_424#	1.18677e-18
C65	a_1000_424##5	a_1290_102#	4.55397e-18
C66	D#1	VPWR#14	4.37991e-18
C67	a_1290_102##17	Q#1	4.82247e-18
C68	a_1835_368##8	a_1835_368##2	1.47703e-19
C69	a_206_368##9	a_753_284#	2.8012e-19
C70	a_1290_102##16	a_1000_424##4	1.14681e-17
C71	a_1290_102##20	a_1290_102##3	1.78814e-18
C72	a_451_503#	a_27_74##3	1.39346e-19
C73	a_206_368##11	D#1	2.95394e-17
C74	VGND#13	a_27_74##7	1.88733e-19
C75	VGND#2	a_1835_368##5	7.44279e-18
C76	VPWR#10	a_27_74##10	6.71116e-18
C77	a_27_74##14	D#4	8.00525e-18
C78	a_1290_102##3	VGND#14	2.12289e-17
C79	a_1000_424##5	a_206_368##7	8.85087e-19
C80	VPWR#16	D#1	8.81753e-19
C81	a_1290_102##20	a_27_74##7	3.13024e-19
C82	a_1000_424#	a_1290_102##9	6.13854e-18
C83	a_1835_368##3	VPWR#4	3.37461e-17
C84	a_1000_424##5	a_1000_424#	5.0287e-19
C85	VPWR#8	a_27_74##10	6.61655e-19
C86	a_1290_102##20	a_27_74##8	3.45366e-19
C87	a_27_74##3	a_206_368##11	2.69435e-17
C88	a_27_74##7	VGND#14	1.39557e-17
C89	a_206_368##9	a_27_74##5	1.30452e-19
C90	a_1290_102##17	VGND#13	3.37026e-17
C91	a_1000_424##5	a_1290_102##20	1.93419e-18
C92	a_1290_102##16	a_1000_424##3	3.41152e-19
C93	VPWR#16	a_27_74##3	5.097e-17
C94	a_27_74##15	a_27_74##19	5.64813e-19
C95	VGND#17	VGND#9	1.71859e-19
C96	a_1835_368##6	a_1835_368##4	4.75112e-17
C97	a_27_74##7	a_1000_424##5	4.28683e-17
C98	a_1290_102##9	a_1290_102##8	1.15837e-17
C99	VGND#14	a_27_74##8	3.36392e-18
C100	a_206_368##11	CLK#1	8.14365e-19
C101	a_27_74##14	D#2	3.3598e-18
C102	a_27_74##19	a_27_74##3	3.24326e-18
C103	VGND#2	a_1290_102##5	4.78472e-18
C104	VPWR#10	a_558_445#	1.5532e-17
C105	a_1000_424##5	a_1290_102##3	5.04522e-18
C106	a_1290_102##7	a_1835_368##9	5.36091e-17
C107	CLK#1	VPWR#16	2.26621e-17
C108	VGND#15	a_27_74##7	2.18163e-19
C109	a_1000_424##5	VGND#14	1.43071e-17
C110	VPWR#8	a_558_445#	2.09962e-19
C111	a_1290_102##7	VPWR#5	3.82562e-17
C112	a_1290_102##17	a_1290_102##20	8.75817e-20
C113	a_27_74##19	CLK#1	6.54436e-17
C114	a_1835_368##8	a_1290_102##8	9.29288e-18
C115	a_1290_102##16	a_1290_102##4	1.42e-19
C116	a_27_74##9	a_1000_424##5	4.16131e-17
C117	a_1290_102##11	a_1835_368##6	3.21691e-17
C118	VGND#14	a_206_368##5	1.93077e-19
C119	VGND#9	a_206_368##3	1.03668e-19
C120	Q#2	a_1290_102##7	2.628e-17
C121	a_753_284##4	a_27_74##9	5.25725e-20
C122	a_1000_424##5	a_27_74##8	2.61717e-17
C123	a_27_74##14	a_206_368##2	4.56026e-17
C124	a_1290_102##13	a_1835_368##6	3.40774e-19
C125	a_27_74##13	a_206_368##2	4.59456e-19
C126	VPWR#10	a_753_284##2	2.9153e-18
C127	a_206_368##4	a_1000_424##5	2.03821e-18
C128	a_206_368##7	a_1290_102##2	3.22233e-18
C129	Q#2	a_1000_424##2	5.79522e-19
C130	a_1290_102##13	a_1290_102##11	5.97745e-18
C131	a_753_284##4	a_206_368##4	6.55433e-17
C132	a_206_368##5	a_1000_424##5	7.50644e-18
C133	a_1835_368##8	a_1290_102##6	3.58692e-17
C134	a_1000_424##6	a_1290_102##4	1.0686e-17
C135	VGND#5	a_1290_102##10	5.55603e-18
C136	a_1000_424##2	a_1290_102##19	4.96381e-17
C137	a_206_368##5	a_753_284##4	1.03885e-17
C138	a_1000_424##2	VPWR#9	1.07596e-17
C139	a_206_368##11	VPWR#12	1.47791e-17
C140	a_1290_102##14	a_1290_102##13	4.9456e-17
C141	a_753_284##4	a_558_445##2	4.72964e-17
C142	VGND#6	a_1000_424#	2.04299e-18
C143	VGND#3	a_1835_368#	4.34436e-18
C144	VGND#1	VPWR#1	1.03343e-17
C145	VGND#15	a_558_445##2	5.63022e-19
C146	VGND#15	a_206_368##5	1.46415e-18
C147	VGND#3	a_1835_368##5	1.71428e-18
C148	VPWR#9	a_1290_102#	1.72513e-18
C149	a_753_284##4	a_558_445##3	1.45696e-17
C150	VGND#5	a_1000_424#	1.23723e-18
C151	a_206_368#	a_206_368##3	6.73136e-19
C152	VPWR#13	a_206_368##3	9.32122e-19
C153	a_1290_102##8	a_1290_102##6	4.39918e-19
C154	a_1000_424##4	a_1290_102##14	2.77601e-17
C155	VGND#3	a_1290_102##5	1.11811e-17
C156	a_753_284##4	a_753_284#	1.84552e-19
C157	a_206_368##7	a_1290_102##19	7.90924e-18
C158	a_206_368##9	VPWR#10	8.56579e-17
C159	VGND#15	a_753_284#	9.53347e-19
C160	a_1835_368##8	a_1835_368#	1.89567e-20
C161	VGND#15	a_558_445##3	2.80216e-17
C162	VGND#3	a_1290_102##12	1.59631e-17
C163	a_206_368##7	VPWR#9	2.69668e-17
C164	VGND#6	a_1290_102##3	2.95287e-18
C165	D#3	a_206_368##3	4.39219e-18
C166	VPWR#9	a_1290_102##2	1.48066e-19
C167	VGND#3	a_1290_102##10	7.58056e-18
C168	a_1000_424##6	a_27_74##10	1.85464e-19
C169	a_558_445##7	a_753_284#	1.28215e-18
C170	a_1000_424##3	a_1000_424##4	3.53057e-17
C171	a_27_74##5	a_753_284##4	1.73836e-18
C172	a_27_74##8	a_1290_102##2	2.13021e-17
C173	a_206_368##7	a_1000_424##7	6.70907e-17
C174	VGND#3	a_1000_424#	4.92334e-18
C175	VPWR#13	D#1	1.55091e-17
C176	a_206_368##9	a_1000_424##7	1.05871e-16
C177	a_753_284##3	VGND#15	1.50597e-17
C178	a_206_368##9	VPWR#8	1.55474e-17
C179	a_27_74##13	a_558_445##5	1.22062e-18
C180	a_27_74##10	a_1290_102##2	1.44173e-20
C181	a_1290_102##17	a_1290_102##9	8.86793e-18
C182	a_1835_368##8	a_1835_368##5	4.65143e-20
C183	VPWR#10	D#1	2.16785e-18
C184	a_558_445##7	a_27_74##5	6.05343e-17
C185	a_27_74##9	a_1290_102##2	6.00773e-18
C186	a_27_74##14	a_451_503#	2.08874e-18
C187	a_1290_102##4	a_1000_424##3	3.03537e-17
C188	a_451_503##2	a_27_74##5	4.63647e-19
C189	VGND#14	a_1000_424##6	4.19757e-18
C190	a_1290_102##5	a_1835_368##3	2.77192e-19
C191	VGND#15	a_206_368#	3.37987e-18
C192	a_1000_424##5	a_1290_102##2	8.91112e-19
C193	a_206_368##9	a_753_284##7	7.45304e-17
C194	VPWR#13	a_27_74##3	2.29729e-18
C195	a_558_445##7	D#4	4.07284e-19
C196	VGND#7	a_206_368##5	4.31049e-18
C197	a_1290_102##17	a_1290_102##8	9.09807e-20
C198	a_206_368##6	a_1290_102##4	1.24889e-17
C199	a_451_503##2	D#4	2.74373e-18
C200	a_27_74##10	a_1000_424##3	1.19915e-19
C201	a_1835_368##8	a_1290_102##5	1.73514e-18
C202	a_27_74##14	VPWR#14	4.32826e-20
C203	VGND#16	D#4	6.28459e-19
C204	a_451_503#	a_558_445##5	4.70108e-17
C205	VGND#6	a_206_368##5	2.10039e-19
C206	a_206_368##14	D#4	1.80451e-18
C207	a_206_368#	a_558_445##7	1.15049e-17
C208	a_206_368##4	a_1000_424##7	9.77142e-18
C209	a_1290_102##16	a_1290_102##9	1.94514e-19
C210	a_27_74##12	a_27_74##10	1.07156e-18
C211	a_206_368##9	VPWR#11	2.90088e-18
C212	a_753_284##7	a_206_368##4	1.40056e-17
C213	a_206_368##4	a_1290_102##2	2.52697e-21
C214	a_27_74##10	a_206_368##6	3.76239e-18
C215	a_451_503##2	a_206_368#	2.06765e-18
C216	VGND#7	a_558_445##3	3.72142e-18
C217	a_1835_368##8	a_1290_102##12	6.8685e-19
C218	a_27_74##14	a_206_368##11	3.87123e-18
C219	VPWR#12	a_27_74##6	6.4664e-20
C220	a_558_445##7	a_27_74##6	3.89618e-17
C221	a_558_445##2	a_753_284##7	4.13005e-17
C222	a_1000_424##5	a_1000_424##6	2.50101e-18
C223	a_558_445##7	a_206_368##2	1.89016e-19
C224	VGND#8	a_206_368#	1.98934e-17
C225	a_1000_424##7	a_1290_102##2	4.99277e-20
C226	VGND#16	a_206_368#	4.5544e-18
C227	a_206_368##9	a_702_445#	7.57139e-19
C228	a_206_368##9	a_206_368##6	9.39153e-19
C229	a_451_503##2	a_206_368##2	3.29036e-19
C230	a_558_445##2	VPWR#11	6.87683e-18
C231	a_558_445#	a_27_74##10	3.8435e-17
C232	a_1290_102##16	a_1290_102##8	1.4005e-19
C233	a_206_368##11	a_558_445##5	4.31792e-17
C234	VGND#8	a_27_74##6	1.19322e-18
C235	a_27_74##6	a_451_503##2	1.22078e-17
C236	VGND#16	a_206_368##2	1.48298e-17
C237	a_1290_102#	a_1000_424#	5.95804e-18
C238	VPWR#3	a_1835_368##4	3.36929e-18
C239	a_206_368##2	a_206_368##14	9.12626e-18
C240	a_558_445##7	D#3	1.21668e-18
C241	a_558_445##5	a_558_445##2	2.03028e-18
C242	VPWR#3	a_1835_368##6	2.43878e-18
C243	VGND#17	a_206_368##2	3.31356e-18
C244	VGND#16	a_27_74##6	2.22061e-19
C245	a_206_368##11	a_451_503#	5.64282e-17
C246	VGND#7	a_753_284##3	4.41588e-18
C247	a_27_74##15	a_206_368##2	4.28843e-19
C248	a_1290_102#	a_27_74##8	2.06378e-18
C249	a_753_284##2	a_558_445#	1.70157e-17
C250	VPWR#3	a_1290_102##11	8.55559e-18
C251	a_206_368##9	a_27_74##10	3.22112e-17
C252	a_451_503##2	D#3	2.1075e-17
C253	a_206_368##9	a_558_445##5	5.01437e-17
C254	a_753_284#	a_558_445##5	1.11232e-18
C255	a_27_74##2	a_206_368##14	2.74401e-17
C256	VPWR#3	a_1290_102##13	4.46982e-18
C257	a_1290_102##17	a_1290_102##12	2.03802e-19
C258	a_206_368##11	VPWR#14	5.38769e-18
C259	a_27_74##8	a_206_368##7	3.4108e-18
C260	VGND#3	VGND#6	5.88971e-17
C261	a_27_74##2	VGND#17	2.2638e-18
C262	a_27_74##7	a_1000_424#	1.69895e-18
C263	VPWR#8	a_27_74##8	2.42467e-19
C264	D#3	VGND#16	1.10354e-17
C265	VGND#9	a_206_368#	1.16502e-17
C266	VPWR#3	a_1290_102##14	4.90246e-19
C267	a_27_74##4	a_753_284##2	2.42278e-17
C268	a_27_74##7	a_1290_102##3	1.16764e-17
C269	VGND#3	VGND#5	6.20453e-17
C270	a_27_74##14	a_27_74##19	3.012e-18
C271	a_451_503##2	a_27_74#	2.52112e-19
C272	a_558_445##5	a_27_74##5	5.81952e-17
C273	a_27_74##7	a_27_74##8	8.75049e-20
C274	a_451_503##2	a_558_445##7	7.80713e-17
C275	a_206_368##9	a_558_445#	3.36448e-17
C276	VGND#3	VGND#2	8.66338e-17
C277	a_451_503#	a_27_74##5	2.30035e-18
C278	VGND#7	a_206_368#	1.34192e-18
C279	VGND#2	a_1835_368##8	2.51915e-19
C280	a_206_368##5	a_27_74##7	8.80766e-18
C281	VPWR#3	a_1000_424##3	2.25856e-18
C282	VGND#16	a_27_74#	2.08788e-18
C283	a_206_368##3	a_27_74##4	7.92406e-18
C284	CLK#2	a_27_74##15	2.56121e-17
C285	a_27_74##14	a_206_368##3	1.53789e-18
C286	VPWR#3	VPWR#8	5.78751e-17
C287	a_1290_102##17	a_1290_102##10	4.0866e-19
C288	a_206_368##11	a_27_74##5	7.50451e-19
C289	a_27_74##9	a_27_74##8	4.88054e-19
C290	VGND#17	D#3	3.80384e-19
C291	VPWR#16	a_206_368##11	7.15542e-17
C292	a_451_503#	D#4	1.63807e-19
C293	a_27_74##9	a_206_368##5	1.54467e-18
C294	VPWR#3	VPWR#6	6.46267e-17
C295	a_27_74#	a_206_368##14	1.39389e-17
C296	a_27_74##12	VGND#14	1.64782e-18
C297	a_27_74##13	a_206_368##3	2.23957e-19
C298	a_206_368#	a_27_74##7	1.15907e-19
C299	a_27_74##9	a_558_445##3	7.10655e-19
C300	a_206_368##9	a_753_284##2	1.0448e-17
C301	a_27_74##15	D#3	3.53224e-19
C302	a_206_368##4	a_27_74##8	1.75041e-19
C303	VGND#16	CLK#3	6.05003e-19
C304	D#1	a_206_368##3	1.22871e-17
C305	VPWR#3	VPWR#2	8.44676e-17
C306	VPWR#2	VPWR#1	7.0073e-19
C307	VPWR#8	VPWR#6	1.0136e-18
C308	a_1290_102##7	a_1290_102##11	1.23676e-18
C309	a_27_74##19	a_206_368##11	2.68257e-18
C310	a_27_74#	VGND#17	2.83663e-17
C311	D#2	a_451_503#	3.61362e-17
C312	a_27_74##3	a_206_368##3	3.30618e-19
C313	a_27_74##9	a_206_368#	1.40227e-19
C314	a_1290_102##7	a_1290_102##13	1.10025e-17
C315	a_558_445##3	a_206_368##4	7.41764e-18
C316	D#2	VPWR#14	3.24054e-18
C317	VGND#6	a_1290_102##17	1.33047e-19
C318	a_1290_102##17	a_1000_424#	9.27218e-18
C319	a_206_368##11	D#2	5.568e-17
C320	a_27_74##15	a_27_74#	1.65347e-18
C321	a_1290_102##7	a_1290_102##14	4.12222e-19
C322	a_27_74##3	D#1	2.79409e-18
C323	a_27_74##19	VPWR#16	7.70981e-17
C324	VPWR#16	D#2	5.26981e-19
C325	a_451_503#	a_206_368##2	2.53027e-18
C326	a_206_368##9	a_27_74##4	9.55558e-18
C327	VGND#9	D#3	7.92657e-19
C328	CLK#3	VGND#17	2.74186e-17
C329	a_1290_102##7	a_1000_424##4	1.26695e-19
C330	VPWR#3	a_1835_368##8	1.81495e-18
C331	a_27_74##19	D#2	1.47129e-19
C332	a_1000_424##2	a_1290_102##14	1.61507e-17
C333	a_206_368##14	a_451_503##2	9.78926e-19
C334	a_206_368##2	a_206_368##11	1.25968e-17
C335	CLK#1	a_27_74##3	4.96404e-17
C336	a_27_74##15	CLK#3	4.82499e-17
C337	a_753_284#	a_558_445##3	1.77197e-17
C338	VGND#5	a_1290_102##17	1.82313e-19
C339	a_1000_424##3	a_1000_424##2	1.79517e-18
C340	a_27_74##12	a_1000_424##5	1.96082e-17
C341	a_27_74##2	a_206_368##11	2.20748e-17
C342	VPWR#12	a_27_74##4	2.87226e-18
C343	a_206_368#	a_753_284#	6.68103e-18
C344	a_1290_102##4	a_1000_424##2	2.24491e-18
C345	VPWR#3	a_1290_102##17	6.12528e-19
C346	a_27_74##13	a_753_284##4	1.94424e-17
C347	VGND#5	a_1290_102##9	4.73543e-20
C348	a_206_368##7	a_1290_102##14	2.34264e-20
C349	a_27_74##2	VPWR#16	1.89221e-17
C350	VGND#3	a_1835_368##8	1.86202e-18
C351	a_27_74##6	a_753_284#	4.60507e-18
C352	VPWR#12	a_206_368##3	2.0519e-18
C353	a_27_74##13	a_717_102#	6.71482e-19
C354	a_206_368##7	a_1000_424##4	1.22945e-19
C355	a_1290_102##16	VPWR#3	1.30186e-17
C356	VGND#2	VGND#1	1.25309e-18
C357	a_206_368#	a_27_74##5	3.50029e-18
C358	VGND#2	a_1835_368##2	6.09207e-20
C359	a_206_368##7	a_1000_424##3	1.07043e-18
C360	VGND#8	a_206_368##3	1.73569e-19
C361	VGND#2	a_1835_368##3	8.85734e-19
C362	a_27_74##5	a_27_74##6	2.54129e-19
C363	a_206_368##7	a_1290_102##4	3.33094e-17
C364	a_27_74##12	a_753_284##4	3.26989e-17
C365	VGND#17	VGND#16	4.06581e-18
C366	CLK#2	a_27_74##19	2.66939e-17
C367	a_206_368#	D#4	1.85502e-18
C368	a_27_74##13	VGND#15	4.82395e-17
C369	a_206_368##7	a_206_368##6	2.21265e-17
C370	VGND#3	a_1290_102##17	3.98383e-18
C371	D#4	a_27_74##6	8.10742e-19
C372	a_1835_368##5	a_1835_368#	3.83953e-17
C373	VPWR#3	a_1000_424##6	7.16736e-19
C374	a_27_74##10	a_206_368##7	4.4175e-18
C375	VPWR#1	a_1835_368##4	3.48001e-17
C376	a_1835_368##9	VPWR#2	4.39466e-18
C377	VGND#2	Q_N#3	1.62927e-17
C378	a_27_74##14	a_27_74##13	5.6819e-19
C379	VGND#15	a_27_74##12	2.2908e-17
C380	Q_N#1	a_1835_368##4	3.68513e-17
C381	a_558_445##5	a_702_445#	1.36468e-18
C382	a_206_368##2	a_206_368#	1.88273e-19
C383	VPWR#1	a_1835_368##6	1.211e-18
C384	a_1000_424##6	a_1290_102##2	2.60428e-17
C385	VPWR#4	a_1835_368##4	7.38817e-19
C386	a_1290_102##5	a_1835_368##5	2.36167e-17
C387	VGND#3	a_1000_424##6	4.91784e-19
C388	a_206_368##2	D#3	7.83649e-18
C389	VPWR#3	a_1835_368##3	3.57452e-18
C390	VGND#6	a_1000_424##2	2.11941e-19
C391	a_206_368##4	a_27_74##10	3.99963e-17
C392	a_27_74#	a_206_368##2	2.64994e-17
C393	Q_N#1	a_1835_368##6	3.54036e-17
C394	a_1835_368##3	VPWR#2	3.71664e-19
C395	VPWR#5	VPWR#2	1.2267e-19
C396	VGND#3	a_1835_368##3	6.48184e-18
C397	a_1290_102##7	VPWR#3	7.90879e-18
C398	VGND#5	a_1000_424##2	3.9915e-20
C399	Q	a_1290_102##9	8.51844e-18
C400	Q	a_1290_102##8	1.31579e-17
C401	a_1000_424##6	a_27_74##8	5.19581e-18
C402	a_558_445##2	a_27_74##10	2.15903e-17
C403	a_1290_102##12	a_1835_368##5	2.89715e-19
C404	VGND#3	a_1290_102##7	3.36021e-18
C405	a_27_74##2	a_27_74#	1.14319e-18
C406	VPWR#3	a_1000_424##2	6.29254e-18
C407	a_1835_368##6	VPWR#4	2.65459e-17
C408	a_27_74##13	a_558_445##7	1.00123e-16
C409	a_27_74##15	VGND#17	1.88943e-17
C410	a_558_445##2	a_558_445#	6.19548e-18
C411	a_27_74##2	CLK#3	7.42416e-19
C412	VGND#3	a_1000_424##2	4.9918e-18
C413	a_27_74##14	a_451_503##2	3.47326e-17
C414	a_558_445##2	a_753_284##2	2.84839e-17
C415	Q_N#1	a_1290_102##11	6.82076e-19
C416	VGND#6	a_1000_424##6	1.24333e-18
C417	a_1290_102##12	a_1290_102##5	4.66715e-18
C418	a_1835_368##8	a_1835_368##3	3.10276e-19
C419	a_1835_368##9	a_1835_368##6	1.41603e-18
C420	VPWR#8	VPWR#7	5.20894e-19
C421	a_558_445##2	a_27_74##4	2.12642e-19
C422	VGND#3	a_1290_102#	5.39211e-18
C423	VGND#6	a_1290_102#	6.4029e-19
C424	VPWR#1	a_1290_102##13	1.68721e-19
C425	a_27_74##13	a_27_74##12	1.47548e-18
C426	a_1290_102##11	VPWR#4	3.28993e-17
C427	a_558_445##2	a_206_368##3	1.4153e-19
C428	a_27_74##5	a_558_445#	2.99404e-19
C429	a_1000_424##6	a_206_368##9	7.62482e-19
C430	VPWR#5	a_1835_368##6	7.03848e-19
C431	VGND#2	a_1835_368##10	4.79931e-18
C432	a_558_445##5	a_206_368#	5.18539e-19
C433	a_27_74##12	a_1000_424#	1.17819e-19
C434	VGND#2	a_1290_102##6	4.38395e-20
C435	a_27_74##5	a_753_284##2	2.7008e-17
C436	a_27_74##13	a_451_503##2	2.66688e-17
C437	a_1835_368##9	a_1290_102##11	7.19041e-17
C438	a_27_74##14	VGND#16	5.02324e-17
C439	a_1000_424##2	VPWR#8	6.26351e-19
C440	Q_N	a_1835_368##2	1.17538e-17
C441	VPWR#4	a_1290_102##13	6.25536e-19
C442	a_206_368##3	a_27_74##5	3.04065e-17
C443	Q_N	a_1290_102##6	2.85532e-19
C444	a_451_503#	a_206_368#	1.37342e-19
C445	a_753_284##4	a_27_74##10	3.52262e-18
C446	a_1290_102##7	a_1835_368##8	3.76692e-17
C447	a_1290_102##10	a_1290_102##12	3.931e-17
C448	VPWR#6	a_1000_424##2	3.65948e-20
C449	VPWR#5	a_1290_102##11	3.35234e-18
C450	a_1290_102##19	VPWR#8	7.86349e-18
C451	VGND#1	Q_N#3	7.51874e-17
C452	a_753_284##4	a_206_368##9	1.35235e-18
C453	D#4	a_206_368##3	2.67234e-18
C454	a_1290_102#	a_1000_424##2	4.65148e-17
C455	a_1835_368##9	a_1290_102##13	2.46359e-18
C456	a_1835_368##8	VPWR#2	2.17145e-19
C457	a_27_74##12	a_1290_102##3	3.99453e-19
C458	VGND#16	a_27_74##13	3.10331e-17
C459	VGND#12	VGND#2	1.81841e-19
C460	a_206_368##7	a_1000_424##2	4.61346e-19
C461	D#2	a_206_368##3	1.58843e-17
C462	a_1290_102##3	a_1248_128#	8.8457e-18
C463	a_1290_102##19	VPWR#6	9.54698e-18
C464	a_27_74##14	a_206_368##14	5.10726e-17
C465	VPWR#5	a_1290_102##13	3.70691e-17
C466	a_27_74##8	a_1248_128#	8.8457e-18
C467	VGND#5	Q#1	8.03477e-18
C468	VPWR#8	a_1290_102#	2.97195e-20
C469	a_27_74##3	D#2	5.2136e-18
C470	a_1835_368##9	a_1290_102##14	3.70922e-19
C471	VGND#4	VGND#1	2.12594e-18
C472	Q_N#3	a_1835_368##2	1.09231e-17
C473	a_1000_424#	a_1290_102##10	3.15443e-17
C474	a_1290_102##16	a_1290_102##7	2.26782e-18
C475	a_451_503#	D#3	9.12641e-20
C476	VGND#7	a_27_74##7	4.23322e-19
C477	Q#2	a_1290_102##13	3.64025e-17
C478	VGND#6	VGND#13	3.07626e-18
C479	a_27_74##2	a_206_368##3	8.89325e-20
C480	VGND#8	a_27_74##13	6.32202e-17
C481	a_27_74##3	a_206_368##2	5.33955e-18
C482	a_1290_102##19	a_1290_102##11	3.27463e-19
C483	VPWR#12	a_27_74##5	2.86374e-19
C484	a_1290_102#	a_27_74##9	6.6689e-19
C485	VGND#6	a_27_74##7	6.77721e-17
C486	Q_N#1	VPWR#1	4.23304e-17
C487	a_27_74##12	a_27_74##8	1.83462e-18
C488	VPWR#5	a_1290_102##14	3.36066e-18
C489	VGND#9	a_27_74##14	5.00853e-18
C490	a_206_368##11	a_27_74##6	1.47331e-19
C491	a_206_368##6	a_1208_479#	1.06882e-17
C492	VGND#8	a_27_74##5	1.28196e-19
C493	a_27_74##9	a_206_368##7	3.66457e-18
C494	VPWR#7	a_1290_102##13	3.36066e-18
C495	VGND#5	a_27_74##7	5.13801e-20
C496	a_27_74##14	D	2.91871e-17
C497	a_27_74##2	a_27_74##3	4.82662e-18
C498	a_1835_368##9	a_1000_424##4	2.37987e-19
C499	a_27_74##14	VGND#17	4.97083e-17
C500	a_27_74##7	a_27_74##9	1.51176e-17
C501	a_206_368##4	a_206_368##7	2.47042e-19
C502	Q#2	a_1290_102##14	3.38723e-17
C503	a_1290_102##17	a_1000_424##2	5.83741e-17
C504	a_27_74##13	a_206_368##5	1.43496e-19
C505	VGND#4	Q_N#3	6.38148e-17
C506	VPWR#3	a_1290_102##8	3.07077e-18
C507	a_206_368##7	VPWR#8	1.90164e-17
C508	a_1290_102##19	a_1290_102##13	4.80301e-19
C509	a_206_368##9	VPWR#12	1.23011e-17
C510	VPWR#4	VPWR#1	1.98933e-18
C511	a_1000_424##2	a_1290_102##16	3.28757e-17
C512	a_1290_102##3	a_1000_424#	2.95501e-18
C513	a_1290_102##17	Q	2.3082e-17
C514	VPWR#3	a_1290_102##6	3.9681e-20
C515	VPWR#7	a_1290_102##14	3.89298e-17
C516	a_1290_102##16	Q	7.33745e-18
C517	a_206_368##4	a_27_74##9	6.88128e-17
C518	VGND#7	a_27_74##9	5.16116e-20
C519	VGND#6	a_1290_102##20	5.58824e-18
C520	a_753_284##2	a_702_445#	7.81736e-18
C521	a_27_74##12	a_206_368##5	4.4514e-17
C522	Q#2	a_1000_424##4	1.22883e-19
C523	a_27_74##4	a_702_445#	7.81736e-18
C524	a_558_445##2	a_27_74##9	5.836e-19
C525	VGND#6	a_27_74##9	9.36306e-20
C526	VGND#9	a_27_74##13	2.67434e-17
C527	a_1290_102##19	a_1290_102##14	1.51513e-18
C528	a_753_284##3	a_717_102#	2.64619e-18
C529	a_558_445##2	a_206_368##4	5.4389e-18
C530	a_27_74##9	a_753_284#	2.94618e-19
C531	a_206_368#	a_717_102#	7.48763e-18
C532	VPWR#4	Q_N#1	3.66844e-17
C533	a_753_284##4	a_753_284##7	1.46868e-18
C534	a_27_74##13	a_558_445##3	1.88352e-17
C535	a_1290_102##16	VPWR#5	7.7113e-18
C536	a_1000_424##4	VPWR#7	2.26135e-17
C537	VGND#3	a_1835_368##2	3.66597e-19
C538	a_27_74##5	a_27_74##9	6.9174e-20
C539	Q_N	VPWR#2	1.62955e-17
C540	VPWR#9	a_1290_102##14	5.26207e-20
C541	a_27_74##15	CLK	1.98705e-17
C542	a_1835_368##8	Q_N	1.21164e-18
C543	VGND#5	a_1290_102##20	7.84658e-18
C544	VGND	a_1290_102##2	3.63254e-20
C545	a_27_74##8	a_1290_102##3	3.51493e-17
C546	a_753_284#	a_558_445##2	6.33859e-17
C547	VGND#3	a_1290_102##9	5.93478e-21
C548	a_1290_102##19	a_1000_424##4	5.14233e-17
C549	a_27_74##12	a_558_445##3	8.14277e-18
C550	a_27_74##5	a_558_445##2	1.99279e-17
C551	VGND#7	a_206_368##4	1.75753e-19
C552	VGND#3	a_1290_102##8	4.66456e-18
C553	a_1835_368##2	Q_N#1	6.88378e-20
C554	D	a_451_503##2	3.72817e-17
C555	VPWR#7	a_1000_424##3	6.80503e-19
C556	a_1835_368##10	VGND#4	4.46745e-17
C557	a_27_74##5	a_753_284#	2.92243e-17
C558	VGND#7	a_27_74##13	3.67198e-18
C559	VGND#1	a_1835_368#	2.67326e-17
C560	Q_N#3	a_1290_102##6	1.16337e-19
C561	a_1290_102##16	VPWR#6	1.86596e-18
C562	a_206_368##14	D	1.28702e-17
C563	VPWR#9	a_1000_424##4	1.89271e-19
C564	VGND#3	a_1290_102##6	8.56447e-20
C565	a_27_74##13	a_753_284##3	2.65703e-17
C566	a_1290_102##16	Q#2	5.82642e-17
C567	a_1000_424##6	a_1290_102#	1.42168e-17
C568	VPWR	VPWR#13	1.00616e-16
C569	VPWR#10	a_27_74##9	7.03945e-20
C570	a_1290_102##19	a_1000_424##3	4.54293e-17
C571	VPWR	VPWR#10	1.16515e-16
C572	D#4	a_27_74##5	7.9616e-19
C573	VPWR	VPWR#8	7.52686e-17
C574	VPWR#2	a_1835_368##4	2.3521e-18
C575	a_558_445##7	a_206_368##3	5.37503e-18
C576	Q_N#3	a_1835_368#	4.03254e-17
C577	VPWR#8	a_27_74##9	1.80832e-19
C578	a_1835_368##9	VPWR#4	7.52507e-17
C579	a_206_368##5	a_27_74##8	1.84102e-18
C580	a_206_368##7	a_1290_102##16	1.87093e-18
C581	a_206_368##7	a_1208_479#	4.76396e-19
C582	a_27_74##12	a_753_284##3	3.39556e-19
C583	a_27_74##14	a_206_368#	6.89425e-19
C584	a_1000_424##3	VPWR#9	1.29233e-17
C585	CLK	a_27_74##19	1.87711e-17
C586	a_206_368##2	a_27_74##5	9.27492e-19
C587	VGND#3	VGND#1	5.37613e-17
C588	VGND#12	VGND#4	4.81038e-18
C589	Q_N#3	Q_N	3.16284e-18
C590	VPWR	a_1000_424##6	9.74155e-18
C591	a_451_503##2	a_206_368##3	2.27877e-18
C592	VGND#1	a_1835_368##5	1.34033e-18
C593	a_206_368##2	D#4	4.75351e-17
C594	VGND#7	a_558_445##2	2.78562e-20
C595	a_1290_102##19	a_1290_102##4	3.47793e-18
C596	a_1835_368##2	VNB	3.80586e-17
C597	a_1290_102##9	VNB	2.07454e-17
C598	a_1290_102##8	VNB	6.48334e-17
C599	a_1290_102##6	VNB	2.50441e-17
C600	VGND#4	a_1835_368#	7.92936e-19
C601	VGND#3	Q_N#3	2.08479e-17
C602	D	a_451_503#	2.34143e-17
C603	a_1290_102##2	VNB	3.2439e-17
C604	VGND#7	a_27_74##12	6.47642e-17
C605	a_206_368##2	D#2	3.67051e-17
C606	a_27_74##13	a_206_368#	6.33512e-17
C607	VGND	VGND#9	7.79296e-17
C608	VPWR	a_206_368##9	5.87541e-17
C609	a_206_368##11	D	3.21795e-18
C610	VPWR#5	VPWR#4	5.50879e-18
C611	VGND	VGND#7	1.0174e-16
C612	VGND	VGND#6	6.99145e-17
C613	a_1000_424##6	a_206_368##7	5.58697e-17
C614	a_1290_102##16	VPWR#7	4.71198e-17
C615	a_1290_102##6	a_1835_368##6	3.67146e-19
C616	VPWR#10	VPWR#11	6.06645e-18
C617	Q_N#3	a_1835_368##5	3.87526e-17
C618	VPWR#9	a_1290_102##4	3.05112e-17
C619	a_27_74##2	a_206_368##2	4.82293e-17
C620	VPWR#2	a_1835_368##6	7.82139e-18
C621	a_558_445##3	a_206_368##5	1.63366e-17
C622	VGND#12	a_1835_368##10	4.18064e-17
C623	Q_N	VPWR#1	6.57639e-17
C624	a_1290_102##19	a_206_368##6	1.69921e-19
C625	a_27_74##12	a_206_368#	1.20019e-19
C626	a_27_74##14	a_27_74##6	1.0597e-18
C627	VGND#1	a_1290_102##5	2.29685e-19
C628	Q_N	Q_N#1	4.90344e-19
C629	VGND#3	a_1835_368##10	2.09523e-17
C630	a_1290_102##17	a_1290_102##19	9.00351e-19
C631	VPWR#4	Q_N	4.91491e-17
C632	a_1835_368##8	a_1835_368##4	5.28102e-20
C633	VGND	a_1000_424##6	1.03534e-17
C634	CLK#2	a_27_74##2	7.54694e-17
C635	VPWR#5	a_1835_368##9	1.8689e-17
C636	a_1835_368##5	VGND#4	1.99528e-17
C637	VGND	a_27_74##14	2.47884e-17
C638	a_1835_368##8	Q_N#3	6.5373e-19
C639	VGND	a_27_74##13	5.44806e-17
C640	VGND#3	VGND#12	2.04866e-17
C641	VGND	a_27_74##12	3.74623e-17
C642	VPWR	a_753_284##4	7.70279e-19
C643	VPWR#9	a_206_368##6	2.65917e-18
C644	D	a_206_368#	8.49273e-19
C645	D	a_27_74##6	7.9894e-20
C646	VGND#6	a_27_74##12	7.22922e-18
C647	VPWR	a_558_445##7	1.91144e-18
C648	a_27_74##13	a_27_74##6	8.72781e-18
C649	a_1000_424##7	a_1290_102##4	3.28472e-20
C650	Q	a_1000_424#	6.65891e-20
C651	D	a_27_74#	1.8086e-19
C652	Q_N#3	a_1290_102##5	1.28991e-18
C653	a_1000_424##6	VPWR#8	1.61295e-18
C654	VGND#3	Q#1	2.49781e-17
C655	a_1000_424##6	a_27_74##7	4.14797e-19
C656	VGND#9	VNB	3.4255e-17
C657	VGND#7	VNB	5.62416e-17
C658	VGND#6	VNB	5.87505e-17
C659	VGND#5	VNB	3.14695e-17
C660	VGND#2	VNB	3.63686e-17
C661	a_1835_368##10	a_1835_368##5	1.02593e-18
C662	VPWR#10	a_558_445##2	9.34539e-19
C663	VGND#1	a_1290_102##12	2.19763e-19
C664	VPWR#13	VNB	5.28103e-17
C665	a_753_284##3	a_558_445##3	1.91607e-17
C666	VPWR#10	VNB	6.61415e-17
C667	VPWR#8	VNB	6.26258e-17
C668	VGND#3	VGND#13	2.06783e-17
C669	VPWR#6	VNB	3.20613e-17
C670	VPWR#2	VNB	3.50241e-17
C671	VPWR#2	a_1290_102##11	4.78179e-18
C672	a_27_74##14	D#3	1.61388e-17
C673	VPWR#9	a_27_74##10	2.67635e-19
C674	a_1835_368##8	VNB	3.62774e-18
C675	VPWR	a_1000_424##7	8.56717e-18
C676	VPWR	a_753_284##7	4.80769e-18
C677	a_1290_102##17	VNB	6.13049e-18
C678	VGND	a_1000_424##5	8.4952e-18
C679	a_1290_102##5	VGND#4	2.39226e-17
C680	a_1290_102##16	VNB	2.35323e-18
C681	a_206_368##6	a_1000_424##7	1.83812e-17
C682	VGND	a_753_284##4	4.84177e-18
C683	VGND	VGND#15	1.67233e-17
C684	a_1000_424##6	VNB	1.7951e-17
C685	a_1835_368##8	a_1835_368##6	1.3712e-19
C686	VPWR	a_558_445##5	1.03119e-17
C687	VGND	a_558_445##7	1.09783e-17
C688	VGND#3	a_1290_102##20	1.50292e-17
C689	VPWR	a_451_503#	6.80977e-18
C690	VGND	a_451_503##2	9.0889e-18
C691	a_27_74##14	VNB	4.39989e-19
C692	VGND	VGND#16	1.66899e-17
C693	a_27_74##13	VNB	2.51243e-17
C694	VGND	a_206_368##14	5.12467e-18
C695	VPWR	a_206_368##11	5.34281e-17
C696	a_27_74##12	VNB	7.70377e-18
C697	Q	a_1290_102##13	9.77367e-19
C698	VGND	VGND#17	2.16876e-17
C699	a_1835_368##8	VGND#4	1.78698e-18
C700	VGND	a_27_74##15	1.83731e-17
C701	Q	a_1290_102##14	2.91947e-18
C702	VPWR	a_27_74##19	1.8986e-17
C703	VGND#12	a_1835_368##5	8.15693e-19
C704	a_206_368#	a_558_445##3	1.6995e-18
C705	a_206_368##9	VNB	1.91171e-17
C706	a_27_74##13	D#3	6.94702e-18
C707	a_1290_102##6	a_1835_368##10	3.50314e-19
C708	Q_N	a_1835_368##4	2.27568e-17
C709	Q#1	VGND#12	7.49034e-17
C710	VPWR#6	a_1290_102##9	5.16772e-20
C711	Q_N	a_1835_368##6	2.14002e-17
C712	a_1835_368##10	a_1290_102##5	2.282e-17
C713	VGND#1	VNB	6.8587e-17
C714	a_558_445##7	a_558_445##5	2.595e-18
C715	VPWR#9	a_558_445#	9.99564e-20
C716	a_1000_424##6	a_27_74##9	9.53151e-17
C717	Q_N#3	VNB	9.88893e-18
C718	Q_N	a_1290_102##11	1.09041e-18
C719	VGND#4	VNB	7.28922e-18
C720	a_1835_368##10	VNB	3.61334e-18
C721	Q_N	a_1290_102##13	5.09732e-20
C722	VGND#12	VNB	1.35293e-17
C723	a_27_74##10	a_1000_424##7	1.19182e-17
C724	Q#1	VNB	4.97718e-18
C725	VGND#13	VNB	3.27277e-18
C726	a_1290_102##20	VNB	1.03927e-17
C727	VPWR	a_206_368#	6.34122e-19
C728	VGND#14	VNB	1.05999e-17
C729	a_206_368#	a_753_284##3	3.61363e-17
C730	a_1000_424##5	VNB	2.15038e-18
C731	VGND	a_206_368##11	2.74277e-18
C732	a_753_284##4	VNB	3.1021e-18
C733	VGND#15	VNB	1.30722e-18
C734	VGND	a_27_74##19	4.89012e-18
C735	VGND#4	a_1290_102##12	6.73777e-19
C736	a_558_445##7	VNB	7.83957e-18
C737	VPWR#10	a_753_284#	4.79164e-19
C738	a_1835_368##3	Q_N#3	2.17535e-17
C739	a_27_74##14	a_27_74#	1.81001e-17
C740	a_451_503##2	VNB	7.99884e-18
C741	VGND#16	VNB	2.87986e-18
C742	a_206_368##14	VNB	5.83803e-18
C743	VGND#17	VNB	3.8828e-18
C744	VPWR#2	a_1290_102##13	1.64866e-19
C745	a_27_74##15	VNB	3.60708e-17
C746	VPWR#1	VNB	7.99925e-17
C747	a_27_74##12	a_27_74##7	1.04185e-17
C748	a_753_284##7	a_27_74##10	3.3362e-17
C749	VPWR#2	a_1835_368##2	4.5102e-20
C750	VPWR#4	VNB	5.04742e-18
C751	VGND	a_1290_102##3	8.68922e-18
C752	a_1835_368##9	VNB	4.35785e-18
C753	VPWR#5	VNB	5.87323e-18
C754	VGND#12	a_1290_102##5	4.71209e-18
C755	Q#2	VNB	4.67182e-19
C756	VGND	a_206_368##5	5.9225e-18
C757	VPWR#7	VNB	8.40366e-19
C758	VGND	a_558_445##3	5.23644e-18
C759	a_1835_368##3	VGND#4	3.9682e-17
C760	a_1290_102##19	VNB	2.11146e-18
C761	a_1835_368##8	a_1290_102##11	6.88125e-19
C762	VGND	a_753_284##3	8.1228e-18
C763	VPWR#9	VNB	3.72369e-18
C764	VGND#12	a_1290_102##8	6.80217e-18
C765	VPWR	a_1290_102##4	4.39864e-18
C766	VPWR#7	VPWR#5	1.24684e-17
C767	VGND	a_206_368#	1.60864e-17
C768	a_1000_424##7	VNB	9.68071e-18
C769	Q	a_1290_102##7	3.63142e-17
C770	a_753_284##7	VNB	4.27597e-18
C771	VPWR#8	a_1290_102##14	2.03253e-19
C772	VGND	D#3	9.01325e-19
C773	VPWR	a_27_74##10	6.78238e-18
C774	a_206_368##9	a_206_368##7	4.57384e-18
C775	VGND	a_27_74#	3.63086e-18
C776	VPWR#3	Q_N	2.18977e-17
C777	a_1000_424##2	Q	1.51821e-18
C778	VPWR	a_558_445#	4.96275e-19
C779	a_206_368##9	a_206_368#	3.91639e-19
C780	a_558_445##5	VNB	1.79005e-18
C781	VGND	CLK#3	9.16243e-19
C782	a_451_503#	a_558_445##7	2.73606e-17
C783	a_451_503#	VNB	2.76224e-18
C784	VGND#3	Q_N	1.54667e-18
C785	VGND#13	VGND#12	3.11105e-18
C786	a_206_368##11	VNB	2.63233e-17
C787	VPWR	a_27_74##4	1.95021e-19
C788	a_1835_368##3	a_1835_368##2	2.99034e-18
C789	a_1835_368##10	a_1290_102##12	1.01505e-18
C790	VGND#13	a_1835_368##5	8.0954e-20
C791	VPWR#16	VNB	1.38553e-18
C792	VPWR	a_206_368##3	1.73531e-21
C793	a_27_74##19	VNB	5.95081e-17
C794	a_1835_368#	VNB	3.37413e-17
C795	VPWR	D#1	7.59807e-18
C796	a_1835_368##5	VNB	3.10625e-17
C797	a_1835_368##3	Q_N	2.92545e-17
C798	a_1290_102##5	VNB	4.05116e-17
C799	VPWR	a_27_74##3	3.60238e-18
C800	D	a_27_74##5	2.02123e-19
C801	a_1290_102##12	VNB	3.52566e-17
C802	VGND#9	D#4	3.35038e-19
C803	VPWR	CLK#1	1.56054e-18
C804	a_1290_102##10	VNB	3.06192e-17
C805	a_1000_424#	VNB	3.71545e-17
C806	D	D#4	1.9927e-17
C807	a_1290_102##3	VNB	2.65775e-17
C808	VGND#6	VGND#5	1.1342e-18
C809	a_27_74##8	VNB	2.03773e-17
C810	a_206_368##4	a_1000_424##6	3.33658e-17
C811	D	D#2	1.2088e-18
C812	a_206_368##5	VNB	2.35844e-17
C813	CLK	CLK#2	1.07885e-17
C814	a_558_445##3	VNB	4.00277e-17
C815	VGND	a_27_74##10	9.87325e-20
C816	VPWR#6	a_1290_102##14	4.01161e-18
C817	Q#1	a_1290_102##5	2.11939e-19
C818	a_753_284##3	VNB	2.49826e-17
C819	a_753_284##7	a_558_445#	2.7868e-17
C820	VPWR	VPWR#12	6.56219e-17
C821	D	a_206_368##2	6.28186e-17
C822	a_206_368#	VNB	1.23411e-16
C823	a_27_74##6	VNB	4.21718e-17
C824	D#3	VNB	2.88129e-17
C825	D	a_27_74##2	4.46637e-19
C826	a_206_368#	a_27_74##6	3.74327e-17
C827	a_27_74#	VNB	3.07935e-17
C828	VGND	a_206_368##3	4.43721e-19
C829	CLK#3	VNB	3.90019e-17
C830	a_1835_368##4	VNB	4.39701e-17
C831	a_1835_368##6	VNB	3.58327e-17
C832	a_1290_102##11	VNB	4.03785e-17
C833	a_27_74##14	CLK#3	1.52662e-18
C834	a_1290_102##13	VNB	3.31504e-17
C835	VPWR	a_206_368##7	1.6303e-17
C836	a_1290_102##14	VNB	3.62481e-17
C837	a_1000_424##4	VNB	2.94005e-17
C838	a_1290_102##12	VGND#12	3.23375e-17
C839	a_1000_424##3	VNB	3.62535e-17
C840	VPWR	a_27_74##9	4.22246e-18
C841	a_1290_102##4	VNB	4.29409e-17
C842	Q#1	a_1290_102##9	3.28442e-18
C843	a_27_74##12	a_27_74##9	6.56458e-18
C844	a_206_368##6	VNB	2.39816e-17
C845	VGND	VGND#8	5.7394e-17
C846	VPWR	a_206_368##4	1.62397e-18
C847	a_27_74##10	VNB	6.0613e-17
C848	a_558_445#	VPWR#11	1.04307e-17
C849	a_558_445#	VNB	4.08095e-17
C850	VPWR	a_558_445##2	7.10657e-18
C851	a_753_284##2	VNB	3.73548e-17
C852	VPWR	a_753_284#	2.88289e-18
C853	a_27_74##4	VNB	2.44022e-17
C854	a_206_368##3	VNB	6.73875e-17
C855	VGND	a_1290_102#	1.01711e-19
C856	VPWR	a_27_74##5	5.8078e-18
C857	D#1	VNB	3.51566e-17
C858	a_27_74##3	VNB	3.93116e-17
C859	VGND#13	Q#1	7.49151e-17
C860	CLK#1	VNB	4.21106e-17
C861	VGND	a_27_74##7	2.98808e-17
C862	VPWR	D#2	6.64096e-18
C863	VGND	a_27_74##9	2.61478e-18
C864	VGND#13	a_1290_102##5	7.20139e-20
C865	VPWR#3	VNB	2.41632e-16
C866	VPWR	a_206_368##2	7.10203e-18
C867	a_206_368#	D#3	1.91969e-17
C868	VGND	a_206_368##4	6.50052e-18
C869	a_1290_102##6	a_1835_368##3	3.55267e-17
C870	a_1835_368##8	a_1290_102##13	2.5087e-20
C871	VGND#3	VNB	2.4902e-16
C872	VPWR#12	VNB	3.52017e-17
C873	VGND	a_558_445##2	2.50128e-18
C874	VPWR	a_27_74##2	3.73478e-18
C875	VGND#8	VNB	2.63534e-17
C876	VGND	a_753_284#	4.57905e-18
C877	VPWR	CLK#2	1.60385e-18
C878	a_753_284##7	a_753_284##2	4.30167e-19
C879	a_1835_368##3	VNB	4.27906e-17
C880	VGND	a_27_74##5	2.52175e-18
C881	a_1290_102##7	VNB	1.53083e-17
C882	a_1000_424##2	VNB	6.47856e-17
C883	VGND	D#4	1.63068e-18
C884	VPWR#8	a_1000_424##4	9.37438e-19
C885	a_1290_102#	VNB	4.28888e-17
C886	a_206_368##7	VNB	4.29876e-17
C887	VGND#12	a_1835_368##8	2.95939e-18
C888	VGND	a_206_368##2	4.60831e-18
C889	a_27_74##7	VNB	7.67062e-17
C890	a_27_74##9	VNB	6.78501e-17
C891	VGND	a_27_74##2	1.56672e-19
C892	VPWR#13	VPWR#14	8.30665e-18
C893	a_206_368##4	VNB	2.83477e-17
C894	VGND	CLK#2	2.16344e-18
C895	a_1290_102##6	a_1835_368##9	3.51631e-19
C896	a_558_445##2	VNB	5.64942e-17
C897	Q#1	a_1290_102##12	4.58331e-17
C898	a_753_284#	VNB	6.03079e-17
C899	a_27_74##5	VNB	5.52148e-17
C900	a_1290_102##7	VGND#12	3.38621e-17
C901	D#4	VNB	2.49845e-17
C902	D#2	VNB	3.98003e-17
C903	a_206_368##2	VNB	1.51895e-16
C904	a_1000_424##6	VPWR#9	6.40353e-18
C905	a_27_74##2	VNB	4.00501e-17
C906	a_1000_424##6	a_558_445##2	7.48306e-20
C907	CLK#2	VNB	4.74826e-17
C908	a_753_284##2	VPWR#11	9.94244e-18
C909	D#3	a_27_74##6	3.73242e-17
C910	a_27_74##13	a_206_368##4	3.03963e-19
C911	VPWR#6	a_1000_424##4	5.5296e-18
C912	VGND#12	a_1290_102##10	1.34022e-18
C913	a_558_445##5	a_558_445#	6.30017e-20
C914	Q#1	a_1290_102##8	3.57821e-18
C915	VPWR	CLK	1.49208e-18
C916	Q#1	a_1290_102##7	2.27037e-18
C917	VPWR	D	2.46339e-18
C918	a_1290_102##16	a_1290_102##11	7.77332e-20
C919	VGND	CLK	1.71153e-18
C920	VGND	D	5.60903e-18
C921	CLK	VNB	2.01323e-17
C922	D	VNB	1.39035e-18
C923	a_27_74##12	a_206_368##4	1.41663e-17
C924	a_1290_102##14	a_1290_102##8	4.12857e-18
C925	Q	VNB	8.80615e-19
C926	Q_N	VNB	1.09149e-17
C927	VGND#13	a_1290_102##12	2.71044e-18
C928	VPWR	VNB	3.13281e-16
C929	VGND	VNB	2.97518e-16
C930	VGND#10	a_27_74##15	2.1475e-17
C931	VPWR#15	CLK#2	9.98517e-20
C932	VGND	VGND#10	9.14122e-17
C933	VGND#10	CLK#3	5.31651e-18
C934	a_27_74##19	VPWR#15	2.10557e-17
C935	VGND#10	VGND#9	1.26264e-19
C936	a_27_74##2	VPWR#15	4.20645e-19
C937	VGND#10	a_27_74##14	4.61827e-18
C938	VPWR#15	VPWR#13	9.30688e-19
C939	VPWR	VPWR#15	9.6206e-17
C940	VGND#10	VNB	5.41542e-17
C941	VPWR#15	CLK#1	5.40444e-18
C942	VGND#10	CLK#2	1.88897e-19
C943	VGND#10	a_27_74#	5.73496e-18
C944	VGND#10	a_206_368##2	1.8897e-19
C945	a_206_368##11	VPWR#15	7.98064e-18
C946	VPWR#15	VNB	4.76907e-17
C947	VPWR#15	a_27_74##3	6.34033e-18
*
*
.ENDS sky130_fd_sc_hs__dfxbp_2
*
