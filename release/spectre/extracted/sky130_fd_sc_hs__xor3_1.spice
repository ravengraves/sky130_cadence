* Extracted by Quantus, converted by sky130cad/quantus.py
*
*
*
*                       LINUX           Wed Nov 18 09:15:26 2026
*
*
*
*  PROGRAM  advgen
*
*  Name           : advgen - Quantus - (64-bit)
*  Version        : 25.1.0-p047
*  Build Date     : Thu Dec 11 23:20:30 PST 2025
*
*  HSPICE LIBRARY
*
*  OPERATING_TEMPERATURE 150
*  QRC_TECH_DIR <path>/tech
*
*
*

*
.SUBCKT sky130_fd_sc_hs__xor3_1 VNB VPB VGND VPWR X A C B
*
*
*  caps2d version: 10
*
*
*       TRANSISTOR CARDS
*
*
XM17 a_27_134##3 a_84_108##3 VGND#10 VNB sky130_fd_pr__nfet_01v8_lvt l=0.15 w=0.64 ad=0.1824 as=0.6949 pd=1.85 ps=3.62
XM8 VGND#10 A#1 a_84_108##11 VNB sky130_fd_pr__nfet_01v8_lvt l=0.15 w=0.64 ad=0.6949 as=0.3404 pd=3.62 ps=2.82
XM6 a_84_108##11 B#9 a_416_86# VNB sky130_fd_pr__nfet_01v8_lvt l=0.15 w=0.64 ad=0.3404 as=0.2075 pd=2.82 ps=1.98
XM2 a_416_86# a_452_288##7 a_27_134# VNB sky130_fd_pr__nfet_01v8_lvt l=0.15 w=0.42 ad=0.2075 as=0.3163 pd=1.98 ps=2.32
XM0 a_27_134# B#11 a_384_392##4 VNB sky130_fd_pr__nfet_01v8_lvt l=0.15 w=0.64 ad=0.3163 as=0.33815 pd=2.32 ps=2.55
XM14 a_384_392##4 a_452_288# a_84_108##4 VNB sky130_fd_pr__nfet_01v8_lvt l=0.15 w=0.64 ad=0.33815 as=0.2848 pd=2.55 ps=2.17
XM1 a_452_288##9 B#1 VGND#9 VNB sky130_fd_pr__nfet_01v8_lvt l=0.15 w=0.74 ad=0.2035 as=0.3885 pd=2.03 ps=2.53
XM12 a_384_392##2 a_1157_298# a_1215_396##5 VNB sky130_fd_pr__nfet_01v8_lvt l=0.15 w=0.64 ad=0.176 as=0.3392 pd=1.83 ps=2.34
XM18 a_1215_396##5 C#7 a_416_86##4 VNB sky130_fd_pr__nfet_01v8_lvt l=0.15 w=0.64 ad=0.3392 as=0.24 pd=2.34 ps=2.03
XM15 a_1157_298##7 C#1 VGND#8 VNB sky130_fd_pr__nfet_01v8_lvt l=0.15 w=0.42 ad=0.1197 as=0.2424 pd=1.41 ps=2.2
XM7 VGND#8 a_1215_396# X#3 VNB sky130_fd_pr__nfet_01v8_lvt l=0.15 w=0.74 ad=0.2424 as=0.2109 pd=2.2 ps=2.05
XM20 a_27_134##6 a_84_108# VPWR#10 VPB sky130_fd_pr__pfet_01v8 l=0.15 w=1 ad=0.295 as=0.5 pd=2.59 ps=3
XM21 VPWR#10 A#4 a_84_108##7 VPB sky130_fd_pr__pfet_01v8 l=0.15 w=1 ad=0.5 as=0.3674 pd=3 ps=2.77
XM9 a_84_108##7 B#5 a_384_392##6 VPB sky130_fd_pr__pfet_01v8 l=0.15 w=0.84 ad=0.3674 as=0.2802 pd=2.77 ps=2.39
XM11 a_384_392##6 a_452_288##5 a_27_134##5 VPB sky130_fd_pr__pfet_01v8 l=0.15 w=0.64 ad=0.2802 as=0.2048 pd=2.39 ps=1.92
XM3 a_27_134##5 B#10 a_416_86##3 VPB sky130_fd_pr__pfet_01v8 l=0.15 w=0.64 ad=0.2048 as=0.30135 pd=1.92 ps=2.45
XM16 a_416_86##3 a_452_288##6 a_84_108##5 VPB sky130_fd_pr__pfet_01v8 l=0.15 w=0.84 ad=0.30135 as=0.5082 pd=2.45 ps=2.89
XM4 a_452_288##8 B#6 VPWR#9 VPB sky130_fd_pr__pfet_01v8 l=0.15 w=1.12 ad=0.3304 as=0.3304 pd=2.83 ps=2.83
XM10 a_416_86##6 a_1157_298##3 a_1215_396##7 VPB sky130_fd_pr__pfet_01v8 l=0.15 w=0.84 ad=0.3192 as=0.5082 pd=2.44 ps=2.89
XM5 a_1215_396##7 C#5 a_384_392# VPB sky130_fd_pr__pfet_01v8 l=0.15 w=0.84 ad=0.5082 as=0.2982 pd=2.89 ps=2.39
XM19 a_1157_298##5 C#6 VPWR#8 VPB sky130_fd_pr__pfet_01v8 l=0.15 w=0.64 ad=0.2528 as=0.4872 pd=2.07 ps=3.32
XM13 VPWR#8 a_1215_396##4 X#1 VPB sky130_fd_pr__pfet_01v8 l=0.15 w=1.12 ad=0.4872 as=0.3304 pd=3.32 ps=2.83
*
*
*       RESISTOR AND CAP/DIODE CARDS
*
Rg1	a_84_108#	a_84_108##2	400.207520
Rg2	a_84_108##2	a_84_108##3	307.937683
Rg3	A#1	A#2	294.260559
Rg4	A#2	A#3	18.784607
Rg5	A#2	A#4	437.431122
Rg6	a_452_288#	a_452_288##2	292.048431
Rg7	a_452_288##2	a_452_288##3	227.451706
Rg8	a_452_288##3	a_452_288##4	446.103638
Rg9	a_452_288##4	a_452_288##5	410.448517
Rg10	a_452_288##3	a_452_288##6	389.204681
Rg11	a_452_288##4	a_452_288##7	341.709442
Rg12	B#1	B#2	397.590515
Rg13	B#2	B#3	248.714600
Rg14	B#3	B#4	1855.137939
Rg15	B#4	B#5	889.127991
Rg16	B#2	B#6	449.490784
Rg17	B#2	B#7	36.508282
Rg18	B#3	B#8	1379.773804
Rg19	B#8	B#9	926.559204
Rg20	B#4	B#10	405.772644
Rg21	B#8	B#11	291.395142
Rg22	a_1157_298#	a_1157_298##2	378.202026
Rg23	a_1157_298##2	a_1157_298##3	350.996918
Rg24	C#1	C#2	450.942902
Rg25	C#2	C#3	401.350433
Rg26	C#3	C#4	38.488544
Rg27	C#4	C#5	501.112396
Rg28	C#2	C#6	380.493225
Rg29	C#4	C#7	394.682556
Rg30	a_1215_396#	a_1215_396##2	423.145813
Rg31	a_1215_396##2	a_1215_396##3	20.753328
Rg32	a_1215_396##2	a_1215_396##4	503.938385
Rf1	A#5	A	0.872686
Rf2	A#3	A#7	161.105484
Rf3	A#5	A#7	11.583416
Rf4	a_27_134#	a_27_134##2	44.158669
Rf5	a_27_134##2	a_27_134##4	197.355804
Rf6	a_27_134##2	a_27_134##5	49.458439
Rf7	a_27_134##4	a_27_134##6	108.242973
Rf8	a_27_134##3	a_27_134##4	7.500000
Rf9	a_416_86#	a_416_86##2	161.963425
Rf10	a_416_86##2	a_416_86##3	41.833874
Rf11	a_84_108##4	a_84_108##6	91.075768
Rf12	a_84_108##6	a_84_108##8	227.067490
Rf13	a_84_108##8	a_84_108##9	21.026392
Rf14	a_84_108##9	a_84_108##2	227.744476
Rf15	a_84_108##9	a_84_108##11	76.613625
Rf16	a_84_108##5	a_84_108##6	7.500000
Rf17	a_84_108##7	a_84_108##8	5.000000
Rf18	a_452_288##8	a_452_288##10	113.756302
Rf19	a_452_288##10	a_452_288##2	285.265625
Rf20	a_452_288##9	a_452_288##10	15.000000
Rf21	B#12	B#7	160.920410
Rf22	B	B#14	0.687606
Rf23	B#12	B#14	5.905091
Rf24	a_1215_396##5	a_1215_396##6	52.273144
Rf25	a_1215_396##6	a_1215_396##7	33.615555
Rf26	C	C#8	1.046777
Rf27	C#9	C#3	161.279587
Rf28	C#8	C#9	8.857635
Rf29	a_416_86##4	a_416_86##5	178.710419
Rf30	a_416_86##5	a_416_86##6	42.655556
Rf31	a_384_392#	a_384_392##3	301.350647
Rf32	a_384_392##3	a_384_392##5	247.887527
Rf33	a_384_392##5	a_384_392##6	242.878830
Rf34	a_384_392##2	a_384_392##3	15.000000
Rf35	a_384_392##4	a_384_392##5	7.500000
Rf36	a_1157_298##2	a_1157_298##6	394.937500
Rf37	a_1157_298##6	a_1157_298##7	139.203033
Rf38	a_1157_298##5	a_1157_298##6	15.000000
Rf39	a_1215_396##8	a_1215_396##3	166.137894
Rf40	X	X#2	0.255814
Rf41	X#2	X	18.674389
Rf42	X	X#4	6.906965
Rf43	X#4	X	12.023236
Rf44	X#1	X#2	5.000000
Rf45	X#3	X#4	7.500000
Rf47	VGND#2	VGND#3	35.770210
Rf48	VGND#3	VGND#4	181.198044
Rf49	VGND#4	VGND#5	151.977844
Rf50	VGND#5	VGND#6	178.932251
Rf52	VGND#2	VGND#8	35.274624
Rf53	VGND#4	VGND#9	37.027283
Rf54	VGND#6	VGND#10	20.597172
Rf56	VPWR#2	VPWR#3	34.309200
Rf57	VPWR#3	VPWR#4	207.861481
Rf58	VPWR#4	VPWR#5	125.314415
Rf59	VPWR#5	VPWR#6	177.122910
Rf61	VPWR#2	VPWR#8	35.727165
Rf62	VPWR#4	VPWR#9	44.934231
Rf63	VPWR#6	VPWR#10	32.125244
Re1	a_416_86##5	a_416_86##2	23.476074
Re2	a_1215_396##8	a_1215_396##6	22.652748
Re3	VPWR#3	VPWR	3.246228
Re4	VPWR	VPWR#5	1.159367
Re5	VGND#3	VGND	3.246228
Re6	VGND	VGND#5	1.159367
*
*       CAPACITOR CARDS
*
*
C1	a_84_108##5	VPWR#9	2.05918e-18
C2	a_452_288##8	B#4	1.21484e-19
C3	A#5	A#1	8.13937e-18
C4	a_1157_298##7	C#4	9.80555e-21
C5	B#8	B#3	6.83568e-19
C6	a_84_108##4	B#1	7.85099e-19
C7	a_384_392##2	B#11	9.4663e-20
C8	a_84_108##5	a_452_288##8	8.7712e-17
C9	a_452_288##9	a_452_288#	4.19289e-19
C10	a_452_288##8	B#3	2.01942e-17
C11	B#7	B#3	4.09151e-20
C12	a_384_392##4	B#1	1.22387e-19
C13	A#5	a_84_108##3	3.2003e-18
C14	B#14	B#6	1.28987e-18
C15	a_1157_298##7	C#2	1.97968e-17
C16	B#7	B#2	1.23526e-17
C17	a_452_288#	a_84_108##4	1.32147e-17
C18	a_452_288##8	B#2	7.31473e-18
C19	a_84_108##5	B#8	4.50447e-20
C20	a_452_288#	a_384_392##4	2.04496e-17
C21	a_84_108##5	B#4	4.35159e-17
C22	C#4	a_416_86##4	7.841e-18
C23	B#4	B#3	3.46669e-19
C24	B#8	a_452_288##2	2.5415e-18
C25	B#11	a_384_392##4	1.89755e-17
C26	a_452_288##2	B#4	2.88822e-18
C27	a_84_108##5	B#3	3.48394e-17
C28	a_416_86#	a_452_288#	3.29788e-19
C29	a_452_288##2	B#3	3.12491e-17
C30	a_384_392#	a_1215_396#	8.30909e-19
C31	B#11	a_27_134#	2.13022e-17
C32	a_27_134##5	a_416_86##3	4.28017e-17
C33	a_452_288##4	a_452_288##2	2.35024e-19
C34	a_384_392##6	a_84_108##5	1.08262e-16
C35	a_384_392##4	a_452_288##7	4.18922e-20
C36	a_84_108##5	B#2	6.99414e-20
C37	a_452_288##3	a_452_288##2	9.25911e-18
C38	a_416_86##6	VPWR#4	1.53362e-17
C39	a_416_86#	B#11	1.43671e-17
C40	a_384_392#	C#1	6.84637e-18
C41	a_27_134#	a_452_288##7	1.02137e-17
C42	a_384_392##6	a_416_86##3	3.40861e-17
C43	a_84_108##5	a_452_288##4	1.67442e-20
C44	a_416_86##3	B#4	9.56558e-19
C45	a_1215_396##5	C#4	1.09097e-18
C46	B#8	a_452_288##4	1.05191e-18
C47	a_452_288##7	a_416_86#	1.90421e-17
C48	a_384_392#	C#7	3.95698e-18
C49	a_384_392##6	a_27_134##5	7.87138e-17
C50	a_27_134#	B#9	7.47518e-19
C51	a_84_108##5	a_452_288##3	2.59763e-19
C52	a_84_108##11	a_452_288##7	1.06147e-19
C53	a_1215_396##5	C#2	8.17282e-20
C54	a_384_392#	a_1157_298#	7.4084e-19
C55	B#9	a_416_86#	2.95325e-17
C56	A#3	a_452_288##4	3.16198e-18
C57	B#4	B#6	5.90984e-18
C58	a_416_86##4	B#3	5.13408e-20
C59	B#9	a_84_108##11	1.98295e-17
C60	B#3	B#6	3.93555e-17
C61	a_84_108##7	a_384_392##6	9.9515e-17
C62	a_416_86#	A#1	1.59366e-18
C63	a_452_288##8	VPWR#4	1.05539e-17
C64	a_27_134##5	B#4	4.01004e-19
C65	B#3	B#2	8.52618e-18
C66	a_384_392##2	C#4	2.629e-18
C67	a_452_288##4	B#4	3.64551e-19
C68	C#9	C#4	1.38081e-17
C69	B#8	a_452_288##3	1.74571e-18
C70	a_84_108##9	a_452_288##5	1.18697e-18
C71	A#1	a_84_108##11	1.44099e-17
C72	a_27_134##3	B#9	5.67319e-19
C73	a_1215_396##6	VPWR#4	7.24693e-19
C74	a_416_86#	a_84_108##3	5.98706e-19
C75	A#1	VGND#10	1.90748e-17
C76	VPWR#10	a_84_108##7	4.94548e-17
C77	VGND#3	VGND#4	1.70019e-18
C78	a_84_108##11	a_84_108##3	1.91378e-18
C79	a_84_108##2	a_452_288##4	1.85091e-20
C80	a_84_108##5	VPWR#4	5.98112e-18
C81	C#9	C#2	1.86888e-19
C82	B#4	a_452_288##6	1.74814e-17
C83	a_84_108##9	B#5	6.02057e-18
C84	a_27_134##3	A#1	3.33484e-17
C85	a_84_108##3	VGND#10	1.67139e-17
C86	a_452_288##6	B#3	8.08213e-18
C87	a_416_86##5	VPWR#4	6.09655e-18
C88	a_27_134##5	a_452_288##4	9.21697e-19
C89	a_384_392##6	B#4	3.99779e-18
C90	a_27_134##3	a_84_108##3	5.04085e-17
C91	a_27_134##6	VPWR#10	6.43109e-17
C92	a_452_288##3	B#4	7.2439e-19
C93	C#8	C#4	5.96267e-18
C94	a_84_108##9	A#4	2.21454e-17
C95	a_452_288##4	a_452_288##6	2.25554e-19
C96	a_27_134##5	a_452_288##3	3.58721e-20
C97	a_384_392##6	B#3	3.28419e-19
C98	a_27_134##2	B#5	1.03529e-17
C99	a_416_86##2	VPWR#4	5.21496e-19
C100	C#8	C#2	2.87372e-19
C101	a_84_108##9	a_84_108#	3.31291e-19
C102	a_416_86##5	VGND#4	1.61654e-18
C103	a_384_392##2	B#3	1.10637e-18
C104	a_384_392##6	a_452_288##4	4.41549e-19
C105	a_84_108##7	B#4	6.83419e-18
C106	a_452_288##3	B#3	4.60722e-20
C107	VPWR#5	VPWR#4	1.36618e-16
C108	a_384_392##2	B#2	3.23896e-18
C109	a_452_288##4	B#10	1.04103e-17
C110	a_384_392##6	a_452_288##3	6.88063e-19
C111	VPWR#8	a_1215_396##4	7.07283e-17
C112	C#1	a_1215_396#	2.55539e-17
C113	a_1157_298##7	VGND#8	6.41428e-17
C114	a_1157_298##5	a_1215_396##4	7.38175e-18
C115	VGND#3	C#8	1.37037e-18
C116	C#6	VPWR#8	1.35743e-17
C117	a_452_288##5	B#4	6.5209e-18
C118	a_384_392##4	a_452_288##6	1.50343e-17
C119	a_384_392##6	B#11	7.7366e-19
C120	a_384_392#	a_1215_396##4	2.92574e-19
C121	C#7	C#1	3.22112e-18
C122	a_1157_298##5	C#6	5.10248e-17
C123	a_1215_396##6	C#9	3.90584e-17
C124	a_84_108##7	a_452_288##4	1.93912e-19
C125	a_452_288##9	B#8	1.91098e-18
C126	VPWR#8	C#5	4.88665e-19
C127	a_1215_396##6	C#8	3.29093e-18
C128	a_384_392##4	B#10	9.8489e-19
C129	a_384_392#	C#6	3.29198e-18
C130	a_1157_298##5	C#5	2.05142e-17
C131	a_27_134#	B#10	5.22135e-19
C132	a_384_392##6	B#9	2.80079e-18
C133	a_1157_298#	C#7	1.17756e-17
C134	a_384_392#	C#5	2.05293e-17
C135	VGND#5	VGND#4	1.33938e-16
C136	a_416_86#	B#10	7.98991e-19
C137	a_384_392##4	a_452_288##5	8.83161e-20
C138	C#9	a_384_392#	3.84519e-17
C139	a_84_108##7	B#9	5.59079e-19
C140	a_1157_298##5	a_1157_298##3	2.34026e-19
C141	a_1215_396##7	C#5	5.12237e-17
C142	B#5	B#4	7.63201e-19
C143	a_416_86##5	B#14	5.39702e-17
C144	a_452_288##9	B#3	3.16906e-17
C145	a_384_392##4	B#5	4.97033e-20
C146	C#8	a_384_392#	1.39786e-17
C147	a_84_108##4	B#8	1.50471e-18
C148	B#1	a_1157_298#	2.86138e-18
C149	a_1157_298##3	a_1215_396##7	3.36836e-17
C150	a_27_134##2	a_27_134#	2.76788e-19
C151	a_452_288##4	a_452_288##3	6.55554e-19
C152	a_1215_396##8	VGND#8	3.64648e-17
C153	a_452_288##9	B#2	6.11329e-18
C154	a_416_86##4	a_1215_396##5	3.42649e-17
C155	a_416_86##6	a_1157_298##3	1.67441e-17
C156	B#14	B#3	1.68908e-19
C157	a_416_86#	B#5	9.46123e-20
C158	a_1157_298##7	a_1215_396##8	1.34858e-17
C159	a_84_108##4	B#4	5.57168e-20
C160	a_27_134##3	a_84_108##9	1.25263e-18
C161	C#2	a_1215_396#	1.94109e-18
C162	VPWR#9	a_1157_298##3	2.23864e-18
C163	a_27_134##2	a_416_86#	6.80871e-17
C164	a_416_86##6	B#6	1.84911e-18
C165	a_384_392##2	a_416_86##4	1.361e-16
C166	a_1157_298##2	VPWR#4	3.48889e-17
C167	B#14	B#2	7.91548e-18
C168	a_84_108##4	B#3	2.48426e-17
C169	VPWR#5	B#14	1.16427e-18
C170	VPWR#9	B#6	6.36197e-17
C171	a_1215_396##8	a_384_392##2	1.1063e-19
C172	a_384_392##4	B#8	2.07229e-17
C173	a_27_134##2	a_84_108##11	5.93604e-17
C174	B#6	a_452_288##8	2.35896e-17
C175	VGND#3	VGND#8	1.51352e-17
C176	B#11	a_452_288#	1.62006e-17
C177	a_416_86##2	a_84_108##9	1.75535e-18
C178	a_84_108##4	B#2	3.28982e-19
C179	VGND#3	a_1157_298##7	2.70024e-17
C180	a_84_108##5	B#6	3.85106e-18
C181	VGND#4	a_1157_298##2	5.25838e-20
C182	a_452_288##7	a_452_288#	2.03347e-19
C183	a_452_288##8	a_452_288##6	2.29171e-19
C184	VGND#3	a_416_86##4	5.91367e-18
C185	VGND#3	a_1215_396##5	1.42246e-18
C186	a_452_288##9	a_416_86##4	6.12638e-19
C187	a_452_288##6	a_84_108##5	3.39487e-17
C188	a_452_288##7	B#11	1.21001e-17
C189	C#9	a_1215_396##3	1.03864e-20
C190	VPWR#5	a_84_108##9	2.63749e-18
C191	a_27_134##2	a_416_86##2	4.09078e-17
C192	VGND#3	a_384_392##2	8.19114e-17
C193	a_452_288##6	a_416_86##3	1.99106e-17
C194	A#7	a_84_108##11	1.18283e-17
C195	a_384_392##4	B#3	2.24786e-17
C196	a_416_86##4	a_1215_396##6	8.00731e-18
C197	B#14	VPWR#9	2.66112e-17
C198	B#9	B#11	6.12621e-19
C199	a_84_108##5	B#10	6.51045e-19
C200	a_27_134##3	a_27_134##2	1.17766e-18
C201	a_384_392##2	VGND#9	1.10002e-16
C202	a_27_134##5	a_452_288##6	1.33196e-18
C203	a_27_134#	B#8	1.5426e-18
C204	B#10	a_416_86##3	2.07007e-17
C205	VPWR#4	B#4	1.26608e-17
C206	B#9	a_452_288##7	2.93995e-17
C207	VGND#5	a_84_108##9	1.73057e-18
C208	a_1215_396##6	a_384_392##2	2.80772e-18
C209	VPWR#5	a_27_134##2	4.43142e-18
C210	a_384_392##6	a_452_288##6	2.08825e-17
C211	A#5	a_84_108##11	2.302e-17
C212	a_384_392##4	B#2	2.34129e-19
C213	a_27_134##5	B#10	3.6577e-17
C214	A#1	a_452_288##7	2.64009e-19
C215	a_452_288##8	B#14	1.9433e-17
C216	a_84_108##7	a_452_288##6	2.71688e-19
C217	a_384_392##2	a_452_288##9	4.63847e-17
C218	a_416_86##5	a_1215_396##5	2.52121e-17
C219	VPWR#5	A#7	3.02099e-18
C220	a_384_392##6	B#10	2.33867e-17
C221	C#7	C#2	9.1367e-19
C222	a_416_86##5	a_384_392##2	6.76009e-17
C223	a_84_108##5	B#5	2.72319e-19
C224	a_27_134##5	a_452_288##5	2.72675e-17
C225	a_384_392##4	a_452_288##4	1.18202e-19
C226	A#1	B#9	1.41754e-17
C227	A#5	VGND#10	4.19055e-19
C228	VGND#5	a_27_134##2	1.71494e-17
C229	C#9	a_1157_298##2	1.09126e-19
C230	a_84_108##7	B#10	6.95414e-19
C231	a_416_86##5	VGND#9	2.76275e-18
C232	a_1215_396##8	VPWR#8	3.47535e-17
C233	a_27_134##3	A#7	6.80442e-19
C234	VPWR#4	B#3	3.75308e-20
C235	C#8	a_1157_298##2	4.2213e-20
C236	a_384_392##6	a_452_288##5	2.51194e-17
C237	a_452_288##9	a_416_86##5	8.40232e-18
C238	a_1215_396##8	a_1157_298##5	4.32519e-17
C239	B#14	a_1157_298##2	1.02439e-19
C240	a_27_134##5	B#5	1.23942e-18
C241	a_416_86##5	a_84_108##4	1.8651e-17
C242	a_84_108##7	a_452_288##5	4.28419e-18
C243	a_384_392##4	a_452_288##3	1.42896e-17
C244	a_416_86#	B#8	1.34433e-17
C245	a_1215_396##8	a_384_392#	2.93147e-17
C246	VGND#5	A#5	5.10173e-18
C247	VPWR#3	VPWR#8	1.64518e-17
C248	a_27_134##3	A#5	2.30335e-17
C249	a_84_108##3	A#1	6.25981e-18
C250	B#5	a_384_392##6	2.98869e-17
C251	a_416_86##5	a_384_392##4	9.31001e-19
C252	a_1215_396##8	C#4	3.19987e-19
C253	a_1157_298##5	VPWR#3	1.31491e-16
C254	a_384_392##4	a_384_392##2	9.75104e-19
C255	a_1157_298#	C#4	1.17921e-18
C256	a_27_134##5	A#4	2.29857e-19
C257	a_416_86##2	a_452_288##9	2.74522e-18
C258	a_84_108##7	B#5	3.29484e-17
C259	VPWR#4	B#2	5.96137e-20
C260	a_1215_396##8	C#2	4.80654e-18
C261	VPWR#3	a_384_392#	6.89656e-18
C262	a_416_86##2	a_84_108##4	9.68589e-18
C263	a_416_86#	B#4	1.10094e-19
C264	a_384_392##6	A#4	1.15609e-18
C265	VPWR#10	B#5	5.65359e-19
C266	a_416_86##2	a_384_392##4	1.23031e-16
C267	VPWR#3	a_1215_396##7	2.03116e-18
C268	VGND#5	a_416_86##4	7.32452e-18
C269	a_27_134#	a_452_288##4	2.14859e-18
C270	a_84_108##7	A#4	4.58186e-17
C271	a_452_288##9	a_84_108##4	7.15281e-17
C272	a_416_86##2	a_27_134#	4.67189e-17
C273	VGND#5	a_1215_396##5	1.97723e-18
C274	VGND#8	a_1215_396##3	6.71457e-18
C275	VGND#3	a_384_392#	2.55947e-17
C276	A#4	VPWR#10	2.98402e-17
C277	a_416_86#	B#3	5.85477e-20
C278	VGND#5	a_384_392##2	5.19228e-17
C279	a_1157_298##7	a_1215_396##3	2.19916e-18
C280	a_84_108##7	a_84_108#	1.94883e-18
C281	a_1215_396##6	a_1157_298##5	4.73142e-18
C282	a_416_86##2	a_84_108##11	6.00058e-19
C283	a_27_134##6	A#4	1.87406e-19
C284	a_384_392##4	a_452_288##9	6.93344e-17
C285	VGND#5	a_452_288##9	1.38355e-17
C286	a_1215_396##6	a_384_392#	4.39604e-17
C287	a_84_108#	VPWR#10	4.03119e-17
C288	VGND#5	a_84_108##4	5.54313e-18
C289	VPWR#3	C#4	1.3747e-19
C290	VGND#4	a_1157_298#	1.15105e-18
C291	a_1215_396##6	a_1215_396##7	1.08341e-19
C292	a_27_134##6	a_84_108#	4.21447e-17
C293	VGND#5	a_384_392##4	1.21232e-16
C294	VPWR#3	C#2	1.03968e-19
C295	VGND#5	a_27_134#	7.49896e-18
C296	C#6	a_1215_396##4	1.38688e-17
C297	a_416_86#	a_452_288##4	1.40276e-18
C298	VGND#5	a_416_86#	9.61486e-17
C299	B#2	a_1157_298#	8.59206e-19
C300	VGND#8	VPWR#8	1.43852e-18
C301	VGND#5	a_84_108##11	4.68374e-18
C302	a_416_86##5	a_416_86##6	2.02118e-18
C303	C#5	a_1215_396##4	4.71015e-19
C304	VGND#4	B#1	6.41877e-18
C305	VPWR#9	a_416_86##5	1.43265e-17
C306	C#5	C#6	4.10675e-18
C307	a_416_86#	a_452_288##3	3.71585e-19
C308	a_27_134##2	a_452_288##2	4.84948e-20
C309	VGND#5	a_27_134##3	3.0527e-17
C310	VPWR#5	a_1157_298##5	5.40014e-18
C311	a_416_86##5	a_452_288##8	2.77796e-17
C312	a_84_108##9	A#3	8.56035e-18
C313	a_384_392##2	a_1157_298##2	1.69631e-18
C314	a_416_86##5	a_84_108##5	5.41844e-18
C315	a_1215_396##8	C#1	2.36609e-18
C316	VGND#3	C#4	1.19115e-19
C317	VPWR#5	a_1215_396##7	6.39528e-18
C318	VGND#4	C#4	1.81826e-20
C319	B#3	B#1	3.49894e-17
C320	B#9	B#5	3.72742e-19
C321	a_1157_298##3	C#5	1.13962e-17
C322	VGND#3	C#2	9.90593e-19
C323	VPWR#5	a_416_86##6	1.97818e-17
C324	a_27_134##2	A#3	1.11499e-18
C325	VPWR#3	C#1	9.62737e-19
C326	a_384_392##2	B#7	1.53687e-17
C327	a_416_86##2	a_84_108##5	1.93948e-17
C328	a_84_108##2	a_84_108##9	2.73205e-18
C329	a_84_108##11	a_452_288##4	1.52315e-18
C330	a_384_392#	VGND#8	5.3903e-18
C331	a_1215_396##3	VPWR#8	4.79617e-18
C332	VGND#3	a_1215_396#	4.79499e-18
C333	a_416_86#	a_384_392##4	3.41116e-17
C334	A#7	A#3	1.54805e-17
C335	VPWR#5	a_452_288##8	1.44897e-17
C336	a_452_288##9	B#7	1.2865e-17
C337	a_1157_298##5	a_1215_396##3	1.76146e-18
C338	A#5	A#3	6.40948e-18
C339	VGND#3	C#1	1.21205e-17
C340	a_27_134##5	a_416_86##2	6.80697e-18
C341	B#8	a_452_288#	1.02068e-17
C342	B#6	a_1157_298##3	4.80284e-18
C343	a_84_108##5	VPWR#5	1.50775e-16
C344	a_84_108##9	a_27_134##5	3.72599e-18
C345	a_384_392#	a_1215_396##3	9.5488e-22
C346	a_416_86##2	a_384_392##6	3.97588e-18
C347	VGND#3	C#7	1.1462e-18
C348	a_384_392#	a_1157_298##7	9.43281e-17
C349	VPWR#5	a_416_86##3	4.75165e-18
C350	a_416_86#	a_27_134#	6.76925e-17
C351	VPWR#5	a_27_134##5	6.84845e-18
C352	a_84_108##2	A#7	2.99695e-17
C353	a_452_288##9	a_452_288##2	7.86433e-18
C354	VGND#5	a_84_108##5	5.88215e-19
C355	a_452_288##2	a_84_108##4	5.97438e-17
C356	VPWR#5	a_384_392##6	2.56854e-17
C357	a_1215_396##6	C#4	1.96958e-17
C358	a_416_86##4	a_384_392#	3.96704e-17
C359	a_452_288#	B#3	1.68611e-17
C360	a_84_108##9	a_384_392##6	1.735e-17
C361	a_384_392##4	a_452_288##2	1.16576e-16
C362	a_84_108##7	VPWR#5	7.17452e-17
C363	a_1157_298##2	a_1157_298##5	1.34481e-18
C364	a_416_86##5	C#7	5.27892e-19
C365	VPWR#5	VPWR#10	2.23639e-17
C366	VGND#5	a_384_392##6	3.93743e-18
C367	a_416_86##5	a_1157_298#	2.34612e-17
C368	VPWR#5	a_27_134##6	2.46354e-17
C369	B#10	a_452_288##6	2.87765e-17
C370	a_1215_396##5	a_384_392#	5.58571e-18
C371	a_1157_298##2	a_1215_396##7	8.193e-17
C372	a_416_86##5	B#1	1.82793e-18
C373	a_1157_298##2	a_416_86##6	7.14422e-17
C374	a_416_86#	a_84_108##11	6.12403e-19
C375	a_84_108##9	a_84_108##7	1.70497e-18
C376	a_452_288##5	a_452_288##6	8.59256e-19
C377	a_452_288##4	a_452_288#	4.24402e-19
C378	VPWR#9	a_1157_298##2	5.53853e-18
C379	a_1215_396##6	B#2	6.23803e-19
C380	a_384_392##2	a_384_392#	1.62384e-18
C381	a_452_288##8	a_1157_298##2	3.95441e-21
C382	a_1215_396##8	a_1215_396##4	1.7725e-18
C383	a_84_108##11	A#3	3.8534e-18
C384	a_452_288##5	B#10	3.4152e-17
C385	A#3	VGND#10	1.66956e-18
C386	a_416_86##2	a_452_288#	8.6321e-19
C387	a_1215_396##8	C#6	1.35222e-18
C388	a_84_108##9	a_452_288##4	1.57956e-18
C389	a_27_134##3	A#3	2.75536e-18
C390	B#5	B#10	1.3635e-18
C391	VPWR#3	a_1215_396##4	4.72561e-18
C392	a_416_86##5	C#4	1.54762e-18
C393	C#8	C#7	3.1925e-18
C394	a_84_108##9	VPWR#10	1.11737e-17
C395	B#11	B#3	5.3731e-19
C396	a_416_86##2	B#11	1.24704e-17
C397	a_452_288##8	B#7	1.36526e-17
C398	VPWR#3	C#6	9.39066e-18
C399	B#5	a_452_288##5	3.20963e-17
C400	a_416_86##2	a_452_288##7	1.39653e-18
C401	a_84_108##2	VGND#10	1.91305e-18
C402	VPWR#3	C#5	2.97754e-18
C403	a_27_134##2	a_384_392##6	1.89208e-17
C404	a_27_134##3	a_84_108##2	4.32746e-17
C405	VGND#4	B#3	5.8841e-18
C406	VGND#5	a_452_288#	1.614e-18
C407	a_452_288##2	a_84_108##5	4.11287e-17
C408	A#4	B#5	3.66515e-17
C409	a_27_134##6	a_84_108##9	4.89997e-19
C410	B#8	a_452_288##7	4.59135e-18
C411	a_416_86##5	B#3	2.755e-18
C412	a_1215_396##6	C#6	1.21898e-19
C413	a_27_134##3	a_84_108##11	2.04823e-17
C414	VGND#5	a_452_288##7	1.42015e-18
C415	a_416_86##5	B#2	1.05117e-17
C416	a_1215_396##6	C#5	4.34155e-18
C417	a_27_134##2	a_84_108##7	2.30754e-18
C418	B#11	a_452_288##3	8.78066e-18
C419	VGND#5	B#9	1.21682e-17
C420	a_84_108#	A#4	1.95992e-17
C421	a_1215_396##6	a_1157_298##3	1.09346e-18
C422	VGND#5	A#1	7.9118e-18
C423	VGND#4	B#2	8.51073e-20
C424	X	C#2	8.30196e-19
C425	a_1215_396##6	B#6	6.71705e-20
C426	a_27_134##5	A#3	4.05908e-19
C427	a_1157_298##5	C#4	1.79465e-18
C428	a_27_134##3	VGND#10	5.00285e-18
C429	VGND#5	a_84_108##3	7.77645e-18
C430	a_416_86##5	a_1157_298##3	3.18507e-18
C431	a_416_86##5	B#6	2.08719e-19
C432	B#7	a_1157_298#	9.25145e-20
C433	a_416_86##2	B#8	1.73791e-19
C434	VPWR#10	A#3	1.55935e-18
C435	a_1157_298##5	C#2	3.96041e-18
C436	VPWR#5	a_1157_298##3	2.45644e-18
C437	B#9	B#8	1.08825e-19
C438	a_416_86##2	B#3	1.13075e-21
C439	a_416_86##2	a_452_288##6	1.20526e-18
C440	a_84_108##2	VPWR#10	1.94019e-17
C441	a_452_288##2	B#1	1.81302e-19
C442	VPWR#5	B#6	2.7544e-18
C443	VGND#4	a_384_392##2	1.02294e-16
C444	C#6	a_1215_396##3	1.36047e-18
C445	a_84_108##2	a_27_134##6	6.98418e-17
C446	a_452_288##2	a_452_288#	1.66348e-17
C447	VPWR#5	a_452_288##6	1.23049e-18
C448	A#7	VPWR#10	3.1615e-18
C449	a_416_86##2	a_452_288##4	1.34316e-18
C450	a_452_288##2	B#11	9.50904e-19
C451	a_416_86##2	a_452_288##5	5.64047e-20
C452	a_1215_396##8	VPWR#3	2.27458e-17
C453	a_416_86##2	a_452_288##3	2.43158e-17
C454	a_27_134##2	B#8	7.51734e-20
C455	a_384_392#	C#4	2.30706e-17
C456	VGND#3	a_1215_396##8	2.27017e-17
C457	VGND#5	B#10	1.05025e-18
C458	C#4	C#2	2.07963e-18
C459	VPWR#5	B#5	1.01744e-17
C460	a_1157_298##2	C#5	3.29221e-18
C461	VPWR#5	A#4	1.25227e-18
C462	a_1157_298##2	a_1157_298##3	2.24034e-17
C463	a_1215_396##6	VPWR#3	1.53419e-17
C464	a_384_392#	C#2	1.64411e-17
C465	VPWR#5	B#4	5.7128e-17
C466	a_84_108##4	a_452_288##8	1.86908e-17
C467	a_27_134##2	B#4	9.43902e-20
C468	VPWR#5	a_84_108#	2.4961e-18
C469	B#6	a_1157_298##2	3.09007e-18
C470	a_452_288##9	a_84_108##5	8.30231e-20
C471	a_84_108##3	A#3	2.60151e-19
C472	B#9	a_452_288##4	5.74423e-19
C473	VGND#3	a_1215_396##6	1.35253e-17
C474	VPWR#5	B#3	2.9913e-19
C475	VPWR#5	a_452_288##4	4.44947e-19
C476	a_84_108##4	a_84_108##5	2.09434e-18
C477	a_416_86##5	a_1215_396##6	1.8964e-17
C478	VPWR#5	VPWR#3	7.46055e-18
C479	VPWR#5	a_452_288##3	2.3568e-19
C480	VPWR#4	a_1157_298##3	3.63547e-18
C481	VGND#5	C#4	1.60884e-22
C482	a_1215_396##8	a_1215_396##3	1.95603e-17
C483	a_1215_396##6	VPWR#5	7.1887e-18
C484	a_384_392##4	a_84_108##5	6.0005e-17
C485	a_1157_298##5	VPWR#8	5.85611e-17
C486	a_416_86##5	VPWR#5	2.38954e-17
C487	VGND#5	B#8	4.34162e-17
C488	VGND#5	a_1215_396##6	8.51392e-18
C489	A#3	a_452_288##5	3.85263e-19
C490	a_416_86##2	VPWR#5	2.68772e-17
C491	VGND#5	a_416_86##5	2.76438e-17
C492	A#1	a_452_288##4	5.18418e-19
C493	A#3	B#5	3.05068e-18
C494	VGND#5	B#3	1.49111e-18
C495	VGND#5	a_416_86##2	2.91686e-17
C496	a_416_86##3	a_384_392##4	4.84027e-17
C497	a_84_108##2	a_452_288##5	4.24168e-20
C498	VPWR#4	B#6	9.56456e-18
C499	VGND#8	a_1215_396#	3.95288e-17
C500	a_84_108##2	B#5	1.94311e-19
C501	a_1157_298##2	a_1215_396##6	5.88296e-17
C502	a_84_108##2	A#4	6.19938e-19
C503	VGND#5	a_452_288##4	3.50702e-18
C504	a_416_86##5	a_1157_298##2	9.98326e-17
C505	a_27_134##2	a_452_288##4	3.84396e-17
C506	a_84_108##2	a_84_108#	1.09895e-17
C507	a_1157_298##7	a_1215_396#	1.71778e-18
C508	VGND#5	a_452_288##3	2.31602e-18
C509	a_384_392#	a_1157_298##5	1.50167e-16
C510	B#7	a_416_86##5	2.10177e-17
C511	C#4	a_1215_396##3	2.51086e-19
C512	VGND#4	a_384_392##4	2.64605e-17
C513	VGND#8	C#1	1.70779e-17
C514	VPWR#5	a_1157_298##2	2.16247e-17
C515	C#2	a_1215_396##3	2.38318e-17
C516	a_416_86#	a_416_86##3	2.03346e-19
C517	VGND#5	a_1157_298##2	3.49052e-18
C518	a_416_86##2	a_452_288##2	1.75358e-17
C519	VGND#5	B#7	2.00532e-18
C520	a_27_134##2	a_452_288##3	4.63578e-19
C521	a_1215_396##7	a_1157_298##5	2.65433e-17
C522	a_1157_298##7	C#1	4.70233e-17
C523	a_384_392##6	a_384_392##4	6.93698e-19
C524	VPWR#5	a_452_288##2	2.17446e-18
C525	X	X#3	1.03383e-17
C526	a_416_86##2	A#3	6.27676e-21
C527	VGND#8	X	6.36245e-17
C528	a_1157_298##7	X	3.46832e-18
C529	VGND#5	a_452_288##2	3.64554e-18
C530	a_27_134##2	a_452_288#	1.32483e-19
C531	VPWR#5	a_84_108##2	6.23422e-18
C532	a_416_86##4	C#1	6.97584e-19
C533	B#7	a_1157_298##2	3.58281e-19
C534	a_27_134#	a_384_392##6	1.25258e-18
C535	a_1215_396##7	a_384_392#	6.30519e-17
C536	VGND#5	a_84_108##2	5.59254e-18
C537	a_1157_298##7	C#7	6.25468e-19
C538	X	X#1	1.60837e-17
C539	VPWR#8	X	7.75475e-17
C540	a_1157_298##5	X	3.45869e-18
C541	a_1215_396##5	C#1	7.83014e-19
C542	a_27_134##2	B#11	1.16999e-18
C543	C#4	VNB	6.23328e-17
C544	C#2	VNB	3.80083e-17
C545	B#8	VNB	1.27242e-16
C546	B#4	VNB	1.53724e-16
C547	a_416_86##4	C#7	4.03086e-17
C548	B#3	VNB	1.60118e-16
C549	B#2	VNB	3.11645e-17
C550	a_452_288##4	VNB	5.34868e-17
C551	a_452_288##3	VNB	3.61398e-17
C552	a_384_392##2	C#1	1.52117e-19
C553	a_84_108##2	A#3	3.54047e-17
C554	X	a_1215_396#	2.04456e-17
C555	C#7	a_1215_396##5	1.38266e-17
C556	a_27_134##2	a_452_288##7	2.98177e-18
C557	a_416_86##4	a_1157_298#	1.76999e-17
C558	a_384_392##2	C#7	1.08136e-17
C559	X	a_1215_396##4	3.05225e-17
C560	a_27_134##2	a_84_108##9	4.88669e-18
C561	X	C#6	7.97076e-19
C562	a_1157_298#	a_1215_396##5	2.24519e-17
C563	VPWR#4	VNB	7.41248e-17
C564	A#7	a_452_288##4	4.86278e-19
C565	VGND#4	VNB	7.43869e-17
C566	a_27_134##2	B#9	3.38452e-17
C567	a_416_86##4	B#1	4.00361e-19
C568	C#9	VNB	4.99283e-18
C569	C#8	VNB	1.30577e-18
C570	B#14	VNB	1.71006e-18
C571	a_1157_298#	a_384_392##2	2.42844e-17
C572	a_1215_396##8	X	4.93985e-17
C573	a_1157_298##2	C#4	1.34769e-17
C574	VPWR#9	a_416_86##6	6.53725e-17
C575	a_84_108##9	VNB	7.73515e-18
C576	C#4	C#6	5.90306e-19
C577	VPWR#3	X	1.79411e-17
C578	C#8	a_416_86##4	2.36188e-17
C579	VPWR#9	B#4	6.33598e-19
C580	a_27_134##2	VNB	1.33129e-17
C581	VGND#3	X	1.73697e-17
C582	A#7	VNB	5.90901e-19
C583	A#5	VNB	6.65281e-19
C584	VGND#8	VNB	4.01738e-18
C585	a_1157_298##7	VNB	7.17687e-18
C586	a_416_86##4	VNB	6.4958e-18
C587	a_1215_396##5	VNB	1.97682e-18
C588	a_384_392##2	VNB	4.19919e-17
C589	VGND#9	VNB	3.67159e-18
C590	a_452_288##9	VNB	6.95861e-18
C591	a_384_392##4	VNB	1.33642e-17
C592	a_27_134#	VNB	1.95929e-18
C593	a_416_86#	VNB	1.3303e-17
C594	a_84_108##11	VNB	2.88227e-18
C595	a_27_134##3	VNB	5.4382e-17
C596	X	a_1215_396##3	1.40685e-17
C597	VGND#9	a_1157_298#	5.60281e-19
C598	VPWR#8	VNB	9.52082e-18
C599	a_1157_298##5	VNB	3.23076e-17
C600	a_384_392#	VNB	3.45251e-17
C601	a_416_86##6	VNB	1.85233e-17
C602	a_27_134##2	A#1	2.23612e-18
C603	VPWR#9	VNB	2.23866e-18
C604	a_452_288##8	VNB	6.67019e-18
C605	a_84_108##5	VNB	2.2805e-17
C606	a_416_86##3	VNB	2.79663e-18
C607	a_27_134##5	VNB	1.62195e-18
C608	a_384_392##6	VNB	5.23241e-18
C609	a_84_108##7	VNB	1.29675e-17
C610	VPWR#9	B#3	1.72197e-18
C611	VPWR#10	VNB	4.06882e-18
C612	a_27_134##6	VNB	6.62093e-17
C613	a_384_392##2	B#1	4.31304e-17
C614	a_1215_396#	VNB	3.8183e-17
C615	C#1	VNB	5.29087e-17
C616	C#7	VNB	3.57479e-17
C617	a_1157_298#	VNB	2.70659e-17
C618	B#1	VNB	3.65026e-17
C619	a_452_288#	VNB	2.11174e-17
C620	B#11	VNB	2.23589e-17
C621	a_452_288##7	VNB	2.62381e-17
C622	B#9	VNB	8.08941e-17
C623	A#1	VNB	2.58016e-17
C624	VGND#8	C#2	1.47965e-18
C625	a_84_108##3	VNB	3.04523e-17
C626	a_1215_396##4	VNB	4.43091e-17
C627	a_452_288##9	a_1157_298#	6.61265e-19
C628	C#6	VNB	4.10914e-17
C629	C#5	VNB	3.90007e-17
C630	a_1215_396##5	C#8	1.701e-17
C631	a_1157_298##3	VNB	2.78947e-17
C632	B#2	a_1157_298##2	6.79483e-18
C633	B#6	VNB	3.75221e-17
C634	a_452_288##6	VNB	3.2907e-17
C635	B#10	VNB	2.96906e-17
C636	a_452_288##5	VNB	2.82694e-17
C637	A#7	a_84_108##9	4.24431e-17
C638	B#5	VNB	7.15603e-17
C639	A#4	VNB	3.53113e-17
C640	a_84_108#	VNB	4.2236e-17
C641	a_1215_396##8	VNB	7.51686e-18
C642	VPWR#3	VNB	1.84056e-16
C643	B#1	VGND#9	2.6643e-17
C644	a_452_288##8	VPWR#9	7.49536e-17
C645	VGND#3	VNB	1.75799e-16
C646	a_1215_396##6	VNB	1.23289e-17
C647	a_416_86##5	VNB	1.72099e-17
C648	a_416_86##2	VNB	7.29118e-18
C649	B#2	VPWR#9	5.79305e-18
C650	VPWR#5	VNB	3.40701e-16
C651	VGND#5	VNB	3.42453e-16
C652	a_1215_396##3	VNB	5.40147e-17
C653	a_1157_298##2	VNB	5.74146e-17
C654	B#7	VNB	2.55465e-18
C655	a_27_134##2	a_84_108##3	3.72667e-19
C656	a_452_288##2	VNB	3.28186e-17
C657	A#3	VNB	4.70822e-17
C658	a_84_108##2	VNB	4.08751e-17
C659	a_384_392##2	a_452_288#	3.42588e-19
C660	a_1157_298##5	VPWR#4	4.00876e-18
C661	X	VNB	1.17242e-16
C662	B#1	a_452_288##9	1.75361e-17
C663	a_27_134##3	a_27_134##6	1.67347e-18
C664	VPWR#3	VPWR#2	6.92156e-17
C665	VGND#6	a_84_108##2	5.45978e-19
C666	a_27_134##6	VPWR#6	2.99766e-17
C667	VGND#6	B#5	2.10529e-19
C668	VGND#6	B#9	1.53482e-17
C669	VGND#6	A#3	1.28126e-18
C670	a_1215_396##8	VGND#2	2.19772e-19
C671	VGND#6	a_27_134##3	8.251e-17
C672	VPWR#6	A#4	5.40787e-18
C673	VGND#5	VGND#6	1.66088e-16
C674	a_1215_396##8	VPWR#2	4.07507e-19
C675	VGND#2	VNB	4.31149e-17
C676	VGND#2	C#1	9.013e-19
C677	VGND#6	a_27_134##2	7.95701e-18
C678	VGND#6	VNB	9.91505e-17
C679	X	VPWR#2	1.76458e-17
C680	VGND#6	VGND#10	1.26208e-17
C681	VGND#2	a_1215_396#	5.74395e-18
C682	VPWR#2	VNB	4.22115e-17
C683	VGND#6	B#11	2.95563e-19
C684	VPWR#6	B#5	1.30107e-17
C685	VPWR#6	VNB	7.43504e-17
C686	a_84_108##7	VPWR#6	5.82479e-17
C687	VPWR#6	B#9	4.15123e-19
C688	VGND#6	a_416_86#	1.92585e-17
C689	a_84_108##2	VPWR#6	7.14545e-19
C690	VGND#6	B#8	3.25663e-20
C691	VGND#2	X	1.49171e-17
C692	VGND#6	a_84_108##3	1.76658e-18
C693	a_84_108##9	VPWR#6	4.46541e-19
C694	VPWR#5	VPWR#6	1.36887e-16
C695	VPWR#2	a_1215_396##4	5.84497e-18
C696	VGND#3	VGND#2	7.29103e-17
C697	VGND#6	A#1	2.62975e-18
C698	VPWR#6	a_84_108#	7.61969e-18
*
*
.ENDS sky130_fd_sc_hs__xor3_1
*
