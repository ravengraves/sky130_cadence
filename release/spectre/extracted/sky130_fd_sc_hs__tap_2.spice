* Extracted by Quantus, converted by sky130cad/quantus.py
*
*
*
*                       LINUX           Wed Nov 18 09:13:20 2026
*
*
*
*  PROGRAM  advgen
*
*  Name           : advgen - Quantus - (64-bit)
*  Version        : 25.1.0-p047
*  Build Date     : Thu Dec 11 23:20:30 PST 2025
*
*  HSPICE LIBRARY
*
*  OPERATING_TEMPERATURE 150
*  QRC_TECH_DIR <path>/tech
*
*
*
*
.SUBCKT sky130_fd_sc_hs__tap_2 VGND VPWR VPB VNB
*
*
*  caps2d version: 10
*
*
*       RESISTOR AND CAP/DIODE CARDS
*
Rf1	VPB	VPB#1	2.750425
Rf2	VPB#1	VPB	2.750425
Rf3	VPB	VPB#2	2.750425
Rf4	VPB#2	VPB	2.750425
Rf5	VPB#1	VPB#2	6.341736
Rf6	VPB	VPB#3	3.170868
Rf7	VPB#2	VPB#3	3.170868
Rf8	VPB	VPB#4	2.750425
Rf9	VPB#4	VPB	2.750425
Rf10	VPB#3	VPB#4	3.170868
Rf11	VPB	VPB#3	3.750000
Rf12	VNB	VNB#1	2.750425
Rf13	VNB#1	VNB	2.750425
Rf14	VNB	VNB#2	3.299417
Rf15	VNB#1	VNB#2	3.042319
Rf16	VNB	VNB#3	2.750425
Rf17	VNB#3	VNB	2.750425
Rf18	VNB#2	VNB#3	3.299417
Rf19	VNB	VNB#4	2.750425
Rf20	VNB#4	VNB	2.750425
Rf21	VNB#3	VNB#4	6.341736
Rf22	VNB	VNB#2	3.750000
*
*       CAPACITOR CARDS
*
*
C1	VPB#1	VNB	4.89393e-17
C2	VPB#4	VNB	1.05863e-16
C3	VNB#3	VNB	1.05975e-16
C4	VNB#4	VNB	4.88278e-17
C5	VNB#4	VPB#1	4.26424e-17
C6	VGND	VNB#3	1.03639e-16
C7	VPWR	VPB#4	1.0268e-16
C8	VGND	VNB	1.73901e-16
C9	VPWR	VNB	1.71807e-16
C10	VGND	VPB#1	6.81519e-18
C11	VPWR	VNB#4	6.81519e-18
*
*
.ENDS sky130_fd_sc_hs__tap_2
*
