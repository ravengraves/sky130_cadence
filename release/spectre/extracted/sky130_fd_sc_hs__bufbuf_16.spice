* Extracted by Quantus, converted by sky130cad/quantus.py
*
*
*
*                       LINUX           Wed Nov 18 08:20:58 2026
*
*
*
*  PROGRAM  advgen
*
*  Name           : advgen - Quantus - (64-bit)
*  Version        : 25.1.0-p047
*  Build Date     : Thu Dec 11 23:20:30 PST 2025
*
*  HSPICE LIBRARY
*
*  OPERATING_TEMPERATURE 150
*  QRC_TECH_DIR <path>/tech
*
*
*

*
.SUBCKT sky130_fd_sc_hs__bufbuf_16 VPB VNB VGND X VPWR A
*
*
*  caps2d version: 10
*
*
*       TRANSISTOR CARDS
*
*
XM22 a_27_368##13 A#1 VGND#28 VNB sky130_fd_pr__nfet_01v8_lvt l=0.15 w=0.74 ad=0.2109 as=0.2072 pd=2.05 ps=2.04
XM36 a_203_74##22 a_27_368##7 VGND#28 VNB sky130_fd_pr__nfet_01v8_lvt l=0.15 w=0.74 ad=0.2072 as=0.2072 pd=2.04 ps=2.04
XM47 VGND#27 a_27_368##5 a_203_74##22 VNB sky130_fd_pr__nfet_01v8_lvt l=0.15 w=0.74 ad=0.2109 as=0.2072 pd=2.05 ps=2.04
XM45 VGND#27 a_27_368##4 a_203_74##25 VNB sky130_fd_pr__nfet_01v8_lvt l=0.15 w=0.74 ad=0.2109 as=0.2109 pd=2.05 ps=2.05
XM8 VGND#26 a_203_74##8 a_588_74##64 VNB sky130_fd_pr__nfet_01v8_lvt l=0.15 w=0.74 ad=0.2627 as=0.2072 pd=2.19 ps=2.04
XM19 a_588_74##64 a_203_74##16 VGND#25 VNB sky130_fd_pr__nfet_01v8_lvt l=0.15 w=0.74 ad=0.2072 as=0.259 pd=2.04 ps=2.18
XM17 a_588_74##69 a_203_74##14 VGND#25 VNB sky130_fd_pr__nfet_01v8_lvt l=0.15 w=0.74 ad=0.2072 as=0.259 pd=2.04 ps=2.18
XM7 VGND#20 a_203_74##12 a_588_74##69 VNB sky130_fd_pr__nfet_01v8_lvt l=0.15 w=0.74 ad=0.259 as=0.2072 pd=2.18 ps=2.04
XM9 VGND#20 a_203_74##10 a_588_74##68 VNB sky130_fd_pr__nfet_01v8_lvt l=0.15 w=0.74 ad=0.259 as=0.2072 pd=2.18 ps=2.04
XM18 a_588_74##68 a_203_74# VGND#19 VNB sky130_fd_pr__nfet_01v8_lvt l=0.15 w=0.74 ad=0.2072 as=0.2072 pd=2.04 ps=2.04
XM15 X#2 a_588_74##57 VGND#19 VNB sky130_fd_pr__nfet_01v8_lvt l=0.15 w=0.74 ad=0.2072 as=0.2072 pd=2.04 ps=2.04
XM31 VGND#18 a_588_74##55 X#2 VNB sky130_fd_pr__nfet_01v8_lvt l=0.15 w=0.74 ad=0.2072 as=0.2072 pd=2.04 ps=2.04
XM13 X#6 a_588_74##51 VGND#18 VNB sky130_fd_pr__nfet_01v8_lvt l=0.15 w=0.74 ad=0.2072 as=0.2072 pd=2.04 ps=2.04
XM39 VGND#17 a_588_74##47 X#6 VNB sky130_fd_pr__nfet_01v8_lvt l=0.15 w=0.74 ad=0.2072 as=0.2072 pd=2.04 ps=2.04
XM3 VGND#17 a_588_74##43 X#8 VNB sky130_fd_pr__nfet_01v8_lvt l=0.15 w=0.74 ad=0.2072 as=0.2072 pd=2.04 ps=2.04
XM48 X#8 a_588_74##39 VGND#16 VNB sky130_fd_pr__nfet_01v8_lvt l=0.15 w=0.74 ad=0.2072 as=0.259 pd=2.04 ps=2.18
XM37 VGND#16 a_588_74##35 X#12 VNB sky130_fd_pr__nfet_01v8_lvt l=0.15 w=0.74 ad=0.259 as=0.2072 pd=2.18 ps=2.04
XM51 X#12 a_588_74##31 VGND#15 VNB sky130_fd_pr__nfet_01v8_lvt l=0.15 w=0.74 ad=0.2072 as=0.259 pd=2.04 ps=2.18
XM29 X#14 a_588_74##29 VGND#15 VNB sky130_fd_pr__nfet_01v8_lvt l=0.15 w=0.74 ad=0.2072 as=0.259 pd=2.04 ps=2.18
XM16 VGND#14 a_588_74##27 X#14 VNB sky130_fd_pr__nfet_01v8_lvt l=0.15 w=0.74 ad=0.259 as=0.2072 pd=2.18 ps=2.04
XM25 VGND#14 a_588_74##24 X#17 VNB sky130_fd_pr__nfet_01v8_lvt l=0.15 w=0.74 ad=0.259 as=0.2072 pd=2.18 ps=2.04
XM30 X#17 a_588_74##22 VGND#13 VNB sky130_fd_pr__nfet_01v8_lvt l=0.15 w=0.74 ad=0.2072 as=0.259 pd=2.04 ps=2.18
XM49 VGND#13 a_588_74##20 X#20 VNB sky130_fd_pr__nfet_01v8_lvt l=0.15 w=0.74 ad=0.259 as=0.2072 pd=2.18 ps=2.04
XM46 X#20 a_588_74##18 VGND#12 VNB sky130_fd_pr__nfet_01v8_lvt l=0.15 w=0.74 ad=0.2072 as=0.2664 pd=2.04 ps=2.2
XM23 X#25 a_588_74##16 VGND#12 VNB sky130_fd_pr__nfet_01v8_lvt l=0.15 w=0.74 ad=0.2072 as=0.2664 pd=2.04 ps=2.2
XM38 VGND#1 a_588_74##15 X#25 VNB sky130_fd_pr__nfet_01v8_lvt l=0.15 w=0.74 ad=0.2627 as=0.2072 pd=2.19 ps=2.04
XM0 a_27_368##12 A#3 VPWR#28 VPB sky130_fd_pr__pfet_01v8 l=0.15 w=1.12 ad=0.3304 as=0.336 pd=2.83 ps=2.84
XM26 VPWR#28 a_27_368##9 a_203_74##24 VPB sky130_fd_pr__pfet_01v8 l=0.15 w=1.12 ad=0.336 as=0.336 pd=2.84 ps=2.84
XM33 VPWR#26 a_27_368##8 a_203_74##24 VPB sky130_fd_pr__pfet_01v8 l=0.15 w=1.12 ad=0.336 as=0.336 pd=2.84 ps=2.84
XM5 a_203_74##26 a_27_368# VPWR#26 VPB sky130_fd_pr__pfet_01v8 l=0.15 w=1.12 ad=0.3304 as=0.336 pd=2.83 ps=2.84
XM14 a_588_74##67 a_203_74##18 VPWR#24 VPB sky130_fd_pr__pfet_01v8 l=0.15 w=1.12 ad=0.336 as=0.3304 pd=2.84 ps=2.83
XM12 a_588_74##67 a_203_74##17 VPWR#21 VPB sky130_fd_pr__pfet_01v8 l=0.15 w=1.12 ad=0.336 as=0.336 pd=2.84 ps=2.84
XM20 VPWR#21 a_203_74##15 a_588_74##71 VPB sky130_fd_pr__pfet_01v8 l=0.15 w=1.12 ad=0.336 as=0.336 pd=2.84 ps=2.84
XM35 VPWR#19 a_203_74##13 a_588_74##71 VPB sky130_fd_pr__pfet_01v8 l=0.15 w=1.12 ad=0.3472 as=0.336 pd=2.86 ps=2.84
XM24 a_588_74##70 a_203_74##11 VPWR#19 VPB sky130_fd_pr__pfet_01v8 l=0.15 w=1.12 ad=0.336 as=0.3472 pd=2.84 ps=2.86
XM42 VPWR#17 a_203_74##9 a_588_74##70 VPB sky130_fd_pr__pfet_01v8 l=0.15 w=1.12 ad=0.3472 as=0.336 pd=2.86 ps=2.84
XM40 VPWR#17 a_588_74##59 X#3 VPB sky130_fd_pr__pfet_01v8 l=0.15 w=1.12 ad=0.3472 as=0.336 pd=2.86 ps=2.84
XM50 X#3 a_588_74##58 VPWR#15 VPB sky130_fd_pr__pfet_01v8 l=0.15 w=1.12 ad=0.336 as=0.392 pd=2.84 ps=2.94
XM44 X#4 a_588_74##52 VPWR#15 VPB sky130_fd_pr__pfet_01v8 l=0.15 w=1.12 ad=0.336 as=0.392 pd=2.84 ps=2.94
XM11 X#4 a_588_74##48 VPWR#13 VPB sky130_fd_pr__pfet_01v8 l=0.15 w=1.12 ad=0.336 as=0.336 pd=2.84 ps=2.84
XM1 VPWR#13 a_588_74##44 X#9 VPB sky130_fd_pr__pfet_01v8 l=0.15 w=1.12 ad=0.336 as=0.336 pd=2.84 ps=2.84
XM41 VPWR#11 a_588_74##40 X#9 VPB sky130_fd_pr__pfet_01v8 l=0.15 w=1.12 ad=0.336 as=0.336 pd=2.84 ps=2.84
XM32 VPWR#11 a_588_74##36 X#10 VPB sky130_fd_pr__pfet_01v8 l=0.15 w=1.12 ad=0.336 as=0.336 pd=2.84 ps=2.84
XM6 VPWR#9 a_588_74##32 X#10 VPB sky130_fd_pr__pfet_01v8 l=0.15 w=1.12 ad=0.336 as=0.336 pd=2.84 ps=2.84
XM21 X#15 a_588_74##28 VPWR#9 VPB sky130_fd_pr__pfet_01v8 l=0.15 w=1.12 ad=0.336 as=0.336 pd=2.84 ps=2.84
XM2 VPWR#7 a_588_74##26 X#15 VPB sky130_fd_pr__pfet_01v8 l=0.15 w=1.12 ad=0.336 as=0.336 pd=2.84 ps=2.84
XM10 VPWR#7 a_588_74##25 X#18 VPB sky130_fd_pr__pfet_01v8 l=0.15 w=1.12 ad=0.336 as=0.336 pd=2.84 ps=2.84
XM28 X#18 a_588_74##23 VPWR#6 VPB sky130_fd_pr__pfet_01v8 l=0.15 w=1.12 ad=0.336 as=0.336 pd=2.84 ps=2.84
XM4 VPWR#6 a_588_74##21 X#21 VPB sky130_fd_pr__pfet_01v8 l=0.15 w=1.12 ad=0.336 as=0.336 pd=2.84 ps=2.84
XM43 X#21 a_588_74##19 VPWR#5 VPB sky130_fd_pr__pfet_01v8 l=0.15 w=1.12 ad=0.336 as=0.336 pd=2.84 ps=2.84
XM34 X#22 a_588_74##17 VPWR#5 VPB sky130_fd_pr__pfet_01v8 l=0.15 w=1.12 ad=0.392 as=0.336 pd=2.94 ps=2.84
XM27 X#22 a_588_74# VPWR#1 VPB sky130_fd_pr__pfet_01v8 l=0.15 w=1.12 ad=0.392 as=0.3304 pd=2.94 ps=2.83
*
*
*       RESISTOR AND CAP/DIODE CARDS
*
Rg1	A#1	A#2	345.814911
Rg2	A#2	A#3	448.815094
Rg3	a_27_368#	a_27_368##2	475.424408
Rg4	a_27_368##2	a_27_368##3	73.670235
Rg5	a_27_368##2	a_27_368##4	379.864502
Rg6	a_27_368##3	a_27_368##5	359.626862
Rg7	a_27_368##3	a_27_368##6	64.081955
Rg8	a_27_368##6	a_27_368##7	368.862610
Rg9	a_27_368##3	a_27_368##8	451.334412
Rg10	a_27_368##6	a_27_368##9	471.862823
Rg11	a_203_74#	a_203_74##2	380.339874
Rg12	a_203_74##2	a_203_74##3	66.369736
Rg13	a_203_74##3	a_203_74##4	79.357681
Rg14	a_203_74##4	a_203_74##5	101.923378
Rg15	a_203_74##5	a_203_74##6	50.805401
Rg16	a_203_74##6	a_203_74##7	62.014694
Rg17	a_203_74##7	a_203_74##8	380.339874
Rg18	a_203_74##2	a_203_74##9	462.979767
Rg19	a_203_74##3	a_203_74##10	378.278412
Rg20	a_203_74##3	a_203_74##11	461.927856
Rg21	a_203_74##4	a_203_74##12	402.986664
Rg22	a_203_74##4	a_203_74##13	434.549042
Rg23	a_203_74##5	a_203_74##14	355.091431
Rg24	a_203_74##5	a_203_74##15	437.731354
Rg25	a_203_74##6	a_203_74##16	415.552856
Rg26	a_203_74##6	a_203_74##17	447.115234
Rg27	a_203_74##7	a_203_74##18	462.979767
Rg28	a_588_74#	a_588_74##2	467.025726
Rg29	a_588_74##2	a_588_74##3	76.213356
Rg30	a_588_74##3	a_588_74##4	47.585129
Rg31	a_588_74##4	a_588_74##5	31.835342
Rg32	a_588_74##5	a_588_74##6	79.420471
Rg33	a_588_74##6	a_588_74##7	46.230042
Rg34	a_588_74##7	a_588_74##8	26.525404
Rg35	a_588_74##8	a_588_74##9	75.631836
Rg36	a_588_74##9	a_588_74##10	50.400467
Rg37	a_588_74##10	a_588_74##11	40.615833
Rg38	a_588_74##11	a_588_74##12	49.804588
Rg39	a_588_74##12	a_588_74##13	26.457779
Rg40	a_588_74##13	a_588_74##14	41.983566
Rg41	a_588_74##2	a_588_74##15	394.071777
Rg42	a_588_74##3	a_588_74##16	377.345459
Rg43	a_588_74##3	a_588_74##17	459.985352
Rg44	a_588_74##5	a_588_74##18	380.374634
Rg45	a_588_74##5	a_588_74##19	462.815369
Rg46	a_588_74##6	a_588_74##20	377.298279
Rg47	a_588_74##6	a_588_74##21	460.935059
Rg48	a_588_74##8	a_588_74##22	458.507355
Rg49	a_588_74##8	a_588_74##23	490.069763
Rg50	a_588_74##9	a_588_74##24	430.991333
Rg51	a_588_74##9	a_588_74##25	462.553741
Rg52	a_588_74##10	a_588_74##26	439.535522
Rg53	a_588_74##11	a_588_74##27	378.985779
Rg54	a_588_74##12	a_588_74##28	419.997406
Rg55	a_588_74##13	a_588_74##29	408.965149
Rg56	a_588_74##14	a_588_74##30	41.269253
Rg57	a_588_74##30	a_588_74##31	360.195496
Rg58	a_588_74##14	a_588_74##32	442.451355
Rg59	a_588_74##30	a_588_74##33	47.908901
Rg60	a_588_74##33	a_588_74##34	26.329714
Rg61	a_588_74##34	a_588_74##35	370.797485
Rg62	a_588_74##33	a_588_74##36	398.356903
Rg63	a_588_74##34	a_588_74##37	42.324486
Rg64	a_588_74##37	a_588_74##38	40.261318
Rg65	a_588_74##38	a_588_74##39	353.536194
Rg66	a_588_74##37	a_588_74##40	442.451355
Rg67	a_588_74##38	a_588_74##41	45.967308
Rg68	a_588_74##41	a_588_74##42	26.151278
Rg69	a_588_74##42	a_588_74##43	356.880188
Rg70	a_588_74##41	a_588_74##44	390.275360
Rg71	a_588_74##42	a_588_74##45	38.696774
Rg72	a_588_74##45	a_588_74##46	37.240570
Rg73	a_588_74##46	a_588_74##47	364.732513
Rg74	a_588_74##45	a_588_74##48	442.451355
Rg75	a_588_74##46	a_588_74##49	48.546375
Rg76	a_588_74##49	a_588_74##50	26.378531
Rg77	a_588_74##50	a_588_74##51	378.985779
Rg78	a_588_74##49	a_588_74##52	403.511597
Rg79	a_588_74##50	a_588_74##53	38.605347
Rg80	a_588_74##53	a_588_74##54	23.160009
Rg81	a_588_74##54	a_588_74##55	415.552856
Rg82	a_588_74##54	a_588_74##56	62.014694
Rg83	a_588_74##56	a_588_74##57	380.339874
Rg84	a_588_74##54	a_588_74##58	447.115234
Rg85	a_588_74##56	a_588_74##59	462.979767
Rf1	A#4	A#2	161.607086
Rf2	A	A#6	1.374290
Rf3	A#4	A#6	6.881835
Rf4	a_27_368##3	a_27_368##11	74.098434
Rf5	a_27_368##11	a_27_368##12	87.301407
Rf6	a_27_368##11	a_27_368##13	80.540115
Rf7	a_203_74##5	a_203_74##20	86.786751
Rf8	a_203_74##20	a_203_74##21	31.824419
Rf9	a_203_74##21	a_203_74##22	79.746735
Rf10	a_203_74##20	a_203_74##23	24.041357
Rf11	a_203_74##23	a_203_74##24	75.866066
Rf12	a_203_74##21	a_203_74##25	19.163639
Rf13	a_203_74##23	a_203_74##26	25.743959
Rf14	a_588_74##60	a_588_74##61	4.850666
Rf15	a_588_74##61	a_588_74##62	23.618671
Rf16	a_588_74##62	a_588_74##63	62.177109
Rf17	a_588_74##63	a_588_74##64	86.749542
Rf18	a_588_74##61	a_588_74##65	18.074591
Rf19	a_588_74##65	a_588_74##66	58.015179
Rf20	a_588_74##66	a_588_74##67	83.666267
Rf21	a_588_74##62	a_588_74##68	23.680330
Rf22	a_588_74##63	a_588_74##69	19.806370
Rf23	a_588_74##65	a_588_74##70	24.814711
Rf24	a_588_74##66	a_588_74##71	21.161278
Rf25	X#1	X#2	72.652695
Rf26	X#1	X#3	19.861145
Rf27	a_588_74##72	a_588_74##53	177.530106
Rf28	X#4	X#5	19.762726
Rf29	X#5	X#6	80.336922
Rf30	a_588_74##74	a_588_74##45	178.730026
Rf31	X#7	X#8	73.769417
Rf32	X#7	X#9	19.762726
Rf33	a_588_74##76	a_588_74##37	178.730026
Rf34	X#10	X#11	19.762726
Rf35	X#11	X#12	73.769417
Rf36	a_588_74##78	a_588_74##14	177.891617
Rf37	X#13	X#14	77.385017
Rf38	X#13	X#15	19.762726
Rf39	a_588_74##80	a_588_74##10	177.200302
Rf40	X#16	X#17	77.686127
Rf41	X#16	X#18	19.762726
Rf42	a_588_74##82	a_588_74##7	176.283249
Rf43	X#19	X#20	81.507072
Rf44	X#19	X#21	19.762726
Rf45	a_588_74##84	a_588_74##4	166.200958
Rf46	X#23	X#24	14.369054
Rf47	X#24	X#25	63.672009
Rf48	X#22	X#23	5.000000
Rf49	VGND#1	VGND#2	103.406296
Rf50	VGND#2	VGND#3	67.887894
Rf51	VGND#3	VGND#4	66.707092
Rf52	VGND#4	VGND#5	70.126724
Rf53	VGND#5	VGND#6	66.860229
Rf54	VGND#6	VGND#7	66.923912
Rf55	VGND#7	VGND#8	64.196556
Rf56	VGND#8	VGND#9	60.389931
Rf57	VGND#9	VGND#10	67.637634
Rf58	VGND#10	VGND#11	81.171097
Rf59	VGND#2	VGND#12	33.306259
Rf60	VGND#3	VGND#13	33.306259
Rf61	VGND#4	VGND#14	38.608265
Rf62	VGND#5	VGND#15	36.201324
Rf63	VGND#6	VGND#16	39.254818
Rf64	VGND#7	VGND#17	46.079414
Rf65	VGND#8	VGND#18	41.038895
Rf66	VGND#9	VGND#19	56.000061
Rf67	VGND#10	VGND#20	37.066368
Rf68	VGND#11	VGND#21	56.954857
Rf69	VGND#21	VGND#22	75.615547
Rf70	VGND#22	VGND#23	59.909691
Rf72	VGND#11	VGND#25	40.564270
Rf73	VGND#21	VGND#26	33.306259
Rf74	VGND#22	VGND#27	42.655182
Rf75	VGND#23	VGND#28	36.279022
Rf76	VPWR#1	VPWR#2	116.372597
Rf77	VPWR#2	VPWR#3	68.798325
Rf78	VPWR#3	VPWR#4	73.294640
Rf79	VPWR#2	VPWR#5	45.573765
Rf80	VPWR#3	VPWR#6	63.974930
Rf81	VPWR#4	VPWR#7	69.722740
Rf82	VPWR#4	VPWR#8	59.634197
Rf83	VPWR#8	VPWR#9	63.974930
Rf84	VPWR#8	VPWR#10	65.941528
Rf85	VPWR#10	VPWR#11	63.974930
Rf86	VPWR#10	VPWR#12	65.941528
Rf87	VPWR#12	VPWR#13	57.891499
Rf88	VPWR#12	VPWR#14	68.798325
Rf89	VPWR#14	VPWR#15	42.062149
Rf90	VPWR#14	VPWR#16	67.337318
Rf91	VPWR#16	VPWR#17	63.974930
Rf92	VPWR#16	VPWR#18	66.672035
Rf93	VPWR#18	VPWR#19	57.891499
Rf94	VPWR#18	VPWR#20	65.941528
Rf95	VPWR#20	VPWR#21	57.891499
Rf96	VPWR#20	VPWR#22	14.342890
Rf97	VPWR#22	VPWR#23	54.455437
Rf98	VPWR#23	VPWR#24	48.259808
Rf99	VPWR#23	VPWR#25	72.085594
Rf100	VPWR#25	VPWR#26	58.622005
Rf101	VPWR#25	VPWR#27	65.941528
Rf102	VPWR#27	VPWR#28	53.143215
Re1	a_588_74##84	a_588_74##82	10.616781
Re2	a_588_74##82	a_588_74##80	0.857139
Re3	a_588_74##80	a_588_74##78	0.825393
Re4	a_588_74##78	a_588_74##76	0.834464
Re5	a_588_74##76	a_588_74##74	0.816323
Re6	a_588_74##74	a_588_74##72	0.793648
Re7	a_588_74##72	a_588_74##60	10.634922
Re8	X#24	X#27	10.612247
Re9	X#27	X#28	0.816323
Re10	X#28	X#29	0.807253
Re11	X#29	X	0.408162
Re12	X	X#30	0.426302
Re13	X#30	X#31	0.807253
Re14	X#31	X#32	0.834464
Re15	X#32	X#1	10.607711
Re16	VPWR#4	VPWR	2.042809
Re17	VPWR	VPWR#22	1.896894
Re18	VGND#4	VGND	2.042809
Re19	VGND	VGND#11	1.896894
Re29	X#19	X#27	9.777782
Re30	X#16	X#28	9.777782
Re31	X#13	X#29	9.777782
Re32	X#11	X#30	9.777782
Re33	X#7	X#31	9.777782
Re34	X#5	X#32	9.777782
*
*       CAPACITOR CARDS
*
*
C1	X#13	VPWR#7	3.08771e-17
C2	a_588_74##74	a_588_74##42	3.04501e-18
C3	a_588_74##24	a_588_74##22	3.98575e-17
C4	VGND#4	X#17	2.09833e-17
C5	VGND#27	VGND#26	8.91282e-19
C6	a_588_74##17	X#22	1.7727e-17
C7	VGND#16	a_588_74##31	4.33494e-19
C8	a_203_74##23	a_203_74##4	1.50605e-19
C9	a_588_74##70	VPWR#16	8.71971e-18
C10	VGND#4	VGND#14	1.49115e-17
C11	X#13	X#15	1.18506e-18
C12	X#12	X#14	4.86458e-18
C13	VGND#11	VGND#22	6.78682e-17
C14	a_588_74##62	a_588_74##56	1.57499e-19
C15	VGND#4	X#14	2.56148e-17
C16	a_588_74##25	a_588_74##23	4.62111e-17
C17	a_588_74##63	a_203_74##16	4.35075e-20
C18	VGND#11	VGND#21	6.09257e-17
C19	a_588_74##61	X#1	1.43997e-17
C20	VPWR#9	X#13	2.00453e-17
C21	VPWR#3	a_588_74##21	1.01155e-17
C22	X#12	a_588_74##35	3.87745e-17
C23	X#4	VPWR#13	5.70426e-17
C24	VPWR#5	a_588_74##17	5.61894e-17
C25	VGND#11	VGND#10	7.91573e-17
C26	VGND#4	VGND#15	1.41262e-17
C27	a_588_74##61	a_203_74##2	2.5139e-17
C28	VPWR#14	a_588_74##54	1.81849e-20
C29	a_588_74##66	a_203_74##15	1.92407e-17
C30	VGND#26	a_203_74##20	1.1282e-17
C31	VGND#8	X#2	7.21478e-18
C32	VGND#11	VGND#9	5.70411e-17
C33	VGND#2	a_588_74##18	3.30567e-18
C34	VGND#4	X#12	1.97221e-17
C35	a_203_74##21	a_203_74##6	3.84506e-20
C36	VGND#11	VGND#8	6.42854e-17
C37	VPWR#2	a_588_74##21	3.00302e-19
C38	VGND#15	a_588_74##39	3.02014e-19
C39	VGND#7	a_588_74##46	5.61291e-20
C40	a_203_74##21	a_203_74##25	2.79506e-18
C41	X#21	a_588_74##17	1.40358e-18
C42	VGND#11	VGND#7	1.5257e-18
C43	VPWR#16	a_203_74##2	2.02358e-20
C44	a_588_74##35	VGND#16	1.95933e-17
C45	a_588_74##4	VPWR#2	4.71486e-19
C46	VGND#4	X#8	1.9747e-17
C47	a_588_74##27	a_588_74##24	2.84573e-17
C48	a_588_74##78	VPWR#9	3.49129e-18
C49	X#12	VGND#15	7.42397e-17
C50	a_588_74##26	a_588_74##25	4.87101e-17
C51	a_588_74##34	a_588_74##32	9.34303e-19
C52	VPWR#15	VPWR#13	1.94092e-18
C53	VGND#3	a_588_74##20	9.72257e-18
C54	VGND#10	a_588_74##68	8.52896e-18
C55	a_588_74##19	VPWR#5	1.96006e-17
C56	VGND#9	VGND#8	1.10961e-18
C57	a_588_74##71	VPWR#20	8.49478e-18
C58	a_203_74##18	a_203_74##6	1.14316e-18
C59	VPWR#14	VPWR#12	6.99578e-19
C60	VPWR#6	a_588_74##17	1.53981e-19
C61	a_203_74##20	a_203_74##7	2.56405e-19
C62	X#12	a_588_74##39	1.59137e-18
C63	a_588_74##60	a_588_74##61	3.23205e-17
C64	VGND#4	X#6	8.83155e-18
C65	a_588_74##63	a_203_74##8	1.59748e-20
C66	a_203_74##23	VPWR#24	2.02585e-17
C67	VPWR#4	a_588_74##46	3.18e-23
C68	X#8	a_588_74##35	1.56758e-18
C69	VPWR#3	a_588_74##23	7.24757e-18
C70	a_588_74##66	a_203_74##17	2.73577e-19
C71	X#21	a_588_74##19	5.11047e-17
C72	a_203_74##21	a_203_74##4	9.63419e-21
C73	VPWR#14	a_588_74##50	3.41821e-21
C74	a_203_74##21	VGND#27	5.33058e-17
C75	a_588_74##66	VPWR#22	3.09114e-18
C76	X#11	VPWR#9	1.64827e-17
C77	a_203_74##4	a_203_74##3	3.79912e-18
C78	VPWR#15	X#4	5.81263e-17
C79	a_588_74##61	a_203_74##15	4.06e-19
C80	a_588_74##39	VGND#16	2.42084e-17
C81	a_588_74##32	a_588_74##30	7.27519e-19
C82	a_588_74##28	a_588_74##26	4.62154e-17
C83	a_588_74##71	VPWR#18	8.44529e-18
C84	VGND#7	a_588_74##42	3.87914e-20
C85	VPWR#22	a_588_74##65	1.47245e-18
C86	VPWR#2	a_588_74##23	8.74044e-20
C87	a_588_74##61	a_588_74##56	1.00201e-17
C88	VGND#16	VGND#15	2.5336e-18
C89	VPWR#5	a_588_74##21	3.71489e-19
C90	X#11	X#10	1.18628e-18
C91	a_588_74##7	VPWR#3	5.58798e-19
C92	VPWR#4	a_588_74##38	3.18e-23
C93	VGND#9	a_588_74##68	5.22792e-18
C94	VGND#17	a_588_74##35	1.69471e-19
C95	VPWR#6	a_588_74##19	3.44144e-19
C96	a_203_74##23	a_203_74##15	1.88902e-19
C97	a_588_74##29	a_588_74##27	3.98594e-17
C98	X#11	VPWR#11	3.40751e-17
C99	VGND#3	a_588_74##22	3.30567e-18
C100	VPWR#2	a_588_74##5	4.66607e-20
C101	a_203_74##20	a_203_74##6	1.89477e-19
C102	VPWR#8	a_588_74##25	8.1728e-20
C103	a_27_368##13	a_27_368##12	6.89687e-19
C104	a_203_74##22	VGND#27	4.07852e-17
C105	VPWR#22	a_588_74##61	2.18136e-18
C106	a_203_74##23	a_203_74##26	1.15094e-18
C107	X#8	a_588_74##39	4.66531e-17
C108	X#21	a_588_74##21	4.58992e-17
C109	VPWR#22	a_203_74##23	1.45205e-18
C110	VPWR#4	a_588_74##30	7.49371e-20
C111	a_27_368#	a_203_74##7	5.69997e-20
C112	a_203_74##20	VPWR#24	4.93334e-18
C113	a_588_74##32	a_588_74##28	4.87096e-17
C114	VPWR#3	a_588_74##25	2.85183e-19
C115	VGND#16	a_588_74##43	4.46469e-19
C116	VPWR#5	a_588_74##23	1.72497e-19
C117	a_203_74##22	a_203_74##21	2.67638e-18
C118	a_588_74##21	VPWR#6	2.38162e-17
C119	VPWR#22	a_203_74##20	2.09309e-18
C120	VGND#16	X#12	7.38351e-17
C121	VGND#17	a_588_74##39	1.49071e-18
C122	a_588_74##76	VPWR#11	7.03018e-18
C123	a_203_74##5	a_203_74##7	2.14126e-17
C124	VGND#11	a_588_74##65	1.81972e-18
C125	a_203_74##5	a_203_74##6	3.39526e-17
C126	a_588_74##67	VPWR#23	3.66941e-18
C127	a_203_74##23	a_27_368##6	1.18457e-20
C128	VPWR#22	a_27_368##11	7.87562e-19
C129	VGND#11	a_588_74##63	3.60438e-18
C130	a_203_74##5	a_203_74##4	1.65595e-17
C131	X#21	a_588_74##23	1.40358e-18
C132	VGND#20	VGND#9	1.54138e-19
C133	VGND#28	VGND#27	1.15684e-18
C134	X#3	VPWR#15	6.70968e-17
C135	VGND#4	a_588_74##46	2.47517e-19
C136	X#18	a_588_74##21	1.40358e-18
C137	a_203_74##5	a_203_74##3	8.08015e-18
C138	X#24	VPWR#2	2.25223e-18
C139	a_203_74##21	a_203_74##8	1.39738e-18
C140	VPWR#4	VPWR#1	5.54154e-17
C141	VGND#11	a_588_74##62	3.37644e-18
C142	a_588_74##72	VGND#18	2.98536e-18
C143	a_588_74##43	X#8	3.1372e-17
C144	a_203_74##20	a_203_74##4	4.85401e-20
C145	a_588_74##31	a_588_74##29	2.93744e-17
C146	VGND#4	a_588_74##42	3.24645e-23
C147	a_203_74##23	VPWR#26	1.88131e-17
C148	VGND#11	a_588_74##61	1.95743e-18
C149	VPWR#22	A#6	3.43457e-18
C150	a_588_74##36	a_588_74##32	4.62154e-17
C151	VPWR#4	X#22	1.80118e-17
C152	a_588_74##42	a_588_74##40	9.34303e-19
C153	X#6	a_588_74##39	1.65359e-19
C154	a_27_368##2	a_203_74##7	3.36973e-18
C155	VGND#10	a_588_74##69	6.92713e-18
C156	A#6	a_27_368##11	1.9943e-17
C157	VPWR#4	a_588_74##8	1.29234e-19
C158	VGND#8	VGND#7	1.38126e-18
C159	VGND#11	a_203_74##23	2.28162e-18
C160	VPWR#8	a_588_74##26	2.85183e-19
C161	a_588_74##23	VPWR#6	2.96058e-17
C162	VPWR#7	a_588_74##21	1.53981e-19
C163	VGND#6	a_588_74##42	4.22692e-20
C164	VGND#16	a_588_74##47	1.97658e-19
C165	X#7	VPWR#11	3.0192e-17
C166	VPWR#12	VPWR#10	6.93111e-19
C167	VGND#11	a_203_74##21	2.20136e-17
C168	VGND#4	a_588_74##38	1.30696e-19
C169	a_588_74##38	a_588_74##34	3.13369e-18
C170	X#8	X#12	5.22578e-18
C171	a_588_74##66	VPWR#20	2.60402e-19
C172	VPWR#4	X#21	1.75339e-17
C173	a_588_74##43	VGND#17	1.72824e-17
C174	VGND#11	a_203_74##20	3.01276e-18
C175	X#7	X#9	1.18375e-18
C176	a_588_74##61	a_203_74##18	1.97692e-19
C177	VPWR#17	VPWR#15	1.99732e-18
C178	VGND#4	a_588_74##34	3.24645e-23
C179	VPWR#3	a_588_74##26	8.1728e-20
C180	VGND#28	a_203_74##22	3.76784e-17
C181	X#18	a_588_74##23	5.11047e-17
C182	VGND#4	VPWR#1	4.93889e-18
C183	X#7	VPWR#13	3.54509e-17
C184	VGND#11	a_27_368##11	2.99207e-18
C185	a_203_74##23	a_27_368##2	1.27834e-18
C186	X#18	VPWR#4	2.60615e-17
C187	a_588_74##40	a_588_74##36	4.87096e-17
C188	X#8	a_588_74##47	1.87211e-18
C189	a_203_74##23	a_203_74##18	1.71113e-18
C190	VPWR#14	a_588_74##46	1.57866e-20
C191	a_203_74##21	a_27_368##4	3.82385e-17
C192	VGND#4	a_588_74##30	7.97879e-20
C193	a_588_74##14	VPWR#8	6.02454e-19
C194	VPWR#6	a_588_74##25	3.44144e-19
C195	X#6	a_588_74##43	1.54958e-18
C196	VPWR#10	a_588_74##28	8.1728e-20
C197	VPWR#7	a_588_74##23	3.44144e-19
C198	VGND#4	VPWR#5	7.60418e-19
C199	a_203_74##24	a_203_74##23	1.87999e-18
C200	a_588_74##35	a_588_74##31	3.98158e-17
C201	a_588_74##84	VPWR#2	1.40685e-19
C202	X#5	a_588_74##54	6.62315e-19
C203	VGND#6	a_588_74##29	7.78845e-20
C204	X#15	VPWR#4	2.8476e-17
C205	a_588_74##40	a_588_74##34	7.27896e-19
C206	VPWR#17	X#3	5.47039e-17
C207	a_27_368##11	a_203_74##7	1.13757e-19
C208	a_27_368##3	a_203_74##7	8.66289e-20
C209	X#5	a_588_74##50	1.29291e-17
C210	a_27_368##11	a_203_74##8	1.90987e-20
C211	VGND#11	A#4	4.51767e-18
C212	VPWR#2	a_588_74##2	2.58403e-20
C213	X#8	VGND#16	7.37752e-17
C214	a_588_74##47	VGND#17	2.18893e-17
C215	a_203_74##21	a_27_368##6	2.8714e-20
C216	X#18	a_588_74##25	4.59016e-17
C217	VPWR#8	a_588_74##28	5.28126e-18
C218	a_588_74##74	VPWR#13	9.47696e-18
C219	a_27_368##13	a_203_74##22	2.27239e-18
C220	a_588_74##66	VPWR#18	2.60402e-19
C221	VGND#27	a_27_368##2	5.8879e-19
C222	VGND#18	a_588_74##43	1.75596e-19
C223	VPWR#4	X#10	1.79898e-17
C224	a_588_74##44	a_588_74##40	4.62154e-17
C225	a_203_74##26	VPWR#25	9.64518e-18
C226	X#5	a_588_74##46	6.97508e-18
C227	VGND#21	a_588_74##64	5.02379e-18
C228	a_27_368##3	a_27_368##6	2.03641e-17
C229	a_203_74##3	a_203_74##2	3.48e-18
C230	X#8	a_588_74##51	1.79784e-19
C231	VGND#5	a_588_74##29	2.96979e-18
C232	VPWR#6	a_588_74##26	1.53981e-19
C233	a_27_368##3	a_27_368##2	1.60118e-17
C234	X#5	a_588_74##42	2.04977e-19
C235	a_588_74##25	VPWR#7	2.38162e-17
C236	VGND#4	a_588_74##8	3.24645e-23
C237	a_203_74##23	a_27_368#	1.89718e-17
C238	a_27_368##11	a_203_74##22	1.59063e-17
C239	a_588_74##47	X#6	1.81227e-17
C240	a_203_74##21	a_27_368##5	1.49736e-18
C241	VPWR#4	X#9	1.79898e-17
C242	VGND#22	VGND#26	6.91438e-19
C243	a_588_74##60	VGND#19	5.25555e-18
C244	X#19	VPWR#3	1.88226e-18
C245	a_588_74##37	VPWR#10	6.02454e-19
C246	a_588_74##56	a_588_74##54	3.52609e-18
C247	X#18	a_588_74##26	1.40358e-18
C248	A#4	a_27_368##11	2.61458e-17
C249	a_588_74##39	a_588_74##35	2.93479e-17
C250	VGND#4	a_588_74##5	1.88174e-19
C251	X#15	a_588_74##25	1.40358e-18
C252	a_203_74##26	VPWR#23	8.07717e-18
C253	a_27_368##13	VGND#28	3.83514e-17
C254	VGND#17	VGND#16	2.15571e-18
C255	VPWR#10	a_588_74##32	2.85183e-19
C256	VGND#17	a_588_74##51	1.58484e-18
C257	X#19	VPWR#2	1.18576e-18
C258	a_588_74##48	a_588_74##44	4.87096e-17
C259	VPWR#4	X#4	1.29531e-17
C260	a_27_368##11	a_27_368##4	2.5659e-20
C261	VGND#6	a_588_74##31	2.97228e-19
C262	a_203_74##22	a_27_368##6	1.21452e-18
C263	a_203_74##21	a_27_368##2	3.86233e-18
C264	VGND#18	a_588_74##47	1.58569e-18
C265	VGND#7	VGND#6	1.28685e-18
C266	VGND#4	VPWR#11	1.00728e-18
C267	a_588_74##50	a_588_74##48	9.34303e-19
C268	a_588_74##26	VPWR#7	2.96058e-17
C269	VGND#4	a_588_74##2	2.39278e-19
C270	a_588_74##4	X#25	2.43845e-17
C271	VGND#6	a_588_74##38	3.47785e-21
C272	a_588_74##5	X#22	2.20061e-19
C273	VPWR#9	a_588_74##25	1.53981e-19
C274	VPWR#12	a_588_74##46	1.89953e-20
C275	a_588_74##70	VPWR#17	6.31537e-17
C276	VPWR#8	a_588_74##32	6.85973e-18
C277	a_588_74##4	VGND#12	3.34038e-17
C278	a_588_74##65	VPWR#18	2.72608e-19
C279	a_588_74##51	X#6	2.27881e-17
C280	VPWR#10	VPWR#8	6.93111e-19
C281	VGND#4	VPWR#13	1.62235e-18
C282	X#20	a_588_74##4	2.07874e-17
C283	a_27_368##11	VGND#28	2.62475e-17
C284	a_588_74##72	a_588_74##54	3.06743e-18
C285	VGND#5	a_588_74##31	5.41223e-18
C286	a_203_74##23	a_27_368##8	3.24712e-19
C287	VGND#7	a_588_74##35	8.63948e-20
C288	X#15	a_588_74##26	5.11047e-17
C289	a_203_74##21	a_27_368##7	2.32052e-19
C290	X#2	a_588_74##47	1.61648e-19
C291	a_203_74##20	a_27_368##6	6.66041e-20
C292	a_588_74##52	a_588_74##48	4.6225e-17
C293	a_588_74##72	a_588_74##50	2.81571e-18
C294	VPWR#12	a_588_74##36	8.1728e-20
C295	VGND#17	X#8	5.63242e-17
C296	VGND#17	a_588_74##55	1.78086e-19
C297	a_588_74##8	a_588_74##5	3.52807e-18
C298	a_588_74##45	VPWR#12	6.02454e-19
C299	a_588_74##82	VPWR#3	4.16151e-19
C300	a_588_74##43	a_588_74##39	3.98416e-17
C301	VPWR#7	a_588_74##28	3.44144e-19
C302	VPWR#19	VPWR#17	1.8524e-18
C303	VGND#18	a_588_74##51	1.40406e-17
C304	A#2	a_27_368##6	2.56088e-17
C305	VGND#11	X#6	9.12108e-18
C306	a_27_368##11	a_27_368##5	7.38057e-19
C307	VPWR#9	a_588_74##26	3.44144e-19
C308	VPWR#10	a_588_74##36	5.15875e-18
C309	VGND#6	a_588_74##35	4.64288e-18
C310	X#5	VPWR#13	3.00169e-17
C311	VGND#11	X#2	1.53286e-17
C312	a_588_74##48	a_588_74##42	7.27896e-19
C313	a_27_368##11	a_203_74##24	3.78231e-17
C314	X#6	a_588_74##55	1.76928e-18
C315	X#15	a_588_74##28	4.59029e-17
C316	VGND#6	a_588_74##34	3.34408e-20
C317	X#5	X#4	1.18628e-18
C318	a_588_74##58	a_588_74##52	3.85897e-17
C319	a_588_74##7	X#20	2.07497e-17
C320	X#2	a_588_74##51	3.54603e-19
C321	VPWR#8	a_588_74##36	2.85183e-19
C322	VGND#11	a_588_74##68	1.74862e-17
C323	X#5	VPWR#15	3.65371e-17
C324	a_588_74##7	VGND#13	3.12909e-17
C325	a_203_74##21	A#1	1.48515e-20
C326	VPWR#19	a_588_74##70	5.87756e-17
C327	a_588_74##30	X#18	1.04529e-19
C328	a_203_74##20	a_27_368##2	1.3331e-17
C329	X#6	X#8	4.99847e-18
C330	VPWR#7	a_588_74##32	1.53981e-19
C331	X#17	a_588_74##7	2.09279e-17
C332	VGND#7	a_588_74##39	3.09852e-19
C333	a_588_74##28	VPWR#9	2.38162e-17
C334	a_203_74##24	VPWR#25	8.7112e-18
C335	a_588_74##2	X#22	2.17861e-19
C336	VGND#11	a_588_74##69	1.98618e-17
C337	a_588_74##84	VGND#2	9.75342e-19
C338	VGND#18	a_588_74##55	3.6656e-17
C339	a_588_74##5	VPWR#5	2.03067e-18
C340	VPWR#12	a_588_74##40	2.85183e-19
C341	a_588_74##53	VPWR#14	3.5507e-19
C342	a_27_368##11	a_27_368##7	4.85129e-18
C343	a_588_74##47	a_588_74##43	4.06589e-17
C344	a_588_74##8	X#21	1.65046e-19
C345	a_588_74##59	a_588_74##58	4.61809e-17
C346	X#15	a_588_74##32	1.40358e-18
C347	VGND#11	a_588_74##64	2.41855e-17
C348	X#16	VPWR#3	1.16249e-18
C349	X#10	a_588_74##28	1.40196e-18
C350	X#1	a_588_74##56	8.03423e-18
C351	X#6	a_588_74##57	1.69467e-19
C352	VGND#11	VGND#26	2.21698e-17
C353	a_27_368##11	VPWR#28	2.00062e-17
C354	a_588_74##72	VPWR#15	1.00579e-17
C355	VGND#6	a_588_74##39	7.97616e-18
C356	a_203_74##23	VPWR#25	2.5317e-19
C357	X#1	a_588_74##54	6.46901e-18
C358	a_588_74##71	a_588_74##70	1.38573e-18
C359	VGND#8	a_588_74##43	9.33107e-20
C360	VPWR#10	a_588_74##40	6.85973e-18
C361	X#2	a_588_74##55	1.32499e-17
C362	VGND#6	VGND#5	1.2976e-18
C363	X#1	a_588_74##50	2.4684e-19
C364	a_588_74##32	VPWR#9	2.96058e-17
C365	VPWR#11	a_588_74##28	1.53981e-19
C366	X#24	a_588_74#	1.14932e-17
C367	X#6	VGND#17	6.37146e-17
C368	a_588_74##10	X#17	2.0811e-17
C369	X#20	a_588_74##30	7.85549e-20
C370	VGND#11	a_203_74##22	1.26162e-17
C371	a_27_368##11	a_27_368##9	6.20428e-18
C372	VPWR#8	a_588_74##40	8.1728e-20
C373	VGND#18	a_588_74##57	1.84067e-18
C374	a_203_74##9	a_588_74##59	4.55196e-17
C375	a_588_74##10	VGND#14	2.93057e-17
C376	X#24	a_588_74##17	1.21876e-17
C377	VPWR#14	a_588_74##44	8.74044e-20
C378	a_203_74##5	VPWR#23	3.35332e-19
C379	X#10	a_588_74##32	5.10731e-17
C380	VGND#7	a_588_74##43	9.23029e-18
C381	VGND#19	a_588_74##55	2.28222e-19
C382	X#14	a_588_74##10	1.21147e-17
C383	VGND#11	a_27_368##13	1.59057e-17
C384	X#1	VPWR#15	3.68626e-17
C385	a_27_368##11	A#1	6.81915e-18
C386	a_588_74##71	VPWR#19	6.12884e-17
C387	a_588_74##84	a_588_74#	2.36723e-18
C388	X#22	VPWR#1	5.6597e-17
C389	a_588_74##51	a_588_74##47	4.07913e-17
C390	X#24	a_588_74##19	4.73952e-19
C391	VGND#5	a_588_74##34	3.95939e-20
C392	X#1	X#3	7.03894e-19
C393	VPWR#12	a_588_74##44	5.15441e-18
C394	VGND#22	a_203_74##22	5.51402e-18
C395	VPWR#9	a_588_74##36	3.44144e-19
C396	X#2	a_588_74##57	3.75574e-17
C397	VPWR#11	a_588_74##32	3.44144e-19
C398	a_588_74##84	a_588_74##17	1.44352e-18
C399	a_27_368##11	a_27_368##12	1.57768e-18
C400	A#6	a_27_368##9	2.81734e-19
C401	a_588_74##34	a_588_74##30	3.52575e-18
C402	VPWR#17	X#1	2.47933e-17
C403	a_588_74##54	a_588_74##50	4.00498e-18
C404	X#24	a_588_74##21	1.37607e-19
C405	a_588_74##30	VPWR#7	1.69798e-18
C406	VGND#4	a_588_74##15	4.96597e-18
C407	VGND#6	a_588_74##43	3.11389e-19
C408	X#19	a_588_74#	4.32401e-19
C409	a_203_74##11	a_203_74##9	4.62115e-17
C410	X#1	a_588_74##70	8.74197e-19
C411	VGND#18	VGND#17	2.23186e-18
C412	VGND#8	a_588_74##47	3.15057e-19
C413	a_588_74##84	a_588_74##19	1.03587e-18
C414	VPWR#10	a_588_74##44	2.85183e-19
C415	VGND#4	a_588_74##16	5.00651e-18
C416	X#10	a_588_74##36	4.58797e-17
C417	a_588_74##5	X#21	1.0783e-19
C418	VGND#18	a_203_74#	1.90842e-19
C419	VPWR#21	VPWR#19	1.87864e-18
C420	X#19	a_588_74##17	1.08077e-18
C421	a_27_368##11	A#3	2.7551e-18
C422	a_588_74##8	VPWR#6	3.17436e-18
C423	VGND#4	a_588_74##18	2.11945e-18
C424	a_588_74##57	VGND#19	1.56191e-17
C425	X#1	a_588_74##71	8.87177e-19
C426	a_588_74##14	X#14	1.20556e-17
C427	a_588_74##82	VGND#3	2.40074e-18
C428	VPWR#5	VPWR#1	2.1297e-18
C429	a_27_368##11	a_27_368##6	2.24573e-18
C430	VGND#4	a_588_74##20	2.40802e-18
C431	a_588_74##14	VGND#15	2.80643e-17
C432	X#19	a_588_74##19	1.45713e-17
C433	a_588_74##60	a_588_74##56	2.02579e-18
C434	VPWR#12	a_588_74##38	3.20522e-20
C435	VPWR#9	a_588_74##40	1.53981e-19
C436	a_588_74##36	VPWR#11	2.38162e-17
C437	a_588_74##60	VPWR#17	1.56261e-17
C438	VGND#21	a_203_74##5	4.29419e-19
C439	VPWR#25	a_27_368##3	6.94814e-20
C440	VGND#7	a_588_74##47	7.56338e-18
C441	X#25	a_588_74##8	8.07037e-20
C442	X#12	a_588_74##14	1.34005e-17
C443	VPWR#14	a_588_74##48	3.00302e-19
C444	a_588_74##82	VGND#2	4.77531e-20
C445	a_203_74##13	a_203_74##11	4.50094e-17
C446	VGND#4	a_588_74##22	1.99518e-18
C447	X#2	a_203_74#	1.78137e-18
C448	a_588_74##55	a_588_74##51	3.96973e-17
C449	a_588_74##4	VPWR#5	2.02878e-17
C450	X#19	a_588_74##21	1.06877e-17
C451	VPWR#22	X#4	4.99883e-18
C452	A#6	A#3	3.80066e-18
C453	a_588_74##68	a_588_74##57	1.93262e-18
C454	VGND#4	a_588_74##24	6.30341e-18
C455	X#13	VPWR#8	9.94858e-19
C456	VPWR#21	a_588_74##71	6.13534e-17
C457	X#10	a_588_74##40	1.40196e-18
C458	VGND#18	X#6	5.38672e-17
C459	X#9	a_588_74##36	1.40358e-18
C460	VPWR#2	VPWR#1	4.50257e-20
C461	VGND#28	VGND#22	1.20311e-18
C462	X#24	a_588_74##5	6.38276e-18
C463	VPWR#12	a_588_74##48	7.18469e-18
C464	X#19	a_588_74##23	6.21397e-19
C465	VGND#4	a_588_74##27	5.6228e-18
C466	A#6	a_27_368##12	3.72726e-17
C467	VPWR#22	X#3	1.77957e-17
C468	VGND#6	a_588_74##47	8.51141e-20
C469	a_588_74##82	a_588_74##21	5.99454e-19
C470	a_203_74#	VGND#19	1.95184e-17
C471	a_588_74##66	a_588_74##65	1.56077e-18
C472	VPWR#5	X#22	6.54251e-17
C473	VGND#4	a_588_74##29	2.51368e-18
C474	VGND#8	a_588_74##51	9.2905e-18
C475	X#19	a_588_74##25	9.71329e-20
C476	a_588_74##40	VPWR#11	2.96058e-17
C477	A#4	a_27_368##13	3.64488e-17
C478	VPWR#13	a_588_74##36	1.53981e-19
C479	a_203_74##15	a_203_74##13	4.54695e-17
C480	VPWR#10	a_588_74##48	8.1728e-20
C481	VGND#20	a_588_74##57	1.36305e-19
C482	VPWR#22	a_588_74##70	1.96777e-17
C483	a_203_74##3	a_588_74##70	1.54062e-19
C484	VGND#4	a_588_74##31	9.57068e-19
C485	a_27_368##11	a_27_368##2	1.70665e-19
C486	X#24	a_588_74##2	7.28745e-18
C487	VPWR#16	a_588_74##52	7.58842e-20
C488	a_588_74##37	X#12	1.33028e-17
C489	a_588_74##67	a_588_74##71	1.40629e-18
C490	VGND#4	a_588_74##35	2.0486e-18
C491	X#16	a_588_74##21	1.10761e-18
C492	VGND#11	VPWR#15	1.16916e-18
C493	X#9	a_588_74##40	5.11047e-17
C494	a_588_74##37	VGND#16	2.5801e-17
C495	a_588_74##30	X#15	1.76068e-19
C496	VGND#22	a_27_368##3	4.65699e-20
C497	VPWR#22	a_588_74##71	1.75738e-17
C498	a_203_74#	a_588_74##68	1.19758e-17
C499	a_588_74##59	a_588_74##54	9.31538e-19
C500	a_588_74##57	a_588_74##55	3.98407e-17
C501	VGND#7	a_588_74##51	3.72406e-19
C502	a_588_74##61	VPWR#16	3.13995e-19
C503	X#8	a_588_74##37	1.35106e-17
C504	a_588_74##7	VPWR#6	1.63663e-17
C505	VGND#4	a_588_74##39	1.97805e-18
C506	X#2	X#6	4.61286e-18
C507	X#16	a_588_74##23	1.29487e-17
C508	VPWR#3	VPWR#2	6.99578e-19
C509	VGND#9	a_588_74##55	4.13661e-19
C510	VPWR#14	a_588_74##52	5.5344e-18
C511	VGND#11	VPWR#17	1.13278e-18
C512	VGND#4	a_588_74##43	2.09405e-18
C513	a_203_74##17	a_203_74##15	4.71858e-17
C514	VGND#5	a_588_74##30	4.10178e-20
C515	a_588_74##67	VPWR#22	3.21331e-17
C516	VPWR#11	a_588_74##44	3.44144e-19
C517	a_588_74##8	X#18	1.02348e-19
C518	VPWR#13	a_588_74##40	3.44144e-19
C519	VGND#19	a_203_74##10	1.86285e-18
C520	X#16	a_588_74##25	9.39488e-18
C521	a_203_74##2	a_588_74##70	1.62845e-19
C522	a_588_74##78	VPWR#8	2.12912e-19
C523	VGND#4	a_588_74##47	2.35057e-18
C524	X#22	VPWR#2	1.75214e-17
C525	a_203_74##5	a_588_74##66	8.84362e-17
C526	VGND#20	a_203_74#	3.00133e-19
C527	a_588_74##67	VPWR#21	6.10077e-17
C528	VPWR#12	a_588_74##52	2.85183e-19
C529	VPWR#10	a_588_74##38	2.91026e-20
C530	VPWR#22	a_203_74##26	2.01388e-17
C531	a_203_74##5	a_588_74##65	3.32785e-18
C532	VPWR#22	a_588_74##56	3.18e-23
C533	X#16	a_588_74##26	1.0169e-18
C534	VPWR#19	a_203_74##4	3.89281e-19
C535	X#9	a_588_74##44	4.59029e-17
C536	VGND#8	a_588_74##55	6.36936e-18
C537	a_588_74##63	a_203_74##5	8.46008e-17
C538	a_203_74##20	VPWR#23	4.82391e-19
C539	a_588_74##62	a_203_74##5	5.31215e-18
C540	VGND#10	a_588_74##57	1.51015e-19
C541	X#25	a_588_74##5	8.8493e-18
C542	X#16	a_588_74##28	9.35729e-20
C543	a_203_74##18	a_203_74##17	4.55429e-17
C544	X#19	a_588_74##30	9.24853e-20
C545	a_588_74##68	a_203_74##10	3.13068e-17
C546	a_203_74##5	a_588_74##61	1.8188e-17
C547	VPWR#22	a_203_74##24	1.8522e-17
C548	a_27_368##2	a_203_74##8	5.76733e-20
C549	X#1	a_203_74##2	1.48913e-18
C550	a_588_74##84	a_588_74##5	2.18082e-18
C551	a_588_74##45	X#8	1.35106e-17
C552	X#17	a_588_74##30	9.64971e-18
C553	a_588_74##80	VGND#3	3.32825e-20
C554	X#2	VGND#18	6.42923e-17
C555	a_588_74##80	a_588_74##26	9.52088e-19
C556	VPWR#11	a_588_74##48	1.53981e-19
C557	a_588_74##44	VPWR#13	2.38162e-17
C558	VPWR#16	a_588_74##58	4.85631e-19
C559	a_588_74##45	VGND#17	2.09705e-17
C560	a_588_74##10	VPWR#7	1.36719e-17
C561	X#21	VPWR#5	5.81154e-17
C562	a_203_74#	a_588_74##57	4.05591e-17
C563	X#6	a_588_74##45	1.27608e-17
C564	VPWR#22	a_27_368##12	1.95836e-17
C565	VPWR#24	VPWR#21	1.94092e-18
C566	X#13	a_588_74##25	8.85033e-19
C567	VGND#7	a_588_74##55	1.02126e-19
C568	VGND#19	a_203_74##12	1.06119e-19
C569	VGND#9	a_588_74##57	7.5923e-18
C570	VPWR#19	a_203_74##3	9.06769e-19
C571	VGND#1	VPWR#1	1.12128e-17
C572	a_203_74##10	VGND#20	1.67271e-17
C573	X#9	a_588_74##48	1.40358e-18
C574	X#11	VPWR#10	1.46487e-18
C575	X#4	a_588_74##44	1.40196e-18
C576	VPWR#14	a_588_74##58	6.74959e-18
C577	X#13	a_588_74##26	1.49205e-17
C578	a_27_368#	a_203_74##18	6.1966e-18
C579	VGND#11	a_203_74##24	3.03303e-18
C580	VGND#1	X#25	7.74256e-17
C581	VGND#19	VPWR#17	9.54163e-19
C582	X#11	VPWR#8	1.00366e-18
C583	X#13	a_588_74##28	9.14145e-18
C584	a_588_74##30	VPWR#9	1.29046e-18
C585	VGND#21	a_203_74##7	5.35053e-21
C586	a_588_74##68	a_203_74##12	1.16e-18
C587	a_588_74##48	VPWR#13	2.96058e-17
C588	VPWR#12	a_588_74##58	7.86402e-20
C589	VPWR#15	a_588_74##44	1.72497e-19
C590	VPWR#10	a_588_74##34	2.05092e-21
C591	VGND#3	VGND#2	1.13178e-18
C592	VPWR#24	a_588_74##67	8.70705e-17
C593	VGND#8	a_588_74##57	4.34401e-19
C594	VPWR#6	VPWR#5	1.94092e-18
C595	X#13	a_588_74##32	1.01173e-18
C596	VGND#19	VGND#18	1.53493e-18
C597	a_588_74##69	a_203_74##10	3.66832e-19
C598	a_588_74##34	X#10	1.65046e-20
C599	VPWR#18	a_588_74##59	7.87992e-20
C600	VGND#10	a_203_74#	4.52951e-19
C601	a_27_368##3	a_203_74##23	3.20683e-17
C602	VGND#3	a_588_74##30	3.82563e-20
C603	A#6	a_27_368##6	4.8646e-19
C604	a_588_74##53	X#6	1.28555e-17
C605	a_588_74##14	VPWR#9	1.13612e-17
C606	a_27_368##8	a_27_368#	4.86904e-17
C607	a_588_74##60	a_203_74##6	5.00959e-20
C608	a_203_74##21	a_27_368##3	3.63018e-17
C609	X#21	VPWR#3	8.52757e-18
C610	X#13	a_588_74##36	9.16482e-20
C611	a_203_74##10	a_203_74#	3.98322e-17
C612	X#4	a_588_74##48	5.10731e-17
C613	X#19	a_588_74##8	7.41464e-18
C614	a_588_74##53	VGND#18	2.58728e-17
C615	a_27_368##3	a_203_74##20	3.76851e-17
C616	VGND#1	a_588_74##15	2.73805e-17
C617	a_588_74##60	a_203_74##4	2.93128e-19
C618	VGND#20	a_203_74##12	3.20723e-17
C619	X#2	a_588_74##53	2.07601e-17
C620	a_588_74##78	a_588_74##32	9.47084e-19
C621	X#20	a_588_74##8	7.55561e-18
C622	VPWR#16	a_588_74##59	9.37093e-18
C623	a_27_368##11	a_27_368##3	3.82582e-19
C624	a_588_74##60	a_203_74##3	1.894e-18
C625	VGND#11	a_588_74##56	3.24645e-23
C626	a_588_74##5	a_588_74##2	3.20297e-18
C627	X#11	a_588_74##28	8.86647e-19
C628	X#24	VGND#12	1.6882e-18
C629	VPWR#13	a_588_74##52	3.44144e-19
C630	VPWR#15	a_588_74##48	3.71489e-19
C631	VGND#12	VGND#1	1.79195e-18
C632	VGND#9	a_203_74#	3.61943e-18
C633	VGND#12	a_588_74##5	6.13361e-18
C634	VGND#11	a_588_74##54	2.20389e-19
C635	X#14	a_588_74##34	8.60111e-20
C636	a_588_74##68	a_203_74##14	1.73843e-19
C637	VPWR#6	X#21	5.71742e-17
C638	X#19	a_588_74##5	4.50186e-18
C639	a_588_74##76	VPWR#10	2.04793e-19
C640	X#11	a_588_74##32	1.54945e-17
C641	a_27_368##9	a_27_368##8	4.7019e-17
C642	VPWR#14	a_588_74##59	3.40282e-19
C643	a_588_74##62	a_588_74##65	6.64669e-18
C644	VGND#11	a_588_74##50	3.24645e-23
C645	VPWR#4	a_588_74#	5.34963e-18
C646	VGND#14	a_588_74##30	4.31818e-18
C647	a_203_74##12	a_588_74##69	1.17854e-17
C648	VGND#19	X#2	6.82336e-17
C649	X#25	a_588_74##2	1.04427e-17
C650	X#25	a_588_74##15	4.06095e-17
C651	X#4	a_588_74##52	4.58797e-17
C652	X#11	a_588_74##36	8.97702e-18
C653	X#21	VPWR#2	8.44089e-18
C654	VPWR#4	a_588_74##17	1.83481e-18
C655	a_588_74##38	VPWR#11	8.82949e-19
C656	VGND#8	a_203_74#	1.12262e-19
C657	a_588_74##37	VPWR#11	9.05045e-18
C658	a_203_74##23	A#2	1.84931e-20
C659	a_588_74##78	VGND#5	1.7668e-18
C660	VPWR#4	a_588_74##19	1.13994e-18
C661	X#11	a_588_74##40	1.0139e-18
C662	VGND#20	a_203_74##14	1.26164e-18
C663	a_203_74##21	A#2	4.70298e-20
C664	a_203_74##12	a_203_74##10	2.40001e-17
C665	a_203_74##26	VPWR#24	5.97923e-17
C666	VGND#10	a_203_74##10	5.28869e-18
C667	VGND#1	a_588_74##16	1.39059e-18
C668	a_203_74##20	A#2	2.1035e-19
C669	a_588_74##52	VPWR#15	2.70954e-17
C670	VPWR#13	a_588_74##58	1.54166e-19
C671	A#3	a_27_368##9	4.86065e-17
C672	VPWR#18	a_203_74##9	2.73569e-19
C673	VGND#25	a_203_74##12	2.927e-19
C674	VPWR#4	a_588_74##21	1.82485e-18
C675	X#11	a_588_74##44	9.16482e-20
C676	VPWR#21	a_203_74##6	7.83584e-19
C677	a_27_368##11	A#2	1.03092e-17
C678	a_203_74##5	VGND#20	1.88637e-18
C679	a_588_74##84	VGND#12	3.41184e-18
C680	a_588_74##30	X#10	1.57363e-19
C681	VGND#12	a_588_74##15	1.43402e-18
C682	VPWR#4	a_588_74##23	1.54344e-18
C683	a_588_74##76	a_588_74##40	9.53387e-19
C684	VGND#12	X#25	6.4743e-17
C685	A#6	A#2	8.96598e-18
C686	a_203_74##5	a_588_74##69	2.51339e-18
C687	a_588_74##50	a_588_74##46	3.52856e-18
C688	X#4	a_588_74##58	1.22945e-18
C689	X#3	a_588_74##52	1.12004e-18
C690	VPWR#16	a_203_74##9	6.4328e-18
C691	VPWR#22	a_203_74##7	2.25602e-20
C692	a_588_74##69	a_203_74##14	3.12532e-17
C693	a_203_74##5	VGND#25	4.26802e-18
C694	VGND#2	VGND#1	9.34474e-19
C695	X#7	a_588_74##36	8.85033e-19
C696	VPWR#4	a_588_74##25	7.85947e-18
C697	A#4	A#2	1.48613e-17
C698	X#7	VPWR#12	1.46485e-18
C699	VGND#9	a_203_74##10	4.4735e-19
C700	a_203_74##5	a_588_74##64	4.81381e-17
C701	VPWR#11	a_588_74##34	4.21599e-19
C702	a_588_74##63	a_588_74##62	2.01799e-19
C703	VPWR#22	a_203_74##6	1.81849e-20
C704	VGND#26	a_203_74##5	2.27715e-17
C705	VGND#11	a_588_74##51	2.24249e-18
C706	X#25	a_588_74##16	3.8432e-17
C707	VPWR#26	VPWR#24	1.99722e-18
C708	VPWR#4	a_588_74##26	8.06392e-18
C709	X#7	a_588_74##40	1.49592e-17
C710	a_588_74##82	a_588_74##8	5.05079e-18
C711	X#7	VPWR#10	1.07338e-18
C712	a_588_74##58	VPWR#15	3.38402e-17
C713	VPWR#14	a_203_74##9	9.36537e-20
C714	VPWR#17	a_588_74##52	1.51244e-19
C715	VGND#11	a_588_74##55	2.16967e-18
C716	VGND#20	a_203_74##16	1.48892e-19
C717	a_588_74##45	VPWR#13	9.05045e-18
C718	VGND#13	a_588_74##8	4.74052e-18
C719	VPWR#4	a_588_74##28	2.2834e-18
C720	X#7	a_588_74##44	8.95632e-18
C721	VPWR#22	a_203_74##3	3.18e-23
C722	VGND#11	a_588_74##57	2.23304e-18
C723	a_203_74##14	VGND#25	1.6698e-17
C724	a_203_74##14	a_203_74##12	3.95267e-17
C725	X#2	a_203_74##2	2.38223e-18
C726	X#8	a_588_74##50	9.30644e-20
C727	VPWR#20	a_203_74##11	8.09218e-20
C728	VGND#1	a_588_74##18	2.89691e-19
C729	X#18	VPWR#6	5.71137e-17
C730	VPWR#4	a_588_74##32	9.69435e-19
C731	X#20	a_588_74##5	4.13728e-18
C732	X#7	a_588_74##48	1.01229e-18
C733	X#3	a_588_74##58	5.18174e-17
C734	VPWR#10	a_588_74##30	1.70701e-20
C735	a_588_74##67	a_203_74##7	1.59724e-18
C736	a_588_74##46	VPWR#13	1.16366e-18
C737	VPWR#25	VPWR#23	7.25855e-19
C738	X#16	a_588_74##30	8.97814e-18
C739	VGND#10	a_203_74##12	4.99713e-18
C740	VGND#11	a_203_74##10	1.05688e-19
C741	VPWR#4	a_588_74##36	1.81269e-18
C742	VGND#12	a_588_74##16	1.71541e-17
C743	X#20	X#25	4.67628e-18
C744	X#7	a_588_74##52	9.16482e-20
C745	a_588_74##69	a_203_74##16	1.16e-18
C746	VPWR#26	a_203_74##26	6.12645e-17
C747	X#14	a_588_74##30	9.50408e-18
C748	VPWR#18	a_203_74##11	7.37528e-18
C749	a_588_74##68	VGND#19	3.30424e-17
C750	VGND#11	a_203_74##12	1.14703e-18
C751	X#18	VPWR#3	8.44089e-18
C752	VGND#10	a_203_74##6	1.95294e-20
C753	a_588_74##64	a_203_74##14	4.0054e-19
C754	VPWR#4	a_588_74##40	9.0813e-19
C755	a_588_74##74	a_588_74##48	9.53387e-19
C756	VPWR#17	a_588_74##58	5.9375e-19
C757	VPWR#15	a_588_74##59	4.09711e-19
C758	VGND#11	a_203_74##14	5.34738e-18
C759	a_588_74##50	X#4	2.75077e-20
C760	a_588_74##38	X#9	1.90372e-19
C761	VGND#2	X#25	1.42387e-17
C762	VPWR#4	a_588_74##44	1.81343e-18
C763	X#25	a_588_74##18	2.07888e-18
C764	a_27_368##3	VGND#27	3.15925e-18
C765	VGND#11	a_203_74##16	5.65049e-18
C766	VPWR#16	a_203_74##11	2.85412e-19
C767	a_588_74##84	X#24	3.09195e-17
C768	VGND#9	a_203_74##12	1.43864e-19
C769	a_27_368##3	a_203_74##22	4.10433e-17
C770	a_588_74##53	VPWR#15	1.90637e-17
C771	a_588_74##74	VPWR#12	2.1701e-19
C772	VGND#11	a_203_74##8	2.12183e-18
C773	VGND#25	a_203_74##16	3.20723e-17
C774	VPWR#7	VPWR#6	1.87864e-18
C775	VGND#28	a_27_368##3	1.6166e-18
C776	X#3	a_588_74##59	4.60135e-17
C777	VPWR#4	a_588_74##48	8.56208e-19
C778	a_588_74##67	a_203_74##6	1.28747e-18
C779	X#20	a_588_74##16	7.85099e-20
C780	VPWR#13	a_588_74##42	1.8228e-18
C781	VGND#11	a_27_368##4	5.44481e-19
C782	a_203_74##24	a_203_74##26	1.11023e-18
C783	a_203_74##16	a_203_74##14	2.40001e-17
C784	X#19	X#24	2.23455e-18
C785	a_588_74##76	VGND#6	1.54829e-18
C786	X#12	a_588_74##38	2.24963e-19
C787	VGND#11	a_27_368##5	6.27401e-19
C788	VGND#11	a_203_74##7	5.43079e-20
C789	a_588_74##59	VPWR#17	2.42135e-17
C790	a_588_74##69	a_203_74##8	1.73843e-19
C791	VPWR#15	a_203_74##9	1.78485e-19
C792	a_588_74##76	VGND#5	4.46975e-20
C793	A#4	a_27_368##6	1.13427e-18
C794	VGND#11	a_27_368##7	2.39989e-19
C795	a_588_74##84	X#19	8.5154e-17
C796	VGND#12	a_588_74##18	4.43337e-17
C797	VGND#20	VGND#19	1.42281e-18
C798	X#20	VGND#12	6.48927e-17
C799	VGND#11	a_203_74##6	4.89574e-20
C800	VPWR#20	a_203_74##13	2.85183e-19
C801	a_588_74##64	a_203_74##16	2.93586e-17
C802	VGND#11	A#1	2.59616e-18
C803	X#5	a_588_74##44	8.86647e-19
C804	a_588_74##62	X#2	3.3285e-18
C805	VGND#10	a_203_74##14	5.78122e-19
C806	X#16	a_588_74##8	6.2199e-18
C807	a_588_74##70	a_588_74##59	1.49908e-18
C808	X#3	a_203_74##9	1.41034e-18
C809	X#5	a_588_74##48	1.49491e-17
C810	VGND#11	a_203_74##3	1.78555e-21
C811	VPWR#7	X#18	5.71742e-17
C812	X#17	a_588_74##8	4.24695e-18
C813	a_203_74##24	VPWR#26	6.23134e-17
C814	X#25	a_588_74##20	2.13621e-19
C815	VGND#10	a_203_74##4	4.09316e-20
C816	VPWR#18	a_203_74##13	5.19108e-18
C817	a_588_74##54	VPWR#15	2.14625e-18
C818	VGND#25	a_203_74##8	1.46243e-18
C819	VGND#11	a_203_74##2	3.37631e-21
C820	a_27_368##13	A#2	5.80648e-18
C821	a_588_74##82	VGND#13	3.5554e-18
C822	X#5	a_588_74##52	9.03994e-18
C823	a_588_74##82	X#19	6.70778e-17
C824	VGND#26	a_203_74##16	1.14045e-18
C825	X#6	a_588_74##56	8.7724e-20
C826	a_203_74##5	VPWR#19	1.56494e-18
C827	VPWR#4	VPWR#14	6.13104e-18
C828	X#8	a_588_74##46	2.20751e-19
C829	a_588_74##18	X#20	1.53889e-17
C830	VGND#11	a_27_368##6	3.47941e-20
C831	VPWR#19	a_588_74##59	1.52075e-19
C832	a_203_74##9	VPWR#17	3.01545e-17
C833	VPWR#8	a_588_74##30	2.78826e-20
C834	X#5	a_588_74##58	7.59852e-19
C835	a_203_74##5	a_588_74##71	2.35532e-18
C836	VGND#3	X#20	5.77431e-18
C837	VPWR#16	a_203_74##13	8.10987e-20
C838	a_203_74##8	a_203_74##16	3.86761e-17
C839	a_588_74##80	a_588_74##30	5.46849e-18
C840	X#12	a_588_74##34	7.36228e-18
C841	a_588_74##46	X#4	1.4636e-19
C842	VGND#11	a_27_368##2	3.49782e-20
C843	X#16	X#19	1.81453e-18
C844	a_203_74##5	VPWR#21	2.37113e-18
C845	X#20	a_588_74##2	1.12267e-19
C846	VPWR#4	VPWR#12	5.92096e-17
C847	VGND#15	a_588_74##30	4.3398e-18
C848	X#5	a_588_74##59	2.42954e-19
C849	X#15	VPWR#8	6.41654e-18
C850	a_203_74##5	a_588_74##67	5.29076e-17
C851	VGND#20	a_588_74##68	4.20273e-17
C852	a_588_74##4	a_588_74##8	5.21467e-20
C853	a_588_74##64	a_203_74##8	3.96125e-17
C854	a_588_74##66	a_203_74##6	4.59564e-18
C855	a_203_74##5	VPWR#24	3.12486e-17
C856	a_588_74##70	a_203_74##9	5.55277e-17
C857	VGND#12	a_588_74##20	2.37027e-18
C858	VPWR#4	VPWR#10	5.90679e-17
C859	VGND#13	VGND#12	1.89091e-18
C860	a_588_74##4	a_588_74##17	2.58077e-18
C861	VPWR#23	a_203_74##15	8.74044e-20
C862	a_588_74##82	X#16	9.21717e-17
C863	VPWR#28	VPWR#26	1.87864e-18
C864	a_588_74##61	X#2	1.28287e-17
C865	a_588_74##50	VPWR#15	9.45646e-19
C866	a_588_74##4	a_588_74##19	4.81023e-18
C867	a_588_74##4	a_588_74##5	2.58914e-17
C868	VPWR#4	VPWR#8	5.69383e-17
C869	a_203_74##3	a_588_74##68	8.71977e-20
C870	a_588_74##62	VGND#19	2.40478e-17
C871	X#1	a_588_74##52	9.78416e-19
C872	VGND#13	a_588_74##18	1.97536e-18
C873	VGND#25	a_27_368##4	4.6969e-20
C874	a_588_74##4	a_588_74##21	1.38035e-19
C875	VPWR#19	a_203_74##9	3.33115e-19
C876	VPWR#17	a_203_74##11	3.44532e-19
C877	VPWR#20	a_203_74##15	5.1193e-18
C878	VGND#10	a_203_74##16	1.67178e-19
C879	VPWR#4	VPWR#3	6.00477e-17
C880	X#1	a_588_74##58	1.38833e-17
C881	VGND#26	a_203_74##8	1.96657e-17
C882	X	a_588_74##30	6.26415e-19
C883	X#6	a_588_74##54	2.09145e-19
C884	a_588_74##80	X#16	6.27445e-17
C885	a_588_74##56	X#3	1.8157e-19
C886	X#8	a_588_74##42	6.48516e-18
C887	VPWR#23	VPWR#20	6.99578e-19
C888	X#1	a_588_74##59	1.09385e-17
C889	VPWR#4	VPWR#2	7.74455e-17
C890	VGND#10	a_203_74##3	2.94279e-20
C891	VGND#16	a_588_74##38	6.22008e-18
C892	VGND#22	a_203_74##8	2.6987e-19
C893	a_588_74##20	X#20	2.21513e-17
C894	VPWR#18	a_203_74##15	5.02784e-19
C895	VPWR#28	a_203_74##24	5.21059e-17
C896	a_588_74##70	a_203_74##11	4.82102e-17
C897	VGND#2	X#20	6.96642e-18
C898	a_27_368##4	a_203_74##8	4.57793e-18
C899	a_588_74##7	a_588_74##21	1.36636e-18
C900	X#1	a_203_74##9	1.82225e-18
C901	X#13	X#16	1.73796e-18
C902	a_588_74##64	a_27_368##4	3.29238e-19
C903	a_588_74##69	a_588_74##68	2.19605e-18
C904	a_27_368##3	VPWR#26	2.74899e-18
C905	X#17	a_588_74##18	1.5031e-19
C906	VGND#22	a_27_368##2	4.56895e-20
C907	X#1	a_203_74##11	4.09048e-21
C908	X#15	VPWR#7	5.71137e-17
C909	a_27_368##3	a_203_74##24	5.02517e-17
C910	a_588_74##60	a_588_74##59	1.6155e-18
C911	a_588_74##74	VGND#7	2.02508e-18
C912	VPWR#22	a_588_74##52	2.08454e-18
C913	VGND#12	a_588_74##22	3.18276e-19
C914	VGND#13	X#20	5.78838e-17
C915	a_588_74##7	a_588_74##30	4.36337e-19
C916	a_588_74##80	X#13	9.79379e-17
C917	VGND#20	a_203_74##4	4.52636e-19
C918	a_203_74##11	VPWR#19	2.45714e-17
C919	X#13	a_588_74##34	9.00762e-20
C920	VPWR#17	a_203_74##13	1.54204e-19
C921	a_588_74##66	a_203_74##4	2.92746e-18
C922	X#1	a_203_74##13	4.3962e-19
C923	a_588_74##60	a_203_74##9	3.93082e-18
C924	VGND#21	a_203_74##8	4.70245e-18
C925	a_203_74##2	a_588_74##68	1.64883e-19
C926	VPWR#22	a_588_74##58	1.49259e-18
C927	a_588_74##74	VGND#6	8.35649e-20
C928	VGND#19	a_588_74##61	1.5799e-17
C929	VGND#13	a_588_74##20	1.76881e-17
C930	a_588_74##60	a_203_74##11	2.01489e-19
C931	a_588_74##54	X#3	1.13332e-19
C932	VGND#26	a_27_368##4	3.12797e-18
C933	VPWR#22	a_588_74##59	1.5721e-18
C934	X#17	a_588_74##5	7.78074e-20
C935	a_588_74##62	a_588_74##68	4.87718e-19
C936	VPWR#23	a_203_74##17	5.19909e-19
C937	a_27_368##12	a_203_74##24	3.01982e-18
C938	a_588_74##71	a_203_74##11	1.66522e-18
C939	a_588_74##70	a_203_74##13	1.71357e-18
C940	VGND#27	a_203_74##8	9.52095e-20
C941	VGND#3	a_588_74##8	4.62821e-20
C942	X#6	a_588_74##50	5.54903e-18
C943	VPWR#22	a_203_74##9	1.32878e-18
C944	VGND#17	a_588_74##46	4.92067e-18
C945	a_588_74##78	X#13	3.56033e-17
C946	X#24	VPWR#4	1.37814e-17
C947	a_588_74##63	VGND#20	1.29644e-17
C948	X#13	a_588_74##30	2.05969e-17
C949	a_588_74##10	a_588_74##26	5.85038e-18
C950	a_588_74##60	a_203_74##15	1.39974e-19
C951	VPWR#22	a_203_74##11	3.42439e-19
C952	X#20	a_588_74##22	1.41903e-18
C953	X#10	VPWR#10	8.52757e-18
C954	X#12	a_588_74##30	2.97582e-18
C955	VPWR#20	a_203_74##17	1.66037e-18
C956	a_588_74##7	a_588_74##8	2.93531e-17
C957	a_588_74##69	VGND#20	3.99411e-17
C958	VPWR#9	VPWR#7	1.87864e-18
C959	a_27_368##5	a_27_368##4	3.52381e-17
C960	X#11	X#13	2.46477e-18
C961	VPWR#21	a_203_74##11	1.53854e-19
C962	A#2	a_27_368##12	4.07047e-18
C963	a_588_74##65	VPWR#17	1.46349e-17
C964	a_203_74##13	VPWR#19	2.93451e-17
C965	VPWR#22	a_203_74##13	9.33432e-19
C966	a_27_368##4	a_203_74##25	2.56133e-17
C967	VGND#10	a_203_74##2	1.27262e-20
C968	VGND#22	a_27_368##4	6.20736e-18
C969	X#17	a_588_74##20	3.38509e-19
C970	X#19	VPWR#4	1.5556e-17
C971	VGND#9	a_588_74##56	2.14021e-20
C972	VPWR#22	a_203_74##15	8.44676e-19
C973	VGND#20	a_203_74##3	6.7495e-19
C974	a_588_74##78	X#11	7.68116e-17
C975	a_588_74##80	VGND#14	3.41184e-18
C976	VGND#4	a_588_74##84	8.84981e-18
C977	VPWR#18	a_203_74##17	8.1728e-20
C978	a_27_368##12	VPWR#28	5.3053e-17
C979	X#17	X#20	4.13701e-18
C980	VPWR#22	a_203_74##17	5.97224e-18
C981	VGND#3	X#17	6.96642e-18
C982	a_588_74##71	a_203_74##13	5.54757e-17
C983	VGND#4	X#19	1.09616e-18
C984	VGND#26	a_27_368##5	2.65149e-19
C985	a_588_74##66	a_203_74##3	1.37346e-19
C986	X#5	VPWR#14	1.36174e-18
C987	VPWR#22	a_203_74##18	2.47084e-18
C988	a_588_74##14	a_588_74##32	5.85211e-18
C989	VGND#13	a_588_74##22	4.40933e-17
C990	a_27_368##4	VGND#27	1.46758e-17
C991	X#16	VPWR#4	1.66083e-17
C992	VGND#4	a_588_74##82	1.19579e-17
C993	VPWR#25	a_203_74##18	1.43319e-19
C994	VPWR#22	a_27_368#	9.58184e-19
C995	X#5	VPWR#12	1.15085e-18
C996	VGND#18	a_588_74##54	4.83254e-18
C997	a_588_74##76	X#11	5.96827e-17
C998	X#10	VPWR#8	8.44089e-18
C999	a_588_74##62	VGND#20	1.61832e-17
C1000	VPWR#21	a_203_74##13	3.44144e-19
C1001	X#8	a_588_74##38	4.12038e-18
C1002	VPWR#19	a_203_74##15	6.12523e-19
C1003	a_588_74##80	VPWR#4	2.42582e-19
C1004	VPWR#9	X#15	5.71742e-17
C1005	VGND#4	X#16	1.34528e-18
C1006	VPWR#22	a_27_368##8	2.92758e-19
C1007	VGND#25	VGND#20	1.89786e-18
C1008	X#7	X#11	1.72816e-18
C1009	X#20	a_588_74##24	1.51754e-19
C1010	a_588_74##63	a_588_74##69	4.87718e-19
C1011	a_588_74##46	a_588_74##42	3.84763e-18
C1012	X#13	VPWR#4	1.53262e-17
C1013	VPWR#23	a_203_74##18	7.79365e-18
C1014	a_27_368##7	a_27_368##5	4.05858e-17
C1015	VPWR#22	a_27_368##9	2.08044e-18
C1016	VGND#4	a_588_74##80	1.399e-17
C1017	a_203_74##22	a_27_368##4	6.41295e-19
C1018	a_588_74##71	a_203_74##15	4.80614e-17
C1019	a_588_74##10	a_588_74##30	2.28688e-17
C1020	a_588_74##76	X#7	1.01675e-16
C1021	VPWR#22	A#3	1.13563e-18
C1022	X#17	a_588_74##22	1.32799e-17
C1023	a_588_74##65	a_588_74##70	2.16821e-19
C1024	a_588_74##37	a_588_74##40	5.85385e-18
C1025	VGND#4	X#13	1.46984e-18
C1026	VGND#10	a_588_74##63	3.0608e-19
C1027	VPWR#20	a_203_74##18	5.03407e-19
C1028	X#17	VGND#13	6.53762e-17
C1029	X#11	VPWR#4	1.46361e-17
C1030	VGND#4	a_588_74##78	1.26139e-17
C1031	VGND#22	a_27_368##5	5.63998e-18
C1032	a_203_74##15	VPWR#21	2.42897e-17
C1033	VGND#27	a_27_368##5	2.75392e-17
C1034	X	VPWR#8	2.95173e-19
C1035	X#24	VPWR#1	3.77733e-17
C1036	VPWR#19	a_203_74##17	1.53981e-19
C1037	VPWR#20	VPWR#18	6.93111e-19
C1038	VGND#2	a_588_74##8	3.69187e-20
C1039	VGND#13	a_588_74##24	2.37027e-18
C1040	a_588_74##74	X#7	5.83276e-17
C1041	a_203_74##2	a_588_74##56	2.46234e-17
C1042	a_588_74##66	VPWR#19	9.52214e-18
C1043	VPWR#20	a_203_74##6	2.05092e-20
C1044	VGND#4	X#11	1.46984e-18
C1045	X#6	a_588_74##46	2.651e-18
C1046	X#2	a_588_74##56	7.97123e-18
C1047	a_588_74##78	a_588_74##30	6.25882e-18
C1048	VGND#4	VGND#7	6.16097e-17
C1049	X#8	a_588_74##34	2.20987e-19
C1050	X#24	X#22	4.24544e-18
C1051	a_588_74##63	a_203_74##6	5.54717e-18
C1052	X#7	VPWR#4	1.70195e-17
C1053	a_588_74##67	a_203_74##15	1.98057e-18
C1054	VGND#14	a_588_74##22	7.25207e-19
C1055	X#9	VPWR#12	8.52757e-18
C1056	a_588_74##45	a_588_74##48	5.85385e-18
C1057	VGND#4	a_588_74##76	1.27199e-17
C1058	VGND#25	a_588_74##69	4.20273e-17
C1059	VGND#5	X#14	6.14532e-18
C1060	a_588_74##72	VPWR#14	2.66458e-19
C1061	a_588_74##71	a_203_74##17	1.707e-18
C1062	VGND#9	a_203_74##2	4.18903e-20
C1063	VGND#4	VGND#6	6.78652e-17
C1064	VGND#22	VGND#21	8.08371e-19
C1065	VGND#25	a_203_74##6	1.62094e-18
C1066	a_203_74##22	a_27_368##5	2.39504e-17
C1067	A#1	a_27_368##7	3.89371e-17
C1068	VGND#4	X#7	1.46984e-18
C1069	VPWR#25	a_27_368#	5.20623e-18
C1070	X#24	VPWR#5	4.10188e-17
C1071	a_588_74##4	X#24	3.01983e-17
C1072	VGND#6	VGND#15	1.2958e-19
C1073	a_588_74##63	VGND#25	2.17027e-17
C1074	VGND#4	VGND#5	5.70385e-17
C1075	VGND#8	a_588_74##56	3.82563e-20
C1076	VPWR#24	a_203_74##15	1.72497e-19
C1077	a_203_74##21	a_203_74##23	3.29622e-18
C1078	a_203_74##17	VPWR#21	2.87647e-17
C1079	X#17	a_588_74##24	3.74544e-17
C1080	a_588_74##84	a_588_74##4	3.25696e-17
C1081	VGND#4	a_588_74##74	1.14208e-17
C1082	X#5	X#7	1.72816e-18
C1083	a_588_74##56	VNB	2.23982e-17
C1084	a_588_74##54	VNB	3.35001e-17
C1085	a_588_74##61	VPWR#17	1.32737e-17
C1086	a_588_74##65	a_203_74##3	2.2768e-18
C1087	VGND#4	VGND#3	5.70455e-17
C1088	a_588_74##50	VNB	2.01281e-17
C1089	a_588_74##65	VPWR#19	7.14744e-18
C1090	a_588_74##46	VNB	3.02028e-17
C1091	VGND#14	VGND#13	1.86497e-18
C1092	a_588_74##42	VNB	2.05158e-17
C1093	X#19	a_588_74##4	2.75592e-17
C1094	VGND#27	a_27_368##7	1.09805e-18
C1095	VPWR#23	a_27_368#	7.78397e-19
C1096	a_588_74##38	VNB	3.32445e-17
C1097	X#10	VPWR#9	5.70426e-17
C1098	X#11	a_588_74##42	9.00762e-20
C1099	a_588_74##34	VNB	1.98649e-17
C1100	a_588_74##74	X#5	9.83665e-17
C1101	a_588_74##62	a_203_74##7	3.20715e-20
C1102	a_588_74##30	VNB	1.05246e-16
C1103	VGND#28	a_27_368##5	1.48705e-18
C1104	VGND#4	VGND#2	6.4886e-17
C1105	a_588_74##30	a_588_74##8	4.50974e-18
C1106	a_588_74##67	a_203_74##17	7.49003e-17
C1107	a_588_74##53	a_588_74##59	1.31866e-19
C1108	VGND#10	a_588_74##62	2.36517e-19
C1109	a_588_74##8	VNB	5.61573e-17
C1110	VGND#13	a_588_74##27	3.18276e-19
C1111	X#9	VPWR#10	8.44089e-18
C1112	a_588_74##5	VNB	5.35706e-17
C1113	X#5	VPWR#4	1.01999e-17
C1114	X#6	a_588_74##42	2.00442e-19
C1115	X#2	a_588_74##54	4.35118e-18
C1116	a_588_74##7	X#19	2.48592e-17
C1117	a_588_74##2	VNB	4.21326e-17
C1118	a_203_74##7	VNB	3.26776e-17
C1119	VPWR#20	a_27_368#	1.74572e-20
C1120	a_203_74##6	VNB	6.87074e-17
C1121	a_203_74##4	VNB	3.27221e-17
C1122	VGND#22	a_27_368##7	9.94253e-19
C1123	a_203_74##3	VNB	2.96848e-17
C1124	a_588_74##66	a_588_74##71	2.16821e-19
C1125	a_588_74##64	a_588_74##69	2.19605e-18
C1126	a_588_74##78	VGND#15	3.30522e-18
C1127	a_203_74##2	VNB	2.31973e-17
C1128	a_588_74##14	a_588_74##34	4.60611e-19
C1129	a_588_74##82	a_588_74##7	2.88474e-17
C1130	a_27_368##6	VNB	2.55043e-17
C1131	a_203_74##4	a_203_74##11	1.09921e-18
C1132	a_27_368##2	VNB	3.4208e-17
C1133	VGND#4	X#5	1.46984e-18
C1134	VGND#14	a_588_74##24	1.69928e-17
C1135	VPWR#24	a_203_74##17	6.45616e-19
C1136	a_588_74##64	a_203_74##7	2.1225e-18
C1137	a_27_368##7	a_203_74##22	1.95229e-17
C1138	X#11	a_588_74##38	1.48779e-19
C1139	VPWR#21	a_203_74##18	6.1269e-19
C1140	a_588_74##84	VPWR#5	5.6437e-18
C1141	X#16	a_588_74##7	2.79973e-17
C1142	a_588_74##63	a_203_74##4	2.51958e-18
C1143	a_588_74##16	a_588_74##15	3.88539e-17
C1144	a_27_368##13	a_27_368##5	1.89459e-19
C1145	X#1	VPWR#16	5.36299e-19
C1146	a_588_74##14	a_588_74##30	2.0895e-17
C1147	a_203_74##7	a_203_74##6	4.33014e-18
C1148	X#11	a_588_74##34	1.47565e-17
C1149	a_588_74##10	X#16	2.10456e-17
C1150	a_588_74##72	X#5	6.0361e-17
C1151	X#1	VPWR#14	1.31345e-18
C1152	a_588_74##8	a_588_74##21	7.29288e-19
C1153	VPWR#11	VPWR#9	1.87864e-18
C1154	X#17	a_588_74##27	1.52024e-18
C1155	a_588_74##64	a_588_74##63	2.01799e-19
C1156	a_588_74##67	a_203_74##18	5.67444e-17
C1157	a_588_74##80	a_588_74##10	2.66408e-17
C1158	VGND#6	X#12	6.51772e-18
C1159	VGND#28	a_27_368##7	3.12994e-17
C1160	VGND#14	X#17	7.38291e-17
C1161	X#1	X#5	2.64036e-18
C1162	VGND#8	a_588_74##54	2.488e-20
C1163	VPWR#18	a_203_74##6	1.77747e-21
C1164	VPWR#25	a_27_368##8	7.48249e-18
C1165	X#13	a_588_74##10	3.6915e-17
C1166	a_588_74##62	a_588_74##57	1.0149e-18
C1167	X#14	a_588_74##24	3.49684e-19
C1168	VGND#11	a_588_74##74	2.68792e-19
C1169	a_588_74##72	X#1	9.6919e-17
C1170	a_203_74##18	VPWR#24	2.17445e-17
C1171	X#11	a_588_74##30	7.07519e-18
C1172	VGND#7	VGND#16	1.51482e-19
C1173	X#2	a_588_74##50	1.83559e-19
C1174	a_588_74##62	a_203_74##6	1.10241e-19
C1175	VPWR#21	a_27_368#	5.5958e-20
C1176	a_588_74##64	VGND#25	4.73472e-17
C1177	a_588_74##14	X#13	2.81381e-17
C1178	VGND#9	a_588_74##62	6.85533e-19
C1179	X#4	VPWR#14	8.4779e-18
C1180	VPWR#23	a_27_368##8	7.78598e-20
C1181	a_203_74##22	A#1	1.46019e-18
C1182	X#5	VPWR#22	7.06409e-18
C1183	X#19	VPWR#5	3.0571e-17
C1184	a_588_74##64	a_203_74##6	9.84928e-19
C1185	a_588_74##78	a_588_74##14	2.51714e-17
C1186	VPWR#4	a_588_74##4	1.36361e-18
C1187	VGND#14	a_588_74##27	4.33863e-17
C1188	a_588_74##72	VGND#9	6.22237e-20
C1189	a_27_368##13	a_27_368##7	8.56418e-19
C1190	a_203_74##26	a_203_74##18	1.4787e-18
C1191	a_588_74##60	X#1	3.3041e-17
C1192	a_588_74##66	VPWR#21	1.72093e-17
C1193	X#11	a_588_74##14	3.45238e-17
C1194	VPWR#25	VNB	2.70897e-17
C1195	VPWR#23	VNB	2.7996e-17
C1196	VGND#4	a_588_74##4	1.38578e-18
C1197	VGND#2	a_588_74##5	7.70477e-20
C1198	VPWR#20	VNB	1.62976e-17
C1199	VPWR#11	X#10	5.71031e-17
C1200	VPWR#18	VNB	2.63929e-17
C1201	a_588_74##72	VGND#8	1.84434e-18
C1202	X#19	X#21	8.72616e-19
C1203	VPWR#4	a_588_74##7	1.61613e-18
C1204	VPWR#16	VNB	2.63421e-17
C1205	VPWR#14	VNB	2.93833e-17
C1206	X	VPWR#9	2.75174e-17
C1207	X#1	VPWR#22	1.34238e-17
C1208	VPWR#12	VNB	2.61133e-17
C1209	VGND#11	a_588_74##72	1.19404e-17
C1210	VPWR#10	VNB	2.60616e-17
C1211	VPWR#8	VNB	2.50066e-17
C1212	VPWR#3	VNB	2.70543e-17
C1213	VGND#22	a_203_74##21	9.94362e-18
C1214	VPWR#2	VNB	3.44661e-17
C1215	a_588_74##37	X#11	2.66209e-17
C1216	VGND#4	a_588_74##7	1.37133e-18
C1217	a_588_74##72	VGND#7	3.49807e-20
C1218	VPWR#26	a_203_74##18	2.38557e-19
C1219	VGND#22	VNB	2.7893e-17
C1220	a_588_74##60	VPWR#22	1.18979e-17
C1221	VGND#28	A#1	2.84169e-17
C1222	a_588_74##10	VPWR#4	2.34485e-18
C1223	X#17	a_588_74##29	1.64707e-19
C1224	VPWR#18	VPWR#16	6.81662e-19
C1225	VGND#11	X#1	1.01311e-18
C1226	VGND#21	VNB	3.15545e-17
C1227	a_588_74##61	a_203_74##7	9.2124e-20
C1228	VPWR#24	a_27_368#	2.6297e-18
C1229	VGND#10	VNB	3.03866e-17
C1230	a_588_74##76	a_588_74##37	2.32757e-17
C1231	a_588_74##18	a_588_74##16	2.74392e-17
C1232	VGND#9	VNB	2.69835e-17
C1233	a_588_74##37	a_588_74##42	4.49524e-19
C1234	X#19	VPWR#6	2.97941e-17
C1235	VGND#8	VNB	2.78631e-17
C1236	VGND#5	X#12	8.32952e-18
C1237	VGND#7	VNB	2.88942e-17
C1238	VGND#6	VNB	2.97704e-17
C1239	a_588_74##60	VPWR#16	2.20915e-18
C1240	VGND#4	a_588_74##10	2.22179e-18
C1241	VGND#5	VNB	2.97599e-17
C1242	X#14	X#17	4.59932e-18
C1243	VGND#3	VNB	2.96793e-17
C1244	VGND#11	a_588_74##60	1.1646e-17
C1245	X#7	a_588_74##37	3.59201e-17
C1246	VGND#2	VNB	3.51858e-17
C1247	VPWR#4	a_588_74##14	1.73397e-18
C1248	X#14	a_588_74##27	1.40839e-17
C1249	X#4	VPWR#12	8.44089e-18
C1250	a_588_74##37	a_588_74##38	1.79616e-17
C1251	X#6	a_588_74##38	8.55973e-20
C1252	VGND#4	a_588_74##14	2.623e-18
C1253	VGND#26	VGND#25	1.89786e-18
C1254	a_588_74##62	a_203_74#	1.25059e-17
C1255	a_203_74##26	a_27_368#	6.4617e-17
C1256	a_588_74##45	X#7	2.64131e-17
C1257	a_588_74##66	VNB	1.42284e-18
C1258	a_588_74##65	a_588_74##59	9.35323e-19
C1259	VPWR#4	a_588_74##37	1.74239e-18
C1260	a_588_74##65	VNB	7.72642e-19
C1261	VGND#8	a_588_74##50	3.07656e-20
C1262	a_588_74##37	a_588_74##34	1.42229e-18
C1263	a_588_74##63	VNB	1.48677e-18
C1264	a_588_74##62	VNB	1.45462e-18
C1265	a_588_74##61	VNB	5.26306e-19
C1266	a_588_74##62	a_203_74##4	3.06246e-19
C1267	a_27_368##13	A#1	2.55104e-17
C1268	a_203_74##23	VNB	5.12898e-18
C1269	a_588_74##74	a_588_74##45	2.17422e-17
C1270	a_203_74##21	VNB	1.36556e-17
C1271	VGND#4	a_588_74##37	2.45377e-18
C1272	VPWR#18	a_203_74##4	1.81849e-20
C1273	a_203_74##20	VNB	6.07463e-18
C1274	a_588_74##76	a_588_74##38	2.22449e-18
C1275	VPWR#25	a_27_368##9	5.02784e-19
C1276	a_27_368##11	VNB	8.74751e-18
C1277	VGND#7	X#8	7.38609e-18
C1278	VPWR#4	a_588_74##45	1.74239e-18
C1279	VGND#14	a_588_74##29	2.22165e-18
C1280	A#6	VNB	1.21755e-17
C1281	a_588_74##17	a_588_74#	3.71089e-17
C1282	A#4	VNB	1.30876e-17
C1283	a_27_368#	VPWR#26	2.48504e-17
C1284	VGND#1	VNB	7.24723e-17
C1285	X#25	VNB	1.21822e-17
C1286	VGND#4	a_588_74##45	1.21278e-18
C1287	VGND#9	a_588_74##61	1.43379e-19
C1288	VGND#12	VNB	1.2809e-18
C1289	VPWR#24	a_27_368##8	1.6453e-19
C1290	X#20	VNB	8.62561e-18
C1291	a_588_74##76	a_588_74##34	3.46676e-18
C1292	VGND#13	VNB	1.20717e-18
C1293	X#17	VNB	3.27944e-18
C1294	VGND#14	VNB	1.05326e-18
C1295	a_588_74##67	a_588_74##66	1.58393e-18
C1296	X#14	VNB	3.53424e-18
C1297	X#5	a_588_74##45	3.65434e-17
C1298	VPWR#22	VPWR#25	6.24468e-17
C1299	VGND#15	a_588_74##27	7.45773e-19
C1300	VGND#15	VNB	5.67642e-18
C1301	X#12	VNB	3.9183e-18
C1302	VGND#16	VNB	5.65504e-18
C1303	a_588_74##82	VPWR#6	5.56167e-18
C1304	X#8	VNB	4.0123e-18
C1305	VPWR#2	a_588_74#	3.0074e-18
C1306	VGND#17	VNB	5.3157e-18
C1307	a_588_74##63	a_203_74##10	3.37088e-20
C1308	X#6	VNB	9.54575e-18
C1309	a_588_74##76	VGND#16	3.09198e-18
C1310	VGND#18	VNB	7.124e-19
C1311	VPWR#22	VPWR#23	6.76137e-17
C1312	a_203_74##24	a_27_368#	2.01285e-18
C1313	X#2	VNB	3.27178e-18
C1314	VGND#19	VNB	5.17389e-18
C1315	a_588_74##53	X#5	2.89695e-17
C1316	VGND#21	a_203_74##21	9.57375e-18
C1317	a_588_74##68	VNB	2.3242e-18
C1318	a_203_74##26	a_27_368##8	1.68814e-18
C1319	VGND#20	VNB	4.11852e-19
C1320	a_588_74##69	VNB	2.11603e-18
C1321	VGND#25	VNB	4.09641e-19
C1322	a_588_74##64	VNB	2.23501e-18
C1323	a_588_74##72	a_588_74##53	2.42221e-17
C1324	VGND#26	VNB	1.32554e-17
C1325	a_588_74##61	a_203_74##6	5.25947e-19
C1326	VPWR#22	VPWR#20	4.17732e-17
C1327	X#14	VGND#14	6.37065e-17
C1328	VGND#27	VNB	1.91432e-19
C1329	a_203_74##22	VNB	4.60686e-18
C1330	VGND#28	VNB	1.90168e-18
C1331	X#1	a_588_74##53	2.74487e-17
C1332	X#14	a_588_74##29	3.79109e-17
C1333	VGND#26	a_588_74##64	6.86494e-17
C1334	X#2	a_588_74##46	8.36768e-20
C1335	a_27_368##13	VNB	3.95088e-17
C1336	VPWR#1	VNB	8.0714e-17
C1337	VPWR#16	a_588_74##56	1.50401e-20
C1338	X#22	VNB	2.76522e-18
C1339	a_27_368##11	a_203_74##23	8.0744e-20
C1340	VPWR#5	VNB	4.09278e-19
C1341	VPWR#22	VPWR#18	6.10788e-17
C1342	VPWR#28	a_27_368#	2.50453e-19
C1343	X#21	VNB	2.14892e-18
C1344	X#9	VPWR#11	5.71137e-17
C1345	X#7	a_588_74##50	9.00762e-20
C1346	a_588_74##20	a_588_74##18	4.08078e-17
C1347	VPWR#6	VNB	2.92383e-18
C1348	a_27_368##8	VPWR#26	2.89166e-17
C1349	X#18	VNB	2.14892e-18
C1350	VPWR#26	a_27_368##2	3.72604e-19
C1351	VPWR#7	VNB	2.92383e-18
C1352	X#3	VPWR#16	7.53414e-18
C1353	X#15	VNB	2.14528e-18
C1354	VPWR#9	VNB	2.92383e-18
C1355	VPWR#22	a_588_74##53	1.02692e-18
C1356	X#10	VNB	2.14892e-18
C1357	VPWR#22	VPWR#16	5.82332e-17
C1358	VPWR#11	VNB	2.92383e-18
C1359	a_588_74##62	a_203_74##10	2.07044e-17
C1360	X#9	VNB	2.14892e-18
C1361	a_588_74##60	a_203_74##5	5.024e-18
C1362	a_588_74##61	a_588_74##59	1.30093e-18
C1363	VPWR#13	VNB	2.92383e-18
C1364	X#4	VNB	2.15213e-18
C1365	VGND#11	a_588_74##53	1.03782e-18
C1366	a_588_74##65	a_203_74##9	8.91121e-18
C1367	VPWR#15	VNB	3.0111e-18
C1368	VGND#6	X#8	8.63445e-18
C1369	X#3	VNB	2.15291e-18
C1370	a_588_74##19	a_588_74##17	4.76502e-17
C1371	VPWR#22	a_203_74##5	1.23235e-17
C1372	VPWR#17	VNB	2.93605e-18
C1373	a_588_74##62	a_203_74##3	4.1641e-18
C1374	a_588_74##70	VNB	2.30954e-18
C1375	VGND#14	a_588_74##31	3.05077e-19
C1376	a_588_74##45	a_588_74##50	4.49524e-19
C1377	VPWR#22	VPWR#14	5.9165e-17
C1378	VPWR#19	VNB	2.93605e-18
C1379	a_588_74##71	VNB	2.16687e-18
C1380	a_203_74##24	a_27_368##8	7.41872e-17
C1381	VPWR#21	VNB	2.92383e-18
C1382	VGND#11	a_203_74##5	1.14622e-17
C1383	a_588_74##67	VNB	2.30536e-18
C1384	X	a_588_74##28	1.99412e-19
C1385	X#16	VPWR#6	3.05376e-17
C1386	VPWR#24	VNB	1.58058e-17
C1387	a_203_74##26	VNB	1.24788e-17
C1388	VPWR#22	a_27_368##3	7.35998e-18
C1389	VPWR#3	a_588_74##17	8.1728e-20
C1390	VPWR#26	VNB	2.92383e-18
C1391	a_203_74##6	a_203_74##15	1.14316e-18
C1392	X#7	a_588_74##46	1.0672e-19
C1393	a_203_74##24	VNB	2.66605e-18
C1394	VPWR#28	VNB	2.82484e-18
C1395	a_203_74##23	a_203_74##7	2.47954e-19
C1396	a_27_368##12	VNB	5.17218e-17
C1397	a_588_74##29	VGND#15	2.19371e-17
C1398	VGND#11	a_27_368##3	6.68012e-18
C1399	a_588_74##15	VNB	3.3002e-17
C1400	a_588_74##45	a_588_74##46	1.80425e-17
C1401	a_588_74##16	VNB	2.72034e-17
C1402	VPWR#18	a_203_74##3	1.9142e-20
C1403	a_588_74##18	VNB	2.66217e-17
C1404	a_588_74##20	VNB	3.37866e-17
C1405	a_588_74##22	VNB	2.72645e-17
C1406	VPWR#25	A#3	2.26247e-19
C1407	a_588_74##24	VNB	2.77583e-17
C1408	a_588_74##45	a_588_74##42	1.42229e-18
C1409	a_588_74##27	VNB	2.654e-17
C1410	X#16	X#18	1.08089e-18
C1411	VPWR#28	a_27_368##8	6.54315e-19
C1412	X#7	a_588_74##42	1.42264e-17
C1413	a_588_74##29	VNB	2.86294e-17
C1414	a_588_74##31	VNB	3.06851e-17
C1415	a_588_74##35	VNB	2.85496e-17
C1416	VPWR#26	a_27_368##9	6.12523e-19
C1417	VPWR#3	a_588_74##8	6.67399e-20
C1418	a_588_74##39	VNB	3.1779e-17
C1419	a_588_74##63	a_203_74##12	1.76681e-17
C1420	a_588_74##43	VNB	3.30796e-17
C1421	a_588_74##47	VNB	3.17942e-17
C1422	a_203_74##15	a_203_74##4	1.14316e-18
C1423	a_588_74##51	VNB	3.16695e-17
C1424	VPWR#13	VPWR#11	1.87864e-18
C1425	VGND#8	X#6	6.14473e-18
C1426	a_588_74##60	VGND#9	1.51584e-18
C1427	a_588_74##55	VNB	2.69324e-17
C1428	X#3	VPWR#14	9.43015e-18
C1429	a_588_74##57	VNB	3.01379e-17
C1430	VGND#15	VGND#14	1.7251e-18
C1431	a_203_74#	VNB	2.50173e-17
C1432	VGND#2	a_588_74##2	3.15681e-20
C1433	a_203_74##10	VNB	2.61746e-17
C1434	VPWR#2	a_588_74##17	4.92863e-18
C1435	a_203_74##12	VNB	2.54471e-17
C1436	X#14	a_588_74##31	1.54186e-18
C1437	X#16	VPWR#7	3.30477e-17
C1438	a_203_74##14	VNB	2.68859e-17
C1439	a_588_74##61	a_203_74##4	1.01606e-18
C1440	a_203_74##16	VNB	2.52402e-17
C1441	a_203_74##8	VNB	3.04837e-17
C1442	VGND#21	a_203_74##20	6.98467e-19
C1443	a_588_74##30	a_588_74##26	1.66244e-18
C1444	a_27_368##4	VNB	3.22531e-17
C1445	a_588_74##66	a_203_74##11	2.71132e-19
C1446	a_27_368##5	VNB	2.46143e-17
C1447	VGND#7	a_588_74##50	4.14313e-20
C1448	a_27_368##7	VNB	2.6821e-17
C1449	a_203_74##24	a_27_368##9	5.54166e-17
C1450	A#1	VNB	3.35807e-17
C1451	a_27_368##11	a_203_74##21	3.13372e-19
C1452	a_203_74##6	a_203_74##4	4.33014e-18
C1453	a_588_74#	VNB	4.05287e-17
C1454	VGND#9	VGND#18	8.05838e-19
C1455	X#7	a_588_74##38	7.81561e-18
C1456	a_588_74##17	VNB	3.30811e-17
C1457	a_588_74##42	a_588_74##38	3.52519e-18
C1458	a_203_74##24	a_27_368##6	6.68645e-19
C1459	X#12	a_588_74##29	1.44083e-18
C1460	a_588_74##19	VNB	3.49554e-17
C1461	a_588_74##21	VNB	3.71066e-17
C1462	a_588_74##23	VNB	3.50112e-17
C1463	a_588_74##21	a_588_74##19	4.62331e-17
C1464	a_588_74##25	VNB	3.20361e-17
C1465	a_588_74##26	VNB	3.76851e-17
C1466	a_588_74##28	VNB	3.21522e-17
C1467	a_588_74##32	VNB	3.71915e-17
C1468	a_588_74##36	VNB	3.21936e-17
C1469	a_588_74##62	a_203_74##12	4.35075e-20
C1470	a_203_74##21	a_588_74##64	1.2837e-18
C1471	a_588_74##40	VNB	3.71917e-17
C1472	a_588_74##61	a_203_74##9	4.90076e-18
C1473	a_588_74##22	a_588_74##20	2.85785e-17
C1474	X#7	a_588_74##34	2.04977e-19
C1475	a_588_74##44	VNB	3.20518e-17
C1476	a_588_74##78	X	4.82261e-17
C1477	a_27_368##9	VPWR#28	2.05325e-17
C1478	a_588_74##48	VNB	3.74433e-17
C1479	a_588_74##65	a_203_74##11	2.03295e-17
C1480	VPWR#1	a_588_74#	2.96507e-17
C1481	a_588_74##52	VNB	3.21521e-17
C1482	VPWR#16	VPWR#14	7.23558e-19
C1483	a_588_74##58	VNB	3.36267e-17
C1484	a_588_74##59	VNB	3.64218e-17
C1485	VPWR#26	A#3	3.50621e-19
C1486	a_588_74##62	a_203_74##2	5.69756e-19
C1487	a_203_74##9	VNB	3.4291e-17
C1488	a_203_74##11	VNB	3.73117e-17
C1489	a_203_74##13	VNB	3.23429e-17
C1490	VGND#10	VGND#9	1.31064e-18
C1491	a_203_74##15	VNB	3.32418e-17
C1492	X	VPWR#4	5.47226e-18
C1493	a_203_74##17	VNB	3.45084e-17
C1494	a_588_74##31	VGND#15	2.76082e-17
C1495	a_203_74##18	VNB	3.70408e-17
C1496	a_27_368#	VNB	3.85876e-17
C1497	a_27_368##8	VNB	3.60547e-17
C1498	VPWR#13	X#9	5.71742e-17
C1499	a_27_368##9	VNB	3.72474e-17
C1500	a_203_74##23	a_203_74##6	4.54275e-19
C1501	A#3	VNB	4.74809e-17
C1502	VGND#4	VGND#1	6.43113e-17
C1503	a_27_368##12	a_27_368##9	2.13026e-18
C1504	X#24	VNB	1.27526e-17
C1505	a_588_74##84	VNB	3.42736e-18
C1506	X#19	VNB	8.84389e-19
C1507	a_203_74##24	A#3	2.89711e-18
C1508	a_588_74##82	VNB	1.72045e-18
C1509	a_588_74##80	VPWR#7	4.02417e-18
C1510	X#16	VNB	5.36027e-19
C1511	VPWR#3	a_588_74##19	2.85183e-19
C1512	VGND#16	a_588_74##29	1.96168e-19
C1513	a_588_74##80	VNB	1.91289e-18
C1514	VGND#7	X#6	8.03159e-18
C1515	X#13	VNB	4.50799e-19
C1516	a_588_74##78	VNB	2.00021e-18
C1517	VGND#4	X#25	1.97192e-17
C1518	X#11	VNB	4.60169e-19
C1519	X#22	a_588_74#	4.305e-17
C1520	VGND#15	X#14	7.38351e-17
C1521	a_588_74##76	VNB	2.2433e-18
C1522	X#7	VNB	4.60077e-19
C1523	a_588_74##63	a_203_74##14	2.13791e-17
C1524	a_588_74##74	VNB	2.39185e-18
C1525	X	a_588_74##14	1.65657e-18
C1526	VPWR#14	a_588_74##56	7.2466e-21
C1527	VPWR#4	VNB	2.94253e-16
C1528	X#14	a_588_74##35	1.66158e-19
C1529	VGND#4	VNB	2.84432e-16
C1530	X#5	VNB	4.60353e-19
C1531	a_588_74##72	VNB	2.30224e-18
C1532	X#1	VNB	7.98283e-19
C1533	VGND#4	VGND#12	1.72291e-17
C1534	a_588_74##60	VNB	1.12206e-18
C1535	A#3	VPWR#28	2.95534e-17
C1536	a_588_74##53	a_588_74##56	4.98162e-20
C1537	a_588_74##74	VGND#17	2.73658e-18
C1538	VPWR#22	VNB	3.15526e-16
C1539	a_588_74##70	VPWR#18	7.82491e-18
C1540	VGND#11	VNB	3.14008e-16
C1541	a_588_74##61	a_203_74##3	9.57643e-18
C1542	a_588_74##4	VNB	2.07723e-18
C1543	a_588_74##23	a_588_74##21	4.8704e-17
C1544	a_588_74##7	VNB	1.46814e-18
C1545	a_588_74##10	VNB	1.31649e-18
C1546	X#12	a_588_74##31	1.53598e-17
C1547	a_588_74##53	a_588_74##54	2.02004e-17
C1548	a_588_74##14	VNB	1.06068e-18
C1549	a_27_368##11	a_203_74##20	9.22352e-19
C1550	VGND#2	a_588_74##16	3.65526e-18
C1551	a_588_74##66	a_203_74##13	1.95331e-17
C1552	a_588_74##37	VNB	9.73895e-19
C1553	a_588_74##45	VNB	6.94579e-19
C1554	a_588_74##53	VNB	1.39026e-18
C1555	VPWR#2	a_588_74##19	7.48353e-18
C1556	VGND#4	X#20	1.43662e-17
C1557	VPWR#1	a_588_74##17	1.31763e-18
C1558	a_588_74##53	a_588_74##50	5.92321e-18
C1559	a_27_368##3	VNB	3.61859e-17
C1560	A#2	VNB	5.55638e-17
C1561	a_203_74##21	a_203_74##7	9.07179e-20
C1562	VPWR#5	a_588_74#	2.07738e-18
C1563	a_27_368##12	A#3	6.10819e-17
C1564	VPWR#16	a_203_74##3	1.09383e-21
C1565	X#1	a_588_74##66	4.41525e-19
C1566	VGND#9	X#2	5.40634e-18
C1567	a_588_74##74	a_588_74##46	1.50645e-18
C1568	VGND#4	VGND#13	1.74103e-17
C1569	a_203_74##21	VGND#26	6.62901e-17
C1570	a_588_74##62	a_203_74##14	1.59748e-20
C1571	a_588_74##61	a_203_74##11	1.87217e-18
C1572	a_588_74##65	a_203_74##13	2.71132e-19
C1573	VGND#15	a_588_74##35	2.08402e-18
C1574	a_588_74##65	X#1	8.49955e-18
C1575	VPWR#22	VPWR#27	8.97725e-17
C1576	VPWR#27	VPWR#25	6.93668e-19
C1577	VGND#23	a_27_368##13	1.82413e-17
C1578	VPWR#27	a_27_368#	1.40462e-19
C1579	a_203_74##24	VPWR#27	8.49566e-18
C1580	VGND#23	VNB	4.62263e-17
C1581	VPWR#27	a_27_368##8	5.30308e-19
C1582	VGND#23	a_27_368##5	7.64954e-19
C1583	VGND#11	VGND#23	9.71457e-17
C1584	VPWR#27	a_27_368##6	2.10273e-20
C1585	VPWR#27	a_27_368##9	9.67379e-18
C1586	a_27_368##12	VPWR#27	2.11451e-17
C1587	VPWR#27	VNB	4.61864e-17
C1588	VGND#23	A#1	6.08844e-18
C1589	VGND#23	A#2	1.64469e-19
C1590	VPWR#27	A#3	7.70319e-18
C1591	VGND#23	A#4	6.38157e-19
C1592	a_27_368##3	VPWR#27	4.04912e-19
C1593	VGND#23	VGND#22	1.12042e-18
C1594	VGND#23	a_203_74##22	5.24724e-18
C1595	VGND#23	a_27_368##7	7.33289e-18
C1596	VPWR#27	A#2	1.54809e-19
C1597	VGND#23	a_27_368##3	5.45001e-19
C1598	VGND#23	a_27_368##6	3.80223e-20
*
*
.ENDS sky130_fd_sc_hs__bufbuf_16
*
