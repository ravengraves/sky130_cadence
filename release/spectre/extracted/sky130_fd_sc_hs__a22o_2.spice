* Extracted by Quantus, converted by sky130cad/quantus.py
*
*
*
*                       LINUX           Wed Nov 18 08:08:38 2026
*
*
*
*  PROGRAM  advgen
*
*  Name           : advgen - Quantus - (64-bit)
*  Version        : 25.1.0-p047
*  Build Date     : Thu Dec 11 23:20:30 PST 2025
*
*  HSPICE LIBRARY
*
*  OPERATING_TEMPERATURE 150
*  QRC_TECH_DIR <path>/tech
*
*
*

*
.SUBCKT sky130_fd_sc_hs__a22o_2 VPB VNB VGND VPWR X A1 B1 B2 A2
*
*
*  caps2d version: 10
*
*
*       TRANSISTOR CARDS
*
*
XM4 X#2 a_81_48##4 VGND#5 VNB sky130_fd_pr__nfet_01v8_lvt l=0.15 w=0.74 ad=0.2072 as=0.1961 pd=2.04 ps=2.01
XM6 VGND#7 a_81_48##5 X#2 VNB sky130_fd_pr__nfet_01v8_lvt l=0.15 w=0.74 ad=0.1961 as=0.2072 pd=2.01 ps=2.04
XM8 a_304_74##2 A1#1 a_81_48##9 VNB sky130_fd_pr__nfet_01v8_lvt l=0.15 w=0.74 ad=0.2109 as=0.259 pd=2.05 ps=2.18
XM7 a_81_48##9 B1#1 a_491_74# VNB sky130_fd_pr__nfet_01v8_lvt l=0.15 w=0.74 ad=0.259 as=0.185 pd=2.18 ps=1.98
XM0 a_491_74# B2#3 VGND#6 VNB sky130_fd_pr__nfet_01v8_lvt l=0.15 w=0.74 ad=0.185 as=0.2886 pd=1.98 ps=2.26
XM10 VGND#6 A2#3 a_304_74# VNB sky130_fd_pr__nfet_01v8_lvt l=0.15 w=0.74 ad=0.2886 as=0.2109 pd=2.26 ps=2.05
XM1 VPWR#7 a_81_48##6 X#1 VPB sky130_fd_pr__pfet_01v8 l=0.15 w=1.12 ad=0.308 as=0.336 pd=2.79 ps=2.84
XM9 X#1 a_81_48# VPWR#6 VPB sky130_fd_pr__pfet_01v8 l=0.15 w=1.12 ad=0.336 as=0.4218 pd=2.84 ps=3.02
XM5 VPWR#6 A1#3 a_388_368##2 VPB sky130_fd_pr__pfet_01v8 l=0.15 w=1 ad=0.4218 as=0.3 pd=3.02 ps=2.6
XM11 a_388_368##2 B1#3 a_81_48##7 VPB sky130_fd_pr__pfet_01v8 l=0.15 w=1 ad=0.3 as=0.35 pd=2.6 ps=2.7
XM2 a_81_48##7 B2#1 a_388_368# VPB sky130_fd_pr__pfet_01v8 l=0.15 w=1 ad=0.35 as=0.37 pd=2.7 ps=2.74
XM3 a_388_368# A2#4 VPWR#1 VPB sky130_fd_pr__pfet_01v8 l=0.15 w=1 ad=0.37 as=0.275 pd=2.74 ps=2.55
*
*
*       RESISTOR AND CAP/DIODE CARDS
*
Rg1	a_81_48#	a_81_48##2	486.547119
Rg2	a_81_48##2	a_81_48##3	63.728664
Rg3	a_81_48##3	a_81_48##4	378.170807
Rg4	a_81_48##3	a_81_48##5	320.892242
Rg5	a_81_48##3	a_81_48##6	506.023621
Rg6	A1#1	A1#2	382.539734
Rg7	A1#2	A1#3	400.207520
Rg8	B1#1	B1#2	394.958344
Rg9	B1#2	B1#3	408.386017
Rg10	B2#1	B2#2	400.207520
Rg11	B2#2	B2#3	382.539734
Rg12	A2#1	A2#2	28.644930
Rg13	A2#2	A2#3	397.555725
Rg14	A2#2	A2#4	415.223511
Rf1	X#1	X	76.418770
Rf2	X	X#3	7.282945
Rf3	X#3	X	7.282945
Rf4	X#2	X#3	7.500000
Rf5	A1#4	A1#2	161.913620
Rf6	A1	A1#6	1.680815
Rf7	A1#4	A1#6	6.080316
Rf8	B1#4	B1	2.344470
Rf9	B1#2	B1#6	162.577271
Rf10	B1#4	B1#6	5.195247
Rf11	a_81_48##7	a_81_48##8	146.067657
Rf12	a_81_48##8	a_81_48##9	92.922356
Rf13	a_388_368#	a_388_368##2	109.133987
Rf14	B2#2	B2#5	162.105804
Rf15	B2#6	B2	1.873004
Rf16	B2#5	B2#6	7.640068
Rf17	a_304_74#	a_304_74##2	218.370438
Rf18	A2#1	A2	166.137894
Rf19	VPWR#1	VPWR#2	156.735596
Rf20	VPWR#2	VPWR#3	27.004150
Rf21	VPWR#3	VPWR#4	68.675751
Rf23	VPWR#3	VPWR#6	35.077789
Rf24	VPWR#4	VPWR#7	44.620285
Rf26	VGND#2	VGND#3	81.426773
Rf27	VGND#3	VGND#4	55.185940
Rf28	VGND#4	VGND#5	109.631966
Rf29	VGND#2	VGND#6	38.247387
Rf30	VGND#4	VGND#7	45.213318
Rf33	a_81_48##2	a_81_48##8	160.232803
Re1	VPWR#2	VPWR	1.227783
Re2	VGND	VGND#3	1.227829
*
*       CAPACITOR CARDS
*
*
C1	a_304_74#	A2#2	6.81103e-18
C2	VGND#4	a_304_74##2	1.43221e-17
C3	VGND#3	a_81_48##3	1.87801e-20
C4	VGND#5	VGND#4	2.17134e-18
C5	B2#2	A2#2	3.40961e-17
C6	VPWR#3	VPWR#1	2.68322e-19
C7	a_81_48##3	X#2	8.50109e-19
C8	VPWR#3	a_388_368##2	1.72899e-18
C9	a_304_74#	VGND#6	8.6349e-17
C10	a_81_48##9	A1#4	2.11324e-17
C11	VGND#4	A2#3	3.60341e-20
C12	A2#2	VPWR#1	6.66715e-18
C13	X#1	VPWR#3	7.16967e-18
C14	a_81_48##2	A2#2	1.19779e-19
C15	a_81_48##9	a_304_74#	3.8379e-17
C16	a_81_48##3	a_81_48##2	4.93842e-18
C17	VGND#4	B2#3	2.41029e-20
C18	VPWR#7	VPWR#3	2.29211e-19
C19	a_304_74##2	VGND#6	3.26624e-17
C20	VGND#4	B1#1	8.40754e-20
C21	VGND#4	a_81_48##3	1.36425e-19
C22	VGND#4	A1#1	1.06595e-18
C23	a_81_48##9	a_304_74##2	7.78072e-17
C24	VGND#4	a_81_48##5	7.50029e-18
C25	a_304_74#	VPWR#1	2.82261e-19
C26	VGND#7	a_304_74##2	3.7779e-17
C27	VGND#4	a_81_48##4	3.31632e-18
C28	a_304_74#	a_81_48##7	1.13547e-17
C29	VGND#5	VGND#7	2.87289e-19
C30	a_81_48##9	a_81_48##7	3.35826e-18
C31	a_304_74#	A2#3	5.39713e-17
C32	a_388_368#	VPWR#1	1.24338e-16
C33	A2#3	VGND#6	2.16945e-17
C34	a_304_74#	B2#3	2.29567e-17
C35	B2#3	VGND#6	2.34835e-17
C36	a_304_74#	B1#1	6.61593e-18
C37	a_81_48##7	a_388_368#	8.35477e-17
C38	VGND#6	B1#1	1.05555e-18
C39	a_304_74##2	A2#3	9.69984e-19
C40	a_81_48##9	B2#3	1.27446e-18
C41	a_388_368##2	a_388_368#	2.82906e-18
C42	a_304_74##2	B2#3	7.69151e-18
C43	a_81_48##7	a_388_368##2	8.50738e-17
C44	a_81_48##9	B1#1	4.2067e-17
C45	VPWR#3	a_81_48#	8.55439e-18
C46	a_304_74##2	B1#1	2.1594e-17
C47	a_81_48##9	A1#1	3.64235e-17
C48	VPWR#3	a_81_48##6	8.40294e-19
C49	VPWR#6	a_388_368##2	5.47661e-17
C50	X#1	a_81_48##7	5.09696e-19
C51	a_304_74##2	A1#1	5.57652e-17
C52	a_81_48##9	a_81_48##5	3.79429e-19
C53	A2	A2#2	2.22368e-17
C54	VPWR#7	a_81_48##3	5.83046e-19
C55	VGND#7	A1#1	8.82019e-19
C56	a_304_74##2	a_81_48##5	1.13689e-18
C57	X#1	VPWR#6	5.18408e-17
C58	a_81_48##5	VGND#7	1.68054e-17
C59	VGND#5	A1#1	1.36641e-19
C60	VGND#3	VGND#4	4.19318e-17
C61	VPWR#7	VPWR#6	2.1011e-18
C62	a_81_48##5	X#2	1.4935e-17
C63	VPWR#2	VPWR#3	2.86484e-17
C64	VGND#7	a_81_48##4	1.00691e-19
C65	VGND#5	a_81_48##5	1.37822e-18
C66	VPWR#7	X#1	6.85243e-17
C67	a_81_48##4	X#2	1.5442e-17
C68	B2	A2#2	8.83025e-18
C69	VGND#5	a_81_48##4	2.4782e-17
C70	B2#3	A2#3	2.47505e-17
C71	VPWR#1	A2#4	4.70748e-17
C72	A2#4	a_388_368#	2.46869e-17
C73	VPWR#1	B2#1	1.47376e-18
C74	B1#1	B2#3	4.6863e-17
C75	a_388_368#	B2#1	5.93836e-17
C76	B2#1	a_81_48##7	2.38258e-17
C77	VPWR#7	a_81_48##4	4.62841e-18
C78	a_388_368#	B1#3	1.65055e-18
C79	A1#1	B1#1	2.50635e-17
C80	a_388_368##2	B2#1	1.25375e-18
C81	a_81_48##7	B1#3	4.04816e-17
C82	VGND#4	a_81_48##2	1.8877e-18
C83	a_388_368##2	B1#3	4.83776e-17
C84	VPWR#1	a_81_48#	2.3714e-19
C85	a_81_48##7	A1#3	1.32815e-17
C86	X#1	B2#1	4.27004e-20
C87	a_81_48##5	A1#1	5.05935e-18
C88	a_81_48##2	VPWR#3	6.8582e-19
C89	a_388_368##2	A1#3	4.04244e-17
C90	X#1	B1#3	6.964e-20
C91	a_81_48##7	a_81_48#	9.97142e-20
C92	A1#3	VPWR#6	2.11743e-17
C93	a_388_368##2	a_81_48#	1.91401e-18
C94	a_81_48##4	a_81_48##5	3.66795e-17
C95	X#1	A1#3	1.55159e-19
C96	VGND#3	a_304_74##2	6.13251e-17
C97	a_81_48##7	a_81_48##6	5.25444e-20
C98	VPWR#6	a_81_48#	4.77071e-17
C99	a_304_74#	B2#2	2.67035e-17
C100	A1#4	B1#2	1.431e-18
C101	VGND#6	B2#2	8.96446e-19
C102	a_81_48#	X#1	1.90884e-17
C103	VPWR#2	VPWR#1	4.16354e-17
C104	VPWR#6	a_81_48##6	2.03677e-18
C105	VPWR#7	a_81_48#	6.44043e-19
C106	VGND#3	VGND#5	2.47837e-17
C107	a_388_368#	VPWR#2	2.4226e-17
C108	X	a_81_48##3	2.20106e-17
C109	X#1	a_81_48##6	4.56808e-17
C110	a_81_48##7	VPWR#2	6.02666e-19
C111	A1#4	A1#2	9.56011e-18
C112	a_81_48##6	VPWR#7	2.5385e-17
C113	a_388_368##2	VPWR#2	4.90783e-17
C114	a_81_48##9	B1#2	1.77482e-17
C115	a_81_48##2	A1#4	3.95291e-17
C116	a_304_74##2	B1#2	3.00842e-18
C117	VPWR#1	B2#2	2.19546e-20
C118	a_81_48##9	A1#2	2.00737e-19
C119	B2#1	A2#4	3.1578e-17
C120	a_304_74##2	A1#2	8.85234e-19
C121	B2#2	a_388_368#	2.17201e-17
C122	B1#3	B2#1	3.47265e-17
C123	a_81_48##2	a_304_74##2	2.66582e-17
C124	B1#2	a_81_48##7	3.02214e-17
C125	a_81_48##2	VGND#7	3.25535e-17
C126	a_388_368##2	B1#2	1.05302e-19
C127	VGND#3	B1#1	3.09211e-18
C128	A1#3	B1#3	4.24762e-17
C129	VGND#3	A1#1	4.48038e-18
C130	a_81_48##2	a_388_368#	1.3028e-20
C131	a_304_74#	a_491_74#	7.69559e-18
C132	A1#2	VPWR#6	1.69011e-18
C133	a_81_48#	A1#3	3.09072e-17
C134	a_81_48##2	VPWR#6	4.58149e-17
C135	VPWR#2	B2#1	3.19935e-18
C136	VGND	A2#2	1.04384e-18
C137	a_304_74##2	a_491_74#	8.62363e-18
C138	a_81_48##2	X#1	9.70872e-18
C139	a_81_48##6	a_81_48#	4.93668e-17
C140	VPWR#2	B1#3	3.18719e-18
C141	VPWR#2	A1#3	5.72227e-18
C142	B2#2	B2#1	2.93242e-18
C143	a_81_48##2	A1#1	2.73289e-18
C144	B2#2	B1#3	4.83529e-19
C145	a_81_48##2	a_81_48##5	3.41548e-18
C146	a_304_74#	A2	2.68543e-17
C147	B1#2	B2#1	5.89453e-19
C148	B1#2	B1#3	1.92736e-18
C149	a_81_48##2	A2#4	1.24036e-19
C150	A2#2	VNB	6.0231e-17
C151	a_304_74#	B2	2.75105e-17
C152	a_81_48##3	VNB	2.31557e-17
C153	B2#3	a_491_74#	3.31349e-18
C154	a_81_48##2	B2#1	1.36211e-19
C155	B1#1	a_491_74#	7.66855e-18
C156	a_81_48##2	B1#3	2.7935e-19
C157	A2	VPWR#1	2.89741e-17
C158	a_81_48#	A1#2	2.01783e-18
C159	A1#4	B1	2.06757e-17
C160	a_81_48##2	A1#3	1.326e-17
C161	VGND#4	X	1.69466e-17
C162	a_81_48##2	a_81_48#	1.29782e-17
C163	VPWR#2	B1#2	1.52787e-20
C164	B2	VPWR#1	4.93589e-19
C165	a_81_48##9	B1	2.35688e-17
C166	a_81_48##2	a_81_48##6	4.03471e-18
C167	B2	a_388_368#	2.21365e-17
C168	VGND#3	B1#2	3.00823e-20
C169	VGND#3	A1#2	3.96839e-20
C170	a_81_48##2	VPWR#2	7.0311e-20
C171	B1#2	B2#2	7.07246e-17
C172	B1	a_81_48##7	2.10613e-17
C173	VPWR	VPWR#3	3.94154e-17
C174	A1#2	B1#2	3.47626e-17
C175	a_81_48##2	B2#2	9.67456e-20
C176	A2	A2#4	1.62245e-18
C177	X	a_81_48##9	1.44845e-18
C178	a_81_48##2	B1#2	2.19276e-19
C179	A1	a_81_48##7	1.54e-17
C180	A2	B2#1	1.08243e-19
C181	VGND	VGND#4	4.15257e-17
C182	X	VGND#7	5.10166e-17
C183	a_81_48##2	A1#2	4.14769e-17
C184	VGND#5	X	7.04433e-17
C185	B2	A2#4	1.63727e-18
C186	X	X#1	9.52689e-19
C187	X	VPWR#7	4.26938e-17
C188	B1	B1#3	1.12194e-19
C189	VPWR	VPWR#1	4.98622e-17
C190	VGND	A1#4	2.60673e-18
C191	VPWR	a_388_368#	2.38809e-17
C192	B1	A1#3	9.45476e-19
C193	VGND#4	VNB	3.60391e-17
C194	VPWR	a_81_48##7	1.06496e-17
C195	VGND	a_304_74#	1.8988e-17
C196	X	B1#1	1.2319e-19
C197	VPWR	a_388_368##2	2.24771e-17
C198	X	A1#1	4.39468e-19
C199	VPWR#3	VNB	2.29101e-17
C200	VGND	a_81_48##9	8.40382e-18
C201	X	a_81_48##5	2.64357e-17
C202	VPWR	X#1	1.47461e-17
C203	A2	B2#2	8.9062e-19
C204	A1	B1#3	3.53163e-19
C205	VGND	a_304_74##2	4.09428e-17
C206	X	a_81_48##4	3.66407e-17
C207	A1	A1#3	2.60716e-18
C208	VGND	VGND#5	2.97878e-17
C209	A1	a_81_48#	1.62331e-18
C210	B2	B2#2	6.05709e-18
C211	A1#4	VNB	1.75313e-18
C212	VPWR	a_81_48##4	7.65215e-19
C213	a_304_74#	VNB	4.79558e-17
C214	VGND#6	VNB	2.00548e-18
C215	X	a_81_48#	5.19706e-18
C216	VPWR	A2#4	2.76014e-18
C217	a_81_48##9	VNB	1.72383e-18
C218	VGND	A2#3	9.94178e-19
C219	X	a_81_48##6	2.13019e-17
C220	B1	B1#2	4.65364e-18
C221	a_304_74##2	VNB	1.42071e-17
C222	VGND	B2#3	9.47234e-19
C223	VGND#7	VNB	5.47141e-18
C224	VGND	B1#1	1.41644e-18
C225	B1	A1#2	5.35343e-18
C226	VGND#5	VNB	8.1402e-17
C227	VGND	A1#1	1.61097e-18
C228	VPWR	A1#3	2.62563e-18
C229	VPWR#1	VNB	8.92002e-17
C230	VGND	a_81_48##5	4.14545e-18
C231	a_388_368#	VNB	9.39685e-18
C232	A1	B1#2	1.06173e-18
C233	VPWR	a_81_48#	1.62677e-19
C234	VGND	a_81_48##4	4.92879e-18
C235	a_388_368##2	VNB	7.36738e-18
C236	VPWR	a_81_48##6	8.59066e-19
C237	A1	A1#2	6.01906e-18
C238	VPWR#6	VNB	1.49573e-18
C239	X#1	VNB	2.20717e-18
C240	a_81_48##2	A1	3.81659e-17
C241	VPWR#7	VNB	4.27408e-17
C242	VPWR	VPWR#2	1.99173e-17
C243	A2#3	VNB	3.25687e-17
C244	B2#3	VNB	2.63658e-17
C245	B1#1	VNB	2.97979e-17
C246	A1#1	VNB	3.13384e-17
C247	a_81_48##5	VNB	2.74641e-17
C248	X	a_81_48##2	9.74644e-17
C249	VPWR	B2#2	2.66863e-18
C250	a_81_48##4	VNB	6.1108e-17
C251	VPWR	B1#2	1.61199e-18
C252	B2	A2	3.72826e-17
C253	A2#4	VNB	3.47078e-17
C254	B2#1	VNB	3.15162e-17
C255	VGND	VGND#3	1.61277e-17
C256	B1#3	VNB	3.12191e-17
C257	VPWR	a_81_48##2	6.60023e-18
C258	A1#3	VNB	2.9608e-17
C259	VGND	B2#2	1.93006e-18
C260	a_81_48#	VNB	3.83435e-17
C261	a_81_48##6	VNB	4.63414e-17
C262	VGND	B1#2	2.8696e-18
C263	VPWR#2	VNB	2.02355e-16
C264	VGND	a_81_48##2	7.30127e-18
C265	VGND#3	VNB	1.97067e-16
C266	B2#2	VNB	3.45193e-17
C267	A1	B1	1.61977e-17
C268	B1#2	VNB	3.31402e-17
C269	A1#2	VNB	3.3424e-17
C270	VPWR	A2	2.08534e-18
C271	a_81_48##2	VNB	3.79702e-17
C272	VPWR	B2	2.79495e-18
C273	VGND	A2	4.07382e-18
C274	VPWR	B1	1.39158e-18
C275	VGND	B2	1.86193e-18
C276	VPWR	A1	2.3782e-18
C277	VGND	B1	1.45329e-18
C278	A2	VNB	2.22409e-17
C279	VPWR	X	3.08294e-18
C280	B2	VNB	1.07892e-18
C281	B1	VNB	1.49893e-18
C282	VGND	X	1.83924e-17
C283	A1	VNB	2.12667e-18
C284	X	VNB	2.99315e-17
C285	VPWR	VNB	7.72101e-17
C286	VGND	VNB	6.74178e-17
C287	VGND#2	VNB	5.62834e-17
C288	VGND#2	a_81_48##5	3.36502e-20
C289	VPWR#2	VPWR#4	4.61493e-17
C290	VGND#2	B2#3	4.74947e-18
C291	VGND#2	a_304_74##2	2.35964e-17
C292	VGND#3	VGND#2	6.02179e-17
C293	VGND	VGND#2	5.86534e-17
C294	VPWR	VPWR#4	4.5678e-17
C295	VGND#2	A1#1	2.2793e-19
C296	VPWR#4	a_81_48##2	1.95112e-20
C297	VGND#2	A2#3	6.54155e-18
C298	VGND#2	A2	5.93717e-19
C299	X#1	VPWR#4	7.79362e-18
C300	VGND#2	a_304_74#	2.14328e-17
C301	VPWR#4	a_81_48##6	6.27715e-18
C302	X	VPWR#4	2.04861e-19
C303	VGND#2	B1#1	2.19022e-18
C304	VGND#2	A2#2	2.731e-19
C305	VGND#4	VGND#2	3.02793e-19
C306	VPWR#4	VNB	4.48003e-17
C307	VPWR#4	a_81_48#	5.16438e-19
C308	VPWR#4	VPWR#3	9.54295e-19
*
*
.ENDS sky130_fd_sc_hs__a22o_2
*
