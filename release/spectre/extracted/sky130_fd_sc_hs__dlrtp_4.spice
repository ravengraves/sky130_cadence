* Extracted by Quantus, converted by sky130cad/quantus.py
*
*
*
*                       LINUX           Wed Nov 18 08:32:41 2026
*
*
*
*  PROGRAM  advgen
*
*  Name           : advgen - Quantus - (64-bit)
*  Version        : 25.1.0-p047
*  Build Date     : Thu Dec 11 23:20:30 PST 2025
*
*  HSPICE LIBRARY
*
*  OPERATING_TEMPERATURE 150
*  QRC_TECH_DIR <path>/tech
*
*
*

*
.SUBCKT sky130_fd_sc_hs__dlrtp_4 VPB VNB VGND VPWR Q RESET_B D GATE
*
*
*  caps2d version: 10
*
*
*       TRANSISTOR CARDS
*
*
XM14 a_27_126##6 D#3 VGND#15 VNB sky130_fd_pr__nfet_01v8_lvt l=0.15 w=0.55 ad=0.15675 as=0.38905 pd=1.67 ps=2.57
XM8 VGND#15 GATE#1 a_240_394##10 VNB sky130_fd_pr__nfet_01v8_lvt l=0.15 w=0.74 ad=0.38905 as=0.2109 pd=2.57 ps=2.05
XM25 a_364_120##9 a_240_394# VGND#14 VNB sky130_fd_pr__nfet_01v8_lvt l=0.15 w=0.74 ad=0.2294 as=0.29885 pd=2.1 ps=2.67
XM27 VGND#14 a_27_126##3 a_559_74# VNB sky130_fd_pr__nfet_01v8_lvt l=0.15 w=0.64 ad=0.29885 as=0.1632 pd=2.67 ps=1.79
XM21 a_559_74# a_364_120# a_640_74##10 VNB sky130_fd_pr__nfet_01v8_lvt l=0.15 w=0.64 ad=0.1632 as=0.2555 pd=1.79 ps=2.13
XM29 a_640_74##10 a_240_394##8 a_755_74# VNB sky130_fd_pr__nfet_01v8_lvt l=0.15 w=0.42 ad=0.2555 as=0.0882 pd=2.13 ps=1.26
XM1 a_755_74# a_797_48##3 VGND#13 VNB sky130_fd_pr__nfet_01v8_lvt l=0.15 w=0.42 ad=0.0882 as=0.1197 pd=1.26 ps=1.41
XM12 a_797_48##24 a_640_74##5 a_938_74##4 VNB sky130_fd_pr__nfet_01v8_lvt l=0.15 w=0.64 ad=0.1824 as=0.1824 pd=1.85 ps=1.85
XM26 a_938_74##2 a_640_74##4 a_797_48##24 VNB sky130_fd_pr__nfet_01v8_lvt l=0.15 w=0.64 ad=0.1792 as=0.1824 pd=1.84 ps=1.85
XM6 a_938_74##2 RESET_B#5 VGND#12 VNB sky130_fd_pr__nfet_01v8_lvt l=0.15 w=0.64 ad=0.1792 as=0.1792 pd=1.84 ps=1.84
XM15 VGND#12 RESET_B#3 a_938_74# VNB sky130_fd_pr__nfet_01v8_lvt l=0.15 w=0.64 ad=0.1792 as=0.1824 pd=1.84 ps=1.85
XM13 VGND#11 a_797_48##14 Q#5 VNB sky130_fd_pr__nfet_01v8_lvt l=0.15 w=0.74 ad=0.2109 as=0.2072 pd=2.05 ps=2.04
XM9 VGND#10 a_797_48##11 Q#5 VNB sky130_fd_pr__nfet_01v8_lvt l=0.15 w=0.74 ad=0.2072 as=0.2072 pd=2.04 ps=2.04
XM18 Q#1 a_797_48##9 VGND#10 VNB sky130_fd_pr__nfet_01v8_lvt l=0.15 w=0.74 ad=0.2072 as=0.2072 pd=2.04 ps=2.04
XM4 Q#1 a_797_48##4 VGND#1 VNB sky130_fd_pr__nfet_01v8_lvt l=0.15 w=0.74 ad=0.2072 as=0.2109 pd=2.04 ps=2.05
XM7 a_27_126##7 D#1 VPWR#14 VPB sky130_fd_pr__pfet_01v8 l=0.15 w=0.84 ad=0.2478 as=0.4557 pd=2.27 ps=3.04
XM5 VPWR#14 GATE#3 a_240_394##13 VPB sky130_fd_pr__pfet_01v8 l=0.15 w=0.84 ad=0.4557 as=0.294 pd=3.04 ps=2.38
XM19 a_364_120##8 a_240_394##4 VPWR#12 VPB sky130_fd_pr__pfet_01v8 l=0.15 w=0.84 ad=0.2478 as=0.3806 pd=2.27 ps=2.79
XM24 VPWR#12 a_27_126# a_562_392# VPB sky130_fd_pr__pfet_01v8 l=0.15 w=1 ad=0.3806 as=0.24 pd=2.79 ps=2.48
XM2 a_562_392# a_240_394##7 a_640_74##9 VPB sky130_fd_pr__pfet_01v8 l=0.15 w=1 ad=0.24 as=0.3328 pd=2.48 ps=2.77
XM17 a_640_74##9 a_364_120##3 a_747_508# VPB sky130_fd_pr__pfet_01v8 l=0.15 w=0.42 ad=0.3328 as=0.1995 pd=2.77 ps=1.79
XM20 a_747_508# a_797_48# VPWR#9 VPB sky130_fd_pr__pfet_01v8 l=0.15 w=0.42 ad=0.1995 as=0.4186 pd=1.79 ps=3.47
XM23 VPWR#9 a_640_74##6 a_797_48##20 VPB sky130_fd_pr__pfet_01v8 l=0.15 w=0.84 ad=0.4186 as=0.252 pd=3.47 ps=2.28
XM28 a_797_48##20 a_640_74# VPWR#7 VPB sky130_fd_pr__pfet_01v8 l=0.15 w=0.84 ad=0.252 as=0.294 pd=2.28 ps=2.38
XM11 a_797_48##23 RESET_B#6 VPWR#7 VPB sky130_fd_pr__pfet_01v8 l=0.15 w=0.84 ad=0.294 as=0.294 pd=2.38 ps=2.38
XM3 VPWR#5 RESET_B#1 a_797_48##23 VPB sky130_fd_pr__pfet_01v8 l=0.15 w=0.84 ad=0.406 as=0.294 pd=3.01 ps=2.38
XM16 VPWR#5 a_797_48##16 Q#4 VPB sky130_fd_pr__pfet_01v8 l=0.15 w=1.12 ad=0.406 as=0.336 pd=3.01 ps=2.84
XM0 Q#4 a_797_48##15 VPWR#3 VPB sky130_fd_pr__pfet_01v8 l=0.15 w=1.12 ad=0.336 as=0.392 pd=2.84 ps=2.94
XM22 VPWR#3 a_797_48##10 Q#6 VPB sky130_fd_pr__pfet_01v8 l=0.15 w=1.12 ad=0.392 as=0.4144 pd=2.94 ps=2.98
XM10 Q#6 a_797_48##8 VPWR#1 VPB sky130_fd_pr__pfet_01v8 l=0.15 w=1.12 ad=0.4144 as=0.364 pd=2.98 ps=2.89
*
*
*       RESISTOR AND CAP/DIODE CARDS
*
Rg1	D#1	D#2	363.040771
Rg2	D#2	D#3	340.656342
Rg3	GATE#1	GATE#2	412.174225
Rg4	GATE#2	GATE#3	375.801636
Rg5	a_240_394#	a_240_394##2	322.953644
Rg6	a_240_394##2	a_240_394##3	71.940140
Rg7	a_240_394##2	a_240_394##4	378.197601
Rg8	a_27_126#	a_27_126##2	400.207520
Rg9	a_27_126##2	a_27_126##3	480.096283
Rg10	a_364_120#	a_364_120##2	439.477417
Rg11	a_364_120##3	a_364_120##4	226.096359
Rg12	a_240_394##5	a_240_394##6	41.441631
Rg13	a_240_394##6	a_240_394##7	779.216919
Rg14	a_240_394##6	a_240_394##8	423.900208
Rg15	a_797_48#	a_797_48##2	233.787552
Rg16	a_797_48##2	a_797_48##3	993.743042
Rg17	a_640_74#	a_640_74##2	421.880493
Rg18	a_640_74##2	a_640_74##3	207.228409
Rg19	a_640_74##2	a_640_74##4	381.555969
Rg20	a_640_74##3	a_640_74##5	399.940826
Rg21	a_640_74##3	a_640_74##6	343.006531
Rg22	RESET_B#1	RESET_B#2	487.415192
Rg23	RESET_B#2	RESET_B#3	274.466827
Rg24	RESET_B#2	RESET_B#4	39.488701
Rg25	RESET_B#4	RESET_B#5	410.559875
Rg26	RESET_B#4	RESET_B#6	440.136902
Rg27	a_797_48##4	a_797_48##5	407.617157
Rg28	a_797_48##5	a_797_48##6	57.058273
Rg29	a_797_48##6	a_797_48##7	45.851303
Rg30	a_797_48##5	a_797_48##8	438.414917
Rg31	a_797_48##6	a_797_48##9	342.058960
Rg32	a_797_48##7	a_797_48##10	451.334412
Rg33	a_797_48##7	a_797_48##11	348.334229
Rg34	a_797_48##7	a_797_48##12	74.132271
Rg35	a_797_48##12	a_797_48##13	24.422762
Rg36	a_797_48##13	a_797_48##14	344.154114
Rg37	a_797_48##12	a_797_48##15	441.762421
Rg38	a_797_48##13	a_797_48##16	500.491058
Rf1	D#4	D	0.839094
Rf2	D#2	D#6	161.071899
Rf3	D#4	D#6	5.708254
Rf4	GATE#2	GATE#5	160.921738
Rf5	GATE#6	GATE	0.688927
Rf6	GATE#5	GATE#6	2.422064
Rf7	a_27_126##2	a_27_126##5	348.369812
Rf8	a_27_126##5	a_27_126##6	111.509979
Rf9	a_27_126##5	a_27_126##7	17.882317
Rf10	a_364_120##4	a_364_120##2	363.967163
Rf11	a_364_120##2	a_364_120##7	71.465111
Rf12	a_364_120##7	a_364_120##8	85.107071
Rf13	a_364_120##7	a_364_120##9	28.247131
Rf14	a_240_394##5	a_240_394##11	438.064209
Rf15	a_240_394##11	a_240_394##12	46.257896
Rf16	a_240_394##12	a_240_394##13	51.928234
Rf17	a_240_394##12	a_240_394##3	164.387070
Rf18	a_240_394##10	a_240_394##11	7.500000
Rf19	a_640_74##3	a_640_74##8	259.741608
Rf20	a_640_74##8	a_640_74##9	78.959297
Rf21	a_640_74##8	a_640_74##10	88.892334
Rf22	RESET_B	RESET_B#7	10.235490
Rf23	RESET_B#7	RESET_B	8.660800
Rf24	a_938_74#	a_938_74##3	79.542404
Rf25	a_938_74##3	a_938_74##4	84.240501
Rf26	a_938_74##2	a_938_74##3	7.500000
Rf27	a_797_48##7	a_797_48##18	121.643600
Rf28	a_797_48##18	a_797_48##19	63.289322
Rf29	a_797_48##19	a_797_48##21	29.035107
Rf30	a_797_48##21	a_797_48##2	187.649750
Rf31	a_797_48##18	a_797_48##23	26.023315
Rf32	a_797_48##19	a_797_48##24	80.290909
Rf33	a_797_48##20	a_797_48##21	7.500000
Rf34	Q#1	Q#2	18.591946
Rf35	Q#2	Q	34.902885
Rf36	Q	Q#3	52.070721
Rf37	Q#3	Q#4	96.104614
Rf38	Q#2	Q#5	60.814251
Rf39	Q#3	Q#6	21.948624
Rf40	VGND#1	VGND#2	97.732796
Rf41	VGND#2	VGND#3	61.788937
Rf42	VGND#3	VGND#4	69.763435
Rf43	VGND#4	VGND#5	132.594925
Rf44	VGND#5	VGND#6	69.796043
Rf45	VGND#6	VGND#7	62.798893
Rf46	VGND#7	VGND#8	120.849503
Rf48	VGND#2	VGND#10	36.037033
Rf49	VGND#3	VGND#11	40.197906
Rf50	VGND#4	VGND#12	31.948624
Rf51	VGND#5	VGND#13	40.352859
Rf52	VGND#7	VGND#14	31.948624
Rf53	VGND#8	VGND#15	42.184113
Rf54	VPWR#1	VPWR#2	93.767952
Rf55	VPWR#2	VPWR#3	39.559868
Rf56	VPWR#2	VPWR#4	83.435661
Rf57	VPWR#4	VPWR#5	37.105022
Rf58	VPWR#4	VPWR#6	75.558197
Rf59	VPWR#6	VPWR#7	44.624348
Rf60	VPWR#6	VPWR#8	83.937767
Rf61	VPWR#8	VPWR#9	25.192423
Rf62	VPWR#8	VPWR#10	92.363106
Rf63	VPWR#10	VPWR#11	62.798893
Rf64	VPWR#11	VPWR#12	32.342297
Rf65	VPWR#11	VPWR#13	123.041023
Rf66	VPWR#13	VPWR#14	29.586588
Rf76	RESET_B#2	RESET_B#7	80.116402
Re1	VPWR#2	VPWR	3.246228
Re2	VPWR	VPWR#10	1.159367
Re3	VGND#2	VGND	3.246228
Re4	VGND	VGND#6	1.159367
*
*       CAPACITOR CARDS
*
*
C1	VGND#11	RESET_B#4	1.67494e-18
C2	a_240_394##12	a_240_394##13	2.10833e-18
C3	VGND#4	RESET_B#5	1.21695e-18
C4	Q#6	a_797_48##15	2.76909e-19
C5	VGND#3	a_797_48##7	1.09098e-18
C6	Q#4	a_797_48##10	1.62649e-18
C7	RESET_B#3	a_797_48##14	4.11678e-18
C8	VPWR#8	a_640_74##3	8.43474e-19
C9	a_797_48##15	VPWR#3	2.53955e-17
C10	VGND#5	a_640_74##4	1.29615e-19
C11	VPWR#6	a_640_74##3	1.03319e-20
C12	VPWR#5	a_797_48##10	3.03503e-19
C13	a_797_48##7	Q#3	9.02845e-17
C14	VPWR#6	RESET_B#4	9.12908e-20
C15	Q#4	a_797_48##15	7.2717e-17
C16	Q#2	a_797_48##7	5.7931e-17
C17	VPWR#11	a_240_394##2	1.51761e-20
C18	a_938_74#	a_797_48##18	4.04481e-18
C19	VGND#4	a_640_74##4	4.66526e-18
C20	VGND#3	a_797_48##18	1.15289e-18
C21	VPWR#3	a_797_48##16	1.18587e-18
C22	VPWR#5	a_797_48##15	2.68843e-18
C23	RESET_B#5	RESET_B#3	3.35957e-17
C24	VPWR#8	a_240_394##6	5.81111e-19
C25	a_240_394##6	a_797_48##3	2.7273e-17
C26	a_797_48##2	VPWR#8	5.17298e-17
C27	a_938_74#	RESET_B#4	4.65698e-18
C28	Q#4	a_797_48##16	1.82787e-17
C29	VGND#5	a_640_74##5	5.93698e-18
C30	a_797_48##23	a_797_48##15	2.56104e-19
C31	a_27_126##7	a_240_394##12	5.11951e-18
C32	VGND#5	a_640_74##3	5.45412e-19
C33	VPWR#7	RESET_B#4	4.23123e-19
C34	VPWR#5	a_797_48##16	6.69057e-17
C35	VPWR#6	a_640_74##2	4.63371e-20
C36	VGND#4	a_640_74##3	2.4901e-20
C37	a_240_394##10	a_640_74##10	3.12323e-17
C38	Q#4	RESET_B#1	5.19367e-19
C39	a_938_74##2	a_797_48##19	7.43146e-18
C40	a_797_48##23	a_797_48##16	1.79776e-18
C41	a_640_74##4	RESET_B#5	3.3422e-17
C42	VPWR#4	RESET_B#4	3.44682e-20
C43	RESET_B#1	VPWR#5	2.01314e-17
C44	VGND#5	a_797_48##3	8.92426e-18
C45	VPWR#7	a_797_48##16	1.29429e-18
C46	a_640_74##10	a_240_394##7	8.11749e-19
C47	a_797_48##23	RESET_B#1	5.24103e-17
C48	a_938_74##2	a_797_48##18	2.18784e-18
C49	VGND#12	RESET_B#4	7.44024e-19
C50	VPWR#5	RESET_B#6	7.37502e-19
C51	VPWR#7	RESET_B#1	2.00755e-18
C52	a_640_74##5	a_640_74##4	3.77929e-17
C53	a_240_394##10	VGND#14	7.3045e-17
C54	a_364_120##4	VPWR#11	1.11939e-17
C55	VGND#14	VGND#5	1.21994e-20
C56	a_797_48##23	RESET_B#6	1.58715e-17
C57	a_797_48##19	a_640_74##3	6.64362e-17
C58	a_797_48##20	RESET_B#1	6.01227e-20
C59	VGND#5	a_240_394##8	7.16231e-19
C60	a_364_120##4	VPWR#8	3.15007e-17
C61	VGND#5	a_240_394##5	2.18289e-17
C62	VPWR#7	RESET_B#6	5.466e-17
C63	a_240_394##10	a_364_120##9	3.93155e-17
C64	VGND#15	VGND#14	1.03699e-18
C65	a_797_48##23	a_640_74#	5.7205e-19
C66	a_797_48##20	RESET_B#6	1.33993e-18
C67	a_797_48##3	a_640_74##5	1.25223e-17
C68	a_640_74#	VPWR#7	2.04187e-17
C69	VGND#2	VGND#1	6.24797e-17
C70	a_364_120#	a_240_394##6	1.38498e-18
C71	VGND#5	a_364_120#	1.15205e-19
C72	a_640_74##8	a_640_74##3	1.74802e-18
C73	a_938_74##2	RESET_B#4	9.37821e-19
C74	VGND#2	Q#1	2.30736e-17
C75	a_797_48##20	a_640_74#	4.60868e-17
C76	VGND#7	a_240_394##10	1.97582e-17
C77	VGND#2	VGND#10	1.79325e-17
C78	VPWR#7	a_640_74##6	8.46402e-19
C79	a_240_394##8	a_797_48##3	4.60899e-17
C80	VGND#7	a_27_126##3	9.40368e-19
C81	VGND#2	Q#5	2.31483e-17
C82	a_797_48##20	a_640_74##6	5.23813e-17
C83	VGND#15	a_240_394##10	4.31378e-17
C84	a_938_74##2	a_640_74##2	8.60028e-20
C85	a_240_394##5	a_797_48##19	1.55295e-18
C86	a_240_394##12	a_240_394##2	1.08133e-19
C87	a_27_126##2	VPWR#11	3.45394e-18
C88	a_640_74##8	a_797_48##2	1.32865e-17
C89	VPWR#7	a_797_48#	7.86767e-19
C90	VGND#5	a_27_126##3	6.70152e-20
C91	a_640_74##6	VPWR#9	1.38389e-17
C92	VGND#2	a_938_74#	4.9916e-18
C93	a_797_48##20	a_797_48#	5.56486e-19
C94	a_364_120#	a_240_394##8	1.67619e-17
C95	a_27_126##6	a_240_394##10	7.12564e-18
C96	VPWR#2	a_797_48##13	2.81578e-20
C97	a_797_48##19	a_797_48##3	1.87231e-19
C98	VGND#7	a_240_394#	3.59676e-18
C99	a_797_48##24	RESET_B#4	1.02049e-18
C100	a_797_48#	VPWR#9	9.72178e-18
C101	a_240_394##5	a_640_74##8	4.89489e-17
C102	a_797_48##20	a_364_120##3	1.45503e-19
C103	VPWR#11	a_240_394##3	1.48044e-19
C104	VPWR#2	a_797_48##6	1.47398e-19
C105	a_27_126##6	VGND#15	4.73311e-17
C106	a_797_48##19	a_797_48##18	1.44307e-18
C107	a_27_126##3	a_364_120#	3.85279e-17
C108	a_27_126##7	GATE#5	1.33632e-17
C109	a_797_48##24	a_640_74##2	1.27445e-18
C110	a_797_48##7	Q#1	2.5634e-18
C111	a_797_48##20	a_240_394##7	1.5003e-19
C112	a_938_74##4	a_797_48##20	1.40236e-18
C113	a_797_48##7	VGND#10	4.10896e-18
C114	a_640_74##8	a_364_120##4	5.67899e-17
C115	a_364_120##3	a_640_74##9	1.04413e-17
C116	a_797_48##7	Q#5	6.05501e-17
C117	VPWR#12	a_797_48#	7.33327e-20
C118	VGND#7	a_240_394##3	3.00467e-19
C119	a_240_394#	a_27_126##3	2.46175e-17
C120	a_797_48##24	a_240_394##6	2.79712e-19
C121	VGND#2	a_797_48##13	7.50956e-19
C122	a_797_48##7	VGND#11	3.52898e-17
C123	VPWR#11	VPWR#8	2.04651e-19
C124	VGND#3	a_797_48##13	2.58904e-20
C125	D#6	a_27_126##7	4.7366e-17
C126	a_640_74##9	a_240_394##7	3.26813e-17
C127	VPWR#12	a_364_120##3	1.27739e-19
C128	GATE#1	a_27_126##3	5.96453e-19
C129	VGND#2	a_797_48##6	1.93736e-19
C130	a_364_120##2	a_640_74##8	6.61194e-17
C131	a_640_74##8	a_797_48##3	4.75489e-19
C132	GATE#1	a_240_394#	4.20999e-18
C133	a_938_74##4	a_640_74##2	4.21238e-20
C134	VGND#13	a_640_74##8	2.86719e-18
C135	a_640_74##9	a_27_126#	1.31973e-18
C136	VPWR#12	a_240_394##7	1.67831e-18
C137	VPWR#2	VPWR#1	7.0882e-17
C138	Q#6	VPWR#2	3.66805e-17
C139	Q#4	VPWR#4	6.49641e-18
C140	a_640_74##8	a_27_126##2	4.27414e-19
C141	VPWR#12	a_27_126#	4.27183e-17
C142	a_240_394##6	a_640_74##9	3.16376e-19
C143	Q#6	VPWR#1	7.31585e-17
C144	VPWR#2	VPWR#3	2.18869e-17
C145	D#3	GATE#1	1.36406e-17
C146	a_364_120##7	a_364_120##2	3.24788e-18
C147	VPWR#6	VPWR#5	2.03419e-18
C148	a_364_120##8	a_27_126#	1.81574e-18
C149	Q#4	VPWR#2	2.35646e-17
C150	a_240_394##4	VPWR#12	1.81672e-17
C151	VGND#1	a_797_48##4	2.78077e-17
C152	VPWR#2	VPWR#5	1.96072e-17
C153	VPWR#3	VPWR#1	1.53949e-18
C154	VPWR#8	VPWR#6	2.81558e-18
C155	VGND#6	a_240_394##10	6.55272e-18
C156	a_364_120##8	a_240_394##4	4.12592e-17
C157	a_364_120##7	a_240_394##2	1.04197e-17
C158	VPWR#14	a_27_126#	1.28171e-18
C159	a_797_48##24	a_640_74##3	3.96076e-19
C160	VGND#2	Q#4	2.60058e-18
C161	VGND#7	a_240_394##2	5.65972e-20
C162	a_364_120##7	a_27_126##2	2.80286e-17
C163	VPWR#12	GATE#3	1.40158e-18
C164	a_797_48##4	Q#1	1.72024e-17
C165	a_240_394##13	a_240_394##4	1.04892e-18
C166	VGND#4	RESET_B#4	1.96492e-19
C167	a_938_74##4	a_640_74##3	2.16736e-17
C168	a_640_74##10	a_640_74##8	2.18649e-18
C169	a_27_126##7	a_27_126#	2.77937e-19
C170	VPWR#3	Q#6	7.31559e-17
C171	a_797_48##23	VPWR#6	4.37262e-18
C172	VGND#1	a_797_48##9	2.20806e-18
C173	a_364_120##8	GATE#3	5.07282e-19
C174	VGND#13	a_640_74##3	5.6739e-18
C175	a_240_394##12	a_240_394##3	2.04231e-17
C176	VPWR#14	a_240_394##4	1.75402e-18
C177	RESET_B#4	a_797_48##13	1.43421e-17
C178	VGND#5	a_240_394##6	6.61834e-19
C179	VGND#10	a_797_48##4	2.31526e-18
C180	VPWR#10	a_240_394##6	2.26975e-20
C181	VPWR#12	D#1	1.03608e-18
C182	a_240_394##13	GATE#3	3.83621e-17
C183	a_27_126##7	a_240_394##4	9.60774e-19
C184	VPWR#8	VPWR#7	7.11796e-18
C185	Q#3	VPWR#1	7.99831e-18
C186	a_797_48##9	Q#1	1.8592e-17
C187	a_797_48##23	VPWR#4	2.94445e-18
C188	Q#4	Q#6	9.26253e-19
C189	GATE#3	VPWR#14	2.09995e-17
C190	VGND#13	a_797_48##2	9.72023e-19
C191	Q#5	a_797_48##4	2.84618e-19
C192	VGND#4	a_640_74##2	2.54234e-20
C193	a_240_394##13	D#1	1.66701e-18
C194	a_27_126##7	GATE#3	3.84955e-17
C195	a_240_394##12	GATE#2	1.03642e-17
C196	a_797_48##7	Q#6	4.05462e-18
C197	VPWR#8	a_797_48##16	4.87892e-19
C198	VGND#10	a_797_48##9	3.27164e-17
C199	a_240_394##5	a_797_48##24	3.11533e-18
C200	D#1	VPWR#14	3.18789e-17
C201	a_797_48##10	a_797_48##8	3.56034e-17
C202	Q#4	VPWR#3	7.34712e-17
C203	a_797_48##7	VPWR#3	4.15674e-18
C204	a_240_394##5	a_938_74##4	7.61493e-18
C205	Q#1	a_797_48##11	1.23384e-18
C206	VPWR#6	a_797_48##16	1.05432e-18
C207	a_27_126##7	D#1	5.68063e-17
C208	a_240_394##5	VGND#13	5.00719e-17
C209	a_797_48##7	Q#4	4.04414e-17
C210	VPWR#6	VPWR#4	8.86394e-19
C211	Q#3	Q#6	4.48638e-18
C212	a_364_120##7	GATE#2	1.02753e-19
C213	a_797_48##20	VPWR#8	1.8113e-17
C214	Q#5	a_797_48##9	6.60468e-19
C215	Q#3	a_797_48##8	2.0422e-17
C216	a_797_48##7	VPWR#5	9.37777e-18
C217	VPWR#4	a_797_48##16	4.2295e-18
C218	VGND#10	a_797_48##11	2.93715e-17
C219	VGND#6	a_240_394##6	4.31598e-20
C220	VPWR#5	VPWR#3	1.77565e-18
C221	GATE#5	a_240_394##3	1.20262e-18
C222	a_240_394##12	D#2	4.8962e-19
C223	a_240_394##5	a_640_74##10	1.08947e-16
C224	a_797_48##15	a_797_48##10	3.8188e-17
C225	a_797_48##7	a_797_48##13	3.24245e-17
C226	Q#1	a_797_48##14	4.14547e-19
C227	a_797_48##20	VPWR#6	3.69558e-18
C228	Q#5	a_797_48##11	3.31714e-17
C229	VPWR#5	Q#4	7.71198e-17
C230	Q#3	VPWR#3	2.94372e-17
C231	a_797_48##7	a_797_48##6	2.50348e-17
C232	Q#3	a_797_48##6	5.39522e-18
C233	VPWR#8	VPWR#9	9.93567e-18
C234	VGND#10	a_797_48##14	2.25169e-18
C235	GATE#5	GATE#2	8.2862e-18
C236	a_797_48##16	a_797_48##15	4.80206e-17
C237	Q#3	a_797_48##10	1.3175e-17
C238	a_240_394##10	a_240_394##5	1.75948e-18
C239	VPWR#4	RESET_B#1	3.51237e-18
C240	a_240_394##12	a_240_394#	3.13903e-19
C241	VGND#11	a_797_48##11	4.43846e-19
C242	D#6	GATE#2	6.12443e-19
C243	Q#1	VGND#1	3.20084e-17
C244	Q#5	a_797_48##14	4.00801e-17
C245	a_797_48##23	Q#4	4.48215e-18
C246	VPWR#8	RESET_B#6	4.37286e-19
C247	VGND#2	a_797_48##4	2.45136e-18
C248	a_364_120##2	a_640_74##10	4.42793e-17
C249	VGND#10	RESET_B#3	9.57079e-20
C250	a_640_74##10	a_240_394##6	6.57569e-18
C251	RESET_B#1	a_797_48##16	3.05425e-17
C252	Q#4	Q#3	1.56845e-18
C253	VPWR#6	RESET_B#6	5.73347e-19
C254	GATE#5	D#2	3.74352e-19
C255	VGND#2	a_797_48##9	1.38133e-18
C256	a_797_48##14	VGND#11	2.0736e-17
C257	a_640_74##3	a_797_48##20	1.71043e-17
C258	Q#3	a_797_48##15	4.68899e-19
C259	a_797_48##23	VPWR#5	5.63224e-17
C260	a_240_394##12	GATE#1	3.60197e-18
C261	VGND#2	a_797_48##11	1.4664e-18
C262	VGND#10	VGND#1	2.78421e-18
C263	D#6	D#2	1.09943e-17
C264	a_640_74##3	VPWR#9	1.52308e-18
C265	Q#5	RESET_B#3	1.43432e-19
C266	a_364_120##8	a_240_394##2	9.82031e-18
C267	VGND#2	a_797_48##14	1.29923e-18
C268	a_240_394##10	a_364_120##2	3.28459e-17
C269	a_938_74#	a_797_48##14	1.13362e-18
C270	a_364_120##7	a_240_394#	2.01694e-17
C271	RESET_B#6	RESET_B#1	3.26373e-17
C272	Q#2	a_797_48##6	3.11384e-18
C273	VPWR#8	a_640_74#	8.51021e-19
C274	a_797_48##20	a_797_48##2	5.2285e-19
C275	a_364_120##9	a_364_120##8	3.42197e-18
C276	VPWR#7	VPWR#5	6.20286e-18
C277	VGND#11	RESET_B#3	3.19131e-18
C278	a_27_126##2	VGND#14	1.05155e-18
C279	a_797_48##2	VPWR#9	3.53763e-18
C280	VPWR#6	a_640_74#	1.7035e-18
C281	VGND#12	a_797_48##14	7.00008e-19
C282	VGND#10	Q#1	3.1994e-17
C283	a_240_394##12	D#3	7.54736e-19
C284	a_240_394##12	a_364_120##9	2.34932e-17
C285	a_240_394##10	a_27_126##2	5.35869e-19
C286	a_938_74#	RESET_B#3	3.66037e-17
C287	a_640_74#	RESET_B#6	3.25753e-17
C288	VPWR#7	a_797_48##23	6.64667e-17
C289	a_938_74##2	a_797_48##14	6.33968e-20
C290	VGND#11	RESET_B#5	2.24411e-19
C291	a_364_120##9	a_240_394##3	5.26213e-18
C292	VPWR#8	a_640_74##6	1.08434e-17
C293	VGND#12	RESET_B#3	2.76118e-17
C294	Q#5	Q#1	3.47845e-18
C295	a_364_120##4	a_797_48##20	1.50766e-18
C296	a_240_394##10	a_240_394##3	1.75737e-18
C297	a_797_48##20	a_797_48##23	8.02752e-19
C298	a_240_394##13	a_240_394##2	2.70333e-20
C299	a_240_394##10	a_240_394##12	3.37258e-18
C300	a_797_48##24	a_797_48##14	1.39615e-19
C301	a_640_74##6	a_640_74#	3.52669e-17
C302	a_938_74#	RESET_B#5	4.51683e-19
C303	a_938_74##2	RESET_B#3	4.33069e-19
C304	a_364_120##7	VGND#14	3.60169e-18
C305	VGND#11	a_640_74##4	2.01626e-19
C306	a_797_48##16	a_797_48##13	3.80102e-18
C307	a_364_120##4	a_640_74##9	7.74695e-17
C308	VGND#12	RESET_B#5	2.46061e-17
C309	a_797_48##20	VPWR#7	6.70363e-17
C310	Q#5	VGND#10	4.58023e-17
C311	VGND#15	GATE#2	3.82838e-18
C312	a_797_48#	a_640_74##6	5.91535e-18
C313	a_797_48##24	RESET_B#3	2.09829e-19
C314	a_938_74#	a_640_74##4	1.94223e-19
C315	VPWR#8	a_797_48#	2.41519e-17
C316	a_640_74##3	a_640_74##2	1.01534e-17
C317	VPWR#12	a_364_120##4	2.5898e-17
C318	a_27_126##6	GATE#2	2.6069e-18
C319	VGND#6	a_240_394##8	4.49509e-18
C320	a_938_74##2	RESET_B#5	3.05637e-17
C321	a_364_120##2	a_640_74##9	4.55613e-17
C322	a_797_48##18	Q#4	7.30156e-19
C323	a_640_74##3	a_240_394##6	1.61946e-18
C324	VGND#11	a_640_74##5	1.45745e-19
C325	VPWR#6	a_797_48#	5.2233e-19
C326	VGND#6	a_364_120#	4.43104e-18
C327	VGND#12	a_640_74##4	1.22339e-18
C328	VPWR#12	VPWR#8	9.66428e-21
C329	a_364_120##3	a_797_48#	1.01511e-17
C330	VGND#11	VGND#10	2.88443e-18
C331	VPWR#12	a_364_120##2	1.05421e-17
C332	a_797_48##24	RESET_B#5	4.40469e-19
C333	a_27_126##6	D#2	7.75787e-18
C334	VPWR#2	a_797_48##8	1.02302e-18
C335	a_797_48##19	a_797_48##13	5.57969e-19
C336	a_797_48##19	RESET_B#1	1.88765e-19
C337	a_938_74##2	a_640_74##4	4.76101e-17
C338	a_797_48##20	VPWR#9	2.0999e-19
C339	VPWR#2	a_797_48##10	1.56989e-18
C340	VGND#15	a_27_126##7	2.30934e-18
C341	a_27_126##6	a_240_394##12	5.97913e-18
C342	VPWR#8	a_364_120##3	2.36402e-18
C343	a_797_48##18	RESET_B#1	1.4881e-17
C344	a_27_126##2	VPWR#12	4.39088e-17
C345	a_240_394##7	a_364_120##3	1.61349e-17
C346	a_797_48##18	VPWR#5	2.16307e-17
C347	VGND#12	a_640_74##5	1.73293e-19
C348	a_240_394##10	a_364_120##7	4.26096e-17
C349	RESET_B#1	a_797_48##13	6.60702e-19
C350	VPWR#2	a_797_48##15	5.95545e-18
C351	a_797_48##3	a_640_74##3	1.19411e-17
C352	a_27_126##2	a_364_120##8	5.80409e-17
C353	VGND#11	Q#5	6.72122e-17
C354	a_640_74##4	a_797_48##24	1.70163e-17
C355	a_27_126##6	a_27_126##7	2.93672e-18
C356	VPWR#2	a_797_48##16	3.09671e-18
C357	a_797_48##19	a_797_48##23	3.00106e-18
C358	a_938_74##2	a_640_74##5	1.16319e-18
C359	a_640_74##2	RESET_B#4	3.01922e-17
C360	a_797_48##3	a_797_48##2	1.26074e-18
C361	a_797_48##19	RESET_B#6	4.9907e-19
C362	a_240_394##5	a_640_74##4	1.27071e-19
C363	a_240_394##6	a_797_48##2	2.02868e-17
C364	a_27_126#	a_240_394##7	5.7049e-17
C365	a_938_74##4	a_640_74##4	1.2376e-18
C366	a_364_120##8	a_240_394##3	4.78276e-18
C367	a_27_126##7	a_27_126##2	1.01406e-18
C368	VGND#12	a_797_48##3	7.41147e-20
C369	a_240_394##5	a_640_74##5	7.8757e-19
C370	a_797_48##18	RESET_B#6	7.9668e-18
C371	a_640_74##5	a_797_48##24	1.88049e-17
C372	VPWR#8	a_240_394##7	7.14193e-20
C373	a_797_48##20	a_640_74##9	2.06301e-19
C374	a_240_394##5	a_797_48##3	3.24821e-17
C375	a_797_48##7	a_797_48##8	4.50281e-19
C376	a_27_126##7	a_240_394##2	2.0651e-20
C377	a_240_394##5	a_240_394##8	1.50713e-17
C378	a_27_126##7	a_240_394##3	2.02808e-18
C379	a_364_120##8	GATE#2	6.80306e-20
C380	a_240_394##4	a_27_126#	2.64123e-17
C381	a_364_120##9	a_240_394##2	1.72985e-18
C382	a_797_48##19	VPWR#7	1.80485e-17
C383	a_797_48##7	a_797_48##10	4.90959e-19
C384	a_938_74##4	a_640_74##5	5.99653e-17
C385	a_240_394##13	GATE#2	3.87175e-18
C386	a_240_394##5	a_364_120#	1.21676e-17
C387	a_797_48##19	a_640_74#	1.37276e-17
C388	GATE#3	a_27_126#	1.98293e-19
C389	a_797_48##7	a_797_48##15	8.982e-19
C390	a_240_394##5	a_27_126##3	1.23026e-19
C391	a_797_48##24	a_797_48##3	9.53963e-19
C392	a_938_74#	VGND#11	4.53629e-17
C393	VPWR#11	a_27_126#	4.76865e-18
C394	a_27_126##7	GATE#2	5.93556e-18
C395	a_797_48##7	a_797_48##16	6.66231e-18
C396	GATE#3	a_240_394##4	5.97094e-18
C397	VGND#13	a_640_74##5	7.66923e-19
C398	RESET_B	a_797_48##13	1.85679e-18
C399	a_797_48##18	VPWR#7	1.67133e-17
C400	a_240_394##13	D#2	4.28134e-20
C401	a_240_394##5	a_640_74##2	2.16619e-19
C402	RESET_B	a_797_48##6	2.05531e-19
C403	VPWR#14	VPWR#11	1.64596e-19
C404	VPWR#8	a_27_126#	2.33554e-20
C405	RESET_B	RESET_B#4	3.42414e-17
C406	a_938_74##4	a_797_48##3	8.58768e-18
C407	RESET_B	a_640_74##2	4.37404e-18
C408	a_240_394##10	a_240_394##6	1.68589e-19
C409	a_240_394##5	a_240_394##6	2.09019e-17
C410	a_27_126##7	D#2	9.63517e-18
C411	a_797_48##19	a_797_48##20	4.06301e-19
C412	VGND#7	VGND#5	2.32836e-19
C413	D#1	GATE#3	1.91037e-17
C414	VGND#12	VGND#11	2.26578e-18
C415	a_797_48##19	a_640_74##6	1.98481e-18
C416	a_364_120##2	a_27_126##3	1.86387e-17
C417	VGND#13	a_797_48##3	2.35343e-17
C418	VPWR#10	a_364_120##3	4.61111e-18
C419	a_364_120##2	a_240_394#	1.63475e-19
C420	VPWR#11	a_240_394##4	5.96505e-18
C421	VPWR#10	a_240_394##7	4.49463e-18
C422	a_240_394##10	a_240_394##2	2.3296e-19
C423	a_27_126##7	VPWR#11	4.52308e-18
C424	a_240_394#	a_27_126##2	4.65818e-18
C425	VGND#6	a_240_394##7	2.15048e-20
C426	a_938_74#	VGND#12	4.05529e-17
C427	a_640_74##3	a_640_74#	4.67058e-18
C428	a_640_74##8	a_640_74#	1.34409e-19
C429	a_797_48##19	RESET_B#4	1.70483e-18
C430	a_640_74##2	RESET_B#6	9.2828e-19
C431	a_640_74##3	a_640_74##6	5.29607e-18
C432	a_640_74##10	a_797_48##3	3.13348e-18
C433	Q	a_797_48##13	2.26861e-19
C434	Q	a_797_48##6	1.81213e-17
C435	a_797_48##2	a_640_74##6	1.66849e-17
C436	a_240_394##6	a_364_120##4	2.5617e-17
C437	GATE#2	a_240_394#	5.3276e-19
C438	a_938_74##2	a_938_74#	2.38898e-18
C439	a_797_48##24	VGND#11	1.51138e-18
C440	a_797_48##2	a_797_48#	3.62737e-18
C441	a_640_74##8	a_640_74##6	1.33185e-19
C442	a_640_74##10	a_240_394##8	2.50606e-17
C443	a_797_48##2	a_364_120##3	2.10922e-19
C444	VPWR#1	a_797_48##6	7.28489e-19
C445	VGND#5	VGND#4	2.32836e-19
C446	a_797_48##19	a_640_74##2	1.69012e-17
C447	VGND#14	a_797_48##3	4.32186e-20
C448	a_240_394##7	a_797_48##2	1.93657e-19
C449	a_364_120##4	a_640_74##6	3.28428e-19
C450	a_240_394##10	a_559_74#	9.05537e-18
C451	a_364_120##4	a_797_48#	9.61762e-18
C452	a_938_74##2	VGND#12	4.28559e-17
C453	a_240_394##5	a_240_394##7	5.31392e-20
C454	a_364_120##4	a_364_120##3	2.11357e-17
C455	a_640_74##10	a_364_120#	2.69173e-17
C456	VPWR#2	a_797_48##7	1.14568e-17
C457	a_797_48##18	RESET_B#4	3.10935e-17
C458	a_364_120##4	a_240_394##7	2.9448e-17
C459	VGND#14	a_240_394##8	1.28526e-19
C460	VGND#2	a_797_48##7	1.17706e-17
C461	GATE	a_240_394##12	1.37004e-17
C462	a_640_74##8	a_797_48##20	1.04879e-21
C463	a_240_394##12	a_364_120##7	1.96912e-17
C464	a_364_120##4	a_27_126#	5.20791e-18
C465	a_797_48##19	a_240_394##6	1.9377e-19
C466	a_364_120##2	a_240_394##6	2.43501e-17
C467	VPWR	a_240_394##6	8.05267e-20
C468	a_364_120##2	a_240_394##7	4.9138e-17
C469	a_364_120##2	a_240_394##2	1.95459e-19
C470	a_364_120##2	a_27_126#	1.1592e-17
C471	a_640_74##10	a_27_126##3	1.24833e-18
C472	a_27_126##2	a_240_394##7	2.06402e-17
C473	a_364_120##2	a_240_394##4	8.21254e-19
C474	VGND#14	a_364_120#	1.52331e-18
C475	a_27_126##2	a_27_126#	2.00055e-17
C476	RESET_B#4	a_797_48##14	1.97461e-18
C477	a_797_48##18	a_640_74##2	9.82772e-20
C478	a_364_120##2	GATE#3	2.87596e-19
C479	a_240_394##10	a_240_394##8	4.34985e-19
C480	a_27_126##2	a_240_394##4	3.19999e-17
C481	VGND#3	VGND#10	6.13128e-20
C482	a_938_74##2	a_797_48##24	3.79274e-17
C483	a_27_126##2	GATE#3	2.22276e-19
C484	a_640_74##10	a_240_394#	3.0695e-19
C485	a_27_126##6	GATE#5	8.96315e-18
C486	VGND#4	VGND#3	9.62942e-19
C487	a_27_126##2	D#1	1.83824e-19
C488	Q#2	VGND#1	3.3351e-18
C489	a_797_48##3	a_755_74#	6.40055e-18
C490	VGND#14	a_27_126##3	2.97139e-17
C491	a_797_48##19	RESET_B	7.3649e-18
C492	a_240_394##13	a_364_120##8	2.28226e-17
C493	a_240_394##8	a_755_74#	8.30138e-19
C494	VPWR#14	VPWR#12	3.66398e-18
C495	RESET_B	a_797_48##18	9.23553e-17
C496	VGND#6	a_240_394##5	5.09538e-17
C497	a_240_394##10	a_364_120#	1.47081e-17
C498	GATE#2	a_240_394##4	2.60593e-20
C499	a_364_120##4	VPWR#10	6.40427e-17
C500	a_797_48##19	VPWR#6	1.10684e-19
C501	a_938_74##4	a_938_74##2	3.12104e-18
C502	VGND	a_640_74##2	2.51707e-20
C503	a_27_126##2	a_240_394##6	1.91513e-18
C504	a_640_74##8	a_240_394##7	9.72647e-18
C505	VGND	a_240_394##6	3.7192e-18
C506	a_640_74##3	a_797_48##2	1.07037e-16
C507	VGND#3	Q#5	6.35961e-18
C508	VGND#6	a_364_120##2	1.37546e-19
C509	a_364_120##3	a_747_508#	1.13814e-17
C510	a_240_394##2	a_27_126##2	3.73218e-17
C511	a_240_394#	VGND#14	2.15916e-17
C512	a_240_394##5	a_640_74##3	9.70739e-18
C513	a_240_394##10	a_27_126##3	2.27784e-17
C514	Q#2	Q	8.67004e-19
C515	Q#2	Q#1	2.98338e-19
C516	a_240_394##5	a_797_48##2	3.37108e-18
C517	a_364_120#	a_559_74#	9.09721e-18
C518	a_240_394#	a_364_120##9	1.19536e-17
C519	a_240_394##7	a_562_392#	1.51039e-17
C520	a_938_74##4	a_797_48##24	4.93908e-17
C521	a_27_126##7	a_364_120##8	2.59726e-17
C522	a_27_126##3	a_559_74#	4.52126e-18
C523	a_364_120##4	a_797_48##2	6.86365e-17
C524	a_27_126##6	D#6	2.29205e-17
C525	a_27_126#	a_562_392#	1.86873e-18
C526	VGND#15	a_27_126##3	2.83465e-19
C527	a_797_48##18	VPWR#6	1.10684e-19
C528	VGND#14	GATE#1	2.34744e-18
C529	a_240_394##5	a_364_120##4	9.83333e-19
C530	VPWR	VPWR#11	8.20355e-17
C531	a_364_120##2	a_797_48##2	2.2951e-20
C532	VPWR#2	VPWR#4	3.87359e-17
C533	VPWR	VPWR#8	1.15255e-16
C534	Q#4	a_797_48##13	2.94243e-18
C535	RESET_B	VGND#11	2.73969e-18
C536	VPWR	VPWR#6	8.46106e-17
C537	RESET_B	a_938_74#	4.32234e-17
C538	a_240_394##10	a_240_394#	1.68917e-17
C539	VPWR	VPWR#4	2.19318e-17
C540	a_640_74##8	a_640_74##9	2.90568e-18
C541	a_27_126##6	D	1.6623e-17
C542	RESET_B	VGND#12	2.54843e-18
C543	a_240_394##5	a_364_120##2	2.77948e-18
C544	a_938_74##2	RESET_B	2.11134e-17
C545	a_797_48##24	RESET_B	4.80491e-18
C546	a_27_126##7	a_240_394##13	6.74089e-17
C547	a_364_120##9	GATE#1	4.01921e-19
C548	a_364_120##2	a_364_120##4	2.98677e-18
C549	VGND#4	a_938_74#	9.40371e-18
C550	a_797_48##13	VNB	5.7548e-17
C551	Q#2	VGND#10	1.63283e-17
C552	GATE	a_240_394##13	1.26382e-17
C553	a_797_48##6	VNB	5.83905e-17
C554	VPWR	a_797_48##19	1.1909e-18
C555	RESET_B#4	VNB	6.65113e-17
C556	VPWR	a_797_48##18	1.89526e-18
C557	a_640_74##2	VNB	2.05367e-17
C558	Q	VGND#1	3.09536e-17
C559	a_240_394##6	VNB	6.7034e-17
C560	a_240_394##2	VNB	1.85069e-17
C561	a_27_126##7	GATE	1.78975e-17
C562	Q#5	a_797_48##13	3.01391e-18
C563	VGND#5	VGND#12	1.1503e-20
C564	VPWR	a_640_74##8	6.38028e-18
C565	a_364_120##2	a_27_126##2	1.38365e-16
C566	a_240_394##10	GATE#1	5.19538e-17
C567	a_27_126##7	VPWR#14	5.93611e-17
C568	a_797_48##18	VPWR#4	2.18114e-19
C569	VPWR	a_240_394##12	1.75538e-18
C570	a_27_126##6	a_240_394#	8.55987e-20
C571	a_27_126##2	a_240_394##3	6.19498e-20
C572	GATE#1	VGND#15	2.28275e-17
C573	D	a_27_126##7	1.82065e-17
C574	VGND#13	a_938_74##4	4.44677e-17
C575	VGND#3	a_938_74#	5.96267e-18
C576	VGND	VGND#7	7.88053e-17
C577	VGND	VGND#5	9.18874e-17
C578	VGND	VGND#4	8.11591e-17
C579	VPWR	D#6	9.37098e-19
C580	VGND	VGND#3	2.22491e-18
C581	a_240_394##10	D#3	2.59156e-18
C582	GATE#2	a_240_394##3	1.83271e-17
C583	Q	VPWR#1	3.72292e-17
C584	VGND	a_797_48##19	2.35586e-18
C585	VGND	a_797_48##18	5.03613e-18
C586	a_364_120##4	a_747_508#	3.08464e-18
C587	a_27_126##6	GATE#1	5.38333e-18
C588	VGND	a_640_74##8	3.72576e-18
C589	RESET_B	a_797_48##4	1.83612e-20
C590	VGND	a_240_394##12	1.65928e-18
C591	a_364_120##4	a_562_392#	3.754e-18
C592	RESET_B	a_797_48##9	2.08938e-20
C593	D#2	GATE#2	1.34048e-17
C594	D#3	VGND#15	2.50133e-17
C595	VGND	a_364_120##7	4.07963e-18
C596	RESET_B	a_797_48##11	3.24633e-20
C597	a_364_120##2	a_562_392#	1.51043e-17
C598	RESET_B	a_797_48##14	4.77014e-19
C599	VGND	GATE#5	5.83991e-18
C600	RESET_B	a_640_74##4	1.63494e-18
C601	VPWR#11	VNB	4.32167e-17
C602	VGND	D#6	1.00182e-18
C603	RESET_B	a_640_74##5	6.12969e-19
C604	VPWR#8	VNB	5.12878e-17
C605	Q#3	VPWR#2	3.07341e-18
C606	VPWR#6	VNB	3.67976e-17
C607	VPWR#4	VNB	3.07541e-17
C608	VGND#12	VGND#3	5.11771e-20
C609	a_27_126##6	D#3	4.17396e-17
C610	VGND#7	VNB	4.28496e-17
C611	Q	a_797_48##4	1.91361e-19
C612	VPWR	VPWR#5	2.02788e-18
C613	VGND#5	VNB	4.67842e-17
C614	VGND#4	VNB	4.44936e-17
C615	Q	a_797_48##9	4.24726e-20
C616	VPWR	a_797_48##23	1.44169e-17
C617	VGND#11	a_797_48##13	6.43491e-18
C618	VGND#3	VNB	3.0321e-17
C619	VGND	a_938_74#	1.16955e-17
C620	Q	a_797_48##11	2.78369e-20
C621	GATE#2	a_240_394##2	1.89211e-19
C622	VGND	VGND#12	1.5785e-17
C623	Q#3	VNB	1.94864e-18
C624	VPWR	a_797_48##20	1.62761e-17
C625	Q#2	VNB	5.13531e-19
C626	VGND	a_938_74##2	2.15438e-17
C627	Q	a_797_48##14	2.43294e-20
C628	VGND	a_797_48##24	7.53875e-18
C629	Q#2	a_797_48##4	2.11257e-17
C630	VGND	a_938_74##4	2.41035e-17
C631	VGND#4	a_938_74##2	3.17262e-17
C632	a_797_48##19	VNB	3.92123e-18
C633	a_797_48##18	VNB	9.57955e-18
C634	VPWR	a_640_74##9	8.43363e-18
C635	VGND	a_640_74##10	1.1482e-17
C636	a_640_74##8	VNB	1.06027e-17
C637	VPWR	VPWR#12	1.62404e-17
C638	VGND	VGND#14	1.60885e-17
C639	VPWR	a_364_120##8	4.58819e-18
C640	VGND#2	VGND#3	7.26938e-17
C641	VGND	a_364_120##9	2.32734e-18
C642	a_240_394##12	VNB	8.93361e-18
C643	VPWR	a_240_394##13	3.98674e-18
C644	VGND	a_240_394##10	4.28192e-17
C645	VPWR	VPWR#14	2.0086e-17
C646	a_364_120##7	VNB	1.49005e-18
C647	VGND	a_27_126##6	1.83586e-17
C648	VPWR	a_27_126##7	3.74167e-17
C649	a_640_74##4	RESET_B#4	5.41032e-18
C650	a_797_48##9	a_797_48##4	4.00647e-17
C651	GATE#5	VNB	4.03807e-19
C652	VGND#3	a_797_48##11	3.31957e-19
C653	D#6	VNB	1.77391e-18
C654	VGND#1	VNB	5.13251e-17
C655	Q#1	VNB	4.68821e-18
C656	Q	a_797_48##8	3.22742e-18
C657	Q#5	VNB	2.53521e-18
C658	Q	a_797_48##10	6.35224e-19
C659	VGND#11	VNB	8.44652e-18
C660	VPWR	a_797_48##3	4.71368e-21
C661	a_938_74#	VNB	9.90648e-18
C662	Q	a_797_48##15	3.17013e-19
C663	VGND#12	VNB	6.96542e-20
C664	a_938_74##2	VNB	2.7969e-18
C665	Q	a_797_48##16	2.63558e-19
C666	VGND#2	Q#3	4.94548e-18
C667	a_797_48##24	VNB	5.29467e-18
C668	a_640_74##8	VPWR#8	1.21899e-18
C669	a_938_74##4	VNB	8.16593e-18
C670	VGND#13	VNB	4.63519e-18
C671	VGND#14	VNB	3.94671e-18
C672	a_364_120##9	VNB	1.44038e-18
C673	a_240_394##10	VNB	1.3462e-17
C674	VGND#15	VNB	9.43571e-18
C675	a_27_126##6	VNB	4.16941e-17
C676	VGND#2	Q#2	3.49166e-18
C677	VPWR#1	VNB	7.10349e-17
C678	VGND	RESET_B#3	5.05364e-19
C679	Q#2	a_797_48##9	1.95672e-17
C680	Q#6	VNB	5.5404e-18
C681	VGND	RESET_B#5	7.64248e-19
C682	VPWR#3	VNB	1.08284e-18
C683	VGND	a_640_74##4	1.22761e-18
C684	Q#4	VNB	2.68554e-18
C685	VPWR#2	a_797_48##18	1.03815e-18
C686	VPWR#5	VNB	5.61546e-18
C687	VGND	a_640_74##5	1.45116e-18
C688	a_797_48##23	VNB	4.4085e-18
C689	VGND	a_797_48##3	5.77276e-18
C690	VPWR	RESET_B#1	7.71109e-18
C691	VPWR#7	VNB	5.31628e-18
C692	VGND	a_240_394##8	1.37602e-18
C693	a_797_48##20	VNB	3.67876e-18
C694	VPWR	RESET_B#6	4.28308e-18
C695	VGND	a_364_120#	1.35222e-18
C696	VPWR	a_640_74#	7.84809e-18
C697	VGND	a_27_126##3	6.02561e-19
C698	a_240_394##12	GATE#5	2.39169e-17
C699	VGND	a_240_394#	8.35454e-18
C700	VPWR	a_640_74##6	7.68655e-18
C701	RESET_B	a_797_48##7	1.57679e-19
C702	VPWR#12	VNB	5.17088e-18
C703	VGND	GATE#1	1.14134e-17
C704	VPWR	a_797_48#	6.6148e-19
C705	VPWR#4	a_797_48##13	5.7465e-20
C706	a_364_120##8	VNB	3.12729e-18
C707	VGND	D#3	1.08515e-17
C708	a_240_394##13	VNB	4.9064e-18
C709	VPWR	a_364_120##3	1.03157e-18
C710	VPWR#2	Q	4.15996e-18
C711	VPWR#14	VNB	1.38702e-17
C712	GATE	a_240_394##3	8.79808e-19
C713	VPWR	a_240_394##7	5.27984e-18
C714	Q#5	RESET_B#4	5.11343e-19
C715	VGND#5	a_938_74##4	3.68914e-17
C716	a_27_126##7	VNB	5.86356e-17
C717	VGND#2	Q	5.31365e-18
C718	RESET_B	a_640_74##3	3.34588e-19
C719	a_797_48##4	VNB	3.16071e-17
C720	VPWR	a_27_126#	1.97059e-18
C721	a_797_48##9	VNB	2.42036e-17
C722	GATE	GATE#2	8.34857e-18
C723	a_797_48##11	VNB	2.40011e-17
C724	VPWR	a_240_394##4	8.07299e-18
C725	a_797_48##14	VNB	2.93328e-17
C726	a_797_48##11	a_797_48##9	3.88097e-17
C727	VPWR	GATE#3	8.12635e-18
C728	RESET_B#3	VNB	2.82756e-17
C729	GATE	D#2	4.43677e-19
C730	RESET_B#5	VNB	2.07155e-17
C731	a_797_48##7	Q	3.22314e-17
C732	VGND#3	a_797_48##14	7.03728e-18
C733	VPWR	D#1	8.33394e-18
C734	a_797_48##8	VPWR#1	3.11817e-17
C735	a_640_74##4	VNB	3.19154e-17
C736	a_640_74##5	VNB	3.68808e-17
C737	a_797_48##3	VNB	7.13892e-17
C738	a_240_394##8	VNB	2.83118e-17
C739	a_364_120#	VNB	2.56458e-17
C740	a_27_126##3	VNB	3.05093e-17
C741	D	D#2	9.82369e-18
C742	a_240_394#	VNB	3.83681e-17
C743	VPWR	VPWR#10	4.95939e-17
C744	VGND	a_240_394##7	4.6195e-20
C745	GATE#1	VNB	4.0801e-17
C746	D#3	VNB	3.94583e-17
C747	a_797_48##8	VNB	4.10179e-17
C748	a_797_48##10	VNB	2.93317e-17
C749	a_797_48##7	VPWR#4	3.74725e-19
C750	a_797_48##15	VNB	3.37222e-17
C751	VPWR	a_640_74##3	5.00791e-18
C752	a_797_48##16	VNB	4.10688e-17
C753	RESET_B#1	VNB	3.62728e-17
C754	VPWR	a_797_48##2	7.6807e-18
C755	RESET_B#6	VNB	3.27128e-17
C756	a_640_74#	VNB	3.42386e-17
C757	VPWR	a_240_394##5	2.37346e-18
C758	a_797_48##8	Q#6	2.83363e-17
C759	a_640_74##6	VNB	3.32011e-17
C760	VPWR	a_364_120##4	4.54819e-17
C761	a_797_48#	VNB	2.29748e-17
C762	VGND	VGND#6	4.48578e-17
C763	a_364_120##3	VNB	2.18203e-17
C764	VPWR	a_364_120##2	3.595e-18
C765	a_240_394##7	VNB	4.20888e-17
C766	a_27_126#	VNB	3.41638e-17
C767	VPWR	a_27_126##2	1.20939e-17
C768	VGND#4	RESET_B#3	9.47606e-19
C769	a_240_394##4	VNB	3.55846e-17
C770	VGND#2	a_797_48##18	4.09385e-18
C771	VGND	a_640_74##3	7.30651e-18
C772	Q#2	Q#3	1.56998e-18
C773	GATE#3	VNB	3.565e-17
C774	VGND	a_797_48##2	7.08236e-19
C775	D#1	VNB	4.44309e-17
C776	VGND#4	a_938_74##4	6.14204e-18
C777	a_240_394##12	a_364_120##8	2.22512e-17
C778	VGND	a_240_394##5	3.16526e-17
C779	VPWR#2	VNB	1.70732e-16
C780	VGND	a_364_120##4	2.90958e-20
C781	VGND#2	VNB	1.65701e-16
C782	VPWR#1	a_797_48##10	1.22765e-18
C783	VGND	a_364_120##2	7.78149e-18
C784	VPWR#10	VNB	2.8016e-17
C785	VGND#6	VNB	2.64949e-17
C786	VGND	a_27_126##2	3.13392e-18
C787	a_797_48##7	VNB	4.15929e-17
C788	VGND	a_240_394##3	5.35611e-20
C789	VGND	GATE#2	4.38794e-19
C790	a_640_74##3	VNB	5.67882e-17
C791	a_797_48##2	VNB	6.18668e-17
C792	VPWR#3	a_797_48##8	2.58942e-18
C793	a_240_394##5	VNB	9.33476e-18
C794	a_364_120##4	VNB	3.87918e-17
C795	a_364_120##2	VNB	3.15239e-17
C796	a_27_126##2	VNB	3.69588e-17
C797	a_240_394##3	VNB	3.47744e-17
C798	GATE#2	VNB	4.34357e-17
C799	D#2	VNB	6.56726e-17
C800	a_797_48##14	a_797_48##11	3.84141e-17
C801	VGND#3	RESET_B#3	8.33417e-19
C802	a_797_48##10	Q#6	3.07464e-17
C803	VGND#5	RESET_B#5	5.37669e-20
C804	VPWR	GATE	2.7606e-18
C805	VPWR	D	1.07083e-18
C806	VGND	D	1.13622e-18
C807	Q#4	a_797_48##8	1.88565e-19
C808	VGND	RESET_B	5.4634e-18
C809	GATE	VNB	4.45403e-20
C810	D	VNB	1.76554e-17
C811	RESET_B	VNB	4.534e-18
C812	Q	VNB	6.10368e-17
C813	VPWR	VNB	3.03996e-16
C814	VGND	VNB	3.08663e-16
C815	a_640_74##8	a_240_394##6	3.43644e-17
C816	VPWR#3	a_797_48##10	6.14409e-17
C817	VGND#8	a_240_394##10	1.85905e-17
C818	VGND#8	a_240_394##3	5.3335e-20
C819	VGND#8	GATE#5	1.20897e-18
C820	VPWR#13	D#2	7.80448e-20
C821	VPWR	VPWR#13	1.05669e-16
C822	VGND#8	VGND#14	6.61395e-19
C823	VGND#8	GATE#1	1.67671e-17
C824	VGND#8	GATE#2	6.96156e-20
C825	VPWR#13	VNB	6.28533e-17
C826	VGND	VGND#8	1.28037e-16
C827	a_27_126##7	VPWR#13	2.04524e-17
C828	VGND#8	a_27_126##6	9.41425e-18
C829	VPWR#13	VPWR#11	1.62175e-19
C830	VGND#8	a_27_126##3	5.357e-19
C831	VGND#8	D#3	3.46727e-18
C832	VPWR#13	GATE#3	6.11199e-18
C833	VGND#8	D#2	1.32703e-19
C834	VGND#8	VGND#7	3.2171e-19
C835	VPWR#13	a_240_394##3	7.88749e-20
C836	VPWR#13	D#1	4.22614e-18
C837	VGND#8	VNB	7.05693e-17
C838	VPWR#13	GATE#2	4.9995e-20
*
*
.ENDS sky130_fd_sc_hs__dlrtp_4
*
