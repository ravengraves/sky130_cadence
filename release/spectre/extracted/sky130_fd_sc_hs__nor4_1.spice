* Extracted by Quantus, converted by sky130cad/quantus.py
*
*
*
*                       LINUX           Wed Nov 18 08:50:58 2026
*
*
*
*  PROGRAM  advgen
*
*  Name           : advgen - Quantus - (64-bit)
*  Version        : 25.1.0-p047
*  Build Date     : Thu Dec 11 23:20:30 PST 2025
*
*  HSPICE LIBRARY
*
*  OPERATING_TEMPERATURE 150
*  QRC_TECH_DIR <path>/tech
*
*
*

*
.SUBCKT sky130_fd_sc_hs__nor4_1 VNB VPB VGND VPWR Y A B C D
*
*
*  caps2d version: 10
*
*
*       TRANSISTOR CARDS
*
*
XM0 VGND#3 A#1 Y#4 VNB sky130_fd_pr__nfet_01v8_lvt l=0.15 w=0.74 ad=0.2627 as=0.2072 pd=2.19 ps=2.04
XM1 Y#4 B#1 VGND#4 VNB sky130_fd_pr__nfet_01v8_lvt l=0.15 w=0.74 ad=0.2072 as=0.3848 pd=2.04 ps=2.52
XM3 VGND#4 C#1 Y#5 VNB sky130_fd_pr__nfet_01v8_lvt l=0.15 w=0.74 ad=0.3848 as=0.2072 pd=2.52 ps=2.04
XM6 Y#5 D#3 VGND#1 VNB sky130_fd_pr__nfet_01v8_lvt l=0.15 w=0.74 ad=0.2072 as=0.23225 pd=2.04 ps=2.19
XM7 VPWR#2 A#4 a_144_368# VPB sky130_fd_pr__pfet_01v8 l=0.15 w=1.12 ad=0.3304 as=0.3024 pd=2.83 ps=2.78
XM2 a_144_368# B#3 a_228_368# VPB sky130_fd_pr__pfet_01v8 l=0.15 w=1.12 ad=0.3024 as=0.4704 pd=2.78 ps=3.08
XM4 a_228_368# C#3 a_342_368# VPB sky130_fd_pr__pfet_01v8 l=0.15 w=1.12 ad=0.4704 as=0.4704 pd=3.08 ps=3.08
XM5 a_342_368# D#1 Y#1 VPB sky130_fd_pr__pfet_01v8 l=0.15 w=1.12 ad=0.4704 as=0.3304 pd=3.08 ps=2.83
*
*
*       RESISTOR AND CAP/DIODE CARDS
*
Rg1	A#1	A#2	322.953644
Rg2	A#2	A#3	35.518757
Rg3	A#2	A#4	507.075531
Rg4	B#1	B#2	382.539734
Rg5	B#2	B#3	434.639221
Rg6	C#1	C#2	382.539734
Rg7	C#2	C#3	434.639221
Rg8	D#1	D#2	434.639221
Rg9	D#2	D#3	382.539734
Rf1	A	A#5	1.422963
Rf2	A#6	A#3	161.655762
Rf3	A#5	A#6	4.765271
Rf4	B	B#2	165.972488
Rf5	C	C#2	166.137894
Rf6	D#4	D#2	162.066422
Rf7	D	D#6	1.833616
Rf8	D#4	D#6	4.913828
Rf9	Y	Y#2	7.885916
Rf10	Y#2	Y#3	129.902863
Rf11	Y#3	Y#4	97.308411
Rf12	Y#3	Y#5	18.149860
Rf13	Y#1	Y#2	5.000000
Rf14	VGND#1	VGND#2	110.928726
Rf15	VGND#2	VGND#3	101.769394
Rf16	VGND#2	VGND#4	41.745289
Rf17	VPWR#1	VPWR#2	111.988716
Re1	VPWR#1	VPWR	1.637070
Re2	VGND	VGND#2	1.637131
*
*       CAPACITOR CARDS
*
*
C1	VGND	VNB	5.63042e-17
C2	VPWR	VNB	7.51899e-17
C3	B	VNB	4.34893e-18
C4	C	VNB	2.55419e-18
C5	D	VNB	4.25747e-18
C6	A#3	VNB	6.41778e-17
C7	B#2	VNB	3.35734e-17
C8	C#2	VNB	2.23016e-17
C9	D#2	VNB	4.34052e-17
C10	VGND#2	VNB	1.83296e-16
C11	VPWR#1	VNB	2.1003e-16
C12	A#4	VNB	4.65986e-17
C13	VGND	B	4.3316e-18
C14	B#3	VNB	3.23461e-17
C15	C#3	VNB	2.92735e-17
C16	D#1	VNB	3.44511e-17
C17	VGND	C	3.65596e-18
C18	A#1	VNB	3.35947e-17
C19	B#1	VNB	2.94221e-17
C20	C#1	VNB	3.2369e-17
C21	VPWR	B	1.63154e-17
C22	D#3	VNB	3.60231e-17
C23	VPWR#2	VNB	8.91257e-17
C24	VPWR	C	9.58848e-18
C25	Y#1	VNB	8.27566e-17
C26	VGND#3	VNB	6.74033e-17
C27	Y#4	VNB	1.46394e-17
C28	VPWR	D	5.87701e-18
C29	VGND#4	VNB	2.14271e-18
C30	Y#5	VNB	4.76739e-18
C31	VGND#1	VNB	6.16457e-17
C32	A#5	VNB	2.40728e-17
C33	A#6	VNB	4.34407e-18
C34	VGND	A#3	6.02094e-19
C35	D#4	VNB	5.72006e-18
C36	Y#3	VNB	3.92827e-17
C37	VGND	VGND#2	5.49292e-17
C38	B	C	6.15372e-17
C39	VPWR	A#3	8.68889e-19
C40	B	a_144_368#	2.71268e-19
C41	C	D	2.45175e-17
C42	VPWR	VPWR#1	6.10047e-17
C43	B	a_228_368#	3.77015e-18
C44	VGND	A#1	4.06235e-18
C45	VGND	B#1	1.3722e-19
C46	VPWR	A#4	4.55208e-18
C47	VGND	C#1	4.03212e-20
C48	VGND	D#3	8.13686e-19
C49	VPWR	B#3	2.86406e-19
C50	C	a_228_368#	4.29175e-18
C51	VGND	VPWR#2	3.56043e-18
C52	VPWR	C#3	1.40598e-18
C53	C	a_342_368#	3.6542e-18
C54	VPWR	D#1	3.10979e-18
C55	B	A#3	7.08245e-18
C56	VGND	VGND#3	4.827e-17
C57	B	B#2	1.82432e-17
C58	VGND	Y#4	1.5358e-17
C59	B	C#2	3.33043e-18
C60	VGND	Y#5	1.6226e-17
C61	VGND	VGND#1	4.56057e-17
C62	VPWR	VPWR#2	4.68199e-17
C63	VGND	A#5	2.57848e-18
C64	C	B#2	3.40785e-18
C65	VGND	A#6	1.84178e-18
C66	C	C#2	1.70656e-17
C67	B	VPWR#1	1.44458e-17
C68	VGND	D#4	3.40404e-18
C69	VPWR	Y#1	2.33396e-17
C70	C	D#2	3.9151e-18
C71	D	C#2	1.81917e-18
C72	VGND	Y#3	9.29738e-18
C73	B	A#4	1.66411e-17
C74	C	VPWR#1	2.81436e-18
C75	D	D#2	5.84299e-18
C76	B	B#3	3.63523e-17
C77	VPWR	A#5	2.38649e-18
C78	B	C#3	1.61333e-17
C79	VPWR	A#6	1.70805e-18
C80	B#2	a_228_368#	4.65238e-19
C81	B	D#1	5.60444e-18
C82	D	VPWR#1	9.68564e-19
C83	C	B#3	2.12085e-18
C84	C	C#3	1.64488e-17
C85	C#2	a_342_368#	4.86397e-19
C86	C	D#1	5.68336e-18
C87	D	C#3	3.83755e-19
C88	A#3	B#2	2.70696e-17
C89	A#4	a_144_368#	1.90708e-18
C90	VPWR#2	B	4.96917e-17
C91	D	D#1	4.82691e-18
C92	B#3	a_144_368#	2.23979e-17
C93	B	Y#1	1.56663e-17
C94	B#2	C#2	2.4848e-17
C95	B#3	a_228_368#	2.82582e-17
C96	Y#4	B	3.15771e-17
C97	C#3	a_228_368#	1.00461e-17
C98	C#2	D#2	3.03521e-17
C99	C	Y#1	1.57582e-17
C100	Y#3	D#4	4.32456e-17
C101	C#3	a_342_368#	3.32671e-17
C102	VPWR#1	B#2	5.47507e-20
C103	A#6	B	9.39921e-18
C104	D#1	a_342_368#	2.57746e-17
C105	VGND#2	C#2	2.03315e-20
C106	VPWR#1	C#2	1.57509e-19
C107	D	Y#1	3.81053e-17
C108	A#4	B#2	3.52899e-18
C109	VPWR#1	D#2	4.50366e-20
C110	C	D#4	2.07583e-17
C111	A#3	B#1	2.85935e-18
C112	Y#3	C	4.36878e-17
C113	VPWR#1	B#3	6.14085e-18
C114	VPWR#2	A#3	7.84715e-18
C115	VPWR#1	C#3	8.60362e-18
C116	VPWR#1	D#1	7.7905e-18
C117	A#4	B#3	5.58531e-17
C118	VGND#2	A#1	9.19315e-19
C119	VGND#2	B#1	5.85139e-18
C120	A#3	VGND#3	8.47001e-18
C121	Y#4	A#3	2.95983e-18
C122	VGND#2	C#1	8.27979e-18
C123	B#3	C#3	2.95003e-17
C124	VGND#2	D#3	2.47223e-18
C125	Y#4	B#2	2.22432e-18
C126	C#3	D#1	3.3858e-17
C127	VGND#4	B#2	8.02726e-19
C128	A#5	A#3	1.06662e-17
C129	VPWR#1	VPWR#2	3.72619e-17
C130	A#6	A#3	1.51676e-17
C131	D#2	Y#1	1.35257e-17
C132	A#6	B#2	3.7895e-18
C133	VPWR#2	A#4	5.3814e-17
C134	VGND#2	VGND#3	3.54422e-17
C135	Y#1	VPWR#1	3.28092e-17
C136	VGND#2	Y#4	1.44389e-17
C137	A#6	C#2	5.71841e-19
C138	VPWR#2	B#3	9.27143e-18
C139	VGND#1	D#2	1.00988e-18
C140	VGND#2	Y#5	1.68095e-17
C141	Y#3	A#3	1.42163e-19
C142	VPWR#2	C#3	9.91551e-19
C143	A#6	D#2	4.55304e-19
C144	VGND#2	VGND#1	3.3325e-17
C145	A#1	B#1	3.75644e-17
C146	Y#1	A#4	6.28182e-19
C147	D#4	C#2	2.52714e-18
C148	VPWR#2	D#1	7.76587e-19
C149	Y#3	B#2	1.04398e-19
C150	Y#1	B#3	2.03288e-18
C151	B#1	C#1	1.51074e-17
C152	D#4	D#2	9.65807e-18
C153	Y#1	C#3	1.06305e-17
C154	Y#3	C#2	2.47261e-18
C155	C#1	D#3	3.89962e-17
C156	Y#1	D#1	5.52659e-17
C157	Y#3	D#2	3.80873e-18
C158	VGND#2	Y#3	7.34654e-19
C159	VGND#3	A#1	4.48136e-17
C160	Y#4	A#1	1.5943e-17
C161	VGND#3	B#1	2.79573e-18
C162	VGND#4	A#1	4.3031e-19
C163	Y#4	B#1	5.63357e-17
C164	VGND#3	C#1	3.24854e-19
C165	B#1	VGND#4	2.50227e-17
C166	Y#4	C#1	6.46377e-19
C167	VPWR#2	Y#1	1.70575e-18
C168	Y#5	B#1	1.79077e-18
C169	C#1	VGND#4	2.12944e-17
C170	VGND#3	VPWR#2	1.31353e-18
C171	VGND#1	B#1	2.6552e-19
C172	Y#5	C#1	3.4182e-17
C173	VGND#4	D#3	3.33179e-19
C174	VGND#1	C#1	1.40992e-18
C175	Y#5	D#3	3.49083e-17
C176	D#3	VGND#1	2.1993e-17
C177	A#5	VPWR#2	1.07186e-17
C178	A#6	VPWR#2	1.86379e-17
C179	VGND#3	Y#4	6.47393e-17
C180	VGND#3	VGND#4	1.50104e-18
C181	Y#4	VGND#4	5.6508e-17
C182	Y#4	Y#5	2.59202e-18
C183	Y#3	C#1	2.31795e-17
C184	VGND#3	A#5	1.86897e-17
C185	VGND#4	Y#5	3.04589e-17
C186	Y#3	D#3	2.0693e-17
C187	VGND#3	A#6	3.14113e-17
C188	VGND#4	VGND#1	1.14583e-18
C189	Y#5	VGND#1	4.52314e-17
C190	D#4	Y#1	1.88064e-17
C191	Y#3	Y#1	2.87902e-18
C192	Y#3	VGND#4	2.27559e-17
C193	Y#3	Y#5	9.59055e-20
C194	Y#3	VGND#1	4.26827e-17
*
*
.ENDS sky130_fd_sc_hs__nor4_1
*
