* Extracted by Quantus, converted by sky130cad/quantus.py
*
*
*
*                       LINUX           Wed Nov 18 08:17:57 2026
*
*
*
*  PROGRAM  advgen
*
*  Name           : advgen - Quantus - (64-bit)
*  Version        : 25.1.0-p047
*  Build Date     : Thu Dec 11 23:20:30 PST 2025
*
*  HSPICE LIBRARY
*
*  OPERATING_TEMPERATURE 150
*  QRC_TECH_DIR <path>/tech
*
*
*

*
.SUBCKT sky130_fd_sc_hs__and3b_4 VPB VNB VGND VPWR X A_N B C
*
*
*  caps2d version: 10
*
*
*       TRANSISTOR CARDS
*
*
XM18 a_27_74##10 A_N#3 VGND#11 VNB sky130_fd_pr__nfet_01v8_lvt l=0.15 w=0.64 ad=0.1824 as=0.1888 pd=1.85 ps=1.87
XM19 a_239_98##3 a_27_74##6 a_298_368##22 VNB sky130_fd_pr__nfet_01v8_lvt l=0.15 w=0.64 ad=0.1824 as=0.1792 pd=1.85 ps=1.84
XM4 a_298_368##22 a_27_74# a_239_98##4 VNB sky130_fd_pr__nfet_01v8_lvt l=0.15 w=0.64 ad=0.1792 as=0.1792 pd=1.84 ps=1.84
XM1 a_239_98##4 B#4 a_498_98##2 VNB sky130_fd_pr__nfet_01v8_lvt l=0.15 w=0.64 ad=0.1792 as=0.224 pd=1.84 ps=1.98
XM16 a_498_98##2 B#1 a_239_98# VNB sky130_fd_pr__nfet_01v8_lvt l=0.15 w=0.64 ad=0.224 as=0.1824 pd=1.98 ps=1.85
XM7 VGND#10 C#4 a_498_98# VNB sky130_fd_pr__nfet_01v8_lvt l=0.15 w=0.64 ad=0.1824 as=0.1792 pd=1.85 ps=1.84
XM11 a_498_98# C#1 VGND#9 VNB sky130_fd_pr__nfet_01v8_lvt l=0.15 w=0.64 ad=0.1792 as=0.2589 pd=1.84 ps=2.2
XM20 X#7 a_298_368##14 VGND#9 VNB sky130_fd_pr__nfet_01v8_lvt l=0.15 w=0.74 ad=0.259 as=0.2589 pd=2.18 ps=2.2
XM21 X#7 a_298_368##12 VGND#8 VNB sky130_fd_pr__nfet_01v8_lvt l=0.15 w=0.74 ad=0.259 as=0.222 pd=2.18 ps=2.08
XM12 VGND#8 a_298_368##10 X#5 VNB sky130_fd_pr__nfet_01v8_lvt l=0.15 w=0.74 ad=0.222 as=0.2072 pd=2.08 ps=2.04
XM15 VGND#1 a_298_368# X#5 VNB sky130_fd_pr__nfet_01v8_lvt l=0.15 w=0.74 ad=0.2109 as=0.2072 pd=2.05 ps=2.04
XM17 a_27_74##11 A_N#1 VPWR#13 VPB sky130_fd_pr__pfet_01v8 l=0.15 w=1 ad=0.295 as=0.4 pd=2.59 ps=2.8
XM6 a_298_368##19 a_27_74##7 VPWR#13 VPB sky130_fd_pr__pfet_01v8 l=0.15 w=1 ad=0.3 as=0.4 pd=2.6 ps=2.8
XM14 VPWR#11 a_27_74##5 a_298_368##19 VPB sky130_fd_pr__pfet_01v8 l=0.15 w=1 ad=0.4 as=0.3 pd=2.8 ps=2.6
XM5 VPWR#11 B#6 a_298_368##21 VPB sky130_fd_pr__pfet_01v8 l=0.15 w=1 ad=0.4 as=0.3 pd=2.8 ps=2.6
XM13 a_298_368##21 B#5 VPWR#9 VPB sky130_fd_pr__pfet_01v8 l=0.15 w=1 ad=0.3 as=0.46 pd=2.6 ps=2.92
XM0 a_298_368##20 C#6 VPWR#9 VPB sky130_fd_pr__pfet_01v8 l=0.15 w=1 ad=0.3 as=0.46 pd=2.6 ps=2.92
XM8 VPWR#8 C#5 a_298_368##20 VPB sky130_fd_pr__pfet_01v8 l=0.15 w=1 ad=0.4764 as=0.3 pd=3.11 ps=2.6
XM2 X#3 a_298_368##8 VPWR#8 VPB sky130_fd_pr__pfet_01v8 l=0.15 w=1.12 ad=0.336 as=0.4764 pd=2.84 ps=3.11
XM3 X#3 a_298_368##13 VPWR#7 VPB sky130_fd_pr__pfet_01v8 l=0.15 w=1.12 ad=0.336 as=0.448 pd=2.84 ps=3.04
XM9 VPWR#7 a_298_368##11 X#6 VPB sky130_fd_pr__pfet_01v8 l=0.15 w=1.12 ad=0.448 as=0.336 pd=3.04 ps=2.84
XM10 VPWR#6 a_298_368##9 X#6 VPB sky130_fd_pr__pfet_01v8 l=0.15 w=1.12 ad=0.3864 as=0.336 pd=2.93 ps=2.84
*
*
*       RESISTOR AND CAP/DIODE CARDS
*
Rg1	A_N#1	A_N#2	500.122223
Rg2	A_N#2	A_N#3	345.183563
Rg3	a_27_74#	a_27_74##2	378.924072
Rg4	a_27_74##2	a_27_74##3	55.175514
Rg5	a_27_74##3	a_27_74##4	33.474648
Rg6	a_27_74##2	a_27_74##5	395.100159
Rg7	a_27_74##3	a_27_74##6	318.226868
Rg8	a_27_74##4	a_27_74##7	409.759766
Rg9	B#1	B#2	358.981934
Rg10	B#2	B#3	66.432877
Rg11	B#3	B#4	336.856995
Rg12	B#2	B#5	415.670532
Rg13	B#3	B#6	394.695099
Rg14	C#1	C#2	461.548126
Rg15	C#2	C#3	65.975197
Rg16	C#2	C#4	302.539368
Rg17	C#2	C#5	433.297058
Rg18	C#3	C#6	411.183624
Rg19	a_298_368#	a_298_368##2	460.438477
Rg20	a_298_368##2	a_298_368##3	21.985598
Rg21	a_298_368##3	a_298_368##4	35.782082
Rg22	a_298_368##4	a_298_368##5	29.808355
Rg23	a_298_368##5	a_298_368##6	35.192207
Rg24	a_298_368##6	a_298_368##7	19.120016
Rg25	a_298_368##7	a_298_368##8	501.911896
Rg26	a_298_368##2	a_298_368##9	391.489655
Rg27	a_298_368##3	a_298_368##10	346.884247
Rg28	a_298_368##4	a_298_368##11	395.585419
Rg29	a_298_368##5	a_298_368##12	362.071960
Rg30	a_298_368##6	a_298_368##13	399.024933
Rg31	a_298_368##7	a_298_368##14	363.675873
Rf1	A_N#4	A_N	0.984182
Rf2	A_N#2	A_N#6	161.216980
Rf3	A_N#4	A_N#6	1.968364
Rf4	a_27_74##4	a_27_74##9	211.752808
Rf5	a_27_74##9	a_27_74##10	105.490318
Rf6	a_27_74##9	a_27_74##11	24.310659
Rf7	B#7	B	1.409262
Rf8	B#3	B#9	161.642059
Rf9	B#7	B#9	10.084890
Rf10	B#10	B	1.409262
Rf11	B#9	B#10	4.584041
Rf12	a_239_98#	a_239_98##2	56.537331
Rf13	a_239_98##2	a_239_98##3	85.247871
Rf14	a_239_98##2	a_239_98##4	15.870530
Rf15	C#7	C	1.791142
Rf16	C#3	C#9	162.023941
Rf17	C#7	C#9	8.404075
Rf18	a_498_98#	a_498_98##2	136.479721
Rf19	a_298_368##5	a_298_368##16	173.316849
Rf20	a_298_368##16	a_298_368##17	69.002625
Rf21	a_298_368##17	a_298_368##18	61.170959
Rf22	a_298_368##18	a_298_368##19	16.978909
Rf23	a_298_368##16	a_298_368##20	17.769421
Rf24	a_298_368##17	a_298_368##21	15.059351
Rf25	a_298_368##18	a_298_368##22	92.097473
Rf26	X	X#1	40.505219
Rf27	X#1	X#2	20.892902
Rf28	X#2	X#3	91.758659
Rf29	X#1	X#4	56.158405
Rf30	X#4	X#5	28.838520
Rf31	X#2	X#6	21.948624
Rf32	X#4	X#7	80.008255
Rf33	VGND#1	VGND#2	93.909737
Rf34	VGND#2	VGND#3	67.887894
Rf35	VGND#3	VGND#4	68.618401
Rf36	VGND#4	VGND#5	24.082130
Rf37	VGND#5	VGND#6	191.051788
Rf39	VGND#2	VGND#8	36.279022
Rf40	VGND#3	VGND#9	33.306259
Rf41	VGND#4	VGND#10	38.247387
Rf42	VGND#6	VGND#11	36.375942
Rf44	VPWR#2	VPWR#3	73.001427
Rf45	VPWR#3	VPWR#4	73.001427
Rf46	VPWR#4	VPWR#5	63.894653
Rf47	VPWR#2	VPWR#6	35.569878
Rf48	VPWR#3	VPWR#7	35.569878
Rf49	VPWR#4	VPWR#8	38.286041
Rf50	VPWR#5	VPWR#9	38.575687
Rf51	VPWR#5	VPWR#10	91.909515
Rf52	VPWR#10	VPWR#11	35.077789
Rf53	VPWR#10	VPWR#12	73.001427
Rf54	VPWR#12	VPWR#13	39.900276
Re1	VPWR#5	VPWR	0.701577
Re2	VGND	VGND#5	0.701602
*
*       CAPACITOR CARDS
*
*
C1	a_239_98#	B#2	1.95161e-19
C2	VGND	VNB	8.81048e-17
C3	VPWR	VNB	8.85979e-17
C4	X	VNB	3.05647e-17
C5	A_N	VNB	2.30521e-19
C6	B	VNB	9.30223e-18
C7	VGND	X	3.04158e-18
C8	C	VNB	2.31843e-18
C9	a_27_74#	a_239_98##4	1.2912e-17
C10	VGND	A_N	3.81788e-18
C11	VPWR	X	3.89656e-18
C12	VGND	B	3.74063e-18
C13	VGND	C	1.9111e-18
C14	VGND#4	VGND#3	1.10644e-18
C15	A_N#2	VNB	6.32714e-17
C16	VPWR	B	3.50085e-18
C17	VPWR#13	VPWR#11	5.47571e-18
C18	a_27_74##4	VNB	7.43603e-17
C19	a_298_368##16	B#5	1.92022e-18
C20	B#3	VNB	2.64399e-17
C21	VPWR	C	1.84645e-18
C22	C#3	VNB	5.12381e-17
C23	a_298_368##5	VNB	5.65491e-17
C24	VGND#5	VNB	3.11429e-16
C25	VPWR#5	VNB	3.02179e-16
C26	a_298_368##22	B#4	6.99485e-19
C27	VGND	A_N#2	1.64335e-18
C28	A_N#1	VNB	4.73363e-17
C29	VGND	a_27_74##4	5.13523e-18
C30	a_27_74##7	VNB	3.41334e-17
C31	a_27_74##5	VNB	3.59377e-17
C32	B#6	VNB	3.34992e-17
C33	VGND	C#3	1.69532e-18
C34	B#5	VNB	3.64091e-17
C35	a_498_98##2	a_27_74#	4.33998e-19
C36	C#6	VNB	3.71756e-17
C37	VGND	a_298_368##5	8.49534e-18
C38	C#5	VNB	3.59748e-17
C39	B	C	2.82778e-17
C40	VGND	VGND#5	3.21917e-17
C41	a_298_368##17	B#5	2.5347e-17
C42	a_298_368##8	VNB	4.69603e-17
C43	X#1	C#2	8.07069e-20
C44	a_298_368##13	VNB	3.12834e-17
C45	VPWR	a_27_74##4	3.40975e-18
C46	a_298_368##11	VNB	3.14728e-17
C47	a_298_368##16	VPWR#8	1.15829e-16
C48	a_298_368##9	VNB	3.92408e-17
C49	VGND#9	X#7	6.81483e-17
C50	A_N#3	VNB	3.33295e-17
C51	VPWR	C#3	1.89087e-18
C52	a_27_74##6	VNB	3.09652e-17
C53	a_298_368##18	VPWR#10	5.68027e-18
C54	a_27_74#	VNB	2.81011e-17
C55	VPWR	a_298_368##5	6.39176e-18
C56	B#4	VNB	2.69887e-17
C57	B#1	VNB	3.23976e-17
C58	C#4	VNB	2.67388e-17
C59	B#4	a_239_98##4	1.2912e-17
C60	VPWR	VPWR#5	4.9642e-17
C61	C#1	VNB	4.34758e-17
C62	a_298_368##14	VNB	3.26553e-17
C63	a_298_368##18	B#5	2.79965e-19
C64	A_N	A_N#2	1.13353e-17
C65	a_298_368##12	VNB	2.52881e-17
C66	B#9	a_298_368##17	1.83365e-17
C67	a_298_368##10	VNB	2.46659e-17
C68	a_298_368#	VNB	3.34506e-17
C69	VPWR	A_N#1	7.41113e-18
C70	a_27_74##11	VNB	4.43922e-17
C71	A_N	a_27_74##4	2.63186e-19
C72	VPWR#13	VNB	9.12316e-18
C73	VPWR	a_27_74##7	7.2802e-18
C74	X#2	VPWR#3	1.34496e-19
C75	VPWR#11	VNB	7.60675e-18
C76	VPWR	a_27_74##5	7.2802e-18
C77	a_298_368##21	VNB	2.56874e-18
C78	VPWR#9	VNB	7.55089e-18
C79	VPWR	B#6	7.25174e-18
C80	a_298_368##22	B#1	3.88492e-19
C81	VGND	A_N#3	4.80569e-18
C82	VPWR#8	VNB	6.5058e-18
C83	VPWR	B#5	7.25174e-18
C84	B	a_27_74##4	1.2225e-17
C85	X#3	VNB	2.24101e-18
C86	VPWR#7	VNB	3.74405e-18
C87	VGND	a_27_74#	2.26241e-18
C88	VPWR	C#6	9.00216e-18
C89	X#6	VNB	3.09418e-18
C90	VGND	B#4	4.07956e-18
C91	B	B#3	5.73452e-18
C92	VPWR#6	VNB	4.10664e-17
C93	VPWR	C#5	7.43799e-18
C94	a_27_74##10	VNB	4.62133e-17
C95	VGND	B#1	9.2039e-18
C96	B#4	a_498_98##2	1.64955e-17
C97	VGND#11	VNB	8.76127e-18
C98	VPWR	a_298_368##8	3.26565e-18
C99	a_298_368##16	C#6	4.29906e-17
C100	VGND	C#4	4.11639e-18
C101	a_239_98##3	VNB	1.547e-17
C102	B	C#3	2.87528e-18
C103	a_298_368##22	VNB	4.30234e-18
C104	VPWR	a_298_368##13	2.01287e-19
C105	VGND	C#1	7.50871e-18
C106	VGND	a_298_368##14	2.90709e-19
C107	a_498_98##2	VNB	6.47955e-18
C108	VPWR	a_298_368##11	1.87826e-19
C109	a_239_98#	VNB	6.79203e-18
C110	VGND	a_298_368##12	7.07767e-19
C111	VGND#10	VNB	4.12076e-18
C112	VPWR	a_298_368##9	1.14881e-18
C113	C	B#3	3.52557e-20
C114	VGND	a_298_368##10	9.50981e-19
C115	a_498_98#	VNB	4.00994e-18
C116	VGND#9	VGND#8	2.20738e-18
C117	VGND#9	VNB	3.79172e-18
C118	VGND	a_298_368#	4.89377e-18
C119	X#7	VNB	5.09541e-18
C120	C	C#3	5.33759e-18
C121	VGND#8	VNB	5.1362e-20
C122	X#5	VNB	4.69661e-18
C123	VGND#1	VNB	7.12338e-17
C124	A_N#6	VNB	3.79666e-18
C125	a_298_368##16	X#3	1.28116e-18
C126	a_27_74##9	VNB	3.56667e-17
C127	B#9	VNB	1.28219e-18
C128	VGND	VPWR#8	3.36266e-18
C129	C#2	a_298_368##20	1.44575e-19
C130	VGND	X#3	2.60212e-18
C131	a_239_98##2	VNB	1.32679e-17
C132	VPWR	C#1	2.84399e-19
C133	B	a_27_74##5	1.51393e-18
C134	a_298_368##16	VNB	5.69617e-18
C135	a_298_368##18	C#6	1.64396e-19
C136	VGND	a_27_74##10	1.61804e-17
C137	VPWR#11	a_298_368##21	5.20466e-17
C138	VGND	VGND#11	1.50291e-17
C139	a_298_368##18	VNB	3.15581e-18
C140	X#1	VNB	5.9078e-18
C141	VGND	a_239_98##3	2.21783e-17
C142	a_498_98##2	B#1	4.28076e-17
C143	X#2	VNB	1.51635e-18
C144	X#4	VNB	7.00306e-18
C145	VPWR	a_27_74##11	1.47588e-17
C146	VGND	a_298_368##22	6.77998e-18
C147	B	B#5	1.49996e-18
C148	VGND#2	VNB	3.23345e-17
C149	VGND#3	VNB	2.91416e-17
C150	VGND	a_498_98##2	8.99176e-18
C151	VGND#4	VNB	2.40001e-17
C152	VGND	a_239_98#	1.61644e-17
C153	B	C#6	1.38095e-19
C154	VGND#10	B#4	5.40824e-19
C155	VGND	a_498_98#	1.45633e-17
C156	VPWR	a_298_368##21	1.43788e-17
C157	VGND	VGND#9	2.19516e-17
C158	VPWR#3	VNB	3.05795e-17
C159	X#7	VGND#8	4.80808e-17
C160	VPWR#4	VNB	2.88787e-17
C161	C	B#6	1.48445e-19
C162	VGND	X#7	1.44727e-17
C163	a_298_368##16	C#5	3.52451e-17
C164	VPWR#10	VNB	3.2671e-17
C165	VGND	X#5	1.19443e-17
C166	VPWR	VPWR#8	2.06964e-17
C167	C	B#5	1.56914e-18
C168	VGND	VGND#1	3.81979e-17
C169	A_N#2	a_27_74##4	3.61333e-17
C170	A_N	a_27_74##6	7.90652e-19
C171	VPWR	X#3	1.66274e-17
C172	a_239_98#	B#1	4.00405e-17
C173	VPWR	VPWR#7	2.08942e-17
C174	A_N	a_27_74#	2.13987e-19
C175	VPWR	X#6	1.62304e-17
C176	VPWR#11	VPWR#9	5.88284e-18
C177	VPWR	VPWR#6	2.17576e-17
C178	VGND	a_27_74##9	3.99495e-18
C179	a_498_98#	B#4	5.61307e-20
C180	VGND	B#9	1.15097e-18
C181	X#1	a_298_368##3	1.23985e-17
C182	a_498_98##2	C#4	5.76519e-19
C183	a_27_74##4	B#3	2.50725e-17
C184	VGND	a_239_98##2	2.88957e-17
C185	VGND#10	C#2	4.83617e-19
C186	VPWR#10	a_27_74##5	2.3505e-18
C187	VGND#10	B#1	3.59631e-18
C188	VGND	a_298_368##16	3.94473e-18
C189	a_298_368##18	C#5	1.43923e-19
C190	VGND	a_298_368##18	1.38344e-18
C191	VGND	X#1	1.00377e-18
C192	X#7	X#5	2.22206e-18
C193	VGND	X#2	3.37666e-18
C194	VGND	X#4	2.07151e-18
C195	a_298_368##21	VPWR#9	5.20267e-17
C196	VGND	VGND#2	4.35785e-17
C197	a_239_98#	C#4	5.80139e-19
C198	VGND	VGND#3	2.28343e-17
C199	X	VPWR#6	1.85305e-17
C200	VGND	VGND#4	3.93184e-17
C201	a_298_368##16	a_298_368##8	6.54544e-19
C202	VPWR#3	a_298_368##7	1.97289e-20
C203	a_498_98#	B#1	3.60782e-19
C204	VPWR	a_27_74##9	1.13394e-17
C205	a_498_98##2	C#1	1.6227e-19
C206	VGND#5	B#3	9.70447e-20
C207	C#3	a_298_368##5	1.73717e-18
C208	VPWR	B#9	1.08151e-18
C209	VGND#10	C#4	4.518e-17
C210	VPWR#5	B#3	2.50277e-20
C211	VGND#5	C#3	8.09254e-19
C212	A_N#1	a_27_74##4	2.06774e-18
C213	VPWR#8	C#2	7.37312e-19
C214	VGND#8	X#5	3.43611e-17
C215	VPWR	a_298_368##16	1.84611e-17
C216	VPWR#5	C#3	2.55941e-20
C217	a_27_74##10	A_N	1.47657e-17
C218	VPWR	a_298_368##17	2.33944e-18
C219	a_27_74##4	a_27_74##7	4.82455e-19
C220	B#2	VNB	2.04319e-17
C221	VPWR#10	B#6	2.16718e-18
C222	C#2	VNB	3.59146e-17
C223	A_N	VGND#11	3.23051e-17
C224	VPWR	a_298_368##18	1.62134e-17
C225	VGND#1	X	1.32046e-17
C226	a_298_368##3	VNB	5.94196e-17
C227	VPWR	X#1	2.83706e-18
C228	VPWR	X#2	1.61959e-18
C229	a_498_98#	C#4	2.1055e-17
C230	a_298_368##7	VNB	3.44104e-17
C231	X#3	X#2	1.64357e-18
C232	A_N	a_298_368##22	4.17602e-18
C233	a_27_74##4	a_27_74##5	3.50266e-20
C234	a_239_98##3	a_239_98##2	4.52151e-18
C235	VGND#10	C#1	2.46909e-18
C236	a_27_74##5	B#3	4.28619e-19
C237	VGND#9	C#4	7.80655e-19
C238	VPWR	VPWR#3	2.30287e-17
C239	VPWR	VPWR#4	2.37981e-17
C240	VGND#8	VGND#1	2.36541e-18
C241	VPWR	VPWR#10	4.58317e-17
C242	X#2	a_298_368##3	6.63773e-18
C243	a_498_98#	C#2	9.32727e-18
C244	a_498_98##2	B#9	4.42215e-18
C245	a_298_368##22	B	1.00903e-17
C246	a_498_98#	C#1	4.05996e-17
C247	VPWR#9	VPWR#8	4.91048e-18
C248	a_239_98##2	a_298_368##18	9.75753e-19
C249	a_498_98##2	B	2.3556e-17
C250	X#1	X	1.28856e-17
C251	a_239_98##2	a_298_368##22	6.14513e-17
C252	VGND#10	a_298_368##14	5.78091e-19
C253	X#2	VPWR#7	2.74634e-17
C254	C#3	C#6	2.00066e-18
C255	VGND#9	C#1	1.55e-17
C256	VPWR#4	a_298_368##7	2.57275e-20
C257	X#5	VGND#1	4.64699e-17
C258	C#3	C#5	4.49952e-19
C259	a_498_98#	a_298_368##14	9.83442e-19
C260	A_N#2	a_27_74##6	3.08242e-18
C261	X#2	a_298_368##13	5.18568e-19
C262	a_498_98##2	C	2.86535e-17
C263	A_N#1	a_27_74##7	2.79659e-17
C264	VPWR#5	B#5	2.16718e-18
C265	a_298_368##5	a_298_368##8	9.94808e-18
C266	a_239_98##2	a_239_98##4	4.05145e-19
C267	VGND#9	a_298_368##14	4.58276e-17
C268	X#2	X#6	2.08835e-19
C269	VPWR#5	C#6	4.63005e-18
C270	a_27_74##7	a_27_74##5	4.16775e-17
C271	a_27_74##4	B#4	8.13667e-19
C272	a_239_98##2	B	2.20946e-17
C273	a_298_368##14	X#7	2.23925e-17
C274	X#1	VPWR#6	2.52539e-17
C275	VPWR#8	X#3	1.01741e-16
C276	VPWR#5	a_298_368##8	3.38824e-19
C277	X#2	a_298_368##11	1.9375e-17
C278	X#4	a_298_368##3	1.46877e-17
C279	B#3	B#2	3.02524e-18
C280	a_298_368##21	VPWR#10	5.48577e-18
C281	VGND#9	a_298_368##12	2.01524e-18
C282	a_27_74##5	B#6	2.78327e-17
C283	B	a_298_368##17	3.98167e-17
C284	a_239_98##2	a_498_98##2	4.31012e-17
C285	a_298_368##18	B	4.10416e-17
C286	VGND#8	a_298_368##14	1.11243e-18
C287	a_239_98##2	a_27_74##6	1.60049e-18
C288	VPWR#4	C#5	4.49672e-18
C289	C#1	a_298_368##7	8.98575e-18
C290	VPWR#8	VPWR#7	1.69573e-18
C291	X#7	a_298_368##12	2.6233e-17
C292	X#1	a_298_368##9	1.56139e-17
C293	C#2	a_298_368##7	1.21513e-18
C294	B#1	C#3	7.76107e-18
C295	B#6	B#5	4.12915e-17
C296	X#5	a_298_368##14	1.69297e-19
C297	X#2	a_298_368##9	6.95743e-18
C298	VGND#8	a_298_368##12	2.87993e-17
C299	C	a_298_368##16	7.52136e-18
C300	X#3	VPWR#7	7.91362e-17
C301	C	a_298_368##17	2.1738e-17
C302	C#2	a_298_368##8	7.98535e-18
C303	a_27_74##4	VPWR#13	2.94863e-17
C304	a_239_98##2	a_27_74#	2.77019e-17
C305	B#5	C#6	2.23797e-17
C306	X#7	a_298_368##10	4.24553e-19
C307	VGND#5	B#4	3.10389e-18
C308	a_27_74##4	a_298_368##19	4.42271e-20
C309	X#5	a_298_368##12	3.9752e-19
C310	VPWR#11	a_27_74##4	6.37705e-19
C311	a_298_368##5	C#1	6.28077e-18
C312	VPWR#4	a_298_368##8	4.66772e-18
C313	VGND#5	B#1	4.63165e-18
C314	X#3	X#6	9.70615e-19
C315	VGND#5	C#4	3.49357e-20
C316	VGND#8	a_298_368##10	3.27819e-17
C317	C#6	C#5	4.12101e-17
C318	B#2	C#3	2.98461e-17
C319	a_239_98##2	VGND#10	3.54683e-18
C320	X#7	a_298_368#	1.8605e-19
C321	X#3	a_298_368##7	6.59061e-18
C322	a_239_98##3	a_298_368##18	1.97726e-18
C323	C#3	C#2	9.96123e-19
C324	a_239_98##2	B#4	3.93381e-17
C325	B#3	a_298_368##21	5.44564e-19
C326	a_298_368##10	X#5	1.77604e-17
C327	VPWR#7	X#6	7.31839e-17
C328	VPWR#3	a_298_368##13	2.5732e-18
C329	a_27_74##10	A_N#2	5.24369e-18
C330	C#5	a_298_368##8	2.58159e-17
C331	VGND#11	A_N#2	1.02647e-17
C332	VGND#8	a_298_368#	1.5381e-18
C333	a_239_98##3	A_N#2	2.73593e-19
C334	VGND#1	a_298_368##10	2.82922e-18
C335	a_298_368##22	A_N#2	1.34475e-18
C336	a_239_98##2	a_498_98#	4.31258e-19
C337	VPWR#7	VPWR#6	1.69608e-18
C338	C#3	VPWR#9	1.71689e-18
C339	a_27_74##10	a_27_74##4	2.10746e-18
C340	a_298_368#	X#5	1.19933e-17
C341	X#4	a_298_368##7	1.35615e-19
C342	a_239_98##2	B#1	1.62078e-18
C343	C#3	a_298_368##7	4.27461e-19
C344	a_298_368##8	a_298_368##13	4.61573e-17
C345	X	a_298_368##3	6.89865e-18
C346	a_27_74##4	a_239_98##3	3.88455e-17
C347	X#3	VPWR#3	8.58066e-18
C348	VPWR#3	a_298_368##11	2.57004e-18
C349	a_298_368##22	a_27_74##4	2.68897e-17
C350	VGND#1	a_298_368#	4.30764e-17
C351	X#6	VPWR#6	7.31559e-17
C352	VGND#9	a_298_368##7	6.63795e-19
C353	VGND#3	C#2	2.14935e-20
C354	a_298_368##13	a_298_368##11	3.0801e-17
C355	a_298_368##5	B#2	2.24352e-19
C356	a_298_368##5	VPWR#8	5.15088e-18
C357	VGND#2	a_298_368##3	8.96189e-20
C358	a_239_98##2	C#4	8.58332e-19
C359	X#3	VPWR#4	8.49566e-18
C360	a_298_368##5	X#3	4.79582e-17
C361	a_298_368##22	B#3	6.16357e-19
C362	VPWR#7	a_298_368##5	2.12585e-18
C363	a_498_98##2	a_298_368##17	4.73654e-18
C364	a_298_368##21	VPWR#5	5.44491e-18
C365	a_239_98##2	VGND#4	2.55581e-18
C366	a_298_368##5	a_298_368##3	1.09797e-17
C367	a_27_74##11	A_N#1	4.4068e-17
C368	a_298_368##11	a_298_368##9	4.61442e-17
C369	a_498_98##2	B#3	4.22923e-18
C370	A_N#6	A_N#2	1.02018e-17
C371	a_239_98#	B#3	2.89071e-20
C372	A_N#1	VPWR#13	3.78411e-17
C373	a_298_368##22	C#3	1.64096e-18
C374	a_239_98##2	C#1	4.21055e-20
C375	a_27_74##11	a_27_74##7	1.38421e-18
C376	VPWR#5	VPWR#8	2.84285e-19
C377	a_27_74##9	A_N#6	4.25665e-17
C378	a_298_368##5	a_298_368##7	2.27269e-17
C379	a_27_74##9	A_N#2	1.92347e-17
C380	a_498_98##2	C#3	2.68e-17
C381	VPWR#11	A_N#1	5.29373e-19
C382	a_27_74##7	VPWR#13	2.98492e-17
C383	a_239_98#	C#3	2.32456e-18
C384	A_N#6	a_27_74##4	1.23349e-17
C385	a_27_74##7	a_298_368##19	2.11885e-17
C386	X#6	VPWR#3	8.49566e-18
C387	VGND#10	C#3	1.80789e-18
C388	X#7	a_298_368##7	1.97551e-18
C389	VGND#4	C#2	1.11945e-19
C390	VPWR#11	a_27_74##7	8.39582e-19
C391	VPWR#13	a_27_74##5	1.47847e-18
C392	a_498_98#	C#3	1.90603e-17
C393	VGND#5	B#2	2.91175e-20
C394	a_27_74##9	a_27_74##4	4.03488e-18
C395	a_27_74##10	VGND#11	5.7057e-17
C396	a_27_74##5	a_298_368##19	2.11885e-17
C397	VPWR#6	a_298_368##3	1.65805e-18
C398	VPWR#13	B#6	3.79276e-19
C399	a_27_74##5	VPWR#11	3.28675e-17
C400	VGND#5	a_298_368##3	7.36148e-21
C401	a_498_98#	a_298_368##16	3.89464e-17
C402	a_298_368##21	a_27_74##5	6.42923e-19
C403	VGND#5	a_498_98##2	1.87039e-18
C404	a_27_74##10	a_239_98##3	3.08651e-18
C405	VPWR#4	VPWR#3	9.53351e-19
C406	VGND#9	a_298_368##5	3.02533e-17
C407	A_N#3	a_27_74##6	3.96984e-18
C408	a_298_368##7	a_298_368##11	4.0453e-20
C409	a_27_74##9	a_27_74##11	3.20607e-20
C410	VGND#5	a_239_98#	1.74157e-17
C411	B#6	VPWR#11	2.93807e-17
C412	a_239_98##2	a_27_74##4	1.59794e-19
C413	VPWR#9	a_27_74##5	3.79276e-19
C414	a_298_368##5	X#7	6.01217e-17
C415	a_298_368##3	a_298_368#	2.12515e-18
C416	B	B#2	5.9975e-18
C417	a_298_368##16	C#1	3.40926e-18
C418	a_298_368##5	VGND#8	3.79969e-18
C419	a_298_368##21	B#6	4.11758e-17
C420	B#9	B#3	1.08619e-17
C421	VGND#5	a_498_98#	4.04408e-20
C422	VGND#11	a_239_98##3	4.38982e-17
C423	VPWR#11	B#5	8.39582e-19
C424	a_298_368##3	X#5	3.53859e-19
C425	VPWR#9	B#6	1.36794e-18
C426	a_27_74##6	a_27_74#	3.58753e-17
C427	a_27_74##9	VPWR#13	2.982e-18
C428	a_298_368##21	B#5	4.76395e-17
C429	a_239_98##2	B#3	8.08448e-19
C430	VPWR#11	C#6	3.71386e-19
C431	B#5	VPWR#9	3.50052e-17
C432	VPWR#5	C#2	2.52529e-20
C433	a_298_368##18	a_27_74##4	4.9552e-17
C434	a_298_368##21	C#6	6.75871e-19
C435	VGND#5	VGND#1	2.73666e-17
C436	a_27_74#	B#4	3.41677e-17
C437	C#6	VPWR#9	3.02691e-17
C438	VPWR#8	B#5	3.55367e-19
C439	a_239_98##3	a_298_368##22	5.56813e-17
C440	VGND#3	a_298_368##16	1.88156e-19
C441	a_298_368##17	B#3	2.44785e-18
C442	C#6	a_298_368##20	1.88578e-17
C443	X#4	X#1	1.43234e-19
C444	C	B#2	1.01602e-17
C445	a_298_368##18	B#3	4.24069e-19
C446	VGND#3	a_298_368##7	5.88847e-20
C447	VPWR#9	C#5	7.07598e-19
C448	VPWR#8	C#6	7.60199e-19
C449	B#4	B#1	2.66117e-17
C450	X#4	C#1	3.1432e-19
C451	C#5	a_298_368##20	2.12088e-17
C452	C#3	a_298_368##16	5.99608e-17
C453	VPWR#9	a_298_368##8	7.04873e-19
C454	C#5	VPWR#8	3.3355e-17
C455	X#4	X#2	4.06903e-18
C456	B#1	C#4	3.15994e-18
C457	VGND#4	C#4	1.02377e-18
C458	a_298_368##8	VPWR#8	3.13696e-17
C459	X#4	a_298_368##14	9.97168e-20
C460	VPWR#10	a_27_74##4	2.39724e-20
C461	VGND#5	a_239_98##2	3.6433e-17
C462	X#3	a_298_368##8	5.5828e-17
C463	a_298_368##22	a_498_98##2	1.51408e-18
C464	VGND#3	C#1	4.31554e-18
C465	C#4	C#1	3.31616e-17
C466	VPWR#8	a_298_368##13	1.25159e-18
C467	VPWR#7	a_298_368##8	7.67963e-19
C468	a_298_368##5	X#1	1.67847e-17
C469	X#3	a_298_368##13	7.32149e-17
C470	VGND#2	a_298_368##14	4.72378e-19
C471	X#4	a_298_368##12	1.61533e-19
C472	a_298_368##5	X#2	6.51636e-17
C473	VPWR#8	a_298_368##11	2.8528e-19
C474	VPWR#10	B#3	2.53659e-20
C475	a_298_368##13	VPWR#7	3.68577e-17
C476	X#4	a_298_368##5	4.18194e-17
C477	VGND#3	a_298_368##14	3.78885e-18
C478	C#1	a_298_368##14	2.69948e-17
C479	X#3	a_298_368##11	5.19482e-19
C480	a_27_74##9	A_N#1	2.66046e-17
C481	X#6	a_298_368##13	3.06241e-19
C482	VGND#2	a_298_368##5	6.74659e-20
C483	a_298_368##22	B#2	2.39742e-19
C484	a_298_368##11	VPWR#7	3.16592e-17
C485	VGND#3	a_298_368##5	7.02048e-19
C486	VGND#4	a_298_368##14	7.91244e-19
C487	VPWR#6	a_298_368##13	2.8528e-19
C488	VGND#2	a_298_368##12	4.74361e-18
C489	VGND#3	a_498_98#	4.44328e-18
C490	X#4	a_298_368##10	1.83643e-17
C491	a_298_368##16	VPWR#5	8.58034e-18
C492	X#6	a_298_368##11	4.78326e-17
C493	VGND#9	VGND#2	6.06909e-20
C494	a_298_368##16	C#2	2.61153e-17
C495	a_298_368##17	VPWR#5	1.70755e-19
C496	a_298_368##14	a_298_368##12	2.90863e-17
C497	a_239_98#	a_498_98##2	4.06817e-17
C498	VPWR#7	a_298_368##9	1.4381e-18
C499	VPWR#6	a_298_368##11	1.34947e-18
C500	a_27_74##11	a_298_368##18	4.97605e-18
C501	VGND#2	X#4	4.59883e-19
C502	VGND#5	VGND#2	4.18309e-17
C503	VGND#4	a_498_98#	5.48101e-18
C504	X#6	a_298_368##9	4.98518e-17
C505	X#4	VGND#8	1.96927e-17
C506	VGND#5	VGND#3	3.76942e-17
C507	VGND#2	a_298_368##10	5.30859e-18
C508	X#4	a_298_368#	6.70374e-18
C509	VGND#5	VGND#4	2.72012e-17
C510	a_298_368##9	VPWR#6	2.86702e-17
C511	a_298_368##5	VPWR#4	2.50928e-19
C512	a_239_98##2	B#9	7.27553e-18
C513	VGND#1	X#1	1.30563e-18
C514	a_298_368##12	a_298_368##10	3.52499e-17
C515	VGND#2	X#7	7.24253e-18
C516	VPWR#13	a_298_368##18	8.23015e-17
C517	VGND#4	VGND#9	9.04875e-19
C518	a_498_98##2	a_498_98#	1.82914e-18
C519	X#4	X#5	1.16271e-18
C520	a_239_98#	VGND#10	2.1936e-17
C521	VGND#2	a_298_368#	7.84444e-19
C522	VGND#3	X#7	7.4696e-18
C523	a_298_368##10	a_298_368#	4.03484e-17
C524	a_298_368##16	VPWR#11	2.51284e-20
C525	a_298_368##18	a_298_368##19	7.98605e-19
C526	a_298_368##18	A_N#1	1.84594e-18
C527	VGND#9	a_298_368##8	3.52427e-18
C528	B#9	B#6	1.99246e-18
C529	a_27_74##10	A_N#6	2.72345e-18
C530	a_27_74##10	A_N#3	3.39803e-17
C531	X#4	VGND#1	2.28043e-17
C532	a_298_368##17	VPWR#11	1.5482e-17
C533	a_298_368##16	VPWR#4	3.73207e-18
C534	VGND#11	A_N#3	1.81582e-17
C535	VPWR#5	VPWR#3	4.00837e-17
C536	a_498_98#	VGND#10	6.90046e-17
C537	a_298_368##21	a_298_368##16	3.00569e-18
C538	VGND#2	X#5	1.10194e-17
C539	a_27_74##10	a_27_74##6	1.56638e-19
C540	a_298_368##18	VPWR#11	7.35293e-17
C541	VPWR#5	VPWR#4	3.89493e-17
C542	a_298_368##18	a_27_74##7	2.89416e-17
C543	a_239_98##3	A_N#3	2.30847e-18
C544	a_498_98##2	B#2	1.39904e-18
C545	VGND#3	VGND#2	1.13178e-18
C546	VPWR#5	VPWR#10	4.14649e-17
C547	VGND#11	a_27_74##6	1.23417e-18
C548	a_298_368##17	a_298_368##21	1.66246e-18
C549	a_298_368##16	a_27_74##5	1.0662e-19
C550	VGND#10	VGND#9	4.02467e-18
C551	a_239_98##3	a_27_74##6	5.71336e-17
C552	a_27_74##11	VPWR#13	7.49609e-17
C553	a_298_368##16	VPWR#9	5.32845e-17
C554	VPWR#8	C#1	1.94456e-18
C555	VGND#2	VGND#1	1.05003e-18
C556	a_298_368##18	a_298_368##21	3.23538e-18
C557	a_298_368##18	a_27_74##5	4.87118e-17
C558	a_27_74##10	a_27_74##9	2.16208e-18
C559	a_27_74##6	a_298_368##22	1.85527e-17
C560	a_498_98#	VGND#9	5.87209e-17
C561	a_298_368##17	VPWR#9	2.18551e-17
C562	a_239_98##3	a_27_74#	1.71179e-18
C563	a_298_368##16	B#6	1.45743e-19
C564	a_298_368##17	VPWR#10	1.70755e-19
C565	a_298_368##17	B#6	1.73e-17
C566	a_298_368##16	a_298_368##20	1.43667e-18
C567	a_27_74#	a_298_368##22	1.48856e-17
C568	a_498_98##2	a_27_74##6	2.28272e-19
C569	VGND#11	a_27_74##9	1.6599e-18
C570	VPWR#3	a_298_368##3	3.1726e-20
C571	a_298_368##18	B#6	1.33604e-18
C572	VGND#6	a_27_74#	3.17639e-18
C573	VPWR#2	VNB	4.04184e-17
C574	VPWR#12	A_N#1	7.22498e-18
C575	X	VPWR#2	1.38235e-18
C576	a_27_74##11	VPWR#12	1.36251e-17
C577	X#1	VPWR#2	3.36446e-19
C578	VGND#6	a_239_98##2	2.23009e-17
C579	VGND#6	A_N	6.54469e-19
C580	VPWR#5	VPWR#2	4.30999e-17
C581	VGND#6	a_27_74##9	1.96589e-19
C582	VPWR#2	a_298_368##9	3.99511e-18
C583	VPWR#12	VNB	6.65546e-17
C584	VPWR	VPWR#2	2.86294e-17
C585	VGND	VGND#6	5.09646e-17
C586	VGND#6	a_27_74##6	3.19583e-18
C587	VPWR#12	VPWR#11	2.97251e-19
C588	VPWR#5	VPWR#12	6.94212e-17
C589	VGND#6	a_27_74##10	2.07643e-17
C590	VGND#6	a_27_74##4	1.32535e-18
C591	a_27_74##4	VPWR#12	2.89989e-19
C592	VPWR#3	VPWR#2	9.5684e-19
C593	a_27_74##9	VPWR#12	3.63188e-18
C594	VPWR#2	a_298_368##3	3.1726e-20
C595	VGND#6	a_239_98##3	4.61754e-17
C596	VPWR#12	A_N#2	5.1489e-19
C597	VGND#6	VNB	7.60706e-17
C598	VGND#6	A_N#3	7.41254e-18
C599	VPWR#12	a_27_74##7	3.82262e-18
C600	X#6	VPWR#2	8.44616e-18
C601	VGND#5	VGND#6	8.73989e-17
C602	VPWR	VPWR#12	7.06898e-17
C603	VPWR#12	VPWR#10	1.38629e-18
C604	a_298_368##18	VPWR#12	5.48662e-18
*
*
.ENDS sky130_fd_sc_hs__and3b_4
*
