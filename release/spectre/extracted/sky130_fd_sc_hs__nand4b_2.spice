* Extracted by Quantus, converted by sky130cad/quantus.py
*
*
*
*                       LINUX           Wed Nov 18 08:47:53 2026
*
*
*
*  PROGRAM  advgen
*
*  Name           : advgen - Quantus - (64-bit)
*  Version        : 25.1.0-p047
*  Build Date     : Thu Dec 11 23:20:30 PST 2025
*
*  HSPICE LIBRARY
*
*  OPERATING_TEMPERATURE 150
*  QRC_TECH_DIR <path>/tech
*
*
*

*
.SUBCKT sky130_fd_sc_hs__nand4b_2 VPB VNB VGND VPWR Y A_N B C D
*
*
*  caps2d version: 10
*
*
*       TRANSISTOR CARDS
*
*
XM17 a_27_74##9 A_N#3 VGND#7 VNB sky130_fd_pr__nfet_01v8_lvt l=0.15 w=0.64 ad=0.1824 as=0.1726 pd=1.85 ps=1.85
XM4 Y#6 a_27_74##5 a_225_74##4 VNB sky130_fd_pr__nfet_01v8_lvt l=0.15 w=0.74 ad=0.2294 as=0.1962 pd=2.1 ps=2.05
XM14 a_225_74##2 a_27_74# Y#6 VNB sky130_fd_pr__nfet_01v8_lvt l=0.15 w=0.74 ad=0.2072 as=0.2294 pd=2.04 ps=2.1
XM5 a_490_74##2 B#7 a_225_74##2 VNB sky130_fd_pr__nfet_01v8_lvt l=0.15 w=0.74 ad=0.3546 as=0.2072 pd=2.56 ps=2.04
XM9 a_225_74# B#5 a_490_74##2 VNB sky130_fd_pr__nfet_01v8_lvt l=0.15 w=0.74 ad=0.197775 as=0.3546 pd=2.05 ps=2.56
XM0 a_490_74# C#5 a_719_123##3 VNB sky130_fd_pr__nfet_01v8_lvt l=0.15 w=0.74 ad=0.2072 as=0.204075 pd=2.04 ps=2.05
XM13 a_719_123##4 C#1 a_490_74# VNB sky130_fd_pr__nfet_01v8_lvt l=0.15 w=0.74 ad=0.2072 as=0.2072 pd=2.04 ps=2.04
XM1 VGND#6 D#5 a_719_123##4 VNB sky130_fd_pr__nfet_01v8_lvt l=0.15 w=0.74 ad=0.222 as=0.2072 pd=2.08 ps=2.04
XM16 a_719_123# D#1 VGND#6 VNB sky130_fd_pr__nfet_01v8_lvt l=0.15 w=0.74 ad=0.2109 as=0.222 pd=2.05 ps=2.08
XM7 a_27_74##10 A_N#1 VPWR#11 VPB sky130_fd_pr__pfet_01v8 l=0.15 w=1 ad=0.295 as=0.426 pd=2.59 ps=3.02
XM2 Y#4 a_27_74##6 VPWR#11 VPB sky130_fd_pr__pfet_01v8 l=0.15 w=1.12 ad=0.336 as=0.426 pd=2.84 ps=3.02
XM10 VPWR#10 a_27_74##4 Y#4 VPB sky130_fd_pr__pfet_01v8 l=0.15 w=1.12 ad=0.7448 as=0.336 pd=3.57 ps=2.84
XM6 VPWR#10 B#6 Y#7 VPB sky130_fd_pr__pfet_01v8 l=0.15 w=1.12 ad=0.7448 as=0.336 pd=3.57 ps=2.84
XM15 Y#7 B#1 VPWR#9 VPB sky130_fd_pr__pfet_01v8 l=0.15 w=1.12 ad=0.336 as=0.448 pd=2.84 ps=3.04
XM3 Y#5 C#6 VPWR#9 VPB sky130_fd_pr__pfet_01v8 l=0.15 w=1.12 ad=0.336 as=0.448 pd=2.84 ps=3.04
XM12 VPWR#8 C#4 Y#5 VPB sky130_fd_pr__pfet_01v8 l=0.15 w=1.12 ad=0.56 as=0.336 pd=3.24 ps=2.84
XM11 Y#1 D#6 VPWR#8 VPB sky130_fd_pr__pfet_01v8 l=0.15 w=1.12 ad=0.336 as=0.56 pd=2.84 ps=3.24
XM8 VPWR#1 D#4 Y#1 VPB sky130_fd_pr__pfet_01v8 l=0.15 w=1.12 ad=0.336 as=0.336 pd=2.84 ps=2.84
*
*
*       RESISTOR AND CAP/DIODE CARDS
*
Rg1	A_N#1	A_N#2	506.679810
Rg2	A_N#2	A_N#3	331.202271
Rg3	a_27_74#	a_27_74##2	393.763794
Rg4	a_27_74##2	a_27_74##3	47.331100
Rg5	a_27_74##2	a_27_74##4	449.791595
Rg6	a_27_74##3	a_27_74##5	400.395355
Rg7	a_27_74##3	a_27_74##6	446.312561
Rg8	B#1	B#2	451.367615
Rg9	B#2	B#3	45.237701
Rg10	B#3	B#4	50.316681
Rg11	B#2	B#5	370.752045
Rg12	B#3	B#6	419.554810
Rg13	B#4	B#7	401.770752
Rg14	C#1	C#2	435.478455
Rg15	C#2	C#3	50.551613
Rg16	C#2	C#4	416.207306
Rg17	C#3	C#5	348.334229
Rg18	C#3	C#6	444.592682
Rg19	D#1	D#2	368.862610
Rg20	D#2	D#3	50.284184
Rg21	D#2	D#4	449.655212
Rg22	D#3	D#5	380.700043
Rg23	D#3	D#6	467.578552
Rf1	A_N	A_N#4	2.755709
Rf2	A_N#4	A_N	16.140581
Rf3	a_27_74##3	a_27_74##8	169.306961
Rf4	a_27_74##8	a_27_74##9	133.548935
Rf5	a_27_74##8	a_27_74##10	76.208038
Rf6	B#8	B	1.823013
Rf7	B#4	B#10	162.055817
Rf8	B#8	B#10	8.098473
Rf9	a_225_74#	a_225_74##3	88.405930
Rf10	a_225_74##3	a_225_74##4	56.172699
Rf11	a_225_74##2	a_225_74##3	15.000000
Rf12	C#7	C	1.409262
Rf13	C#3	C#9	81.525665
Rf14	C#7	C#9	7.945672
Rf15	C#10	C	1.409262
Rf16	C#9	C#10	6.723260
Rf17	a_490_74#	a_490_74##2	139.731033
Rf18	Y#1	Y#2	93.702293
Rf19	Y#2	Y#3	66.781960
Rf20	Y#3	Y#4	111.850578
Rf21	Y#2	Y#5	17.027714
Rf22	Y#3	Y	15.589558
Rf23	Y	Y#6	116.378349
Rf24	Y#3	Y#7	19.708256
Rf25	D	D#7	4.125637
Rf26	D#7	D	10.543295
Rf27	a_719_123#	a_719_123##2	62.962234
Rf28	a_719_123##2	a_719_123##3	58.396423
Rf29	a_719_123##2	a_719_123##4	19.086887
Rf30	VPWR#1	VPWR#2	112.244980
Rf31	VPWR#2	VPWR#3	77.384460
Rf32	VPWR#3	VPWR#4	39.787987
Rf33	VPWR#4	VPWR#5	42.888290
Rf34	VPWR#5	VPWR#6	79.389008
Rf36	VPWR#2	VPWR#8	32.420494
Rf37	VPWR#3	VPWR#9	32.322075
Rf38	VPWR#5	VPWR#10	17.377279
Rf39	VPWR#6	VPWR#11	36.514511
Rf41	VGND#2	VGND#3	157.034042
Rf42	VGND#3	VGND#4	158.495041
Rf44	VGND#2	VGND#6	34.507496
Rf45	VGND#4	VGND#7	33.326477
Rf50	D#3	D#7	160.232803
Rf46	A_N#2	A_N#4	80.116402
Re1	VPWR#4	VPWR	0.818510
Re2	VGND	VGND#3	0.818540
*
*       CAPACITOR CARDS
*
*
C1	a_719_123#	VGND#6	4.02453e-17
C2	Y#5	VPWR#3	9.97267e-18
C3	VPWR#5	VPWR#9	3.62243e-19
C4	Y#5	VPWR#2	6.95592e-18
C5	a_719_123##4	a_719_123#	3.25777e-18
C6	Y#3	Y#1	1.01224e-21
C7	a_719_123##4	VGND#6	3.32474e-17
C8	Y#2	Y#1	2.25532e-20
C9	Y#6	B#10	1.73597e-17
C10	a_490_74#	VGND#6	4.45351e-18
C11	Y#2	VPWR#8	2.55737e-17
C12	a_490_74#	a_719_123##4	3.36293e-17
C13	a_27_74##8	Y#6	5.26265e-17
C14	Y#4	VPWR#5	7.49722e-18
C15	Y#2	Y#5	1.5535e-18
C16	a_719_123##3	a_719_123##4	3.36263e-18
C17	Y#3	VPWR#9	2.81234e-17
C18	a_27_74##8	a_225_74##4	2.35945e-17
C19	VPWR#4	B#3	3.96003e-20
C20	a_490_74#	a_719_123##3	6.33318e-17
C21	VPWR#11	VPWR#5	1.74825e-20
C22	Y#2	VPWR#9	9.26988e-18
C23	Y#3	Y#7	2.68731e-19
C24	Y#7	Y#2	2.97655e-19
C25	Y#3	VPWR#10	3.67103e-17
C26	a_225_74#	a_719_123##3	2.52615e-17
C27	a_490_74##2	a_490_74#	1.2691e-18
C28	VGND#3	B#3	9.53398e-20
C29	a_225_74##2	a_490_74#	1.09032e-18
C30	Y#4	Y#3	5.97046e-19
C31	a_225_74#	a_490_74##2	5.28615e-17
C32	D#3	D#2	2.58045e-18
C33	a_225_74##2	a_225_74#	1.65087e-18
C34	Y#6	a_719_123##3	1.00691e-18
C35	a_719_123#	VPWR#1	3.61776e-19
C36	B#10	B#3	8.2438e-18
C37	a_225_74##2	a_490_74##2	3.79616e-17
C38	a_719_123##2	D#5	1.72231e-17
C39	a_225_74##2	Y#6	6.16391e-17
C40	B#3	C#3	1.88114e-17
C41	a_719_123##2	C#1	2.11874e-17
C42	a_225_74##2	a_225_74##4	3.77626e-22
C43	VGND#7	a_490_74##2	1.26514e-18
C44	a_225_74##4	Y#6	2.38626e-17
C45	a_225_74##2	VGND#7	7.55252e-22
C46	a_27_74##9	a_225_74##2	3.26344e-21
C47	a_27_74##8	Y#4	2.19625e-17
C48	B#4	B#3	2.03036e-18
C49	a_27_74##8	B#3	6.34536e-20
C50	a_27_74##2	B#4	2.55909e-17
C51	VGND#7	a_225_74##4	2.40923e-17
C52	a_27_74##2	B#3	2.34057e-19
C53	a_27_74##8	VPWR#11	3.74798e-17
C54	a_27_74##8	a_27_74##10	3.03836e-19
C55	a_27_74##9	VGND#7	5.76132e-17
C56	a_27_74##8	a_27_74##2	2.24316e-19
C57	a_27_74##3	a_27_74##2	3.96172e-18
C58	VPWR#5	VPWR#3	9.84043e-19
C59	a_719_123#	D#1	3.67354e-17
C60	Y#1	VPWR#1	9.18618e-17
C61	VGND#6	D#1	3.20767e-17
C62	a_719_123#	D#5	1.17997e-18
C63	a_719_123#	D#2	4.44951e-19
C64	a_719_123##4	D#1	1.22089e-18
C65	VPWR#8	VPWR#1	1.46643e-18
C66	VGND#6	D#5	3.11681e-17
C67	a_719_123#	C#1	2.67207e-19
C68	Y#1	VPWR#8	6.40457e-17
C69	VPWR#3	VPWR#2	8.44973e-19
C70	D#5	a_719_123##4	1.5763e-17
C71	VGND#6	C#1	2.22144e-18
C72	Y#6	Y#4	8.05336e-18
C73	VPWR#2	D#6	5.68243e-18
C74	a_490_74#	D#5	1.83856e-18
C75	Y#5	Y#1	2.25532e-18
C76	C#1	a_719_123##4	1.84512e-17
C77	Y#3	D#4	1.68208e-19
C78	a_719_123##3	D#5	2.73446e-19
C79	Y#5	VPWR#8	4.771e-17
C80	VGND#6	D#2	1.24403e-19
C81	a_490_74#	C#1	3.23626e-17
C82	VPWR#2	C#4	5.68243e-18
C83	a_719_123##4	C#5	1.0683e-18
C84	B#3	C#5	1.58713e-19
C85	VPWR#5	C#6	6.83781e-20
C86	a_719_123##3	C#1	6.26252e-19
C87	VPWR#9	VPWR#8	1.41812e-18
C88	VGND#6	B#5	8.10367e-20
C89	Y#3	D#6	2.10949e-19
C90	a_490_74#	C#5	3.64838e-17
C91	VPWR#3	C#6	2.57874e-18
C92	Y#2	D#6	5.47547e-21
C93	a_719_123##4	B#5	8.41137e-20
C94	VPWR#9	Y#5	6.22435e-17
C95	a_27_74##8	a_27_74##5	5.55303e-18
C96	a_719_123##3	C#5	3.60149e-17
C97	VPWR#5	B#1	2.88128e-19
C98	a_490_74#	B#5	4.49728e-19
C99	Y#3	C#4	3.73219e-19
C100	Y#7	Y#5	2.58831e-18
C101	a_225_74#	C#5	6.01933e-19
C102	VPWR#3	B#1	5.36113e-18
C103	Y#3	VPWR#5	1.6906e-19
C104	Y#2	C#4	2.3052e-17
C105	a_719_123##3	B#5	2.66272e-18
C106	a_27_74##8	A_N#3	2.42385e-19
C107	a_490_74##2	C#5	3.2815e-19
C108	a_490_74#	B#7	1.36974e-19
C109	Y#7	VPWR#9	6.22197e-17
C110	a_225_74#	B#5	4.10193e-17
C111	VPWR#5	B#6	3.06854e-18
C112	Y#3	C#6	8.11915e-19
C113	a_225_74##2	C#5	1.68668e-19
C114	a_719_123##3	B#7	2.00651e-19
C115	Y#3	VPWR#3	5.55487e-19
C116	VPWR#10	VPWR#9	1.6499e-18
C117	Y#2	C#6	2.05904e-17
C118	a_490_74##2	B#5	3.95726e-17
C119	Y#6	C#5	1.43125e-19
C120	a_225_74#	B#7	6.55162e-19
C121	a_225_74##2	B#5	7.42604e-19
C122	VPWR#10	Y#7	6.414e-17
C123	a_719_123##3	a_27_74#	1.09442e-19
C124	VPWR#5	a_27_74##4	4.61744e-18
C125	Y#3	B#1	2.12231e-17
C126	B#7	a_490_74##2	2.24917e-17
C127	Y#2	VPWR#3	1.6661e-19
C128	Y#2	B#1	8.69361e-20
C129	Y#6	B#5	2.63727e-19
C130	C#9	C#6	5.99084e-19
C131	Y#4	Y#7	2.01487e-18
C132	a_225_74##2	B#7	4.50087e-17
C133	a_490_74##2	a_27_74#	6.57029e-19
C134	Y#3	B#6	2.8086e-17
C135	VPWR#5	a_27_74##6	2.8028e-19
C136	Y#6	B#7	1.82496e-17
C137	Y#4	VPWR#10	8.61558e-17
C138	Y#2	VPWR#2	3.28319e-19
C139	a_225_74##2	a_27_74#	3.60348e-17
C140	VGND#7	B#5	2.46555e-19
C141	a_490_74##2	a_27_74##5	3.58695e-19
C142	VPWR#11	VPWR#10	1.90153e-18
C143	Y#6	a_27_74#	4.17062e-17
C144	Y#3	a_27_74##4	5.14624e-19
C145	VGND#7	B#7	1.70936e-19
C146	a_225_74##2	a_27_74##5	1.1154e-18
C147	VPWR#11	Y#4	8.09704e-17
C148	a_490_74##2	A_N#3	2.57211e-19
C149	a_27_74##9	B#7	2.11726e-19
C150	Y#6	a_27_74##5	2.92468e-17
C151	VGND#7	a_27_74#	5.77958e-19
C152	a_225_74##2	A_N#3	6.55284e-19
C153	a_27_74##10	Y#4	3.24319e-18
C154	B#10	B#1	3.94426e-19
C155	Y#3	a_27_74##6	7.63548e-20
C156	a_225_74##4	a_27_74##5	4.67347e-17
C157	a_27_74##9	a_27_74#	3.15206e-19
C158	a_719_123##2	Y#2	5.16359e-18
C159	Y#6	A_N#3	6.11524e-19
C160	a_27_74##10	VPWR#11	6.38816e-17
C161	VGND#7	a_27_74##5	2.70467e-18
C162	a_225_74##4	A_N#3	6.20796e-19
C163	B#10	B#6	2.10614e-18
C164	a_27_74##9	a_27_74##5	8.96826e-19
C165	Y#3	A_N#1	7.21664e-20
C166	VGND#7	A_N#3	3.97524e-17
C167	VPWR#4	VPWR#5	4.1559e-17
C168	a_27_74##8	B#6	5.91999e-19
C169	VPWR#4	VPWR#3	3.37642e-17
C170	a_27_74##9	A_N#3	3.21951e-17
C171	VPWR#4	VPWR#2	4.84094e-17
C172	a_27_74##8	a_27_74##4	1.84415e-18
C173	D#5	D#1	3.49906e-17
C174	D	D#2	1.96383e-17
C175	a_27_74##8	a_27_74##6	5.02752e-18
C176	D#4	VPWR#1	3.62372e-17
C177	a_225_74#	B#3	9.81304e-19
C178	C#1	D#5	3.97738e-17
C179	Y#1	D#4	5.53406e-17
C180	VPWR#2	D#3	4.10788e-20
C181	VPWR#1	D#6	1.40059e-18
C182	VPWR#8	D#4	1.26292e-18
C183	Y#1	D#6	6.69099e-17
C184	a_719_123##2	D#3	1.4923e-17
C185	VPWR#1	C#4	2.6382e-19
C186	C#5	C#1	3.88683e-17
C187	VPWR#3	C#3	2.77202e-20
C188	D#6	VPWR#8	3.44235e-17
C189	VPWR#2	C#3	1.16161e-20
C190	Y#1	C#4	5.53023e-19
C191	Y#5	D#6	1.51043e-18
C192	C	B#3	4.16157e-18
C193	a_719_123##2	C#3	2.10496e-18
C194	C#4	VPWR#8	3.9037e-17
C195	a_490_74##2	B#3	1.03671e-18
C196	VPWR#9	D#6	2.66291e-19
C197	B#5	C#5	5.05823e-18
C198	Y#5	C#4	5.26054e-17
C199	VPWR#8	C#6	6.27948e-19
C200	C#9	Y#2	2.19237e-17
C201	Y#2	C#3	7.98113e-18
C202	VPWR#9	C#4	7.75891e-19
C203	Y#5	C#6	4.61817e-17
C204	VPWR#5	a_27_74##3	1.62405e-20
C205	B#7	B#5	1.95411e-17
C206	VPWR#8	B#1	2.54353e-19
C207	C#6	VPWR#9	2.93145e-17
C208	C#9	C#3	9.90035e-18
C209	Y#3	B#4	4.435e-18
C210	Y#5	B#1	7.55966e-19
C211	Y#7	C#6	8.42902e-19
C212	B#1	VPWR#9	3.62567e-17
C213	VPWR#10	C#6	2.67788e-19
C214	a_27_74#	B#7	3.83009e-17
C215	a_225_74##2	B#3	3.17913e-19
C216	B	a_27_74##2	1.23095e-17
C217	Y#7	B#1	5.41074e-17
C218	VPWR#9	B#6	1.26567e-18
C219	VPWR#10	B#1	5.4982e-19
C220	VGND#3	a_490_74#	3.89214e-17
C221	a_719_123#	D#3	4.12521e-19
C222	Y#7	B#6	4.674e-17
C223	VGND#6	D#3	6.96827e-19
C224	a_27_74##5	a_27_74#	3.47752e-17
C225	VPWR#9	a_27_74##4	1.78823e-19
C226	B#10	B#4	1.30093e-17
C227	B#6	VPWR#10	3.77851e-17
C228	Y#7	a_27_74##4	5.82642e-19
C229	VGND#3	a_490_74##2	6.86052e-17
C230	Y#4	B#6	1.17921e-18
C231	B#10	Y#3	2.7629e-17
C232	a_225_74##2	a_27_74##2	1.92891e-19
C233	a_27_74##8	B#4	1.97482e-18
C234	VGND#3	a_225_74##2	2.34993e-17
C235	a_27_74##4	VPWR#10	4.31547e-17
C236	A_N#3	a_27_74##5	4.24422e-18
C237	VPWR#11	B#6	1.16315e-19
C238	Y#4	a_27_74##4	7.74701e-17
C239	a_490_74#	C#3	1.7175e-18
C240	VPWR#10	a_27_74##6	5.37719e-19
C241	VPWR#4	VPWR#1	2.75921e-17
C242	VPWR#11	a_27_74##4	3.06508e-18
C243	a_719_123##3	C#3	7.36714e-18
C244	a_27_74##8	a_27_74##3	2.85141e-17
C245	a_27_74##6	Y#4	1.92515e-17
C246	a_27_74##10	a_27_74##4	2.86549e-19
C247	VPWR#11	a_27_74##6	6.88113e-17
C248	Y#4	A_N#1	1.48527e-18
C249	a_27_74##10	a_27_74##6	2.08717e-18
C250	a_27_74##8	A_N#2	5.10331e-17
C251	a_27_74##8	Y#3	2.57421e-18
C252	A_N#1	VPWR#11	2.58376e-17
C253	a_490_74##2	B#4	2.03481e-19
C254	Y#6	a_27_74##2	2.15942e-18
C255	Y#7	VPWR#4	1.67572e-17
C256	a_27_74##10	A_N#1	6.3493e-17
C257	a_225_74##2	B#4	2.54164e-19
C258	D#3	Y#1	1.51803e-17
C259	Y	D#2	9.90609e-20
C260	Y	B#3	2.80106e-17
C261	D#6	D#4	4.57203e-17
C262	Y	a_27_74##2	8.21669e-20
C263	a_225_74##2	a_27_74##3	6.005e-20
C264	Y#6	a_27_74##3	2.47179e-18
C265	VPWR#8	C#3	1.70714e-18
C266	a_225_74##4	a_27_74##3	3.15647e-19
C267	C#3	Y#5	5.44564e-19
C268	C#4	D#6	2.30377e-17
C269	C#3	VPWR#9	7.56451e-19
C270	Y#6	A_N#2	5.02354e-20
C271	VGND#3	D#1	7.19571e-21
C272	a_719_123##2	VGND#6	1.89103e-17
C273	C#6	C#4	4.58837e-17
C274	A_N#2	VGND#7	4.56724e-18
C275	VGND#3	D#5	3.59786e-20
C276	a_27_74##9	A_N#2	3.23794e-17
C277	B#4	VPWR#10	3.16396e-18
C278	VGND#3	C#5	1.43042e-18
C279	B#1	C#6	3.02884e-17
C280	C#1	D#3	1.79007e-18
C281	a_719_123##2	a_719_123##4	3.18435e-19
C282	VGND#3	B#5	4.47052e-18
C283	a_719_123##2	D	4.83466e-17
C284	VGND#3	B#7	5.18728e-18
C285	Y#4	a_27_74##3	3.94315e-18
C286	D	Y#2	1.60861e-17
C287	C#3	C#1	1.79007e-18
C288	VGND#3	a_27_74#	5.35671e-18
C289	B#6	B#1	4.54914e-17
C290	a_719_123##2	a_490_74#	1.49924e-17
C291	a_719_123##2	C	9.74208e-18
C292	a_27_74##4	B#6	1.09661e-17
C293	C	Y#3	2.93464e-18
C294	A_N#2	a_27_74##10	4.30597e-17
C295	C	Y#2	4.37711e-17
C296	a_27_74##6	a_27_74##4	4.62019e-17
C297	a_719_123#	D	4.9991e-17
C298	D	VGND#6	2.83338e-18
C299	D#3	D#6	1.31061e-18
C300	B	Y#3	7.95612e-18
C301	VPWR#4	B#1	1.60209e-18
C302	A_N#1	a_27_74##6	3.05139e-17
C303	a_490_74#	Y#3	1.08351e-18
C304	VPWR#4	B#6	1.60165e-18
C305	B#3	B#1	3.75431e-19
C306	Y#3	B#3	3.21819e-18
C307	A_N#2	a_27_74##5	3.83591e-18
C308	C	a_490_74#	5.12545e-18
C309	C	a_719_123##3	3.4457e-17
C310	a_27_74##8	B	1.98414e-17
C311	B#1	C#3	2.44139e-19
C312	D	VPWR#1	3.69699e-17
C313	D	Y#1	5.03572e-17
C314	D#2	VNB	3.17713e-17
C315	B#3	VNB	4.55808e-17
C316	a_27_74##2	VNB	2.33765e-17
C317	Y	Y#3	9.51318e-18
C318	Y#6	B	2.82701e-17
C319	a_225_74#	Y#3	1.89324e-18
C320	VPWR	VPWR#5	2.73754e-17
C321	Y	B#10	2.55992e-17
C322	VPWR	VPWR#3	2.22339e-17
C323	A_N#1	a_27_74##3	2.93711e-18
C324	VPWR	VPWR#2	2.88723e-17
C325	a_27_74##8	Y	5.43344e-19
C326	VGND#3	C#3	7.28819e-20
C327	VPWR	Y#3	5.77217e-18
C328	VPWR	Y#2	3.17609e-18
C329	C#3	D#3	1.77414e-17
C330	VGND#3	B#4	1.54164e-20
C331	A_N	a_27_74##9	3.9756e-17
C332	a_490_74##2	Y#3	3.64643e-19
C333	VPWR	C#9	1.244e-18
C334	Y	a_719_123##3	1.53907e-17
C335	B	Y#4	1.53253e-17
C336	Y	a_225_74#	4.63827e-17
C337	Y	a_490_74##2	9.78853e-19
C338	VPWR	B#10	2.09338e-18
C339	a_225_74##2	Y	1.55989e-17
C340	VPWR	a_27_74##8	4.0144e-18
C341	D	D#4	4.99333e-18
C342	VGND	a_719_123##2	4.48967e-18
C343	D	D#6	7.42956e-19
C344	VGND	Y#3	1.73601e-18
C345	A_N	a_27_74##10	1.39854e-17
C346	D	C#4	8.60264e-19
C347	VGND	C#9	1.27709e-18
C348	C#9	a_719_123##3	2.21166e-17
C349	C	D#6	1.01977e-20
C350	VGND	B#10	1.93209e-18
C351	A_N#2	a_27_74##3	1.5689e-17
C352	C	C#4	2.58363e-18
C353	VGND	a_27_74##8	1.041e-17
C354	C	C#6	1.45306e-18
C355	VPWR	VPWR#1	3.86553e-17
C356	VGND	a_719_123#	1.43793e-17
C357	VPWR	Y#1	1.71691e-17
C358	Y	D#1	2.15603e-19
C359	C	B#1	9.02354e-19
C360	VPWR	VPWR#8	2.09159e-17
C361	VPWR#5	VNB	3.2551e-17
C362	VGND	a_719_123##4	1.09306e-17
C363	VPWR#3	VNB	2.56827e-17
C364	Y	D#5	1.45359e-19
C365	VPWR	Y#5	1.5835e-17
C366	VGND	a_490_74#	3.01085e-17
C367	VPWR#2	VNB	3.68814e-17
C368	VGND	a_719_123##3	8.04354e-18
C369	VPWR	VPWR#9	2.14779e-17
C370	Y	C#1	3.60866e-19
C371	a_719_123##2	VNB	1.96949e-18
C372	VGND	a_225_74#	8.30887e-18
C373	VPWR	Y#7	1.74251e-17
C374	Y	C#5	1.59376e-18
C375	VGND	a_490_74##2	2.51259e-17
C376	Y#3	VNB	7.34276e-20
C377	VPWR	VPWR#10	3.56623e-17
C378	VGND	a_225_74##2	2.34051e-17
C379	Y	B#5	1.63398e-17
C380	VPWR	Y#4	1.59128e-17
C381	VGND	Y#6	7.72687e-18
C382	VGND	a_225_74##4	1.91088e-17
C383	VPWR	VPWR#11	2.04111e-17
C384	C#9	VNB	1.36411e-18
C385	VGND	VGND#7	1.63209e-17
C386	VPWR	a_27_74##10	1.5601e-17
C387	VGND	a_27_74##9	1.61875e-17
C388	B	a_27_74##4	2.23744e-18
C389	B#10	VNB	4.62046e-18
C390	a_27_74##8	VNB	1.55045e-17
C391	B	a_27_74##6	3.61097e-19
C392	D	D#3	1.37156e-17
C393	a_719_123#	VNB	4.34241e-17
C394	B	A_N#1	2.14486e-19
C395	D	C#3	1.34084e-17
C396	VGND#6	VNB	3.20218e-18
C397	a_719_123##4	VNB	4.85579e-18
C398	a_490_74#	VNB	1.23673e-17
C399	a_719_123##3	VNB	4.61496e-18
C400	VGND	Y#4	1.23458e-18
C401	C	D#3	4.82705e-19
C402	a_225_74#	VNB	5.33028e-18
C403	a_490_74##2	VNB	6.57913e-18
C404	Y	C#6	3.89798e-19
C405	VGND	a_27_74##10	2.94582e-18
C406	a_225_74##2	VNB	3.05069e-18
C407	C	C#3	2.14419e-17
C408	Y#6	VNB	1.31472e-18
C409	VGND	D#1	4.52143e-18
C410	Y	B#1	1.01382e-18
C411	a_225_74##4	VNB	6.66236e-18
C412	VGND	D#5	4.1104e-18
C413	VGND#7	VNB	3.89732e-18
C414	Y	B#6	8.93671e-19
C415	VGND	C#1	5.18916e-18
C416	VPWR	D#4	1.83853e-18
C417	a_27_74##9	VNB	3.92419e-17
C418	VPWR#1	VNB	7.45993e-17
C419	Y	a_27_74##4	8.08181e-20
C420	VPWR	D#6	1.36848e-19
C421	Y#1	VNB	2.20229e-18
C422	VGND	B#5	2.90396e-18
C423	VPWR#8	VNB	3.92974e-18
C424	VPWR	C#4	2.37238e-19
C425	VGND	B#7	3.36309e-19
C426	Y#5	VNB	2.1429e-18
C427	VPWR	C#6	2.32951e-19
C428	VPWR#9	VNB	3.95869e-18
C429	VGND	a_27_74#	9.07772e-19
C430	B	B#4	5.6235e-18
C431	Y#7	VNB	2.31651e-18
C432	VGND	a_27_74##5	1.40183e-18
C433	VPWR	B#1	9.1385e-19
C434	VPWR#10	VNB	4.40053e-18
C435	VGND	A_N#3	1.54585e-18
C436	B	a_27_74##3	4.96508e-20
C437	Y#4	VNB	2.42576e-18
C438	VPWR	B#6	2.19506e-20
C439	VPWR#11	VNB	4.94379e-18
C440	a_27_74##10	VNB	5.54028e-17
C441	D#1	VNB	3.63164e-17
C442	VPWR	a_27_74##6	2.98305e-18
C443	D#5	VNB	2.70688e-17
C444	C#1	VNB	2.79516e-17
C445	VPWR	A_N#1	7.42754e-18
C446	Y	D#3	1.80245e-19
C447	C#5	VNB	3.14856e-17
C448	B#5	VNB	3.79231e-17
C449	Y	C#3	4.24395e-18
C450	VPWR#2	VPWR#1	8.72682e-19
C451	A_N	A_N#2	1.84192e-17
C452	B#7	VNB	2.89797e-17
C453	VPWR	VPWR#4	8.18424e-18
C454	a_27_74#	VNB	3.01483e-17
C455	Y	B#4	1.34879e-18
C456	a_27_74##5	VNB	3.21171e-17
C457	A_N#3	VNB	3.10959e-17
C458	Y	a_27_74##3	3.83145e-20
C459	VPWR	D#3	6.96016e-19
C460	D#4	VNB	3.96041e-17
C461	Y	A_N#2	1.04074e-19
C462	D#6	VNB	3.46645e-17
C463	C#4	VNB	3.65827e-17
C464	C	D	2.98478e-17
C465	C#6	VNB	3.17031e-17
C466	B#1	VNB	3.76229e-17
C467	VGND	VGND#3	3.92885e-17
C468	B#6	VNB	3.3921e-17
C469	VGND	D#3	7.23345e-19
C470	VPWR	A_N#2	2.98947e-18
C471	a_27_74##4	VNB	3.25706e-17
C472	VGND	C#3	7.33266e-19
C473	a_27_74##6	VNB	3.68151e-17
C474	A_N#1	VNB	4.82992e-17
C475	VPWR#4	VNB	2.45365e-16
C476	VGND	A_N#2	3.51427e-18
C477	VGND#3	VNB	3.00357e-16
C478	D#3	VNB	2.96187e-17
C479	C#3	VNB	6.78109e-17
C480	B#4	VNB	2.29763e-17
C481	Y	C	3.21307e-17
C482	a_27_74##3	VNB	3.08367e-17
C483	VPWR	D	6.84191e-18
C484	A_N#2	VNB	8.14259e-17
C485	VPWR	C	3.02564e-18
C486	VGND	D	6.63105e-18
C487	VPWR	B	1.81902e-18
C488	VGND	C	4.41493e-18
C489	VPWR	A_N	8.03763e-18
C490	VGND	B	1.91262e-18
C491	Y#1	VPWR#2	1.55085e-17
C492	D	VNB	3.2907e-17
C493	VGND	A_N	3.54308e-18
C494	C	VNB	4.39213e-18
C495	B	VNB	1.42807e-18
C496	VGND	Y	6.47365e-18
C497	A_N	VNB	3.2964e-17
C498	Y	VNB	2.94047e-18
C499	VPWR	VNB	6.74509e-17
C500	VGND	VNB	9.42864e-17
C501	VGND#2	VNB	6.5965e-17
C502	VGND#4	a_27_74##9	1.78949e-17
C503	VGND#4	A_N#2	6.99056e-19
C504	VGND#2	C#1	3.90335e-18
C505	a_27_74##8	VPWR#6	3.27464e-19
C506	VGND#4	VNB	7.04729e-17
C507	Y#4	VPWR#6	7.60796e-18
C508	VGND#4	a_27_74##5	5.35671e-18
C509	VPWR#6	A_N#2	2.51765e-18
C510	VPWR	VPWR#6	5.14217e-17
C511	VGND#4	a_27_74##8	2.77373e-18
C512	VGND#2	B#5	1.70676e-19
C513	VGND#3	VGND#2	7.80762e-17
C514	VGND	VGND#2	6.33387e-17
C515	VGND#2	D#5	8.7661e-19
C516	VGND#2	a_490_74#	3.31487e-17
C517	VGND#4	a_27_74##3	9.01167e-20
C518	VGND#4	a_27_74##2	2.91248e-20
C519	VPWR#6	VPWR#5	1.35777e-18
C520	VGND#2	a_719_123#	1.53091e-17
C521	VPWR#6	A_N#1	9.51067e-18
C522	VGND	VGND#4	5.17227e-17
C523	VGND#4	a_225_74##2	5.29435e-18
C524	VPWR#6	a_27_74##3	3.34362e-20
C525	a_27_74##10	VPWR#6	1.39116e-17
C526	VGND#2	C#3	3.59623e-20
C527	VGND#2	C#5	2.45476e-18
C528	VPWR#6	a_27_74##6	4.35193e-18
C529	VGND#2	a_719_123##2	1.04253e-18
C530	VGND#2	D#1	1.65009e-18
C531	VGND#2	a_719_123##4	9.69827e-18
C532	VPWR#6	VNB	6.71084e-17
C533	VGND#4	a_225_74##4	2.85081e-17
C534	VGND#4	A_N#3	1.2305e-18
C535	VPWR#4	VPWR#6	7.11264e-17
C536	VGND#3	VGND#4	7.7713e-17
*
*
.ENDS sky130_fd_sc_hs__nand4b_2
*
