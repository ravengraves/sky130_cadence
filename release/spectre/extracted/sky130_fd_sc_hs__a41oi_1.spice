* Extracted by Quantus, converted by sky130cad/quantus.py
*
*
*
*                       LINUX           Wed Nov 18 08:15:32 2026
*
*
*
*  PROGRAM  advgen
*
*  Name           : advgen - Quantus - (64-bit)
*  Version        : 25.1.0-p047
*  Build Date     : Thu Dec 11 23:20:30 PST 2025
*
*  HSPICE LIBRARY
*
*  OPERATING_TEMPERATURE 150
*  QRC_TECH_DIR <path>/tech
*
*
*

*
.SUBCKT sky130_fd_sc_hs__a41oi_1 VPB VNB VGND VPWR Y B1 A1 A4 A3 A2
*
*
*  caps2d version: 10
*
*
*       TRANSISTOR CARDS
*
*
XM8 Y#3 B1#4 VGND#4 VNB sky130_fd_pr__nfet_01v8_lvt l=0.15 w=0.74 ad=0.2109 as=0.4921 pd=2.05 ps=2.81
XM9 VGND#4 A4#1 a_277_74# VNB sky130_fd_pr__nfet_01v8_lvt l=0.15 w=0.74 ad=0.4921 as=0.1776 pd=2.81 ps=1.96
XM7 a_277_74# A3#3 a_355_74# VNB sky130_fd_pr__nfet_01v8_lvt l=0.15 w=0.74 ad=0.1776 as=0.3108 pd=1.96 ps=2.32
XM3 a_355_74# A2#3 a_469_74# VNB sky130_fd_pr__nfet_01v8_lvt l=0.15 w=0.74 ad=0.3108 as=0.3108 pd=2.32 ps=2.32
XM6 a_469_74# A1#3 Y#1 VNB sky130_fd_pr__nfet_01v8_lvt l=0.15 w=0.74 ad=0.3108 as=0.2109 pd=2.32 ps=2.05
XM0 Y#4 B1#1 a_116_368##4 VPB sky130_fd_pr__pfet_01v8 l=0.15 w=1.12 ad=0.3304 as=0.392 pd=2.83 ps=2.94
XM4 a_116_368##4 A4#3 VPWR#6 VPB sky130_fd_pr__pfet_01v8 l=0.15 w=1.12 ad=0.392 as=0.7728 pd=2.94 ps=3.62
XM1 VPWR#6 A3#1 a_116_368##2 VPB sky130_fd_pr__pfet_01v8 l=0.15 w=1.12 ad=0.7728 as=0.336 pd=3.62 ps=2.84
XM5 a_116_368##2 A2#1 VPWR#5 VPB sky130_fd_pr__pfet_01v8 l=0.15 w=1.12 ad=0.336 as=0.4592 pd=2.84 ps=3.06
XM2 VPWR#5 A1#4 a_116_368# VPB sky130_fd_pr__pfet_01v8 l=0.15 w=1.12 ad=0.4592 as=0.3304 pd=3.06 ps=2.83
*
*
*       RESISTOR AND CAP/DIODE CARDS
*
Rg1	B1#1	B1#2	471.862823
Rg2	B1#2	B1#3	28.628225
Rg3	B1#2	B1#4	368.862610
Rg4	A4#1	A4#2	409.393127
Rg5	A4#2	A4#3	451.603058
Rg6	A3#1	A3#2	434.639221
Rg7	A3#2	A3#3	382.539734
Rg8	A2#1	A2#2	434.639221
Rg9	A2#2	A2#3	382.539734
Rg10	A1#1	A1#2	28.644930
Rg11	A1#2	A1#3	368.862610
Rg12	A1#2	A1#4	471.862823
Rf1	B1	B1#3	168.106262
Rf2	A4#2	A4	166.137894
Rf3	A3#4	A3#2	161.913620
Rf4	A3	A3#6	1.680815
Rf5	A3#4	A3#6	5.034561
Rf6	A2#2	A2#5	162.008423
Rf7	A2#6	A2	1.775621
Rf8	A2#5	A2#6	8.556877
Rf9	Y#1	Y#2	183.147339
Rf10	Y#2	Y#3	45.157154
Rf11	Y#2	Y	9.155093
Rf12	Y	Y#4	81.516785
Rf13	a_116_368#	a_116_368##3	50.295948
Rf14	a_116_368##3	a_116_368##4	80.782104
Rf15	a_116_368##2	a_116_368##3	15.000000
Rf16	A1	A1#1	168.106262
Rf18	VPWR#2	VPWR#3	66.117004
Rf20	VPWR#2	VPWR#5	38.744106
Rf21	VPWR#3	VPWR#6	19.672245
Rf22	VGND#1	VGND#2	54.243668
Rf24	VGND#2	VGND#4	16.383686
Re1	VPWR#3	VPWR	1.403190
Re2	VGND	VGND#1	1.403242
*
*       CAPACITOR CARDS
*
*
C1	VGND#1	A1#2	3.74753e-19
C2	A1#1	A1#2	1.41423e-17
C3	A2#2	A1#2	2.88728e-17
C4	Y#1	A1#2	6.77874e-18
C5	Y#2	A3#4	2.64602e-17
C6	Y#2	VGND#4	2.67341e-18
C7	Y#1	A3#4	1.00057e-17
C8	Y#2	a_116_368##2	1.33896e-18
C9	Y#2	a_116_368##4	4.6059e-18
C10	Y#2	Y#4	6.63824e-19
C11	A1#2	a_116_368#	5.1304e-18
C12	Y#2	A1#3	2.23524e-20
C13	Y#1	a_116_368#	3.02096e-18
C14	Y#2	A2#3	3.21132e-20
C15	Y#2	A3#3	2.60367e-17
C16	Y#1	a_116_368##2	6.24462e-18
C17	Y#2	A4#1	2.32448e-17
C18	Y#2	B1#4	1.47529e-17
C19	Y#1	A1#3	5.70471e-17
C20	a_116_368#	VPWR#5	6.60254e-17
C21	A2	A1#2	8.68289e-18
C22	Y#1	A2#3	3.39643e-17
C23	a_116_368##2	VPWR#5	2.64295e-17
C24	Y#1	A3#3	1.7877e-18
C25	a_116_368##4	a_116_368#	2.04565e-18
C26	Y#3	Y#4	1.12704e-18
C27	Y#1	A4#1	1.36053e-18
C28	a_116_368##2	VPWR#6	9.1978e-19
C29	Y#4	VPWR#5	1.86037e-20
C30	Y#3	A2#3	4.83633e-19
C31	a_116_368##4	VPWR#6	8.06373e-18
C32	Y#3	A3#3	6.78739e-19
C33	A4#1	VGND#4	2.22439e-17
C34	Y#3	A4#1	2.89078e-18
C35	B1#4	VGND#4	1.39604e-17
C36	Y#4	a_116_368##4	1.06062e-16
C37	Y#3	B1#4	3.45574e-17
C38	VGND#1	Y#2	3.59769e-18
C39	A1	A1#2	1.0857e-17
C40	A2#3	A1#3	2.55182e-17
C41	a_116_368#	A1#4	6.52511e-17
C42	A1#4	VPWR#5	3.19143e-17
C43	a_116_368#	A2#1	2.15791e-18
C44	A3#3	A2#3	2.66797e-17
C45	A2#1	VPWR#5	3.65272e-17
C46	a_116_368#	A3#1	4.33907e-19
C47	a_116_368##2	A2#1	5.84758e-17
C48	VPWR#5	A3#1	2.86169e-18
C49	a_116_368##4	A1#4	3.51896e-19
C50	a_116_368#	A4#3	1.25439e-19
C51	Y#2	A3#2	8.04992e-19
C52	A4#1	A3#3	5.35651e-17
C53	a_116_368##2	A3#1	5.7137e-17
C54	Y#4	A1#4	3.92011e-19
C55	a_116_368##4	A2#1	5.19638e-19
C56	VGND#1	Y#1	3.05144e-17
C57	A3#1	VPWR#6	3.01706e-17
C58	Y#2	A4#2	6.35231e-18
C59	Y#4	A2#1	3.11052e-19
C60	A3#4	A2#2	1.88488e-17
C61	a_116_368##4	A3#1	3.02637e-18
C62	B1#4	A4#1	9.27611e-18
C63	A4#3	VPWR#6	9.7008e-18
C64	A1#1	Y#1	3.09746e-17
C65	Y#4	A3#1	1.26825e-18
C66	A2#3	A1#2	8.63616e-19
C67	a_116_368##4	A4#3	6.54055e-17
C68	Y#2	B1#3	1.75711e-19
C69	A3#4	A3#2	1.11588e-17
C70	Y#1	A2#2	2.80408e-17
C71	Y#4	A4#3	9.4188e-18
C72	B1#1	a_116_368##4	2.68872e-17
C73	A3#4	A4#2	3.79039e-18
C74	Y#4	B1#1	6.06039e-17
C75	Y	A1#2	2.77809e-19
C76	Y#1	A3#2	1.96049e-18
C77	A2#1	A1#4	2.98468e-17
C78	A2#2	VPWR#5	1.15368e-18
C79	A2#2	a_116_368##2	3.52176e-17
C80	VGND#1	A1#3	5.47099e-18
C81	A3#1	A2#1	4.92724e-17
C82	VGND#1	A2#3	8.40981e-18
C83	a_116_368##2	A3#2	1.87616e-18
C84	Y#2	a_355_74#	9.91923e-19
C85	VGND#1	A3#3	8.40981e-18
C86	A3#2	VPWR#6	4.56849e-19
C87	B1#3	Y#3	4.08798e-17
C88	A4#3	A3#1	1.12357e-17
C89	A4#2	VPWR#6	6.57862e-19
C90	Y#2	a_277_74#	3.08046e-18
C91	a_116_368##4	A4#2	6.73877e-18
C92	Y#1	a_469_74#	5.60258e-18
C93	B1#1	A4#3	3.78721e-17
C94	B1#3	Y#4	5.1304e-18
C95	Y#1	a_355_74#	4.59161e-18
C96	VGND	A1#2	1.0726e-18
C97	A2#2	A1#4	7.31026e-19
C98	A2#2	A2#1	2.04157e-18
C99	B1#3	A4#1	2.81538e-19
C100	A2#2	A3#1	5.99799e-19
C101	Y#1	A2	1.88287e-17
C102	Y#2	A4	2.86362e-17
C103	A1#3	a_469_74#	2.26015e-17
C104	A2#3	a_469_74#	2.23148e-17
C105	VGND#1	A1#1	6.32879e-19
C106	A2	a_116_368#	2.46793e-17
C107	A4	A3#4	1.59421e-17
C108	B1#1	A4#2	8.59356e-19
C109	A1#2	VNB	5.99841e-17
C110	A2#3	a_355_74#	2.19981e-17
C111	VGND#1	A2#2	2.30485e-19
C112	A2	a_116_368##2	7.21974e-18
C113	A3#3	a_355_74#	2.19981e-17
C114	A1#1	A2#2	4.95216e-19
C115	VGND#1	A3#2	2.26346e-19
C116	A3#3	a_277_74#	1.65187e-17
C117	A3	a_116_368##2	4.93274e-17
C118	A4#1	a_277_74#	1.65187e-17
C119	A3#2	A2#2	2.95606e-17
C120	A1#1	A4#2	3.8943e-19
C121	A4#2	A3#2	2.60191e-17
C122	A4	a_116_368##4	3.36674e-17
C123	A1	a_116_368#	2.89867e-17
C124	Y#4	A4	2.35764e-18
C125	A2	A1#4	2.24051e-18
C126	B1#3	A4#2	1.82837e-17
C127	A3	A2#1	5.84057e-19
C128	A3	A3#1	2.03387e-18
C129	A3	A4#3	1.73323e-19
C130	B1	Y#4	3.15576e-17
C131	A4	A3#1	4.00447e-19
C132	A4	A4#3	1.68519e-18
C133	A1	A1#4	2.52292e-18
C134	A2	A1#1	1.69363e-17
C135	A4	B1#1	1.78552e-19
C136	VGND	Y#2	1.40848e-17
C137	A2	A2#2	6.33562e-18
C138	VPWR	a_116_368#	1.78292e-17
C139	Y	A2#3	4.44644e-20
C140	VGND	A3#4	2.9468e-18
C141	A3	A2#2	1.37822e-17
C142	Y	A3#3	7.46555e-20
C143	VPWR	a_116_368##2	9.59821e-18
C144	Y	A4#1	2.85872e-19
C145	A3	A3#2	5.97078e-18
C146	VGND	Y#1	2.72203e-17
C147	VPWR	a_116_368##4	1.89354e-17
C148	B1	A4#3	1.54755e-19
C149	VPWR	Y#4	2.01599e-17
C150	A3	A4#2	1.95438e-18
C151	B1	B1#1	2.8576e-18
C152	A4	A3#2	3.45799e-18
C153	Y#2	VNB	4.39247e-18
C154	VGND	Y#3	1.57123e-17
C155	A4	A4#2	2.00797e-17
C156	A1	A2#2	4.6127e-19
C157	Y	A4#3	1.09902e-18
C158	A4	B1#3	1.00977e-18
C159	A3#4	VNB	1.69917e-18
C160	Y	B1#1	1.82243e-18
C161	Y#2	A1#2	1.5966e-20
C162	VPWR	A1#4	8.74174e-19
C163	Y#1	VNB	4.68099e-17
C164	VGND	A1#3	1.03272e-18
C165	VPWR	A2#1	9.88045e-19
C166	VGND	A2#3	1.30478e-18
C167	VPWR	A3#1	4.06179e-19
C168	VGND	A3#3	1.23036e-18
C169	VGND	A4#1	5.00033e-19
C170	Y#3	VNB	4.04837e-17
C171	B1	A4#2	4.48234e-19
C172	VPWR	B1#1	1.18572e-18
C173	VGND	B1#4	8.42763e-19
C174	a_116_368#	VNB	5.1031e-17
C175	VPWR#5	VNB	1.6905e-18
C176	Y	A2#2	1.45744e-19
C177	B1	B1#3	1.15251e-17
C178	Y	A3#2	5.22588e-19
C179	a_116_368##4	VNB	2.70163e-18
C180	Y#4	VNB	5.00167e-17
C181	Y	A4#2	7.53006e-18
C182	A1#3	VNB	3.32145e-17
C183	A2#3	VNB	2.82257e-17
C184	B1#3	Y	2.87222e-17
C185	VPWR	A2#2	1.91008e-18
C186	A3#3	VNB	2.77374e-17
C187	A4#1	VNB	2.67772e-17
C188	B1#4	VNB	3.90705e-17
C189	A4	A3	1.27995e-17
C190	VGND	VGND#1	5.63397e-17
C191	A2	A1	2.22332e-17
C192	A1#4	VNB	4.17966e-17
C193	A2#1	VNB	3.11735e-17
C194	VGND	A1#1	4.20367e-18
C195	A3#1	VNB	2.92339e-17
C196	VGND	A2#2	1.88217e-18
C197	A4#3	VNB	3.33843e-17
C198	VGND	A3#2	5.71353e-21
C199	B1#1	VNB	4.50787e-17
C200	VGND	B1#3	4.83737e-18
C201	VGND#1	VNB	2.29147e-16
C202	A1#1	VNB	9.3392e-18
C203	A2#2	VNB	3.82842e-17
C204	A3#2	VNB	3.41381e-17
C205	VPWR	A2	1.85468e-18
C206	A4#2	VNB	4.7153e-17
C207	Y	A4	3.68816e-17
C208	B1#3	VNB	7.36784e-17
C209	VPWR	A3	2.84291e-18
C210	VPWR	A4	2.32135e-18
C211	VGND	A2	1.94693e-18
C212	B1	Y	2.05613e-17
C213	VPWR	A1	3.77091e-18
C214	VGND	A4	2.54575e-18
C215	VPWR	B1	3.77091e-18
C216	A2	VNB	2.16412e-18
C217	A3	VNB	2.8689e-18
C218	A4	VNB	5.95775e-18
C219	A1	VNB	1.36835e-17
C220	B1	VNB	1.31419e-17
C221	Y	VNB	8.38027e-18
C222	VPWR	VNB	5.66481e-17
C223	VGND	VNB	5.39911e-17
C224	a_116_368##4	VPWR#3	9.19807e-17
C225	VPWR#3	A1#4	2.31872e-18
C226	VGND#2	Y#1	5.27425e-18
C227	VGND#2	VNB	5.83317e-17
C228	VPWR	VPWR#3	9.50584e-17
C229	VPWR#3	A4#3	1.8287e-17
C230	VPWR#2	A2#1	8.84036e-18
C231	VPWR#3	A4#2	7.73483e-19
C232	A1	VPWR#2	4.94776e-19
C233	VGND#2	A3#3	4.37978e-18
C234	VGND#2	VGND#4	1.00199e-17
C235	VPWR	VPWR#2	5.95883e-17
C236	a_116_368##2	VPWR#3	3.46929e-17
C237	a_116_368##2	VPWR#2	1.56682e-18
C238	B1	VPWR#3	4.9518e-19
C239	VGND#2	Y#2	4.49092e-17
C240	Y#4	VPWR#3	2.37678e-17
C241	VPWR#3	A2#1	4.8936e-18
C242	VGND#1	VGND#2	6.21612e-17
C243	VGND#2	A4#1	3.04492e-17
C244	VPWR#2	A3#1	9.87077e-19
C245	VGND#2	Y#3	5.35518e-17
C246	VPWR#3	B1#1	7.19355e-18
C247	VPWR#3	B1#3	4.0583e-19
C248	VGND#2	A1#3	1.30801e-18
C249	a_116_368#	VPWR#2	2.102e-17
C250	VPWR#3	VPWR#6	1.19364e-17
C251	VPWR#2	A1#2	4.05221e-19
C252	VGND#2	A4#2	1.65141e-18
C253	VPWR#3	A3#1	3.41356e-17
C254	VGND#2	B1#4	2.18416e-17
C255	VGND	VGND#2	7.34773e-17
C256	VPWR#3	A3#2	5.78807e-19
C257	VPWR#2	A1#4	6.74663e-18
C258	VPWR#3	VNB	2.33584e-16
C259	VPWR#3	VPWR#5	1.61553e-17
C260	VGND#2	A2#3	2.2791e-18
C261	VPWR#3	VPWR#2	5.64141e-17
C262	VPWR#2	VNB	5.13672e-17
C263	VGND#2	B1#3	8.41602e-19
*
*
.ENDS sky130_fd_sc_hs__a41oi_1
*
