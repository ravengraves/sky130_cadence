* Extracted by Quantus, converted by sky130cad/quantus.py
*
*
*
*                       LINUX           Wed Nov 18 08:10:05 2026
*
*
*
*  PROGRAM  advgen
*
*  Name           : advgen - Quantus - (64-bit)
*  Version        : 25.1.0-p047
*  Build Date     : Thu Dec 11 23:20:30 PST 2025
*
*  HSPICE LIBRARY
*
*  OPERATING_TEMPERATURE 150
*  QRC_TECH_DIR <path>/tech
*
*
*

*
.SUBCKT sky130_fd_sc_hs__a2bb2o_1 VPB VNB VGND VPWR X B1 A1_N A2_N B2
*
*
*  caps2d version: 10
*
*
*       TRANSISTOR CARDS
*
*
XM10 X#1 a_93_264# VGND#9 VNB sky130_fd_pr__nfet_01v8_lvt l=0.15 w=0.74 ad=0.1961 as=0.23735 pd=2.01 ps=2.16
XM2 VGND#9 A1_N#3 a_257_126##6 VNB sky130_fd_pr__nfet_01v8_lvt l=0.15 w=0.55 ad=0.23735 as=0.154 pd=2.16 ps=1.66
XM6 a_257_126##6 A2_N#1 VGND#8 VNB sky130_fd_pr__nfet_01v8_lvt l=0.15 w=0.55 ad=0.154 as=0.424 pd=1.66 ps=2.74
XM5 VGND#8 a_257_126##3 a_93_264##4 VNB sky130_fd_pr__nfet_01v8_lvt l=0.15 w=0.64 ad=0.424 as=0.1792 pd=2.74 ps=1.84
XM11 a_93_264##4 B2#3 a_605_126# VNB sky130_fd_pr__nfet_01v8_lvt l=0.15 w=0.64 ad=0.1792 as=0.2496 pd=1.84 ps=2.06
XM9 a_605_126# B1#2 VGND#7 VNB sky130_fd_pr__nfet_01v8_lvt l=0.15 w=0.64 ad=0.2496 as=0.1696 pd=2.06 ps=1.81
XM4 X#2 a_93_264##3 VPWR#7 VPB sky130_fd_pr__pfet_01v8 l=0.15 w=1.12 ad=0.308 as=0.398 pd=2.79 ps=2.97
XM3 VPWR#7 A1_N#1 a_258_392# VPB sky130_fd_pr__pfet_01v8 l=0.15 w=1 ad=0.398 as=0.24 pd=2.97 ps=2.48
XM7 a_258_392# A2_N#3 a_257_126##8 VPB sky130_fd_pr__pfet_01v8 l=0.15 w=1 ad=0.24 as=0.275 pd=2.48 ps=2.55
XM0 a_93_264##7 a_257_126# a_530_392##2 VPB sky130_fd_pr__pfet_01v8 l=0.15 w=1 ad=0.275 as=0.3 pd=2.55 ps=2.6
XM1 a_530_392##2 B2#1 VPWR#6 VPB sky130_fd_pr__pfet_01v8 l=0.15 w=1 ad=0.3 as=0.33 pd=2.6 ps=2.66
XM8 VPWR#6 B1#3 a_530_392# VPB sky130_fd_pr__pfet_01v8 l=0.15 w=1 ad=0.33 as=0.275 pd=2.66 ps=2.55
*
*
*       RESISTOR AND CAP/DIODE CARDS
*
Rg1	a_93_264#	a_93_264##2	325.153534
Rg2	a_93_264##2	a_93_264##3	447.963806
Rg3	A1_N#1	A1_N#2	487.557587
Rg4	A1_N#2	A1_N#3	265.839417
Rg5	A2_N#1	A2_N#2	253.420792
Rg6	A2_N#2	A2_N#3	497.252655
Rg7	a_257_126#	a_257_126##2	409.090576
Rg8	a_257_126##2	a_257_126##3	319.414948
Rg9	a_257_126##3	a_257_126##4	279.244598
Rg10	B2#1	B2#2	409.090576
Rg11	B2#2	B2#3	319.414948
Rg12	B1#1	B1#2	307.798767
Rg13	B1#2	B1#3	796.488403
Rf1	X#1	X	83.397896
Rf2	X	X#3	11.031110
Rf3	X#3	X	0.151111
Rf4	X#2	X#3	5.000000
Rf5	A1_N#2	A1_N	167.983414
Rf6	A2_N#2	A2_N	167.020599
Rf7	a_257_126##4	a_257_126##6	237.437653
Rf8	a_257_126##2	a_257_126##8	251.074127
Rf9	a_93_264##4	a_93_264##5	155.110840
Rf10	a_93_264##5	a_93_264##2	228.263519
Rf11	a_93_264##5	a_93_264##7	162.662247
Rf12	B2#2	B2#5	161.138672
Rf13	B2#6	B2	0.905865
Rf14	B2#5	B2#6	3.149382
Rf15	a_530_392#	a_530_392##2	123.544014
Rf16	B1#4	B1	1.879015
Rf17	B1#1	B1#6	162.111816
Rf18	B1#4	B1#6	1.581070
Rf19	B1#7	B1	1.879015
Rf20	B1#6	B1#7	13.597200
Rf22	VPWR#2	VPWR#3	80.680389
Rf23	VPWR#3	VPWR#4	90.192833
Rf25	VPWR#2	VPWR#6	29.622076
Rf26	VPWR#4	VPWR#7	35.274624
Rf28	VGND#2	VGND#3	27.955275
Rf29	VGND#3	VGND#4	50.502884
Rf30	VGND#4	VGND#5	89.462326
Rf32	VGND#2	VGND#7	100.153412
Rf33	VGND#3	VGND#8	107.915802
Rf34	VGND#5	VGND#9	33.896767
Re1	VPWR#3	VPWR	1.091357
Re2	VGND	VGND#4	1.091398
*
*       CAPACITOR CARDS
*
*
C1	VGND#3	VGND#8	1.77545e-18
C2	VGND#9	VGND#3	2.49558e-20
C3	B1#7	VGND#7	8.50895e-18
C4	B1#4	VGND#7	2.25991e-17
C5	a_93_264##4	B2#5	7.90485e-18
C6	B1#7	a_530_392#	1.83254e-18
C7	VGND#8	B2#5	1.5681e-18
C8	VGND#8	a_93_264##5	1.76793e-18
C9	a_257_126##6	a_93_264##5	5.89013e-18
C10	VGND#9	a_93_264##5	6.43827e-19
C11	VGND#3	B2#3	7.93129e-18
C12	a_93_264##4	VGND#7	7.73833e-18
C13	B2#5	a_530_392##2	2.46252e-17
C14	VGND#8	VGND#7	2.19119e-17
C15	a_257_126##6	VGND#7	1.66094e-18
C16	a_93_264##4	VGND#8	8.39582e-17
C17	a_93_264##5	a_93_264##7	3.51168e-18
C18	a_93_264##5	a_257_126##8	1.04009e-16
C19	a_257_126##6	VGND#8	3.08976e-17
C20	VGND#7	a_530_392#	1.55841e-17
C21	B1#4	B1#2	3.7631e-18
C22	X#1	a_93_264##4	3.829e-18
C23	B1#4	B2#3	6.25751e-19
C24	a_93_264##5	VPWR#7	5.09979e-17
C25	VGND#9	a_257_126##6	6.3033e-17
C26	VGND#7	a_530_392##2	6.25468e-19
C27	X#1	VGND#9	5.19514e-17
C28	a_93_264##4	a_530_392##2	5.33787e-18
C29	a_93_264##4	a_257_126##8	5.78733e-19
C30	a_530_392#	VPWR#6	7.10564e-17
C31	a_530_392##2	a_530_392#	2.04794e-18
C32	VGND#7	B1#2	4.07937e-17
C33	a_530_392##2	VPWR#6	6.83345e-17
C34	VGND#7	B2#3	1.22015e-17
C35	a_93_264##4	B1#2	3.62959e-18
C36	a_93_264##7	VPWR#6	3.95285e-18
C37	VGND#7	a_257_126##3	2.74878e-18
C38	VGND#8	B1#2	9.10244e-19
C39	a_93_264##7	a_530_392##2	3.97936e-17
C40	a_93_264##4	B2#3	2.06533e-17
C41	a_257_126##6	B1#2	2.21663e-19
C42	VGND#7	A2_N#1	1.00724e-18
C43	VGND#8	B2#3	9.54117e-18
C44	a_257_126##8	a_530_392##2	2.34185e-17
C45	a_93_264##4	a_257_126##3	3.3445e-17
C46	a_257_126##6	B2#3	3.72418e-19
C47	a_93_264##7	a_257_126##8	9.08734e-17
C48	VGND#8	a_257_126##3	3.60615e-17
C49	a_93_264##4	A2_N#1	4.42073e-18
C50	a_257_126##6	a_257_126##3	1.40805e-18
C51	A2_N#1	VGND#8	1.41394e-17
C52	VGND#4	VGND#3	2.15511e-17
C53	a_93_264##4	A1_N#3	6.61329e-19
C54	VPWR#7	a_93_264##7	1.64382e-17
C55	a_93_264##5	a_257_126#	1.46398e-18
C56	a_257_126##6	A2_N#1	3.6231e-17
C57	X#1	a_257_126##3	2.87375e-19
C58	a_93_264##4	a_93_264#	7.60432e-19
C59	VGND#9	A2_N#1	9.3403e-19
C60	A1_N#3	a_257_126##6	2.58353e-17
C61	VGND#3	B1#1	1.54678e-18
C62	a_93_264##5	A2_N#3	2.89012e-17
C63	X#1	A2_N#1	8.81648e-19
C64	A1_N#3	VGND#9	1.4716e-17
C65	a_257_126##6	a_93_264#	2.27377e-18
C66	a_93_264##5	A1_N#1	2.64978e-17
C67	X#1	A1_N#3	2.07341e-18
C68	VGND#9	a_93_264#	4.15618e-17
C69	X#1	a_93_264#	2.43179e-17
C70	a_93_264##5	a_93_264##3	1.58139e-18
C71	VGND#3	a_257_126##2	4.10665e-20
C72	VGND#3	a_257_126##4	4.52232e-17
C73	a_530_392#	B1#3	3.57078e-17
C74	B1#4	B1#1	7.92824e-18
C75	B2#3	B1#2	2.07445e-17
C76	VPWR#6	B1#3	4.66443e-17
C77	a_530_392#	B2#1	7.46443e-19
C78	a_530_392##2	B1#3	7.10424e-19
C79	VPWR#6	B2#1	4.52708e-17
C80	a_530_392#	a_257_126#	2.73263e-19
C81	a_257_126##3	B2#3	3.23653e-17
C82	a_530_392##2	B2#1	5.4903e-17
C83	VPWR#6	a_257_126#	2.75776e-18
C84	B2#5	B2#2	1.07813e-17
C85	a_93_264##7	B2#1	1.78148e-18
C86	a_530_392##2	a_257_126#	1.5365e-17
C87	VPWR#6	A2_N#3	1.2117e-19
C88	a_257_126##8	B2#1	7.50283e-19
C89	A2_N#1	a_257_126##3	5.57172e-18
C90	a_93_264##7	a_257_126#	5.67765e-17
C91	a_530_392##2	A2_N#3	2.83134e-19
C92	a_257_126##2	B2#5	2.72189e-17
C93	a_257_126##8	a_257_126#	1.29276e-17
C94	VPWR#6	A1_N#1	3.10283e-20
C95	a_93_264##7	A2_N#3	2.10539e-17
C96	VPWR#7	B2#1	3.75712e-20
C97	a_93_264##5	a_257_126##2	4.57659e-17
C98	A1_N#3	A2_N#1	3.03744e-17
C99	a_257_126##8	A2_N#3	4.55765e-17
C100	B1#1	VGND#7	2.59452e-17
C101	a_93_264##7	A1_N#1	4.78903e-18
C102	VPWR#7	a_257_126#	1.19838e-19
C103	a_257_126##8	A1_N#1	1.44051e-18
C104	VGND#4	a_257_126##6	2.05878e-17
C105	a_93_264#	A1_N#3	2.59891e-17
C106	VPWR#7	A2_N#3	4.2946e-18
C107	VGND#7	B2#2	4.0364e-18
C108	a_93_264##7	a_93_264##3	6.82089e-19
C109	A1_N#1	VPWR#7	2.30741e-17
C110	a_93_264##4	B2#2	1.53495e-19
C111	A2_N#2	a_93_264##5	5.08658e-17
C112	VPWR#7	a_93_264##3	5.3722e-17
C113	a_93_264##7	VPWR#3	6.85058e-17
C114	a_257_126##2	a_93_264##4	3.78149e-17
C115	a_530_392#	B1#1	9.93671e-19
C116	A1_N#2	a_93_264##5	3.47824e-17
C117	a_257_126##8	VPWR#3	6.53e-19
C118	VGND#8	a_257_126##2	5.74606e-19
C119	a_93_264##4	a_257_126##4	6.83465e-19
C120	a_93_264##2	a_93_264##5	1.4001e-18
C121	a_257_126##4	VGND#8	6.42106e-17
C122	VPWR#6	B2#2	5.6811e-19
C123	B2#1	B1#3	3.6543e-17
C124	a_530_392##2	B2#2	1.41123e-18
C125	A2_N#2	a_93_264##4	3.52089e-17
C126	VGND#9	a_257_126##4	3.10154e-19
C127	A2_N#2	VGND#8	1.16231e-17
C128	a_257_126##6	A2_N#2	2.07106e-17
C129	a_257_126##2	a_530_392##2	1.56453e-17
C130	a_257_126#	B2#1	4.32986e-17
C131	a_257_126##2	a_93_264##7	6.01088e-19
C132	VGND#4	B2#3	7.58366e-20
C133	A1_N#2	VGND#9	4.86108e-18
C134	a_93_264##7	a_257_126##4	1.67469e-19
C135	B2#3	B1#1	4.29872e-18
C136	A2_N#3	a_257_126#	5.69047e-18
C137	X#1	A1_N#2	6.50878e-19
C138	VGND#4	A2_N#1	7.25846e-19
C139	a_257_126##8	a_257_126##4	3.75086e-19
C140	B2#2	B1#2	1.65308e-17
C141	a_93_264##5	a_258_392#	2.36044e-17
C142	a_93_264##7	A2_N#2	2.54649e-19
C143	VGND#9	a_93_264##2	9.2221e-18
C144	a_257_126##8	A2_N#2	1.04007e-18
C145	a_93_264##2	X#1	4.77521e-17
C146	VGND#4	a_93_264#	3.55614e-20
C147	A1_N#1	A2_N#3	6.2799e-17
C148	a_257_126##4	B2#3	7.90822e-18
C149	a_93_264##3	A1_N#1	3.67283e-17
C150	VPWR#3	a_257_126#	5.4884e-18
C151	VPWR#7	A1_N#2	7.42662e-19
C152	VPWR#3	A2_N#3	2.54261e-18
C153	A2_N#1	a_257_126##4	2.75605e-18
C154	B2#2	B1#3	1.699e-17
C155	A2_N#2	a_257_126##3	2.58928e-18
C156	VGND#7	a_605_126#	1.25255e-17
C157	a_93_264##2	VPWR#7	2.45836e-17
C158	A2_N#2	A2_N#1	3.23389e-18
C159	a_93_264##2	X#2	1.34364e-18
C160	a_93_264#	a_257_126##4	6.069e-19
C161	a_257_126##2	B1#3	6.33269e-19
C162	A2_N#2	A1_N#3	8.35165e-19
C163	a_257_126##2	B2#1	9.66959e-19
C164	a_257_126##2	a_257_126#	4.82191e-18
C165	a_93_264##7	a_258_392#	1.75689e-18
C166	VGND#3	B2#5	1.46704e-19
C167	a_93_264#	A1_N#2	4.51364e-19
C168	A2_N#3	a_257_126##2	1.39729e-18
C169	a_257_126##2	A1_N#1	1.08986e-19
C170	VGND#7	B2	1.25226e-17
C171	a_257_126##2	VPWR#3	5.65066e-19
C172	B1#2	a_605_126#	9.17677e-18
C173	B2#3	a_605_126#	1.28933e-17
C174	a_93_264##3	A1_N#2	3.37172e-18
C175	VGND#4	a_257_126##4	5.07635e-17
C176	VPWR#3	A2_N#2	8.71168e-20
C177	a_257_126##2	B2#2	3.83265e-17
C178	B2	VPWR#6	4.74225e-19
C179	a_257_126##4	B1#1	3.15527e-18
C180	a_93_264##2	a_93_264##3	4.74134e-18
C181	VGND#4	A2_N#2	4.76636e-20
C182	B2	a_530_392##2	1.23524e-17
C183	a_257_126##4	a_257_126##2	1.20157e-18
C184	A2_N#3	a_258_392#	4.65775e-18
C185	a_257_126##6	A1_N	2.25746e-17
C186	A2_N#2	a_257_126##2	1.15219e-17
C187	VGND#9	A1_N	1.37955e-17
C188	A1_N#1	a_258_392#	9.29375e-18
C189	B2	B1#2	4.31716e-18
C190	X#1	A1_N	3.50579e-18
C191	a_257_126##4	A2_N#2	2.63422e-19
C192	X	a_93_264##5	2.15399e-18
C193	a_93_264##2	a_257_126##2	6.76376e-20
C194	A1_N#2	A2_N#2	5.60915e-17
C195	B2	B1#3	4.3345e-18
C196	VPWR	B2#5	1.09086e-18
C197	a_93_264##2	A1_N#2	6.3916e-17
C198	VGND	VGND#3	2.4732e-17
C199	VPWR	a_93_264##5	5.91925e-18
C200	X#1	X	4.11262e-18
C201	A1_N	A2_N#1	1.11223e-18
C202	A1_N	A1_N#3	3.67442e-18
C203	VGND	B1#7	1.42163e-17
C204	A1_N	a_93_264#	2.43786e-18
C205	VGND	B1#4	6.67163e-18
C206	VGND	B2#5	1.66743e-18
C207	X	VPWR#7	6.66434e-17
C208	VGND	a_93_264##5	4.52687e-18
C209	X	X#2	1.34016e-17
C210	VPWR	a_530_392#	1.582e-17
C211	VPWR	VPWR#6	2.46442e-17
C212	VGND#3	VNB	1.84709e-17
C213	VPWR	a_530_392##2	1.27889e-17
C214	VPWR	a_93_264##7	4.13536e-17
C215	B2	B2#2	5.21424e-18
C216	VGND	VGND#7	6.19089e-18
C217	VPWR	a_257_126##8	1.22077e-17
C218	VGND	a_93_264##4	7.7263e-18
C219	VPWR	VPWR#7	2.23381e-17
C220	B1#7	VNB	4.34853e-17
C221	VGND	VGND#8	1.14044e-17
C222	VGND	a_257_126##6	2.1939e-17
C223	B1#4	VNB	2.40694e-19
C224	VGND	X#1	2.13271e-17
C225	VGND	a_530_392#	3.51133e-18
C226	a_93_264##5	VNB	1.2134e-17
C227	X	A2_N#3	2.87904e-19
C228	X	A1_N#1	7.93768e-19
C229	VGND#7	VNB	2.83387e-17
C230	X	a_93_264##3	2.78582e-17
C231	VPWR	B1#3	2.03579e-18
C232	a_93_264##4	VNB	5.81954e-18
C233	VPWR	B2#1	1.31778e-18
C234	VGND	B2#3	2.13746e-18
C235	A1_N	A2_N#2	1.8081e-17
C236	a_257_126##6	VNB	1.29124e-17
C237	VPWR	a_257_126#	1.07376e-18
C238	VGND#9	VNB	6.24832e-18
C239	VPWR	A2_N#3	1.51927e-18
C240	X#1	VNB	5.97924e-17
C241	A1_N	A1_N#2	4.41888e-18
C242	a_530_392#	VNB	5.73112e-17
C243	VGND	A1_N#3	3.88629e-18
C244	VPWR	A1_N#1	1.5698e-18
C245	VPWR#6	VNB	2.80411e-18
C246	VGND	a_93_264#	3.87601e-18
C247	a_93_264##2	A1_N	1.12135e-17
C248	a_530_392##2	VNB	7.91264e-18
C249	VPWR	a_93_264##3	4.56823e-18
C250	a_93_264##7	VNB	1.28293e-17
C251	B2	a_605_126#	1.8969e-18
C252	a_257_126##8	VNB	5.49475e-18
C253	VPWR	VPWR#3	1.92242e-17
C254	VPWR#7	VNB	3.70521e-18
C255	B1#2	VNB	4.44258e-17
C256	B2#3	VNB	2.87825e-17
C257	a_257_126##3	VNB	1.48981e-17
C258	A2_N#1	VNB	2.49873e-17
C259	A1_N#3	VNB	2.19175e-17
C260	VPWR	a_257_126##2	1.90592e-18
C261	a_93_264#	VNB	3.86987e-17
C262	X	a_93_264##2	5.95021e-17
C263	B1#3	VNB	5.67347e-17
C264	VGND	VGND#4	1.71976e-17
C265	VPWR	A2_N#2	2.35336e-18
C266	B2#1	VNB	2.73058e-17
C267	VGND	B1#1	1.12386e-17
C268	a_257_126#	VNB	3.35715e-17
C269	VPWR	A1_N#2	2.13277e-18
C270	VGND	B2#2	3.47007e-19
C271	A2_N#3	VNB	3.81319e-17
C272	VPWR	a_93_264##2	3.5373e-18
C273	A1_N#1	VNB	3.255e-17
C274	VGND	a_257_126##2	2.68024e-18
C275	a_93_264##3	VNB	4.09147e-17
C276	VGND	a_257_126##4	2.67512e-17
C277	VGND	A2_N#2	3.69598e-18
C278	VPWR#3	VNB	2.19158e-16
C279	VGND#4	VNB	2.14702e-16
C280	VGND	A1_N#2	1.04027e-18
C281	B1#1	VNB	5.51382e-17
C282	VGND	a_93_264##2	5.60669e-18
C283	B2#2	VNB	3.07715e-17
C284	a_257_126##2	VNB	3.34405e-17
C285	a_257_126##4	VNB	5.27739e-17
C286	A2_N#2	VNB	4.55036e-17
C287	A1_N#2	VNB	3.01719e-17
C288	a_93_264##2	VNB	4.53424e-17
C289	VPWR	B2	9.91529e-19
C290	VGND	B2	1.22141e-18
C291	VGND	A1_N	3.25502e-18
C292	B2	VNB	4.94328e-18
C293	VPWR	X	2.23996e-17
C294	A1_N	VNB	1.25568e-19
C295	VGND	X	9.06802e-19
C296	X	VNB	7.77457e-17
C297	VPWR	VNB	8.12326e-17
C298	VGND	VNB	7.67074e-17
C299	VPWR#2	VNB	6.51838e-17
C300	VPWR#4	A1_N#1	2.87835e-18
C301	VGND#5	a_257_126##4	6.55296e-19
C302	VPWR#4	VNB	5.8036e-17
C303	a_93_264##2	VPWR#4	3.52207e-19
C304	X	VPWR#4	2.67835e-17
C305	VGND#2	B1#7	3.14489e-17
C306	VGND#2	VNB	5.21515e-17
C307	a_530_392##2	VPWR#2	1.08228e-17
C308	VGND#2	a_257_126##4	1.14578e-18
C309	VGND#5	A2_N#1	3.50467e-19
C310	VGND#5	VNB	6.13905e-17
C311	VPWR#4	A2_N#3	1.89028e-18
C312	VGND#5	a_93_264#	8.89447e-18
C313	VGND#5	VGND#3	2.11381e-19
C314	VGND#2	VGND#7	6.35632e-19
C315	VPWR#3	VPWR#2	6.99829e-17
C316	a_93_264##5	VPWR#4	3.86158e-19
C317	VPWR#2	B2#1	1.84024e-18
C318	VGND#3	VGND#2	2.7037e-17
C319	VGND#2	B1#1	3.71783e-17
C320	VGND#5	A1_N	6.36614e-19
C321	VGND#5	a_257_126##6	2.47427e-17
C322	VGND	VGND#2	4.35301e-17
C323	VPWR#4	a_93_264##3	3.32431e-18
C324	VPWR	VPWR#2	4.76811e-17
C325	VGND#5	a_93_264##2	7.50817e-19
C326	VGND#2	B2#5	1.70301e-19
C327	VGND#5	X#1	2.24683e-17
C328	VGND#2	B2#3	1.90143e-18
C329	a_93_264##7	VPWR#4	2.03417e-17
C330	VPWR	VPWR#4	4.10214e-17
C331	VGND	VGND#5	6.17843e-17
C332	VGND#5	A1_N#3	3.20389e-18
C333	VGND#4	VGND#5	6.77244e-17
C334	VPWR#2	B1#3	1.85023e-18
C335	VPWR#3	VPWR#4	6.7114e-17
C336	VGND#4	VGND#2	5.52741e-17
C337	a_530_392#	VPWR#2	1.78835e-17
C338	VGND#2	B1#4	4.03025e-17
*
*
.ENDS sky130_fd_sc_hs__a2bb2o_1
*
