* Extracted by Quantus, converted by sky130cad/quantus.py
*
*
*
*                       LINUX           Wed Nov 18 08:51:33 2026
*
*
*
*  PROGRAM  advgen
*
*  Name           : advgen - Quantus - (64-bit)
*  Version        : 25.1.0-p047
*  Build Date     : Thu Dec 11 23:20:30 PST 2025
*
*  HSPICE LIBRARY
*
*  OPERATING_TEMPERATURE 150
*  QRC_TECH_DIR <path>/tech
*
*
*

*
.SUBCKT sky130_fd_sc_hs__nor4b_1 VNB VPB VGND VPWR Y D_N A B C
*
*
*  caps2d version: 10
*
*
*       TRANSISTOR CARDS
*
*
XM7 a_57_368##7 D_N#1 VGND#7 VNB sky130_fd_pr__nfet_01v8_lvt l=0.15 w=0.55 ad=0.15675 as=0.2785 pd=1.67 ps=2.32
XM4 VGND#7 A#1 Y#4 VNB sky130_fd_pr__nfet_01v8_lvt l=0.15 w=0.74 ad=0.2785 as=0.2072 pd=2.32 ps=2.04
XM2 Y#4 B#1 VGND#6 VNB sky130_fd_pr__nfet_01v8_lvt l=0.15 w=0.74 ad=0.2072 as=0.3182 pd=2.04 ps=2.34
XM6 VGND#6 C#1 Y#5 VNB sky130_fd_pr__nfet_01v8_lvt l=0.15 w=0.74 ad=0.3182 as=0.2072 pd=2.34 ps=2.04
XM9 Y#5 a_57_368##3 VGND#1 VNB sky130_fd_pr__nfet_01v8_lvt l=0.15 w=0.74 ad=0.2072 as=0.2627 pd=2.04 ps=2.19
XM5 a_57_368##6 D_N#3 VPWR#4 VPB sky130_fd_pr__pfet_01v8 l=0.15 w=0.84 ad=0.2478 as=0.4354 pd=2.27 ps=3.08
XM1 VPWR#4 A#3 a_260_368# VPB sky130_fd_pr__pfet_01v8 l=0.15 w=1.12 ad=0.4354 as=0.3024 pd=3.08 ps=2.78
XM3 a_260_368# B#3 a_344_368# VPB sky130_fd_pr__pfet_01v8 l=0.15 w=1.12 ad=0.3024 as=0.4032 pd=2.78 ps=2.96
XM0 a_344_368# C#3 a_446_368# VPB sky130_fd_pr__pfet_01v8 l=0.15 w=1.12 ad=0.4032 as=0.4704 pd=2.96 ps=3.08
XM8 a_446_368# a_57_368# Y#1 VPB sky130_fd_pr__pfet_01v8 l=0.15 w=1.12 ad=0.4704 as=0.4648 pd=3.08 ps=3.07
*
*
*       RESISTOR AND CAP/DIODE CARDS
*
Rg1	D_N#1	D_N#2	311.748383
Rg2	D_N#2	D_N#3	467.750092
Rg3	A#1	A#2	382.539734
Rg4	A#2	A#3	434.639221
Rg5	B#1	B#2	382.539734
Rg6	B#2	B#3	434.639221
Rg7	C#1	C#2	382.539734
Rg8	C#2	C#3	434.639221
Rg9	a_57_368#	a_57_368##2	434.639221
Rg10	a_57_368##2	a_57_368##3	382.539734
Rf1	D_N	D_N#2	164.563202
Rf2	A#2	A#5	160.996811
Rf3	A#6	A	0.764007
Rf4	A#5	A#6	5.905091
Rf5	B	B#2	166.137894
Rf6	C#4	C#2	161.302414
Rf7	C	C#6	1.069610
Rf8	C#4	C#6	5.583287
Rf9	a_57_368##2	a_57_368##5	343.173218
Rf10	a_57_368##5	a_57_368##6	13.545121
Rf11	a_57_368##5	a_57_368##7	101.936157
Rf12	Y#2	Y	0.352983
Rf13	Y	Y#3	113.516327
Rf14	Y#3	Y#4	88.690407
Rf15	Y#2	Y	12.707388
Rf16	Y#3	Y#5	18.149860
Rf17	Y#1	Y#2	5.000000
Rf18	VGND#1	VGND#2	105.198044
Rf19	VGND#2	VGND#3	20.064354
Rf20	VGND#3	VGND#4	52.937077
Rf22	VGND#2	VGND#6	35.098007
Rf23	VGND#4	VGND#7	37.066368
Rf24	VPWR#1	VPWR#2	49.649803
Rf26	VPWR#2	VPWR#4	31.534731
Re1	VPWR#1	VPWR	1.403190
Re2	VGND	VGND#3	1.403242
*
*       CAPACITOR CARDS
*
*
C1	VGND#2	Y#3	2.91756e-19
C2	Y#3	C#4	4.41866e-17
C3	a_57_368##5	A#6	4.13348e-17
C4	VGND#2	VGND#1	1.32318e-18
C5	VGND#2	Y#5	1.68095e-17
C6	a_57_368##5	A#5	3.42334e-18
C7	Y#3	VGND#1	4.30064e-17
C8	Y#3	Y#5	9.59055e-20
C9	Y#3	VGND#6	2.06219e-17
C10	Y#4	a_57_368##5	5.80032e-18
C11	VGND#7	a_57_368##5	3.4992e-18
C12	Y#3	Y#1	3.32125e-18
C13	a_57_368##7	a_57_368##5	2.74254e-18
C14	Y#5	VGND#1	4.52314e-17
C15	Y#4	A#5	1.17381e-17
C16	VGND#2	a_57_368##3	2.40296e-18
C17	VGND#6	VGND#1	2.28753e-18
C18	a_57_368##5	VPWR#4	7.02133e-17
C19	VGND#7	A#5	8.33369e-18
C20	VGND#2	C#1	5.06493e-18
C21	VGND#6	Y#5	4.30273e-17
C22	Y#3	a_57_368##3	2.13004e-17
C23	a_57_368##7	A#5	1.18866e-19
C24	a_57_368##5	a_57_368##6	3.73754e-18
C25	Y#4	Y#5	3.01612e-18
C26	VGND#2	B#1	2.04817e-18
C27	Y#3	C#1	2.22061e-17
C28	Y#4	VGND#6	5.70212e-17
C29	VGND#2	A#1	3.40119e-19
C30	VGND#7	VGND#6	1.69044e-18
C31	VGND#7	Y#4	5.37595e-17
C32	VGND#2	D_N#1	1.29496e-19
C33	a_57_368##7	Y#4	2.09251e-18
C34	a_57_368##7	VGND#7	5.30321e-17
C35	a_57_368##5	a_57_368#	5.45193e-19
C36	a_57_368##3	VGND#1	2.34645e-17
C37	Y#5	a_57_368##3	3.49083e-17
C38	VGND#1	C#1	1.38237e-18
C39	a_57_368##5	C#3	4.68941e-19
C40	VGND#6	a_57_368##3	7.93159e-19
C41	Y#5	C#1	3.34276e-17
C42	VGND#1	B#1	2.87556e-19
C43	a_57_368##5	B#3	1.5435e-17
C44	C#1	VGND#6	2.12362e-17
C45	Y#5	B#1	9.89775e-19
C46	Y#4	C#1	6.36799e-19
C47	B#1	VGND#6	2.44079e-17
C48	a_57_368##5	A#3	2.01649e-17
C49	VGND#7	C#1	1.39945e-19
C50	Y#4	B#1	6.07669e-17
C51	VGND#6	A#1	4.12965e-19
C52	a_57_368##5	D_N#3	5.04919e-17
C53	VGND#7	B#1	5.48376e-19
C54	Y#4	A#1	4.08438e-17
C55	VGND#6	D_N#1	2.60919e-19
C56	A#1	VGND#7	1.86061e-17
C57	A#6	B#3	5.45369e-19
C58	Y#4	D_N#1	5.03141e-20
C59	a_57_368##7	A#1	2.19391e-19
C60	VGND#3	VGND#2	3.44656e-17
C61	D_N#1	VGND#7	2.1606e-17
C62	A#6	A#3	2.07107e-18
C63	a_57_368##5	VPWR#1	1.79342e-18
C64	a_57_368##7	D_N#1	3.05784e-17
C65	A#6	D_N#3	2.54426e-18
C66	Y#3	a_57_368##2	5.57305e-17
C67	VGND#2	C#2	3.85385e-20
C68	C#1	a_57_368##3	3.8967e-17
C69	a_57_368#	Y#1	2.14311e-17
C70	Y#3	C#2	3.68411e-18
C71	Y#1	C#3	3.84863e-18
C72	B#1	C#1	2.09257e-17
C73	Y#3	B#2	9.59977e-20
C74	C#4	a_57_368##2	2.37961e-17
C75	Y#1	B#3	1.64998e-18
C76	VPWR#4	a_57_368#	3.45524e-18
C77	Y#1	A#3	1.44368e-18
C78	A#1	B#1	3.81767e-17
C79	C#4	C#2	9.02939e-18
C80	Y#3	A#2	6.34867e-20
C81	VPWR#4	C#3	4.94492e-18
C82	VGND#3	VGND#1	3.30167e-17
C83	a_57_368##5	A#2	3.56878e-18
C84	C#4	B#2	2.18662e-18
C85	VPWR#4	B#3	8.72429e-18
C86	D_N#1	A#1	1.82629e-17
C87	VGND#1	a_57_368##2	9.68203e-19
C88	VGND#3	Y#4	1.35892e-17
C89	A#6	B#2	1.58011e-18
C90	VPWR#4	A#3	5.83051e-17
C91	D_N#2	a_57_368##5	1.34129e-17
C92	A#5	B#2	2.1228e-18
C93	D_N#3	VPWR#4	2.61392e-17
C94	Y#4	a_57_368##2	1.24941e-18
C95	A#6	A#2	7.00064e-18
C96	D_N#3	a_57_368##6	8.83312e-18
C97	VGND#6	C#2	5.49724e-19
C98	A#5	A#2	1.17782e-17
C99	A#6	D_N#2	8.03629e-19
C100	a_57_368##2	Y#1	8.19687e-17
C101	VGND#6	B#2	6.47359e-19
C102	Y#4	B#2	3.39591e-18
C103	A#5	D_N#2	3.84554e-18
C104	C#3	a_57_368#	3.39541e-17
C105	a_57_368##2	VPWR#4	2.11367e-20
C106	VGND#7	A#2	2.89807e-18
C107	B#3	C#3	4.22552e-17
C108	Y#4	D_N#2	2.22183e-18
C109	a_57_368##5	a_260_368#	6.95994e-18
C110	VGND#3	B#1	5.5386e-18
C111	D_N#2	a_57_368##7	6.05817e-17
C112	A#3	B#3	6.02617e-17
C113	VPWR#1	a_57_368#	4.60523e-18
C114	A#2	VPWR#4	1.29566e-18
C115	D_N#3	A#3	2.40917e-17
C116	VPWR#1	C#3	8.62136e-18
C117	VPWR#1	B#3	8.59262e-18
C118	a_57_368##2	a_57_368#	1.35157e-17
C119	a_57_368##2	C#3	2.93491e-17
C120	a_57_368##2	B#3	9.12796e-18
C121	B	a_57_368##5	2.1863e-17
C122	a_57_368##2	A#3	1.53953e-19
C123	D_N#2	A#1	6.82964e-18
C124	a_57_368##2	D_N#3	1.42951e-19
C125	B	C#4	1.87408e-17
C126	A#6	B	1.30199e-17
C127	a_57_368##2	VPWR#1	5.83007e-18
C128	A#5	B	1.71674e-17
C129	VPWR#1	C#2	1.60817e-19
C130	D_N#3	A#2	6.95603e-18
C131	VPWR#1	B#2	1.34544e-19
C132	D_N	a_57_368##5	6.42599e-18
C133	a_57_368#	a_446_368#	3.38717e-17
C134	Y#4	B	4.27186e-17
C135	C#2	a_57_368##2	3.60742e-17
C136	C#3	a_446_368#	3.06704e-17
C137	VGND#3	B#2	3.75092e-20
C138	a_57_368##2	B#2	1.70109e-18
C139	C#3	a_344_368#	3.11341e-17
C140	B#2	C#2	2.92653e-17
C141	B#3	a_344_368#	3.11341e-17
C142	D_N	A#5	1.14158e-17
C143	B#3	a_260_368#	2.6874e-17
C144	A#2	B#2	3.56304e-17
C145	D_N	Y#4	4.85024e-18
C146	A#3	a_260_368#	2.6874e-17
C147	VGND#7	D_N	1.29035e-17
C148	VPWR	a_57_368##5	2.76626e-17
C149	C	a_57_368#	8.22443e-19
C150	a_57_368##2	a_446_368#	8.70413e-18
C151	D_N#2	A#2	2.50972e-17
C152	C	C#3	2.04752e-18
C153	C#2	a_446_368#	5.29945e-19
C154	C	B#3	4.19106e-19
C155	a_57_368##2	a_344_368#	9.19683e-18
C156	VPWR	A#6	2.51368e-18
C157	B	C#3	6.0156e-19
C158	VGND	VGND#2	4.3201e-17
C159	Y	Y#1	7.29308e-18
C160	B	B#3	2.02945e-18
C161	B#2	a_344_368#	4.20301e-19
C162	VGND	Y#3	8.28911e-18
C163	B	A#3	6.49696e-19
C164	VGND	a_57_368##5	2.46161e-18
C165	D_N	A#1	1.50127e-18
C166	VGND	C#4	2.72916e-18
C167	C	a_57_368##2	5.80932e-17
C168	VGND	A#5	3.48282e-18
C169	C	C#2	5.66116e-18
C170	VGND	VGND#1	4.60574e-17
C171	VGND	Y#5	1.6226e-17
C172	VPWR	VPWR#4	2.22163e-17
C173	B	a_57_368##2	1.83725e-17
C174	C	B#2	1.59373e-18
C175	VGND	Y#4	1.76339e-17
C176	B	C#2	2.75952e-18
C177	Y	a_57_368#	1.23683e-17
C178	VGND	a_57_368##7	2.23262e-17
C179	Y	C#3	3.2309e-18
C180	B	B#2	1.43554e-17
C181	VGND	Y#1	8.81247e-19
C182	Y	B#3	1.38515e-18
C183	B	A#2	3.69715e-18
C184	Y	A#3	1.21196e-18
C185	VPWR	a_57_368#	4.68519e-18
C186	D_N	a_57_368##2	1.09474e-19
C187	VGND	a_57_368##3	1.274e-18
C188	VPWR	C#3	1.58281e-18
C189	D_N	C#2	1.15518e-19
C190	VGND	C#1	3.42738e-19
C191	Y	VPWR#1	2.68111e-17
C192	VPWR	B#3	1.48096e-18
C193	D_N	B#2	2.36955e-19
C194	VPWR	A#3	7.21388e-19
C195	VGND	A#1	1.40719e-18
C196	VGND#2	VNB	2.76896e-17
C197	VGND	D_N#1	2.25003e-18
C198	VPWR	D_N#3	8.2294e-18
C199	D_N	A#2	2.99058e-18
C200	Y#3	VNB	2.94648e-17
C201	a_57_368##5	VNB	6.9543e-17
C202	D_N	D_N#2	1.2085e-17
C203	VPWR	VPWR#1	5.77989e-17
C204	C#4	VNB	1.07145e-18
C205	A#6	VNB	1.43763e-18
C206	VPWR	a_57_368##2	1.88938e-17
C207	A#5	VNB	1.62035e-18
C208	VGND#1	VNB	6.10207e-17
C209	Y#5	VNB	4.76739e-18
C210	B	C	1.49633e-17
C211	VGND#6	VNB	3.17376e-18
C212	Y#4	VNB	6.57852e-18
C213	VGND#7	VNB	6.82666e-18
C214	VGND	VGND#3	9.2617e-18
C215	a_57_368##7	VNB	5.88768e-17
C216	Y#1	VNB	5.29163e-17
C217	VGND	a_57_368##2	3.62106e-18
C218	VPWR	D_N#2	1.3157e-18
C219	VPWR#4	VNB	1.14486e-17
C220	a_57_368##3	VNB	3.61057e-17
C221	C#1	VNB	2.9189e-17
C222	B#1	VNB	3.17323e-17
C223	VGND	D_N#2	2.20104e-18
C224	A#1	VNB	3.06945e-17
C225	D_N#1	VNB	3.27816e-17
C226	a_57_368#	VNB	3.48751e-17
C227	C#3	VNB	2.80863e-17
C228	B#3	VNB	2.72047e-17
C229	A#3	VNB	3.36468e-17
C230	VPWR	C	2.62342e-18
C231	D_N#3	VNB	5.1768e-17
C232	VPWR	B	2.50972e-18
C233	VPWR#1	VNB	2.29249e-16
C234	VGND#3	VNB	1.6642e-16
C235	a_57_368##2	VNB	5.05868e-17
C236	C#2	VNB	2.80992e-17
C237	B#2	VNB	2.9814e-17
C238	VGND	B	2.58428e-18
C239	VPWR	D_N	1.44922e-18
C240	A#2	VNB	2.40598e-17
C241	D_N#2	VNB	6.22874e-17
C242	VPWR	Y	1.94223e-17
C243	VGND	D_N	2.09431e-18
C244	C	VNB	2.68076e-18
C245	B	VNB	3.00452e-18
C246	D_N	VNB	3.59248e-19
C247	Y	VNB	2.09411e-17
C248	VPWR	VNB	6.21376e-17
C249	VGND	VNB	6.20005e-17
C250	VGND#4	D_N#1	7.97918e-18
C251	VPWR#2	D_N#3	3.40047e-18
C252	VGND#3	VGND#4	5.84421e-17
C253	VGND#4	VNB	5.3148e-17
C254	VGND#4	A#1	7.48249e-18
C255	VGND#4	VGND#2	1.35535e-18
C256	VGND#4	a_57_368##7	2.98593e-17
C257	VPWR#2	A#3	4.08078e-18
C258	VGND#4	B#1	8.08188e-19
C259	VPWR#2	VNB	5.48824e-17
C260	VGND	VGND#4	5.84612e-17
C261	VGND#4	C#1	1.44855e-19
C262	VGND#4	Y#4	3.66599e-18
C263	VGND#4	VGND#6	6.01046e-19
C264	VGND#4	D_N#2	1.99847e-19
C265	a_57_368##5	VPWR#2	1.30941e-17
C266	VGND#4	D_N	5.60634e-19
C267	VPWR#2	D_N#2	8.65102e-20
C268	VPWR#1	VPWR#2	5.8989e-17
C269	VPWR	VPWR#2	4.14949e-17
C270	VGND#4	A#5	4.12191e-19
*
*
.ENDS sky130_fd_sc_hs__nor4b_1
*
