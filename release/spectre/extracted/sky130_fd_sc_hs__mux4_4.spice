* Extracted by Quantus, converted by sky130cad/quantus.py
*
*
*
*                       LINUX           Wed Nov 18 08:44:19 2026
*
*
*
*  PROGRAM  advgen
*
*  Name           : advgen - Quantus - (64-bit)
*  Version        : 25.1.0-p047
*  Build Date     : Thu Dec 11 23:20:30 PST 2025
*
*  HSPICE LIBRARY
*
*  OPERATING_TEMPERATURE 150
*  QRC_TECH_DIR <path>/tech
*
*
*

*
.SUBCKT sky130_fd_sc_hs__mux4_4 VPB VNB VGND VPWR X S1 A2 S0 A3 A1 A0
*
*
*  caps2d version: 10
*
*
*       TRANSISTOR CARDS
*
*
XM36 a_114_126# A1#4 VGND#12 VNB sky130_fd_pr__nfet_01v8_lvt l=0.15 w=0.64 ad=0.1792 as=0.1824 pd=1.84 ps=1.85
XM28 VGND#21 A1#5 a_114_126# VNB sky130_fd_pr__nfet_01v8_lvt l=0.15 w=0.64 ad=0.2208 as=0.1792 pd=1.97 ps=1.84
XM47 a_299_126##2 A0#5 VGND#21 VNB sky130_fd_pr__nfet_01v8_lvt l=0.15 w=0.64 ad=0.1792 as=0.2208 pd=1.84 ps=1.97
XM31 VGND#20 A0#3 a_299_126##2 VNB sky130_fd_pr__nfet_01v8_lvt l=0.15 w=0.64 ad=0.3525 as=0.1792 pd=2.83 ps=1.84
XM17 a_509_392##10 S0#7 a_114_126##2 VNB sky130_fd_pr__nfet_01v8_lvt l=0.15 w=0.64 ad=0.31625 as=0.208 pd=2.58 ps=1.93
XM14 a_114_126##2 S0#13 a_509_392# VNB sky130_fd_pr__nfet_01v8_lvt l=0.15 w=0.64 ad=0.208 as=0.1792 pd=1.93 ps=1.84
XM32 a_299_126# a_758_306##7 a_509_392# VNB sky130_fd_pr__nfet_01v8_lvt l=0.15 w=0.64 ad=0.1792 as=0.1792 pd=1.84 ps=1.84
XM12 a_509_392##3 a_758_306# a_299_126# VNB sky130_fd_pr__nfet_01v8_lvt l=0.15 w=0.64 ad=0.1824 as=0.1792 pd=1.85 ps=1.84
XM24 a_758_306##16 S0#11 VGND#19 VNB sky130_fd_pr__nfet_01v8_lvt l=0.15 w=0.74 ad=0.2109 as=0.2109 pd=2.05 ps=2.05
XM49 a_1191_121##7 a_758_306##11 a_1278_121##2 VNB sky130_fd_pr__nfet_01v8_lvt l=0.15 w=0.64 ad=0.1824 as=0.1792 pd=1.85 ps=1.84
XM5 a_1278_121##2 a_758_306##12 a_1191_121##11 VNB sky130_fd_pr__nfet_01v8_lvt l=0.15 w=0.64 ad=0.1792 as=0.1792 pd=1.84 ps=1.84
XM20 a_1191_121##11 S0#10 a_1450_121##2 VNB sky130_fd_pr__nfet_01v8_lvt l=0.15 w=0.64 ad=0.1792 as=0.1792 pd=1.84 ps=1.84
XM18 a_1450_121##2 S0#4 a_1191_121##13 VNB sky130_fd_pr__nfet_01v8_lvt l=0.15 w=0.64 ad=0.1792 as=0.2336 pd=1.84 ps=2.01
XM23 a_1278_121# A2#4 VGND#18 VNB sky130_fd_pr__nfet_01v8_lvt l=0.15 w=0.64 ad=0.1792 as=0.2887 pd=1.84 ps=2.39
XM7 VGND#17 A2#1 a_1278_121# VNB sky130_fd_pr__nfet_01v8_lvt l=0.15 w=0.64 ad=0.1792 as=0.1792 pd=1.84 ps=1.84
XM19 VGND#17 A3#5 a_1450_121# VNB sky130_fd_pr__nfet_01v8_lvt l=0.15 w=0.64 ad=0.1792 as=0.1792 pd=1.84 ps=1.84
XM4 a_1450_121# A3#6 VGND#16 VNB sky130_fd_pr__nfet_01v8_lvt l=0.15 w=0.64 ad=0.1792 as=0.1824 pd=1.84 ps=1.85
XM25 a_2199_74##19 S1#5 a_1191_121##8 VNB sky130_fd_pr__nfet_01v8_lvt l=0.15 w=0.64 ad=0.1824 as=0.33235 pd=1.85 ps=2.51
XM35 a_1191_121##8 S1#7 a_2199_74##17 VNB sky130_fd_pr__nfet_01v8_lvt l=0.15 w=0.64 ad=0.33235 as=0.448 pd=2.51 ps=2.68
XM1 a_2199_74##17 a_2489_347##6 a_509_392##15 VNB sky130_fd_pr__nfet_01v8_lvt l=0.15 w=0.64 ad=0.448 as=0.1792 pd=2.68 ps=1.84
XM11 a_509_392##15 a_2489_347# a_2199_74##21 VNB sky130_fd_pr__nfet_01v8_lvt l=0.15 w=0.64 ad=0.1792 as=0.2272 pd=1.84 ps=1.99
XM33 a_2489_347##7 S1#12 VGND#15 VNB sky130_fd_pr__nfet_01v8_lvt l=0.15 w=0.74 ad=0.2109 as=0.4292 pd=2.05 ps=2.64
XM37 X#5 a_2199_74##12 VGND#15 VNB sky130_fd_pr__nfet_01v8_lvt l=0.15 w=0.74 ad=0.2072 as=0.4292 pd=2.04 ps=2.64
XM44 VGND#14 a_2199_74##8 X#5 VNB sky130_fd_pr__nfet_01v8_lvt l=0.15 w=0.74 ad=0.2072 as=0.2072 pd=2.04 ps=2.04
XM30 X#1 a_2199_74##6 VGND#14 VNB sky130_fd_pr__nfet_01v8_lvt l=0.15 w=0.74 ad=0.2072 as=0.2072 pd=2.04 ps=2.04
XM43 VGND#1 a_2199_74# X#1 VNB sky130_fd_pr__nfet_01v8_lvt l=0.15 w=0.74 ad=0.2109 as=0.2072 pd=2.05 ps=2.04
XM50 a_116_392##2 A1#6 VPWR#13 VPB sky130_fd_pr__pfet_01v8 l=0.15 w=1 ad=0.3 as=0.295 pd=2.6 ps=2.59
XM15 VPWR#21 A1#1 a_116_392##2 VPB sky130_fd_pr__pfet_01v8 l=0.15 w=1 ad=0.3 as=0.3 pd=2.6 ps=2.6
XM39 a_296_392# A0#6 VPWR#21 VPB sky130_fd_pr__pfet_01v8 l=0.15 w=1 ad=0.35 as=0.3 pd=2.7 ps=2.6
XM26 VPWR#20 A0#1 a_296_392# VPB sky130_fd_pr__pfet_01v8 l=0.15 w=1 ad=0.295 as=0.35 pd=2.59 ps=2.7
XM16 a_296_392##2 S0#8 a_509_392##9 VPB sky130_fd_pr__pfet_01v8 l=0.15 w=1 ad=0.325 as=0.31 pd=2.65 ps=2.62
XM40 a_509_392##11 S0#14 a_296_392##2 VPB sky130_fd_pr__pfet_01v8 l=0.15 w=1 ad=0.325 as=0.325 pd=2.65 ps=2.65
XM27 a_509_392##11 a_758_306##4 a_116_392# VPB sky130_fd_pr__pfet_01v8 l=0.15 w=1 ad=0.325 as=0.3 pd=2.65 ps=2.6
XM2 a_116_392# a_758_306##5 a_509_392##6 VPB sky130_fd_pr__pfet_01v8 l=0.15 w=1 ad=0.3 as=0.295 pd=2.6 ps=2.59
XM13 a_758_306##17 S0#12 VPWR#19 VPB sky130_fd_pr__pfet_01v8 l=0.15 w=1.12 ad=0.3304 as=0.3304 pd=2.83 ps=2.83
XM34 a_1191_121##9 a_758_306##13 a_1285_377# VPB sky130_fd_pr__pfet_01v8 l=0.15 w=1 ad=0.295 as=0.3 pd=2.59 ps=2.6
XM6 a_1285_377# a_758_306##8 a_1191_121##10 VPB sky130_fd_pr__pfet_01v8 l=0.15 w=1 ad=0.3 as=0.3 pd=2.6 ps=2.6
XM38 a_1191_121##10 S0#15 a_1465_377##2 VPB sky130_fd_pr__pfet_01v8 l=0.15 w=1 ad=0.3 as=0.3 pd=2.6 ps=2.6
XM8 a_1465_377##2 S0#1 a_1191_121##3 VPB sky130_fd_pr__pfet_01v8 l=0.15 w=1 ad=0.3 as=0.295 pd=2.6 ps=2.59
XM10 VPWR#18 A2#5 a_1465_377# VPB sky130_fd_pr__pfet_01v8 l=0.15 w=1 ad=0.44815 as=0.3 pd=3.23 ps=2.6
XM45 a_1465_377# A2#3 VPWR#17 VPB sky130_fd_pr__pfet_01v8 l=0.15 w=1 ad=0.3 as=0.5505 pd=2.6 ps=3.43
XM41 VPWR#17 A3#7 a_1285_377##2 VPB sky130_fd_pr__pfet_01v8 l=0.15 w=1 ad=0.5505 as=0.3 pd=3.43 ps=2.6
XM3 a_1285_377##2 A3#1 VPWR#16 VPB sky130_fd_pr__pfet_01v8 l=0.15 w=1 ad=0.3 as=0.295 pd=2.6 ps=2.59
XM46 a_2199_74##22 S1#8 a_509_392##12 VPB sky130_fd_pr__pfet_01v8 l=0.15 w=1 ad=0.295 as=0.35 pd=2.59 ps=2.7
XM0 a_509_392##12 S1#1 a_2199_74##24 VPB sky130_fd_pr__pfet_01v8 l=0.15 w=1 ad=0.35 as=0.35 pd=2.7 ps=2.7
XM9 a_2199_74##24 a_2489_347##4 a_1191_121# VPB sky130_fd_pr__pfet_01v8 l=0.15 w=1 ad=0.35 as=0.35 pd=2.7 ps=2.7
XM21 a_1191_121# a_2489_347##5 a_2199_74##26 VPB sky130_fd_pr__pfet_01v8 l=0.15 w=1 ad=0.35 as=0.345 pd=2.7 ps=2.69
XM48 a_2489_347##10 S1#9 VPWR#15 VPB sky130_fd_pr__pfet_01v8 l=0.15 w=1.12 ad=0.3696 as=0.4088 pd=2.9 ps=2.97
XM22 VPWR#15 a_2199_74##14 X#4 VPB sky130_fd_pr__pfet_01v8 l=0.15 w=1.12 ad=0.4088 as=0.336 pd=2.97 ps=2.84
XM42 X#4 a_2199_74##13 VPWR#14 VPB sky130_fd_pr__pfet_01v8 l=0.15 w=1.12 ad=0.336 as=0.392 pd=2.84 ps=2.94
XM51 VPWR#14 a_2199_74##9 X#6 VPB sky130_fd_pr__pfet_01v8 l=0.15 w=1.12 ad=0.392 as=0.336 pd=2.94 ps=2.84
XM29 X#6 a_2199_74##5 VPWR#1 VPB sky130_fd_pr__pfet_01v8 l=0.15 w=1.12 ad=0.336 as=0.3864 pd=2.84 ps=2.93
*
*
*       RESISTOR AND CAP/DIODE CARDS
*
Rg1	A1#1	A1#2	425.526398
Rg2	A1#2	A1#3	55.599739
Rg3	A1#3	A1#4	304.732208
Rg4	A1#2	A1#5	337.382050
Rg5	A1#3	A1#6	394.407837
Rg6	A0#1	A0#2	418.462708
Rg7	A0#2	A0#3	386.767334
Rg8	A0#2	A0#4	69.988121
Rg9	A0#4	A0#5	345.908142
Rg10	A0#4	A0#6	415.223511
Rg11	a_758_306#	a_758_306##2	361.211456
Rg12	a_758_306##2	a_758_306##3	80.690147
Rg13	a_758_306##3	a_758_306##4	501.298187
Rg14	a_758_306##2	a_758_306##5	404.251099
Rg15	a_758_306##2	a_758_306##6	277.647888
Rg16	a_758_306##3	a_758_306##7	368.170197
Rg17	a_758_306##8	a_758_306##9	432.594025
Rg18	a_758_306##9	a_758_306##10	61.505905
Rg19	a_758_306##10	a_758_306##11	270.300476
Rg20	a_758_306##9	a_758_306##12	313.731110
Rg21	a_758_306##10	a_758_306##13	398.849365
Rg22	S0#1	S0#2	394.695099
Rg23	S0#2	S0#3	37.394096
Rg24	S0#3	S0#4	327.440338
Rg25	S0#2	S0#5	2404.139160
Rg26	S0#5	S0#6	1060.442871
Rg27	S0#6	S0#7	711.397278
Rg28	S0#7	S0#8	799.387817
Rg29	S0#3	S0#9	59.578423
Rg30	S0#9	S0#10	332.672974
Rg31	S0#5	S0#11	288.390350
Rg32	S0#11	S0#12	877.014160
Rg33	S0#6	S0#13	426.106262
Rg34	S0#13	S0#14	799.387817
Rg35	S0#9	S0#15	418.288849
Rg36	A2#1	A2#2	403.054626
Rg37	A2#2	A2#3	486.917389
Rg38	A2#2	A2#4	354.283203
Rg39	A2#2	A2#5	534.113525
Rg40	A3#1	A3#2	480.610504
Rg41	A3#2	A3#3	31.581308
Rg42	A3#3	A3#4	21.754395
Rg43	A3#4	A3#5	476.973816
Rg44	A3#2	A3#6	553.743958
Rg45	A3#4	A3#7	426.463684
Rg46	S1#1	S1#2	505.621979
Rg47	S1#2	S1#3	19.844902
Rg48	S1#3	S1#4	71.039948
Rg49	S1#4	S1#5	372.353638
Rg50	S1#2	S1#6	51.301041
Rg51	S1#3	S1#7	355.459747
Rg52	S1#4	S1#8	502.274445
Rg53	a_2489_347#	a_2489_347##2	485.676941
Rg54	a_2489_347##2	a_2489_347##3	50.120777
Rg55	a_2489_347##3	a_2489_347##4	469.546173
Rg56	a_2489_347##2	a_2489_347##5	378.002960
Rg57	a_2489_347##3	a_2489_347##6	468.135925
Rg58	S1#9	S1#10	515.875366
Rg59	S1#10	S1#11	107.740356
Rg60	S1#10	S1#12	318.702759
Rg61	a_2199_74#	a_2199_74##2	410.988098
Rg62	a_2199_74##2	a_2199_74##3	55.837200
Rg63	a_2199_74##3	a_2199_74##4	46.720535
Rg64	a_2199_74##2	a_2199_74##5	441.762421
Rg65	a_2199_74##3	a_2199_74##6	363.093384
Rg66	a_2199_74##4	a_2199_74##7	30.358044
Rg67	a_2199_74##7	a_2199_74##8	342.058960
Rg68	a_2199_74##4	a_2199_74##9	451.334412
Rg69	a_2199_74##7	a_2199_74##10	28.503550
Rg70	a_2199_74##10	a_2199_74##11	44.772530
Rg71	a_2199_74##11	a_2199_74##12	338.792633
Rg72	a_2199_74##10	a_2199_74##13	441.762421
Rg73	a_2199_74##11	a_2199_74##14	513.922241
Rf1	A1	A1#7	6.495599
Rf2	A1#7	A1	12.400690
Rf3	A0	A0#7	12.203854
Rf4	A0#7	A0	6.692436
Rf5	a_296_392#	a_296_392##2	117.413712
Rf6	a_114_126#	a_114_126##2	216.664337
Rf7	a_116_392#	a_116_392##2	329.048004
Rf8	a_299_126#	a_299_126##2	210.718323
Rf9	a_509_392#	a_509_392##2	48.589886
Rf10	a_509_392##2	a_509_392##4	78.224419
Rf11	a_509_392##4	a_509_392##5	71.237595
Rf12	a_509_392##5	a_509_392##7	16.037813
Rf13	a_509_392##7	a_509_392##8	77.906837
Rf14	a_509_392##8	a_509_392##9	85.449570
Rf15	a_509_392##2	a_509_392##10	80.899902
Rf16	a_509_392##8	a_509_392##11	22.539133
Rf17	a_509_392##3	a_509_392##4	7.500000
Rf18	a_509_392##6	a_509_392##7	5.000000
Rf19	a_758_306##10	a_758_306##6	170.640625
Rf20	a_758_306##6	a_758_306##16	42.782917
Rf21	a_758_306##6	a_758_306##17	46.484516
Rf22	S0	S0#16	4.591745
Rf23	S0#16	S0	13.775237
Rf24	a_1465_377#	a_1465_377##2	143.407684
Rf25	a_1278_121#	a_1278_121##2	240.412277
Rf26	A2#6	A2	2.254818
Rf27	A2#2	A2#8	82.371223
Rf28	A2#6	A2#8	5.649055
Rf29	A2#9	A2	2.254818
Rf30	A2#8	A2#9	6.676157
Rf31	a_1450_121#	a_1450_121##2	220.606995
Rf32	a_1285_377#	a_1285_377##2	285.767761
Rf33	A3	A3#8	9.644981
Rf34	A3#8	A3	9.251308
Rf35	a_1191_121#	a_1191_121##2	220.063446
Rf36	a_1191_121##2	a_1191_121##4	209.826340
Rf37	a_1191_121##4	a_1191_121##5	67.710220
Rf38	a_1191_121##5	a_1191_121##6	54.166054
Rf39	a_1191_121##6	a_1191_121##7	73.728203
Rf40	a_1191_121##2	a_1191_121##8	200.452484
Rf41	a_1191_121##5	a_1191_121##9	91.895760
Rf42	a_1191_121##5	a_1191_121##10	30.843397
Rf43	a_1191_121##6	a_1191_121##12	9.211320
Rf44	a_1191_121##12	a_1191_121##13	82.338875
Rf45	a_1191_121##3	a_1191_121##4	15.000000
Rf46	a_1191_121##11	a_1191_121##12	7.500000
Rf47	a_509_392##13	a_509_392##14	7.676618
Rf48	a_509_392##14	a_509_392##15	130.485580
Rf49	a_509_392##12	a_509_392##13	15.000000
Rf50	S1#11	S1	227.934357
Rf51	S1	S1#6	170.697113
Rf52	a_2489_347##7	a_2489_347##8	84.717888
Rf53	a_2489_347##8	a_2489_347##2	215.532974
Rf54	a_2489_347##8	a_2489_347##10	29.026114
Rf55	a_2199_74##4	a_2199_74##16	225.337128
Rf56	a_2199_74##16	a_2199_74##18	75.204567
Rf57	a_2199_74##18	a_2199_74##20	71.933777
Rf58	a_2199_74##16	a_2199_74##21	10.276406
Rf59	a_2199_74##20	a_2199_74##23	59.443394
Rf60	a_2199_74##23	a_2199_74##25	82.360115
Rf61	a_2199_74##25	a_2199_74##26	85.716766
Rf62	a_2199_74##17	a_2199_74##18	7.500000
Rf63	a_2199_74##19	a_2199_74##20	15.000000
Rf64	a_2199_74##22	a_2199_74##23	7.500000
Rf65	a_2199_74##24	a_2199_74##25	7.500000
Rf66	X#1	X#2	18.781376
Rf67	X#2	X	45.989067
Rf68	X	X#3	48.418198
Rf69	X#3	X#4	88.106133
Rf70	X#2	X#5	80.612747
Rf71	X#3	X#6	21.948624
Rf72	VGND#1	VGND#2	98.400856
Rf73	VGND#2	VGND#3	36.558064
Rf74	VGND#3	VGND#4	23.474201
Rf75	VGND#4	VGND#5	320.092041
Rf76	VGND#5	VGND#6	24.869984
Rf77	VGND#6	VGND#7	38.019073
Rf78	VGND#7	VGND#8	65.753731
Rf79	VGND#8	VGND#9	227.868484
Rf80	VGND#9	VGND#10	159.225540
Rf81	VGND#10	VGND#11	88.731819
Rf82	VGND#11	VGND#13	183.202667
Rf83	VGND#2	VGND#14	42.655182
Rf84	VGND#4	VGND#15	56.430489
Rf85	VGND#5	VGND#16	38.480759
Rf86	VGND#7	VGND#17	38.817978
Rf87	VGND#8	VGND#18	24.468842
Rf88	VGND#9	VGND#19	33.306259
Rf89	VGND#11	VGND#20	26.043533
Rf90	VGND#13	VGND#21	59.399597
Rf91	VGND#12	VGND#13	7.500000
Rf92	VPWR#1	VPWR#2	100.992142
Rf93	VPWR#2	VPWR#3	29.983519
Rf94	VPWR#3	VPWR#4	42.344753
Rf95	VPWR#4	VPWR#5	291.544983
Rf96	VPWR#5	VPWR#6	34.431774
Rf97	VPWR#6	VPWR#7	37.956036
Rf98	VPWR#7	VPWR#8	78.474533
Rf99	VPWR#8	VPWR#9	213.258377
Rf100	VPWR#9	VPWR#10	161.051804
Rf101	VPWR#10	VPWR#11	86.962906
Rf102	VPWR#11	VPWR#12	69.463600
Rf103	VPWR#12	VPWR#13	116.595291
Rf104	VPWR#2	VPWR#14	42.573776
Rf105	VPWR#4	VPWR#15	38.286041
Rf106	VPWR#5	VPWR#16	53.325844
Rf107	VPWR#7	VPWR#17	22.481674
Rf108	VPWR#8	VPWR#18	22.697315
Rf109	VPWR#9	VPWR#19	38.286041
Rf110	VPWR#11	VPWR#20	37.027283
Rf111	VPWR#12	VPWR#21	38.224945
Rf112	A1#3	A1#7	80.116402
Rf113	A0#2	A0#7	53.410934
Rf116	S0#2	S0#16	53.410934
Rf118	A3#3	A3#8	80.116402
Re1	a_509_392##14	a_509_392##5	31.709354
Re2	VPWR#3	VPWR#23	3.332833
Re3	VPWR#23	VPWR	0.645336
Re4	VPWR	VPWR#10	2.634420
Re5	VGND#3	VGND#23	3.332833
Re6	VGND#23	VGND	0.645336
Re7	VGND	VGND#10	2.634420
Re11	VPWR#6	VPWR#23	0.698413
Re14	VGND#6	VGND#23	0.698413
*
*       CAPACITOR CARDS
*
*
C1	a_509_392##9	VPWR#10	4.80169e-17
C2	A3#6	S1#5	3.71703e-18
C3	a_2199_74##24	a_2489_347##4	5.94465e-17
C4	a_1191_121##2	S1#5	4.65872e-19
C5	VPWR#8	VPWR#18	4.04144e-18
C6	a_1278_121##2	a_758_306##12	2.63319e-17
C7	S0#5	a_758_306##10	4.11833e-18
C8	S1#3	a_2489_347##3	1.26211e-18
C9	a_509_392##3	VGND#19	3.20135e-18
C10	a_1191_121##5	a_758_306##9	3.88966e-18
C11	A2#9	A3#4	9.51867e-18
C12	VGND#1	a_2199_74#	2.97888e-17
C13	a_509_392##2	a_758_306##2	2.8802e-19
C14	A3#1	S1#8	3.99515e-18
C15	a_1278_121#	S0#3	3.17797e-17
C16	S0#5	S0#3	7.36516e-20
C17	a_1191_121#	S1#1	1.61903e-17
C18	A2#8	a_1191_121##3	1.96024e-17
C19	a_509_392##12	a_2489_347##4	4.46526e-19
C20	VPWR#10	a_296_392#	2.08372e-17
C21	a_758_306##17	VPWR#19	7.92989e-17
C22	a_758_306##10	a_758_306##9	1.16553e-17
C23	a_509_392##14	a_2489_347##6	5.90482e-20
C24	a_2199_74##17	a_1191_121##8	2.92223e-17
C25	a_2199_74##19	a_509_392##15	4.03412e-18
C26	a_1191_121##9	a_1191_121##5	2.07495e-19
C27	VPWR#8	S0#15	3.65138e-18
C28	a_1191_121##7	a_758_306##12	4.33532e-19
C29	VGND#2	VGND#1	1.81455e-18
C30	a_509_392##3	A0#2	5.27778e-19
C31	a_2489_347##7	S1#10	4.70743e-18
C32	S0#3	A2#5	3.87934e-19
C33	a_2199_74##24	S1#1	3.30992e-17
C34	A3#3	a_1285_377##2	2.37113e-18
C35	a_2489_347##10	VPWR#15	7.97493e-17
C36	a_1450_121##2	A3#4	7.3518e-20
C37	a_509_392##14	S1#7	7.47269e-18
C38	a_2199_74##22	a_2489_347##4	1.98955e-19
C39	VPWR#10	a_116_392##2	2.53997e-17
C40	a_2199_74#	X#1	1.33201e-17
C41	a_1191_121##13	S0#9	5.65241e-20
C42	a_1278_121##2	a_758_306##11	2.50268e-17
C43	a_509_392##14	S1#5	2.55242e-18
C44	A3#5	A3#6	4.19744e-17
C45	a_509_392##3	a_758_306##16	5.98816e-17
C46	A3#7	A3#1	4.18537e-17
C47	A2#6	a_1191_121##3	2.51515e-17
C48	a_1191_121##2	A3#6	5.70135e-18
C49	a_1191_121#	S1#8	1.69589e-17
C50	a_509_392##6	VPWR#19	3.16647e-18
C51	VPWR#10	VPWR#13	5.69939e-17
C52	a_509_392##12	S1#1	3.2587e-17
C53	a_114_126##2	A0#2	1.6602e-18
C54	VGND#1	a_2199_74##6	2.42019e-18
C55	a_1191_121##2	a_2489_347##5	7.14391e-20
C56	a_758_306##6	S0#9	2.14862e-19
C57	X#4	a_2199_74##7	2.81889e-19
C58	a_1285_377##2	A2#2	1.20918e-18
C59	VGND#14	a_2199_74#	2.84073e-19
C60	a_2199_74##24	S1#8	7.0928e-19
C61	a_1191_121##7	a_758_306##11	2.67495e-17
C62	VGND#20	A0#2	1.03311e-18
C63	a_2199_74##22	S1#1	1.32058e-18
C64	VPWR#9	a_758_306##8	3.65637e-18
C65	A1#2	A0#5	3.9908e-19
C66	a_299_126##2	A0#2	1.00653e-17
C67	a_509_392##14	S1#4	1.4805e-17
C68	a_509_392##6	a_758_306##17	5.3694e-17
C69	S0#5	a_758_306##6	4.95134e-18
C70	A2#3	A3#7	2.11337e-17
C71	S1#4	S1#3	6.38978e-18
C72	VGND#2	X#1	1.36893e-17
C73	a_1465_377#	A2#2	3.80085e-19
C74	X#1	a_2199_74##6	3.09805e-17
C75	a_1278_121##2	S0#11	2.44181e-18
C76	S1#8	a_509_392##12	1.84504e-17
C77	VGND#11	a_114_126##2	3.32636e-18
C78	a_2199_74##16	a_2489_347##10	7.84142e-20
C79	S0#5	a_758_306##9	3.09876e-19
C80	a_2489_347##8	X#4	1.46082e-18
C81	a_509_392##14	S1#3	2.18012e-17
C82	VGND#19	a_758_306##11	2.73133e-18
C83	a_114_126#	A0#2	4.008e-19
C84	A2#1	A3#5	3.35088e-17
C85	a_758_306##6	a_758_306##9	6.99319e-20
C86	a_1191_121##2	A3#5	7.30562e-19
C87	A2#9	A3#6	4.43756e-20
C88	a_1191_121##3	A2#2	6.85494e-19
C89	VGND#8	VGND#7	1.15638e-18
C90	a_2199_74##22	S1#8	8.08713e-17
C91	VGND#1	a_2199_74##8	3.18252e-19
C92	a_2199_74##26	a_2489_347##10	4.42304e-17
C93	a_1191_121#	VPWR#15	1.46953e-18
C94	a_1191_121##7	S0#11	2.95525e-18
C95	X#3	VPWR#2	1.34496e-19
C96	VGND#6	A3#6	3.89562e-18
C97	a_1191_121##8	a_2199_74##19	7.97095e-17
C98	VPWR#9	a_758_306##9	3.90875e-21
C99	a_1191_121##2	a_2489_347##4	1.033e-19
C100	a_2199_74##6	VGND#14	1.42294e-17
C101	a_758_306##2	a_758_306##6	4.08541e-18
C102	a_299_126##2	A1#3	6.48098e-20
C103	a_758_306##16	a_758_306##11	3.02536e-20
C104	a_2199_74##4	a_2199_74#	1.35235e-20
C105	a_1450_121##2	S0#9	2.42266e-18
C106	A2#5	A2#3	4.97585e-17
C107	VGND#10	VGND#11	1.04432e-16
C108	VGND#6	A3#5	1.77067e-18
C109	X#2	VGND#1	3.34716e-18
C110	VGND#21	A1#3	2.38955e-17
C111	VPWR#16	S1#8	6.48805e-19
C112	a_509_392##14	a_1191_121##2	8.65346e-17
C113	a_2489_347##8	S1#10	8.99082e-18
C114	a_1191_121##13	S0#5	3.2557e-19
C115	a_2199_74##4	a_2199_74##6	1.66791e-20
C116	a_299_126#	a_509_392##3	8.03612e-17
C117	VPWR#8	S0#3	7.82524e-20
C118	A1#3	a_114_126#	3.91682e-18
C119	VPWR#9	a_758_306##13	8.40529e-18
C120	a_299_126#	a_509_392##8	1.2746e-18
C121	VGND#10	VGND#9	1.44966e-16
C122	X#1	a_2199_74##8	1.79499e-18
C123	VGND#19	S0#11	4.46046e-17
C124	VGND#12	A1#3	2.36731e-17
C125	a_2199_74##4	a_2199_74##8	3.25983e-20
C126	a_2199_74##22	A3#1	8.15934e-19
C127	VPWR#12	A0#4	1.50187e-20
C128	X#5	a_2199_74##6	4.13425e-19
C129	a_509_392##6	a_116_392#	3.93821e-17
C130	a_2489_347##8	VPWR#15	2.86445e-17
C131	a_2199_74##4	VPWR#4	2.39526e-19
C132	VGND#11	a_509_392##10	2.06707e-17
C133	A2#4	A2#1	3.6972e-17
C134	a_509_392##14	A2#9	6.03739e-18
C135	a_2199_74##4	a_2199_74##12	7.51726e-19
C136	a_1191_121##7	a_758_306#	1.18118e-19
C137	a_1191_121##2	A2#1	9.29265e-20
C138	S0#1	A2#5	5.49419e-18
C139	VGND#16	a_1191_121##8	4.74887e-17
C140	S0#11	a_758_306##16	1.76983e-17
C141	A3#1	VPWR#16	1.65808e-17
C142	a_299_126##2	A0#4	9.74075e-19
C143	a_2199_74##4	S1#12	7.52601e-18
C144	VGND#14	a_2199_74##8	2.73591e-17
C145	a_1191_121##2	S1#1	1.90303e-19
C146	a_2489_347##7	S1#3	1.50039e-21
C147	a_1191_121##13	S0#3	8.50209e-18
C148	a_1191_121##8	a_1191_121##2	1.40947e-18
C149	a_2199_74##4	a_2489_347#	1.02457e-19
C150	a_509_392##14	A2#8	4.40101e-18
C151	a_509_392##11	a_509_392##6	5.17037e-18
C152	a_1191_121##2	VPWR#6	2.4324e-19
C153	a_1285_377##2	A3#1	4.75467e-17
C154	a_2199_74##26	a_1191_121#	6.37927e-17
C155	a_2489_347##8	a_2489_347##3	8.95649e-19
C156	X#2	X#1	4.65045e-19
C157	X#1	a_2199_74##12	3.16008e-19
C158	a_509_392##3	S0#11	2.17132e-18
C159	a_1191_121##6	S0#4	1.66394e-18
C160	a_509_392##14	A2#6	5.45756e-18
C161	S0#15	S0#1	4.18177e-17
C162	S1#11	S1#12	2.23664e-19
C163	X#5	a_2199_74##8	2.92283e-17
C164	VGND#11	A0#3	1.222e-18
C165	VPWR#9	S0#12	2.10332e-18
C166	VPWR#16	A3#7	3.44338e-19
C167	VPWR#6	A3#4	4.38156e-20
C168	a_758_306##10	a_1285_377#	2.63281e-18
C169	a_758_306##16	a_758_306#	1.18336e-18
C170	S1#11	a_2489_347#	1.83916e-17
C171	a_299_126##2	A1#2	5.4093e-20
C172	VGND#2	X#5	4.09583e-19
C173	a_2489_347##8	a_2489_347##10	3.13452e-18
C174	A0#4	A0#2	3.03812e-18
C175	VPWR#12	A1#2	3.3735e-21
C176	a_1450_121##2	S0#5	1.57876e-19
C177	a_1191_121##2	A2#4	7.11492e-20
C178	a_509_392##2	a_509_392##3	2.72774e-18
C179	a_758_306##10	a_1191_121##9	4.67252e-17
C180	a_116_392#	a_509_392##11	9.84857e-17
C181	VPWR#4	S1#11	9.79365e-19
C182	VGND#14	a_2199_74##12	1.13207e-18
C183	a_1285_377#	VPWR#9	4.75574e-17
C184	A2#9	a_1191_121##2	2.02507e-17
C185	a_509_392#	a_299_126#	6.4922e-17
C186	a_2199_74##11	a_2199_74##7	3.98083e-18
C187	a_1285_377##2	A3#7	5.61174e-17
C188	VGND#2	a_2199_74##11	2.07544e-20
C189	a_2199_74##14	a_2199_74##11	9.4311e-19
C190	a_1191_121##6	A2#6	1.61526e-18
C191	a_758_306##10	VPWR#19	7.58135e-18
C192	a_2199_74##24	a_2199_74##26	2.59148e-18
C193	a_1191_121##2	S1#8	2.57103e-18
C194	a_758_306##8	S0#9	6.05827e-19
C195	VGND#15	a_2199_74##8	3.44516e-19
C196	VGND#7	VGND#5	1.1306e-18
C197	a_758_306##8	S0#15	4.31968e-17
C198	a_1191_121##2	a_2199_74##19	5.4437e-17
C199	a_509_392##3	a_758_306#	4.76489e-17
C200	a_1465_377#	S0#3	9.59253e-19
C201	VPWR#16	A2#3	1.48001e-19
C202	A3#7	VPWR#17	2.77889e-17
C203	VGND#4	a_2199_74##4	2.69106e-19
C204	VPWR#9	a_758_306##2	1.11125e-20
C205	a_1191_121##6	S0#10	3.30178e-17
C206	X#5	a_2199_74##12	4.0076e-17
C207	X#2	VGND#14	1.87619e-17
C208	a_509_392##15	a_2489_347##3	6.92388e-19
C209	VPWR#11	a_758_306##5	4.30248e-20
C210	a_116_392#	a_296_392##2	7.07847e-17
C211	VPWR#3	a_2199_74##5	9.79e-20
C212	a_1285_377#	VPWR#8	1.03999e-16
C213	A0	a_758_306##3	1.17416e-18
C214	a_299_126#	a_758_306#	1.13943e-17
C215	A3#4	S1#4	2.52352e-18
C216	a_509_392##5	a_1191_121##6	3.19846e-18
C217	a_1285_377##2	A2#3	2.74803e-17
C218	a_758_306##6	VPWR#19	2.00393e-17
C219	a_1450_121##2	S0#3	3.03227e-17
C220	a_1465_377#	A3#7	1.75464e-18
C221	S0#5	a_758_306##2	2.82296e-19
C222	S0#10	S0#4	3.4878e-17
C223	VGND#11	A0#5	1.12763e-18
C224	VGND#2	a_2199_74#	9.76388e-19
C225	A0	A0#4	1.98021e-17
C226	a_1191_121#	a_2199_74##24	1.06765e-16
C227	a_114_126##2	a_299_126#	4.40734e-17
C228	a_509_392##15	a_2199_74##24	1.1e-18
C229	VPWR#3	a_2199_74##9	1.5023e-19
C230	a_2199_74##26	a_2489_347##8	1.1455e-18
C231	a_509_392##2	a_299_126#	3.00128e-17
C232	a_758_306##13	a_758_306##8	4.28141e-17
C233	A0	A1#2	1.23021e-17
C234	a_758_306##6	a_758_306##17	3.99579e-19
C235	a_2199_74##4	X#3	7.39623e-17
C236	VGND#14	S1#12	8.98664e-20
C237	VGND#15	VGND#2	1.37626e-18
C238	a_509_392##5	a_1191_121##5	5.47028e-17
C239	S1#6	a_2489_347##6	1.3637e-17
C240	a_509_392##3	a_758_306##7	1.73762e-18
C241	VGND#3	VGND#1	6.21263e-17
C242	a_509_392##5	S0#13	3.06328e-19
C243	A2#3	VPWR#17	2.31028e-17
C244	a_2199_74##12	VGND#15	1.93885e-17
C245	VGND#10	a_758_306##11	3.0496e-18
C246	X#2	a_2199_74##4	5.76338e-17
C247	VPWR#3	a_2199_74##13	2.75004e-18
C248	a_2489_347##2	VPWR#4	7.35627e-19
C249	a_296_392##2	a_509_392##11	6.37925e-17
C250	a_1191_121##2	A3#1	2.35254e-17
C251	a_116_392#	a_509_392##9	2.45701e-19
C252	a_1191_121##9	VPWR#9	1.19183e-17
C253	VGND#16	a_1191_121##2	3.22151e-17
C254	a_509_392##5	S0#7	1.77564e-19
C255	VGND#6	A3#4	2.93111e-19
C256	VGND#3	X#1	1.42374e-17
C257	a_2199_74##16	a_2489_347##8	5.92813e-19
C258	a_1278_121##2	S0#9	1.81655e-19
C259	A1#3	A0#4	1.73745e-18
C260	VPWR#3	a_2199_74##14	5.02298e-18
C261	a_1285_377##2	A2#5	2.64318e-17
C262	a_1465_377#	A2#3	2.90698e-17
C263	a_758_306##16	S0#13	2.15818e-20
C264	A1#3	A1#2	1.2483e-17
C265	a_299_126#	a_758_306##7	3.73662e-17
C266	S0#3	A2#4	1.46738e-17
C267	S0#12	a_758_306##13	7.59014e-18
C268	a_1191_121#	a_509_392##12	4.17227e-19
C269	VGND#10	a_758_306#	2.06096e-18
C270	a_1191_121##6	a_758_306##12	2.57963e-17
C271	a_509_392##6	a_299_126#	5.38982e-22
C272	a_1450_121#	VGND#16	5.78031e-17
C273	VGND#4	S1#11	3.56331e-19
C274	a_114_126##2	a_509_392#	3.21229e-17
C275	a_2489_347##7	a_2199_74##12	1.87852e-19
C276	VPWR#3	S1#9	4.76237e-18
C277	S1#9	a_2199_74##11	1.64996e-18
C278	VPWR#15	a_2489_347##3	1.86823e-19
C279	a_758_306##12	S0#10	3.42587e-17
C280	VGND#10	a_758_306##7	1.30354e-18
C281	VPWR#11	a_758_306##4	6.40462e-20
C282	a_509_392##9	a_509_392##11	4.54378e-18
C283	VGND#19	S0#7	2.46693e-20
C284	VGND#3	X#5	2.91754e-17
C285	a_509_392##2	a_509_392#	2.94648e-19
C286	a_116_392#	A0#2	7.55168e-18
C287	a_509_392##3	S0#13	7.64373e-19
C288	VGND#2	a_2199_74##6	5.85877e-18
C289	X#2	a_2199_74#	2.06454e-17
C290	VGND#11	A1#5	1.12602e-18
C291	a_758_306##7	a_509_392#	1.30678e-17
C292	VGND#10	S0#13	1.2115e-19
C293	S1#12	VGND#15	1.38302e-17
C294	a_114_126#	A0#4	4.19101e-19
C295	a_1465_377#	A2#5	3.56887e-17
C296	a_1191_121##3	A2#3	1.77439e-17
C297	VPWR#5	S1#6	1.05991e-19
C298	a_2199_74##17	a_2489_347##3	2.00262e-19
C299	A3#3	A3#6	2.71332e-18
C300	a_758_306##5	S0#12	5.7144e-18
C301	VGND#10	S0#7	5.08971e-17
C302	a_1191_121##2	A3#7	1.68627e-17
C303	a_758_306##16	S0#7	8.57877e-20
C304	a_2199_74##24	a_509_392##12	4.10311e-17
C305	a_1191_121#	a_2199_74##22	3.05332e-17
C306	a_1450_121#	a_1191_121##2	8.7022e-18
C307	VGND#2	a_2199_74##7	9.3492e-20
C308	VGND#3	a_2489_347##7	1.03187e-17
C309	a_299_126#	S0#13	2.43067e-17
C310	a_509_392##15	S1#3	4.14245e-19
C311	a_296_392##2	a_509_392##9	6.43919e-17
C312	a_299_126#	a_116_392#	1.04853e-16
C313	VGND#10	A0#3	2.8636e-18
C314	a_114_126##2	a_758_306##7	1.27378e-18
C315	A2#5	VPWR#18	3.09347e-17
C316	a_1465_377##2	A2#3	7.48522e-20
C317	a_116_392#	A1#3	7.30657e-20
C318	VGND#17	VGND#16	1.96897e-18
C319	VPWR#20	A0#2	1.18092e-18
C320	a_296_392#	A0#4	2.22341e-19
C321	a_1285_377#	A3#7	2.44077e-19
C322	VGND#4	a_2199_74##8	5.25371e-19
C323	S1#12	a_2489_347##7	2.10781e-17
C324	VPWR#8	VPWR#7	2.22202e-18
C325	a_1191_121##6	a_758_306##11	1.35435e-18
C326	a_296_392#	A0#2	2.13619e-18
C327	a_509_392##14	a_2489_347##5	4.98039e-19
C328	a_509_392##3	S0#7	2.32286e-18
C329	a_758_306##11	a_758_306##12	3.37643e-17
C330	S0#13	a_509_392#	1.61298e-17
C331	a_758_306##4	a_758_306##5	4.27799e-17
C332	a_1191_121##3	A2#5	1.48642e-17
C333	A2#6	S0#9	2.4102e-20
C334	a_2489_347##8	a_2199_74##4	3.4473e-17
C335	a_509_392##2	a_114_126##2	1.61799e-17
C336	VGND#10	a_1191_121##6	1.04954e-18
C337	A2#2	A3#5	5.01762e-18
C338	a_509_392##10	a_758_306##7	1.97943e-19
C339	a_509_392##14	a_2489_347##4	1.76597e-18
C340	a_2199_74##22	a_2199_74##24	2.59148e-18
C341	a_116_392##2	A0#2	7.30814e-18
C342	VPWR#11	S0#14	1.74287e-19
C343	a_1278_121##2	S0#5	2.01603e-17
C344	VGND#10	a_1191_121##5	1.33109e-18
C345	S0#9	a_1465_377##2	2.57489e-19
C346	a_2199_74##24	a_2489_347##8	1.58929e-18
C347	a_2199_74##17	S1#4	7.13037e-20
C348	X#2	a_2199_74##6	2.02115e-17
C349	VGND#10	A1#4	3.01432e-18
C350	S0#3	S0#4	3.25995e-17
C351	VGND#2	a_2199_74##8	8.21448e-18
C352	a_1465_377##2	A2#5	3.97565e-19
C353	a_299_126#	S0#7	1.41325e-17
C354	a_509_392##14	S1#1	1.15288e-17
C355	a_1285_377#	A2#3	4.01818e-19
C356	a_114_126##2	a_509_392##10	6.07504e-17
C357	S0#13	a_114_126##2	1.59854e-17
C358	a_1191_121##2	A2#3	3.28404e-19
C359	a_299_126##2	a_299_126#	2.22271e-18
C360	a_2199_74##16	S1#11	5.65977e-17
C361	a_1450_121#	VGND#17	6.52189e-17
C362	S0#14	a_758_306##4	4.04467e-17
C363	A2#6	S0#4	1.63189e-19
C364	a_509_392##14	S1#8	7.72113e-18
C365	a_1191_121##3	S0#1	4.09315e-17
C366	S0#3	a_1191_121##3	1.22935e-17
C367	a_2489_347##7	a_2489_347#	1.3167e-18
C368	VGND#11	a_114_126#	6.94373e-17
C369	a_1191_121##10	A2#5	5.29107e-19
C370	A1#3	a_116_392##2	3.43075e-17
C371	a_1191_121##5	A2#5	1.38581e-19
C372	a_509_392#	S0#7	7.54235e-19
C373	VPWR#20	a_509_392##9	3.20475e-17
C374	a_296_392#	a_296_392##2	1.31991e-18
C375	a_758_306##17	VPWR#9	1.44785e-17
C376	VGND#5	a_2489_347##3	4.99344e-22
C377	a_509_392##15	S1#12	3.51795e-19
C378	a_1191_121##6	S0#11	3.48843e-19
C379	a_2199_74##22	a_509_392##12	4.11972e-17
C380	VGND#4	a_2199_74##12	2.26296e-18
C381	S0#11	a_758_306##11	5.04994e-18
C382	VGND#5	a_2199_74##17	5.5568e-17
C383	a_509_392##10	S0#13	4.2047e-19
C384	VGND#5	S1#6	2.79133e-19
C385	A1#3	VPWR#13	5.99438e-18
C386	a_509_392##10	a_509_392##2	2.18708e-18
C387	a_1465_377##2	S0#1	4.36029e-17
C388	a_509_392##5	S0#5	3.1992e-19
C389	a_299_126##2	a_758_306##7	2.40512e-19
C390	a_1285_377#	A2#5	2.46651e-18
C391	a_1278_121##2	S0#3	2.96644e-18
C392	a_1191_121##6	a_1191_121##13	2.97315e-18
C393	a_2489_347##8	S1#11	5.6535e-17
C394	VPWR#12	S0#8	1.83009e-20
C395	X#3	a_2199_74##7	9.86489e-18
C396	a_299_126#	A0#3	7.53214e-20
C397	a_2199_74##17	S1#3	5.44864e-19
C398	a_2199_74##17	a_509_392##14	2.32673e-17
C399	S0#8	S0#14	4.91725e-17
C400	a_2489_347#	a_2199_74##21	1.23997e-17
C401	a_114_126##2	VGND#20	3.31827e-17
C402	VPWR#6	A3#1	3.0252e-18
C403	a_2489_347##3	S1#9	1.64757e-18
C404	a_114_126##2	S0#7	5.22448e-17
C405	a_1450_121#	A2#9	2.63947e-17
C406	VGND#4	S1#10	6.73413e-20
C407	a_1191_121##10	S0#1	1.37694e-18
C408	S0#5	S0#10	1.80966e-17
C409	VPWR#8	A2#2	4.85389e-20
C410	a_2199_74##17	S1#12	1.17146e-19
C411	VPWR#11	S0#8	9.8434e-19
C412	VGND#2	a_2199_74##12	1.12004e-18
C413	a_509_392##14	a_1191_121##8	2.39065e-18
C414	a_1450_121#	a_1278_121#	3.73829e-17
C415	VPWR#6	A3#7	1.68148e-18
C416	a_1191_121##2	A2#5	3.7892e-19
C417	VPWR#2	VPWR#1	8.05022e-19
C418	VPWR#7	A2#2	3.99538e-19
C419	a_2489_347##7	a_2489_347##6	9.36979e-20
C420	A2#6	S0#10	9.46864e-20
C421	a_1465_377##2	S0#15	3.41661e-17
C422	a_509_392##8	VPWR#10	1.05967e-16
C423	a_1285_377#	S0#1	1.7631e-17
C424	a_2199_74##19	a_509_392##14	6.9018e-17
C425	a_509_392##10	S0#7	3.43579e-17
C426	a_509_392##5	a_758_306##3	1.19319e-19
C427	a_509_392##15	a_2489_347#	2.79703e-17
C428	VGND#4	a_2199_74##17	2.61058e-17
C429	A0#1	S0#8	3.93701e-18
C430	a_1191_121##7	S0#5	6.54166e-18
C431	a_299_126##2	S0#13	3.84654e-19
C432	a_758_306#	S0#11	5.42249e-18
C433	a_1191_121##5	S0#1	8.05811e-19
C434	VPWR#2	a_2199_74##5	6.22645e-19
C435	S1#4	a_1191_121##8	1.11452e-18
C436	a_1278_121##2	a_758_306##9	8.46549e-20
C437	a_509_392##14	VGND#16	8.7961e-18
C438	a_509_392##5	a_758_306##2	1.80173e-17
C439	a_296_392#	VPWR#20	6.11728e-17
C440	S0#15	a_1191_121##10	2.11397e-17
C441	VGND#5	S1#4	1.98173e-19
C442	VGND#4	VGND#2	1.10481e-18
C443	a_509_392##10	VGND#20	1.87157e-17
C444	VGND#4	S1#12	5.77645e-18
C445	a_114_126##2	a_299_126##2	8.48583e-17
C446	a_116_392##2	a_296_392##2	6.23413e-18
C447	VGND#5	a_1191_121##8	8.83721e-17
C448	a_114_126##2	A0#3	1.40004e-17
C449	a_509_392##6	VPWR#9	2.43257e-17
C450	a_1191_121##6	a_1450_121##2	4.12671e-17
C451	S0#7	VGND#20	3.61977e-18
C452	a_2489_347##3	a_2199_74##26	6.79779e-18
C453	S1#10	a_2199_74##11	1.4869e-17
C454	S0	A3#4	2.41965e-21
C455	VPWR#7	VPWR#5	7.01534e-19
C456	a_2489_347##2	a_2489_347##8	2.81361e-18
C457	a_509_392##14	a_1450_121#	1.02713e-17
C458	S0#3	a_1465_377##2	3.13204e-18
C459	S0	S0#9	9.00189e-18
C460	X#1	VGND#1	3.83514e-17
C461	a_758_306##6	S0#10	4.90451e-20
C462	a_2199_74##17	a_2489_347#	9.257e-19
C463	S0#11	a_758_306##10	2.49154e-18
C464	a_1278_121#	VGND#17	3.40529e-17
C465	a_1465_377##2	a_758_306##8	9.47801e-19
C466	a_1285_377#	S0#15	1.37077e-17
C467	a_758_306##9	S0#10	6.20378e-19
C468	VPWR#12	A0#1	6.02897e-19
C469	A0#6	A0#1	3.34318e-17
C470	a_758_306##2	S0#12	1.7085e-18
C471	S0	S0#3	3.85557e-17
C472	a_509_392##14	VGND#17	3.10065e-18
C473	a_758_306##6	a_758_306##12	6.90505e-20
C474	VGND#4	a_2489_347##3	3.77027e-20
C475	S0	a_758_306##9	6.508e-19
C476	a_509_392##10	A0#3	1.9362e-18
C477	a_2489_347##7	S1#7	7.45196e-20
C478	VGND#2	S1#12	2.28759e-19
C479	a_299_126##2	S0#7	1.20254e-17
C480	VPWR#21	VPWR#20	2.1297e-18
C481	a_758_306##3	a_758_306##2	4.96104e-18
C482	a_758_306##6	a_758_306##11	2.21675e-19
C483	VPWR#11	A0#1	5.72672e-18
C484	a_758_306##8	a_1191_121##10	2.33291e-17
C485	a_1191_121##9	S0#15	1.79433e-19
C486	a_509_392##15	a_2489_347##6	3.78694e-17
C487	a_509_392##14	a_1278_121#	4.3307e-18
C488	X#6	VPWR#2	1.4945e-17
C489	a_299_126##2	a_116_392#	3.33897e-17
C490	a_2199_74##4	a_2199_74##11	3.04272e-17
C491	S1#10	a_2199_74##12	6.03584e-19
C492	a_758_306##7	a_758_306#	3.58733e-17
C493	S0#13	S0#11	4.14871e-20
C494	S1#3	a_1191_121##8	3.27164e-19
C495	a_758_306##6	S0#11	2.65177e-17
C496	X#2	a_2199_74##7	5.41673e-18
C497	a_116_392##2	A0#4	6.64012e-19
C498	a_299_126##2	a_509_392##10	6.69722e-19
C499	VGND#21	a_114_126##2	4.0678e-18
C500	a_114_126##2	A0#5	7.06239e-19
C501	VGND#8	A2#2	7.30838e-19
C502	a_1191_121##5	S0#15	1.96615e-17
C503	S0#5	a_758_306##12	1.80857e-17
C504	A1#1	A0#6	4.25234e-17
C505	A0#3	VGND#20	2.18947e-17
C506	a_758_306##6	a_758_306#	6.33544e-19
C507	a_1285_377#	a_758_306##8	5.31977e-17
C508	A2#6	S0#3	5.05215e-18
C509	a_1450_121#	A2#8	2.00864e-17
C510	VGND#7	A2#2	8.20671e-20
C511	VGND#21	S0#7	6.46655e-20
C512	VPWR#2	a_2199_74##9	4.554e-18
C513	VGND#5	S1#3	7.71466e-20
C514	VGND#4	a_2489_347#	4.58842e-18
C515	a_2199_74##4	a_2199_74##7	3.6223e-17
C516	VPWR#21	a_296_392#	5.92154e-17
C517	a_1191_121##6	a_1191_121##11	1.81249e-18
C518	a_116_392##2	VPWR#20	2.10026e-18
C519	a_2199_74##17	a_2489_347##6	3.00382e-17
C520	VGND#14	VGND#1	1.01212e-18
C521	S0#7	S0#11	1.09157e-19
C522	VPWR#10	a_758_306##3	1.23473e-20
C523	VGND#10	a_509_392##2	9.77581e-17
C524	a_1191_121##10	a_758_306##13	6.22131e-19
C525	a_1191_121##9	a_758_306##8	4.03947e-19
C526	a_758_306##17	S0#15	1.59596e-19
C527	a_509_392##5	a_758_306##8	9.41065e-19
C528	VGND#19	S0#5	9.08379e-18
C529	a_2489_347##2	S1#1	4.23858e-19
C530	a_299_126##2	A0#3	3.58084e-17
C531	a_116_392##2	A1#2	2.20034e-19
C532	a_1285_377#	S0#9	5.20463e-20
C533	a_509_392##14	a_1450_121##2	5.91382e-18
C534	VGND#7	VGND#16	4.33174e-19
C535	A1#6	A1#1	4.14889e-17
C536	a_2199_74##19	S1#4	2.4093e-17
C537	VPWR#10	a_758_306##2	9.29676e-21
C538	a_114_126#	S0#7	1.17993e-18
C539	S1#6	a_2489_347##4	1.37251e-17
C540	a_509_392##5	a_758_306##13	3.38197e-18
C541	VPWR#12	A0#6	7.13627e-18
C542	a_509_392##15	S1#7	9.59064e-18
C543	a_299_126##2	VGND#20	2.76055e-18
C544	VPWR#9	a_758_306##10	1.0156e-19
C545	a_509_392##15	a_2489_347##4	4.24096e-19
C546	a_1285_377#	a_758_306##13	4.3503e-17
C547	a_1285_377##2	VPWR#16	5.24985e-17
C548	S0#13	a_758_306##7	3.69912e-17
C549	S0#7	a_758_306#	1.19579e-17
C550	S1#6	S1#1	2.17857e-18
C551	a_1191_121#	a_2489_347##3	1.23908e-18
C552	a_116_392##2	a_296_392#	8.22372e-17
C553	a_509_392##5	S0#12	4.02432e-18
C554	a_2199_74##4	S1#10	1.65847e-17
C555	VGND#21	A0#3	2.95056e-18
C556	VPWR#11	A0#6	4.98861e-19
C557	A0#2	S0#7	5.22896e-18
C558	VPWR#10	a_758_306##13	4.04102e-18
C559	a_1450_121#	A2#6	1.00324e-17
C560	a_1191_121##5	a_758_306##8	1.5147e-17
C561	VGND#6	a_1450_121#	1.32696e-17
C562	a_1191_121##9	a_758_306##13	7.53565e-17
C563	a_1191_121##10	S0#12	6.27794e-20
C564	a_758_306##17	a_758_306##8	1.93341e-19
C565	a_2199_74##17	a_2489_347##4	2.54155e-19
C566	a_509_392##5	a_758_306##5	7.64547e-18
C567	a_1278_121#	VGND#18	3.25651e-18
C568	a_1191_121##13	VGND#17	5.47229e-20
C569	a_2199_74##17	S1#7	4.79218e-17
C570	VPWR#10	S0#12	1.86595e-18
C571	S0#7	a_758_306##7	1.55858e-17
C572	VGND#10	S0#5	2.37894e-17
C573	A0#5	a_299_126##2	1.25472e-17
C574	VGND#14	X#1	3.60545e-17
C575	a_1191_121##6	a_1278_121##2	8.41363e-17
C576	VPWR#2	a_2199_74##13	5.05429e-18
C577	a_114_126#	A0#3	1.13855e-17
C578	a_509_392##5	a_758_306##4	7.20785e-19
C579	a_2199_74##19	a_2489_347##6	1.41923e-19
C580	VPWR#19	a_758_306##13	3.4348e-18
C581	a_1285_377#	S0#12	1.9094e-18
C582	A3#3	S1#8	1.52541e-19
C583	VGND#4	a_2489_347##6	4.51996e-18
C584	A1#3	S0#7	5.05455e-19
C585	VPWR#10	a_758_306##5	5.71661e-18
C586	a_116_392##2	VPWR#21	8.5102e-17
C587	a_2199_74##19	S1#3	5.63151e-20
C588	a_114_126#	a_509_392##10	2.64506e-18
C589	a_1191_121#	S1#4	6.50282e-20
C590	S0#5	a_758_306##11	2.14321e-17
C591	a_509_392##15	S1#5	5.56863e-19
C592	a_509_392##5	S0#14	1.15161e-20
C593	a_509_392##8	a_116_392#	2.43419e-17
C594	VPWR#10	a_758_306##4	6.08584e-18
C595	S0#7	S0#13	5.06562e-17
C596	VGND#21	A0#5	3.88771e-17
C597	a_1191_121##9	S0#12	1.63308e-18
C598	a_758_306##17	a_758_306##13	5.85932e-19
C599	VGND#7	a_1450_121#	1.34766e-18
C600	a_2199_74##16	VGND#15	4.58654e-17
C601	S1#7	a_1191_121##8	1.5614e-17
C602	a_509_392##5	S0#8	6.46966e-21
C603	VPWR#10	S0#14	6.05753e-18
C604	VPWR#12	A1#1	5.24538e-18
C605	a_2489_347##8	VPWR#4	1.17412e-18
C606	VGND#10	a_758_306##3	9.76094e-20
C607	a_758_306##6	VPWR#9	1.08213e-18
C608	VGND#8	VGND#17	2.02424e-18
C609	VPWR#19	S0#12	6.84107e-17
C610	a_1191_121##2	a_1191_121#	8.75186e-19
C611	a_758_306##16	S0#5	6.86129e-18
C612	VGND#5	S1#7	4.61364e-18
C613	a_1278_121#	a_1191_121##13	4.73325e-17
C614	a_299_126##2	A1#5	8.05365e-19
C615	VPWR#13	VPWR#21	2.00319e-18
C616	a_1191_121##5	a_758_306##13	9.27177e-19
C617	VGND#9	a_758_306##10	1.11414e-18
C618	a_2199_74##17	S1#5	3.49693e-19
C619	VPWR#10	S0#8	6.46423e-18
C620	VGND#10	a_758_306##2	3.84291e-19
C621	a_114_126#	A0#5	2.02113e-17
C622	VPWR#4	a_2199_74##14	2.88355e-18
C623	a_1285_377##2	VPWR#17	2.12929e-18
C624	X#4	VPWR#2	1.34496e-19
C625	a_296_392##2	VPWR#11	1.03224e-18
C626	X#5	X#1	2.66468e-18
C627	a_2199_74##4	X#1	2.53882e-18
C628	VGND#21	a_299_126##2	2.97572e-17
C629	a_2199_74##19	S1#7	1.23058e-18
C630	a_114_126#	VGND#20	2.05601e-17
C631	a_1191_121#	S1#3	1.2785e-19
C632	S1#3	a_2489_347##4	9.89477e-19
C633	S0#12	a_758_306##17	2.0972e-17
C634	VPWR#10	A0#1	4.73165e-19
C635	a_1191_121##7	a_1191_121##6	2.34428e-18
C636	a_509_392##5	a_1278_121#	1.84419e-18
C637	a_2199_74##16	a_2199_74##12	9.87086e-19
C638	a_2199_74##4	VGND#14	2.54309e-18
C639	a_1285_377#	S0#3	2.83986e-18
C640	VGND#9	S0#5	6.21741e-17
C641	a_2199_74##24	a_2489_347##3	3.17054e-18
C642	VGND#21	A1#5	3.29233e-17
C643	VPWR#2	a_2199_74##14	2.99535e-19
C644	VGND#2	X#2	3.16169e-19
C645	VPWR#10	A0#6	5.78869e-19
C646	VGND#12	A0#5	1.88608e-19
C647	a_758_306##4	a_758_306##2	3.03158e-18
C648	A0#3	S0#7	3.29584e-18
C649	VPWR#13	a_116_392##2	7.76528e-17
C650	a_509_392##8	a_509_392##11	5.48579e-20
C651	a_1191_121##8	S1#5	4.59813e-17
C652	a_509_392##6	S0#12	3.01613e-18
C653	a_2199_74##4	X#5	5.24025e-17
C654	VPWR#19	a_758_306##5	7.58151e-19
C655	X#3	a_2199_74##5	2.13357e-17
C656	S1#11	a_2489_347##3	3.5566e-17
C657	VPWR#10	A1#1	7.08168e-19
C658	a_2199_74##16	a_2489_347##7	7.00544e-17
C659	a_299_126##2	A1#4	6.64354e-19
C660	VPWR#12	A0#2	2.7155e-20
C661	a_1285_377##2	a_1465_377#	7.44817e-17
C662	a_509_392##5	a_1191_121##13	2.97345e-18
C663	a_2199_74##4	VGND#15	6.94671e-17
C664	a_1278_121#	a_1450_121##2	6.23807e-17
C665	a_114_126#	A1#5	2.75419e-17
C666	A3#3	a_1191_121##2	8.7781e-17
C667	VPWR#3	VPWR#1	6.70906e-17
C668	a_758_306##17	a_758_306##5	1.60122e-18
C669	VPWR#11	A0#2	2.39692e-20
C670	VPWR#10	A1#6	2.60606e-18
C671	a_2199_74##17	A3#6	7.89808e-20
C672	a_114_126#	a_299_126##2	2.22536e-17
C673	VGND#12	VGND#20	3.26389e-19
C674	a_2489_347##7	a_2199_74##4	4.85345e-17
C675	a_509_392##5	a_1450_121##2	6.41892e-18
C676	a_1285_377#	a_758_306##9	5.89531e-20
C677	VPWR#12	A1#6	2.35048e-18
C678	a_1191_121##5	S0#12	3.71211e-19
C679	X#5	VGND#14	4.1172e-17
C680	VGND#8	a_1278_121#	1.08038e-16
C681	a_2199_74##19	S1#5	4.03641e-17
C682	a_509_392##14	VPWR#6	1.68606e-18
C683	VGND#5	S1#5	5.14777e-18
C684	VPWR#3	X#6	1.76739e-17
C685	VGND#21	A1#4	9.45644e-19
C686	a_2199_74##19	A3#4	2.67656e-19
C687	VGND#9	a_758_306##6	2.87129e-18
C688	a_509_392##6	a_758_306##5	7.2187e-17
C689	VPWR#19	a_758_306##4	6.53077e-20
C690	VPWR#4	S1#9	5.13336e-18
C691	VGND#12	A1#5	8.54052e-19
C692	A2#9	A3#3	2.69723e-17
C693	VPWR#15	VPWR#2	2.2441e-19
C694	a_1191_121##9	S0#5	2.2139e-19
C695	VPWR#11	a_509_392##9	2.31504e-17
C696	a_1191_121##6	A2#2	3.04461e-19
C697	A0#5	A0#3	3.6457e-17
C698	a_2199_74##16	S1#12	3.05115e-17
C699	a_509_392##2	a_116_392#	9.79268e-20
C700	a_1191_121##8	A3#6	1.03191e-18
C701	a_1285_377##2	VPWR#18	4.75085e-19
C702	a_509_392##5	a_1278_121##2	5.90387e-18
C703	a_509_392##3	S0#5	1.42831e-17
C704	a_758_306##5	a_116_392#	2.05704e-17
C705	a_509_392##8	a_296_392##2	1.34163e-17
C706	X#2	X#3	3.43187e-18
C707	a_114_126#	A1#4	2.53282e-17
C708	VGND#16	S1#5	7.20383e-19
C709	X	a_2199_74##11	2.60732e-19
C710	VPWR#2	S1#9	8.38978e-20
C711	X#4	VPWR#3	3.57324e-17
C712	a_1450_121##2	VGND#18	2.23123e-18
C713	X	a_2199_74##7	2.18275e-17
C714	a_509_392##5	a_1191_121##7	4.92842e-18
C715	a_2489_347##10	VPWR#4	2.16601e-17
C716	VGND#7	A3#6	6.27325e-19
C717	VGND#21	a_114_126#	8.41159e-17
C718	S0#14	a_758_306##3	8.70577e-18
C719	X#3	a_2199_74##9	1.80919e-17
C720	X	S1#10	4.93448e-19
C721	a_2199_74##24	S1#3	1.34254e-19
C722	a_509_392##11	a_758_306##5	2.68184e-18
C723	a_509_392##6	a_758_306##4	1.72124e-18
C724	a_2199_74##16	a_2199_74##21	1.08844e-17
C725	VPWR#19	S0#14	3.54952e-20
C726	a_2199_74##4	VPWR#3	1.21272e-17
C727	a_1191_121##2	A2#2	2.30074e-18
C728	a_2489_347##7	S1#11	2.41933e-17
C729	a_509_392##5	VGND#19	6.75059e-18
C730	VPWR#3	VPWR#15	2.0815e-17
C731	VGND#7	a_1278_121#	7.01268e-18
C732	VGND#8	S0#5	7.67134e-18
C733	a_2199_74##19	A3#6	7.84357e-19
C734	VPWR#4	VPWR#2	8.82913e-19
C735	A1#3	VPWR#12	6.08407e-20
C736	S0#12	a_758_306##10	6.69683e-18
C737	VGND#15	VGND#14	9.55738e-19
C738	a_1191_121##6	S0	1.10879e-17
C739	VGND#12	A1#4	3.56358e-17
C740	A0	VGND#20	4.82263e-18
C741	a_1191_121##5	S0	4.05301e-17
C742	a_2489_347##2	S1#10	4.74969e-19
C743	A0	a_299_126##2	8.39493e-17
C744	VGND#3	a_2199_74##4	1.05508e-17
C745	a_1450_121#	S1#5	1.9064e-19
C746	S1#11	a_2199_74##21	2.98553e-19
C747	a_758_306##4	a_116_392#	2.7347e-17
C748	a_1191_121##3	a_1285_377##2	1.2847e-18
C749	a_509_392##5	a_758_306##16	3.52639e-19
C750	VGND#21	A0	2.573e-17
C751	VPWR#3	S1#11	2.60813e-18
C752	VPWR#3	a_2489_347##10	1.96891e-17
C753	VGND#11	A0#2	1.92634e-20
C754	a_114_126#	A0	3.19516e-18
C755	VGND#8	VGND#18	6.96308e-18
C756	VGND#5	A3#6	3.17074e-18
C757	a_2489_347##2	a_2489_347##3	2.77715e-17
C758	A1#5	A0#5	2.56994e-17
C759	A2#9	A2#2	1.47948e-17
C760	a_758_306##6	S0#12	3.31285e-17
C761	a_509_392##15	S1#11	9.34255e-18
C762	VGND#3	S1#11	8.01581e-18
C763	a_509_392##3	a_509_392##5	3.46093e-18
C764	VGND#3	X#4	3.1287e-18
C765	S0	A2#6	2.51764e-17
C766	VPWR#3	a_2489_347##2	2.08567e-18
C767	VPWR#4	a_2489_347##5	4.26853e-18
C768	a_509_392##11	a_758_306##4	5.37374e-17
C769	VPWR#3	a_2199_74##26	6.14817e-18
C770	VGND#16	A3#6	4.65163e-17
C771	a_509_392##5	VPWR#10	5.45118e-17
C772	VGND#12	VGND#21	2.44687e-18
C773	a_2199_74##16	a_2489_347#	2.92448e-17
C774	a_1191_121##13	a_1450_121##2	5.61865e-17
C775	a_1278_121##2	a_1278_121#	1.09693e-18
C776	VGND#3	a_2489_347##2	7.38528e-19
C777	S0#5	a_758_306#	7.11311e-18
C778	A2#8	A2#2	1.15193e-17
C779	VGND#3	VPWR#15	3.94109e-18
C780	VGND#10	a_509_392##5	6.88659e-19
C781	a_296_392##2	a_758_306##4	1.0928e-18
C782	a_116_392#	S0#14	2.37031e-17
C783	a_1465_377#	VPWR#18	2.69732e-18
C784	a_509_392##14	a_2489_347##2	3.83966e-18
C785	a_2199_74##6	a_2199_74#	3.9061e-17
C786	A2#6	A2#2	1.68646e-17
C787	VPWR#19	S0#5	1.18445e-18
C788	X#3	a_2199_74##13	5.27464e-19
C789	VGND#7	A3#5	4.50035e-18
C790	a_2199_74##26	VPWR#4	2.21004e-17
C791	VGND#15	X#5	6.30868e-17
C792	a_2199_74##16	a_509_392##15	4.86221e-17
C793	a_758_306##2	S0#11	1.80011e-19
C794	a_1450_121#	A3#6	1.45386e-17
C795	a_509_392##9	a_758_306##4	3.33597e-19
C796	a_1191_121##2	a_2199_74##22	1.24605e-16
C797	S0#14	a_509_392##11	3.93996e-17
C798	A1	VGND#12	3.95371e-17
C799	a_509_392##14	S1#6	4.96665e-17
C800	VGND#8	S0#3	2.57237e-17
C801	A1#4	A1#5	3.46209e-17
C802	VGND#10	a_1278_121##2	1.59282e-17
C803	a_758_306##17	S0#9	2.59343e-20
C804	a_296_392#	VPWR#12	9.92557e-18
C805	a_299_126##2	a_116_392##2	3.99925e-18
C806	VPWR#5	a_2489_347##4	1.83098e-18
C807	A0#2	S0#8	6.36052e-18
C808	VGND#12	a_114_126#	8.25925e-17
C809	a_509_392##14	A3#3	1.55584e-17
C810	S0#14	a_296_392##2	2.05556e-17
C811	VGND#10	a_1191_121##7	1.40047e-17
C812	X#3	VPWR#1	5.37478e-18
C813	VGND#16	A3#5	1.68528e-18
C814	VGND#11	A1#3	1.16186e-21
C815	a_116_392#	S0#8	2.6681e-17
C816	a_1191_121#	VPWR#5	7.45302e-17
C817	VGND#5	A3#5	7.17888e-19
C818	VPWR#10	a_299_126#	1.26329e-18
C819	a_1191_121##3	a_1465_377#	7.02437e-17
C820	a_1191_121##6	a_758_306##10	3.10384e-17
C821	a_2489_347##7	a_2489_347##8	1.67881e-18
C822	VGND#17	A3#6	5.19631e-19
C823	VGND#8	A2#1	9.8483e-19
C824	VGND#10	VGND#19	2.22022e-17
C825	a_2199_74##16	a_2489_347##6	7.76566e-19
C826	VPWR#4	a_2489_347##4	2.67516e-18
C827	a_758_306##10	a_1191_121##5	3.71538e-17
C828	a_509_392##9	S0#14	1.07056e-18
C829	a_509_392##11	S0#8	2.29879e-18
C830	VGND#6	A3#3	4.98592e-19
C831	a_296_392#	VPWR#11	9.35314e-18
C832	A1#2	A0#4	2.40995e-17
C833	VGND#21	a_116_392##2	5.1635e-18
C834	VGND#10	a_758_306##16	1.77455e-17
C835	a_1450_121##2	S0	9.36567e-17
C836	S1#6	a_2489_347##3	4.31953e-17
C837	a_1450_121#	A3#5	4.93526e-17
C838	a_509_392##2	a_758_306#	6.33219e-19
C839	a_2199_74##8	a_2199_74##6	3.62344e-17
C840	a_509_392##3	a_758_306##3	4.07627e-20
C841	a_296_392##2	S0#8	5.19889e-17
C842	a_2199_74##5	VPWR#1	3.12686e-17
C843	a_1450_121##2	A2#6	1.24356e-17
C844	a_116_392#	A0#1	1.40065e-18
C845	VGND#10	a_509_392##3	2.55308e-17
C846	A0	a_116_392#	2.95849e-17
C847	a_2199_74##17	a_2199_74##16	2.77799e-18
C848	VGND#7	A2#1	7.19972e-18
C849	a_1191_121##2	VPWR#16	9.16253e-17
C850	a_1191_121#	VPWR#4	3.95492e-17
C851	a_509_392##14	a_1191_121#	2.19087e-18
C852	a_1191_121##3	VPWR#18	2.36881e-18
C853	a_509_392##15	S1#6	8.7336e-17
C854	A3#4	S1#8	6.00899e-19
C855	S1#11	a_2489_347##2	4.22054e-17
C856	S1#3	a_2489_347##6	6.8885e-20
C857	a_1278_121##2	a_1191_121##13	2.96166e-17
C858	VGND#10	a_299_126#	1.185e-17
C859	a_296_392#	S0#14	1.17996e-19
C860	a_509_392##9	S0#8	5.52321e-17
C861	VGND#16	A2#1	1.90842e-19
C862	S1#6	S1#3	2.65393e-18
C863	A0	VPWR#20	3.47765e-18
C864	a_2199_74##22	S1#4	6.9163e-18
C865	X#5	a_2199_74##11	3.72804e-18
C866	a_2199_74##17	S1#6	1.67734e-18
C867	a_1450_121#	A3#4	3.96367e-18
C868	A0	a_296_392#	3.46184e-18
C869	X#6	a_2199_74##5	4.98518e-17
C870	a_509_392##14	a_2199_74##24	2.46175e-17
C871	A3#5	VGND#17	1.3229e-17
C872	S1#6	S1#11	3.04396e-18
C873	VPWR#5	S1#1	4.53677e-18
C874	X#3	X#6	2.08835e-19
C875	A0	a_116_392##2	1.14695e-16
C876	a_758_306##6	a_1191_121##6	1.18216e-18
C877	VPWR#20	S0#8	7.21163e-19
C878	VGND#5	A2#1	1.12262e-19
C879	VGND#14	a_2199_74##7	7.51117e-19
C880	a_296_392##2	A0#1	7.70068e-19
C881	a_509_392##5	a_758_306##10	1.81595e-17
C882	a_116_392#	A0#6	3.70717e-19
C883	S1#6	a_2489_347##2	4.31172e-17
C884	a_509_392##14	a_509_392##12	1.35627e-17
C885	VGND#7	S0#3	4.15264e-19
C886	VGND#10	a_114_126##2	1.94419e-17
C887	VGND#11	A0#4	8.70809e-21
C888	VGND#8	A2#4	9.56745e-18
C889	X#2	X	2.61998e-19
C890	a_2199_74##16	S1#7	1.42774e-19
C891	VPWR#1	a_2199_74##9	1.34148e-18
C892	VPWR#10	a_758_306##10	1.65538e-18
C893	a_1450_121#	A2#1	1.91784e-17
C894	a_509_392##3	a_758_306##2	7.95175e-18
C895	VPWR#14	a_2199_74##5	7.67688e-19
C896	a_509_392##5	a_758_306##6	4.33119e-17
C897	a_296_392#	S0#8	4.03713e-19
C898	a_509_392##9	A0#1	8.66645e-19
C899	a_509_392##14	a_2199_74##22	1.00563e-16
C900	VGND#10	a_509_392##10	5.21315e-17
C901	a_509_392##2	a_758_306##7	5.23803e-18
C902	VGND#10	a_758_306##10	7.25804e-18
C903	VPWR#10	a_758_306##6	3.29961e-18
C904	a_2199_74##22	S1#3	3.3031e-19
C905	a_509_392##5	A0#2	6.05967e-19
C906	VPWR#2	a_2199_74##7	1.45105e-19
C907	VGND#4	a_2199_74##16	1.1357e-16
C908	VPWR#3	VPWR#4	9.02224e-17
C909	VGND#9	a_758_306##2	1.21446e-19
C910	VGND	S1#4	4.03315e-19
C911	a_2199_74##12	a_2199_74##8	3.83136e-17
C912	VGND	S1#3	1.42306e-19
C913	VGND#10	VGND#20	1.9589e-17
C914	a_1191_121##2	a_1285_377##2	4.30968e-17
C915	VGND	A3#4	8.0258e-19
C916	a_509_392##14	VPWR#16	7.18753e-18
C917	X#6	a_2199_74##9	4.78213e-17
C918	VPWR#21	S0#8	6.15507e-20
C919	VGND#10	a_758_306##6	6.18951e-18
C920	A0#1	VPWR#20	3.18083e-17
C921	A1	VPWR#13	3.4206e-17
C922	a_296_392##2	A0#6	8.61273e-20
C923	VGND#7	A2#4	8.12812e-19
C924	VGND	S0#5	9.41023e-18
C925	a_116_392#	A1#1	2.37257e-19
C926	VGND	S0#3	1.01617e-17
C927	VPWR#7	S1#8	9.06007e-20
C928	VGND#17	A2#1	2.58369e-17
C929	VPWR#3	VPWR#2	6.44063e-17
C930	VGND#10	a_299_126##2	8.36262e-18
C931	a_509_392##14	a_1285_377##2	1.99625e-17
C932	A3#3	A2#2	4.29829e-18
C933	VPWR	VPWR#9	1.29164e-17
C934	VPWR#10	A1#3	1.87853e-18
C935	a_116_392##2	S0#8	1.17322e-19
C936	a_296_392#	A0#1	6.47745e-17
C937	VPWR	VPWR#8	1.12346e-16
C938	VPWR	VPWR#7	5.21789e-17
C939	S0	a_1191_121##3	9.2158e-17
C940	a_1191_121##3	a_1465_377##2	5.99731e-17
C941	VPWR#1	a_2199_74##13	2.79651e-19
C942	VPWR	VPWR#5	1.22996e-16
C943	a_299_126#	a_758_306##3	9.62243e-18
C944	a_1465_377#	a_1285_377#	6.60436e-18
C945	VPWR	VPWR#4	4.80189e-17
C946	a_2199_74##9	VPWR#14	2.7829e-17
C947	a_1191_121##2	S1#4	4.43668e-18
C948	VGND#10	VGND#21	9.64884e-18
C949	VGND#10	A1#3	1.91404e-18
C950	a_1450_121##2	A3#6	7.0579e-19
C951	a_116_392##2	VPWR#12	1.73545e-17
C952	a_509_392##14	VPWR#17	4.0026e-21
C953	X#3	VPWR#14	2.2781e-17
C954	VPWR#5	S1#8	5.12247e-18
C955	a_1450_121#	A2#4	1.71731e-17
C956	S0#3	A3#4	6.79376e-20
C957	a_2199_74##9	a_2199_74##5	4.68336e-17
C958	A3#3	S1#4	5.95759e-19
C959	VGND#12	VPWR#13	4.23876e-19
C960	VPWR#21	A0#1	1.64249e-18
C961	VPWR#20	A0#6	3.60043e-19
C962	VGND#10	a_114_126#	4.7596e-17
C963	A2#1	a_1278_121#	1.27348e-17
C964	X	VGND#1	3.06258e-17
C965	a_296_392##2	A1#1	8.16927e-20
C966	VGND#16	A3#3	7.5614e-18
C967	a_116_392#	A1#6	2.38067e-19
C968	VGND#8	S0#4	1.95414e-18
C969	a_509_392##2	S0#13	6.21359e-18
C970	a_509_392##14	a_1465_377#	1.60859e-17
C971	X#6	a_2199_74##13	1.50692e-18
C972	a_1191_121##13	A3#5	2.09474e-19
C973	X#4	a_2199_74##9	1.81116e-18
C974	VGND#15	a_2199_74##11	2.03587e-18
C975	VGND#10	VGND#12	7.27633e-17
C976	a_1191_121##6	S0#9	4.87238e-18
C977	a_116_392##2	A0#1	1.76082e-17
C978	a_1450_121#	A3#3	1.94835e-17
C979	A0	S0#13	3.52457e-19
C980	A0#6	a_296_392#	2.15403e-17
C981	VGND#9	a_1278_121##2	5.12639e-17
C982	a_1285_377##2	VPWR#6	1.67357e-17
C983	A0	S0#7	3.02308e-18
C984	VGND#17	A2#4	1.38556e-18
C985	a_1191_121##2	VPWR#17	3.98434e-18
C986	a_1285_377#	VPWR#18	3.84246e-19
C987	S1#12	a_2199_74##12	1.16277e-17
C988	VGND#5	S0#3	2.55904e-20
C989	a_509_392##8	a_758_306##3	8.12354e-20
C990	VPWR	a_1191_121##5	1.648e-18
C991	A3#3	A3#4	3.27142e-17
C992	VGND#5	a_2489_347##4	4.91021e-20
C993	a_2199_74##13	VPWR#14	3.23495e-17
C994	VPWR	a_1191_121##2	3.22271e-17
C995	VPWR#21	A0#6	4.43402e-17
C996	a_299_126#	a_758_306##2	5.37035e-18
C997	X#6	VPWR#1	7.50438e-17
C998	VPWR#15	a_2199_74##9	2.81749e-19
C999	a_509_392##14	a_1191_121##3	4.73203e-17
C1000	a_2199_74##22	A3#4	6.03302e-19
C1001	a_1450_121##2	A3#5	3.06908e-19
C1002	a_2199_74##13	a_2199_74##9	3.86872e-17
C1003	a_758_306##6	a_758_306##10	4.38871e-18
C1004	VPWR#7	A3#1	1.2431e-18
C1005	a_509_392##8	a_758_306##4	2.56134e-17
C1006	a_2199_74##11	VNB	4.65049e-17
C1007	a_2199_74##7	VNB	9.02043e-17
C1008	a_116_392##2	A0#6	2.0913e-17
C1009	a_509_392##14	a_1465_377##2	2.12455e-18
C1010	S1#10	VNB	2.79648e-17
C1011	a_2489_347##3	VNB	6.00327e-17
C1012	a_1278_121#	A2#4	4.09418e-17
C1013	S1#4	VNB	3.97582e-17
C1014	S1#3	VNB	2.78669e-17
C1015	a_509_392##14	VPWR#8	3.97576e-18
C1016	X#4	a_2199_74##13	7.49418e-17
C1017	A3#4	VNB	7.54343e-17
C1018	S0#9	VNB	2.31001e-17
C1019	X#4	X#3	1.75181e-18
C1020	S0#5	VNB	1.88575e-16
C1021	a_1191_121##13	A2#1	2.96956e-19
C1022	S0#3	VNB	1.73243e-16
C1023	a_1191_121##10	a_1465_377##2	3.76687e-17
C1024	VGND	VGND#9	1.95329e-17
C1025	a_1285_377#	a_1191_121##3	3.89061e-19
C1026	a_758_306##9	VNB	2.05243e-17
C1027	VGND	VGND#8	1.30018e-16
C1028	a_758_306##3	VNB	2.37829e-17
C1029	VPWR#5	A3#1	4.52294e-18
C1030	a_509_392##2	S0#7	2.12415e-17
C1031	VPWR#13	VPWR#12	7.06672e-19
C1032	a_758_306##2	VNB	3.29635e-17
C1033	VGND	VGND#7	5.98408e-17
C1034	A0#4	VNB	2.31152e-17
C1035	VPWR#13	A0#6	2.59902e-19
C1036	VGND	VGND#5	1.44526e-16
C1037	a_2489_347##3	S1#10	9.30735e-19
C1038	VGND#8	a_1278_121##2	4.40597e-17
C1039	A1#2	VNB	1.86739e-17
C1040	a_1450_121#	A2#2	2.16419e-18
C1041	A1#1	VPWR#21	1.97018e-17
C1042	VGND	VGND#4	4.01825e-17
C1043	X	VPWR#1	3.01299e-17
C1044	a_509_392##14	VPWR#7	4.32905e-18
C1045	a_758_306##17	a_758_306##2	1.45508e-19
C1046	VPWR#4	S1#10	6.06576e-20
C1047	VGND#8	S0#10	1.45909e-18
C1048	a_1450_121##2	a_1191_121##3	4.68406e-18
C1049	VPWR#14	a_2199_74##14	3.70183e-19
C1050	VGND	a_2199_74##16	1.10562e-17
C1051	VPWR#14	VPWR#1	2.24827e-18
C1052	VPWR#15	a_2199_74##13	1.36503e-18
C1053	a_509_392##14	a_1285_377#	5.61396e-19
C1054	S0#13	a_758_306##3	1.88414e-17
C1055	A2#4	VGND#18	8.37557e-18
C1056	a_116_392##2	A1#1	7.04515e-17
C1057	a_2199_74##4	X#6	2.41881e-18
C1058	S0#5	S0#9	4.38402e-19
C1059	a_509_392##14	VPWR#5	3.06492e-18
C1060	A3#3	S0#3	5.81402e-20
C1061	a_1191_121##2	a_1465_377#	2.58772e-21
C1062	VGND#9	a_1191_121##7	6.1344e-18
C1063	a_509_392##8	a_758_306##2	6.11655e-20
C1064	a_1278_121#	A2#2	1.23268e-18
C1065	VGND	a_1191_121##6	1.09877e-17
C1066	a_2489_347#	S1#12	4.36208e-18
C1067	a_2199_74##14	a_2199_74##13	4.7005e-17
C1068	VGND	a_1191_121##5	1.55006e-18
C1069	a_1450_121##2	A2#1	1.5952e-19
C1070	VPWR#8	A3#7	4.37667e-19
C1071	VGND	a_1191_121##2	7.88801e-18
C1072	VGND	A2#9	2.23424e-18
C1073	a_2199_74##4	VPWR#14	4.18879e-18
C1074	VGND	A2#8	1.71484e-18
C1075	S1#5	S1#3	1.54484e-19
C1076	X#4	a_2199_74##14	5.56113e-17
C1077	VPWR#13	A1#1	1.23306e-18
C1078	VGND	A2#6	2.11593e-18
C1079	a_1465_377##2	a_1285_377#	7.72968e-17
C1080	VPWR#7	VPWR#16	1.99508e-18
C1081	VPWR#21	A1#6	7.14071e-19
C1082	a_509_392##8	S0#14	2.4034e-17
C1083	a_1278_121#	S0#4	1.54579e-18
C1084	a_509_392##15	a_2489_347##7	1.93625e-18
C1085	a_1191_121##5	S0#9	5.39455e-18
C1086	a_2489_347##8	a_2199_74##14	1.144e-19
C1087	a_1191_121##7	a_1278_121##2	3.93129e-17
C1088	a_2199_74##4	X#4	4.8733e-17
C1089	VPWR#3	X#3	2.14133e-18
C1090	a_1191_121##13	A2#4	7.21331e-19
C1091	VPWR#7	A3#7	9.20763e-18
C1092	VGND#9	a_758_306##12	1.95414e-18
C1093	a_116_392##2	A1#6	5.10685e-17
C1094	VPWR#5	S1#4	5.93607e-20
C1095	VPWR#14	S1#9	1.7228e-19
C1096	VPWR#12	VNB	3.44243e-17
C1097	a_509_392##2	A0#3	9.78188e-20
C1098	a_1450_121##2	A2#2	7.59948e-18
C1099	a_2199_74##4	VPWR#15	3.32995e-17
C1100	VPWR#11	VNB	3.59049e-17
C1101	VPWR#14	X#6	7.20139e-17
C1102	A2#2	A3#4	2.52417e-17
C1103	a_2199_74##14	VPWR#15	2.93295e-17
C1104	VPWR#9	VNB	8.22807e-17
C1105	VGND	a_509_392##15	1.25062e-17
C1106	VPWR#8	VNB	6.35297e-17
C1107	VPWR	a_2199_74##26	1.36735e-17
C1108	VGND	a_2199_74##17	3.62214e-17
C1109	VPWR#7	VNB	2.94565e-17
C1110	VPWR	a_1191_121#	4.62842e-17
C1111	VPWR#5	VNB	6.92475e-17
C1112	VGND	a_1191_121##8	3.76974e-17
C1113	A0	S0#14	1.15182e-20
C1114	VPWR#4	VNB	7.47163e-17
C1115	VGND	a_2199_74##19	1.42308e-17
C1116	VPWR	a_2199_74##24	1.29662e-17
C1117	VPWR#2	VNB	2.57514e-17
C1118	VPWR	a_509_392##12	4.77726e-18
C1119	VGND#11	VNB	6.25258e-17
C1120	VGND	a_1450_121#	2.09358e-17
C1121	A0	S0#8	7.99815e-19
C1122	VPWR	a_2199_74##22	9.38082e-18
C1123	VGND#9	VNB	6.74013e-17
C1124	VGND#8	VNB	5.72323e-17
C1125	a_1285_377##2	VPWR#8	3.91257e-17
C1126	VGND	a_1278_121#	3.69737e-17
C1127	VGND#7	VNB	2.25008e-17
C1128	VPWR#13	A1#6	3.25037e-17
C1129	VGND#5	VNB	7.76919e-17
C1130	VPWR	a_1285_377##2	3.97666e-17
C1131	VPWR#5	A3#7	5.30852e-19
C1132	VGND#4	VNB	7.45459e-17
C1133	VPWR#1	a_2199_74##7	6.40677e-19
C1134	VGND	a_1191_121##13	8.48885e-18
C1135	VGND#2	VNB	2.76907e-17
C1136	X	a_2199_74#	1.91361e-19
C1137	S1#9	a_2199_74##14	3.69145e-17
C1138	VGND	a_1450_121##2	1.20732e-17
C1139	X#3	VNB	2.97508e-18
C1140	VPWR	a_1465_377#	2.86507e-18
C1141	X#2	VNB	8.38717e-19
C1142	X	a_2199_74##6	4.24726e-20
C1143	a_1191_121##6	S0#5	2.53133e-18
C1144	a_1285_377#	a_1191_121##10	6.58687e-17
C1145	VGND	a_1278_121##2	2.39853e-17
C1146	X	a_2199_74##8	2.78369e-20
C1147	VPWR	a_1191_121##3	5.78321e-18
C1148	a_1450_121##2	A2#4	4.94094e-19
C1149	X	a_2199_74##12	2.43294e-20
C1150	VPWR	a_1465_377##2	5.98014e-18
C1151	VPWR#4	a_2489_347##3	1.17953e-19
C1152	X#4	S1#9	1.55673e-18
C1153	a_2199_74##16	VNB	1.64892e-17
C1154	VPWR#3	a_2199_74##11	7.48876e-20
C1155	VPWR	a_1191_121##10	4.84783e-18
C1156	VPWR	a_1285_377#	4.89975e-17
C1157	a_2489_347##8	VNB	1.05382e-17
C1158	VGND#3	VGND#4	9.53745e-17
C1159	a_1191_121##2	VPWR#5	4.98346e-17
C1160	a_1191_121##5	VNB	4.88901e-18
C1161	a_2489_347##6	a_2489_347#	4.05021e-17
C1162	a_509_392##5	a_1191_121##3	2.66435e-17
C1163	a_1191_121##2	VNB	5.38244e-17
C1164	a_1278_121#	S0#10	1.86478e-19
C1165	A2#9	VNB	2.70082e-18
C1166	VGND#19	a_1278_121##2	1.00496e-17
C1167	A2#8	VNB	3.27752e-18
C1168	A2#6	VNB	1.26814e-18
C1169	A1#1	A0#4	4.57266e-19
C1170	a_1191_121##13	S0#4	2.55558e-17
C1171	A3#6	S1#4	1.2218e-18
C1172	VGND#3	VGND#2	6.82023e-17
C1173	a_1191_121##6	a_1191_121##5	3.32759e-18
C1174	a_509_392##8	VNB	6.17649e-18
C1175	VPWR#8	A2#3	1.86394e-18
C1176	S1#9	VPWR#15	4.18157e-17
C1177	a_509_392##2	VNB	1.15507e-17
C1178	X#4	X#6	1.03453e-18
C1179	a_509_392##5	a_1465_377##2	1.62719e-17
C1180	VGND#1	VNB	5.40425e-17
C1181	X#1	VNB	2.39239e-18
C1182	a_1191_121##2	A3#4	8.63599e-18
C1183	VGND#14	VNB	1.94671e-19
C1184	a_509_392##14	VGND#8	1.81849e-18
C1185	a_2489_347##8	S1#9	5.1021e-18
C1186	S0#7	a_758_306##3	2.70684e-19
C1187	X#5	VNB	2.37926e-18
C1188	a_1285_377##2	VPWR#7	5.16085e-17
C1189	VGND#15	VNB	4.45732e-18
C1190	VPWR#3	a_2199_74##7	6.75164e-21
C1191	a_2489_347##8	a_2199_74##11	7.87721e-19
C1192	a_2489_347##7	VNB	3.74174e-18
C1193	a_509_392##15	VNB	1.43446e-18
C1194	A2#9	S1#4	1.19158e-18
C1195	S0#3	A2#2	1.83364e-17
C1196	a_1450_121#	S0#3	2.92889e-19
C1197	S0#9	S0#3	1.84102e-18
C1198	a_2199_74##17	VNB	6.20463e-18
C1199	a_1191_121##9	a_1191_121##10	1.68873e-18
C1200	VGND#3	X#3	4.8022e-18
C1201	a_1191_121##8	VNB	1.41072e-17
C1202	VPWR#10	A0	5.30151e-18
C1203	a_2199_74##19	VNB	9.89858e-18
C1204	VGND	a_1191_121##3	7.61526e-18
C1205	VGND#16	VNB	3.32777e-18
C1206	a_509_392##5	a_1191_121##10	1.28231e-19
C1207	a_1450_121#	VNB	5.22627e-18
C1208	a_2489_347##5	S1#9	3.60984e-18
C1209	VGND#17	VNB	3.2163e-19
C1210	VGND#10	A0	7.00249e-18
C1211	a_1278_121#	VNB	9.20858e-18
C1212	VGND#9	a_758_306##11	2.77849e-18
C1213	VPWR#7	A2#3	1.33672e-17
C1214	a_1450_121##2	VNB	6.82834e-18
C1215	A2#3	A3#4	1.09811e-18
C1216	a_1278_121##2	VNB	1.77361e-17
C1217	VPWR#5	S1#3	4.36571e-20
C1218	S1#9	a_2489_347##10	2.61692e-17
C1219	a_1191_121##7	VNB	6.28548e-18
C1220	a_1191_121##5	a_1465_377##2	1.2931e-17
C1221	VGND#19	VNB	9.46995e-18
C1222	a_1450_121##2	S0#4	3.4984e-17
C1223	a_758_306##16	VNB	8.57641e-18
C1224	VPWR#10	A1	2.322e-18
C1225	a_1191_121#	a_2199_74##14	2.12504e-19
C1226	a_509_392##3	VNB	1.40553e-17
C1227	VGND#3	X#2	2.60425e-18
C1228	a_299_126#	VNB	3.18844e-18
C1229	a_509_392##5	a_1285_377#	1.9806e-17
C1230	VGND#10	A1	2.19037e-18
C1231	a_114_126##2	VNB	5.17199e-18
C1232	a_509_392##10	VNB	8.45846e-18
C1233	X	a_2199_74##14	2.86014e-20
C1234	VGND#20	VNB	5.7163e-18
C1235	S0#7	a_758_306##2	2.99947e-19
C1236	a_299_126##2	VNB	1.41069e-17
C1237	X	S1#9	1.31422e-19
C1238	VGND#21	VNB	2.52522e-18
C1239	a_1191_121##6	S0#3	5.05453e-19
C1240	a_114_126#	VNB	2.42944e-17
C1241	VGND#12	VNB	8.6158e-17
C1242	VPWR#1	VNB	7.015e-17
C1243	X#6	VNB	3.09418e-18
C1244	VPWR#5	A2#3	6.9812e-20
C1245	VPWR#14	VNB	3.0111e-18
C1246	X#4	VNB	2.74228e-18
C1247	a_509_392##14	S0	7.95877e-18
C1248	a_1278_121#	a_758_306##12	1.12953e-19
C1249	VGND#19	a_1191_121##7	4.2245e-17
C1250	VPWR#15	VNB	4.84404e-18
C1251	a_2199_74##16	S1#10	2.82268e-19
C1252	a_2489_347##10	VNB	1.38839e-17
C1253	a_509_392##5	a_1191_121##9	3.74993e-17
C1254	a_2199_74##26	VNB	1.4735e-17
C1255	VPWR#15	a_2489_347##5	5.39063e-19
C1256	VGND	a_2489_347#	1.64068e-18
C1257	a_1191_121#	VNB	5.90762e-18
C1258	X#4	VPWR#14	6.38411e-17
C1259	a_2199_74##24	VNB	1.39676e-18
C1260	VGND	a_2489_347##6	1.67127e-18
C1261	a_2199_74##26	S1#9	3.73031e-18
C1262	VGND	S1#7	7.13148e-19
C1263	a_1191_121##13	S0#10	1.35352e-18
C1264	a_2199_74##22	VNB	1.06778e-17
C1265	VGND	S1#5	2.26135e-18
C1266	VPWR#16	VNB	1.24186e-18
C1267	a_1285_377##2	VNB	2.14792e-18
C1268	VGND	A3#6	7.89442e-19
C1269	a_509_392##5	S0	1.6382e-17
C1270	a_1191_121##9	a_1285_377#	5.61926e-17
C1271	a_116_392#	a_758_306##3	2.13339e-17
C1272	S1#7	a_2489_347##6	6.75554e-18
C1273	VGND	A3#5	1.00105e-18
C1274	a_1465_377#	VNB	3.39917e-19
C1275	VGND	A2#1	2.40879e-19
C1276	a_1191_121##3	VNB	7.1558e-18
C1277	VGND	A2#4	6.73764e-20
C1278	a_1465_377##2	VNB	2.3062e-18
C1279	a_509_392##5	VPWR#19	3.77469e-17
C1280	VGND	S0#10	7.15366e-19
C1281	a_1285_377#	VNB	2.37126e-17
C1282	a_1191_121##9	VNB	1.37671e-17
C1283	A0	A0#2	2.99446e-17
C1284	VGND#9	a_758_306##16	1.25286e-17
C1285	VPWR	a_2489_347##5	2.01701e-18
C1286	VPWR#19	VNB	1.40481e-17
C1287	a_758_306##17	VNB	1.28894e-17
C1288	VPWR	a_2489_347##4	1.65299e-18
C1289	a_1285_377##2	A3#4	6.46396e-19
C1290	a_509_392##6	VNB	9.79401e-18
C1291	VPWR	S1#1	1.63348e-18
C1292	a_116_392#	VNB	8.05118e-18
C1293	A1#3	A0	2.62791e-17
C1294	a_2489_347##4	a_2489_347##5	3.16345e-17
C1295	a_509_392##11	VNB	2.04793e-18
C1296	VPWR	S1#8	8.49799e-20
C1297	a_296_392##2	VNB	4.791e-18
C1298	a_509_392##9	VNB	8.36333e-18
C1299	VPWR#20	VNB	4.25059e-18
C1300	a_2489_347##2	a_2199_74##26	4.96085e-17
C1301	a_2489_347##10	a_2489_347##5	3.43013e-18
C1302	a_296_392#	VNB	5.62665e-18
C1303	VPWR#10	a_1285_377#	1.83855e-17
C1304	VPWR#21	VNB	4.09278e-19
C1305	a_116_392##2	VNB	7.41581e-18
C1306	VPWR#8	A2#5	1.44673e-17
C1307	a_1191_121#	S1#9	5.71955e-19
C1308	a_509_392##5	a_758_306##17	5.69077e-17
C1309	VPWR#13	VNB	7.45619e-17
C1310	a_2489_347##8	a_2489_347##5	3.35153e-19
C1311	a_2199_74#	VNB	2.94247e-17
C1312	A1	A1#3	1.91021e-17
C1313	a_2199_74##6	VNB	2.64016e-17
C1314	a_2199_74##8	VNB	2.7126e-17
C1315	a_2199_74##12	VNB	2.92601e-17
C1316	S0	A2#2	5.77819e-18
C1317	VGND#3	a_2199_74##11	1.96867e-19
C1318	S1#12	VNB	3.48702e-17
C1319	S0#10	a_1450_121##2	1.33041e-17
C1320	a_2489_347#	VNB	3.24556e-17
C1321	a_1278_121##2	a_758_306##10	4.06508e-19
C1322	a_2489_347##6	VNB	3.32323e-17
C1323	VPWR#7	VPWR#17	4.115e-18
C1324	S1#7	VNB	2.71961e-17
C1325	S1#5	VNB	3.16376e-17
C1326	A3#6	VNB	4.41945e-17
C1327	VPWR#3	X	2.40133e-18
C1328	VPWR#10	a_1191_121##9	1.41716e-17
C1329	A3#5	VNB	3.07537e-17
C1330	A2#1	VNB	2.57261e-17
C1331	VGND#3	X	4.62441e-18
C1332	VPWR#3	a_2489_347##8	2.83977e-18
C1333	A2#4	VNB	2.97259e-17
C1334	a_509_392##5	a_509_392##6	1.17805e-18
C1335	a_1278_121##2	S0#4	8.40667e-18
C1336	S0#4	VNB	2.24588e-17
C1337	VGND#3	a_2199_74#	1.38443e-18
C1338	S0#10	VNB	2.14932e-17
C1339	a_1191_121##5	a_1191_121##10	1.00834e-18
C1340	a_758_306##12	VNB	1.96643e-17
C1341	a_1191_121##7	a_758_306##10	5.76846e-17
C1342	a_116_392#	a_758_306##2	7.45887e-18
C1343	VPWR#15	a_2489_347##4	4.36057e-20
C1344	a_758_306##11	VNB	2.18753e-17
C1345	S0#11	VNB	3.42229e-17
C1346	VPWR#19	a_1285_377#	2.68068e-18
C1347	A3#4	A3#6	7.2415e-18
C1348	VPWR#15	VPWR#14	2.15425e-18
C1349	a_2199_74##26	a_2489_347##5	5.55069e-17
C1350	a_758_306#	VNB	2.47336e-17
C1351	VPWR#7	A2#5	1.97175e-18
C1352	a_509_392##5	VPWR#9	9.98899e-18
C1353	a_758_306##7	VNB	2.15581e-17
C1354	a_758_306##16	a_1191_121##7	1.81563e-18
C1355	S0#13	VNB	3.65838e-17
C1356	S0#7	VNB	1.41294e-16
C1357	a_2199_74##24	S1#9	3.08466e-19
C1358	A0#3	VNB	2.78591e-17
C1359	VPWR#10	VPWR#19	1.64323e-17
C1360	A0#5	VNB	2.9259e-17
C1361	a_116_392#	S0#7	3.63944e-19
C1362	A1#5	VNB	2.21701e-17
C1363	A1#4	VNB	3.03683e-17
C1364	a_2199_74##4	X	2.61726e-17
C1365	a_1191_121##6	a_758_306##9	3.87561e-18
C1366	VGND#19	a_758_306##10	1.72354e-18
C1367	a_116_392#	a_509_392##5	5.5284e-17
C1368	a_2199_74##5	VNB	3.8848e-17
C1369	a_509_392##14	VPWR	8.95301e-17
C1370	a_2199_74##9	VNB	3.27709e-17
C1371	VGND#3	a_2199_74##6	2.72614e-19
C1372	a_509_392##15	a_2199_74##17	8.01325e-17
C1373	a_2199_74##13	VNB	3.60492e-17
C1374	VPWR	VPWR#6	2.53164e-17
C1375	a_2199_74##14	VNB	3.55311e-17
C1376	VGND#3	a_2199_74##16	4.18003e-17
C1377	S1#9	VNB	3.99154e-17
C1378	VGND#17	S0#3	1.81168e-19
C1379	a_2489_347##5	VNB	3.06866e-17
C1380	a_509_392##5	VPWR	3.16047e-17
C1381	VGND#3	a_2199_74##7	1.47829e-19
C1382	a_2489_347##4	VNB	3.98307e-17
C1383	S0#10	a_1191_121##11	1.29422e-17
C1384	a_758_306##9	S0#9	3.00434e-17
C1385	S1#1	VNB	3.71209e-17
C1386	a_2199_74##16	a_2489_347##3	1.4416e-19
C1387	S1#8	VNB	4.5577e-17
C1388	VPWR#10	a_758_306##17	1.58122e-17
C1389	S1#1	a_2489_347##4	3.91811e-17
C1390	A3#1	VNB	3.40828e-17
C1391	A3#7	VNB	3.30929e-17
C1392	S1#6	a_2199_74##26	2.93186e-18
C1393	A2#3	VNB	3.85121e-17
C1394	a_509_392##5	a_509_392##11	3.41307e-18
C1395	A2#5	VNB	4.40423e-17
C1396	S0#1	VNB	3.43666e-17
C1397	a_1191_121#	a_2489_347##5	5.15289e-17
C1398	VPWR	a_2489_347##2	1.84345e-18
C1399	S0#15	VNB	3.00718e-17
C1400	S1#5	S1#7	1.81532e-17
C1401	VGND	a_509_392##14	5.7323e-18
C1402	a_758_306##8	VNB	3.05502e-17
C1403	VPWR	S1#6	5.87771e-18
C1404	VGND#3	a_2199_74##8	3.31159e-19
C1405	a_758_306##13	VNB	3.94535e-17
C1406	S0#12	VNB	4.6805e-17
C1407	VGND	VGND#6	2.28534e-17
C1408	a_758_306##5	VNB	3.14813e-17
C1409	a_758_306##4	VNB	3.72082e-17
C1410	VGND#10	a_1191_121##9	2.39932e-18
C1411	S0#14	VNB	4.44435e-17
C1412	VPWR#8	S0#9	5.4123e-21
C1413	S0#8	VNB	4.92556e-17
C1414	A2#9	a_1191_121##3	1.06691e-17
C1415	a_509_392##6	VPWR#10	2.88213e-17
C1416	a_1191_121#	S1#6	3.19939e-19
C1417	A0#1	VNB	3.10143e-17
C1418	a_509_392##11	S0#7	3.92328e-19
C1419	A0#6	VNB	2.91798e-17
C1420	A1#1	VNB	2.95008e-17
C1421	VGND	S1#11	1.23117e-18
C1422	a_116_392#	A0#4	8.45467e-20
C1423	A1#6	VNB	3.89242e-17
C1424	a_509_392##5	a_296_392##2	1.74157e-18
C1425	VGND	a_2489_347##2	1.97683e-18
C1426	VGND	S1#6	7.49945e-18
C1427	VPWR#3	VNB	1.89705e-16
C1428	VPWR#19	a_1191_121##9	6.99419e-17
C1429	a_1191_121##5	S0#3	7.29719e-19
C1430	VGND#9	a_509_392##3	2.18256e-17
C1431	VGND#3	VNB	1.84476e-16
C1432	VGND	A3#3	5.68439e-18
C1433	a_509_392##14	VNB	1.19634e-17
C1434	VPWR#6	VNB	1.33979e-17
C1435	VGND#3	a_2199_74##12	6.35952e-18
C1436	VGND#6	VNB	1.23327e-17
C1437	a_509_392##5	VNB	1.33887e-17
C1438	VGND#10	VPWR#19	3.99905e-18
C1439	a_2199_74##26	a_2489_347##4	4.35441e-19
C1440	VPWR#10	VNB	3.48026e-16
C1441	S1#6	a_2199_74##24	5.52063e-17
C1442	VPWR#15	X#4	1.01651e-16
C1443	VGND#10	VNB	3.32951e-16
C1444	a_1278_121##2	S0#10	9.29193e-18
C1445	VPWR#10	a_116_392#	1.33113e-17
C1446	a_2199_74##4	VNB	5.2409e-18
C1447	a_2489_347##8	a_2489_347##4	6.68532e-20
C1448	a_2199_74##24	a_2489_347##5	2.51451e-18
C1449	VPWR#10	VPWR#12	8.28023e-17
C1450	S1#11	VNB	5.68433e-17
C1451	a_2489_347##2	VNB	7.46091e-18
C1452	a_2489_347##8	a_2199_74##7	2.01285e-19
C1453	a_509_392##2	a_758_306##3	5.77632e-20
C1454	S1#6	VNB	4.1462e-17
C1455	A3#3	VNB	8.74302e-18
C1456	a_758_306##16	VGND#19	6.71041e-17
C1457	A2#2	VNB	7.87533e-17
C1458	VPWR#8	S0#1	3.9363e-18
C1459	a_758_306##10	VNB	6.19789e-17
C1460	a_758_306##6	VNB	4.9729e-17
C1461	A0#2	VNB	6.33314e-17
C1462	A1#3	VNB	7.14548e-17
C1463	VGND#3	S1#12	1.79902e-18
C1464	VGND#19	a_758_306##6	2.47123e-17
C1465	VGND#3	a_2489_347##8	2.26637e-18
C1466	a_1191_121##5	a_1285_377#	2.53957e-17
C1467	VPWR#10	VPWR#11	7.88137e-17
C1468	a_296_392##2	S0#7	5.10576e-19
C1469	VGND#3	S1#10	1.39312e-19
C1470	VPWR#12	VPWR#11	4.46528e-19
C1471	S1#8	S1#1	3.63846e-17
C1472	a_1191_121#	a_2489_347##4	3.53048e-17
C1473	a_758_306##12	a_1191_121##11	3.42975e-18
C1474	A0	VNB	6.83663e-18
C1475	VGND	S0	6.02717e-18
C1476	VPWR#10	a_296_392##2	1.22073e-17
C1477	a_116_392#	A1#2	1.80463e-19
C1478	VPWR#7	S0#1	1.51399e-19
C1479	A1	VNB	1.80154e-17
C1480	VPWR#10	VPWR#9	1.3218e-16
C1481	VPWR#14	a_2199_74##7	1.85452e-18
C1482	a_1191_121##7	S0#10	1.89459e-19
C1483	S0	VNB	7.86478e-18
C1484	a_758_306##10	S0#9	4.40556e-18
C1485	a_509_392##3	a_758_306##6	3.00621e-17
C1486	X	VNB	5.41741e-17
C1487	VPWR	VNB	2.31533e-16
C1488	VGND	VNB	2.55943e-16
C1489	VGND#10	a_116_392#	8.44169e-18
C1490	X#4	a_2199_74##11	2.47112e-18
*
*
.ENDS sky130_fd_sc_hs__mux4_4
*
