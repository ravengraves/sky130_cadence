* Extracted by Quantus, converted by sky130cad/quantus.py
*
*
*
*                       LINUX           Wed Nov 18 08:31:11 2026
*
*
*
*  PROGRAM  advgen
*
*  Name           : advgen - Quantus - (64-bit)
*  Version        : 25.1.0-p047
*  Build Date     : Thu Dec 11 23:20:30 PST 2025
*
*  HSPICE LIBRARY
*
*  OPERATING_TEMPERATURE 150
*  QRC_TECH_DIR <path>/tech
*
*
*

*
.SUBCKT sky130_fd_sc_hs__dlrbp_1 VPB VNB VGND VPWR Q Q_N RESET_B D GATE
*
*
*  caps2d version: 10
*
*
*       TRANSISTOR CARDS
*
*
XM14 a_27_142##7 D#3 VGND#13 VNB sky130_fd_pr__nfet_01v8_lvt l=0.15 w=0.55 ad=0.15675 as=0.28915 pd=1.67 ps=2.3
XM11 VGND#13 GATE#3 a_226_104##10 VNB sky130_fd_pr__nfet_01v8_lvt l=0.15 w=0.74 ad=0.28915 as=0.2701 pd=2.3 ps=2.21
XM13 a_353_98##8 a_226_104##4 VGND#12 VNB sky130_fd_pr__nfet_01v8_lvt l=0.15 w=0.74 ad=0.259 as=0.38615 pd=2.18 ps=2.98
XM9 VGND#12 a_27_142# a_571_80# VNB sky130_fd_pr__nfet_01v8_lvt l=0.15 w=0.64 ad=0.38615 as=0.1344 pd=2.98 ps=1.7
XM20 a_571_80# a_353_98##2 a_642_392##8 VNB sky130_fd_pr__nfet_01v8_lvt l=0.15 w=0.64 ad=0.1344 as=0.2692 pd=1.7 ps=2.3
XM8 a_642_392##8 a_226_104##6 a_775_124# VNB sky130_fd_pr__nfet_01v8_lvt l=0.15 w=0.42 ad=0.2692 as=0.1008 pd=2.3 ps=1.32
XM22 a_775_124# a_823_98##2 VGND#11 VNB sky130_fd_pr__nfet_01v8_lvt l=0.15 w=0.42 ad=0.1008 as=0.1197 pd=1.32 ps=1.41
XM5 a_823_98##15 a_642_392# a_1051_74# VNB sky130_fd_pr__nfet_01v8_lvt l=0.15 w=0.74 ad=0.2109 as=0.1776 pd=2.05 ps=1.96
XM12 a_1051_74# RESET_B#3 VGND#10 VNB sky130_fd_pr__nfet_01v8_lvt l=0.15 w=0.74 ad=0.1776 as=0.2664 pd=1.96 ps=2.2
XM16 VGND#10 a_823_98##7 Q#1 VNB sky130_fd_pr__nfet_01v8_lvt l=0.15 w=0.74 ad=0.2664 as=0.2109 pd=2.2 ps=2.05
XM19 a_1342_74##6 a_823_98##8 VGND#9 VNB sky130_fd_pr__nfet_01v8_lvt l=0.15 w=0.55 ad=0.15675 as=0.24835 pd=1.67 ps=2.2
XM23 VGND#9 a_1342_74##3 Q_N#2 VNB sky130_fd_pr__nfet_01v8_lvt l=0.15 w=0.74 ad=0.24835 as=0.2738 pd=2.2 ps=2.22
XM6 a_27_142##5 D#1 VPWR#13 VPB sky130_fd_pr__pfet_01v8 l=0.15 w=0.84 ad=0.2478 as=0.4557 pd=2.27 ps=3.04
XM4 VPWR#13 GATE#1 a_226_104##12 VPB sky130_fd_pr__pfet_01v8 l=0.15 w=0.84 ad=0.4557 as=0.3066 pd=3.04 ps=2.41
XM7 a_353_98##9 a_226_104# VPWR#12 VPB sky130_fd_pr__pfet_01v8 l=0.15 w=0.84 ad=0.2478 as=0.3756 pd=2.27 ps=2.78
XM10 VPWR#12 a_27_142##3 a_564_392# VPB sky130_fd_pr__pfet_01v8 l=0.15 w=1 ad=0.3756 as=0.24 pd=2.78 ps=2.48
XM17 a_564_392# a_226_104##5 a_642_392##7 VPB sky130_fd_pr__pfet_01v8 l=0.15 w=1 ad=0.24 as=0.3528 pd=2.48 ps=2.81
XM1 a_642_392##7 a_353_98##3 a_753_508# VPB sky130_fd_pr__pfet_01v8 l=0.15 w=0.42 ad=0.3528 as=0.2121 pd=2.81 ps=1.85
XM2 a_753_508# a_823_98##3 VPWR#11 VPB sky130_fd_pr__pfet_01v8 l=0.15 w=0.42 ad=0.2121 as=0.4669 pd=1.85 ps=3.58
XM15 VPWR#11 a_642_392##4 a_823_98##12 VPB sky130_fd_pr__pfet_01v8 l=0.15 w=1.12 ad=0.4669 as=0.364 pd=3.58 ps=2.89
XM18 a_823_98##12 RESET_B#1 VPWR#10 VPB sky130_fd_pr__pfet_01v8 l=0.15 w=1.12 ad=0.364 as=0.392 pd=2.89 ps=2.94
XM0 VPWR#10 a_823_98##9 Q#2 VPB sky130_fd_pr__pfet_01v8 l=0.15 w=1.12 ad=0.392 as=0.3304 pd=2.94 ps=2.83
XM21 a_1342_74##7 a_823_98##4 VPWR#9 VPB sky130_fd_pr__pfet_01v8 l=0.15 w=0.84 ad=0.2478 as=0.3724 pd=2.27 ps=2.95
XM3 VPWR#9 a_1342_74# Q_N#1 VPB sky130_fd_pr__pfet_01v8 l=0.15 w=1.12 ad=0.3724 as=0.3304 pd=2.95 ps=2.83
*
*
*       RESISTOR AND CAP/DIODE CARDS
*
Rg1	D#1	D#2	374.296387
Rg2	D#2	D#3	297.119965
Rg3	GATE#1	GATE#2	376.506195
Rg4	GATE#2	GATE#3	353.846649
Rg5	a_226_104#	a_226_104##2	450.930145
Rg6	a_226_104##2	a_226_104##3	337.777069
Rg7	a_226_104##2	a_226_104##4	346.269409
Rg8	a_27_142#	a_27_142##2	450.990417
Rg9	a_27_142##2	a_27_142##3	400.207520
Rg10	a_353_98#	a_353_98##2	439.477417
Rg11	a_226_104##5	a_226_104##6	1194.912964
Rg12	a_226_104##6	a_226_104##7	216.119781
Rg13	a_353_98##3	a_353_98##4	226.096359
Rg14	a_823_98#	a_823_98##2	670.011780
Rg15	a_823_98#	a_823_98##3	260.436676
Rg16	a_642_392#	a_642_392##2	397.555725
Rg17	a_642_392##2	a_642_392##3	64.065247
Rg18	a_642_392##2	a_642_392##4	449.655212
Rg19	RESET_B#1	RESET_B#2	500.238068
Rg20	RESET_B#2	RESET_B#3	320.356293
Rg21	a_823_98##4	a_823_98##5	631.209290
Rg22	a_823_98##5	a_823_98##6	413.053864
Rg23	a_823_98##6	a_823_98##7	377.027313
Rg24	a_823_98##5	a_823_98##8	429.479401
Rg25	a_823_98##6	a_823_98##9	429.126801
Rg26	a_1342_74#	a_1342_74##2	444.758148
Rg27	a_1342_74##2	a_1342_74##3	362.118225
Rf1	D#2	D#5	161.115265
Rf2	D#6	D	0.882458
Rf3	D#5	D#6	4.724072
Rf4	GATE#2	GATE#5	161.216980
Rf5	GATE#6	GATE	0.984182
Rf6	GATE#5	GATE#6	2.362036
Rf7	a_27_142##2	a_27_142##6	370.528564
Rf8	a_27_142##6	a_27_142##7	96.836456
Rf9	a_27_142##5	a_27_142##6	7.500000
Rf10	a_226_104##7	a_226_104##9	311.017944
Rf11	a_226_104##9	a_226_104##10	11.583857
Rf12	a_226_104##9	a_226_104##3	22.179983
Rf13	a_226_104##3	a_226_104##12	49.212986
Rf14	a_353_98##4	a_353_98#	362.913940
Rf15	a_353_98#	a_353_98##7	77.350121
Rf16	a_353_98##7	a_353_98##8	23.120478
Rf17	a_353_98##7	a_353_98##9	74.137711
Rf18	a_642_392##3	a_642_392##6	241.269485
Rf19	a_642_392##6	a_642_392##7	85.818977
Rf20	a_642_392##6	a_642_392##8	80.247177
Rf21	RESET_B	RESET_B#4	1.588424
Rf22	RESET_B#5	RESET_B#2	161.821228
Rf23	RESET_B#4	RESET_B#5	3.882813
Rf24	a_823_98##6	a_823_98##11	212.619568
Rf25	a_823_98##11	a_823_98##13	16.933725
Rf26	a_823_98##13	a_823_98#	195.237274
Rf27	a_823_98##11	a_823_98##15	68.375557
Rf28	a_823_98##12	a_823_98##13	5.000000
Rf29	Q	Q#1	115.294113
Rf30	Q	Q#2	9.176575
Rf31	a_1342_74##2	a_1342_74##5	181.117142
Rf32	a_1342_74##5	a_1342_74##6	70.872147
Rf33	a_1342_74##5	a_1342_74##7	84.156235
Rf34	Q_N#1	Q_N	94.776497
Rf35	Q_N	Q_N#3	7.169846
Rf36	Q_N#3	Q_N	6.792485
Rf37	Q_N#2	Q_N#3	7.500000
Rf39	VPWR#2	VPWR#3	113.845490
Rf40	VPWR#3	VPWR#4	84.981728
Rf41	VPWR#4	VPWR#5	101.020027
Rf42	VPWR#5	VPWR#6	61.517616
Rf43	VPWR#6	VPWR#7	124.316513
Rf45	VPWR#2	VPWR#9	38.772522
Rf46	VPWR#3	VPWR#10	44.620285
Rf47	VPWR#4	VPWR#11	15.998544
Rf48	VPWR#6	VPWR#12	31.707861
Rf49	VPWR#7	VPWR#13	28.799242
Rf51	VGND#2	VGND#3	122.627251
Rf52	VGND#3	VGND#4	100.760612
Rf53	VGND#4	VGND#5	76.313240
Rf54	VGND#5	VGND#6	63.894653
Rf55	VGND#6	VGND#7	123.771523
Rf57	VGND#2	VGND#9	34.245285
Rf58	VGND#3	VGND#10	31.829987
Rf59	VGND#4	VGND#11	44.349312
Rf60	VGND#6	VGND#12	24.468842
Rf61	VGND#7	VGND#13	39.211349
Re1	VPWR#2	VPWR	4.549932
Re2	VPWR	VPWR#5	0.974985
Re3	VGND#2	VGND	4.549932
Re4	VGND	VGND#5	0.974985
*
*       CAPACITOR CARDS
*
*
C1	a_823_98##6	VPWR#3	5.11537e-19
C2	a_27_142##5	VPWR#6	1.46804e-18
C3	a_823_98##15	Q#1	5.35897e-18
C4	a_1342_74##5	a_1342_74##2	5.14268e-19
C5	a_823_98##7	a_823_98##5	5.97374e-19
C6	VGND#4	a_642_392##3	1.97622e-18
C7	a_823_98##8	a_1342_74##3	2.66594e-17
C8	Q_N#1	a_1342_74#	4.92203e-17
C9	a_823_98##15	VGND#10	3.21586e-17
C10	a_1342_74#	VPWR#9	2.38226e-17
C11	a_353_98##8	a_226_104##2	1.18455e-17
C12	VPWR#3	RESET_B#2	5.19882e-20
C13	VGND#3	a_823_98##7	7.53109e-18
C14	a_1342_74##5	a_823_98##6	4.59807e-19
C15	Q_N#1	a_823_98##4	4.74046e-18
C16	a_1342_74##7	a_1342_74#	7.89305e-19
C17	a_823_98##7	a_823_98##8	4.51887e-18
C18	VPWR#9	a_823_98##4	4.64627e-17
C19	VGND#4	RESET_B#3	2.59295e-19
C20	a_642_392##3	VPWR#4	2.26464e-18
C21	a_1342_74##7	a_823_98##4	1.88965e-17
C22	VGND#3	RESET_B#3	4.41234e-18
C23	a_823_98##11	a_823_98##6	2.43355e-18
C24	VPWR#9	a_823_98##9	1.06431e-18
C25	VGND#4	a_353_98##4	4.31719e-19
C26	a_642_392##8	a_226_104##5	1.17495e-18
C27	a_642_392##6	a_642_392##7	1.92834e-18
C28	RESET_B#3	a_823_98##7	2.70232e-17
C29	a_226_104##10	a_226_104##2	3.86159e-19
C30	a_1342_74##7	a_823_98##9	1.04079e-18
C31	VGND#3	Q#1	2.12026e-17
C32	VGND#4	a_642_392#	2.10216e-18
C33	a_823_98#	VPWR#4	2.91723e-17
C34	VPWR#10	a_823_98##4	3.24047e-19
C35	VPWR#9	RESET_B#1	2.35124e-19
C36	VGND#11	a_823_98##15	5.12461e-17
C37	RESET_B#5	a_823_98##6	2.73912e-17
C38	a_823_98##9	Q#2	2.97775e-17
C39	VGND#4	VGND#10	8.20848e-19
C40	a_823_98##11	RESET_B#2	5.53861e-18
C41	VGND#3	a_642_392#	5.36658e-18
C42	VGND#6	a_226_104##7	3.84117e-17
C43	D#5	VGND#13	1.27892e-17
C44	a_823_98##9	VPWR#10	2.85474e-17
C45	VGND#4	a_226_104##7	2.07639e-17
C46	a_642_392#	RESET_B#3	4.75107e-17
C47	VPWR#6	a_353_98##4	1.32571e-17
C48	VGND#3	a_226_104##7	1.14219e-19
C49	VGND#4	a_823_98##2	2.46729e-18
C50	a_353_98##4	VPWR#4	3.04488e-17
C51	RESET_B#5	RESET_B#2	1.07952e-17
C52	RESET_B#1	VPWR#10	3.2772e-17
C53	a_642_392##3	a_823_98##11	5.04762e-17
C54	RESET_B#4	RESET_B#2	6.11991e-18
C55	a_1342_74##5	a_1342_74##3	1.36371e-18
C56	a_27_142##7	D#5	1.98028e-17
C57	a_642_392##8	a_823_98##15	3.62054e-18
C58	RESET_B#1	a_823_98##12	2.49592e-17
C59	a_823_98##2	a_642_392#	5.04635e-18
C60	VPWR#10	a_642_392##4	6.55718e-19
C61	a_823_98##11	a_823_98#	5.27273e-19
C62	a_642_392##4	a_823_98##12	2.51372e-17
C63	a_642_392##8	VGND#11	1.55812e-17
C64	a_1342_74##5	a_823_98##8	2.57873e-18
C65	VGND#4	a_823_98##15	1.90072e-17
C66	VPWR#10	a_823_98##3	1.23933e-19
C67	a_642_392##6	a_642_392##3	7.07879e-18
C68	VGND#6	a_27_142##2	5.54862e-19
C69	a_642_392##4	VPWR#11	1.55297e-17
C70	a_823_98##2	a_642_392##2	6.11132e-19
C71	a_226_104##6	a_823_98##2	5.28831e-17
C72	Q_N#2	Q_N#1	2.99444e-18
C73	a_27_142##7	a_226_104##2	2.55993e-20
C74	VGND#3	a_823_98##15	7.28499e-18
C75	a_353_98##4	a_823_98##11	3.4274e-18
C76	a_823_98##3	VPWR#11	1.32127e-17
C77	Q_N#1	a_823_98##5	9.43969e-20
C78	a_1342_74##5	a_823_98##7	3.15835e-19
C79	a_642_392##6	a_823_98#	3.22929e-18
C80	a_353_98##2	a_226_104##6	8.91542e-18
C81	VGND#6	a_226_104##3	1.39669e-19
C82	VGND#6	a_27_142#	8.04576e-18
C83	VPWR#4	a_823_98##2	2.67401e-19
C84	a_27_142##2	VPWR#6	6.91148e-18
C85	a_1342_74##5	a_823_98##5	4.11658e-17
C86	Q_N#2	a_1342_74##2	3.84909e-17
C87	a_642_392##6	a_353_98##4	4.15635e-17
C88	VPWR#4	VPWR#3	7.69157e-19
C89	a_1342_74##5	Q_N#2	3.46246e-18
C90	a_1342_74##2	VGND#9	1.92999e-17
C91	a_353_98##3	a_642_392##7	1.07902e-17
C92	a_27_142#	a_353_98##2	5.16454e-17
C93	VGND#6	a_226_104##4	9.49341e-18
C94	VPWR#6	a_226_104##3	1.60045e-19
C95	a_642_392##7	a_226_104##5	3.09363e-17
C96	a_226_104##7	a_642_392##6	3.07836e-18
C97	VGND#9	a_1342_74##5	1.30567e-18
C98	a_226_104##4	a_27_142#	2.39087e-17
C99	a_642_392##7	a_27_142##3	1.13283e-18
C100	a_353_98##8	a_642_392##8	4.41857e-18
C101	Q#1	a_823_98##6	6.70906e-17
C102	VPWR#12	a_226_104##5	8.24456e-19
C103	VGND#6	GATE#3	5.65904e-19
C104	VGND#10	a_823_98##6	4.4116e-18
C105	a_353_98#	a_642_392##6	7.05264e-17
C106	GATE#3	a_226_104##4	4.60974e-18
C107	VPWR#12	a_27_142##3	3.89766e-17
C108	a_226_104##10	a_642_392##8	1.21082e-18
C109	Q#1	RESET_B#2	2.45765e-19
C110	a_353_98##9	a_27_142##3	1.85931e-18
C111	RESET_B#2	VGND#10	3.82322e-18
C112	a_226_104#	VPWR#12	1.76199e-17
C113	VGND#6	VGND#12	7.35472e-18
C114	a_642_392##6	a_27_142##2	5.48707e-19
C115	a_353_98##8	VGND#12	1.92521e-18
C116	D#3	GATE#3	2.09481e-17
C117	a_353_98##9	a_226_104#	4.45998e-17
C118	a_823_98##15	RESET_B#2	2.14077e-18
C119	Q#1	a_1342_74##5	4.19894e-17
C120	VPWR#13	a_27_142##3	1.22229e-18
C121	VPWR#12	GATE#1	1.41915e-18
C122	a_226_104##12	a_226_104#	6.59429e-19
C123	a_226_104##10	VGND#12	4.76408e-18
C124	a_353_98##9	GATE#1	4.27155e-19
C125	VGND#3	a_823_98##11	4.40175e-19
C126	VPWR#13	a_226_104#	1.65191e-18
C127	VPWR#12	D#1	1.03633e-18
C128	a_823_98##15	a_642_392##3	3.03406e-17
C129	a_226_104##12	GATE#1	4.01253e-17
C130	a_27_142##5	a_226_104#	9.25577e-19
C131	VGND#11	a_642_392##3	1.02432e-17
C132	a_226_104##10	a_353_98##8	1.0106e-16
C133	GATE#1	VPWR#13	3.22617e-17
C134	VGND#13	VGND#12	1.18682e-19
C135	a_1342_74##2	Q_N#1	1.37774e-17
C136	a_226_104##12	D#1	3.02495e-18
C137	a_27_142##5	GATE#1	3.8063e-17
C138	a_1342_74##2	VPWR#9	2.07471e-17
C139	VGND#11	a_823_98#	2.06633e-18
C140	D#1	VPWR#13	3.23843e-17
C141	a_823_98##5	a_1342_74##2	2.87054e-17
C142	VGND#6	a_226_104##10	4.63736e-17
C143	RESET_B#4	a_642_392#	7.79049e-20
C144	a_27_142##5	D#1	5.66187e-17
C145	a_823_98##4	a_1342_74#	4.35368e-17
C146	VGND#10	a_226_104##7	4.81796e-19
C147	VGND#13	a_226_104##10	5.43402e-17
C148	a_823_98##6	Q#2	3.82821e-19
C149	VGND#13	VGND#6	2.5568e-18
C150	a_823_98##15	a_226_104##7	3.18426e-19
C151	a_823_98##6	VPWR#10	2.83002e-17
C152	a_226_104##7	VGND#11	1.59192e-17
C153	a_27_142##7	a_226_104##10	1.18642e-20
C154	a_642_392##6	a_823_98##2	4.17028e-18
C155	a_823_98##9	a_823_98##4	7.83307e-18
C156	a_823_98##6	a_823_98##5	2.73309e-18
C157	Q_N#2	a_823_98##5	6.91982e-19
C158	a_226_104##7	a_642_392##8	5.67984e-17
C159	a_823_98##6	a_642_392##2	1.64239e-19
C160	VPWR#10	RESET_B#2	4.54161e-19
C161	GATE#3	a_226_104##2	1.53855e-19
C162	a_27_142##7	VGND#13	4.94991e-17
C163	VGND#10	a_823_98##11	9.62817e-19
C164	a_823_98##11	a_642_392##2	9.30759e-18
C165	a_226_104##7	VGND#12	3.6818e-19
C166	RESET_B#1	a_823_98##9	3.81568e-17
C167	a_642_392##6	a_226_104##6	1.59102e-17
C168	a_226_104##7	a_353_98##8	5.348e-19
C169	a_353_98#	a_642_392##8	4.0211e-17
C170	a_226_104##10	a_226_104##7	1.69647e-18
C171	a_642_392##3	VPWR#11	3.26081e-19
C172	VGND#3	RESET_B#4	1.31e-18
C173	a_642_392##4	RESET_B#1	4.11679e-17
C174	VGND#4	a_642_392##6	1.10082e-18
C175	a_353_98##8	a_353_98#	2.15434e-18
C176	D#5	VPWR#13	7.90375e-20
C177	D#5	D#2	1.17094e-17
C178	a_642_392##2	RESET_B#2	2.93945e-17
C179	a_823_98##11	VPWR#4	5.75005e-17
C180	RESET_B#5	Q#1	3.0095e-18
C181	a_823_98##3	a_642_392##4	7.91e-18
C182	a_353_98##8	a_27_142##2	2.62943e-17
C183	a_27_142##5	D#5	3.41226e-17
C184	a_226_104##10	a_27_142##2	1.22093e-18
C185	a_823_98##15	a_823_98##11	2.29937e-18
C186	VPWR#3	a_823_98##4	1.95957e-19
C187	a_823_98##11	VPWR#3	7.93326e-18
C188	VGND#10	RESET_B#5	1.85741e-17
C189	a_226_104##3	a_353_98##8	3.27719e-17
C190	a_353_98##3	a_823_98##3	9.11118e-18
C191	VPWR#9	Q_N#1	7.65477e-17
C192	a_353_98##4	a_642_392##7	9.11823e-17
C193	a_226_104##10	a_226_104##3	4.30507e-18
C194	VPWR#4	a_823_98##9	3.99088e-19
C195	a_1342_74##5	a_1342_74#	2.29495e-19
C196	a_1342_74##6	a_823_98##5	3.93382e-18
C197	a_642_392##3	a_642_392##2	2.26146e-19
C198	VPWR#12	a_353_98##4	2.4985e-17
C199	a_27_142##7	a_226_104##3	1.22522e-18
C200	VGND#5	a_353_98##2	4.07902e-18
C201	a_1342_74##7	Q_N#1	4.23245e-18
C202	RESET_B#2	a_823_98##7	5.52451e-18
C203	a_1342_74##3	Q_N#2	1.68171e-17
C204	a_226_104##5	a_353_98##3	1.49075e-17
C205	VPWR#3	a_823_98##9	6.73296e-18
C206	a_226_104##10	GATE#2	3.48244e-18
C207	GATE	a_226_104##2	1.52716e-20
C208	a_27_142##7	GATE#2	2.50318e-19
C209	a_642_392#	RESET_B#2	5.39404e-18
C210	VGND#9	a_1342_74##3	4.11134e-17
C211	a_353_98#	a_642_392##7	4.94314e-17
C212	a_1342_74##7	VPWR#9	6.56214e-17
C213	VPWR#4	RESET_B#1	1.85456e-18
C214	a_1342_74##5	a_823_98##4	6.08682e-18
C215	a_27_142##3	a_226_104##5	5.71149e-17
C216	Q_N#2	a_823_98##8	1.83568e-18
C217	RESET_B#5	a_823_98##5	2.66218e-19
C218	VGND#13	D#2	8.38696e-18
C219	VPWR#12	a_353_98#	1.15235e-17
C220	VPWR#3	RESET_B#1	5.48337e-18
C221	a_1342_74##6	a_1342_74##3	1.71745e-18
C222	a_27_142##7	D#2	3.83108e-18
C223	a_823_98##2	a_642_392##3	1.88747e-17
C224	VGND#9	a_823_98##8	1.54651e-17
C225	Q#1	a_823_98##5	7.51707e-18
C226	a_823_98#	a_642_392##2	1.84114e-19
C227	a_226_104#	a_27_142##3	2.69884e-17
C228	a_642_392##3	a_226_104##6	9.90311e-19
C229	a_27_142##2	VPWR#12	4.52401e-17
C230	a_1342_74##5	a_823_98##9	1.7132e-19
C231	VPWR#4	a_642_392##4	1.89856e-17
C232	a_823_98##15	RESET_B#4	2.73489e-17
C233	a_27_142##2	a_353_98##9	8.09204e-17
C234	GATE#1	a_27_142##3	2.41786e-19
C235	a_1342_74##6	a_823_98##8	4.53758e-17
C236	VPWR#10	VPWR#9	1.21761e-18
C237	a_226_104##6	a_823_98#	5.47287e-18
C238	VPWR#3	a_642_392##4	5.05062e-19
C239	VGND#9	a_823_98##7	9.6674e-19
C240	VGND#10	a_1342_74##3	3.36574e-19
C241	GATE#1	a_226_104#	5.66488e-18
C242	a_27_142##2	VPWR#13	3.76507e-20
C243	a_823_98##11	a_823_98##4	1.02935e-19
C244	a_226_104##3	a_353_98##9	2.91381e-17
C245	a_823_98##4	a_1342_74##2	2.63702e-18
C246	VPWR#6	a_823_98##3	7.51996e-20
C247	Q#1	a_823_98##8	3.29264e-18
C248	a_642_392##6	a_823_98##15	6.40636e-19
C249	a_226_104##7	a_642_392#	1.65878e-18
C250	a_1342_74##6	a_823_98##7	1.23758e-18
C251	a_226_104##7	a_823_98##2	1.32878e-17
C252	VPWR#4	a_823_98##3	2.46419e-17
C253	a_823_98##6	a_823_98##4	4.03952e-19
C254	D#1	GATE#1	2.07675e-17
C255	VGND#9	RESET_B#3	2.33259e-19
C256	VGND#10	a_823_98##8	6.93741e-19
C257	a_353_98##9	GATE#2	4.19689e-20
C258	a_27_142##5	a_226_104##3	3.57453e-18
C259	a_226_104##7	a_226_104##6	5.81606e-19
C260	VPWR#5	a_353_98##3	4.61111e-18
C261	a_823_98##6	a_823_98##9	7.17018e-18
C262	a_226_104##12	GATE#2	1.94576e-18
C263	VPWR#3	a_823_98##3	3.82232e-20
C264	Q#1	a_823_98##7	5.19294e-17
C265	a_823_98##15	a_1051_74#	2.12406e-20
C266	a_226_104##7	a_353_98##2	3.15015e-17
C267	a_823_98##11	a_823_98##9	1.77098e-18
C268	RESET_B#1	a_823_98##6	2.35686e-18
C269	VPWR#5	a_226_104##5	4.5129e-18
C270	a_642_392##6	VPWR#4	8.08812e-19
C271	VPWR#6	a_353_98##3	2.90927e-19
C272	RESET_B#4	a_642_392##2	4.17678e-18
C273	a_226_104##7	a_27_142#	2.93929e-17
C274	a_353_98#	a_226_104##6	1.82765e-17
C275	GATE#2	a_27_142##5	8.17581e-18
C276	a_353_98##8	a_353_98##9	2.61982e-18
C277	a_823_98##7	VGND#10	1.92722e-17
C278	a_226_104##12	D#2	1.36099e-19
C279	a_226_104##7	a_226_104##4	1.17126e-18
C280	VGND#5	a_226_104##5	9.54363e-20
C281	VPWR#4	a_353_98##3	2.78786e-18
C282	VPWR#13	D#2	5.24295e-19
C283	Q#1	RESET_B#3	1.91181e-18
C284	a_353_98#	a_27_142#	2.07824e-17
C285	a_226_104##7	GATE#3	3.57438e-19
C286	a_27_142##2	a_226_104##6	1.48523e-18
C287	a_27_142##5	D#2	8.37753e-18
C288	VPWR#3	VPWR#9	1.1355e-19
C289	a_823_98##11	RESET_B#1	5.36577e-17
C290	a_642_392##3	a_642_392##4	9.52194e-19
C291	VGND#10	RESET_B#3	4.28146e-17
C292	VPWR#6	a_226_104##5	6.26481e-19
C293	a_226_104##4	a_27_142##2	1.12891e-18
C294	Q#1	a_642_392#	3.66841e-19
C295	a_823_98##15	a_823_98##7	5.50884e-19
C296	a_823_98#	a_642_392##4	1.11008e-17
C297	VPWR#4	a_226_104##5	1.52081e-19
C298	a_226_104##10	a_226_104##12	3.20584e-18
C299	a_353_98##4	RESET_B#1	2.90022e-19
C300	a_353_98##4	a_642_392##4	5.70773e-19
C301	VGND#10	a_642_392#	6.7749e-18
C302	a_823_98##11	a_642_392##4	4.58188e-17
C303	a_226_104##3	GATE#3	8.17666e-20
C304	a_642_392##8	a_642_392##6	3.209e-18
C305	a_353_98##4	a_823_98##3	1.1194e-17
C306	a_823_98##15	RESET_B#3	9.35392e-18
C307	a_226_104##3	D#3	2.77631e-20
C308	a_226_104##5	a_823_98#	6.79829e-18
C309	VPWR#6	a_27_142##3	7.30207e-18
C310	a_353_98##4	a_353_98##3	2.1213e-17
C311	a_1342_74##5	Q_N#1	4.74923e-18
C312	VGND#6	a_226_104##2	2.78046e-20
C313	VPWR#4	a_27_142##3	5.674e-20
C314	a_353_98##4	a_226_104##5	5.46659e-17
C315	a_642_392##2	RESET_B#1	2.64916e-18
C316	a_353_98##4	a_27_142##3	4.78846e-18
C317	a_823_98##15	a_642_392#	4.77644e-17
C318	a_823_98##11	a_823_98##3	1.20764e-18
C319	a_226_104##7	a_226_104##5	1.49965e-18
C320	a_353_98#	a_353_98##3	2.08612e-19
C321	VGND#4	a_642_392##2	2.19292e-20
C322	a_353_98#	a_226_104##2	2.78691e-19
C323	VPWR#6	a_226_104#	5.96581e-18
C324	Q	a_823_98##5	4.91561e-19
C325	a_353_98#	a_226_104##5	5.75135e-17
C326	VGND#11	a_642_392#	1.06678e-18
C327	VPWR#4	VPWR#10	2.3414e-18
C328	VGND#13	a_27_142##5	4.81519e-18
C329	a_353_98#	a_27_142##3	1.18338e-17
C330	a_823_98##15	a_823_98##2	4.71831e-18
C331	a_27_142##2	a_226_104##5	2.10785e-17
C332	a_823_98##15	a_642_392##2	8.04743e-18
C333	a_353_98#	a_226_104#	8.17254e-19
C334	a_823_98##11	a_353_98##3	2.95348e-19
C335	a_642_392##6	a_642_392##4	4.18805e-20
C336	a_27_142##2	a_27_142##3	1.83256e-17
C337	a_353_98#	GATE#1	2.88541e-19
C338	a_27_142##7	a_27_142##5	3.65595e-18
C339	VGND#11	a_823_98##2	4.50175e-17
C340	a_27_142##2	a_226_104#	3.987e-17
C341	a_642_392#	a_1051_74#	1.33329e-17
C342	a_27_142##2	GATE#1	3.50352e-19
C343	a_823_98##15	a_226_104##6	4.39134e-19
C344	a_642_392##8	a_642_392#	8.45264e-20
C345	RESET_B#2	a_823_98##6	3.62427e-17
C346	a_226_104##3	a_226_104#	1.97697e-19
C347	a_353_98##4	VPWR#5	6.59057e-17
C348	a_27_142##2	D#1	2.47799e-19
C349	a_353_98##9	a_226_104##2	3.59054e-18
C350	GATE#2	a_226_104#	1.48309e-18
C351	VGND#11	a_226_104##6	3.07874e-18
C352	a_226_104##2	a_27_142##2	3.10715e-17
C353	VGND#5	a_226_104##7	6.88747e-17
C354	a_642_392##8	a_823_98##2	5.44186e-18
C355	a_353_98##3	a_753_508#	1.17351e-17
C356	VGND#5	a_353_98#	1.3842e-19
C357	a_823_98##2	a_775_124#	9.87534e-18
C358	a_642_392##3	a_823_98#	9.31002e-17
C359	a_226_104##6	a_775_124#	9.87534e-18
C360	VPWR#4	VPWR#11	1.18978e-17
C361	VGND#11	a_353_98##2	3.54696e-19
C362	VGND#6	VGND#4	2.32383e-19
C363	a_642_392##8	a_226_104##6	3.38104e-17
C364	a_226_104##5	a_564_392#	1.54309e-17
C365	a_353_98##4	a_823_98#	6.5374e-17
C366	a_27_142##3	a_564_392#	1.6367e-18
C367	GATE	a_226_104##10	1.44817e-17
C368	RESET_B#5	a_823_98##11	1.77727e-17
C369	a_353_98#	a_823_98#	7.87676e-20
C370	a_642_392##8	a_353_98##2	2.6865e-17
C371	a_226_104##3	a_226_104##2	1.19117e-17
C372	a_353_98##2	a_571_80#	7.18415e-18
C373	a_642_392##6	a_226_104##5	3.25444e-17
C374	VGND	a_226_104##2	4.57057e-19
C375	a_27_142#	a_571_80#	9.92599e-18
C376	a_353_98#	a_353_98##4	4.30436e-18
C377	a_226_104##7	a_353_98#	1.94954e-17
C378	Q	VPWR#3	2.10219e-17
C379	VGND#9	Q_N#2	3.09774e-17
C380	D	VGND#13	2.36947e-17
C381	a_226_104##7	a_27_142##2	1.91608e-19
C382	Q	a_1342_74##5	3.14141e-17
C383	a_642_392##8	a_27_142#	2.08158e-18
C384	a_353_98##8	a_226_104##6	5.1466e-20
C385	a_353_98#	a_27_142##2	1.4107e-16
C386	a_823_98##11	Q	5.92223e-19
C387	a_823_98##11	RESET_B#4	2.73764e-17
C388	GATE	a_226_104##12	1.12602e-17
C389	Q_N	Q_N#2	3.55169e-18
C390	VGND#9	Q_N	2.01323e-17
C391	GATE	a_27_142##5	3.52048e-19
C392	a_226_104##3	a_27_142##2	2.15143e-18
C393	a_1342_74##6	Q_N#2	2.35522e-18
C394	VGND#4	VGND#3	4.11981e-19
C395	a_353_98##8	a_353_98##2	2.96779e-19
C396	a_642_392##8	a_226_104##4	7.66671e-19
C397	VPWR	VPWR#6	9.72324e-17
C398	VPWR	VPWR#4	1.26878e-16
C399	VPWR	VPWR#3	8.62127e-17
C400	a_353_98##4	a_753_508#	3.1961e-18
C401	GATE#2	a_226_104##2	1.44624e-19
C402	a_27_142#	VGND#12	1.60948e-17
C403	VGND#9	a_823_98##4	4.46593e-19
C404	GATE#2	a_226_104##3	3.09259e-17
C405	a_823_98##5	VNB	3.62887e-17
C406	D	VPWR#13	1.64398e-18
C407	a_642_392##2	VNB	1.72261e-17
C408	a_226_104##2	VNB	1.82957e-17
C409	D	a_27_142##5	5.84413e-18
C410	VPWR	a_823_98##11	2.40888e-17
C411	a_353_98##4	a_564_392#	3.03049e-18
C412	a_642_392##6	a_823_98##11	3.83842e-19
C413	a_226_104##3	D#2	2.6946e-19
C414	a_226_104##10	a_353_98##2	1.35033e-19
C415	VPWR	RESET_B#5	1.47936e-18
C416	VPWR	RESET_B#4	1.19534e-18
C417	VPWR	a_642_392##6	5.52362e-18
C418	Q#1	Q	3.39673e-18
C419	D#2	GATE#2	2.74065e-17
C420	a_353_98##8	a_27_142#	1.05332e-18
C421	a_642_392##8	a_642_392##2	9.046e-20
C422	a_642_392##8	GATE#3	1.72525e-19
C423	a_1342_74##6	VGND#9	5.0758e-17
C424	a_353_98#	a_564_392#	1.57785e-17
C425	VGND	VGND#6	8.93408e-17
C426	VGND	VGND#4	9.69041e-17
C427	a_226_104##4	VGND#12	1.60166e-17
C428	VGND	VGND#3	8.98331e-17
C429	a_823_98##11	VPWR#10	7.65307e-17
C430	a_226_104##10	a_27_142#	5.00975e-19
C431	VPWR	D#5	1.57575e-18
C432	a_353_98##8	a_226_104##4	2.77091e-17
C433	VGND	a_823_98##11	4.10539e-18
C434	Q	a_1342_74##7	9.03561e-17
C435	a_226_104##12	a_353_98##9	2.87493e-17
C436	Q	Q#2	1.87215e-18
C437	VPWR#13	VPWR#12	4.1905e-18
C438	VGND	RESET_B#5	1.48365e-18
C439	VPWR#10	Q	8.00227e-17
C440	VGND	RESET_B#4	3.88847e-18
C441	Q_N	a_1342_74##3	6.63231e-18
C442	VGND	a_642_392##6	6.65014e-18
C443	VGND#13	a_27_142#	5.86418e-19
C444	GATE	a_226_104#	1.00792e-19
C445	a_226_104##10	a_226_104##4	1.12807e-17
C446	VGND#6	VNB	4.85051e-17
C447	VGND#4	VNB	4.58885e-17
C448	a_226_104##7	a_571_80#	8.93746e-19
C449	VGND#3	VNB	4.70403e-17
C450	a_823_98##11	a_823_98##12	4.64606e-18
C451	VGND	D#5	2.06749e-18
C452	a_353_98##8	GATE#3	1.01555e-18
C453	VPWR#6	VNB	4.36145e-17
C454	VPWR#4	VNB	5.02931e-17
C455	a_823_98##5	a_1342_74##3	3.10332e-18
C456	VPWR#3	VNB	3.61875e-17
C457	VGND	Q#1	2.0679e-17
C458	VGND	VGND#10	2.09089e-17
C459	a_1342_74##5	VNB	3.60973e-18
C460	Q#1	a_1342_74##6	5.41476e-17
C461	VGND	a_823_98##15	2.21546e-17
C462	VGND#10	VGND#9	6.2882e-19
C463	VGND#13	a_226_104##4	2.0212e-18
C464	VPWR	a_642_392##7	9.31989e-18
C465	a_823_98##11	VNB	6.5496e-18
C466	VGND	a_642_392##8	1.09535e-17
C467	VPWR	a_353_98##9	4.21743e-18
C468	RESET_B#5	VNB	3.69406e-19
C469	RESET_B#4	VNB	2.90821e-21
C470	VPWR	a_226_104##12	4.68466e-18
C471	a_642_392##6	VNB	1.2616e-17
C472	VGND	a_353_98##8	8.60215e-18
C473	VPWR	VPWR#13	2.0633e-17
C474	GATE#3	a_226_104##10	3.25304e-17
C475	VGND	a_226_104##10	3.49208e-17
C476	VPWR	a_27_142##5	3.51863e-17
C477	VGND	a_27_142##7	1.47368e-17
C478	Q	a_823_98##4	4.45196e-18
C479	Q	a_823_98##9	3.30594e-17
C480	D#5	VNB	1.08084e-18
C481	Q	RESET_B#1	1.67601e-18
C482	Q_N#2	VNB	4.27891e-17
C483	VGND#9	VNB	3.95042e-18
C484	a_1342_74##6	VNB	1.16375e-17
C485	Q#1	VNB	1.64552e-17
C486	GATE#3	VGND#13	2.87766e-17
C487	VGND#10	VNB	1.31909e-18
C488	VGND	a_353_98##9	5.83144e-19
C489	a_823_98##11	VPWR#11	2.66928e-18
C490	a_823_98##15	VNB	1.08687e-17
C491	VGND#11	VNB	1.01535e-17
C492	a_642_392##8	VNB	4.59385e-19
C493	a_27_142##5	a_226_104##12	5.93348e-17
C494	GATE	a_226_104##3	3.52602e-17
C495	a_353_98##8	VNB	7.12021e-18
C496	VGND	a_823_98##7	1.0943e-18
C497	a_226_104##10	D#3	1.67989e-18
C498	a_226_104##10	VNB	1.76028e-17
C499	VPWR	a_823_98##9	1.71657e-18
C500	VGND	RESET_B#3	8.94048e-19
C501	VGND#13	VNB	2.70397e-17
C502	a_27_142##7	VNB	4.31434e-17
C503	VPWR	RESET_B#1	8.67824e-19
C504	GATE	GATE#2	5.37141e-18
C505	Q_N#1	VNB	6.14482e-17
C506	VGND	a_823_98##2	5.40104e-18
C507	VPWR	a_642_392##4	3.59982e-19
C508	VPWR#9	VNB	2.70458e-18
C509	a_1342_74##7	VNB	5.47509e-18
C510	VPWR	a_823_98##3	9.62131e-19
C511	VPWR#10	VNB	3.0111e-18
C512	VPWR	a_353_98##3	8.8818e-19
C513	VGND	a_27_142#	2.77743e-18
C514	a_27_142##7	GATE#3	1.57625e-18
C515	VGND	a_226_104##4	9.47289e-18
C516	VPWR	a_226_104##5	4.84717e-18
C517	VGND	GATE#3	7.06793e-18
C518	D	GATE#2	3.16632e-17
C519	VPWR	a_27_142##3	1.28912e-18
C520	VGND	D#3	8.35025e-18
C521	VPWR	a_226_104#	8.29371e-18
C522	VPWR#12	VNB	4.30901e-18
C523	D	D#2	4.3649e-18
C524	VPWR	GATE#1	8.61503e-18
C525	a_353_98##9	VNB	3.766e-18
C526	a_226_104##12	VNB	4.95649e-18
C527	VPWR	D#1	8.43886e-18
C528	VPWR#13	VNB	1.33672e-17
C529	a_823_98##6	Q	5.59263e-17
C530	a_27_142##5	VNB	6.73981e-17
C531	D#3	VGND#13	2.50117e-17
C532	a_1342_74##3	VNB	3.33476e-17
C533	VGND#3	a_823_98##6	1.02473e-18
C534	a_27_142##5	VPWR#13	5.55981e-17
C535	a_823_98##8	VNB	3.36248e-17
C536	a_823_98##7	VNB	3.31142e-17
C537	RESET_B#3	VNB	3.73634e-17
C538	a_642_392#	VNB	3.36464e-17
C539	VPWR	VPWR#5	5.06089e-17
C540	a_823_98##2	VNB	5.09801e-17
C541	a_226_104##6	VNB	3.71782e-17
C542	VGND#10	Q#1	5.67638e-17
C543	a_353_98##2	VNB	2.32047e-17
C544	a_27_142#	VNB	3.2125e-17
C545	a_226_104##4	VNB	4.04746e-17
C546	VPWR	a_823_98##6	4.29162e-18
C547	GATE#3	VNB	3.44926e-17
C548	D#3	VNB	3.74349e-17
C549	VPWR	a_642_392##3	5.58154e-18
C550	a_1342_74#	VNB	3.87572e-17
C551	a_823_98##4	VNB	5.59751e-17
C552	VPWR	a_823_98#	6.30489e-18
C553	a_823_98##9	VNB	3.70191e-17
C554	VPWR	a_353_98##4	4.6475e-17
C555	RESET_B#1	VNB	3.54862e-17
C556	a_642_392##4	VNB	3.41439e-17
C557	a_27_142##7	D#3	3.01222e-17
C558	VGND	VGND#5	4.73406e-17
C559	a_823_98##3	VNB	2.73684e-17
C560	a_353_98##3	VNB	2.17549e-17
C561	VPWR	a_353_98#	3.39464e-18
C562	a_226_104##5	VNB	6.39437e-17
C563	VGND	a_823_98##6	8.14063e-18
C564	VPWR	a_27_142##2	1.75788e-17
C565	a_27_142##3	VNB	3.45488e-17
C566	VGND	RESET_B#2	1.88178e-19
C567	a_226_104#	VNB	4.00771e-17
C568	VPWR	a_226_104##3	1.48278e-18
C569	VGND	a_642_392##3	1.104e-17
C570	GATE#1	VNB	3.49541e-17
C571	D#1	VNB	3.81972e-17
C572	VPWR	GATE#2	2.50719e-18
C573	VPWR#13	VPWR#6	3.18439e-19
C574	VGND	a_353_98##4	8.52979e-19
C575	VGND	a_226_104##7	4.26125e-17
C576	VPWR#5	VNB	2.8671e-17
C577	VGND	a_353_98#	8.34804e-18
C578	VGND#5	VNB	2.63637e-17
C579	VGND	a_27_142##2	2.96146e-18
C580	a_1342_74##2	VNB	4.09582e-17
C581	VPWR#6	a_226_104##2	3.87658e-20
C582	VGND	a_226_104##3	3.09153e-18
C583	a_823_98##6	VNB	5.51993e-17
C584	RESET_B#2	VNB	3.28537e-17
C585	VGND	GATE#2	4.44511e-18
C586	a_642_392##3	VNB	5.01105e-17
C587	VGND	D#2	2.16766e-19
C588	a_823_98#	VNB	5.58033e-17
C589	a_353_98##4	VNB	4.52871e-17
C590	a_226_104##7	VNB	5.10942e-17
C591	a_353_98#	VNB	2.41083e-17
C592	a_27_142##2	VNB	3.87304e-17
C593	a_226_104##3	VNB	4.8569e-17
C594	GATE#2	VNB	2.74947e-17
C595	D#2	VNB	4.5004e-17
C596	VPWR	GATE	1.01537e-18
C597	VPWR	D	1.70488e-18
C598	VGND	GATE	1.07999e-18
C599	VGND	D	1.3164e-18
C600	VPWR#4	a_642_392##2	7.71377e-20
C601	GATE	VNB	4.84438e-19
C602	VPWR	Q	2.00362e-17
C603	D	VNB	1.23738e-18
C604	Q_N	VNB	1.58572e-17
C605	Q	VNB	2.41149e-17
C606	VPWR	VNB	2.98564e-16
C607	VGND	VNB	3.1442e-16
C608	VGND#7	D#3	2.74309e-18
C609	a_1342_74##5	VPWR#2	2.80543e-18
C610	VGND	VGND#7	1.29755e-16
C611	VGND#2	a_823_98##6	1.27845e-19
C612	VGND#2	VNB	1.58681e-16
C613	VGND#7	GATE	6.11336e-20
C614	VPWR#2	VNB	1.60325e-16
C615	VGND#2	Q_N#1	1.80711e-18
C616	VPWR#7	VNB	6.23497e-17
C617	a_1342_74##7	VPWR#2	2.82801e-17
C618	VGND#7	GATE#2	1.18546e-18
C619	VGND#2	a_823_98##5	2.93362e-18
C620	VGND#2	Q#1	4.03031e-18
C621	VPWR#7	GATE#1	6.42327e-18
C622	VGND#7	VGND#6	4.38672e-19
C623	Q	VPWR#2	1.0088e-17
C624	a_1342_74##2	VPWR#2	5.39811e-18
C625	VPWR#7	GATE#2	4.00736e-20
C626	VGND#7	GATE#3	6.55344e-18
C627	VGND#7	VNB	6.69202e-17
C628	VGND#7	a_27_142#	4.13142e-19
C629	VPWR#2	a_1342_74#	8.2794e-18
C630	VPWR	VPWR#2	2.51457e-18
C631	VGND#2	VGND#9	2.32426e-17
C632	Q_N#1	VPWR#2	4.14889e-17
C633	VPWR#2	a_823_98##6	2.2515e-20
C634	VGND#2	a_1342_74##3	4.87604e-18
C635	VGND#2	a_1342_74##2	6.42784e-18
C636	VGND#7	a_226_104##3	6.94572e-20
C637	VGND#3	VGND#2	3.03704e-19
C638	VGND#7	a_27_142##7	7.9361e-18
C639	a_27_142##5	VPWR#7	2.24204e-17
C640	VGND#2	a_1342_74##5	9.24833e-19
C641	VGND#7	a_226_104##10	1.43616e-17
C642	VGND	VGND#2	5.60565e-18
C643	VPWR#7	D#1	4.40387e-18
C644	VPWR#2	a_823_98##4	1.03297e-17
C645	VGND#2	Q_N	4.29294e-17
C646	VGND#7	D#5	4.19773e-19
C647	VPWR#3	VPWR#2	3.94175e-19
C648	VPWR#7	a_226_104##3	8.16677e-20
C649	VPWR#2	VPWR#9	1.89089e-17
C650	VGND#2	a_1342_74##6	3.84519e-17
C651	VPWR#7	VPWR#6	1.10864e-19
C652	VPWR#2	a_823_98##5	1.58493e-18
C653	VPWR	VPWR#7	1.04856e-16
C654	VGND#2	a_823_98##8	3.34544e-18
*
*
.ENDS sky130_fd_sc_hs__dlrbp_1
*
