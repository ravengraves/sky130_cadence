* Extracted by Quantus, converted by sky130cad/quantus.py
*
*
*
*                       LINUX           Wed Nov 18 08:47:15 2026
*
*
*
*  PROGRAM  advgen
*
*  Name           : advgen - Quantus - (64-bit)
*  Version        : 25.1.0-p047
*  Build Date     : Thu Dec 11 23:20:30 PST 2025
*
*  HSPICE LIBRARY
*
*  OPERATING_TEMPERATURE 150
*  QRC_TECH_DIR <path>/tech
*
*
*

*
.SUBCKT sky130_fd_sc_hs__nand4_4 VPB VNB VGND VPWR Y D C B A
*
*
*  caps2d version: 10
*
*
*       TRANSISTOR CARDS
*
*
XM10 a_27_74##8 D#10 VGND#7 VNB sky130_fd_pr__nfet_01v8_lvt l=0.15 w=0.74 ad=0.2109 as=0.259 pd=2.05 ps=2.18
XM21 a_27_74##7 D#9 VGND#7 VNB sky130_fd_pr__nfet_01v8_lvt l=0.15 w=0.74 ad=0.259 as=0.259 pd=2.18 ps=2.18
XM16 VGND#6 D#7 a_27_74##7 VNB sky130_fd_pr__nfet_01v8_lvt l=0.15 w=0.74 ad=0.407 as=0.259 pd=2.58 ps=2.18
XM17 VGND#6 D#5 a_27_74##4 VNB sky130_fd_pr__nfet_01v8_lvt l=0.15 w=0.74 ad=0.407 as=0.259 pd=2.58 ps=2.18
XM11 a_27_74##4 C#6 a_554_74##3 VNB sky130_fd_pr__nfet_01v8_lvt l=0.15 w=0.74 ad=0.259 as=0.2072 pd=2.18 ps=2.04
XM13 a_554_74##3 C#9 a_27_74##2 VNB sky130_fd_pr__nfet_01v8_lvt l=0.15 w=0.74 ad=0.2072 as=0.2072 pd=2.04 ps=2.04
XM18 a_554_74# C#7 a_27_74##2 VNB sky130_fd_pr__nfet_01v8_lvt l=0.15 w=0.74 ad=0.2072 as=0.2072 pd=2.04 ps=2.04
XM7 a_27_74# C#1 a_554_74# VNB sky130_fd_pr__nfet_01v8_lvt l=0.15 w=0.74 ad=0.19515 as=0.2072 pd=2.05 ps=2.04
XM9 a_923_74##8 B#7 a_554_74##4 VNB sky130_fd_pr__nfet_01v8_lvt l=0.15 w=0.74 ad=0.1969 as=0.2072 pd=2.05 ps=2.04
XM15 a_554_74##4 B#5 a_923_74##6 VNB sky130_fd_pr__nfet_01v8_lvt l=0.15 w=0.74 ad=0.2072 as=0.2072 pd=2.04 ps=2.04
XM19 a_554_74##6 B#4 a_923_74##6 VNB sky130_fd_pr__nfet_01v8_lvt l=0.15 w=0.74 ad=0.2072 as=0.2072 pd=2.04 ps=2.04
XM0 a_923_74##4 B#1 a_554_74##6 VNB sky130_fd_pr__nfet_01v8_lvt l=0.15 w=0.74 ad=0.2072 as=0.2072 pd=2.04 ps=2.04
XM6 Y#10 A#8 a_923_74##4 VNB sky130_fd_pr__nfet_01v8_lvt l=0.15 w=0.74 ad=0.2072 as=0.2072 pd=2.04 ps=2.04
XM1 a_923_74##2 A#7 Y#10 VNB sky130_fd_pr__nfet_01v8_lvt l=0.15 w=0.74 ad=0.2072 as=0.2072 pd=2.04 ps=2.04
XM8 Y#8 A#5 a_923_74##2 VNB sky130_fd_pr__nfet_01v8_lvt l=0.15 w=0.74 ad=0.3256 as=0.2072 pd=2.36 ps=2.04
XM23 a_923_74# A#1 Y#8 VNB sky130_fd_pr__nfet_01v8_lvt l=0.15 w=0.74 ad=0.1962 as=0.3256 pd=2.05 ps=2.36
XM5 Y#1 D#6 VPWR#7 VPB sky130_fd_pr__pfet_01v8 l=0.15 w=1.12 ad=0.392 as=1.736 pd=2.94 ps=5.34
XM2 VPWR#10 D#1 Y#1 VPB sky130_fd_pr__pfet_01v8 l=0.15 w=1.12 ad=0.336 as=0.392 pd=2.84 ps=2.94
XM12 Y#2 C#10 VPWR#10 VPB sky130_fd_pr__pfet_01v8 l=0.15 w=1.12 ad=0.7616 as=0.336 pd=3.6 ps=2.84
XM20 VPWR#9 C#8 Y#2 VPB sky130_fd_pr__pfet_01v8 l=0.15 w=1.12 ad=0.9744 as=0.7616 pd=3.98 ps=3.6
XM3 VPWR#9 B#9 Y#4 VPB sky130_fd_pr__pfet_01v8 l=0.15 w=1.12 ad=0.9744 as=0.7616 pd=3.98 ps=3.6
XM22 Y#4 B#8 VPWR#8 VPB sky130_fd_pr__pfet_01v8 l=0.15 w=1.12 ad=0.7616 as=1.8592 pd=3.6 ps=5.56
XM14 VPWR#8 A#9 Y#6 VPB sky130_fd_pr__pfet_01v8 l=0.15 w=1.12 ad=1.8592 as=0.8736 pd=5.56 ps=3.8
XM4 Y#6 A#4 VPWR#1 VPB sky130_fd_pr__pfet_01v8 l=0.15 w=1.12 ad=0.8736 as=0.3304 pd=3.8 ps=2.83
*
*
*       RESISTOR AND CAP/DIODE CARDS
*
Rg1	D#1	D#2	454.869080
Rg2	D#2	D#3	76.976173
Rg3	D#3	D#4	57.284767
Rg4	D#2	D#5	418.139221
Rg5	D#3	D#6	419.554810
Rg6	D#4	D#7	377.027313
Rg7	D#4	D#8	81.544861
Rg8	D#8	D#9	370.752045
Rg9	D#8	D#10	474.920227
Rg10	C#1	C#2	451.932220
Rg11	C#2	C#3	43.647682
Rg12	C#3	C#4	30.358044
Rg13	C#4	C#5	60.971695
Rg14	C#5	C#6	397.555725
Rg15	C#2	C#7	394.561310
Rg16	C#2	C#8	446.660797
Rg17	C#4	C#9	370.752045
Rg18	C#5	C#10	449.655212
Rg19	B#1	B#2	450.454926
Rg20	B#2	B#3	93.750946
Rg21	B#2	B#4	370.752045
Rg22	B#3	B#5	380.313354
Rg23	B#3	B#6	63.826347
Rg24	B#6	B#7	370.752045
Rg25	B#3	B#8	429.126801
Rg26	B#6	B#9	502.051483
Rg27	A#1	A#2	397.555725
Rg28	A#2	A#3	116.761421
Rg29	A#2	A#4	449.655212
Rg30	A#3	A#5	377.027313
Rg31	A#3	A#6	36.757153
Rg32	A#6	A#7	413.013641
Rg33	A#6	A#8	474.428833
Rg34	A#6	A#9	452.720551
Rf1	D	D#11	6.876061
Rf2	D#11	D	7.792870
Rf3	C	C#11	9.320884
Rf4	C#11	C	5.348048
Rf5	a_27_74#	a_27_74##3	48.855850
Rf6	a_27_74##3	a_27_74##5	36.946182
Rf7	a_27_74##5	a_27_74##6	89.515961
Rf8	a_27_74##6	a_27_74##7	18.149860
Rf9	a_27_74##6	a_27_74##8	87.959900
Rf10	a_27_74##2	a_27_74##3	15.000000
Rf11	a_27_74##4	a_27_74##5	7.500000
Rf12	B	B#10	6.264856
Rf13	B#10	B	8.404075
Rf14	a_554_74##2	a_554_74##3	54.555492
Rf15	a_554_74##2	a_554_74##5	70.847191
Rf16	a_554_74##5	a_554_74##6	56.758797
Rf17	a_554_74#	a_554_74##2	15.000000
Rf18	a_554_74##4	a_554_74##5	15.000000
Rf19	A	A#10	0.916808
Rf20	A#10	A	13.752123
Rf21	Y#1	Y#3	78.347855
Rf22	Y#3	Y#5	98.541420
Rf23	Y#5	Y#7	157.503708
Rf24	Y#7	Y	48.328136
Rf25	Y	Y#9	37.948242
Rf26	Y#9	Y#10	60.851810
Rf27	Y#2	Y#3	2.500000
Rf28	Y#4	Y#5	2.500000
Rf29	Y#6	Y#7	2.500000
Rf30	Y#8	Y#9	15.000000
Rf31	a_923_74#	a_923_74##3	77.362259
Rf32	a_923_74##3	a_923_74##5	50.674179
Rf33	a_923_74##5	a_923_74##7	50.674179
Rf34	a_923_74##7	a_923_74##8	65.674179
Rf35	a_923_74##2	a_923_74##3	15.000000
Rf36	a_923_74##4	a_923_74##5	15.000000
Rf37	a_923_74##6	a_923_74##7	15.000000
Rf38	VPWR#1	VPWR#2	77.974731
Rf39	VPWR#2	VPWR#3	103.216454
Rf40	VPWR#3	VPWR#4	166.340347
Rf41	VPWR#4	VPWR#5	50.705303
Rf42	VPWR#5	VPWR#6	63.894653
Rf43	VPWR#6	VPWR#7	86.945595
Rf44	VPWR#3	VPWR#8	6.545681
Rf45	VPWR#4	VPWR#9	13.142626
Rf46	VPWR#6	VPWR#10	31.534731
Rf47	VGND#1	VGND#2	315.578125
Rf48	VGND#2	VGND#3	115.395248
Rf49	VGND#3	VGND#4	73.001427
Rf51	VGND#3	VGND#6	38.247387
Rf52	VGND#4	VGND#7	38.247387
Rf53	D#4	D#11	32.046562
Rf54	C#3	C#11	40.058201
Rf55	B#3	B#10	32.046562
Rf56	A#3	A#10	40.058201
Re1	VPWR#2	VPWR	3.735117
Re2	VPWR	VPWR#5	1.067176
Re3	VGND#1	VGND	3.735117
Re4	VGND	VGND#2	1.067176
*
*       CAPACITOR CARDS
*
*
C1	VGND	VNB	3.15553e-16
C2	VPWR	VNB	2.77142e-16
C3	Y	VNB	5.41298e-17
C4	Y#8	A#6	2.63231e-18
C5	D	VNB	5.41156e-17
C6	C	VNB	2.59599e-17
C7	a_923_74##8	a_923_74##6	3.85971e-18
C8	B	VNB	3.43835e-17
C9	A	VNB	2.52186e-17
C10	VGND	D	1.29413e-17
C11	a_27_74##4	C#9	2.29607e-18
C12	VGND	C	9.56502e-18
C13	VPWR	D	1.54378e-17
C14	VGND	B	9.89675e-18
C15	D#4	VNB	2.61288e-17
C16	VPWR	C	1.16665e-17
C17	B#3	VNB	3.31436e-17
C18	VPWR	B	1.198e-17
C19	VGND#2	VNB	8.1096e-17
C20	VPWR#5	VNB	1.71368e-17
C21	VGND#1	VNB	2.46959e-16
C22	VPWR#2	VNB	1.37698e-16
C23	D	C	3.30983e-17
C24	Y#4	B#1	3.24513e-18
C25	VGND#6	C#7	1.19086e-19
C26	A	Y	3.68276e-17
C27	D#6	VNB	3.55537e-17
C28	D#1	VNB	2.88577e-17
C29	C#10	VNB	2.94755e-17
C30	C#8	VNB	3.03365e-17
C31	B#9	VNB	5.84667e-17
C32	VGND	VGND#2	1.47875e-16
C33	B#8	VNB	3.02884e-17
C34	C	B	3.5826e-17
C35	a_554_74##3	C#9	3.65353e-17
C36	A#9	VNB	3.05387e-17
C37	VGND	VGND#1	8.66892e-17
C38	A#4	VNB	3.79804e-17
C39	VPWR#4	C#10	8.67762e-19
C40	D#10	VNB	6.51708e-17
C41	D#9	VNB	2.56789e-17
C42	D#7	VNB	3.02212e-17
C43	D#5	VNB	3.26415e-17
C44	C#6	VNB	3.16511e-17
C45	B	A	1.67855e-17
C46	C#9	VNB	2.98547e-17
C47	VPWR	VPWR#5	3.09229e-17
C48	C#7	VNB	3.04265e-17
C49	C#1	VNB	5.18017e-17
C50	B#7	VNB	3.34311e-17
C51	a_27_74##4	C#7	1.30767e-18
C52	B#5	VNB	3.06115e-17
C53	a_923_74##6	a_554_74##4	3.30226e-17
C54	Y#1	VPWR#6	9.32814e-18
C55	D	D#4	1.86234e-17
C56	B#4	VNB	3.04144e-17
C57	B#1	VNB	4.27386e-17
C58	A#8	VNB	4.3776e-17
C59	VPWR#6	C#10	9.78637e-19
C60	A#7	VNB	3.04438e-17
C61	VPWR	D#6	1.26409e-18
C62	A#5	VNB	3.13886e-17
C63	a_27_74##2	C#4	1.10202e-18
C64	A#1	VNB	3.92747e-17
C65	a_27_74##2	C#9	3.69556e-17
C66	VGND	D#10	7.34567e-19
C67	VPWR#7	VNB	1.35516e-16
C68	VPWR	D#1	4.8345e-19
C69	Y#1	VNB	2.82952e-18
C70	VGND	D#9	5.1028e-19
C71	VPWR#10	VNB	1.40547e-19
C72	VPWR	C#10	5.90986e-19
C73	VGND#1	Y	5.48029e-18
C74	VGND	D#7	7.10043e-20
C75	Y#2	VNB	7.37572e-18
C76	VGND#6	C#1	1.20408e-19
C77	VPWR	C#8	5.74816e-19
C78	VGND	D#5	1.72622e-19
C79	Y#4	VNB	7.60996e-18
C80	VGND	C#6	6.62363e-19
C81	VPWR	B#9	5.98499e-19
C82	a_27_74##6	VGND#7	1.89802e-17
C83	Y#6	VNB	1.83622e-17
C84	VGND	C#9	6.43429e-19
C85	VPWR	B#8	5.06565e-19
C86	VPWR#1	VNB	6.11188e-17
C87	a_27_74##8	VNB	4.34472e-17
C88	VGND	C#7	7.04835e-19
C89	VPWR#7	Y#1	1.07824e-16
C90	VGND#7	VNB	8.74655e-19
C91	VGND	C#1	7.27813e-19
C92	A#6	A#2	2.1738e-18
C93	a_27_74##7	VNB	2.63465e-18
C94	VGND#6	VNB	2.07545e-18
C95	VGND	B#7	8.98193e-19
C96	a_923_74#	A#2	3.76403e-19
C97	a_27_74##4	VNB	8.43789e-18
C98	VGND	B#5	8.75215e-19
C99	a_554_74##3	VNB	4.84462e-19
C100	a_27_74##2	VNB	4.1991e-18
C101	VGND	B#4	8.6578e-19
C102	VPWR#10	VPWR#4	1.13743e-18
C103	a_554_74#	VNB	8.99178e-18
C104	B	B#3	2.16776e-17
C105	Y#6	B#1	2.53846e-18
C106	VGND	B#1	8.6578e-19
C107	a_27_74#	VNB	6.93471e-18
C108	a_923_74##8	VNB	6.18802e-18
C109	VGND	A#8	1.32312e-19
C110	a_554_74##4	VNB	4.56643e-18
C111	a_923_74##6	VNB	3.89485e-18
C112	D	D#6	5.10884e-18
C113	a_554_74##6	VNB	5.82054e-19
C114	A#8	VPWR#8	3.10657e-19
C115	a_923_74##4	VNB	3.89485e-18
C116	Y#10	VNB	6.06936e-19
C117	a_27_74##4	C#1	9.46481e-19
C118	D	D#1	2.28643e-18
C119	a_923_74##2	VNB	4.45881e-18
C120	A	B#3	1.81888e-20
C121	Y	A#9	1.12215e-18
C122	Y#8	VNB	1.04276e-18
C123	a_923_74#	VNB	2.59188e-17
C124	a_554_74##4	a_554_74##6	2.70752e-19
C125	D	C#10	5.12938e-19
C126	Y	A#4	5.75273e-18
C127	VPWR#4	C#8	2.95533e-17
C128	a_27_74##2	C#5	1.62159e-19
C129	a_27_74##2	C#7	3.69556e-17
C130	a_27_74##6	VNB	1.81277e-18
C131	VPWR#7	VPWR#10	2.34591e-18
C132	C	D#1	8.39662e-19
C133	VGND	a_27_74##8	1.81762e-17
C134	C	C#10	2.1107e-18
C135	VGND	a_27_74##7	1.71053e-17
C136	VGND#1	A	8.26457e-18
C137	C#4	Y#2	1.26208e-17
C138	C	C#8	2.17752e-18
C139	VPWR#3	VNB	8.1548e-17
C140	D#2	C#5	2.56908e-17
C141	VGND	a_27_74##4	2.58282e-17
C142	Y#6	A#8	4.13046e-18
C143	VPWR#4	VNB	4.80251e-17
C144	VPWR#6	VNB	3.00881e-17
C145	VGND	a_554_74##3	5.4944e-18
C146	a_27_74##6	a_27_74##7	5.33767e-19
C147	VGND	a_27_74##2	2.47901e-17
C148	VPWR#2	A	9.61464e-18
C149	C	B#9	6.03372e-18
C150	VGND#3	VNB	4.50951e-17
C151	D	D#10	1.87031e-17
C152	VPWR	VPWR#7	2.32365e-16
C153	VGND	a_554_74#	1.14685e-17
C154	VGND	a_27_74#	1.89444e-17
C155	a_554_74#	C#7	3.65353e-17
C156	VPWR	Y#1	1.85837e-17
C157	VGND	a_923_74##8	1.80579e-17
C158	VPWR	VPWR#10	2.1685e-17
C159	VGND	a_554_74##4	1.06601e-17
C160	VPWR	Y#2	3.22607e-17
C161	VGND	a_923_74##6	2.18497e-17
C162	VGND	a_554_74##6	6.71527e-18
C163	B	C#8	9.21812e-20
C164	VGND	a_923_74##4	1.86861e-17
C165	VPWR	Y#4	3.54681e-17
C166	Y#1	VPWR#10	7.20935e-17
C167	D#4	D#2	1.62223e-18
C168	Y	B#1	2.38562e-19
C169	B	B#9	1.36943e-17
C170	a_554_74##6	a_923_74##6	3.32176e-17
C171	Y#2	VPWR#4	1.05047e-16
C172	VPWR	Y#6	2.28142e-18
C173	Y	A#8	1.75457e-19
C174	VPWR#3	B#9	9.14068e-19
C175	B	B#8	2.17271e-18
C176	Y	A#7	1.05568e-19
C177	Y	A#5	2.35997e-19
C178	B	A#9	2.7755e-19
C179	C#5	Y#2	1.27335e-18
C180	Y	A#1	9.32642e-18
C181	VGND	a_27_74##6	3.87026e-18
C182	D#8	D#4	2.58024e-18
C183	a_554_74##4	C#9	2.35003e-19
C184	VPWR#4	B#9	3.78908e-17
C185	A	B#8	7.65846e-20
C186	a_554_74#	C#1	3.73991e-17
C187	A	A#9	2.16759e-18
C188	Y#1	Y#2	2.72908e-18
C189	a_27_74##6	VGND#6	2.70082e-17
C190	Y#2	VPWR#6	8.26486e-18
C191	A	A#4	1.13656e-18
C192	Y	VPWR#8	2.05774e-19
C193	C#4	C#1	3.20043e-18
C194	a_554_74#	C#4	4.41371e-18
C195	C	C#1	1.28638e-17
C196	Y	Y#6	3.14918e-19
C197	Y	VPWR#1	2.28363e-18
C198	VGND	VGND#3	1.0155e-16
C199	a_923_74##6	a_923_74##4	3.85971e-18
C200	D	VPWR#7	1.64154e-16
C201	VGND#2	B#3	2.0176e-20
C202	D	Y#1	5.35921e-17
C203	a_27_74#	C#1	4.89417e-17
C204	a_554_74##4	C#7	2.98891e-19
C205	VPWR#4	VPWR#9	1.31472e-17
C206	VPWR#3	B#8	3.14692e-17
C207	B	C#1	6.15611e-18
C208	Y#2	VPWR#10	8.90892e-17
C209	VGND#1	B#3	9.88399e-20
C210	a_923_74##8	C#1	5.92305e-19
C211	VPWR#4	B#8	1.36356e-18
C212	a_27_74##8	D	5.27886e-17
C213	Y#4	VPWR#3	1.56318e-16
C214	D#2	VNB	2.81316e-17
C215	D#3	VNB	2.84587e-17
C216	B	A#8	5.96573e-18
C217	D#8	VNB	3.33127e-17
C218	a_923_74##4	a_554_74##6	1.13343e-17
C219	C	Y#2	1.35777e-16
C220	C#4	VNB	5.95602e-17
C221	C#4	B#9	1.20962e-19
C222	C#5	VNB	2.56704e-17
C223	C#4	VPWR#9	7.30958e-19
C224	B#2	VNB	3.27122e-17
C225	a_27_74#	B#7	6.90776e-19
C226	B#6	VNB	2.45588e-17
C227	VPWR	VPWR#3	1.83088e-16
C228	A#2	VNB	4.18057e-17
C229	a_27_74##4	D	3.77233e-17
C230	VPWR	VPWR#4	1.48792e-16
C231	A#6	VNB	6.20984e-17
C232	Y	a_923_74#	2.93491e-17
C233	a_27_74##6	D#9	1.71498e-17
C234	C	Y#4	1.9999e-17
C235	VPWR	VPWR#6	5.79879e-17
C236	a_554_74##4	C#1	8.99206e-19
C237	A	B#1	6.53377e-18
C238	C#1	B#6	8.22036e-19
C239	A	A#8	1.09613e-17
C240	VPWR#3	A#9	3.91375e-17
C241	Y#4	VPWR#4	1.25019e-16
C242	a_923_74##8	B#7	4.95328e-17
C243	Y#2	VPWR#9	3.2298e-18
C244	B	Y#4	1.58352e-16
C245	a_554_74##6	Y#10	1.22152e-17
C246	a_27_74##4	C	2.40038e-17
C247	B#9	B#3	2.18654e-19
C248	a_554_74##3	C	4.22201e-17
C249	VPWR#3	VPWR#8	4.4124e-17
C250	a_554_74##4	B#7	4.07245e-17
C251	a_554_74#	C	6.45013e-17
C252	a_27_74##6	D#7	2.33366e-17
C253	a_27_74#	C#4	3.93814e-19
C254	Y#2	Y#4	1.50294e-18
C255	a_923_74##8	B#5	1.10168e-18
C256	a_27_74##6	D	1.00389e-16
C257	a_27_74##6	D#3	4.07826e-18
C258	a_923_74##6	B#7	1.59615e-18
C259	VGND#2	B#9	3.16634e-19
C260	VPWR#3	A#4	1.32521e-18
C261	VPWR#5	C#8	7.04077e-19
C262	A	Y#6	1.24763e-16
C263	a_923_74##4	Y#10	1.14161e-17
C264	a_27_74##8	VPWR#7	3.27106e-19
C265	a_554_74##4	B#5	3.61969e-17
C266	a_554_74#	B	8.52845e-18
C267	Y#4	VPWR#9	5.792e-18
C268	a_554_74##6	B#7	1.67254e-19
C269	Y#6	VPWR#3	1.41172e-16
C270	a_554_74##4	B	7.75669e-17
C271	a_923_74##6	B#5	3.60966e-17
C272	D#6	D#1	3.67329e-17
C273	a_554_74##6	B	4.27906e-17
C274	a_27_74##6	D#8	2.9433e-18
C275	a_923_74##4	a_923_74##2	3.85971e-18
C276	a_554_74##4	B#4	7.97885e-19
C277	a_554_74##6	B#5	3.99904e-19
C278	D#1	C#10	4.65205e-17
C279	VPWR#2	A#9	7.24365e-19
C280	VPWR#6	D#2	2.65791e-20
C281	a_923_74##6	B#4	3.65556e-17
C282	VPWR#3	VPWR#1	1.1902e-18
C283	Y#4	VPWR#8	1.17035e-17
C284	VPWR#2	A#4	1.64439e-18
C285	a_923_74##4	A	1.43678e-18
C286	a_923_74##2	Y#10	3.69082e-17
C287	Y#10	A	4.34355e-17
C288	a_554_74##4	B#1	1.67254e-19
C289	Y#4	B#2	1.04297e-17
C290	VGND#2	C#6	5.31202e-18
C291	C#10	C#8	1.12821e-17
C292	Y#8	A	4.9608e-17
C293	B#3	B#2	3.20043e-18
C294	a_554_74##6	B#4	3.63552e-17
C295	VGND#2	C#9	5.35671e-18
C296	D#4	VPWR#7	9.26424e-18
C297	B#6	B#3	3.20043e-18
C298	VGND#2	C#7	5.36658e-18
C299	a_923_74##6	B#1	1.10168e-18
C300	B#6	Y#4	7.96326e-18
C301	C#8	B#9	4.80802e-18
C302	VGND#2	C#1	5.3774e-18
C303	a_923_74##4	B#4	1.10168e-18
C304	B#3	A#6	2.97891e-20
C305	Y#10	Y#8	2.41447e-19
C306	VPWR#6	D#3	6.55077e-21
C307	VGND#2	B#7	5.35671e-18
C308	a_554_74##6	B#1	3.01994e-17
C309	Y#6	VPWR#8	1.54285e-17
C310	Y#10	B#4	1.67254e-19
C311	a_27_74##4	Y#1	3.4832e-18
C312	B#9	B#8	1.13665e-17
C313	a_923_74##4	B#1	4.28218e-17
C314	Y#8	a_923_74##2	3.2476e-17
C315	VGND#3	a_27_74##6	2.25448e-19
C316	a_554_74##6	A#8	2.6257e-18
C317	VPWR#4	C#4	9.95981e-19
C318	B#8	A#9	9.7685e-19
C319	VPWR#3	B#2	3.22594e-18
C320	Y#10	B#1	2.70553e-18
C321	VGND#1	B#5	5.36658e-18
C322	B#2	VPWR#8	1.96993e-18
C323	a_923_74##8	B#6	5.09751e-19
C324	VGND#1	B#4	5.35671e-18
C325	a_923_74##4	A#8	4.4302e-17
C326	Y#6	VPWR#1	9.695e-17
C327	B#3	Y#4	3.3636e-18
C328	a_923_74##2	a_923_74#	3.08565e-18
C329	VGND#1	B#1	5.3774e-18
C330	B#3	VPWR#8	2.92383e-19
C331	a_554_74##6	A#7	1.67254e-19
C332	A#9	A#4	7.99506e-18
C333	a_27_74##4	Y#2	2.73444e-18
C334	VGND#1	A#8	6.11864e-18
C335	Y#10	A#8	2.73137e-17
C336	VGND#3	D#9	7.78153e-19
C337	VGND#1	A#7	6.28908e-18
C338	C#5	C#4	3.41908e-18
C339	VPWR#3	B#6	3.65643e-20
C340	a_923_74##4	A#7	1.10168e-18
C341	Y	A#2	1.81514e-17
C342	VGND#1	A#5	6.23404e-18
C343	Y	A#6	6.43796e-19
C344	a_923_74#	Y#8	1.58078e-17
C345	a_923_74##2	A#8	1.10168e-18
C346	VGND#1	A#1	6.87985e-18
C347	Y#10	A#7	3.60212e-17
C348	VGND#3	D#2	9.89722e-20
C349	Y#2	VPWR#5	2.42417e-17
C350	Y#8	A#8	1.52387e-19
C351	VGND#2	C#4	2.05387e-19
C352	A#6	VPWR#8	8.36947e-19
C353	VPWR#6	C#4	1.47628e-20
C354	VGND#3	D#7	6.04706e-18
C355	a_923_74##2	A#7	3.60966e-17
C356	VGND#2	C#5	4.2619e-20
C357	a_554_74##4	B#6	2.05876e-18
C358	Y#10	A#5	4.05046e-19
C359	VGND#2	B#6	6.7329e-20
C360	Y#8	A#7	6.5779e-19
C361	D	D#2	1.37896e-17
C362	C#1	B#9	1.31563e-17
C363	D	D#3	1.45212e-17
C364	D#10	D#9	2.46837e-17
C365	a_923_74##8	B#3	2.2875e-19
C366	D	D#8	2.30736e-17
C367	a_27_74##8	VGND#7	5.65503e-17
C368	a_554_74##4	B#3	3.82972e-18
C369	B#2	B#1	3.20043e-18
C370	a_923_74##2	A#5	3.89913e-17
C371	D	C#5	6.73452e-18
C372	VPWR#6	C#5	1.77417e-20
C373	VPWR#4	B#6	7.54817e-20
C374	VPWR#3	A#6	1.14518e-18
C375	a_923_74##6	B#3	5.60699e-19
C376	VGND#3	D#5	8.31818e-18
C377	VGND#2	a_27_74##4	1.09403e-17
C378	Y#10	A#1	2.35335e-19
C379	D#6	VPWR#7	3.97025e-17
C380	a_27_74##6	D#4	3.39605e-18
C381	A#2	Y#6	2.82096e-18
C382	Y#8	A#5	4.38915e-17
C383	D#9	D#7	2.83523e-17
C384	a_923_74##6	B#2	5.17713e-19
C385	a_27_74##8	a_27_74##7	2.99118e-18
C386	Y#1	D#6	5.31296e-17
C387	VGND#3	a_27_74##7	8.43305e-18
C388	VGND#2	a_27_74##2	3.91555e-17
C389	a_27_74##8	D#8	1.45657e-18
C390	a_923_74##2	A#1	1.79683e-18
C391	VPWR#10	D#6	2.53968e-18
C392	VGND#2	a_554_74#	1.45331e-18
C393	VPWR#7	D#1	9.07272e-19
C394	Y#6	VPWR#2	7.17049e-17
C395	a_554_74#	Y#4	5.73859e-18
C396	VPWR#5	C#4	1.47515e-19
C397	a_923_74#	A#5	1.75578e-18
C398	VGND#2	a_27_74#	3.06983e-17
C399	A#6	Y#6	1.28333e-17
C400	Y#2	D#6	4.94452e-19
C401	Y#1	D#1	3.62388e-17
C402	VPWR#2	VPWR#1	6.30924e-17
C403	VGND#3	C#6	6.6752e-19
C404	VGND#7	a_27_74##7	4.52314e-17
C405	VGND#2	a_923_74##8	2.8753e-17
C406	D#7	D#5	1.36884e-17
C407	D#10	D#8	2.53731e-18
C408	Y#8	A#1	3.83689e-17
C409	VPWR#10	D#1	4.56454e-17
C410	VGND#2	a_554_74##4	1.40341e-18
C411	Y#2	D#1	9.28994e-19
C412	C	D#2	8.00419e-18
C413	Y#1	C#10	4.62904e-19
C414	a_923_74#	A#1	3.34372e-17
C415	VGND#7	VGND#6	1.33648e-18
C416	VPWR#10	C#10	5.27529e-17
C417	C	C#4	4.20895e-17
C418	C	C#5	1.73766e-17
C419	D#5	C#6	2.8319e-17
C420	Y#1	C#8	1.42994e-19
C421	Y#2	C#10	5.39848e-17
C422	VGND#3	C#9	2.9404e-19
C423	VPWR#10	C#8	9.45372e-19
C424	a_27_74##7	VGND#6	4.52314e-17
C425	a_554_74##6	B#2	4.20872e-18
C426	VGND#7	D#8	1.15829e-18
C427	VGND#1	a_923_74##8	1.34691e-18
C428	VGND#3	a_27_74##4	1.92065e-17
C429	Y#4	C#10	1.98877e-19
C430	Y#2	C#8	5.06804e-17
C431	VGND#3	D#4	3.58181e-20
C432	C#6	C#9	4.06774e-17
C433	VPWR#4	C#1	1.21012e-18
C434	C#8	VPWR#9	3.69958e-17
C435	VGND#1	a_923_74##6	3.70425e-17
C436	a_27_74##7	a_27_74##4	2.55573e-18
C437	VGND#3	C#7	1.45937e-19
C438	Y#2	B#9	5.32076e-19
C439	Y#4	C#8	7.96518e-19
C440	VGND#1	B#2	1.26044e-19
C441	A#8	A#6	3.20043e-18
C442	VGND#1	a_923_74##4	4.354e-17
C443	B#9	VPWR#9	3.69958e-17
C444	C#9	C#7	4.06774e-17
C445	VGND#1	Y#10	6.90932e-18
C446	a_554_74##6	Y#4	2.54559e-18
C447	a_27_74##4	VGND#6	3.57461e-17
C448	VGND#1	A#2	9.2039e-20
C449	Y#2	B#8	2.81352e-19
C450	Y#4	B#9	5.76257e-17
C451	B	C#4	2.1893e-20
C452	VGND#1	a_923_74##2	6.45022e-17
C453	VGND#1	A#6	2.13904e-19
C454	B	B#2	3.04284e-17
C455	B	B#6	1.8786e-17
C456	VPWR#3	B#3	4.32375e-19
C457	VGND#1	Y#8	7.62143e-18
C458	VGND#3	C#1	1.33118e-19
C459	B	A#6	6.5918e-20
C460	a_923_74##4	Y#4	7.05215e-19
C461	VGND#1	a_923_74#	5.41847e-17
C462	C#7	C#1	4.06774e-17
C463	Y#4	B#8	5.34792e-17
C464	a_923_74##4	B#2	2.88624e-19
C465	B#8	VPWR#8	3.99265e-17
C466	D#10	VPWR#7	5.94714e-18
C467	Y#4	A#9	6.23097e-19
C468	Y#6	B#8	6.30198e-19
C469	a_27_74##4	a_554_74##3	4.37661e-17
C470	C#1	B#7	3.68445e-18
C471	A#9	VPWR#8	3.99265e-17
C472	Y#6	A#9	6.22542e-17
C473	VPWR#2	A#2	3.93046e-20
C474	VGND#6	D#3	1.99557e-18
C475	a_923_74##4	Y#6	3.81319e-18
C476	VPWR#1	A#9	1.31549e-18
C477	VPWR#2	A#6	1.47057e-19
C478	B#7	B#5	4.15239e-17
C479	A	A#2	1.47766e-17
C480	Y#6	A#4	5.66128e-17
C481	A	A#6	4.40835e-17
C482	VPWR#4	VPWR#3	1.7835e-18
C483	a_27_74##2	a_554_74##3	3.91383e-17
C484	VPWR#3	B#1	1.21012e-18
C485	VPWR#1	A#4	3.7664e-17
C486	a_923_74##4	A#6	2.73272e-19
C487	D#3	D#2	7.05287e-19
C488	B#5	B#4	4.04539e-17
C489	a_27_74##4	D#2	4.11615e-18
C490	a_554_74#	B#9	1.31065e-18
C491	a_27_74##4	a_27_74#	7.53401e-20
C492	VPWR#7	D#3	2.04712e-20
C493	VPWR#3	A#8	1.36947e-18
C494	Y#8	Y#6	1.98309e-18
C495	a_923_74##8	B#9	6.7496e-19
C496	D#8	VPWR#7	1.16589e-17
C497	a_27_74##4	D#3	1.48029e-18
C498	a_554_74#	a_27_74##2	3.54508e-17
C499	B#4	B#1	4.14265e-17
C500	a_554_74##4	B#9	2.939e-18
C501	a_27_74##8	D#10	5.15706e-17
C502	VPWR#6	VPWR#4	6.05851e-19
C503	D#10	VGND#7	1.80221e-17
C504	D#2	Y#1	1.88514e-18
C505	Y#10	A#6	4.20265e-18
C506	a_27_74##8	D#9	1.83577e-18
C507	a_27_74##7	D#10	9.34443e-19
C508	B#1	A#8	6.66324e-17
C509	a_923_74#	VPWR#1	7.25569e-20
C510	VPWR#2	VPWR#3	7.44106e-17
C511	D#3	Y#1	1.959e-18
C512	VGND#7	D#9	3.73854e-17
C513	a_27_74#	a_554_74#	4.90902e-17
C514	a_27_74##8	D#7	2.32314e-19
C515	D#9	a_27_74##7	1.37611e-17
C516	VGND#7	D#7	1.21805e-18
C517	A#8	A#7	4.14265e-17
C518	VGND#6	D#9	3.62413e-19
C519	a_554_74##4	a_27_74##2	5.34585e-21
C520	Y#2	C#1	1.90854e-18
C521	a_923_74##2	A#2	4.29866e-20
C522	a_27_74##7	D#7	4.1765e-17
C523	C#1	VPWR#9	8.18598e-19
C524	VGND#7	D#5	9.72954e-20
C525	a_27_74##4	C#5	1.48921e-19
C526	D#7	VGND#6	2.56491e-17
C527	a_27_74#	a_923_74##8	2.84549e-17
C528	a_923_74##2	A#6	1.026e-18
C529	a_27_74##7	D#5	6.56616e-19
C530	Y#4	C#1	9.82443e-19
C531	A#7	A#5	4.05123e-17
C532	a_27_74##4	D#7	1.40696e-18
C533	D#5	VGND#6	2.1563e-17
C534	a_27_74##4	D#5	5.77285e-17
C535	a_554_74##3	C#4	2.06355e-18
C536	VGND#6	C#6	3.53235e-19
C537	A#5	A#1	2.12568e-17
C538	a_554_74##3	D#5	7.29415e-19
C539	Y#8	A#2	2.94064e-18
C540	a_554_74##4	a_923_74##8	5.43821e-17
C541	a_27_74##4	C#6	4.32973e-17
C542	a_554_74##3	C#5	1.36137e-18
C543	VGND#6	C#9	1.93788e-19
C544	VPWR#7	VPWR#6	1.03994e-18
C545	a_554_74##3	C#6	2.59761e-17
C546	VPWR#6	D#1	9.79909e-19
C547	VGND#4	D#8	2.2443e-20
C548	VGND#4	D#7	1.01401e-18
C549	VGND#4	D#10	6.05021e-18
C550	VGND#4	VGND#3	1.10043e-18
C551	VGND#4	VNB	4.90356e-17
C552	VGND#4	D#5	1.48241e-19
C553	VGND#4	a_27_74##7	9.20068e-18
C554	VGND#4	D#9	5.28335e-18
C555	VGND#4	a_27_74##8	2.10084e-17
C556	VGND	VGND#4	1.02028e-16
C557	VGND#4	D#4	4.51127e-20
C558	VGND#4	a_27_74##6	2.25448e-19
*
*
.ENDS sky130_fd_sc_hs__nand4_4
*
