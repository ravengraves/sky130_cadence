* Extracted by Quantus, converted by sky130cad/quantus.py
*
*
*
*                       LINUX           Wed Nov 18 08:02:43 2026
*
*
*
*  PROGRAM  advgen
*
*  Name           : advgen - Quantus - (64-bit)
*  Version        : 25.1.0-p047
*  Build Date     : Thu Dec 11 23:20:30 PST 2025
*
*  HSPICE LIBRARY
*
*  OPERATING_TEMPERATURE 150
*  QRC_TECH_DIR <path>/tech
*
*
*

*
.SUBCKT sky130_fd_sc_hs__a211o_1 VPB VNB VGND VPWR X B1 C1 A2 A1
*
*
*  caps2d version: 10
*
*
*       TRANSISTOR CARDS
*
*
XM0 X#3 a_81_264# VGND#7 VNB sky130_fd_pr__nfet_01v8_lvt l=0.15 w=0.74 ad=0.1961 as=0.31285 pd=2.01 ps=2.7
XM8 VGND#7 A2#1 a_366_136# VNB sky130_fd_pr__nfet_01v8_lvt l=0.15 w=0.64 ad=0.31285 as=0.208 pd=2.7 ps=1.93
XM9 a_366_136# A1#1 a_81_264##7 VNB sky130_fd_pr__nfet_01v8_lvt l=0.15 w=0.64 ad=0.208 as=0.1792 pd=1.93 ps=1.84
XM7 a_81_264##7 B1#2 VGND#6 VNB sky130_fd_pr__nfet_01v8_lvt l=0.15 w=0.64 ad=0.1792 as=0.224 pd=1.84 ps=1.98
XM3 VGND#6 C1#2 a_81_264##5 VNB sky130_fd_pr__nfet_01v8_lvt l=0.15 w=0.64 ad=0.224 as=0.1696 pd=1.98 ps=1.81
XM4 X#1 a_81_264##3 VPWR#5 VPB sky130_fd_pr__pfet_01v8 l=0.15 w=1.12 ad=0.308 as=0.308 pd=2.79 ps=2.79
XM2 a_279_392##2 A2#3 VPWR#3 VPB sky130_fd_pr__pfet_01v8 l=0.15 w=1 ad=0.275 as=0.33 pd=2.55 ps=2.66
XM1 VPWR#3 A1#3 a_279_392# VPB sky130_fd_pr__pfet_01v8 l=0.15 w=1 ad=0.33 as=0.3 pd=2.66 ps=2.6
XM5 a_279_392# B1#1 a_550_392# VPB sky130_fd_pr__pfet_01v8 l=0.15 w=1 ad=0.3 as=0.24 pd=2.6 ps=2.48
XM6 a_550_392# C1#3 a_81_264##4 VPB sky130_fd_pr__pfet_01v8 l=0.15 w=1 ad=0.24 as=0.275 pd=2.48 ps=2.55
*
*
*       RESISTOR AND CAP/DIODE CARDS
*
Rg1	a_81_264#	a_81_264##2	421.091736
Rg2	a_81_264##2	a_81_264##3	507.166138
Rg3	A2#1	A2#2	290.721832
Rg4	A2#2	A2#3	409.090576
Rg5	A1#1	A1#2	303.140442
Rg6	A1#2	A1#3	417.269073
Rg7	B1#1	B1#2	774.737183
Rg8	B1#2	B1#3	279.244598
Rg9	C1#1	C1#2	353.079407
Rg10	C1#2	C1#3	803.312195
Rf1	X	X#2	0.186110
Rf2	X#2	X	13.585999
Rf3	X	X#3	95.191010
Rf4	X#1	X#2	5.000000
Rf5	A2#2	A2	162.790939
Rf6	a_279_392#	a_279_392##2	98.269417
Rf7	A1	A1#4	16.927925
Rf8	A1#4	A1	1.968364
Rf9	B1#3	B1	182.192688
Rf10	a_81_264##4	a_81_264##6	45.934086
Rf11	a_81_264##6	a_81_264##8	54.427605
Rf12	a_81_264##8	a_81_264##2	192.871643
Rf13	a_81_264##5	a_81_264##6	15.000000
Rf14	a_81_264##7	a_81_264##8	15.000000
Rf15	C1#1	C1#5	161.023331
Rf16	C1#6	C1	0.790535
Rf17	C1#5	C1#6	5.905091
Rf19	VGND#2	VGND#3	88.489143
Rf20	VGND#3	VGND#4	32.077354
Rf22	VGND#2	VGND#6	78.890556
Rf23	VGND#4	VGND#7	19.508286
Rf25	VPWR#2	VPWR#3	51.706009
Rf26	VPWR#2	VPWR#4	84.771393
Rf27	VPWR#4	VPWR#5	48.259808
Rf30	A1#2	A1#4	160.232803
Re1	VPWR#2	VPWR	1.227783
Re2	VGND	VGND#3	1.227829
*
*       CAPACITOR CARDS
*
*
C1	VGND	VNB	6.66069e-17
C2	VPWR	VNB	7.48035e-17
C3	X	VNB	5.62396e-17
C4	B1	VNB	1.0138e-17
C5	C1	VNB	1.85657e-17
C6	VGND	X	8.7198e-19
C7	A2	VNB	4.45749e-20
C8	A1	VNB	7.87765e-19
C9	VGND	B1	1.42238e-17
C10	VPWR	X	1.736e-17
C11	VGND	A2	1.56359e-18
C12	VGND	A1	3.5422e-18
C13	a_81_264##2	VNB	1.08511e-16
C14	A2#2	VNB	2.98396e-17
C15	VPWR	A2	1.37888e-18
C16	A1#2	VNB	2.82666e-17
C17	B1#3	VNB	4.3787e-17
C18	VPWR	A1	5.03328e-18
C19	C1#1	VNB	5.8003e-17
C20	VGND#3	VNB	1.9552e-16
C21	X	A2	2.33918e-18
C22	VGND	a_81_264##2	8.67229e-18
C23	a_81_264##3	VNB	4.85099e-17
C24	A2#3	VNB	3.6998e-17
C25	A1#3	VNB	3.02026e-17
C26	B1#1	VNB	3.55507e-17
C27	VGND	B1#3	1.84309e-17
C28	C1#3	VNB	3.60447e-17
C29	VGND	C1#1	4.72144e-18
C30	a_81_264#	VNB	3.69817e-17
C31	A2#1	VNB	2.49527e-17
C32	VGND	VGND#3	1.55349e-17
C33	VPWR	a_81_264##2	1.31531e-17
C34	A1#1	VNB	2.50961e-17
C35	B1#2	VNB	2.29163e-17
C36	C1#2	VNB	6.29349e-17
C37	X#1	VNB	1.99637e-17
C38	VPWR#5	VNB	1.64503e-17
C39	a_279_392##2	VNB	1.80253e-17
C40	A2	A1	2.42839e-17
C41	VPWR#3	VNB	3.76629e-18
C42	X	a_81_264##2	4.70705e-17
C43	a_279_392#	VNB	4.4825e-18
C44	a_81_264##4	VNB	6.42401e-17
C45	X	A2#2	3.70913e-19
C46	X#3	VNB	7.59834e-17
C47	a_81_264##5	VGND#6	4.4238e-17
C48	VGND#7	VNB	3.29909e-18
C49	VGND	a_81_264#	1.31224e-18
C50	a_81_264##7	VNB	1.32539e-19
C51	VGND#6	VNB	8.42957e-18
C52	VGND	A2#1	3.43046e-18
C53	VPWR	a_81_264##3	3.63216e-18
C54	a_81_264##5	VNB	2.75255e-17
C55	VPWR	A2#3	1.10989e-18
C56	VGND	C1#2	1.4758e-19
C57	A1	a_366_136#	7.98687e-19
C58	VPWR	A1#3	1.00694e-18
C59	B1	A1#2	6.89032e-19
C60	VPWR	B1#1	2.35632e-18
C61	VPWR	C1#3	6.12748e-18
C62	C1#5	VNB	8.81523e-18
C63	X	a_81_264##3	2.9063e-17
C64	a_81_264##2	A2	4.07389e-17
C65	VGND#3	B1	3.02293e-17
C66	X	A2#3	7.13459e-19
C67	VGND	X#3	3.82734e-17
C68	A2	A2#2	1.66251e-17
C69	VGND	a_81_264##7	1.24109e-17
C70	C1	C1#1	1.02782e-17
C71	VGND	VGND#6	3.59563e-18
C72	A2	A1#2	2.77467e-18
C73	VGND	a_81_264##5	7.56877e-18
C74	VPWR	a_279_392##2	1.74814e-17
C75	A1	A2#2	4.1256e-18
C76	VPWR	a_279_392#	1.71024e-17
C77	A1	A1#2	1.78362e-17
C78	VPWR	a_81_264##4	2.07626e-17
C79	VGND	C1#5	1.49584e-17
C80	X	X#1	3.00557e-18
C81	B1	a_81_264#	1.08373e-18
C82	X	VPWR#5	4.89897e-17
C83	B1	A2#1	3.18412e-18
C84	A2	a_81_264##3	1.0524e-18
C85	B1	A1#1	1.53072e-17
C86	B1	B1#2	8.82808e-19
C87	B1	C1#2	2.89489e-19
C88	X#3	X	3.83107e-18
C89	C1	C1#2	1.91322e-18
C90	A1	B1#1	1.34659e-17
C91	a_81_264##2	A2#2	3.16291e-17
C92	A1	C1#3	1.87788e-18
C93	VGND#7	B1	2.20439e-17
C94	a_81_264##2	A1#2	3.00621e-20
C95	B1	a_81_264##7	1.6704e-17
C96	B1	VGND#6	2.46131e-18
C97	A2#2	A1#2	2.81793e-17
C98	A1	B1#2	9.82514e-18
C99	A2	a_279_392##2	3.61422e-17
C100	A1	C1#2	4.46278e-18
C101	VGND#6	C1	1.72721e-17
C102	C1	a_81_264##5	1.3794e-17
C103	A2#1	a_366_136#	1.48037e-17
C104	A1	VPWR#3	4.74225e-19
C105	A2	VGND#7	5.59081e-19
C106	B1#1	a_550_392#	2.3145e-17
C107	VGND#3	A1#2	3.71816e-20
C108	A1#1	a_366_136#	1.34358e-17
C109	A1	a_279_392#	5.79183e-17
C110	C1#3	a_550_392#	2.41308e-17
C111	a_81_264##7	A2	1.26688e-17
C112	VGND#3	B1#3	7.4688e-18
C113	A1	a_81_264##4	1.13689e-17
C114	a_81_264##3	A2#2	9.54184e-19
C115	A1	a_81_264##7	6.86497e-17
C116	A1	a_81_264##5	9.29097e-18
C117	a_81_264##2	a_81_264#	3.86847e-18
C118	A1#2	B1#1	1.53714e-17
C119	VGND#6	C1#5	4.89397e-18
C120	a_81_264##2	A2#1	1.11112e-17
C121	a_81_264##2	A1#1	2.16447e-19
C122	a_81_264##2	B1#2	1.52098e-19
C123	a_81_264##7	a_366_136#	5.9979e-18
C124	a_81_264##2	C1#2	4.12843e-19
C125	a_81_264#	B1#3	1.02484e-18
C126	a_81_264##2	VPWR#5	4.82975e-17
C127	a_81_264##2	a_279_392##2	9.81893e-18
C128	A1#2	B1#2	1.75245e-17
C129	a_81_264##3	A2#3	4.41287e-18
C130	A1#1	B1#3	9.22887e-18
C131	VPWR#5	A2#2	3.3769e-19
C132	a_279_392##2	A2#2	5.93164e-18
C133	B1#3	C1#2	3.13495e-17
C134	VPWR#5	A1#2	8.08348e-20
C135	VGND#3	A2#1	1.99291e-18
C136	A2#3	A1#3	3.76314e-17
C137	X#3	a_81_264##2	7.36699e-17
C138	VGND#3	A1#1	9.55484e-19
C139	VPWR#3	A1#2	5.31425e-19
C140	a_81_264##2	VGND#7	4.10651e-17
C141	a_81_264##4	A2#2	1.257e-19
C142	a_279_392#	A1#2	1.60237e-18
C143	A1#3	B1#1	4.19405e-17
C144	VGND#7	A2#2	9.88143e-19
C145	a_81_264##4	A1#2	1.49209e-19
C146	a_81_264##5	a_81_264##2	2.13581e-19
C147	B1#1	C1#3	7.73471e-17
C148	a_81_264##5	A2#2	1.45046e-20
C149	a_81_264##7	A1#2	3.11976e-18
C150	VGND#7	B1#3	4.355e-19
C151	X#1	a_81_264##3	2.50414e-17
C152	a_81_264##5	A1#2	5.58535e-20
C153	B1#3	a_81_264##7	1.57762e-17
C154	a_81_264##3	VPWR#5	4.46321e-17
C155	B1#3	VGND#6	3.68506e-17
C156	X#1	A2#3	4.54826e-19
C157	a_279_392##2	a_81_264##3	8.80159e-18
C158	a_81_264##5	B1#3	3.25838e-19
C159	VPWR#5	A2#3	5.86614e-18
C160	VPWR#3	a_81_264##3	4.30648e-19
C161	B1#1	C1#2	5.04158e-18
C162	a_279_392##2	A2#3	4.49568e-17
C163	a_81_264#	A2#1	1.946e-17
C164	C1#1	a_81_264##5	6.4797e-18
C165	VPWR#5	A1#3	4.95572e-19
C166	VGND#3	a_81_264##7	1.85045e-18
C167	A2#3	VPWR#3	2.92198e-17
C168	a_279_392##2	A1#3	1.66186e-18
C169	VPWR#5	B1#1	2.29862e-19
C170	a_279_392#	A2#3	1.98275e-18
C171	A1#3	VPWR#3	2.40317e-17
C172	A2#1	A1#1	2.66695e-17
C173	VPWR#5	C1#3	3.29882e-19
C174	a_279_392#	A1#3	6.25863e-17
C175	a_81_264##4	A2#3	4.11195e-19
C176	VPWR#3	B1#1	7.55437e-19
C177	a_279_392#	B1#1	5.91739e-17
C178	A1#1	B1#2	3.16271e-17
C179	VPWR#3	C1#3	5.48689e-19
C180	a_81_264##4	A1#3	4.91198e-19
C181	C1#5	C1#1	2.01709e-17
C182	a_279_392#	C1#3	1.06659e-17
C183	a_81_264##4	B1#1	1.22039e-17
C184	B1#2	C1#2	3.76562e-17
C185	a_81_264##4	C1#3	5.39265e-17
C186	X#3	a_81_264#	2.23943e-17
C187	X#1	VPWR#5	3.65655e-17
C188	VGND#7	a_81_264#	3.31838e-17
C189	X#3	A2#1	9.92808e-19
C190	VGND#7	A2#1	3.15893e-17
C191	VPWR#5	a_279_392##2	4.52487e-17
C192	X#3	A1#1	2.47777e-19
C193	a_81_264##7	a_81_264#	7.86799e-19
C194	a_81_264##4	B1#2	1.00085e-19
C195	VPWR#5	VPWR#3	1.59112e-18
C196	VGND#7	A1#1	2.48007e-18
C197	a_81_264##7	A2#1	1.47233e-17
C198	a_81_264##4	C1#2	3.44075e-18
C199	a_279_392##2	VPWR#3	6.3978e-17
C200	VGND#7	B1#2	2.38716e-19
C201	VGND#6	A2#1	4.19232e-19
C202	a_81_264##7	A1#1	4.06741e-17
C203	a_279_392##2	a_279_392#	2.89198e-18
C204	a_81_264##5	A2#1	1.04433e-19
C205	VGND#7	C1#2	1.54413e-19
C206	VGND#6	A1#1	1.79888e-18
C207	a_279_392#	VPWR#3	6.24351e-17
C208	a_81_264##7	B1#2	4.15862e-17
C209	a_81_264##5	A1#1	2.01073e-19
C210	B1#2	VGND#6	1.73862e-17
C211	a_81_264##7	C1#2	1.54086e-18
C212	a_81_264##5	B1#2	2.4387e-18
C213	VGND#6	C1#2	3.46127e-17
C214	a_81_264##5	C1#2	4.2145e-17
C215	a_279_392#	a_81_264##4	3.57613e-17
C216	a_81_264##7	a_279_392##2	4.55755e-18
C217	a_81_264##7	a_279_392#	1.61337e-18
C218	X#3	VGND#7	5.46407e-17
C219	X#3	a_81_264##7	2.17492e-18
C220	VGND#7	a_81_264##7	4.32229e-18
C221	VGND#7	VGND#6	3.0022e-18
C222	a_81_264##7	VGND#6	2.30739e-17
C223	a_81_264##4	VPWR#2	2.75406e-17
C224	VPWR	VPWR#4	5.54285e-17
C225	VGND#4	VGND#2	4.39201e-19
C226	VGND#4	B1	3.20915e-18
C227	VPWR#2	A2#2	4.92247e-20
C228	VGND#2	VGND#6	1.59739e-18
C229	VPWR	VPWR#2	7.82502e-17
C230	VPWR#2	C1#2	7.92565e-20
C231	VGND#4	C1#2	6.02426e-20
C232	A1	VPWR#2	7.53926e-19
C233	VGND#3	VGND#4	7.50897e-17
C234	VPWR#4	A2#3	6.54061e-19
C235	a_279_392#	VPWR#2	1.96892e-17
C236	VGND#2	a_81_264##5	6.91389e-19
C237	VPWR#2	B1#1	8.23779e-18
C238	X	VPWR#4	2.18435e-17
C239	VPWR#2	VNB	2.57636e-16
C240	VGND#2	C1#5	4.49674e-17
C241	a_81_264##2	VPWR#4	2.03901e-18
C242	VGND#4	X#3	4.62343e-17
C243	a_279_392##2	VPWR#2	1.64941e-17
C244	VPWR#2	A2#3	5.40661e-18
C245	VPWR#4	A1#3	6.4592e-20
C246	VGND#2	VNB	4.84502e-17
C247	VGND#4	a_81_264##2	7.895e-19
C248	VGND#4	VNB	6.83685e-17
C249	VGND#2	C1#2	9.23618e-18
C250	VGND#2	B1#3	5.17662e-17
C251	VGND#4	a_81_264#	7.63139e-18
C252	VGND	VGND#2	5.32575e-17
C253	VPWR#2	VPWR#4	5.86854e-17
C254	VGND	VGND#4	7.60195e-17
C255	VPWR#2	C1#3	6.42289e-18
C256	VPWR#4	VNB	5.35391e-17
C257	VGND#2	C1#1	9.22982e-18
C258	VGND#4	A2#1	5.85776e-20
C259	a_279_392##2	VPWR#4	1.29819e-18
C260	VGND#3	VGND#2	5.66866e-17
C261	VGND#4	a_81_264##7	2.42265e-20
C262	VPWR#2	A1#3	5.17594e-18
C263	VGND#4	B1#3	7.90202e-19
C264	VPWR#4	VPWR#3	1.11809e-19
C265	VGND#2	a_81_264#	1.17783e-19
C266	VPWR#2	a_81_264##3	9.67062e-20
C267	VPWR#4	a_81_264##3	8.34095e-18
*
*
.ENDS sky130_fd_sc_hs__a211o_1
*
