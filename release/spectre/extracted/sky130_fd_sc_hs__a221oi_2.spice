* Extracted by Quantus, converted by sky130cad/quantus.py
*
*
*
*                       LINUX           Wed Nov 18 08:07:34 2026
*
*
*
*  PROGRAM  advgen
*
*  Name           : advgen - Quantus - (64-bit)
*  Version        : 25.1.0-p047
*  Build Date     : Thu Dec 11 23:20:30 PST 2025
*
*  HSPICE LIBRARY
*
*  OPERATING_TEMPERATURE 150
*  QRC_TECH_DIR <path>/tech
*
*
*

*
.SUBCKT sky130_fd_sc_hs__a221oi_2 VPB VNB VGND VPWR Y C1 B1 B2 A1 A2
*
*
*  caps2d version: 10
*
*
*       TRANSISTOR CARDS
*
*
XM6 VGND#9 C1#7 Y#5 VNB sky130_fd_pr__nfet_01v8_lvt l=0.15 w=0.74 ad=0.222 as=0.1961 pd=2.08 ps=2.01
XM10 Y#7 C1#1 VGND#9 VNB sky130_fd_pr__nfet_01v8_lvt l=0.15 w=0.74 ad=0.2072 as=0.222 pd=2.04 ps=2.08
XM2 a_293_74##2 B1#3 Y#7 VNB sky130_fd_pr__nfet_01v8_lvt l=0.15 w=0.74 ad=0.2368 as=0.2072 pd=2.12 ps=2.04
XM16 a_293_74##2 B2#5 VGND#8 VNB sky130_fd_pr__nfet_01v8_lvt l=0.15 w=0.74 ad=0.2368 as=0.2886 pd=2.12 ps=2.26
XM17 VGND#8 B2#1 a_293_74# VNB sky130_fd_pr__nfet_01v8_lvt l=0.15 w=0.74 ad=0.2886 as=0.2072 pd=2.26 ps=2.04
XM11 Y#6 B1#4 a_293_74# VNB sky130_fd_pr__nfet_01v8_lvt l=0.15 w=0.74 ad=0.2368 as=0.2072 pd=2.12 ps=2.04
XM18 a_675_74##2 A1#3 Y#6 VNB sky130_fd_pr__nfet_01v8_lvt l=0.15 w=0.74 ad=0.4958 as=0.2368 pd=2.82 ps=2.12
XM19 VGND#7 A2#4 a_675_74##2 VNB sky130_fd_pr__nfet_01v8_lvt l=0.15 w=0.74 ad=0.259 as=0.4958 pd=2.18 ps=2.82
XM4 a_675_74# A2#5 VGND#7 VNB sky130_fd_pr__nfet_01v8_lvt l=0.15 w=0.74 ad=0.2072 as=0.259 pd=2.04 ps=2.18
XM5 Y#1 A1#6 a_675_74# VNB sky130_fd_pr__nfet_01v8_lvt l=0.15 w=0.74 ad=0.1961 as=0.2072 pd=2.01 ps=2.04
XM0 Y#8 C1#5 a_29_368##3 VPB sky130_fd_pr__pfet_01v8 l=0.15 w=1.12 ad=0.336 as=0.308 pd=2.84 ps=2.79
XM7 a_29_368# C1#6 Y#8 VPB sky130_fd_pr__pfet_01v8 l=0.15 w=1.12 ad=0.336 as=0.336 pd=2.84 ps=2.84
XM12 a_294_368##5 B1#1 a_29_368# VPB sky130_fd_pr__pfet_01v8 l=0.15 w=1.12 ad=0.3696 as=0.336 pd=2.9 ps=2.84
XM8 a_294_368##5 B2#7 a_29_368##6 VPB sky130_fd_pr__pfet_01v8 l=0.15 w=1.12 ad=0.3696 as=0.336 pd=2.9 ps=2.84
XM1 a_29_368##6 B2#6 a_294_368##3 VPB sky130_fd_pr__pfet_01v8 l=0.15 w=1.12 ad=0.336 as=0.336 pd=2.84 ps=2.84
XM9 a_29_368##4 B1#6 a_294_368##3 VPB sky130_fd_pr__pfet_01v8 l=0.15 w=1.12 ad=0.308 as=0.336 pd=2.79 ps=2.84
XM13 VPWR#8 A1#1 a_294_368##6 VPB sky130_fd_pr__pfet_01v8 l=0.15 w=1.12 ad=0.308 as=0.336 pd=2.79 ps=2.84
XM3 a_294_368##6 A2#6 VPWR#7 VPB sky130_fd_pr__pfet_01v8 l=0.15 w=1.12 ad=0.336 as=0.336 pd=2.84 ps=2.84
XM14 VPWR#7 A2#1 a_294_368# VPB sky130_fd_pr__pfet_01v8 l=0.15 w=1.12 ad=0.336 as=0.336 pd=2.84 ps=2.84
XM15 a_294_368# A1#4 VPWR#6 VPB sky130_fd_pr__pfet_01v8 l=0.15 w=1.12 ad=0.336 as=0.308 pd=2.84 ps=2.79
*
*
*       RESISTOR AND CAP/DIODE CARDS
*
Rg1	C1#1	C1#2	397.555725
Rg2	C1#2	C1#3	20.753328
Rg3	C1#3	C1#4	32.582375
Rg4	C1#4	C1#5	449.655212
Rg5	C1#2	C1#6	449.655212
Rg6	C1#4	C1#7	397.555725
Rg7	B1#1	B1#2	434.639221
Rg8	B1#2	B1#3	382.539734
Rg9	B2#1	B2#2	413.013641
Rg10	B2#2	B2#3	40.445728
Rg11	B2#3	B2#4	28.644930
Rg12	B2#4	B2#5	397.555725
Rg13	B2#2	B2#6	452.720551
Rg14	B2#4	B2#7	449.655212
Rg15	B1#4	B1#5	382.539734
Rg16	B1#5	B1#6	434.639221
Rg17	A1#1	A1#2	452.509125
Rg18	A1#2	A1#3	432.749878
Rg19	A2#1	A2#2	450.639984
Rg20	A2#2	A2#3	62.490269
Rg21	A2#3	A2#4	377.027313
Rg22	A2#2	A2#5	399.275177
Rg23	A2#3	A2#6	429.126801
Rg24	A1#4	A1#5	434.639221
Rg25	A1#5	A1#6	382.539734
Rf1	C1#3	C1	166.137894
Rf2	B2#3	B2#9	161.163345
Rf3	B2#10	B2	0.930548
Rf4	B2#9	B2#10	5.905091
Rf5	a_293_74#	a_293_74##2	88.642479
Rf6	a_29_368#	a_29_368##2	41.877155
Rf7	a_29_368##2	a_29_368##3	89.080147
Rf8	a_29_368##2	a_29_368##5	78.318329
Rf9	a_29_368##5	a_29_368##6	15.000000
Rf10	a_29_368##4	a_29_368##5	15.000000
Rf11	B1#7	B1	4.235304
Rf12	B1	B1#2	268.640625
Rf13	B1#7	B1	5.631601
Rf14	A2#7	A2	1.409262
Rf15	A2#3	A2#9	161.642059
Rf16	A2#7	A2#9	4.838849
Rf17	A2#10	A2	1.409262
Rf18	A2#9	A2#10	13.027670
Rf19	a_675_74#	a_675_74##2	86.395561
Rf20	a_294_368#	a_294_368##2	75.195015
Rf21	a_294_368##2	a_294_368##4	103.707169
Rf22	a_294_368##4	a_294_368##5	74.014366
Rf23	a_294_368##2	a_294_368##6	13.130533
Rf24	a_294_368##3	a_294_368##4	15.000000
Rf25	Y#1	Y#2	187.798752
Rf26	Y#2	Y#3	138.633011
Rf27	Y#3	Y#4	61.513077
Rf28	Y#4	Y#5	25.328739
Rf29	Y#2	Y#6	26.886599
Rf30	Y#3	Y#7	28.967793
Rf31	Y#4	Y	10.044295
Rf32	Y	Y#8	59.887470
Rf33	A1	A1#7	14.298001
Rf34	A1#7	A1	3.902984
Rf35	A1	A1#2	298.673859
Rf37	VPWR#2	VPWR#3	68.798325
Rf38	VPWR#3	VPWR#4	68.798325
Rf39	VPWR#4	VPWR#5	43.863113
Rf40	VPWR#2	VPWR#6	44.934231
Rf41	VPWR#3	VPWR#7	48.224632
Rf42	VPWR#4	VPWR#8	37.538910
Rf44	VGND#2	VGND#3	108.455452
Rf45	VGND#3	VGND#4	56.218658
Rf46	VGND#4	VGND#5	100.378693
Rf48	VGND#2	VGND#7	31.161278
Rf49	VGND#4	VGND#8	30.708553
Rf50	VGND#5	VGND#9	36.980446
Rf56	A1#5	A1#7	160.232803
Rf53	B1#5	B1#7	160.232803
Re1	VPWR#5	VPWR	0.818510
Re2	VGND	VGND#3	0.818540
*
*       CAPACITOR CARDS
*
*
C1	a_293_74##2	a_293_74#	2.55487e-18
C2	VGND#4	B2#1	2.64771e-18
C3	Y#1	A2#2	6.57723e-18
C4	a_293_74##2	VGND#8	4.12085e-17
C5	A2#2	A1#5	3.14648e-17
C6	VGND#4	B2#5	9.28585e-19
C7	Y#7	a_293_74##2	4.54235e-17
C8	VGND#9	VGND#8	9.22685e-19
C9	VGND#4	B1#3	2.16672e-18
C10	a_675_74#	A2#2	8.61962e-20
C11	A2#3	A2#2	2.16813e-18
C12	Y#2	A2#4	9.53251e-18
C13	a_29_368##2	a_294_368##5	1.71936e-17
C14	Y#3	A1#3	1.03792e-19
C15	VGND#9	Y#7	4.17197e-17
C16	a_29_368##2	a_29_368#	6.1905e-20
C17	Y#2	A1#3	1.15363e-17
C18	Y#5	Y#7	1.67676e-18
C19	VGND#7	A2#2	6.93852e-20
C20	Y#3	B1#4	1.45855e-19
C21	a_29_368##2	Y#8	1.52101e-17
C22	Y#5	VGND#9	4.25052e-17
C23	Y#2	B1#4	9.34451e-18
C24	a_294_368##2	VPWR#4	9.8337e-18
C25	Y#3	B2#1	2.80569e-19
C26	Y#2	B2#1	8.1616e-18
C27	a_294_368##2	VPWR#3	8.95967e-18
C28	Y#3	B2#5	9.73047e-18
C29	B2#4	B1#5	3.27423e-17
C30	Y#3	B1#3	1.33696e-17
C31	a_294_368#	VPWR#6	5.5326e-17
C32	VPWR#7	VPWR#6	1.836e-18
C33	Y#3	C1#1	1.86571e-17
C34	VPWR#3	A1#4	5.7175e-19
C35	a_294_368#	VPWR#7	3.82266e-17
C36	Y#1	A1#6	2.96973e-17
C37	Y#3	C1#7	1.99429e-19
C38	VPWR#4	A2#1	9.67286e-20
C39	VPWR#6	VPWR#8	1.92634e-20
C40	a_675_74#	A1#6	3.60863e-17
C41	VPWR#3	A2#1	5.14027e-18
C42	Y#1	A2#5	9.3182e-18
C43	VGND#7	A1#6	1.97481e-18
C44	a_675_74#	A2#5	3.76024e-17
C45	VPWR#4	A2#6	5.82836e-19
C46	Y#1	A2#4	9.61656e-19
C47	a_675_74##2	A1#6	2.55926e-19
C48	VPWR#8	VPWR#7	1.836e-18
C49	B1#2	B2#4	3.99383e-17
C50	VPWR#3	A2#6	5.16452e-18
C51	A2#5	VGND#7	2.22404e-17
C52	a_293_74#	B2#4	6.83662e-19
C53	a_675_74#	A2#4	9.04821e-19
C54	Y#6	A1#6	4.85266e-19
C55	C1#4	B1#2	4.26437e-17
C56	a_675_74##2	A2#5	5.42918e-19
C57	Y#1	A1#3	3.7606e-19
C58	VPWR#4	A1#1	5.86697e-18
C59	A2#4	VGND#7	2.4592e-17
C60	VPWR#3	A1#1	5.36525e-19
C61	a_675_74#	A1#3	1.43128e-19
C62	Y#6	A2#5	3.98295e-19
C63	a_675_74##2	A2#4	3.74622e-17
C64	VGND#7	A1#3	1.20066e-18
C65	VPWR#4	B1#6	1.16702e-18
C66	Y#6	A2#4	1.25118e-18
C67	Y#2	a_294_368##2	2.46118e-18
C68	a_675_74##2	A1#3	4.68494e-17
C69	VPWR#3	B1#6	2.13702e-20
C70	VGND#8	B2#4	1.1354e-18
C71	VGND#7	B1#4	2.75299e-19
C72	a_294_368##2	A2#1	1.58151e-18
C73	A1#3	Y#6	1.80134e-17
C74	VPWR#4	B2#6	2.12921e-19
C75	a_675_74##2	B1#4	1.71453e-18
C76	VGND#8	A2#4	2.8921e-19
C77	a_294_368##3	a_29_368##4	5.13652e-19
C78	a_293_74#	A1#3	1.46575e-18
C79	a_29_368##6	VPWR#8	3.24334e-17
C80	VGND#7	B2#1	1.82551e-19
C81	B1#4	Y#6	2.16335e-17
C82	a_294_368##2	A2#6	3.50116e-17
C83	VGND#8	A1#3	6.97675e-19
C84	a_29_368##6	a_29_368##4	2.05273e-18
C85	a_293_74#	B1#4	3.84348e-17
C86	VPWR#4	B2#7	6.88782e-20
C87	Y#6	B2#1	1.56924e-18
C88	a_293_74##2	B2#4	6.52416e-19
C89	a_294_368##3	a_29_368##6	9.12713e-17
C90	VGND#8	B1#4	1.17349e-18
C91	a_294_368##2	A1#1	3.65577e-17
C92	a_293_74#	B2#1	4.36139e-17
C93	Y#6	B2#5	3.26305e-19
C94	a_29_368#	a_29_368##4	1.12748e-20
C95	VPWR#4	B1#1	3.79909e-20
C96	B2#1	VGND#8	2.28924e-17
C97	Y#3	B2#4	1.38224e-17
C98	a_293_74#	B2#5	5.41781e-19
C99	a_294_368##2	B1#6	8.25027e-19
C100	a_29_368##6	a_294_368##5	4.38706e-17
C101	a_293_74##2	B2#1	4.85449e-19
C102	Y#6	B1#3	1.71429e-19
C103	B2#5	VGND#8	2.49095e-17
C104	a_293_74#	B1#3	1.91361e-19
C105	a_29_368#	a_29_368##6	4.03933e-18
C106	a_293_74##2	B2#5	3.08259e-17
C107	Y#6	C1#1	1.14671e-19
C108	a_294_368##2	B2#6	2.96096e-19
C109	VGND#9	B2#1	8.28265e-20
C110	VGND#8	B1#3	1.83523e-18
C111	a_29_368#	a_294_368##5	3.71202e-17
C112	a_293_74##2	B1#3	3.51465e-17
C113	VGND#9	B2#5	1.29744e-19
C114	VGND#8	C1#1	2.84906e-19
C115	Y#3	C1#4	4.03187e-18
C116	Y#2	B2#4	1.16993e-17
C117	a_294_368##2	B2#7	2.05561e-19
C118	B1#3	Y#7	1.17983e-17
C119	a_293_74##2	C1#1	1.20634e-18
C120	Y#8	a_29_368#	5.94827e-17
C121	VGND#9	B1#3	1.5355e-18
C122	C1#1	Y#7	1.71547e-17
C123	Y#5	B1#3	1.41619e-19
C124	a_29_368##3	a_29_368#	3.49365e-18
C125	VGND#9	C1#1	3.42507e-17
C126	B2#10	B1#6	3.54983e-19
C127	Y#7	C1#7	5.92953e-19
C128	Y#8	a_29_368##3	7.66164e-17
C129	Y#5	C1#1	6.23667e-19
C130	VGND#3	VGND#4	4.48577e-17
C131	VPWR#5	VPWR#4	3.24602e-17
C132	VGND#9	C1#7	3.02901e-17
C133	VPWR#5	VPWR#3	3.60713e-17
C134	B2#10	B2#6	8.91462e-19
C135	VGND#9	C1#4	1.03859e-18
C136	C1#7	Y#5	1.54448e-17
C137	B2#10	B2#7	8.27501e-19
C138	VGND#4	a_293_74#	5.41294e-18
C139	a_29_368##2	B1#1	1.60037e-17
C140	A2#5	A1#6	4.01461e-17
C141	B2#10	B1#1	3.43856e-19
C142	A1#4	VPWR#6	2.8945e-17
C143	a_29_368##2	C1#6	1.9275e-17
C144	Y#3	B2#9	2.02384e-17
C145	a_294_368#	A1#4	4.59342e-17
C146	A2#4	A2#5	2.96524e-17
C147	VPWR#6	A2#1	1.92988e-18
C148	VPWR#7	A1#4	6.42591e-19
C149	VGND#3	Y#2	1.19478e-18
C150	a_294_368#	A2#1	5.2564e-17
C151	Y#2	B2#9	2.09818e-17
C152	VGND#4	a_293_74##2	2.0411e-17
C153	VPWR#6	A2#6	8.75777e-19
C154	A2#1	VPWR#7	2.51867e-17
C155	A1#3	A2#4	8.66616e-18
C156	a_294_368#	A2#6	1.22713e-18
C157	VPWR#4	A1#2	1.32024e-19
C158	a_294_368#	A2#2	9.32511e-20
C159	VPWR#6	A1#1	6.1919e-19
C160	A2#6	VPWR#7	2.70326e-17
C161	A2	A2#2	1.03165e-17
C162	VPWR#8	A2#1	1.63173e-19
C163	A2#6	a_294_368##6	2.32435e-17
C164	B1#4	A1#3	3.41865e-17
C165	VPWR#7	A1#1	5.79572e-19
C166	a_29_368##2	VPWR#5	6.46349e-17
C167	Y#2	A2#3	9.85895e-18
C168	VPWR#8	A2#6	6.10718e-19
C169	A1#1	a_294_368##6	2.32435e-17
C170	a_294_368##2	A2#3	2.41167e-19
C171	VPWR#7	B1#6	5.40661e-20
C172	A1#1	VPWR#8	3.55067e-17
C173	B2#1	B1#4	3.93712e-17
C174	Y#2	A1#2	6.33589e-17
C175	A2#2	VPWR#7	1.91073e-19
C176	VPWR#8	B1#6	8.71355e-19
C177	A1	A2#2	5.4908e-18
C178	VGND#4	B1#2	5.66743e-20
C179	A1#2	a_294_368##2	8.24162e-17
C180	B1#6	a_29_368##4	3.6209e-17
C181	B2#5	B2#1	2.50514e-17
C182	a_29_368##6	A1#1	1.00218e-18
C183	VPWR#8	B2#6	3.65626e-20
C184	Y#2	B1#5	1.01658e-17
C185	a_294_368##3	B1#6	3.6855e-17
C186	a_294_368##5	A1#1	2.80254e-19
C187	a_29_368##6	B1#6	2.71813e-17
C188	a_294_368##3	B2#6	3.28256e-17
C189	B1#3	B2#5	3.34725e-17
C190	a_294_368##5	B1#6	5.97781e-19
C191	a_29_368##6	B2#6	5.03877e-17
C192	Y#1	A1#5	7.88667e-18
C193	VGND#3	a_675_74##2	1.56578e-17
C194	a_29_368#	B1#6	4.26319e-19
C195	Y#2	a_675_74##2	6.655e-17
C196	VGND#3	Y#6	1.34962e-17
C197	a_294_368##5	B2#6	1.26487e-18
C198	Y#3	Y#6	1.16865e-18
C199	VGND#3	a_293_74#	1.61345e-17
C200	a_29_368##6	B2#7	3.8213e-17
C201	C1#1	B1#3	4.17271e-17
C202	a_29_368#	B2#6	8.79417e-19
C203	Y#3	B1#2	5.16586e-17
C204	Y#1	A2#3	1.90378e-17
C205	a_294_368##5	B2#7	4.36902e-17
C206	a_675_74#	A2#3	5.3986e-19
C207	Y#2	Y#6	1.55522e-19
C208	a_29_368##6	B1#1	5.58161e-19
C209	a_29_368#	B2#7	1.70069e-18
C210	VGND#7	A2#3	7.89711e-19
C211	C1#7	C1#1	3.58144e-17
C212	B2#10	B1#5	7.9717e-19
C213	a_294_368##5	B1#1	3.72104e-17
C214	a_675_74##2	A2#3	3.72657e-19
C215	a_29_368##6	C1#6	3.01111e-19
C216	B1#1	a_29_368#	2.34034e-17
C217	B2#9	B1#5	8.1154e-19
C218	a_294_368##5	C1#6	1.07213e-18
C219	Y#2	a_293_74#	5.46731e-17
C220	Y#8	B1#1	1.64888e-18
C221	a_675_74##2	A1#2	2.53845e-18
C222	Y#3	VGND#8	1.23397e-19
C223	C1#6	a_29_368#	2.9363e-17
C224	B1	B2#4	6.9099e-18
C225	a_29_368##3	B1#1	2.99106e-19
C226	Y#8	C1#6	4.98696e-17
C227	A1#5	VPWR#6	2.83992e-18
C228	B1#2	a_29_368##2	1.30174e-18
C229	a_29_368#	C1#5	2.47725e-18
C230	a_29_368##3	C1#6	1.29914e-18
C231	Y#2	VGND#8	1.46514e-19
C232	B1#2	B2#10	1.4194e-17
C233	VPWR#3	VPWR#6	8.39315e-20
C234	Y#8	C1#5	6.16942e-17
C235	Y#3	a_293_74##2	5.47761e-17
C236	a_293_74#	B1#5	4.39013e-19
C237	a_29_368##6	VPWR#5	8.66248e-17
C238	B1#2	B2#9	8.71319e-18
C239	a_29_368##3	C1#5	3.77079e-17
C240	a_294_368#	A2#3	1.41484e-19
C241	A2#1	A1#4	4.525e-17
C242	a_293_74##2	Y#2	3.35428e-19
C243	A2#3	VPWR#7	8.07563e-19
C244	a_294_368#	VPWR#3	9.00904e-18
C245	Y#3	Y#7	3.11391e-18
C246	C1	B2#4	1.02692e-18
C247	C1	C1#4	2.4464e-17
C248	a_29_368##3	VPWR#5	5.03936e-17
C249	A2#6	A2#1	4.72207e-17
C250	A1#2	a_294_368##6	2.20338e-18
C251	A1#2	VPWR#8	4.68714e-18
C252	Y#3	VGND#9	1.51095e-17
C253	a_293_74##2	B1#2	6.87506e-19
C254	A1#1	A2#6	4.57122e-17
C255	B1#5	a_29_368##4	4.96698e-19
C256	a_294_368##3	B1#5	4.74327e-19
C257	VGND#3	A1#3	4.64e-18
C258	B1#6	A1#1	5.5795e-18
C259	Y	B2#4	1.28579e-19
C260	a_29_368##6	B1#5	3.65838e-19
C261	Y	C1#4	1.75091e-17
C262	VGND#3	B1#4	4.64e-18
C263	a_294_368##3	B2#4	1.03515e-19
C264	B2#6	B1#6	4.65343e-17
C265	A1#3	A2#3	1.49762e-19
C266	Y#2	A2	2.1249e-17
C267	B2#7	B2#6	4.52671e-17
C268	B1#2	a_294_368##5	4.33911e-17
C269	B1#2	a_29_368#	3.17671e-17
C270	B1#5	A1#3	5.53618e-19
C271	B1#1	B2#7	3.94892e-17
C272	B2#4	a_29_368##6	9.21501e-19
C273	a_294_368##3	VPWR#4	6.87225e-19
C274	A1	a_294_368##2	1.21037e-17
C275	C1#6	B1#1	4.64437e-17
C276	VPWR#5	B1#6	5.33885e-18
C277	VPWR#5	B2#6	3.86284e-18
C278	Y#1	A2	3.02745e-17
C279	A1#2	A1#4	7.5832e-20
C280	C1#5	C1#6	4.56719e-17
C281	VPWR#5	B2#7	4.46413e-18
C282	A2#3	A2#6	1.66875e-18
C283	a_29_368##6	VPWR#4	3.11658e-18
C284	A1#2	A2#1	1.31233e-19
C285	Y#1	a_675_74#	1.02132e-16
C286	VPWR#5	B1#1	4.45437e-18
C287	a_294_368##2	a_294_368#	3.01982e-18
C288	A1#2	A2#6	9.38081e-18
C289	Y#1	A1	6.38064e-17
C290	VPWR#5	C1#6	4.4526e-18
C291	VGND	B2#4	5.20382e-19
C292	A1#2	A1#1	1.35263e-17
C293	Y#2	B1	6.43213e-17
C294	a_294_368##5	B2#4	3.50124e-19
C295	VPWR#5	C1#5	4.4526e-18
C296	A1#2	B1#6	5.60861e-19
C297	B1	a_294_368##2	8.64044e-18
C298	Y#1	VGND#7	8.79903e-19
C299	a_294_368##2	VPWR#7	3.82814e-17
C300	a_29_368##2	C1#4	8.75613e-20
C301	Y#3	C1	2.17156e-17
C302	a_675_74#	VGND#7	4.44051e-17
C303	B2#10	B1	3.98419e-17
C304	a_675_74##2	Y#1	1.25005e-17
C305	A1	VPWR#6	6.12964e-17
C306	A1	a_294_368#	5.19924e-17
C307	B2#10	B2#4	8.01346e-18
C308	B2#9	B1	5.98535e-18
C309	B1#2	B1#6	7.57946e-20
C310	A1	VPWR#7	1.36113e-18
C311	B1#2	B2#6	1.44084e-19
C312	a_294_368##2	a_294_368##6	1.3641e-18
C313	B1#2	B2#7	1.79452e-17
C314	A2#2	VNB	2.15948e-17
C315	C1	a_29_368##2	1.20082e-18
C316	a_675_74##2	a_675_74#	2.73631e-18
C317	B2#4	VNB	5.2924e-17
C318	B1#2	B1#1	9.6601e-18
C319	C1#4	VNB	6.03335e-17
C320	Y	Y#3	3.63452e-18
C321	B1#2	C1#6	1.15118e-18
C322	VGND#3	A1#2	5.46172e-20
C323	VPWR#5	B1#5	4.42985e-20
C324	B1#2	C1#5	1.23042e-19
C325	VGND#3	B1#5	8.6766e-20
C326	a_294_368##2	VPWR#8	6.21633e-17
C327	VPWR	VPWR#4	3.32396e-17
C328	A1#2	A2#3	4.72081e-17
C329	VPWR	VPWR#3	2.70845e-17
C330	a_675_74##2	VGND#7	4.19503e-17
C331	Y#6	a_675_74#	7.33221e-20
C332	VPWR#5	B1#2	1.58981e-20
C333	B1	a_29_368##4	1.54441e-19
C334	B1	a_294_368##3	8.77774e-17
C335	B1#5	A1#2	3.01762e-17
C336	B1	a_29_368##6	2.42751e-18
C337	VPWR	a_294_368##2	2.04521e-17
C338	B1	a_294_368##5	1.33285e-17
C339	A2	A1#4	5.99831e-19
C340	VGND	VGND#4	2.46935e-17
C341	A2	A2#1	1.78982e-18
C342	VPWR	a_29_368##2	2.65013e-17
C343	A2	A2#6	3.65123e-19
C344	VPWR	B2#10	1.81387e-18
C345	Y	VGND#9	1.55587e-17
C346	A2	A1#1	1.11007e-18
C347	Y	Y#5	1.4917e-18
C348	A1	A1#4	1.45001e-17
C349	VPWR#4	VPWR#3	7.0017e-19
C350	A1	A2#1	1.59945e-17
C351	VGND	Y#3	6.51349e-18
C352	C1	Y#8	2.79196e-17
C353	VGND	Y#2	1.12263e-17
C354	A1	A2#6	3.85075e-18
C355	A1	A1#1	1.59528e-19
C356	Y#6	a_675_74##2	5.21273e-17
C357	Y	a_29_368#	3.38906e-18
C358	Y	Y#8	2.61885e-18
C359	VGND#4	VNB	3.48103e-17
C360	VPWR	a_294_368#	1.67185e-17
C361	VGND	B2#9	2.5581e-18
C362	Y	a_29_368##3	9.05205e-19
C363	VGND	Y#1	1.98088e-17
C364	VPWR#4	VNB	2.63397e-17
C365	VPWR#3	VNB	2.67791e-17
C366	VGND	a_675_74#	1.69678e-17
C367	VGND	VGND#7	1.63286e-17
C368	VGND	a_675_74##2	2.85474e-17
C369	VPWR	a_294_368##3	7.91464e-18
C370	VGND	Y#6	1.35948e-17
C371	B1	A1#1	8.19425e-19
C372	VGND	a_293_74#	1.75338e-17
C373	VPWR	a_29_368##6	4.51445e-17
C374	Y#3	VNB	3.92681e-18
C375	VGND	VGND#8	1.73333e-17
C376	B1	B1#6	1.44054e-17
C377	a_293_74#	a_675_74##2	6.39922e-19
C378	Y#2	VNB	5.21561e-18
C379	VPWR	a_294_368##5	8.83104e-18
C380	A2	A1#5	3.88879e-18
C381	VGND	a_293_74##2	1.74094e-17
C382	VPWR#5	B2#4	2.27116e-20
C383	a_294_368##2	VNB	4.15066e-18
C384	VGND	Y#7	1.17862e-17
C385	B1	B2#6	1.74009e-17
C386	VPWR	Y#8	1.17238e-17
C387	A2	A2#3	7.88739e-18
C388	VGND	Y#5	1.52609e-17
C389	VPWR	a_29_368##3	2.10444e-17
C390	Y	B1#3	4.29424e-20
C391	B1	B2#7	2.36201e-19
C392	Y	C1#1	1.89112e-19
C393	B1	B1#1	1.43576e-19
C394	A1#2	A2	4.7159e-17
C395	B2#9	B2#4	1.03605e-17
C396	A1	A1#5	2.18008e-17
C397	C1#4	Y#8	2.83019e-18
C398	Y	C1#7	1.85519e-17
C399	a_29_368##2	VNB	4.19926e-18
C400	B2#10	VNB	1.82318e-18
C401	A2#3	A1	1.05959e-17
C402	B2#9	VNB	8.87836e-19
C403	Y#1	VNB	5.12277e-17
C404	A1#2	A1	1.35955e-18
C405	a_675_74#	VNB	4.5811e-18
C406	VGND#7	VNB	5.65519e-18
C407	C1	B1#1	4.51713e-19
C408	a_675_74##2	VNB	5.15846e-18
C409	VPWR#5	C1#4	2.25602e-20
C410	Y#3	a_29_368#	6.92734e-18
C411	VGND	a_29_368#	1.31326e-18
C412	Y#6	VNB	5.1007e-18
C413	C1	C1#6	6.11958e-18
C414	a_293_74#	VNB	1.8977e-18
C415	VGND#8	VNB	5.1683e-18
C416	a_293_74#	Y#6	5.04647e-17
C417	a_293_74##2	VNB	2.59698e-18
C418	C1	C1#5	1.58133e-18
C419	VGND	A1#6	2.19462e-18
C420	Y#7	VNB	4.57364e-18
C421	VGND	A2#5	3.17518e-19
C422	VGND#9	VNB	1.44977e-18
C423	Y#5	VNB	2.80671e-17
C424	VGND	A2#4	3.13574e-19
C425	VPWR	A1#4	8.96192e-19
C426	VPWR#6	VNB	4.78448e-17
C427	VGND	A1#3	1.64061e-18
C428	VPWR	A2#1	6.15827e-19
C429	a_294_368#	VNB	2.13373e-18
C430	Y	B1#1	1.7892e-19
C431	VGND	B1#4	1.78535e-18
C432	VPWR#7	VNB	2.79388e-18
C433	VPWR	A2#6	6.15641e-19
C434	VGND	B2#1	2.7451e-19
C435	Y	C1#6	9.52712e-19
C436	B1	A1#2	6.67841e-17
C437	VPWR#8	VNB	3.59603e-18
C438	VPWR	A1#1	5.81745e-19
C439	VGND	B2#5	3.05709e-19
C440	Y	C1#5	4.91178e-18
C441	VGND	B1#3	1.62669e-18
C442	VPWR	B1#6	1.20002e-18
C443	B1	B1#5	1.76122e-17
C444	a_294_368##3	VNB	1.76458e-18
C445	a_29_368##6	VNB	1.21077e-17
C446	VGND	C1#1	8.22447e-19
C447	VPWR	B2#6	4.50049e-19
C448	VGND	C1#7	1.66197e-18
C449	VPWR	B2#7	1.67572e-18
C450	Y#8	VNB	1.31069e-17
C451	VPWR	B1#1	1.67571e-18
C452	a_29_368##3	VNB	4.4902e-17
C453	B1#2	B1	1.92541e-18
C454	VGND#4	Y#3	8.1995e-20
C455	A1#6	VNB	3.35369e-17
C456	VPWR	C1#6	1.67345e-18
C457	C1	B1#5	2.07275e-19
C458	A2#5	VNB	2.47889e-17
C459	A2#4	VNB	2.62119e-17
C460	VPWR	C1#5	2.45862e-18
C461	A1#3	VNB	2.9389e-17
C462	B1#4	VNB	2.70218e-17
C463	B2#1	VNB	2.6777e-17
C464	C1	B1#2	2.0862e-17
C465	VPWR	VPWR#5	6.63647e-17
C466	B2#5	VNB	2.59413e-17
C467	B1#3	VNB	2.70906e-17
C468	C1#1	VNB	2.51514e-17
C469	C1#7	VNB	3.23733e-17
C470	VPWR	A2#3	8.3712e-19
C471	A2	A1	5.27259e-17
C472	A1#4	VNB	3.83974e-17
C473	Y	B1#2	1.14402e-18
C474	A2#1	VNB	3.23389e-17
C475	VPWR	A1#2	5.18441e-18
C476	A2#6	VNB	3.20557e-17
C477	A1#1	VNB	3.32624e-17
C478	B1#6	VNB	3.57505e-17
C479	VGND	VGND#3	2.35559e-17
C480	B2#6	VNB	3.14476e-17
C481	B2#7	VNB	3.31232e-17
C482	VPWR	B1#2	4.45639e-18
C483	VGND	A2#3	1.12334e-18
C484	B1#1	VNB	3.24765e-17
C485	C1#6	VNB	3.16548e-17
C486	VGND	A1#2	3.57014e-18
C487	C1#5	VNB	4.50818e-17
C488	VPWR#5	VNB	3.40535e-16
C489	VGND#3	VNB	2.65608e-16
C490	VGND	B1#2	3.11813e-18
C491	A1#5	VNB	4.7958e-17
C492	A2#3	VNB	3.34157e-17
C493	A1#2	VNB	5.82779e-17
C494	a_293_74#	VGND#8	4.32533e-17
C495	B1#5	VNB	3.28361e-17
C496	a_29_368##3	C1#4	8.2983e-20
C497	VPWR	A2	2.36448e-18
C498	B1#2	VNB	3.42198e-17
C499	VPWR	A1	9.65164e-18
C500	VGND	A2	2.88543e-18
C501	Y	C1	4.78313e-17
C502	VGND	A1	8.57797e-18
C503	VPWR	B1	7.76916e-18
C504	VPWR	C1	3.15001e-18
C505	A2	VNB	1.79612e-18
C506	VGND	B1	6.48961e-18
C507	A1	VNB	3.25996e-17
C508	VGND	C1	2.62748e-18
C509	B1	VNB	6.88704e-18
C510	VGND	Y	1.39203e-18
C511	C1	VNB	5.88911e-18
C512	Y	VNB	4.60011e-17
C513	VPWR	VNB	8.81276e-17
C514	VGND	VNB	7.85798e-17
C515	VGND#2	a_675_74#	2.06275e-17
C516	VPWR#2	A2#1	5.45681e-19
C517	VGND#5	Y#7	1.3682e-17
C518	VGND#5	B2#1	8.4385e-20
C519	VPWR#3	VPWR#2	7.0017e-19
C520	VGND#3	VGND#2	9.14952e-17
C521	VPWR	VPWR#2	4.21482e-17
C522	VGND#5	C1#1	5.46975e-18
C523	VGND#2	A2#5	9.28585e-19
C524	VPWR#2	VNB	3.86137e-17
C525	VGND	VGND#2	5.46956e-17
C526	VGND#2	A1#2	1.16751e-19
C527	VPWR#5	VPWR#2	3.92882e-17
C528	VGND#5	VGND#8	2.64511e-20
C529	VPWR#2	A1#4	5.96897e-18
C530	VGND#3	VGND#5	6.11663e-17
C531	VGND	VGND#5	6.0615e-17
C532	A1	VPWR#2	1.53328e-18
C533	VGND#5	B2#5	1.91103e-19
C534	VGND#2	Y#1	1.83386e-17
C535	VPWR#2	A2#6	8.74044e-20
C536	a_294_368#	VPWR#2	8.42461e-18
C537	VGND#5	C1#7	5.26158e-18
C538	VGND#5	B1#2	3.85719e-20
C539	VGND#2	A1#5	8.68753e-20
C540	VGND#2	A2#4	9.28585e-19
C541	VGND#5	Y#3	8.59911e-19
C542	VGND#2	VNB	8.07151e-17
C543	VGND#2	a_675_74##2	2.51366e-17
C544	VGND#5	Y	2.91756e-19
C545	VGND#5	VGND#4	4.07433e-19
C546	VGND#5	Y#5	1.78839e-17
C547	VGND#5	VNB	5.43399e-17
C548	VGND#2	A1#6	7.36691e-18
C549	VGND#2	A1	1.73574e-18
C550	VGND#5	B1#3	3.87391e-18
*
*
.ENDS sky130_fd_sc_hs__a221oi_2
*
