* Extracted by Quantus, converted by sky130cad/quantus.py
*
*
*
*                       LINUX           Wed Nov 18 08:55:55 2026
*
*
*
*  PROGRAM  advgen
*
*  Name           : advgen - Quantus - (64-bit)
*  Version        : 25.1.0-p047
*  Build Date     : Thu Dec 11 23:20:30 PST 2025
*
*  HSPICE LIBRARY
*
*  OPERATING_TEMPERATURE 150
*  QRC_TECH_DIR <path>/tech
*
*
*

*
.SUBCKT sky130_fd_sc_hs__o21ba_1 VNB VPB VGND VPWR X A1 A2 B1_N
*
*
*  caps2d version: 10
*
*
*       TRANSISTOR CARDS
*
*
XM7 a_27_74##2 A1#3 VGND#7 VNB sky130_fd_pr__nfet_01v8_lvt l=0.15 w=0.64 ad=0.1824 as=0.2688 pd=1.85 ps=2.12
XM4 VGND#7 A2#1 a_27_74# VNB sky130_fd_pr__nfet_01v8_lvt l=0.15 w=0.64 ad=0.2688 as=0.1888 pd=2.12 ps=1.87
XM2 a_27_74# a_281_244# a_200_392##7 VNB sky130_fd_pr__nfet_01v8_lvt l=0.15 w=0.64 ad=0.1888 as=0.2176 pd=1.87 ps=1.96
XM9 a_281_244##5 B1_N#1 VGND#6 VNB sky130_fd_pr__nfet_01v8_lvt l=0.15 w=0.55 ad=0.275 as=0.2899 pd=2.1 ps=2.32
XM6 VGND#6 a_200_392# X#3 VNB sky130_fd_pr__nfet_01v8_lvt l=0.15 w=0.74 ad=0.2899 as=0.2109 pd=2.32 ps=2.05
XM5 VPWR#6 A1#1 a_116_392# VPB sky130_fd_pr__pfet_01v8 l=0.15 w=1 ad=0.295 as=0.27 pd=2.59 ps=2.54
XM0 a_116_392# A2#3 a_200_392##5 VPB sky130_fd_pr__pfet_01v8 l=0.15 w=1 ad=0.27 as=0.42 pd=2.54 ps=2.84
XM3 a_200_392##5 a_281_244##3 VPWR#5 VPB sky130_fd_pr__pfet_01v8 l=0.15 w=1 ad=0.42 as=0.295 pd=2.84 ps=2.59
XM8 a_281_244##7 B1_N#3 VPWR#4 VPB sky130_fd_pr__pfet_01v8 l=0.15 w=0.84 ad=0.3108 as=0.462 pd=2.42 ps=3.11
XM1 VPWR#4 a_200_392##3 X#1 VPB sky130_fd_pr__pfet_01v8 l=0.15 w=1.12 ad=0.462 as=0.3304 pd=3.11 ps=2.83
*
*
*       RESISTOR AND CAP/DIODE CARDS
*
Rg1	A1#1	A1#2	434.667297
Rg2	A1#2	A1#3	313.964966
Rg3	A2#1	A2#2	318.451508
Rg4	A2#2	A2#3	433.675812
Rg5	a_281_244#	a_281_244##2	345.981567
Rg6	a_281_244##2	a_281_244##3	536.582520
Rg7	a_281_244##2	a_281_244##4	282.714783
Rg8	B1_N#1	B1_N#2	253.420792
Rg9	B1_N#2	B1_N#3	411.718903
Rg10	a_200_392#	a_200_392##2	364.180084
Rg11	a_200_392##2	a_200_392##3	446.820007
Rf1	A1	A1#4	1.441604
Rf2	A1#5	A1#2	81.558006
Rf3	A1#4	A1#5	5.254016
Rf4	A1	A1#7	1.441604
Rf5	A1#5	A1#7	6.181196
Rf6	A2#4	A2	1.988420
Rf7	A2#2	A2#6	82.104820
Rf8	A2#4	A2#6	4.672586
Rf9	A2#7	A2	1.988420
Rf10	A2#6	A2#7	5.497160
Rf11	a_27_74#	a_27_74##2	89.486664
Rf12	a_281_244##5	a_281_244##4	55.095619
Rf13	a_281_244##4	a_281_244##7	48.227470
Rf14	B1_N	B1_N#4	0.705966
Rf15	B1_N#5	B1_N#2	160.938766
Rf16	B1_N#4	B1_N#5	3.543054
Rf17	a_200_392##2	a_200_392##6	335.330750
Rf18	a_200_392##6	a_200_392##7	105.990501
Rf19	a_200_392##5	a_200_392##6	5.000000
Rf20	X	X#2	0.181173
Rf21	X#2	X	13.225628
Rf22	X	X#3	86.677177
Rf23	X#1	X#2	5.000000
Rf25	VPWR#2	VPWR#3	83.253029
Rf26	VPWR#2	VPWR#4	33.326477
Rf27	VPWR#3	VPWR#5	36.824379
Rf28	VPWR#3	VPWR#6	155.702866
Rf30	VGND#2	VGND#3	82.887779
Rf31	VGND#3	VGND#4	83.253036
Rf33	VGND#2	VGND#6	23.661278
Rf34	VGND#4	VGND#7	32.342297
Re1	VPWR#3	VPWR	1.227783
Re2	VGND	VGND#3	1.227829
*
*       CAPACITOR CARDS
*
*
C1	A2#7	a_281_244##2	2.76668e-18
C2	a_281_244##2	B1_N#3	1.66256e-19
C3	VGND#3	a_281_244##2	1.07398e-19
C4	X#3	a_281_244##2	2.93201e-19
C5	a_200_392##2	a_281_244##2	1.89357e-19
C6	B1_N#4	X#3	5.0398e-18
C7	a_281_244##2	B1_N#2	3.58089e-19
C8	a_281_244##5	B1_N#4	2.69419e-17
C9	a_281_244##4	a_281_244##2	4.86341e-19
C10	A2#7	a_200_392##7	1.10562e-18
C11	a_200_392##7	a_281_244##2	1.41045e-17
C12	A2#2	a_281_244##2	4.73339e-17
C13	B1_N#5	a_281_244##7	1.2656e-17
C14	VGND#6	X#3	5.99933e-17
C15	B1_N#5	a_200_392##5	1.22743e-18
C16	a_281_244##5	VGND#6	3.07062e-17
C17	a_200_392##7	VGND#6	8.31746e-18
C18	A2#7	a_200_392##5	4.88002e-17
C19	a_200_392##7	a_281_244##5	3.2396e-17
C20	A1#4	a_27_74##2	4.8162e-17
C21	a_27_74#	a_200_392##7	6.06843e-17
C22	B1_N#4	a_200_392#	1.50546e-18
C23	A2#7	VPWR#6	4.46771e-19
C24	a_27_74#	VGND#7	4.43655e-17
C25	a_27_74##2	a_27_74#	2.65318e-18
C26	a_27_74##2	VGND#7	5.12337e-17
C27	a_281_244##5	a_281_244##7	3.58584e-18
C28	a_200_392##7	a_200_392##5	2.5436e-18
C29	X#3	a_200_392#	3.8483e-17
C30	a_27_74#	a_200_392##5	3.90561e-18
C31	a_281_244##7	a_281_244##2	5.50211e-20
C32	a_200_392#	VGND#6	2.38852e-17
C33	X#3	B1_N#1	2.92838e-18
C34	B1_N#1	VGND#6	2.46505e-17
C35	X#3	a_281_244#	2.0152e-19
C36	a_200_392##7	a_200_392#	1.39268e-18
C37	VPWR#5	VPWR#4	7.08273e-18
C38	a_281_244##5	B1_N#1	2.34328e-17
C39	A2#7	B1_N#3	1.2292e-19
C40	VGND#6	a_281_244#	1.22597e-18
C41	a_27_74#	a_200_392#	1.25531e-19
C42	a_200_392##7	B1_N#1	3.08312e-18
C43	a_200_392##5	VPWR#4	8.23767e-20
C44	a_281_244##5	a_281_244#	7.88795e-19
C45	a_27_74##2	VPWR#6	2.44882e-19
C46	VGND#6	A2#1	1.15014e-19
C47	VPWR#5	a_281_244##2	3.55345e-19
C48	a_27_74#	B1_N#1	2.51511e-19
C49	A2#7	a_281_244##3	2.48504e-18
C50	a_200_392##5	a_281_244##7	1.10537e-16
C51	a_281_244#	a_200_392##7	2.83019e-17
C52	a_27_74#	a_281_244#	4.40522e-17
C53	a_200_392##5	VPWR#5	7.58683e-17
C54	a_200_392##7	A2#1	8.54516e-19
C55	VGND#7	a_281_244#	1.49444e-18
C56	a_27_74#	A2#1	4.82958e-17
C57	a_200_392##7	A1#3	6.30689e-19
C58	A2#1	VGND#7	2.16183e-17
C59	VPWR#6	VPWR#5	6.509e-19
C60	a_27_74#	A1#3	8.47241e-19
C61	a_27_74##2	A2#1	8.45626e-19
C62	a_200_392##5	a_281_244##2	2.33036e-18
C63	VPWR#6	a_200_392##5	3.0592e-17
C64	A1#3	VGND#7	2.56475e-17
C65	a_27_74##2	A1#3	4.52608e-17
C66	A2#7	VPWR#3	6.31481e-19
C67	B1_N#5	a_200_392##2	2.16145e-17
C68	B1_N#4	a_200_392##2	4.45859e-18
C69	X#1	a_200_392##3	2.37538e-17
C70	B1_N#1	a_200_392#	1.97975e-17
C71	a_200_392##3	VPWR#4	2.47258e-17
C72	B1_N#5	B1_N#2	1.25022e-17
C73	X#1	B1_N#3	1.89128e-18
C74	B1_N#4	B1_N#2	1.13315e-17
C75	a_281_244##7	a_200_392##3	2.3536e-18
C76	a_281_244#	a_200_392#	2.67227e-19
C77	B1_N#3	VPWR#4	2.40326e-17
C78	X#1	a_281_244##3	3.57636e-19
C79	VPWR#5	a_200_392##3	2.03209e-18
C80	a_281_244#	B1_N#1	2.81096e-18
C81	A2#7	B1_N#2	7.17032e-20
C82	a_281_244##7	B1_N#3	3.6232e-17
C83	a_281_244##4	B1_N#5	1.85071e-17
C84	VPWR#4	a_281_244##3	1.41379e-18
C85	a_200_392##5	a_200_392##3	6.67784e-19
C86	a_281_244##4	B1_N#4	1.5209e-17
C87	VPWR#5	B1_N#3	2.1627e-18
C88	a_281_244##7	a_281_244##3	1.15381e-18
C89	a_200_392##5	B1_N#3	2.04873e-17
C90	A2#1	a_281_244#	3.09563e-17
C91	VPWR#5	a_281_244##3	5.07087e-17
C92	VGND#3	a_281_244##5	6.31371e-18
C93	a_200_392##5	a_281_244##3	7.60446e-17
C94	X#3	a_200_392##2	2.78233e-17
C95	VPWR#5	A2#3	1.87566e-18
C96	A2#7	A2#2	1.48956e-17
C97	VGND#3	a_200_392##7	2.46791e-17
C98	a_200_392##2	VGND#6	2.10295e-17
C99	A1#3	A2#1	1.87465e-17
C100	A2#3	a_200_392##5	2.7314e-17
C101	VGND#3	a_27_74#	5.76641e-18
C102	VPWR#5	A1#1	6.9274e-19
C103	VPWR#6	a_281_244##3	4.1677e-18
C104	X#3	B1_N#2	5.17928e-19
C105	a_200_392##5	A1#1	1.01724e-17
C106	A2#7	A1#2	1.92968e-18
C107	VPWR#6	A2#3	1.4839e-17
C108	B1_N#2	a_281_244##5	3.80998e-18
C109	a_281_244##4	X#3	2.13909e-18
C110	A1#5	A2#2	1.25047e-17
C111	VPWR#6	A1#1	5.81959e-17
C112	A1#4	A2#2	1.69901e-17
C113	a_281_244##4	a_281_244##5	8.81781e-19
C114	a_200_392##2	X#1	3.81391e-17
C115	a_200_392##5	VPWR#3	2.55757e-17
C116	a_200_392##7	a_281_244##4	5.29055e-17
C117	a_200_392##2	VPWR#4	5.79981e-17
C118	A1#5	A1#2	9.58925e-18
C119	a_281_244##7	a_200_392##2	1.80766e-17
C120	A1#4	A1#2	1.61227e-17
C121	VPWR#3	VPWR#6	3.90356e-17
C122	A2#2	a_200_392##7	2.55273e-17
C123	B1_N#3	a_200_392##3	2.42588e-17
C124	a_27_74#	A2#2	5.25183e-17
C125	a_281_244##7	B1_N#2	2.23203e-18
C126	a_200_392##5	a_200_392##2	1.5839e-18
C127	a_281_244##3	a_200_392##3	4.11868e-19
C128	A2#2	VGND#7	2.39177e-18
C129	a_281_244##3	B1_N#3	3.72236e-18
C130	a_200_392##5	B1_N#2	5.49697e-19
C131	a_281_244##2	B1_N#1	1.97322e-19
C132	VPWR#5	a_281_244##4	4.71738e-19
C133	VGND#3	a_281_244#	4.86778e-18
C134	a_27_74##2	A1#2	5.31156e-18
C135	a_200_392##5	a_281_244##4	1.22868e-17
C136	A2#3	a_281_244##3	2.61423e-17
C137	B1_N#2	a_200_392#	1.00826e-18
C138	a_200_392##5	A2#2	4.61006e-18
C139	a_281_244##4	a_200_392#	2.9282e-19
C140	A1#1	A2#3	6.2104e-17
C141	a_281_244##4	B1_N#1	8.01592e-19
C142	a_200_392##5	A1#2	6.48283e-19
C143	a_281_244##4	a_281_244#	2.93497e-19
C144	VPWR#3	a_281_244##3	9.52904e-19
C145	a_200_392##2	a_200_392##3	1.29441e-17
C146	A2#2	B1_N#1	9.48931e-20
C147	VPWR#6	A1#2	6.95365e-18
C148	VPWR#3	A2#3	6.03801e-18
C149	A2#2	a_281_244#	2.26917e-18
C150	a_200_392##2	B1_N#3	2.17996e-17
C151	a_200_392##2	a_281_244##3	2.17834e-19
C152	a_281_244##4	B1_N#3	2.46809e-19
C153	A2#2	a_281_244##3	8.41679e-18
C154	A1	A2#7	1.34991e-17
C155	VPWR#3	a_281_244##4	4.21279e-19
C156	B1_N#2	a_200_392##2	3.28986e-17
C157	VGND#3	a_281_244##4	2.3035e-18
C158	VPWR#3	A2#2	5.04981e-20
C159	a_281_244##4	a_200_392##2	4.50447e-18
C160	A2#3	a_116_392#	2.52858e-17
C161	a_281_244##4	B1_N#2	2.71683e-17
C162	A1#1	a_116_392#	2.61244e-17
C163	a_281_244##2	VNB	3.26848e-17
C164	VPWR	B1_N#5	2.98372e-18
C165	X#3	X	3.95354e-18
C166	VPWR	A2#7	6.77637e-18
C167	X	X#1	3.16601e-18
C168	A1#2	A2#2	4.92454e-17
C169	A1	VPWR#6	4.20639e-17
C170	VPWR#4	X	2.91193e-17
C171	VGND	B1_N#4	5.05682e-18
C172	VPWR	VPWR#4	1.62815e-17
C173	VGND	A1#4	3.95537e-18
C174	VPWR	a_281_244##7	6.67958e-18
C175	VGND	X#3	1.95187e-17
C176	VPWR	VPWR#5	1.63153e-17
C177	VGND	a_281_244##5	1.83956e-17
C178	VPWR	a_200_392##5	3.3698e-17
C179	VGND	a_200_392##7	1.6842e-17
C180	VGND	a_27_74#	1.74652e-17
C181	VPWR	VPWR#6	4.93316e-17
C182	VGND	VGND#7	1.61612e-17
C183	VGND	a_27_74##2	1.75222e-17
C184	X	a_200_392##3	2.21047e-17
C185	X	B1_N#3	6.82708e-19
C186	VGND	a_281_244##7	2.26629e-18
C187	X	a_281_244##3	2.01096e-19
C188	VPWR	a_200_392##3	4.01115e-18
C189	VGND	a_200_392#	2.17936e-18
C190	VPWR	B1_N#3	6.54029e-18
C191	VGND	B1_N#1	6.85601e-18
C192	VPWR	a_281_244##3	4.80042e-19
C193	VGND	a_281_244#	6.7016e-18
C194	VGND	A2#1	2.57605e-19
C195	VPWR	A2#3	2.43786e-18
C196	B1_N#5	VNB	9.17872e-19
C197	VGND	A1#3	1.11241e-18
C198	VPWR	A1#1	1.70865e-18
C199	B1_N#4	VNB	2.0193e-18
C200	a_200_392##2	X	5.75212e-17
C201	A1	A2#2	1.78736e-18
C202	VPWR	VPWR#3	4.33449e-17
C203	A1	A1#2	1.53981e-17
C204	A1#5	VNB	6.03786e-18
C205	A1#4	VNB	1.10084e-17
C206	VPWR	a_200_392##2	7.38182e-18
C207	X#3	VNB	5.29447e-17
C208	VGND#6	VNB	6.47053e-18
C209	a_281_244##5	VNB	4.79798e-18
C210	a_200_392##7	VNB	1.64005e-17
C211	a_27_74#	VNB	2.04044e-18
C212	VGND#7	VNB	5.74501e-18
C213	a_27_74##2	VNB	3.31409e-17
C214	X#1	VNB	1.98209e-17
C215	VGND	VGND#3	2.39147e-17
C216	VPWR#4	VNB	7.5448e-18
C217	a_281_244##7	VNB	1.2012e-17
C218	VGND	a_200_392##2	5.44143e-18
C219	VPWR#5	VNB	5.91126e-18
C220	a_200_392##5	VNB	2.02712e-17
C221	VGND	B1_N#2	3.32079e-19
C222	VPWR#6	VNB	8.22847e-17
C223	VGND	a_281_244##4	7.78834e-18
C224	a_200_392#	VNB	3.70254e-17
C225	B1_N#1	VNB	3.68356e-17
C226	VGND	A2#2	4.44826e-18
C227	a_281_244#	VNB	3.14875e-17
C228	A2#1	VNB	2.35637e-17
C229	A1#3	VNB	3.17388e-17
C230	a_200_392##3	VNB	3.68183e-17
C231	B1_N#3	VNB	4.31413e-17
C232	a_281_244##3	VNB	3.49125e-17
C233	A2#3	VNB	2.73044e-17
C234	A1#1	VNB	2.84444e-17
C235	VPWR#3	VNB	2.22413e-16
C236	VGND#3	VNB	2.04977e-16
C237	a_200_392##2	VNB	4.08621e-17
C238	B1_N#2	VNB	2.93766e-17
C239	VPWR	A1	4.05426e-18
C240	a_281_244##4	VNB	5.1418e-17
C241	A2#2	VNB	4.78621e-17
C242	A1#2	VNB	6.7772e-17
C243	VPWR	X	2.00542e-17
C244	VGND	X	8.9408e-19
C245	A1	VNB	1.04611e-17
C246	X	VNB	4.92153e-17
C247	VPWR	VNB	6.74734e-17
C248	VGND	VNB	6.62085e-17
C249	VGND#4	a_27_74#	1.41236e-17
C250	VGND#2	X#3	2.25788e-17
C251	VPWR#2	B1_N#2	1.18601e-19
C252	VGND#4	A2#1	2.74194e-18
C253	VGND#2	a_281_244#	4.72145e-19
C254	VGND#3	VGND#2	5.98143e-17
C255	VGND#2	B1_N#4	1.12574e-18
C256	VGND	VGND#2	6.23599e-17
C257	a_200_392##5	VPWR#2	2.9634e-18
C258	VGND#4	A1#3	2.71238e-18
C259	VPWR#3	VPWR#2	5.89943e-17
C260	VGND#2	A2#1	1.00964e-19
C261	VGND	VGND#4	3.53744e-17
C262	VGND#4	a_27_74##2	2.09852e-17
C263	X	VPWR#2	2.23581e-17
C264	VGND#2	a_200_392##2	7.656e-19
C265	VPWR#2	VNB	5.34847e-17
C266	VGND#2	a_281_244##5	4.71313e-18
C267	VGND#4	A1#2	2.84605e-19
C268	VGND#2	B1_N#2	4.64907e-19
C269	VGND#2	VNB	5.67317e-17
C270	VPWR	VPWR#2	4.19991e-17
C271	VGND#4	VNB	5.28542e-17
C272	VPWR#2	a_200_392##3	4.62988e-18
C273	VGND#3	VGND#4	5.97538e-17
C274	VGND#2	a_200_392#	1.19146e-17
C275	a_200_392##2	VPWR#2	9.09055e-19
C276	VGND#2	B1_N#1	5.54107e-18
C277	VPWR#2	B1_N#3	4.51272e-18
*
*
.ENDS sky130_fd_sc_hs__o21ba_1
*
