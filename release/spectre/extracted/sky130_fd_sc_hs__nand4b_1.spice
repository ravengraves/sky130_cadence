* Extracted by Quantus, converted by sky130cad/quantus.py
*
*
*
*                       LINUX           Wed Nov 18 08:47:41 2026
*
*
*
*  PROGRAM  advgen
*
*  Name           : advgen - Quantus - (64-bit)
*  Version        : 25.1.0-p047
*  Build Date     : Thu Dec 11 23:20:30 PST 2025
*
*  HSPICE LIBRARY
*
*  OPERATING_TEMPERATURE 150
*  QRC_TECH_DIR <path>/tech
*
*
*

*
.SUBCKT sky130_fd_sc_hs__nand4b_1 VPB VNB VGND VPWR Y A_N D C B
*
*
*  caps2d version: 10
*
*
*       TRANSISTOR CARDS
*
*
XM0 a_27_112##5 A_N#1 VGND#4 VNB sky130_fd_pr__nfet_01v8_lvt l=0.15 w=0.55 ad=0.2695 as=0.2696 pd=2.08 ps=2.26
XM4 VGND#4 D#1 a_263_74# VNB sky130_fd_pr__nfet_01v8_lvt l=0.15 w=0.74 ad=0.2696 as=0.1776 pd=2.26 ps=1.96
XM3 a_263_74# C#3 a_341_74# VNB sky130_fd_pr__nfet_01v8_lvt l=0.15 w=0.74 ad=0.1776 as=0.2664 pd=1.96 ps=2.2
XM7 a_341_74# B#3 a_443_74# VNB sky130_fd_pr__nfet_01v8_lvt l=0.15 w=0.74 ad=0.2664 as=0.2886 pd=2.2 ps=2.26
XM9 a_443_74# a_27_112##3 Y#1 VNB sky130_fd_pr__nfet_01v8_lvt l=0.15 w=0.74 ad=0.2886 as=0.3404 pd=2.26 ps=2.4
XM1 a_27_112##7 A_N#3 VPWR#7 VPB sky130_fd_pr__pfet_01v8 l=0.15 w=0.84 ad=0.2478 as=0.462 pd=2.27 ps=3.11
XM2 VPWR#7 D#3 Y#3 VPB sky130_fd_pr__pfet_01v8 l=0.15 w=1.12 ad=0.462 as=0.336 pd=3.11 ps=2.84
XM6 Y#3 C#1 VPWR#6 VPB sky130_fd_pr__pfet_01v8 l=0.15 w=1.12 ad=0.336 as=0.4704 pd=2.84 ps=3.08
XM8 VPWR#6 B#1 Y#4 VPB sky130_fd_pr__pfet_01v8 l=0.15 w=1.12 ad=0.4704 as=0.336 pd=3.08 ps=2.84
XM5 Y#4 a_27_112# VPWR#1 VPB sky130_fd_pr__pfet_01v8 l=0.15 w=1.12 ad=0.336 as=0.3864 pd=2.84 ps=2.93
*
*
*       RESISTOR AND CAP/DIODE CARDS
*
Rg1	A_N#1	A_N#2	253.420792
Rg2	A_N#2	A_N#3	411.718903
Rg3	D#1	D#2	307.937683
Rg4	D#2	D#3	492.059540
Rg5	C#1	C#2	492.059540
Rg6	C#2	C#3	307.937683
Rg7	B#1	B#2	492.059540
Rg8	B#2	B#3	307.937683
Rg9	a_27_112#	a_27_112##2	492.059540
Rg10	a_27_112##2	a_27_112##3	307.937683
Rf1	A_N#4	A_N#2	161.821228
Rf2	A_N	A_N#6	1.588424
Rf3	A_N#4	A_N#6	3.882813
Rf4	D#4	D	0.882458
Rf5	D#2	D#6	161.115265
Rf6	D#4	D#6	3.543054
Rf7	C#2	C	163.775864
Rf8	B	B#4	1.235440
Rf9	B#5	B#2	161.468246
Rf10	B#4	B#5	3.349972
Rf11	a_27_112##2	a_27_112##6	335.439941
Rf12	a_27_112##6	a_27_112##7	99.077995
Rf13	a_27_112##5	a_27_112##6	15.000000
Rf14	Y#1	Y#2	123.354500
Rf15	Y#2	Y	10.251500
Rf16	Y	Y#3	39.963360
Rf17	Y#2	Y#4	15.375146
Rf18	VPWR#1	VPWR#2	105.770363
Rf19	VPWR#2	VPWR#3	19.699100
Rf20	VPWR#3	VPWR#4	53.302330
Rf22	VPWR#2	VPWR#6	32.518913
Rf23	VPWR#4	VPWR#7	38.286041
Rf24	VGND#1	VGND#2	48.188797
Rf26	VGND#2	VGND#4	33.326477
Re1	VPWR#3	VPWR	1.403190
Re2	VGND	VGND#1	1.403242
*
*       CAPACITOR CARDS
*
*
C1	A_N#6	D#6	1.80068e-17
C2	VPWR#2	VPWR#1	9.16231e-19
C3	Y#4	VPWR#2	1.50811e-17
C4	a_27_112##5	A_N#6	1.85092e-17
C5	a_27_112##5	A_N#4	3.94561e-17
C6	D#6	Y#3	1.2446e-17
C7	D#6	VPWR#7	1.96176e-17
C8	A_N#6	VPWR#7	1.4593e-17
C9	a_27_112##5	VGND#4	4.4411e-17
C10	VPWR#2	B#1	2.94711e-18
C11	a_27_112##7	A_N#4	2.86147e-17
C12	Y#1	a_27_112##3	1.9902e-17
C13	Y#4	VPWR#1	7.03057e-17
C14	VPWR#6	VPWR#1	1.6e-18
C15	Y#1	B#3	3.65696e-18
C16	a_27_112##5	Y#3	6.35276e-18
C17	VPWR#6	Y#4	5.99104e-17
C18	a_27_112##5	VPWR#7	5.25955e-18
C19	Y#1	C#3	1.70763e-18
C20	Y#3	Y#4	2.9555e-18
C21	a_27_112##5	a_27_112##7	2.91832e-18
C22	VGND#4	a_27_112##3	2.25232e-18
C23	Y#1	D#1	1.52528e-18
C24	Y#3	VPWR#6	6.69047e-17
C25	a_27_112##5	a_27_112##3	6.26173e-19
C26	VGND#4	B#3	3.06936e-18
C27	VPWR#7	VPWR#6	1.69608e-18
C28	a_27_112##5	B#3	7.23188e-19
C29	VGND#4	C#3	5.3556e-18
C30	VPWR#3	VPWR#2	3.25605e-17
C31	VPWR#7	Y#3	1.02717e-16
C32	a_27_112##5	C#3	2.22613e-17
C33	VGND#4	D#1	3.81046e-17
C34	a_27_112##7	Y#3	1.78125e-18
C35	a_27_112##5	D#1	1.96231e-17
C36	A_N#1	VGND#4	2.20939e-17
C37	a_27_112##7	VPWR#7	6.60876e-17
C38	a_27_112##5	A_N#1	3.9263e-17
C39	B#3	a_27_112##3	2.7054e-17
C40	a_27_112#	VPWR#1	3.20048e-17
C41	B#5	a_27_112##2	2.0826e-17
C42	Y#4	a_27_112#	4.70818e-17
C43	a_27_112##2	B#4	5.43094e-17
C44	VPWR#1	B#1	1.37004e-18
C45	VPWR#6	a_27_112#	1.35765e-18
C46	C#3	B#3	3.0698e-17
C47	Y#4	B#1	4.65404e-17
C48	B#5	B#2	8.18257e-18
C49	VPWR#1	C#1	2.85027e-19
C50	B#4	B#2	7.7451e-18
C51	B#1	VPWR#6	3.19883e-17
C52	Y#4	C#1	6.25651e-19
C53	Y#3	B#1	5.91287e-19
C54	D#1	C#3	4.98414e-17
C55	C#2	B#5	1.48965e-17
C56	C#1	VPWR#6	3.67093e-17
C57	B#4	C#2	1.77663e-18
C58	VPWR#7	B#1	2.83766e-19
C59	VGND#1	Y#1	2.67156e-17
C60	Y#3	C#1	8.60225e-17
C61	VPWR#6	D#3	1.2717e-18
C62	VPWR#7	C#1	1.34947e-18
C63	A_N#1	D#1	2.14003e-17
C64	Y#3	D#3	5.74222e-17
C65	a_27_112##2	Y#1	7.66396e-17
C66	D#6	C#2	1.36899e-17
C67	a_27_112##7	C#1	3.58652e-20
C68	D#3	VPWR#7	3.1539e-17
C69	Y#3	A_N#3	1.68343e-18
C70	VPWR#3	VPWR#1	3.46137e-17
C71	a_27_112##7	D#3	1.54966e-18
C72	Y#1	B#2	5.59464e-20
C73	D#6	D#2	9.84789e-18
C74	A_N#3	VPWR#7	3.25254e-17
C75	VGND#1	a_27_112##5	3.0794e-18
C76	a_27_112##2	VGND#4	1.78954e-20
C77	a_27_112##7	A_N#3	4.17107e-17
C78	A_N#6	D#2	3.95591e-18
C79	Y#1	C#2	2.87931e-20
C80	D#6	A_N#2	1.95518e-18
C81	Y#3	VPWR#3	1.34469e-17
C82	VPWR#1	a_27_112##2	9.36707e-19
C83	A_N#6	A_N#2	6.64368e-18
C84	Y#1	D#2	1.97422e-20
C85	B#1	a_27_112#	4.76818e-17
C86	A_N#4	A_N#2	1.07304e-17
C87	VPWR#6	B#2	3.87589e-19
C88	D#2	VGND#4	1.62283e-18
C89	VGND#1	a_27_112##3	5.69817e-18
C90	C#1	B#1	2.90385e-17
C91	a_27_112##5	D#2	2.69356e-18
C92	VGND#1	B#3	8.33879e-18
C93	VPWR#6	C#2	4.36331e-19
C94	a_27_112##2	a_27_112##3	1.34352e-17
C95	VGND#1	C#3	8.33879e-18
C96	C#2	Y#3	3.43784e-17
C97	a_27_112##7	B#2	9.93434e-20
C98	a_27_112##2	B#3	2.70535e-17
C99	A_N#2	a_27_112##5	9.04444e-18
C100	D#3	C#1	4.89106e-17
C101	a_27_112##2	C#3	4.30423e-19
C102	a_27_112##7	C#2	1.29407e-19
C103	a_27_112##2	D#1	2.00359e-19
C104	VPWR#7	D#2	2.7646e-18
C105	a_27_112##2	A_N#1	2.16429e-19
C106	A_N#3	D#3	2.49693e-17
C107	a_27_112##7	D#2	2.66785e-19
C108	VPWR#3	C#1	5.69316e-18
C109	a_27_112##7	A_N#2	7.99038e-18
C110	C	B#5	3.2406e-18
C111	a_27_112##5	a_263_74#	5.23364e-18
C112	C	B#4	1.22524e-17
C113	a_27_112##3	a_443_74#	2.12754e-17
C114	B#3	a_443_74#	1.85209e-17
C115	D#6	C	2.96854e-18
C116	B#3	a_341_74#	2.00839e-17
C117	VGND#1	a_27_112##2	1.16438e-17
C118	C#3	a_341_74#	2.00839e-17
C119	VGND#1	B#2	5.16111e-19
C120	A_N#6	D	1.35419e-17
C121	C#3	a_263_74#	1.58629e-17
C122	B#2	a_27_112##2	4.26371e-17
C123	VGND#1	C#2	4.4106e-19
C124	D#1	a_263_74#	1.58629e-17
C125	a_27_112##5	C	2.0927e-17
C126	Y	VPWR#2	1.75535e-19
C127	a_27_112##2	C#2	2.26399e-18
C128	C#2	B#2	3.11729e-17
C129	B#5	Y	4.64327e-17
C130	a_27_112##5	D	4.18631e-17
C131	D#2	C#2	3.82989e-17
C132	VPWR	VPWR#2	2.02526e-17
C133	a_27_112##2	a_443_74#	6.33226e-18
C134	Y#1	Y	3.17799e-18
C135	VPWR	B#5	2.0461e-18
C136	A_N#2	D#2	2.96076e-17
C137	B#2	a_443_74#	9.77477e-19
C138	a_27_112##2	a_341_74#	7.70943e-18
C139	VPWR	D#6	2.65725e-18
C140	VPWR	A_N#6	1.13958e-18
C141	Y	VPWR#1	5.71349e-17
C142	VPWR	A_N#4	2.0229e-18
C143	Y	Y#4	2.9229e-19
C144	C#2	a_341_74#	8.0991e-19
C145	Y	VPWR#6	3.10101e-17
C146	VGND	B#4	3.28459e-18
C147	VPWR	VPWR#1	4.51027e-17
C148	VGND	A_N#6	1.41555e-18
C149	VPWR	Y#4	1.7373e-17
C150	VPWR	VPWR#6	2.08932e-17
C151	VGND	A_N#4	1.87235e-18
C152	VPWR	Y#3	1.80469e-17
C153	VGND	Y#1	1.83935e-17
C154	VPWR#2	VNB	2.55015e-17
C155	VPWR	VPWR#7	2.08907e-17
C156	a_27_112##2	C	2.02288e-17
C157	VPWR	a_27_112##7	1.79115e-17
C158	C	B#2	1.28446e-18
C159	VGND	VGND#4	1.63402e-17
C160	Y	a_27_112#	2.82343e-17
C161	B#5	VNB	1.69026e-19
C162	VGND	a_27_112##5	2.80991e-17
C163	B#4	VNB	2.84419e-18
C164	Y	B#1	3.27746e-17
C165	C	C#2	8.41069e-18
C166	D#6	VNB	1.04885e-18
C167	C	D#2	1.38205e-18
C168	VGND	Y#3	3.89367e-18
C169	A_N#6	VNB	1.04672e-18
C170	VGND	VPWR#7	4.05065e-18
C171	D	C#2	1.66873e-18
C172	A_N#4	VNB	6.8859e-18
C173	VGND	a_27_112##7	2.14787e-18
C174	VPWR	a_27_112#	2.26238e-19
C175	Y#1	VNB	6.0791e-17
C176	VGND	a_27_112##3	2.16026e-18
C177	D	D#2	8.88568e-18
C178	VPWR	B#1	2.21031e-19
C179	VGND	B#3	1.37819e-18
C180	VPWR	C#1	1.36036e-19
C181	VGND	C#3	1.30753e-18
C182	D	A_N#2	1.12259e-18
C183	VGND#4	VNB	8.09756e-18
C184	VPWR	D#3	3.22132e-18
C185	VGND	D#1	4.62002e-19
C186	a_27_112##5	VNB	3.59388e-17
C187	VPWR#1	VNB	7.86809e-17
C188	VGND	A_N#1	8.51091e-18
C189	VPWR	A_N#3	6.54029e-18
C190	a_27_112##2	Y	5.24069e-17
C191	Y#4	VNB	2.24517e-18
C192	VPWR#6	VNB	3.78119e-18
C193	Y	B#2	1.9813e-18
C194	Y#3	VNB	6.05736e-18
C195	VPWR	VPWR#3	9.51108e-18
C196	VPWR#7	VNB	1.83095e-17
C197	C#2	Y	9.81833e-18
C198	a_27_112##7	VNB	6.93416e-17
C199	a_27_112##3	VNB	2.92691e-17
C200	Y	D#2	7.01944e-20
C201	VPWR	a_27_112##2	2.29545e-18
C202	B#3	VNB	2.54357e-17
C203	C#3	VNB	2.35705e-17
C204	D#1	VNB	2.81644e-17
C205	A_N#1	VNB	4.06011e-17
C206	VPWR	C#2	1.83626e-18
C207	a_27_112#	VNB	4.33382e-17
C208	VGND	VGND#1	5.61146e-17
C209	B#1	VNB	3.53834e-17
C210	VGND	a_27_112##2	2.21875e-17
C211	C#1	VNB	3.81652e-17
C212	VGND	B#2	3.32079e-19
C213	D#3	VNB	3.806e-17
C214	A_N#3	VNB	4.27541e-17
C215	VGND	C#2	3.32079e-19
C216	D	C	1.1445e-17
C217	VPWR#3	VNB	1.65849e-16
C218	VGND	A_N#2	3.32079e-19
C219	VGND#1	VNB	2.28877e-16
C220	a_27_112##2	VNB	4.95098e-17
C221	B#2	VNB	2.51605e-17
C222	C#2	VNB	2.68531e-17
C223	D#2	VNB	2.76146e-17
C224	A_N#2	VNB	4.04895e-17
C225	VGND	C	3.14633e-18
C226	VGND	D	3.21542e-18
C227	VPWR	Y	7.14163e-18
C228	C	VNB	3.43474e-18
C229	D	VNB	2.0222e-18
C230	VGND	Y	6.13104e-18
C231	Y	VNB	2.99477e-17
C232	VPWR	VNB	6.1061e-17
C233	VGND	VNB	5.84165e-17
C234	VPWR#3	VPWR#4	5.79859e-17
C235	D#6	VPWR#4	2.24667e-19
C236	Y#3	VPWR#4	3.79314e-18
C237	VPWR#4	A_N#2	8.4195e-20
C238	VGND#2	A_N#1	4.12261e-18
C239	VGND#2	A_N#2	4.64907e-19
C240	VPWR#4	A_N#3	4.75088e-18
C241	VGND#1	VGND#2	5.97538e-17
C242	VPWR#4	VNB	5.29025e-17
C243	VGND#2	D#1	3.85399e-18
C244	VPWR#4	VPWR#2	9.5684e-19
C245	VPWR#4	D#3	4.65862e-18
C246	VGND#2	a_27_112##5	1.41422e-17
C247	A_N#4	VPWR#4	1.98681e-19
C248	VGND#2	VNB	5.63413e-17
C249	VPWR	VPWR#4	4.11913e-17
C250	A_N#6	VPWR#4	1.20215e-19
C251	VGND	VGND#2	4.30227e-17
C252	a_27_112##7	VPWR#4	1.18517e-17
*
*
.ENDS sky130_fd_sc_hs__nand4b_1
*
