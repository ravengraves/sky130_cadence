* Extracted by Quantus, converted by sky130cad/quantus.py
*
*
*
*                       LINUX           Wed Nov 18 08:02:43 2026
*
*
*
*  PROGRAM  advgen
*
*  Name           : advgen - Quantus - (64-bit)
*  Version        : 25.1.0-p047
*  Build Date     : Thu Dec 11 23:20:30 PST 2025
*
*  HSPICE LIBRARY
*
*  OPERATING_TEMPERATURE 150
*  QRC_TECH_DIR <path>/tech
*
*
*

*
.SUBCKT sky130_fd_sc_hs__a2111oi_4 VPB VNB VGND VPWR Y D1 C1 B1 A1 A2
*
*
*  caps2d version: 10
*
*
*       TRANSISTOR CARDS
*
*
XM12 VGND#14 D1#6 Y#8 VNB sky130_fd_pr__nfet_01v8_lvt l=0.15 w=0.74 ad=0.1961 as=0.2072 pd=2.01 ps=2.04
XM20 Y#8 D1#5 VGND#13 VNB sky130_fd_pr__nfet_01v8_lvt l=0.15 w=0.74 ad=0.2072 as=0.2072 pd=2.04 ps=2.04
XM17 VGND#13 C1#6 Y#7 VNB sky130_fd_pr__nfet_01v8_lvt l=0.15 w=0.74 ad=0.2072 as=0.2072 pd=2.04 ps=2.04
XM24 Y#7 C1#8 VGND#12 VNB sky130_fd_pr__nfet_01v8_lvt l=0.15 w=0.74 ad=0.2072 as=0.8732 pd=2.04 ps=3.84
XM26 VGND#12 B1#10 Y#1 VNB sky130_fd_pr__nfet_01v8_lvt l=0.15 w=0.74 ad=0.8732 as=0.2072 pd=3.84 ps=2.04
XM1 Y#1 B1#7 VGND#11 VNB sky130_fd_pr__nfet_01v8_lvt l=0.15 w=0.74 ad=0.2072 as=0.1961 pd=2.04 ps=2.01
XM32 Y#5 A1#12 a_1228_74##7 VNB sky130_fd_pr__nfet_01v8_lvt l=0.15 w=0.74 ad=0.2072 as=0.2109 pd=2.04 ps=2.05
XM18 a_1228_74##5 A1#10 Y#5 VNB sky130_fd_pr__nfet_01v8_lvt l=0.15 w=0.74 ad=0.2072 as=0.2072 pd=2.04 ps=2.04
XM22 a_1228_74##5 A1#8 Y#11 VNB sky130_fd_pr__nfet_01v8_lvt l=0.15 w=0.74 ad=0.2072 as=0.2072 pd=2.04 ps=2.04
XM27 Y#11 A1#1 a_1228_74##3 VNB sky130_fd_pr__nfet_01v8_lvt l=0.15 w=0.74 ad=0.2072 as=0.2072 pd=2.04 ps=2.04
XM4 VGND#10 A2#7 a_1228_74##3 VNB sky130_fd_pr__nfet_01v8_lvt l=0.15 w=0.74 ad=0.2072 as=0.2072 pd=2.04 ps=2.04
XM31 VGND#10 A2#11 a_1228_74##8 VNB sky130_fd_pr__nfet_01v8_lvt l=0.15 w=0.74 ad=0.2072 as=0.2072 pd=2.04 ps=2.04
XM11 a_1228_74##8 A2#9 VGND#9 VNB sky130_fd_pr__nfet_01v8_lvt l=0.15 w=0.74 ad=0.2072 as=0.2072 pd=2.04 ps=2.04
XM29 a_1228_74# A2#8 VGND#9 VNB sky130_fd_pr__nfet_01v8_lvt l=0.15 w=0.74 ad=0.2109 as=0.2072 pd=2.05 ps=2.04
XM19 a_29_368##6 D1#9 Y#10 VPB sky130_fd_pr__pfet_01v8 l=0.15 w=1.12 ad=0.308 as=0.336 pd=2.79 ps=2.84
XM5 Y#10 D1#10 a_29_368##8 VPB sky130_fd_pr__pfet_01v8 l=0.15 w=1.12 ad=0.336 as=0.336 pd=2.84 ps=2.84
XM0 Y#12 D1#7 a_29_368##8 VPB sky130_fd_pr__pfet_01v8 l=0.15 w=1.12 ad=0.336 as=0.336 pd=2.84 ps=2.84
XM14 a_29_368##3 D1#1 Y#12 VPB sky130_fd_pr__pfet_01v8 l=0.15 w=1.12 ad=0.336 as=0.336 pd=2.84 ps=2.84
XM9 a_474_368##4 C1#10 a_29_368##3 VPB sky130_fd_pr__pfet_01v8 l=0.15 w=1.12 ad=0.336 as=0.336 pd=2.84 ps=2.84
XM23 a_29_368##7 C1#9 a_474_368##4 VPB sky130_fd_pr__pfet_01v8 l=0.15 w=1.12 ad=0.336 as=0.336 pd=2.84 ps=2.84
XM21 a_29_368##7 C1#7 a_474_368##6 VPB sky130_fd_pr__pfet_01v8 l=0.15 w=1.12 ad=0.336 as=0.336 pd=2.84 ps=2.84
XM7 a_474_368##6 C1#1 a_29_368# VPB sky130_fd_pr__pfet_01v8 l=0.15 w=1.12 ad=0.336 as=0.308 pd=2.84 ps=2.79
XM2 a_853_368##7 B1#9 a_474_368##5 VPB sky130_fd_pr__pfet_01v8 l=0.15 w=1.12 ad=0.3304 as=0.336 pd=2.83 ps=2.84
XM25 a_474_368##5 B1#8 a_853_368##12 VPB sky130_fd_pr__pfet_01v8 l=0.15 w=1.12 ad=0.336 as=0.336 pd=2.84 ps=2.84
XM8 a_853_368##12 B1#4 a_474_368# VPB sky130_fd_pr__pfet_01v8 l=0.15 w=1.12 ad=0.336 as=0.336 pd=2.84 ps=2.84
XM6 a_474_368# B1#1 a_853_368##11 VPB sky130_fd_pr__pfet_01v8 l=0.15 w=1.12 ad=0.336 as=0.336 pd=2.84 ps=2.84
XM10 a_853_368##11 A1#6 VPWR#10 VPB sky130_fd_pr__pfet_01v8 l=0.15 w=1.12 ad=0.336 as=0.336 pd=2.84 ps=2.84
XM30 VPWR#10 A1#11 a_853_368##10 VPB sky130_fd_pr__pfet_01v8 l=0.15 w=1.12 ad=0.336 as=0.336 pd=2.84 ps=2.84
XM28 VPWR#9 A1#9 a_853_368##10 VPB sky130_fd_pr__pfet_01v8 l=0.15 w=1.12 ad=0.336 as=0.336 pd=2.84 ps=2.84
XM13 a_853_368##9 A1#7 VPWR#9 VPB sky130_fd_pr__pfet_01v8 l=0.15 w=1.12 ad=0.336 as=0.336 pd=2.84 ps=2.84
XM16 a_853_368##9 A2#13 VPWR#8 VPB sky130_fd_pr__pfet_01v8 l=0.15 w=1.12 ad=0.336 as=0.336 pd=2.84 ps=2.84
XM3 VPWR#8 A2#12 a_853_368##8 VPB sky130_fd_pr__pfet_01v8 l=0.15 w=1.12 ad=0.336 as=0.336 pd=2.84 ps=2.84
XM15 a_853_368##8 A2#10 VPWR#7 VPB sky130_fd_pr__pfet_01v8 l=0.15 w=1.12 ad=0.336 as=0.336 pd=2.84 ps=2.84
XM33 VPWR#7 A2#1 a_853_368# VPB sky130_fd_pr__pfet_01v8 l=0.15 w=1.12 ad=0.336 as=0.308 pd=2.84 ps=2.79
*
*
*       RESISTOR AND CAP/DIODE CARDS
*
Rg1	D1#1	D1#2	561.358704
Rg2	D1#2	D1#3	61.878078
Rg3	D1#3	D1#4	17.181139
Rg4	D1#2	D1#5	377.236847
Rg5	D1#3	D1#6	362.264893
Rg6	D1#3	D1#7	451.213501
Rg7	D1#4	D1#8	52.285404
Rg8	D1#8	D1#9	565.649353
Rg9	D1#8	D1#10	476.975128
Rg10	C1#1	C1#2	453.614502
Rg11	C1#2	C1#3	56.868057
Rg12	C1#3	C1#4	25.545227
Rg13	C1#4	C1#5	68.017754
Rg14	C1#5	C1#6	397.883728
Rg15	C1#2	C1#7	428.171417
Rg16	C1#4	C1#8	430.991333
Rg17	C1#4	C1#9	462.553741
Rg18	C1#5	C1#10	464.317322
Rg19	B1#1	B1#2	502.825806
Rg20	B1#2	B1#3	67.050835
Rg21	B1#2	B1#4	419.554810
Rg22	B1#3	B1#5	96.474297
Rg23	B1#5	B1#6	29.487911
Rg24	B1#6	B1#7	370.752045
Rg25	B1#3	B1#8	429.126801
Rg26	B1#5	B1#9	419.554810
Rg27	B1#6	B1#10	501.772278
Rg28	A1#1	A1#2	397.555725
Rg29	A1#2	A1#3	90.016602
Rg30	A1#3	A1#4	51.916321
Rg31	A1#4	A1#5	66.386436
Rg32	A1#5	A1#6	454.869080
Rg33	A1#2	A1#7	449.655212
Rg34	A1#3	A1#8	373.041962
Rg35	A1#3	A1#9	424.977325
Rg36	A1#4	A1#10	397.590515
Rg37	A1#4	A1#11	449.490784
Rg38	A1#5	A1#12	418.139221
Rg39	A2#1	A2#2	455.914490
Rg40	A2#2	A2#3	66.369736
Rg41	A2#3	A2#4	45.616405
Rg42	A2#4	A2#5	33.804066
Rg43	A2#5	A2#6	66.386436
Rg44	A2#6	A2#7	397.555725
Rg45	A2#2	A2#8	426.989899
Rg46	A2#3	A2#9	401.054016
Rg47	A2#3	A2#10	450.571655
Rg48	A2#5	A2#11	395.494293
Rg49	A2#5	A2#12	448.603302
Rg50	A2#6	A2#13	449.655212
Rf1	D1	D1#4	40.957573
Rf2	C1#11	C1	0.792982
Rf3	C1#3	C1#13	40.851185
Rf4	C1#11	C1#13	8.251274
Rf5	C1#14	C1	0.792982
Rf6	C1#13	C1#14	6.417657
Rf7	a_29_368#	a_29_368##2	80.185562
Rf8	a_29_368##2	a_29_368##4	74.606598
Rf9	a_29_368##4	a_29_368##5	81.104050
Rf10	a_29_368##5	a_29_368##6	94.963860
Rf11	a_29_368##2	a_29_368##7	17.622940
Rf12	a_29_368##5	a_29_368##8	36.706856
Rf13	a_29_368##3	a_29_368##4	5.000000
Rf14	a_474_368#	a_474_368##2	80.804855
Rf15	a_474_368##2	a_474_368##3	105.143646
Rf16	a_474_368##3	a_474_368##4	82.601906
Rf17	a_474_368##2	a_474_368##5	18.740368
Rf18	a_474_368##3	a_474_368##6	18.445114
Rf19	B1	B1#11	10.543295
Rf20	B1#11	B1	4.125637
Rf21	Y#1	Y#2	19.548817
Rf22	Y#2	Y#3	125.425125
Rf23	Y#3	Y#4	59.543056
Rf24	Y#4	Y	115.879623
Rf25	Y#2	Y#6	150.599075
Rf26	Y#3	Y#7	16.967133
Rf27	Y#4	Y#8	18.078979
Rf28	Y	Y#9	37.419216
Rf29	Y#9	Y#10	22.775515
Rf30	Y#6	Y#11	57.464378
Rf31	Y#9	Y#12	89.125153
Rf32	Y#5	Y#6	15.000000
Rf33	A1	A1#13	7.334466
Rf34	A1#13	A1	7.334466
Rf37	a_1228_74#	a_1228_74##2	85.866737
Rf38	a_1228_74##2	a_1228_74##4	84.090828
Rf39	a_1228_74##4	a_1228_74##6	56.771667
Rf40	a_1228_74##6	a_1228_74##7	56.640839
Rf41	a_1228_74##2	a_1228_74##8	28.306047
Rf42	a_1228_74##3	a_1228_74##4	7.500000
Rf43	a_1228_74##5	a_1228_74##6	15.000000
Rf44	a_853_368#	a_853_368##2	86.609100
Rf45	a_853_368##2	a_853_368##3	65.818954
Rf46	a_853_368##3	a_853_368##4	65.941528
Rf47	a_853_368##4	a_853_368##5	65.941528
Rf48	a_853_368##5	a_853_368##6	65.892853
Rf49	a_853_368##6	a_853_368##7	81.678612
Rf50	a_853_368##2	a_853_368##8	17.027714
Rf51	a_853_368##3	a_853_368##9	28.362816
Rf52	a_853_368##4	a_853_368##10	28.362816
Rf53	a_853_368##5	a_853_368##11	28.362816
Rf54	a_853_368##6	a_853_368##12	17.622940
Rf56	VPWR#2	VPWR#3	74.142540
Rf57	VPWR#3	VPWR#4	62.104916
Rf58	VPWR#4	VPWR#5	65.696381
Rf59	VPWR#5	VPWR#6	241.042099
Rf60	VPWR#2	VPWR#7	38.736572
Rf61	VPWR#3	VPWR#8	43.353802
Rf62	VPWR#4	VPWR#9	33.109421
Rf63	VPWR#5	VPWR#10	33.109421
Rf65	VGND#2	VGND#3	66.816673
Rf66	VGND#3	VGND#4	273.768707
Rf67	VGND#4	VGND#5	99.251091
Rf68	VGND#5	VGND#6	100.054649
Rf69	VGND#6	VGND#7	62.774361
Rf71	VGND#2	VGND#9	38.247387
Rf72	VGND#3	VGND#10	41.745289
Rf73	VGND#4	VGND#11	36.869534
Rf74	VGND#5	VGND#12	13.345897
Rf75	VGND#6	VGND#13	33.326477
Rf76	VGND#7	VGND#14	33.326477
Rf80	A1#3	A1#13	40.058201
Rf81	A2#4	A2	40.058201
Rf79	B1#3	B1#11	32.046562
Re1	VPWR#3	VPWR	2.687498
Re2	VPWR	VPWR#6	1.343749
Re3	VGND#3	VGND	2.687498
Re4	VGND	VGND#5	1.343749
*
*       CAPACITOR CARDS
*
*
C1	Y#10	Y#12	4.88921e-18
C2	VGND#11	a_1228_74##7	9.16907e-18
C3	A1#4	VPWR#9	6.47602e-19
C4	D1#6	Y#8	2.00242e-17
C5	VGND#4	Y#5	7.33196e-18
C6	VGND#14	D1#6	2.56475e-17
C7	Y#10	a_29_368##8	5.09848e-17
C8	C1#11	D1#8	7.04561e-19
C9	A1#2	VPWR#9	6.13865e-19
C10	a_29_368##6	a_29_368##8	3.51463e-18
C11	B1#6	B1#3	8.81379e-19
C12	A1#2	A2#6	2.6224e-17
C13	B1#1	A1#5	2.00065e-17
C14	B1#3	B1#2	8.81379e-19
C15	Y#1	VGND#11	3.95436e-17
C16	a_29_368##6	Y#10	6.67976e-17
C17	VGND#4	a_1228_74##7	2.34428e-17
C18	a_474_368##2	B1#8	1.6306e-17
C19	A1#4	a_853_368##10	6.57862e-19
C20	VGND#12	VGND#11	2.23033e-18
C21	a_853_368#	A2#1	3.78798e-17
C22	C1#11	D1#2	3.66289e-18
C23	a_474_368##2	a_853_368##12	1.78583e-17
C24	Y#2	a_853_368##7	1.40033e-18
C25	a_474_368##2	B1#9	2.18539e-17
C26	VPWR#7	A2#1	4.4741e-17
C27	A1#5	VPWR#10	6.32316e-19
C28	a_853_368#	A2#10	1.1603e-18
C29	VGND#12	Y#1	5.41451e-17
C30	B1#2	B1#1	8.81379e-19
C31	a_853_368##8	A2#1	2.27487e-18
C32	a_474_368##3	C1#1	2.17911e-17
C33	a_853_368##5	VPWR#5	9.60456e-19
C34	A2#10	VPWR#7	2.25963e-17
C35	VPWR#8	A2#1	2.70458e-19
C36	a_474_368##2	a_474_368##5	9.1041e-20
C37	C1#3	C1#4	1.01455e-17
C38	a_474_368##2	C1#1	1.22908e-20
C39	Y#2	a_29_368#	1.4716e-17
C40	A1#4	VPWR#10	6.13865e-19
C41	A2#9	A2#8	3.9603e-17
C42	a_853_368#	A2#12	2.33468e-19
C43	a_853_368##8	A2#10	5.30329e-17
C44	C1#14	B1#9	5.77071e-19
C45	a_29_368#	B1#10	4.20733e-18
C46	VGND#4	Y#1	6.94285e-18
C47	VPWR#7	A2#12	6.87375e-19
C48	VPWR#8	A2#10	3.71489e-19
C49	a_474_368##3	C1#7	1.62778e-17
C50	VGND#6	VGND#12	1.52785e-18
C51	a_853_368##4	VPWR#5	3.13618e-19
C52	a_474_368##2	a_853_368##7	3.5169e-17
C53	a_853_368#	A2#13	1.42355e-19
C54	a_853_368##8	A2#12	4.65336e-17
C55	A2#11	A2#9	4.09562e-17
C56	C1#14	C1#1	1.69536e-18
C57	a_474_368##3	a_29_368#	3.53849e-17
C58	VPWR#7	A2#13	1.72497e-19
C59	A2#12	VPWR#8	2.21054e-17
C60	D1#8	D1#2	4.85845e-18
C61	VGND#12	VGND#4	1.23586e-18
C62	Y#5	B1#1	4.9289e-18
C63	a_853_368#	A1#7	9.41412e-20
C64	D1#4	C1#5	5.62475e-18
C65	a_1228_74##2	a_1228_74#	5.2354e-19
C66	a_853_368##8	A2#13	1.78193e-18
C67	a_853_368##9	A2#12	2.17848e-19
C68	VGND#13	VGND#12	2.28016e-18
C69	VGND#4	A1#5	4.13281e-20
C70	D1#4	C1#4	3.26062e-19
C71	a_29_368##2	C1#7	1.17764e-17
C72	a_1228_74##3	A1#2	1.28462e-19
C73	Y#3	C1#14	2.83472e-17
C74	a_853_368##4	VPWR#4	3.13618e-19
C75	VPWR#8	A2#13	4.28625e-17
C76	D1#4	D1#8	4.44469e-17
C77	C1#14	C1#7	1.8704e-18
C78	a_474_368##3	a_474_368##6	8.78465e-20
C79	A2#7	A2#11	3.97309e-17
C80	a_853_368##8	A1#7	2.04886e-19
C81	D1#4	D1#2	1.80754e-17
C82	A2#13	a_853_368##9	2.14149e-17
C83	a_1228_74##3	a_853_368##3	3.77794e-18
C84	a_1228_74##2	VGND#9	2.12919e-17
C85	a_29_368##2	C1#9	1.17076e-17
C86	VPWR#8	A1#7	1.65292e-18
C87	Y#4	a_29_368##3	4.43878e-18
C88	VPWR#9	A2#13	2.12694e-18
C89	a_474_368##6	a_474_368##2	4.50401e-20
C90	Y#2	C1#14	1.99852e-17
C91	Y#11	A1#4	2.30493e-18
C92	A1#5	A1#4	4.0818e-18
C93	a_853_368##3	VPWR#4	3.13618e-19
C94	A1#7	a_853_368##9	2.61267e-17
C95	a_474_368##3	a_29_368##7	2.17357e-17
C96	a_853_368##10	A2#13	9.62907e-20
C97	A1#1	A2#7	4.09007e-17
C98	Y#3	a_29_368##3	3.38547e-18
C99	VPWR#9	A1#7	5.22195e-17
C100	Y#9	a_29_368##8	8.67282e-18
C101	Y#11	A1#2	1.45411e-18
C102	a_1228_74##2	a_1228_74##8	1.24483e-18
C103	a_29_368##2	a_474_368##3	5.00315e-19
C104	a_853_368##9	A1#9	2.23229e-19
C105	a_853_368##10	A1#7	2.23229e-19
C106	VPWR#3	VPWR#5	2.65937e-17
C107	Y#9	D1#10	2.34674e-17
C108	Y#8	VGND#13	2.9889e-17
C109	Y#5	a_853_368##5	9.50291e-18
C110	VPWR#3	VPWR#4	5.51579e-17
C111	VPWR#9	A1#9	4.57251e-17
C112	A1#8	A1#1	4.04988e-17
C113	VGND#6	Y#8	5.61019e-18
C114	C1#14	a_29_368#	1.1869e-17
C115	a_853_368##9	A1#11	9.62907e-20
C116	A1#9	a_853_368##10	2.14335e-17
C117	Y#9	Y#10	3.95309e-20
C118	a_29_368##2	a_474_368##6	1.77118e-17
C119	a_1228_74##5	A1#4	1.12779e-18
C120	C1#11	C1#10	2.15157e-18
C121	a_1228_74##2	VGND#10	2.25094e-17
C122	VGND#14	VGND#13	1.67692e-18
C123	VPWR#9	A1#11	2.13205e-18
C124	VPWR#10	A1#9	2.52395e-18
C125	Y#3	C1#11	4.58536e-17
C126	Y#9	D1#9	1.73434e-17
C127	a_29_368##5	D1#7	1.61105e-17
C128	a_1228_74##2	A2#8	1.95034e-19
C129	VGND#4	A1#12	3.9076e-18
C130	A1#11	a_853_368##10	2.61267e-17
C131	A1#10	A1#8	4.13259e-17
C132	VPWR#3	a_853_368##4	3.04277e-18
C133	a_853_368##11	A1#9	9.62907e-20
C134	VGND#4	B1#6	5.16869e-20
C135	a_853_368##3	VPWR#3	3.31787e-18
C136	C1#4	B1#9	3.49797e-20
C137	a_29_368##2	a_29_368##7	2.1195e-18
C138	VGND#14	Y#8	2.98694e-17
C139	a_1228_74##5	A1#2	1.59417e-19
C140	VPWR#10	A1#11	5.19665e-17
C141	Y#9	a_29_368##6	2.52959e-18
C142	C1#11	D1#1	1.10036e-18
C143	a_853_368##2	VPWR#3	3.49181e-18
C144	Y#5	A1#5	3.05635e-18
C145	a_1228_74##3	a_1228_74##2	5.06977e-19
C146	a_853_368##10	A1#6	2.23229e-19
C147	a_853_368##11	A1#11	2.23229e-19
C148	a_29_368##5	D1#10	1.83149e-17
C149	a_1228_74##2	A2#9	1.70268e-17
C150	A1#12	A1#10	4.00207e-17
C151	VPWR#10	A1#6	4.57094e-17
C152	a_853_368##5	a_853_368##4	8.32696e-19
C153	VGND#4	B1#7	5.09783e-18
C154	B1#2	a_474_368#	1.22514e-18
C155	a_29_368##2	a_474_368##4	1.8773e-17
C156	a_853_368##10	B1#1	9.62907e-20
C157	A1#6	a_853_368##11	2.14335e-17
C158	Y#5	A1#4	3.32828e-18
C159	A1#4	A1#2	4.0818e-18
C160	B1#6	A1#5	2.66524e-19
C161	VPWR#10	B1#1	2.34878e-18
C162	a_474_368#	A1#6	2.18289e-18
C163	VGND#6	C1#5	6.03681e-20
C164	a_1228_74##2	A2#11	1.69132e-17
C165	B1#7	A1#12	6.09463e-19
C166	a_29_368##5	Y#12	2.34693e-17
C167	B1#1	a_853_368##11	2.61255e-17
C168	a_853_368##12	A1#6	2.4535e-19
C169	VGND#6	Y#4	3.87788e-19
C170	VGND#3	a_1228_74##2	4.36192e-18
C171	VGND#4	B1#10	9.63666e-19
C172	VPWR#10	B1#4	2.65252e-19
C173	a_474_368#	B1#1	5.25175e-17
C174	a_1228_74##7	A1#5	4.18928e-19
C175	VGND#4	B1#2	6.69539e-19
C176	a_853_368##11	B1#4	2.22475e-19
C177	a_853_368##12	B1#1	5.88871e-19
C178	B1#10	B1#7	4.01953e-17
C179	a_29_368##5	a_29_368##8	5.47123e-20
C180	a_1228_74##2	A2#7	9.24914e-20
C181	B1#2	a_853_368##12	2.19287e-20
C182	a_474_368#	B1#4	5.39554e-17
C183	VPWR#10	B1#8	7.33399e-20
C184	Y#9	D1#8	5.38701e-18
C185	C1#11	D1#9	3.18515e-19
C186	C1#14	a_29_368##2	3.60176e-17
C187	a_1228_74##7	A1#4	1.43977e-19
C188	VGND#6	Y#3	7.36548e-18
C189	a_853_368##4	a_853_368##3	8.32696e-19
C190	a_853_368#	VPWR#7	5.44097e-17
C191	B1#4	a_853_368##12	2.42892e-17
C192	a_853_368##11	B1#8	9.57069e-20
C193	VGND#4	C1#8	5.12439e-20
C194	B1#6	a_474_368##5	5.95253e-19
C195	a_474_368#	B1#8	1.32799e-18
C196	a_474_368##5	B1#4	1.58531e-18
C197	VPWR#10	B1#9	4.59545e-20
C198	a_29_368#	B1#1	2.14401e-19
C199	C1#8	B1#10	1.80059e-18
C200	a_29_368##5	Y#10	1.65321e-17
C201	C1#4	C1#7	3.50884e-19
C202	B1#8	a_853_368##12	2.76675e-17
C203	a_853_368##7	B1#4	2.619e-19
C204	a_1228_74##2	A1#1	3.90164e-20
C205	a_853_368##8	a_853_368#	2.54679e-18
C206	B1#10	B1#6	3.20043e-18
C207	VGND#6	C1#6	1.22302e-18
C208	Y#2	B1#6	1.29853e-17
C209	a_474_368##5	B1#8	4.27646e-17
C210	a_29_368#	B1#4	3.29042e-19
C211	C1#11	a_29_368##3	1.88866e-17
C212	A2#4	a_853_368##3	2.37355e-17
C213	a_853_368##7	B1#8	6.15422e-19
C214	Y#5	B1#2	6.3099e-18
C215	a_853_368##12	B1#9	9.90034e-19
C216	C1#6	C1#8	3.93472e-17
C217	a_853_368##8	VPWR#7	5.29637e-17
C218	A2#4	a_853_368##2	9.1755e-17
C219	VGND#4	B1#3	6.99003e-19
C220	a_474_368##5	B1#9	3.78924e-17
C221	a_29_368#	B1#8	5.31671e-19
C222	a_474_368##3	VPWR#6	8.86517e-17
C223	VPWR#5	A1#4	2.32007e-20
C224	a_853_368##7	B1#9	4.48481e-17
C225	a_474_368##2	VPWR#6	5.92537e-17
C226	a_853_368##12	C1#1	8.21395e-20
C227	a_1228_74##2	A2#4	8.74853e-17
C228	B1#6	a_853_368##7	7.89192e-18
C229	VGND#6	D1#5	1.22302e-18
C230	VGND#4	Y#2	6.04619e-18
C231	Y#12	C1#11	4.32597e-18
C232	a_853_368##3	a_853_368##2	2.47229e-20
C233	Y#3	C1#5	2.8807e-18
C234	VPWR#8	VPWR#7	2.00319e-18
C235	a_29_368##5	VPWR#6	7.15277e-17
C236	a_853_368#	a_853_368##9	4.75919e-21
C237	VPWR#5	B1#3	2.15003e-20
C238	a_29_368#	B1#9	4.26221e-18
C239	D1#5	C1#6	3.7881e-17
C240	a_474_368##5	C1#1	4.50662e-19
C241	a_474_368##6	B1#9	4.62953e-19
C242	a_853_368##7	C1#1	1.39545e-18
C243	C1#4	B1#10	3.93805e-17
C244	C1#11	a_29_368##2	2.42176e-17
C245	VPWR#8	a_853_368##8	5.30395e-17
C246	a_29_368#	C1#1	6.23283e-17
C247	a_29_368##7	B1#9	8.21395e-20
C248	VGND#3	a_1228_74#	1.59218e-17
C249	a_853_368##6	B1#3	3.15645e-18
C250	Y#2	B1#2	8.77312e-19
C251	Y#3	C1#4	9.77852e-18
C252	D1#6	D1#5	3.89051e-17
C253	a_474_368##6	C1#1	4.29361e-17
C254	Y#4	D1#8	8.16341e-18
C255	VGND#3	a_1228_74##8	1.70999e-17
C256	VGND#11	B1#6	1.64791e-18
C257	a_29_368##7	C1#1	9.90034e-19
C258	a_29_368#	C1#7	1.99016e-18
C259	a_853_368##9	a_853_368##8	1.48337e-18
C260	VPWR#4	A1#4	2.01982e-20
C261	VGND#3	a_1228_74##3	4.1641e-17
C262	a_474_368##6	C1#7	3.77144e-17
C263	VGND#3	Y#11	5.75514e-18
C264	C1#7	a_29_368##7	2.42952e-17
C265	a_29_368#	C1#9	1.05383e-18
C266	VGND#3	a_1228_74##5	6.35618e-17
C267	C1#10	C1#4	2.31595e-19
C268	a_853_368##9	VPWR#8	5.11921e-17
C269	a_474_368##4	C1#7	1.29153e-18
C270	Y#12	C1#1	2.62969e-19
C271	VGND#3	Y#5	3.95536e-18
C272	a_474_368##6	C1#9	1.61512e-18
C273	VGND#6	D1#2	6.28723e-20
C274	VGND#3	a_1228_74##7	8.10825e-18
C275	a_29_368##3	C1#7	2.79543e-19
C276	a_474_368##3	B1#6	3.98949e-19
C277	C1#9	a_29_368##7	2.76027e-17
C278	a_29_368#	C1#10	4.13585e-19
C279	A1	A2#6	9.98593e-18
C280	Y#2	C1#4	9.33643e-18
C281	Y#12	C1#7	2.97978e-19
C282	a_474_368##4	C1#9	5.90379e-17
C283	VPWR#9	VPWR#8	2.66815e-18
C284	a_29_368##3	C1#9	2.12798e-18
C285	A1	A1#5	1.27138e-17
C286	Y#2	B1#3	8.09642e-18
C287	a_29_368##7	C1#10	5.71993e-19
C288	Y#4	D1#2	1.36549e-18
C289	A1	A1#4	3.72815e-17
C290	a_29_368#	D1#1	1.22019e-19
C291	A1	A1#2	1.95584e-17
C292	Y#12	C1#9	3.79893e-19
C293	a_1228_74#	A2#4	2.03493e-17
C294	C1#10	a_474_368##4	2.27733e-17
C295	VPWR#3	a_853_368#	1.65872e-17
C296	A2#10	A2#1	4.67863e-17
C297	VPWR#9	a_853_368##9	5.20507e-17
C298	a_474_368##2	B1#3	1.5452e-19
C299	D1#1	C1#5	3.08613e-18
C300	a_29_368##3	C1#10	7.36861e-17
C301	a_853_368##8	VPWR#3	2.57065e-17
C302	Y#3	C1#3	1.99852e-17
C303	Y#12	C1#10	5.12517e-19
C304	a_1228_74##3	A2#4	1.80254e-17
C305	VGND#3	a_853_368#	6.4426e-18
C306	a_853_368##10	a_853_368##9	1.21858e-18
C307	a_29_368#	C1#4	4.37194e-19
C308	a_29_368##3	D1#1	7.35922e-17
C309	A2#12	A2#10	4.58732e-17
C310	VPWR#5	B1#2	2.43771e-20
C311	a_853_368##9	VPWR#3	1.73584e-17
C312	a_474_368##2	B1#6	1.37957e-18
C313	D1#8	D1#1	3.00363e-18
C314	D1#4	Y#9	5.34346e-17
C315	VPWR#3	VPWR#9	2.18645e-17
C316	D1#1	Y#12	2.26571e-17
C317	a_1228_74#	A2#8	3.09495e-17
C318	VPWR#3	a_853_368##10	1.21533e-17
C319	Y#4	D1#4	9.89855e-17
C320	a_29_368##8	D1#1	6.0816e-19
C321	a_853_368##9	VPWR#4	5.25459e-18
C322	a_29_368##3	D1#7	2.29791e-18
C323	VGND#12	B1#6	4.37525e-20
C324	a_853_368##10	VPWR#9	5.21059e-17
C325	Y#3	D1#2	8.30567e-19
C326	VPWR#3	VPWR#10	1.04919e-17
C327	B1	A1#5	6.93786e-18
C328	A2#13	A2#12	4.70164e-17
C329	C1#3	a_29_368##2	2.12376e-17
C330	Y#12	D1#7	5.27572e-17
C331	VGND#9	A2#8	2.95713e-17
C332	B1	B1#6	3.00176e-17
C333	D1#7	a_29_368##8	2.31163e-17
C334	B1	B1#2	1.69261e-17
C335	a_29_368##3	D1#10	3.46651e-19
C336	a_853_368##2	a_853_368#	2.54679e-20
C337	a_1228_74#	A2#9	8.48022e-19
C338	B1	C1#4	5.24947e-18
C339	VPWR#10	VPWR#9	2.06267e-18
C340	Y#10	D1#7	2.68226e-18
C341	Y#12	D1#10	2.01088e-18
C342	D1#4	a_29_368##5	6.61875e-19
C343	a_1228_74##8	A2#8	6.43198e-19
C344	A1#7	A2#13	4.77507e-17
C345	D1#2	C1#6	1.89375e-18
C346	a_29_368##6	D1#7	3.00902e-19
C347	Y#2	VGND#11	3.4642e-17
C348	D1#10	a_29_368##8	2.78893e-17
C349	Y#2	B1#7	2.18182e-17
C350	VGND#9	A2#9	2.83665e-17
C351	C1#4	a_474_368##6	1.38568e-18
C352	Y#3	Y#1	9.46649e-19
C353	Y#10	D1#10	5.15332e-17
C354	VPWR#10	a_853_368##10	5.20507e-17
C355	A2#4	a_853_368#	1.04334e-17
C356	a_1228_74#	A2#11	1.87602e-19
C357	a_474_368##3	C1#4	1.61104e-19
C358	a_29_368##6	D1#10	1.30694e-18
C359	a_853_368##10	VPWR#5	5.25459e-18
C360	a_29_368##8	D1#9	1.29161e-18
C361	Y#3	B1#10	7.18159e-19
C362	a_853_368##2	VPWR#7	2.29828e-17
C363	A1#9	A1#7	4.65863e-17
C364	A2#9	a_1228_74##8	1.38198e-17
C365	D1#4	C1#11	1.84941e-17
C366	Y#10	D1#9	4.63842e-17
C367	a_853_368##3	a_853_368##8	9.64192e-19
C368	VGND#9	A2#11	1.37067e-18
C369	Y#2	Y#1	9.42743e-19
C370	a_853_368##11	a_853_368##10	1.21858e-18
C371	a_29_368##6	D1#9	4.38222e-17
C372	Y#2	B1#10	3.34057e-17
C373	VGND#10	A2#9	1.37067e-18
C374	a_853_368##10	VPWR#4	5.20514e-18
C375	Y#3	VGND#12	1.01362e-16
C376	VGND#12	C1#5	8.6615e-21
C377	A1#11	A1#9	4.77579e-17
C378	a_853_368##3	A2#6	4.22779e-19
C379	a_474_368##2	VPWR#5	2.75353e-17
C380	A2#11	a_1228_74##8	1.72195e-17
C381	Y#3	C1#8	4.57084e-17
C382	a_853_368##2	a_853_368##8	1.34628e-18
C383	a_1228_74##3	A2#9	1.67688e-19
C384	a_853_368##11	VPWR#10	5.21059e-17
C385	C1#4	a_29_368##7	5.44564e-19
C386	a_853_368##5	A1#5	8.71697e-19
C387	Y#2	VGND#12	4.88354e-17
C388	a_474_368##3	B1#10	1.84052e-18
C389	VGND#10	A2#11	3.27157e-17
C390	Y#2	C1#8	3.67326e-19
C391	a_853_368##3	VPWR#8	1.20413e-17
C392	A1#6	A1#11	4.65863e-17
C393	D1#10	D1#8	2.59382e-18
C394	VGND#12	C1#4	6.74248e-18
C395	Y#3	Y#7	2.67707e-18
C396	a_474_368##4	VPWR#6	3.8216e-17
C397	a_1228_74##8	A2#7	3.05025e-19
C398	a_474_368#	VPWR#10	3.7323e-18
C399	Y#4	VGND#13	1.70048e-17
C400	a_29_368##3	VPWR#6	4.09615e-17
C401	a_1228_74##3	A2#11	3.97516e-19
C402	a_1228_74#	VGND#9	4.90368e-17
C403	Y#3	C1#6	2.90625e-17
C404	B1#1	A1#6	4.77191e-17
C405	a_853_368##2	VPWR#8	1.30848e-17
C406	a_853_368##11	VPWR#5	1.05092e-17
C407	VGND#10	A2#7	2.82474e-17
C408	a_853_368##2	A2#1	1.02058e-20
C409	VGND#3	A2#8	1.4927e-18
C410	a_474_368#	a_853_368##11	5.32396e-17
C411	C1#4	B1#6	3.42801e-19
C412	VGND#3	A2#9	1.60764e-18
C413	a_853_368##3	a_853_368##9	4.94619e-18
C414	Y#4	D1#5	1.39468e-17
C415	C1#5	a_474_368##4	6.52285e-19
C416	Y#3	VGND#13	4.54395e-17
C417	a_1228_74##8	A1#1	1.28671e-19
C418	a_29_368##6	VPWR#6	5.04188e-17
C419	a_853_368##2	A2#6	4.91425e-19
C420	VGND#3	A2#11	6.12277e-18
C421	a_1228_74##3	A2#7	3.06142e-17
C422	Y#4	Y#8	1.68389e-18
C423	a_474_368#	B1#3	8.01215e-21
C424	B1#4	B1#1	4.60841e-17
C425	a_853_368##6	B1#6	3.7564e-19
C426	a_1228_74##8	a_1228_74#	1.72657e-18
C427	a_853_368##4	VPWR#9	1.56403e-17
C428	VGND#3	A2#7	6.07969e-18
C429	Y#3	D1#5	1.36411e-18
C430	B1#3	a_853_368##12	5.22635e-19
C431	a_853_368##12	a_853_368##11	1.30433e-18
C432	VGND#10	A1#1	1.43332e-18
C433	C1#4	a_474_368##4	5.15841e-19
C434	B1#3	a_474_368##5	6.01877e-19
C435	VGND#3	A1#1	7.00804e-18
C436	D1#9	D1#8	7.56504e-18
C437	Y#11	A2#7	9.35087e-19
C438	a_474_368#	VPWR#5	4.04107e-17
C439	a_853_368##2	A2#10	1.69072e-17
C440	VGND#3	A1#8	6.54204e-18
C441	B1#8	B1#4	4.69614e-17
C442	Y#4	D1#6	1.92306e-17
C443	Y#8	Y#3	3.28605e-18
C444	VGND#3	A1#10	6.34723e-18
C445	a_853_368##3	VPWR#9	1.55915e-17
C446	a_1228_74##3	A1#1	3.76376e-17
C447	C1#14	B1#10	5.84834e-18
C448	a_1228_74##8	VGND#9	4.16102e-17
C449	a_474_368#	a_853_368##12	4.76905e-17
C450	a_853_368##2	A2#5	4.68619e-18
C451	VGND#3	A1#12	1.94311e-18
C452	a_1228_74##5	A2#7	1.74501e-19
C453	Y#4	VGND#14	3.52082e-17
C454	VPWR#4	A1#7	1.83922e-18
C455	Y#3	D1#6	8.6942e-19
C456	VGND#10	A1#8	2.90512e-19
C457	a_853_368##4	a_853_368##10	3.80666e-18
C458	a_853_368##3	A2#12	1.45232e-19
C459	B1#9	B1#8	4.60448e-17
C460	Y#11	A1#1	3.06805e-17
C461	VPWR#3	A2#5	2.04712e-20
C462	A1	a_853_368##5	2.3602e-17
C463	a_853_368##4	A1#4	4.72169e-18
C464	a_29_368##3	C1#5	3.06159e-18
C465	Y	C1#5	4.97386e-19
C466	A1	a_853_368##4	7.39238e-17
C467	a_474_368##5	a_474_368#	3.25667e-18
C468	a_853_368##5	VPWR#10	1.56403e-17
C469	a_853_368##2	A2#12	1.69953e-17
C470	a_1228_74##3	A1#8	6.91211e-19
C471	A1	a_853_368##3	4.79176e-17
C472	Y	D1#8	2.40701e-17
C473	VGND#10	VGND#9	1.66094e-18
C474	a_853_368##6	a_474_368##2	5.00315e-19
C475	a_1228_74##5	A1#1	4.21666e-19
C476	Y	D1#2	8.89196e-20
C477	VPWR#6	B1#10	1.28605e-19
C478	a_853_368##4	A2#13	6.57987e-20
C479	C1#1	B1#9	5.31267e-18
C480	VGND#10	A1#10	1.55626e-19
C481	Y#11	A1#8	3.77038e-17
C482	a_474_368##5	a_853_368##12	4.05815e-17
C483	a_853_368##6	B1#2	1.1837e-18
C484	A2#5	VPWR#7	6.47602e-19
C485	VPWR#3	A2#1	2.06273e-18
C486	a_853_368##4	VPWR#10	1.55938e-17
C487	VPWR#4	A1#9	1.83922e-18
C488	a_853_368##3	A2#13	1.75683e-17
C489	C1#14	B1#6	1.76528e-19
C490	a_1228_74##3	A1#10	3.74243e-19
C491	B1	a_853_368##6	7.86966e-17
C492	VPWR#3	A2#10	1.08087e-18
C493	D1#4	a_29_368##3	1.05838e-18
C494	C1#7	C1#1	4.77871e-17
C495	a_29_368##5	D1#8	1.51461e-19
C496	B1	a_853_368##5	3.02292e-17
C497	VGND#10	a_1228_74##8	4.15829e-17
C498	a_1228_74##5	A1#8	3.4156e-17
C499	D1#4	Y#12	4.73675e-17
C500	a_853_368##2	A2#13	5.3297e-21
C501	a_853_368##5	a_853_368##11	6.82094e-18
C502	VPWR#3	A2#12	5.95549e-18
C503	VGND#10	A1#12	1.49876e-19
C504	a_853_368##7	a_853_368##12	3.234e-18
C505	a_29_368#	a_474_368#	1.09711e-20
C506	VPWR#3	A2#13	5.86785e-18
C507	Y#11	A1#10	8.62185e-19
C508	a_853_368##4	A1#7	1.5254e-19
C509	VPWR#5	A1#11	1.83922e-18
C510	a_853_368##2	A2#2	8.60074e-19
C511	C1#9	C1#7	4.78429e-17
C512	Y#5	A1#8	1.40246e-18
C513	a_853_368##6	a_474_368#	1.62761e-17
C514	VPWR#3	A1#7	1.54844e-18
C515	VGND#3	A2#5	3.85385e-20
C516	a_1228_74##3	A1#12	2.85186e-19
C517	a_29_368##2	C1#5	5.72376e-19
C518	Y#12	C1#5	6.00881e-19
C519	a_853_368##3	A1#7	1.38715e-17
C520	VPWR#3	A1#9	1.09837e-18
C521	a_1228_74##3	a_1228_74##8	1.67195e-18
C522	a_1228_74##5	A1#10	3.4497e-17
C523	a_853_368##7	a_474_368##5	5.26679e-17
C524	VPWR#3	A1#11	1.15118e-18
C525	Y#2	B1	1.05345e-16
C526	a_1228_74##7	A1#8	1.83404e-19
C527	C1#10	C1#9	4.74035e-17
C528	A2#2	VPWR#7	6.23885e-19
C529	a_853_368##5	A1#9	6.57987e-20
C530	a_853_368##2	A1#7	2.06956e-21
C531	a_853_368##5	a_474_368#	1.30857e-17
C532	A2#4	A2#1	3.26719e-18
C533	VGND#3	A1#5	1.13348e-20
C534	Y#5	A1#10	3.83852e-17
C535	VGND#4	B1#1	4.55214e-19
C536	a_1228_74##3	A1	3.00558e-17
C537	a_853_368##5	B1#2	7.73081e-19
C538	A2#4	A2#10	2.04648e-18
C539	a_853_368##4	A1#9	1.39949e-17
C540	VGND#3	A1#4	1.72375e-19
C541	Y#11	A1	4.22022e-17
C542	A2#5	a_853_368##8	6.21314e-19
C543	C1#14	B1	1.3753e-17
C544	VPWR#5	A1#6	1.83922e-18
C545	D1#1	C1#10	5.04077e-17
C546	a_853_368##6	a_853_368##12	2.8911e-18
C547	a_29_368##2	C1#4	4.51936e-18
C548	A2#4	A2#12	2.0582e-18
C549	a_1228_74##5	A1#12	8.53829e-19
C550	a_1228_74##3	VGND#10	5.1521e-17
C551	A2#6	A2#5	4.0818e-18
C552	Y#5	A1	6.44621e-17
C553	VGND#3	A1#2	4.22022e-20
C554	a_1228_74##7	A1#10	8.21817e-19
C555	a_29_368##5	D1#2	8.57225e-20
C556	a_853_368##3	A1#2	8.93875e-19
C557	a_853_368##3	A1#9	1.5254e-19
C558	A2#4	A2#13	2.44232e-18
C559	D1#4	B1#10	6.55955e-19
C560	A2#4	A1#7	4.20429e-19
C561	a_29_368#	a_853_368##7	6.54031e-17
C562	D1#7	D1#1	4.67789e-17
C563	Y#5	A1#12	4.57561e-17
C564	a_474_368##6	a_474_368##5	1.65147e-18
C565	D1#4	C1#8	8.89261e-19
C566	a_853_368##5	A1#11	1.5254e-19
C567	a_853_368##12	a_853_368##5	1.64129e-18
C568	VGND#11	A1#10	1.85148e-19
C569	D1#4	C1#6	1.87639e-18
C570	Y#12	D1#8	9.387e-18
C571	C1#5	C1#4	3.26682e-18
C572	Y#5	B1	6.11956e-17
C573	a_853_368##4	A1#11	1.38715e-17
C574	a_1228_74##7	A1#12	4.32782e-17
C575	D1#10	D1#7	4.71276e-17
C576	VGND	D1#8	8.8001e-19
C577	VPWR#6	B1#9	4.4526e-18
C578	A2#6	VPWR#8	6.29318e-19
C579	VPWR#5	B1#1	5.09634e-18
C580	a_853_368##6	a_474_368##5	1.85887e-17
C581	VGND	D1#2	3.13262e-19
C582	VPWR#6	C1#1	4.42473e-18
C583	a_853_368##3	A1#11	6.57987e-20
C584	Y#5	B1#7	1.08118e-18
C585	a_1228_74##2	A2#6	1.60237e-18
C586	D1#8	Y#8	4.32883e-19
C587	VGND#11	A1#12	2.49051e-18
C588	VPWR#6	C1#7	4.42473e-18
C589	D1#9	D1#10	4.79179e-17
C590	a_853_368##5	A1#6	1.66235e-17
C591	VPWR#6	C1#9	4.46348e-18
C592	a_1228_74##3	Y#11	4.73427e-17
C593	a_29_368#	a_474_368##6	5.21057e-17
C594	a_1228_74##7	B1#7	1.30851e-18
C595	A2#5	VPWR#8	6.13865e-19
C596	C1#14	C1#4	2.80811e-17
C597	VPWR#6	C1#10	5.42649e-18
C598	Y#12	D1#2	1.56426e-18
C599	a_853_368##4	A1#6	1.5254e-19
C600	Y	Y#9	2.63508e-18
C601	VPWR#6	D1#1	4.47251e-18
C602	VPWR#6	B1#6	6.79943e-20
C603	VPWR#5	B1#4	4.4526e-18
C604	VGND#11	B1#7	4.42234e-17
C605	VPWR#6	D1#7	4.43427e-18
C606	a_29_368##7	a_29_368#	3.234e-18
C607	a_1228_74##2	A2#5	6.15561e-18
C608	A2#6	VNB	2.45492e-17
C609	VPWR	VPWR#5	9.52148e-17
C610	VPWR#6	D1#10	4.46319e-18
C611	A2#5	VNB	5.57282e-17
C612	B1	a_853_368##7	4.7651e-17
C613	a_1228_74##5	a_1228_74##3	7.50209e-19
C614	A2#2	VNB	3.99247e-17
C615	A1#5	VNB	2.8137e-17
C616	a_29_368##8	D1#8	7.33605e-19
C617	A1#4	VNB	5.60725e-17
C618	A1#2	VNB	2.66054e-17
C619	VPWR	a_853_368##6	2.29692e-18
C620	B1#6	VNB	5.77087e-17
C621	VPWR#6	D1#9	4.4804e-18
C622	VPWR	a_853_368##5	3.9557e-18
C623	B1#2	VNB	3.31182e-17
C624	B1#7	Y#1	1.30783e-17
C625	VPWR#6	C1#5	9.83787e-20
C626	C1#5	VNB	2.67264e-17
C627	VPWR	a_853_368##4	2.08472e-20
C628	a_853_368##5	B1#1	1.64638e-17
C629	C1#4	VNB	9.83988e-17
C630	D1#8	VNB	1.03681e-16
C631	D1#2	Y#8	4.55225e-19
C632	D1#2	VNB	2.38777e-17
C633	VPWR#6	C1#4	5.5536e-20
C634	a_29_368##7	a_474_368##6	4.05956e-17
C635	VGND#11	B1#10	1.8966e-18
C636	VPWR	Y#9	4.15817e-18
C637	a_853_368##4	B1#1	6.57987e-20
C638	D1#8	VGND#14	3.01474e-18
C639	VGND#12	B1#7	1.1184e-18
C640	VPWR#6	D1#8	1.28849e-19
C641	VPWR	a_474_368##3	3.98729e-17
C642	VPWR#5	B1#8	4.4526e-18
C643	Y#11	a_1228_74##5	3.55589e-17
C644	VPWR	a_474_368##2	3.88039e-17
C645	VGND	VGND#6	5.4172e-17
C646	VPWR	a_29_368##5	3.1708e-17
C647	VGND	VGND#4	1.65273e-16
C648	Y#1	B1#10	3.11159e-17
C649	a_853_368##6	B1#4	1.17764e-17
C650	VPWR	a_29_368##2	2.45443e-18
C651	VPWR#3	A2#4	8.8993e-18
C652	a_474_368##4	a_474_368##6	3.28832e-18
C653	VPWR	C1#14	3.55874e-18
C654	Y	VGND#13	1.19804e-20
C655	VPWR	C1#11	3.51951e-18
C656	VGND#3	A2#4	7.91697e-18
C657	VPWR#6	D1#2	2.86526e-20
C658	a_1228_74#	A2#2	4.25479e-19
C659	VGND#11	C1#8	7.27915e-20
C660	a_853_368##5	B1#4	2.79948e-19
C661	VGND#9	A2#5	7.19946e-19
C662	B1#10	VGND#12	2.95938e-17
C663	VGND	Y#9	4.093e-18
C664	a_474_368##4	a_29_368##7	4.40744e-17
C665	VGND	Y#4	7.90778e-18
C666	Y#5	Y#11	2.43605e-18
C667	VGND	Y#3	2.02947e-17
C668	a_1228_74##3	a_1228_74##7	2.30928e-20
C669	VGND	Y#2	1.51181e-17
C670	Y#1	C1#8	2.88963e-19
C671	VPWR#6	B1#3	1.12044e-20
C672	A1	A2#13	8.6835e-19
C673	a_1228_74##2	A2#2	2.00907e-19
C674	A1	A1#7	2.0856e-18
C675	VGND	C1#14	3.17862e-18
C676	A2#4	A2#6	1.25033e-17
C677	A1	A1#9	2.09005e-18
C678	VGND	C1#11	2.86299e-18
C679	VGND#6	VNB	2.84196e-17
C680	a_853_368##6	B1#8	1.17253e-17
C681	A1	A1#11	2.1032e-18
C682	VGND#4	VNB	8.20924e-17
C683	A2#4	A2#5	3.66736e-17
C684	A1	A1#6	1.91759e-18
C685	C1#8	VGND#12	3.40201e-17
C686	a_29_368##3	a_29_368##7	3.59297e-18
C687	VPWR#5	VNB	6.35852e-17
C688	Y#12	a_474_368##6	1.98522e-20
C689	VPWR#4	VNB	2.69834e-17
C690	VPWR	VPWR#10	1.1261e-17
C691	A1	B1#1	5.51034e-18
C692	VPWR	a_853_368##11	1.21891e-17
C693	VGND#13	B1#10	7.35386e-20
C694	Y	a_29_368##6	2.48308e-17
C695	VPWR	a_474_368#	2.20807e-17
C696	VGND	Y#5	1.46658e-17
C697	VPWR	a_853_368##12	7.23312e-18
C698	a_853_368##5	B1#8	1.20431e-19
C699	VGND	a_1228_74##7	1.72052e-17
C700	a_1228_74##5	Y#5	3.64928e-17
C701	VGND	Y#1	1.49594e-17
C702	VPWR	a_853_368##7	9.09145e-18
C703	a_1228_74##2	VNB	1.68424e-18
C704	A2#4	A2#2	1.8552e-17
C705	VGND	VGND#12	1.74744e-16
C706	B1	A1#6	9.61827e-19
C707	VPWR	a_29_368#	1.00147e-17
C708	Y#9	VNB	1.71073e-18
C709	VGND	VGND#13	1.60961e-17
C710	B1	B1#1	1.20765e-17
C711	VGND	Y#8	1.18861e-17
C712	VPWR	a_29_368##7	7.23312e-18
C713	Y#4	VNB	4.03358e-18
C714	C1#8	Y#7	1.49662e-17
C715	Y#3	VNB	5.79056e-18
C716	VGND	VGND#14	1.62962e-17
C717	VPWR	a_474_368##4	1.81955e-17
C718	Y#2	VNB	2.03252e-17
C719	B1	B1#4	2.1032e-18
C720	VPWR	a_29_368##3	2.35384e-17
C721	a_474_368##3	VNB	9.53609e-18
C722	VPWR	Y#12	8.4999e-18
C723	a_474_368##2	VNB	1.00075e-17
C724	B1	B1#8	2.1032e-18
C725	a_29_368##3	a_474_368##4	6.8157e-17
C726	a_29_368##5	VNB	5.68151e-18
C727	VPWR	Y#10	8.92738e-18
C728	B1	B1#9	2.21575e-18
C729	C1#14	VNB	3.8687e-18
C730	VPWR	a_29_368##6	2.36568e-17
C731	B1	C1#1	8.82537e-19
C732	C1#11	VNB	2.68235e-18
C733	VGND#12	C1#6	6.07086e-19
C734	Y	C1#6	1.65451e-19
C735	a_1228_74#	VNB	4.53892e-17
C736	B1	C1#7	1.66337e-19
C737	VGND#9	VNB	1.3093e-18
C738	Y	D1#5	1.81035e-19
C739	a_1228_74##8	VNB	4.55126e-18
C740	A2#4	A1#2	4.80896e-18
C741	VGND#10	VNB	3.01253e-20
C742	Y	D1#6	1.21163e-18
C743	VGND#13	C1#8	2.17129e-18
C744	a_1228_74##3	VNB	6.10105e-18
C745	Y#11	VNB	5.15612e-19
C746	VGND#9	A2#2	7.25042e-20
C747	VGND	a_29_368#	4.23056e-18
C748	a_1228_74##5	VNB	4.28444e-18
C749	A2#5	A2#2	4.03955e-18
C750	Y#5	VNB	2.63134e-17
C751	a_1228_74##7	VNB	1.64728e-17
C752	VGND#11	VNB	1.46179e-17
C753	Y#1	VNB	2.37362e-18
C754	a_1228_74##7	a_1228_74##5	2.84193e-19
C755	VGND#12	VNB	5.9323e-17
C756	VGND	Y#12	3.27364e-18
C757	Y#8	VNB	5.34128e-18
C758	VGND#14	VNB	1.88578e-17
C759	C1#6	Y#7	3.42975e-18
C760	VPWR#3	A1	8.79388e-18
C761	a_853_368#	VNB	6.1349e-17
C762	VPWR#7	VNB	2.60465e-18
C763	a_853_368##8	VNB	2.1429e-18
C764	VPWR#8	VNB	4.09278e-19
C765	VGND#3	A1	8.15585e-18
C766	a_853_368##9	VNB	4.61348e-18
C767	Y#8	C1#8	4.50406e-19
C768	VPWR#9	VNB	2.18747e-19
C769	a_853_368##10	VNB	4.61348e-18
C770	VPWR#10	VNB	2.40309e-19
C771	a_29_368##6	D1#8	7.62562e-20
C772	a_853_368##11	VNB	4.62062e-18
C773	a_474_368#	VNB	2.57549e-18
C774	VGND	A1#12	1.98127e-18
C775	a_853_368##7	VNB	7.79016e-18
C776	VGND	B1#7	6.92164e-19
C777	a_29_368#	VNB	1.08033e-17
C778	A1	A2#4	4.27844e-17
C779	C1#11	C1#5	1.39417e-17
C780	VGND	B1#10	9.88977e-19
C781	a_474_368##4	VNB	2.5614e-18
C782	VGND#13	C1#6	3.1469e-17
C783	VGND	C1#6	1.04667e-18
C784	a_29_368##3	VNB	2.05313e-18
C785	VGND	D1#5	5.88656e-19
C786	Y#12	VNB	1.29503e-18
C787	VPWR	A1#6	1.28992e-18
C788	VGND	D1#6	5.5043e-19
C789	a_29_368##3	Y#12	6.658e-17
C790	VPWR	B1#1	2.50895e-18
C791	Y#10	VNB	3.90604e-18
C792	a_29_368##6	VNB	5.38509e-17
C793	VPWR	B1#4	1.4711e-18
C794	A2#8	VNB	3.04277e-17
C795	A2#9	VNB	2.51814e-17
C796	VPWR	B1#8	1.57704e-18
C797	A2#11	VNB	2.53967e-17
C798	VPWR	B1#9	1.60757e-18
C799	A2#7	VNB	2.53964e-17
C800	Y#5	a_1228_74##7	4.82287e-17
C801	A1#1	VNB	3.01411e-17
C802	B1	B1#3	1.9078e-17
C803	VPWR	C1#1	1.61599e-18
C804	A1#8	VNB	2.99018e-17
C805	A1#10	VNB	2.97888e-17
C806	VPWR	C1#7	1.58546e-18
C807	A1#12	VNB	4.1095e-17
C808	Y	D1#9	1.3825e-17
C809	VPWR	C1#9	1.57698e-18
C810	B1#7	VNB	2.86433e-17
C811	B1#10	VNB	5.0487e-17
C812	VPWR	C1#10	7.79937e-19
C813	C1#8	VNB	2.92789e-17
C814	Y#8	C1#6	1.17986e-18
C815	C1#6	VNB	2.50701e-17
C816	VPWR	D1#1	1.56033e-18
C817	D1#5	VNB	2.22821e-17
C818	VPWR	D1#7	1.65796e-18
C819	VGND#10	A2#6	5.05143e-19
C820	D1#6	VNB	3.53242e-17
C821	VPWR	D1#10	1.64246e-18
C822	A2#1	VNB	3.72084e-17
C823	A2#10	VNB	3.06236e-17
C824	VPWR	D1#9	2.42952e-18
C825	Y#3	Y#2	1.20337e-18
C826	A2#12	VNB	3.06234e-17
C827	A2#13	VNB	2.96106e-17
C828	A1#7	VNB	2.89498e-17
C829	a_29_368##8	a_29_368##3	4.14108e-18
C830	A1#9	VNB	2.86999e-17
C831	A1#11	VNB	2.89486e-17
C832	A1#6	VNB	2.99295e-17
C833	VPWR#5	VPWR#4	1.22366e-18
C834	VPWR	VPWR#6	2.68841e-16
C835	VGND#13	D1#5	2.82141e-17
C836	B1#1	VNB	5.75933e-17
C837	B1#4	VNB	3.20319e-17
C838	C1#11	C1#4	1.23166e-17
C839	B1#8	VNB	3.20987e-17
C840	B1#9	VNB	3.79042e-17
C841	C1#1	VNB	3.46679e-17
C842	Y	D1#4	5.54072e-17
C843	C1#7	VNB	3.22731e-17
C844	C1#9	VNB	3.13638e-17
C845	VGND	VGND#3	6.55283e-18
C846	C1#10	VNB	3.09218e-17
C847	D1#1	VNB	3.8421e-17
C848	VPWR	C1#3	1.50716e-18
C849	B1	A1	2.49429e-17
C850	D1#7	VNB	3.13575e-17
C851	VPWR	D1#4	8.28905e-18
C852	D1#10	VNB	3.51453e-17
C853	D1#9	VNB	5.58778e-17
C854	VPWR#3	VNB	1.95145e-16
C855	VGND#3	VNB	2.47675e-16
C856	VGND	C1#3	1.04373e-18
C857	VPWR#6	VNB	1.60987e-16
C858	VGND	D1#4	9.78871e-18
C859	D1#5	Y#8	1.62702e-17
C860	A2#4	VNB	2.98532e-17
C861	Y#12	a_29_368##8	5.81244e-17
C862	B1#3	VNB	3.69948e-17
C863	C1#3	VNB	1.97701e-18
C864	D1#4	VNB	1.52826e-17
C865	VPWR	A1	1.71099e-18
C866	VGND#10	A2#5	2.59788e-19
C867	VPWR	B1	1.19404e-17
C868	VGND	A1	1.42063e-18
C869	VGND	B1	1.07179e-17
C870	A1	VNB	1.48027e-17
C871	VPWR	Y	2.5717e-18
C872	VGND#13	D1#6	2.02621e-18
C873	B1	VNB	3.41596e-17
C874	VGND	Y	1.57604e-17
C875	a_1228_74#	a_853_368#	1.60165e-17
C876	Y	VNB	7.01456e-17
C877	VGND#14	D1#5	1.94127e-18
C878	VPWR	VNB	3.20334e-16
C879	VGND	VNB	3.0958e-16
C880	D1#2	C1#5	2.62171e-17
C881	Y#9	a_29_368##5	2.33033e-18
C882	VPWR#2	A2#12	5.45681e-19
C883	a_853_368##8	VPWR#2	8.43957e-18
C884	VGND#7	D1#8	1.93415e-18
C885	VGND#2	a_1228_74##8	5.19931e-18
C886	VGND#2	A2#9	5.3214e-18
C887	VGND#7	D1#6	1.23778e-18
C888	VGND#7	Y#8	5.6635e-18
C889	VGND#2	a_1228_74#	1.7841e-17
C890	VPWR#2	VNB	4.44215e-17
C891	VGND#7	Y#4	2.36153e-18
C892	a_853_368##2	VPWR#2	3.13618e-19
C893	VGND#2	A2#2	4.56785e-20
C894	VPWR#2	A2#10	5.37415e-18
C895	VGND#2	A2#5	3.58181e-20
C896	VGND#2	A2#11	9.71076e-19
C897	VPWR#2	A2#5	2.56572e-20
C898	VGND	VGND#7	1.08147e-16
C899	VPWR#2	A2#13	8.74044e-20
C900	VGND#3	VGND#2	1.02019e-16
C901	VGND#2	A2#8	5.36914e-18
C902	VGND#2	VNB	4.95183e-17
C903	VGND#7	D1#2	1.19378e-21
C904	VPWR#3	VPWR#2	9.14461e-17
C905	VGND#7	Y	1.02507e-17
C906	VPWR#2	A2#1	4.64543e-18
C907	a_853_368#	VPWR#2	1.78953e-17
C908	VGND#7	VGND#6	1.733e-18
C909	VGND#7	VNB	6.46446e-17
C910	VGND#2	a_1228_74##2	2.91756e-19
*
*
.ENDS sky130_fd_sc_hs__a2111oi_4
*
