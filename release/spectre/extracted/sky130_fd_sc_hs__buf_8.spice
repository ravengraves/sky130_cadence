* Extracted by Quantus, converted by sky130cad/quantus.py
*
*
*
*                       LINUX           Wed Nov 18 08:20:47 2026
*
*
*
*  PROGRAM  advgen
*
*  Name           : advgen - Quantus - (64-bit)
*  Version        : 25.1.0-p047
*  Build Date     : Thu Dec 11 23:20:30 PST 2025
*
*  HSPICE LIBRARY
*
*  OPERATING_TEMPERATURE 150
*  QRC_TECH_DIR <path>/tech
*
*
*

*
.SUBCKT sky130_fd_sc_hs__buf_8 VPB VNB VGND VPWR X A
*
*
*  caps2d version: 10
*
*
*       TRANSISTOR CARDS
*
*
XM5 a_27_74##30 A#7 VGND#13 VNB sky130_fd_pr__nfet_01v8_lvt l=0.15 w=0.74 ad=0.2109 as=0.2405 pd=2.05 ps=2.13
XM20 a_27_74##33 A#5 VGND#13 VNB sky130_fd_pr__nfet_01v8_lvt l=0.15 w=0.74 ad=0.2072 as=0.2405 pd=2.04 ps=2.13
XM2 VGND#12 A#4 a_27_74##33 VNB sky130_fd_pr__nfet_01v8_lvt l=0.15 w=0.74 ad=0.2072 as=0.2072 pd=2.04 ps=2.04
XM1 X#7 a_27_74##12 VGND#12 VNB sky130_fd_pr__nfet_01v8_lvt l=0.15 w=0.74 ad=0.2072 as=0.2072 pd=2.04 ps=2.04
XM9 X#7 a_27_74##25 VGND#11 VNB sky130_fd_pr__nfet_01v8_lvt l=0.15 w=0.74 ad=0.2072 as=0.259 pd=2.04 ps=2.18
XM6 VGND#11 a_27_74##23 X#14 VNB sky130_fd_pr__nfet_01v8_lvt l=0.15 w=0.74 ad=0.259 as=0.2072 pd=2.18 ps=2.04
XM13 VGND#10 a_27_74##20 X#14 VNB sky130_fd_pr__nfet_01v8_lvt l=0.15 w=0.74 ad=0.3108 as=0.2072 pd=2.32 ps=2.04
XM16 VGND#10 a_27_74##18 X#13 VNB sky130_fd_pr__nfet_01v8_lvt l=0.15 w=0.74 ad=0.3108 as=0.2072 pd=2.32 ps=2.04
XM18 X#13 a_27_74##16 VGND#9 VNB sky130_fd_pr__nfet_01v8_lvt l=0.15 w=0.74 ad=0.2072 as=0.3108 pd=2.04 ps=2.32
XM10 X#12 a_27_74##14 VGND#9 VNB sky130_fd_pr__nfet_01v8_lvt l=0.15 w=0.74 ad=0.2109 as=0.3108 pd=2.05 ps=2.32
XM4 VGND#1 a_27_74##13 X#12 VNB sky130_fd_pr__nfet_01v8_lvt l=0.15 w=0.74 ad=0.2627 as=0.2109 pd=2.19 ps=2.05
XM7 VPWR#13 A#9 a_27_74##32 VPB sky130_fd_pr__pfet_01v8 l=0.15 w=1.12 ad=0.336 as=0.3304 pd=2.84 ps=2.83
XM17 a_27_74##34 A#8 VPWR#13 VPB sky130_fd_pr__pfet_01v8 l=0.15 w=1.12 ad=0.336 as=0.336 pd=2.84 ps=2.84
XM21 a_27_74##34 A#1 VPWR#12 VPB sky130_fd_pr__pfet_01v8 l=0.15 w=1.12 ad=0.336 as=0.336 pd=2.84 ps=2.84
XM0 VPWR#12 a_27_74##26 X#9 VPB sky130_fd_pr__pfet_01v8 l=0.15 w=1.12 ad=0.336 as=0.392 pd=2.84 ps=2.94
XM3 X#9 a_27_74##24 VPWR#11 VPB sky130_fd_pr__pfet_01v8 l=0.15 w=1.12 ad=0.392 as=0.392 pd=2.94 ps=2.94
XM12 X#15 a_27_74##22 VPWR#11 VPB sky130_fd_pr__pfet_01v8 l=0.15 w=1.12 ad=0.336 as=0.392 pd=2.84 ps=2.94
XM11 VPWR#10 a_27_74##21 X#15 VPB sky130_fd_pr__pfet_01v8 l=0.15 w=1.12 ad=0.392 as=0.336 pd=2.94 ps=2.84
XM15 X#1 a_27_74##19 VPWR#10 VPB sky130_fd_pr__pfet_01v8 l=0.15 w=1.12 ad=0.336 as=0.392 pd=2.84 ps=2.94
XM14 VPWR#9 a_27_74##17 X#1 VPB sky130_fd_pr__pfet_01v8 l=0.15 w=1.12 ad=0.3752 as=0.336 pd=2.91 ps=2.84
XM19 VPWR#9 a_27_74##15 X#10 VPB sky130_fd_pr__pfet_01v8 l=0.15 w=1.12 ad=0.3752 as=0.3528 pd=2.91 ps=2.87
XM8 X#10 a_27_74# VPWR#1 VPB sky130_fd_pr__pfet_01v8 l=0.15 w=1.12 ad=0.3528 as=0.3304 pd=2.87 ps=2.83
*
*
*       RESISTOR AND CAP/DIODE CARDS
*
Rg1	A#1	A#2	449.655212
Rg2	A#2	A#3	73.670235
Rg3	A#2	A#4	397.555725
Rg4	A#3	A#5	378.670319
Rg5	A#3	A#6	64.081955
Rg6	A#6	A#7	397.555725
Rg7	A#3	A#8	429.126801
Rg8	A#6	A#9	449.655212
Rg9	a_27_74#	a_27_74##2	471.862823
Rg10	a_27_74##2	a_27_74##3	69.322823
Rg11	a_27_74##3	a_27_74##4	89.891396
Rg12	a_27_74##4	a_27_74##5	74.621574
Rg13	a_27_74##5	a_27_74##6	90.259354
Rg14	a_27_74##6	a_27_74##7	67.261230
Rg15	a_27_74##7	a_27_74##8	26.827145
Rg16	a_27_74##8	a_27_74##9	60.792149
Rg17	a_27_74##9	a_27_74##10	26.827145
Rg18	a_27_74##10	a_27_74##11	53.084805
Rg19	a_27_74##11	a_27_74##12	367.525269
Rg20	a_27_74##2	a_27_74##13	368.862610
Rg21	a_27_74##3	a_27_74##14	365.868195
Rg22	a_27_74##3	a_27_74##15	468.868408
Rg23	a_27_74##4	a_27_74##16	442.169952
Rg24	a_27_74##4	a_27_74##17	485.209564
Rg25	a_27_74##5	a_27_74##18	418.708130
Rg26	a_27_74##5	a_27_74##19	461.747772
Rg27	a_27_74##6	a_27_74##20	352.592896
Rg28	a_27_74##6	a_27_74##21	455.593079
Rg29	a_27_74##7	a_27_74##22	407.365845
Rg30	a_27_74##8	a_27_74##23	372.745422
Rg31	a_27_74##9	a_27_74##24	407.365845
Rg32	a_27_74##10	a_27_74##25	372.745422
Rg33	a_27_74##11	a_27_74##26	471.279327
Rf1	A	A#10	8.404075
Rf2	A#10	A	6.264856
Rf3	a_27_74##6	a_27_74##28	77.267906
Rf4	a_27_74##28	a_27_74##29	58.863873
Rf5	a_27_74##29	a_27_74##30	89.445404
Rf6	a_27_74##28	a_27_74##31	73.351395
Rf7	a_27_74##31	a_27_74##32	81.107391
Rf8	a_27_74##29	a_27_74##33	28.306047
Rf9	a_27_74##31	a_27_74##34	18.602406
Rf10	X#1	X#2	21.947609
Rf11	X#2	X#3	60.658752
Rf12	X#3	X#4	59.731056
Rf13	X#4	X#5	64.311272
Rf14	X#5	X#6	73.001427
Rf15	X#6	X#7	92.929268
Rf16	X#2	X#8	69.348907
Rf17	X#8	X#9	88.106133
Rf18	X#3	X	6.423806
Rf19	X	X#11	14.164948
Rf20	X#11	X	0.194040
Rf21	X#4	X#12	19.939056
Rf22	X#5	X#13	16.181496
Rf23	X#6	X#14	16.181496
Rf24	X#8	X#15	21.948624
Rf25	X#10	X#11	5.000000
Rf26	VGND#1	VGND#2	103.041039
Rf27	VGND#2	VGND#3	73.001427
Rf28	VGND#3	VGND#4	43.440514
Rf29	VGND#4	VGND#5	29.560919
Rf30	VGND#5	VGND#6	62.774361
Rf31	VGND#6	VGND#7	66.061630
Rf33	VGND#2	VGND#9	36.279022
Rf34	VGND#3	VGND#10	36.279022
Rf35	VGND#5	VGND#11	36.279022
Rf36	VGND#6	VGND#12	38.247387
Rf37	VGND#7	VGND#13	38.247387
Rf38	VPWR#1	VPWR#2	116.372597
Rf39	VPWR#2	VPWR#3	69.463600
Rf40	VPWR#3	VPWR#4	50.802910
Rf41	VPWR#4	VPWR#5	18.660692
Rf42	VPWR#5	VPWR#6	69.463600
Rf43	VPWR#6	VPWR#7	68.798325
Rf45	VPWR#2	VPWR#9	42.573776
Rf46	VPWR#3	VPWR#10	42.573776
Rf47	VPWR#5	VPWR#11	42.573776
Rf48	VPWR#6	VPWR#12	38.736572
Rf49	VPWR#7	VPWR#13	53.143215
Rf50	A#3	A#10	53.410934
Re1	VPWR#4	VPWR	0.818510
Re2	VGND	VGND#4	0.818540
*
*       CAPACITOR CARDS
*
*
C1	X#6	a_27_74##25	1.23647e-18
C2	VGND#1	a_27_74##14	1.35644e-18
C3	VGND	VNB	6.19321e-17
C4	VPWR	VNB	7.37421e-17
C5	X	VNB	3.19972e-18
C6	A	VNB	3.58241e-17
C7	A#3	VNB	3.18259e-17
C8	VGND	A	7.84316e-18
C9	a_27_74##6	VNB	4.19801e-17
C10	VPWR	X	1.67654e-17
C11	VGND#4	VNB	2.4583e-16
C12	a_27_74##28	X#3	4.12843e-17
C13	VPWR#4	VNB	2.46283e-16
C14	VPWR	A	7.3548e-18
C15	a_27_74##13	X#12	1.5623e-17
C16	A#9	VNB	4.38433e-17
C17	A#8	VNB	3.19663e-17
C18	VGND	a_27_74##6	7.14291e-20
C19	A#1	VNB	3.15055e-17
C20	VGND	VGND#4	8.6737e-18
C21	a_27_74##26	VNB	3.28934e-17
C22	a_27_74##31	A#6	4.16739e-19
C23	a_27_74##24	VNB	3.50851e-17
C24	a_27_74##22	VNB	3.44773e-17
C25	a_27_74##21	VNB	3.49027e-17
C26	a_27_74##19	VNB	3.11584e-17
C27	a_27_74##17	VNB	3.25888e-17
C28	a_27_74##15	VNB	3.05857e-17
C29	VPWR	VPWR#4	9.75534e-18
C30	a_27_74#	VNB	4.07827e-17
C31	A#7	VNB	3.42131e-17
C32	A#5	VNB	2.62756e-17
C33	A	A#3	1.97901e-17
C34	VPWR	A#9	1.22293e-18
C35	A#4	VNB	2.46135e-17
C36	VGND#6	A#4	5.3402e-18
C37	a_27_74##12	VNB	2.76305e-17
C38	VPWR	A#8	8.98547e-19
C39	a_27_74##25	VNB	2.50093e-17
C40	VGND#1	a_27_74##13	2.848e-17
C41	a_27_74##23	VNB	2.6861e-17
C42	VPWR	A#1	7.73501e-19
C43	a_27_74##20	VNB	2.88494e-17
C44	a_27_74##18	VNB	2.8392e-17
C45	VPWR	a_27_74##26	3.23988e-18
C46	a_27_74##16	VNB	2.88137e-17
C47	a_27_74##14	VNB	2.7668e-17
C48	X#6	a_27_74##23	3.81081e-17
C49	VPWR	a_27_74##24	3.75165e-19
C50	a_27_74##13	VNB	3.32438e-17
C51	a_27_74##32	VNB	4.93569e-17
C52	VPWR#13	VNB	2.82484e-18
C53	VPWR	a_27_74##22	3.86137e-19
C54	X#4	a_27_74##20	4.74673e-20
C55	VGND	A#7	1.6266e-18
C56	a_27_74##34	VNB	2.1429e-18
C57	VPWR#12	VNB	4.09278e-19
C58	VPWR	a_27_74##21	9.37514e-19
C59	VGND	A#5	1.24172e-18
C60	X#9	VNB	3.13039e-18
C61	A	A#9	3.34096e-18
C62	VGND	A#4	6.41819e-19
C63	VPWR#11	VNB	3.0111e-18
C64	VPWR	a_27_74##19	3.31805e-19
C65	X#15	VNB	2.17062e-18
C66	X#4	a_27_74##28	4.42091e-17
C67	VGND	a_27_74##12	2.88201e-19
C68	VPWR#10	VNB	3.0111e-18
C69	VPWR	a_27_74##17	9.48206e-19
C70	a_27_74##28	a_27_74##8	1.75759e-17
C71	A	A#8	2.04649e-18
C72	VGND	a_27_74##25	6.90727e-19
C73	X#1	VNB	2.17062e-18
C74	VPWR#9	VNB	2.98972e-18
C75	VPWR	a_27_74##15	3.95207e-19
C76	VGND	a_27_74##23	2.50251e-19
C77	A	A#1	1.67282e-18
C78	VGND	a_27_74##20	2.60217e-19
C79	VPWR	a_27_74#	5.15463e-18
C80	VPWR#1	VNB	8.2508e-17
C81	a_27_74##30	VNB	4.6567e-17
C82	VGND	a_27_74##18	2.52699e-19
C83	VGND#13	VNB	1.68167e-18
C84	a_27_74##33	VNB	4.55126e-18
C85	VGND	a_27_74##16	2.52699e-19
C86	A	a_27_74##26	2.60666e-19
C87	a_27_74##5	a_27_74##4	6.13118e-18
C88	VGND#12	VNB	3.01253e-20
C89	VGND	a_27_74##14	8.25943e-20
C90	VGND#5	a_27_74##12	5.03507e-19
C91	X#7	VNB	4.73751e-18
C92	VGND#11	VNB	4.56457e-19
C93	VGND	a_27_74##13	4.8687e-18
C94	VPWR#9	VPWR#1	2.08873e-18
C95	X#5	a_27_74##20	5.46317e-19
C96	VGND#4	a_27_74##6	1.70953e-20
C97	X	a_27_74##17	1.17341e-18
C98	VGND#10	VNB	2.74373e-18
C99	X	a_27_74##15	1.7333e-17
C100	VGND#9	VNB	2.74373e-18
C101	X	a_27_74#	2.46494e-17
C102	VGND#1	VNB	7.25252e-17
C103	VPWR#4	a_27_74##6	7.4695e-20
C104	VGND	X#9	2.53295e-18
C105	a_27_74##28	VNB	6.95962e-18
C106	a_27_74##29	VNB	1.05018e-18
C107	X#2	VNB	1.12417e-18
C108	X#3	VNB	1.0052e-17
C109	VGND#6	a_27_74##12	8.08969e-18
C110	X#4	VNB	1.1555e-17
C111	X#5	VNB	3.06511e-18
C112	X#6	VNB	3.39483e-18
C113	X#6	a_27_74##20	4.34661e-17
C114	X#8	VNB	1.4662e-18
C115	VGND	VPWR#1	4.09786e-18
C116	X#4	a_27_74##18	7.1135e-20
C117	VGND	a_27_74##30	1.44751e-17
C118	VGND#2	VNB	3.73028e-17
C119	VPWR	a_27_74##32	1.76333e-17
C120	X#5	a_27_74##28	8.41974e-17
C121	VGND#3	VNB	2.74374e-17
C122	VGND#3	a_27_74##25	1.2617e-19
C123	VGND#5	VNB	2.13599e-17
C124	VGND	a_27_74##33	1.09176e-17
C125	VGND#6	VNB	2.69663e-17
C126	VPWR	a_27_74##34	1.5835e-17
C127	VGND	X#7	1.18229e-17
C128	VPWR#2	VNB	3.34617e-17
C129	VPWR#3	VNB	2.46748e-17
C130	VPWR#5	VNB	2.00483e-17
C131	VPWR	X#9	1.76186e-17
C132	VPWR#6	VNB	2.87125e-17
C133	VPWR	X#15	1.62877e-17
C134	X#5	a_27_74##18	3.90918e-17
C135	VGND	VGND#1	3.79306e-17
C136	VPWR	X#1	1.62375e-17
C137	VGND#5	a_27_74##25	4.71705e-18
C138	VPWR#3	VPWR#2	7.4289e-19
C139	VGND	a_27_74##28	1.88372e-17
C140	VPWR	VPWR#1	3.14853e-17
C141	VGND	a_27_74##29	3.02332e-18
C142	VGND	X#2	3.48194e-18
C143	VGND	X#3	1.57998e-18
C144	VGND	X#4	2.16032e-17
C145	VGND	X#5	1.8245e-17
C146	A#9	A#8	4.73903e-17
C147	VGND	X#6	1.86944e-17
C148	VGND#6	a_27_74##25	6.31238e-19
C149	X#6	a_27_74##18	5.46317e-19
C150	X#6	a_27_74##28	9.02744e-17
C151	VGND	X#8	3.89332e-18
C152	X#4	a_27_74##16	7.05168e-19
C153	a_27_74##28	a_27_74##10	1.88553e-17
C154	VGND	VGND#2	4.66495e-17
C155	A	a_27_74##32	4.47687e-17
C156	X#2	X#3	1.75427e-18
C157	VGND	VGND#3	3.99288e-17
C158	VGND#3	a_27_74##23	4.07818e-19
C159	VGND	VGND#5	3.63743e-17
C160	VPWR#4	a_27_74##22	5.68487e-18
C161	VPWR#9	X	7.11481e-17
C162	VGND	VGND#6	4.1407e-17
C163	X	X#10	9.16142e-18
C164	A#8	A#1	4.58173e-17
C165	X	VPWR#1	6.29381e-17
C166	VGND#2	VGND#1	1.33909e-18
C167	A#2	a_27_74##11	2.76091e-17
C168	X#5	a_27_74##16	4.34813e-17
C169	VPWR	a_27_74##28	1.40557e-17
C170	VGND#5	a_27_74##23	2.58205e-18
C171	VPWR	a_27_74##31	3.7907e-18
C172	VPWR	X#2	2.08785e-18
C173	VPWR	X#3	9.53882e-19
C174	VGND#2	a_27_74##20	1.2699e-19
C175	A#1	a_27_74##26	4.7119e-17
C176	a_27_74##28	X#8	9.30445e-17
C177	a_27_74##28	a_27_74##11	1.66607e-17
C178	X#4	a_27_74##14	3.84303e-17
C179	VPWR	X#8	3.06175e-18
C180	a_27_74##30	A	4.52645e-17
C181	VGND#3	a_27_74##20	3.36831e-18
C182	a_27_74##26	a_27_74##24	3.71983e-17
C183	a_27_74##32	a_27_74##31	6.21728e-19
C184	X#5	a_27_74##14	5.46317e-19
C185	VPWR	VPWR#2	3.86744e-17
C186	A#2	VNB	2.40757e-17
C187	A#6	VNB	3.63126e-17
C188	VPWR	VPWR#3	3.23961e-17
C189	a_27_74##2	VNB	4.01587e-17
C190	VGND#5	a_27_74##10	3.33063e-20
C191	VPWR	VPWR#5	3.19338e-17
C192	a_27_74##3	VNB	3.61769e-17
C193	X#2	a_27_74##3	7.32513e-19
C194	a_27_74##4	VNB	3.51873e-17
C195	VPWR	VPWR#6	3.73666e-17
C196	a_27_74##5	VNB	3.44337e-17
C197	VGND#5	a_27_74##20	4.07818e-19
C198	a_27_74##8	VNB	3.65638e-17
C199	a_27_74##10	VNB	3.95677e-17
C200	VGND#4	a_27_74##23	2.42944e-18
C201	a_27_74##11	VNB	2.76194e-17
C202	A#3	VPWR#13	9.49831e-19
C203	a_27_74##24	a_27_74##22	3.79763e-17
C204	VGND#2	a_27_74##18	4.07818e-19
C205	VPWR#5	VPWR#3	7.4289e-19
C206	X#4	a_27_74##13	2.48191e-17
C207	A#3	a_27_74##34	2.74109e-19
C208	a_27_74##30	VGND#13	5.10937e-17
C209	VGND#4	a_27_74##20	1.72641e-18
C210	X#4	X#3	3.11253e-18
C211	a_27_74##31	VPWR#13	1.74539e-17
C212	VGND#3	a_27_74##18	5.11242e-18
C213	A	a_27_74##28	4.65018e-17
C214	a_27_74##22	a_27_74##21	4.61523e-17
C215	a_27_74##29	A	6.79742e-17
C216	A	a_27_74##31	6.96163e-17
C217	X#2	a_27_74##4	6.20919e-18
C218	X	VPWR#2	1.77529e-17
C219	a_27_74##30	a_27_74##33	1.61116e-18
C220	VGND#5	a_27_74##11	1.24589e-20
C221	VGND#5	a_27_74##18	1.2699e-19
C222	VGND#2	a_27_74##16	5.11242e-18
C223	a_27_74##21	a_27_74##19	3.79843e-17
C224	a_27_74##28	VPWR#12	2.11405e-18
C225	X#3	a_27_74##2	9.49458e-18
C226	a_27_74##31	a_27_74##34	1.36226e-18
C227	VPWR#10	a_27_74##6	5.92551e-19
C228	VPWR#2	a_27_74##2	4.96731e-20
C229	VGND#13	A#3	8.39499e-19
C230	VGND#13	a_27_74##33	3.4144e-17
C231	VGND#3	a_27_74##16	4.07818e-19
C232	X#2	a_27_74##5	5.5599e-18
C233	a_27_74##19	a_27_74##17	4.61523e-17
C234	VGND	A#2	1.61907e-20
C235	a_27_74##28	X#9	6.09812e-17
C236	X#8	X#2	1.75181e-18
C237	VGND#2	a_27_74##14	5.14757e-18
C238	VGND	a_27_74##3	1.7753e-18
C239	X#3	a_27_74##3	4.03163e-18
C240	X#5	X#4	2.65725e-18
C241	VGND	a_27_74##4	5.85424e-20
C242	VGND	a_27_74##5	6.99564e-20
C243	a_27_74##31	VPWR#12	2.46193e-17
C244	VGND#13	VGND#12	1.53057e-18
C245	VGND	a_27_74##8	7.54792e-20
C246	a_27_74##17	a_27_74##15	4.05785e-17
C247	VPWR#6	VPWR#5	4.50095e-20
C248	VGND	a_27_74##10	7.41906e-20
C249	VGND	a_27_74##11	4.32625e-20
C250	X#15	VPWR#4	1.44501e-17
C251	a_27_74##32	A#9	5.81998e-17
C252	VGND#3	a_27_74##14	1.2699e-19
C253	VPWR#2	a_27_74##3	5.02826e-20
C254	A#9	VPWR#13	3.08474e-17
C255	a_27_74##34	A#9	1.99344e-18
C256	a_27_74##28	VPWR#11	3.14569e-18
C257	a_27_74##15	a_27_74#	4.45467e-17
C258	a_27_74##33	VGND#12	4.16102e-17
C259	a_27_74##32	A#8	2.12167e-18
C260	VPWR#12	A#9	2.70458e-19
C261	VGND#10	a_27_74##6	1.19966e-18
C262	X#3	a_27_74##4	2.42156e-19
C263	VGND#2	a_27_74##13	7.73642e-19
C264	a_27_74##31	X#9	1.92806e-17
C265	a_27_74##28	A#3	2.4711e-19
C266	A#8	VPWR#13	2.52415e-17
C267	VGND#6	a_27_74##11	4.63586e-20
C268	VPWR#4	VPWR#1	2.71908e-17
C269	a_27_74##29	A#3	4.17655e-18
C270	a_27_74##34	A#8	4.59447e-17
C271	a_27_74##31	A#3	2.63947e-18
C272	X#4	a_27_74##2	9.04411e-18
C273	A#4	a_27_74##11	1.06381e-18
C274	VPWR#12	A#8	3.71489e-19
C275	a_27_74##33	X#7	1.67195e-18
C276	VPWR#2	a_27_74##4	3.39043e-20
C277	VPWR#13	A#1	6.54315e-19
C278	a_27_74##28	X#15	2.35532e-18
C279	X#7	a_27_74##10	1.17151e-18
C280	a_27_74##34	A#1	5.23987e-17
C281	X#3	a_27_74##5	1.40198e-19
C282	a_27_74##28	a_27_74##6	1.97216e-17
C283	X#6	X#5	2.65318e-18
C284	A#2	a_27_74##26	1.16603e-18
C285	A#1	VPWR#12	2.10476e-17
C286	VPWR#13	a_27_74##26	1.53981e-19
C287	VGND#6	a_27_74##28	5.36453e-19
C288	X#9	A#1	8.93413e-19
C289	VGND#12	X#7	4.15829e-17
C290	X#4	a_27_74##3	5.28966e-18
C291	VGND#4	VGND#1	2.9889e-17
C292	X#2	a_27_74##6	9.3278e-20
C293	a_27_74##34	a_27_74##26	1.67418e-18
C294	X#7	a_27_74##11	1.87868e-18
C295	X#3	a_27_74##6	9.61155e-20
C296	a_27_74##28	VPWR#10	3.14569e-18
C297	X#9	a_27_74##10	4.88572e-18
C298	VGND#11	a_27_74##8	3.03892e-19
C299	VPWR#12	a_27_74##26	4.72402e-17
C300	X#4	a_27_74##6	4.9366e-20
C301	X#5	a_27_74##6	1.39635e-18
C302	VGND#6	A#3	9.74797e-21
C303	X#9	a_27_74##26	1.94195e-17
C304	X#6	a_27_74##6	2.68005e-18
C305	A#7	A#5	2.84838e-17
C306	a_27_74##34	a_27_74##24	1.64737e-19
C307	VGND#12	VGND#11	1.66094e-18
C308	X#8	a_27_74##6	4.91114e-18
C309	VPWR#11	a_27_74##26	3.60043e-19
C310	X#9	a_27_74##11	1.11441e-18
C311	VPWR#12	a_27_74##24	1.4025e-18
C312	X#4	a_27_74##4	1.64056e-19
C313	VGND#6	a_27_74##29	2.91756e-19
C314	a_27_74##28	X#1	2.35532e-18
C315	X#9	a_27_74##24	7.59269e-17
C316	A#5	A#4	4.10592e-17
C317	a_27_74##24	VPWR#11	3.23495e-17
C318	VPWR#11	a_27_74##8	7.50244e-19
C319	VPWR#12	a_27_74##22	1.78501e-19
C320	X#3	a_27_74##8	7.46755e-20
C321	X#7	VGND#11	4.59942e-17
C322	VPWR#6	A#2	2.01982e-20
C323	VGND#4	X#6	1.50048e-17
C324	VPWR#3	a_27_74##4	2.24113e-20
C325	X#15	a_27_74##24	1.38068e-18
C326	X#9	a_27_74##22	1.81116e-18
C327	VGND#1	VPWR#1	1.3848e-17
C328	VGND#11	a_27_74##10	7.81517e-19
C329	a_27_74##26	a_27_74##10	1.45672e-18
C330	VPWR#10	a_27_74##24	1.71283e-19
C331	X#4	a_27_74##5	7.39804e-20
C332	a_27_74##22	VPWR#11	2.784e-17
C333	a_27_74##28	VPWR#9	2.90858e-18
C334	X#2	VPWR#10	1.39099e-17
C335	A#4	a_27_74##12	3.9017e-17
C336	X#9	X#8	1.75181e-18
C337	VGND#4	VGND#2	4.57658e-17
C338	X#15	a_27_74##22	4.78091e-17
C339	X#5	a_27_74##3	2.00907e-19
C340	VGND#4	VGND#3	3.37593e-17
C341	VGND#2	X#4	1.49188e-17
C342	VGND#4	VGND#5	2.71003e-17
C343	VPWR#10	a_27_74##22	3.70183e-19
C344	VPWR#11	a_27_74##21	4.09291e-19
C345	VPWR#11	a_27_74##10	2.62446e-19
C346	VGND#4	VGND#6	3.55754e-17
C347	X#8	VPWR#4	2.65037e-19
C348	VPWR#3	a_27_74##5	3.04743e-20
C349	X#15	a_27_74##21	5.57819e-17
C350	a_27_74##12	a_27_74##25	4.06095e-17
C351	X#2	X#1	2.09634e-19
C352	a_27_74##21	VPWR#10	3.23495e-17
C353	a_27_74##28	A#9	4.02886e-19
C354	VPWR#11	a_27_74##19	1.78501e-19
C355	X#8	VPWR#11	2.3888e-17
C356	X#5	a_27_74##4	2.76583e-18
C357	X#1	a_27_74##21	1.37574e-18
C358	VGND#10	a_27_74##5	2.68279e-19
C359	X#15	a_27_74##19	1.49253e-18
C360	VGND#2	X#5	8.67527e-18
C361	a_27_74##31	A#9	1.94029e-19
C362	X#1	X#3	9.92727e-19
C363	VPWR#9	a_27_74##21	1.71283e-19
C364	a_27_74##19	VPWR#10	2.784e-17
C365	VGND#11	VGND#10	1.94088e-18
C366	a_27_74##25	a_27_74##23	2.38379e-17
C367	X#2	VPWR#9	1.10934e-17
C368	X#1	a_27_74##19	4.77813e-17
C369	a_27_74##28	A#8	5.50473e-19
C370	X#8	X#15	2.08835e-19
C371	X#5	a_27_74##5	3.02766e-18
C372	VPWR#4	VPWR#2	4.49989e-17
C373	A	A#2	1.2439e-17
C374	VPWR#9	a_27_74##19	3.70183e-19
C375	VPWR#10	a_27_74##17	4.09291e-19
C376	A	A#6	2.10326e-17
C377	VPWR#4	VPWR#3	3.37642e-17
C378	a_27_74##31	A#8	1.75424e-17
C379	VGND#3	X#5	7.58888e-18
C380	X#3	VPWR#9	1.67002e-17
C381	VPWR#4	VPWR#5	2.4937e-17
C382	X#1	a_27_74##17	5.5768e-17
C383	a_27_74##23	a_27_74##20	3.73861e-17
C384	VPWR#4	VPWR#6	3.86794e-17
C385	VPWR#10	a_27_74##5	4.6072e-19
C386	a_27_74##28	A#1	2.51939e-18
C387	a_27_74##17	VPWR#9	3.17923e-17
C388	VPWR#10	a_27_74##15	1.77407e-19
C389	X#8	VPWR#10	1.11313e-17
C390	A	a_27_74##11	6.96604e-18
C391	a_27_74##28	VPWR#6	2.77644e-19
C392	X#1	a_27_74##15	1.54173e-18
C393	a_27_74##30	a_27_74##29	4.88545e-19
C394	a_27_74##31	A#1	2.0622e-17
C395	X#3	X#10	2.13118e-18
C396	VGND#3	X#6	1.201e-18
C397	a_27_74##20	a_27_74##18	2.159e-17
C398	VPWR#1	a_27_74##17	2.47008e-19
C399	a_27_74##15	VPWR#9	2.78524e-17
C400	a_27_74##28	a_27_74##26	1.42609e-18
C401	X#1	a_27_74#	1.05287e-19
C402	a_27_74##15	X#10	2.4792e-17
C403	X#2	VPWR#2	2.5317e-19
C404	a_27_74##29	VGND#13	2.15316e-17
C405	VPWR#9	a_27_74#	1.89057e-18
C406	VPWR#1	a_27_74##15	1.16347e-18
C407	a_27_74##31	a_27_74##26	4.86334e-18
C408	VGND#9	a_27_74##3	1.25402e-18
C409	X#3	VPWR#1	2.62035e-17
C410	a_27_74##18	a_27_74##16	3.73861e-17
C411	VGND#5	X#6	6.82638e-20
C412	a_27_74#	X#10	2.51029e-17
C413	a_27_74##28	a_27_74##24	1.22687e-19
C414	a_27_74##34	VPWR#6	8.43957e-18
C415	X#2	VPWR#3	1.34496e-19
C416	VGND#10	VGND#9	1.94088e-18
C417	VPWR#1	a_27_74#	3.18937e-17
C418	VPWR#6	A#9	1.47917e-19
C419	X#3	VPWR#2	1.34496e-19
C420	a_27_74##29	a_27_74##33	1.44528e-18
C421	a_27_74##31	a_27_74##24	4.67736e-19
C422	VGND#9	a_27_74##4	6.91328e-19
C423	a_27_74##28	VGND#12	2.43095e-17
C424	a_27_74##16	a_27_74##14	2.15901e-17
C425	a_27_74##31	VPWR#6	3.13618e-19
C426	a_27_74##21	a_27_74##5	1.45672e-18
C427	a_27_74##2	X#12	1.82557e-19
C428	a_27_74##29	VGND#12	4.13054e-18
C429	a_27_74##28	X#7	5.77472e-17
C430	VPWR#6	A#8	3.00302e-19
C431	VPWR#9	a_27_74##3	7.14206e-19
C432	a_27_74##14	a_27_74##13	3.74645e-17
C433	a_27_74##8	a_27_74##21	1.71475e-18
C434	X#9	VPWR#5	7.96875e-18
C435	X#6	a_27_74##8	3.42456e-18
C436	a_27_74##10	a_27_74##8	5.12871e-18
C437	a_27_74##30	A#7	3.36278e-17
C438	X#8	a_27_74##24	3.13689e-19
C439	a_27_74##3	X#12	5.59991e-21
C440	a_27_74##29	X#7	8.953e-19
C441	VPWR#9	a_27_74##4	2.79217e-19
C442	VGND#13	A#7	3.2486e-17
C443	a_27_74##28	VGND#11	3.61992e-18
C444	X#9	VPWR#6	9.96117e-18
C445	X#2	a_27_74##21	3.13689e-19
C446	a_27_74##30	A#5	7.58611e-19
C447	a_27_74##33	A#7	1.2109e-18
C448	VPWR#6	A#1	5.25743e-18
C449	VPWR#5	a_27_74##10	3.39043e-20
C450	X#8	a_27_74##22	1.67169e-17
C451	A#5	VGND#13	1.70855e-17
C452	VGND#12	A#7	1.68077e-19
C453	VGND#3	VGND#2	1.35051e-18
C454	a_27_74##2	X#10	1.24673e-19
C455	a_27_74##28	X#14	2.51339e-18
C456	a_27_74##30	A#4	1.78265e-19
C457	A#5	a_27_74##33	1.76611e-17
C458	VGND#9	VGND#1	1.92793e-18
C459	X#15	VPWR#3	2.38285e-18
C460	X#2	a_27_74##19	1.57575e-17
C461	VPWR#5	a_27_74##26	2.88401e-19
C462	VGND#13	A#4	1.35824e-18
C463	VGND#12	A#5	1.22396e-18
C464	X#6	a_27_74##10	2.3883e-18
C465	a_27_74##32	VPWR#13	5.2514e-17
C466	VPWR#6	a_27_74##26	7.30448e-18
C467	a_27_74##3	X#10	3.82432e-21
C468	X#8	a_27_74##21	1.95882e-17
C469	A#4	a_27_74##33	1.38198e-17
C470	a_27_74##28	VGND#10	4.74247e-18
C471	X#7	A#5	1.97573e-19
C472	X#8	a_27_74##8	5.42707e-18
C473	a_27_74##32	a_27_74##34	2.36849e-18
C474	A#3	A#2	4.0818e-18
C475	X#2	a_27_74##17	1.65667e-17
C476	VGND#12	A#4	2.82083e-17
C477	A#6	A#3	3.60937e-18
C478	VPWR#3	a_27_74##24	8.34499e-20
C479	X#3	a_27_74##17	4.88346e-19
C480	VPWR#5	a_27_74##24	7.57183e-18
C481	a_27_74##33	a_27_74##12	3.05025e-19
C482	VPWR#13	a_27_74##34	5.21059e-17
C483	X#7	A#4	4.68361e-19
C484	X#8	a_27_74##19	3.13689e-19
C485	a_27_74##28	X#13	2.51339e-18
C486	VPWR#6	a_27_74##24	3.90125e-19
C487	X#1	VPWR#2	7.70372e-18
C488	VGND#5	VGND#3	1.35051e-18
C489	VGND#12	a_27_74##12	3.23993e-17
C490	VPWR#6	a_27_74##10	4.6834e-20
C491	X#2	a_27_74##15	3.20566e-19
C492	VPWR#13	VPWR#12	1.94092e-18
C493	a_27_74##33	a_27_74##25	1.28671e-19
C494	a_27_74##12	X#7	1.98537e-17
C495	VPWR#3	a_27_74##22	2.99535e-19
C496	X#3	a_27_74##15	1.75669e-17
C497	a_27_74##3	a_27_74##2	3.39361e-18
C498	X#1	VPWR#3	9.23811e-18
C499	X#8	VPWR#3	2.5317e-19
C500	a_27_74##28	VGND#9	5.20067e-18
C501	VPWR#5	a_27_74##22	1.9722e-18
C502	a_27_74##34	VPWR#12	5.29637e-17
C503	VGND#12	a_27_74##25	1.21722e-18
C504	VGND#11	a_27_74##12	1.26346e-18
C505	VGND#2	a_27_74##2	4.80437e-20
C506	X#8	a_27_74##10	7.17523e-19
C507	VPWR#6	a_27_74##22	9.12873e-20
C508	X#2	a_27_74#	1.86054e-19
C509	X#7	a_27_74##25	2.45988e-17
C510	a_27_74##34	X#9	2.17937e-18
C511	VPWR#6	a_27_74##11	3.50454e-20
C512	VPWR#2	a_27_74##21	8.34499e-20
C513	X#3	a_27_74#	1.01961e-17
C514	X#7	X#6	2.41878e-18
C515	VGND#11	a_27_74##25	3.18087e-17
C516	VPWR#3	a_27_74##21	5.36045e-18
C517	VPWR#12	X#9	6.1225e-17
C518	VPWR#5	a_27_74##21	3.40035e-19
C519	a_27_74##30	A#6	1.43505e-19
C520	VGND#2	a_27_74##3	4.86332e-20
C521	X#7	a_27_74##23	3.76464e-19
C522	VGND#6	VGND#5	1.14921e-18
C523	a_27_74##6	a_27_74##5	3.38517e-18
C524	a_27_74##29	A#7	1.74373e-19
C525	a_27_74##23	VGND#11	1.71352e-17
C526	a_27_74##8	a_27_74##6	4.35927e-18
C527	VPWR#12	VPWR#11	2.1297e-18
C528	VGND#10	a_27_74##25	1.58735e-19
C529	VPWR#2	a_27_74##19	2.99535e-19
C530	X#6	VGND#11	6.32358e-17
C531	a_27_74##4	a_27_74##15	1.52524e-18
C532	VPWR#3	a_27_74##19	4.54396e-18
C533	a_27_74##23	X#14	1.49295e-17
C534	VGND#2	a_27_74##4	2.59377e-20
C535	X#9	VPWR#11	6.38411e-17
C536	VPWR#5	a_27_74##19	9.12873e-20
C537	a_27_74##29	A#5	2.256e-17
C538	VGND#11	a_27_74##20	3.49779e-19
C539	VGND#10	a_27_74##23	3.49779e-19
C540	VPWR#2	VPWR#1	7.4061e-19
C541	a_27_74##28	A#2	9.92255e-18
C542	X#6	X#14	4.68449e-19
C543	a_27_74##20	X#14	1.49295e-17
C544	VPWR#2	a_27_74##17	5.30705e-18
C545	X#9	X#15	1.03453e-18
C546	X#5	VGND#10	5.66902e-17
C547	VGND#11	a_27_74##18	1.61089e-19
C548	VPWR#3	a_27_74##17	3.40035e-19
C549	a_27_74##11	a_27_74##10	3.98083e-18
C550	VGND#2	a_27_74##5	2.00428e-20
C551	a_27_74##29	A#4	1.62757e-17
C552	a_27_74##20	VGND#10	2.36211e-17
C553	VGND#13	A#6	3.09171e-19
C554	VPWR#11	X#15	7.20139e-17
C555	a_27_74##28	A#6	2.21672e-19
C556	a_27_74##30	a_27_74##32	1.6024e-19
C557	X#6	VGND#10	5.68717e-17
C558	a_27_74##28	a_27_74##12	4.0235e-18
C559	VGND#6	a_27_74##33	6.3108e-18
C560	X#5	X#13	4.68449e-19
C561	VPWR#2	a_27_74##15	2.98606e-18
C562	X#4	VGND#9	5.54661e-17
C563	a_27_74##18	VGND#10	2.08967e-17
C564	VPWR#11	VPWR#10	2.09124e-18
C565	VGND#4	a_27_74##8	7.66341e-20
C566	a_27_74##29	a_27_74##12	1.63336e-19
C567	VGND#9	a_27_74##20	1.61089e-19
C568	VPWR#3	a_27_74##15	9.10311e-20
C569	a_27_74##4	a_27_74##3	3.48568e-18
C570	a_27_74##18	X#13	1.49295e-17
C571	a_27_74##28	a_27_74##25	5.37924e-19
C572	X#15	VPWR#10	6.2273e-17
C573	VGND#6	A#2	3.58492e-20
C574	X#5	VGND#9	5.6839e-17
C575	VGND#10	a_27_74##16	3.49779e-19
C576	a_27_74##29	A#2	1.5585e-18
C577	X#4	X#12	4.99079e-19
C578	VGND#9	a_27_74##18	3.49779e-19
C579	a_27_74##29	a_27_74##25	6.89014e-20
C580	VPWR#2	a_27_74#	2.90885e-18
C581	VGND#5	X#7	5.51402e-18
C582	X#15	X#1	1.00695e-18
C583	a_27_74##28	a_27_74##3	1.81843e-17
C584	a_27_74##16	X#13	1.49295e-17
C585	a_27_74##28	a_27_74##23	1.12425e-19
C586	VGND#3	a_27_74##5	4.71594e-20
C587	A#6	VPWR#13	2.86194e-19
C588	VGND#10	a_27_74##14	1.61089e-19
C589	a_27_74##16	VGND#9	2.36211e-17
C590	a_27_74##29	A#6	8.16447e-19
C591	VPWR#10	X#1	7.20139e-17
C592	VGND#1	X#4	8.06099e-17
C593	VGND#6	X#7	5.24724e-18
C594	a_27_74##28	a_27_74##31	8.40132e-19
C595	a_27_74##28	a_27_74##4	1.68974e-17
C596	VGND#6	A#7	2.94575e-19
C597	VPWR#4	a_27_74##8	9.14229e-21
C598	a_27_74##28	a_27_74##20	5.56318e-20
C599	VPWR#10	VPWR#9	2.09124e-18
C600	a_27_74##14	VGND#9	2.0901e-17
C601	X#6	a_27_74##12	2.02452e-19
C602	VGND#1	a_27_74##16	2.85235e-19
C603	VGND#6	VGND#11	7.59287e-19
C604	a_27_74##28	X#2	8.19241e-17
C605	a_27_74##29	a_27_74##31	1.21187e-18
C606	a_27_74##28	a_27_74##5	1.67916e-17
C607	a_27_74##14	X#12	1.51323e-17
C608	a_27_74##31	A#2	1.23962e-18
C609	X#1	VPWR#9	6.2273e-17
C610	VGND#6	A#5	6.5224e-19
C611	a_27_74##28	a_27_74##18	4.18373e-20
C612	A#2	a_27_74##34	2.70455e-19
C613	VGND#9	a_27_74##13	6.73073e-19
C614	VGND#7	A#4	8.966e-19
C615	VGND#7	a_27_74##29	5.90144e-19
C616	VPWR#4	VPWR#7	5.11648e-17
C617	VGND#7	VNB	4.72777e-17
C618	VGND#7	a_27_74##30	1.7841e-17
C619	VPWR#7	VPWR#6	7.0017e-19
C620	a_27_74##34	VPWR#7	8.48902e-18
C621	VGND#7	A#3	2.60702e-20
C622	VGND#7	A#5	5.4601e-18
C623	VPWR#7	A#3	2.04712e-20
C624	a_27_74##32	VPWR#7	2.1222e-17
C625	a_27_74##31	VPWR#7	3.13618e-19
C626	VGND#7	VGND#6	1.71482e-18
C627	VGND#7	A#7	5.41533e-18
C628	VGND#7	a_27_74##33	4.13722e-18
C629	VPWR	VPWR#7	4.42896e-17
C630	VGND#4	VGND#7	5.05724e-17
C631	VPWR#7	a_27_74##26	8.1728e-20
C632	VPWR#7	VNB	4.64251e-17
C633	VPWR#7	A#1	5.30308e-19
C634	VPWR#7	A#8	5.25568e-18
C635	VGND	VGND#7	5.35463e-17
C636	VPWR#7	A#9	7.70872e-18
*
*
.ENDS sky130_fd_sc_hs__buf_8
*
