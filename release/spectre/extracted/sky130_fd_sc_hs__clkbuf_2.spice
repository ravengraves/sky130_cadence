* Extracted by Quantus, converted by sky130cad/quantus.py
*
*
*
*                       LINUX           Wed Nov 18 08:22:15 2026
*
*
*
*  PROGRAM  advgen
*
*  Name           : advgen - Quantus - (64-bit)
*  Version        : 25.1.0-p047
*  Build Date     : Thu Dec 11 23:20:30 PST 2025
*
*  HSPICE LIBRARY
*
*  OPERATING_TEMPERATURE 150
*  QRC_TECH_DIR <path>/tech
*
*
*

*
.SUBCKT sky130_fd_sc_hs__clkbuf_2 VPB VNB VGND VPWR X A
*
*
*  caps2d version: 10
*
*
*       TRANSISTOR CARDS
*
*
XM2 X#2 a_43_192##5 VGND#4 VNB sky130_fd_pr__nfet_01v8_lvt l=0.15 w=0.42 ad=0.1176 as=0.1197 pd=1.4 ps=1.41
XM5 VGND#5 a_43_192##4 X#2 VNB sky130_fd_pr__nfet_01v8_lvt l=0.15 w=0.42 ad=0.147 as=0.1176 pd=1.54 ps=1.4
XM1 VGND#5 A#1 a_43_192##7 VNB sky130_fd_pr__nfet_01v8_lvt l=0.15 w=0.42 ad=0.147 as=0.1197 pd=1.54 ps=1.41
XM0 X#1 a_43_192##6 VPWR#4 VPB sky130_fd_pr__pfet_01v8 l=0.15 w=1.12 ad=0.336 as=0.3192 pd=2.84 ps=2.81
XM3 VPWR#3 a_43_192# X#1 VPB sky130_fd_pr__pfet_01v8 l=0.15 w=1.12 ad=0.336 as=0.336 pd=2.84 ps=2.84
XM4 VPWR#3 A#3 a_43_192##10 VPB sky130_fd_pr__pfet_01v8 l=0.15 w=1.12 ad=0.336 as=0.3528 pd=2.84 ps=2.87
*
*
*       RESISTOR AND CAP/DIODE CARDS
*
Rg1	a_43_192#	a_43_192##2	520.345886
Rg2	a_43_192##2	a_43_192##3	39.826813
Rg3	a_43_192##2	a_43_192##4	313.931824
Rg4	a_43_192##3	a_43_192##5	266.907867
Rg5	a_43_192##3	a_43_192##6	473.203217
Rg6	A#1	A#2	312.712891
Rg7	A#2	A#3	468.107513
Rf1	X#1	X#3	108.238937
Rf2	X#3	X	0.573968
Rf3	X#2	X#3	15.000000
Rf4	A	A#4	1.239712
Rf5	A#5	A#2	81.356110
Rf6	A#4	A#5	1.599584
Rf7	A	A#7	1.239712
Rf8	A#5	A#7	10.237334
Rf9	A	A#8	1.239712
Rf10	A#7	A#8	11.836917
Rf11	a_43_192##7	a_43_192##8	141.355087
Rf12	a_43_192##8	a_43_192##3	241.203979
Rf13	a_43_192##8	a_43_192##10	16.915861
Rf15	VPWR#2	VPWR#3	36.824379
Rf16	VPWR#2	VPWR#4	81.535355
Rf18	VGND#2	VGND#3	16.103926
Rf19	VGND#3	VGND#4	92.476357
Rf20	VGND#2	VGND#5	40.352859
Re1	VPWR#2	VPWR	2.455682
Re2	VGND	VGND#3	2.455774
*
*       CAPACITOR CARDS
*
*
C1	VGND	VNB	5.01996e-17
C2	VPWR	VNB	4.91684e-17
C3	A	VNB	1.85608e-18
C4	a_43_192##3	VNB	1.57188e-16
C5	VGND	A	5.73549e-18
C6	A#2	VNB	6.94922e-17
C7	VGND#3	VNB	1.25018e-16
C8	VPWR	A	4.80057e-18
C9	VGND	a_43_192##3	8.70078e-18
C10	a_43_192##6	VNB	3.79304e-17
C11	a_43_192#	VNB	2.93937e-17
C12	A#3	VNB	3.48038e-17
C13	VGND	VGND#3	1.49181e-17
C14	a_43_192##5	VNB	3.0038e-17
C15	VPWR	a_43_192##3	3.89095e-18
C16	a_43_192##4	VNB	2.78755e-17
C17	A#1	VNB	2.87824e-17
C18	VPWR#4	VNB	4.6636e-17
C19	X#1	VNB	7.04554e-19
C20	VPWR#3	VNB	2.00156e-18
C21	VGND#4	VNB	5.17377e-17
C22	X#2	VNB	4.23175e-18
C23	VGND	a_43_192##5	1.99209e-18
C24	VGND#5	VNB	8.54505e-18
C25	A	a_43_192##3	1.07974e-17
C26	VPWR	a_43_192##6	3.40703e-19
C27	a_43_192##7	VNB	5.64596e-17
C28	VGND	a_43_192##4	4.04672e-18
C29	VPWR	a_43_192#	3.13573e-19
C30	A	A#2	2.24806e-17
C31	VGND	A#1	1.7679e-18
C32	VPWR	A#3	1.68127e-18
C33	VGND	X#1	1.13788e-18
C34	a_43_192##8	VNB	6.70121e-17
C35	VGND	VGND#4	2.89047e-17
C36	VGND	X#2	1.76983e-17
C37	VPWR	VPWR#4	3.28223e-17
C38	VGND	a_43_192##7	1.92181e-17
C39	VPWR	X#1	4.49833e-18
C40	a_43_192##3	A#2	5.6681e-17
C41	A	a_43_192#	7.51316e-18
C42	VPWR	VPWR#3	1.62204e-17
C43	A	A#3	1.26923e-17
C44	VGND#3	a_43_192##3	1.83595e-18
C45	a_43_192##3	a_43_192##6	1.62748e-17
C46	X#1	A	5.09647e-17
C47	a_43_192##3	a_43_192#	9.74736e-19
C48	A	VPWR#3	8.01557e-20
C49	VPWR	a_43_192##8	2.84408e-17
C50	A	a_43_192##10	2.63456e-18
C51	a_43_192##3	A#3	5.36286e-19
C52	a_43_192#	A#2	1.06932e-18
C53	X#2	A	1.97022e-17
C54	VGND#5	A	2.64615e-17
C55	a_43_192##7	A	3.81746e-17
C56	a_43_192##3	A#1	9.08052e-19
C57	a_43_192##3	VPWR#4	4.50509e-17
C58	X#1	a_43_192##3	9.27653e-17
C59	VGND#3	a_43_192##5	5.24673e-18
C60	VGND#3	a_43_192##4	8.10537e-18
C61	a_43_192##6	a_43_192#	5.01699e-17
C62	A	a_43_192##8	9.64143e-17
C63	X#1	A#2	1.583e-17
C64	a_43_192##3	VGND#4	3.47772e-17
C65	X#2	a_43_192##3	5.24061e-17
C66	a_43_192#	A#3	4.64896e-17
C67	a_43_192##7	a_43_192##3	1.27113e-19
C68	X#2	A#2	1.728e-18
C69	VGND#5	A#2	2.55554e-18
C70	VGND#3	VGND#4	2.06458e-17
C71	A#2	a_43_192##7	3.12551e-17
C72	VGND#3	X#2	1.7277e-17
C73	VPWR#4	a_43_192##6	2.79483e-17
C74	X#1	a_43_192##6	3.71152e-17
C75	a_43_192##3	a_43_192##8	2.54466e-18
C76	VPWR#4	a_43_192#	4.8653e-18
C77	VPWR#3	a_43_192##6	5.2231e-18
C78	X#1	a_43_192#	4.01723e-17
C79	a_43_192##5	a_43_192##4	2.52542e-17
C80	VPWR#3	a_43_192#	3.20483e-17
C81	a_43_192##8	A#2	7.11101e-18
C82	X#1	A#3	7.82959e-19
C83	VPWR#3	A#3	3.81851e-17
C84	a_43_192##4	A#1	1.9898e-17
C85	A#3	a_43_192##10	5.53472e-18
C86	VGND#4	a_43_192##5	1.63468e-17
C87	X#2	a_43_192##5	2.52389e-17
C88	VGND#4	a_43_192##4	1.34033e-18
C89	VPWR#4	VPWR#3	1.03307e-17
C90	VGND#5	a_43_192##5	5.29846e-19
C91	a_43_192##8	a_43_192##6	5.52149e-18
C92	X#2	a_43_192##4	2.76292e-17
C93	VGND#4	A#1	6.20278e-19
C94	a_43_192##4	VGND#5	1.43056e-17
C95	X#2	A#1	9.66816e-19
C96	a_43_192##8	a_43_192#	1.50848e-17
C97	a_43_192##7	a_43_192##4	8.64565e-19
C98	A#1	VGND#5	1.32379e-17
C99	a_43_192##8	A#3	3.43009e-17
C100	a_43_192##7	A#1	2.38467e-17
C101	X#2	X#1	1.46595e-18
C102	VGND#4	X#2	3.67358e-17
C103	VGND#4	VGND#5	1.37899e-18
C104	X#2	VGND#5	4.71224e-17
C105	X#2	a_43_192##7	2.57348e-18
C106	VGND#5	a_43_192##7	4.04217e-17
C107	a_43_192##8	X#1	3.78926e-17
C108	a_43_192##8	VPWR#3	6.57597e-17
C109	a_43_192##8	a_43_192##10	1.47102e-17
C110	X#2	a_43_192##8	7.75609e-20
C111	a_43_192##8	VGND#5	1.66599e-18
C112	a_43_192##7	a_43_192##8	1.23096e-18
C113	VGND#2	a_43_192##7	2.2174e-17
C114	a_43_192##8	VPWR#2	2.44008e-17
C115	VGND#2	VNB	3.88712e-17
C116	VGND#2	A#2	1.24767e-19
C117	VPWR#2	a_43_192#	3.99024e-18
C118	VGND#2	a_43_192##5	9.24163e-19
C119	VPWR	VPWR#2	4.26713e-17
C120	VPWR#2	VNB	1.60871e-16
C121	a_43_192##3	VPWR#2	3.7467e-19
C122	VGND	VGND#2	4.39172e-17
C123	VGND#3	VGND#2	3.87261e-17
C124	VGND#2	a_43_192##4	2.7905e-18
C125	VPWR#2	A#3	1.79256e-18
C126	VGND#2	A	6.90333e-19
C127	VPWR#2	a_43_192##6	3.87232e-18
C128	VGND#4	VGND#2	1.2517e-18
C129	VPWR#2	VPWR#4	2.54778e-17
C130	VPWR#2	A#2	2.89216e-20
C131	VGND#2	A#1	7.92292e-18
*
*
.ENDS sky130_fd_sc_hs__clkbuf_2
*
