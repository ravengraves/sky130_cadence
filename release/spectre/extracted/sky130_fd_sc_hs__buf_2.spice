* Extracted by Quantus, converted by sky130cad/quantus.py
*
*
*
*                       LINUX           Wed Nov 18 08:20:08 2026
*
*
*
*  PROGRAM  advgen
*
*  Name           : advgen - Quantus - (64-bit)
*  Version        : 25.1.0-p047
*  Build Date     : Thu Dec 11 23:20:30 PST 2025
*
*  HSPICE LIBRARY
*
*  OPERATING_TEMPERATURE 150
*  QRC_TECH_DIR <path>/tech
*
*
*

*
.SUBCKT sky130_fd_sc_hs__buf_2 VPB VNB VGND VPWR X A
*
*
*  caps2d version: 10
*
*
*       TRANSISTOR CARDS
*
*
XM3 VGND#7 a_21_260##6 X#1 VNB sky130_fd_pr__nfet_01v8_lvt l=0.15 w=0.74 ad=0.2109 as=0.2072 pd=2.05 ps=2.04
XM5 X#1 a_21_260##5 VGND#6 VNB sky130_fd_pr__nfet_01v8_lvt l=0.15 w=0.74 ad=0.2072 as=0.3107 pd=2.04 ps=2.34
XM2 VGND#6 A#1 a_21_260##8 VNB sky130_fd_pr__nfet_01v8_lvt l=0.15 w=0.64 ad=0.3107 as=0.1824 pd=2.34 ps=1.85
XM1 X#2 a_21_260##7 VPWR#4 VPB sky130_fd_pr__pfet_01v8 l=0.15 w=1.12 ad=0.336 as=0.756 pd=2.84 ps=3.59
XM4 VPWR#6 a_21_260# X#2 VPB sky130_fd_pr__pfet_01v8 l=0.15 w=1.12 ad=0.4204 as=0.336 pd=3.01 ps=2.84
XM0 VPWR#6 A#3 a_21_260##11 VPB sky130_fd_pr__pfet_01v8 l=0.15 w=1 ad=0.4204 as=0.32 pd=3.01 ps=2.64
*
*
*       RESISTOR AND CAP/DIODE CARDS
*
Rg1	a_21_260#	a_21_260##2	526.145996
Rg2	a_21_260##2	a_21_260##3	62.936840
Rg3	a_21_260##3	a_21_260##4	81.034950
Rg4	a_21_260##2	a_21_260##5	423.145813
Rg5	a_21_260##3	a_21_260##6	396.127869
Rg6	a_21_260##3	a_21_260##7	439.167511
Rg7	A#1	A#2	349.264282
Rg8	A#2	A#3	395.625153
Rf1	X#1	X	29.057510
Rf2	X	X#3	11.295456
Rf3	X#3	X	1.764915
Rf4	X#2	X#3	15.000000
Rf5	A#2	A#5	162.426666
Rf6	A#6	A	2.193861
Rf7	A#5	A#6	5.195247
Rf8	a_21_260##8	a_21_260##9	138.508545
Rf9	a_21_260##9	a_21_260##4	211.703156
Rf10	a_21_260##9	a_21_260##11	35.993610
Rf12	VGND#2	VGND#3	29.926170
Rf13	VGND#3	VGND#4	40.941093
Rf15	VGND#2	VGND#6	38.247387
Rf16	VGND#4	VGND#7	41.038895
Rf18	VPWR#2	VPWR#3	26.273645
Rf19	VPWR#3	VPWR#5	35.566719
Rf20	VPWR#5	VPWR#4	32.783554
Rf21	VPWR#2	VPWR#6	33.326477
Rf22	VPWR#4	VPWR#5	15.000000
Re1	VPWR#3	VPWR	1.964508
Re2	VGND	VGND#3	1.964582
*
*       CAPACITOR CARDS
*
*
C1	A#5	a_21_260##2	1.49684e-18
C2	a_21_260##8	a_21_260##2	6.81867e-18
C3	a_21_260##3	X#1	1.65515e-19
C4	a_21_260##2	X#1	1.97476e-19
C5	VGND#7	a_21_260##3	1.20887e-18
C6	a_21_260##3	X#2	1.09539e-19
C7	a_21_260##2	X#2	1.32259e-19
C8	a_21_260##3	VPWR#4	1.00977e-19
C9	a_21_260##2	A#1	5.71813e-19
C10	a_21_260##3	a_21_260#	1.34448e-18
C11	VPWR#3	a_21_260##3	5.32467e-20
C12	VPWR#3	a_21_260##2	6.42905e-20
C13	VGND#3	a_21_260##3	4.61815e-20
C14	VGND#3	a_21_260##2	5.54118e-20
C15	a_21_260##2	A#2	1.72654e-17
C16	a_21_260##4	a_21_260##3	1.09625e-17
C17	a_21_260##9	A#5	1.90773e-17
C18	a_21_260##8	a_21_260##9	1.15208e-18
C19	a_21_260##8	A#5	4.3388e-17
C20	a_21_260##9	VGND#7	1.52658e-19
C21	a_21_260##9	a_21_260##11	1.75654e-17
C22	a_21_260##9	VPWR#6	5.59607e-17
C23	a_21_260##8	VGND#6	6.63587e-17
C24	X	a_21_260##3	1.56363e-17
C25	X#1	a_21_260##8	1.48751e-17
C26	a_21_260##9	X#2	3.828e-18
C27	X	a_21_260##2	1.85519e-17
C28	A#5	a_21_260##11	1.55095e-17
C29	X#1	VGND#6	5.06464e-17
C30	a_21_260##9	VPWR#4	1.39066e-18
C31	VGND#7	VGND#6	1.26164e-18
C32	a_21_260##8	a_21_260##11	7.78482e-19
C33	VGND#7	X#1	6.36871e-17
C34	a_21_260##3	a_21_260##2	3.58177e-18
C35	a_21_260##8	A#1	4.29234e-17
C36	a_21_260##11	VPWR#6	1.77818e-17
C37	A#1	VGND#6	2.36908e-17
C38	a_21_260##8	a_21_260##5	4.88967e-18
C39	a_21_260##9	A#3	8.06578e-18
C40	X#1	A#1	2.24842e-18
C41	a_21_260##5	VGND#6	2.19112e-17
C42	VPWR#4	a_21_260##11	1.08816e-18
C43	VGND#7	A#1	3.42601e-19
C44	a_21_260##9	a_21_260#	1.92792e-17
C45	X#1	a_21_260##5	4.18132e-17
C46	VGND#6	a_21_260##6	4.85116e-19
C47	VPWR#4	VPWR#6	1.23309e-17
C48	A#5	A#3	2.70018e-18
C49	VGND#7	a_21_260##5	7.29652e-19
C50	X#1	a_21_260##6	3.78527e-17
C51	a_21_260##9	a_21_260##7	1.40647e-17
C52	A#5	a_21_260#	1.97749e-19
C53	VGND#7	a_21_260##6	2.09987e-17
C54	a_21_260##9	VPWR#3	3.77826e-18
C55	a_21_260##11	A#3	5.35806e-17
C56	a_21_260##5	A#1	2.11254e-17
C57	A#3	VPWR#6	2.15046e-17
C58	a_21_260##11	a_21_260#	3.34318e-18
C59	a_21_260##3	VNB	2.74928e-17
C60	a_21_260##2	VNB	2.75984e-17
C61	VPWR#6	a_21_260#	4.03477e-17
C62	a_21_260##6	a_21_260##5	3.83612e-17
C63	a_21_260##11	a_21_260##7	6.27814e-19
C64	a_21_260##9	A#2	2.46359e-18
C65	VPWR#4	A#3	3.67787e-19
C66	a_21_260#	X#2	2.61416e-17
C67	VPWR#6	a_21_260##7	5.28797e-18
C68	a_21_260##9	a_21_260##3	2.15986e-19
C69	VPWR#4	a_21_260#	5.57166e-18
C70	a_21_260##7	X#2	2.68567e-17
C71	A#5	A#2	1.21126e-17
C72	a_21_260##4	a_21_260##9	2.13231e-18
C73	VPWR#4	a_21_260##7	3.66357e-17
C74	VGND#3	X#1	1.59141e-17
C75	a_21_260##9	a_21_260##2	3.07579e-18
C76	a_21_260##8	A#2	7.92973e-18
C77	VPWR#3	VPWR#4	4.14947e-17
C78	A#2	a_21_260##11	4.73143e-18
C79	a_21_260#	A#3	3.15061e-17
C80	a_21_260##4	VGND#7	4.30654e-17
C81	VGND#3	a_21_260##5	3.3911e-18
C82	a_21_260##7	a_21_260#	4.98991e-17
C83	VGND#3	a_21_260##6	1.91984e-18
C84	a_21_260##4	VPWR#4	1.30406e-16
C85	VPWR#3	a_21_260#	4.3503e-18
C86	X	a_21_260##9	8.30183e-17
C87	a_21_260##8	A	1.82828e-17
C88	VPWR#3	a_21_260##7	2.89078e-18
C89	a_21_260#	A#2	7.51972e-19
C90	A	a_21_260##11	1.91967e-17
C91	X	a_21_260##8	3.93532e-17
C92	VPWR	a_21_260##9	9.8209e-18
C93	a_21_260##4	A#3	1.73569e-19
C94	a_21_260##4	a_21_260#	4.19565e-19
C95	VPWR	A#5	1.57828e-18
C96	a_21_260##4	a_21_260##7	8.44104e-18
C97	X	A#1	3.18071e-19
C98	VPWR	a_21_260##11	1.64161e-17
C99	VGND	A#5	1.75412e-18
C100	VPWR	VPWR#6	1.63035e-17
C101	X	a_21_260##5	2.05196e-18
C102	VGND#3	a_21_260##4	1.752e-21
C103	VGND	a_21_260##8	1.8536e-17
C104	X	a_21_260##6	1.5956e-18
C105	VPWR	VPWR#4	6.4194e-17
C106	VGND	X#1	1.73669e-17
C107	a_21_260##9	VNB	5.69016e-18
C108	X	A#3	1.02871e-18
C109	X	a_21_260#	1.39683e-17
C110	A#5	VNB	1.05442e-18
C111	X	a_21_260##7	9.08157e-18
C112	VGND	VPWR#4	2.91641e-18
C113	a_21_260##8	VNB	4.61733e-17
C114	VPWR	A#3	5.50132e-18
C115	VGND#6	VNB	3.87974e-18
C116	VGND	A#1	7.56462e-18
C117	X#1	VNB	2.82376e-18
C118	VGND	a_21_260##5	3.19444e-18
C119	VPWR	a_21_260#	5.27479e-19
C120	VGND#7	VNB	3.81591e-17
C121	A	A#2	1.10145e-17
C122	VGND	a_21_260##6	4.39627e-18
C123	a_21_260##11	VNB	4.62065e-17
C124	VPWR	a_21_260##7	4.27236e-19
C125	VPWR#6	VNB	4.61425e-18
C126	VPWR#4	VNB	9.42569e-17
C127	X	A#2	1.27909e-18
C128	VPWR	VPWR#3	1.21533e-17
C129	A#1	VNB	3.76323e-17
C130	a_21_260##5	VNB	2.8927e-17
C131	a_21_260##4	X	8.11093e-17
C132	a_21_260##6	VNB	3.60751e-17
C133	A#3	VNB	4.33734e-17
C134	VPWR	a_21_260##4	5.23722e-18
C135	a_21_260#	VNB	3.5841e-17
C136	VGND	VGND#3	8.94444e-18
C137	a_21_260##7	VNB	2.99471e-17
C138	VGND	a_21_260##4	1.34529e-17
C139	VPWR#3	VNB	1.35036e-16
C140	VGND#3	VNB	1.35192e-16
C141	VPWR	A	1.56068e-18
C142	A#2	VNB	5.18396e-17
C143	a_21_260##4	VNB	9.41533e-17
C144	VPWR	X	4.37624e-18
C145	VGND	A	1.62105e-18
C146	A	VNB	2.29278e-17
C147	X	VNB	5.53525e-18
C148	VPWR	VNB	5.2703e-17
C149	VGND	VNB	5.97639e-17
C150	VGND#4	a_21_260##6	8.90752e-18
C151	VGND#4	VGND#2	1.29733e-18
C152	VGND#2	VNB	4.58169e-17
C153	VGND#4	a_21_260##5	5.99544e-19
C154	VGND	VGND#2	5.14204e-17
C155	VGND#4	VNB	4.15548e-17
C156	VPWR#2	A#2	8.36374e-20
C157	VGND	VGND#4	4.70022e-17
C158	VGND#2	A#2	8.68244e-20
C159	VPWR#2	VNB	4.39675e-17
C160	VGND#3	VGND#2	4.53864e-17
C161	VPWR#4	VPWR#2	1.62343e-18
C162	VPWR#3	VPWR#2	4.61092e-17
C163	VGND#2	a_21_260##6	1.02755e-18
C164	VPWR	VPWR#2	3.25156e-17
C165	VGND#4	a_21_260##4	3.04692e-18
C166	VGND#2	a_21_260##5	4.20378e-18
C167	VGND#2	A#1	2.62985e-18
C168	VGND#3	VGND#4	4.15927e-17
C169	VGND#7	VGND#2	9.37215e-19
C170	a_21_260##11	VPWR#2	1.62345e-17
C171	VGND#2	a_21_260##8	1.50185e-17
C172	VPWR#2	A#3	4.47819e-18
*
*
.ENDS sky130_fd_sc_hs__buf_2
*
