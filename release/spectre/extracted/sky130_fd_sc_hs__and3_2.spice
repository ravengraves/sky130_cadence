* Extracted by Quantus, converted by sky130cad/quantus.py
*
*
*
*                       LINUX           Wed Nov 18 08:17:16 2026
*
*
*
*  PROGRAM  advgen
*
*  Name           : advgen - Quantus - (64-bit)
*  Version        : 25.1.0-p047
*  Build Date     : Thu Dec 11 23:20:30 PST 2025
*
*  HSPICE LIBRARY
*
*  OPERATING_TEMPERATURE 150
*  QRC_TECH_DIR <path>/tech
*
*
*

*
.SUBCKT sky130_fd_sc_hs__and3_2 VPB VNB VGND VPWR X A B C
*
*
*  caps2d version: 10
*
*
*       TRANSISTOR CARDS
*
*
XM0 a_41_384##12 A#2 a_133_136# VNB sky130_fd_pr__nfet_01v8_lvt l=0.15 w=0.64 ad=0.1824 as=0.2688 pd=1.85 ps=2.12
XM2 a_133_136# B#1 a_247_136# VNB sky130_fd_pr__nfet_01v8_lvt l=0.15 w=0.64 ad=0.2688 as=0.1536 pd=2.12 ps=1.76
XM4 a_247_136# C#3 VGND#5 VNB sky130_fd_pr__nfet_01v8_lvt l=0.15 w=0.64 ad=0.1536 as=0.34045 pd=1.76 ps=2.68
XM1 VGND#5 a_41_384##6 X#2 VNB sky130_fd_pr__nfet_01v8_lvt l=0.15 w=0.74 ad=0.34045 as=0.2368 pd=2.68 ps=2.12
XM6 X#2 a_41_384##4 VGND#2 VNB sky130_fd_pr__nfet_01v8_lvt l=0.15 w=0.74 ad=0.2368 as=0.3552 pd=2.12 ps=2.44
XM7 a_41_384##10 A#1 VPWR#7 VPB sky130_fd_pr__pfet_01v8 l=0.15 w=0.84 ad=0.2478 as=0.3528 pd=2.27 ps=2.52
XM8 VPWR#7 B#3 a_41_384##11 VPB sky130_fd_pr__pfet_01v8 l=0.15 w=0.84 ad=0.3528 as=0.252 pd=2.52 ps=2.28
XM3 a_41_384##11 C#1 VPWR#6 VPB sky130_fd_pr__pfet_01v8 l=0.15 w=0.84 ad=0.252 as=0.569 pd=2.28 ps=3.38
XM5 X#1 a_41_384##5 VPWR#6 VPB sky130_fd_pr__pfet_01v8 l=0.15 w=1.12 ad=0.336 as=0.569 pd=2.84 ps=3.38
XM9 VPWR#1 a_41_384# X#1 VPB sky130_fd_pr__pfet_01v8 l=0.15 w=1.12 ad=0.4088 as=0.336 pd=2.97 ps=2.84
*
*
*       RESISTOR AND CAP/DIODE CARDS
*
Rg1	A#1	A#2	711.427246
Rg2	A#2	A#3	341.373138
Rg3	B#1	B#2	279.244598
Rg4	B#2	B#3	354.298584
Rg5	C#1	C#2	353.154785
Rg6	C#2	C#3	278.100800
Rg7	a_41_384#	a_41_384##2	451.871674
Rg8	a_41_384##2	a_41_384##3	65.520645
Rg9	a_41_384##2	a_41_384##4	342.058960
Rg10	a_41_384##3	a_41_384##5	433.568329
Rg11	a_41_384##3	a_41_384##6	380.700043
Rf1	B#4	B	1.439107
Rf2	B#2	B#6	161.671906
Rf3	B#4	B#6	9.597501
Rf4	B#7	B	1.439107
Rf5	B#6	B#7	2.239417
Rf6	A	A#3	8.221563
Rf7	A#3	A	6.956707
Rf8	C#2	C	162.988510
Rf9	a_41_384##3	a_41_384##8	243.037628
Rf10	a_41_384##8	a_41_384##9	66.505722
Rf11	a_41_384##9	a_41_384##10	19.491049
Rf12	a_41_384##8	a_41_384##11	17.165678
Rf13	a_41_384##9	a_41_384##12	51.524689
Rf14	X#1	X	95.471245
Rf15	X	X#2	15.184011
Rf17	VGND#3	VGND#4	96.956329
Rf18	VGND#4	VGND#5	38.772522
Rf19	VGND#2	VGND#3	7.500000
Rf20	VPWR#1	VPWR#2	109.116585
Rf21	VPWR#2	VPWR#3	26.273645
Rf22	VPWR#3	VPWR#4	60.607380
Rf24	VPWR#2	VPWR#6	31.534731
Rf25	VPWR#4	VPWR#7	46.120842
Re1	VPWR#3	VPWR	1.403190
Re2	VGND	VGND#4	1.403242
*
*       CAPACITOR CARDS
*
*
C1	VPWR#2	a_41_384##2	5.97248e-20
C2	a_41_384##9	a_41_384##8	2.57322e-18
C3	a_41_384##3	a_41_384##2	2.65502e-18
C4	a_41_384##9	B#7	6.6397e-18
C5	B#7	a_41_384##8	4.53881e-17
C6	VGND#2	a_41_384##2	1.72087e-18
C7	VGND#5	a_41_384##8	3.33289e-18
C8	VPWR#2	VPWR#1	9.16231e-19
C9	X#1	VPWR#2	1.55859e-17
C10	X#2	a_41_384##2	2.18046e-17
C11	a_41_384##8	X#1	2.11601e-18
C12	X#2	VGND#2	4.92496e-17
C13	a_41_384##12	B#7	5.98749e-19
C14	a_41_384##8	VPWR#6	3.70387e-17
C15	VGND#5	VGND#2	2.97764e-18
C16	a_41_384##8	a_41_384##11	8.21897e-18
C17	VGND#5	X#2	6.89698e-17
C18	a_41_384##9	VPWR#7	6.82755e-17
C19	a_41_384##12	B#6	7.87348e-18
C20	a_41_384##8	VPWR#7	5.70389e-17
C21	a_41_384##9	a_41_384##10	4.45971e-18
C22	a_41_384##12	VGND#5	7.16853e-18
C23	X#2	X#1	3.98667e-18
C24	VPWR#2	a_41_384##5	4.62419e-18
C25	a_41_384##4	VGND#2	2.2465e-17
C26	X#1	VPWR#1	1.0995e-16
C27	X#2	a_41_384##4	3.87705e-17
C28	VPWR#6	VPWR#1	1.6e-18
C29	VGND#2	a_41_384##6	2.54531e-18
C30	VGND#5	a_41_384##4	1.41605e-18
C31	X#2	a_41_384##6	4.39665e-17
C32	VPWR#6	X#1	6.78694e-17
C33	a_41_384##9	a_41_384##5	2.46336e-20
C34	a_41_384##6	VGND#5	2.32818e-17
C35	a_41_384##8	a_41_384##5	1.35124e-18
C36	X#2	C#3	1.43925e-18
C37	B#6	A#2	2.09789e-18
C38	a_41_384##9	C#1	1.67242e-19
C39	C#3	VGND#5	2.6339e-17
C40	X#2	B#1	1.5399e-19
C41	a_41_384##8	C#1	4.36569e-17
C42	VPWR#7	VPWR#6	3.13248e-18
C43	B	a_41_384##2	5.94586e-20
C44	VGND#5	B#1	3.91035e-18
C45	a_41_384##9	B#3	1.61934e-18
C46	a_41_384##12	a_41_384##6	5.46959e-19
C47	a_41_384##8	B#3	3.8057e-17
C48	VGND#5	A#2	2.08185e-18
C49	a_41_384##12	C#3	8.04884e-19
C50	a_41_384##9	A#1	5.29023e-17
C51	X#1	a_41_384##2	2.91125e-18
C52	a_41_384##8	A#1	1.62972e-18
C53	VPWR#3	VPWR#2	3.45667e-17
C54	a_41_384##12	B#1	5.19345e-18
C55	a_41_384##12	A#2	3.69161e-17
C56	B#7	A#1	1.54328e-18
C57	a_41_384##8	VPWR#3	7.00451e-18
C58	a_41_384##3	VPWR#2	2.66551e-19
C59	B#6	A#1	1.08512e-19
C60	a_41_384##6	a_41_384##4	3.07088e-17
C61	VPWR#1	a_41_384#	3.34891e-17
C62	X#1	a_41_384#	5.83293e-17
C63	VPWR#1	a_41_384##5	1.31754e-18
C64	a_41_384##9	a_41_384##3	9.99223e-19
C65	VPWR#6	a_41_384#	1.48351e-18
C66	C#3	a_41_384##6	1.78316e-17
C67	X#1	a_41_384##5	5.5532e-17
C68	a_41_384##5	VPWR#6	2.96141e-17
C69	a_41_384##9	C#2	4.02228e-20
C70	X#1	C#1	1.51861e-18
C71	a_41_384##8	C#2	2.1369e-18
C72	B#1	C#3	4.30157e-17
C73	C#1	VPWR#6	3.00861e-17
C74	a_41_384##12	A#1	8.24204e-19
C75	VPWR#7	a_41_384##5	4.0294e-19
C76	C#1	a_41_384##11	1.78015e-17
C77	a_41_384##9	B#2	1.63783e-18
C78	VGND#4	VGND#2	3.65057e-17
C79	VPWR#6	B#3	5.84639e-19
C80	a_41_384##8	B#2	2.43165e-18
C81	VPWR#7	C#1	1.54134e-18
C82	VGND#4	X#2	1.5179e-17
C83	A#2	B#1	1.68858e-17
C84	B#7	C#2	2.26363e-18
C85	B#3	a_41_384##11	1.78015e-17
C86	VPWR#6	A#1	3.00948e-19
C87	a_41_384##9	A#3	8.12268e-19
C88	B#3	VPWR#7	2.62928e-17
C89	B#6	C#2	2.04171e-18
C90	a_41_384##3	X#2	6.74367e-17
C91	B#7	B#2	8.21494e-18
C92	VPWR#3	VPWR#1	3.0802e-17
C93	VGND#5	a_41_384##3	2.39759e-18
C94	A#1	VPWR#7	3.24332e-17
C95	B#6	B#2	7.00052e-18
C96	A#1	a_41_384##10	9.045e-18
C97	VGND#5	C#2	4.49979e-18
C98	a_41_384##3	X#1	4.17942e-17
C99	VGND#2	A#3	3.59341e-19
C100	a_41_384##5	a_41_384#	4.56538e-17
C101	a_41_384##3	VPWR#6	2.786e-17
C102	X#2	A#3	2.90658e-19
C103	VGND	a_41_384##2	2.14997e-18
C104	X#1	C#2	1.76689e-19
C105	VGND#5	A#3	2.09461e-18
C106	a_41_384##12	B#2	2.20911e-18
C107	C#2	VPWR#6	4.65236e-19
C108	C#1	a_41_384##5	1.59001e-17
C109	VGND#4	a_41_384##6	7.13286e-18
C110	a_41_384##12	A#3	7.33754e-18
C111	VGND#4	C#3	3.56503e-18
C112	B#3	C#1	3.50291e-17
C113	VGND#4	B#1	9.54308e-19
C114	B#2	VPWR#7	1.35027e-18
C115	C#3	a_41_384##3	5.47463e-18
C116	a_41_384##3	B#1	2.74506e-19
C117	VPWR#7	A#3	2.77679e-19
C118	A#1	B#3	2.14177e-17
C119	C	a_41_384##8	3.66259e-17
C120	VPWR#3	C#1	3.94021e-18
C121	a_41_384##2	VNB	3.99651e-17
C122	a_41_384##3	a_41_384#	4.35597e-19
C123	B#7	C	1.24992e-17
C124	A#3	a_41_384##6	1.14741e-18
C125	a_41_384##3	a_41_384##5	4.51107e-18
C126	B#6	C	1.59178e-17
C127	A#2	B#2	1.52395e-17
C128	A#3	B#1	7.26774e-18
C129	a_41_384##3	C#1	1.13433e-18
C130	C#2	a_41_384##5	2.44928e-18
C131	a_41_384##3	B#3	1.68334e-19
C132	C	VGND#5	1.95943e-17
C133	A	a_41_384##9	3.37745e-18
C134	A	a_41_384##8	6.03175e-19
C135	a_41_384##3	A#1	1.27916e-19
C136	C#3	a_247_136#	1.17564e-17
C137	B	X#2	3.11661e-18
C138	B#1	a_247_136#	1.18303e-17
C139	A#1	B#2	1.26232e-17
C140	B#1	a_133_136#	1.58015e-17
C141	VGND#4	a_41_384##3	1.01001e-18
C142	a_41_384##12	B	1.08252e-17
C143	VPWR#3	C#2	1.55608e-19
C144	A#2	a_133_136#	1.45015e-17
C145	A	VGND#5	2.70261e-17
C146	VPWR	VPWR#2	2.27155e-17
C147	C#2	a_41_384##3	2.65818e-17
C148	VGND#4	B#2	3.5494e-20
C149	A	a_41_384##12	4.95884e-17
C150	VPWR	a_41_384##9	1.64658e-17
C151	VPWR	a_41_384##8	1.79355e-17
C152	a_41_384##3	B#2	1.65051e-19
C153	VGND#4	A#3	1.25776e-17
C154	B	a_41_384##4	4.64368e-19
C155	B	a_41_384##6	6.12047e-19
C156	B#2	C#2	2.63593e-17
C157	VPWR	B#7	3.17919e-18
C158	B	C#3	5.17185e-18
C159	B	B#1	1.00773e-17
C160	B	A#2	3.91221e-18
C161	C	a_41_384##5	2.18405e-20
C162	A	a_41_384##6	7.76317e-19
C163	A	C#3	3.35306e-18
C164	A	B#1	1.4959e-17
C165	A	A#2	7.41542e-18
C166	VPWR	VPWR#1	4.05041e-17
C167	VPWR	X#1	1.7425e-17
C168	VPWR	VPWR#6	2.15941e-17
C169	VGND	VGND#2	5.08912e-17
C170	VPWR#2	VNB	2.70045e-17
C171	VGND	X#2	1.75369e-17
C172	B#2	a_133_136#	9.19113e-19
C173	VGND	VGND#5	1.83553e-17
C174	VGND#4	C	8.12746e-19
C175	a_41_384##9	VNB	5.17766e-17
C176	a_41_384##8	VNB	2.88008e-18
C177	C	a_41_384##3	3.01847e-17
C178	VGND	a_41_384##12	6.7685e-18
C179	VGND	VPWR#1	3.69012e-18
C180	VGND	X#1	8.22422e-19
C181	C	C#2	1.79305e-17
C182	B#7	VNB	1.20577e-18
C183	B	a_41_384##3	5.10156e-18
C184	C	B#2	2.61319e-18
C185	VGND#2	VNB	6.40267e-17
C186	B	C#2	1.09142e-18
C187	X#2	VNB	1.37285e-17
C188	VGND#4	A	9.18653e-17
C189	VPWR	a_41_384#	4.50536e-18
C190	VGND	a_41_384##4	5.96773e-18
C191	VGND#5	VNB	1.0133e-17
C192	VGND	a_41_384##6	7.86655e-18
C193	VPWR	a_41_384##5	3.20351e-18
C194	B	B#2	4.41695e-18
C195	VGND	C#3	7.31457e-18
C196	VPWR	C#1	8.56789e-18
C197	a_41_384##12	VNB	3.40261e-17
C198	VPWR#1	VNB	8.62146e-17
C199	VPWR	B#3	6.69919e-18
C200	X#1	VNB	4.82338e-18
C201	VPWR#6	VNB	6.68911e-18
C202	VPWR	A#1	7.08288e-18
C203	A	B#2	1.93558e-18
C204	VPWR#7	VNB	6.86243e-18
C205	A	A#3	4.29609e-17
C206	VPWR	VPWR#3	1.27964e-17
C207	a_41_384##4	VNB	3.1864e-17
C208	a_41_384##6	VNB	3.21992e-17
C209	B	a_133_136#	2.01403e-18
C210	C#3	VNB	3.07802e-17
C211	VPWR	a_41_384##3	3.5511e-18
C212	B#1	VNB	2.27647e-17
C213	A#2	VNB	3.47932e-17
C214	a_41_384#	VNB	3.89716e-17
C215	a_41_384##5	VNB	3.5325e-17
C216	VGND	VGND#4	6.91276e-17
C217	B	C	8.65097e-18
C218	C#1	VNB	3.56384e-17
C219	VGND	a_41_384##3	5.89089e-18
C220	B#3	VNB	3.14431e-17
C221	A#1	VNB	5.43191e-17
C222	VPWR#3	VNB	1.70509e-16
C223	VGND	A#3	7.16998e-18
C224	A	B	1.16773e-17
C225	VGND#4	VNB	2.44012e-16
C226	a_41_384##3	VNB	3.69133e-17
C227	C#2	VNB	2.07984e-17
C228	B#2	VNB	2.57836e-17
C229	VPWR	C	2.11345e-18
C230	A#3	VNB	8.3641e-17
C231	VGND	C	3.77287e-18
C232	VGND	B	5.31e-18
C233	VGND	A	4.21925e-17
C234	C	VNB	1.19051e-18
C235	A	VNB	4.4806e-17
C236	VPWR	VNB	6.41626e-17
C237	VGND	VNB	7.14064e-17
C238	VGND#3	VGND#2	4.52294e-18
C239	VPWR#4	VPWR#2	6.71009e-19
C240	VPWR#4	a_41_384##5	8.97456e-19
C241	X#2	VGND#3	2.72456e-17
C242	a_41_384##9	VPWR#4	1.10725e-17
C243	VPWR#4	B#3	2.25491e-18
C244	a_41_384##8	VPWR#4	2.77412e-18
C245	VPWR#4	A#1	1.88348e-18
C246	VPWR#3	VPWR#4	5.59797e-17
C247	VGND#3	VNB	1.95426e-17
C248	VGND#3	a_41_384##4	4.40224e-18
C249	VPWR#4	VPWR#6	2.8022e-18
C250	VPWR	VPWR#4	5.98972e-17
C251	VPWR#4	VNB	6.1781e-17
C252	VGND#3	VPWR#1	1.29793e-17
*
*
.ENDS sky130_fd_sc_hs__and3_2
*
