* Extracted by Quantus, converted by sky130cad/quantus.py
*
*
*
*                       LINUX           Wed Nov 18 09:08:21 2026
*
*
*
*  PROGRAM  advgen
*
*  Name           : advgen - Quantus - (64-bit)
*  Version        : 25.1.0-p047
*  Build Date     : Thu Dec 11 23:20:30 PST 2025
*
*  HSPICE LIBRARY
*
*  OPERATING_TEMPERATURE 150
*  QRC_TECH_DIR <path>/tech
*
*
*

*
.SUBCKT sky130_fd_sc_hs__or4bb_2 VNB VPB VGND VPWR X B C_N D_N A
*
*
*  caps2d version: 10
*
*
*       TRANSISTOR CARDS
*
*
XM14 a_27_424##7 D_N#1 VGND#11 VNB sky130_fd_pr__nfet_01v8_lvt l=0.15 w=0.55 ad=0.15675 as=0.25585 pd=1.67 ps=2.21
XM11 VGND#11 a_182_270##6 X#2 VNB sky130_fd_pr__nfet_01v8_lvt l=0.15 w=0.74 ad=0.25585 as=0.2072 pd=2.21 ps=2.04
XM15 X#2 a_182_270##5 VGND#10 VNB sky130_fd_pr__nfet_01v8_lvt l=0.15 w=0.74 ad=0.2072 as=0.3994 pd=2.04 ps=2.65
XM13 VGND#10 a_27_424##3 a_182_270##10 VNB sky130_fd_pr__nfet_01v8_lvt l=0.15 w=0.64 ad=0.3994 as=0.3336 pd=2.65 ps=2.41
XM6 a_182_270##10 a_548_110##3 VGND#9 VNB sky130_fd_pr__nfet_01v8_lvt l=0.15 w=0.64 ad=0.3336 as=0.2496 pd=2.41 ps=2.06
XM4 VGND#9 B#2 a_182_270##7 VNB sky130_fd_pr__nfet_01v8_lvt l=0.15 w=0.64 ad=0.2496 as=0.1856 pd=2.06 ps=1.86
XM9 a_182_270##7 A#1 VGND#8 VNB sky130_fd_pr__nfet_01v8_lvt l=0.15 w=0.64 ad=0.1856 as=0.259875 pd=1.86 ps=2.45
XM12 VGND#8 C_N#4 a_548_110##7 VNB sky130_fd_pr__nfet_01v8_lvt l=0.15 w=0.55 ad=0.259875 as=0.15675 pd=2.45 ps=1.67
XM3 a_27_424##6 D_N#3 VPWR#9 VPB sky130_fd_pr__pfet_01v8 l=0.15 w=0.84 ad=0.2394 as=0.3724 pd=2.25 ps=2.95
XM8 VPWR#9 a_182_270##4 X#1 VPB sky130_fd_pr__pfet_01v8 l=0.15 w=1.12 ad=0.3724 as=0.336 pd=2.95 ps=2.84
XM0 X#1 a_182_270# VPWR#8 VPB sky130_fd_pr__pfet_01v8 l=0.15 w=1.12 ad=0.336 as=0.3192 pd=2.84 ps=2.81
XM2 a_182_270##11 a_27_424# a_503_392# VPB sky130_fd_pr__pfet_01v8 l=0.15 w=1 ad=0.285 as=0.27 pd=2.57 ps=2.54
XM5 a_503_392# a_548_110# a_587_392# VPB sky130_fd_pr__pfet_01v8 l=0.15 w=1 ad=0.27 as=0.36 pd=2.54 ps=2.72
XM1 a_587_392# B#1 a_689_392# VPB sky130_fd_pr__pfet_01v8 l=0.15 w=1 ad=0.36 as=0.24 pd=2.72 ps=2.48
XM7 a_689_392# A#3 VPWR#7 VPB sky130_fd_pr__pfet_01v8 l=0.15 w=1 ad=0.24 as=0.3748 pd=2.48 ps=2.78
XM10 VPWR#7 C_N#3 a_548_110##4 VPB sky130_fd_pr__pfet_01v8 l=0.15 w=0.84 ad=0.3748 as=0.2436 pd=2.78 ps=2.26
*
*
*       RESISTOR AND CAP/DIODE CARDS
*
Rg1	D_N#1	D_N#2	250.704742
Rg2	D_N#2	D_N#3	474.670807
Rg3	a_182_270#	a_182_270##2	426.210968
Rg4	a_182_270##2	a_182_270##3	114.952988
Rg5	a_182_270##3	a_182_270##4	478.422913
Rg6	a_182_270##2	a_182_270##5	299.509430
Rg7	a_182_270##3	a_182_270##6	309.526886
Rg8	a_27_424#	a_27_424##2	439.661804
Rg9	a_27_424##2	a_27_424##3	346.854279
Rg10	a_548_110#	a_548_110##2	400.207520
Rg11	a_548_110##2	a_548_110##3	302.199066
Rg12	B#1	B#2	774.737183
Rg13	B#2	B#3	279.244598
Rg14	A#1	A#2	302.199066
Rg15	A#2	A#3	400.207520
Rg16	C_N#1	C_N#2	27.660566
Rg17	C_N#2	C_N#3	444.135834
Rg18	C_N#2	C_N#4	374.601227
Rf1	D_N#4	D_N#2	162.448425
Rf2	D_N	D_N#6	2.215620
Rf3	D_N#4	D_N#6	4.635897
Rf4	X	X#1	84.591171
Rf5	X	X#3	4.771111
Rf6	X#3	X	13.811110
Rf7	X#2	X#3	7.500000
Rf8	a_27_424##2	a_27_424##5	282.016144
Rf9	a_27_424##5	a_27_424##6	33.837097
Rf10	a_27_424##5	a_27_424##7	125.175735
Rf11	B#3	B	171.289017
Rf12	a_182_270##7	a_182_270##8	86.879440
Rf13	a_182_270##8	a_182_270##2	231.675720
Rf14	a_182_270##8	a_182_270##10	19.485615
Rf15	a_182_270##8	a_182_270##11	133.354431
Rf16	A#2	A	169.484116
Rf17	a_548_110##4	a_548_110##5	21.886322
Rf18	a_548_110##5	a_548_110##2	264.279144
Rf19	a_548_110##5	a_548_110##7	117.764923
Rf20	C_N	C_N#1	170.095932
Rf22	VGND#2	VGND#3	87.368851
Rf23	VGND#3	VGND#4	36.258038
Rf24	VGND#4	VGND#5	43.399704
Rf25	VGND#5	VGND#6	76.670494
Rf27	VGND#2	VGND#8	35.688515
Rf28	VGND#3	VGND#9	67.668427
Rf29	VGND#5	VGND#10	35.204811
Rf30	VGND#6	VGND#11	44.445877
Rf32	VPWR#2	VPWR#3	115.760506
Rf33	VPWR#3	VPWR#4	52.937077
Rf34	VPWR#4	VPWR#5	66.061630
Rf36	VPWR#2	VPWR#7	33.109421
Rf37	VPWR#4	VPWR#8	32.735970
Rf38	VPWR#5	VPWR#9	32.735970
Re1	VPWR#3	VPWR	0.982218
Re2	VGND	VGND#4	0.982254
*
*       CAPACITOR CARDS
*
*
C1	VPWR#9	VPWR#8	1.15603e-17
C2	VGND	VNB	6.85542e-17
C3	VPWR	VNB	6.37678e-17
C4	X	VNB	3.0627e-18
C5	C_N	VNB	1.46604e-17
C6	A	VNB	1.56559e-18
C7	VPWR#3	VPWR#4	3.42658e-17
C8	VGND	X	1.34043e-17
C9	a_182_270##5	X#2	2.44675e-20
C10	D_N#2	VNB	5.36069e-17
C11	a_182_270##2	VNB	3.03559e-17
C12	a_27_424##2	VNB	5.44833e-17
C13	a_548_110##2	VNB	2.5731e-17
C14	B#3	VNB	6.12464e-17
C15	A#2	VNB	2.48671e-17
C16	C_N#1	VNB	1.17958e-17
C17	VGND#4	VNB	2.16644e-16
C18	VPWR#3	VNB	2.35732e-16
C19	D_N#3	VNB	5.08307e-17
C20	VGND	A	1.66098e-18
C21	a_182_270##4	VNB	3.33647e-17
C22	VPWR	C_N	3.46688e-18
C23	a_182_270#	VNB	3.93517e-17
C24	a_27_424#	VNB	3.74169e-17
C25	D_N#6	a_182_270##3	1.26659e-19
C26	a_548_110#	VNB	3.01139e-17
C27	B#1	VNB	3.83953e-17
C28	A#3	VNB	2.92014e-17
C29	C_N#3	VNB	4.7967e-17
C30	D_N#1	VNB	3.66404e-17
C31	VPWR	A	1.36277e-18
C32	a_182_270##6	VNB	2.90442e-17
C33	a_182_270##5	VNB	3.05108e-17
C34	a_27_424##3	VNB	3.5184e-17
C35	a_548_110##3	VNB	2.79272e-17
C36	B#2	VNB	2.50899e-17
C37	A#1	VNB	2.2896e-17
C38	C_N#4	VNB	3.53848e-17
C39	a_27_424##6	VNB	4.98695e-17
C40	VPWR#9	VNB	1.63928e-18
C41	X#1	VNB	4.71756e-19
C42	VPWR#8	VNB	5.91916e-18
C43	a_182_270##11	VNB	5.96894e-18
C44	VPWR#7	VNB	7.13991e-18
C45	a_182_270##5	VGND#10	2.65507e-17
C46	a_27_424##7	VNB	3.38824e-17
C47	VGND	a_182_270##2	6.42907e-18
C48	VGND#11	VNB	1.26249e-17
C49	VGND#10	VNB	6.36355e-18
C50	VGND	a_27_424##2	2.91125e-18
C51	a_182_270##8	a_548_110#	8.85369e-19
C52	D_N#4	a_27_424##5	7.0219e-18
C53	VGND#9	VNB	1.59501e-18
C54	VGND	a_548_110##2	2.54841e-18
C55	VGND#8	VNB	6.67244e-18
C56	a_548_110##7	VNB	3.97654e-17
C57	D_N#4	VNB	1.09127e-17
C58	VGND	B#3	2.482e-17
C59	D_N#6	VNB	9.96045e-18
C60	VGND	A#2	3.36745e-18
C61	a_27_424##5	VNB	1.01609e-17
C62	VGND	C_N#1	3.52875e-18
C63	a_182_270##8	VNB	9.32961e-18
C64	VGND	VGND#4	1.13568e-17
C65	VPWR	a_182_270##2	3.47798e-18
C66	a_548_110##5	VNB	4.69277e-17
C67	VPWR	a_27_424##2	7.15528e-18
C68	a_548_110##5	a_27_424#	2.51155e-19
C69	VGND#3	VNB	3.01417e-17
C70	VGND#5	VNB	3.57154e-17
C71	VPWR	a_548_110##2	1.20462e-17
C72	VPWR#4	VNB	2.90819e-17
C73	X	D_N#2	8.01026e-20
C74	VPWR	A#2	1.13158e-18
C75	X	a_182_270##2	2.56341e-17
C76	VPWR	VPWR#3	2.73003e-17
C77	X	B#3	6.4547e-20
C78	VPWR	D_N#3	5.88669e-19
C79	VGND	D_N#1	7.18153e-18
C80	a_27_424##3	VGND#10	2.52395e-17
C81	VGND	a_182_270##6	5.74164e-18
C82	VPWR	a_182_270##4	5.52948e-19
C83	VGND	a_182_270##5	8.03001e-18
C84	a_182_270##8	a_548_110##7	2.18993e-19
C85	VPWR	a_182_270#	3.69817e-19
C86	VGND	a_27_424##3	7.0766e-18
C87	VPWR	a_27_424#	4.79885e-19
C88	VGND	a_548_110##3	1.82864e-18
C89	VPWR	a_548_110#	1.49017e-18
C90	VGND	A#1	3.4389e-18
C91	VPWR	B#1	1.57213e-18
C92	VGND	C_N#4	4.10985e-18
C93	VGND#9	a_182_270##5	2.39142e-19
C94	VPWR	A#3	7.60823e-19
C95	VPWR	C_N#3	6.98585e-18
C96	VGND	X#1	1.87879e-18
C97	VPWR#8	a_182_270##11	3.12229e-17
C98	a_27_424##3	a_182_270##10	9.96944e-18
C99	a_548_110##5	a_548_110#	3.9647e-19
C100	a_182_270##7	a_548_110##5	1.18942e-19
C101	VGND	a_27_424##7	1.48509e-17
C102	a_182_270##3	VNB	1.96023e-17
C103	C_N#2	VNB	7.07914e-17
C104	VGND#10	a_548_110##3	1.05406e-18
C105	VGND#11	VGND#5	1.43946e-18
C106	VPWR	a_27_424##6	1.70576e-17
C107	VGND	VGND#9	3.25153e-18
C108	VPWR	VPWR#9	1.81809e-17
C109	a_548_110##2	A	1.58557e-17
C110	VGND	a_182_270##7	6.94587e-18
C111	X	D_N#1	2.07505e-18
C112	VPWR	X#1	2.57895e-18
C113	X	a_182_270##6	2.0648e-17
C114	VGND	a_548_110##7	1.53831e-17
C115	VPWR	VPWR#8	1.8262e-17
C116	VGND#9	a_27_424##3	1.70243e-18
C117	VGND	D_N#4	3.6801e-18
C118	X	a_182_270##5	1.45808e-17
C119	VPWR	a_182_270##11	2.15184e-17
C120	D_N#6	a_27_424##5	1.75692e-17
C121	X	a_27_424##3	1.41364e-18
C122	A	A#2	7.53266e-18
C123	X	a_548_110##3	1.92814e-19
C124	a_548_110##3	a_182_270##10	7.52462e-18
C125	VPWR	VPWR#7	2.12945e-17
C126	VGND	a_182_270##8	1.85988e-17
C127	a_548_110##5	B#1	8.20081e-19
C128	a_182_270##7	a_27_424##3	1.85143e-19
C129	VGND#8	a_548_110##5	3.01355e-18
C130	X	X#1	1.06187e-18
C131	VGND	VGND#3	3.46316e-17
C132	VGND	VGND#5	5.30913e-17
C133	VGND#9	a_548_110##3	3.1846e-17
C134	a_548_110##2	a_503_392#	2.61809e-18
C135	VPWR	D_N#6	3.94123e-18
C136	a_27_424##7	a_27_424##6	5.69246e-19
C137	a_27_424##7	X	4.15036e-17
C138	VPWR	a_27_424##5	1.12829e-17
C139	VGND#11	X	3.45544e-17
C140	VGND#10	VGND#3	8.76379e-19
C141	X	X#2	2.28247e-18
C142	a_548_110##2	a_587_392#	8.04977e-18
C143	X	VGND#10	3.01812e-17
C144	a_182_270##7	a_548_110##3	8.27326e-19
C145	A	B#1	4.61243e-18
C146	VPWR	a_548_110##5	2.03898e-17
C147	a_548_110##5	A#3	2.08889e-17
C148	a_548_110##2	a_689_392#	9.85603e-20
C149	a_548_110##7	a_548_110##5	2.07365e-18
C150	B#2	VGND#9	1.62667e-17
C151	VGND#8	a_548_110##3	2.6968e-19
C152	VPWR	VPWR#4	2.47507e-17
C153	a_182_270##2	a_27_424##2	5.65272e-17
C154	a_182_270##7	B#2	4.92763e-17
C155	X	a_182_270##8	2.40144e-18
C156	a_27_424##7	a_182_270##3	4.12448e-18
C157	VPWR#4	a_182_270#	3.99217e-18
C158	a_182_270##2	a_548_110##2	3.42572e-20
C159	VGND#9	A#1	8.16026e-19
C160	a_548_110##7	a_548_110##3	9.17977e-20
C161	A	B#2	4.82037e-18
C162	a_548_110##5	C_N#3	4.0331e-17
C163	a_27_424##7	X#1	9.3029e-18
C164	a_27_424##2	a_548_110##2	3.39375e-17
C165	a_182_270##11	VPWR#7	1.08755e-17
C166	VGND#8	B#2	6.58405e-19
C167	a_27_424#	a_503_392#	1.98266e-17
C168	VGND#5	X	3.95383e-18
C169	a_548_110#	a_503_392#	7.88445e-18
C170	a_182_270##7	A#1	3.30141e-17
C171	a_548_110##2	B#3	5.45987e-19
C172	VGND#9	C_N#4	3.74561e-19
C173	a_548_110##7	B#2	1.52252e-19
C174	VGND#4	a_182_270##2	4.30044e-22
C175	a_548_110#	a_587_392#	2.82122e-17
C176	VGND#3	VGND#9	1.61255e-18
C177	a_548_110##2	A#2	1.21044e-18
C178	B#1	a_587_392#	2.79751e-17
C179	A#1	VGND#8	1.1144e-17
C180	VGND#4	a_27_424##2	1.35572e-19
C181	a_182_270##7	C_N#4	2.37092e-18
C182	VPWR#3	a_27_424##2	6.30952e-20
C183	D_N#2	a_182_270##4	7.2443e-18
C184	a_182_270##8	a_182_270##6	2.04945e-19
C185	B#1	a_689_392#	2.24607e-17
C186	a_548_110##7	A#1	5.99579e-18
C187	VGND	C_N#2	1.39769e-18
C188	A#3	a_689_392#	2.24607e-17
C189	a_548_110##2	VPWR#3	2.71654e-18
C190	a_182_270##4	a_182_270##2	2.21897e-18
C191	VGND#8	C_N#4	3.04555e-17
C192	a_548_110##5	C_N	4.54151e-17
C193	a_27_424##2	D_N#3	1.26122e-19
C194	a_27_424##5	a_182_270##3	2.65228e-18
C195	a_27_424##2	a_182_270##4	4.96887e-19
C196	a_182_270##7	A	3.05936e-17
C197	a_182_270##8	a_182_270##5	1.17795e-18
C198	A#1	C_N#2	8.67246e-18
C199	a_182_270#	a_27_424##2	6.74958e-18
C200	a_548_110##7	C_N#4	2.49977e-17
C201	a_27_424##2	a_27_424#	1.0895e-17
C202	a_27_424#	a_548_110##2	5.62085e-18
C203	a_182_270##8	a_27_424##3	3.5148e-17
C204	a_548_110##2	a_548_110#	1.11492e-17
C205	a_182_270##11	a_503_392#	1.25621e-18
C206	a_548_110##2	B#1	4.63988e-17
C207	A	a_548_110##5	2.3256e-17
C208	D_N#2	a_182_270##3	1.64198e-17
C209	a_548_110##2	A#3	2.40829e-19
C210	a_182_270##2	a_182_270##6	6.38804e-19
C211	a_182_270##3	X#2	3.75895e-19
C212	a_548_110##2	C_N#3	1.97198e-19
C213	a_182_270##2	a_182_270##5	2.95287e-18
C214	a_182_270##8	a_548_110##3	2.82772e-17
C215	a_182_270##2	a_27_424##3	2.7902e-18
C216	B#1	A#2	1.59206e-17
C217	a_182_270##2	a_548_110##3	1.07666e-19
C218	D_N#6	a_27_424##6	2.17699e-17
C219	A#2	C_N#3	6.37069e-18
C220	a_27_424##6	D_N#2	2.89051e-18
C221	VPWR#3	a_27_424#	4.84764e-18
C222	D_N#3	a_182_270##4	3.61097e-17
C223	a_182_270##8	B#2	7.53906e-19
C224	a_27_424##2	a_548_110##3	8.08609e-19
C225	VPWR#3	a_548_110#	8.59647e-18
C226	X#1	D_N#2	8.93501e-19
C227	a_182_270##5	B#3	4.8428e-19
C228	a_548_110##5	a_548_110##3	2.17748e-21
C229	a_182_270##4	a_182_270#	4.87936e-17
C230	X	a_182_270##3	2.89045e-18
C231	a_27_424##3	B#3	1.0896e-18
C232	a_548_110##2	B#2	1.92849e-17
C233	a_182_270##3	a_182_270##2	3.67771e-18
C234	a_182_270##8	A#1	3.64534e-20
C235	X#1	a_182_270##2	3.3163e-17
C236	a_548_110##3	B#3	9.89974e-18
C237	a_182_270##2	VPWR#8	2.69322e-18
C238	VGND#5	a_182_270##6	6.56706e-19
C239	a_27_424##7	VGND#11	4.74234e-17
C240	B#3	B#2	2.08209e-18
C241	a_182_270#	a_27_424#	5.5701e-18
C242	X#1	a_27_424##2	1.29998e-17
C243	a_548_110##5	B#2	2.39693e-19
C244	B#3	A#1	1.28963e-17
C245	a_182_270##8	a_548_110##5	6.8463e-19
C246	VGND#3	a_182_270##5	2.09157e-19
C247	a_27_424##2	VPWR#8	2.38515e-17
C248	B#2	A#2	1.65819e-17
C249	B#3	C_N#4	4.1194e-18
C250	a_182_270##8	a_503_392#	5.35717e-20
C251	a_27_424##2	a_182_270##11	7.64333e-17
C252	a_182_270##8	C_N#2	9.49594e-20
C253	a_27_424##7	D_N#2	6.49977e-18
C254	VGND#5	a_182_270##5	7.20495e-18
C255	a_27_424#	a_548_110#	5.17832e-17
C256	VGND#4	a_27_424##3	1.17459e-18
C257	a_27_424##5	VPWR#9	4.87488e-17
C258	a_548_110##5	A#1	7.80445e-21
C259	VGND#4	a_548_110##3	9.77783e-20
C260	a_182_270##11	a_548_110##2	2.38393e-17
C261	a_27_424##2	a_182_270##3	6.96523e-20
C262	a_548_110#	B#1	3.78321e-17
C263	VGND#5	a_27_424##3	2.58053e-18
C264	a_182_270##2	X#2	2.00477e-20
C265	a_27_424##5	X#1	8.45135e-17
C266	VGND#11	VGND#10	1.51926e-18
C267	a_182_270##2	VGND#10	3.62246e-17
C268	VGND#4	C_N#4	3.52486e-20
C269	VGND#3	a_548_110##3	1.12779e-18
C270	B#1	A#3	6.22726e-17
C271	D_N#4	D_N#2	1.41424e-17
C272	VGND#10	a_27_424##2	1.2126e-18
C273	a_27_424##5	VPWR#8	2.25478e-17
C274	a_548_110##5	a_689_392#	4.65399e-18
C275	a_27_424##2	a_182_270##10	5.39342e-19
C276	D_N#6	D_N#2	1.23842e-17
C277	A#3	C_N#3	2.68259e-17
C278	A#2	VPWR#7	1.12603e-18
C279	C_N	C_N#2	1.24032e-17
C280	a_27_424##5	D_N#2	4.87952e-18
C281	X#1	a_182_270##3	8.25976e-18
C282	VPWR#4	a_182_270##3	1.153e-21
C283	a_548_110##7	a_27_424##2	2.26834e-20
C284	a_548_110##2	VGND#9	2.61588e-18
C285	a_27_424##6	D_N#3	5.0981e-17
C286	VGND#10	B#3	7.23104e-19
C287	a_182_270##11	VPWR#3	2.30304e-17
C288	a_182_270##7	a_548_110##2	2.08695e-17
C289	D_N#3	VPWR#9	2.49864e-17
C290	a_182_270##2	a_27_424##5	9.30765e-18
C291	a_27_424##6	a_182_270##4	1.12897e-18
C292	VGND#9	B#3	3.04147e-17
C293	X#1	D_N#3	5.2135e-19
C294	a_182_270##8	a_182_270##11	1.63565e-18
C295	VGND#10	VGND#9	4.01856e-18
C296	VPWR#9	a_182_270##4	3.6298e-17
C297	a_182_270##2	a_182_270##8	3.78706e-18
C298	B#3	a_182_270##7	3.05669e-17
C299	a_27_424##6	a_182_270#	1.93705e-19
C300	B#3	VGND#8	3.43562e-17
C301	X#1	a_182_270##4	3.52562e-17
C302	D_N#4	a_27_424##7	5.61472e-17
C303	a_27_424##5	a_27_424##2	1.75567e-18
C304	a_182_270##11	D_N#3	1.00046e-19
C305	VGND#3	a_182_270##8	4.04093e-19
C306	VPWR#9	a_182_270#	4.70317e-18
C307	VPWR#8	a_182_270##4	3.21578e-18
C308	a_27_424##6	a_27_424#	9.60646e-20
C309	a_182_270##8	a_27_424##2	8.53491e-17
C310	D_N#1	a_182_270##6	2.30437e-17
C311	X#1	a_182_270#	3.50811e-17
C312	VGND#8	A#2	2.52133e-18
C313	a_182_270##11	a_182_270##4	7.95023e-20
C314	VPWR#8	a_182_270#	4.89289e-17
C315	VGND#5	a_182_270##8	4.04732e-19
C316	X#1	a_27_424#	1.38756e-18
C317	a_548_110##5	a_27_424##2	1.43507e-20
C318	a_182_270##7	C_N#2	4.99994e-19
C319	a_182_270##11	a_182_270#	2.63945e-18
C320	a_182_270##8	a_548_110##2	7.19001e-17
C321	a_182_270##6	a_182_270##5	3.78236e-17
C322	a_548_110##5	C_N#2	1.25883e-17
C323	VPWR#8	a_27_424#	2.97228e-18
C324	a_548_110##7	C_N#1	3.18656e-17
C325	a_182_270##7	VGND#9	3.0363e-17
C326	a_182_270##11	a_27_424#	5.87367e-17
C327	VGND#5	a_182_270##2	7.70317e-19
C328	VPWR#8	a_548_110#	6.16041e-19
C329	a_548_110##2	a_548_110##5	2.33779e-18
C330	a_182_270##5	a_27_424##3	1.25709e-17
C331	VGND#9	VGND#8	3.64586e-18
C332	a_182_270##11	a_548_110#	1.36378e-17
C333	A#2	C_N#2	2.95146e-17
C334	VPWR#8	B#1	3.28723e-19
C335	VPWR#4	a_182_270##2	5.68815e-20
C336	a_182_270##11	B#1	3.66621e-18
C337	a_182_270##8	A#2	1.85284e-20
C338	VGND#9	a_548_110##7	6.22146e-19
C339	VPWR#8	A#3	1.85714e-19
C340	a_27_424##5	VPWR#4	1.98185e-18
C341	a_27_424##7	a_27_424##5	1.52623e-18
C342	a_27_424##3	a_548_110##3	1.68331e-17
C343	VPWR#7	a_27_424#	1.30764e-18
C344	VGND#3	a_548_110##2	4.76532e-20
C345	a_182_270##11	A#3	1.46126e-18
C346	A#2	a_548_110##5	6.24314e-17
C347	a_182_270##7	a_548_110##7	2.21026e-17
C348	VPWR#7	a_548_110#	2.45753e-18
C349	a_27_424##2	VPWR#4	1.95693e-18
C350	a_182_270##11	C_N#3	2.90085e-19
C351	a_548_110##3	B#2	1.93945e-17
C352	VGND#3	B#3	4.79676e-17
C353	C_N#1	C_N#2	1.24438e-17
C354	VPWR#7	B#1	5.83027e-18
C355	a_548_110##7	VGND#8	4.75079e-17
C356	a_548_110##5	C_N#1	1.04066e-17
C357	VGND#4	a_182_270##8	9.35522e-18
C358	VGND#5	B#3	1.2771e-18
C359	a_548_110##5	VPWR#7	7.75811e-17
C360	VPWR#7	A#3	5.48043e-17
C361	a_548_110##7	C_N#2	1.33571e-17
C362	B#2	A#1	3.02532e-17
C363	a_548_110##5	a_548_110##4	4.39724e-18
C364	C_N#3	VPWR#7	2.53161e-17
C365	VGND#4	a_182_270##3	8.06332e-21
C366	C_N#3	a_548_110##4	8.90308e-18
C367	A#1	C_N#4	2.04154e-17
C368	D_N#4	a_182_270##3	7.66615e-19
C369	D_N#6	a_182_270##4	2.66226e-19
C370	a_27_424##5	D_N#3	2.78795e-18
C371	a_182_270##8	VGND#10	2.38908e-17
C372	VGND#4	VGND#3	3.24477e-17
C373	a_27_424##5	a_182_270##4	2.6497e-17
C374	VGND#4	VGND#5	3.89594e-17
C375	a_27_424##7	D_N#1	3.73642e-17
C376	a_182_270##8	a_182_270##10	1.99596e-17
C377	a_182_270##11	VPWR#4	2.34802e-18
C378	a_27_424##5	a_182_270#	2.59326e-17
C379	a_27_424##6	VPWR#9	3.33144e-17
C380	D_N#1	VGND#11	2.00982e-17
C381	a_27_424##7	a_182_270##6	6.87254e-18
C382	a_182_270##8	VGND#9	5.48041e-17
C383	a_182_270##8	a_182_270#	5.93639e-20
C384	a_182_270##6	VGND#11	1.92197e-17
C385	a_27_424##5	a_27_424#	3.77926e-19
C386	a_182_270##6	X#2	1.49803e-17
C387	a_182_270##8	a_182_270##7	2.28002e-18
C388	VGND#11	a_182_270##5	1.17498e-18
C389	VGND#5	VGND#3	2.68909e-18
C390	a_182_270##8	a_27_424#	2.25012e-18
C391	VGND#10	a_182_270##6	2.57899e-18
C392	VPWR	VPWR#2	5.11355e-17
C393	VGND#2	A#1	3.132e-18
C394	VGND#6	a_27_424##7	8.00875e-18
C395	VGND#6	VNB	5.46824e-17
C396	VPWR#2	C_N#3	4.25391e-18
C397	VPWR#5	VPWR#4	1.39595e-18
C398	VGND	VGND#6	5.26471e-17
C399	VPWR#5	a_182_270##3	5.57285e-20
C400	VPWR	VPWR#5	3.69725e-17
C401	VPWR#2	VNB	6.34275e-17
C402	VGND#3	VGND#2	7.97817e-19
C403	VGND#6	D_N#1	1.80932e-18
C404	VGND#4	VGND#2	5.79982e-17
C405	a_27_424##5	VPWR#5	1.97381e-18
C406	VGND#2	A#2	6.5599e-19
C407	VGND#6	X	6.22954e-18
C408	VPWR#5	VNB	4.87583e-17
C409	VGND#6	VGND#5	2.49099e-18
C410	VGND#6	a_182_270##2	6.87367e-22
C411	VPWR#2	A#3	4.05991e-18
C412	VPWR#5	D_N#2	5.43169e-20
C413	VGND#2	C_N#4	1.06286e-18
C414	VPWR#5	a_182_270##4	4.1331e-18
C415	VPWR#2	C_N#2	4.20044e-19
C416	a_548_110##5	VPWR#2	1.25821e-17
C417	VGND#4	VGND#6	5.31956e-17
C418	a_548_110##2	VPWR#2	1.49801e-18
C419	VPWR#3	VPWR#5	5.26695e-17
C420	VPWR#3	VPWR#2	6.9682e-17
C421	VGND#6	a_182_270##3	3.35564e-20
C422	VGND#2	C_N#1	5.01029e-19
C423	VGND#2	B#3	2.65006e-17
C424	VGND#6	a_182_270##6	4.19733e-18
C425	C_N	VPWR#2	4.68735e-19
C426	VGND#6	D_N#2	1.53619e-19
C427	a_27_424##6	VPWR#5	2.1332e-17
C428	VGND#2	A	9.06063e-20
C429	VGND#2	a_548_110##7	1.35854e-17
C430	VPWR#2	B#1	8.65606e-18
C431	VGND#2	a_182_270##7	9.58493e-19
C432	VGND#2	C_N#2	3.17026e-19
C433	VGND	VGND#2	5.42213e-17
C434	VPWR#5	D_N#3	5.57133e-18
C435	VGND#2	VNB	5.4051e-17
*
*
.ENDS sky130_fd_sc_hs__or4bb_2
*
