* Extracted by Quantus, converted by sky130cad/quantus.py
*
*
*
*                       LINUX           Wed Nov 18 08:32:44 2026
*
*
*
*  PROGRAM  advgen
*
*  Name           : advgen - Quantus - (64-bit)
*  Version        : 25.1.0-p047
*  Build Date     : Thu Dec 11 23:20:30 PST 2025
*
*  HSPICE LIBRARY
*
*  OPERATING_TEMPERATURE 150
*  QRC_TECH_DIR <path>/tech
*
*
*

*
.SUBCKT sky130_fd_sc_hs__dlxbn_1 VPB VNB VGND VPWR Q Q_N D GATE_N
*
*
*  caps2d version: 10
*
*
*       TRANSISTOR CARDS
*
*
XM14 a_27_120##5 D#3 VGND#13 VNB sky130_fd_pr__nfet_01v8_lvt l=0.15 w=0.55 ad=0.15675 as=0.37805 pd=1.67 ps=2.82
XM10 VGND#13 GATE_N#3 a_232_82##11 VNB sky130_fd_pr__nfet_01v8_lvt l=0.15 w=0.74 ad=0.37805 as=0.2109 pd=2.82 ps=2.05
XM12 a_343_80##9 a_232_82##4 VGND#12 VNB sky130_fd_pr__nfet_01v8_lvt l=0.15 w=0.74 ad=0.3182 as=0.361275 pd=2.34 ps=2.78
XM13 VGND#12 a_27_120# a_575_79# VNB sky130_fd_pr__nfet_01v8_lvt l=0.15 w=0.64 ad=0.361275 as=0.1536 pd=2.78 ps=1.76
XM11 a_575_79# a_232_82##7 a_653_79##7 VNB sky130_fd_pr__nfet_01v8_lvt l=0.15 w=0.64 ad=0.1536 as=0.4099 pd=1.76 ps=2.97
XM0 a_653_79##7 a_343_80##3 a_852_123# VNB sky130_fd_pr__nfet_01v8_lvt l=0.15 w=0.42 ad=0.4099 as=0.1008 pd=2.97 ps=1.32
XM15 a_852_123# a_863_294# VGND#11 VNB sky130_fd_pr__nfet_01v8_lvt l=0.15 w=0.42 ad=0.1008 as=0.279675 pd=1.32 ps=2.32
XM19 VGND#11 a_653_79##3 a_863_294##11 VNB sky130_fd_pr__nfet_01v8_lvt l=0.15 w=0.74 ad=0.279675 as=0.2183 pd=2.32 ps=2.07
XM17 Q#1 a_863_294##9 VGND#10 VNB sky130_fd_pr__nfet_01v8_lvt l=0.15 w=0.74 ad=0.2109 as=0.2455 pd=2.05 ps=2.2
XM6 VGND#10 a_863_294##4 a_1347_424##8 VNB sky130_fd_pr__nfet_01v8_lvt l=0.15 w=0.55 ad=0.2455 as=0.15675 pd=2.2 ps=1.67
XM21 VGND#9 a_1347_424# Q_N#3 VNB sky130_fd_pr__nfet_01v8_lvt l=0.15 w=0.74 ad=0.2109 as=0.2072 pd=2.05 ps=2.04
XM3 a_27_120##7 D#1 VPWR#11 VPB sky130_fd_pr__pfet_01v8 l=0.15 w=0.84 ad=0.294 as=0.294 pd=2.38 ps=2.38
XM7 VPWR#11 GATE_N#1 a_232_82##12 VPB sky130_fd_pr__pfet_01v8 l=0.15 w=0.84 ad=0.294 as=0.2478 pd=2.38 ps=2.27
XM16 a_343_80##7 a_232_82# VPWR#9 VPB sky130_fd_pr__pfet_01v8 l=0.15 w=0.84 ad=0.2478 as=0.3806 pd=2.27 ps=2.79
XM18 VPWR#9 a_27_120##3 a_571_392# VPB sky130_fd_pr__pfet_01v8 l=0.15 w=1 ad=0.3806 as=0.27 pd=2.79 ps=2.54
XM20 a_571_392# a_343_80# a_653_79##6 VPB sky130_fd_pr__pfet_01v8 l=0.15 w=1 ad=0.27 as=0.4057 pd=2.54 ps=3.2
XM8 a_653_79##6 a_232_82##5 a_805_392# VPB sky130_fd_pr__pfet_01v8 l=0.15 w=0.42 ad=0.4057 as=0.1407 pd=3.2 ps=1.51
XM2 a_805_392# a_863_294##3 VPWR#6 VPB sky130_fd_pr__pfet_01v8 l=0.15 w=0.42 ad=0.1407 as=0.445 pd=1.51 ps=3.39
XM4 VPWR#6 a_653_79# a_863_294##15 VPB sky130_fd_pr__pfet_01v8 l=0.15 w=1.12 ad=0.445 as=0.3136 pd=3.39 ps=2.8
XM9 Q#3 a_863_294##10 VPWR#4 VPB sky130_fd_pr__pfet_01v8 l=0.15 w=1.12 ad=0.3136 as=0.3724 pd=2.8 ps=2.95
XM5 VPWR#4 a_863_294##8 a_1347_424##7 VPB sky130_fd_pr__pfet_01v8 l=0.15 w=0.84 ad=0.3724 as=0.2478 pd=2.95 ps=2.27
XM1 VPWR#1 a_1347_424##4 Q_N#1 VPB sky130_fd_pr__pfet_01v8 l=0.15 w=1.12 ad=0.3136 as=0.3304 pd=2.8 ps=2.83
*
*
*       RESISTOR AND CAP/DIODE CARDS
*
Rg1	D#1	D#2	435.533173
Rg2	D#2	D#3	341.409607
Rg3	GATE_N#1	GATE_N#2	357.417023
Rg4	GATE_N#2	GATE_N#3	624.393921
Rg5	a_232_82#	a_232_82##2	518.768005
Rg6	a_232_82##2	a_232_82##3	340.039551
Rg7	a_232_82##2	a_232_82##4	297.530212
Rg8	a_27_120#	a_27_120##2	338.356293
Rg9	a_27_120##2	a_27_120##3	495.636230
Rg10	a_343_80#	a_343_80##2	560.440308
Rg11	a_232_82##5	a_232_82##6	228.357101
Rg12	a_232_82##6	a_232_82##7	699.850342
Rg13	a_343_80##3	a_343_80##4	216.119781
Rg14	a_863_294#	a_863_294##2	402.042786
Rg15	a_863_294##2	a_863_294##3	233.205399
Rg16	a_653_79#	a_653_79##2	453.641205
Rg17	a_653_79##2	a_653_79##3	304.732025
Rg18	a_863_294##4	a_863_294##5	332.499786
Rg19	a_863_294##5	a_863_294##6	66.502022
Rg20	a_863_294##6	a_863_294##7	267.616547
Rg21	a_863_294##5	a_863_294##8	611.057373
Rg22	a_863_294##6	a_863_294##9	385.028137
Rg23	a_863_294##6	a_863_294##10	567.347046
Rg24	a_1347_424#	a_1347_424##2	368.862610
Rg25	a_1347_424##2	a_1347_424##3	45.362373
Rg26	a_1347_424##2	a_1347_424##4	471.862823
Rf1	D#2	D#5	81.262962
Rf2	D#6	D	1.146560
Rf3	D#5	D#6	2.386103
Rf4	GATE_N	GATE_N#2	169.680954
Rf5	a_27_120##2	a_27_120##6	359.720459
Rf6	a_27_120##6	a_27_120##7	109.298599
Rf7	a_27_120##5	a_27_120##6	15.000000
Rf8	a_232_82##6	a_232_82##9	395.610901
Rf9	a_232_82##9	a_232_82##3	71.654610
Rf10	a_232_82##3	a_232_82##11	47.196419
Rf11	a_232_82##9	a_232_82##12	12.799901
Rf12	a_343_80##4	a_343_80##2	291.900208
Rf13	a_343_80##2	a_343_80##8	50.435936
Rf14	a_343_80##8	a_343_80##9	96.751007
Rf15	a_343_80##7	a_343_80##8	15.000000
Rf16	a_653_79##2	a_653_79##5	232.821350
Rf17	a_653_79##5	a_653_79##6	81.821686
Rf18	a_653_79##5	a_653_79##7	14.545408
Rf19	a_863_294##11	a_863_294##7	48.289330
Rf20	a_863_294##7	a_863_294##13	18.032730
Rf21	a_863_294##13	a_863_294##2	217.827454
Rf22	a_863_294##13	a_863_294##15	25.315214
Rf23	Q#2	Q	7.652909
Rf24	Q	Q#3	91.681953
Rf25	Q#2	Q	6.504973
Rf26	Q#1	Q#2	7.500000
Rf27	a_1347_424##3	a_1347_424##6	172.199478
Rf28	a_1347_424##6	a_1347_424##7	47.916454
Rf29	a_1347_424##6	a_1347_424##8	38.869682
Rf30	Q_N	Q_N#2	0.194040
Rf31	Q_N#2	Q_N	14.164948
Rf32	Q_N	Q_N#4	7.179494
Rf33	Q_N#4	Q_N	7.179494
Rf34	Q_N#1	Q_N#2	5.000000
Rf35	Q_N#3	Q_N#4	7.500000
Rf37	VGND#2	VGND#3	75.274826
Rf38	VGND#3	VGND#4	113.601799
Rf39	VGND#4	VGND#5	110.281715
Rf40	VGND#5	VGND#6	62.248123
Rf41	VGND#6	VGND#7	125.412262
Rf43	VGND#2	VGND#9	45.656124
Rf44	VGND#3	VGND#10	56.213299
Rf45	VGND#4	VGND#11	31.928406
Rf46	VGND#6	VGND#12	24.334328
Rf47	VGND#7	VGND#13	24.468842
Rf48	VPWR#1	VPWR#2	52.877037
Rf49	VPWR#2	VPWR#3	75.457451
Rf50	VPWR#3	VPWR#4	43.597031
Rf51	VPWR#3	VPWR#5	122.339249
Rf52	VPWR#5	VPWR#6	33.754433
Rf53	VPWR#5	VPWR#7	101.487045
Rf54	VPWR#7	VPWR#8	59.511623
Rf55	VPWR#8	VPWR#9	31.948624
Rf56	VPWR#8	VPWR#10	120.118996
Rf57	VPWR#10	VPWR#11	32.518913
Re1	VPWR#2	VPWR	4.549932
Re2	VPWR	VPWR#7	0.974985
Re3	VGND#2	VGND	4.549932
Re4	VGND	VGND#5	0.974985
*
*       CAPACITOR CARDS
*
*
C1	a_232_82##12	a_653_79##6	3.08194e-20
C2	VPWR#5	VPWR#6	6.16861e-19
C3	a_343_80##9	a_27_120#	1.28233e-18
C4	a_343_80##7	VPWR#9	1.42948e-18
C5	a_232_82##4	VGND#12	8.7976e-18
C6	Q#1	a_863_294##6	2.17367e-17
C7	a_343_80##9	a_232_82##4	3.74534e-17
C8	a_232_82##12	VPWR#9	4.76393e-17
C9	a_232_82##11	a_232_82##4	6.07453e-19
C10	a_232_82##12	a_343_80##7	1.03491e-16
C11	VPWR#11	VPWR#9	7.57111e-19
C12	a_343_80##9	GATE_N#3	7.51465e-19
C13	a_863_294##6	a_863_294##5	2.42653e-18
C14	a_1347_424##6	VPWR#1	6.39628e-18
C15	a_232_82##11	GATE_N#3	3.63504e-17
C16	a_27_120##5	a_232_82##4	3.85397e-19
C17	GATE_N#3	VGND#13	1.80297e-17
C18	VPWR#11	a_232_82##12	6.0131e-17
C19	a_232_82##11	D#3	2.57529e-18
C20	a_343_80##7	a_232_82##2	8.83351e-18
C21	a_863_294##13	a_863_294##6	2.05095e-19
C22	a_27_120##5	GATE_N#3	3.71913e-17
C23	D#3	VGND#13	1.48663e-17
C24	a_27_120##7	a_232_82##12	1.72369e-18
C25	a_27_120##5	D#3	4.23332e-17
C26	a_27_120##7	VPWR#11	5.4932e-17
C27	VGND#4	a_653_79##5	1.68892e-18
C28	a_863_294##7	VPWR#5	3.74228e-19
C29	a_232_82##12	a_232_82##2	1.02565e-19
C30	a_863_294##7	VPWR#3	9.07709e-19
C31	a_1347_424##8	VGND#9	4.27161e-17
C32	Q#3	a_1347_424##6	7.95823e-18
C33	a_653_79##6	a_232_82##7	7.13507e-19
C34	a_1347_424##4	Q_N#1	1.20508e-17
C35	VGND#10	VGND#9	2.61364e-18
C36	VGND#4	a_863_294##7	4.23445e-19
C37	a_1347_424##4	VPWR#1	2.39173e-17
C38	a_863_294##4	a_1347_424#	4.34699e-18
C39	VGND#3	a_863_294##7	1.49854e-18
C40	a_232_82##12	VPWR#8	9.84843e-18
C41	a_1347_424##7	a_1347_424##4	1.75432e-18
C42	VGND#10	a_1347_424##8	5.12388e-17
C43	a_1347_424##6	a_1347_424##3	7.77419e-19
C44	a_863_294##9	a_1347_424#	3.92534e-19
C45	a_863_294##2	VPWR#5	6.65139e-19
C46	VPWR#1	a_863_294##8	2.69121e-18
C47	VPWR#4	a_1347_424##4	5.76733e-19
C48	VGND#4	a_653_79##2	1.28342e-18
C49	a_1347_424##7	a_863_294##8	6.14663e-17
C50	a_863_294##9	a_863_294##4	2.29677e-17
C51	Q#1	a_1347_424##8	1.51548e-19
C52	VPWR#1	a_863_294##10	2.76611e-19
C53	a_863_294##8	VPWR#4	2.11599e-17
C54	a_863_294##13	Q#3	2.2864e-17
C55	a_1347_424##7	a_863_294##10	1.99529e-18
C56	VGND#4	a_863_294##2	2.74378e-19
C57	Q#3	a_863_294##8	2.8568e-18
C58	Q#1	VGND#10	5.3396e-17
C59	a_863_294##10	VPWR#4	2.91519e-17
C60	a_653_79##3	a_863_294##9	3.84264e-18
C61	Q#3	a_863_294##10	8.36986e-17
C62	a_863_294##13	a_863_294##15	1.41783e-18
C63	VGND#6	a_343_80##4	1.06965e-17
C64	VPWR#4	a_653_79#	4.60513e-19
C65	a_232_82##6	VPWR#5	4.19563e-18
C66	VGND#4	a_343_80##4	2.10773e-17
C67	a_863_294##15	a_863_294##10	1.47037e-18
C68	a_653_79##5	a_863_294##7	8.60363e-20
C69	Q#3	a_653_79#	4.28725e-18
C70	a_863_294#	a_653_79##3	1.86478e-17
C71	VGND#3	a_343_80##4	3.46448e-19
C72	a_863_294##5	a_1347_424#	3.48193e-19
C73	a_653_79##2	a_863_294##13	2.46701e-17
C74	a_863_294##13	VPWR#6	9.49621e-18
C75	a_863_294##11	Q#1	3.44565e-17
C76	a_863_294##15	a_653_79#	6.12656e-17
C77	a_653_79#	VPWR#6	2.60025e-17
C78	a_653_79##5	a_653_79##2	1.43401e-18
C79	a_343_80##3	a_863_294#	3.77206e-17
C80	a_863_294##15	a_863_294##3	7.09032e-19
C81	VPWR#6	a_863_294##3	3.45982e-17
C82	VGND#6	a_343_80##2	4.49733e-19
C83	a_863_294##15	a_232_82##5	3.57473e-20
C84	a_653_79##5	a_863_294##2	3.13103e-17
C85	VGND#11	a_863_294##11	5.38354e-17
C86	a_232_82##7	a_343_80##3	2.08799e-18
C87	VPWR#6	a_232_82##5	3.00583e-18
C88	a_863_294##15	a_343_80#	1.82871e-19
C89	VPWR#6	a_343_80#	1.86681e-18
C90	VGND#6	a_27_120##2	5.54845e-17
C91	VPWR#8	a_232_82##3	2.35275e-19
C92	a_343_80##4	a_653_79##5	6.55121e-17
C93	a_232_82##5	a_653_79##6	1.31177e-17
C94	a_27_120#	a_232_82##7	4.44424e-17
C95	D#5	VGND#13	1.23404e-18
C96	a_232_82##6	a_863_294##13	1.14017e-18
C97	a_1347_424##3	VGND#9	3.41532e-17
C98	VPWR#6	a_27_120##3	5.37351e-19
C99	a_653_79##6	a_343_80#	3.54685e-17
C100	a_653_79##5	a_653_79##6	4.08403e-18
C101	a_653_79##5	a_232_82##6	8.60624e-17
C102	VGND#6	a_232_82##3	3.5014e-19
C103	a_232_82##4	a_27_120#	2.15056e-17
C104	a_27_120##5	D#5	3.21028e-17
C105	a_653_79##6	a_27_120##3	1.81659e-18
C106	VGND#3	a_1347_424#	1.47909e-18
C107	VPWR#9	a_343_80#	5.44487e-18
C108	a_343_80##2	a_653_79##5	8.20041e-17
C109	VPWR#9	a_27_120##3	4.09227e-17
C110	a_653_79##3	a_863_294##6	1.13245e-19
C111	a_863_294##7	Q#1	4.56516e-17
C112	GATE_N#3	a_232_82##4	4.0047e-18
C113	a_232_82##12	a_343_80#	1.26638e-17
C114	a_343_80##9	a_232_82##2	8.19291e-18
C115	a_863_294##7	a_863_294##11	4.97925e-19
C116	a_1347_424##7	VPWR#2	2.85461e-17
C117	VGND#3	a_863_294##4	3.87159e-18
C118	a_232_82#	VPWR#9	2.71871e-17
C119	VPWR#8	a_232_82##2	3.35162e-20
C120	a_232_82##12	a_27_120##3	1.76596e-17
C121	a_653_79##5	a_27_120##2	1.43168e-19
C122	Q#1	a_653_79##2	5.25596e-20
C123	a_343_80##7	a_232_82#	4.32604e-17
C124	D#3	GATE_N#3	1.92847e-17
C125	VPWR#11	a_27_120##3	5.02257e-19
C126	a_863_294##11	a_653_79##2	1.06968e-17
C127	VPWR#9	GATE_N#1	2.63885e-18
C128	a_232_82##12	a_232_82#	1.73817e-17
C129	a_653_79##2	VGND#11	4.6768e-17
C130	VGND#3	a_863_294##9	1.20171e-17
C131	a_343_80##7	GATE_N#1	3.63709e-19
C132	VPWR#5	a_343_80##3	1.28718e-18
C133	VPWR#9	D#1	3.76574e-19
C134	a_232_82##12	GATE_N#1	5.27386e-17
C135	VPWR#3	a_863_294##6	4.56069e-20
C136	VGND#4	a_653_79##3	4.48715e-18
C137	a_27_120##7	a_232_82#	2.78611e-19
C138	a_1347_424##6	a_1347_424#	7.5341e-19
C139	VGND#9	VPWR#1	5.15253e-19
C140	GATE_N#1	VPWR#11	2.28116e-17
C141	a_232_82##12	D#1	2.41267e-18
C142	VGND#3	a_653_79##3	6.53865e-19
C143	a_27_120##7	GATE_N#1	1.17118e-18
C144	a_863_294##11	a_343_80##4	2.39627e-19
C145	a_1347_424##3	VPWR#1	3.57072e-17
C146	VPWR#11	D#1	4.51345e-17
C147	a_343_80##4	VGND#11	1.86487e-17
C148	VGND#4	a_863_294#	3.63111e-18
C149	a_1347_424##6	a_863_294##4	3.58591e-19
C150	a_27_120##7	D#1	2.10801e-17
C151	a_343_80##4	a_653_79##7	6.88879e-19
C152	a_863_294##8	a_1347_424##4	6.81689e-18
C153	a_1347_424##6	a_863_294##9	7.41375e-20
C154	a_232_82##6	a_653_79##7	2.3293e-18
C155	a_343_80##4	a_343_80##9	6.17784e-19
C156	a_863_294##7	Q#3	1.2642e-17
C157	a_343_80##2	VGND#11	9.83489e-19
C158	a_863_294##7	a_863_294##15	3.5163e-19
C159	a_863_294##10	a_863_294##8	3.65259e-17
C160	VGND#6	a_232_82##7	1.70802e-18
C161	a_232_82##12	VPWR#7	1.87303e-18
C162	VGND#10	VPWR#4	6.18132e-18
C163	VPWR#5	VPWR#3	3.33406e-19
C164	a_653_79#	a_863_294##10	7.12072e-18
C165	a_653_79##2	VPWR#6	2.97315e-18
C166	VGND#6	a_27_120#	1.43189e-17
C167	a_232_82##11	a_343_80##9	1.70683e-17
C168	a_863_294##2	VPWR#6	4.72375e-17
C169	a_27_120##2	VGND#12	5.8891e-18
C170	a_863_294##3	a_653_79#	1.00074e-17
C171	D#5	D#2	1.68079e-17
C172	a_27_120##2	a_343_80##9	7.53997e-17
C173	Q#1	Q#3	2.9491e-18
C174	VGND#3	VGND#9	4.79459e-18
C175	a_27_120##2	VGND#13	2.00884e-20
C176	a_863_294##5	a_1347_424##3	1.3562e-17
C177	VGND#6	a_232_82##4	1.32936e-17
C178	a_232_82##5	a_863_294##3	1.84053e-17
C179	a_343_80#	a_653_79#	6.09673e-19
C180	a_343_80##9	a_232_82##3	3.66675e-17
C181	a_232_82##6	a_863_294##15	3.36205e-19
C182	a_343_80##4	a_653_79##6	3.37896e-19
C183	a_653_79##5	a_863_294##9	5.64975e-20
C184	a_232_82##6	VPWR#6	3.18907e-17
C185	a_27_120##5	a_343_80##9	1.16184e-17
C186	VPWR#7	a_232_82##7	7.34981e-20
C187	a_27_120##5	a_232_82##3	8.74139e-18
C188	a_343_80#	a_232_82##5	7.44309e-18
C189	VGND#3	a_1347_424##8	5.32714e-18
C190	a_232_82##6	a_653_79##6	9.78415e-17
C191	a_863_294##7	a_863_294##9	1.31919e-19
C192	VGND#6	GATE_N#3	1.44488e-18
C193	VGND#5	a_232_82##7	4.25554e-18
C194	a_863_294##7	a_653_79##3	5.49053e-19
C195	a_27_120##5	a_232_82##11	4.78507e-17
C196	a_653_79##5	a_653_79##3	1.06791e-18
C197	a_863_294##7	a_863_294##6	8.16284e-20
C198	a_653_79##2	a_863_294##9	2.01418e-19
C199	a_27_120##5	GATE_N#2	3.98125e-18
C200	a_343_80##2	a_653_79##6	4.59331e-17
C201	a_863_294##7	a_863_294#	2.2251e-20
C202	VPWR#1	a_863_294##5	5.16778e-20
C203	VPWR#2	a_1347_424##4	1.3794e-17
C204	a_27_120##3	a_343_80#	5.21285e-17
C205	a_653_79##2	a_653_79##3	4.28984e-18
C206	a_863_294##7	a_343_80##3	7.626e-21
C207	VPWR#2	a_863_294##8	2.82844e-18
C208	VGND#3	VGND#10	7.01743e-19
C209	a_27_120##5	VGND#13	5.62755e-18
C210	a_653_79##2	a_863_294#	1.60627e-17
C211	a_27_120##5	D#2	8.34972e-18
C212	a_343_80##7	a_343_80##2	2.70161e-18
C213	VPWR#2	a_863_294##10	1.3153e-19
C214	a_653_79##5	a_863_294#	8.2233e-18
C215	a_232_82#	a_27_120##3	2.98286e-17
C216	a_343_80##2	a_232_82##12	3.36736e-17
C217	VGND#6	a_232_82##2	5.18088e-20
C218	VPWR#9	a_27_120##2	4.02785e-19
C219	D	a_232_82##2	8.54363e-20
C220	GATE_N#1	a_27_120##3	3.57319e-19
C221	a_27_120##2	a_343_80##7	2.61119e-17
C222	a_343_80##4	a_653_79##3	4.81699e-18
C223	VPWR#3	a_1347_424##4	3.54149e-19
C224	a_232_82##12	a_27_120##2	4.44076e-19
C225	a_343_80##4	a_863_294#	1.08445e-17
C226	GATE_N#1	a_232_82#	4.09757e-18
C227	a_653_79##2	a_863_294##6	2.00162e-19
C228	a_653_79##5	a_343_80##3	2.89686e-17
C229	VGND#4	a_863_294##11	2.21533e-17
C230	a_343_80##4	a_343_80##3	2.95655e-19
C231	a_232_82##3	a_343_80##7	4.10092e-17
C232	a_343_80##4	a_232_82##7	2.41961e-17
C233	a_232_82##6	a_863_294#	1.07518e-18
C234	a_232_82##3	a_232_82##12	7.06556e-18
C235	VPWR#5	a_863_294##8	3.06366e-19
C236	D#1	GATE_N#1	2.96443e-17
C237	a_232_82##6	a_343_80##3	1.3921e-17
C238	a_343_80##4	a_27_120#	5.51771e-18
C239	a_343_80##2	a_653_79##3	8.00924e-20
C240	VGND#3	a_863_294##6	7.13136e-20
C241	a_343_80##7	GATE_N#2	1.96358e-18
C242	VPWR#7	a_232_82##5	1.32588e-18
C243	a_232_82##6	a_232_82##7	2.18149e-19
C244	a_343_80##4	a_232_82##4	1.88214e-18
C245	VPWR#3	a_863_294##8	7.10002e-18
C246	a_343_80##2	a_863_294#	1.07019e-19
C247	GATE_N#2	a_232_82##12	2.18315e-18
C248	a_653_79##5	a_232_82##7	2.14346e-17
C249	VPWR#7	a_343_80#	8.3088e-18
C250	a_343_80##2	a_343_80##3	6.69695e-19
C251	a_343_80##4	GATE_N#3	5.88285e-19
C252	GATE_N#2	VPWR#11	8.42535e-19
C253	Q_N	a_863_294##5	1.01312e-18
C254	VPWR#4	a_863_294##6	2.16011e-18
C255	a_343_80##2	a_232_82##7	4.26744e-17
C256	a_27_120##7	GATE_N#2	6.53334e-19
C257	a_863_294##7	a_653_79#	6.46888e-20
C258	VPWR#5	a_863_294##10	1.70863e-18
C259	D#5	a_27_120##7	5.25257e-17
C260	a_343_80##2	a_27_120#	4.29592e-18
C261	a_863_294##2	a_863_294##6	5.16212e-21
C262	a_27_120##2	a_232_82##7	1.33216e-17
C263	VPWR#4	a_863_294##5	2.15955e-18
C264	VGND#11	VGND#3	4.54991e-19
C265	a_27_120##7	D#2	1.44821e-17
C266	VPWR#3	a_863_294##10	9.9735e-18
C267	a_27_120##2	a_27_120#	1.92513e-17
C268	a_863_294##2	a_653_79#	7.48522e-18
C269	a_27_120##2	a_232_82##4	3.22131e-17
C270	a_863_294##2	a_863_294##3	2.82125e-18
C271	a_27_120##2	GATE_N#3	4.40036e-19
C272	VPWR#5	a_653_79#	1.24208e-17
C273	a_27_120##2	D#3	2.84429e-19
C274	a_863_294##2	a_232_82##5	3.96467e-19
C275	a_1347_424##7	VPWR#1	8.72699e-17
C276	a_1347_424#	Q_N#3	7.60377e-18
C277	a_232_82##3	GATE_N#3	9.70713e-18
C278	a_232_82##6	a_653_79#	4.40561e-19
C279	Q#3	a_863_294##6	7.16085e-18
C280	a_232_82##6	a_863_294##3	7.83712e-18
C281	a_232_82##12	a_571_392#	3.76001e-18
C282	a_1347_424#	VGND#9	2.10296e-17
C283	a_232_82##6	a_232_82##5	1.61406e-17
C284	a_1347_424##3	VPWR#2	4.83891e-18
C285	VPWR#4	VPWR#1	2.18922e-18
C286	Q#3	a_863_294##5	7.11548e-19
C287	Q#1	a_1347_424##6	1.19777e-17
C288	a_232_82##6	a_343_80#	1.98154e-17
C289	VPWR#5	a_863_294##3	1.35313e-18
C290	D#2	GATE_N#3	1.09331e-17
C291	a_343_80##2	a_232_82##5	1.06775e-19
C292	a_232_82##6	a_27_120##3	3.11333e-19
C293	a_1347_424##8	a_1347_424#	1.12431e-18
C294	a_343_80##2	a_343_80#	3.05585e-18
C295	a_1347_424##6	a_1347_424##4	1.52411e-18
C296	a_232_82##6	a_232_82#	2.33044e-19
C297	VPWR#4	a_1347_424##7	8.26777e-17
C298	VGND#9	a_863_294##4	2.91801e-18
C299	a_343_80##2	a_27_120##3	2.58645e-17
C300	VGND#10	a_1347_424#	5.79276e-19
C301	VGND#6	VGND#12	8.96792e-18
C302	a_1347_424##8	a_863_294##4	3.76835e-17
C303	VPWR#5	a_232_82##5	1.11374e-18
C304	Q#3	a_1347_424##7	6.47266e-18
C305	a_232_82#	a_27_120##2	2.08793e-18
C306	VGND#9	a_863_294##9	1.08234e-18
C307	a_1347_424##6	a_863_294##8	5.87267e-19
C308	a_232_82##3	a_232_82#	8.96748e-19
C309	a_863_294##4	VGND#10	1.76619e-17
C310	Q#3	VPWR#4	8.28341e-17
C311	a_653_79##2	a_863_294##7	8.10651e-17
C312	VGND#5	a_343_80##4	8.1314e-17
C313	a_1347_424##8	a_863_294##9	9.5555e-19
C314	GATE_N#2	a_232_82#	3.34908e-18
C315	a_232_82##6	VPWR#7	1.08618e-17
C316	a_863_294##2	a_863_294##7	2.68297e-18
C317	VGND#5	a_232_82##6	3.126e-19
C318	Q#1	a_863_294##4	8.18246e-19
C319	a_863_294#	a_852_123#	9.87534e-18
C320	VPWR#7	a_343_80##2	5.24442e-20
C321	VPWR#5	a_343_80#	2.68824e-18
C322	a_343_80##9	a_343_80##7	2.24033e-18
C323	D#1	GATE_N#2	5.28755e-19
C324	VGND#4	VGND#3	4.00816e-19
C325	a_653_79##2	a_863_294##2	6.46125e-17
C326	a_343_80##3	a_852_123#	9.87534e-18
C327	a_1347_424##6	a_863_294##10	1.12805e-18
C328	a_863_294##9	VGND#10	2.09416e-17
C329	VGND#5	a_343_80##2	1.85777e-20
C330	a_232_82##5	a_805_392#	8.88729e-18
C331	a_863_294##5	a_1347_424##4	9.38424e-19
C332	VGND	a_863_294##6	1.75185e-18
C333	VGND	a_863_294##5	1.9211e-18
C334	a_1347_424##6	Q_N	5.89429e-18
C335	VGND	a_232_82##2	5.70401e-19
C336	a_653_79##2	a_232_82##6	1.3022e-19
C337	Q#1	a_863_294##9	4.44085e-17
C338	VPWR#8	a_27_120##3	4.23533e-18
C339	a_343_80#	a_571_392#	1.48781e-17
C340	a_863_294##15	Q#3	6.94919e-17
C341	a_232_82##6	a_863_294##2	7.73921e-17
C342	a_27_120##3	a_571_392#	1.99778e-17
C343	a_343_80##4	a_232_82##6	4.33937e-18
C344	VPWR#5	a_27_120##3	6.99812e-19
C345	a_653_79##2	a_27_120##2	1.68883e-19
C346	a_232_82##7	a_575_79#	1.14486e-17
C347	a_863_294##11	a_863_294##9	1.38706e-18
C348	VGND#3	Q	2.94022e-17
C349	a_27_120#	a_575_79#	2.1755e-20
C350	a_343_80##4	a_343_80##2	3.37453e-18
C351	Q#1	a_653_79##3	9.02037e-19
C352	a_343_80##2	a_232_82##2	1.73348e-19
C353	a_343_80##2	a_232_82##6	2.02488e-17
C354	a_27_120##2	a_343_80##4	5.94194e-18
C355	VGND#11	a_863_294##9	6.54758e-19
C356	a_863_294##13	a_863_294##10	6.91841e-19
C357	a_27_120##2	a_232_82##6	9.37636e-19
C358	Q_N	Q_N#3	3.80006e-18
C359	a_863_294##11	a_863_294##13	3.12138e-18
C360	VPWR#8	a_232_82#	5.9848e-18
C361	VGND#9	Q_N	7.23134e-17
C362	a_1347_424##8	Q_N	1.51824e-19
C363	D	VGND#13	1.71121e-18
C364	VPWR	VPWR#8	8.08952e-17
C365	a_863_294##11	a_653_79##3	4.40376e-17
C366	VPWR	VPWR#5	1.37098e-16
C367	a_27_120##5	D	6.53605e-18
C368	a_343_80##2	a_27_120##2	1.37071e-16
C369	VPWR	VPWR#3	7.10531e-17
C370	VPWR#6	a_863_294##15	5.94837e-17
C371	a_863_294##6	VNB	2.87647e-17
C372	a_863_294##5	VNB	4.06451e-17
C373	a_232_82##2	VNB	1.97895e-17
C374	GATE_N	a_232_82##12	3.88218e-17
C375	a_27_120##2	a_232_82##3	1.09184e-18
C376	GATE_N	VPWR#11	1.4517e-17
C377	a_653_79##3	VGND#11	2.40858e-17
C378	a_27_120##7	GATE_N	5.7575e-18
C379	VPWR	a_863_294##13	9.81059e-19
C380	a_863_294##13	a_653_79#	2.04062e-17
C381	a_863_294##11	a_863_294#	8.47482e-19
C382	Q_N	Q_N#1	5.91619e-18
C383	Q	VGND#10	1.21442e-17
C384	VPWR#1	Q_N	8.71621e-17
C385	Q	Q#1	8.57529e-19
C386	a_232_82##3	GATE_N#2	6.1216e-17
C387	a_863_294##11	Q	1.65102e-17
C388	VGND#6	a_27_120##5	2.06322e-18
C389	D	VPWR#11	7.0565e-18
C390	a_232_82##3	D#2	3.74923e-18
C391	a_27_120##5	VPWR#11	2.17191e-18
C392	a_863_294#	VGND#11	1.89958e-17
C393	VGND	VGND#6	9.50294e-17
C394	D#2	GATE_N#2	3.88413e-17
C395	a_232_82##2	a_27_120##2	3.34966e-17
C396	VGND	VGND#4	9.75999e-17
C397	VGND	VGND#3	7.41657e-17
C398	a_653_79##5	a_863_294##11	3.61203e-19
C399	VPWR	D#5	3.86965e-18
C400	a_863_294##11	a_343_80##3	3.10906e-20
C401	a_1347_424##6	a_863_294##6	4.37149e-19
C402	VGND	a_863_294##13	2.20904e-18
C403	a_863_294##13	a_863_294##3	4.34031e-19
C404	Q_N	a_1347_424#	2.63181e-17
C405	VGND	a_653_79##5	2.15716e-17
C406	Q_N	a_863_294##4	9.50547e-20
C407	a_27_120##5	a_27_120##7	1.47276e-18
C408	D	GATE_N#3	2.38793e-18
C409	a_863_294##10	a_863_294##5	6.2781e-18
C410	VGND#11	a_343_80##3	2.02912e-18
C411	a_1347_424##7	VPWR#3	9.64217e-18
C412	VPWR#8	VNB	4.23759e-17
C413	VPWR#5	VNB	6.64379e-17
C414	VGND	D#5	2.09809e-18
C415	VPWR#3	VNB	3.87361e-17
C416	Q	a_1347_424#	1.47199e-19
C417	GATE_N	a_232_82#	2.39631e-19
C418	a_343_80##4	a_575_79#	8.07515e-19
C419	a_653_79##5	VGND#11	8.89345e-18
C420	VPWR	Q#3	2.06852e-17
C421	VGND#6	VNB	4.7585e-17
C422	Q	a_863_294##4	2.93413e-19
C423	VGND#4	VNB	5.07471e-17
C424	VPWR	a_863_294##15	2.04706e-17
C425	VGND#3	VNB	4.57343e-17
C426	Q	a_863_294##9	1.24621e-17
C427	GATE_N	GATE_N#1	5.87518e-18
C428	VGND	a_863_294##11	1.99343e-17
C429	Q	a_653_79##3	4.54343e-19
C430	GATE_N	D#1	1.86398e-18
C431	VGND	VGND#11	2.13552e-17
C432	VPWR	a_653_79##6	4.698e-18
C433	Q_N	a_1347_424##4	3.65012e-17
C434	a_1347_424##6	VNB	5.72019e-18
C435	a_1347_424##6	a_863_294##5	2.67821e-17
C436	VPWR#5	VPWR#4	1.33239e-18
C437	VPWR	VPWR#9	1.52371e-17
C438	a_863_294##13	VNB	5.4279e-18
C439	VPWR	a_343_80##7	7.53664e-18
C440	VGND	a_343_80##9	6.82059e-18
C441	D	a_232_82#	1.53785e-20
C442	a_863_294##13	a_232_82##5	1.21374e-19
C443	VPWR	a_232_82##12	4.12105e-17
C444	a_653_79##5	VNB	1.74226e-17
C445	VGND	a_232_82##11	5.94692e-18
C446	VPWR	VPWR#11	1.91514e-17
C447	a_863_294##13	VPWR#5	2.30058e-19
C448	VGND	a_27_120##5	3.62608e-17
C449	VPWR	a_27_120##7	2.31176e-17
C450	VGND#11	a_232_82##7	3.02981e-19
C451	VGND	Q#3	1.56419e-18
C452	a_343_80##3	a_653_79##7	1.41279e-17
C453	a_232_82##3	a_232_82##2	1.19785e-17
C454	D#5	VNB	2.25374e-18
C455	VPWR	a_343_80##3	1.37902e-18
C456	VGND#9	VNB	1.24331e-17
C457	a_1347_424##8	VNB	1.02776e-17
C458	VGND#10	VNB	3.05781e-18
C459	Q#1	VNB	6.50769e-18
C460	a_863_294##11	VNB	1.01969e-17
C461	VGND	a_343_80##7	4.10392e-18
C462	a_653_79#	a_863_294##6	7.96155e-19
C463	VGND#11	VNB	3.43251e-18
C464	Q_N	VPWR#2	4.22319e-17
C465	a_343_80##9	VNB	3.0818e-18
C466	VGND	a_863_294##4	2.63049e-18
C467	a_232_82##11	VNB	3.22694e-18
C468	VPWR	a_863_294##8	3.3318e-18
C469	VGND	a_863_294##9	4.50932e-18
C470	a_27_120##5	VNB	5.30142e-17
C471	VPWR	a_863_294##10	3.81564e-18
C472	VGND	a_653_79##3	1.44887e-18
C473	VGND	a_863_294#	8.12494e-18
C474	VPWR	a_653_79#	9.1529e-18
C475	VPWR#1	VNB	1.48138e-17
C476	Q_N	a_1347_424##3	4.47145e-17
C477	a_1347_424##7	VNB	1.59845e-17
C478	VPWR	a_863_294##3	1.9292e-18
C479	VPWR#4	VNB	3.21664e-18
C480	VGND	a_232_82##7	1.05376e-18
C481	Q#3	VNB	1.62026e-17
C482	VPWR	a_232_82##5	1.71029e-21
C483	VGND	a_27_120#	9.16987e-18
C484	a_863_294##15	VNB	1.30888e-17
C485	GATE_N	a_232_82##3	3.80325e-18
C486	VPWR	a_343_80#	7.50889e-19
C487	VPWR#6	VNB	8.52008e-18
C488	VGND	a_232_82##4	9.94059e-18
C489	VPWR#5	Q#3	2.63114e-18
C490	VGND	GATE_N#3	9.88862e-18
C491	VPWR	a_27_120##3	6.02136e-19
C492	a_653_79##6	VNB	2.65232e-18
C493	GATE_N	GATE_N#2	6.59018e-18
C494	VGND	D#3	8.39135e-18
C495	VPWR	a_232_82#	8.58973e-18
C496	a_232_82##7	a_653_79##7	8.36031e-18
C497	VPWR#9	VNB	2.63483e-18
C498	VPWR	GATE_N#1	1.92133e-18
C499	a_343_80##7	VNB	9.50148e-18
C500	GATE_N	D#2	1.05795e-18
C501	a_232_82##12	VNB	1.74925e-17
C502	VPWR	D#1	2.10228e-18
C503	D	a_232_82##3	1.83498e-17
C504	VPWR#11	VNB	3.24491e-18
C505	a_27_120##7	VNB	7.60601e-17
C506	a_1347_424#	VNB	3.41772e-17
C507	D	GATE_N#2	3.08298e-17
C508	a_863_294##4	VNB	3.4176e-17
C509	a_863_294##9	VNB	3.12944e-17
C510	a_653_79##3	VNB	2.99617e-17
C511	D	D#2	1.049e-17
C512	a_863_294#	VNB	3.1839e-17
C513	VPWR	VPWR#7	6.11392e-17
C514	a_343_80##3	VNB	2.38679e-17
C515	a_232_82##7	VNB	3.96589e-17
C516	a_27_120#	VNB	3.20721e-17
C517	a_232_82##4	VNB	3.65759e-17
C518	GATE_N#3	VNB	4.16343e-17
C519	VPWR	a_863_294##7	4.07699e-18
C520	D#3	VNB	3.35806e-17
C521	VPWR	a_653_79##2	2.49618e-18
C522	a_653_79##5	a_653_79##7	9.397e-18
C523	a_1347_424##4	VNB	4.29172e-17
C524	VPWR	a_863_294##2	4.53384e-18
C525	a_863_294##8	VNB	4.9434e-17
C526	a_863_294##10	VNB	4.76012e-17
C527	a_653_79#	VNB	4.43667e-17
C528	Q#3	VPWR#3	1.92182e-17
C529	VPWR	a_232_82##6	2.22418e-17
C530	a_863_294##3	VNB	2.31809e-17
C531	VGND	VGND#5	5.67255e-17
C532	a_232_82##5	VNB	2.75242e-17
C533	VPWR	a_343_80##2	6.28977e-18
C534	a_343_80#	VNB	3.96388e-17
C535	a_27_120##3	VNB	3.4387e-17
C536	VGND	a_863_294##7	8.79135e-18
C537	VPWR	a_27_120##2	3.37053e-18
C538	a_232_82#	VNB	5.4811e-17
C539	VGND	a_653_79##2	5.48277e-18
C540	VGND#10	a_863_294##6	5.13667e-18
C541	VPWR	a_232_82##3	4.89704e-18
C542	GATE_N#1	VNB	3.42128e-17
C543	VGND	a_863_294##2	3.05822e-18
C544	D#1	VNB	3.29348e-17
C545	VGND	a_343_80##4	4.91118e-17
C546	VPWR#2	VNB	1.53145e-16
C547	VGND	a_232_82##6	2.46039e-18
C548	VGND	a_343_80##2	5.23057e-18
C549	VPWR#7	VNB	3.27264e-17
C550	VGND#5	VNB	3.39844e-17
C551	VGND	a_27_120##2	2.23376e-17
C552	a_1347_424##3	VNB	7.80095e-17
C553	VGND	a_232_82##3	6.21303e-18
C554	a_863_294##7	VNB	4.78047e-17
C555	VGND	GATE_N#2	3.90938e-18
C556	a_653_79##2	VNB	3.57473e-17
C557	a_863_294##2	VNB	4.31972e-17
C558	VPWR#5	a_863_294##15	1.94633e-17
C559	a_343_80##4	VNB	6.4439e-17
C560	GATE_N#2	a_232_82##2	9.82893e-19
C561	a_232_82##6	VNB	6.67888e-17
C562	a_343_80##2	VNB	3.53199e-17
C563	a_27_120##2	VNB	4.0983e-17
C564	D	GATE_N	6.68159e-18
C565	a_232_82##3	VNB	5.06039e-17
C566	GATE_N#2	VNB	3.50666e-17
C567	VPWR#2	VPWR#3	1.44634e-17
C568	D#2	VNB	6.73365e-17
C569	VPWR	GATE_N	4.07418e-18
C570	VPWR	D	2.04632e-18
C571	VGND	D	2.8953e-18
C572	VGND#10	a_863_294##5	1.13508e-17
C573	GATE_N	VNB	1.38505e-18
C574	D	VNB	3.49031e-19
C575	VGND	Q	1.96087e-17
C576	Q_N	VNB	1.12182e-16
C577	Q	VNB	4.83381e-18
C578	VPWR	VNB	3.08009e-16
C579	VGND	VNB	3.10211e-16
C580	a_27_120#	VGND#12	1.60479e-17
C581	VPWR#10	D#1	4.06714e-18
C582	VGND#2	VPWR#1	3.20853e-18
C583	VGND#7	GATE_N#3	1.5158e-17
C584	VGND#7	a_27_120##5	7.00436e-17
C585	VGND#2	a_1347_424#	1.36043e-17
C586	VPWR#10	D#2	7.26397e-20
C587	VGND#7	a_232_82##4	1.75308e-18
C588	VPWR#10	GATE_N#1	4.51567e-18
C589	VGND#2	a_863_294##4	5.19391e-18
C590	VGND#7	VGND#13	7.17136e-18
C591	D	VPWR#10	2.26641e-20
C592	VGND#2	a_863_294##9	3.80272e-19
C593	VGND#7	D#2	1.20455e-18
C594	VGND#2	Q_N	4.22135e-17
C595	VGND#7	a_27_120#	8.50662e-19
C596	a_232_82##12	VPWR#10	2.21827e-17
C597	VGND#7	VNB	7.48361e-17
C598	VPWR	VPWR#10	1.09534e-16
C599	VGND#2	a_1347_424##3	6.53863e-18
C600	VPWR#10	GATE_N#2	3.59603e-20
C601	VGND#7	GATE_N#2	5.3367e-20
C602	VGND	VGND#7	1.19807e-16
C603	GATE_N	VPWR#10	5.26858e-19
C604	VGND#7	a_232_82##3	1.55817e-19
C605	VGND#2	VNB	1.54108e-16
C606	D#5	VPWR#10	4.81511e-19
C607	VGND#2	VGND#3	1.65472e-17
C608	VGND#7	VGND#6	1.99678e-18
C609	VPWR#10	a_232_82##3	7.53915e-20
C610	a_27_120##7	VPWR#10	2.75012e-17
C611	VPWR#10	VNB	6.27727e-17
C612	VGND#7	D#3	2.83703e-18
C613	VGND#2	a_1347_424##8	2.09272e-17
C614	VPWR#10	VPWR#8	3.25333e-19
*
*
.ENDS sky130_fd_sc_hs__dlxbn_1
*
