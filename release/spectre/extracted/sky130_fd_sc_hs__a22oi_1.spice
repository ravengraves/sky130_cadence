* Extracted by Quantus, converted by sky130cad/quantus.py
*
*
*
*                       LINUX           Wed Nov 18 08:09:15 2026
*
*
*
*  PROGRAM  advgen
*
*  Name           : advgen - Quantus - (64-bit)
*  Version        : 25.1.0-p047
*  Build Date     : Thu Dec 11 23:20:30 PST 2025
*
*  HSPICE LIBRARY
*
*  OPERATING_TEMPERATURE 150
*  QRC_TECH_DIR <path>/tech
*
*
*

*
.SUBCKT sky130_fd_sc_hs__a22oi_1 VPB VNB VGND VPWR Y B2 B1 A1 A2
*
*
*  caps2d version: 10
*
*
*       TRANSISTOR CARDS
*
*
XM7 VGND#7 B2#1 a_159_74# VNB sky130_fd_pr__nfet_01v8_lvt l=0.15 w=0.74 ad=0.1961 as=0.1554 pd=2.01 ps=1.9
XM4 a_159_74# B1#3 Y#1 VNB sky130_fd_pr__nfet_01v8_lvt l=0.15 w=0.74 ad=0.1554 as=0.2886 pd=1.9 ps=2.26
XM2 Y#1 A1#3 a_339_74# VNB sky130_fd_pr__nfet_01v8_lvt l=0.15 w=0.74 ad=0.2886 as=0.2886 pd=2.26 ps=2.26
XM3 a_339_74# A2#3 VGND#6 VNB sky130_fd_pr__nfet_01v8_lvt l=0.15 w=0.74 ad=0.2886 as=0.1961 pd=2.26 ps=2.01
XM1 a_71_368##4 B2#4 Y#2 VPB sky130_fd_pr__pfet_01v8 l=0.15 w=1.12 ad=0.308 as=0.336 pd=2.79 ps=2.84
XM6 Y#2 B1#1 a_71_368##2 VPB sky130_fd_pr__pfet_01v8 l=0.15 w=1.12 ad=0.336 as=0.3696 pd=2.84 ps=2.9
XM5 a_71_368##2 A1#1 VPWR#4 VPB sky130_fd_pr__pfet_01v8 l=0.15 w=1.12 ad=0.3696 as=0.4368 pd=2.9 ps=3.02
XM0 VPWR#4 A2#1 a_71_368# VPB sky130_fd_pr__pfet_01v8 l=0.15 w=1.12 ad=0.4368 as=0.308 pd=3.02 ps=2.79
*
*
*       RESISTOR AND CAP/DIODE CARDS
*
Rg1	B2#1	B2#2	322.953644
Rg2	B2#2	B2#3	228.235504
Rg3	B2#2	B2#4	507.075531
Rg4	B1#1	B1#2	434.639221
Rg5	B1#2	B1#3	382.539734
Rg6	A1#1	A1#2	434.639221
Rg7	A1#2	A1#3	382.539734
Rg8	A2#1	A2#2	434.639221
Rg9	A2#2	A2#3	382.539734
Rf1	B2	B2#3	11.022836
Rf2	B2#3	B2	3.543054
Rf3	B1#2	B1	166.137894
Rf4	Y#1	Y	60.829636
Rf5	Y	Y#2	55.639824
Rf6	A1#2	A1	166.137894
Rf7	a_71_368#	a_71_368##3	99.843964
Rf8	a_71_368##3	a_71_368##4	94.365250
Rf9	a_71_368##2	a_71_368##3	5.000000
Rf10	A2#4	A2	1.409262
Rf11	A2#2	A2#6	161.642059
Rf12	A2#4	A2#6	2.750425
Rf13	A2#7	A2	1.409262
Rf14	A2#6	A2#7	11.918507
Rf16	VGND#2	VGND#3	68.277679
Rf17	VGND#3	VGND#4	68.277679
Rf19	VGND#2	VGND#6	33.306259
Rf20	VGND#4	VGND#7	38.247387
Rf22	VPWR#2	VPWR#3	32.837208
Rf23	VPWR#2	VPWR#4	30.224882
Re1	VPWR#3	VPWR	1.637070
Re2	VGND	VGND#3	1.637131
*
*       CAPACITOR CARDS
*
*
C1	B2#2	B1#3	4.11483e-18
C2	VPWR#3	B2#2	1.01954e-20
C3	B2#2	B1#2	3.39352e-17
C4	VGND#6	A2#6	1.81983e-17
C5	A2#6	a_71_368#	2.01033e-17
C6	Y#1	VGND#6	2.3158e-17
C7	VGND#7	VGND#6	5.34517e-19
C8	VGND#7	Y#1	1.94933e-17
C9	Y#1	a_71_368##2	6.79045e-18
C10	Y#1	Y#2	1.27321e-18
C11	VGND#6	A2#3	4.22457e-17
C12	a_71_368#	VPWR#4	8.71223e-17
C13	VGND#6	A1#3	8.74833e-18
C14	a_71_368##2	a_71_368#	2.51349e-18
C15	A2#6	A2#1	1.97219e-18
C16	Y#1	A2#3	9.1512e-18
C17	B1	B2#2	4.0012e-18
C18	a_71_368##2	VPWR#4	8.9107e-17
C19	VGND#6	B1#3	2.86551e-19
C20	VGND#7	a_71_368##4	2.69904e-18
C21	Y#1	A1#3	5.32248e-17
C22	VGND#6	B2#1	2.67313e-19
C23	VGND#7	A2#3	1.81451e-19
C24	Y#1	B1#3	5.73423e-17
C25	a_71_368##2	Y#2	5.88453e-17
C26	VGND#7	A1#3	1.42643e-19
C27	Y#1	B2#1	6.71767e-18
C28	a_71_368##4	a_71_368##2	3.01982e-18
C29	VGND#7	B1#3	5.61611e-18
C30	Y#2	a_71_368##4	7.17858e-17
C31	B2	B2#2	1.21679e-18
C32	VGND#7	B2#2	1.84774e-18
C33	VGND#7	B2#1	2.90539e-17
C34	a_71_368#	A2#1	5.55143e-17
C35	A1#3	A2#3	2.90045e-17
C36	A2#1	VPWR#4	3.54133e-17
C37	Y	B2#2	1.86159e-17
C38	a_71_368#	A1#1	8.60967e-19
C39	A2#6	A2#2	1.9467e-17
C40	a_71_368##2	A2#1	1.40491e-18
C41	A1#1	VPWR#4	3.67936e-17
C42	B1#3	A1#3	2.26597e-17
C43	a_71_368#	B1#1	1.88979e-19
C44	a_71_368##2	A1#1	3.89915e-17
C45	VPWR#4	B1#1	1.74635e-18
C46	a_71_368##2	B1#1	6.66967e-17
C47	B2#1	B1#3	5.7341e-17
C48	VPWR#4	B2#4	2.53202e-19
C49	B1#1	Y#2	2.14857e-17
C50	a_71_368##2	B2#4	2.84194e-18
C51	VGND#3	Y#1	2.22463e-17
C52	VGND#6	A2#2	4.994e-18
C53	a_71_368##4	B1#1	1.73137e-18
C54	Y#2	B2#4	4.11457e-17
C55	a_71_368##4	B2#4	4.87511e-17
C56	a_71_368##2	VPWR#3	3.56843e-17
C57	A2#2	a_71_368#	3.15925e-18
C58	a_71_368##4	VPWR#3	6.05092e-17
C59	Y#1	B1#2	3.60547e-18
C60	A1#1	A2#1	3.18372e-17
C61	A1#2	VPWR#4	1.35163e-18
C62	VGND	B2#2	1.48201e-18
C63	a_71_368##2	A1#2	1.9931e-18
C64	B1#1	A1#1	4.06185e-17
C65	VGND#3	A1#3	7.53109e-18
C66	B2#3	VGND#7	5.93002e-18
C67	VGND#3	B1#3	3.13504e-18
C68	B1#2	a_71_368##2	2.01325e-18
C69	B2#4	B1#1	4.66959e-17
C70	VPWR#3	A1#1	2.01479e-19
C71	a_71_368##4	B2#3	3.83862e-18
C72	VPWR#3	B1#1	4.47364e-18
C73	VPWR#3	B2#4	4.46319e-18
C74	B2#2	VNB	2.14732e-17
C75	Y#1	a_159_74#	4.90347e-19
C76	VGND#6	A2	1.49773e-17
C77	A2#3	a_339_74#	2.29635e-17
C78	B2#4	B1#2	3.04238e-18
C79	A2	a_71_368#	3.92222e-17
C80	A1#3	a_339_74#	2.26111e-17
C81	Y#1	A1	1.74395e-17
C82	VGND#3	A1#2	1.52631e-19
C83	VPWR#3	B1#2	1.58981e-20
C84	B1#3	a_159_74#	1.45628e-17
C85	A1#2	A2#2	3.42237e-17
C86	Y#1	B1	3.80967e-17
C87	VGND#3	B1#2	8.68753e-20
C88	VPWR#3	B2#3	8.90167e-19
C89	A1	a_71_368##2	2.55338e-17
C90	B2#1	a_159_74#	1.54251e-17
C91	VGND#3	B2#3	1.71863e-21
C92	B1#2	A1#2	3.44901e-17
C93	a_71_368##4	B2#2	4.81904e-19
C94	B1	a_71_368##2	2.54816e-17
C95	B1	Y#2	1.01082e-17
C96	VGND#7	B2	1.13844e-17
C97	A2	A2#1	1.4004e-18
C98	B1	a_71_368##4	8.25556e-19
C99	A2	A1#1	4.36526e-19
C100	VPWR	A2#6	1.244e-18
C101	A1	A2#1	8.58454e-19
C102	B2	a_71_368##4	9.69647e-18
C103	Y	VGND#7	1.69564e-17
C104	A1	A1#1	2.02258e-18
C105	A1	B1#1	4.48886e-19
C106	Y	Y#2	1.71349e-18
C107	B1	A1#1	7.18161e-19
C108	Y	a_71_368##4	8.05885e-20
C109	VGND	A2#6	1.27461e-18
C110	B1	B1#1	2.90485e-18
C111	A2	A2#2	7.51469e-18
C112	B1	B2#4	1.36152e-18
C113	VPWR	a_71_368#	1.75264e-17
C114	VGND#3	A1	1.3586e-18
C115	VPWR	VPWR#4	2.42351e-17
C116	A2	A1#2	4.45831e-18
C117	VPWR	a_71_368##2	2.01068e-17
C118	Y	B2#1	1.23741e-17
C119	A1	A2#2	4.09963e-18
C120	VGND	VGND#6	2.23844e-17
C121	VPWR	Y#2	8.41723e-18
C122	VPWR	a_71_368##4	2.60607e-17
C123	B2	B2#4	2.10041e-18
C124	A1	A1#2	1.63264e-17
C125	VGND	Y#1	2.07832e-17
C126	Y	A2#1	2.46806e-19
C127	Y	A1#1	3.25325e-19
C128	A1	B1#2	3.57948e-18
C129	B2	VPWR#3	1.54526e-18
C130	Y	B1#1	1.19039e-18
C131	B1	A1#2	3.73322e-18
C132	Y	B2#4	4.07619e-18
C133	B1	B1#2	1.44064e-17
C134	VPWR	A2#1	9.98921e-19
C135	VGND#6	VNB	3.96903e-17
C136	VGND	A2#3	1.50446e-18
C137	VPWR	A1#1	4.22631e-19
C138	VGND	A1#3	1.25096e-18
C139	VPWR	B1#1	1.41752e-18
C140	Y#1	VNB	7.1448e-18
C141	VGND	B1#3	1.26462e-19
C142	VPWR	B2#4	2.4302e-18
C143	VGND#7	VNB	2.43853e-17
C144	VGND	B2#1	4.25977e-19
C145	Y	A2#2	1.48616e-19
C146	a_71_368#	VNB	5.06454e-17
C147	B2	B2#3	2.28366e-17
C148	VPWR#4	VNB	4.24436e-18
C149	Y	A1#2	2.66059e-19
C150	VPWR	VPWR#3	3.59168e-17
C151	a_71_368##2	VNB	2.54699e-18
C152	Y#2	VNB	9.27096e-18
C153	Y	B1#2	5.36037e-18
C154	a_71_368##4	VNB	4.31634e-17
C155	A2#3	VNB	2.65788e-17
C156	A1	A2	3.86706e-17
C157	A1#3	VNB	2.74913e-17
C158	B1#3	VNB	2.45002e-17
C159	B2#1	VNB	3.14036e-17
C160	VGND	VGND#3	2.00074e-17
C161	A2#1	VNB	3.83472e-17
C162	A1#1	VNB	2.87326e-17
C163	B1	A1	3.02588e-17
C164	B1#1	VNB	3.27965e-17
C165	VGND	A1#2	1.85044e-18
C166	B2#4	VNB	4.92586e-17
C167	Y	a_159_74#	2.27599e-18
C168	VPWR#3	VNB	1.97866e-16
C169	VGND	B2#3	1.68836e-18
C170	VGND#3	VNB	1.64266e-16
C171	A2#2	VNB	4.52578e-17
C172	A1#2	VNB	2.58893e-17
C173	VPWR	A2	6.47898e-18
C174	B1#2	VNB	3.07923e-17
C175	Y	B1	3.98196e-17
C176	B2#3	VNB	5.19904e-17
C177	VPWR	A1	2.51368e-18
C178	B2	Y	5.28115e-17
C179	VGND	A2	8.29582e-18
C180	VPWR	B1	2.99584e-18
C181	VGND	A1	6.22879e-18
C182	VPWR	B2	7.03482e-18
C183	VGND	B1	2.73429e-18
C184	A2	VNB	3.98293e-17
C185	VGND	B2	6.84678e-18
C186	A1	VNB	2.76273e-18
C187	B1	VNB	4.58048e-18
C188	VGND	Y	4.62143e-18
C189	B2	VNB	3.75946e-17
C190	Y	VNB	1.61523e-17
C191	VPWR	VNB	6.94541e-17
C192	VGND	VNB	6.66017e-17
C193	VPWR#2	A1#1	7.4835e-19
C194	VGND#4	B2#3	8.46058e-19
C195	a_71_368#	VPWR#2	2.0924e-17
C196	VGND#2	VNB	4.41071e-17
C197	VGND#4	A2#3	2.32976e-19
C198	a_71_368##2	VPWR#2	1.27407e-19
C199	VGND#3	VGND#2	4.44783e-17
C200	VPWR#3	VPWR#2	5.4134e-17
C201	VGND#4	VNB	4.60281e-17
C202	VGND#4	VGND#6	1.19036e-20
C203	VPWR#2	A2#2	4.50366e-20
C204	VPWR	VPWR#2	3.60618e-17
C205	VGND#4	B1#3	3.69336e-18
C206	VGND#2	A2#3	5.6164e-18
C207	VPWR#2	VNB	5.08155e-17
C208	VGND#2	A1	4.52709e-19
C209	VGND#4	Y#1	1.68838e-19
C210	VGND#4	Y	1.56205e-18
C211	VGND#2	A1#2	1.10299e-19
C212	VPWR#2	A2#1	2.58372e-18
C213	VGND	VGND#2	3.43938e-17
C214	A2	VPWR#2	1.42881e-18
C215	VGND	VGND#4	5.06187e-17
C216	VGND#4	VGND#2	2.30594e-19
C217	VGND#3	VGND#4	4.45187e-17
C218	VGND#4	A1#3	2.57747e-19
C219	VGND#2	A2	2.51203e-18
C220	VGND#4	B2	2.09639e-18
C221	VGND#4	B2#1	9.44568e-18
*
*
.ENDS sky130_fd_sc_hs__a22oi_1
*
