* Extracted by Quantus, converted by sky130cad/quantus.py
*
*
*
*                       LINUX           Wed Nov 18 09:00:23 2026
*
*
*
*  PROGRAM  advgen
*
*  Name           : advgen - Quantus - (64-bit)
*  Version        : 25.1.0-p047
*  Build Date     : Thu Dec 11 23:20:30 PST 2025
*
*  HSPICE LIBRARY
*
*  OPERATING_TEMPERATURE 150
*  QRC_TECH_DIR <path>/tech
*
*
*

*
.SUBCKT sky130_fd_sc_hs__o2bb2ai_4 VNB VPB VGND VPWR Y A1_N A2_N B2 B1
*
*
*  caps2d version: 10
*
*
*       TRANSISTOR CARDS
*
*
XM34 a_27_74##6 A1_N#6 VGND#15 VNB sky130_fd_pr__nfet_01v8_lvt l=0.15 w=0.74 ad=0.2109 as=0.2072 pd=2.05 ps=2.04
XM12 VGND#15 A1_N#10 a_27_74##8 VNB sky130_fd_pr__nfet_01v8_lvt l=0.15 w=0.74 ad=0.2072 as=0.2146 pd=2.04 ps=2.06
XM6 VGND#14 A1_N#8 a_27_74##8 VNB sky130_fd_pr__nfet_01v8_lvt l=0.15 w=0.74 ad=0.2072 as=0.2146 pd=2.04 ps=2.06
XM38 a_27_74##3 A1_N#7 VGND#14 VNB sky130_fd_pr__nfet_01v8_lvt l=0.15 w=0.74 ad=0.2072 as=0.2072 pd=2.04 ps=2.04
XM25 a_27_74##3 A2_N#6 a_114_368##25 VNB sky130_fd_pr__nfet_01v8_lvt l=0.15 w=0.74 ad=0.2072 as=0.2072 pd=2.04 ps=2.04
XM13 a_114_368##25 A2_N#10 a_27_74##7 VNB sky130_fd_pr__nfet_01v8_lvt l=0.15 w=0.74 ad=0.2072 as=0.2775 pd=2.04 ps=2.23
XM30 a_114_368##21 A2_N#8 a_27_74##7 VNB sky130_fd_pr__nfet_01v8_lvt l=0.15 w=0.74 ad=0.2405 as=0.2775 pd=2.13 ps=2.23
XM17 a_27_74# A2_N#1 a_114_368##21 VNB sky130_fd_pr__nfet_01v8_lvt l=0.15 w=0.74 ad=0.2109 as=0.2405 pd=2.05 ps=2.13
XM22 a_857_74##8 a_114_368##12 Y#10 VNB sky130_fd_pr__nfet_01v8_lvt l=0.15 w=0.74 ad=0.2109 as=0.2072 pd=2.05 ps=2.04
XM5 Y#10 a_114_368##10 a_857_74##12 VNB sky130_fd_pr__nfet_01v8_lvt l=0.15 w=0.74 ad=0.2072 as=0.2072 pd=2.04 ps=2.04
XM32 a_857_74##12 a_114_368##8 Y#8 VNB sky130_fd_pr__nfet_01v8_lvt l=0.15 w=0.74 ad=0.2072 as=0.2072 pd=2.04 ps=2.04
XM10 Y#8 a_114_368# a_857_74##5 VNB sky130_fd_pr__nfet_01v8_lvt l=0.15 w=0.74 ad=0.2072 as=0.2072 pd=2.04 ps=2.04
XM29 VGND#13 B2#6 a_857_74##5 VNB sky130_fd_pr__nfet_01v8_lvt l=0.15 w=0.74 ad=0.259 as=0.2072 pd=2.18 ps=2.04
XM26 VGND#13 B2#10 a_857_74##11 VNB sky130_fd_pr__nfet_01v8_lvt l=0.15 w=0.74 ad=0.259 as=0.2072 pd=2.18 ps=2.04
XM39 a_857_74##11 B2#8 VGND#12 VNB sky130_fd_pr__nfet_01v8_lvt l=0.15 w=0.74 ad=0.2072 as=0.259 pd=2.04 ps=2.18
XM1 a_857_74##10 B2#1 VGND#12 VNB sky130_fd_pr__nfet_01v8_lvt l=0.15 w=0.74 ad=0.2072 as=0.259 pd=2.04 ps=2.18
XM36 VGND#11 B1#6 a_857_74##10 VNB sky130_fd_pr__nfet_01v8_lvt l=0.15 w=0.74 ad=0.2072 as=0.2072 pd=2.04 ps=2.04
XM2 a_857_74##9 B1#10 VGND#11 VNB sky130_fd_pr__nfet_01v8_lvt l=0.15 w=0.74 ad=0.2072 as=0.2072 pd=2.04 ps=2.04
XM35 VGND#10 B1#8 a_857_74##9 VNB sky130_fd_pr__nfet_01v8_lvt l=0.15 w=0.74 ad=0.259 as=0.2072 pd=2.18 ps=2.04
XM8 a_857_74# B1#7 VGND#10 VNB sky130_fd_pr__nfet_01v8_lvt l=0.15 w=0.74 ad=0.2109 as=0.259 pd=2.05 ps=2.18
XM4 a_114_368##19 A1_N#12 VPWR#11 VPB sky130_fd_pr__pfet_01v8 l=0.15 w=1.12 ad=0.336 as=0.3192 pd=2.84 ps=2.81
XM0 a_114_368##19 A1_N#11 VPWR#19 VPB sky130_fd_pr__pfet_01v8 l=0.15 w=1.12 ad=0.336 as=0.336 pd=2.84 ps=2.84
XM15 VPWR#19 A1_N#9 a_114_368##24 VPB sky130_fd_pr__pfet_01v8 l=0.15 w=1.12 ad=0.336 as=0.336 pd=2.84 ps=2.84
XM21 VPWR#18 A1_N#1 a_114_368##24 VPB sky130_fd_pr__pfet_01v8 l=0.15 w=1.12 ad=0.336 as=0.336 pd=2.84 ps=2.84
XM23 VPWR#18 A2_N#12 a_114_368##23 VPB sky130_fd_pr__pfet_01v8 l=0.15 w=1.12 ad=0.336 as=0.336 pd=2.84 ps=2.84
XM7 a_114_368##23 A2_N#11 VPWR#17 VPB sky130_fd_pr__pfet_01v8 l=0.15 w=1.12 ad=0.336 as=0.336 pd=2.84 ps=2.84
XM24 VPWR#17 A2_N#9 a_114_368##22 VPB sky130_fd_pr__pfet_01v8 l=0.15 w=1.12 ad=0.336 as=0.336 pd=2.84 ps=2.84
XM9 a_114_368##22 A2_N#7 VPWR#16 VPB sky130_fd_pr__pfet_01v8 l=0.15 w=1.12 ad=0.336 as=0.336 pd=2.84 ps=2.84
XM31 Y#5 a_114_368##7 VPWR#16 VPB sky130_fd_pr__pfet_01v8 l=0.15 w=1.12 ad=0.336 as=0.336 pd=2.84 ps=2.84
XM19 Y#5 a_114_368##13 VPWR#15 VPB sky130_fd_pr__pfet_01v8 l=0.15 w=1.12 ad=0.336 as=0.336 pd=2.84 ps=2.84
XM27 VPWR#15 a_114_368##11 Y#9 VPB sky130_fd_pr__pfet_01v8 l=0.15 w=1.12 ad=0.336 as=0.336 pd=2.84 ps=2.84
XM16 VPWR#14 a_114_368##9 Y#9 VPB sky130_fd_pr__pfet_01v8 l=0.15 w=1.12 ad=0.3192 as=0.336 pd=2.81 ps=2.84
XM28 Y#6 B2#12 a_1215_368##6 VPB sky130_fd_pr__pfet_01v8 l=0.15 w=1.12 ad=0.336 as=0.3192 pd=2.84 ps=2.81
XM14 a_1215_368##8 B2#11 Y#6 VPB sky130_fd_pr__pfet_01v8 l=0.15 w=1.12 ad=0.336 as=0.336 pd=2.84 ps=2.84
XM33 Y#1 B2#9 a_1215_368##8 VPB sky130_fd_pr__pfet_01v8 l=0.15 w=1.12 ad=0.336 as=0.336 pd=2.84 ps=2.84
XM11 a_1215_368##3 B2#7 Y#1 VPB sky130_fd_pr__pfet_01v8 l=0.15 w=1.12 ad=0.336 as=0.336 pd=2.84 ps=2.84
XM37 VPWR#13 B1#12 a_1215_368##3 VPB sky130_fd_pr__pfet_01v8 l=0.15 w=1.12 ad=0.336 as=0.336 pd=2.84 ps=2.84
XM18 a_1215_368##7 B1#11 VPWR#13 VPB sky130_fd_pr__pfet_01v8 l=0.15 w=1.12 ad=0.336 as=0.336 pd=2.84 ps=2.84
XM3 VPWR#12 B1#9 a_1215_368##7 VPB sky130_fd_pr__pfet_01v8 l=0.15 w=1.12 ad=0.336 as=0.336 pd=2.84 ps=2.84
XM20 a_1215_368# B1#1 VPWR#12 VPB sky130_fd_pr__pfet_01v8 l=0.15 w=1.12 ad=0.3192 as=0.336 pd=2.81 ps=2.84
*
*
*       RESISTOR AND CAP/DIODE CARDS
*
Rg1	A1_N#1	A1_N#2	453.216797
Rg2	A1_N#2	A1_N#3	66.369736
Rg3	A1_N#3	A1_N#4	49.947598
Rg4	A1_N#4	A1_N#5	91.667946
Rg5	A1_N#5	A1_N#6	386.464874
Rg6	A1_N#2	A1_N#7	408.557617
Rg7	A1_N#3	A1_N#8	394.805237
Rg8	A1_N#3	A1_N#9	448.030548
Rg9	A1_N#4	A1_N#10	372.242950
Rg10	A1_N#4	A1_N#11	424.406799
Rg11	A1_N#5	A1_N#12	455.983154
Rg12	A2_N#1	A2_N#2	355.363220
Rg13	A2_N#2	A2_N#3	207.129684
Rg14	A2_N#3	A2_N#4	78.457649
Rg15	A2_N#4	A2_N#5	57.166595
Rg16	A2_N#5	A2_N#6	379.705933
Rg17	A2_N#2	A2_N#7	517.028381
Rg18	A2_N#3	A2_N#8	381.468018
Rg19	A2_N#3	A2_N#9	450.783356
Rg20	A2_N#4	A2_N#10	377.164642
Rg21	A2_N#4	A2_N#11	434.497742
Rg22	A2_N#5	A2_N#12	454.165009
Rg23	a_114_368#	a_114_368##2	541.715210
Rg24	a_114_368##2	a_114_368##3	72.814507
Rg25	a_114_368##3	a_114_368##4	8.507745
Rg26	a_114_368##4	a_114_368##5	37.742893
Rg27	a_114_368##5	a_114_368##6	38.904106
Rg28	a_114_368##6	a_114_368##7	524.347168
Rg29	a_114_368##2	a_114_368##8	374.534637
Rg30	a_114_368##2	a_114_368##9	473.258270
Rg31	a_114_368##3	a_114_368##10	402.169800
Rg32	a_114_368##4	a_114_368##11	426.918213
Rg33	a_114_368##5	a_114_368##12	376.151245
Rg34	a_114_368##6	a_114_368##13	407.365845
Rg35	B2#1	B2#2	397.555725
Rg36	B2#2	B2#3	66.369736
Rg37	B2#3	B2#4	62.744301
Rg38	B2#4	B2#5	81.042801
Rg39	B2#5	B2#6	393.079071
Rg40	B2#2	B2#7	449.655212
Rg41	B2#3	B2#8	396.457733
Rg42	B2#3	B2#9	449.042694
Rg43	B2#4	B2#10	376.444397
Rg44	B2#4	B2#11	428.724243
Rg45	B2#5	B2#12	450.322266
Rg46	B1#1	B1#2	456.189240
Rg47	B1#2	B1#3	90.833923
Rg48	B1#3	B1#4	52.153172
Rg49	B1#4	B1#5	62.871655
Rg50	B1#5	B1#6	451.838898
Rg51	B1#2	B1#7	386.149536
Rg52	B1#3	B1#8	372.588959
Rg53	B1#3	B1#9	424.688446
Rg54	B1#4	B1#10	424.485199
Rg55	B1#4	B1#11	438.831757
Rg56	B1#5	B1#12	503.938385
Rf1	A1_N	A1_N#13	3.361630
Rf2	A1_N#13	A1_N	11.307302
Rf3	A2_N#13	A2_N	0.997598
Rf4	A2_N#4	A2_N#15	54.408531
Rf5	A2_N#13	A2_N#15	2.750425
Rf6	A2_N#16	A2_N	0.997598
Rf7	A2_N#15	A2_N#16	11.918507
Rf8	a_27_74#	a_27_74##2	93.160019
Rf9	a_27_74##2	a_27_74##4	92.369064
Rf10	a_27_74##4	a_27_74##5	84.448494
Rf11	a_27_74##5	a_27_74##6	86.515793
Rf12	a_27_74##2	a_27_74##7	21.713133
Rf13	a_27_74##5	a_27_74##8	27.049631
Rf14	a_27_74##3	a_27_74##4	7.500000
Rf15	a_114_368##5	a_114_368##15	85.153412
Rf16	a_114_368##15	a_114_368##16	38.668674
Rf17	a_114_368##16	a_114_368##17	56.949951
Rf18	a_114_368##17	a_114_368##18	65.696381
Rf19	a_114_368##18	a_114_368##19	79.532700
Rf20	a_114_368##15	a_114_368##20	25.415773
Rf21	a_114_368##20	a_114_368##21	32.927555
Rf22	a_114_368##16	a_114_368##22	20.955824
Rf23	a_114_368##17	a_114_368##23	17.027714
Rf24	a_114_368##18	a_114_368##24	17.027714
Rf25	a_114_368##20	a_114_368##25	82.377556
Rf26	B2	B2#13	14.516130
Rf27	B2#13	B2	0.152801
Rf28	Y#1	Y#2	77.753891
Rf29	Y#2	Y#3	76.743370
Rf30	Y#3	Y	7.026720
Rf31	Y	Y#4	13.469505
Rf32	Y#4	Y#5	81.169632
Rf33	Y#2	Y#6	15.689406
Rf34	Y#3	Y#7	58.221695
Rf35	Y#7	Y#8	22.687914
Rf36	Y#4	Y#9	19.603786
Rf37	Y#7	Y#10	69.167389
Rf38	B1	B1#13	11.154500
Rf39	B1#13	B1	3.514431
Rf40	a_857_74#	a_857_74##2	87.993027
Rf41	a_857_74##2	a_857_74##3	68.733101
Rf42	a_857_74##3	a_857_74##4	68.002594
Rf43	a_857_74##4	a_857_74##6	86.217117
Rf44	a_857_74##6	a_857_74##7	87.378098
Rf45	a_857_74##7	a_857_74##8	88.460457
Rf46	a_857_74##2	a_857_74##9	21.341251
Rf47	a_857_74##3	a_857_74##10	21.341251
Rf48	a_857_74##4	a_857_74##11	21.341251
Rf49	a_857_74##7	a_857_74##12	26.674736
Rf50	a_857_74##5	a_857_74##6	7.500000
Rf51	a_1215_368#	a_1215_368##2	79.092201
Rf52	a_1215_368##2	a_1215_368##4	87.913902
Rf53	a_1215_368##4	a_1215_368##5	93.857086
Rf54	a_1215_368##5	a_1215_368##6	87.352280
Rf55	a_1215_368##2	a_1215_368##7	17.027714
Rf56	a_1215_368##5	a_1215_368##8	24.845327
Rf57	a_1215_368##3	a_1215_368##4	5.000000
Rf59	VGND#2	VGND#3	72.331985
Rf60	VGND#3	VGND#4	65.903542
Rf61	VGND#4	VGND#5	67.887894
Rf62	VGND#5	VGND#6	235.198059
Rf63	VGND#6	VGND#7	130.005341
Rf64	VGND#7	VGND#8	63.504868
Rf66	VGND#2	VGND#10	37.263206
Rf67	VGND#3	VGND#11	40.761108
Rf68	VGND#4	VGND#12	37.263206
Rf69	VGND#5	VGND#13	37.263206
Rf70	VGND#7	VGND#14	35.098007
Rf71	VGND#8	VGND#15	35.098007
Rf73	VPWR#2	VPWR#3	71.550179
Rf74	VPWR#3	VPWR#4	200.170349
Rf75	VPWR#4	VPWR#5	65.818954
Rf76	VPWR#5	VPWR#6	65.941528
Rf77	VPWR#6	VPWR#7	37.353798
Rf78	VPWR#7	VPWR#8	28.587736
Rf79	VPWR#8	VPWR#9	65.941528
Rf80	VPWR#9	VPWR#10	65.941528
Rf81	VPWR#10	VPWR#11	113.641121
Rf82	VPWR#2	VPWR#12	45.269882
Rf83	VPWR#3	VPWR#13	41.430836
Rf84	VPWR#4	VPWR#14	32.518913
Rf85	VPWR#5	VPWR#15	58.622005
Rf86	VPWR#6	VPWR#16	67.810089
Rf87	VPWR#8	VPWR#17	53.143215
Rf88	VPWR#9	VPWR#18	53.143215
Rf89	VPWR#10	VPWR#19	53.143215
Rf93	B2#4	B2#13	40.058201
Rf94	B1#3	B1#13	32.046562
Rf90	A1_N#4	A1_N#13	32.046562
Re1	VPWR#3	VPWR	2.687498
Re2	VPWR	VPWR#7	1.343749
Re3	VGND#3	VGND	2.687498
Re4	VGND	VGND#6	1.343749
*
*       CAPACITOR CARDS
*
*
C1	VGND#15	a_27_74##8	4.16705e-17
C2	VPWR#5	a_114_368##6	4.5102e-20
C3	a_857_74##3	B2#1	2.57665e-17
C4	VGND#5	a_114_368##8	4.73835e-18
C5	Y#7	B2#3	1.32417e-19
C6	B1#6	B1#10	3.97678e-17
C7	VGND#10	B1#4	7.62684e-19
C8	a_1215_368##5	VPWR#4	2.79349e-17
C9	a_857_74##2	B2#1	4.36499e-20
C10	a_857_74##4	B2#8	1.77623e-17
C11	a_114_368##4	a_114_368##9	1.71475e-18
C12	a_27_74##6	a_27_74##8	1.78931e-18
C13	a_114_368##16	A2_N#7	9.58355e-18
C14	VPWR#10	A1_N#12	2.33518e-18
C15	B2#3	B2#2	3.46424e-18
C16	a_114_368##5	a_114_368##6	2.65536e-17
C17	a_1215_368#	B1#1	5.46374e-17
C18	a_857_74##3	B2#8	1.20285e-19
C19	a_114_368##5	a_114_368##4	1.23932e-17
C20	VPWR#5	a_114_368##4	1.95099e-20
C21	VGND#10	B1#2	5.05191e-19
C22	Y#7	B2#2	1.42918e-19
C23	B1#1	VPWR#12	2.81049e-17
C24	a_27_74##6	VGND#15	4.79169e-17
C25	VGND#5	VGND#4	1.22239e-18
C26	VGND#5	a_114_368##10	4.54228e-18
C27	a_114_368##25	A2_N#5	2.56822e-18
C28	a_114_368##5	a_114_368##2	9.84881e-18
C29	B2#1	B1#6	3.99829e-17
C30	a_114_368##17	A2_N#9	5.11358e-21
C31	Y#7	B2#1	1.18695e-19
C32	VPWR#10	A1_N#5	2.04712e-20
C33	a_857_74##4	B2#10	2.15916e-17
C34	a_114_368##16	A2_N#9	1.9045e-17
C35	a_1215_368#	B1#9	2.03396e-18
C36	a_1215_368##7	B1#1	2.11245e-18
C37	a_114_368##21	A1_N#2	1.3738e-19
C38	Y#4	Y#2	1.76662e-19
C39	B1#9	VPWR#12	2.97803e-17
C40	VPWR#13	B1#1	1.92716e-19
C41	a_857_74##3	B2#10	4.41656e-20
C42	A2_N#16	A2_N#7	1.08629e-18
C43	a_857_74#	VGND#10	4.72739e-17
C44	Y#7	a_114_368##6	1.6083e-19
C45	a_1215_368##7	B1#9	5.33182e-17
C46	a_114_368##17	A2_N#11	1.68983e-17
C47	B2#8	B2#1	2.48773e-17
C48	Y#7	B2#8	1.12218e-19
C49	a_1215_368##2	a_1215_368#	2.96061e-20
C50	VGND#5	a_114_368##12	4.94437e-20
C51	a_114_368##16	A2_N#11	3.47801e-19
C52	a_857_74##4	B2#6	1.20285e-19
C53	VPWR#12	B1#11	7.54097e-19
C54	VPWR#13	B1#9	4.26411e-19
C55	a_857_74##7	a_114_368#	1.16681e-20
C56	VPWR#4	a_114_368##4	1.75589e-20
C57	a_1215_368##7	B1#11	4.63659e-17
C58	a_114_368##18	A2_N#12	5.11358e-21
C59	VGND#11	B1#5	5.94378e-19
C60	A2_N#1	a_114_368##6	1.23847e-19
C61	a_857_74##9	a_857_74#	2.07735e-18
C62	A2_N#16	A2_N#9	1.6399e-18
C63	VGND#7	A2_N#1	4.41e-20
C64	A2_N#4	A2_N#5	1.94379e-17
C65	a_114_368##17	A2_N#12	1.97655e-17
C66	B2#10	B2#8	4.00358e-17
C67	Y#7	a_114_368##4	2.15125e-19
C68	A2_N#4	A2_N#3	2.68229e-18
C69	B1#11	VPWR#13	2.26485e-17
C70	VPWR#12	B1#12	1.77652e-19
C71	a_1215_368##6	VPWR#4	4.57563e-17
C72	Y#7	B2#10	1.94695e-19
C73	a_1215_368##2	VPWR#12	1.73926e-17
C74	a_114_368##16	A2_N#12	1.93539e-19
C75	a_857_74##4	a_114_368#	4.41656e-20
C76	a_1215_368##7	B1#12	1.71742e-18
C77	a_1215_368##3	B1#11	3.94081e-19
C78	a_857_74##7	a_114_368##8	1.45309e-17
C79	A2_N#4	A1_N#2	5.00437e-18
C80	VGND#11	B1#4	2.72608e-19
C81	a_857_74##9	VGND#10	4.36725e-17
C82	VPWR#5	VPWR#14	2.83194e-19
C83	VPWR#13	B1#12	4.27824e-17
C84	a_114_368##18	A1_N#1	1.69064e-17
C85	Y#4	a_114_368##6	4.8495e-18
C86	a_1215_368#	VPWR#12	6.26147e-17
C87	VPWR#3	VPWR#4	2.11825e-17
C88	a_114_368##21	a_114_368##9	1.89248e-19
C89	B2#6	B2#10	2.4722e-17
C90	a_114_368##17	A1_N#1	5.11358e-21
C91	VGND#7	A2_N#8	7.34386e-20
C92	a_1215_368##3	B1#12	5.51424e-17
C93	a_1215_368##7	B2#7	2.05875e-19
C94	Y#7	B2#6	1.48787e-18
C95	a_114_368##16	A1_N#1	1.22797e-19
C96	Y#2	B2#5	1.14099e-18
C97	a_1215_368##2	a_1215_368##7	1.68724e-18
C98	Y#1	B1#12	1.52486e-18
C99	VPWR#13	B2#7	1.33873e-18
C100	a_1215_368##7	a_1215_368#	2.96061e-18
C101	VGND#11	VGND#10	1.82757e-18
C102	a_857_74##7	a_114_368##10	1.46138e-17
C103	a_114_368##18	A1_N#9	1.69947e-17
C104	a_1215_368##3	B2#7	3.20506e-17
C105	a_1215_368##8	B1#12	2.8844e-19
C106	Y#4	a_114_368##4	4.49321e-18
C107	Y#9	VPWR#5	6.5158e-18
C108	VPWR#4	a_114_368##2	4.96731e-20
C109	a_114_368#	B2#6	4.04046e-17
C110	a_114_368##21	a_114_368##16	2.87149e-18
C111	A1_N#5	A1_N#4	4.03955e-18
C112	Y#1	B2#7	5.41364e-17
C113	VPWR#13	B2#9	2.64728e-20
C114	Y#7	a_114_368##2	1.43729e-17
C115	A2_N#3	VPWR#17	6.19192e-19
C116	VGND#7	A2_N#10	2.80855e-19
C117	a_114_368##16	A1_N#9	7.96779e-20
C118	Y#7	a_114_368#	1.9975e-17
C119	a_1215_368##7	VPWR#12	5.62248e-17
C120	a_114_368##7	a_114_368##6	4.28687e-18
C121	VPWR#9	A1_N#2	1.98672e-20
C122	A1_N#4	A1_N#2	4.0818e-18
C123	a_1215_368##8	B2#7	6.80843e-19
C124	a_1215_368##2	VPWR#13	2.3403e-17
C125	a_1215_368##3	B2#9	6.80843e-19
C126	VGND#11	a_857_74##9	4.14899e-17
C127	Y#9	VPWR#4	7.18936e-18
C128	a_114_368##18	A1_N#11	5.11358e-21
C129	Y#1	B2#9	5.24516e-17
C130	B1#2	a_1215_368#	3.5035e-18
C131	VPWR#13	B2#11	1.4145e-20
C132	a_1215_368##5	VPWR#3	7.66602e-17
C133	a_114_368##8	a_114_368#	3.86238e-17
C134	a_114_368##2	B2#5	3.0305e-18
C135	a_27_74#	a_114_368##7	5.7669e-19
C136	VPWR#13	VPWR#12	2.23473e-18
C137	VGND#3	VGND#5	2.75501e-17
C138	B2#9	a_1215_368##8	2.44384e-17
C139	a_1215_368##3	B2#11	2.8844e-19
C140	VGND#3	VGND#4	7.75645e-17
C141	a_1215_368##2	VPWR#3	3.40483e-18
C142	a_114_368##21	a_114_368##7	1.13523e-18
C143	a_1215_368##5	Y#1	3.18216e-17
C144	A2_N#5	a_114_368##23	1.37055e-19
C145	Y#7	a_114_368##8	2.41157e-17
C146	a_857_74##10	a_857_74##9	2.01103e-18
C147	VGND#7	A2_N#6	5.07801e-18
C148	a_27_74##3	a_114_368##18	4.1862e-18
C149	VPWR#14	B2#7	3.70502e-20
C150	Y#1	B2#11	1.33203e-18
C151	VPWR#13	B2#12	1.0916e-20
C152	a_27_74##3	A1_N#2	1.45187e-18
C153	a_1215_368##3	a_1215_368##2	2.55072e-20
C154	VPWR#13	a_1215_368##7	5.69874e-17
C155	Y#5	VPWR#6	8.49566e-18
C156	a_1215_368##6	B2#9	3.14939e-19
C157	B2#11	a_1215_368##8	2.78446e-17
C158	a_114_368##10	a_114_368##8	3.92939e-17
C159	Y#4	a_114_368##2	2.2794e-18
C160	B1#4	VPWR#12	6.47602e-19
C161	A2_N#2	a_114_368##7	1.95756e-17
C162	a_114_368##21	A2_N#7	6.05298e-18
C163	a_857_74#	B1#7	3.10933e-17
C164	VPWR#14	B2#9	6.62817e-20
C165	B2#11	Y#6	2.32435e-17
C166	a_27_74##3	a_114_368##17	3.51273e-18
C167	a_857_74##10	VGND#11	4.15308e-17
C168	Y#5	VPWR#5	8.7112e-18
C169	Y#7	a_114_368##10	1.22441e-18
C170	a_1215_368##3	a_1215_368##7	2.55072e-18
C171	a_1215_368##6	B2#11	7.22766e-19
C172	a_1215_368##5	a_1215_368##8	2.74582e-18
C173	a_1215_368##8	B2#12	1.18026e-18
C174	VGND#7	A1_N#7	4.0939e-18
C175	a_114_368##21	VPWR#16	7.09411e-18
C176	VGND#10	B1#7	3.39147e-17
C177	B1#2	VPWR#12	6.32556e-19
C178	a_114_368##6	a_114_368##4	1.84431e-18
C179	VPWR#14	B2#11	1.91002e-19
C180	a_114_368##12	a_114_368##10	3.75513e-17
C181	B2#12	Y#6	2.32435e-17
C182	a_114_368##21	A2_N#9	9.2259e-19
C183	VGND#3	a_857_74##4	2.30653e-18
C184	a_27_74##2	a_27_74#	2.44333e-18
C185	a_857_74#	B1#8	8.04667e-19
C186	a_1215_368##3	VPWR#13	6.55823e-17
C187	a_1215_368##6	B2#12	3.84642e-17
C188	VGND#12	VGND#11	1.82757e-18
C189	VGND#3	a_857_74##3	3.28851e-18
C190	a_1215_368##8	a_114_368##9	9.97364e-20
C191	a_857_74##9	B1#7	1.54207e-18
C192	VPWR#3	Y#2	5.8042e-18
C193	VGND#14	A1_N#2	2.01976e-19
C194	VGND#3	a_857_74##2	3.74308e-18
C195	Y#7	A2_N#2	4.29819e-20
C196	VPWR#14	B2#12	2.24516e-18
C197	A2_N#3	A2_N#7	4.87349e-18
C198	Y#7	a_114_368##12	1.54645e-19
C199	B1#8	VGND#10	1.67667e-17
C200	a_1215_368##5	Y#6	3.15831e-19
C201	A2_N#1	a_114_368##12	5.24183e-18
C202	Y#9	B2#12	2.81914e-19
C203	VGND#11	B1#7	2.0877e-19
C204	a_1215_368##6	a_114_368##9	2.43937e-18
C205	VGND#7	A1_N#8	4.32319e-18
C206	B1#4	a_1215_368##7	6.39588e-19
C207	a_27_74##2	a_114_368##21	5.86009e-17
C208	VGND#12	a_857_74##10	4.37001e-17
C209	VPWR#14	a_114_368##9	6.27136e-17
C210	a_857_74##9	B1#8	3.63001e-17
C211	VGND#5	a_857_74##7	6.31109e-17
C212	a_857_74##3	a_1215_368##3	1.02331e-17
C213	a_114_368##9	Y#9	1.91215e-17
C214	a_1215_368##6	a_114_368##11	2.08407e-19
C215	VGND#10	B1#10	4.82425e-19
C216	Y#1	a_1215_368##3	6.5843e-17
C217	Y#7	A2_N#1	8.34355e-20
C218	A2_N#8	A2_N#1	2.98411e-17
C219	VGND#11	B1#8	1.28044e-18
C220	VPWR#15	a_114_368##9	5.7865e-19
C221	VPWR#14	a_114_368##11	2.39861e-18
C222	a_114_368##21	A2_N#16	6.60402e-17
C223	VGND#6	a_857_74##7	5.21139e-18
C224	a_857_74##11	a_857_74##10	2.07735e-18
C225	a_27_74##2	a_27_74##7	1.27314e-17
C226	VGND#12	B2#3	6.8208e-19
C227	B1#5	VPWR#13	6.84376e-19
C228	VGND#7	A1_N#10	6.38445e-19
C229	B1#10	a_857_74##9	1.13459e-17
C230	VPWR#4	B2#4	1.69302e-20
C231	Y#9	a_114_368##11	4.38264e-17
C232	a_857_74##10	B1#8	1.62526e-19
C233	a_1215_368##8	a_1215_368##3	3.68474e-18
C234	a_27_74##5	a_27_74##3	4.54893e-19
C235	VGND#15	A1_N#5	4.3298e-19
C236	a_114_368##11	VPWR#15	2.41838e-17
C237	VPWR#14	a_114_368##13	3.06214e-19
C238	VPWR#10	VPWR#9	6.93111e-19
C239	a_857_74##3	Y#1	3.66562e-18
C240	A2_N#10	A2_N#8	2.54586e-17
C241	VGND#4	a_857_74##10	6.75347e-18
C242	VGND#11	B1#10	3.28324e-17
C243	a_114_368##23	VPWR#9	8.48902e-18
C244	Y#5	a_114_368##11	2.01797e-18
C245	Y#9	a_114_368##13	1.28565e-18
C246	B1#4	VPWR#13	5.51649e-19
C247	a_857_74##11	VGND#12	4.15308e-17
C248	B1#3	a_1215_368##2	6.31844e-17
C249	VGND#5	B2#4	3.17376e-20
C250	VGND#12	B2#2	5.46231e-19
C251	a_114_368##18	a_114_368##17	2.96061e-20
C252	Y#1	a_1215_368##8	4.65633e-17
C253	a_27_74##2	a_114_368##25	6.47044e-17
C254	a_857_74##9	B1#6	3.71903e-19
C255	a_114_368##5	VPWR#6	3.25952e-19
C256	VPWR#16	a_114_368##11	1.53981e-19
C257	VGND#4	B2#4	5.39539e-20
C258	a_114_368##13	VPWR#15	2.88136e-17
C259	a_857_74##10	B1#10	3.71903e-19
C260	Y#4	VPWR#5	2.5317e-19
C261	a_114_368##23	VPWR#8	8.43957e-18
C262	a_114_368##16	VPWR#7	1.02906e-19
C263	Y#5	a_114_368##13	7.19007e-17
C264	a_27_74##5	VGND#14	2.26056e-17
C265	A2_N#6	A2_N#10	3.76198e-17
C266	VGND#11	B1#6	2.83625e-17
C267	a_857_74##3	B1#3	3.05922e-17
C268	VPWR#16	a_114_368##13	3.44144e-19
C269	VGND#5	a_114_368##4	6.79207e-21
C270	VGND#5	a_857_74##4	2.25448e-19
C271	a_1215_368##5	B2#4	8.46999e-20
C272	a_857_74##2	B1#3	5.0945e-17
C273	VPWR#15	a_114_368##7	3.44144e-19
C274	VGND#13	VGND#12	1.82757e-18
C275	a_114_368##25	A2_N#16	1.2543e-19
C276	A1_N#7	A2_N#5	7.59423e-19
C277	a_857_74##9	B2#1	1.62526e-19
C278	a_27_74##3	a_27_74##2	2.37845e-18
C279	VPWR#9	A2_N#4	9.7839e-21
C280	Y#5	a_114_368##7	5.61446e-17
C281	B1#6	a_857_74##10	1.13459e-17
C282	VGND#5	a_857_74##11	6.75347e-18
C283	VPWR#8	A2_N#4	1.98359e-20
C284	a_27_74##6	A1_N#5	4.26332e-18
C285	a_114_368##7	VPWR#16	2.23943e-17
C286	A1_N#7	A2_N#6	3.9493e-17
C287	Y#4	VPWR#4	2.01092e-19
C288	VPWR#15	A2_N#7	1.53981e-19
C289	a_27_74##5	a_27_74##8	1.21184e-18
C290	VGND#11	B2#1	1.28044e-18
C291	VGND#3	a_857_74#	1.55218e-17
C292	a_857_74##4	B2#4	4.97058e-18
C293	VGND#12	B1#6	2.81859e-19
C294	a_114_368##22	a_114_368##7	1.41568e-18
C295	VGND#13	a_857_74##11	4.37001e-17
C296	a_114_368##24	VPWR#10	8.48902e-18
C297	Y#5	A2_N#7	2.01215e-18
C298	VGND#4	a_857_74##4	2.91756e-19
C299	VGND#3	a_857_74##9	2.12863e-17
C300	VPWR#17	a_114_368##7	1.53981e-19
C301	A2_N#7	VPWR#16	2.8647e-17
C302	VGND#13	B2#5	8.10367e-19
C303	a_857_74##10	B2#1	3.15347e-17
C304	A1_N#2	a_114_368##24	2.70455e-19
C305	VGND#4	a_857_74##11	6.9283e-18
C306	a_114_368##17	a_114_368##16	2.96061e-20
C307	a_1215_368##6	a_1215_368##8	3.7805e-18
C308	VPWR#9	VPWR#8	6.93111e-19
C309	Y#7	B2#4	2.2974e-19
C310	A1_N#8	A1_N#7	3.97317e-17
C311	VPWR#10	A1_N#4	4.06694e-20
C312	VGND#7	A2_N#4	6.27424e-21
C313	a_114_368##24	VPWR#9	8.43957e-18
C314	a_114_368##22	A2_N#7	5.30955e-17
C315	VGND#3	a_857_74##10	2.18877e-17
C316	VGND#6	a_27_74##2	6.64407e-17
C317	a_114_368##4	a_114_368##2	4.35927e-18
C318	VGND#11	B2#8	1.43377e-19
C319	a_114_368##18	VPWR#10	3.13618e-19
C320	a_27_74##5	VGND#15	2.25094e-17
C321	VGND#7	A2_N#5	2.8453e-20
C322	B2#1	VGND#12	1.64822e-17
C323	a_857_74##5	a_857_74##11	2.01343e-18
C324	VPWR#17	A2_N#7	3.44144e-19
C325	VPWR#16	A2_N#9	3.44144e-19
C326	Y#2	B2#4	2.29143e-18
C327	VGND#3	a_857_74##11	1.43086e-17
C328	a_1215_368##6	Y#6	3.20146e-19
C329	a_114_368##22	A2_N#9	4.41968e-17
C330	a_857_74##10	B2#8	1.15948e-18
C331	A1_N#10	A1_N#8	3.89531e-17
C332	a_857_74##11	B2#1	3.47003e-19
C333	VGND#4	a_857_74##3	2.25484e-19
C334	VGND#5	a_114_368##2	7.73232e-20
C335	A2_N#9	VPWR#17	2.47104e-17
C336	VPWR#16	A2_N#11	1.53981e-19
C337	Y#7	a_114_368##5	2.43578e-17
C338	a_857_74##5	VGND#13	5.04756e-17
C339	VGND#12	B2#8	3.25319e-17
C340	a_27_74##6	a_27_74##5	4.69695e-19
C341	VGND#7	A1_N#4	3.80851e-20
C342	a_114_368##5	Y#4	6.39728e-17
C343	a_114_368##23	A2_N#9	1.76565e-18
C344	a_114_368##18	VPWR#9	3.13618e-19
C345	a_114_368##22	A2_N#11	1.76565e-18
C346	VGND#5	a_857_74##5	3.44799e-17
C347	a_27_74##2	a_114_368##12	6.78987e-20
C348	VPWR#18	A2_N#9	1.53981e-19
C349	A2_N#11	VPWR#17	2.84583e-17
C350	a_857_74##10	B2#10	1.64446e-19
C351	Y#2	Y#1	2.62096e-18
C352	A1_N#6	A1_N#10	3.96029e-17
C353	B1	B1#4	1.35325e-17
C354	B2#8	a_857_74##11	1.13453e-17
C355	B1	B1#2	2.75246e-17
C356	a_114_368##23	A2_N#11	5.30137e-17
C357	VPWR#14	a_1215_368##6	5.89432e-17
C358	a_114_368##19	VPWR#10	1.70072e-17
C359	VGND#12	B2#10	1.28044e-18
C360	VPWR#18	A2_N#11	3.44144e-19
C361	VPWR#17	A2_N#12	3.44144e-19
C362	A1_N#5	a_114_368##19	1.46925e-18
C363	VGND#13	B2#8	2.81859e-19
C364	a_27_74##2	A2_N#1	1.24182e-18
C365	a_114_368##23	A2_N#12	4.64918e-17
C366	VPWR#8	VPWR#6	6.93111e-19
C367	a_114_368##17	VPWR#9	3.13618e-19
C368	a_857_74##11	B2#10	3.15347e-17
C369	Y#9	a_1215_368##6	1.1974e-18
C370	Y#2	a_1215_368##8	4.97777e-17
C371	A2_N#12	VPWR#18	2.47104e-17
C372	VPWR#17	A1_N#1	1.53981e-19
C373	a_857_74##2	a_857_74#	5.57916e-19
C374	a_114_368##21	VPWR#7	2.46934e-20
C375	VPWR#3	a_1215_368#	1.82516e-17
C376	a_114_368##21	VPWR#6	2.49403e-19
C377	a_114_368##24	A2_N#12	1.76565e-18
C378	VGND#12	B2#6	1.43377e-19
C379	a_114_368##23	A1_N#1	1.76565e-18
C380	B2#10	VGND#13	1.64525e-17
C381	A2_N#4	a_114_368##17	6.87294e-17
C382	VPWR#19	A2_N#12	1.53981e-19
C383	a_1215_368##7	VPWR#3	2.57065e-17
C384	Y#9	VPWR#14	5.08673e-17
C385	A1_N#1	VPWR#18	2.84583e-17
C386	VGND#6	a_857_74##8	4.89457e-17
C387	VPWR#11	VPWR#10	7.0017e-19
C388	a_27_74##2	A2_N#8	2.63727e-17
C389	a_1215_368##2	B1#5	9.9655e-19
C390	a_857_74##11	B2#6	1.15948e-18
C391	VGND#6	a_27_74#	4.85084e-17
C392	B2	B1#5	5.20402e-18
C393	B2#3	Y#1	1.4151e-18
C394	a_114_368##24	A1_N#1	5.30137e-17
C395	a_114_368##17	VPWR#8	3.13618e-19
C396	a_1215_368##2	B1#1	9.23947e-21
C397	a_857_74##5	B2#10	4.09682e-19
C398	a_1215_368##3	VPWR#3	4.69092e-17
C399	Y#2	Y#6	6.23038e-19
C400	B2	B2#5	2.06432e-17
C401	a_857_74##12	a_857_74##5	3.02029e-18
C402	VPWR#19	A1_N#1	3.44144e-19
C403	B2	B2#3	1.52461e-17
C404	VPWR#3	Y#1	9.99656e-18
C405	A2_N#2	a_114_368##6	3.87023e-19
C406	B2	B2#2	7.46191e-18
C407	VPWR#18	A1_N#9	3.44144e-19
C408	VPWR#15	VPWR#14	2.28687e-18
C409	a_857_74##2	VGND#10	2.392e-17
C410	B1#9	B1#1	4.72694e-17
C411	VGND#13	B2#6	3.21968e-17
C412	A1_N#5	VPWR#11	3.70304e-18
C413	a_27_74##2	A2_N#4	9.72985e-19
C414	a_114_368##18	A1_N#4	3.53938e-18
C415	a_114_368##24	A1_N#9	4.64918e-17
C416	VGND#13	B2#4	3.65242e-19
C417	A2_N#16	A2_N#4	1.74417e-18
C418	B2	a_114_368##2	2.7641e-18
C419	B2#2	Y#1	1.39623e-18
C420	a_1215_368##5	B2#3	8.58444e-20
C421	a_27_74##2	A2_N#10	2.21813e-17
C422	a_857_74##11	a_114_368#	1.64446e-19
C423	A1_N#9	VPWR#19	2.47104e-17
C424	a_27_74##5	A2_N#6	3.53833e-20
C425	a_857_74##5	B2#6	2.87035e-17
C426	VPWR#18	A1_N#11	1.53981e-19
C427	VPWR#15	Y#9	5.37255e-17
C428	a_1215_368##2	B1#4	4.64078e-18
C429	a_114_368##19	A1_N#9	1.77076e-18
C430	B1#11	B1#9	4.67394e-17
C431	a_114_368##24	A1_N#11	1.76565e-18
C432	a_27_74##5	A1_N#4	6.39117e-18
C433	a_1215_368##2	B1#9	1.644e-17
C434	Y#2	a_1215_368##6	7.37933e-17
C435	VPWR#11	A1_N#9	2.59902e-19
C436	a_114_368##16	VPWR#8	2.05812e-19
C437	VGND#13	a_114_368#	1.02958e-18
C438	a_27_74##6	VPWR#11	3.27106e-19
C439	A1_N#11	VPWR#19	2.84583e-17
C440	VPWR#6	VPWR#5	6.93111e-19
C441	a_857_74##2	a_857_74##9	5.26243e-19
C442	a_114_368##19	A1_N#11	7.00401e-17
C443	a_857_74##3	VGND#11	1.4166e-17
C444	a_27_74##2	A2_N#6	4.62933e-19
C445	a_857_74##5	a_114_368#	3.41281e-17
C446	VPWR#11	A1_N#11	1.23306e-18
C447	B1#12	B1#11	4.78741e-17
C448	a_1215_368##5	B2#2	8.46999e-20
C449	a_27_74##5	A1_N#7	8.34775e-20
C450	a_857_74##12	B2#6	2.32438e-19
C451	a_114_368##5	a_857_74##12	2.54684e-18
C452	VPWR#19	A1_N#12	6.79311e-19
C453	Y#4	Y#9	6.88466e-19
C454	a_114_368##5	Y#10	6.00899e-17
C455	a_1215_368##2	B1#2	8.33478e-19
C456	a_114_368##19	A1_N#12	5.42553e-17
C457	a_114_368##5	a_857_74##8	4.30621e-17
C458	a_114_368#	Y#8	1.44708e-17
C459	a_114_368##17	A2_N#5	6.35482e-19
C460	Y#5	VPWR#15	6.23134e-17
C461	a_1215_368##2	B1#11	1.65686e-17
C462	a_27_74#	a_114_368##5	2.50838e-17
C463	A1_N#12	VPWR#11	3.36408e-17
C464	A2_N#16	a_114_368##17	3.82589e-18
C465	B2#7	B1#12	4.69671e-17
C466	a_857_74##2	VGND#11	1.4121e-17
C467	a_857_74##5	a_114_368##8	5.51013e-19
C468	B1#4	B1#9	2.31942e-19
C469	Y#10	a_857_74##12	2.68086e-17
C470	a_27_74##2	A1_N#7	2.02452e-19
C471	a_857_74##12	a_114_368#	5.51013e-19
C472	a_857_74##3	a_857_74##10	5.26243e-19
C473	VGND#7	A1_N#2	1.51492e-20
C474	a_27_74##5	A1_N#8	1.70719e-17
C475	B1#3	a_1215_368##3	1.16372e-17
C476	VPWR#16	VPWR#15	1.87864e-18
C477	VPWR#4	B2#11	4.46413e-18
C478	a_857_74##4	VGND#12	1.24297e-17
C479	B2#5	Y#6	2.74109e-19
C480	B1#5	B1#4	4.0818e-18
C481	a_114_368##8	Y#8	1.44708e-17
C482	Y#4	VPWR#15	2.68643e-17
C483	B2#9	B2#7	4.59893e-17
C484	a_114_368##21	A2_N#4	7.2225e-19
C485	Y#9	Y#2	7.5245e-19
C486	a_114_368##22	VPWR#7	1.67613e-17
C487	A2_N#16	a_114_368##16	2.11073e-17
C488	a_1215_368##2	B1#12	3.67239e-18
C489	a_857_74##5	a_114_368##10	2.32438e-19
C490	a_857_74##8	a_857_74##12	3.11896e-18
C491	a_114_368##8	a_857_74##12	1.54816e-17
C492	VPWR#16	Y#5	8.52167e-17
C493	a_114_368##25	A2_N#4	6.59923e-17
C494	a_27_74##3	A2_N#4	1.79418e-18
C495	Y#1	B2#4	6.64366e-19
C496	a_27_74##5	A1_N#10	1.69563e-17
C497	a_857_74##3	VGND#12	1.58072e-17
C498	B2#11	B2#9	4.70176e-17
C499	a_1215_368##5	B2#7	5.45974e-18
C500	B2#4	a_1215_368##8	1.20005e-18
C501	VPWR#5	VPWR#4	9.69359e-19
C502	Y#10	a_114_368##8	9.963e-19
C503	B2#4	Y#6	2.70455e-19
C504	a_114_368##21	A1_N#4	9.92067e-20
C505	a_857_74##4	a_857_74##11	5.26243e-19
C506	Y#5	Y#4	3.84717e-18
C507	VPWR#4	B2#12	4.47374e-18
C508	VGND#3	B1#7	1.72038e-18
C509	A1_N	A2_N#5	9.63544e-18
C510	a_857_74##8	Y#10	6.0129e-17
C511	a_114_368##10	a_857_74##12	1.74657e-17
C512	VGND#3	B1#8	7.43835e-19
C513	A1_N	A1_N#5	2.74038e-17
C514	a_857_74##8	a_114_368##8	2.60042e-19
C515	B2#12	B2#11	4.60403e-17
C516	a_857_74#	a_1215_368#	3.20481e-19
C517	a_1215_368##2	B2#7	2.05875e-21
C518	A1_N	A1_N#2	1.38737e-17
C519	VGND#14	A1_N#4	6.21465e-19
C520	VGND#3	B1#10	5.79199e-18
C521	a_114_368##22	VPWR#16	5.76466e-17
C522	VGND#3	B1#6	5.75148e-18
C523	a_27_74##5	A1_N#6	1.75415e-19
C524	Y#10	a_114_368##10	4.30164e-17
C525	a_1215_368##6	B2#5	8.58444e-20
C526	VGND#15	A1_N#4	3.31951e-19
C527	VGND#3	B2#1	7.29522e-19
C528	a_114_368##2	Y#8	1.71072e-19
C529	a_1215_368##5	B2#9	1.56452e-17
C530	a_114_368##16	A2_N#3	9.50763e-19
C531	VPWR#5	a_114_368##9	4.75825e-19
C532	a_114_368##9	B2#12	6.4729e-18
C533	a_857_74##12	a_114_368##4	1.06817e-20
C534	a_114_368##5	Y#9	2.35532e-18
C535	VGND#3	B2#8	8.19587e-19
C536	a_857_74##4	VGND#13	2.36927e-17
C537	a_857_74##12	a_114_368##12	9.76664e-19
C538	a_857_74##8	a_114_368##10	5.95044e-19
C539	a_114_368##5	VPWR#15	2.40518e-18
C540	VGND#3	B2#10	1.51907e-19
C541	VPWR#4	a_114_368##9	1.80816e-18
C542	VPWR#17	VPWR#16	1.87864e-18
C543	a_114_368##21	a_114_368##8	3.81288e-20
C544	a_114_368##5	Y#5	4.69807e-17
C545	B1	a_1215_368##2	3.1182e-17
C546	a_114_368##18	A1_N#2	1.19906e-18
C547	a_114_368##5	VPWR#16	1.26869e-17
C548	Y#10	a_114_368##12	3.20186e-17
C549	a_857_74##7	Y#8	8.96418e-19
C550	Y	B2#5	1.07082e-18
C551	a_114_368##11	a_114_368##9	4.71608e-17
C552	Y	a_114_368##6	5.50043e-19
C553	Y	a_114_368##4	1.03682e-18
C554	a_857_74##2	B1	3.55961e-17
C555	a_27_74#	a_857_74##8	6.40717e-17
C556	VPWR#17	a_114_368##22	5.21059e-17
C557	Y	a_114_368##2	3.46396e-18
C558	VPWR#3	B1#4	2.04712e-20
C559	VPWR#6	a_114_368##11	8.1728e-20
C560	a_857_74##12	A2_N#1	7.804e-20
C561	a_857_74##8	a_114_368##12	3.8416e-17
C562	Y#10	a_114_368##6	2.40116e-18
C563	a_1215_368##5	B2#11	1.5558e-17
C564	a_114_368##21	a_114_368##10	5.578e-20
C565	a_857_74##5	a_857_74##4	5.40749e-19
C566	VPWR#5	a_114_368##11	5.07346e-18
C567	a_114_368##13	a_114_368##11	4.79037e-17
C568	B1#12	B1#4	2.31942e-19
C569	A2_N#4	VPWR#17	6.49347e-19
C570	a_27_74#	a_114_368##12	1.52877e-18
C571	VPWR#3	B2#3	1.13558e-20
C572	a_114_368##23	a_114_368##22	2.96061e-18
C573	A2_N#4	a_114_368##23	4.07509e-19
C574	B1#4	B1#2	3.41818e-18
C575	VPWR#3	B2#2	1.12044e-20
C576	a_857_74##12	a_114_368##2	6.81755e-19
C577	a_857_74##7	a_857_74##12	2.43406e-19
C578	a_857_74##4	B2	8.62424e-17
C579	a_857_74##8	A2_N#1	1.52914e-18
C580	a_114_368##7	a_114_368##13	4.62096e-17
C581	a_857_74##3	B2	1.82682e-17
C582	Y#10	a_114_368##4	6.1416e-19
C583	a_114_368##21	a_114_368##12	1.79666e-19
C584	Y#7	B2	1.53709e-17
C585	a_857_74##4	a_857_74##3	5.57916e-19
C586	a_114_368##23	VPWR#17	5.20507e-17
C587	VGND#6	a_114_368##12	4.46238e-18
C588	VPWR#6	a_114_368##13	2.85183e-19
C589	a_27_74#	A2_N#1	4.23729e-17
C590	a_857_74##3	B1#5	1.14804e-18
C591	B2	Y#2	8.7058e-17
C592	VGND#6	A2_N#1	4.48038e-18
C593	A2_N#7	a_114_368##7	5.30735e-17
C594	A1_N#4	a_114_368##24	2.74109e-19
C595	VPWR#5	a_114_368##13	7.34667e-18
C596	a_27_74#	a_114_368##21	6.89657e-17
C597	VGND#6	A2_N#8	4.43427e-18
C598	A1_N#4	VPWR#19	1.84663e-18
C599	a_857_74#	B1	4.21923e-17
C600	VGND#7	a_27_74##3	3.17302e-17
C601	VGND#6	A2_N#10	4.43427e-18
C602	A1_N#4	a_114_368##19	1.51266e-18
C603	a_114_368##21	A2_N#1	3.78735e-17
C604	VPWR#18	VPWR#17	1.87864e-18
C605	VPWR#3	B1#1	1.35704e-18
C606	VGND#3	B1#4	5.44073e-20
C607	A1_N	VPWR#10	1.9844e-20
C608	a_857_74##7	Y#10	1.62812e-17
C609	a_857_74##8	a_114_368##6	6.68629e-18
C610	VPWR#3	B1#9	9.47362e-19
C611	A2_N#9	A2_N#7	4.55459e-17
C612	a_27_74#	A2_N#8	4.03705e-19
C613	VPWR#8	a_114_368##7	8.1728e-20
C614	VPWR#3	B1#11	5.2353e-18
C615	a_857_74##7	Y#7	2.63059e-17
C616	VPWR#18	a_114_368##23	5.21059e-17
C617	VPWR#3	B1#12	5.03484e-18
C618	a_857_74##7	a_114_368##6	1.16958e-19
C619	VPWR#6	a_114_368##7	7.22661e-18
C620	a_114_368##16	Y#5	6.71779e-19
C621	A2_N#11	A2_N#9	4.75303e-17
C622	Y#2	a_1215_368##5	1.63179e-17
C623	a_114_368##21	A2_N#8	2.80054e-17
C624	Y#10	a_114_368##2	1.0686e-18
C625	VPWR#3	B2#7	6.48303e-18
C626	a_114_368##25	A2_N#1	1.94418e-19
C627	VPWR#5	a_114_368##7	2.85183e-19
C628	a_857_74##4	B2#5	2.46455e-18
C629	VPWR#3	B2#9	6.23274e-18
C630	a_27_74#	A2_N#10	1.78624e-19
C631	Y#2	B2#9	1.57063e-18
C632	a_114_368##24	a_114_368##23	2.96061e-18
C633	VPWR#3	B2#11	1.6217e-18
C634	A2_N#8	a_27_74##7	1.0294e-17
C635	A2_N#12	A2_N#11	4.58544e-17
C636	a_114_368##21	a_27_74##7	2.5868e-19
C637	A2_N#3	A2_N#2	7.47673e-18
C638	a_857_74##5	B2	4.03706e-17
C639	a_857_74##2	B1#5	4.04408e-19
C640	VPWR#3	B2#12	3.20503e-20
C641	a_857_74##3	a_857_74##2	5.40104e-19
C642	a_114_368##21	A2_N#10	4.68127e-19
C643	Y	VPWR#4	1.21628e-18
C644	VPWR#8	A2_N#7	2.85183e-19
C645	a_114_368##25	A2_N#8	9.55024e-19
C646	VGND	a_114_368##6	5.00333e-19
C647	B1	a_1215_368#	4.49723e-17
C648	a_114_368##16	VPWR#16	2.5473e-17
C649	VGND	a_114_368##4	4.69444e-20
C650	a_857_74##7	a_114_368##4	2.23253e-19
C651	a_114_368##24	VPWR#18	5.20507e-17
C652	A1_N#1	A2_N#12	4.74903e-17
C653	VGND	a_114_368##2	9.20233e-19
C654	a_857_74##5	Y#7	5.31968e-17
C655	A1_N	a_114_368##18	7.83074e-17
C656	VGND	A2_N#3	1.33362e-18
C657	VPWR#6	A2_N#7	4.67272e-18
C658	A2_N#10	a_27_74##7	1.29198e-17
C659	B1#3	B1#12	2.07025e-18
C660	a_857_74##4	B2#3	1.10354e-18
C661	a_27_74##3	A2_N#8	1.72185e-19
C662	a_27_74##5	A1_N	8.83957e-17
C663	a_114_368##25	a_114_368##21	2.59023e-18
C664	B1#3	B2#7	8.39733e-19
C665	VPWR#5	A2_N#7	8.1728e-20
C666	Y#2	B2#11	3.38297e-17
C667	A1_N#9	A1_N#1	4.5808e-17
C668	VGND#7	a_27_74##8	5.44631e-18
C669	B1#3	B2#9	2.07909e-19
C670	VPWR#19	VPWR#18	1.87864e-18
C671	a_114_368##25	A2_N#10	4.44046e-17
C672	a_857_74##2	B1#4	6.12019e-18
C673	Y#7	Y	4.15059e-18
C674	VPWR	VPWR#10	7.0596e-17
C675	VPWR#9	A2_N#9	8.1728e-20
C676	Y#4	B2#12	4.55492e-20
C677	VPWR	VPWR#9	6.06949e-17
C678	B2#2	B1#5	3.12157e-17
C679	A1_N#11	A1_N#9	4.75303e-17
C680	a_114_368##16	a_114_368##22	9.64995e-19
C681	VPWR	VPWR#8	4.59047e-17
C682	VPWR	VPWR#6	5.37254e-17
C683	VGND#4	B1#6	4.44675e-19
C684	B2	Y#1	5.18714e-17
C685	VPWR#14	a_114_368##2	3.41456e-19
C686	VPWR	VPWR#5	6.03915e-17
C687	VPWR	VPWR#4	8.61644e-17
C688	a_27_74##3	A2_N#10	4.01042e-19
C689	VPWR#8	A2_N#9	2.86927e-18
C690	a_114_368##25	a_27_74##7	3.15678e-19
C691	VPWR#19	a_114_368##24	5.21059e-17
C692	VPWR#7	A2_N#7	1.90502e-18
C693	VGND#6	a_114_368##7	4.44855e-19
C694	a_114_368##17	VPWR#17	9.64418e-18
C695	VPWR#7	A2_N#9	2.2096e-18
C696	A1_N#12	A1_N#11	4.57353e-17
C697	VPWR#6	A2_N#9	2.85183e-19
C698	a_114_368##25	A2_N#6	3.24645e-17
C699	VPWR	a_1215_368##5	1.33181e-19
C700	Y#2	B2#12	3.82177e-17
C701	a_114_368##19	a_114_368##24	2.96061e-18
C702	a_27_74##3	A1_N	2.92384e-17
C703	a_857_74##2	B1#2	1.27719e-18
C704	a_27_74##3	A2_N#6	4.68195e-17
C705	VPWR	Y#4	2.00926e-18
C706	a_114_368#	B2#5	1.44673e-17
C707	Y#4	a_114_368##9	9.99137e-18
C708	a_114_368##16	VPWR#17	9.44106e-18
C709	VPWR#7	A2_N#3	3.74368e-20
C710	VPWR	Y#2	5.72075e-18
C711	a_114_368##21	a_114_368##6	1.08476e-18
C712	a_27_74##6	A1_N	4.27327e-17
C713	VPWR	a_114_368##18	2.86323e-18
C714	VPWR#9	A2_N#11	2.85183e-19
C715	a_114_368##5	a_114_368##7	1.66497e-17
C716	a_857_74##3	B2#3	7.57314e-19
C717	VPWR	a_114_368##17	2.70383e-18
C718	VPWR#7	A2_N#2	3.69376e-20
C719	VGND#4	B2#1	5.27198e-18
C720	VPWR	a_114_368##16	1.16334e-18
C721	Y#7	a_857_74##12	2.89254e-17
C722	a_857_74##7	a_114_368##2	2.73752e-19
C723	a_114_368##25	A1_N#7	1.23391e-18
C724	VGND#7	a_27_74##5	2.91756e-19
C725	VGND#14	A2_N#6	1.09159e-18
C726	a_114_368##19	VPWR#19	5.51789e-17
C727	a_114_368##17	a_114_368##23	1.34628e-18
C728	VPWR#8	A2_N#11	5.11299e-18
C729	VGND	VGND#7	9.81563e-17
C730	VPWR	A2_N#16	2.22589e-18
C731	VGND	VGND#5	1.10907e-16
C732	Y#2	a_114_368##9	2.93278e-19
C733	VPWR#6	A2_N#11	8.1728e-20
C734	a_27_74##3	A1_N#7	2.57758e-17
C735	a_27_74##3	a_114_368##25	5.46527e-17
C736	VPWR#15	a_114_368##6	8.25599e-19
C737	a_27_74##8	A2_N#6	1.34794e-19
C738	VGND	a_857_74##7	2.7543e-17
C739	a_27_74##5	A1_N#5	1.37346e-18
C740	a_114_368##18	VPWR#18	1.18006e-17
C741	VGND	a_857_74##4	1.10826e-18
C742	a_114_368##21	a_114_368##4	5.80113e-20
C743	A2_N#4	A2_N#11	2.04506e-18
C744	VGND#5	B2#8	7.58492e-19
C745	VPWR#11	VPWR#19	1.94092e-18
C746	B2	a_114_368#	1.8176e-17
C747	VGND#6	a_114_368##6	2.02064e-19
C748	VGND	Y#7	9.29924e-18
C749	VGND	Y#4	3.6374e-18
C750	A2_N#4	A2_N#12	2.95938e-18
C751	Y#4	a_114_368##11	1.88477e-17
C752	VGND#14	A1_N#7	3.1582e-17
C753	VGND#6	a_114_368##4	1.12499e-20
C754	A2_N#4	A1_N#1	6.74879e-19
C755	VPWR#10	A2_N#12	8.1728e-20
C756	A1_N#2	A2_N#5	3.66095e-17
C757	VPWR#14	a_114_368#	5.12631e-19
C758	VPWR	a_114_368##21	1.69922e-18
C759	Y	a_1215_368##6	7.49355e-18
C760	VPWR#3	B1#3	5.87547e-18
C761	a_857_74##3	B2#2	1.69722e-18
C762	A1_N	a_114_368##19	5.42369e-17
C763	Y	VPWR#14	3.52977e-17
C764	Y#10	Y#7	3.29647e-18
C765	VGND	a_27_74##5	4.07016e-18
C766	A1_N	VPWR#11	3.24563e-17
C767	VGND	a_27_74##2	3.28946e-17
C768	VGND#4	B2#8	5.06543e-18
C769	a_114_368##17	VPWR#18	1.02811e-17
C770	a_27_74##2	A2_N#5	2.33923e-19
C771	VPWR#9	A2_N#12	5.11299e-18
C772	VGND	A2_N#16	1.92093e-18
C773	VGND#3	B1#3	5.42246e-18
C774	a_27_74##3	A1_N#8	3.97516e-19
C775	VPWR#11	a_114_368##19	7.82032e-17
C776	VPWR#3	B2#4	1.83964e-20
C777	B1#5	VNB	2.62437e-17
C778	a_27_74##8	A1_N#7	3.1801e-19
C779	B1#4	VNB	5.63682e-17
C780	B1	B1#1	3.2639e-18
C781	B1#2	VNB	5.21167e-17
C782	a_857_74##2	B1#7	2.23038e-19
C783	B2#5	VNB	3.20654e-17
C784	B2#3	VNB	2.31736e-17
C785	B2#2	VNB	2.47177e-17
C786	a_114_368##6	VNB	6.0555e-17
C787	B1	B1#9	2.03504e-18
C788	a_114_368##4	VNB	1.98829e-17
C789	Y#2	a_114_368##11	8.3819e-20
C790	a_114_368##2	VNB	3.49795e-17
C791	A2_N#5	VNB	2.81566e-17
C792	VPWR#8	A2_N#12	2.85183e-19
C793	A2_N#3	VNB	2.47672e-17
C794	A2_N#2	VNB	1.87996e-17
C795	A1_N#5	VNB	5.1643e-17
C796	A1_N#2	VNB	2.57738e-17
C797	B1#3	B1#5	1.66798e-17
C798	VGND#6	A2_N#3	4.06781e-20
C799	a_114_368##18	a_114_368##24	1.34628e-18
C800	VGND#14	A1_N#8	2.9183e-17
C801	VGND	a_857_74##5	1.75675e-17
C802	B1#3	B1#4	2.48613e-17
C803	VPWR	a_1215_368##6	2.32882e-17
C804	VGND	Y#10	8.79941e-18
C805	VPWR	VPWR#14	2.19416e-17
C806	VGND#6	A2_N#2	2.34651e-20
C807	VGND	a_857_74##8	2.26779e-17
C808	VPWR	Y#9	1.50215e-17
C809	VGND	a_27_74#	2.25003e-17
C810	VPWR#4	a_114_368#	3.65152e-19
C811	VGND	a_114_368##21	1.18072e-17
C812	VGND#5	B2#10	5.33152e-18
C813	a_857_74##3	B1#8	4.36499e-20
C814	Y#4	a_114_368##13	7.21542e-19
C815	VPWR	Y#5	1.8522e-17
C816	B2	B1#12	2.91807e-19
C817	VGND#6	a_114_368##5	9.9502e-19
C818	VGND	a_114_368##25	9.28333e-18
C819	VGND	a_27_74##3	1.78436e-17
C820	VPWR	a_114_368##22	1.88433e-17
C821	B2	B2#7	1.36545e-18
C822	a_27_74##3	A1_N#10	1.67794e-19
C823	VGND	a_27_74##8	1.22008e-17
C824	VPWR	a_114_368##23	1.72175e-17
C825	B2	B2#9	2.05574e-18
C826	A1_N#8	a_27_74##8	1.42189e-17
C827	a_27_74##3	VGND#14	5.58806e-17
C828	VGND#6	A2_N#4	4.39394e-20
C829	VGND	a_27_74##6	1.55586e-17
C830	B2	B2#11	2.06454e-18
C831	VPWR	a_114_368##24	1.72175e-17
C832	Y	a_114_368#	2.40452e-18
C833	a_27_74##2	A2_N#3	5.71242e-19
C834	B2	B2#12	2.09019e-18
C835	B1#3	B2#3	4.93783e-20
C836	VPWR	a_114_368##19	1.81093e-17
C837	VPWR#10	A1_N#1	2.85183e-19
C838	a_114_368##21	a_114_368##2	1.04539e-19
C839	VPWR	VPWR#11	5.63614e-17
C840	B2	a_114_368##9	2.10316e-19
C841	Y#5	a_114_368##6	6.07196e-18
C842	VGND#4	B2#10	5.91927e-19
C843	B1#3	B2#2	5.68674e-18
C844	a_857_74##2	B1#8	2.15111e-17
C845	VGND#14	A1_N#10	1.4028e-18
C846	VGND#15	A1_N#8	1.67452e-18
C847	VPWR#9	A1_N#1	5.10757e-18
C848	VGND#7	a_27_74##2	1.37756e-17
C849	VPWR#10	VNB	3.15224e-17
C850	VPWR#9	VNB	2.61696e-17
C851	VGND	Y#5	3.03303e-18
C852	a_27_74##5	A1_N#2	5.59668e-19
C853	VPWR#8	VNB	1.87157e-17
C854	VPWR#6	VNB	2.00808e-17
C855	VGND	VPWR#16	2.72465e-18
C856	VPWR#5	VNB	2.62134e-17
C857	VPWR#4	VNB	5.91835e-17
C858	a_114_368##18	VPWR#19	1.44663e-17
C859	a_114_368##2	a_114_368#	1.5088e-18
C860	VGND#7	VNB	4.19686e-17
C861	VGND#5	VNB	6.6142e-17
C862	VGND#4	VNB	2.91759e-17
C863	VPWR#8	A1_N#1	8.1728e-20
C864	a_1215_368##5	VNB	5.40453e-18
C865	a_114_368##16	a_114_368##24	7.63555e-22
C866	a_857_74##7	VNB	5.35793e-18
C867	A1_N#10	a_27_74##8	1.76978e-17
C868	a_857_74##4	VNB	1.62202e-18
C869	a_27_74##8	a_27_74##3	1.73293e-18
C870	a_857_74##3	VNB	4.43771e-18
C871	a_27_74#	A2_N#2	1.52522e-19
C872	a_857_74##2	VNB	1.42747e-18
C873	a_27_74##6	A1_N#8	1.87539e-19
C874	Y#7	VNB	1.50907e-18
C875	Y#4	VNB	1.26681e-18
C876	a_857_74##3	B1#10	9.98825e-20
C877	Y	B2#7	1.59475e-19
C878	a_114_368##16	VNB	4.38203e-19
C879	a_114_368##21	A2_N#5	3.62555e-20
C880	Y	B2#9	1.32101e-19
C881	VPWR#3	B1	6.09662e-18
C882	VGND#5	B2#6	4.75632e-18
C883	a_27_74##5	VNB	1.7566e-18
C884	VGND	B2#6	8.39544e-19
C885	Y	B2#11	2.16788e-19
C886	a_27_74##2	VNB	6.42897e-18
C887	VGND	a_114_368#	2.47277e-18
C888	A2_N#16	VNB	1.72523e-18
C889	VGND#3	B1	5.27919e-18
C890	a_27_74##2	A2_N#2	5.6529e-20
C891	VGND	a_114_368##8	1.64944e-18
C892	Y	B2#12	8.81821e-19
C893	VGND	a_114_368##10	1.63851e-18
C894	Y	a_114_368##9	1.61152e-17
C895	VGND#15	A1_N#10	3.40415e-17
C896	a_857_74#	VNB	4.33305e-17
C897	VGND	a_114_368##12	1.67093e-18
C898	VGND#10	VNB	2.02178e-18
C899	a_857_74##9	VNB	2.12109e-18
C900	VGND	A2_N#1	1.67663e-18
C901	VPWR#3	B2	6.46047e-18
C902	VGND#11	VNB	3.53192e-20
C903	a_857_74##10	VNB	2.12109e-18
C904	VGND	A2_N#8	1.6429e-18
C905	VPWR#4	B2#5	1.13558e-20
C906	VGND#12	VNB	3.97937e-19
C907	A1_N	A2_N#12	9.9479e-19
C908	a_857_74##11	VNB	2.12109e-18
C909	VGND	A2_N#10	1.54859e-18
C910	VPWR#6	a_114_368##6	5.88154e-20
C911	VGND#3	B2	5.504e-18
C912	VGND#13	VNB	3.97937e-19
C913	a_857_74##5	VNB	3.72296e-18
C914	VGND	A2_N#6	1.46569e-18
C915	Y	a_114_368##7	2.82327e-19
C916	A1_N	A1_N#1	1.98712e-18
C917	VGND	A1_N#7	8.39544e-19
C918	Y#10	VNB	3.98928e-19
C919	Y	A2_N#7	2.20694e-19
C920	a_857_74##8	VNB	1.40196e-17
C921	VGND	A1_N#8	6.35575e-19
C922	A1_N	A1_N#9	2.04646e-18
C923	a_27_74#	VNB	1.49242e-17
C924	a_114_368##21	VNB	7.25562e-19
C925	VGND	A1_N#10	6.35575e-19
C926	B1#8	B1#7	2.48026e-17
C927	VPWR	B2#12	2.04147e-18
C928	A1_N	A1_N#11	2.04678e-18
C929	a_114_368##25	VNB	5.11641e-19
C930	VGND	A1_N#6	1.6266e-18
C931	a_27_74##3	VNB	6.25298e-18
C932	a_857_74##2	B1#10	1.70119e-17
C933	VPWR	a_114_368##9	1.00124e-18
C934	VPWR#10	A1_N#9	5.10765e-18
C935	VGND#14	VNB	4.67461e-20
C936	a_27_74##8	VNB	4.60476e-18
C937	A1_N	A1_N#12	5.87049e-18
C938	VGND#15	VNB	2.25711e-18
C939	VPWR	a_114_368##11	8.22478e-19
C940	B2	B1#3	1.94967e-17
C941	VGND#4	B2#6	1.72693e-19
C942	a_27_74##6	VNB	4.30086e-17
C943	a_27_74##8	A1_N#6	6.68248e-19
C944	a_1215_368#	VNB	5.37799e-17
C945	VPWR	a_114_368##13	3.74989e-19
C946	VPWR#12	VNB	3.07328e-18
C947	a_27_74##8	VGND#14	4.16996e-17
C948	a_27_74##6	A1_N#10	8.48022e-19
C949	a_1215_368##7	VNB	2.1429e-18
C950	B2	B2#4	2.11547e-17
C951	VPWR#13	VNB	4.82501e-19
C952	VPWR	a_114_368##7	2.55153e-18
C953	a_1215_368##3	VNB	2.53806e-18
C954	a_114_368##19	a_114_368##18	2.96061e-20
C955	VPWR	A2_N#7	3.34024e-18
C956	a_1215_368##6	VNB	1.28419e-17
C957	VPWR	A2_N#9	7.96105e-19
C958	VPWR#14	VNB	7.91083e-18
C959	VPWR#9	A1_N#9	2.85183e-19
C960	Y#9	VNB	2.27222e-18
C961	VPWR	A2_N#11	8.32449e-19
C962	VPWR#15	VNB	2.92383e-18
C963	Y#5	VNB	2.2917e-18
C964	VPWR#16	VNB	3.68812e-18
C965	VPWR	A2_N#12	8.32449e-19
C966	a_114_368##22	VNB	2.33095e-18
C967	VPWR#17	VNB	2.92383e-18
C968	VPWR	A1_N#1	8.32673e-19
C969	a_114_368##21	A2_N#3	1.25823e-17
C970	a_114_368##23	VNB	2.1429e-18
C971	VPWR#18	VNB	2.92383e-18
C972	a_114_368##24	VNB	2.1429e-18
C973	VPWR	A1_N#9	8.32449e-19
C974	VPWR#19	VNB	2.92383e-18
C975	B2#5	B2#4	3.46161e-18
C976	a_114_368##19	VNB	2.19739e-18
C977	VGND	a_114_368##7	1.70634e-18
C978	VPWR	A1_N#11	7.45268e-19
C979	VPWR#11	VNB	7.62732e-17
C980	B1#7	VNB	3.06436e-17
C981	VGND#15	A1_N#6	3.02801e-17
C982	A2_N#16	A2_N#3	1.35436e-17
C983	B1#8	VNB	2.71082e-17
C984	VPWR	A1_N#12	2.47835e-18
C985	B1#10	VNB	2.51389e-17
C986	B1#6	VNB	2.53811e-17
C987	B2#1	VNB	2.71195e-17
C988	B2#8	VNB	2.55657e-17
C989	B2#10	VNB	2.71509e-17
C990	A1_N	A2_N#4	2.85436e-17
C991	B2#4	B2#3	4.0818e-18
C992	B2#6	VNB	2.49585e-17
C993	a_857_74##3	B1#6	1.39582e-17
C994	a_114_368#	VNB	4.77172e-17
C995	Y#7	Y#4	8.72949e-19
C996	a_114_368##8	VNB	2.83697e-17
C997	a_114_368##10	VNB	2.83901e-17
C998	A1_N	A1_N#4	3.68917e-17
C999	a_114_368##12	VNB	3.11284e-17
C1000	VPWR	VPWR#7	2.46057e-17
C1001	A2_N#1	VNB	3.18963e-17
C1002	a_114_368##5	Y	1.56379e-17
C1003	A2_N#8	VNB	2.87198e-17
C1004	A2_N#10	VNB	2.89576e-17
C1005	A2_N#6	VNB	2.87781e-17
C1006	A1_N#7	VNB	2.51369e-17
C1007	A1_N#8	VNB	2.52499e-17
C1008	A1_N#10	VNB	2.52713e-17
C1009	VGND#5	a_114_368#	5.16251e-18
C1010	A1_N#6	VNB	3.36817e-17
C1011	B1#1	VNB	3.86312e-17
C1012	VPWR	a_114_368##5	9.31253e-18
C1013	B1#9	VNB	3.22759e-17
C1014	B1#11	VNB	2.99925e-17
C1015	VPWR	A2_N#4	4.47996e-18
C1016	B1#12	VNB	2.82578e-17
C1017	VGND	VGND#6	1.29314e-16
C1018	a_27_74##6	A1_N#6	3.07273e-17
C1019	B2#7	VNB	3.30114e-17
C1020	VGND#15	VGND#14	2.87989e-18
C1021	B2#9	VNB	3.20411e-17
C1022	B2#11	VNB	3.21289e-17
C1023	B2#12	VNB	3.39208e-17
C1024	a_114_368##9	VNB	3.28691e-17
C1025	Y#7	B2#5	7.92252e-19
C1026	a_114_368##11	VNB	3.16106e-17
C1027	VGND	a_114_368##5	1.2878e-17
C1028	a_114_368##13	VNB	3.45478e-17
C1029	a_114_368##7	VNB	5.778e-17
C1030	VGND	A2_N#4	5.42927e-18
C1031	A2_N#7	VNB	3.97354e-17
C1032	A2_N#9	VNB	3.3324e-17
C1033	A2_N#11	VNB	3.27868e-17
C1034	B1#10	B1#8	4.0035e-17
C1035	A2_N#12	VNB	3.34824e-17
C1036	A1_N#1	VNB	3.26921e-17
C1037	A1_N#9	VNB	3.24123e-17
C1038	a_857_74##2	B1#6	9.98825e-20
C1039	A1_N#11	VNB	3.26299e-17
C1040	Y	B2	5.0642e-17
C1041	a_114_368##9	B2#5	1.74948e-19
C1042	A1_N#12	VNB	4.05145e-17
C1043	a_114_368##21	A2_N#2	2.63758e-17
C1044	VPWR#3	VNB	2.31594e-16
C1045	a_857_74##4	B2#1	9.3195e-20
C1046	VGND#3	VNB	1.97087e-16
C1047	a_857_74#	B1#2	4.39433e-18
C1048	VPWR	B2	5.47845e-18
C1049	VPWR#7	VNB	1.32712e-17
C1050	VGND#6	VNB	7.69619e-17
C1051	B1#3	VNB	8.68796e-18
C1052	VPWR#9	A2_N#5	1.01895e-20
C1053	B2#4	VNB	3.39985e-17
C1054	a_114_368##5	VNB	5.15915e-18
C1055	VGND	B2	5.19347e-18
C1056	VPWR	A1_N	1.28458e-17
C1057	A2_N#4	VNB	3.36605e-17
C1058	A1_N#4	VNB	5.65766e-17
C1059	VPWR#10	A1_N#11	5.10765e-18
C1060	VPWR	Y	5.17318e-18
C1061	VGND	A1_N	1.15858e-17
C1062	VGND	Y	4.29998e-19
C1063	B1	VNB	3.33426e-17
C1064	B2	VNB	2.15794e-17
C1065	A2_N#16	A2_N#2	7.32065e-19
C1066	a_114_368##16	a_114_368##7	5.22009e-19
C1067	A1_N	VNB	4.13914e-17
C1068	Y	VNB	7.17338e-18
C1069	VPWR	VNB	2.97584e-16
C1070	VGND	VNB	3.06292e-16
C1071	VPWR#9	A1_N#11	8.1728e-20
C1072	VGND#8	A1_N#8	6.38445e-19
C1073	VGND#8	A1_N#10	4.3597e-18
C1074	VGND#8	A1_N#6	4.09596e-18
C1075	VGND#2	a_857_74#	1.7841e-17
C1076	VGND#2	a_857_74##2	2.25448e-19
C1077	VGND#8	VGND#7	1.09767e-18
C1078	a_1215_368##2	VPWR#2	2.40114e-19
C1079	VPWR#3	VPWR#2	8.84794e-17
C1080	VGND#8	a_27_74##5	2.91756e-19
C1081	VGND#2	B1#4	1.99493e-20
C1082	VGND#2	B1#7	5.00635e-18
C1083	VGND#2	a_857_74##9	6.70407e-18
C1084	VGND#2	VNB	4.77127e-17
C1085	a_1215_368#	VPWR#2	2.05646e-17
C1086	VGND#8	a_27_74##8	5.49571e-18
C1087	VGND#2	B1#2	9.02254e-20
C1088	VGND#3	VGND#2	9.8991e-17
C1089	a_1215_368##7	VPWR#2	8.43957e-18
C1090	VGND	VGND#8	9.43911e-17
C1091	VGND#2	B1#8	5.33152e-18
C1092	VGND#8	A1_N#4	4.08055e-20
C1093	VGND#8	A1_N#5	8.79584e-20
C1094	VGND#8	a_27_74##6	1.7841e-17
C1095	VPWR#2	B1#1	4.82583e-18
C1096	VPWR#2	B1#9	4.7576e-18
C1097	VGND#8	VNB	4.39239e-17
C1098	VPWR#2	B1#11	5.12045e-19
C1099	VPWR#2	B1#12	7.39235e-20
C1100	VGND#2	B1#10	7.58492e-19
C1101	VPWR#2	B1#4	2.70219e-20
C1102	VPWR#2	VNB	4.50504e-17
C1103	VPWR#2	B1#2	4.88579e-20
*
*
.ENDS sky130_fd_sc_hs__o2bb2ai_4
*
