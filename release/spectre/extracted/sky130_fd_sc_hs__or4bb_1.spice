* Extracted by Quantus, converted by sky130cad/quantus.py
*
*
*
*                       LINUX           Wed Nov 18 09:08:21 2026
*
*
*
*  PROGRAM  advgen
*
*  Name           : advgen - Quantus - (64-bit)
*  Version        : 25.1.0-p047
*  Build Date     : Thu Dec 11 23:20:30 PST 2025
*
*  HSPICE LIBRARY
*
*  OPERATING_TEMPERATURE 150
*  QRC_TECH_DIR <path>/tech
*
*
*

*
.SUBCKT sky130_fd_sc_hs__or4bb_1 VNB VPB VGND VPWR X D_N C_N B A
*
*
*  caps2d version: 10
*
*
*       TRANSISTOR CARDS
*
*
XM5 a_27_424##7 C_N#1 VGND#11 VNB sky130_fd_pr__nfet_01v8_lvt l=0.15 w=0.55 ad=0.15675 as=0.231 pd=1.67 ps=1.94
XM3 VGND#11 D_N#1 a_216_424##7 VNB sky130_fd_pr__nfet_01v8_lvt l=0.15 w=0.55 ad=0.231 as=0.15675 pd=1.94 ps=1.67
XM11 VGND#10 a_216_424##4 a_357_378##9 VNB sky130_fd_pr__nfet_01v8_lvt l=0.15 w=0.55 ad=0.165 as=0.18425 pd=1.7 ps=1.77
XM0 a_357_378##9 a_27_424# VGND#9 VNB sky130_fd_pr__nfet_01v8_lvt l=0.15 w=0.55 ad=0.18425 as=0.22825 pd=1.77 ps=1.93
XM6 VGND#9 B#1 a_357_378##8 VNB sky130_fd_pr__nfet_01v8_lvt l=0.15 w=0.55 ad=0.22825 as=0.1925 pd=1.93 ps=1.8
XM2 a_357_378##8 A#1 VGND#8 VNB sky130_fd_pr__nfet_01v8_lvt l=0.15 w=0.55 ad=0.1925 as=0.29775 pd=1.8 ps=2.39
XM13 VGND#8 a_357_378# X#1 VNB sky130_fd_pr__nfet_01v8_lvt l=0.15 w=0.74 ad=0.29775 as=0.2109 pd=2.39 ps=2.05
XM10 a_27_424##6 C_N#4 VPWR#7 VPB sky130_fd_pr__pfet_01v8 l=0.15 w=0.84 ad=0.2478 as=0.294 pd=2.27 ps=2.38
XM1 VPWR#7 D_N#3 a_216_424##8 VPB sky130_fd_pr__pfet_01v8 l=0.15 w=0.84 ad=0.294 as=0.43785 pd=2.38 ps=2.97
XM12 a_357_378##7 a_216_424# a_446_378# VPB sky130_fd_pr__pfet_01v8 l=0.15 w=1 ad=0.295 as=0.27 pd=2.59 ps=2.54
XM8 a_446_378# a_27_424##3 a_530_378# VPB sky130_fd_pr__pfet_01v8 l=0.15 w=1 ad=0.27 as=0.33 pd=2.54 ps=2.66
XM7 a_530_378# B#3 a_626_378# VPB sky130_fd_pr__pfet_01v8 l=0.15 w=1 ad=0.33 as=0.39 pd=2.66 ps=2.78
XM4 a_626_378# A#3 VPWR#6 VPB sky130_fd_pr__pfet_01v8 l=0.15 w=1 ad=0.39 as=0.4724 pd=2.78 ps=3.11
XM9 VPWR#6 a_357_378##3 X#3 VPB sky130_fd_pr__pfet_01v8 l=0.15 w=1.12 ad=0.4724 as=0.3304 pd=3.11 ps=2.83
*
*
*       RESISTOR AND CAP/DIODE CARDS
*
Rg1	C_N#1	C_N#2	423.379517
Rg2	C_N#2	C_N#3	24.690777
Rg3	C_N#2	C_N#4	513.739746
Rg4	D_N#1	D_N#2	288.188507
Rg5	D_N#2	D_N#3	482.862061
Rg6	a_216_424#	a_216_424##2	610.968689
Rg7	a_216_424##2	a_216_424##3	28.593161
Rg8	a_216_424##2	a_216_424##4	450.857361
Rg9	a_27_424#	a_27_424##2	357.657318
Rg10	a_27_424##2	a_27_424##3	500.608307
Rg11	B#1	B#2	437.056641
Rg12	B#2	B#3	422.415131
Rg13	A#1	A#2	437.056641
Rg14	A#2	A#3	422.415131
Rg15	a_357_378#	a_357_378##2	353.846649
Rg16	a_357_378##2	a_357_378##3	456.846832
Rf1	C_N#5	C_N#3	160.919952
Rf2	C_N	C_N#7	0.687145
Rf3	C_N#5	C_N#7	7.873454
Rf4	D_N#4	D_N	0.695947
Rf5	D_N#2	D_N#6	80.812347
Rf6	D_N#4	D_N#6	3.349972
Rf7	a_216_424##3	a_216_424##6	81.816498
Rf8	a_216_424##6	a_216_424##7	65.720062
Rf9	a_216_424##6	a_216_424##8	68.925606
Rf10	a_27_424##2	a_27_424##5	390.062927
Rf11	a_27_424##5	a_27_424##6	19.743486
Rf12	a_27_424##5	a_27_424##7	129.888947
Rf13	B	B#2	166.137894
Rf14	A#4	A#2	161.302414
Rf15	A	A#6	1.069610
Rf16	A#4	A#6	5.583287
Rf17	a_357_378##2	a_357_378##5	221.247253
Rf18	a_357_378##5	a_357_378##6	77.826645
Rf19	a_357_378##6	a_357_378##7	105.006638
Rf20	a_357_378##5	a_357_378##8	23.090988
Rf21	a_357_378##6	a_357_378##9	23.090988
Rf22	X#2	X	6.530186
Rf23	X	X#3	83.305748
Rf24	X#2	X	6.530186
Rf25	X#1	X#2	7.500000
Rf27	VGND#2	VGND#3	75.345924
Rf28	VGND#3	VGND#4	39.575714
Rf29	VGND#4	VGND#5	32.905540
Rf30	VGND#5	VGND#6	83.651100
Rf32	VGND#2	VGND#8	35.098007
Rf33	VGND#3	VGND#9	29.274549
Rf34	VGND#5	VGND#10	37.027283
Rf35	VGND#6	VGND#11	34.113823
Rf37	VPWR#2	VPWR#3	109.916458
Rf38	VPWR#3	VPWR#4	118.317268
Rf40	VPWR#2	VPWR#6	35.727165
Rf41	VPWR#4	VPWR#7	31.948624
Re1	VPWR#3	VPWR	0.982218
Re2	VGND	VGND#4	0.982254
*
*       CAPACITOR CARDS
*
*
C1	a_27_424#	a_357_378##9	1.2481e-17
C2	a_357_378##6	a_357_378##9	2.93667e-18
C3	VGND	VNB	7.19517e-17
C4	VPWR	VNB	8.42673e-17
C5	X	VNB	1.52003e-17
C6	B	VNB	3.29646e-18
C7	VGND	X	2.06005e-17
C8	C_N#3	VNB	9.83883e-17
C9	VGND#10	B#1	1.82853e-19
C10	D_N#2	VNB	6.99211e-17
C11	a_216_424##3	VNB	9.33589e-17
C12	a_27_424##2	VNB	4.41077e-17
C13	B#2	VNB	3.04862e-17
C14	A#2	VNB	3.36221e-17
C15	a_357_378##5	VGND#9	4.86773e-17
C16	a_357_378##2	VNB	4.88906e-17
C17	VGND#4	VNB	2.14098e-16
C18	VGND	B	4.74318e-18
C19	VPWR#3	VNB	2.46661e-16
C20	C_N#4	VNB	4.936e-17
C21	D_N#3	VNB	3.76875e-17
C22	a_216_424#	VNB	3.54952e-17
C23	a_27_424##3	VNB	3.3877e-17
C24	B#3	VNB	3.4686e-17
C25	A#3	VNB	3.87658e-17
C26	VPWR	B	1.61344e-17
C27	a_357_378##3	VNB	4.30407e-17
C28	C_N#1	VNB	3.70764e-17
C29	D_N#1	VNB	2.99124e-17
C30	a_216_424##4	VNB	2.63449e-17
C31	a_27_424#	VNB	2.56248e-17
C32	B#1	VNB	2.6341e-17
C33	a_27_424#	VGND#9	1.69837e-17
C34	A#1	VNB	3.12167e-17
C35	a_357_378#	VNB	3.19642e-17
C36	a_27_424##6	VNB	4.81995e-17
C37	VPWR#7	VNB	1.94516e-18
C38	a_216_424##8	VNB	8.26274e-18
C39	a_357_378##7	VNB	9.4068e-19
C40	VPWR#6	VNB	4.95024e-18
C41	X#3	VNB	8.04068e-17
C42	a_27_424##7	VNB	4.38499e-17
C43	VGND	C_N#3	5.29822e-18
C44	VGND#11	VNB	3.79535e-18
C45	a_216_424##7	VNB	1.10839e-17
C46	a_27_424##7	a_27_424##6	1.17301e-18
C47	VGND#10	VNB	4.71049e-19
C48	VGND	D_N#2	5.44471e-18
C49	VGND#9	VNB	1.03535e-18
C50	VGND	a_216_424##3	7.44819e-18
C51	VGND#8	VNB	3.16508e-18
C52	X#1	VNB	3.3873e-17
C53	VGND	a_27_424##2	4.57514e-18
C54	C_N#7	VNB	9.15854e-18
C55	D_N#6	VNB	2.11409e-18
C56	a_27_424##5	VNB	2.51384e-17
C57	VGND	a_357_378##2	3.8389e-18
C58	A#4	VNB	9.13309e-19
C59	VGND	VGND#4	8.0489e-18
C60	A#6	VNB	1.94674e-18
C61	a_357_378##5	VNB	1.56061e-17
C62	a_357_378##6	VNB	1.1368e-17
C63	VPWR	a_216_424##3	2.29485e-18
C64	a_357_378##6	VGND#9	5.24299e-17
C65	VPWR	a_27_424##2	2.37268e-17
C66	VGND#3	VNB	2.73667e-17
C67	VGND#5	VNB	2.61097e-17
C68	VGND#11	VGND#5	2.43026e-19
C69	VPWR	a_357_378##2	3.24845e-18
C70	VGND#9	B#1	3.40475e-17
C71	a_357_378##5	a_357_378##8	2.86805e-18
C72	VPWR	VPWR#3	2.81473e-17
C73	C_N#7	a_27_424##5	1.93436e-17
C74	VGND	C_N#1	1.09768e-18
C75	VPWR	C_N#4	6.59074e-19
C76	VGND	D_N#1	1.34537e-18
C77	VGND	a_216_424##4	7.92776e-19
C78	VPWR	D_N#3	1.53323e-18
C79	B	a_530_378#	6.65329e-18
C80	VGND	a_27_424#	4.94766e-19
C81	VPWR	a_216_424#	1.31435e-20
C82	VGND	B#1	4.33329e-19
C83	B	a_626_378#	2.42168e-18
C84	VGND	A#1	2.30683e-19
C85	VGND	a_357_378#	2.22688e-18
C86	VPWR	B#3	9.25273e-18
C87	VPWR	A#3	7.45359e-18
C88	VPWR	a_357_378##3	3.71255e-18
C89	VGND	a_216_424##8	8.16605e-19
C90	B#1	a_357_378##8	1.62508e-18
C91	VGND	a_357_378##7	7.77542e-19
C92	VGND	X#3	2.11019e-18
C93	VGND#9	A#1	1.49707e-18
C94	VGND	a_27_424##7	1.93021e-17
C95	VGND	a_216_424##7	2.24218e-17
C96	a_27_424##2	B	1.2294e-16
C97	VGND	VGND#9	1.98284e-17
C98	B	B#2	1.95625e-17
C99	VPWR	a_27_424##6	1.6341e-17
C100	VGND#5	a_216_424##7	1.37139e-17
C101	VPWR	VPWR#7	1.80898e-17
C102	a_357_378##5	VGND#8	5.40647e-17
C103	VGND#8	B#1	6.38537e-19
C104	VPWR	a_216_424##8	5.54035e-18
C105	B	A#2	2.92164e-18
C106	VPWR	a_357_378##7	1.01532e-17
C107	A#1	a_357_378##8	1.27851e-17
C108	VPWR	VPWR#6	2.1224e-17
C109	B	VPWR#3	4.82005e-18
C110	VPWR	X#3	2.33852e-17
C111	X	A#1	4.1038e-19
C112	X	a_357_378#	1.09798e-17
C113	VGND#9	a_357_378#	3.84712e-19
C114	VGND	A#4	3.24205e-18
C115	VGND	a_357_378##5	1.91046e-17
C116	VGND	a_357_378##6	2.15361e-17
C117	A#1	VGND#8	2.07275e-17
C118	a_27_424##5	D_N#6	2.88959e-17
C119	B	a_27_424##3	6.67084e-18
C120	VGND	VGND#3	2.22632e-17
C121	a_216_424##7	a_216_424##8	2.09463e-18
C122	VGND	VGND#5	3.07139e-17
C123	a_357_378##5	X#1	3.02894e-18
C124	B	B#3	3.7228e-17
C125	VPWR	C_N#7	3.52631e-18
C126	VPWR	D_N#6	3.45307e-18
C127	B	A#3	1.39945e-17
C128	a_27_424##2	a_446_378#	6.27888e-18
C129	B	a_357_378##3	5.22796e-18
C130	X#1	A#1	1.66038e-18
C131	VPWR	a_27_424##5	3.77476e-17
C132	a_27_424##2	a_530_378#	6.7512e-18
C133	a_357_378#	VGND#8	2.13421e-17
C134	VGND#8	X	1.82287e-17
C135	VPWR	A#6	4.84474e-18
C136	X	X#1	1.04952e-18
C137	C_N#3	D_N#2	3.04413e-17
C138	B#2	a_626_378#	2.2306e-19
C139	A#6	a_357_378##3	1.95569e-18
C140	a_216_424##3	C_N#3	4.50992e-19
C141	X#1	a_357_378#	2.40764e-17
C142	VGND#10	a_357_378##7	1.79597e-18
C143	D_N#2	a_216_424##3	7.59108e-17
C144	VPWR#6	X#3	9.26892e-17
C145	VGND#5	VGND#3	1.16231e-18
C146	a_216_424#	a_446_378#	1.68421e-17
C147	a_216_424##3	a_27_424##2	4.79224e-17
C148	a_27_424##3	a_446_378#	1.98563e-17
C149	B	VPWR#6	3.69143e-17
C150	B	X#3	4.02325e-18
C151	VGND#5	VGND#9	4.90868e-20
C152	a_27_424##2	B#2	3.81972e-17
C153	a_27_424##3	a_530_378#	2.26715e-17
C154	B#3	a_530_378#	2.27032e-17
C155	a_27_424##2	A#2	4.51362e-19
C156	VGND#4	a_216_424##3	9.47749e-20
C157	a_27_424##2	a_357_378##2	3.46191e-18
C158	B#2	A#2	3.35201e-17
C159	B#3	a_626_378#	2.44555e-17
C160	VPWR#3	a_216_424##3	5.78204e-20
C161	A#3	a_626_378#	5.81158e-20
C162	VGND#4	a_27_424##2	1.23731e-19
C163	a_357_378##2	B#2	2.5257e-19
C164	C_N#4	D_N#2	1.65111e-18
C165	a_27_424##2	VPWR#3	5.01766e-17
C166	A#2	a_357_378##2	3.38906e-17
C167	C_N#7	a_27_424##6	1.79713e-17
C168	D_N#2	a_216_424#	7.82581e-19
C169	a_216_424##3	a_216_424#	1.01548e-18
C170	a_27_424##2	D_N#3	2.29352e-19
C171	a_27_424##7	VGND#11	6.19303e-17
C172	B	A#4	1.87408e-17
C173	a_216_424##3	a_27_424##3	4.87788e-18
C174	a_27_424##2	a_216_424#	1.51916e-17
C175	B	A#6	2.2233e-17
C176	a_357_378##7	a_446_378#	7.35452e-18
C177	a_27_424##2	a_27_424##3	3.52216e-17
C178	a_357_378##5	B	1.65657e-17
C179	a_27_424##7	a_216_424##7	3.13755e-18
C180	a_27_424##2	B#3	1.07546e-17
C181	C_N#1	D_N#2	5.60265e-18
C182	a_27_424##3	B#2	3.24034e-18
C183	a_27_424##2	A#3	6.41367e-19
C184	a_357_378##6	D_N#1	7.4596e-19
C185	a_27_424##2	a_357_378##3	1.25601e-18
C186	a_216_424##3	C_N#1	9.73521e-20
C187	VGND#11	a_216_424##7	4.18963e-17
C188	D_N#1	a_216_424##3	4.23126e-19
C189	a_216_424##3	a_216_424##4	1.98404e-19
C190	a_27_424##6	C_N#3	4.02458e-18
C191	VGND#11	VGND#10	1.95477e-18
C192	a_216_424##3	a_27_424#	2.74773e-18
C193	a_357_378##6	a_216_424##4	1.76391e-17
C194	VPWR#3	a_216_424#	3.67855e-18
C195	A#2	a_357_378##3	2.80832e-18
C196	D_N#6	a_216_424##8	2.00181e-17
C197	VPWR#3	a_27_424##3	3.68967e-18
C198	C_N#4	D_N#3	3.33928e-17
C199	a_357_378##5	a_27_424#	4.69371e-19
C200	a_216_424##7	VGND#10	3.36546e-17
C201	VPWR#3	B#3	3.54743e-18
C202	a_27_424##2	B#1	2.86719e-18
C203	VGND#5	C_N#1	9.326e-20
C204	a_216_424##8	D_N#2	6.31646e-18
C205	a_357_378##6	a_27_424#	3.90777e-17
C206	a_27_424##6	a_27_424##5	2.44474e-18
C207	a_357_378##7	D_N#2	8.82133e-20
C208	D_N#3	a_216_424#	5.16332e-18
C209	a_27_424##2	a_357_378#	1.43129e-19
C210	a_357_378##5	B#1	2.5392e-17
C211	a_357_378##7	a_216_424##3	5.05934e-17
C212	X#1	X#3	3.54747e-18
C213	VGND#5	D_N#1	5.90456e-19
C214	a_27_424##7	C_N#3	6.08862e-17
C215	a_216_424#	a_27_424##3	5.01497e-17
C216	a_357_378##6	B#1	6.68279e-19
C217	a_27_424##5	VPWR#7	7.60512e-17
C218	a_357_378##7	a_27_424##2	1.18028e-16
C219	A#2	a_357_378#	1.54427e-18
C220	a_357_378##5	A#1	3.80579e-17
C221	VGND#4	a_27_424#	1.77691e-18
C222	a_27_424##7	D_N#2	3.34766e-17
C223	a_27_424##3	B#3	3.84152e-17
C224	VGND#10	VGND#9	2.32535e-18
C225	VGND#11	D_N#2	7.61146e-18
C226	a_357_378##2	a_357_378#	4.20345e-18
C227	VGND#5	a_216_424##4	4.61888e-18
C228	a_27_424##5	a_216_424##8	4.79475e-17
C229	a_357_378##6	A#1	2.39414e-19
C230	D_N#2	a_216_424##7	2.34266e-17
C231	a_27_424##7	a_216_424##3	2.46981e-18
C232	a_27_424##2	VPWR#6	3.71311e-18
C233	a_357_378##5	a_357_378#	8.31872e-19
C234	VGND#3	a_27_424#	1.70754e-18
C235	B#3	A#3	2.97753e-17
C236	a_27_424##5	a_357_378##7	4.78199e-17
C237	a_216_424##3	VGND#10	1.63068e-17
C238	VGND#5	a_27_424#	5.96287e-19
C239	C_N#7	C_N#3	1.25122e-17
C240	A#3	a_357_378##3	3.00154e-17
C241	VGND#3	B#1	9.55661e-19
C242	A#2	VPWR#6	3.03052e-18
C243	D_N#6	C_N#3	1.07198e-18
C244	X#3	A#2	1.50397e-19
C245	VGND#5	B#1	9.39263e-20
C246	C_N#7	D_N#2	5.9943e-19
C247	a_357_378##2	VPWR#6	7.85785e-18
C248	a_27_424##6	C_N#4	4.05044e-17
C249	a_357_378##5	A#4	3.94227e-17
C250	a_357_378##2	X#3	5.23684e-17
C251	D_N#6	D_N#2	1.80434e-17
C252	VGND#9	VGND#8	2.39424e-18
C253	C_N#4	VPWR#7	2.49511e-17
C254	C_N#3	a_27_424##5	1.60292e-17
C255	a_27_424##7	D_N#6	1.00475e-17
C256	a_27_424##6	D_N#3	1.80694e-18
C257	VGND#9	B#2	6.40264e-19
C258	a_216_424##8	C_N#4	1.9784e-18
C259	VPWR#7	D_N#3	3.21139e-17
C260	a_357_378##7	C_N#4	2.73563e-19
C261	D_N#6	a_216_424##3	4.06719e-17
C262	a_27_424##6	a_216_424#	9.59772e-20
C263	D_N#3	a_216_424##8	1.37479e-17
C264	a_27_424##5	D_N#2	6.823e-18
C265	VPWR#7	a_216_424#	2.0863e-19
C266	C_N#1	D_N#1	1.72096e-17
C267	a_357_378##7	D_N#3	3.37605e-18
C268	a_216_424##8	a_216_424#	5.99999e-19
C269	VGND#8	A#2	4.40204e-19
C270	X#1	A#2	9.842e-20
C271	a_357_378##7	a_216_424#	6.93352e-17
C272	a_27_424##5	a_216_424##3	6.66612e-18
C273	D_N#1	a_216_424##4	3.18895e-18
C274	VGND#8	X#1	2.03327e-17
C275	a_357_378##2	VGND#8	2.27921e-17
C276	a_357_378##7	a_27_424##3	6.22807e-18
C277	a_357_378##2	X#1	4.01373e-17
C278	a_27_424##5	a_27_424##2	1.57314e-18
C279	a_216_424##4	a_27_424#	2.27856e-17
C280	a_357_378##5	a_216_424##3	1.74161e-19
C281	a_27_424##7	a_27_424##5	2.99902e-19
C282	a_357_378##6	a_216_424##3	4.9139e-17
C283	VPWR#6	a_27_424##3	3.79914e-19
C284	a_27_424#	B#1	1.80118e-17
C285	A#6	VPWR#6	1.40015e-17
C286	A#4	B#2	2.18662e-18
C287	VGND#11	a_27_424##5	1.23186e-18
C288	a_357_378##5	a_27_424##2	2.36875e-19
C289	VPWR#6	B#3	5.14537e-18
C290	a_357_378##6	a_27_424##2	6.72996e-17
C291	a_357_378##6	a_357_378##5	5.29833e-18
C292	A#6	B#2	2.15432e-18
C293	X#3	B#3	1.58267e-19
C294	VGND#5	a_216_424##3	6.30938e-19
C295	B#1	A#1	2.64216e-17
C296	A#6	X#3	4.09184e-18
C297	A#4	A#2	9.46549e-18
C298	A#3	VPWR#6	3.93745e-17
C299	a_357_378##5	B#2	5.15839e-18
C300	a_357_378##5	VPWR#6	1.37108e-18
C301	X#3	A#3	2.99635e-18
C302	A#6	A#2	9.77455e-18
C303	a_357_378##3	VPWR#6	3.69518e-17
C304	A#4	a_357_378##2	2.56317e-17
C305	A#1	a_357_378#	1.86973e-17
C306	a_357_378##5	A#2	8.52446e-18
C307	X#3	a_357_378##3	5.30286e-17
C308	a_357_378##6	A#2	5.09284e-20
C309	A#6	a_357_378##2	6.27945e-18
C310	a_27_424##5	VPWR#3	3.96503e-17
C311	a_27_424##7	C_N#1	4.00791e-17
C312	a_27_424##6	VPWR#7	3.16407e-17
C313	C_N#1	VGND#11	2.25413e-17
C314	VGND#4	a_357_378##6	1.75461e-17
C315	a_27_424##7	D_N#1	3.08931e-18
C316	a_216_424##7	C_N#1	1.59005e-18
C317	a_27_424##5	C_N#4	1.64865e-17
C318	D_N#1	VGND#11	1.83349e-17
C319	a_27_424##7	a_216_424##4	3.57401e-19
C320	VGND#10	C_N#1	2.52643e-19
C321	VGND#3	a_357_378##5	9.51439e-18
C322	a_216_424##7	D_N#1	4.14569e-17
C323	VGND#11	a_216_424##4	5.41539e-19
C324	a_27_424##5	D_N#3	3.43704e-17
C325	a_216_424##7	a_357_378##6	1.21857e-17
C326	VGND#4	VGND#3	3.52149e-17
C327	VGND#10	D_N#1	1.18286e-18
C328	a_216_424##7	a_216_424##4	3.42662e-18
C329	VGND#4	VGND#5	3.2145e-17
C330	VGND#3	a_357_378##6	5.28166e-19
C331	a_216_424##8	a_357_378##7	2.71338e-17
C332	VGND#10	a_216_424##4	3.11741e-17
C333	a_27_424##5	a_216_424#	9.54808e-18
C334	a_216_424##7	a_27_424#	2.47965e-19
C335	VGND#10	a_357_378##6	3.64634e-17
C336	a_216_424##4	a_357_378##9	1.58697e-18
C337	VGND#10	a_27_424#	1.22927e-18
C338	VGND#5	a_357_378##6	1.22689e-18
C339	a_27_424##5	a_27_424##3	1.10098e-19
C340	VGND#9	a_216_424##4	1.15457e-18
C341	VGND#6	C_N#1	4.95642e-18
C342	VGND#2	VNB	5.16064e-17
C343	VPWR#2	B#2	5.35671e-20
C344	VGND#6	D_N#2	8.29154e-19
C345	VGND#9	VGND#2	4.96225e-20
C346	VGND	VGND#2	5.83275e-17
C347	VGND#2	B#1	5.02029e-19
C348	VGND#2	a_357_378##5	8.6585e-18
C349	VGND#2	A#2	5.47082e-20
C350	VPWR#4	D_N#3	9.49048e-19
C351	VPWR#2	A#3	1.71285e-17
C352	VGND#2	X	2.28468e-17
C353	VGND#6	VNB	5.45359e-17
C354	VPWR#3	VPWR#4	6.90199e-17
C355	VGND#2	a_357_378#	7.18198e-18
C356	VGND#4	VGND#2	5.70902e-17
C357	VPWR#4	a_216_424##3	2.0098e-20
C358	VPWR	VPWR#2	4.81131e-17
C359	a_27_424##5	VPWR#4	4.01534e-17
C360	VGND#6	a_216_424##4	2.23343e-19
C361	VPWR#2	VNB	6.19725e-17
C362	VPWR	VPWR#4	3.96013e-17
C363	VGND#3	VGND#2	1.18491e-18
C364	VPWR#4	VNB	6.07257e-17
C365	VGND	VGND#6	5.63918e-17
C366	a_357_378##2	VPWR#2	3.1691e-19
C367	a_27_424##6	VPWR#4	2.09786e-17
C368	VGND#6	a_27_424##7	2.10284e-17
C369	A#6	VPWR#2	7.90821e-19
C370	VPWR#4	C_N#4	2.51826e-18
C371	VGND#6	C_N#3	8.629e-19
C372	VPWR#2	B#3	1.56429e-18
C373	VPWR#4	D_N#2	3.38397e-20
C374	VGND#6	VGND#5	9.39053e-19
C375	VGND#6	a_216_424##7	1.28596e-17
C376	VGND#4	VGND#6	6.00565e-17
C377	VGND#6	D_N#1	6.63018e-18
C378	VGND#2	A#1	4.91585e-18
C379	VGND#2	a_357_378##2	4.41816e-19
C380	VPWR#3	VPWR#2	7.12869e-17
C381	X#3	VPWR#2	2.80402e-17
C382	B	VPWR#2	6.90065e-18
C383	VPWR#2	a_357_378##3	4.63558e-18
C384	VPWR#4	C_N#3	1.85284e-19
*
*
.ENDS sky130_fd_sc_hs__or4bb_1
*
