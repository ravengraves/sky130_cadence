* Extracted by Quantus, converted by sky130cad/quantus.py
*
*
*
*                       LINUX           Wed Nov 18 08:52:53 2026
*
*
*
*  PROGRAM  advgen
*
*  Name           : advgen - Quantus - (64-bit)
*  Version        : 25.1.0-p047
*  Build Date     : Thu Dec 11 23:20:30 PST 2025
*
*  HSPICE LIBRARY
*
*  OPERATING_TEMPERATURE 150
*  QRC_TECH_DIR <path>/tech
*
*
*

*
.SUBCKT sky130_fd_sc_hs__o2111a_2 VNB VPB VGND VPWR X A1 A2 B1 C1 D1
*
*
*  caps2d version: 10
*
*
*       TRANSISTOR CARDS
*
*
XM6 a_54_74##2 A1#1 VGND#7 VNB sky130_fd_pr__nfet_01v8_lvt l=0.15 w=0.74 ad=0.2627 as=0.3108 pd=2.19 ps=2.32
XM9 VGND#7 A2#1 a_54_74# VNB sky130_fd_pr__nfet_01v8_lvt l=0.15 w=0.74 ad=0.3108 as=0.259 pd=2.32 ps=2.18
XM7 a_54_74# B1#1 a_369_74# VNB sky130_fd_pr__nfet_01v8_lvt l=0.15 w=0.74 ad=0.259 as=0.2294 pd=2.18 ps=2.1
XM4 a_369_74# C1#3 a_461_74# VNB sky130_fd_pr__nfet_01v8_lvt l=0.15 w=0.74 ad=0.2294 as=0.3108 pd=2.1 ps=2.32
XM8 a_461_74# D1#3 a_236_368##7 VNB sky130_fd_pr__nfet_01v8_lvt l=0.15 w=0.74 ad=0.3108 as=0.2109 pd=2.32 ps=2.05
XM3 X#1 a_236_368##5 VGND#6 VNB sky130_fd_pr__nfet_01v8_lvt l=0.15 w=0.74 ad=0.2072 as=0.2627 pd=2.04 ps=2.19
XM13 VGND#1 a_236_368# X#1 VNB sky130_fd_pr__nfet_01v8_lvt l=0.15 w=0.74 ad=0.222 as=0.2072 pd=2.08 ps=2.04
XM0 VPWR#9 A1#4 a_152_368# VPB sky130_fd_pr__pfet_01v8 l=0.15 w=1 ad=0.295 as=0.27 pd=2.59 ps=2.54
XM2 a_152_368# A2#3 a_236_368##10 VPB sky130_fd_pr__pfet_01v8 l=0.15 w=1 ad=0.27 as=0.42 pd=2.54 ps=2.84
XM11 a_236_368##10 B1#3 VPWR#8 VPB sky130_fd_pr__pfet_01v8 l=0.15 w=1 ad=0.42 as=0.49 pd=2.84 ps=2.98
XM12 VPWR#8 C1#1 a_236_368##11 VPB sky130_fd_pr__pfet_01v8 l=0.15 w=1 ad=0.49 as=0.35 pd=2.98 ps=2.7
XM1 a_236_368##11 D1#4 VPWR#7 VPB sky130_fd_pr__pfet_01v8 l=0.15 w=1 ad=0.35 as=0.8618 pd=2.7 ps=3.9
XM5 VPWR#7 a_236_368##6 X#3 VPB sky130_fd_pr__pfet_01v8 l=0.15 w=1.12 ad=0.8618 as=0.336 pd=3.9 ps=2.84
XM10 X#3 a_236_368##4 VPWR#1 VPB sky130_fd_pr__pfet_01v8 l=0.15 w=1.12 ad=0.336 as=0.3864 pd=2.84 ps=2.93
*
*
*       RESISTOR AND CAP/DIODE CARDS
*
Rg1	A1#1	A1#2	322.953644
Rg2	A1#2	A1#3	110.713348
Rg3	A1#2	A1#4	472.643829
Rg4	A2#1	A2#2	307.937683
Rg5	A2#2	A2#3	457.627838
Rg6	B1#1	B1#2	307.937683
Rg7	B1#2	B1#3	457.627838
Rg8	C1#1	C1#2	401.956665
Rg9	C1#2	C1#3	515.488770
Rg10	D1#1	D1#2	36.519821
Rg11	D1#2	D1#3	397.555725
Rg12	D1#2	D1#4	415.223511
Rg13	a_236_368#	a_236_368##2	368.897400
Rg14	a_236_368##2	a_236_368##3	102.502281
Rg15	a_236_368##2	a_236_368##4	471.698395
Rg16	a_236_368##3	a_236_368##5	357.924225
Rg17	a_236_368##3	a_236_368##6	448.418579
Rf1	A1	A1#3	9.883524
Rf2	A1#3	A1	7.059660
Rf3	A2	A2#2	163.775864
Rf4	a_54_74#	a_54_74##2	100.894753
Rf5	B1	B1#4	1.235440
Rf6	B1#5	B1#2	161.468246
Rf7	B1#4	B1#5	3.349972
Rf8	C1#2	C1#5	161.893311
Rf9	C1#6	C1	1.660508
Rf10	C1#5	C1#6	9.779288
Rf11	D1#1	D1	166.137894
Rf12	a_236_368##7	a_236_368##8	73.935356
Rf13	a_236_368##8	a_236_368##9	108.726471
Rf14	a_236_368##9	a_236_368##10	90.066086
Rf15	a_236_368##9	a_236_368##11	15.059351
Rf16	X	X#2	7.282945
Rf17	X#2	X	7.282945
Rf18	X	X#3	90.636475
Rf19	X#1	X#2	7.500000
Rf20	VPWR#1	VPWR#2	125.385674
Rf21	VPWR#2	VPWR#3	64.457886
Rf22	VPWR#3	VPWR#4	32.848190
Rf23	VPWR#4	VPWR#5	108.796173
Rf25	VPWR#2	VPWR#7	15.321080
Rf26	VPWR#4	VPWR#8	35.077789
Rf27	VPWR#5	VPWR#9	40.648079
Rf28	VGND#1	VGND#2	108.864052
Rf29	VGND#2	VGND#3	85.809799
Rf30	VGND#3	VGND#4	103.301086
Rf32	VGND#2	VGND#6	36.475861
Rf33	VGND#4	VGND#7	27.917620
Rf39	a_236_368##3	a_236_368##8	160.232803
Re1	VPWR#3	VPWR	0.982218
Re2	VGND	VGND#3	0.982254
*
*       CAPACITOR CARDS
*
*
C1	VGND#2	a_236_368##2	7.8494e-20
C2	B1#5	C1#5	1.47786e-17
C3	VGND#2	D1#2	2.29082e-19
C4	VGND#3	a_236_368##2	6.36412e-21
C5	VGND#3	D1#2	1.92692e-20
C6	a_236_368##7	a_236_368##9	3.70644e-18
C7	a_236_368##3	a_236_368##2	3.87858e-18
C8	D1#2	a_236_368##3	2.51355e-17
C9	X#3	a_236_368##2	1.48615e-18
C10	X#3	D1#2	2.15685e-20
C11	VPWR#2	VPWR#1	2.57641e-18
C12	VPWR#2	X#3	8.58435e-17
C13	D1#2	VPWR#7	1.2609e-18
C14	VPWR#2	a_236_368##2	4.5102e-20
C15	VPWR#2	VPWR#7	1.79309e-17
C16	C1#2	D1#2	2.93276e-17
C17	VPWR#2	D1#2	1.81767e-18
C18	a_236_368##11	VPWR#2	5.7881e-17
C19	X#1	VGND#1	2.13869e-17
C20	VGND#6	VGND#1	9.66594e-19
C21	a_236_368##9	VPWR#7	3.67974e-18
C22	VPWR#8	VPWR#2	4.39869e-18
C23	a_236_368##10	VPWR#4	1.38012e-17
C24	B1#2	D1#2	4.178e-19
C25	VGND#6	X#1	2.04201e-17
C26	a_236_368##9	a_236_368##11	3.15388e-18
C27	a_236_368##7	X#1	1.23535e-18
C28	VGND#2	a_236_368#	3.24822e-18
C29	a_236_368##9	VPWR#8	2.42738e-17
C30	a_236_368##7	VGND#6	3.54776e-17
C31	VGND#2	a_236_368##5	8.82082e-18
C32	VGND#2	D1#3	1.82846e-18
C33	VGND#2	C1#3	4.42929e-19
C34	a_54_74#	a_236_368##7	1.1919e-17
C35	a_236_368##9	D1#2	4.21872e-18
C36	VGND#1	VPWR#1	1.44681e-17
C37	VGND#2	B1#1	1.7305e-19
C38	VGND#2	A2#1	1.69433e-19
C39	B1#5	a_236_368##10	2.32234e-17
C40	a_54_74#	VGND#7	5.44025e-17
C41	a_54_74##2	a_54_74#	2.08658e-18
C42	a_54_74##2	VGND#7	5.73317e-17
C43	VGND#1	a_236_368#	2.49793e-17
C44	VPWR#2	a_236_368##4	1.29967e-18
C45	X#3	VPWR#1	1.09454e-16
C46	X#1	a_236_368#	2.17642e-17
C47	VPWR#4	a_236_368##6	7.00404e-20
C48	VGND#1	a_236_368##5	1.38466e-18
C49	VPWR#2	a_236_368##6	2.40583e-17
C50	VGND#6	a_236_368#	3.69612e-19
C51	a_54_74#	a_236_368##10	6.42234e-18
C52	X#1	a_236_368##5	2.08045e-17
C53	VGND#1	D1#3	1.51482e-19
C54	VGND#6	a_236_368##5	1.07752e-17
C55	VPWR#2	D1#4	3.03022e-17
C56	X#1	D1#3	1.57816e-19
C57	a_236_368##11	X#3	1.7523e-18
C58	a_236_368##7	a_236_368##5	1.91228e-18
C59	VGND#6	D1#3	1.47106e-18
C60	VPWR#2	C1#1	2.04398e-18
C61	a_236_368##7	D1#3	6.51176e-17
C62	a_236_368##9	D1#4	1.87139e-17
C63	VGND#6	C1#3	1.81594e-19
C64	VPWR#4	B1#3	2.1707e-18
C65	a_236_368##7	C1#3	6.7106e-18
C66	VPWR#2	B1#3	4.49611e-19
C67	VGND#6	B1#1	9.05267e-20
C68	a_236_368##9	C1#1	1.95809e-17
C69	VPWR#8	a_236_368##11	3.72887e-17
C70	a_236_368##7	B1#1	2.24612e-18
C71	a_54_74#	D1#3	2.24695e-18
C72	a_236_368##10	a_236_368##11	2.85719e-18
C73	VGND#6	A2#1	9.50699e-20
C74	VGND#7	D1#3	4.28498e-19
C75	a_236_368##7	A2#1	5.42577e-19
C76	a_236_368##10	VPWR#8	7.34779e-17
C77	a_54_74#	C1#3	5.06139e-18
C78	VGND#7	C1#3	6.57405e-19
C79	a_236_368##7	A1#1	5.03347e-19
C80	a_54_74#	B1#1	4.78953e-17
C81	C1#5	C1#1	2.0171e-18
C82	VPWR#9	VPWR#8	2.38376e-18
C83	VGND#7	B1#1	2.07195e-18
C84	a_54_74#	A2#1	3.02318e-17
C85	C1#5	B1#3	2.13026e-18
C86	a_54_74##2	B1#1	1.72998e-19
C87	VPWR#9	a_236_368##10	3.04945e-17
C88	VGND#7	A2#1	3.67806e-17
C89	VPWR#3	VPWR#4	4.04849e-17
C90	VGND#3	VGND#2	5.25257e-17
C91	a_54_74#	A1#1	9.05571e-19
C92	VPWR#3	VPWR#2	6.00892e-17
C93	a_54_74##2	A2#1	8.24262e-19
C94	C1#5	A2#3	8.79163e-19
C95	VGND#7	A1#1	3.41695e-17
C96	D1	D1#2	1.7323e-17
C97	a_54_74##2	A1#1	3.0037e-17
C98	VGND#2	a_236_368##3	5.43184e-19
C99	C1#5	A1#4	5.41934e-19
C100	a_236_368##9	VPWR#3	3.36488e-19
C101	a_236_368##3	VPWR#2	3.93823e-17
C102	a_236_368##5	a_236_368#	3.92608e-17
C103	VPWR#1	a_236_368##4	3.32957e-17
C104	C1	D1#2	1.89297e-17
C105	X#3	a_236_368##4	5.80726e-17
C106	VPWR#1	a_236_368##6	1.3945e-18
C107	D1#3	a_236_368##5	4.35481e-18
C108	VGND#3	C1#5	1.81549e-18
C109	X#3	a_236_368##6	5.58411e-17
C110	a_236_368##6	VPWR#7	7.98185e-18
C111	X#3	D1#4	7.46656e-19
C112	C1#3	D1#3	3.1281e-17
C113	a_236_368##11	a_236_368##6	6.07835e-19
C114	D1#4	VPWR#7	3.10757e-17
C115	a_236_368##9	C1#2	2.54207e-18
C116	X#3	C1#1	1.48879e-19
C117	VPWR#8	a_236_368##6	1.61552e-19
C118	B1#5	a_236_368##3	9.1731e-20
C119	D1#4	a_236_368##11	2.07873e-17
C120	B1#1	C1#3	4.02986e-17
C121	VPWR#8	D1#4	1.14097e-18
C122	VGND#3	VGND#1	2.58532e-17
C123	A2#2	VPWR#4	4.96003e-19
C124	a_236_368##11	C1#1	4.49251e-17
C125	a_236_368##10	D1#4	2.42495e-19
C126	C1#1	VPWR#8	3.08013e-17
C127	C1#5	C1#2	1.87305e-17
C128	a_236_368##11	B1#3	1.97389e-18
C129	A2#1	B1#1	2.8272e-17
C130	VGND#3	a_236_368##7	7.82906e-18
C131	a_236_368##10	C1#1	1.20525e-18
C132	a_236_368##3	X#1	1.14148e-20
C133	B1#3	VPWR#8	3.5931e-17
C134	B1#5	C1#2	2.55152e-18
C135	a_236_368##3	VGND#6	2.85482e-17
C136	C1#5	B1#2	4.37603e-18
C137	a_236_368##10	B1#3	7.98698e-17
C138	a_236_368##7	a_236_368##3	1.97525e-18
C139	VPWR#8	A2#3	9.11802e-19
C140	VPWR#9	C1#1	2.40208e-19
C141	A1#1	A2#1	2.04476e-17
C142	B1#5	B1#2	1.01911e-17
C143	a_236_368##10	A2#3	2.27643e-17
C144	VPWR#3	VPWR#1	2.95983e-17
C145	VPWR#9	B1#3	2.79496e-18
C146	C1#5	A2#2	5.09308e-19
C147	VPWR#8	A1#4	6.32293e-19
C148	a_236_368##10	A1#4	8.29868e-18
C149	A2#2	B1#5	1.62833e-17
C150	VPWR#9	A2#3	1.23487e-17
C151	VPWR#4	VPWR#2	1.18987e-18
C152	C1#5	A1#3	5.38196e-19
C153	a_236_368##11	VPWR#3	1.07644e-17
C154	VPWR#9	A1#4	5.72489e-17
C155	a_236_368##3	X#3	4.84078e-17
C156	a_236_368##3	VPWR#7	6.50119e-18
C157	a_236_368##6	a_236_368##4	4.66005e-17
C158	B1#2	a_54_74#	3.18435e-17
C159	a_236_368##3	VPWR#8	4.83379e-20
C160	D1#2	a_236_368##6	1.65522e-19
C161	D1#4	a_236_368##6	5.66393e-18
C162	a_54_74#	A2#2	3.59004e-17
C163	a_236_368##2	X#1	3.05917e-19
C164	A2#2	VGND#7	1.52575e-18
C165	X	a_236_368##2	1.70406e-17
C166	C1#2	a_236_368##11	2.70455e-19
C167	X	D1#2	1.65962e-21
C168	C1#2	VPWR#8	2.37561e-19
C169	a_236_368##3	a_236_368#	9.92225e-20
C170	a_236_368##9	VPWR#4	2.46205e-19
C171	VGND#3	D1#3	7.87371e-18
C172	C1#1	D1#4	3.33936e-17
C173	a_236_368##3	a_236_368##5	4.161e-18
C174	VGND#3	C1#3	8.64062e-18
C175	A1#3	a_54_74##2	9.04723e-18
C176	VPWR#8	B1#2	6.92757e-19
C177	D1#3	a_236_368##3	1.53796e-19
C178	VGND#3	B1#1	4.34213e-18
C179	a_236_368##10	B1#2	1.97428e-18
C180	B1#3	C1#1	2.00461e-17
C181	a_236_368##9	VPWR#2	3.26153e-17
C182	A2#2	a_236_368##10	1.93572e-17
C183	A2#3	B1#3	2.77814e-17
C184	B1#2	C1#3	4.73087e-18
C185	D1	a_236_368##9	3.60851e-17
C186	a_236_368##3	a_236_368##4	8.14912e-20
C187	VPWR#9	A1#3	7.24253e-18
C188	A1#4	A2#3	6.22537e-17
C189	VPWR#3	C1#1	4.61055e-18
C190	a_236_368##3	a_236_368##6	6.20182e-18
C191	a_236_368##3	D1#4	7.44253e-19
C192	C1	a_236_368##9	3.21942e-17
C193	a_236_368##3	C1#1	1.80274e-19
C194	a_236_368##3	B1#3	1.10015e-19
C195	B1#3	C1#2	1.46357e-18
C196	a_236_368##7	D1	3.90163e-17
C197	a_236_368##7	D1#2	7.84931e-18
C198	VGND#3	a_236_368##3	2.37467e-22
C199	D1#3	a_461_74#	2.28418e-17
C200	C1#3	a_461_74#	2.28418e-17
C201	VPWR#3	C1#2	3.19099e-20
C202	VGND#3	C1#2	2.60638e-19
C203	C1#3	a_369_74#	2.02669e-17
C204	a_236_368##3	C1#2	6.27255e-20
C205	B1#1	a_369_74#	2.02669e-17
C206	VGND#3	B1#2	1.59035e-18
C207	B1#2	a_236_368##3	1.89474e-18
C208	VGND#2	X	1.67763e-17
C209	A2#3	a_152_368#	2.52858e-17
C210	A1#4	a_152_368#	2.61244e-17
C211	B1#2	C1#2	2.89553e-17
C212	A2#2	B1#2	4.63125e-17
C213	VPWR	VPWR#4	4.71772e-17
C214	VPWR	VPWR#2	8.5628e-17
C215	D1	a_236_368##6	4.76794e-19
C216	a_54_74##2	A1	6.52079e-17
C217	X	VGND#1	4.2276e-17
C218	VPWR	a_236_368##9	4.72555e-18
C219	A1#3	A2#2	3.57983e-17
C220	D1	D1#4	1.57238e-18
C221	VGND#6	X	2.16738e-17
C222	a_236_368##7	X	1.65962e-18
C223	a_236_368##2	VNB	4.12032e-17
C224	D1#2	VNB	4.74327e-17
C225	VPWR	C1#5	2.01982e-18
C226	C1#5	a_236_368##9	3.2164e-17
C227	VPWR	B1#5	2.56531e-18
C228	C1	D1#4	2.27565e-18
C229	VGND#2	VGND#1	1.66909e-18
C230	VGND	VGND#2	5.28292e-17
C231	A1	VPWR#9	3.45142e-17
C232	X	X#3	1.47008e-18
C233	B1#2	a_369_74#	3.45513e-19
C234	VGND	C1#5	5.74287e-18
C235	D1	a_236_368##3	3.31385e-17
C236	X	a_236_368#	1.65718e-17
C237	VPWR	VPWR#1	3.78794e-17
C238	VPWR	X#3	2.00951e-17
C239	X	a_236_368##5	1.62581e-17
C240	VGND#3	C1	1.32616e-18
C241	X	D1#3	4.56775e-19
C242	VGND	VGND#1	3.14625e-17
C243	VPWR	a_236_368##11	1.49029e-17
C244	VGND	a_236_368##7	1.73156e-17
C245	VPWR	a_236_368##10	1.6103e-17
C246	C1	C1#2	5.7047e-18
C247	VGND	a_54_74#	1.79109e-17
C248	VGND	VGND#7	2.67414e-17
C249	VGND	a_54_74##2	1.80491e-17
C250	VGND	VPWR#1	3.41489e-18
C251	VGND	X#3	2.22026e-18
C252	VGND	a_236_368##10	3.57075e-18
C253	VGND	VPWR#9	3.28185e-18
C254	VPWR	a_236_368##4	5.5161e-18
C255	VGND	a_236_368#	5.05873e-18
C256	VGND	a_236_368##5	2.85489e-18
C257	VPWR	a_236_368##6	3.01182e-18
C258	VGND	D1#3	4.18958e-18
C259	VPWR	D1#4	2.71378e-18
C260	VGND#2	VNB	4.4784e-17
C261	VGND	C1#3	1.2073e-18
C262	VPWR	C1#1	7.59167e-18
C263	VGND	B1#1	1.45228e-18
C264	VPWR#4	VNB	3.41843e-17
C265	VPWR	B1#3	7.37508e-18
C266	VPWR#2	VNB	5.28224e-17
C267	VGND	A2#1	6.10908e-19
C268	VGND	A1#1	1.51997e-18
C269	VPWR	A2#3	9.15527e-18
C270	X	a_236_368##3	6.10186e-17
C271	VPWR	A1#4	4.00595e-18
C272	A1	A2#2	3.80661e-17
C273	C1#5	VNB	4.24628e-18
C274	A1	A1#3	3.44296e-17
C275	VPWR	VPWR#3	1.07145e-17
C276	B1#5	VNB	1.26816e-18
C277	VGND#1	VNB	7.05587e-17
C278	VPWR	a_236_368##3	5.48815e-18
C279	VGND#6	VNB	6.88197e-18
C280	a_236_368##7	VNB	1.3529e-17
C281	C1	D1	3.73472e-17
C282	a_54_74#	VNB	2.64108e-18
C283	VGND#7	VNB	3.27571e-18
C284	a_54_74##2	VNB	3.66174e-17
C285	VPWR#1	VNB	8.45144e-17
C286	X#3	VNB	5.77167e-18
C287	VGND	VGND#3	3.28786e-17
C288	VPWR	A2#2	5.18764e-18
C289	a_236_368##11	VNB	3.3466e-18
C290	VGND	a_236_368##3	5.14189e-18
C291	VPWR#8	VNB	8.32852e-18
C292	VPWR	A1#3	2.53108e-18
C293	a_236_368##10	VNB	7.94646e-18
C294	VPWR#9	VNB	5.2527e-17
C295	VGND	C1#2	1.75107e-18
C296	a_236_368#	VNB	3.1218e-17
C297	VGND#2	a_236_368##7	1.35574e-17
C298	a_236_368##5	VNB	3.2984e-17
C299	VGND	B1#2	6.26721e-18
C300	D1#3	VNB	3.41896e-17
C301	C1#3	VNB	2.39014e-17
C302	VGND	A2#2	3.29826e-18
C303	B1#1	VNB	2.65123e-17
C304	A2#1	VNB	2.30452e-17
C305	VGND	A1#3	1.09738e-18
C306	A1#1	VNB	3.18177e-17
C307	a_236_368##4	VNB	3.94908e-17
C308	a_236_368##6	VNB	3.49403e-17
C309	D1#4	VNB	3.18061e-17
C310	C1#1	VNB	3.41212e-17
C311	B1#3	VNB	4.12907e-17
C312	A2#3	VNB	3.08936e-17
C313	VPWR	D1	2.74362e-18
C314	A1#4	VNB	3.68008e-17
C315	VPWR#3	VNB	2.1494e-16
C316	VPWR	C1	1.81662e-18
C317	VGND#3	VNB	2.40157e-16
C318	a_236_368##3	VNB	3.45111e-17
C319	VGND	D1	2.76529e-18
C320	C1#2	VNB	3.51859e-17
C321	B1#2	VNB	3.07267e-17
C322	VGND	C1	5.7082e-18
C323	A2#2	VNB	2.87802e-17
C324	A1#3	VNB	7.79263e-17
C325	VPWR	A1	7.60244e-18
C326	VGND	A1	8.50368e-18
C327	VGND	X	1.55186e-17
C328	D1	VNB	9.76172e-18
C329	C1	VNB	6.193e-18
C330	A1	VNB	3.50401e-17
C331	X	VNB	1.36975e-17
C332	VPWR	VNB	7.18552e-17
C333	VGND	VNB	8.14888e-17
C334	VGND#4	a_54_74#	2.04777e-17
C335	VPWR#5	VNB	5.13981e-17
C336	VGND#4	B1#2	3.44037e-19
C337	VGND#4	B1#1	3.13993e-18
C338	VPWR#5	VPWR#4	5.99231e-19
C339	VGND#4	VNB	6.58113e-17
C340	VPWR#5	A2#3	7.22503e-18
C341	A2#2	VPWR#5	6.95159e-19
C342	VGND#4	A1	1.89374e-18
C343	VGND#4	A2#1	9.5181e-19
C344	VGND	VGND#4	4.42141e-17
C345	VGND#3	VGND#4	7.56349e-17
C346	VPWR	VPWR#5	5.78005e-17
C347	VGND#4	a_54_74##2	2.17493e-17
C348	VGND#4	A1#3	1.03792e-18
C349	VPWR#3	VPWR#5	5.19673e-17
C350	VPWR#5	VPWR#8	1.69681e-19
C351	A1	VPWR#5	1.14464e-18
C352	VPWR#5	A1#4	3.41985e-18
C353	VPWR#5	A1#3	9.10466e-19
C354	VGND#4	A1#1	9.56465e-19
*
*
.ENDS sky130_fd_sc_hs__o2111a_2
*
