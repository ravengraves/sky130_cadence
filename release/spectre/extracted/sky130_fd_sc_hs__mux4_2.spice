* Extracted by Quantus, converted by sky130cad/quantus.py
*
*
*
*                       LINUX           Wed Nov 18 08:44:15 2026
*
*
*
*  PROGRAM  advgen
*
*  Name           : advgen - Quantus - (64-bit)
*  Version        : 25.1.0-p047
*  Build Date     : Thu Dec 11 23:20:30 PST 2025
*
*  HSPICE LIBRARY
*
*  OPERATING_TEMPERATURE 150
*  QRC_TECH_DIR <path>/tech
*
*
*

*
.SUBCKT sky130_fd_sc_hs__mux4_2 VPB VNB VGND VPWR X S0 A2 A1 A0 A3 S1
*
*
*  caps2d version: 10
*
*
*       TRANSISTOR CARDS
*
*
XM23 a_31_94##7 S0#3 VGND#12 VNB sky130_fd_pr__nfet_01v8_lvt l=0.15 w=0.64 ad=0.1824 as=0.3709 pd=1.85 ps=2.55
XM6 VGND#12 A1#3 a_255_74# VNB sky130_fd_pr__nfet_01v8_lvt l=0.15 w=0.74 ad=0.3709 as=0.1776 pd=2.55 ps=1.96
XM1 a_255_74# S0#5 a_333_74##4 VNB sky130_fd_pr__nfet_01v8_lvt l=0.15 w=0.74 ad=0.1776 as=0.5328 pd=1.96 ps=2.92
XM18 a_333_74##4 a_31_94# a_507_74# VNB sky130_fd_pr__nfet_01v8_lvt l=0.15 w=0.74 ad=0.5328 as=0.5772 pd=2.92 ps=3.04
XM19 a_507_74# A0#3 VGND#11 VNB sky130_fd_pr__nfet_01v8_lvt l=0.15 w=0.74 ad=0.5772 as=0.3996 pd=3.04 ps=2.56
XM8 VGND#11 A3#3 a_831_74# VNB sky130_fd_pr__nfet_01v8_lvt l=0.15 w=0.74 ad=0.3996 as=0.1776 pd=2.56 ps=1.96
XM15 a_831_74# S0#9 a_909_74##3 VNB sky130_fd_pr__nfet_01v8_lvt l=0.15 w=0.74 ad=0.1776 as=0.3996 pd=1.96 ps=2.56
XM12 a_909_74##3 a_31_94##4 a_1047_74# VNB sky130_fd_pr__nfet_01v8_lvt l=0.15 w=0.74 ad=0.3996 as=0.5772 pd=2.56 ps=3.04
XM13 a_1047_74# A2#3 VGND#10 VNB sky130_fd_pr__nfet_01v8_lvt l=0.15 w=0.74 ad=0.5772 as=0.2072 pd=3.04 ps=2.04
XM24 a_909_74# S1#3 a_1429_74##10 VNB sky130_fd_pr__nfet_01v8_lvt l=0.15 w=0.74 ad=0.2072 as=0.30295 pd=2.04 ps=2.65
XM9 a_1429_74##10 a_1500_94##3 a_333_74# VNB sky130_fd_pr__nfet_01v8_lvt l=0.15 w=0.74 ad=0.30295 as=0.2109 pd=2.65 ps=2.05
XM17 a_1500_94##8 S1#2 VGND#9 VNB sky130_fd_pr__nfet_01v8_lvt l=0.15 w=0.64 ad=0.276725 as=0.5021 pd=2.15 ps=2.96
XM3 VGND#9 a_1429_74##6 X#1 VNB sky130_fd_pr__nfet_01v8_lvt l=0.15 w=0.74 ad=0.5021 as=0.2072 pd=2.96 ps=2.04
XM25 X#1 a_1429_74##5 VGND#1 VNB sky130_fd_pr__nfet_01v8_lvt l=0.15 w=0.74 ad=0.2072 as=0.2109 pd=2.04 ps=2.05
XM10 a_31_94##9 S0#1 VPWR#12 VPB sky130_fd_pr__pfet_01v8 l=0.15 w=1 ad=0.295 as=0.45 pd=2.59 ps=2.9
XM26 VPWR#12 A1#1 a_264_392# VPB sky130_fd_pr__pfet_01v8 l=0.15 w=1 ad=0.45 as=0.9 pd=2.9 ps=3.8
XM27 a_264_392# a_31_94##3 a_333_74##6 VPB sky130_fd_pr__pfet_01v8 l=0.15 w=1 ad=0.9 as=0.57 pd=3.8 ps=3.14
XM4 a_333_74##6 S0#6 a_618_392# VPB sky130_fd_pr__pfet_01v8 l=0.15 w=1 ad=0.57 as=0.27 pd=3.14 ps=2.54
XM21 a_618_392# A0#1 VPWR#11 VPB sky130_fd_pr__pfet_01v8 l=0.15 w=1 ad=0.27 as=0.54 pd=2.54 ps=3.08
XM16 VPWR#11 A3#1 a_840_392# VPB sky130_fd_pr__pfet_01v8 l=0.15 w=1 ad=0.54 as=0.72 pd=3.08 ps=3.44
XM20 a_840_392# a_31_94##6 a_909_74##6 VPB sky130_fd_pr__pfet_01v8 l=0.15 w=1 ad=0.72 as=0.54 pd=3.44 ps=3.08
XM0 a_909_74##6 S0#10 a_1152_392# VPB sky130_fd_pr__pfet_01v8 l=0.15 w=1 ad=0.54 as=0.27 pd=3.08 ps=2.54
XM5 a_1152_392# A2#1 VPWR#10 VPB sky130_fd_pr__pfet_01v8 l=0.15 w=1 ad=0.27 as=0.295 pd=2.54 ps=2.59
XM22 a_333_74##5 S1#5 a_1429_74##11 VPB sky130_fd_pr__pfet_01v8 l=0.15 w=1 ad=0.32 as=0.3 pd=2.64 ps=2.6
XM11 a_1429_74##11 a_1500_94##4 a_909_74##5 VPB sky130_fd_pr__pfet_01v8 l=0.15 w=1 ad=0.3 as=0.29 pd=2.6 ps=2.58
XM14 a_1500_94##5 S1#1 VPWR#9 VPB sky130_fd_pr__pfet_01v8 l=0.15 w=1 ad=0.425 as=0.7698 pd=2.85 ps=3.71
XM7 X#3 a_1429_74##7 VPWR#9 VPB sky130_fd_pr__pfet_01v8 l=0.15 w=1.12 ad=0.336 as=0.7698 pd=2.84 ps=3.71
XM2 VPWR#1 a_1429_74# X#3 VPB sky130_fd_pr__pfet_01v8 l=0.15 w=1.12 ad=0.3248 as=0.336 pd=2.82 ps=2.84
*
*
*       RESISTOR AND CAP/DIODE CARDS
*
Rg1	S0#1	S0#2	509.830780
Rg2	S0#2	S0#3	279.244598
Rg3	A1#1	A1#2	410.912048
Rg4	A1#2	A1#3	450.462952
Rg5	S0#4	S0#5	330.892151
Rg6	a_31_94#	a_31_94##2	466.665070
Rg7	a_31_94##2	a_31_94##3	403.578156
Rg8	S0#6	S0#7	409.090576
Rg9	A0#1	A0#2	409.090576
Rg10	A0#2	A0#3	360.758118
Rg11	A3#1	A3#2	416.555420
Rg12	A3#2	A3#3	439.925934
Rg13	S0#8	S0#9	307.937683
Rg14	a_31_94##4	a_31_94##5	445.664551
Rg15	a_31_94##5	a_31_94##6	411.313293
Rg16	S0#10	S0#11	422.415131
Rg17	A2#1	A2#2	509.830780
Rg18	A2#2	A2#3	307.937683
Rg19	a_1500_94#	a_1500_94##2	74.909935
Rg20	a_1500_94##2	a_1500_94##3	322.953644
Rg21	a_1500_94##2	a_1500_94##4	424.106537
Rg22	S1#1	S1#2	800.838623
Rg23	S1#2	S1#3	1583.899414
Rg24	S1#3	S1#4	452.344543
Rg25	S1#4	S1#5	425.447571
Rg26	a_1429_74#	a_1429_74##2	509.716370
Rg27	a_1429_74##2	a_1429_74##3	72.254349
Rg28	a_1429_74##3	a_1429_74##4	69.811211
Rg29	a_1429_74##2	a_1429_74##5	371.221527
Rg30	a_1429_74##3	a_1429_74##6	341.892395
Rg31	a_1429_74##3	a_1429_74##7	430.841003
Rf1	a_31_94##7	a_31_94##8	97.411545
Rf2	a_31_94##8	a_31_94##9	20.302376
Rf3	A1#2	A1#5	161.189423
Rf4	A1#6	A1	0.956614
Rf5	A1#5	A1#6	2.362036
Rf6	a_31_94##10	a_31_94##2	189.328384
Rf7	A0#2	A0#5	161.115265
Rf8	A0#6	A0	0.882458
Rf9	A0#5	A0#6	4.724072
Rf10	A3#2	A3#5	161.189423
Rf11	A3#6	A3	0.956614
Rf12	A3#5	A3#6	2.362036
Rf13	a_31_94##12	a_31_94##5	175.921265
Rf14	S0#11	S0#13	249.531219
Rf15	S0#13	S0#14	109.439827
Rf16	S0#14	S0#15	174.530197
Rf17	S0#15	S0	61.923592
Rf18	S0	S0#2	163.409653
Rf19	S0#13	S0#8	164.387070
Rf20	S0#14	S0#7	180.218185
Rf21	S0#15	S0#4	171.420700
Rf22	A2	A2#4	1.992609
Rf23	A2#5	A2#2	162.225418
Rf24	A2#4	A2#5	2.750425
Rf25	A2	A2#7	1.992609
Rf26	A2#5	A2#7	8.556877
Rf27	S1	S1#4	174.995529
Rf28	a_333_74#	a_333_74##2	151.799957
Rf29	a_333_74##2	a_333_74##3	249.621475
Rf30	a_333_74##3	a_333_74##4	104.648941
Rf31	a_333_74##2	a_333_74##5	28.107952
Rf32	a_333_74##3	a_333_74##6	11.503683
Rf33	a_1500_94##5	a_1500_94##6	42.181599
Rf34	a_1500_94##6	a_1500_94#	85.066650
Rf35	a_1500_94##6	a_1500_94##8	39.896759
Rf36	a_909_74#	a_909_74##2	11.874412
Rf37	a_909_74##2	a_909_74##3	145.587479
Rf38	a_909_74##2	a_909_74##4	345.014587
Rf39	a_909_74##4	a_909_74##5	14.795025
Rf40	a_909_74##4	a_909_74##6	189.642334
Rf41	a_1429_74##4	a_1429_74##9	163.795547
Rf42	a_1429_74##9	a_1429_74##10	224.962936
Rf43	a_1429_74##9	a_1429_74##11	241.427719
Rf44	X	X#2	2.165200
Rf45	X	X#4	13.585999
Rf46	X#4	X	0.186110
Rf47	X#2	X	12.400689
Rf48	X#1	X#2	7.500000
Rf49	X#3	X#4	5.000000
Rf50	VPWR#1	VPWR#2	115.707314
Rf51	VPWR#2	VPWR#3	54.520660
Rf52	VPWR#3	VPWR#4	168.722107
Rf53	VPWR#4	VPWR#5	186.229691
Rf54	VPWR#5	VPWR#6	30.656675
Rf55	VPWR#6	VPWR#7	178.218674
Rf57	VPWR#2	VPWR#9	67.444832
Rf58	VPWR#4	VPWR#10	32.342297
Rf59	VPWR#5	VPWR#11	31.534731
Rf60	VPWR#7	VPWR#12	35.727165
Rf61	VGND#1	VGND#2	112.215530
Rf62	VGND#2	VGND#3	54.520660
Rf63	VGND#3	VGND#4	170.548370
Rf64	VGND#4	VGND#5	191.302826
Rf65	VGND#5	VGND#6	23.676462
Rf66	VGND#6	VGND#7	173.470383
Rf68	VGND#2	VGND#9	64.100792
Rf69	VGND#4	VGND#10	31.948624
Rf70	VGND#5	VGND#11	24.005709
Rf71	VGND#7	VGND#12	31.141060
Re1	a_31_94##12	a_31_94##10	14.521620
Re2	a_31_94##10	a_31_94##8	12.874965
Re3	VPWR#3	VPWR	2.512894
Re4	VPWR	VPWR#6	1.435940
Re5	VGND#3	VGND	2.512894
Re6	VGND	VGND#6	1.435940
*
*       CAPACITOR CARDS
*
*
C1	VPWR#5	a_31_94##6	5.83663e-18
C2	S0#13	A3#2	5.23642e-18
C3	S0#15	A1#3	1.85171e-17
C4	a_1429_74##11	VPWR#9	1.2937e-18
C5	a_909_74##4	S1#5	3.22018e-17
C6	S1#2	VGND#9	2.24043e-17
C7	a_333_74#	S1#4	3.34353e-17
C8	a_333_74##2	S1#1	3.1077e-19
C9	S0#14	a_333_74##4	9.89624e-17
C10	VPWR#4	a_31_94##6	1.77206e-18
C11	a_31_94##8	VGND#12	5.62774e-18
C12	VPWR#12	a_31_94##3	4.07345e-18
C13	a_1429_74##10	S1#4	1.33786e-19
C14	VGND#6	a_333_74##4	1.16971e-17
C15	a_333_74##3	VPWR#5	9.84508e-18
C16	A3#5	a_333_74##3	2.12075e-17
C17	S1#2	a_1500_94##8	3.05684e-17
C18	a_1429_74##11	a_1500_94##5	4.00277e-18
C19	S0#14	A0#2	1.2701e-17
C20	a_31_94##7	a_31_94##8	4.02509e-18
C21	S0#13	A0#2	1.50541e-19
C22	S0#15	S0#3	4.38693e-19
C23	S1#4	a_1500_94##2	2.4349e-17
C24	a_1429_74##10	a_1429_74##6	1.21415e-19
C25	A1#1	VPWR#12	3.83423e-17
C26	VPWR#5	A3#1	4.4856e-18
C27	a_909_74##4	A2#1	6.61446e-19
C28	VGND#6	VGND#12	2.22165e-17
C29	A3#5	A3#2	6.28038e-18
C30	a_333_74#	S1#2	3.881e-19
C31	a_333_74##2	a_1500_94##4	6.25039e-19
C32	VGND#4	a_1429_74##10	2.83108e-17
C33	a_1429_74##11	a_909_74##5	9.00693e-19
C34	a_333_74##2	a_1429_74##11	1.00616e-20
C35	VGND#9	VGND#1	2.3428e-18
C36	a_31_94##9	A1#1	1.96072e-18
C37	VGND#12	S0#15	3.04061e-17
C38	VGND#6	a_31_94##7	1.52971e-17
C39	a_1500_94##8	a_1500_94##3	2.81072e-18
C40	S0#1	VPWR#12	4.21438e-17
C41	a_333_74##2	VPWR#5	8.06423e-19
C42	a_1429_74##10	S1#2	2.06506e-17
C43	A2#2	VGND#10	1.76932e-18
C44	S0#7	S0#13	6.88131e-19
C45	VGND#2	a_1429_74##3	3.97985e-20
C46	a_31_94##12	a_909_74##6	2.85039e-18
C47	a_31_94##9	S0#1	3.65291e-17
C48	a_333_74#	a_1500_94##3	2.58323e-17
C49	A3#5	A0#2	3.06495e-18
C50	a_909_74##4	S0#10	4.17613e-19
C51	a_333_74##2	S1#5	1.9904e-18
C52	a_1500_94##8	S1#3	8.29214e-19
C53	a_1429_74##7	a_1429_74#	4.61619e-17
C54	S0#15	a_31_94##2	2.24741e-17
C55	a_31_94##7	S0#15	2.43304e-18
C56	a_333_74##2	a_333_74##5	3.16491e-18
C57	a_909_74##4	a_1429_74##9	1.2342e-16
C58	S0#14	a_31_94##2	1.41759e-18
C59	a_1500_94##3	a_1429_74##10	2.58231e-17
C60	VPWR#6	VPWR#10	1.61111e-17
C61	a_31_94##12	VPWR#11	1.04267e-17
C62	S0#13	a_31_94##2	1.36714e-19
C63	a_333_74#	S1#3	1.16136e-17
C64	A0#5	A0#2	1.14154e-17
C65	VGND#2	a_1429_74##2	3.2521e-20
C66	VPWR#9	a_1429_74##4	7.68561e-18
C67	a_1500_94##8	A2#3	4.93013e-19
C68	a_909_74##3	S0#11	5.67542e-17
C69	S1#1	a_1429_74##7	1.03697e-17
C70	VPWR#6	a_909_74##6	3.0371e-17
C71	S0#15	S0#4	1.79402e-17
C72	a_333_74##2	A2#1	2.14033e-17
C73	VPWR#10	a_1429_74##11	1.04201e-17
C74	a_1429_74##10	S1#3	4.41512e-17
C75	a_333_74##2	VPWR#10	3.99486e-18
C76	a_1429_74##9	a_909_74##2	6.55834e-17
C77	a_1500_94##4	a_1429_74##7	2.41035e-20
C78	S0#7	A0#5	2.85788e-17
C79	A0#5	a_333_74##3	2.47529e-17
C80	a_333_74##3	S0#10	1.27483e-19
C81	a_909_74##3	a_31_94##5	6.60631e-19
C82	VPWR#6	VPWR#11	1.67028e-17
C83	S1#3	a_909_74#	1.21377e-17
C84	a_31_94##10	a_333_74##6	1.71228e-18
C85	a_1500_94#	a_1500_94##5	7.52118e-19
C86	VGND#3	a_1429_74##5	7.14691e-18
C87	a_1500_94##4	S1#1	4.79075e-18
C88	a_1429_74##10	A2#3	6.38572e-19
C89	S0#15	A1#2	2.98813e-18
C90	a_333_74##2	S0#10	2.03176e-17
C91	a_1500_94#	a_909_74##5	3.63572e-18
C92	VGND#2	a_1429_74##5	2.78538e-18
C93	a_1429_74##3	X#3	1.37538e-19
C94	VGND#3	a_1429_74##6	7.14691e-18
C95	VGND#10	S1#3	2.41895e-18
C96	VPWR#12	a_31_94##10	2.53376e-18
C97	a_1429_74##11	a_1500_94#	1.16357e-18
C98	S0#8	a_909_74##3	3.76198e-18
C99	S0#15	S0#14	1.34128e-18
C100	VGND#3	S1#2	2.77549e-17
C101	a_333_74##3	a_31_94##6	2.2295e-17
C102	S1#5	a_1500_94##4	4.28182e-17
C103	a_1429_74##2	X#3	1.90353e-19
C104	S0#2	S0#15	3.03707e-18
C105	a_333_74##2	a_1152_392#	3.33356e-18
C106	VPWR#6	VPWR#12	1.66628e-17
C107	VGND#10	A2#3	4.38646e-17
C108	a_333_74##2	a_31_94##6	1.60014e-17
C109	a_333_74##2	a_909_74##6	1.45824e-16
C110	VGND#3	S1#3	2.38952e-17
C111	a_333_74#	a_1500_94##8	1.54953e-17
C112	VPWR#6	a_31_94##9	1.66525e-17
C113	VGND#2	a_1429_74##6	4.37153e-18
C114	a_909_74##3	S1#3	1.79614e-19
C115	S1#4	a_333_74##5	2.79347e-17
C116	a_31_94##8	VPWR#12	5.90571e-17
C117	VGND#4	a_909_74##3	1.59564e-17
C118	A2#1	S1#5	3.42705e-18
C119	VGND#11	A3#2	1.13529e-18
C120	a_333_74##3	A3#1	4.3217e-17
C121	a_909_74##6	VPWR#10	5.72579e-17
C122	a_1429_74##9	VGND#9	1.02169e-16
C123	a_333_74##3	a_840_392#	9.44582e-18
C124	VGND#10	a_31_94##4	2.80098e-18
C125	a_31_94##8	a_31_94##9	1.225e-18
C126	a_333_74##2	A3#1	2.47476e-19
C127	a_909_74##3	A2#3	2.65994e-18
C128	VPWR#10	A2#2	3.90088e-19
C129	S0#14	S0#13	5.75527e-19
C130	VGND#2	S1#2	2.13374e-18
C131	A0#2	VGND#11	4.15428e-18
C132	S0#10	A2#1	5.15131e-17
C133	VGND#10	S0#9	3.45659e-19
C134	a_333_74##3	VPWR#11	1.13177e-16
C135	a_333_74##3	A0#1	4.78423e-17
C136	a_333_74##3	a_618_392#	5.50256e-19
C137	a_909_74##6	A2#2	4.52669e-19
C138	a_333_74#	a_1429_74##10	2.11394e-18
C139	a_909_74##3	a_31_94##4	6.23788e-17
C140	A1#5	A1#2	8.33576e-18
C141	a_333_74##4	A0#2	2.46678e-19
C142	VGND#11	A2#3	3.54542e-19
C143	a_31_94##6	S0#10	1.59308e-17
C144	VGND#10	A3#3	2.37676e-19
C145	S0#11	a_909_74##6	1.25271e-18
C146	a_1429_74##3	X#1	4.38544e-19
C147	a_909_74##3	S0#9	4.70667e-17
C148	a_333_74#	a_909_74#	4.48748e-19
C149	a_333_74##3	S0#6	3.78989e-17
C150	S0#2	A1#5	3.23914e-17
C151	VGND#11	a_31_94##4	5.26951e-19
C152	S1#2	a_1429_74##4	1.72744e-17
C153	a_31_94##5	a_909_74##6	9.17556e-19
C154	VGND#4	S1#3	1.33553e-17
C155	A3#1	a_31_94##6	1.32621e-17
C156	a_909_74##2	VGND#9	5.70814e-18
C157	VPWR#11	a_909_74##6	7.06377e-18
C158	VGND#6	A2#3	6.18899e-19
C159	a_333_74##4	a_31_94##2	2.23922e-17
C160	VGND#3	VGND#4	4.81599e-17
C161	a_909_74##3	A3#3	6.59422e-18
C162	a_1429_74##2	X#1	3.58353e-19
C163	a_1500_94##8	a_909_74##4	7.23328e-18
C164	S1#2	a_1500_94#	1.61496e-17
C165	VPWR#3	a_1429_74#	5.31556e-18
C166	VGND#6	a_31_94##4	2.21175e-19
C167	VGND#11	S0#9	3.73335e-18
C168	a_333_74##3	a_333_74##6	1.32501e-17
C169	VGND#3	VGND#2	7.22878e-17
C170	a_333_74##3	a_31_94##3	2.41876e-17
C171	a_1500_94#	a_1500_94##3	7.1576e-19
C172	VGND#6	S0#9	9.54709e-18
C173	VPWR#3	a_1429_74##7	4.37122e-18
C174	A0#1	A3#1	1.65572e-17
C175	a_1429_74##10	a_1429_74##9	9.52684e-19
C176	VPWR#3	VPWR#4	5.06988e-17
C177	S1#3	a_1500_94#	1.50764e-18
C178	a_333_74##4	S0#4	1.23153e-18
C179	a_909_74##3	A0#3	3.00792e-18
C180	VGND#9	a_1429_74##3	1.45238e-19
C181	VGND#6	A3#3	1.16315e-17
C182	VGND#10	a_1429_74##10	3.23424e-18
C183	a_909_74##2	a_1500_94##8	6.68736e-17
C184	VPWR#3	S1#1	4.20543e-18
C185	VGND#4	A2#3	3.65084e-18
C186	S1#4	a_1500_94##3	4.93281e-18
C187	VPWR#3	VPWR#2	6.74253e-17
C188	A3#3	VGND#11	2.30643e-17
C189	a_333_74#	a_909_74##4	4.34818e-18
C190	VGND#6	A0#3	7.42894e-18
C191	a_333_74##2	a_909_74##4	1.81607e-17
C192	S1#3	S1#4	3.99264e-19
C193	VPWR#3	a_1500_94##4	5.65724e-18
C194	VPWR#2	a_1429_74##3	1.70115e-20
C195	S0#6	A0#1	4.85947e-17
C196	a_333_74##3	A1#1	2.64075e-18
C197	VGND#6	a_31_94#	8.99573e-18
C198	VPWR#11	A3#2	1.2653e-18
C199	VPWR#3	S1#5	2.07007e-18
C200	VGND#6	S0#5	4.998e-19
C201	A2#2	S1#3	1.72981e-18
C202	VGND#11	A0#3	4.4523e-17
C203	VGND#12	A1#2	8.73629e-19
C204	a_909_74##2	a_333_74#	8.86257e-17
C205	a_1429_74##9	a_1429_74##6	2.57081e-18
C206	VGND#6	A1#3	4.86145e-19
C207	VGND#4	a_31_94##4	5.53386e-18
C208	a_909_74##2	a_1047_74#	8.22812e-19
C209	VPWR#11	A0#2	1.06222e-18
C210	a_31_94##3	S0#6	1.6238e-17
C211	a_909_74##2	a_333_74##2	3.84627e-17
C212	S0#11	S1#3	3.65054e-19
C213	a_31_94##4	A2#2	9.08301e-19
C214	VPWR#12	a_333_74##3	1.1675e-17
C215	VGND#6	S0#3	8.87672e-18
C216	a_1429_74##9	VPWR#3	2.29119e-17
C217	VPWR#2	a_1429_74##2	2.35439e-20
C218	a_333_74##3	S0#1	1.72434e-18
C219	a_31_94##12	S1#5	1.57288e-19
C220	a_31_94##12	VPWR#5	7.11822e-18
C221	VGND#11	a_31_94#	2.34521e-18
C222	S0#2	VGND#12	2.95687e-17
C223	S0#11	A2#3	2.63631e-18
C224	a_333_74##4	A0#3	6.86671e-19
C225	a_31_94##7	S0#2	3.59206e-17
C226	a_31_94##12	A2#1	7.9306e-19
C227	a_31_94##12	VPWR#4	9.65699e-19
C228	S0#11	a_31_94##4	8.24923e-18
C229	A1#1	a_31_94##3	1.01586e-17
C230	S1	a_1500_94##2	1.88334e-17
C231	a_909_74##2	a_1429_74##10	1.37409e-16
C232	VPWR#3	a_909_74##4	3.3881e-17
C233	a_1429_74##9	S1#2	2.53508e-17
C234	a_31_94##12	S0#10	2.52894e-18
C235	a_909_74##4	a_1429_74##6	4.57069e-20
C236	S0#7	a_333_74##6	4.74225e-19
C237	VGND#11	S0#5	5.44551e-19
C238	VGND#3	a_1429_74##9	4.66934e-17
C239	a_31_94##12	a_31_94##6	1.03147e-17
C240	a_333_74##4	a_31_94#	5.37086e-17
C241	S0#13	A3#5	2.31054e-17
C242	a_31_94##10	VPWR#5	1.47243e-19
C243	VPWR#6	A2#1	4.86354e-19
C244	S0#1	A1#1	2.61155e-17
C245	a_909_74##2	a_1429_74##6	7.43791e-19
C246	a_31_94##12	A3#1	1.48185e-18
C247	S0#8	a_31_94##4	4.43911e-18
C248	a_909_74##3	VGND#10	7.34136e-18
C249	VPWR#6	S0#10	8.81081e-19
C250	a_909_74##2	a_909_74#	6.92658e-18
C251	S1#1	a_1429_74##4	9.00195e-18
C252	a_31_94##12	A0#1	3.50608e-20
C253	a_1429_74##9	a_1500_94##3	2.33056e-19
C254	a_909_74##4	S1#2	1.05799e-17
C255	S0#5	a_333_74##4	2.00778e-17
C256	A3#3	S0#8	6.14479e-18
C257	VGND#3	a_909_74##2	3.91554e-17
C258	a_1500_94#	S1#1	1.78752e-17
C259	a_31_94##12	S0#6	1.8116e-20
C260	VGND#12	a_31_94#	9.98238e-19
C261	VPWR#6	VPWR#5	9.70407e-17
C262	a_909_74##2	S1#2	3.31467e-17
C263	a_1500_94#	a_1500_94##4	1.14056e-18
C264	VPWR#3	a_333_74##2	5.91937e-19
C265	a_31_94##10	S0#6	4.69691e-19
C266	VPWR#6	A0#1	1.60047e-18
C267	VPWR#6	VPWR#4	9.95095e-17
C268	a_909_74##2	VGND#10	6.01038e-17
C269	a_1500_94#	S1#5	1.74649e-19
C270	a_31_94##10	a_31_94##3	1.00434e-17
C271	a_1429_74##9	S1#3	8.34379e-20
C272	VGND#12	S0#5	5.63833e-18
C273	a_909_74##4	a_1500_94##3	1.01222e-19
C274	VGND#1	VPWR#1	1.00661e-17
C275	a_333_74##3	a_333_74##2	1.71676e-18
C276	VPWR#6	S0#6	3.20951e-18
C277	a_1500_94#	A2#1	1.45778e-19
C278	VPWR#12	A1#2	5.29845e-18
C279	A0#2	A3#3	3.73117e-18
C280	S0#14	A0#5	2.01143e-17
C281	a_31_94##10	A1#1	6.0712e-18
C282	VPWR#6	a_31_94##3	7.63645e-18
C283	VGND#6	VGND#4	1.01028e-16
C284	a_31_94##7	S0#5	4.47173e-19
C285	A2#1	S1#4	1.44632e-18
C286	a_909_74##2	a_1500_94##3	2.79867e-17
C287	VGND#3	a_333_74##2	1.52982e-18
C288	a_31_94##10	S0#1	4.51661e-19
C289	VPWR#6	A1#1	1.66373e-18
C290	a_31_94#	A0#2	7.93513e-19
C291	a_31_94##8	a_31_94##3	8.82899e-21
C292	VGND#12	A1#3	4.79848e-17
C293	S0#2	VPWR#12	5.92023e-18
C294	a_909_74##6	a_1152_392#	6.09096e-18
C295	VPWR#6	S0#1	2.81809e-18
C296	a_31_94##8	A1#1	1.65158e-18
C297	a_909_74##4	S1#3	1.71747e-20
C298	a_31_94##7	A1#3	4.18199e-18
C299	a_31_94##12	a_333_74##3	6.35191e-17
C300	a_31_94##9	VPWR#12	6.61482e-17
C301	a_31_94##8	S0#1	1.43628e-17
C302	S0#11	A2#1	5.6441e-18
C303	S0#3	VGND#12	2.01059e-17
C304	a_909_74##2	S1#3	3.24167e-17
C305	a_31_94##12	a_333_74##2	6.4056e-17
C306	a_333_74##2	S1#2	8.15947e-20
C307	VGND#11	a_909_74##3	2.0043e-17
C308	S0#14	a_507_74#	1.50068e-17
C309	a_31_94##5	A2#1	3.29328e-19
C310	a_909_74##3	a_909_74##2	1.10439e-18
C311	a_333_74##2	a_909_74#	7.29571e-19
C312	VGND#2	a_1429_74##4	7.6643e-20
C313	a_31_94##7	S0#3	2.98169e-17
C314	VPWR#6	a_909_74##4	1.80135e-18
C315	a_31_94##5	S0#10	3.34341e-19
C316	S0#4	a_31_94#	2.12967e-18
C317	a_909_74##3	a_1047_74#	1.37054e-17
C318	a_31_94##12	VPWR#6	4.28649e-17
C319	a_31_94##10	a_333_74##3	1.06937e-16
C320	a_1429_74##9	a_1429_74##3	1.14733e-18
C321	a_31_94##10	VPWR#6	7.56478e-17
C322	A3#1	a_31_94##5	5.92346e-20
C323	A1#3	S0#4	9.53471e-18
C324	a_909_74##2	A2#3	2.84233e-17
C325	VPWR#3	a_1429_74##4	8.49739e-19
C326	a_333_74##2	a_1500_94##3	1.46119e-19
C327	a_31_94##8	a_31_94##10	3.96937e-19
C328	VGND#3	a_1429_74##4	1.45482e-18
C329	VPWR#3	a_1500_94#	2.91599e-18
C330	VGND#9	VPWR#9	3.00089e-18
C331	S0#15	A1#5	2.53216e-18
C332	a_31_94##8	VPWR#6	2.5746e-17
C333	VGND#3	a_1500_94#	2.19081e-18
C334	a_333_74##3	VPWR#6	1.06547e-16
C335	VPWR#3	S1#4	1.74291e-18
C336	VPWR#2	a_1429_74##4	6.7228e-20
C337	S0#15	a_255_74#	2.20815e-19
C338	S0#2	A1#3	1.38883e-17
C339	a_1429_74##6	a_1429_74##5	3.62364e-17
C340	VPWR#6	a_333_74##2	1.34039e-17
C341	VGND#3	S1#4	1.46783e-18
C342	a_909_74##2	a_31_94##4	3.09683e-19
C343	VPWR#1	a_1429_74#	3.23574e-17
C344	S0#2	S0#3	2.05464e-18
C345	VGND#6	a_31_94##8	2.12231e-18
C346	VGND#4	S1#4	3.56086e-20
C347	a_31_94##12	S1#4	4.8173e-20
C348	S1	a_909_74##4	9.81128e-18
C349	A3#5	VPWR#11	1.8969e-18
C350	a_1429_74#	X#3	2.44129e-17
C351	VGND#3	a_1429_74##3	8.62111e-20
C352	VGND#6	a_909_74##2	8.16622e-18
C353	VPWR#1	a_1429_74##7	1.26838e-18
C354	a_1429_74##9	a_1429_74##4	2.45013e-17
C355	a_31_94##12	S0#11	9.09509e-20
C356	VPWR#9	a_1429_74#	5.84147e-19
C357	S1#2	a_1429_74##6	8.17592e-18
C358	VGND#3	a_1429_74##2	7.68704e-21
C359	a_333_74##2	A2#3	2.12972e-18
C360	a_909_74##3	a_333_74##2	2.52791e-18
C361	a_31_94##12	a_31_94##5	1.23802e-18
C362	a_1429_74##7	X#3	2.37392e-17
C363	a_333_74##4	a_507_74#	1.90222e-18
C364	A2#5	a_333_74##2	1.25982e-17
C365	VPWR#6	S0#11	2.94492e-18
C366	a_909_74##4	a_1429_74##4	4.97517e-18
C367	VPWR#1	S1#1	4.47026e-19
C368	a_31_94##12	S0#8	7.8181e-18
C369	a_31_94##12	S0#14	1.50536e-18
C370	VPWR#4	S1#4	6.34552e-20
C371	VPWR#2	VPWR#1	6.99578e-19
C372	a_1429_74##7	VPWR#9	2.69578e-17
C373	A3	a_333_74##3	1.2424e-17
C374	a_1429_74##11	VGND#9	1.09241e-21
C375	A1#1	a_31_94##2	9.10817e-19
C376	a_31_94##12	A3#2	4.53467e-19
C377	a_1500_94#	S1#4	1.55315e-19
C378	a_31_94##12	S0#13	2.45111e-17
C379	VGND#6	a_333_74##2	2.11164e-18
C380	VGND#6	S0#11	4.88198e-18
C381	a_31_94##2	S0#1	1.29608e-19
C382	a_333_74##2	a_31_94##4	2.95947e-19
C383	a_1500_94##3	S1#2	4.99335e-18
C384	a_31_94##10	S0#15	2.6829e-17
C385	a_1500_94#	A2#2	8.88327e-20
C386	a_31_94##12	A0#2	1.24306e-19
C387	VGND#6	a_31_94##5	4.04264e-18
C388	A2#1	a_1152_392#	1.44909e-17
C389	S1#1	VPWR#9	1.97122e-17
C390	VGND#4	S0#11	4.04126e-19
C391	A2#2	S1#4	8.10611e-18
C392	a_31_94##10	S0#14	5.56666e-18
C393	a_1500_94#	a_909_74##4	1.01369e-16
C394	S0#10	a_1152_392#	1.40117e-17
C395	a_31_94##12	S0#7	4.94073e-20
C396	VGND#6	S0#8	8.87989e-19
C397	A1#5	S0#1	1.83069e-18
C398	S1#3	S1#2	2.72037e-19
C399	S0#1	A1#2	5.52822e-18
C400	A0	a_333_74##3	1.56277e-17
C401	A2#3	a_1047_74#	2.50176e-17
C402	S0#13	A3	2.22326e-17
C403	a_31_94##10	S0#7	8.00865e-18
C404	a_909_74##2	a_1500_94#	7.25125e-18
C405	S1#1	a_1500_94##5	3.8451e-17
C406	a_31_94##4	a_1047_74#	2.4196e-17
C407	VPWR#6	S0#7	4.92247e-20
C408	S0#11	A2#2	3.57306e-17
C409	a_1429_74##11	a_1429_74##7	1.15704e-19
C410	a_31_94##6	a_840_392#	2.4259e-17
C411	a_31_94##10	a_31_94##2	2.07147e-18
C412	VPWR#6	S0#15	5.36858e-18
C413	S1#3	a_1500_94##3	4.00391e-17
C414	A3#1	a_840_392#	3.60018e-17
C415	a_31_94##5	A2#2	1.12926e-18
C416	VPWR#6	a_31_94##2	1.19252e-18
C417	X	a_1429_74##3	1.56362e-17
C418	a_333_74#	S1	3.53327e-17
C419	X	a_1429_74##2	1.65773e-17
C420	a_31_94##10	S0#4	8.08338e-18
C421	VGND#6	S0#7	2.5711e-19
C422	a_1500_94##5	a_1500_94##4	7.82646e-19
C423	a_31_94##8	a_31_94##2	2.42174e-19
C424	a_31_94##5	S0#11	6.84007e-17
C425	S1#4	a_909_74##4	3.59544e-18
C426	a_31_94##12	A3#5	5.21616e-18
C427	S0#14	A0	1.85208e-17
C428	VPWR#6	S0#4	3.81245e-18
C429	a_1429_74##11	S1#1	1.63725e-17
C430	VGND#2	a_1429_74##9	1.97613e-17
C431	VPWR#6	S0#13	3.50413e-18
C432	VGND#6	a_31_94##2	3.38997e-18
C433	VPWR#4	S0#11	4.7594e-20
C434	S0#11	S0#8	1.78931e-19
C435	a_909_74##2	S1#4	6.45453e-19
C436	A0#1	a_618_392#	1.96119e-17
C437	a_333_74#	a_333_74##5	4.17688e-19
C438	a_1500_94##4	a_909_74##5	2.81753e-17
C439	a_333_74##2	a_1500_94#	1.40284e-18
C440	VPWR#6	A1#2	3.44266e-20
C441	a_909_74##4	a_1500_94##2	1.78218e-20
C442	S0#6	a_618_392#	1.96119e-17
C443	a_31_94##8	S0#15	3.64349e-19
C444	A0	A3#5	2.84688e-17
C445	S0#9	a_831_74#	1.73994e-17
C446	S0#8	a_31_94##5	2.17984e-17
C447	VGND#6	S0#4	4.34239e-19
C448	a_31_94##8	A1#2	1.59333e-18
C449	A3#3	a_831_74#	1.73994e-17
C450	VPWR#6	S0#2	7.20591e-19
C451	A2#3	S1#3	5.2841e-18
C452	A3#2	a_31_94##5	6.7653e-18
C453	a_1429_74##11	a_1500_94##4	4.61313e-17
C454	S0#15	A1	3.62923e-17
C455	a_31_94##8	S0#2	4.65217e-17
C456	a_31_94##3	a_264_392#	4.12734e-17
C457	A3#2	S0#8	2.23863e-17
C458	a_909_74##2	A2	2.68015e-17
C459	a_31_94##5	A0#2	1.27494e-19
C460	VGND#6	S0#2	1.00639e-17
C461	A1#1	a_264_392#	3.47415e-17
C462	a_333_74##5	a_1500_94##4	3.25594e-18
C463	A2	a_333_74##2	7.0971e-17
C464	A0#3	a_507_74#	3.54299e-18
C465	VPWR#4	a_31_94##5	6.78314e-20
C466	a_909_74##2	A2#2	2.58483e-18
C467	a_31_94##12	a_840_392#	6.74877e-18
C468	a_31_94#	a_507_74#	2.20864e-17
C469	a_333_74##2	S1#4	3.92493e-17
C470	VGND#6	S0#15	2.8465e-17
C471	a_1429_74##11	S1#5	3.36759e-17
C472	A0#2	A3#2	3.34943e-17
C473	VPWR#10	a_1500_94##4	2.04568e-19
C474	VGND#6	S0#14	6.31626e-17
C475	a_31_94##4	A2#3	6.73006e-18
C476	VGND#3	VGND#1	5.24598e-17
C477	a_31_94##10	A0#5	5.49601e-18
C478	a_333_74##5	S1#5	3.84592e-17
C479	S0#7	A0#2	3.73309e-17
C480	VGND#6	S0#13	1.77889e-17
C481	a_1429_74##11	A2#1	2.43531e-18
C482	a_1429_74##3	a_1429_74#	8.80869e-19
C483	a_31_94##10	a_264_392#	2.04759e-17
C484	VPWR#5	S0#8	3.58902e-19
C485	a_31_94##2	A0#2	1.42218e-18
C486	VPWR#10	S1#5	5.52529e-18
C487	a_333_74##2	A2#2	7.7739e-18
C488	a_31_94##2	S0#7	2.51294e-17
C489	VGND#4	a_909_74##2	1.85572e-17
C490	S0#5	a_255_74#	1.33061e-17
C491	a_31_94##7	VGND#12	2.22837e-17
C492	A2#5	S1#4	3.61205e-19
C493	VPWR#2	a_1429_74#	2.4916e-18
C494	a_909_74##6	a_1500_94##4	4.94348e-19
C495	VGND#2	X	1.21875e-17
C496	A1#3	a_255_74#	1.08775e-18
C497	X	VPWR#2	1.79879e-17
C498	S1	S1#3	5.10731e-19
C499	a_1429_74##11	VPWR#4	2.48258e-17
C500	S0#9	a_31_94##4	1.21728e-17
C501	S0#4	a_31_94##2	2.37796e-17
C502	VGND#3	a_1500_94##8	6.11945e-18
C503	S0#15	a_333_74##3	1.40038e-18
C504	VPWR#10	A2#1	4.92729e-17
C505	a_1429_74##9	VPWR#9	1.38166e-16
C506	a_1429_74##9	X	2.80226e-17
C507	A1#2	a_31_94##2	4.42196e-18
C508	a_909_74##6	S1#5	9.61868e-19
C509	A0	VPWR#11	9.684e-19
C510	VGND#3	a_333_74#	5.37e-18
C511	A1#2	S0#4	2.03912e-17
C512	S0#11	a_333_74##2	2.76526e-17
C513	A2#5	A2#2	6.78105e-18
C514	S0#2	S0#4	1.35204e-19
C515	VGND#6	A3#5	1.09191e-18
C516	VGND#3	a_1429_74##10	1.19093e-16
C517	VPWR#10	S0#10	3.33852e-18
C518	VPWR#2	a_1429_74##7	8.07141e-18
C519	a_31_94##12	a_831_74#	3.35953e-19
C520	S0#2	A1#2	3.03928e-17
C521	a_909_74##6	A2#1	2.64876e-17
C522	A3#3	S0#9	5.01278e-17
C523	S0#14	a_333_74##3	6.43072e-18
C524	VPWR#6	A1#5	1.63796e-19
C525	VPWR#10	a_31_94##6	1.2157e-18
C526	S0#11	a_1047_74#	3.33688e-18
C527	S0#14	a_31_94##4	2.25099e-19
C528	X	VGND#1	7.34709e-17
C529	a_31_94##5	a_333_74##2	1.17216e-18
C530	a_909_74##6	S0#10	5.25044e-17
C531	a_31_94##2	a_264_392#	3.89011e-19
C532	VGND#6	A0#5	9.84692e-19
C533	VGND#9	X	6.61271e-17
C534	S0#11	A2#5	1.80539e-17
C535	A1#5	VPWR#12	2.06965e-17
C536	a_1429_74##3	VNB	1.92733e-17
C537	a_1429_74##2	VNB	3.42781e-17
C538	a_1500_94##2	VNB	1.60575e-17
C539	VPWR#11	A2#1	5.93205e-19
C540	VPWR#2	S1#1	2.38839e-19
C541	a_31_94##10	a_255_74#	6.41364e-19
C542	S0#13	a_31_94##4	9.94239e-18
C543	a_31_94##8	A1#5	1.02512e-17
C544	VPWR#10	A3#1	6.64758e-19
C545	A0#3	A3#3	1.09499e-17
C546	S0#13	a_333_74##3	1.1886e-17
C547	A2	S1#3	7.79504e-20
C548	a_909_74##6	a_31_94##6	4.18951e-17
C549	A2	a_31_94##4	2.26252e-19
C550	X	VPWR#1	8.57003e-17
C551	VPWR#3	S1	2.86935e-18
C552	a_333_74##3	S0#8	3.45026e-18
C553	X	X#3	7.21339e-19
C554	VPWR#9	X	9.69387e-17
C555	VGND#3	S1	2.27719e-18
C556	S0#14	S0#9	2.38675e-19
C557	VPWR#11	S0#10	7.66744e-19
C558	S1#1	a_1429_74##3	1.07936e-18
C559	VPWR#4	a_1500_94##4	1.25721e-18
C560	a_909_74##4	a_1500_94##5	1.14672e-16
C561	a_1429_74##9	VPWR#2	1.30616e-17
C562	a_1429_74##9	a_1429_74##7	2.49094e-18
C563	A2#5	a_31_94##5	9.4571e-20
C564	a_31_94##12	A3	3.89596e-18
C565	VGND#6	A1#5	1.50968e-18
C566	a_1429_74##3	a_1429_74##2	2.96714e-18
C567	a_31_94##12	a_909_74##3	4.56322e-18
C568	a_909_74##6	A3#1	2.68708e-18
C569	S0#13	A2#2	2.57796e-19
C570	S0#13	S0#9	5.93109e-18
C571	VGND#2	VGND#1	2.21165e-18
C572	VPWR#2	a_1500_94##4	1.85242e-19
C573	S1	a_1500_94#	3.02204e-17
C574	VPWR#11	a_31_94##6	3.37452e-18
C575	X	a_1429_74##5	2.37436e-17
C576	VGND#4	VNB	7.93209e-17
C577	a_31_94#	A0#3	7.35829e-18
C578	VGND#2	VNB	3.51342e-17
C579	X	a_1429_74##6	2.22451e-17
C580	A2	A2#1	3.06033e-18
C581	S1	S1#4	5.53672e-18
C582	S0#14	a_909_74##3	4.39853e-20
C583	VGND#6	A3	8.54022e-19
C584	X	S1#2	4.57187e-19
C585	a_31_94##12	A0	3.20184e-18
C586	VPWR#9	VPWR#1	1.73109e-18
C587	VPWR#5	VNB	5.14713e-17
C588	VPWR#4	VNB	8.02892e-17
C589	VPWR#2	VNB	3.1729e-17
C590	a_31_94##10	A0	1.10452e-18
C591	a_1429_74##11	a_1429_74##9	1.04373e-18
C592	a_1429_74##9	VNB	2.0505e-17
C593	S0#14	A3#3	6.98601e-19
C594	a_909_74##4	VNB	1.72844e-17
C595	a_1500_94##2	S1#1	5.38289e-19
C596	a_333_74##3	A3#2	3.02865e-18
C597	a_909_74##2	VNB	1.5033e-17
C598	a_333_74##3	VNB	1.67418e-17
C599	VGND#6	A0	8.56816e-19
C600	a_333_74##2	VNB	1.72961e-17
C601	a_909_74##6	A0#1	8.24294e-19
C602	a_31_94##12	VGND#11	4.35222e-18
C603	A2#5	VNB	5.86465e-19
C604	a_31_94##10	A1	6.99706e-18
C605	a_909_74##4	a_909_74##5	4.38033e-18
C606	VPWR#6	A1	1.74035e-18
C607	VPWR#4	S1#5	7.2061e-18
C608	A3	a_31_94##5	7.47543e-18
C609	A3#1	VPWR#11	3.28159e-17
C610	a_1429_74##9	S1#1	1.62064e-17
C611	S0#15	VNB	5.79677e-18
C612	a_31_94##8	A1	1.01967e-18
C613	S0#14	VNB	5.88297e-18
C614	A3	S0#8	2.29337e-18
C615	a_909_74##4	VPWR#4	7.8541e-18
C616	S0#13	VNB	9.68327e-18
C617	X	a_1429_74#	3.23385e-17
C618	S0#15	A0#3	1.20422e-19
C619	VGND#6	A1	1.31378e-18
C620	X	a_1429_74##7	3.16487e-17
C621	S0#13	S0#11	2.59976e-18
C622	A3	A3#2	9.15367e-18
C623	X	S1#1	4.13713e-19
C624	S0#13	A3#3	2.70368e-17
C625	A3#5	VNB	1.81998e-18
C626	a_909_74##3	S0#13	6.4213e-17
C627	VGND#1	a_1429_74##5	2.44797e-17
C628	VPWR#6	A2	3.97692e-18
C629	A1#5	VNB	1.81946e-18
C630	VGND#1	VNB	7.36728e-17
C631	A0	A3#2	3.32958e-18
C632	VGND#6	A2	5.18124e-18
C633	VPWR#2	S1#5	3.52285e-20
C634	VGND#9	VNB	2.40195e-18
C635	a_1500_94##8	VNB	4.06399e-18
C636	S0#5	a_31_94#	6.94085e-18
C637	a_333_74#	VNB	2.13319e-18
C638	A0	A0#2	4.94987e-18
C639	VPWR#3	VPWR#1	5.37602e-17
C640	a_1429_74##10	VNB	1.70515e-17
C641	VGND#10	VNB	3.39213e-18
C642	a_909_74##3	VNB	3.40508e-18
C643	A2	S1#4	4.54382e-19
C644	S0#14	A0#3	1.9884e-17
C645	a_31_94##10	VGND#11	2.32903e-18
C646	VGND#11	VNB	1.70763e-18
C647	A0#1	VPWR#11	3.56316e-17
C648	A2	A2#2	2.03869e-17
C649	a_333_74##4	VNB	1.16191e-18
C650	VGND#12	VNB	5.31534e-18
C651	S0#11	A2	4.2394e-17
C652	a_31_94##7	VNB	4.10895e-17
C653	a_333_74##3	A0#2	2.16548e-18
C654	a_909_74##6	VPWR#4	3.17608e-17
C655	VPWR#1	VNB	7.97514e-17
C656	VPWR#3	X	2.08441e-17
C657	a_31_94##5	A2	1.47888e-18
C658	VPWR#9	VNB	9.77903e-19
C659	VGND#3	X	1.94472e-17
C660	a_1500_94##5	VNB	3.97213e-18
C661	a_1429_74##5	X#1	1.54402e-17
C662	A1	a_31_94##2	7.30414e-18
C663	a_1429_74##11	VNB	1.23872e-17
C664	a_333_74##5	VNB	2.13014e-18
C665	a_909_74##4	S1#1	3.1709e-17
C666	VPWR#10	VNB	2.38389e-18
C667	A1	S0#4	2.32124e-18
C668	a_1429_74##4	VGND#9	7.87478e-18
C669	a_909_74##6	VNB	1.05703e-18
C670	A1	A1#2	1.09088e-17
C671	a_909_74##4	a_1429_74##11	1.33516e-16
C672	VPWR#11	VNB	4.65345e-18
C673	S0#15	a_31_94#	2.28413e-18
C674	S0#13	a_31_94##5	3.79942e-17
C675	a_1429_74##9	a_1500_94##4	2.33728e-19
C676	VPWR#4	A2#1	3.96975e-18
C677	VGND#1	a_1429_74##6	1.19981e-18
C678	VPWR#12	VNB	9.47921e-18
C679	a_31_94##9	VNB	3.38071e-17
C680	a_1429_74##5	VNB	3.07714e-17
C681	a_1429_74##6	VNB	2.79825e-17
C682	S1#2	VNB	9.969e-17
C683	VGND#3	VPWR#1	3.13753e-18
C684	a_1500_94##3	VNB	2.9847e-17
C685	S1#3	VNB	8.4121e-17
C686	VPWR#11	S0#6	1.26728e-18
C687	A2#3	VNB	3.16373e-17
C688	a_31_94##4	VNB	3.23303e-17
C689	a_31_94##10	a_333_74##4	1.10488e-17
C690	S0#9	VNB	2.62294e-17
C691	A3#3	VNB	3.0689e-17
C692	A0#3	VNB	2.68948e-17
C693	S0#14	VGND#11	5.78127e-17
C694	a_31_94#	VNB	3.4496e-17
C695	S0#5	VNB	2.79825e-17
C696	A1#3	VNB	3.45826e-17
C697	VGND#9	a_1429_74##5	1.10634e-18
C698	S0#3	VNB	3.46011e-17
C699	A1#3	S0#5	4.89437e-17
C700	a_1429_74#	VNB	3.988e-17
C701	a_1429_74##7	VNB	3.43063e-17
C702	S1#1	VNB	5.21623e-17
C703	VPWR#3	a_1500_94##5	5.91372e-18
C704	a_1500_94##4	VNB	3.50729e-17
C705	S0#14	a_31_94#	3.11859e-17
C706	S1#5	VNB	4.17752e-17
C707	A2#1	VNB	3.67757e-17
C708	S0#10	VNB	3.3401e-17
C709	a_31_94##6	VNB	3.29705e-17
C710	VGND#6	VGND#10	1.59292e-17
C711	A3#1	VNB	3.11393e-17
C712	a_1429_74##6	X#1	1.49333e-17
C713	A0#1	VNB	3.14736e-17
C714	S0#6	VNB	3.23519e-17
C715	a_31_94##3	VNB	3.50785e-17
C716	S0#14	S0#8	6.88361e-20
C717	A1#1	VNB	3.77312e-17
C718	a_333_74##3	S0#7	7.0354e-17
C719	S0#1	VNB	4.53283e-17
C720	VPWR#3	VNB	2.54693e-16
C721	a_333_74##2	a_1500_94##2	1.15282e-19
C722	VGND#3	VNB	2.35268e-16
C723	a_31_94##12	VNB	1.47822e-18
C724	VPWR#11	a_31_94##3	5.6479e-19
C725	VGND#3	VPWR#9	1.43299e-18
C726	a_31_94##10	VNB	1.82611e-18
C727	VPWR#6	VNB	3.23096e-16
C728	VGND#1	S1#2	9.76701e-19
C729	a_31_94##8	VNB	4.92203e-17
C730	VGND#6	VNB	3.79836e-16
C731	a_909_74##4	a_1500_94##4	3.7381e-17
C732	a_1429_74##4	VNB	2.56428e-17
C733	S0#15	S0#5	2.14447e-17
C734	a_1500_94#	VNB	5.66739e-17
C735	S0#13	S0#8	2.1711e-17
C736	S1#4	VNB	4.16803e-17
C737	S0#6	a_333_74##6	8.24916e-18
C738	A2#2	VNB	3.54837e-17
C739	a_909_74##4	a_333_74##5	4.11577e-17
C740	S0#11	VNB	3.24166e-17
C741	a_31_94##5	VNB	4.26733e-17
C742	VGND#11	S0#13	2.49982e-17
C743	S0#8	VNB	1.94407e-17
C744	A3#2	VNB	4.20282e-17
C745	A0#2	VNB	4.5711e-17
C746	S0#7	VNB	2.70622e-17
C747	a_31_94##2	VNB	4.85423e-17
C748	VPWR#4	S0#10	5.97632e-18
C749	S0#4	VNB	2.24437e-17
C750	a_1429_74##6	VGND#9	1.57842e-17
C751	A1#2	VNB	3.67703e-17
C752	a_1429_74##11	VPWR#3	1.46628e-16
C753	VGND#6	a_909_74##3	6.01072e-17
C754	S0#2	VNB	6.00979e-17
C755	a_333_74#	a_1500_94#	3.34868e-17
C756	a_1500_94#	a_1500_94##2	2.14902e-19
C757	S0#3	A1#3	1.36437e-17
C758	S0#14	S0#5	2.36859e-19
C759	S0#15	a_333_74##4	8.74057e-17
C760	VPWR#3	a_333_74##5	2.69746e-18
C761	S1	VNB	2.44836e-18
C762	a_1429_74##10	a_1500_94#	7.29184e-19
C763	A3	VNB	2.88354e-18
C764	a_31_94##3	a_333_74##6	1.5736e-17
C765	A0	VNB	3.44595e-19
C766	A1	VNB	1.37931e-18
C767	S0#14	A3#2	9.77165e-20
C768	A2	VNB	4.9425e-18
C769	X	VNB	1.77693e-17
C770	a_333_74##3	a_31_94##2	4.11089e-17
C771	VPWR#12	S0#6	1.18873e-18
C772	VPWR#7	S0#4	6.40341e-19
C773	VGND#7	S0#4	1.40757e-19
C774	VGND#7	VNB	8.2133e-17
C775	VGND#7	S0#3	4.11096e-18
C776	VGND#6	VGND#7	1.42062e-16
C777	VPWR#7	a_31_94##2	1.76527e-19
C778	a_31_94##8	VPWR#7	5.98008e-18
C779	VGND#7	S0#2	3.48926e-18
C780	A1#5	VPWR#7	6.20795e-20
C781	VGND#7	a_31_94##2	9.11225e-20
C782	VGND#7	A1#3	3.73938e-18
C783	VPWR#6	VPWR#7	1.40115e-16
C784	VGND#7	S0#15	2.68867e-17
C785	VPWR#7	S0#1	4.64817e-18
C786	a_31_94##9	VPWR#7	2.08067e-17
C787	VPWR#7	VNB	7.95939e-17
C788	A1	VPWR#7	6.72671e-19
C789	a_31_94##10	VPWR#7	1.15677e-17
C790	VPWR#7	A1#1	6.84271e-18
C791	S0#2	VPWR#7	2.74665e-19
C792	S0#15	VPWR#7	1.40722e-18
C793	VGND#7	S0#5	5.99511e-18
C794	VGND#7	a_31_94##7	1.36641e-17
*
*
.ENDS sky130_fd_sc_hs__mux4_2
*
