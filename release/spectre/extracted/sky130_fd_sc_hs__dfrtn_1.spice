* Extracted by Quantus, converted by sky130cad/quantus.py
*
*
*
*                       LINUX           Wed Nov 18 08:26:50 2026
*
*
*
*  PROGRAM  advgen
*
*  Name           : advgen - Quantus - (64-bit)
*  Version        : 25.1.0-p047
*  Build Date     : Thu Dec 11 23:20:30 PST 2025
*
*  HSPICE LIBRARY
*
*  OPERATING_TEMPERATURE 150
*  QRC_TECH_DIR <path>/tech
*
*
*

*
.SUBCKT sky130_fd_sc_hs__dfrtn_1 VPB VNB VGND RESET_B VPWR Q D CLK_N
*
*
*  caps2d version: 10
*
*
*       TRANSISTOR CARDS
*
*
XM12 a_33_74##4 D#1 a_120_74# VNB sky130_fd_pr__nfet_01v8_lvt l=0.15 w=0.42 ad=0.1197 as=0.1008 pd=1.41 ps=1.32
XM3 a_120_74# RESET_B#1 VGND#14 VNB sky130_fd_pr__nfet_01v8_lvt l=0.15 w=0.42 ad=0.1008 as=0.2424 pd=1.32 ps=2.2
XM0 VGND#14 CLK_N#3 a_300_74##14 VNB sky130_fd_pr__nfet_01v8_lvt l=0.15 w=0.74 ad=0.2424 as=0.2035 pd=2.2 ps=2.03
XM29 VGND#13 a_300_74##8 a_507_368##11 VNB sky130_fd_pr__nfet_01v8_lvt l=0.15 w=0.74 ad=0.3593 as=0.2596 pd=2.88 ps=2.24
XM14 a_33_74##5 a_507_368# a_714_127##10 VNB sky130_fd_pr__nfet_01v8_lvt l=0.15 w=0.42 ad=0.1113 as=0.2226 pd=1.37 ps=1.9
XM4 a_714_127##10 a_300_74##3 a_850_127# VNB sky130_fd_pr__nfet_01v8_lvt l=0.15 w=0.42 ad=0.2226 as=0.0882 pd=1.9 ps=1.26
XM17 a_850_127# a_856_304# a_922_127# VNB sky130_fd_pr__nfet_01v8_lvt l=0.15 w=0.42 ad=0.0882 as=0.0882 pd=1.26 ps=1.26
XM18 a_922_127# RESET_B#4 VGND#12 VNB sky130_fd_pr__nfet_01v8_lvt l=0.15 w=0.42 ad=0.0882 as=0.48065 pd=1.26 ps=3.43
XM11 VGND#12 a_714_127##4 a_856_304##8 VNB sky130_fd_pr__nfet_01v8_lvt l=0.15 w=0.74 ad=0.48065 as=0.2146 pd=3.43 ps=2.06
XM24 a_856_304##8 a_300_74##2 a_1266_119##10 VNB sky130_fd_pr__nfet_01v8_lvt l=0.15 w=0.74 ad=0.2146 as=0.6134 pd=2.06 ps=4.02
XM10 a_1266_119##10 a_507_368##5 a_1550_119# VNB sky130_fd_pr__nfet_01v8_lvt l=0.15 w=0.42 ad=0.6134 as=0.1008 pd=4.02 ps=1.32
XM5 a_1550_119# a_1598_93# VGND#11 VNB sky130_fd_pr__nfet_01v8_lvt l=0.15 w=0.42 ad=0.1008 as=0.1638 pd=1.32 ps=1.62
XM16 VGND#11 RESET_B#7 a_1736_119# VNB sky130_fd_pr__nfet_01v8_lvt l=0.15 w=0.42 ad=0.1638 as=0.1008 pd=1.62 ps=1.32
XM21 a_1736_119# a_1266_119##5 a_1598_93##4 VNB sky130_fd_pr__nfet_01v8_lvt l=0.15 w=0.42 ad=0.1008 as=0.1197 pd=1.32 ps=1.41
XM27 a_1934_94##6 a_1266_119##7 VGND#10 VNB sky130_fd_pr__nfet_01v8_lvt l=0.15 w=0.55 ad=0.15675 as=0.25215 pd=1.67 ps=2.2
XM28 VGND#10 a_1934_94##3 Q#3 VNB sky130_fd_pr__nfet_01v8_lvt l=0.15 w=0.74 ad=0.25215 as=0.2146 pd=2.2 ps=2.06
XM2 VPWR#11 D#3 a_33_74##6 VPB sky130_fd_pr__pfet_01v8 l=0.15 w=0.42 ad=0.1218 as=0.126 pd=1.42 ps=1.44
XM22 a_33_74##6 RESET_B#3 VPWR#18 VPB sky130_fd_pr__pfet_01v8 l=0.15 w=0.42 ad=0.126 as=0.3346 pd=1.44 ps=2.95
XM25 VPWR#18 CLK_N#1 a_300_74##12 VPB sky130_fd_pr__pfet_01v8 l=0.15 w=1.12 ad=0.3346 as=0.3248 pd=2.95 ps=2.82
XM1 VPWR#17 a_300_74##9 a_507_368##13 VPB sky130_fd_pr__pfet_01v8 l=0.15 w=1.12 ad=0.3304 as=0.4312 pd=2.83 ps=3.01
XM23 a_33_74# a_300_74##7 a_714_127##8 VPB sky130_fd_pr__pfet_01v8 l=0.15 w=0.42 ad=0.1239 as=0.126 pd=1.43 ps=1.44
XM8 a_714_127##8 a_507_368##3 a_817_508# VPB sky130_fd_pr__pfet_01v8 l=0.15 w=0.42 ad=0.126 as=0.1008 pd=1.44 ps=1.32
XM15 a_817_508# a_856_304##3 VPWR#16 VPB sky130_fd_pr__pfet_01v8 l=0.15 w=0.42 ad=0.1008 as=0.1512 pd=1.32 ps=1.56
XM9 VPWR#16 RESET_B#6 a_714_127##9 VPB sky130_fd_pr__pfet_01v8 l=0.15 w=0.42 ad=0.1512 as=0.1155 pd=1.56 ps=1.39
XM30 VPWR#15 a_714_127# a_856_304##6 VPB sky130_fd_pr__pfet_01v8 l=0.15 w=1 ad=0.275 as=0.78 pd=2.55 ps=3.56
XM26 a_856_304##6 a_507_368##7 a_1266_119##12 VPB sky130_fd_pr__pfet_01v8 l=0.15 w=1 ad=0.78 as=0.4477 pd=3.56 ps=3.4
XM31 a_1266_119##12 a_300_74##11 a_1547_508# VPB sky130_fd_pr__pfet_01v8 l=0.15 w=0.42 ad=0.4477 as=0.1134 pd=3.4 ps=1.38
XM13 a_1547_508# a_1598_93##3 VPWR#14 VPB sky130_fd_pr__pfet_01v8 l=0.15 w=0.42 ad=0.1134 as=0.1638 pd=1.38 ps=1.62
XM6 VPWR#14 RESET_B#9 a_1598_93##7 VPB sky130_fd_pr__pfet_01v8 l=0.15 w=0.42 ad=0.1638 as=0.126 pd=1.62 ps=1.44
XM7 a_1598_93##7 a_1266_119##6 VPWR#13 VPB sky130_fd_pr__pfet_01v8 l=0.15 w=0.42 ad=0.126 as=0.1155 pd=1.44 ps=1.39
XM19 a_1934_94##7 a_1266_119# VPWR#12 VPB sky130_fd_pr__pfet_01v8 l=0.15 w=0.84 ad=0.231 as=0.3724 pd=2.23 ps=2.95
XM20 VPWR#12 a_1934_94# Q#1 VPB sky130_fd_pr__pfet_01v8 l=0.15 w=1.12 ad=0.3724 as=0.3192 pd=2.95 ps=2.81
*
*
*       RESISTOR AND CAP/DIODE CARDS
*
Rg1	D#1	D#2	328.968140
Rg2	D#2	D#3	644.160217
Rg3	RESET_B#1	RESET_B#2	474.357666
Rg4	RESET_B#2	RESET_B#3	539.171814
Rg5	CLK_N#1	CLK_N#2	489.343506
Rg6	CLK_N#2	CLK_N#3	305.221649
Rg7	a_507_368#	a_507_368##2	198.131927
Rg8	a_507_368##3	a_507_368##4	473.960266
Rg9	a_856_304#	a_856_304##2	419.840759
Rg10	a_856_304##2	a_856_304##3	465.217651
Rg11	RESET_B#4	RESET_B#5	391.147675
Rg12	RESET_B#5	RESET_B#6	486.968872
Rg13	a_714_127#	a_714_127##2	420.437378
Rg14	a_714_127##2	a_714_127##3	51.268543
Rg15	a_714_127##2	a_714_127##4	357.883698
Rg16	a_300_74#	a_300_74##2	322.284241
Rg17	a_300_74##2	a_300_74##3	1918.077271
Rg18	a_300_74##3	a_300_74##4	813.165100
Rg19	a_300_74##4	a_300_74##5	308.530579
Rg20	a_300_74##5	a_300_74##6	233.162476
Rg21	a_300_74##4	a_300_74##7	871.254883
Rg22	a_300_74##5	a_300_74##8	319.959229
Rg23	a_300_74##5	a_300_74##9	446.660797
Rg24	a_300_74##10	a_300_74##11	284.788483
Rg25	a_507_368##5	a_507_368##6	409.972015
Rg26	a_507_368##6	a_507_368##7	594.118469
Rg27	a_1598_93#	a_1598_93##2	721.118286
Rg28	a_1598_93##2	a_1598_93##3	253.774399
Rg29	RESET_B#7	RESET_B#8	411.232849
Rg30	RESET_B#8	RESET_B#9	489.143982
Rg31	a_1266_119#	a_1266_119##2	742.112793
Rg32	a_1266_119##2	a_1266_119##3	109.733414
Rg33	a_1266_119##3	a_1266_119##4	50.564472
Rg34	a_1266_119##4	a_1266_119##5	197.778931
Rg35	a_1266_119##2	a_1266_119##6	373.206299
Rg36	a_1266_119##4	a_1266_119##7	672.321777
Rg37	a_1934_94#	a_1934_94##2	456.142303
Rg38	a_1934_94##2	a_1934_94##3	320.356293
Rf1	D	D#2	80.116402
Rf2	RESET_B#2	RESET_B#11	162.660614
Rf3	RESET_B#12	RESET_B	12.205586
Rf4	RESET_B#11	RESET_B#12	6.876061
Rf5	CLK_N#4	CLK_N#2	162.112686
Rf6	CLK_N	CLK_N#6	1.879877
Rf7	CLK_N#4	CLK_N#6	4.941762
Rf8	a_300_74##12	a_300_74##6	49.872116
Rf9	a_300_74##6	a_300_74##14	51.614761
Rf10	a_33_74#	a_33_74##2	91.284660
Rf11	a_33_74##2	a_33_74##3	118.477127
Rf12	a_33_74##3	a_33_74##4	152.385422
Rf13	a_33_74##2	a_33_74##5	183.536591
Rf14	a_33_74##3	a_33_74##6	35.492405
Rf15	RESET_B#5	RESET_B#15	172.175797
Rf16	a_714_127##3	a_714_127##6	200.583878
Rf17	a_714_127##6	a_714_127##7	79.952415
Rf18	a_714_127##7	a_714_127##8	58.395573
Rf19	a_714_127##6	a_714_127##9	37.066368
Rf20	a_714_127##7	a_714_127##10	101.595848
Rf21	a_856_304##2	a_856_304##5	285.415283
Rf22	a_856_304##5	a_856_304##7	65.904663
Rf23	a_856_304##5	a_856_304##8	18.633333
Rf24	a_856_304##6	a_856_304##7	2.500000
Rf25	a_507_368##6	a_507_368##9	426.578156
Rf26	a_507_368##9	a_507_368##10	113.237000
Rf27	a_507_368##10	a_507_368##11	24.199945
Rf28	a_507_368##9	a_507_368##2	95.191437
Rf29	a_507_368##10	a_507_368##14	32.119984
Rf30	a_507_368##14	a_507_368##4	190.884460
Rf31	a_507_368##13	a_507_368##14	15.000000
Rf32	a_300_74##10	a_300_74#	324.893250
Rf33	RESET_B#16	RESET_B#17	0.540855
Rf34	RESET_B#8	RESET_B#19	160.773651
Rf35	RESET_B#16	RESET_B#19	5.708254
Rf36	a_1266_119##3	a_1266_119##9	171.000092
Rf37	a_1266_119##9	a_1266_119##11	38.213188
Rf38	a_1266_119##11	a_1266_119##10	41.376068
Rf39	a_1266_119##9	a_1266_119##12	138.796158
Rf40	a_1266_119##10	a_1266_119##11	15.000000
Rf41	a_1598_93##4	a_1598_93##5	143.766464
Rf42	a_1598_93##5	a_1598_93##2	184.413223
Rf43	a_1598_93##5	a_1598_93##7	33.022697
Rf44	a_1934_94##2	a_1934_94##5	179.936127
Rf45	a_1934_94##5	a_1934_94##6	52.668877
Rf46	a_1934_94##5	a_1934_94##7	59.372662
Rf47	Q	Q#2	0.186110
Rf48	Q#2	Q	13.585999
Rf49	Q	Q#3	83.984680
Rf50	Q#1	Q#2	5.000000
Rf52	VGND#2	VGND#3	102.668762
Rf53	VGND#3	VGND#4	39.748585
Rf54	VGND#4	VGND#5	229.655350
Rf55	VGND#5	VGND#6	133.657867
Rf56	VGND#6	VGND#7	85.809799
Rf57	VGND#7	VGND#8	74.154533
Rf59	VGND#2	VGND#10	43.341213
Rf60	VGND#4	VGND#11	34.594494
Rf61	VGND#5	VGND#12	32.735970
Rf62	VGND#7	VGND#13	23.484661
Rf63	VGND#8	VGND#14	40.352859
Rf65	VPWR#2	VPWR#3	68.733101
Rf66	VPWR#3	VPWR#4	33.270790
Rf67	VPWR#4	VPWR#5	41.979504
Rf68	VPWR#5	VPWR#6	193.534744
Rf69	VPWR#6	VPWR#7	75.192947
Rf70	VPWR#7	VPWR#8	92.384338
Rf71	VPWR#8	VPWR#9	82.157272
Rf72	VPWR#9	VPWR#10	73.731934
Rf73	VPWR#10	VPWR#11	101.733116
Rf74	VPWR#2	VPWR#12	43.597031
Rf75	VPWR#3	VPWR#13	40.352859
Rf76	VPWR#5	VPWR#14	34.507496
Rf77	VPWR#6	VPWR#15	31.731567
Rf78	VPWR#7	VPWR#16	34.507496
Rf79	VPWR#9	VPWR#17	31.751787
Rf80	VPWR#10	VPWR#18	33.523315
Re1	RESET_B#17	RESET_B#15	15.344948
Re2	RESET_B#15	RESET_B	6.390494
Re4	VPWR#4	VPWR	2.377092
Re5	VPWR	VPWR#8	1.528131
Re6	VGND#3	VGND	2.377092
Re7	VGND	VGND#6	1.528131
*
*       CAPACITOR CARDS
*
*
C1	a_33_74##2	a_507_368##4	2.2487e-19
C2	VPWR#8	a_856_304##6	3.23162e-17
C3	a_1934_94##7	a_1266_119##7	5.58351e-20
C4	RESET_B#17	VPWR#5	5.29634e-18
C5	a_300_74#	a_1266_119##10	1.8969e-18
C6	RESET_B#15	a_714_127##8	3.79321e-18
C7	VPWR#8	VPWR#15	1.47177e-17
C8	a_1266_119##9	a_1266_119##5	2.17944e-19
C9	a_714_127##8	a_714_127##6	5.60495e-19
C10	a_1266_119##6	a_1266_119#	4.97338e-18
C11	a_300_74##4	a_507_368##11	5.77712e-19
C12	a_1266_119##12	VPWR#5	2.41058e-17
C13	RESET_B#15	a_33_74#	1.30544e-18
C14	a_714_127##10	a_856_304#	3.80664e-18
C15	VPWR#8	a_714_127##9	1.73127e-17
C16	a_1598_93##5	a_1934_94##5	2.68401e-17
C17	a_33_74#	a_714_127##7	2.64831e-18
C18	a_300_74##5	a_300_74##3	1.561e-19
C19	RESET_B#15	a_507_368##13	1.40478e-18
C20	a_300_74##4	a_300_74##7	1.57432e-18
C21	a_856_304##6	VPWR#6	4.10512e-17
C22	VGND#5	RESET_B#4	3.82159e-18
C23	VPWR#4	VPWR#6	1.99769e-17
C24	a_714_127##6	a_507_368##7	8.95356e-20
C25	a_33_74#	a_714_127##8	4.08438e-17
C26	a_507_368##10	a_507_368##9	2.10793e-18
C27	RESET_B#9	a_1266_119##6	2.79808e-17
C28	a_714_127##10	a_300_74##3	5.69334e-17
C29	a_507_368##9	VGND#12	5.44348e-17
C30	VPWR#4	VPWR#5	1.05293e-16
C31	a_1266_119##9	RESET_B#7	5.49586e-19
C32	VPWR#7	VPWR#15	2.54081e-19
C33	a_714_127##8	VPWR#8	4.22919e-17
C34	a_507_368##13	a_714_127##7	6.62733e-19
C35	a_714_127##7	a_714_127#	1.11803e-19
C36	VPWR#4	VPWR#3	5.7204e-17
C37	a_300_74##6	a_33_74##2	4.03776e-17
C38	a_33_74#	VPWR#8	4.17825e-17
C39	VPWR#14	RESET_B#8	1.14828e-18
C40	a_33_74##5	a_300_74##3	4.05556e-20
C41	VPWR#4	a_1266_119##7	1.07061e-18
C42	a_33_74##5	a_507_368##11	4.28804e-18
C43	a_714_127##6	a_714_127#	4.18636e-18
C44	VPWR#8	a_507_368##13	5.11169e-18
C45	a_1598_93##3	RESET_B#9	1.49479e-17
C46	a_507_368#	a_714_127##10	1.67915e-17
C47	VGND#5	a_856_304#	2.31534e-18
C48	RESET_B#17	VGND#5	6.62045e-20
C49	VGND#3	a_1934_94##3	7.26518e-18
C50	VGND#12	RESET_B#5	3.0323e-19
C51	VPWR#8	VPWR#17	1.03272e-17
C52	a_1266_119##9	a_1598_93#	2.29287e-17
C53	a_507_368##13	a_33_74#	1.92756e-17
C54	a_300_74##9	a_300_74##4	8.64317e-18
C55	VGND#3	a_1266_119##7	9.08466e-18
C56	RESET_B#17	VGND#4	6.09147e-18
C57	a_33_74##3	CLK_N#2	2.26853e-20
C58	a_1598_93##2	VPWR#14	3.43367e-17
C59	a_507_368#	a_33_74##5	1.23762e-17
C60	a_714_127##7	RESET_B#6	2.4153e-19
C61	a_714_127##9	VPWR#7	8.7331e-18
C62	VPWR#8	a_300_74##12	6.59542e-18
C63	a_33_74##2	CLK_N#2	5.51174e-19
C64	VGND#6	a_507_368##13	2.56651e-19
C65	RESET_B#17	a_507_368##5	1.9022e-18
C66	a_856_304##5	a_856_304##8	2.12842e-18
C67	VGND#7	a_300_74##3	2.21576e-19
C68	a_33_74##5	VGND#13	4.99386e-18
C69	VGND#3	a_1266_119##5	1.59954e-17
C70	a_507_368#	a_300_74##4	1.56068e-17
C71	a_714_127##10	a_300_74##8	2.69764e-20
C72	a_300_74##11	a_1598_93##3	3.16095e-17
C73	VPWR#8	VPWR#18	6.68296e-18
C74	a_714_127##6	RESET_B#6	1.1102e-17
C75	a_1266_119##12	a_1598_93##2	3.37482e-17
C76	VPWR#17	a_33_74#	9.94846e-18
C77	RESET_B#15	VPWR#7	3.46496e-18
C78	VGND#3	RESET_B#7	5.95988e-18
C79	a_33_74#	a_300_74##4	2.66972e-19
C80	a_507_368##10	a_300_74##5	6.886e-18
C81	a_507_368##10	a_300_74##7	2.63569e-19
C82	VGND#6	a_300_74##12	1.34309e-18
C83	VPWR#8	a_33_74##6	1.45825e-17
C84	VGND#5	a_300_74##3	2.39949e-17
C85	a_714_127##9	VPWR#6	8.91077e-18
C86	a_33_74##5	a_300_74##8	3.5123e-17
C87	RESET_B#15	VPWR#6	4.38736e-18
C88	a_33_74##3	RESET_B#2	4.3902e-17
C89	VGND#3	a_1598_93#	3.92468e-18
C90	CLK_N#4	CLK_N#2	1.79353e-17
C91	a_1266_119##9	a_507_368##5	8.39782e-18
C92	a_507_368##10	a_714_127##10	2.34591e-17
C93	a_714_127##7	a_856_304##3	1.11855e-18
C94	a_300_74##14	a_33_74##5	4.75617e-17
C95	VPWR#8	VPWR#11	6.37658e-17
C96	CLK_N#1	a_300_74##5	4.43743e-19
C97	a_714_127##10	a_856_304##2	2.48904e-17
C98	a_1266_119##12	a_300_74##10	6.78647e-17
C99	a_856_304##5	VGND#12	1.0921e-18
C100	VGND#3	a_507_368##5	7.98715e-18
C101	a_507_368##7	a_300_74##11	7.09566e-18
C102	a_300_74##8	a_507_368##11	1.46056e-17
C103	a_714_127##6	a_856_304##3	6.73135e-19
C104	a_856_304##6	a_300_74##10	1.72759e-17
C105	a_507_368##13	a_300_74##5	2.39069e-18
C106	a_33_74##5	CLK_N#3	4.68419e-19
C107	RESET_B#17	a_1934_94##5	2.60694e-18
C108	a_507_368##10	a_300_74##4	3.34729e-17
C109	a_507_368##9	a_714_127##10	1.06568e-16
C110	a_300_74##8	VGND#13	1.84342e-17
C111	a_33_74##3	D#2	1.18481e-17
C112	CLK_N#4	RESET_B#2	2.87687e-18
C113	a_1266_119##12	a_507_368##6	2.02457e-18
C114	VGND#3	VGND#5	4.27428e-18
C115	a_714_127##7	a_507_368##3	3.53921e-18
C116	a_33_74##5	a_507_368##10	9.18969e-17
C117	a_1266_119##9	a_300_74##2	2.52744e-19
C118	RESET_B#16	a_1598_93#	1.9243e-18
C119	a_714_127#	a_507_368##7	7.75941e-18
C120	VGND#12	a_507_368##2	7.03551e-20
C121	a_507_368##6	a_856_304##6	2.75837e-20
C122	a_33_74##2	a_507_368##13	7.51312e-17
C123	a_507_368##13	a_300_74##4	2.99709e-17
C124	VGND#3	VGND#4	1.39923e-16
C125	a_300_74##14	a_300_74##8	7.14101e-18
C126	VPWR#8	VPWR#10	7.0644e-17
C127	a_300_74##12	VPWR#17	1.2922e-18
C128	a_714_127##6	a_507_368##3	2.38577e-19
C129	a_300_74#	a_1266_119##12	7.5382e-19
C130	a_300_74##14	VGND#13	4.56279e-18
C131	a_1598_93##5	a_1934_94##7	2.95303e-17
C132	VGND#7	a_300_74##8	1.10128e-17
C133	a_507_368##9	a_856_304##5	7.52179e-17
C134	RESET_B#17	a_1598_93##5	4.23543e-18
C135	VPWR#8	VPWR#9	7.06591e-17
C136	CLK_N#4	D#2	5.1418e-19
C137	VPWR#4	a_1934_94##5	1.3447e-18
C138	a_300_74#	a_856_304##6	7.24796e-17
C139	a_33_74##5	a_507_368##9	4.02688e-17
C140	a_1266_119##7	a_1934_94##2	4.11111e-18
C141	RESET_B#6	a_714_127#	5.53874e-18
C142	a_507_368##2	a_33_74##5	4.37187e-17
C143	a_714_127##7	a_300_74##7	2.2071e-18
C144	VPWR#8	VPWR#7	8.35056e-17
C145	VPWR#18	VPWR#17	8.84227e-18
C146	a_1266_119##12	a_507_368##5	7.56837e-20
C147	a_507_368##10	a_507_368##11	3.92707e-18
C148	a_33_74##2	VPWR#17	4.16572e-17
C149	a_300_74##14	CLK_N#3	4.9706e-17
C150	RESET_B#15	VGND#5	5.41899e-18
C151	VPWR#17	a_300_74##5	4.74297e-21
C152	VPWR#8	VPWR#6	8.9858e-17
C153	RESET_B#17	a_1266_119##9	4.50548e-17
C154	RESET_B#15	a_300_74##3	6.31351e-18
C155	a_33_74##3	a_300_74##12	1.80444e-17
C156	a_1934_94##5	a_1266_119##4	9.61427e-19
C157	a_856_304##6	a_714_127##3	2.83569e-17
C158	a_1266_119##9	a_1598_93##5	8.87352e-19
C159	CLK_N#3	VGND#14	1.87915e-17
C160	a_300_74##14	a_507_368##2	1.37734e-19
C161	a_1598_93##5	VPWR#13	1.30257e-17
C162	a_714_127##3	VPWR#15	2.86638e-18
C163	a_507_368##10	a_714_127##7	8.21962e-19
C164	a_856_304##3	RESET_B#6	2.81948e-17
C165	a_300_74##6	a_33_74##5	8.55445e-18
C166	VGND#7	CLK_N#3	2.54396e-18
C167	VPWR#4	a_1598_93##5	7.75812e-18
C168	a_714_127##8	VPWR#7	5.15171e-18
C169	a_33_74##4	a_300_74##8	1.22936e-19
C170	VGND#14	a_507_368##2	1.12784e-19
C171	a_300_74##14	RESET_B#1	2.50576e-18
C172	VGND#3	a_1934_94##5	1.84504e-18
C173	a_714_127##7	a_300_74##9	1.94074e-19
C174	a_33_74##2	a_507_368##3	7.14911e-20
C175	a_1266_119##3	RESET_B#7	1.07236e-17
C176	a_33_74##2	a_300_74##12	8.81041e-17
C177	VGND#14	a_300_74##14	4.58813e-17
C178	a_856_304##6	RESET_B#5	4.16582e-19
C179	a_300_74##6	VGND#13	1.37324e-19
C180	a_856_304##6	a_300_74##2	6.18831e-21
C181	a_1266_119##3	a_1598_93#	1.36122e-19
C182	RESET_B#1	VGND#14	1.6081e-17
C183	VGND#6	RESET_B#4	3.24871e-18
C184	a_33_74##3	VPWR#18	4.04987e-17
C185	a_300_74##4	a_856_304##2	7.11235e-19
C186	VPWR#8	a_300_74##3	1.15863e-19
C187	a_33_74##5	CLK_N#2	1.30214e-19
C188	a_507_368##3	a_856_304##3	4.78638e-17
C189	a_33_74##4	CLK_N#3	4.008e-18
C190	a_1934_94##5	a_1266_119##2	7.79357e-20
C191	a_300_74##14	D#1	2.12765e-19
C192	a_714_127##7	VPWR#7	1.64541e-18
C193	VGND#6	a_856_304#	2.19791e-18
C194	a_507_368##9	a_714_127##7	3.77974e-19
C195	VPWR#4	a_1934_94#	2.82358e-18
C196	RESET_B#17	RESET_B#16	1.48755e-17
C197	a_1598_93#	RESET_B#8	1.13141e-17
C198	a_33_74##6	VPWR#18	3.60455e-17
C199	a_1934_94##5	Q#3	1.8019e-18
C200	a_33_74##2	a_300_74##7	1.06234e-18
C201	VGND#6	a_300_74##3	6.05039e-18
C202	VGND#7	RESET_B#1	4.44031e-19
C203	a_33_74##4	a_300_74##6	2.9177e-19
C204	VPWR#4	a_1266_119#	7.51329e-18
C205	VGND#14	D#1	3.2314e-18
C206	CLK_N#2	a_300_74##14	5.12953e-18
C207	a_33_74##4	RESET_B#1	1.18068e-17
C208	a_300_74##7	a_507_368##3	2.85856e-17
C209	VPWR#4	a_1266_119##6	2.09264e-18
C210	VPWR#11	VPWR#18	1.77567e-18
C211	a_33_74##3	a_300_74##9	8.30847e-19
C212	VPWR#16	a_856_304##2	8.7795e-19
C213	VGND#3	a_1266_119#	3.46616e-19
C214	VGND#6	a_300_74##8	7.782e-18
C215	VGND#3	a_1266_119##9	2.84475e-18
C216	a_1266_119##10	a_1266_119##12	3.05151e-19
C217	a_33_74##4	a_300_74##14	6.05403e-18
C218	VPWR#4	RESET_B#9	2.13123e-18
C219	a_33_74##4	CLK_N#2	4.36236e-19
C220	a_1266_119##9	a_1550_119#	5.06096e-21
C221	VPWR#4	RESET_B#16	5.22175e-19
C222	VGND#6	CLK_N#3	2.77979e-19
C223	a_33_74##2	a_300_74##9	3.71167e-17
C224	a_714_127##6	VPWR#7	2.39011e-19
C225	a_1598_93##5	VPWR#14	1.98176e-18
C226	a_300_74##14	RESET_B#2	1.56873e-19
C227	a_1934_94##5	VGND#10	5.87627e-18
C228	a_300_74##4	a_507_368##4	4.10576e-17
C229	VPWR#11	a_33_74##6	3.4797e-17
C230	a_33_74##4	D#1	2.86144e-17
C231	VPWR#4	a_1598_93##3	1.24524e-18
C232	VGND#14	RESET_B#2	5.15563e-18
C233	a_300_74##9	a_300_74##7	1.32248e-17
C234	VGND#6	RESET_B#1	2.41091e-18
C235	a_507_368##5	a_300_74##10	9.83647e-18
C236	a_33_74##3	VPWR#11	9.41171e-19
C237	VPWR#10	VPWR#17	3.16397e-19
C238	VGND#6	VGND#7	8.1146e-17
C239	a_33_74##4	VGND#14	2.44273e-17
C240	a_33_74##3	CLK_N#1	3.35702e-17
C241	a_507_368##13	a_856_304##2	7.16273e-20
C242	VGND#6	D#1	2.16439e-18
C243	CLK_N#4	a_300_74##12	7.42039e-18
C244	a_33_74##4	RESET_B#2	2.35237e-17
C245	a_507_368##6	a_1598_93#	3.94904e-18
C246	VGND#5	a_507_368##9	2.18499e-17
C247	a_507_368##4	a_714_127##8	1.02585e-17
C248	VGND#6	VGND#5	1.45262e-16
C249	VPWR#3	a_1934_94#	3.62897e-19
C250	a_300_74##14	D#2	8.67334e-19
C251	a_507_368##6	a_507_368##5	1.67725e-18
C252	a_1598_93##4	a_1266_119##4	2.95464e-17
C253	a_33_74##2	CLK_N#1	8.83944e-19
C254	a_714_127##6	VPWR#6	5.05483e-19
C255	a_507_368##4	a_33_74#	2.23441e-17
C256	CLK_N#1	a_300_74##9	5.87912e-18
C257	VGND#3	RESET_B#16	5.40485e-19
C258	a_507_368##6	a_300_74##2	5.98631e-17
C259	VGND#10	Q#3	5.6814e-17
C260	a_33_74##4	D#2	2.0346e-17
C261	a_507_368##6	a_714_127##4	9.05908e-18
C262	a_33_74##3	RESET_B#3	2.06327e-17
C263	VPWR#5	a_1266_119#	2.00558e-20
C264	a_507_368##6	RESET_B#4	1.2035e-18
C265	RESET_B#3	CLK_N#1	3.18545e-17
C266	a_507_368##2	a_300_74##4	2.78208e-18
C267	a_33_74##3	VPWR#10	1.54524e-18
C268	a_1598_93##4	a_1266_119##2	8.26622e-20
C269	a_33_74##2	RESET_B#3	1.3384e-19
C270	VGND#5	a_1266_119##10	1.06619e-18
C271	a_507_368##6	a_856_304#	1.28976e-19
C272	VPWR#3	a_1266_119#	1.37599e-18
C273	RESET_B#16	a_1598_93##5	8.16155e-19
C274	a_1934_94#	Q#1	1.16459e-17
C275	a_507_368##9	a_300_74##2	9.93564e-19
C276	a_507_368##6	a_300_74##3	1.93581e-19
C277	a_300_74##2	a_714_127##3	2.58149e-18
C278	a_1266_119##12	a_1598_93##5	1.1508e-18
C279	a_1266_119##4	a_1266_119##2	3.73705e-18
C280	a_1598_93##4	a_1934_94##5	4.93262e-17
C281	a_33_74##3	D#3	1.8132e-17
C282	D#3	RESET_B#3	3.73287e-17
C283	a_1598_93##5	a_1266_119##4	8.72192e-19
C284	a_1266_119##7	a_1934_94##3	2.78004e-17
C285	a_1934_94##7	a_1266_119##4	7.09904e-19
C286	a_1934_94#	VPWR#12	2.3604e-17
C287	a_1266_119##4	a_1934_94#	5.05153e-20
C288	VPWR#4	a_1266_119##4	6.31309e-19
C289	VGND#4	a_1266_119##10	2.30664e-17
C290	VPWR#5	a_1266_119##6	4.78158e-19
C291	a_856_304##5	a_714_127##6	2.24993e-18
C292	a_856_304##5	a_507_368##5	2.85915e-19
C293	VPWR#8	a_714_127#	7.72307e-19
C294	a_33_74##2	a_507_368##10	2.8204e-17
C295	RESET_B#5	a_714_127##4	1.33043e-18
C296	a_33_74##2	VPWR#10	1.51545e-18
C297	VPWR#4	a_1266_119##2	7.2803e-19
C298	a_1934_94##7	a_1934_94#	1.81783e-18
C299	a_1934_94##6	VGND#10	4.42184e-17
C300	a_1266_119##2	a_1934_94#	4.25461e-19
C301	a_300_74##6	a_300_74##5	4.15134e-19
C302	a_507_368##9	a_714_127##4	5.13556e-18
C303	VPWR#3	a_1266_119##6	4.51949e-18
C304	a_1934_94##7	a_1266_119##2	3.56486e-19
C305	a_1266_119#	VPWR#12	2.62117e-17
C306	VGND#4	a_1266_119##3	3.02633e-19
C307	a_507_368##9	a_922_127#	1.19506e-18
C308	a_856_304#	RESET_B#5	1.51054e-18
C309	a_300_74##12	CLK_N#2	2.24577e-18
C310	VPWR#13	a_1934_94#	2.52116e-19
C311	a_856_304##2	a_714_127##4	8.47688e-20
C312	a_1598_93##5	a_1266_119##2	3.97249e-17
C313	a_714_127##8	a_300_74##3	2.96842e-19
C314	a_1266_119##5	a_1266_119##7	3.75367e-18
C315	a_1934_94##5	a_1934_94##2	3.99644e-19
C316	a_300_74##3	RESET_B#5	9.53563e-19
C317	a_856_304##2	RESET_B#4	9.14375e-18
C318	a_856_304##5	a_300_74##2	3.29451e-17
C319	a_1934_94##7	a_1266_119#	7.36001e-17
C320	VPWR#8	a_507_368##3	4.36455e-20
C321	a_1598_93##2	RESET_B#9	1.72022e-17
C322	VPWR#5	RESET_B#9	6.41325e-18
C323	a_33_74##2	VPWR#9	7.46302e-18
C324	RESET_B#15	a_507_368##10	1.8585e-17
C325	a_856_304##2	a_856_304#	5.46148e-18
C326	VPWR#12	a_1266_119##6	5.1587e-19
C327	a_300_74##12	RESET_B#2	1.66799e-18
C328	VPWR#8	a_300_74##7	8.7586e-18
C329	a_33_74##6	VPWR#10	1.36807e-17
C330	a_507_368##9	RESET_B#4	2.27773e-17
C331	a_1266_119##12	a_1547_508#	2.04706e-18
C332	a_300_74##3	a_856_304##2	1.96247e-17
C333	a_1266_119##9	RESET_B#16	2.3165e-17
C334	VPWR#13	a_1266_119#	1.36692e-18
C335	a_1266_119##4	a_1266_119#	1.80186e-19
C336	RESET_B#2	VPWR#18	6.51794e-19
C337	RESET_B#15	a_507_368##9	1.43207e-17
C338	VGND#3	a_1266_119##4	3.38947e-18
C339	VPWR#3	RESET_B#9	4.27213e-19
C340	a_714_127##7	a_300_74##5	2.5458e-20
C341	VGND#6	a_300_74##7	2.82834e-19
C342	a_1934_94##7	a_1266_119##6	3.64583e-18
C343	a_300_74##10	a_1598_93##3	7.00203e-19
C344	a_1598_93##5	a_1934_94##2	8.663e-20
C345	RESET_B#17	VPWR#4	3.22536e-17
C346	VGND#3	a_1266_119##2	7.3166e-19
C347	a_1598_93##7	a_1266_119#	2.12886e-20
C348	a_300_74##12	D#2	8.05101e-19
C349	a_714_127##7	a_714_127##6	1.82227e-18
C350	a_300_74##3	a_507_368##4	1.25257e-17
C351	a_1266_119##2	a_1266_119#	1.34453e-18
C352	a_856_304##5	a_714_127##4	4.05914e-17
C353	a_33_74##5	a_33_74##2	3.65539e-19
C354	a_1598_93##4	a_1934_94##6	4.56537e-17
C355	RESET_B#7	a_1266_119##5	3.44531e-17
C356	VGND#3	RESET_B#17	3.1283e-17
C357	VPWR#9	a_300_74##5	1.11994e-19
C358	VPWR#13	a_1266_119##2	4.01522e-18
C359	a_1266_119##10	a_1550_119#	1.25415e-18
C360	a_1598_93##4	a_1598_93##5	1.58864e-18
C361	VPWR#13	a_1266_119##6	9.10877e-18
C362	VPWR#5	a_300_74##10	4.9419e-19
C363	a_507_368##7	a_300_74##10	2.80476e-17
C364	VPWR#14	a_1266_119#	1.01687e-19
C365	VPWR#5	a_1598_93##3	6.93995e-18
C366	a_507_368##9	a_856_304#	2.0932e-17
C367	a_507_368##2	a_300_74##3	1.59764e-17
C368	VPWR#11	D#2	1.14655e-18
C369	RESET_B#15	a_856_304##5	2.34237e-17
C370	VPWR#8	D#3	3.89861e-18
C371	a_300_74##10	a_714_127#	4.5457e-19
C372	VPWR#11	VPWR#10	1.41949e-18
C373	a_1598_93##7	a_1266_119##6	2.82547e-17
C374	a_714_127##6	a_300_74##2	3.77838e-20
C375	a_714_127##7	a_300_74##4	5.13309e-19
C376	a_507_368##9	a_850_127#	4.63628e-19
C377	RESET_B#15	VPWR#4	8.86047e-19
C378	VPWR#3	a_1598_93##3	1.43756e-19
C379	a_1934_94##7	VPWR#12	7.67987e-17
C380	a_1266_119##3	a_1598_93##5	5.34518e-17
C381	VPWR#13	RESET_B#9	2.41249e-19
C382	a_300_74##8	a_507_368##2	1.08488e-17
C383	VGND#11	VGND#10	2.61495e-18
C384	a_507_368##10	a_300_74##3	7.60868e-18
C385	a_1266_119##9	a_1266_119##4	7.15821e-20
C386	a_856_304##5	RESET_B#4	1.19278e-18
C387	VPWR#14	a_1266_119##6	7.44052e-19
C388	a_1934_94##5	a_1934_94#	3.42125e-19
C389	CLK_N#3	a_507_368##2	8.89643e-19
C390	VGND#3	RESET_B#15	9.54537e-19
C391	RESET_B#15	a_714_127##7	4.13294e-17
C392	a_300_74#	a_507_368##7	2.43151e-17
C393	a_1598_93#	RESET_B#7	1.99467e-17
C394	VPWR#6	a_507_368##6	1.28123e-20
C395	VPWR#8	a_507_368##10	2.7315e-18
C396	a_1598_93##7	RESET_B#9	2.4677e-17
C397	VPWR#9	a_300_74##4	4.41084e-20
C398	a_300_74##6	a_300_74##8	9.65134e-19
C399	a_507_368##9	a_300_74##3	4.15524e-17
C400	VPWR#5	a_507_368##6	2.10763e-19
C401	a_1266_119##9	a_1266_119##3	1.5641e-18
C402	RESET_B#15	a_714_127##6	1.71968e-17
C403	a_714_127##3	a_507_368##7	7.52765e-19
C404	VPWR#5	a_300_74##11	6.33104e-18
C405	VPWR#13	VPWR#12	1.48101e-18
C406	VPWR#13	a_1598_93##3	1.13057e-19
C407	a_300_74##6	CLK_N#3	1.23531e-19
C408	VGND#11	a_1934_94##6	1.97601e-18
C409	VPWR#14	RESET_B#9	9.39577e-18
C410	a_714_127##3	a_714_127#	1.44373e-18
C411	a_1266_119##9	a_1598_93##4	6.16875e-19
C412	CLK_N#2	a_300_74##8	1.69623e-18
C413	a_507_368##10	a_507_368#	6.38797e-18
C414	a_856_304##5	a_856_304#	2.80903e-19
C415	a_1598_93##5	RESET_B#8	4.15526e-17
C416	a_1598_93##7	a_1598_93##3	1.13534e-18
C417	a_1266_119##9	a_1266_119##2	8.08498e-20
C418	RESET_B#15	VPWR#8	6.1485e-17
C419	VPWR#4	a_1934_94##2	4.18319e-18
C420	RESET_B#15	a_300_74##4	6.27986e-18
C421	RESET_B#17	a_1266_119##3	8.33263e-18
C422	RESET_B#5	a_714_127#	2.20733e-18
C423	a_1934_94##5	a_1266_119#	1.79697e-17
C424	VGND#6	a_507_368##10	5.60875e-18
C425	a_507_368##5	a_1598_93#	4.68357e-17
C426	VPWR#13	a_1934_94##7	4.05872e-17
C427	VPWR#6	a_507_368##7	8.07014e-18
C428	VGND#6	RESET_B#15	6.10813e-17
C429	Q#3	a_1934_94##3	3.38805e-17
C430	VGND#3	a_1934_94##2	4.22274e-18
C431	a_507_368##9	a_507_368#	1.08309e-17
C432	VPWR#4	a_1266_119##3	2.73005e-18
C433	VPWR#14	a_1598_93##3	2.58618e-17
C434	a_1598_93##5	a_1934_94#	3.25564e-19
C435	RESET_B#17	RESET_B#8	1.55331e-17
C436	a_1266_119##9	RESET_B#8	3.4124e-18
C437	VGND#6	a_507_368##9	1.0028e-16
C438	VGND#11	a_1598_93##4	1.33956e-17
C439	RESET_B#2	CLK_N#3	3.9353e-18
C440	a_1266_119##3	RESET_B#16	3.28058e-18
C441	a_1266_119##12	RESET_B#9	7.61783e-19
C442	a_1598_93##7	a_300_74##11	9.73164e-21
C443	VGND#3	a_1266_119##3	1.23752e-17
C444	VPWR#4	RESET_B#8	1.01745e-18
C445	VPWR#5	a_507_368##7	1.11057e-19
C446	a_856_304##2	RESET_B#6	7.12328e-19
C447	RESET_B#17	a_1598_93##2	1.58084e-17
C448	a_507_368##10	a_300_74##8	6.31065e-18
C449	a_856_304##5	a_300_74##3	3.13597e-19
C450	a_1934_94##3	VGND#10	2.2471e-17
C451	VGND#5	a_507_368##6	7.79447e-17
C452	VGND#14	a_33_74##3	4.52154e-19
C453	a_1598_93##7	a_1934_94##7	1.67198e-18
C454	VGND#3	RESET_B#8	1.16112e-18
C455	VPWR#8	a_714_127##7	3.61006e-18
C456	a_1598_93##5	a_1598_93##2	2.29944e-19
C457	VPWR#4	a_1598_93##2	3.25224e-18
C458	VPWR#14	a_300_74##11	2.85189e-18
C459	VPWR#7	a_714_127#	3.08806e-19
C460	RESET_B#9	a_1266_119##2	5.75216e-18
C461	RESET_B#17	a_300_74##10	3.7121e-17
C462	a_507_368##6	VGND#4	4.75327e-18
C463	D#2	RESET_B#1	9.58492e-18
C464	Q#3	a_1266_119##7	3.04827e-18
C465	a_1266_119##12	a_1598_93##3	6.35508e-18
C466	a_1598_93##5	VPWR#5	6.53738e-19
C467	VGND#7	a_33_74##5	2.60485e-17
C468	a_300_74##2	a_507_368##5	2.01902e-18
C469	VPWR#8	a_714_127##6	5.20709e-18
C470	a_507_368##9	a_300_74##8	3.72161e-19
C471	VGND#6	a_856_304##5	9.99487e-18
C472	VPWR#4	a_300_74##10	4.96999e-18
C473	a_507_368##4	a_856_304##3	1.82214e-18
C474	RESET_B#17	a_507_368##6	2.50945e-17
C475	a_1934_94##6	a_1934_94##3	8.03006e-19
C476	a_1598_93##5	a_1266_119#	9.59221e-19
C477	VPWR#6	a_714_127#	1.63333e-18
C478	VPWR#6	a_714_127##3	1.73943e-19
C479	a_1266_119##9	a_1598_93##2	2.37906e-17
C480	RESET_B#16	RESET_B#8	5.23791e-18
C481	VGND#3	a_300_74##10	1.81887e-18
C482	a_1598_93##7	VPWR#13	3.63334e-17
C483	a_856_304##6	a_1598_93##3	3.94723e-19
C484	a_33_74##2	a_714_127##7	1.36048e-18
C485	a_1266_119##7	VGND#10	2.52333e-17
C486	VPWR#14	a_507_368##7	6.61093e-19
C487	a_1266_119##5	a_1736_119#	9.87534e-18
C488	RESET_B#17	a_300_74#	9.0357e-18
C489	a_507_368##4	a_300_74##7	2.80586e-17
C490	a_714_127##7	a_300_74##3	1.99891e-18
C491	a_300_74##5	a_300_74##4	3.63578e-18
C492	RESET_B#17	a_1598_93##4	8.78915e-19
C493	a_1266_119##12	a_300_74##11	4.05927e-17
C494	RESET_B#7	a_1736_119#	9.87534e-18
C495	VGND#11	a_1266_119##9	2.35148e-17
C496	VGND#3	a_507_368##6	4.45384e-18
C497	VPWR#4	a_300_74#	2.24855e-18
C498	VGND#5	a_300_74#	3.45065e-20
C499	VPWR#3	a_1266_119##4	2.68793e-19
C500	a_1598_93##5	a_300_74##10	2.10141e-19
C501	a_1266_119##10	a_1598_93##4	8.92959e-19
C502	VPWR#8	a_33_74##3	8.89502e-18
C503	RESET_B#15	a_507_368##6	8.68368e-18
C504	RESET_B#7	a_1266_119##4	9.58906e-18
C505	VGND#3	a_300_74#	7.94024e-20
C506	VPWR#7	RESET_B#6	4.82948e-18
C507	a_1934_94##6	a_1266_119##7	4.05101e-17
C508	VPWR#14	VPWR#13	1.32052e-18
C509	a_856_304##6	a_300_74##11	1.53867e-18
C510	a_300_74##2	a_714_127##4	5.32325e-17
C511	a_1598_93##5	VPWR#3	1.24794e-18
C512	a_507_368##9	CLK_N#3	9.96656e-20
C513	Q	a_1266_119##4	1.12854e-19
C514	a_714_127##6	a_300_74##3	7.27834e-20
C515	Q	a_1266_119##2	9.95327e-20
C516	VPWR#7	RESET_B#5	2.38658e-20
C517	a_33_74##2	VPWR#8	1.92472e-17
C518	RESET_B#15	a_300_74#	3.22791e-17
C519	a_1598_93##5	a_1266_119##6	3.69836e-18
C520	RESET_B#17	VGND#11	4.94095e-18
C521	a_1266_119##12	a_507_368##7	3.92921e-17
C522	RESET_B#16	a_1598_93##2	2.18989e-17
C523	a_300_74##10	a_1266_119##9	4.41634e-17
C524	VGND#10	a_1266_119##5	7.21176e-19
C525	a_1266_119##3	RESET_B#8	5.89917e-17
C526	VGND#3	Q#3	1.92201e-17
C527	VPWR#6	RESET_B#5	2.50591e-20
C528	VPWR#15	a_300_74##11	3.26051e-19
C529	a_300_74##6	a_300_74##9	5.55115e-19
C530	RESET_B#15	a_714_127##3	3.16397e-17
C531	a_1598_93##4	a_1266_119##7	1.1797e-18
C532	VGND#6	a_507_368##6	4.43983e-17
C533	a_300_74##6	CLK_N#1	1.96091e-18
C534	a_507_368##7	a_856_304##6	3.84537e-17
C535	VPWR#8	a_300_74#	1.14829e-18
C536	VPWR#14	a_1598_93##7	3.54828e-17
C537	RESET_B#15	RESET_B#5	2.67898e-17
C538	a_1598_93#	a_1550_119#	6.74405e-19
C539	a_1598_93##2	RESET_B#8	4.09852e-17
C540	a_1934_94##6	a_1266_119##5	1.60631e-18
C541	VGND#11	a_1934_94##3	8.49853e-19
C542	VGND#5	a_714_127##3	2.11435e-19
C543	VPWR#8	a_300_74##4	6.76279e-20
C544	VPWR#3	a_1266_119##2	4.25115e-19
C545	VGND#6	a_300_74#	2.52746e-18
C546	RESET_B#17	a_1266_119##10	7.35731e-18
C547	a_1266_119##12	a_714_127#	1.09674e-19
C548	VGND#3	a_1934_94##6	1.3422e-17
C549	a_1598_93##3	a_1547_508#	6.0855e-18
C550	a_507_368##5	a_1550_119#	7.47675e-18
C551	RESET_B#4	a_714_127##4	5.21695e-18
C552	VPWR#15	a_507_368##7	1.87879e-18
C553	a_300_74##11	a_1547_508#	8.32893e-18
C554	RESET_B#15	a_856_304##2	4.90052e-17
C555	a_1266_119##3	a_507_368##6	3.83064e-19
C556	VGND#10	RESET_B#7	1.42328e-19
C557	VPWR#7	a_856_304##3	6.63844e-18
C558	VGND#6	a_714_127##3	1.78137e-18
C559	VGND#7	VGND#13	5.86334e-18
C560	VGND#3	a_1598_93##4	3.27241e-17
C561	VPWR#8	RESET_B#5	2.2763e-18
C562	RESET_B#16	a_300_74##10	8.35359e-19
C563	a_1598_93##5	RESET_B#9	1.40469e-17
C564	a_856_304##6	a_714_127#	4.91525e-17
C565	a_507_368##6	a_1266_119##9	2.53979e-17
C566	VPWR#10	VPWR#9	8.97684e-19
C567	a_300_74##10	a_1598_93##2	4.17617e-17
C568	VPWR#8	CLK_N#4	5.61486e-19
C569	RESET_B#2	CLK_N#1	1.61849e-17
C570	a_1598_93##4	a_1266_119##5	3.30998e-17
C571	a_300_74##14	CLK_N#4	1.15342e-17
C572	RESET_B#15	a_507_368##4	2.04394e-17
C573	a_1266_119##10	VGND#11	2.44338e-17
C574	VGND#6	RESET_B#5	9.55262e-19
C575	VPWR#8	a_856_304##2	1.49319e-18
C576	a_300_74##3	a_300_74##2	1.4363e-19
C577	a_507_368##6	a_1598_93##2	8.42475e-19
C578	a_1934_94##6	RESET_B#7	1.87173e-19
C579	VGND#11	a_1266_119##7	1.71899e-18
C580	VPWR#15	a_714_127#	5.50889e-17
C581	D#3	RESET_B#2	5.1357e-18
C582	RESET_B#15	a_507_368##2	1.15833e-18
C583	VGND#6	a_856_304##2	3.94186e-18
C584	a_507_368##4	VPWR#8	4.81728e-18
C585	a_507_368##6	a_300_74##10	4.77419e-17
C586	a_300_74#	a_1598_93##2	1.22321e-19
C587	a_856_304##6	RESET_B#6	4.22934e-19
C588	a_1266_119##12	a_1598_93##7	1.23098e-18
C589	a_856_304#	RESET_B#4	4.66158e-17
C590	VGND#6	a_507_368##4	3.05075e-18
C591	a_300_74##3	a_714_127##4	2.03528e-19
C592	a_714_127##9	a_714_127#	9.49675e-19
C593	VGND#6	a_300_74##5	6.25642e-22
C594	a_856_304##3	a_817_508#	9.87534e-18
C595	a_1598_93##4	RESET_B#7	3.3935e-18
C596	VGND#6	CLK_N#4	1.71413e-18
C597	a_507_368##3	a_817_508#	9.87534e-18
C598	RESET_B#16	a_507_368##6	8.40582e-20
C599	VPWR#7	a_507_368##3	2.35982e-18
C600	VGND#6	a_507_368##2	6.20745e-17
C601	a_300_74#	a_507_368##6	7.5485e-17
C602	VGND#7	a_300_74##14	4.76158e-17
C603	VPWR#15	RESET_B#6	3.24965e-18
C604	RESET_B#4	a_922_127#	6.53546e-18
C605	a_300_74##10	a_714_127##3	2.18e-20
C606	a_1598_93##5	a_1598_93##3	1.10777e-19
C607	a_300_74#	a_1266_119##9	2.75848e-18
C608	VGND#6	a_300_74##4	1.03309e-19
C609	VGND#11	a_1266_119##5	4.62748e-18
C610	a_856_304#	a_922_127#	6.53546e-18
C611	VGND#3	a_1266_119##10	3.47647e-17
C612	VPWR#16	a_714_127#	5.89667e-19
C613	a_300_74##3	RESET_B#4	1.93556e-17
C614	a_507_368##6	a_714_127##3	9.0208e-20
C615	VGND#6	a_300_74##6	1.42119e-19
C616	a_1266_119##12	VPWR#14	1.89261e-17
C617	a_714_127##9	RESET_B#6	3.43629e-17
C618	a_714_127##3	a_300_74#	3.52508e-17
C619	VPWR#15	a_856_304##3	3.88263e-19
C620	a_1598_93##4	a_1598_93#	5.03981e-19
C621	VPWR#8	RESET_B#2	1.95341e-18
C622	a_33_74##3	a_33_74##2	2.66876e-18
C623	a_300_74##3	a_856_304#	6.85525e-17
C624	a_1266_119##4	a_1934_94##2	2.31239e-18
C625	VGND#5	a_856_304##2	5.78737e-19
C626	VPWR#16	RESET_B#6	9.92441e-18
C627	a_33_74##2	a_300_74##5	1.92438e-17
C628	VGND#6	RESET_B#2	2.82933e-18
C629	VGND#11	RESET_B#7	3.11334e-17
C630	RESET_B#5	a_714_127##3	4.81882e-17
C631	RESET_B#15	a_1266_119##10	7.0476e-19
C632	VPWR#8	D#2	3.61917e-19
C633	a_856_304##6	VPWR#14	2.40567e-18
C634	a_714_127##9	a_856_304##3	1.51375e-18
C635	a_1934_94##5	Q	5.56037e-18
C636	a_1598_93##5	a_300_74##11	1.26511e-20
C637	a_856_304#	a_850_127#	6.44707e-18
C638	VGND#14	VGND#7	1.45965e-18
C639	VGND#6	D#2	2.06731e-18
C640	VPWR#7	a_300_74##7	2.80819e-19
C641	a_856_304##2	a_714_127##3	2.14701e-18
C642	a_1266_119##7	a_1266_119#	6.56591e-18
C643	a_1266_119##10	a_1266_119##5	8.49636e-20
C644	a_300_74##3	a_850_127#	1.80904e-18
C645	D	a_33_74##3	5.57361e-17
C646	a_856_304##2	RESET_B#5	1.14699e-16
C647	a_714_127##3	a_507_368##4	2.17033e-19
C648	VPWR#16	a_856_304##3	2.51934e-17
C649	a_33_74##2	a_300_74##8	5.86745e-19
C650	a_1598_93##4	a_507_368##5	2.61135e-19
C651	RESET_B#15	VGND#12	1.46992e-18
C652	a_714_127##8	RESET_B#6	4.62932e-19
C653	a_714_127##9	a_507_368##3	2.85357e-19
C654	a_33_74##4	CLK_N#4	5.51531e-18
C655	a_507_368##9	a_507_368##6	1.40688e-18
C656	a_507_368#	a_300_74##3	1.53621e-17
C657	a_33_74##2	a_300_74##4	1.02955e-18
C658	VGND#11	a_1598_93#	2.86973e-17
C659	a_300_74##14	a_300_74##12	1.37563e-18
C660	a_507_368##4	a_856_304##2	2.19954e-17
C661	VPWR#9	a_300_74##9	3.97864e-18
C662	a_1266_119##10	RESET_B#7	1.85047e-19
C663	a_300_74##14	CLK_N	1.48497e-17
C664	VPWR#16	a_507_368##3	3.18731e-18
C665	Q#3	a_1934_94##2	2.61963e-17
C666	a_714_127##8	a_856_304##3	5.06531e-18
C667	a_300_74##8	a_300_74##3	3.18954e-19
C668	a_1266_119##3	a_1266_119##4	2.60384e-17
C669	a_856_304##6	a_1266_119##12	3.62936e-17
C670	VPWR#7	a_300_74##9	6.06148e-20
C671	VPWR#9	a_300_74##6	7.59273e-20
C672	a_856_304##5	a_856_304##6	2.03062e-18
C673	a_507_368##6	a_856_304##5	1.08475e-16
C674	a_1934_94##2	VGND#10	2.79245e-17
C675	RESET_B#15	a_714_127##10	1.54838e-18
C676	VGND#11	a_507_368##5	4.92035e-18
C677	a_1266_119##3	a_1266_119##2	3.92634e-18
C678	a_300_74##8	a_507_368#	3.33578e-18
C679	VPWR#16	a_300_74##7	6.56702e-19
C680	Q#3	Q	3.83461e-18
C681	VGND#7	a_507_368##2	1.15948e-17
C682	RESET_B#15	a_33_74##5	1.199e-18
C683	a_714_127##8	a_507_368##3	3.40415e-17
C684	VPWR#10	CLK_N#1	4.13067e-18
C685	a_1266_119##10	a_1598_93#	4.99668e-18
C686	VPWR#3	VPWR#12	7.77531e-19
C687	D	a_33_74##4	7.00715e-17
C688	VGND#5	a_507_368##2	7.73707e-20
C689	a_1598_93##4	a_1934_94##2	4.45961e-19
C690	CLK_N#2	a_300_74##6	3.12769e-17
C691	a_33_74#	a_507_368##3	1.25634e-18
C692	VPWR#5	a_507_368##5	3.86332e-20
C693	a_300_74##6	RESET_B#2	1.20601e-19
C694	VPWR#16	a_300_74##9	3.09116e-19
C695	CLK_N	a_300_74##12	7.51767e-18
C696	VPWR#10	CLK_N#2	1.29536e-19
C697	VPWR#17	a_856_304##3	1.74697e-19
C698	a_856_304##5	a_1266_119##9	1.25463e-19
C699	VGND#11	a_300_74##2	1.44173e-18
C700	a_856_304##5	VPWR#15	9.47483e-19
C701	a_856_304##5	a_300_74#	2.07206e-17
C702	a_714_127##8	a_300_74##7	2.70478e-17
C703	RESET_B#2	CLK_N#2	3.58714e-17
C704	a_300_74##6	D#2	1.54405e-20
C705	D#1	a_120_74#	7.66854e-18
C706	a_1266_119##10	a_507_368##5	2.42227e-17
C707	VPWR#15	a_856_304##6	6.42424e-17
C708	CLK_N#3	a_300_74##8	4.03497e-18
C709	a_507_368##9	a_714_127##3	1.18464e-18
C710	Q	Q#1	5.64751e-18
C711	VPWR#7	VPWR#6	8.95033e-19
C712	VPWR#12	Q	6.54502e-17
C713	a_1934_94##7	Q	3.27933e-18
C714	a_33_74#	a_300_74##7	3.40525e-17
C715	D#2	RESET_B#2	3.58043e-17
C716	a_1266_119##3	a_1598_93##4	7.13874e-17
C717	RESET_B#8	a_1266_119##4	3.68706e-17
C718	VGND#6	VGND#12	1.09806e-17
C719	VGND#7	a_300_74##6	2.84334e-18
C720	VPWR#17	a_507_368##3	2.66993e-19
C721	a_1266_119##4	VNB	5.87803e-17
C722	a_1266_119##2	VNB	4.58602e-17
C723	a_300_74##5	VNB	2.38671e-17
C724	VPWR#10	RESET_B#3	2.5551e-18
C725	a_300_74##4	VNB	6.74875e-17
C726	a_1934_94##7	VPWR#3	8.7309e-18
C727	a_714_127##8	a_300_74##9	4.48239e-19
C728	D	VPWR#11	1.49111e-17
C729	a_1934_94##5	a_1934_94##3	5.25073e-19
C730	RESET_B#8	a_1266_119##2	2.27394e-17
C731	VPWR#4	a_1934_94##7	1.80874e-17
C732	CLK_N	a_300_74##8	8.41653e-20
C733	CLK_N#4	a_33_74##3	6.87206e-19
C734	a_856_304##5	a_714_127##3	6.30914e-17
C735	a_714_127##6	a_856_304##6	2.97071e-17
C736	VGND#11	a_1266_119##3	9.9345e-18
C737	a_300_74##2	a_1266_119##10	9.88705e-18
C738	a_33_74#	a_300_74##9	5.27294e-18
C739	RESET_B#17	VPWR#14	4.04844e-18
C740	VPWR#17	a_300_74##7	2.16495e-18
C741	RESET_B#1	CLK_N#3	2.56096e-17
C742	a_507_368##9	RESET_B#5	7.07267e-19
C743	VGND#4	RESET_B#7	9.30721e-19
C744	a_300_74##9	a_507_368##13	2.19366e-17
C745	VGND#6	a_714_127##10	5.81152e-18
C746	a_714_127##7	a_714_127##3	1.11137e-18
C747	a_1598_93##7	VPWR#4	3.39159e-17
C748	a_714_127##9	VPWR#15	5.07646e-17
C749	a_300_74##2	a_856_304##8	1.4593e-17
C750	a_33_74#	CLK_N#1	4.41005e-19
C751	VPWR#10	VNB	3.68669e-17
C752	VGND#7	CLK_N#2	9.8081e-20
C753	VGND#6	a_33_74##5	2.36767e-17
C754	VPWR#9	VNB	3.80751e-17
C755	VPWR#7	VNB	3.72839e-17
C756	VPWR#6	VNB	5.73828e-17
C757	VPWR#17	a_300_74##9	5.47622e-17
C758	VPWR#5	VNB	5.20812e-17
C759	RESET_B#17	a_1266_119##12	6.73039e-18
C760	VPWR#3	VNB	2.3085e-17
C761	VGND#11	RESET_B#8	9.03882e-19
C762	a_1934_94##5	a_1266_119##7	2.46473e-17
C763	VGND#7	VNB	4.12683e-17
C764	VGND#5	VNB	6.5912e-17
C765	VGND#4	VNB	6.87785e-17
C766	a_856_304##5	RESET_B#5	1.08661e-17
C767	a_714_127##6	VPWR#15	2.66928e-17
C768	a_1934_94##5	VNB	6.63403e-18
C769	VGND#12	a_300_74##2	6.34031e-18
C770	a_1598_93##5	VNB	7.59633e-18
C771	a_1266_119##9	VNB	1.20336e-17
C772	a_300_74##12	a_300_74##9	5.54471e-18
C773	D#1	RESET_B#1	3.32389e-17
C774	Q	a_1934_94#	3.63934e-17
C775	VPWR#16	VPWR#15	2.57797e-18
C776	Q	a_1266_119#	5.05274e-18
C777	RESET_B#16	VNB	1.28907e-18
C778	a_507_368##9	a_856_304##2	5.81056e-17
C779	a_507_368##10	VNB	5.92853e-18
C780	a_714_127##4	a_856_304##8	1.5323e-17
C781	a_507_368##9	VNB	1.20429e-17
C782	VPWR#17	CLK_N#1	6.42529e-18
C783	a_714_127##7	RESET_B#5	9.85512e-20
C784	a_856_304##5	VNB	6.56767e-18
C785	VGND#4	a_1598_93#	2.3626e-18
C786	VPWR#4	a_1266_119##12	3.50268e-17
C787	a_714_127##7	VNB	6.13058e-18
C788	a_714_127##6	VNB	1.01817e-17
C789	VPWR#18	a_300_74##9	1.8715e-18
C790	D	D#3	7.64998e-18
C791	VGND#7	a_300_74##5	8.02909e-20
C792	a_33_74##3	VNB	1.66272e-17
C793	a_33_74##2	VNB	4.65568e-18
C794	VGND#6	a_300_74##14	2.56777e-17
C795	a_714_127##6	RESET_B#5	3.93117e-17
C796	VGND#11	a_1598_93##2	6.04887e-19
C797	CLK_N#4	VNB	5.48936e-19
C798	VGND#6	CLK_N	6.4301e-19
C799	a_300_74##12	CLK_N#1	4.11904e-17
C800	Q#3	VNB	4.90948e-17
C801	VGND#10	VNB	7.96544e-18
C802	VPWR#4	a_856_304##6	4.71934e-18
C803	a_1934_94##6	VNB	5.1748e-19
C804	a_1598_93##4	VNB	1.7147e-17
C805	VPWR#16	a_714_127##9	4.05901e-17
C806	VGND#11	VNB	8.34981e-18
C807	a_33_74##6	a_300_74##9	5.21938e-19
C808	a_714_127##4	VGND#12	1.26368e-17
C809	a_856_304##2	a_856_304##5	1.27952e-18
C810	VGND#4	a_1266_119##9	3.31807e-19
C811	VPWR#8	D	4.72338e-18
C812	VGND#12	VNB	6.11536e-18
C813	VGND#6	D	6.77727e-18
C814	a_507_368##10	a_507_368##4	1.88366e-17
C815	a_714_127##10	VNB	1.90118e-18
C816	a_33_74##5	VNB	6.09764e-18
C817	VPWR#4	Q	2.0669e-17
C818	VGND#3	Q	1.01834e-18
C819	a_300_74##14	VNB	1.21111e-17
C820	VPWR#18	CLK_N#1	3.59942e-17
C821	VGND#14	VNB	3.96131e-18
C822	a_33_74##4	VNB	3.29444e-17
C823	a_714_127##7	VPWR#16	3.12748e-18
C824	VPWR#12	VNB	3.78157e-18
C825	a_1934_94##7	VNB	1.00134e-17
C826	a_507_368##9	a_507_368##4	5.46134e-20
C827	VPWR#13	VNB	8.04819e-18
C828	a_1598_93##7	VNB	2.82088e-18
C829	VPWR#14	VNB	1.53734e-18
C830	a_1266_119##12	VNB	3.71604e-18
C831	a_1934_94##2	Q	2.61724e-17
C832	a_300_74##12	RESET_B#3	7.0388e-19
C833	a_507_368##10	a_507_368##13	4.35052e-18
C834	a_856_304##6	VNB	7.08181e-18
C835	a_714_127##7	a_856_304##2	6.39949e-17
C836	VPWR#15	VNB	6.94771e-18
C837	a_714_127##9	VNB	9.92102e-18
C838	VPWR#16	VNB	1.90374e-18
C839	a_714_127##8	VNB	4.59079e-18
C840	VGND#6	a_33_74##4	2.62402e-17
C841	a_33_74##6	CLK_N#1	1.64908e-18
C842	a_33_74#	VNB	9.72033e-18
C843	a_33_74##5	a_300_74##5	1.30026e-18
C844	a_507_368##13	VNB	2.45254e-19
C845	VPWR#17	VNB	2.13722e-18
C846	CLK_N	a_300_74##6	3.77531e-17
C847	a_300_74##12	VNB	7.76136e-18
C848	VPWR#18	VNB	6.35096e-19
C849	VGND#4	a_507_368##5	4.52151e-18
C850	a_856_304##2	a_714_127##6	1.55182e-17
C851	a_33_74##6	VNB	2.67182e-18
C852	CLK_N	CLK_N#2	6.08973e-18
C853	VPWR#11	VNB	5.50308e-17
C854	a_1934_94##3	VNB	3.3952e-17
C855	a_1266_119##7	VNB	6.36988e-17
C856	a_1266_119##5	VNB	2.50117e-17
C857	RESET_B#4	VGND#12	1.83561e-17
C858	RESET_B#7	VNB	2.55096e-17
C859	RESET_B#3	VPWR#18	1.37928e-17
C860	a_1598_93#	VNB	3.76477e-17
C861	VGND#7	a_300_74##4	1.53826e-20
C862	a_507_368##5	VNB	4.13377e-17
C863	a_300_74##2	VNB	9.89529e-17
C864	a_714_127##4	VNB	2.32603e-17
C865	RESET_B#4	VNB	2.63621e-17
C866	a_856_304#	VNB	1.88989e-17
C867	VPWR#11	CLK_N#1	4.36897e-19
C868	a_300_74##3	VNB	1.30677e-16
C869	D	RESET_B#2	1.81179e-18
C870	a_714_127##6	VPWR#16	1.61761e-17
C871	a_507_368#	VNB	1.95837e-17
C872	a_300_74##8	VNB	3.65322e-17
C873	D	D#2	4.58348e-17
C874	CLK_N#3	VNB	3.70618e-17
C875	RESET_B#1	VNB	3.57258e-17
C876	D#1	VNB	3.08283e-17
C877	a_300_74##12	D#3	6.52634e-19
C878	a_1934_94#	VNB	4.15322e-17
C879	a_1266_119##10	a_300_74##10	2.69852e-18
C880	a_1266_119#	VNB	6.33827e-17
C881	a_507_368##2	a_507_368##10	3.14701e-18
C882	a_1266_119##6	VNB	3.06727e-17
C883	RESET_B#9	VNB	3.56731e-17
C884	a_33_74##6	RESET_B#3	2.69879e-17
C885	a_1598_93##3	VNB	2.14851e-17
C886	a_300_74##11	VNB	2.19995e-17
C887	a_507_368##7	VNB	5.20989e-17
C888	RESET_B#15	a_856_304##6	2.8438e-17
C889	a_714_127#	VNB	3.51781e-17
C890	a_714_127##8	a_714_127##9	2.36591e-18
C891	RESET_B#6	VNB	4.32166e-17
C892	a_856_304##3	VNB	3.01488e-17
C893	VGND#5	a_300_74##2	2.58451e-17
C894	VPWR#14	VPWR#3	8.5834e-19
C895	a_507_368##3	VNB	2.78342e-17
C896	a_300_74##7	VNB	7.08933e-17
C897	a_507_368##9	a_507_368##2	1.60013e-17
C898	a_300_74##9	VNB	4.60812e-17
C899	CLK_N#1	VNB	4.62724e-17
C900	a_33_74##5	a_300_74##4	3.12155e-18
C901	RESET_B#3	VNB	3.60196e-17
C902	VPWR#18	D#3	1.34665e-18
C903	D#3	VNB	6.71164e-17
C904	a_507_368##6	VGND#11	3.60708e-18
C905	a_714_127##7	a_507_368##4	6.34607e-17
C906	RESET_B#17	VNB	3.94526e-18
C907	VPWR#4	VNB	2.21141e-16
C908	VGND#3	VNB	2.45797e-16
C909	RESET_B#15	VNB	1.71344e-17
C910	VPWR#11	RESET_B#3	2.40799e-18
C911	RESET_B#15	VPWR#15	8.18807e-18
C912	VPWR#8	VNB	2.97496e-16
C913	a_714_127##10	a_714_127##4	5.59285e-19
C914	VGND#6	VNB	3.15787e-16
C915	VGND#12	a_856_304#	1.18909e-18
C916	a_1934_94##2	VNB	4.66042e-17
C917	a_1266_119##3	VNB	4.85625e-18
C918	RESET_B#8	VNB	5.52189e-17
C919	a_714_127##6	a_507_368##4	2.25334e-20
C920	a_1598_93##2	VNB	6.1806e-17
C921	a_300_74##10	VNB	8.04175e-17
C922	a_507_368##6	VNB	8.20597e-17
C923	a_300_74#	VNB	2.29856e-17
C924	a_714_127##3	VNB	4.89676e-17
C925	a_33_74##6	D#3	8.574e-18
C926	RESET_B#5	VNB	5.35072e-17
C927	a_856_304##2	VNB	5.78921e-17
C928	a_1266_119##9	a_1266_119##7	7.38577e-20
C929	a_507_368##4	VNB	5.47214e-17
C930	VGND#4	a_300_74##2	6.66173e-19
C931	a_507_368##2	VNB	7.5295e-17
C932	a_300_74##6	VNB	2.63511e-17
C933	VPWR#7	a_300_74##3	3.63435e-19
C934	CLK_N#2	VNB	3.25984e-17
C935	a_1934_94##2	VPWR#12	1.58135e-17
C936	a_714_127##8	VPWR#16	2.08557e-17
C937	RESET_B#2	VNB	5.99959e-17
C938	D#2	VNB	1.10316e-16
C939	a_507_368##6	a_1266_119##10	1.32478e-16
C940	a_1266_119#	a_1934_94#	3.97021e-17
C941	VPWR#11	D#3	3.36469e-17
C942	RESET_B#15	VPWR#16	3.99384e-18
C943	a_300_74##5	a_507_368##11	5.05174e-19
C944	VPWR#5	VPWR#3	7.01212e-19
C945	CLK_N	VNB	4.61538e-18
C946	D	VNB	4.14414e-17
C947	Q	VNB	6.76873e-17
C948	a_1266_119##12	VPWR#6	3.63934e-18
C949	a_714_127##10	RESET_B#4	1.04838e-18
C950	RESET_B#17	VPWR#6	1.44182e-18
C951	VGND#12	a_300_74##3	8.91091e-18
C952	a_507_368##6	VGND#12	3.69975e-17
C953	VGND#5	a_714_127##4	2.18903e-18
C954	VGND#14	RESET_B	1.19471e-17
C955	RESET_B	a_300_74##9	2.23887e-19
C956	RESET_B	VPWR#18	3.25354e-18
C957	VPWR#2	a_1934_94#	1.00904e-17
C958	VGND#8	D	1.06867e-18
C959	VPWR#8	RESET_B	3.72502e-17
C960	RESET_B	CLK_N#4	2.93633e-17
C961	RESET_B	a_300_74##14	2.97497e-18
C962	VGND#8	CLK_N#3	8.37771e-18
C963	RESET_B	a_300_74##12	1.52584e-17
C964	VGND#8	a_300_74##14	9.32648e-18
C965	a_1934_94##7	VPWR#2	8.93283e-18
C966	VGND#2	VNB	6.15042e-17
C967	Q	VPWR#2	2.18653e-17
C968	RESET_B	VPWR#17	3.993e-18
C969	RESET_B	a_300_74##4	3.01753e-18
C970	VGND#4	VGND#2	3.01813e-19
C971	RESET_B	VNB	7.734e-18
C972	RESET_B	a_507_368##13	2.99278e-17
C973	RESET_B	VPWR#9	4.01705e-18
C974	RESET_B	a_300_74##5	5.62633e-19
C975	VGND#2	a_1934_94##2	4.81086e-19
C976	RESET_B	a_33_74##5	3.07746e-18
C977	RESET_B	a_33_74#	7.87228e-19
C978	VGND#8	VNB	6.29096e-17
C979	RESET_B	VPWR#10	1.60703e-18
C980	VGND#8	D#2	9.89721e-19
C981	RESET_B	a_33_74##2	3.82228e-17
C982	RESET_B	a_507_368##10	2.65088e-18
C983	VPWR#2	VNB	4.71988e-17
C984	RESET_B	RESET_B#2	2.24652e-17
C985	RESET_B	a_33_74##3	2.03601e-17
C986	VGND#6	VGND#8	1.17285e-16
C987	VGND#8	RESET_B#2	7.35479e-19
C988	RESET_B	VGND#7	5.63547e-18
C989	VGND#2	a_1266_119##7	5.18969e-18
C990	VGND#3	VGND#2	1.14146e-16
C991	VGND#2	a_1266_119#	6.09273e-19
C992	VGND#2	a_1934_94##3	4.2512e-18
C993	RESET_B	CLK_N#2	1.08644e-17
C994	RESET_B	VGND#8	1.17317e-18
C995	VGND#8	CLK_N#2	9.08157e-20
C996	VPWR#2	a_1266_119##6	3.51821e-19
C997	VPWR#3	VPWR#2	8.55212e-19
C998	VGND#8	a_33_74##4	3.07511e-17
C999	RESET_B	a_300_74##6	4.2431e-17
C1000	RESET_B	D	3.72589e-18
C1001	VPWR#2	a_1266_119##7	6.37928e-19
C1002	VGND#8	VGND#7	1.19385e-18
C1003	RESET_B	a_507_368##2	1.3905e-19
C1004	a_1934_94##5	VPWR#2	3.04965e-19
C1005	RESET_B	CLK_N	8.00039e-18
C1006	VGND#8	D#1	6.15807e-18
C1007	VGND#2	a_1934_94##6	9.29235e-18
C1008	VGND#2	a_1266_119##2	2.92679e-19
C1009	VPWR#2	a_1266_119#	8.04146e-18
C1010	VGND#2	a_1266_119##4	5.89386e-19
C1011	VGND#8	CLK_N#4	5.41575e-19
C1012	RESET_B	CLK_N#1	4.51924e-18
C1013	VGND#2	a_1934_94##5	5.38057e-19
C1014	VGND#8	a_507_368##2	1.50264e-19
C1015	VGND#6	RESET_B	3.98839e-17
C1016	a_1934_94##2	VPWR#2	3.49457e-19
C1017	VGND#2	Q#3	1.6627e-17
C1018	VGND#8	RESET_B#1	9.2555e-18
C1019	VPWR#4	VPWR#2	9.54892e-17
*
*
.ENDS sky130_fd_sc_hs__dfrtn_1
*
