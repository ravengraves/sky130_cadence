* Extracted by Quantus, converted by sky130cad/quantus.py
*
*
*
*                       LINUX           Wed Nov 18 08:06:52 2026
*
*
*
*  PROGRAM  advgen
*
*  Name           : advgen - Quantus - (64-bit)
*  Version        : 25.1.0-p047
*  Build Date     : Thu Dec 11 23:20:30 PST 2025
*
*  HSPICE LIBRARY
*
*  OPERATING_TEMPERATURE 150
*  QRC_TECH_DIR <path>/tech
*
*
*

*
.SUBCKT sky130_fd_sc_hs__a221oi_1 VPB VNB VGND VPWR Y A2 C1 B2 B1 A1
*
*
*  caps2d version: 10
*
*
*       TRANSISTOR CARDS
*
*
XM3 Y#2 C1#1 VGND#7 VNB sky130_fd_pr__nfet_01v8_lvt l=0.15 w=0.74 ad=0.4477 as=0.2886 pd=2.69 ps=2.26
XM5 VGND#7 B2#1 a_351_74# VNB sky130_fd_pr__nfet_01v8_lvt l=0.15 w=0.74 ad=0.2886 as=0.1554 pd=2.26 ps=1.9
XM6 a_351_74# B1#3 Y#1 VNB sky130_fd_pr__nfet_01v8_lvt l=0.15 w=0.74 ad=0.1554 as=0.4218 pd=1.9 ps=2.62
XM2 Y#1 A1#1 a_567_74# VNB sky130_fd_pr__nfet_01v8_lvt l=0.15 w=0.74 ad=0.4218 as=0.1554 pd=2.62 ps=1.9
XM7 a_567_74# A2#3 VGND#6 VNB sky130_fd_pr__nfet_01v8_lvt l=0.15 w=0.74 ad=0.1554 as=0.1961 pd=1.9 ps=2.01
XM8 Y#4 C1#3 a_118_368##2 VPB sky130_fd_pr__pfet_01v8 l=0.15 w=1.12 ad=0.308 as=0.308 pd=2.79 ps=2.79
XM9 a_263_368##3 B2#3 a_118_368# VPB sky130_fd_pr__pfet_01v8 l=0.15 w=1.12 ad=0.308 as=0.336 pd=2.79 ps=2.84
XM1 a_118_368# B1#1 a_263_368##4 VPB sky130_fd_pr__pfet_01v8 l=0.15 w=1.12 ad=0.336 as=0.3696 pd=2.84 ps=2.9
XM0 a_263_368##4 A1#3 VPWR#4 VPB sky130_fd_pr__pfet_01v8 l=0.15 w=1.12 ad=0.3696 as=0.4368 pd=2.9 ps=3.02
XM4 VPWR#4 A2#1 a_263_368# VPB sky130_fd_pr__pfet_01v8 l=0.15 w=1.12 ad=0.4368 as=0.308 pd=3.02 ps=2.79
*
*
*       RESISTOR AND CAP/DIODE CARDS
*
Rg1	C1#1	C1#2	455.703491
Rg2	C1#2	C1#3	461.849823
Rg3	B2#1	B2#2	382.539734
Rg4	B2#2	B2#3	434.639221
Rg5	B1#1	B1#2	434.639221
Rg6	B1#2	B1#3	382.539734
Rg7	A1#1	A1#2	382.539734
Rg8	A1#2	A1#3	434.639221
Rg9	A2#1	A2#2	492.059540
Rg10	A2#2	A2#3	307.937683
Rf1	C1	C1#2	166.137894
Rf2	B2#4	B2	1.409262
Rf3	B2#2	B2#6	161.642059
Rf4	B2#4	B2#6	11.918507
Rf5	B2#7	B2	1.409262
Rf6	B2#6	B2#7	2.750425
Rf7	a_118_368#	a_118_368##2	118.316803
Rf8	B1#2	B1	166.137894
Rf9	Y#1	Y#3	117.301109
Rf10	Y#3	Y	8.350531
Rf11	Y	Y#5	18.674389
Rf12	Y#5	Y	0.255814
Rf13	Y#2	Y#3	3.750000
Rf14	Y#4	Y#5	5.000000
Rf15	A1#2	A1	166.137894
Rf16	a_263_368#	a_263_368##2	83.228302
Rf17	a_263_368##2	a_263_368##3	85.518326
Rf18	a_263_368##2	a_263_368##4	20.631947
Rf19	A2	A2#4	13.766337
Rf20	A2#4	A2	3.176847
Rf22	VGND#2	VGND#3	103.341919
Rf23	VGND#3	VGND#4	34.654106
Rf25	VGND#2	VGND#6	32.026825
Rf26	VGND#4	VGND#7	35.844460
Rf28	VPWR#2	VPWR#3	67.901443
Rf29	VPWR#2	VPWR#4	30.876266
Rf34	A2#2	A2#4	160.232803
Re1	VPWR#3	VPWR	1.227783
Re2	VGND	VGND#3	1.227829
*
*       CAPACITOR CARDS
*
*
C1	VGND	VNB	7.20503e-17
C2	VPWR	VNB	7.9965e-17
C3	Y	VNB	1.43431e-16
C4	A2	VNB	3.35065e-17
C5	C1	VNB	8.11704e-18
C6	VGND	Y	4.27796e-17
C7	B2	VNB	9.17082e-18
C8	B1	VNB	3.97202e-18
C9	VGND	A2	8.22204e-18
C10	A1	VNB	6.10995e-18
C11	VPWR	Y	1.75619e-17
C12	VGND	C1	2.76529e-18
C13	VGND	B2	3.38988e-18
C14	VPWR	A2	6.03457e-18
C15	VGND	B1	2.49498e-18
C16	VPWR	C1	3.53409e-18
C17	VGND#7	VGND#6	6.45603e-19
C18	VGND	A1	5.56048e-18
C19	C1#2	VNB	7.66614e-17
C20	VPWR	B2	5.21947e-18
C21	B2#2	VNB	3.58065e-17
C22	Y	C1	8.449e-17
C23	B1#2	VNB	2.87488e-17
C24	VPWR	B1	2.51368e-18
C25	A1#2	VNB	3.09877e-17
C26	A2#2	VNB	4.8072e-17
C27	Y	B2	3.71488e-17
C28	VPWR	A1	2.51368e-18
C29	VGND#3	VNB	1.98174e-16
C30	VPWR#3	VNB	2.50538e-16
C31	C1#3	VNB	4.10475e-17
C32	B2#3	VNB	3.61541e-17
C33	VGND	B2#2	1.29442e-18
C34	B1#1	VNB	3.11977e-17
C35	A1#3	VNB	2.94424e-17
C36	A2#1	VNB	4.56932e-17
C37	C1	B2	3.21144e-17
C38	VGND	A1#2	4.18992e-19
C39	C1#1	VNB	3.91257e-17
C40	A1	A2	2.7347e-17
C41	VGND	A2#2	9.26042e-19
C42	B2#1	VNB	2.58968e-17
C43	VGND	VGND#3	2.09042e-17
C44	B1#3	VNB	2.6287e-17
C45	A1#1	VNB	2.73676e-17
C46	A2#3	VNB	2.23843e-17
C47	VPWR	B2#2	1.24247e-18
C48	a_118_368##2	VNB	2.5981e-17
C49	B2	B1	3.8217e-17
C50	a_263_368##3	VNB	7.71183e-18
C51	a_118_368#	VNB	3.18151e-18
C52	a_263_368##4	VNB	4.98801e-18
C53	VPWR#4	VNB	4.9532e-18
C54	VPWR	A2#2	8.09849e-19
C55	Y	C1#2	2.67723e-17
C56	a_263_368#	VNB	5.64089e-17
C57	Y	B2#2	2.24937e-17
C58	VGND#7	VNB	1.28835e-18
C59	VPWR	VPWR#3	4.98038e-17
C60	VGND	C1#1	9.51596e-19
C61	Y#1	VNB	1.68868e-17
C62	B1	A1	3.02756e-17
C63	Y	B1#2	2.46055e-19
C64	VGND	B2#1	5.80765e-19
C65	VGND#6	VNB	3.36285e-17
C66	VPWR	C1#3	6.01474e-18
C67	VGND	B1#3	1.2778e-18
C68	VGND	A1#1	1.204e-18
C69	VPWR	B2#3	1.55133e-18
C70	VGND	A2#3	4.68052e-19
C71	A2	B2#2	5.89848e-19
C72	VPWR	B1#1	2.49307e-18
C73	VPWR	A1#3	4.27063e-19
C74	A2	B1#2	1.01739e-18
C75	Y	VPWR#3	1.76955e-17
C76	C1	C1#2	1.87899e-17
C77	VPWR	A2#1	1.01184e-18
C78	A2	A1#2	6.28469e-18
C79	a_263_368##3	a_263_368##2	9.20542e-19
C80	C1	B2#2	2.40372e-20
C81	A2	A2#2	2.06462e-17
C82	Y	C1#3	3.01715e-17
C83	Y#1	VGND#6	2.04403e-17
C84	VGND	a_263_368#	2.99426e-18
C85	Y	B2#3	3.02263e-19
C86	B2	C1#2	1.82682e-17
C87	Y	B1#1	1.09112e-19
C88	VGND	Y#1	2.3836e-17
C89	B2	B2#2	6.59581e-18
C90	VGND	VGND#6	2.23601e-17
C91	VPWR	a_118_368##2	2.80928e-17
C92	B2	B1#2	5.39333e-18
C93	VPWR	a_263_368##3	8.16237e-18
C94	Y	C1#1	4.81517e-17
C95	VPWR	a_118_368#	2.32017e-17
C96	B1	B2#2	3.20999e-18
C97	C1	VPWR#3	3.51086e-19
C98	Y	B2#1	1.06977e-17
C99	VPWR	a_263_368##4	1.39212e-17
C100	VPWR	VPWR#4	2.53437e-17
C101	Y	B1#3	3.82138e-19
C102	B1	B1#2	1.49288e-17
C103	VPWR	a_263_368#	1.74321e-17
C104	Y	A1#1	1.51154e-19
C105	C1	C1#3	4.52946e-18
C106	B1	A1#2	2.99673e-18
C107	a_263_368##2	a_118_368#	1.94146e-17
C108	Y	Y#4	1.55685e-17
C109	C1	B2#3	1.0121e-19
C110	Y	a_118_368##2	8.16059e-17
C111	A2	C1#1	5.75649e-19
C112	A1	B1#2	4.172e-18
C113	A1	A1#2	1.77125e-17
C114	B2	C1#3	1.82045e-19
C115	B2	B2#3	1.39165e-18
C116	A1	A2#2	5.45623e-18
C117	B2	B1#1	5.53135e-19
C118	Y	Y#2	5.02458e-18
C119	VGND#3	A1	6.18455e-20
C120	Y	VGND#7	7.87497e-17
C121	Y	Y#1	2.10558e-18
C122	B1	B2#3	6.65848e-19
C123	VPWR	a_263_368##2	4.05636e-18
C124	a_263_368##2	a_263_368##4	6.27601e-18
C125	B1	B1#1	2.01533e-18
C126	B1	A1#3	7.18161e-19
C127	A2	a_263_368#	2.69529e-17
C128	C1	a_118_368##2	2.605e-17
C129	A1	B1#1	5.56146e-19
C130	A1	A1#3	2.04879e-18
C131	C1#2	B2#2	2.996e-17
C132	A1	A2#1	2.84609e-18
C133	VGND#6	A2	2.62569e-17
C134	a_263_368##2	VPWR#4	2.57843e-17
C135	B2	a_118_368##2	4.32434e-18
C136	B2	a_263_368##3	3.96101e-17
C137	B2#2	B1#2	3.58412e-17
C138	B2#1	a_351_74#	1.49899e-17
C139	B1#2	A1#2	2.84898e-17
C140	a_263_368##2	a_263_368#	9.81904e-19
C141	B1#3	a_351_74#	1.49899e-17
C142	VPWR#3	C1#2	1.52709e-19
C143	Y#1	B2	1.47669e-17
C144	VPWR#3	B2#2	2.49828e-20
C145	VGND#3	B1#2	8.68753e-20
C146	A1#2	A2#2	3.41112e-17
C147	A1#1	a_567_74#	1.50905e-17
C148	VPWR#3	B1#2	2.86597e-20
C149	VGND#3	A1#2	8.00644e-20
C150	Y#1	B1	4.26582e-17
C151	A2#3	a_567_74#	1.596e-17
C152	B2#2	B2#3	6.56806e-19
C153	Y#1	A1	2.18476e-17
C154	Y#1	a_351_74#	2.77486e-18
C155	C1#1	B2#2	3.63634e-18
C156	B1	a_263_368##2	4.15177e-17
C157	VPWR#3	C1#3	5.53017e-18
C158	A1#2	A2#1	2.0245e-18
C159	VPWR#3	B2#3	4.4526e-18
C160	A1	a_263_368##2	3.29247e-17
C161	VPWR#3	B1#1	5.14644e-18
C162	Y#1	a_263_368##2	9.16941e-18
C163	C1#2	a_118_368##2	9.54483e-18
C164	C1#3	B2#3	4.61097e-18
C165	B2#2	a_263_368##3	2.41453e-17
C166	a_118_368#	B2#2	1.88858e-19
C167	B2#3	B1#1	4.62065e-17
C168	VGND#3	B2#1	2.74844e-18
C169	A1#1	A2#2	3.65846e-18
C170	VGND#3	B1#3	5.68253e-18
C171	B1#2	a_263_368##4	3.10657e-19
C172	B1#1	A1#3	4.13578e-17
C173	VGND#7	B2#2	1.06868e-18
C174	A1#3	A2#1	3.1877e-17
C175	A1#2	VPWR#4	1.61108e-18
C176	a_118_368##2	VPWR#3	6.4718e-17
C177	Y#1	B1#2	3.60547e-18
C178	A2#2	a_263_368#	1.24951e-17
C179	a_118_368#	VPWR#3	4.94122e-17
C180	Y#1	A1#2	4.20914e-18
C181	a_263_368##4	VPWR#3	5.25459e-18
C182	a_118_368##2	C1#3	7.71063e-17
C183	a_263_368##3	C1#3	6.52816e-18
C184	a_118_368##2	B2#3	3.89533e-18
C185	Y#1	A2#2	1.06115e-18
C186	a_118_368#	C1#3	4.9045e-19
C187	a_263_368##3	B2#3	7.43814e-17
C188	C1#1	B2#1	2.04383e-17
C189	a_263_368##4	C1#3	4.91073e-20
C190	A2#2	VGND#6	1.98897e-17
C191	VGND#3	Y#1	2.48646e-17
C192	a_118_368#	B2#3	6.08666e-17
C193	VPWR#4	C1#3	1.03884e-19
C194	a_263_368##3	B1#1	4.40347e-19
C195	a_263_368##4	B2#3	4.53763e-19
C196	a_118_368#	B1#1	5.29538e-17
C197	B2#1	B1#3	6.09891e-17
C198	a_263_368##3	A1#3	1.89732e-19
C199	VPWR#4	B2#3	2.42755e-19
C200	B1#1	a_263_368##4	2.85298e-17
C201	a_263_368#	B2#3	2.20816e-19
C202	a_118_368#	A1#3	2.32318e-18
C203	a_263_368##2	B1#2	1.73035e-18
C204	VPWR#4	B1#1	2.27548e-18
C205	A1#3	a_263_368##4	2.4474e-17
C206	B1#3	A1#1	1.3396e-17
C207	a_118_368#	A2#1	8.00324e-19
C208	a_263_368#	B1#1	4.24452e-19
C209	A1#3	VPWR#4	3.73931e-17
C210	a_263_368##2	A1#2	4.09176e-18
C211	a_263_368##4	A2#1	4.76135e-19
C212	a_263_368#	A1#3	1.34786e-18
C213	A2#1	VPWR#4	3.5602e-17
C214	A1#1	A2#3	6.12429e-17
C215	a_263_368#	A2#1	6.13932e-17
C216	a_263_368##2	VPWR#3	6.46838e-19
C217	C1#1	Y#2	1.38554e-17
C218	C1#1	VGND#7	1.94664e-17
C219	a_118_368##2	a_263_368##3	5.30909e-17
C220	VGND#7	B2#1	3.91108e-17
C221	Y#1	C1#1	4.9609e-19
C222	a_118_368##2	a_118_368#	2.28676e-18
C223	a_263_368##2	C1#3	3.35566e-20
C224	VGND#7	B1#3	3.95373e-18
C225	Y#1	B2#1	1.16922e-17
C226	a_118_368#	a_263_368##3	6.99615e-17
C227	VGND#7	A1#1	1.65481e-18
C228	a_263_368##2	B2#3	3.10072e-19
C229	Y#1	B1#3	4.47821e-17
C230	a_263_368##3	a_263_368##4	1.34713e-18
C231	VGND#6	B2#1	1.989e-19
C232	VGND#7	A2#3	1.61261e-19
C233	a_263_368##2	B1#1	1.61184e-17
C234	a_118_368#	a_263_368##4	5.36257e-17
C235	A1#1	Y#1	2.94166e-17
C236	VGND#6	B1#3	3.65012e-18
C237	a_118_368#	VPWR#4	3.77358e-18
C238	Y#1	A2#3	7.64885e-18
C239	a_263_368##2	A1#3	1.79587e-17
C240	VGND#6	A1#1	1.02194e-17
C241	a_263_368##4	VPWR#4	6.14341e-17
C242	a_263_368##2	A2#1	3.25359e-19
C243	VGND#6	A2#3	3.73937e-17
C244	a_263_368##4	a_263_368#	1.43693e-18
C245	a_263_368#	VPWR#4	7.93372e-17
C246	Y#1	a_263_368##3	1.58258e-18
C247	VGND#7	Y#1	1.67514e-17
C248	VGND#2	VNB	5.0143e-17
C249	VGND#4	VNB	6.59278e-17
C250	VGND#4	B1#3	1.31459e-18
C251	VPWR#2	A1#3	9.77087e-19
C252	VGND#4	Y	5.2205e-17
C253	a_263_368##4	VPWR#2	9.16153e-18
C254	VPWR#2	VNB	5.77429e-17
C255	A2	VPWR#2	1.08366e-18
C256	VGND#4	Y#1	2.61918e-19
C257	VPWR#3	VPWR#2	6.37637e-17
C258	VGND#2	A1	1.4271e-18
C259	VGND#3	VGND#4	7.35763e-17
C260	VGND#4	B2#1	5.29031e-18
C261	VGND#2	A1#2	4.84925e-20
C262	VGND#4	VGND#2	2.31824e-19
C263	VGND#4	A2#3	1.32293e-19
C264	VGND#2	A2#3	3.75761e-18
C265	VGND	VGND#2	3.93675e-17
C266	VGND#4	VGND#6	1.19433e-20
C267	VGND#2	A2	2.84634e-18
C268	VGND#4	C1#1	6.0624e-18
C269	a_263_368#	VPWR#2	2.09387e-17
C270	VPWR	VPWR#2	3.94542e-17
C271	VGND	VGND#4	6.95783e-17
C272	VGND#3	VGND#2	5.41642e-17
C273	a_263_368##2	VPWR#2	1.6661e-19
C274	VPWR#2	A2#2	9.46869e-20
C275	VGND#4	A1#1	4.93564e-19
C276	VPWR#2	A2#1	2.58793e-18
C277	VGND#4	C1#2	2.91672e-19
C278	VGND#2	A1#1	8.73644e-18
*
*
.ENDS sky130_fd_sc_hs__a221oi_1
*
