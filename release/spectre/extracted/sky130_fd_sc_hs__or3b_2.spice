* Extracted by Quantus, converted by sky130cad/quantus.py
*
*
*
*                       LINUX           Wed Nov 18 09:06:58 2026
*
*
*
*  PROGRAM  advgen
*
*  Name           : advgen - Quantus - (64-bit)
*  Version        : 25.1.0-p047
*  Build Date     : Thu Dec 11 23:20:30 PST 2025
*
*  HSPICE LIBRARY
*
*  OPERATING_TEMPERATURE 150
*  QRC_TECH_DIR <path>/tech
*
*
*

*
.SUBCKT sky130_fd_sc_hs__or3b_2 VNB VPB VGND VPWR X C_N A B
*
*
*  caps2d version: 10
*
*
*       TRANSISTOR CARDS
*
*
XM8 a_27_368##7 C_N#1 VGND#8 VNB sky130_fd_pr__nfet_01v8_lvt l=0.15 w=0.55 ad=0.15675 as=0.25215 pd=1.67 ps=2.2
XM3 X#3 a_190_260##6 VGND#8 VNB sky130_fd_pr__nfet_01v8_lvt l=0.15 w=0.74 ad=0.2072 as=0.25215 pd=2.04 ps=2.2
XM11 VGND#7 a_190_260# X#3 VNB sky130_fd_pr__nfet_01v8_lvt l=0.15 w=0.74 ad=0.393 as=0.2072 pd=2.63 ps=2.04
XM9 VGND#7 A#1 a_190_260##12 VNB sky130_fd_pr__nfet_01v8_lvt l=0.15 w=0.64 ad=0.393 as=0.224 pd=2.63 ps=1.98
XM4 a_190_260##12 B#1 VGND#6 VNB sky130_fd_pr__nfet_01v8_lvt l=0.15 w=0.64 ad=0.224 as=0.2688 pd=1.98 ps=2.12
XM10 VGND#6 a_27_368# a_190_260##11 VNB sky130_fd_pr__nfet_01v8_lvt l=0.15 w=0.64 ad=0.2688 as=0.1824 pd=2.12 ps=1.85
XM0 a_27_368##6 C_N#4 VPWR#6 VPB sky130_fd_pr__pfet_01v8 l=0.15 w=0.84 ad=0.2478 as=0.406 pd=2.27 ps=3.01
XM1 X#1 a_190_260##4 VPWR#6 VPB sky130_fd_pr__pfet_01v8 l=0.15 w=1.12 ad=0.336 as=0.406 pd=2.84 ps=3.01
XM6 VPWR#5 a_190_260##5 X#1 VPB sky130_fd_pr__pfet_01v8 l=0.15 w=1.12 ad=0.63715 as=0.336 pd=3.41 ps=2.84
XM7 VPWR#5 A#3 a_458_368# VPB sky130_fd_pr__pfet_01v8 l=0.15 w=1 ad=0.63715 as=0.27 pd=3.41 ps=2.54
XM2 a_458_368# B#3 a_542_368# VPB sky130_fd_pr__pfet_01v8 l=0.15 w=1 ad=0.27 as=0.39 pd=2.54 ps=2.78
XM5 a_542_368# a_27_368##3 a_190_260##7 VPB sky130_fd_pr__pfet_01v8 l=0.15 w=1 ad=0.39 as=0.295 pd=2.78 ps=2.59
*
*
*       RESISTOR AND CAP/DIODE CARDS
*
Rg1	C_N#1	C_N#2	352.174377
Rg2	C_N#2	C_N#3	41.905544
Rg3	C_N#2	C_N#4	417.721924
Rg4	a_190_260#	a_190_260##2	347.931671
Rg5	a_190_260##2	a_190_260##3	191.577057
Rg6	a_190_260##3	a_190_260##4	526.067078
Rg7	a_190_260##2	a_190_260##5	450.931854
Rg8	a_190_260##3	a_190_260##6	346.943268
Rg9	A#1	A#2	353.846649
Rg10	A#2	A#3	400.207520
Rg11	B#1	B#2	396.707642
Rg12	B#2	B#3	412.311401
Rg13	a_27_368#	a_27_368##2	353.846649
Rg14	a_27_368##2	a_27_368##3	389.079926
Rf1	C_N	C_N#3	168.106262
Rf2	X	X#2	16.613226
Rf3	X#2	X	2.690693
Rf4	X#2	X#3	83.887009
Rf5	X#1	X#2	15.000000
Rf6	A	A#2	166.137894
Rf7	B#4	B#2	160.844009
Rf8	B	B#6	0.611206
Rf9	B#4	B#6	5.905091
Rf10	a_27_368##2	a_27_368##5	381.146454
Rf11	a_27_368##5	a_27_368##6	17.022808
Rf12	a_27_368##5	a_27_368##7	101.304298
Rf13	a_190_260##7	a_190_260##8	111.061607
Rf14	a_190_260##8	a_190_260##9	64.997192
Rf15	a_190_260##9	a_190_260##2	234.763718
Rf16	a_190_260##8	a_190_260##11	17.986210
Rf17	a_190_260##9	a_190_260##12	16.181496
Rf19	VGND#2	VGND#3	81.536346
Rf20	VGND#3	VGND#4	79.686562
Rf22	VGND#2	VGND#6	37.066368
Rf23	VGND#3	VGND#7	31.922186
Rf24	VGND#4	VGND#8	51.511902
Rf26	VPWR#2	VPWR#3	82.778206
Rf28	VPWR#2	VPWR#5	30.362614
Rf29	VPWR#3	VPWR#6	33.326477
Re1	VPWR#2	VPWR	1.227783
Re2	VGND	VGND#3	1.227829
*
*       CAPACITOR CARDS
*
*
C1	a_190_260##9	a_190_260##8	2.7035e-18
C2	a_190_260##9	B#4	4.33068e-17
C3	a_190_260##8	a_190_260##11	3.07817e-18
C4	a_190_260##9	VGND#6	5.42156e-17
C5	a_190_260##8	VGND#6	5.30865e-17
C6	a_190_260##9	a_190_260##12	3.18404e-18
C7	a_190_260##9	VGND#7	3.63024e-17
C8	X#3	a_190_260##3	6.67609e-18
C9	X#3	a_190_260##9	3.37245e-18
C10	a_190_260##8	a_190_260##7	1.92635e-18
C11	a_190_260##3	a_190_260##2	9.04436e-18
C12	a_27_368##7	a_190_260##3	3.69688e-18
C13	C_N#3	a_190_260##3	1.71537e-17
C14	VGND#7	VGND#6	3.78327e-18
C15	X#3	VGND#7	4.64999e-17
C16	a_190_260##9	a_27_368#	9.21326e-19
C17	a_190_260##8	a_27_368#	3.85053e-17
C18	VGND#8	VGND#7	1.16131e-18
C19	a_190_260##9	B#1	4.22884e-17
C20	VGND#8	X#3	4.26847e-17
C21	a_190_260##8	B#1	8.63994e-19
C22	a_190_260##9	A#1	3.42533e-17
C23	a_27_368##7	X#3	2.46701e-17
C24	a_27_368##7	VGND#8	3.02202e-17
C25	a_190_260##9	a_190_260#	8.59356e-19
C26	a_27_368#	a_190_260##11	6.60958e-18
C27	a_27_368#	VGND#6	2.37757e-17
C28	VPWR#5	a_190_260##7	5.6007e-18
C29	B#1	VGND#6	2.38997e-17
C30	a_190_260##8	a_27_368##3	2.28327e-20
C31	VGND#7	a_27_368#	4.2015e-19
C32	B#1	a_190_260##12	1.48766e-17
C33	VGND#6	A#1	1.36249e-18
C34	VGND#8	a_27_368##6	2.20421e-18
C35	VGND#7	B#1	1.54894e-18
C36	A#1	a_190_260##12	2.32155e-18
C37	a_27_368##7	a_27_368##6	2.26659e-18
C38	VGND#6	a_190_260#	3.92297e-19
C39	X#3	B#1	2.8092e-19
C40	A#1	VGND#7	2.58627e-17
C41	X#3	A#1	1.0543e-18
C42	a_190_260#	VGND#7	2.43282e-17
C43	VGND#8	A#1	1.23607e-19
C44	VPWR#6	VPWR#5	1.02358e-17
C45	X#3	a_190_260#	4.3731e-17
C46	VGND#7	a_190_260##6	3.86879e-19
C47	VGND#8	a_190_260#	5.03921e-19
C48	a_27_368##6	VPWR#5	5.37451e-17
C49	X#3	a_190_260##6	3.81301e-17
C50	a_27_368##6	X#1	4.14748e-18
C51	a_190_260##6	VGND#8	1.63483e-17
C52	X#3	C_N#1	3.7351e-18
C53	a_27_368##6	a_190_260##3	1.40837e-18
C54	a_27_368##7	a_190_260##6	5.55641e-18
C55	a_27_368##6	VPWR#6	5.38379e-17
C56	C_N#1	VGND#8	1.86662e-17
C57	a_27_368##7	C_N#1	3.62024e-17
C58	A	a_190_260##3	3.36391e-20
C59	B#1	a_27_368#	1.9549e-17
C60	VGND#3	a_190_260##9	6.33838e-18
C61	a_190_260##7	a_27_368##3	3.91922e-17
C62	a_190_260##7	B#3	6.28095e-18
C63	A#1	B#1	2.4547e-17
C64	a_190_260##9	a_27_368##2	7.90705e-18
C65	a_190_260##8	a_27_368##2	9.00466e-17
C66	a_190_260##7	A#3	1.79644e-18
C67	VPWR#5	a_27_368##3	2.32663e-18
C68	a_190_260##9	B#2	2.85911e-18
C69	a_190_260#	A#1	1.33331e-17
C70	VPWR#5	B#3	2.73412e-18
C71	a_190_260##7	a_190_260##5	7.47477e-19
C72	a_190_260##8	B#2	2.46137e-19
C73	A#3	VPWR#5	3.74917e-17
C74	B#4	a_27_368##2	1.78214e-17
C75	a_190_260##9	A#2	1.25014e-18
C76	a_190_260##6	a_190_260#	3.85161e-17
C77	a_190_260##8	A#2	9.89031e-20
C78	a_190_260##5	VPWR#5	4.32914e-17
C79	a_27_368##6	B#3	1.75801e-19
C80	VPWR#6	A#3	8.87053e-19
C81	VGND#3	VGND#6	5.54224e-19
C82	B#4	B#2	9.32287e-18
C83	a_190_260##5	X#1	2.59374e-17
C84	VPWR#5	a_190_260##4	4.41735e-18
C85	a_27_368##6	A#3	5.0797e-19
C86	C_N#1	a_190_260##6	2.50652e-17
C87	VPWR#6	a_190_260##5	5.62198e-18
C88	VGND#6	a_27_368##2	1.0728e-18
C89	a_190_260##4	X#1	2.59374e-17
C90	X	a_190_260##3	9.59469e-18
C91	B#4	A#2	2.78122e-18
C92	VGND#3	X#3	8.67788e-18
C93	a_27_368##6	a_190_260##5	2.59523e-17
C94	VPWR#6	a_190_260##4	3.50186e-17
C95	VGND#8	VGND#3	4.03402e-19
C96	a_27_368##6	a_190_260##4	2.91225e-17
C97	C_N#4	VPWR#6	2.61728e-17
C98	a_27_368##6	C_N#4	5.50365e-17
C99	a_27_368##2	a_190_260##7	6.76862e-17
C100	VGND#7	A#2	1.06793e-18
C101	X#3	A#2	2.03084e-21
C102	B#3	a_27_368##3	3.20356e-17
C103	a_190_260##2	VGND#7	3.09548e-17
C104	X#3	a_190_260##2	4.12535e-17
C105	A#3	B#3	5.23546e-17
C106	a_27_368##6	a_27_368##2	9.44673e-19
C107	X#3	C_N#3	5.72173e-19
C108	A#2	VPWR#5	9.6189e-19
C109	VGND#3	A#1	1.85407e-18
C110	a_190_260##5	A#3	1.61785e-17
C111	a_27_368##7	C_N#3	7.06719e-17
C112	VGND#3	a_190_260#	8.79528e-18
C113	a_190_260##2	VPWR#5	1.96336e-18
C114	VGND#3	a_190_260##6	9.56719e-19
C115	a_27_368##6	A#2	4.91651e-19
C116	VGND	a_190_260##3	3.36052e-19
C117	a_190_260##4	a_190_260##5	5.07154e-17
C118	a_190_260##2	a_27_368##6	2.26079e-18
C119	C_N#4	a_190_260##4	2.90671e-17
C120	C_N#3	a_27_368##6	8.74134e-18
C121	a_27_368##2	a_27_368##3	1.86197e-17
C122	a_190_260##2	A#1	3.77026e-19
C123	a_27_368##2	B#3	3.7002e-17
C124	a_190_260##2	a_190_260#	3.2982e-18
C125	a_190_260##2	a_190_260##6	1.24794e-19
C126	a_27_368##2	A#3	2.82642e-17
C127	a_27_368##2	a_190_260##5	5.52161e-19
C128	a_190_260##9	A	3.12699e-17
C129	a_27_368##2	a_190_260##4	2.56207e-19
C130	a_27_368##2	C_N#4	1.87352e-19
C131	a_190_260##5	A#2	4.02993e-19
C132	A	B#4	1.71674e-17
C133	a_190_260##4	a_190_260##2	4.16548e-18
C134	a_27_368##3	a_542_368#	2.92795e-17
C135	C_N#3	a_190_260##4	1.93657e-18
C136	B#3	a_542_368#	2.61598e-17
C137	B#2	a_27_368##2	3.09924e-17
C138	B#3	a_458_368#	1.82048e-17
C139	VGND#3	a_190_260##2	4.91021e-19
C140	A	VPWR#5	2.43e-18
C141	A#3	a_458_368#	1.70146e-17
C142	A#2	B#2	3.49997e-17
C143	a_190_260##2	a_27_368##2	1.25229e-19
C144	a_190_260##3	VNB	2.0019e-17
C145	C_N	a_27_368##7	1.31561e-18
C146	A	a_27_368##6	1.64422e-17
C147	a_190_260##2	B#2	2.00617e-19
C148	a_190_260##2	A#2	3.00297e-17
C149	X#3	X	2.90726e-18
C150	a_27_368##7	X	8.76633e-18
C151	C_N	a_27_368##6	5.03951e-17
C152	a_27_368##2	a_542_368#	8.15294e-18
C153	B	B#3	1.96172e-18
C154	VGND	a_190_260##9	1.79808e-17
C155	X	VPWR#5	2.58603e-18
C156	B	A#3	6.49696e-19
C157	B#2	a_542_368#	4.20301e-19
C158	VGND	a_190_260##8	1.89596e-17
C159	X	X#1	2.92852e-19
C160	a_27_368##2	a_458_368#	6.55179e-18
C161	A	a_27_368##3	3.95126e-19
C162	a_27_368##6	X	1.04341e-16
C163	A	B#3	2.75365e-18
C164	VGND	B#4	2.80029e-18
C165	VPWR	a_190_260##7	2.02621e-17
C166	A	A#3	1.1866e-17
C167	A	a_190_260##5	9.52777e-19
C168	VPWR	VPWR#5	2.22297e-17
C169	A	a_190_260##4	2.54696e-19
C170	VPWR	VPWR#6	1.62551e-17
C171	VGND	X#3	1.63769e-17
C172	VPWR	a_27_368##6	2.98675e-17
C173	VGND	a_27_368##7	1.73687e-17
C174	B	a_27_368##2	4.45405e-17
C175	B	B#2	5.67147e-18
C176	C_N	C_N#4	2.87982e-18
C177	X	A#3	2.19182e-18
C178	B	A#2	9.1593e-19
C179	A	a_27_368##2	4.40535e-17
C180	X	a_190_260##5	1.95726e-17
C181	X	a_190_260##4	1.28397e-17
C182	A	B#2	3.63393e-18
C183	VGND	a_27_368#	7.65191e-18
C184	VPWR	a_27_368##3	1.00135e-17
C185	X	C_N#4	2.63471e-18
C186	VGND	B#1	7.56462e-18
C187	A	A#2	1.77149e-17
C188	VPWR	B#3	9.00216e-18
C189	VGND	A#1	5.84393e-18
C190	VPWR	A#3	7.25174e-18
C191	VGND	a_190_260#	1.24918e-18
C192	a_190_260##2	A	4.00905e-17
C193	VPWR	a_190_260##5	6.97412e-19
C194	VGND	a_190_260##6	2.3667e-18
C195	VGND	C_N#1	8.73939e-18
C196	VPWR	a_190_260##4	3.66645e-19
C197	a_190_260##9	VNB	9.02501e-18
C198	a_190_260##8	VNB	6.94169e-17
C199	VPWR	C_N#4	6.64656e-18
C200	B#4	VNB	1.31089e-18
C201	C_N	C_N#3	1.10275e-17
C202	X	A#2	5.40098e-20
C203	VGND#6	VNB	7.3195e-18
C204	X	a_190_260##2	6.21109e-17
C205	A	a_458_368#	3.88177e-19
C206	VPWR	a_27_368##2	2.01733e-17
C207	VGND#7	VNB	4.20945e-18
C208	X#3	VNB	2.20254e-18
C209	X	C_N#3	2.28573e-18
C210	VGND#8	VNB	7.90154e-18
C211	a_27_368##7	VNB	3.59077e-17
C212	a_190_260##7	VNB	5.81858e-17
C213	VGND	VGND#3	6.10593e-17
C214	VPWR	a_190_260##2	2.6533e-18
C215	VPWR#5	VNB	8.20027e-18
C216	VGND	a_27_368##2	3.62166e-18
C217	VPWR#6	VNB	1.08004e-17
C218	a_27_368##6	VNB	4.6641e-17
C219	A	B	1.46973e-17
C220	a_27_368#	VNB	3.61136e-17
C221	B#1	VNB	3.23684e-17
C222	A#1	VNB	3.05015e-17
C223	a_190_260#	VNB	2.92188e-17
C224	VGND	a_190_260##2	7.23635e-18
C225	a_190_260##6	VNB	2.88906e-17
C226	C_N#1	VNB	3.6604e-17
C227	VGND	C_N#3	6.29904e-18
C228	a_27_368##3	VNB	3.73908e-17
C229	B#3	VNB	2.96775e-17
C230	A#3	VNB	3.20579e-17
C231	a_190_260##5	VNB	3.5092e-17
C232	a_190_260##4	VNB	4.07425e-17
C233	X	A	3.96196e-17
C234	C_N#4	VNB	4.53416e-17
C235	VPWR	B	2.51368e-18
C236	VGND#3	VNB	2.10452e-16
C237	VPWR	A	3.96881e-18
C238	a_27_368##2	VNB	5.23272e-17
C239	B#2	VNB	3.32543e-17
C240	VPWR	C_N	3.77091e-18
C241	A#2	VNB	2.68236e-17
C242	a_190_260##2	VNB	4.0125e-17
C243	VGND	A	3.50532e-18
C244	C_N#3	VNB	7.49308e-17
C245	VPWR	X	5.61211e-18
C246	VGND	X	2.59967e-18
C247	B	VNB	1.66948e-18
C248	A	VNB	2.80641e-18
C249	C_N	VNB	1.32919e-17
C250	X	VNB	9.23476e-19
C251	VPWR	VNB	6.38755e-17
C252	VGND	VNB	6.90046e-17
C253	VGND#2	a_190_260#	2.3341e-19
C254	VPWR#3	C_N#4	3.27152e-18
C255	VPWR#2	a_27_368##3	6.16576e-18
C256	VGND#4	C_N#3	1.36141e-18
C257	VPWR#2	B#2	1.31577e-19
C258	VGND#2	a_190_260##9	6.88859e-18
C259	VGND#3	VGND#4	5.68213e-17
C260	VPWR#3	a_190_260##2	2.6265e-20
C261	VGND#4	C_N#1	2.61115e-18
C262	a_27_368##6	VPWR#2	2.32531e-18
C263	VPWR#2	A#3	6.60277e-18
C264	VPWR#3	VPWR#5	1.10389e-19
C265	VPWR	VPWR#3	4.03949e-17
C266	VGND#4	a_190_260##2	1.11297e-20
C267	VPWR#2	a_190_260##2	1.99361e-20
C268	VGND#4	a_190_260##3	3.08065e-20
C269	VPWR#3	a_190_260##4	3.98892e-18
C270	VGND#4	X#3	7.12315e-18
C271	VGND#2	VNB	5.48993e-17
C272	VGND#2	B#2	6.97837e-20
C273	VGND#4	VNB	5.29152e-17
C274	VGND#2	B#1	2.39564e-18
C275	VGND#4	a_190_260##6	6.59759e-18
C276	a_27_368##6	VPWR#3	1.19841e-17
C277	VPWR#3	VNB	5.29574e-17
C278	a_27_368##2	VPWR#2	9.70795e-18
C279	VPWR#2	VPWR#3	5.72312e-17
C280	VGND#2	a_27_368#	2.39828e-18
C281	VGND#4	a_190_260#	8.10462e-19
C282	a_190_260##7	VPWR#2	2.1637e-17
C283	VPWR#2	B#3	3.52148e-18
C284	VGND	VGND#2	5.85468e-17
C285	VGND#3	VGND#2	5.91754e-17
C286	VPWR#2	VNB	2.63454e-16
C287	VGND	VGND#4	4.42311e-17
C288	C_N	VPWR#3	4.94776e-19
C289	VPWR#3	a_190_260##3	4.74669e-20
C290	VPWR#2	a_190_260##5	8.40798e-18
C291	VGND#4	a_27_368##7	1.42226e-17
C292	VGND#2	a_190_260##8	1.76998e-17
C293	VPWR#3	C_N#3	4.66388e-19
C294	VPWR	VPWR#2	7.37194e-17
*
*
.ENDS sky130_fd_sc_hs__or3b_2
*
