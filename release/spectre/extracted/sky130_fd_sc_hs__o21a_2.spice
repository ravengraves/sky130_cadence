* Extracted by Quantus, converted by sky130cad/quantus.py
*
*
*
*                       LINUX           Wed Nov 18 08:54:58 2026
*
*
*
*  PROGRAM  advgen
*
*  Name           : advgen - Quantus - (64-bit)
*  Version        : 25.1.0-p047
*  Build Date     : Thu Dec 11 23:20:30 PST 2025
*
*  HSPICE LIBRARY
*
*  OPERATING_TEMPERATURE 150
*  QRC_TECH_DIR <path>/tech
*
*
*

*
.SUBCKT sky130_fd_sc_hs__o21a_2 VNB VPB VGND VPWR X A1 A2 B1
*
*
*  caps2d version: 10
*
*
*       TRANSISTOR CARDS
*
*
XM5 a_54_74##2 A1#4 VGND#7 VNB sky130_fd_pr__nfet_01v8_lvt l=0.15 w=0.74 ad=0.2627 as=0.3404 pd=2.19 ps=2.4
XM9 VGND#7 A2#1 a_54_74# VNB sky130_fd_pr__nfet_01v8_lvt l=0.15 w=0.74 ad=0.3404 as=0.2405 pd=2.4 ps=2.13
XM6 a_54_74# B1#1 a_244_368##10 VNB sky130_fd_pr__nfet_01v8_lvt l=0.15 w=0.74 ad=0.2405 as=0.2627 pd=2.13 ps=2.19
XM3 VGND#6 a_244_368##5 X#2 VNB sky130_fd_pr__nfet_01v8_lvt l=0.15 w=0.74 ad=0.2627 as=0.2072 pd=2.19 ps=2.04
XM7 X#2 a_244_368# VGND#1 VNB sky130_fd_pr__nfet_01v8_lvt l=0.15 w=0.74 ad=0.2072 as=0.2109 pd=2.04 ps=2.05
XM0 VPWR#7 A1#1 a_160_368# VPB sky130_fd_pr__pfet_01v8 l=0.15 w=1 ad=0.295 as=0.27 pd=2.59 ps=2.54
XM2 a_160_368# A2#3 a_244_368##9 VPB sky130_fd_pr__pfet_01v8 l=0.15 w=1 ad=0.27 as=0.42 pd=2.54 ps=2.84
XM4 a_244_368##9 B1#3 VPWR#5 VPB sky130_fd_pr__pfet_01v8 l=0.15 w=1 ad=0.42 as=0.5862 pd=2.84 ps=3.32
XM1 X#1 a_244_368##4 VPWR#5 VPB sky130_fd_pr__pfet_01v8 l=0.15 w=1.12 ad=0.336 as=0.5862 pd=2.84 ps=3.32
XM8 VPWR#4 a_244_368##6 X#1 VPB sky130_fd_pr__pfet_01v8 l=0.15 w=1.12 ad=0.3864 as=0.336 pd=2.93 ps=2.84
*
*
*       RESISTOR AND CAP/DIODE CARDS
*
Rg1	A1#1	A1#2	529.443604
Rg2	A1#2	A1#3	118.588242
Rg3	A1#2	A1#4	380.488098
Rg4	A2#1	A2#2	307.937683
Rg5	A2#2	A2#3	457.627838
Rg6	B1#1	B1#2	320.356293
Rg7	B1#2	B1#3	473.984863
Rg8	a_244_368#	a_244_368##2	525.048279
Rg9	a_244_368##2	a_244_368##3	68.074074
Rg10	a_244_368##3	a_244_368##4	486.547119
Rg11	a_244_368##2	a_244_368##5	318.843872
Rg12	a_244_368##2	a_244_368##6	499.297394
Rf1	A1	A1#3	9.883524
Rf2	A1#3	A1	7.059660
Rf3	A2	A2#2	163.775864
Rf4	a_54_74#	a_54_74##2	102.384186
Rf5	B1	B1#4	1.510368
Rf6	B1#5	B1#2	161.743164
Rf7	B1#4	B1#5	3.882813
Rf8	a_244_368##3	a_244_368##8	167.535431
Rf9	a_244_368##8	a_244_368##9	98.009506
Rf10	a_244_368##8	a_244_368##10	49.344376
Rf11	X	X#1	56.936794
Rf12	X	X#3	7.282945
Rf13	X#3	X	7.282945
Rf14	X#2	X#3	7.500000
Rf15	VGND#1	VGND#2	110.555344
Rf16	VGND#2	VGND#3	51.841320
Rf17	VGND#3	VGND#4	67.689766
Rf19	VGND#2	VGND#6	31.731567
Rf20	VGND#4	VGND#7	26.715260
Rf22	VPWR#2	VPWR#3	91.105957
Rf23	VPWR#2	VPWR#4	36.061966
Rf24	VPWR#3	VPWR#5	38.437725
Rf25	VPWR#3	VPWR#6	103.707169
Rf26	VPWR#6	VPWR#7	40.648079
Re1	VPWR#3	VPWR	1.227783
Re2	VGND	VGND#3	1.227829
*
*       CAPACITOR CARDS
*
*
C1	VGND#2	a_244_368##2	9.39137e-20
C2	a_244_368##8	a_244_368##2	2.98962e-19
C3	VGND#2	a_244_368##8	1.98521e-19
C4	VGND#3	a_244_368##2	1.36128e-20
C5	a_244_368##3	a_244_368##2	4.70096e-18
C6	B1#5	a_244_368##8	3.64086e-17
C7	VGND#2	VGND#1	9.1825e-19
C8	VGND#2	a_244_368##10	4.13262e-18
C9	a_244_368##2	X#2	6.16203e-19
C10	a_244_368##8	VGND#6	2.38154e-17
C11	a_244_368##10	a_244_368##8	2.14478e-18
C12	VGND#6	a_244_368##2	2.72192e-18
C13	a_244_368##10	B1#5	1.51597e-17
C14	VGND#2	X#1	1.05219e-19
C15	a_54_74#	B1#4	2.3332e-17
C16	VGND#6	VGND#1	1.71243e-18
C17	a_244_368##8	X#1	4.61096e-17
C18	a_244_368##8	VPWR#5	3.49613e-17
C19	a_244_368##10	VGND#6	6.82871e-17
C20	VGND#2	a_244_368#	1.81156e-18
C21	a_54_74#	a_244_368##10	5.85657e-17
C22	VGND#7	VGND#6	1.18084e-18
C23	B1#5	a_244_368##9	1.7999e-17
C24	VGND#2	a_244_368##5	3.06718e-18
C25	B1#4	a_244_368##9	2.16687e-17
C26	a_54_74#	VGND#7	4.76238e-17
C27	a_244_368##10	a_54_74##2	7.80837e-21
C28	a_244_368##8	a_244_368##5	5.14727e-19
C29	a_54_74##2	a_54_74#	3.44064e-18
C30	VGND#6	X#1	5.03604e-18
C31	a_54_74##2	VGND#7	4.88751e-17
C32	a_244_368##8	B1#1	9.99731e-19
C33	a_244_368##8	A2#1	2.69637e-19
C34	a_244_368##10	a_244_368##9	5.88417e-19
C35	a_244_368##8	A1#4	1.79192e-19
C36	VGND#1	a_244_368#	2.67966e-17
C37	a_54_74#	a_244_368##9	6.11377e-18
C38	a_244_368#	X#2	1.56256e-17
C39	X#1	VPWR#4	8.17562e-17
C40	VGND#1	a_244_368##5	1.42098e-18
C41	VPWR#4	a_244_368##2	8.37626e-19
C42	VGND#6	a_244_368#	1.50742e-18
C43	VPWR#5	VPWR#4	1.69608e-18
C44	a_244_368##5	X#2	1.4935e-17
C45	VGND#1	B1#1	1.53754e-19
C46	a_244_368##5	VGND#6	2.51945e-17
C47	VPWR#5	X#1	8.72046e-17
C48	a_244_368##10	a_244_368##5	1.85551e-18
C49	a_244_368##8	a_244_368##4	4.44777e-18
C50	a_244_368##9	X#1	2.18378e-18
C51	VGND#6	B1#1	2.59448e-18
C52	a_244_368##9	VPWR#5	4.78611e-17
C53	B1#1	a_244_368##10	2.9196e-17
C54	VGND#6	A2#1	2.17523e-19
C55	VGND#7	a_244_368##5	2.95407e-19
C56	a_54_74#	B1#1	4.24894e-17
C57	X#1	a_244_368##2	8.45742e-19
C58	a_244_368##10	A2#1	2.16833e-19
C59	VPWR#4	a_244_368#	9.83261e-19
C60	VGND#6	A1#4	2.17723e-19
C61	VGND#7	B1#1	1.38123e-18
C62	a_54_74#	A2#1	2.88932e-17
C63	VPWR#7	VPWR#5	1.94383e-18
C64	a_244_368##10	A1#4	1.441e-19
C65	a_54_74##2	B1#1	4.81861e-19
C66	A2#1	VGND#7	2.43626e-17
C67	VPWR#7	a_244_368##9	3.00225e-17
C68	a_54_74#	A1#4	1.45854e-18
C69	a_54_74##2	A2#1	1.40848e-18
C70	VGND#7	A1#4	2.97774e-17
C71	a_54_74##2	A1#4	3.17152e-17
C72	VGND#3	VGND#2	4.32434e-17
C73	a_244_368##8	VPWR#3	2.24582e-19
C74	a_244_368##5	a_244_368#	3.66997e-17
C75	a_244_368##6	VPWR#4	2.94284e-17
C76	VGND#2	a_244_368##3	9.58764e-20
C77	X#1	a_244_368##6	6.32657e-17
C78	VPWR#4	a_244_368##4	1.3945e-18
C79	X	a_244_368##2	1.58369e-17
C80	VPWR#5	a_244_368##6	1.48454e-18
C81	B1#1	a_244_368##5	3.32543e-18
C82	a_244_368##8	a_244_368##3	2.25771e-17
C83	VGND#3	B1#5	6.39573e-19
C84	X#1	a_244_368##4	5.95759e-17
C85	a_244_368##4	VPWR#5	3.43185e-17
C86	X#1	B1#3	1.31959e-18
C87	a_244_368##8	B1#2	7.1654e-18
C88	B1#5	a_244_368##3	1.55634e-18
C89	a_244_368##9	a_244_368##4	1.76372e-18
C90	A2#1	B1#1	3.11627e-17
C91	B1#3	VPWR#5	3.59469e-17
C92	VGND#3	VGND#1	2.51469e-17
C93	a_244_368##9	B1#3	8.18079e-17
C94	VPWR#5	A2#3	6.57802e-19
C95	B1#5	B1#2	1.23084e-17
C96	VPWR#7	a_244_368##4	5.00303e-19
C97	a_244_368##8	A2#2	2.28865e-19
C98	A1#4	A2#1	1.60881e-17
C99	B1#4	B1#2	6.96655e-18
C100	a_244_368##9	A2#3	2.79942e-17
C101	VGND#3	a_244_368##10	2.12854e-17
C102	VPWR#7	B1#3	2.77405e-18
C103	VPWR#5	A1#1	2.71886e-19
C104	VGND#3	a_54_74#	1.33646e-17
C105	a_244_368##8	A1#3	3.06711e-19
C106	VGND#6	a_244_368##3	9.39536e-18
C107	a_244_368##9	A1#1	1.04547e-17
C108	B1#4	A2#2	3.34526e-18
C109	VPWR#7	A2#3	1.23939e-17
C110	X#1	VPWR#3	8.4992e-18
C111	VPWR#7	A1#1	5.65837e-17
C112	B1#2	a_244_368##10	2.34235e-18
C113	a_244_368##9	VPWR#3	1.41939e-17
C114	B1#2	a_54_74#	1.99314e-18
C115	X#1	a_244_368##3	4.02446e-18
C116	a_54_74#	A2#2	2.51834e-18
C117	a_244_368##4	a_244_368##6	4.77798e-17
C118	A2#2	VGND#7	1.58643e-18
C119	VGND	a_244_368##2	1.15677e-18
C120	VGND#3	a_244_368#	4.05606e-21
C121	B1#3	a_244_368##4	1.97332e-17
C122	a_244_368##9	B1#2	3.69809e-18
C123	A1#3	a_54_74##2	8.39093e-18
C124	VGND#3	B1#1	7.45096e-18
C125	a_244_368##9	A2#2	5.2293e-18
C126	A2#3	B1#3	2.68346e-17
C127	A1#1	A2#3	6.22227e-17
C128	VPWR#3	a_244_368##4	4.65862e-18
C129	VPWR#7	A1#3	7.78171e-18
C130	VPWR#3	B1#3	4.70887e-18
C131	A2	B1#4	3.04244e-17
C132	VGND#2	X	1.68405e-17
C133	VPWR#3	a_244_368##3	4.30395e-20
C134	a_54_74#	A2	3.39489e-17
C135	a_244_368##8	X	2.05657e-17
C136	VPWR#3	B1#2	6.77075e-20
C137	a_244_368##2	VNB	2.24009e-17
C138	VGND#3	B1#2	1.66767e-19
C139	VPWR#3	A2#2	2.63424e-19
C140	A2	a_244_368##9	2.11485e-17
C141	B1#2	a_244_368##3	1.4921e-17
C142	a_54_74##2	A1	6.52374e-17
C143	X	VGND#1	7.0374e-17
C144	A2#3	a_160_368#	2.52858e-17
C145	VPWR	a_244_368##8	5.09571e-18
C146	VGND#6	X	6.3109e-17
C147	A1#1	a_160_368#	2.61244e-17
C148	a_244_368##10	X	1.65342e-18
C149	VPWR	B1#5	1.21156e-18
C150	A2#2	B1#2	3.0043e-17
C151	VPWR	B1#4	9.94154e-19
C152	A1	VPWR#7	3.0092e-17
C153	X	VPWR#4	3.69394e-17
C154	VGND	VGND#2	2.46713e-17
C155	A1#3	A2#2	3.06505e-17
C156	VGND	a_244_368##8	2.56395e-18
C157	VGND	B1#5	3.1688e-18
C158	VGND	B1#4	1.45455e-18
C159	X	a_244_368#	3.52957e-17
C160	VPWR	VPWR#4	2.17673e-17
C161	VPWR	X#1	1.71021e-17
C162	X	a_244_368##5	2.20581e-17
C163	VGND	VGND#1	3.11815e-17
C164	VPWR	VPWR#5	2.21555e-17
C165	X	B1#1	3.42537e-19
C166	VPWR	a_244_368##9	1.68505e-17
C167	VGND	VGND#6	1.96552e-17
C168	VGND	a_244_368##10	1.905e-17
C169	VGND	a_54_74#	1.86159e-17
C170	VPWR	a_244_368#	1.13285e-18
C171	VGND	a_54_74##2	1.88224e-17
C172	A2	VPWR#3	2.17858e-19
C173	X	a_244_368##6	1.11394e-17
C174	VGND	X#1	2.98938e-18
C175	VGND	a_244_368##9	4.23384e-18
C176	VGND	VPWR#7	3.28185e-18
C177	A2	B1#2	3.35459e-18
C178	VPWR	a_244_368##6	4.79792e-19
C179	VGND	a_244_368#	4.22084e-18
C180	VGND	a_244_368##5	3.78602e-18
C181	VPWR	a_244_368##4	3.20247e-18
C182	A2	A2#2	2.04435e-17
C183	VGND	B1#1	1.53811e-18
C184	VPWR	B1#3	9.15527e-18
C185	VGND	A2#1	1.50332e-19
C186	A2	A1#3	4.52408e-18
C187	VPWR	A2#3	9.15527e-18
C188	VGND#2	VNB	3.3974e-17
C189	VGND	A1#4	1.54707e-18
C190	VPWR	A1#1	4.09705e-18
C191	A1	A2#2	5.20365e-18
C192	a_244_368##8	VNB	9.18281e-18
C193	X	a_244_368##3	2.95298e-19
C194	A1	A1#3	3.46394e-17
C195	B1#5	VNB	1.89179e-18
C196	X	B1#2	6.84033e-20
C197	VPWR	VPWR#3	3.46211e-17
C198	B1#4	VNB	8.62991e-19
C199	VGND#1	VNB	8.10091e-17
C200	VGND#6	VNB	9.84446e-18
C201	a_244_368##10	VNB	1.36697e-17
C202	a_54_74#	VNB	2.60753e-18
C203	VGND#7	VNB	3.85814e-18
C204	a_54_74##2	VNB	3.7103e-17
C205	VPWR	A2#2	2.65974e-19
C206	VPWR#4	VNB	4.34896e-17
C207	X#1	VNB	5.44953e-18
C208	VGND	VGND#3	1.72996e-17
C209	VPWR#5	VNB	5.44728e-18
C210	VPWR	A1#3	2.91286e-18
C211	a_244_368##9	VNB	1.2277e-17
C212	VGND	a_244_368##3	2.31727e-18
C213	VPWR#7	VNB	5.24199e-17
C214	VGND	B1#2	3.32079e-19
C215	a_244_368#	VNB	5.42612e-17
C216	a_244_368##5	VNB	2.91462e-17
C217	VGND	A2#2	3.32079e-19
C218	B1#1	VNB	3.3161e-17
C219	A2#1	VNB	2.27276e-17
C220	VGND	A1#3	1.18593e-18
C221	A1	A2	2.76255e-17
C222	A1#4	VNB	3.14983e-17
C223	a_244_368##6	VNB	4.37424e-17
C224	a_244_368##4	VNB	3.84629e-17
C225	B1#3	VNB	3.89016e-17
C226	A2#3	VNB	3.2746e-17
C227	A1#1	VNB	3.60879e-17
C228	VPWR	A2	4.56174e-18
C229	VPWR#3	VNB	2.13132e-16
C230	VGND#3	VNB	1.91958e-16
C231	VPWR	A1	7.60244e-18
C232	a_244_368##3	VNB	3.38248e-17
C233	B1#2	VNB	2.88891e-17
C234	VGND	A2	3.02153e-18
C235	A2#2	VNB	2.4421e-17
C236	VPWR	X	3.1484e-18
C237	A1#3	VNB	8.2196e-17
C238	VGND	A1	8.50368e-18
C239	VGND	X	1.68536e-17
C240	A2	VNB	4.24585e-18
C241	A1	VNB	3.67396e-17
C242	X	VNB	3.50371e-17
C243	VPWR	VNB	7.92985e-17
C244	VGND	VNB	6.95249e-17
C245	VPWR#6	A2#3	7.22503e-18
C246	VGND#4	B1#1	7.22208e-19
C247	VPWR#2	VNB	5.07178e-17
C248	VGND#4	A1#4	3.87215e-18
C249	A1	VPWR#6	1.10478e-18
C250	VPWR#6	VNB	5.25672e-17
C251	VPWR#2	a_244_368##6	2.89216e-18
C252	VPWR#6	a_244_368##4	2.31877e-19
C253	VGND#4	VGND#2	3.7827e-19
C254	VPWR#3	VPWR#6	5.40807e-17
C255	VPWR#6	A1#3	1.09628e-18
C256	VGND#4	A1	1.89374e-18
C257	X#1	VPWR#2	8.60531e-18
C258	VGND#4	VGND#6	1.52265e-19
C259	VGND#4	a_54_74#	8.04602e-18
C260	VPWR#6	A1#1	3.42627e-18
C261	VGND#4	a_54_74##2	2.25913e-17
C262	VGND#4	a_244_368##5	1.07365e-19
C263	VPWR#2	a_244_368#	6.63367e-19
C264	VGND#4	A2#1	5.212e-18
C265	VPWR#2	a_244_368##3	4.24656e-20
C266	A2	VPWR#6	7.09879e-19
C267	VGND#3	VGND#4	6.62328e-17
C268	VPWR#3	VPWR#2	5.30093e-17
C269	VGND#4	A1#3	1.02402e-18
C270	VPWR#6	VPWR#5	1.71013e-19
C271	VPWR	VPWR#2	3.55961e-17
C272	VPWR#5	VPWR#2	6.02734e-20
C273	VGND	VGND#4	6.30378e-17
C274	VGND#4	VNB	5.99193e-17
C275	VPWR	VPWR#6	5.90758e-17
*
*
.ENDS sky130_fd_sc_hs__o21a_2
*
