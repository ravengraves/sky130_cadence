* Extracted by Quantus, converted by sky130cad/quantus.py
*
*
*
*                       LINUX           Wed Nov 18 08:02:45 2026
*
*
*
*  PROGRAM  advgen
*
*  Name           : advgen - Quantus - (64-bit)
*  Version        : 25.1.0-p047
*  Build Date     : Thu Dec 11 23:20:30 PST 2025
*
*  HSPICE LIBRARY
*
*  OPERATING_TEMPERATURE 150
*  QRC_TECH_DIR <path>/tech
*
*
*

*
.SUBCKT sky130_fd_sc_hs__a211o_2 VPB VNB VGND VPWR X A2 A1 B1 C1
*
*
*  caps2d version: 10
*
*
*       TRANSISTOR CARDS
*
*
XM9 X#3 a_85_270##7 VGND#9 VNB sky130_fd_pr__nfet_01v8_lvt l=0.15 w=0.74 ad=0.2072 as=0.1961 pd=2.04 ps=2.01
XM10 VGND#8 a_85_270# X#3 VNB sky130_fd_pr__nfet_01v8_lvt l=0.15 w=0.74 ad=0.4884 as=0.2072 pd=2.8 ps=2.04
XM7 VGND#8 A2#4 a_399_74# VNB sky130_fd_pr__nfet_01v8_lvt l=0.15 w=0.74 ad=0.4884 as=0.1554 pd=2.8 ps=1.9
XM5 a_399_74# A1#3 a_85_270##11 VNB sky130_fd_pr__nfet_01v8_lvt l=0.15 w=0.74 ad=0.1554 as=0.2886 pd=1.9 ps=2.26
XM1 a_85_270##11 B1#3 VGND#7 VNB sky130_fd_pr__nfet_01v8_lvt l=0.15 w=0.74 ad=0.2886 as=0.2886 pd=2.26 ps=2.26
XM2 VGND#7 C1#1 a_85_270##8 VNB sky130_fd_pr__nfet_01v8_lvt l=0.15 w=0.74 ad=0.2886 as=0.1961 pd=2.26 ps=2.01
XM4 X#1 a_85_270##5 VPWR#5 VPB sky130_fd_pr__pfet_01v8 l=0.15 w=1.12 ad=0.336 as=0.308 pd=2.84 ps=2.79
XM8 VPWR#7 a_85_270##6 X#1 VPB sky130_fd_pr__pfet_01v8 l=0.15 w=1.12 ad=0.308 as=0.336 pd=2.79 ps=2.84
XM3 a_317_392##2 A2#1 VPWR#6 VPB sky130_fd_pr__pfet_01v8 l=0.15 w=1 ad=0.275 as=0.39 pd=2.55 ps=2.78
XM6 VPWR#6 A1#1 a_317_392# VPB sky130_fd_pr__pfet_01v8 l=0.15 w=1 ad=0.39 as=0.3 pd=2.78 ps=2.6
XM11 a_317_392# B1#1 a_600_392# VPB sky130_fd_pr__pfet_01v8 l=0.15 w=1 ad=0.3 as=0.27 pd=2.6 ps=2.54
XM0 a_600_392# C1#3 a_85_270##12 VPB sky130_fd_pr__pfet_01v8 l=0.15 w=1 ad=0.27 as=0.275 pd=2.54 ps=2.55
*
*
*       RESISTOR AND CAP/DIODE CARDS
*
Rg1	a_85_270#	a_85_270##2	382.316010
Rg2	a_85_270##2	a_85_270##3	35.654938
Rg3	a_85_270##3	a_85_270##4	135.463974
Rg4	a_85_270##4	a_85_270##5	536.727417
Rg5	a_85_270##3	a_85_270##6	416.207306
Rg6	a_85_270##4	a_85_270##7	357.389252
Rg7	A2#1	A2#2	535.743774
Rg8	A2#2	A2#3	26.659500
Rg9	A2#2	A2#4	352.167450
Rg10	A1#1	A1#2	541.321899
Rg11	A1#2	A1#3	357.745544
Rg12	B1#1	B1#2	492.429810
Rg13	B1#2	B1#3	330.892151
Rg14	C1#1	C1#2	509.225098
Rg15	C1#2	C1#3	478.389740
Rg16	C1#2	C1#4	26.659500
Rf1	X	X#2	0.246578
Rf2	X#2	X	18.000221
Rf3	X	X#3	40.879711
Rf4	X#1	X#2	5.000000
Rf5	A2	A2#3	169.680954
Rf6	A1#4	A1#2	162.903839
Rf7	A1	A1#6	2.671036
Rf8	A1#4	A1#6	6.466482
Rf9	a_317_392#	a_317_392##2	94.267578
Rf10	B1#2	B1#5	162.903839
Rf11	B1#6	B1	2.671036
Rf12	B1#5	B1#6	6.466482
Rf13	C1#4	C1	162.201172
Rf14	a_85_270##8	a_85_270##9	95.544228
Rf15	a_85_270##9	a_85_270##10	119.298454
Rf16	a_85_270##9	a_85_270##11	14.578120
Rf17	a_85_270##10	a_85_270##12	212.528595
Rf19	VGND#2	VGND#3	75.705307
Rf20	VGND#3	VGND#4	49.407127
Rf21	VGND#4	VGND#5	57.052898
Rf23	VGND#2	VGND#7	41.419106
Rf24	VGND#4	VGND#8	43.539917
Rf25	VGND#5	VGND#9	35.098007
Rf27	VPWR#2	VPWR#3	21.916979
Rf28	VPWR#3	VPWR#4	53.302330
Rf29	VPWR#4	VPWR#5	117.039032
Rf30	VPWR#2	VPWR#6	34.602036
Rf31	VPWR#4	VPWR#7	31.534731
Rf36	a_85_270##2	a_85_270##10	160.232803
Re1	VPWR#3	VPWR	1.227783
Re2	VGND	VGND#3	1.227829
*
*       CAPACITOR CARDS
*
*
C1	a_85_270##8	C1#2	4.79494e-18
C2	a_85_270##5	a_85_270##3	4.14166e-18
C3	a_85_270##9	A1#4	5.81849e-17
C4	VGND#3	a_85_270##3	3.75776e-21
C5	a_85_270##9	a_85_270##8	2.1077e-18
C6	VGND#4	VGND#8	8.90767e-18
C7	a_85_270##9	VGND#7	6.26017e-17
C8	VGND#8	a_85_270##3	6.57404e-19
C9	VGND#4	X#3	5.19931e-18
C10	a_85_270##9	a_85_270##11	9.06151e-18
C11	B1#2	C1#2	3.78772e-17
C12	a_85_270##9	VGND#8	2.9986e-17
C13	X#3	a_85_270##9	1.12188e-18
C14	a_317_392##2	VPWR#4	3.51696e-18
C15	VGND#9	a_85_270##4	2.68639e-18
C16	a_85_270##4	a_85_270##3	7.75824e-18
C17	a_85_270##12	C1#2	4.61096e-18
C18	a_85_270##9	a_85_270##12	4.58335e-18
C19	A1#4	a_85_270##11	1.8969e-18
C20	B1#6	a_85_270##12	5.80959e-17
C21	VPWR#5	VPWR#4	9.86498e-19
C22	a_85_270##3	A2#3	3.43277e-17
C23	a_85_270##8	VGND#7	4.91789e-17
C24	VPWR#4	a_85_270##4	6.66582e-20
C25	a_85_270##2	C1#2	1.63966e-19
C26	a_85_270##2	a_85_270##4	4.69958e-19
C27	a_85_270##2	a_85_270##3	2.37273e-17
C28	VGND#8	VGND#7	1.09589e-20
C29	a_85_270##8	a_85_270##12	2.99377e-18
C30	a_85_270##9	C1#1	9.17175e-19
C31	X#3	VGND#8	3.61054e-17
C32	a_85_270##9	B1#3	2.47301e-17
C33	VGND#9	VGND#8	2.77709e-18
C34	VGND#4	a_85_270#	3.84403e-18
C35	a_85_270##9	A1#3	3.7095e-17
C36	X#3	VGND#9	5.77452e-17
C37	a_85_270##9	A2#4	2.9714e-17
C38	a_85_270##9	a_85_270#	3.77987e-19
C39	a_85_270##9	a_85_270##7	2.8744e-19
C40	a_85_270##12	a_317_392#	6.77834e-17
C41	a_85_270##8	C1#1	3.81605e-17
C42	VGND#4	a_85_270##3	3.43676e-20
C43	a_85_270##3	VPWR#7	1.71568e-18
C44	VGND#7	C1#1	3.57394e-17
C45	a_85_270##8	B1#3	7.93959e-19
C46	VPWR#4	a_85_270##6	3.31215e-18
C47	VGND#7	B1#3	3.41674e-17
C48	a_85_270##8	A1#3	1.65163e-19
C49	a_317_392#	VPWR#6	5.11071e-17
C50	B1#3	a_85_270##11	4.64299e-18
C51	VGND#7	A1#3	1.56596e-18
C52	VPWR#4	a_85_270##5	3.12265e-18
C53	a_317_392##2	a_317_392#	2.67264e-18
C54	A1#3	a_85_270##11	1.80976e-17
C55	VGND#9	VPWR#5	6.99563e-18
C56	B1#6	B1#1	2.04464e-18
C57	VGND#7	A2#4	2.94239e-19
C58	VGND#8	B1#3	6.0771e-20
C59	a_317_392##2	VPWR#6	4.39e-17
C60	VGND#7	a_85_270#	6.12958e-20
C61	VPWR#7	VPWR#6	2.42314e-18
C62	VGND#8	A1#3	3.66813e-18
C63	B1#6	A1#1	9.11469e-19
C64	X#3	A1#3	1.07525e-19
C65	VPWR#7	a_317_392##2	6.04821e-17
C66	VGND#8	A2#4	4.43471e-17
C67	C1	C1#2	2.0316e-17
C68	VPWR#3	VPWR#4	4.27921e-17
C69	X#3	A2#4	4.27504e-19
C70	VGND#8	a_85_270#	4.15465e-17
C71	X#1	VPWR#7	2.77635e-17
C72	a_85_270#	X#3	1.38002e-17
C73	VGND#8	a_85_270##7	2.7259e-18
C74	VPWR#5	VPWR#7	1.7987e-18
C75	VGND#9	a_85_270#	2.06256e-18
C76	X#3	a_85_270##7	2.53578e-17
C77	VPWR#5	X#1	3.30215e-17
C78	VGND#9	a_85_270##7	2.77242e-17
C79	VGND#3	VGND#4	2.77057e-17
C80	VGND#3	a_85_270##9	1.13574e-17
C81	a_85_270##12	C1#3	5.73272e-17
C82	B1#3	C1#1	2.33608e-17
C83	a_85_270##12	B1#1	2.68284e-17
C84	a_317_392#	C1#3	7.60444e-18
C85	VPWR#4	A2#3	7.39648e-20
C86	A1#3	B1#3	2.41474e-17
C87	VPWR#6	C1#3	5.50637e-19
C88	a_85_270##12	A1#1	1.45655e-17
C89	a_317_392#	B1#1	4.76921e-17
C90	a_85_270##9	B1#2	4.21759e-17
C91	VPWR#6	B1#1	8.07889e-19
C92	a_85_270##12	A2#1	4.45338e-19
C93	a_317_392#	A1#1	5.27271e-17
C94	VGND#4	A2#3	7.85669e-20
C95	A2#4	A1#3	5.7621e-17
C96	B1#6	B1#2	7.32581e-18
C97	a_85_270##2	VPWR#4	9.38656e-19
C98	A1#1	VPWR#6	2.72702e-17
C99	a_85_270##9	A1#2	3.19395e-18
C100	a_317_392#	A2#1	7.53787e-19
C101	a_317_392##2	A1#1	1.08906e-18
C102	A2#1	VPWR#6	2.94902e-17
C103	A2	a_85_270##3	2.3142e-18
C104	X#1	B1#1	2.56799e-19
C105	B1#6	A1#2	1.81298e-18
C106	VGND#4	a_85_270##2	7.98321e-19
C107	a_85_270#	A2#4	8.18579e-18
C108	VPWR#7	A1#1	2.74864e-19
C109	a_317_392##2	A2#1	6.89909e-17
C110	a_85_270##9	A2#3	2.23087e-17
C111	A1#4	B1#2	2.46975e-17
C112	X#1	A1#1	2.86985e-19
C113	VPWR#6	a_85_270##6	5.35013e-19
C114	VPWR#7	A2#1	3.13395e-18
C115	a_317_392##2	a_85_270##6	1.27162e-18
C116	a_85_270##7	a_85_270#	4.14177e-17
C117	X#1	A2#1	7.98619e-19
C118	VGND#3	VGND#8	1.67384e-17
C119	a_85_270##9	a_85_270##2	2.7371e-18
C120	VPWR#7	a_85_270##6	6.06209e-17
C121	A1#4	A1#2	1.26453e-17
C122	a_85_270##8	B1#2	1.53839e-17
C123	B1#2	VGND#7	2.65752e-18
C124	a_85_270##6	X#1	7.51828e-18
C125	B1#6	C1#2	5.41041e-18
C126	VPWR#7	a_85_270##5	2.85804e-18
C127	VPWR#5	a_85_270##6	1.20836e-18
C128	X	a_85_270##4	2.04384e-17
C129	A2#3	A1#4	2.72319e-17
C130	X	a_85_270##3	1.11893e-17
C131	X#1	a_85_270##5	3.43152e-17
C132	VPWR#5	a_85_270##5	3.23234e-17
C133	a_317_392##2	VPWR#3	1.45523e-17
C134	a_85_270##12	B1#2	5.25358e-19
C135	VPWR#3	VPWR#5	2.48235e-17
C136	B1#1	C1#3	5.42367e-17
C137	A2#3	VGND#8	5.04063e-18
C138	a_317_392#	B1#2	3.74593e-19
C139	VPWR	C1#2	9.57191e-20
C140	a_317_392#	A1#2	2.7857e-19
C141	A1#1	B1#1	4.66929e-17
C142	a_85_270##2	VGND#8	4.98434e-17
C143	VPWR#6	A1#2	2.68582e-19
C144	X#3	a_85_270##2	1.44272e-17
C145	a_85_270##9	a_399_74#	3.37437e-18
C146	VGND#3	A1#3	5.50066e-18
C147	A2#1	A1#1	3.25776e-17
C148	VGND#3	A2#4	7.36143e-18
C149	B1#2	C1#1	8.9496e-18
C150	a_317_392##2	A2#3	9.41224e-19
C151	a_85_270##2	a_317_392#	1.00609e-17
C152	a_85_270##2	VPWR#6	1.68469e-18
C153	a_85_270##6	A2#1	7.23067e-18
C154	a_85_270##2	a_317_392##2	6.29474e-17
C155	a_85_270##2	VPWR#7	3.13625e-17
C156	a_85_270##12	a_600_392#	4.08698e-18
C157	VGND	a_85_270##4	2.42861e-18
C158	VGND	a_85_270##3	4.19009e-19
C159	a_85_270##5	a_85_270##6	4.68668e-17
C160	B1#6	C1	2.0263e-17
C161	a_85_270##2	C1#1	1.39002e-19
C162	VPWR#3	A2#1	5.59503e-18
C163	a_85_270##2	B1#3	1.22127e-19
C164	a_85_270##2	A1#3	2.0298e-19
C165	a_85_270#	A2#3	5.05874e-19
C166	a_85_270##2	A2#4	6.58554e-19
C167	a_85_270##2	a_85_270#	8.15027e-18
C168	a_85_270##8	C1	1.94228e-17
C169	a_85_270##2	a_85_270##7	9.3109e-19
C170	A1	B1#6	1.74082e-17
C171	C1#2	VNB	6.9642e-17
C172	a_85_270##2	C1#3	2.21078e-20
C173	a_85_270##4	VNB	3.52467e-17
C174	a_85_270##3	VNB	3.11328e-17
C175	a_85_270##2	B1#1	1.89025e-19
C176	C1	a_85_270##12	3.30819e-17
C177	a_85_270##2	A1#1	4.06802e-19
C178	a_85_270##6	A2#3	6.31717e-19
C179	X	VPWR#4	1.37557e-17
C180	a_85_270##2	A2#1	1.79801e-17
C181	A1#3	a_399_74#	1.44693e-17
C182	C1#3	a_600_392#	2.52006e-17
C183	a_85_270##2	a_85_270##6	7.64471e-18
C184	A2#4	a_399_74#	1.44693e-17
C185	B1#1	a_600_392#	2.43792e-17
C186	a_85_270##2	a_85_270##5	2.24982e-18
C187	A2	A1#4	3.54751e-18
C188	VGND#3	A1#2	1.49227e-20
C189	VPWR#3	A2#3	1.11835e-19
C190	VGND#3	A2#3	1.40722e-19
C191	A1	a_85_270##12	2.47337e-17
C192	VPWR	VPWR#4	2.59972e-17
C193	A1#2	B1#2	4.11611e-17
C194	A2#3	A1#2	3.7505e-17
C195	a_85_270##2	B1#2	3.10869e-20
C196	VPWR	B1#6	3.56554e-18
C197	a_85_270##2	A1#2	1.11175e-18
C198	C1	B1#1	1.56771e-19
C199	X	X#3	1.32908e-19
C200	a_85_270##2	A2#3	4.28715e-17
C201	X	VGND#9	1.16451e-19
C202	VGND	VGND#4	1.69267e-17
C203	VGND	a_85_270##9	2.58406e-17
C204	B1#1	C1#2	5.85642e-18
C205	X	VPWR#7	2.77635e-17
C206	X	X#1	2.99258e-18
C207	A1	B1#1	5.22884e-19
C208	VPWR#5	X	5.70744e-17
C209	VPWR	a_85_270##12	2.48066e-17
C210	VGND	A1#4	4.39404e-18
C211	A1	A1#1	2.72778e-18
C212	VPWR#4	VNB	3.45395e-17
C213	VPWR	a_317_392#	1.69203e-17
C214	A1	A2#1	1.66554e-18
C215	VGND	a_85_270##8	1.61548e-17
C216	VGND	VGND#7	1.91471e-17
C217	VPWR	a_317_392##2	1.77159e-17
C218	VGND#4	VNB	2.20905e-17
C219	VPWR	VPWR#7	1.92343e-17
C220	X	a_85_270#	3.28268e-18
C221	B1#2	C1	1.20776e-17
C222	A2	A1#1	1.21101e-19
C223	VGND	VGND#8	2.68152e-17
C224	X	a_85_270##7	5.90863e-18
C225	VPWR	VPWR#5	3.29296e-17
C226	VGND	X#3	1.34395e-17
C227	a_85_270##9	VNB	2.9305e-18
C228	A2	A2#1	4.0259e-18
C229	B1#6	VNB	4.22679e-19
C230	A2	a_85_270##6	2.87918e-19
C231	A1#4	VNB	1.43503e-19
C232	X	A2#1	3.29337e-19
C233	a_85_270##8	VNB	4.38938e-17
C234	A1	B1#2	1.47144e-18
C235	VGND#7	VNB	1.89889e-18
C236	X	a_85_270##6	1.29619e-17
C237	VGND	VPWR#5	5.64721e-18
C238	VPWR	C1#3	1.27291e-18
C239	VGND	C1#1	2.03654e-18
C240	X	a_85_270##5	2.30792e-17
C241	A1	A1#2	8.0606e-18
C242	VGND#8	VNB	3.2692e-18
C243	VGND	B1#3	6.49193e-19
C244	VPWR	B1#1	1.73096e-18
C245	X#3	VNB	8.40775e-18
C246	VGND	A1#3	1.42561e-19
C247	A1	A2#3	3.33028e-18
C248	VGND#9	VNB	2.75e-17
C249	VPWR	A1#1	3.29195e-19
C250	a_85_270##12	VNB	5.54186e-17
C251	VGND	A2#4	1.72073e-18
C252	VPWR	A2#1	1.8597e-19
C253	VGND	a_85_270#	3.03125e-19
C254	A1	a_85_270##2	3.13868e-17
C255	a_317_392#	VNB	2.09331e-18
C256	A2	A1#2	8.53686e-19
C257	VPWR	a_85_270##6	4.60886e-18
C258	VGND	a_85_270##7	5.58797e-19
C259	VPWR#6	VNB	3.90899e-18
C260	a_317_392##2	VNB	1.05811e-17
C261	VPWR	a_85_270##5	5.12175e-18
C262	A2	A2#3	1.1454e-17
C263	VPWR#7	VNB	7.50949e-18
C264	a_85_270##2	A2	5.9593e-17
C265	VPWR#5	VNB	8.73165e-17
C266	VPWR	VPWR#3	1.00106e-17
C267	C1#1	VNB	4.20853e-17
C268	B1#3	VNB	2.50456e-17
C269	A1#3	VNB	2.43974e-17
C270	X	A2#3	1.55574e-20
C271	A2#4	VNB	2.79629e-17
C272	a_85_270#	VNB	2.95708e-17
C273	X	a_85_270##2	7.98063e-17
C274	a_85_270##7	VNB	3.9094e-17
C275	VPWR	A1#2	9.57191e-20
C276	C1#3	VNB	3.15801e-17
C277	VPWR	A2#3	9.57191e-20
C278	B1#1	VNB	3.27179e-17
C279	VGND	VGND#3	2.12828e-17
C280	A1#1	VNB	3.41311e-17
C281	VPWR	a_85_270##2	7.9073e-18
C282	A2#1	VNB	4.58982e-17
C283	VGND	B1#2	3.82751e-18
C284	a_85_270##6	VNB	3.52318e-17
C285	a_85_270##5	VNB	4.69365e-17
C286	VGND	A2#3	2.92998e-18
C287	VPWR#3	VNB	1.83131e-16
C288	VGND	a_85_270##2	8.03771e-18
C289	VGND#3	VNB	1.97358e-16
C290	B1#2	VNB	3.22869e-17
C291	A2	A1	2.01602e-17
C292	A1#2	VNB	2.99754e-17
C293	A2#3	VNB	3.73384e-17
C294	VPWR	C1	1.80705e-18
C295	a_85_270##2	VNB	1.38331e-17
C296	VGND	C1	2.40039e-18
C297	VPWR	A1	3.45368e-18
C298	VPWR	A2	2.72613e-18
C299	C1	VNB	1.82247e-17
C300	VPWR	X	1.7595e-17
C301	A1	VNB	2.63134e-18
C302	A2	VNB	1.66029e-18
C303	X	VNB	2.28936e-17
C304	VPWR	VNB	6.46813e-17
C305	VGND	VNB	7.08381e-17
C306	VGND	VGND#2	3.78369e-17
C307	VGND#3	VGND#5	3.97766e-17
C308	VPWR#3	VPWR#2	7.58009e-17
C309	VPWR#2	C1#2	9.39745e-20
C310	a_85_270##12	VPWR#2	2.56799e-17
C311	VPWR#2	C1#3	5.88729e-18
C312	VGND#5	VGND#8	7.51287e-20
C313	VGND#5	a_85_270##7	5.29009e-18
C314	VGND#2	a_85_270##9	1.42217e-17
C315	VPWR#2	B1#1	8.15458e-18
C316	VGND	VGND#5	4.23333e-17
C317	VGND#5	a_85_270##3	3.4132e-20
C318	VGND#2	C1#1	7.45373e-18
C319	VGND#2	VNB	5.43411e-17
C320	VGND#2	C1#2	1.0197e-19
C321	VGND#5	X#3	5.55982e-18
C322	VPWR	VPWR#2	6.64985e-17
C323	a_317_392#	VPWR#2	1.96281e-17
C324	VPWR#2	A1#1	4.58454e-18
C325	VGND#5	VNB	3.86739e-17
C326	VPWR#2	B1#2	5.63632e-20
C327	VPWR#2	A2#1	2.06191e-18
C328	VGND#2	B1#3	9.50429e-19
C329	VGND#5	VGND#4	1.31491e-18
C330	VPWR#4	VPWR#2	8.5704e-19
C331	VPWR#2	VNB	6.67509e-17
C332	VGND#2	a_85_270##8	2.17016e-17
C333	VGND#2	A1#2	1.13744e-19
C334	VPWR#2	a_85_270##6	3.00521e-19
C335	VPWR#7	VPWR#2	2.43948e-19
C336	VGND#2	VGND#7	1.27495e-17
C337	VGND#3	VGND#2	6.02179e-17
C338	VGND#4	VGND#2	2.15683e-19
C339	VGND#5	a_85_270#	6.57892e-19
*
*
.ENDS sky130_fd_sc_hs__a211o_2
*
