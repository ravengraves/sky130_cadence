* Extracted by Quantus, converted by sky130cad/quantus.py
*
*
*
*                       LINUX           Wed Nov 18 08:10:52 2026
*
*
*
*  PROGRAM  advgen
*
*  Name           : advgen - Quantus - (64-bit)
*  Version        : 25.1.0-p047
*  Build Date     : Thu Dec 11 23:20:30 PST 2025
*
*  HSPICE LIBRARY
*
*  OPERATING_TEMPERATURE 150
*  QRC_TECH_DIR <path>/tech
*
*
*

*
.SUBCKT sky130_fd_sc_hs__a2bb2oi_2 VPB VNB VGND VPWR Y A1_N B2 B1 A2_N
*
*
*  caps2d version: 10
*
*
*       TRANSISTOR CARDS
*
*
XM15 VGND#10 A1_N#2 a_212_102##10 VNB sky130_fd_pr__nfet_01v8_lvt l=0.15 w=0.64 ad=0.1696 as=0.208 pd=1.81 ps=1.93
XM11 a_212_102##10 A2_N#1 VGND#9 VNB sky130_fd_pr__nfet_01v8_lvt l=0.15 w=0.64 ad=0.208 as=0.2441 pd=1.93 ps=2.16
XM8 Y#3 a_212_102##7 VGND#9 VNB sky130_fd_pr__nfet_01v8_lvt l=0.15 w=0.74 ad=0.2072 as=0.2441 pd=2.04 ps=2.16
XM1 VGND#8 a_212_102##6 Y#3 VNB sky130_fd_pr__nfet_01v8_lvt l=0.15 w=0.74 ad=0.1961 as=0.2072 pd=2.01 ps=2.04
XM0 a_615_74##4 B2#7 Y#1 VNB sky130_fd_pr__nfet_01v8_lvt l=0.15 w=0.74 ad=0.1961 as=0.2072 pd=2.01 ps=2.04
XM3 Y#1 B2#1 a_615_74##2 VNB sky130_fd_pr__nfet_01v8_lvt l=0.15 w=0.74 ad=0.2072 as=0.2072 pd=2.04 ps=2.04
XM9 a_615_74##2 B1#5 VGND#7 VNB sky130_fd_pr__nfet_01v8_lvt l=0.15 w=0.74 ad=0.2072 as=0.2072 pd=2.04 ps=2.04
XM7 VGND#7 B1#4 a_615_74# VNB sky130_fd_pr__nfet_01v8_lvt l=0.15 w=0.74 ad=0.2072 as=0.1961 pd=2.04 ps=2.01
XM6 VPWR#9 A1_N#1 a_209_392# VPB sky130_fd_pr__pfet_01v8 l=0.15 w=1 ad=0.275 as=0.24 pd=2.55 ps=2.48
XM10 a_209_392# A2_N#3 a_212_102##11 VPB sky130_fd_pr__pfet_01v8 l=0.15 w=1 ad=0.24 as=0.275 pd=2.48 ps=2.55
XM2 Y#4 a_212_102##5 a_424_368##5 VPB sky130_fd_pr__pfet_01v8 l=0.15 w=1.12 ad=0.336 as=0.308 pd=2.84 ps=2.79
XM12 a_424_368##3 a_212_102# Y#4 VPB sky130_fd_pr__pfet_01v8 l=0.15 w=1.12 ad=0.336 as=0.336 pd=2.84 ps=2.84
XM4 VPWR#8 B2#5 a_424_368##3 VPB sky130_fd_pr__pfet_01v8 l=0.15 w=1.12 ad=0.336 as=0.336 pd=2.84 ps=2.84
XM13 a_424_368##6 B2#6 VPWR#8 VPB sky130_fd_pr__pfet_01v8 l=0.15 w=1.12 ad=0.336 as=0.336 pd=2.84 ps=2.84
XM14 a_424_368##6 B1#6 VPWR#7 VPB sky130_fd_pr__pfet_01v8 l=0.15 w=1.12 ad=0.336 as=0.336 pd=2.84 ps=2.84
XM5 VPWR#7 B1#1 a_424_368# VPB sky130_fd_pr__pfet_01v8 l=0.15 w=1.12 ad=0.336 as=0.308 pd=2.84 ps=2.79
*
*
*       RESISTOR AND CAP/DIODE CARDS
*
Rg1	A1_N#1	A1_N#2	848.691284
Rg2	A1_N#2	A1_N#3	563.995422
Rg3	A2_N#1	A2_N#2	388.278381
Rg4	A2_N#2	A2_N#3	409.090576
Rg5	a_212_102#	a_212_102##2	655.666565
Rg6	a_212_102##2	a_212_102##3	34.104832
Rg7	a_212_102##3	a_212_102##4	58.120785
Rg8	a_212_102##2	a_212_102##5	423.882568
Rg9	a_212_102##3	a_212_102##6	375.544922
Rg10	a_212_102##4	a_212_102##7	369.222809
Rg11	B2#1	B2#2	377.298279
Rg12	B2#2	B2#3	47.336258
Rg13	B2#3	B2#4	21.754395
Rg14	B2#4	B2#5	465.909943
Rg15	B2#2	B2#6	460.935059
Rg16	B2#4	B2#7	388.798645
Rg17	B1#1	B1#2	449.655212
Rg18	B1#2	B1#3	56.190357
Rg19	B1#2	B1#4	397.555725
Rg20	B1#3	B1#5	401.146606
Rg21	B1#3	B1#6	451.603058
Rf1	A1_N#3	A1_N	164.366364
Rf2	A2_N#4	A2_N	0.680301
Rf3	A2_N#2	A2_N#6	160.913101
Rf4	A2_N#4	A2_N#6	9.251308
Rf5	a_212_102##4	a_212_102##9	165.370239
Rf6	a_212_102##9	a_212_102##10	80.843246
Rf7	a_212_102##9	a_212_102##11	55.557919
Rf8	B2	B2#3	167.318909
Rf9	Y#1	Y#2	63.471848
Rf10	Y#2	Y#3	76.577225
Rf11	Y#2	Y	2.734193
Rf12	Y	Y#4	55.280090
Rf13	B1#7	B1	1.409262
Rf14	B1#3	B1#9	161.642059
Rf15	B1#7	B1#9	8.098473
Rf16	B1#10	B1	1.409262
Rf17	B1#9	B1#10	6.570459
Rf18	a_615_74#	a_615_74##3	98.486214
Rf19	a_615_74##3	a_615_74##4	73.010193
Rf20	a_615_74##2	a_615_74##3	7.500000
Rf21	a_424_368#	a_424_368##2	86.731674
Rf22	a_424_368##2	a_424_368##4	82.091774
Rf23	a_424_368##4	a_424_368##5	120.129807
Rf24	a_424_368##2	a_424_368##6	31.284834
Rf25	a_424_368##3	a_424_368##4	5.000000
Rf27	VPWR#2	VPWR#3	65.696381
Rf28	VPWR#3	VPWR#4	69.738693
Rf29	VPWR#4	VPWR#5	138.406158
Rf31	VPWR#2	VPWR#7	31.534731
Rf32	VPWR#3	VPWR#8	31.534731
Rf33	VPWR#5	VPWR#9	35.924004
Rf35	VGND#2	VGND#3	133.130829
Rf36	VGND#3	VGND#4	67.620224
Rf37	VGND#4	VGND#5	73.424034
Rf39	VGND#2	VGND#7	41.120300
Rf40	VGND#3	VGND#8	40.564270
Rf41	VGND#4	VGND#9	41.003098
Rf42	VGND#5	VGND#10	45.899349
Re1	VPWR#4	VPWR	0.892922
Re2	VGND	VGND#3	0.892955
*
*       CAPACITOR CARDS
*
*
C1	VGND	VNB	7.57896e-17
C2	VPWR	VNB	7.66457e-17
C3	a_212_102##3	a_212_102#	1.58148e-18
C4	Y	VNB	1.55657e-17
C5	B2	VNB	3.19714e-18
C6	VGND	Y	1.08813e-17
C7	B1	VNB	1.91466e-17
C8	VPWR#3	B2#5	1.84009e-18
C9	A2_N	VNB	4.80481e-18
C10	VPWR	Y	1.88597e-18
C11	a_615_74##2	B2#1	3.95224e-17
C12	a_212_102##9	a_212_102##3	5.03009e-19
C13	VGND	B1	3.0689e-18
C14	a_424_368##3	a_424_368##6	8.39315e-19
C15	VGND	A2_N	1.73284e-18
C16	VPWR	B2	2.58998e-18
C17	a_424_368##2	B1#6	1.43676e-17
C18	A1_N#3	VNB	9.89589e-17
C19	A2_N#2	VNB	4.19964e-17
C20	VPWR	B1	3.29774e-18
C21	a_212_102##4	VNB	3.25501e-17
C22	Y	B2	1.65394e-18
C23	VPWR	A2_N	4.24509e-18
C24	B2#3	VNB	5.34483e-19
C25	B1#3	VNB	3.15572e-17
C26	Y#1	B1#5	8.98859e-19
C27	VGND#3	VNB	2.64298e-16
C28	VPWR#4	VNB	2.5943e-16
C29	VGND	A1_N#3	2.15797e-17
C30	A1_N#1	VNB	5.60182e-17
C31	A2_N#3	VNB	2.97289e-17
C32	a_212_102##5	VNB	3.72829e-17
C33	a_212_102#	VNB	5.07966e-17
C34	B2#5	VNB	2.92481e-17
C35	VGND	B2#3	2.81647e-18
C36	VGND#4	a_212_102##10	5.08744e-18
C37	B2#6	VNB	3.00105e-17
C38	B2	B1	1.67429e-17
C39	VGND#7	B2#1	1.47495e-18
C40	B1#6	VNB	2.83722e-17
C41	VGND	VGND#3	5.61374e-17
C42	B1#1	VNB	3.71758e-17
C43	a_212_102#	B2#4	1.96475e-17
C44	A1_N#2	VNB	6.85251e-17
C45	A2_N#1	VNB	3.21093e-17
C46	a_212_102##7	VNB	2.97405e-17
C47	VPWR	a_212_102##4	1.39289e-18
C48	a_212_102##6	VNB	3.01862e-17
C49	B2#7	VNB	3.74226e-17
C50	VPWR#8	a_424_368##6	5.05407e-17
C51	B2#1	VNB	2.92382e-17
C52	B1#5	VNB	2.50163e-17
C53	a_615_74##2	B1#5	2.32931e-17
C54	B1#4	VNB	3.13931e-17
C55	VPWR#9	VNB	4.97822e-17
C56	a_212_102##11	VNB	2.54078e-17
C57	VPWR	VPWR#4	2.59126e-17
C58	Y	a_212_102##4	1.88666e-19
C59	a_424_368##5	VNB	1.59599e-17
C60	Y#4	VNB	1.29111e-18
C61	a_424_368##3	VNB	3.78345e-18
C62	Y	B2#3	1.32066e-17
C63	VPWR	A1_N#1	4.49226e-18
C64	VPWR#8	VNB	2.4038e-19
C65	a_424_368##6	VNB	4.61348e-18
C66	a_615_74#	B2#1	2.16679e-19
C67	Y	B1#3	4.71183e-19
C68	VPWR#3	B2#6	1.84009e-18
C69	VPWR	A2_N#3	2.5332e-18
C70	VPWR#7	VNB	2.48892e-18
C71	VGND	A1_N#2	6.6453e-18
C72	a_424_368#	VNB	6.0617e-17
C73	VGND	A2_N#1	7.54353e-18
C74	VGND#10	VNB	2.83518e-17
C75	VPWR	a_212_102##5	1.47751e-18
C76	VGND#3	Y	3.0423e-18
C77	a_424_368##2	B1#1	4.70377e-19
C78	a_212_102##10	VNB	8.52278e-18
C79	VGND	a_212_102##7	3.95758e-18
C80	VGND#9	VNB	7.77715e-20
C81	VPWR	a_212_102#	1.43557e-18
C82	VGND	a_212_102##6	4.22686e-18
C83	Y#3	VNB	4.70686e-18
C84	VGND#8	VNB	2.79444e-18
C85	VPWR	B2#5	1.28619e-18
C86	VGND	B2#7	1.05197e-18
C87	a_615_74##4	VNB	7.27416e-18
C88	VGND	B2#1	9.70259e-19
C89	Y#1	VNB	3.30114e-19
C90	VPWR	B2#6	1.0778e-18
C91	a_615_74##2	VNB	4.44612e-18
C92	VGND	B1#5	8.62456e-19
C93	VGND#7	B1#5	2.90753e-17
C94	VPWR	B1#6	1.15118e-18
C95	VGND#7	VNB	7.7993e-19
C96	a_424_368##3	a_424_368#	5.18901e-19
C97	VGND	B1#4	9.22719e-19
C98	a_615_74#	VNB	4.571e-17
C99	VPWR#8	VPWR#7	2.06271e-18
C100	VPWR	B1#1	1.93796e-18
C101	VGND	VPWR#9	2.28536e-18
C102	a_212_102##9	a_212_102##7	3.15707e-18
C103	A2_N#6	VNB	2.84859e-19
C104	VGND	a_424_368##5	1.43619e-18
C105	a_212_102##9	VNB	9.39893e-18
C106	Y	a_212_102#	5.46948e-18
C107	B2	B1#3	1.04284e-18
C108	a_615_74##2	B1#4	7.4152e-19
C109	VGND	a_424_368##3	3.13705e-18
C110	B1#9	VNB	2.11894e-18
C111	A2_N	A2_N#2	5.49894e-18
C112	B2#3	B1	1.25044e-17
C113	VGND	a_424_368#	4.86396e-18
C114	a_212_102##9	B2#4	3.16015e-19
C115	B1	B1#3	9.4932e-18
C116	VGND	a_212_102##10	1.48334e-17
C117	a_615_74#	B1#5	1.92143e-18
C118	VPWR#3	VNB	2.90784e-17
C119	VGND	Y#3	1.05187e-17
C120	VPWR	VPWR#9	2.05003e-17
C121	VGND	a_615_74##4	1.87442e-17
C122	VGND#4	VNB	3.11093e-17
C123	a_424_368##6	VPWR#7	5.05943e-17
C124	VPWR	a_212_102##11	2.16182e-17
C125	VGND	Y#1	5.17075e-18
C126	Y	a_212_102##7	1.33639e-19
C127	VGND	a_615_74##2	1.80389e-17
C128	VPWR	a_424_368##5	2.81861e-17
C129	B1#4	VGND#7	1.58244e-17
C130	Y	a_212_102##6	1.16702e-17
C131	B2	a_212_102##5	2.20941e-19
C132	VPWR	Y#4	8.03817e-18
C133	VGND	a_615_74#	1.76188e-17
C134	Y#3	a_212_102##3	1.12537e-19
C135	Y	B2#7	9.21951e-18
C136	VPWR	a_424_368##3	1.65104e-17
C137	B2	a_212_102#	2.08207e-18
C138	VPWR	VPWR#8	2.18156e-17
C139	Y	B2#1	2.85048e-19
C140	VGND	A2_N#6	1.30593e-18
C141	a_212_102##9	a_212_102##6	4.28533e-19
C142	VPWR	a_424_368##6	1.11396e-17
C143	B2	B2#5	1.73539e-18
C144	Y	B1#5	2.59415e-19
C145	Y#3	a_424_368##5	3.39758e-18
C146	VPWR	VPWR#7	2.19957e-17
C147	VGND	a_212_102##9	5.19516e-18
C148	Y	B1#4	2.23363e-19
C149	B2	B2#6	4.15862e-19
C150	VPWR	a_424_368#	1.5258e-17
C151	B2	B1#6	3.51414e-19
C152	VGND	B1#9	1.15927e-18
C153	A2_N	A1_N#1	7.62284e-18
C154	a_615_74#	B1#4	4.76207e-17
C155	a_424_368##6	a_424_368#	8.39315e-19
C156	Y	a_424_368##5	8.22212e-19
C157	VGND#4	Y#3	4.5731e-18
C158	B1	B2#6	1.57849e-18
C159	Y	a_424_368##3	1.47928e-17
C160	B1	B1#6	2.86916e-19
C161	B1	B1#1	3.05429e-18
C162	VPWR	A2_N#6	1.96515e-18
C163	VGND	VGND#4	4.50376e-17
C164	VPWR	a_212_102##9	2.5613e-18
C165	a_424_368#	VPWR#7	5.9475e-17
C166	Y	VGND#8	3.45354e-17
C167	A2_N#2	a_212_102##4	1.95452e-17
C168	Y	a_615_74##4	1.64848e-17
C169	A1_N#1	a_209_392#	2.41308e-17
C170	VPWR	B1#9	1.10987e-18
C171	A2_N#3	a_209_392#	2.3145e-17
C172	A2_N	A1_N#2	4.68718e-18
C173	VPWR	a_424_368##2	3.97839e-18
C174	VGND#3	A1_N#3	1.533e-19
C175	VGND#4	VGND#8	1.55021e-18
C176	Y#4	B2	5.38983e-18
C177	VPWR	VPWR#3	2.25563e-17
C178	B2	a_424_368##3	8.74133e-18
C179	a_212_102##3	VNB	2.95427e-17
C180	a_212_102##9	Y	1.7164e-17
C181	B2#4	VNB	5.25828e-17
C182	B1#2	VNB	3.77487e-17
C183	VGND#8	a_212_102##3	1.34576e-18
C184	VGND#3	a_212_102##4	4.02479e-20
C185	B2#3	B1#3	1.01838e-18
C186	VPWR#4	a_212_102##4	2.0449e-19
C187	A1_N#1	A2_N#2	2.0785e-17
C188	B1	a_424_368#	1.26295e-17
C189	A2_N#2	a_212_102##5	9.87884e-19
C190	Y#1	a_424_368##3	9.59075e-19
C191	a_615_74##2	B1	2.19397e-17
C192	a_212_102##10	A2_N	2.90056e-17
C193	VGND#10	a_212_102##10	5.74113e-17
C194	B2#3	a_212_102#	8.97068e-19
C195	a_615_74#	B1	2.51401e-17
C196	A1_N#3	A1_N#2	5.17176e-18
C197	A2_N#2	a_212_102##3	2.97874e-19
C198	B2	a_424_368##2	2.93069e-17
C199	VGND#10	VGND#9	3.66164e-18
C200	A1_N#2	A2_N#2	1.57388e-17
C201	A2_N#6	a_212_102##11	1.82588e-17
C202	VGND#3	a_212_102#	3.36164e-19
C203	VPWR#4	a_212_102##5	4.47531e-18
C204	B2#6	B1#3	6.51373e-19
C205	VPWR#4	a_212_102#	4.48015e-18
C206	A1_N#1	A2_N#3	6.74011e-17
C207	A2_N#1	a_212_102##4	2.15145e-18
C208	a_212_102##10	VGND#9	3.07728e-17
C209	VGND#4	A1_N#2	1.81749e-18
C210	B1	a_424_368##2	3.39985e-17
C211	A2_N#3	a_212_102##5	4.97101e-18
C212	VPWR#9	A1_N#3	7.01177e-19
C213	a_615_74##4	B2#4	3.23049e-19
C214	a_212_102##10	Y#3	2.52906e-18
C215	VGND#3	A1_N#2	2.07837e-19
C216	a_212_102##9	a_212_102##11	3.14846e-18
C217	a_212_102##4	a_212_102##3	1.24249e-18
C218	a_212_102##5	a_212_102#	4.71011e-17
C219	VGND#4	A2_N#1	4.60515e-18
C220	a_424_368##5	a_212_102##3	2.93902e-18
C221	VGND#9	Y#3	4.62683e-17
C222	a_212_102##11	A2_N#2	5.33667e-18
C223	VGND#3	a_212_102##7	6.66922e-19
C224	a_424_368##5	A2_N#2	3.38966e-20
C225	VGND#3	a_212_102##6	5.96607e-18
C226	a_212_102#	B2#5	4.70798e-17
C227	Y#4	A2_N#2	1.83234e-19
C228	a_212_102##9	a_424_368##5	1.67691e-17
C229	VGND#9	VGND#8	1.81913e-18
C230	VGND#3	B2#7	6.85656e-18
C231	a_424_368##5	a_212_102##4	5.42955e-18
C232	VGND#4	a_212_102##7	8.86539e-18
C233	VGND#3	B2#1	1.27401e-19
C234	VGND#10	A1_N#3	4.30615e-17
C235	B2#5	B2#6	4.72712e-17
C236	VGND#3	B1#5	5.7082e-20
C237	a_212_102##10	A1_N#3	4.95229e-19
C238	a_212_102##9	Y#4	5.71653e-18
C239	Y#1	B2#4	3.0549e-18
C240	Y#3	VGND#8	3.61403e-17
C241	a_615_74#	a_424_368#	1.52539e-17
C242	Y	a_212_102##3	1.74293e-17
C243	B2#6	B1#6	4.77458e-17
C244	Y	B2#4	9.01348e-18
C245	a_212_102##10	A2_N#2	2.35905e-18
C246	VGND#4	a_212_102##6	9.67716e-19
C247	Y#4	a_212_102##3	7.5292e-18
C248	Y	B1#2	2.63568e-19
C249	VGND#9	A2_N#2	4.23578e-19
C250	B2#3	B2#4	1.23611e-17
C251	B1#9	a_424_368##2	1.88231e-17
C252	B1#6	B1#1	4.63153e-17
C253	Y#3	Y#1	1.25673e-18
C254	VGND#8	a_615_74##4	2.05252e-17
C255	a_212_102##11	VPWR#4	9.78766e-18
C256	VGND#4	B2#7	8.67813e-20
C257	Y#3	a_212_102##4	3.39645e-18
C258	a_424_368##5	VPWR#4	6.21131e-17
C259	Y#4	B2#4	6.39648e-19
C260	B1#3	VPWR#7	1.16635e-18
C261	VPWR#9	A1_N#1	5.23456e-17
C262	VGND#8	Y#1	2.12518e-18
C263	a_615_74##2	B2#4	2.14865e-19
C264	a_424_368##3	VPWR#4	1.47054e-17
C265	VPWR#9	A2_N#3	1.1501e-17
C266	a_212_102##11	A1_N#1	1.22965e-17
C267	a_424_368##5	A1_N#1	7.56753e-19
C268	VGND#8	a_615_74##2	1.32501e-18
C269	a_615_74##4	Y#1	2.0727e-17
C270	A2_N#6	A2_N#2	1.23131e-17
C271	VPWR#9	a_212_102##5	4.59456e-19
C272	a_212_102##11	A2_N#3	7.32425e-17
C273	B2#3	Y#1	4.04858e-17
C274	B2#4	B1#3	2.85081e-17
C275	B1#3	B1#2	4.03955e-18
C276	a_424_368##5	A2_N#3	2.83402e-18
C277	a_212_102##9	A2_N#2	8.10092e-18
C278	VPWR#9	a_212_102#	3.4801e-20
C279	VGND#8	VGND#7	5.35373e-19
C280	a_212_102##11	a_212_102##5	2.01851e-18
C281	A2_N#6	a_212_102##4	3.59031e-18
C282	A1_N#2	A2_N#1	3.38902e-17
C283	VGND#3	Y#3	4.57919e-18
C284	a_424_368##3	B2#4	8.47658e-20
C285	a_212_102##10	A2_N#6	1.9485e-17
C286	a_424_368##5	a_212_102##5	3.35124e-17
C287	a_424_368##3	A2_N#3	6.18316e-20
C288	a_615_74##2	B1#3	7.17523e-19
C289	A1_N#2	a_212_102##7	1.14107e-18
C290	Y#4	a_212_102##5	4.63477e-17
C291	VGND#3	a_615_74##4	2.31601e-17
C292	VGND#7	B1#3	9.54117e-19
C293	a_615_74##2	Y#1	4.69575e-17
C294	VPWR#8	A2_N#3	8.14327e-20
C295	a_212_102##9	a_212_102##4	2.38627e-17
C296	a_424_368##5	a_212_102#	1.14939e-17
C297	a_615_74#	B1#3	2.11436e-18
C298	A2_N#1	a_212_102##7	2.90675e-17
C299	a_424_368##3	a_212_102##5	2.32722e-18
C300	B2	a_212_102##3	7.90737e-20
C301	VGND#3	a_212_102##3	1.3325e-20
C302	B2	B2#4	1.0897e-17
C303	a_212_102#	Y#4	2.11869e-17
C304	VPWR#8	a_212_102##5	2.91198e-19
C305	VGND#7	B1#2	6.49469e-20
C306	a_424_368##3	a_212_102#	5.66896e-17
C307	a_212_102##3	B2#4	1.62206e-18
C308	Y#4	B2#5	3.76557e-19
C309	a_212_102##7	a_212_102##6	4.00039e-17
C310	VPWR#8	a_212_102#	2.01946e-18
C311	a_424_368##3	a_424_368##2	1.27996e-18
C312	a_424_368##3	B2#5	3.36098e-17
C313	a_615_74##2	VGND#7	5.04778e-17
C314	VGND#4	a_212_102##9	4.81764e-19
C315	a_424_368##6	a_212_102#	6.41938e-20
C316	B2#4	VPWR#8	1.26774e-18
C317	VPWR#8	B2#5	4.5309e-17
C318	a_212_102##6	B2#7	3.48344e-18
C319	a_424_368##3	B2#6	6.27323e-19
C320	a_424_368##6	B2#5	1.48819e-19
C321	a_424_368##2	VPWR#8	2.47386e-17
C322	a_424_368#	a_212_102#	4.67943e-20
C323	a_615_74##2	a_615_74#	2.67476e-18
C324	VPWR#9	A1_N#2	9.61615e-19
C325	VPWR#8	B2#6	5.15917e-17
C326	a_212_102##9	VGND#9	3.09083e-17
C327	VPWR#4	a_212_102##3	3.50141e-20
C328	B1	B2#4	1.03477e-17
C329	a_424_368##3	B1#6	2.9432e-19
C330	B1#9	B1#3	1.03279e-17
C331	B1	B1#2	1.466e-17
C332	B2#6	a_424_368##6	2.57546e-17
C333	a_615_74#	B1#2	2.06019e-19
C334	a_424_368#	B2#5	6.72138e-20
C335	VGND#4	A2_N#2	5.09599e-20
C336	B2#7	B2#1	3.95622e-17
C337	a_615_74#	VGND#7	5.80956e-17
C338	VPWR#8	B1#6	2.13205e-18
C339	a_424_368##2	a_424_368##6	4.82665e-18
C340	VPWR#7	B2#6	2.64683e-18
C341	a_424_368##3	B1#1	6.72138e-20
C342	a_212_102##9	Y#3	3.11589e-17
C343	B1#6	a_424_368##6	2.10613e-17
C344	a_212_102##9	VPWR#4	3.3799e-19
C345	a_424_368#	B2#6	2.9432e-19
C346	a_424_368##2	B1#3	1.57151e-18
C347	VPWR#7	B1#6	4.58468e-17
C348	B2#1	B1#5	4.00518e-17
C349	a_424_368##6	B1#1	3.08444e-19
C350	VGND#4	a_212_102##4	4.32192e-20
C351	a_424_368##2	VPWR#7	2.49398e-17
C352	a_424_368#	B1#6	1.31273e-18
C353	a_424_368##3	VPWR#3	1.35443e-17
C354	VPWR#7	B1#1	4.75539e-17
C355	a_424_368##2	B2#4	1.85303e-18
C356	a_424_368#	B1#1	3.82978e-17
C357	B1#5	B1#4	3.67853e-17
C358	a_424_368##2	a_424_368#	1.27996e-18
C359	a_212_102##9	A1_N#1	1.15168e-19
C360	a_424_368##2	VPWR#3	3.13618e-19
C361	a_212_102##6	B2#4	1.0757e-19
C362	a_424_368##2	B1#2	1.56035e-19
C363	A2_N#6	a_212_102##5	1.97408e-19
C364	a_424_368##6	VPWR#3	5.25459e-18
C365	VGND#10	A1_N#2	1.61042e-17
C366	B1#2	VPWR#7	1.16568e-19
C367	a_212_102##9	a_212_102##5	1.00964e-18
C368	A2_N#6	a_212_102##3	7.06513e-20
C369	a_212_102##10	A1_N#2	4.93666e-17
C370	VPWR#4	VPWR#3	3.87797e-17
C371	VGND#10	A2_N#1	7.35309e-19
C372	VGND#3	VGND#4	4.0377e-17
C373	VGND#9	A1_N#2	2.42244e-18
C374	VPWR#9	a_212_102##11	3.54226e-17
C375	a_212_102##10	A2_N#1	3.34394e-17
C376	Y#3	A1_N#2	2.2399e-19
C377	VGND#10	a_212_102##7	3.46554e-19
C378	A2_N#1	VGND#9	1.79212e-17
C379	VPWR#9	a_424_368##5	1.70958e-18
C380	a_212_102##10	a_212_102##7	1.11723e-18
C381	Y#3	A2_N#1	4.92403e-19
C382	VGND#9	a_212_102##7	3.75278e-17
C383	a_212_102##10	a_212_102##6	1.88123e-19
C384	a_212_102##7	Y#3	1.94773e-17
C385	a_212_102##11	a_424_368##5	1.06803e-16
C386	VGND#9	a_212_102##6	1.47898e-18
C387	VGND#8	a_212_102##7	1.53374e-18
C388	a_615_74##2	B1#9	1.5983e-17
C389	a_212_102##11	Y#4	5.31317e-19
C390	Y#3	a_212_102##6	1.42106e-17
C391	VGND#8	a_212_102##6	4.13831e-17
C392	a_424_368##5	Y#4	9.75921e-17
C393	a_424_368##2	a_212_102#	9.78956e-20
C394	Y#1	a_212_102##7	1.17001e-19
C395	Y#3	B2#7	3.07414e-19
C396	a_615_74##4	a_212_102##6	5.94645e-19
C397	a_424_368##5	a_424_368##3	2.52464e-18
C398	a_212_102##9	A2_N#6	3.3462e-17
C399	VGND#8	B2#7	3.4062e-18
C400	Y#1	a_212_102##6	8.1876e-19
C401	a_424_368##2	B2#5	2.26949e-19
C402	a_615_74##4	B2#7	4.08126e-17
C403	Y#4	a_424_368##3	6.99583e-17
C404	a_615_74#	B1#9	3.47766e-18
C405	a_615_74##2	a_212_102##6	1.63709e-19
C406	VGND#8	B2#1	3.18488e-19
C407	Y#1	a_424_368##2	1.51529e-18
C408	VGND#10	VPWR#9	9.16647e-18
C409	B1#9	B1#6	1.78262e-18
C410	Y#1	B2#7	3.10213e-17
C411	B2#4	B1#5	8.13667e-19
C412	VGND#7	a_212_102##6	7.51943e-20
C413	a_424_368##2	B2#6	2.25039e-17
C414	a_615_74##2	B2#7	3.75411e-19
C415	VGND#8	B1#5	1.98126e-19
C416	a_424_368##3	VPWR#8	6.49595e-17
C417	Y#1	B2#1	3.12168e-17
C418	a_615_74##2	a_424_368##2	1.16657e-18
C419	a_212_102##9	A1_N#2	5.83918e-19
C420	VGND#7	B2#7	2.53438e-19
C421	VGND#2	B1#5	5.40872e-18
C422	A2_N#6	VPWR#5	3.09499e-19
C423	A2_N	VPWR#5	1.26569e-18
C424	VGND#5	a_212_102##7	7.2591e-19
C425	VGND#8	VGND#2	1.42766e-19
C426	VPWR#2	B1#6	1.83922e-18
C427	VPWR#4	VPWR#5	7.31326e-17
C428	VPWR#5	A1_N#1	4.64969e-18
C429	VPWR#3	VPWR#2	1.22166e-18
C430	VGND	VGND#2	6.29836e-17
C431	VPWR	VPWR#2	3.4652e-17
C432	VPWR#4	VPWR#2	5.31309e-17
C433	VGND#2	a_212_102##6	1.29621e-19
C434	VGND#5	a_212_102##10	4.31373e-18
C435	VGND	VGND#5	4.96491e-17
C436	VPWR#2	VNB	4.8165e-17
C437	VGND#2	B2#1	6.57649e-18
C438	VPWR#5	VNB	7.16261e-17
C439	VPWR	VPWR#5	5.40217e-17
C440	a_424_368#	VPWR#2	1.78953e-17
C441	VPWR#2	B1#1	1.84209e-18
C442	a_424_368##6	VPWR#2	5.20514e-18
C443	VGND#2	B1#4	6.07494e-18
C444	VPWR#5	A2_N#2	4.75801e-20
C445	VGND#5	A1_N#3	4.36199e-17
C446	VGND#3	VGND#5	5.25903e-17
C447	VGND#2	a_615_74##4	5.38079e-18
C448	VGND#2	VNB	6.63652e-17
C449	VGND#5	VGND#4	2.28791e-18
C450	VPWR#5	A2_N#3	7.71765e-18
C451	VGND#5	VNB	4.59601e-17
C452	VGND#2	B2#4	9.57745e-20
C453	VGND#2	a_615_74##2	2.30246e-17
C454	VGND#3	VGND#2	7.37882e-17
C455	a_424_368##2	VPWR#2	3.13618e-19
C456	a_212_102##11	VPWR#5	1.56747e-17
C457	VGND#5	A1_N#2	9.95601e-18
C458	VGND#2	B2#7	4.50094e-19
C459	VGND#2	a_615_74#	2.10747e-17
*
*
.ENDS sky130_fd_sc_hs__a2bb2oi_2
*
