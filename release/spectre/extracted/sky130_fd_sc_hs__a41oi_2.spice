* Extracted by Quantus, converted by sky130cad/quantus.py
*
*
*
*                       LINUX           Wed Nov 18 08:15:49 2026
*
*
*
*  PROGRAM  advgen
*
*  Name           : advgen - Quantus - (64-bit)
*  Version        : 25.1.0-p047
*  Build Date     : Thu Dec 11 23:20:30 PST 2025
*
*  HSPICE LIBRARY
*
*  OPERATING_TEMPERATURE 150
*  QRC_TECH_DIR <path>/tech
*
*
*

*
.SUBCKT sky130_fd_sc_hs__a41oi_2 VPB VNB VGND VPWR Y A2 B1 A3 A4 A1
*
*
*  caps2d version: 10
*
*
*       TRANSISTOR CARDS
*
*
XM2 VGND#4 B1#5 Y#3 VNB sky130_fd_pr__nfet_01v8_lvt l=0.15 w=0.74 ad=0.2627 as=0.2109 pd=2.19 ps=2.05
XM9 a_239_74##4 A1#6 Y#1 VNB sky130_fd_pr__nfet_01v8_lvt l=0.15 w=0.74 ad=0.2109 as=0.2072 pd=2.05 ps=2.04
XM14 Y#1 A1#5 a_239_74##2 VNB sky130_fd_pr__nfet_01v8_lvt l=0.15 w=0.74 ad=0.2072 as=0.259 pd=2.04 ps=2.18
XM5 a_512_74##2 A2#4 a_239_74##2 VNB sky130_fd_pr__nfet_01v8_lvt l=0.15 w=0.74 ad=0.2072 as=0.259 pd=2.04 ps=2.18
XM10 a_239_74# A2#5 a_512_74##2 VNB sky130_fd_pr__nfet_01v8_lvt l=0.15 w=0.74 ad=0.2109 as=0.2072 pd=2.05 ps=2.04
XM6 a_512_74# A3#6 a_709_74##3 VNB sky130_fd_pr__nfet_01v8_lvt l=0.15 w=0.74 ad=0.2072 as=0.2109 pd=2.04 ps=2.05
XM1 a_709_74##4 A3#1 a_512_74# VNB sky130_fd_pr__nfet_01v8_lvt l=0.15 w=0.74 ad=0.2072 as=0.2072 pd=2.04 ps=2.04
XM3 a_709_74##4 A4#4 VGND#5 VNB sky130_fd_pr__nfet_01v8_lvt l=0.15 w=0.74 ad=0.2072 as=0.2442 pd=2.04 ps=2.14
XM16 VGND#5 A4#1 a_709_74# VNB sky130_fd_pr__nfet_01v8_lvt l=0.15 w=0.74 ad=0.2442 as=0.2257 pd=2.14 ps=2.09
XM0 a_27_368##8 B1#4 Y#4 VPB sky130_fd_pr__pfet_01v8 l=0.15 w=1.12 ad=0.3304 as=0.392 pd=2.83 ps=2.94
XM7 Y#4 B1#1 a_27_368##6 VPB sky130_fd_pr__pfet_01v8 l=0.15 w=1.12 ad=0.392 as=0.392 pd=2.94 ps=2.94
XM13 a_27_368##6 A1#4 VPWR#9 VPB sky130_fd_pr__pfet_01v8 l=0.15 w=1.12 ad=0.392 as=0.6608 pd=2.94 ps=3.42
XM18 VPWR#9 A1#1 a_27_368##4 VPB sky130_fd_pr__pfet_01v8 l=0.15 w=1.12 ad=0.6608 as=0.336 pd=3.42 ps=2.84
XM11 VPWR#7 A2#6 a_27_368##4 VPB sky130_fd_pr__pfet_01v8 l=0.15 w=1.12 ad=0.448 as=0.336 pd=3.04 ps=2.84
XM12 a_27_368##10 A2#1 VPWR#7 VPB sky130_fd_pr__pfet_01v8 l=0.15 w=1.12 ad=0.336 as=0.448 pd=2.84 ps=3.04
XM15 VPWR#6 A3#4 a_27_368##10 VPB sky130_fd_pr__pfet_01v8 l=0.15 w=1.12 ad=0.448 as=0.336 pd=3.04 ps=2.84
XM17 a_27_368##9 A3#5 VPWR#6 VPB sky130_fd_pr__pfet_01v8 l=0.15 w=1.12 ad=0.4312 as=0.448 pd=3.01 ps=3.04
XM4 a_27_368##9 A4#6 VPWR#5 VPB sky130_fd_pr__pfet_01v8 l=0.15 w=1.12 ad=0.4312 as=0.336 pd=3.01 ps=2.84
XM8 VPWR#5 A4#5 a_27_368# VPB sky130_fd_pr__pfet_01v8 l=0.15 w=1.12 ad=0.336 as=0.3584 pd=2.84 ps=2.88
*
*
*       RESISTOR AND CAP/DIODE CARDS
*
Rg1	B1#1	B1#2	468.258911
Rg2	B1#2	B1#3	30.613651
Rg3	B1#3	B1#4	454.195099
Rg4	B1#3	B1#5	385.711578
Rg5	A1#1	A1#2	511.412872
Rg6	A1#2	A1#3	65.146400
Rg7	A1#3	A1#4	432.936401
Rg8	A1#2	A1#5	369.205597
Rg9	A1#3	A1#6	390.297302
Rg10	A2#1	A2#2	479.431183
Rg11	A2#2	A2#3	39.319511
Rg12	A2#3	A2#4	362.881927
Rg13	A2#2	A2#5	302.902252
Rg14	A2#3	A2#6	442.567169
Rg15	A3#1	A3#2	377.027313
Rg16	A3#2	A3#3	109.264427
Rg17	A3#3	A3#4	562.551208
Rg18	A3#2	A3#5	429.126801
Rg19	A3#3	A3#6	357.389252
Rg20	A4#1	A4#2	402.789612
Rg21	A4#2	A4#3	43.410355
Rg22	A4#3	A4#4	397.555725
Rg23	A4#2	A4#5	451.603058
Rg24	A4#3	A4#6	449.655212
Rf1	B1#6	B1	1.048652
Rf2	B1#7	B1	1.048652
Rf3	B1#6	B1#7	14.668931
Rf4	B1#2	B1#9	81.165054
Rf5	B1#7	B1#9	0.916808
Rf6	A1#3	A1#8	162.093903
Rf7	A1#9	A1	1.861096
Rf8	A1#8	A1#9	5.161376
Rf9	Y#1	Y#2	27.816257
Rf10	Y#2	Y#3	88.278931
Rf11	Y#2	Y	21.523798
Rf12	Y	Y#4	147.299500
Rf13	a_239_74#	a_239_74##3	78.537254
Rf14	a_239_74##3	a_239_74##4	97.649902
Rf15	a_239_74##2	a_239_74##3	7.500000
Rf16	A2#2	A2	82.177834
Rf17	a_512_74#	a_512_74##2	100.350815
Rf18	A3#7	A3	1.409262
Rf19	A3#2	A3#9	161.642059
Rf20	A3#7	A3#9	5.042445
Rf21	A3#10	A3	1.409262
Rf22	A3#9	A3#10	9.626486
Rf23	A4#7	A4	1.409262
Rf24	A4#2	A4#9	161.642059
Rf25	A4#7	A4#9	1.528014
Rf26	A4#10	A4	1.409262
Rf27	A4#9	A4#10	13.140918
Rf28	a_27_368#	a_27_368##2	88.814140
Rf29	a_27_368##2	a_27_368##3	74.261650
Rf30	a_27_368##3	a_27_368##5	81.076653
Rf31	a_27_368##5	a_27_368##7	80.951668
Rf32	a_27_368##7	a_27_368##8	101.532333
Rf33	a_27_368##2	a_27_368##9	16.283215
Rf34	a_27_368##3	a_27_368##10	18.602406
Rf35	a_27_368##4	a_27_368##5	5.000000
Rf36	a_27_368##6	a_27_368##7	7.500000
Rf37	a_709_74#	a_709_74##2	83.296364
Rf38	a_709_74##2	a_709_74##3	55.157803
Rf39	a_709_74##2	a_709_74##4	18.542366
Rf41	VPWR#2	VPWR#3	75.558197
Rf42	VPWR#3	VPWR#4	81.463295
Rf43	VPWR#2	VPWR#5	32.026825
Rf44	VPWR#3	VPWR#6	32.420494
Rf45	VPWR#4	VPWR#7	35.918396
Rf46	VPWR#4	VPWR#8	73.356918
Rf47	VPWR#8	VPWR#9	26.842010
Rf50	VGND#2	VGND#3	153.381516
Rf51	VGND#3	VGND#4	223.106125
Rf52	VGND#2	VGND#5	38.247387
Re1	VPWR#4	VPWR	0.818510
Re2	VGND	VGND#3	0.818540
*
*       CAPACITOR CARDS
*
*
C1	a_27_368##3	VPWR#3	1.6661e-19
C2	a_512_74#	a_709_74##3	4.47241e-17
C3	a_239_74#	a_709_74##4	2.819e-18
C4	A1#2	VPWR#9	1.52741e-18
C5	B1#9	Y#3	4.08157e-17
C6	a_27_368##2	VPWR#3	1.6661e-19
C7	a_709_74##2	A4#1	6.86473e-19
C8	VPWR#4	A2#3	1.78313e-20
C9	a_239_74#	a_709_74##3	2.21493e-17
C10	A1#8	B1#3	2.68325e-18
C11	a_709_74##2	A4#4	2.41777e-17
C12	a_27_368##6	A1#2	1.52256e-19
C13	a_239_74##2	a_512_74#	1.06576e-18
C14	a_27_368##6	B1#3	1.14459e-20
C15	a_239_74#	a_512_74##2	6.10266e-17
C16	a_709_74##2	A3#1	2.10137e-17
C17	VGND#3	A3#3	9.0275e-20
C18	VGND#3	A2#3	4.73874e-19
C19	VGND#3	A1#2	1.30211e-19
C20	a_709_74#	a_27_368#	3.21086e-19
C21	a_239_74##2	a_512_74##2	3.74161e-17
C22	a_709_74##2	a_27_368##2	4.44458e-18
C23	B1#3	Y#4	4.03774e-18
C24	B1#9	B1#3	1.65547e-17
C25	a_239_74##2	Y#1	3.83993e-17
C26	a_239_74##4	a_239_74##2	2.79219e-18
C27	a_27_368##8	B1#3	2.33497e-19
C28	Y#2	Y#4	2.70943e-18
C29	A3#2	A4#3	2.54882e-17
C30	a_239_74##4	Y#1	3.99301e-17
C31	A3#3	A3#2	6.86381e-18
C32	a_27_368##3	a_27_368##2	5.35499e-19
C33	Y#3	Y#1	2.06773e-18
C34	a_709_74#	A4#3	1.61986e-18
C35	Y#3	a_239_74##4	4.69381e-17
C36	VGND#4	a_239_74##4	2.85826e-17
C37	A2#2	A2#3	2.32521e-17
C38	B1#9	Y#4	3.68213e-17
C39	A2#2	A1#2	4.06489e-18
C40	VGND#4	Y#3	8.55192e-17
C41	a_709_74##2	A4#3	3.07159e-18
C42	VGND#5	A4#3	1.35209e-18
C43	Y#2	A3#6	5.78791e-19
C44	A1#3	A1#2	2.44321e-18
C45	A4#9	a_27_368##2	2.95637e-18
C46	a_239_74#	a_27_368##4	5.30918e-20
C47	B1#3	A1#3	1.68585e-17
C48	a_709_74##2	A3#9	1.62952e-17
C49	VPWR#3	A3#5	2.52277e-18
C50	Y#2	A2#5	1.25806e-18
C51	a_27_368#	VPWR#5	7.037e-17
C52	a_709_74#	A4#1	4.87381e-17
C53	a_239_74##2	a_27_368##4	8.96353e-18
C54	Y#2	A2#4	4.25032e-18
C55	a_27_368##2	A4#5	1.86548e-19
C56	a_27_368##9	a_27_368#	2.01529e-18
C57	VPWR#3	A3#4	2.58443e-18
C58	A4#1	VGND#5	1.82195e-17
C59	a_709_74#	A4#4	1.66832e-18
C60	A2#3	A3#6	3.82199e-18
C61	a_27_368##9	VPWR#5	6.42475e-17
C62	Y#2	A1#5	1.57601e-17
C63	a_27_368##2	A4#6	2.13929e-17
C64	VGND#5	A4#4	3.20502e-17
C65	A4#9	A4#5	2.0286e-18
C66	a_709_74#	A3#1	2.02452e-19
C67	VPWR#6	VPWR#5	1.10863e-18
C68	A4#4	a_709_74##4	1.18148e-17
C69	a_27_368##3	A3#5	1.05439e-19
C70	Y#2	A1#6	1.95747e-17
C71	VGND#5	A3#1	1.3958e-18
C72	VPWR#6	a_27_368##9	6.42475e-17
C73	a_27_368##2	A3#5	1.90722e-17
C74	a_512_74#	A4#4	1.17877e-18
C75	a_512_74#	A3#3	7.91378e-19
C76	A3#1	a_709_74##4	1.70553e-17
C77	VGND#5	A3#6	2.1421e-19
C78	a_27_368##10	a_27_368##9	2.08975e-18
C79	Y#2	B1#5	1.55519e-19
C80	a_27_368##3	A3#4	2.19051e-17
C81	A3#9	a_27_368##2	1.77486e-17
C82	a_512_74#	A3#1	3.08149e-17
C83	a_27_368##2	A3#4	1.07004e-19
C84	a_239_74#	A4#4	2.27883e-19
C85	a_709_74##4	A3#6	3.36439e-19
C86	a_27_368##10	VPWR#6	6.22197e-17
C87	VGND#5	A2#5	9.43284e-20
C88	a_512_74#	A3#6	4.23e-17
C89	Y#3	Y#4	4.77763e-18
C90	a_27_368##3	A2#1	1.83872e-17
C91	a_239_74#	A3#1	3.21943e-19
C92	a_709_74##4	A2#5	1.42554e-19
C93	VPWR#7	VPWR#6	1.69573e-18
C94	a_709_74##3	A3#6	4.72552e-17
C95	a_27_368##3	A3#3	1.95884e-18
C96	a_709_74##3	A3#3	4.51266e-18
C97	a_512_74#	A2#5	5.13638e-19
C98	VPWR#7	a_27_368##10	6.22435e-17
C99	a_239_74#	A3#6	2.38035e-18
C100	a_709_74##4	A2#4	2.94903e-21
C101	A2#4	A2#3	1.16626e-18
C102	A3#9	A3#5	1.99315e-18
C103	a_27_368##3	A2#6	1.08011e-19
C104	a_709_74##3	A2#5	1.81196e-18
C105	a_239_74##2	A3#1	2.97581e-19
C106	VGND#4	a_27_368##8	3.66633e-19
C107	a_27_368##4	a_27_368##10	2.07064e-18
C108	a_512_74#	A2#4	1.47736e-19
C109	a_27_368##2	A4#3	1.72216e-18
C110	a_27_368##3	A2#3	2.19373e-18
C111	a_239_74#	A2#5	4.7503e-17
C112	a_239_74##2	A3#6	6.06079e-19
C113	a_709_74##3	A2#4	2.35216e-19
C114	a_27_368##4	VPWR#7	7.24908e-17
C115	a_512_74##2	A2#5	3.75383e-17
C116	a_512_74#	A1#5	1.07482e-19
C117	a_239_74#	A2#4	1.27644e-18
C118	a_27_368##2	A3#3	1.88412e-19
C119	a_239_74##2	A2#5	1.51438e-18
C120	VPWR#9	VPWR#7	1.8257e-18
C121	a_709_74##3	A1#5	1.73359e-19
C122	a_512_74##2	A2#4	2.55004e-17
C123	A1#5	A2#3	1.97194e-18
C124	a_239_74#	A1#5	5.73134e-19
C125	a_27_368##4	VPWR#9	5.78808e-17
C126	a_239_74#	A2#3	1.05454e-17
C127	a_239_74##2	A2#4	3.4724e-17
C128	a_512_74##2	A1#5	5.74174e-19
C129	a_27_368##6	a_27_368##4	2.45038e-18
C130	Y#1	A2#4	5.14037e-19
C131	a_239_74##2	A1#5	3.43928e-17
C132	a_239_74##4	A2#4	2.17549e-19
C133	a_27_368##6	VPWR#9	6.76358e-17
C134	Y#4	a_27_368##4	4.01559e-19
C135	Y#1	A1#5	2.50191e-17
C136	a_239_74##2	A1#6	4.2716e-19
C137	Y#4	VPWR#9	1.3198e-18
C138	a_239_74##4	A1#5	1.10108e-18
C139	VGND#4	A2#4	5.14245e-20
C140	A1#6	Y#1	1.2976e-17
C141	a_512_74##2	A2#3	2.9556e-18
C142	Y#3	A1#5	1.87738e-19
C143	VPWR#4	VPWR#3	4.17392e-17
C144	a_27_368##6	Y#4	1.10622e-16
C145	a_239_74##4	A1#6	5.01861e-17
C146	VGND#4	A1#5	5.20108e-20
C147	Y#1	B1#5	4.43522e-19
C148	a_27_368##8	a_27_368##6	2.59148e-18
C149	Y#3	A1#6	1.88334e-18
C150	a_239_74##4	B1#5	3.02989e-18
C151	VGND#4	A1#6	1.49303e-18
C152	a_27_368##8	Y#4	9.30523e-17
C153	Y#3	B1#5	5.36161e-17
C154	VGND#4	B1#5	3.85335e-17
C155	a_239_74##2	A2#3	7.48991e-19
C156	a_27_368##3	VPWR#4	1.6661e-19
C157	A4#9	A4#3	1.02516e-17
C158	a_239_74##2	A1#2	1.81455e-18
C159	a_709_74##2	a_709_74#	2.88543e-18
C160	A4#4	A4#1	2.76149e-17
C161	VPWR#3	A3#2	3.64865e-20
C162	a_27_368#	A4#5	3.66846e-17
C163	A1	B1#3	1.59408e-18
C164	a_709_74##2	VGND#5	2.00249e-17
C165	VPWR#5	A4#5	4.73348e-17
C166	B1#9	B1#1	2.00091e-18
C167	a_27_368#	A4#6	8.41012e-19
C168	A3#1	A4#4	4.15629e-17
C169	a_27_368##9	A4#5	7.32544e-19
C170	a_709_74##2	A3#2	1.14447e-18
C171	VPWR#5	A4#6	4.57637e-17
C172	a_27_368#	A3#5	1.94797e-19
C173	a_709_74##2	a_709_74##4	8.71223e-19
C174	A4#6	a_27_368##9	2.14914e-17
C175	VPWR#5	A3#5	1.20797e-18
C176	A3#6	A3#1	4.03903e-17
C177	A4	A4#3	1.74996e-17
C178	a_27_368##2	A3#2	2.88857e-18
C179	VPWR#6	A4#6	6.69117e-19
C180	a_27_368##9	A3#5	5.13627e-17
C181	VPWR#5	A3#4	2.27736e-19
C182	A3#5	VPWR#6	3.18551e-17
C183	a_709_74##2	a_512_74#	1.4418e-17
C184	A2#2	a_27_368##3	1.83248e-17
C185	a_27_368##9	A3#4	4.17575e-19
C186	A2#5	A3#6	2.8335e-18
C187	a_27_368##10	A3#5	4.11471e-19
C188	a_27_368##4	A4#6	1.28588e-19
C189	A3#4	VPWR#6	3.62278e-17
C190	a_239_74##4	A1#2	5.16672e-20
C191	VPWR#7	A3#5	2.8528e-19
C192	a_27_368##10	A3#4	5.30654e-17
C193	A3#9	A3#2	1.10188e-17
C194	a_27_368##4	A3#5	1.43971e-19
C195	VPWR#6	A2#1	7.67963e-19
C196	A2#4	A2#5	3.79358e-17
C197	VPWR#7	A3#4	7.67963e-19
C198	A3	A4#3	1.11015e-17
C199	A3	A3#3	5.66375e-18
C200	a_27_368##10	A2#1	4.56211e-17
C201	a_27_368##4	A3#4	2.38093e-19
C202	VPWR#6	A2#6	2.8528e-19
C203	A2#1	VPWR#7	3.19803e-17
C204	A1#5	A2#4	2.77811e-17
C205	a_27_368##10	A2#6	4.11471e-19
C206	a_27_368##4	A2#1	1.29641e-18
C207	a_709_74#	A4#9	1.95497e-17
C208	A2#6	VPWR#7	3.62278e-17
C209	VPWR#9	A2#1	3.22405e-19
C210	a_27_368##4	A2#6	7.82908e-17
C211	VGND#3	a_512_74#	2.54722e-17
C212	A1#6	A1#5	3.84804e-17
C213	VPWR#7	A1#1	1.2717e-18
C214	VPWR#9	A2#6	8.20841e-19
C215	a_709_74##3	a_27_368##3	4.82776e-18
C216	Y#3	B1#3	9.01577e-18
C217	a_27_368##4	A1#1	7.48323e-17
C218	Y#2	A1#3	8.52292e-18
C219	VPWR#7	A1#4	2.16048e-19
C220	B1	B1#3	2.49001e-17
C221	A1#1	VPWR#9	3.1729e-17
C222	VGND#3	a_512_74##2	4.11808e-17
C223	B1#5	A1#6	4.63435e-18
C224	a_27_368##4	A1#4	1.32863e-18
C225	VGND#3	a_239_74##2	4.43733e-17
C226	a_27_368##6	A1#1	1.02152e-18
C227	Y#2	A1#8	3.20336e-17
C228	A1#8	A1#3	1.1802e-17
C229	A1#4	VPWR#9	3.88026e-17
C230	Y#4	A1#1	6.6465e-20
C231	a_512_74#	A3#2	5.63274e-19
C232	VGND#3	a_239_74##4	2.59018e-17
C233	a_27_368##4	B1#1	5.58948e-20
C234	a_27_368##6	A1#4	6.64322e-17
C235	B1#9	A1#3	6.23591e-18
C236	a_709_74##3	A3#2	1.53766e-18
C237	VPWR#9	B1#1	4.80754e-19
C238	Y#4	A1#4	1.90384e-17
C239	VGND#3	VGND#4	6.27201e-17
C240	a_27_368##6	B1#1	3.66417e-17
C241	a_27_368##8	A1#4	2.82339e-19
C242	VGND#4	B1#3	2.67195e-18
C243	A2	A4#3	5.58311e-19
C244	VPWR#9	B1#4	2.51149e-19
C245	A2	A3#3	1.48305e-17
C246	Y#4	B1#1	5.98925e-17
C247	A2	A2#3	1.62387e-17
C248	a_239_74#	A2#2	2.47122e-17
C249	a_27_368##6	B1#4	7.78931e-19
C250	a_27_368##10	VPWR#4	8.48902e-18
C251	A2#3	A3#4	4.05898e-18
C252	a_27_368##8	B1#1	2.33473e-18
C253	B1#4	Y#4	2.56561e-17
C254	a_27_368##4	VPWR#4	8.85935e-18
C255	a_27_368##8	B1#4	6.03461e-17
C256	A4#6	A4#5	4.63266e-17
C257	VPWR#9	VPWR#4	4.46499e-19
C258	A4#3	VPWR#5	1.29155e-18
C259	A3#2	a_27_368##9	2.52181e-19
C260	A3#5	A4#6	3.16661e-17
C261	a_239_74##4	A1#3	7.31382e-19
C262	A3#2	VPWR#6	6.73497e-19
C263	Y	A3#3	9.11043e-20
C264	Y	A2#3	6.21343e-18
C265	Y	A1#2	3.06972e-17
C266	Y	B1#3	6.80379e-19
C267	VGND#4	A1#3	4.34644e-20
C268	A3#4	A3#5	3.07923e-17
C269	VPWR#3	VPWR#5	1.26119e-19
C270	A2#2	VPWR#7	2.72947e-18
C271	B1#9	A1#8	9.76713e-18
C272	A2#2	a_27_368##4	1.0503e-17
C273	A2#1	A3#4	4.69155e-17
C274	VGND#3	A3#6	2.3134e-18
C275	a_709_74##2	A4	1.57123e-17
C276	a_27_368##9	VPWR#3	9.72638e-18
C277	VGND#3	A2#5	5.16202e-18
C278	A2#6	A2#1	3.14694e-17
C279	A1#3	VPWR#9	1.57975e-18
C280	A4	a_27_368##2	1.95642e-17
C281	VGND#3	A2#4	4.76927e-18
C282	a_27_368##6	A1#3	5.74752e-19
C283	VGND#3	A1#5	4.47785e-18
C284	Y#4	A1#3	1.39341e-18
C285	VGND#3	A1#6	4.47785e-18
C286	A1#1	A2#6	4.68578e-17
C287	a_709_74##2	A3	3.85409e-17
C288	A3	a_27_368##3	7.8257e-18
C289	A3	a_27_368##2	5.0218e-17
C290	B1#9	A1	9.38273e-18
C291	A1#4	A1#1	1.57574e-17
C292	B1#1	A1#4	3.6285e-17
C293	a_27_368##10	VPWR#3	8.43957e-18
C294	VPWR#6	A3#3	7.04194e-19
C295	VPWR#4	A2#1	2.58065e-18
C296	VGND	A3#3	5.22072e-19
C297	VGND	A2#3	7.46232e-19
C298	a_709_74#	A4	3.35142e-17
C299	VPWR#4	A2#6	2.58073e-18
C300	B1#4	B1#1	3.72553e-17
C301	B1#5	A1#3	3.58063e-19
C302	a_27_368##2	a_27_368#	5.1321e-19
C303	Y#2	a_709_74##3	4.07192e-18
C304	A3#4	A3#2	5.1299e-18
C305	A2	a_27_368##3	6.01089e-17
C306	a_709_74##3	A3	1.2576e-17
C307	Y#2	a_239_74#	3.77934e-18
C308	A2#2	A2#6	1.88012e-18
C309	A4	a_27_368#	3.14501e-17
C310	a_27_368##2	VPWR#5	2.45023e-17
C311	A2#2	A1#1	3.71636e-19
C312	Y#2	A3#3	8.5943e-20
C313	A4#3	VNB	6.70482e-17
C314	A3#3	VNB	2.44856e-17
C315	A2#3	VNB	7.41159e-17
C316	A1#2	VNB	2.84059e-17
C317	A1	Y#4	3.35894e-17
C318	B1#3	VNB	7.18456e-17
C319	A1#3	A1#1	4.75543e-19
C320	VPWR	VPWR#3	2.32891e-17
C321	B1#1	A1#3	1.56443e-19
C322	A4#9	a_27_368#	1.56559e-17
C323	a_27_368##2	a_27_368##9	3.57286e-18
C324	B1	Y#3	1.89936e-17
C325	Y#2	A2#3	2.37409e-18
C326	Y#2	Y	3.54235e-18
C327	a_512_74#	A2	4.41046e-18
C328	B1	VGND#4	3.2144e-17
C329	a_709_74##3	A2	3.25673e-17
C330	VPWR	a_27_368##3	2.88894e-18
C331	a_239_74#	A2	1.4785e-17
C332	A1#8	Y	1.54011e-17
C333	VPWR	a_27_368##2	2.90384e-18
C334	a_512_74##2	A2	1.02324e-18
C335	a_27_368##3	VPWR#6	1.80787e-17
C336	B1#9	Y	3.71198e-18
C337	VPWR	A4#9	1.07602e-18
C338	Y#2	a_239_74##2	2.75195e-17
C339	VGND#3	A1#3	2.49036e-20
C340	VPWR	A3#9	1.08151e-18
C341	Y#2	A1#2	3.02927e-18
C342	A2#3	A3#3	1.99695e-17
C343	a_27_368##2	VPWR#6	1.74526e-17
C344	B1	Y#4	2.01682e-17
C345	VGND	a_709_74##2	4.79917e-18
C346	B1	a_27_368##8	3.04918e-17
C347	VPWR	B1#9	2.15152e-18
C348	A2#2	A1#3	2.16129e-19
C349	A4	A4#5	1.39423e-18
C350	a_27_368##3	a_27_368##10	1.36226e-18
C351	VGND	A4#9	1.16652e-18
C352	A4	A4#6	1.37712e-18
C353	Y#2	Y#1	4.96428e-19
C354	a_709_74#	VGND#5	5.67231e-17
C355	A4	A3#5	1.39745e-19
C356	VGND	A3#9	1.15516e-18
C357	A1	A1#1	2.25379e-19
C358	A3	A4#5	4.55245e-19
C359	Y#2	B1#3	8.83691e-19
C360	A2#3	VPWR#7	1.53742e-18
C361	VGND	Y#2	4.8094e-18
C362	A3	A4#6	1.65523e-18
C363	Y	a_27_368##4	6.24921e-17
C364	VGND	A1#8	2.61565e-18
C365	Y	VPWR#9	5.02527e-18
C366	A3	A3#5	7.59883e-20
C367	A1	B1#1	6.11606e-19
C368	VPWR#3	VNB	3.10625e-17
C369	Y	a_27_368##6	1.09664e-17
C370	VGND	B1#9	2.40027e-18
C371	A3	A3#4	1.7065e-18
C372	VPWR	a_27_368#	1.65026e-17
C373	a_709_74##2	VNB	2.82417e-18
C374	VPWR	VPWR#5	2.26887e-17
C375	Y	a_27_368##8	6.93493e-21
C376	VGND	a_709_74#	1.69254e-17
C377	VPWR	a_27_368##9	1.78353e-17
C378	VGND	a_709_74##4	1.11899e-17
C379	VPWR	VPWR#6	2.09055e-17
C380	VGND	a_512_74#	2.74694e-17
C381	VPWR	a_27_368##10	1.5835e-17
C382	VGND	a_709_74##3	6.31179e-18
C383	a_27_368##3	VPWR#7	2.47039e-17
C384	Y#2	a_239_74##4	1.925e-17
C385	VPWR	VPWR#7	2.08915e-17
C386	A4#9	VNB	1.71663e-18
C387	VGND	a_239_74#	7.57503e-18
C388	VPWR	a_27_368##4	1.96282e-17
C389	VGND	a_512_74##2	2.47078e-17
C390	VGND	a_239_74##2	2.17915e-17
C391	VPWR	VPWR#9	3.09645e-17
C392	A3#9	VNB	1.01145e-18
C393	VGND	Y#1	6.97195e-18
C394	VPWR	a_27_368##6	2.34764e-17
C395	VGND	a_239_74##4	2.19525e-17
C396	VPWR	Y#4	1.1254e-17
C397	VGND	Y#3	1.78831e-17
C398	Y#2	VNB	3.57049e-18
C399	VPWR	a_27_368##8	2.51626e-17
C400	VGND	VGND#4	6.0534e-17
C401	A2	A3#5	4.90954e-19
C402	A2	A3#4	6.02601e-18
C403	A1#8	VNB	3.14175e-19
C404	B1#9	VNB	4.66216e-18
C405	A2	A2#1	2.95197e-18
C406	a_709_74#	VNB	4.36149e-17
C407	B1	B1#4	5.45325e-18
C408	A4	A3#2	1.31332e-18
C409	VGND#5	VNB	8.75857e-19
C410	A1	A1#3	1.17115e-17
C411	VGND	a_27_368##4	4.07208e-18
C412	a_709_74##4	VNB	4.55828e-18
C413	a_512_74#	VNB	9.07892e-18
C414	a_709_74##4	VGND#5	3.97544e-17
C415	a_709_74##3	VNB	3.28886e-18
C416	a_239_74#	VNB	1.58593e-18
C417	a_512_74##2	VNB	6.18484e-18
C418	a_239_74##2	VNB	4.41337e-18
C419	Y	A2#1	1.92255e-19
C420	A3	A3#2	1.11254e-17
C421	VGND	A4#1	4.89486e-19
C422	Y#3	Y#2	3.46614e-19
C423	a_239_74##4	VNB	1.0883e-17
C424	Y	A2#6	3.96845e-19
C425	VGND	A4#4	8.39544e-19
C426	Y#3	VNB	1.6145e-17
C427	VPWR	A4#5	1.35953e-18
C428	VGND#4	VNB	1.01758e-16
C429	VGND	A3#1	1.6231e-18
C430	Y	A1#1	8.94182e-18
C431	a_27_368#	VNB	5.16951e-17
C432	VPWR	A4#6	5.03319e-19
C433	VGND	A3#6	2.57756e-18
C434	a_27_368##4	a_27_368##3	5.43544e-19
C435	VPWR#5	VNB	2.31414e-18
C436	Y	A1#4	1.56452e-18
C437	VGND	A2#5	1.12554e-18
C438	VPWR	A3#5	1.65084e-19
C439	a_27_368##9	VNB	3.12193e-18
C440	VPWR#6	VNB	3.74405e-18
C441	VGND	A2#4	3.88644e-18
C442	Y	B1#1	5.09692e-19
C443	VPWR	A3#4	2.25528e-19
C444	a_27_368##10	VNB	2.1429e-18
C445	VGND	A1#5	1.67649e-18
C446	VPWR#7	VNB	3.74405e-18
C447	VPWR	A2#1	2.07999e-19
C448	Y	B1#4	1.9464e-19
C449	VGND	A1#6	2.48845e-18
C450	a_27_368##4	VNB	4.02452e-18
C451	VPWR	A2#6	1.99367e-19
C452	VPWR#9	VNB	6.06897e-18
C453	VGND	B1#5	7.83239e-18
C454	a_27_368##6	VNB	2.76619e-18
C455	A2	A3#2	1.58274e-18
C456	a_27_368##8	VNB	5.47076e-17
C457	VPWR	A1#4	3.54389e-19
C458	A4#1	VNB	3.10532e-17
C459	a_27_368##4	A2#3	4.76495e-18
C460	VPWR	B1#1	1.51768e-18
C461	A4#4	VNB	2.61459e-17
C462	A3#1	VNB	2.76104e-17
C463	VPWR	B1#4	2.29361e-18
C464	a_512_74#	VGND#5	7.57677e-19
C465	A3#6	VNB	3.36349e-17
C466	A2#5	VNB	2.80737e-17
C467	A2#4	VNB	2.45101e-17
C468	VPWR	VPWR#4	2.31125e-17
C469	A1#5	VNB	2.94989e-17
C470	Y	A2#2	1.9336e-17
C471	A1#6	VNB	3.66381e-17
C472	B1#5	VNB	4.12172e-17
C473	Y	A1#3	1.57503e-18
C474	A4#5	VNB	3.59288e-17
C475	A4#6	VNB	2.98294e-17
C476	A3#5	VNB	3.138e-17
C477	VPWR	A2#2	2.9407e-18
C478	A3#4	VNB	3.73344e-17
C479	A2#1	VNB	3.24196e-17
C480	A3	A4	2.8796e-17
C481	VGND	VGND#3	5.06497e-17
C482	A2#6	VNB	3.46724e-17
C483	A1#1	VNB	3.55086e-17
C484	a_27_368##4	A1#2	5.46626e-19
C485	A1#4	VNB	3.26157e-17
C486	B1#1	VNB	3.41055e-17
C487	VGND	A2#2	2.6368e-18
C488	B1#4	VNB	4.14841e-17
C489	VPWR#4	VNB	2.64084e-16
C490	VGND#3	VNB	3.10938e-16
C491	A1	Y	2.30176e-17
C492	A2	A3	3.0745e-17
C493	a_512_74#	a_709_74##4	2.93241e-17
C494	A3#2	VNB	3.35122e-17
C495	A2#2	VNB	1.54779e-18
C496	VPWR	A1	2.27448e-18
C497	A1#3	VNB	3.45772e-17
C498	VPWR	A4	3.50865e-18
C499	VPWR	A3	3.50085e-18
C500	VGND	A4	3.61068e-18
C501	VPWR	B1	4.1858e-18
C502	A1#2	A2#3	2.19208e-17
C503	VGND	A3	3.14224e-18
C504	VPWR	A2	3.41615e-18
C505	A1	VNB	2.60299e-18
C506	VGND	B1	4.82251e-18
C507	A4	VNB	2.84112e-17
C508	VPWR	Y	4.40136e-18
C509	VGND	A2	5.07235e-18
C510	A3	VNB	6.26718e-18
C511	B1	VNB	2.62534e-17
C512	A2	VNB	5.67336e-18
C513	Y	VNB	8.24966e-19
C514	VPWR	VNB	7.16376e-17
C515	VGND	VNB	8.63124e-17
C516	VPWR#4	VPWR#8	1.0376e-16
C517	VGND#2	A3#1	5.87749e-18
C518	a_27_368##2	VPWR#2	1.6661e-19
C519	VPWR#8	B1#4	4.4526e-18
C520	a_27_368##9	VPWR#2	1.08285e-17
C521	a_27_368#	VPWR#2	2.20773e-17
C522	VPWR#3	VPWR#2	7.49705e-19
C523	VPWR#8	A1#4	2.27736e-18
C524	VGND#2	A4#1	5.88774e-18
C525	VPWR#8	B1#3	3.22505e-20
C526	VGND#2	a_709_74##4	1.04974e-17
C527	VGND#2	A3#2	6.16942e-20
C528	VPWR#2	A4#5	9.77087e-19
C529	VGND	VGND#2	6.89299e-17
C530	VPWR#8	A2#3	2.93427e-20
C531	VGND#2	A3#6	3.39124e-18
C532	VPWR#2	VNB	4.86153e-17
C533	a_27_368##8	VPWR#8	5.88218e-17
C534	VPWR	VPWR#2	3.27147e-17
C535	VGND#2	a_709_74#	2.11553e-17
C536	a_27_368##6	VPWR#8	4.4267e-17
C537	VGND#3	VGND#2	7.90852e-17
C538	VPWR#8	VNB	8.25448e-17
C539	VGND#2	A4#4	5.28587e-18
C540	VPWR#8	B1#1	4.45244e-18
C541	VGND#2	a_512_74#	1.97744e-17
C542	a_27_368##4	VPWR#8	8.53157e-18
C543	VPWR#4	VPWR#2	5.46355e-17
C544	VPWR	VPWR#8	4.95722e-17
C545	VGND#2	VNB	6.88513e-17
C546	VGND#2	A2#5	2.06061e-19
C547	VPWR#8	A1#1	2.55773e-18
C548	VGND#2	a_709_74##2	1.26684e-18
C549	VPWR#2	A4#6	9.78637e-19
*
*
.ENDS sky130_fd_sc_hs__a41oi_2
*
