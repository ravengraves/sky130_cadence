* Extracted by Quantus, converted by sky130cad/quantus.py
*
*
*
*                       LINUX           Wed Nov 18 08:44:03 2026
*
*
*
*  PROGRAM  advgen
*
*  Name           : advgen - Quantus - (64-bit)
*  Version        : 25.1.0-p047
*  Build Date     : Thu Dec 11 23:20:30 PST 2025
*
*  HSPICE LIBRARY
*
*  OPERATING_TEMPERATURE 150
*  QRC_TECH_DIR <path>/tech
*
*
*

*
.SUBCKT sky130_fd_sc_hs__mux2i_4 VPB VNB VGND VPWR Y S A1 A0
*
*
*  caps2d version: 10
*
*
*       TRANSISTOR CARDS
*
*
XM1 a_114_85##5 A1#7 Y#18 VNB sky130_fd_pr__nfet_01v8_lvt l=0.15 w=0.74 ad=0.2072 as=0.2109 pd=2.04 ps=2.05
XM22 a_114_85##5 A1#11 Y#17 VNB sky130_fd_pr__nfet_01v8_lvt l=0.15 w=0.74 ad=0.2072 as=0.2072 pd=2.04 ps=2.04
XM19 Y#17 A1#9 a_114_85##6 VNB sky130_fd_pr__nfet_01v8_lvt l=0.15 w=0.74 ad=0.2072 as=0.2701 pd=2.04 ps=2.21
XM14 Y#12 A1#1 a_114_85##6 VNB sky130_fd_pr__nfet_01v8_lvt l=0.15 w=0.74 ad=0.2072 as=0.2701 pd=2.04 ps=2.21
XM9 Y#12 A0#10 a_475_85##6 VNB sky130_fd_pr__nfet_01v8_lvt l=0.15 w=0.74 ad=0.2072 as=0.259 pd=2.04 ps=2.18
XM4 a_475_85##6 A0#8 Y#10 VNB sky130_fd_pr__nfet_01v8_lvt l=0.15 w=0.74 ad=0.259 as=0.2405 pd=2.18 ps=2.13
XM12 a_475_85##4 A0#6 Y#10 VNB sky130_fd_pr__nfet_01v8_lvt l=0.15 w=0.74 ad=0.2072 as=0.2405 pd=2.04 ps=2.13
XM15 Y#8 A0#5 a_475_85##4 VNB sky130_fd_pr__nfet_01v8_lvt l=0.15 w=0.74 ad=0.2109 as=0.2072 pd=2.05 ps=2.04
XM27 VGND#12 a_1030_268##13 a_475_85##2 VNB sky130_fd_pr__nfet_01v8_lvt l=0.15 w=0.74 ad=0.36 as=0.2072 pd=2.83 ps=2.04
XM8 a_475_85##2 a_1030_268##11 VGND#11 VNB sky130_fd_pr__nfet_01v8_lvt l=0.15 w=0.74 ad=0.2072 as=0.4063 pd=2.04 ps=2.98
XM2 VGND#11 a_1030_268##9 a_475_85# VNB sky130_fd_pr__nfet_01v8_lvt l=0.15 w=0.74 ad=0.4063 as=0.2072 pd=2.98 ps=2.04
XM23 a_475_85# a_1030_268# VGND#10 VNB sky130_fd_pr__nfet_01v8_lvt l=0.15 w=0.74 ad=0.2072 as=0.3923 pd=2.04 ps=2.82
XM34 a_114_85##2 S#18 VGND#10 VNB sky130_fd_pr__nfet_01v8_lvt l=0.15 w=0.74 ad=0.2072 as=0.3923 pd=2.04 ps=2.82
XM5 a_114_85##2 S#14 VGND#9 VNB sky130_fd_pr__nfet_01v8_lvt l=0.15 w=0.74 ad=0.2072 as=0.3774 pd=2.04 ps=2.5
XM30 VGND#9 S#12 a_114_85# VNB sky130_fd_pr__nfet_01v8_lvt l=0.15 w=0.74 ad=0.3774 as=0.2072 pd=2.5 ps=2.04
XM25 VGND#4 S#10 a_114_85# VNB sky130_fd_pr__nfet_01v8_lvt l=0.15 w=0.74 ad=0.259 as=0.2072 pd=2.18 ps=2.04
XM26 VGND#4 S#8 a_1030_268##14 VNB sky130_fd_pr__nfet_01v8_lvt l=0.15 w=0.74 ad=0.259 as=0.2627 pd=2.18 ps=2.19
XM21 a_116_368##5 A1#13 Y#7 VPB sky130_fd_pr__pfet_01v8 l=0.15 w=1.12 ad=0.336 as=0.3304 pd=2.84 ps=2.83
XM0 Y#15 A1#12 a_116_368##5 VPB sky130_fd_pr__pfet_01v8 l=0.15 w=1.12 ad=0.336 as=0.336 pd=2.84 ps=2.84
XM7 Y#15 A1#10 a_116_368##6 VPB sky130_fd_pr__pfet_01v8 l=0.15 w=1.12 ad=0.336 as=0.336 pd=2.84 ps=2.84
XM18 a_116_368##6 A1#8 Y#14 VPB sky130_fd_pr__pfet_01v8 l=0.15 w=1.12 ad=0.336 as=0.3472 pd=2.84 ps=2.86
XM32 a_478_368##4 A0#12 Y#14 VPB sky130_fd_pr__pfet_01v8 l=0.15 w=1.12 ad=0.3808 as=0.3472 pd=2.92 ps=2.86
XM20 Y#1 A0#11 a_478_368##4 VPB sky130_fd_pr__pfet_01v8 l=0.15 w=1.12 ad=0.392 as=0.3808 pd=2.94 ps=2.92
XM31 Y#1 A0#7 a_478_368##6 VPB sky130_fd_pr__pfet_01v8 l=0.15 w=1.12 ad=0.392 as=0.392 pd=2.94 ps=2.94
XM16 a_478_368##6 A0#1 Y#3 VPB sky130_fd_pr__pfet_01v8 l=0.15 w=1.12 ad=0.392 as=0.3864 pd=2.94 ps=2.93
XM6 a_116_368##2 a_1030_268##7 VPWR#11 VPB sky130_fd_pr__pfet_01v8 l=0.15 w=1.12 ad=0.336 as=0.7504 pd=2.84 ps=3.58
XM17 a_116_368##2 a_1030_268##12 VPWR#9 VPB sky130_fd_pr__pfet_01v8 l=0.15 w=1.12 ad=0.336 as=0.336 pd=2.84 ps=2.84
XM3 VPWR#9 a_1030_268##10 a_116_368# VPB sky130_fd_pr__pfet_01v8 l=0.15 w=1.12 ad=0.336 as=0.4256 pd=2.84 ps=3
XM33 VPWR#13 a_1030_268##8 a_116_368# VPB sky130_fd_pr__pfet_01v8 l=0.15 w=1.12 ad=0.392 as=0.4256 pd=2.94 ps=3
XM24 VPWR#13 S#20 a_478_368##5 VPB sky130_fd_pr__pfet_01v8 l=0.15 w=1.12 ad=0.392 as=0.336 pd=2.94 ps=2.84
XM28 a_478_368##5 S#19 VPWR#12 VPB sky130_fd_pr__pfet_01v8 l=0.15 w=1.12 ad=0.336 as=0.448 pd=2.84 ps=3.04
XM11 VPWR#12 S#15 a_478_368# VPB sky130_fd_pr__pfet_01v8 l=0.15 w=1.12 ad=0.448 as=0.336 pd=3.04 ps=2.84
XM10 a_478_368# S#11 VPWR#7 VPB sky130_fd_pr__pfet_01v8 l=0.15 w=1.12 ad=0.336 as=0.3724 pd=2.84 ps=2.95
XM29 VPWR#7 S#9 a_1030_268##17 VPB sky130_fd_pr__pfet_01v8 l=0.15 w=0.84 ad=0.3724 as=0.252 pd=2.95 ps=2.28
XM13 a_1030_268##17 S#1 VPWR#1 VPB sky130_fd_pr__pfet_01v8 l=0.15 w=0.84 ad=0.252 as=0.2478 pd=2.28 ps=2.27
*
*
*       RESISTOR AND CAP/DIODE CARDS
*
Rg1	A1#1	A1#2	365.993317
Rg2	A1#2	A1#3	66.369736
Rg3	A1#3	A1#4	33.804066
Rg4	A1#4	A1#5	45.616405
Rg5	A1#5	A1#6	66.386436
Rg6	A1#6	A1#7	365.993317
Rg7	A1#2	A1#8	449.655212
Rg8	A1#3	A1#9	367.589844
Rg9	A1#3	A1#10	450.102234
Rg10	A1#5	A1#11	363.242828
Rg11	A1#5	A1#12	448.030548
Rg12	A1#6	A1#13	449.655212
Rg13	A0#1	A0#2	527.993835
Rg14	A0#2	A0#3	166.921478
Rg15	A0#3	A0#4	99.588348
Rg16	A0#2	A0#5	359.292084
Rg17	A0#3	A0#6	392.922791
Rg18	A0#3	A0#7	438.831757
Rg19	A0#4	A0#8	347.107910
Rg20	A0#4	A0#9	64.081955
Rg21	A0#9	A0#10	365.993317
Rg22	A0#4	A0#11	429.126801
Rg23	A0#9	A0#12	449.655212
Rg24	a_1030_268#	a_1030_268##2	403.247070
Rg25	a_1030_268##2	a_1030_268##3	59.018768
Rg26	a_1030_268##3	a_1030_268##4	55.975315
Rg27	a_1030_268##4	a_1030_268##5	49.947598
Rg28	a_1030_268##5	a_1030_268##6	66.386436
Rg29	a_1030_268##6	a_1030_268##7	460.356018
Rg30	a_1030_268##2	a_1030_268##8	423.996338
Rg31	a_1030_268##3	a_1030_268##9	342.058960
Rg32	a_1030_268##4	a_1030_268##10	428.848328
Rg33	a_1030_268##5	a_1030_268##11	326.451965
Rg34	a_1030_268##5	a_1030_268##12	455.013184
Rg35	a_1030_268##6	a_1030_268##13	352.387848
Rg36	S#1	S#2	453.105377
Rg37	S#2	S#3	44.772530
Rg38	S#3	S#4	42.284615
Rg39	S#4	S#5	43.268978
Rg40	S#5	S#6	27.519188
Rg41	S#6	S#7	32.326767
Rg42	S#2	S#8	292.883667
Rg43	S#3	S#9	379.187866
Rg44	S#4	S#10	296.149994
Rg45	S#5	S#11	459.528503
Rg46	S#6	S#12	296.149994
Rg47	S#7	S#13	85.207878
Rg48	S#13	S#14	296.149994
Rg49	S#7	S#15	469.100494
Rg50	S#13	S#16	25.550463
Rg51	S#16	S#17	45.237701
Rg52	S#17	S#18	296.149994
Rg53	S#16	S#19	459.528503
Rg54	S#17	S#20	496.744537
Rf1	A1	A1#14	14.363330
Rf2	A1#14	A1	0.305603
Rf3	A0	A0#4	57.136509
Rf4	Y#1	Y#2	19.350082
Rf5	Y#2	Y#4	40.255608
Rf6	Y#2	Y#5	73.001427
Rf7	Y#5	Y#6	65.818954
Rf8	Y#6	Y#7	87.091774
Rf9	Y#4	Y	8.335827
Rf10	Y	Y#9	44.327438
Rf11	Y#9	Y#11	46.143101
Rf12	Y#11	Y#13	44.673332
Rf13	Y#5	Y#14	14.705224
Rf14	Y#6	Y#15	21.914129
Rf15	Y#13	Y#16	60.821571
Rf16	Y#16	Y#17	29.962008
Rf17	Y#16	Y#18	83.344177
Rf18	Y#3	Y#4	7.500000
Rf19	Y#8	Y#9	15.000000
Rf20	Y#10	Y#11	15.000000
Rf21	Y#12	Y#13	7.500000
Rf22	a_116_368#	a_116_368##3	49.528465
Rf23	a_116_368##3	a_116_368##4	280.457520
Rf24	a_116_368##4	a_116_368##5	78.577522
Rf25	a_116_368##4	a_116_368##6	21.341251
Rf26	a_116_368##2	a_116_368##3	15.000000
Rf27	a_475_85#	a_475_85##3	87.141960
Rf28	a_475_85##3	a_475_85##5	169.081329
Rf29	a_475_85##5	a_475_85##6	81.110695
Rf30	a_475_85##2	a_475_85##3	15.000000
Rf31	a_475_85##4	a_475_85##5	15.000000
Rf32	a_478_368#	a_478_368##2	80.236443
Rf33	a_478_368##2	a_478_368##3	281.895264
Rf34	a_478_368##3	a_478_368##4	89.161133
Rf35	a_478_368##2	a_478_368##5	10.866916
Rf36	a_478_368##3	a_478_368##6	19.351097
Rf37	a_114_85#	a_114_85##3	88.167534
Rf38	a_114_85##3	a_114_85##4	453.982727
Rf39	a_114_85##4	a_114_85##5	84.445480
Rf40	a_114_85##4	a_114_85##6	24.862514
Rf41	a_114_85##2	a_114_85##3	7.500000
Rf42	S	S#7	23.626659
Rf43	a_1030_268##14	a_1030_268##15	104.293861
Rf44	a_1030_268##15	a_1030_268##4	259.236694
Rf45	a_1030_268##15	a_1030_268##17	25.612295
Rf46	VPWR#1	VPWR#2	105.381485
Rf47	VPWR#2	VPWR#3	35.462307
Rf48	VPWR#3	VPWR#4	36.865967
Rf49	VPWR#4	VPWR#5	73.001427
Rf50	VPWR#5	VPWR#6	258.208984
Rf51	VPWR#2	VPWR#8	46.073757
Rf52	VPWR#8	VPWR#10	215.688812
Rf53	VPWR#10	VPWR#11	44.919979
Rf54	VPWR#4	VPWR#12	31.948624
Rf55	VPWR#5	VPWR#13	31.948624
Rf56	VPWR#7	VPWR#8	7.500000
Rf57	VPWR#9	VPWR#10	15.000000
Rf59	VGND#2	VGND#3	55.493843
Rf60	VGND#2	VGND#4	33.306259
Rf61	VGND#3	VGND#5	101.479134
Rf62	VGND#5	VGND#6	74.462440
Rf63	VGND#6	VGND#7	71.597771
Rf64	VGND#7	VGND#8	124.218658
Rf65	VGND#3	VGND#9	32.456623
Rf66	VGND#5	VGND#10	24.468842
Rf67	VGND#6	VGND#11	24.468842
Rf68	VGND#7	VGND#12	27.306370
Rf69	A1#4	A1#14	40.058201
Re1	VPWR#3	VPWR	2.687498
Re2	VPWR	VPWR#6	1.343749
Re3	VGND#3	VGND	2.687498
Re4	VGND	VGND#8	1.343749
*
*       CAPACITOR CARDS
*
*
C1	S#17	VGND#10	1.27925e-18
C2	a_475_85##2	VGND#12	6.4793e-18
C3	VGND#5	VGND#9	3.22858e-18
C4	VGND#8	A0#2	3.94425e-20
C5	Y#12	A0#10	4.02214e-17
C6	a_478_368##3	a_116_368##2	1.64653e-16
C7	S#7	S#5	2.10486e-17
C8	VGND#8	A1#6	2.0419e-20
C9	VGND#6	a_114_85##2	4.9675e-17
C10	VGND#8	A1#5	7.55282e-20
C11	a_114_85##6	A0#10	1.06011e-18
C12	Y#15	a_116_368##6	3.40698e-17
C13	S#7	S#3	2.04621e-17
C14	a_478_368##3	a_1030_268##10	8.43728e-19
C15	VGND#8	A1#2	2.06745e-20
C16	a_475_85##4	VGND#11	1.65086e-19
C17	a_478_368##2	a_116_368##2	2.673e-17
C18	Y#12	A1#1	4.56702e-17
C19	a_478_368##2	a_1030_268##10	1.39299e-17
C20	a_116_368##5	a_116_368##6	4.83152e-18
C21	Y#7	Y#14	2.9667e-20
C22	VGND#5	a_114_85##2	5.72564e-17
C23	S#7	a_1030_268##3	2.29511e-19
C24	a_478_368##3	VPWR#11	6.84801e-17
C25	A1#1	a_114_85##6	1.54352e-17
C26	S#7	a_1030_268##2	6.58761e-18
C27	S#20	S#16	1.85554e-19
C28	a_1030_268##4	S#17	1.18668e-17
C29	a_478_368##3	a_1030_268##12	1.46083e-18
C30	Y#12	A1#9	1.41317e-18
C31	a_1030_268##4	S#16	6.47749e-18
C32	a_116_368##5	Y#15	4.42079e-17
C33	Y#17	A1#1	4.47308e-19
C34	a_478_368##2	a_1030_268##12	1.25477e-17
C35	a_114_85##6	A1#9	2.96773e-17
C36	a_1030_268##4	S#5	4.69665e-20
C37	Y#7	Y#15	2.54942e-18
C38	a_478_368##3	Y#3	2.42735e-18
C39	VGND#5	VGND#10	7.62555e-18
C40	Y#12	A1#11	2.28127e-19
C41	A1#9	Y#17	1.49745e-17
C42	a_478_368##3	a_1030_268##7	2.10697e-17
C43	a_1030_268#	S#17	8.86311e-19
C44	Y#7	a_116_368##5	5.91799e-17
C45	a_1030_268##4	a_1030_268##6	1.75221e-17
C46	a_114_85##6	A1#11	1.64163e-18
C47	a_114_85##5	A1#9	1.21642e-18
C48	a_1030_268##4	a_1030_268##5	2.90517e-17
C49	a_478_368##2	a_1030_268##7	4.01596e-19
C50	a_1030_268##4	a_1030_268##3	1.00525e-17
C51	A1#11	Y#17	1.71767e-17
C52	Y#8	a_475_85##4	9.16156e-17
C53	a_1030_268##4	a_1030_268##2	1.87397e-17
C54	Y#18	A1#9	2.1825e-19
C55	a_478_368##3	a_478_368##6	3.33972e-18
C56	a_114_85##5	A1#11	3.60245e-17
C57	a_478_368##3	A0#1	2.97349e-17
C58	a_1030_268##4	A0#2	3.12846e-18
C59	VGND#6	VGND#11	7.17136e-18
C60	a_478_368##3	a_1030_268##6	1.98389e-19
C61	Y#17	A1#7	9.75171e-19
C62	Y#18	A1#11	9.8656e-19
C63	a_114_85##5	A1#7	3.15955e-17
C64	a_114_85##4	A0#9	1.33524e-19
C65	a_478_368##3	Y#1	2.47673e-19
C66	a_1030_268##14	a_1030_268##15	2.32389e-18
C67	a_478_368##3	A0#7	1.84099e-17
C68	Y#18	A1#7	3.45234e-17
C69	a_1030_268##2	S#20	1.82263e-18
C70	a_475_85##4	Y#10	3.57601e-17
C71	a_114_85##2	a_1030_268##6	3.8543e-19
C72	S#10	S#8	2.76141e-17
C73	a_478_368##3	a_1030_268##5	2.07701e-19
C74	Y#2	a_478_368##3	2.89598e-17
C75	A1#5	A1#2	2.20453e-18
C76	A0#9	A0#4	2.11976e-18
C77	a_478_368##4	a_478_368##3	2.59148e-18
C78	a_114_85##4	A0#3	2.95584e-19
C79	A0#4	A0#3	2.18496e-18
C80	a_475_85##4	a_475_85##6	5.96415e-21
C81	a_114_85##2	a_1030_268##5	1.86099e-18
C82	Y#6	a_116_368##4	9.4177e-19
C83	a_478_368##3	A0#11	7.53191e-19
C84	a_116_368##4	a_478_368##6	8.04481e-19
C85	a_116_368##4	A0#7	1.57566e-17
C86	S#12	S#10	3.64252e-17
C87	VGND#12	VGND#6	3.97657e-18
C88	VPWR#9	S#17	4.47746e-19
C89	Y#10	a_475_85##6	3.537e-17
C90	a_114_85##4	A0#2	3.58121e-19
C91	Y#2	a_1030_268##7	5.71303e-20
C92	a_114_85##2	a_1030_268##3	8.1513e-20
C93	VPWR#1	S#1	3.65567e-17
C94	Y#5	a_116_368##4	3.76224e-17
C95	a_116_368##4	Y#1	1.35262e-18
C96	a_478_368##2	a_1030_268##5	4.7715e-19
C97	a_116_368##4	A0#11	1.56341e-17
C98	VGND#5	S#12	3.54922e-19
C99	S#1	a_1030_268##17	1.71297e-17
C100	VGND#5	S#17	1.06471e-18
C101	S#14	S#12	1.50779e-17
C102	a_114_85##6	a_475_85##4	5.043e-20
C103	VPWR#1	S#9	2.72702e-18
C104	VPWR#7	S#1	1.38017e-18
C105	a_114_85##2	a_1030_268##2	4.01195e-19
C106	Y#2	A0#1	1.11781e-18
C107	a_1030_268##17	S#9	3.92779e-17
C108	a_116_368##4	a_478_368##4	6.22811e-17
C109	Y#5	A0#7	1.98955e-19
C110	a_116_368##4	A0#12	1.82443e-17
C111	a_478_368##2	a_1030_268##3	6.18421e-19
C112	Y#12	a_475_85##6	3.6844e-17
C113	VPWR#1	S#11	2.70466e-18
C114	S#9	VPWR#7	2.30429e-17
C115	VGND#5	S#14	8.12894e-19
C116	S#18	S#14	3.64427e-17
C117	VGND#5	S#16	5.95065e-20
C118	Y#2	A0#7	2.11349e-17
C119	a_1030_268##17	S#11	1.81161e-18
C120	a_478_368#	S#9	8.75009e-19
C121	a_114_85##4	A1#5	2.51522e-19
C122	VGND#6	S#18	5.90981e-19
C123	Y#5	A0#11	1.17418e-18
C124	VPWR#7	S#11	4.10228e-17
C125	a_116_368##4	Y#14	5.10662e-19
C126	a_116_368##4	A1#8	1.59323e-17
C127	a_478_368##2	a_1030_268##2	8.62546e-19
C128	a_1030_268##17	S#15	4.42158e-19
C129	a_478_368#	S#11	4.7155e-17
C130	a_1030_268#	S#18	2.10499e-17
C131	a_478_368##3	A0#3	2.56261e-19
C132	VGND#5	S#18	8.70437e-18
C133	Y#2	A0#11	1.74171e-17
C134	VPWR#7	S#15	1.4292e-17
C135	Y#12	a_114_85##6	3.76518e-17
C136	a_475_85#	a_1030_268##5	2.65969e-18
C137	VPWR#12	S#11	1.29522e-18
C138	a_1030_268##2	VPWR#13	5.88658e-19
C139	Y#5	A0#12	3.86809e-17
C140	a_116_368##4	a_116_368##6	5.24145e-20
C141	a_478_368#	S#15	5.2916e-17
C142	a_1030_268##17	S#19	2.59e-19
C143	a_116_368##4	A1#10	1.64361e-17
C144	VGND#6	a_1030_268#	1.27566e-18
C145	a_1030_268##9	a_1030_268#	4.06262e-17
C146	a_478_368##3	A0#2	4.27207e-19
C147	VPWR#7	S#19	1.3988e-17
C148	S#15	VPWR#12	3.17808e-17
C149	a_116_368#	a_1030_268##5	1.40868e-19
C150	Y#2	A0#12	4.3235e-19
C151	Y#17	Y#12	2.87371e-18
C152	a_475_85#	a_1030_268##3	3.81964e-19
C153	VGND#5	a_1030_268#	1.13627e-17
C154	a_478_368#	S#19	5.24626e-19
C155	a_1030_268##17	S#20	1.71225e-19
C156	VGND#7	a_114_85##4	4.4001e-17
C157	Y#5	A1#8	3.32249e-17
C158	a_1030_268##6	a_1030_268##5	1.3718e-18
C159	a_116_368##4	Y#15	1.01425e-17
C160	S#19	VPWR#12	3.32178e-17
C161	a_116_368#	a_1030_268##3	4.63958e-19
C162	VPWR#7	S#20	2.14285e-19
C163	VPWR#13	S#15	2.8528e-19
C164	Y#17	a_114_85##6	2.24656e-17
C165	VGND#6	a_1030_268##9	1.20797e-17
C166	a_1030_268##11	a_1030_268##9	2.16222e-17
C167	a_475_85#	a_1030_268##2	2.02799e-18
C168	S#19	a_478_368##5	2.27326e-17
C169	Y#6	A1#10	1.32591e-17
C170	VPWR#3	VPWR#5	4.48141e-17
C171	a_1030_268##11	a_1030_268##3	1.36305e-18
C172	VPWR#9	a_1030_268##6	1.22185e-18
C173	VGND#3	VGND#5	6.57429e-17
C174	a_116_368#	a_1030_268##2	5.08395e-20
C175	VGND#5	a_1030_268##9	1.27566e-18
C176	VPWR#12	S#20	7.67963e-19
C177	VPWR#13	S#19	7.67963e-19
C178	Y#5	A1#10	1.50295e-18
C179	VPWR#7	a_1030_268##8	2.12474e-19
C180	VPWR#9	S#15	2.99096e-19
C181	VPWR#3	VPWR#4	4.83898e-17
C182	a_114_85##5	a_114_85##6	4.03371e-18
C183	VPWR#3	VPWR#2	7.79747e-17
C184	S#20	a_478_368##5	2.27326e-17
C185	Y#5	a_478_368##4	5.80728e-17
C186	a_1030_268##13	a_1030_268##11	3.9034e-17
C187	VPWR#9	a_1030_268##5	4.14109e-18
C188	S#20	VPWR#13	2.88414e-17
C189	VGND#6	a_1030_268##11	8.68897e-18
C190	VPWR#3	a_1030_268##15	1.16211e-17
C191	VPWR#12	a_1030_268##8	2.81672e-19
C192	VPWR#9	S#19	2.79209e-19
C193	Y#2	Y#1	3.17481e-18
C194	Y#6	A1#12	1.3146e-17
C195	a_475_85##2	a_1030_268##6	1.53286e-18
C196	VPWR#5	VPWR#4	9.5684e-19
C197	a_114_85##5	Y#17	2.81499e-17
C198	VGND#7	a_1030_268##6	9.19421e-21
C199	Y#5	A1#12	2.51452e-19
C200	VGND#5	a_1030_268##11	4.27951e-19
C201	VPWR#9	a_1030_268##3	2.89024e-18
C202	VPWR#13	a_1030_268##8	3.65377e-17
C203	VPWR#9	S#20	1.36516e-17
C204	VGND#7	a_1030_268##13	2.6343e-18
C205	Y#5	Y#14	4.37357e-18
C206	A0#5	a_1030_268##13	1.72023e-18
C207	Y#2	a_478_368##4	4.4299e-17
C208	a_1030_268##8	a_116_368#	2.86426e-17
C209	Y#18	Y#17	2.6177e-18
C210	a_475_85##2	a_1030_268##5	4.0222e-18
C211	VPWR#3	a_478_368##2	2.14477e-17
C212	A0#1	a_1030_268##6	2.62843e-19
C213	Y#6	a_116_368##6	1.11024e-17
C214	VGND#3	a_1030_268##15	6.35878e-18
C215	a_116_368##2	a_1030_268##6	1.4931e-19
C216	VGND#6	a_1030_268##13	1.80615e-18
C217	VPWR#9	a_1030_268##2	1.24459e-18
C218	VPWR#9	a_1030_268##8	1.76888e-17
C219	VPWR#13	a_1030_268##10	1.07412e-18
C220	VGND#7	a_1030_268##5	3.88066e-20
C221	Y#5	a_116_368##6	4.76343e-17
C222	a_116_368#	a_1030_268##10	5.01336e-17
C223	A0#6	A0#5	3.89209e-17
C224	Y#18	a_114_85##5	4.7103e-17
C225	a_116_368##2	a_1030_268##5	3.73882e-19
C226	VPWR#9	a_1030_268##10	4.57505e-17
C227	Y#6	Y#15	2.47687e-18
C228	VPWR#13	a_1030_268##12	1.99309e-19
C229	VGND#12	a_1030_268##6	3.19679e-19
C230	VGND#6	A0#5	2.68553e-19
C231	VPWR#4	VPWR#2	8.80709e-19
C232	A0#3	A0#1	3.5171e-18
C233	Y#15	Y#5	3.00383e-18
C234	A0#8	A0#6	3.15514e-17
C235	a_114_85##4	a_475_85##2	1.47858e-18
C236	VPWR#9	a_1030_268##12	4.51352e-17
C237	VPWR#13	a_1030_268##7	7.94242e-20
C238	a_116_368##2	a_1030_268##12	4.45297e-17
C239	Y#6	a_116_368##5	2.38037e-17
C240	A0#2	a_1030_268##13	7.1835e-20
C241	Y#5	Y#2	2.58898e-18
C242	a_478_368##2	VPWR#6	6.4933e-19
C243	a_116_368##4	A0#9	3.94884e-20
C244	VGND#6	a_1030_268##5	1.23652e-18
C245	A0#10	A0#8	2.39734e-17
C246	a_116_368##2	a_1030_268##7	4.6567e-17
C247	VGND#8	a_114_85##4	2.26478e-16
C248	a_114_85##4	VGND#12	2.02177e-17
C249	a_116_368##4	VPWR#6	1.63872e-16
C250	VPWR#11	a_1030_268##7	6.23768e-17
C251	Y#8	a_1030_268##6	8.92219e-19
C252	a_1030_268##5	a_1030_268##2	1.06983e-18
C253	a_116_368##2	A0#1	1.87406e-17
C254	a_475_85##2	VPWR#11	2.00121e-17
C255	a_1030_268##15	S#7	1.68897e-16
C256	a_116_368##4	A0#3	1.31374e-19
C257	A1#1	A0#10	3.80797e-17
C258	VPWR#11	A0#1	8.37485e-19
C259	VGND#6	a_1030_268##3	1.28178e-20
C260	a_1030_268##17	VPWR#1	5.52563e-17
C261	VPWR#5	S#17	4.04023e-20
C262	a_114_85##4	a_1030_268##9	2.5548e-19
C263	S#17	S#16	3.08654e-18
C264	a_114_85##4	Y#8	1.05011e-18
C265	A0#1	Y#3	2.38066e-17
C266	a_116_368##2	A0#7	1.871e-19
C267	a_116_368##2	A0#2	7.5463e-20
C268	VGND#3	a_1030_268##14	1.83836e-17
C269	A0#1	a_478_368##6	2.4857e-17
C270	A1#9	A1#1	2.23348e-17
C271	VGND#3	VGND#4	2.03665e-17
C272	a_116_368##4	A0#2	4.00344e-20
C273	VPWR#7	VPWR#1	3.17255e-18
C274	VGND#3	a_114_85#	3.00183e-17
C275	VGND#3	VGND#9	2.15602e-17
C276	a_478_368##4	A0#1	1.98955e-19
C277	VGND#6	a_1030_268##2	2.71488e-20
C278	A0#7	a_478_368##6	1.64638e-17
C279	a_1030_268##15	VPWR#2	1.48872e-18
C280	a_114_85##4	a_475_85##4	1.16164e-16
C281	VGND#3	a_114_85##2	3.48623e-17
C282	A0#7	Y#1	2.48356e-17
C283	A1#11	A1#9	3.955e-17
C284	a_1030_268##3	a_1030_268##2	1.84431e-18
C285	VPWR#7	a_1030_268##17	5.84046e-17
C286	a_475_85##4	VPWR#11	7.31675e-19
C287	A0#11	A0#3	1.85656e-19
C288	a_116_368##6	A0#1	3.81893e-19
C289	VGND#3	a_475_85#	8.64698e-19
C290	a_478_368##4	A0#7	7.61424e-19
C291	A0#11	Y#1	1.9005e-17
C292	VPWR#4	S#17	4.52506e-20
C293	a_114_85##4	A0#4	7.88723e-19
C294	a_114_85##4	a_1030_268##13	4.21434e-19
C295	a_116_368##6	A0#7	4.54755e-19
C296	a_114_85##4	Y#10	1.19381e-18
C297	a_478_368##4	A0#11	5.01536e-17
C298	A1#7	A1#11	3.86784e-17
C299	Y#8	A0#9	6.50619e-20
C300	a_116_368##4	A1#5	9.61458e-20
C301	a_475_85##4	a_478_368##3	3.49647e-18
C302	a_116_368##6	A0#11	8.16484e-19
C303	A0#12	a_478_368##4	2.53293e-17
C304	VPWR#7	a_478_368#	9.21831e-17
C305	VGND#5	a_1030_268##2	3.97176e-20
C306	A0	a_1030_268##6	4.95505e-19
C307	a_116_368##4	A0#4	2.99883e-19
C308	A0#12	Y#14	2.37323e-17
C309	S#7	a_1030_268##14	3.01222e-17
C310	a_114_85##4	A0#5	1.29778e-17
C311	a_114_85##4	a_475_85##6	5.81331e-17
C312	VGND#4	S#7	4.7149e-17
C313	a_116_368##6	A0#12	1.28587e-18
C314	A0	A0#9	1.53721e-17
C315	A0#2	a_1030_268##6	1.48361e-18
C316	Y#8	A0#3	2.95862e-19
C317	A0	A0#3	1.73253e-17
C318	a_114_85#	S#7	7.05828e-17
C319	a_1030_268##14	S#8	1.96366e-17
C320	VPWR#3	VPWR#1	5.84668e-17
C321	A0	A0#2	6.1655e-19
C322	VPWR#7	VPWR#12	1.84411e-18
C323	S#7	VGND#9	3.33347e-18
C324	A1#8	Y#14	2.37323e-17
C325	VPWR#3	a_1030_268##17	1.25436e-17
C326	a_114_85##2	S#7	7.7536e-17
C327	A0	A1#2	8.38222e-18
C328	VPWR#7	VPWR#3	7.17617e-18
C329	A1#8	a_116_368##6	2.12878e-17
C330	VGND#4	S#8	4.29293e-17
C331	a_478_368#	VPWR#3	3.53444e-17
C332	Y#7	A0#12	9.68338e-20
C333	Y#5	A0#4	6.35698e-19
C334	Y#15	A1#8	4.41143e-19
C335	Y#8	A0#2	9.74535e-18
C336	a_478_368#	VPWR#12	4.29188e-17
C337	a_114_85##4	A0#6	7.89785e-18
C338	VPWR#7	a_478_368##5	4.1995e-20
C339	VPWR#3	VPWR#12	1.47379e-17
C340	a_114_85##4	Y#12	3.88522e-17
C341	a_1030_268##14	S#10	5.87615e-19
C342	Y#2	A0#4	2.33541e-18
C343	a_116_368##6	A1#10	3.96761e-17
C344	a_478_368##2	VPWR#5	8.96886e-18
C345	S#9	S#1	3.81779e-17
C346	a_114_85#	S#8	1.6186e-18
C347	a_114_85##2	a_1030_268##4	6.56465e-18
C348	Y#7	A1#8	1.42355e-19
C349	VPWR#3	VPWR#13	1.51849e-17
C350	A1#10	Y#15	2.30101e-17
C351	S#10	VGND#4	1.9159e-17
C352	a_1030_268##4	a_475_85#	6.55478e-17
C353	a_116_368##5	A1#10	1.71192e-18
C354	VPWR#7	VPWR#13	7.78255e-22
C355	a_116_368##6	A1#12	2.25389e-18
C356	VGND#9	S#8	5.92487e-19
C357	a_1030_268##4	VGND#11	5.79681e-18
C358	VPWR#3	VPWR#9	3.55074e-18
C359	A1	A0#9	6.16287e-18
C360	Y#7	A1#10	4.51735e-19
C361	a_475_85##4	A0#3	4.4503e-19
C362	a_1030_268##14	S#12	3.02599e-19
C363	VGND#8	a_114_85##5	4.7812e-17
C364	S#11	S#9	3.21101e-17
C365	a_1030_268##4	a_475_85##2	8.27658e-17
C366	A1#12	Y#15	2.64822e-17
C367	a_114_85##4	A0#8	8.33375e-18
C368	Y#16	A1#6	1.12898e-18
C369	a_114_85##4	a_114_85##6	7.41244e-19
C370	a_114_85#	S#10	4.04667e-17
C371	A1	A1#6	1.75628e-17
C372	a_1030_268##4	VGND#12	4.78737e-19
C373	VGND#8	Y#18	1.53856e-17
C374	A1	A1#5	3.67201e-17
C375	a_116_368##5	A1#12	6.07642e-17
C376	a_478_368##2	VPWR#4	8.78455e-18
C377	Y#8	a_1030_268##4	4.7258e-18
C378	A1	A1#2	1.18866e-17
C379	Y#7	A1#12	1.36186e-18
C380	VGND#4	S#12	1.50296e-18
C381	Y#15	A1#13	9.36898e-19
C382	VGND#9	S#10	8.73864e-19
C383	S#15	S#11	4.73986e-17
C384	a_475_85##4	A0#2	5.51862e-19
C385	a_116_368##5	A1#13	4.90095e-17
C386	a_1030_268##14	S#14	1.93855e-19
C387	a_116_368#	VPWR#6	4.76411e-17
C388	a_114_85#	S#12	4.60275e-17
C389	VPWR#13	VPWR#12	1.69573e-18
C390	Y#7	A1#13	4.11016e-17
C391	Y#16	A1#5	5.16904e-18
C392	a_114_85##4	A0#10	9.47428e-18
C393	Y#8	A0#4	1.0569e-19
C394	a_114_85##4	Y#17	1.33284e-17
C395	VGND#4	a_1030_268##14	5.44688e-17
C396	a_475_85##4	A0#4	7.43664e-20
C397	a_116_368##2	VPWR#6	1.67475e-16
C398	VGND#4	S#14	3.61877e-19
C399	VPWR#7	S#7	9.67196e-19
C400	S#19	S#15	3.14856e-17
C401	VPWR#2	VPWR#1	8.04476e-18
C402	Y#10	A0#4	4.27279e-18
C403	S#12	VGND#9	2.65429e-17
C404	a_478_368#	S#7	7.87882e-19
C405	a_475_85##6	A0#4	1.1031e-18
C406	Y#12	A0#4	1.51028e-18
C407	VPWR#12	S#7	1.17235e-19
C408	Y#10	A0#3	3.06461e-18
C409	A0#3	Y#1	3.34413e-19
C410	a_114_85#	S#14	7.3913e-19
C411	a_114_85##2	S#12	8.32737e-19
C412	S#20	S#19	4.7336e-17
C413	Y#8	A1#2	2.12265e-19
C414	a_1030_268##4	VPWR#7	2.23618e-17
C415	a_114_85##4	A1#1	8.79076e-18
C416	a_475_85#	S#10	4.76326e-19
C417	S#14	VGND#9	2.82385e-17
C418	a_1030_268##17	VPWR#2	5.98335e-18
C419	a_1030_268##4	a_478_368##5	5.07732e-19
C420	a_1030_268##4	VPWR#13	4.17867e-19
C421	a_1030_268##8	S#20	3.7568e-17
C422	a_1030_268##15	VPWR#1	3.17512e-17
C423	a_475_85##6	A0#9	1.9986e-19
C424	VGND#3	S#8	4.63318e-18
C425	a_114_85##2	S#14	4.71929e-17
C426	a_1030_268##4	a_116_368#	4.31545e-18
C427	a_114_85#	VGND#4	5.56416e-17
C428	a_1030_268##14	VGND#9	7.88476e-20
C429	a_116_368#	VPWR#13	3.25562e-17
C430	a_116_368##5	VPWR#6	4.92349e-17
C431	VPWR#9	a_478_368##5	8.89986e-19
C432	a_478_368##4	A0#9	1.27525e-19
C433	VGND#3	S#10	9.08951e-18
C434	a_1030_268##4	VPWR#9	1.5228e-16
C435	a_475_85#	S#12	5.1579e-19
C436	a_114_85##4	A1#9	8.60855e-18
C437	Y#7	VPWR#6	1.8278e-17
C438	a_1030_268##4	a_116_368##2	2.35532e-18
C439	VGND#9	S#18	8.78555e-19
C440	VGND#3	S#12	1.16881e-17
C441	Y	a_1030_268##6	3.48435e-18
C442	a_1030_268##4	VPWR#11	2.38889e-17
C443	a_1030_268##10	a_1030_268##8	3.35579e-17
C444	Y	a_1030_268##5	1.47325e-19
C445	VGND#3	S#14	1.16881e-17
C446	VPWR#2	VPWR#7	1.55561e-18
C447	a_478_368##4	A0#3	3.53568e-20
C448	VGND#3	S#18	9.08951e-18
C449	Y	A0#3	8.79268e-18
C450	VPWR#9	VPWR#13	1.12046e-18
C451	a_1030_268##15	S#16	3.29249e-18
C452	Y	A0#2	1.52394e-17
C453	a_114_85##2	S#18	4.73143e-17
C454	VGND#3	a_1030_268#	9.25484e-18
C455	VGND#9	VGND#4	2.93274e-18
C456	a_1030_268##15	a_1030_268##17	1.64186e-18
C457	a_475_85#	S#14	8.24393e-19
C458	a_478_368#	VPWR#4	5.96352e-19
C459	a_1030_268##12	a_1030_268##10	4.57364e-17
C460	VGND#9	a_1030_268#	4.12679e-19
C461	S#18	VGND#10	1.80109e-17
C462	a_116_368#	VPWR#9	2.32975e-18
C463	S#7	S#8	2.5969e-18
C464	A0#4	Y#1	3.9289e-19
C465	a_114_85##2	a_1030_268#	2.89865e-17
C466	A0#4	a_478_368##4	1.27279e-18
C467	a_1030_268##7	a_1030_268##12	4.57364e-17
C468	S#7	S#10	4.00281e-18
C469	a_478_368#	VPWR#2	1.17677e-17
C470	Y#12	A0#9	9.79023e-19
C471	a_114_85#	VGND#9	4.41051e-17
C472	a_475_85#	S#18	3.0666e-18
C473	S#7	S#12	2.69745e-18
C474	a_1030_268##15	VPWR#7	1.03436e-16
C475	S#7	S#14	2.69745e-18
C476	a_1030_268#	VGND#10	1.94845e-17
C477	S#7	S#18	2.52444e-18
C478	VPWR#2	S#3	8.99042e-20
C479	A0#1	a_1030_268##7	2.30039e-18
C480	S#7	a_1030_268#	3.29889e-18
C481	a_114_85##2	a_1030_268##9	2.20619e-17
C482	S#7	a_1030_268##9	1.0058e-18
C483	VGND#8	A0#5	3.82681e-18
C484	a_114_85##2	a_114_85#	3.95536e-18
C485	a_475_85#	a_1030_268#	2.80761e-17
C486	VPWR#9	a_116_368##2	3.87054e-18
C487	S#7	a_1030_268##11	7.24788e-19
C488	VGND#8	A0#6	3.82681e-18
C489	VPWR#12	VPWR#2	1.47878e-18
C490	A0#7	A0#1	3.54539e-17
C491	S#7	a_1030_268##13	7.06363e-19
C492	VPWR#2	S#1	2.80953e-18
C493	VGND#8	A0#8	3.82681e-18
C494	VPWR#3	S#1	4.06728e-18
C495	a_1030_268##15	a_478_368#	3.65804e-19
C496	VGND#8	A0#10	3.82681e-18
C497	Y#16	a_114_85##6	1.29688e-17
C498	VPWR#3	S#9	7.5995e-18
C499	VGND#12	S#18	3.88309e-19
C500	VGND#8	A1#1	3.858e-18
C501	a_114_85##2	a_1030_268##11	2.41781e-17
C502	A0	Y#5	2.62534e-17
C503	A0#11	A0#7	3.59869e-17
C504	a_475_85#	a_1030_268##9	3.58178e-17
C505	a_114_85##2	VGND#9	4.50165e-17
C506	VGND#8	A1#9	3.82681e-18
C507	VPWR#3	S#11	5.33573e-18
C508	A0	Y#2	5.48689e-17
C509	Y#16	A1#9	1.74967e-17
C510	VGND#8	A1#11	3.82681e-18
C511	a_1030_268##15	S#1	1.57998e-17
C512	VPWR#3	S#15	1.99892e-18
C513	VGND#8	A1#7	4.12458e-18
C514	VPWR#3	S#19	2.77894e-21
C515	Y#16	A1	7.74936e-17
C516	a_1030_268##15	S#5	1.00144e-17
C517	a_116_368##2	VPWR#11	4.50221e-18
C518	A0#12	A0#11	3.32854e-17
C519	a_1030_268##9	VGND#11	1.80057e-17
C520	VPWR#2	S#9	2.89729e-18
C521	VPWR#3	S#20	2.23613e-21
C522	VGND#12	a_1030_268#	3.45056e-19
C523	Y#16	Y#17	4.68545e-19
C524	a_1030_268##15	VPWR#12	1.02252e-18
C525	Y#18	Y#7	1.23737e-17
C526	a_114_85##2	a_1030_268##13	2.46882e-17
C527	A1	Y#6	7.86887e-17
C528	A1	Y#5	2.37829e-17
C529	A0#3	A0#2	5.87104e-18
C530	a_475_85#	a_1030_268##11	8.78997e-19
C531	VPWR#3	a_1030_268##8	2.89183e-20
C532	VGND	A0#3	9.5212e-19
C533	Y#6	A1#6	9.05954e-19
C534	A1#8	A0#12	4.39677e-17
C535	Y#16	A1#11	1.66712e-17
C536	A0	Y#8	2.44664e-18
C537	a_116_368##2	Y#3	1.44053e-18
C538	A0	Y#10	5.94253e-17
C539	a_1030_268##15	S#9	1.49783e-17
C540	a_1030_268##11	VGND#11	1.71864e-17
C541	A0	a_475_85##6	4.41029e-18
C542	Y#12	A1#5	8.31334e-19
C543	Y#12	A0	3.89152e-17
C544	VGND#12	a_1030_268##9	1.65706e-18
C545	VPWR#6	a_1030_268##8	3.55396e-18
C546	A1#10	A1#8	4.42012e-17
C547	a_114_85##2	A0#5	2.52397e-18
C548	VPWR#2	S#11	9.49868e-18
C549	Y#16	a_114_85##5	2.01678e-17
C550	a_475_85#	a_1030_268##13	5.43989e-19
C551	VPWR#6	a_1030_268##10	4.45342e-18
C552	a_114_85##2	VGND#10	5.49489e-18
C553	a_116_368##2	a_478_368##6	5.30372e-19
C554	a_475_85##2	a_1030_268##11	3.29986e-17
C555	Y#6	A1#5	4.02568e-18
C556	VPWR#6	a_1030_268##12	4.45342e-18
C557	S#3	S#1	1.85446e-19
C558	A1#12	A1#10	4.67475e-17
C559	VGND#3	S#17	5.52667e-19
C560	VPWR#7	a_478_368##2	3.59882e-17
C561	VPWR#6	a_1030_268##7	4.45342e-18
C562	Y	a_478_368##3	8.12372e-17
C563	a_1030_268##4	S#19	8.46638e-18
C564	Y#12	A1	2.57008e-17
C565	Y#10	Y#2	2.2527e-18
C566	VGND#3	S#16	6.71793e-19
C567	A1	a_114_85##6	3.87103e-18
C568	VPWR#6	A0#1	4.48302e-18
C569	VGND#12	a_1030_268##11	1.75101e-18
C570	a_1030_268##4	S#20	1.28104e-17
C571	A1	Y#17	2.76631e-18
C572	a_1030_268##15	S#11	8.27299e-18
C573	VPWR#4	S#15	1.66013e-18
C574	A1	a_114_85##5	2.51339e-18
C575	S#17	VNB	3.01763e-17
C576	a_475_85##4	a_1030_268##9	1.92167e-19
C577	S#16	VNB	2.84397e-17
C578	VPWR#6	A0#7	4.42929e-18
C579	a_114_85##2	A0#6	4.82813e-19
C580	A1#13	A1#12	4.59657e-17
C581	Y#18	A1	1.59157e-17
C582	a_1030_268##4	a_1030_268##8	4.38651e-18
C583	S#5	VNB	2.81323e-17
C584	Y#12	Y#5	7.98369e-18
C585	a_114_85##2	a_475_85#	5.81517e-17
C586	S#3	VNB	4.80262e-17
C587	a_1030_268##15	S#3	2.30277e-17
C588	a_475_85##2	a_1030_268##13	2.96669e-17
C589	A1#5	a_116_368##6	5.87261e-19
C590	a_1030_268##6	VNB	1.82914e-17
C591	a_1030_268##4	a_1030_268##10	1.31012e-18
C592	VPWR#6	A0#11	4.45453e-18
C593	a_1030_268##5	VNB	3.81469e-17
C594	a_1030_268##3	VNB	1.24411e-17
C595	a_1030_268##2	VNB	2.74104e-17
C596	VPWR#2	S#15	6.73719e-19
C597	A0#9	VNB	2.33609e-17
C598	Y#8	a_1030_268##11	2.09813e-19
C599	A0#3	VNB	2.70572e-17
C600	VPWR	VPWR#5	1.07344e-18
C601	A0#2	VNB	3.06596e-17
C602	Y#2	Y	2.59148e-18
C603	a_1030_268##4	a_1030_268##12	4.77505e-19
C604	A1#6	VNB	4.00983e-17
C605	VPWR#6	A0#12	4.46413e-18
C606	VGND#3	S#5	8.70078e-19
C607	VPWR#7	S#17	1.45517e-19
C608	A1#5	VNB	5.30771e-17
C609	Y#12	A1#2	1.52712e-18
C610	A1#2	VNB	2.62012e-17
C611	A0	a_478_368##4	9.32642e-19
C612	a_1030_268##4	a_1030_268##7	3.96397e-19
C613	VPWR#6	A1#8	4.4526e-18
C614	a_1030_268##13	VGND#12	1.2312e-17
C615	a_478_368##2	a_478_368#	2.64007e-18
C616	VPWR	a_478_368##3	3.15046e-17
C617	a_114_85##6	A1#5	5.84686e-19
C618	VPWR	a_478_368##2	9.60773e-18
C619	VPWR#6	A1#10	4.46413e-18
C620	VGND#3	S#3	4.71371e-19
C621	a_475_85##4	a_1030_268##11	2.63004e-19
C622	a_114_85##2	A0#8	3.30214e-19
C623	VPWR	a_116_368##4	6.38052e-17
C624	VPWR#6	A1#12	4.46413e-18
C625	a_114_85##2	VGND#11	2.5948e-18
C626	a_1030_268##15	S#15	8.47357e-18
C627	VPWR#4	S#19	2.55249e-18
C628	Y#8	Y	1.59887e-17
C629	VPWR#7	S#16	7.46243e-19
C630	Y#8	a_1030_268##13	1.09376e-18
C631	a_475_85##4	Y	2.24698e-18
C632	VPWR	Y#6	2.84767e-18
C633	VPWR#6	A1#13	5.13076e-18
C634	Y#10	Y	2.38192e-18
C635	VGND	VGND#7	7.007e-17
C636	VPWR	Y#5	1.16191e-17
C637	VGND	VGND#6	7.3716e-17
C638	Y#5	A1#5	4.71096e-19
C639	VGND	VGND#5	7.07676e-18
C640	VPWR	Y#2	5.34145e-18
C641	A1#2	a_116_368##6	5.83681e-19
C642	VPWR#2	S#19	2.57768e-19
C643	a_1030_268##14	S#3	8.26005e-18
C644	VGND#12	A0#5	4.09867e-19
C645	A1	Y#7	1.39203e-17
C646	a_475_85##4	a_1030_268##13	1.53659e-18
C647	VGND	a_114_85##4	1.03723e-16
C648	a_478_368##3	a_116_368##4	3.70323e-17
C649	a_478_368##2	VPWR#12	4.3006e-17
C650	a_114_85##4	Y#16	8.91233e-19
C651	VPWR#5	S#20	2.55321e-18
C652	a_114_85##2	a_475_85##2	1.15173e-16
C653	Y#8	A0#5	4.26843e-17
C654	VPWR#3	S#7	1.26215e-17
C655	VGND	Y#16	3.00647e-18
C656	Y	VPWR#9	3.54503e-20
C657	A1#5	Y#15	6.39588e-19
C658	Y	VPWR#11	3.75855e-17
C659	VGND#3	S#7	1.71428e-17
C660	Y#2	A0#3	1.25982e-18
C661	Y	Y#3	7.06038e-18
C662	VPWR#3	a_1030_268##4	4.99045e-18
C663	Y	a_478_368##6	1.28847e-18
C664	a_114_85##6	A1#2	8.29481e-19
C665	VGND#3	a_1030_268##4	5.02045e-18
C666	VGND#7	VNB	4.15929e-17
C667	a_475_85##4	A0#5	3.25813e-17
C668	VGND#6	VNB	3.71175e-17
C669	VGND#5	VNB	3.65601e-17
C670	VGND	a_114_85##2	2.79338e-17
C671	VGND#7	VGND#6	1.20516e-19
C672	VGND	a_475_85#	4.23164e-18
C673	VPWR#5	VNB	2.36402e-17
C674	VPWR#4	VNB	2.46266e-17
C675	VPWR	a_116_368#	2.18377e-17
C676	VGND	a_475_85##2	1.00456e-17
C677	VPWR#2	VNB	3.56266e-17
C678	VGND	VGND#12	1.46797e-17
C679	VPWR	VPWR#9	6.90916e-18
C680	a_475_85#	VGND#11	6.26013e-19
C681	a_1030_268##15	VNB	2.20907e-17
C682	VPWR#6	A0#4	3.96696e-20
C683	VGND	Y#8	6.62539e-18
C684	VPWR	a_116_368##2	6.28481e-17
C685	VGND	a_475_85##4	1.88208e-17
C686	a_478_368##2	a_478_368##5	1.5569e-18
C687	a_114_85##2	VGND#12	4.32582e-17
C688	a_114_85##4	VNB	3.57542e-17
C689	Y#8	A0#6	5.54622e-20
C690	VPWR	VPWR#11	7.73988e-18
C691	VGND	Y#10	6.86746e-18
C692	a_478_368##2	S#15	8.32976e-19
C693	a_478_368##3	VNB	7.92789e-18
C694	VGND	a_475_85##6	7.97214e-18
C695	a_478_368##2	VNB	2.07307e-18
C696	a_1030_268##4	S#7	7.51209e-17
C697	VGND	Y#12	1.20019e-17
C698	VGND#8	A0#4	7.80007e-20
C699	S#16	VGND#9	5.04836e-19
C700	a_116_368##4	VNB	1.18829e-17
C701	VGND	Y#17	5.8676e-18
C702	VPWR	a_478_368##4	9.70039e-18
C703	VPWR#5	a_1030_268##8	3.76301e-19
C704	VGND	a_114_85##5	2.18286e-17
C705	Y#16	VNB	7.53047e-19
C706	VGND	Y#18	1.6387e-17
C707	a_478_368##4	Y#1	1.01841e-18
C708	VPWR	Y#15	6.14543e-18
C709	a_478_368#	S#16	1.8332e-19
C710	a_478_368##3	VPWR#13	4.54234e-20
C711	VPWR#6	a_1030_268##6	1.10317e-20
C712	VPWR	a_116_368##5	2.35191e-17
C713	VPWR	Y#7	1.76575e-17
C714	Y#5	A1#2	8.93875e-19
C715	a_475_85##4	A0#6	2.68235e-17
C716	a_1030_268##14	VNB	4.6331e-17
C717	VPWR#7	S#5	1.30648e-18
C718	VGND#4	VNB	3.50748e-18
C719	a_114_85#	VNB	2.07498e-18
C720	VPWR#6	a_1030_268##5	3.6448e-20
C721	A1#6	a_116_368##5	5.91569e-19
C722	VGND#9	VNB	6.26267e-18
C723	A0	A0#1	9.03554e-19
C724	a_114_85##2	VNB	1.15666e-17
C725	S#3	VGND#4	6.83302e-18
C726	VGND	VPWR#11	7.02654e-18
C727	a_475_85#	VNB	6.28e-19
C728	S#5	S#3	2.05943e-18
C729	a_475_85##2	VNB	8.65217e-18
C730	VGND#12	VNB	3.42178e-18
C731	A0	A0#11	2.10043e-18
C732	VPWR#6	a_1030_268##3	3.59023e-20
C733	Y#8	VNB	5.83181e-18
C734	a_475_85##4	VNB	1.8823e-17
C735	S#5	a_114_85#	4.4341e-18
C736	VGND#12	VGND#10	1.79648e-20
C737	Y#8	A0#8	3.18748e-20
C738	Y#10	VNB	8.37272e-19
C739	A0	A0#12	1.70816e-18
C740	a_478_368##2	S#17	5.05116e-19
C741	Y#12	VNB	3.276e-18
C742	a_116_368##6	a_478_368##6	1.27802e-21
C743	a_114_85##6	VNB	6.54173e-20
C744	A0	A1#8	3.41543e-19
C745	Y#10	A0#6	3.8067e-17
C746	a_114_85##5	A1#6	4.34064e-19
C747	VPWR#6	a_1030_268##2	3.5998e-21
C748	a_114_85##5	VNB	1.14422e-17
C749	VGND	Y#7	4.44228e-18
C750	Y#18	VNB	4.30299e-17
C751	VPWR#1	VNB	8.09506e-17
C752	A1	A0#11	1.96626e-19
C753	a_478_368##2	VPWR#13	6.389e-17
C754	a_1030_268##17	VNB	3.94029e-18
C755	Y#12	A0#5	1.32709e-19
C756	VPWR#7	VNB	1.86806e-18
C757	a_478_368##2	S#19	3.25644e-17
C758	A1	A0#12	7.53288e-19
C759	a_478_368#	VNB	2.12733e-18
C760	VPWR#12	VNB	3.74405e-18
C761	A1#5	a_116_368##5	6.69526e-19
C762	VPWR#6	A0#9	5.22367e-21
C763	A1	A1#8	1.69683e-18
C764	VPWR#13	VNB	8.88034e-19
C765	a_116_368#	VNB	4.42518e-18
C766	VGND	a_1030_268##9	9.25484e-18
C767	A1	A1#10	2.1032e-18
C768	a_114_85##2	S#17	2.39191e-18
C769	a_116_368##2	VNB	1.78261e-17
C770	a_475_85##4	A0#8	9.84332e-20
C771	VGND	a_1030_268##11	8.71688e-18
C772	VPWR#11	VNB	1.84183e-18
C773	Y	a_1030_268##10	6.02287e-19
C774	A1#2	A0#9	2.48081e-17
C775	VGND	a_1030_268##13	8.71688e-18
C776	A1	A1#12	2.10322e-18
C777	VPWR#6	A0#3	2.46713e-20
C778	Y	a_1030_268##12	8.46256e-19
C779	A1	A1#13	3.30338e-18
C780	Y	a_1030_268##7	3.80992e-18
C781	a_116_368##6	VNB	5.91083e-20
C782	Y	A0#1	2.60711e-17
C783	a_116_368##5	VNB	8.34151e-18
C784	Y	A0#7	7.99478e-18
C785	VPWR#6	A0#2	4.55058e-20
C786	a_114_85##6	A0#5	3.42665e-19
C787	Y#7	VNB	5.56203e-17
C788	S#8	VNB	3.45688e-17
C789	VPWR	a_1030_268##8	4.5109e-19
C790	Y	A0#11	6.67728e-19
C791	S#10	VNB	2.83961e-17
C792	VGND	A1#7	4.96172e-18
C793	VPWR	a_1030_268##10	1.18648e-18
C794	S#12	VNB	2.96507e-17
C795	Y	A0#12	2.72553e-19
C796	a_475_85##2	VGND#11	8.10633e-19
C797	Y#8	A0#10	1.96218e-20
C798	S#14	VNB	3.04265e-17
C799	VPWR	a_1030_268##12	1.28762e-18
C800	S#18	VNB	2.88515e-17
C801	Y	A1#8	1.68585e-19
C802	a_114_85##5	A1#5	3.46665e-19
C803	a_1030_268#	VNB	3.13573e-17
C804	VPWR	a_1030_268##7	1.65307e-18
C805	VPWR#6	A1#6	1.13558e-20
C806	Y#10	A0#8	3.64622e-17
C807	a_1030_268##9	VNB	3.17785e-17
C808	Y	A1#10	1.70965e-19
C809	a_475_85##4	a_114_85##2	2.80197e-17
C810	VPWR	A0#1	1.68537e-18
C811	a_1030_268##11	VNB	2.93935e-17
C812	a_1030_268##13	VNB	3.13939e-17
C813	a_478_368##3	S#20	5.48046e-19
C814	VPWR	A0#7	1.65693e-18
C815	A0#5	VNB	3.23374e-17
C816	A0	A0#4	2.23786e-17
C817	Y#12	A0#6	1.80774e-19
C818	A0#6	VNB	2.62285e-17
C819	VPWR	A0#11	1.64848e-18
C820	A0#8	VNB	2.64749e-17
C821	VPWR	A0#12	1.64557e-18
C822	A0#10	VNB	2.62884e-17
C823	a_478_368##2	S#16	3.09663e-19
C824	VPWR#6	A1#5	4.89057e-20
C825	A1#1	VNB	2.67954e-17
C826	VPWR	A1#8	1.64246e-18
C827	A1#9	VNB	2.62366e-17
C828	A1	A0#4	2.70361e-20
C829	A1#11	VNB	2.56748e-17
C830	VPWR	A1#10	1.57704e-18
C831	A1#7	VNB	3.71066e-17
C832	VPWR	A1#12	1.57716e-18
C833	S#1	VNB	3.82469e-17
C834	VPWR	A1#13	3.44892e-18
C835	a_475_85##4	A0#10	6.73212e-20
C836	a_478_368##2	a_116_368#	6.10188e-17
C837	S#9	VNB	3.40451e-17
C838	S#11	VNB	3.70415e-17
C839	S#16	a_114_85##2	4.1378e-18
C840	a_478_368##2	S#20	2.98142e-17
C841	S#15	VNB	3.36947e-17
C842	VGND#6	VGND#5	4.48955e-18
C843	a_475_85##6	A0#8	3.23837e-17
C844	S#19	VNB	3.36409e-17
C845	S#20	VNB	3.21529e-17
C846	a_1030_268##8	VNB	2.9929e-17
C847	Y	a_1030_268##4	1.02287e-17
C848	a_1030_268##10	VNB	3.16068e-17
C849	VPWR	VPWR#6	3.59318e-16
C850	a_1030_268##12	VNB	3.15008e-17
C851	VPWR#6	A1#2	1.12044e-20
C852	a_114_85##6	A0#6	3.62525e-19
C853	a_1030_268##7	VNB	3.93906e-17
C854	A0#1	VNB	3.98672e-17
C855	VPWR#12	S#16	4.54796e-19
C856	A0#7	VNB	3.25668e-17
C857	A0#11	VNB	3.22314e-17
C858	VPWR	a_1030_268##4	8.31546e-18
C859	A0#12	VNB	3.31628e-17
C860	A1#8	VNB	3.25008e-17
C861	Y#8	A1#1	1.97186e-20
C862	VPWR#9	a_478_368##3	1.93252e-17
C863	A1#10	VNB	3.20359e-17
C864	VGND	VGND#8	2.2261e-16
C865	A1#12	VNB	3.16164e-17
C866	A1#13	VNB	4.11521e-17
C867	VGND	a_1030_268##4	7.81267e-18
C868	A1	A0	2.13353e-17
C869	VPWR#3	VNB	1.80316e-16
C870	a_114_85##2	Y#10	9.28635e-20
C871	VGND#3	VNB	2.17024e-16
C872	Y#12	A0#8	6.54415e-19
C873	VPWR#6	VNB	2.14616e-16
C874	VGND#8	VNB	1.38641e-16
C875	S#7	VNB	4.50454e-17
C876	a_1030_268##4	VNB	7.80698e-18
C877	A0	Y	2.0037e-17
C878	VGND#7	a_114_85##2	6.10717e-18
C879	A0#4	VNB	3.73367e-17
C880	Y#18	A1#6	2.01604e-19
C881	VPWR	A0	7.03146e-18
C882	S#7	S#17	1.84888e-17
C883	a_478_368##3	a_1030_268##8	5.31317e-19
C884	VPWR	A1	8.8993e-18
C885	a_1030_268##2	S#17	3.11858e-17
C886	VGND	A0	5.81489e-18
C887	VGND	A1	8.08782e-18
C888	VPWR	Y	8.77353e-18
C889	A0#10	a_475_85##6	1.85994e-17
C890	A0	VNB	5.7527e-18
C891	A1	VNB	2.44722e-17
C892	VGND	Y	5.50575e-18
C893	S#7	S#16	2.07832e-17
C894	VGND#8	A0#9	1.31703e-20
C895	Y	VNB	1.3239e-17
C896	a_114_85##6	A0#8	6.61821e-19
C897	A1#6	A1#5	2.56729e-18
C898	VPWR	VNB	3.32195e-16
C899	VGND	VNB	3.32609e-16
C900	a_478_368##2	VPWR#9	1.49836e-16
C901	a_478_368##2	a_1030_268##8	1.97349e-17
C902	VGND#8	A0#3	3.06333e-20
C903	VGND#2	S#3	1.16881e-19
C904	VGND#2	a_1030_268##14	1.88183e-17
C905	VGND#2	S#8	3.52134e-18
C906	VGND#2	VNB	5.26826e-17
C907	VGND#2	S#10	4.43618e-18
C908	VGND#2	a_1030_268##15	6.16576e-20
C909	VGND#2	a_114_85#	2.70578e-18
C910	VGND#2	S#7	1.35305e-18
C911	VGND#9	VGND#2	3.27494e-19
C912	VGND#3	VGND#2	8.97282e-17
*
*
.ENDS sky130_fd_sc_hs__mux2i_4
*
