* Extracted by Quantus, converted by sky130cad/quantus.py
*
*
*
*                       LINUX           Wed Nov 18 08:11:44 2026
*
*
*
*  PROGRAM  advgen
*
*  Name           : advgen - Quantus - (64-bit)
*  Version        : 25.1.0-p047
*  Build Date     : Thu Dec 11 23:20:30 PST 2025
*
*  HSPICE LIBRARY
*
*  OPERATING_TEMPERATURE 150
*  QRC_TECH_DIR <path>/tech
*
*
*

*
.SUBCKT sky130_fd_sc_hs__a311oi_1 VPB VNB VGND VPWR Y A3 A2 A1 B1 C1
*
*
*  caps2d version: 10
*
*
*       TRANSISTOR CARDS
*
*
XM9 VGND#7 A3#1 a_159_74# VNB sky130_fd_pr__nfet_01v8_lvt l=0.15 w=0.74 ad=0.1961 as=0.1554 pd=2.01 ps=1.9
XM5 a_159_74# A2#3 a_231_74# VNB sky130_fd_pr__nfet_01v8_lvt l=0.15 w=0.74 ad=0.1554 as=0.2886 pd=1.9 ps=2.26
XM1 a_231_74# A1#3 Y#3 VNB sky130_fd_pr__nfet_01v8_lvt l=0.15 w=0.74 ad=0.2886 as=0.2886 pd=2.26 ps=2.26
XM3 Y#3 B1#3 VGND#6 VNB sky130_fd_pr__nfet_01v8_lvt l=0.15 w=0.74 ad=0.2886 as=0.2886 pd=2.26 ps=2.26
XM4 VGND#6 C1#3 Y#5 VNB sky130_fd_pr__nfet_01v8_lvt l=0.15 w=0.74 ad=0.2886 as=0.1961 pd=2.26 ps=2.01
XM0 VPWR#4 A3#4 a_156_368##2 VPB sky130_fd_pr__pfet_01v8 l=0.15 w=1.12 ad=0.308 as=0.336 pd=2.79 ps=2.84
XM8 a_156_368##2 A2#1 VPWR#1 VPB sky130_fd_pr__pfet_01v8 l=0.15 w=1.12 ad=0.336 as=0.5376 pd=2.84 ps=3.2
XM7 VPWR#1 A1#1 a_156_368# VPB sky130_fd_pr__pfet_01v8 l=0.15 w=1.12 ad=0.5376 as=0.336 pd=3.2 ps=2.84
XM2 a_156_368# B1#1 a_462_368# VPB sky130_fd_pr__pfet_01v8 l=0.15 w=1.12 ad=0.336 as=0.3696 pd=2.84 ps=2.9
XM6 a_462_368# C1#4 Y#1 VPB sky130_fd_pr__pfet_01v8 l=0.15 w=1.12 ad=0.3696 as=0.308 pd=2.9 ps=2.79
*
*
*       RESISTOR AND CAP/DIODE CARDS
*
Rg1	A3#1	A3#2	322.953644
Rg2	A3#2	A3#3	56.190353
Rg3	A3#2	A3#4	507.075531
Rg4	A2#1	A2#2	434.639221
Rg5	A2#2	A2#3	382.539734
Rg6	A1#1	A1#2	434.639221
Rg7	A1#2	A1#3	382.539734
Rg8	B1#1	B1#2	434.639221
Rg9	B1#2	B1#3	382.539734
Rg10	C1#1	C1#2	56.207058
Rg11	C1#2	C1#3	397.555725
Rg12	C1#2	C1#4	449.655212
Rf1	A3	A3#5	0.996305
Rf2	A3#6	A3#3	161.229111
Rf3	A3#5	A3#6	3.176847
Rf4	A3	A3#8	0.996305
Rf5	A3#6	A3#8	9.883524
Rf6	A2#2	A2	166.137894
Rf7	A1#2	A1	166.137894
Rf8	a_156_368#	a_156_368##2	99.070595
Rf9	B1#4	B1	1.409262
Rf10	B1#2	B1#6	161.642059
Rf11	B1#4	B1#6	2.750425
Rf12	B1#7	B1	1.409262
Rf13	B1#6	B1#7	11.918507
Rf14	Y#1	Y#2	293.808563
Rf15	Y#2	Y	1.201738
Rf16	Y	Y#4	2.599982
Rf17	Y#4	Y	2.599982
Rf18	Y#2	Y#5	114.122894
Rf19	Y#3	Y#4	7.500000
Rf20	C1#1	C1	166.137894
Rf22	VGND#2	VGND#3	52.186226
Rf23	VGND#3	VGND#4	85.809799
Rf25	VGND#2	VGND#6	35.844460
Rf26	VGND#4	VGND#7	38.247387
Rf27	VPWR#1	VPWR#2	33.348000
Rf28	VPWR#2	VPWR#3	93.647026
Rf29	VPWR#3	VPWR#4	38.736572
Re1	VPWR#2	VPWR	1.403190
Re2	VGND	VGND#3	1.403242
*
*       CAPACITOR CARDS
*
*
C1	B1#2	C1#2	3.42343e-17
C2	Y#5	C1#2	1.1036e-18
C3	A3#2	A2#2	3.39376e-17
C4	Y#5	VGND#6	5.99842e-17
C5	VGND#7	A3#2	2.81858e-19
C6	VGND#7	A3#5	1.51098e-17
C7	VGND#7	VGND#6	5.42306e-19
C8	Y#5	Y#1	4.62164e-18
C9	Y#5	C1#3	4.47898e-17
C10	C1	C1#2	3.37388e-19
C11	C1#3	VGND#6	1.91915e-17
C12	Y#1	a_156_368#	8.23801e-17
C13	Y#5	B1#3	8.87855e-19
C14	VGND#6	B1#3	3.48722e-17
C15	Y#1	VPWR#1	4.03296e-18
C16	Y#5	A1#3	1.91965e-19
C17	B1#3	Y#3	2.47535e-18
C18	VGND#6	A1#3	6.06446e-19
C19	Y#1	a_156_368##2	7.16201e-18
C20	VGND#7	VPWR#4	2.59443e-18
C21	B1	C1#2	1.69551e-17
C22	A1#3	Y#3	1.80988e-17
C23	a_156_368#	VPWR#1	5.5161e-17
C24	VGND#6	A2#3	1.35018e-19
C25	a_156_368##2	a_156_368#	2.36331e-18
C26	VGND#7	B1#3	7.60664e-20
C27	VGND#6	A3#1	1.47879e-19
C28	a_156_368##2	VPWR#1	5.60154e-17
C29	VGND#7	A1#3	1.42643e-19
C30	VPWR#4	VPWR#1	2.20081e-18
C31	VGND#7	A2#3	5.27162e-18
C32	VPWR#4	a_156_368##2	5.26195e-17
C33	VGND#7	A3#1	3.17055e-17
C34	B1#3	C1#3	1.99516e-17
C35	Y#1	C1#4	6.02155e-17
C36	A2	A3#2	4.08559e-18
C37	Y#1	B1#1	2.65473e-17
C38	a_156_368#	C1#4	7.43719e-18
C39	A1#3	B1#3	2.45256e-17
C40	Y#1	A1#1	1.4033e-17
C41	VPWR#1	C1#4	8.93052e-19
C42	a_156_368#	B1#1	5.03877e-17
C43	Y#1	A2#1	2.61969e-19
C44	VPWR#1	B1#1	1.33302e-18
C45	A2#3	A1#3	2.36106e-17
C46	a_156_368#	A1#1	5.64021e-17
C47	A3	A3#2	1.43723e-18
C48	A1#1	VPWR#1	3.55135e-17
C49	Y#1	A3#4	2.93232e-19
C50	a_156_368#	A2#1	5.55913e-19
C51	a_156_368##2	A1#1	5.55913e-19
C52	A3#1	A2#3	5.68873e-17
C53	A2#1	VPWR#1	3.77855e-17
C54	Y#5	C1#1	6.7111e-18
C55	VPWR#4	A1#1	1.64318e-19
C56	a_156_368##2	A2#1	5.81441e-17
C57	VPWR#1	A3#4	1.52516e-18
C58	Y#1	VPWR#2	2.57968e-17
C59	VPWR#4	A2#1	6.81043e-19
C60	a_156_368##2	A3#4	4.56849e-17
C61	VGND#6	B1#2	9.68203e-19
C62	A3#4	VPWR#4	2.29736e-17
C63	a_156_368#	VPWR#2	1.96281e-17
C64	Y	C1#2	1.03767e-19
C65	Y	A3#2	1.12109e-17
C66	C1#1	Y#1	6.64797e-18
C67	a_156_368##2	VPWR#2	9.44928e-18
C68	A3#6	A3#3	1.08809e-17
C69	B1#2	Y#1	2.03303e-17
C70	A3#5	A3#3	8.95364e-18
C71	B1#1	C1#4	4.23316e-17
C72	Y#1	A1#2	4.06809e-18
C73	A1#1	B1#1	4.60519e-17
C74	a_156_368#	A1#2	1.38928e-18
C75	VGND#3	A1#3	5.35671e-18
C76	A1#2	VPWR#1	1.25799e-18
C77	A3#3	VGND#7	6.32567e-18
C78	VGND#3	A2#3	1.7087e-18
C79	A2#1	A1#1	2.27495e-17
C80	A2#2	VPWR#1	6.51627e-19
C81	VPWR#2	C1#4	5.6924e-18
C82	a_156_368##2	A2#2	3.37634e-19
C83	A3#4	A2#1	4.52427e-17
C84	VPWR#2	B1#1	7.6604e-18
C85	A3#2	A2#3	4.11494e-18
C86	VPWR#2	A1#1	2.55589e-18
C87	Y#1	a_462_368#	5.91051e-18
C88	VPWR#4	A3#3	4.437e-18
C89	VPWR#2	A2#1	2.56505e-18
C90	VGND	A3#2	1.59254e-18
C91	B1#2	B1#1	1.41414e-18
C92	Y#5	C1	2.95852e-17
C93	VPWR#2	C1#1	4.17284e-19
C94	Y#5	B1	3.2437e-17
C95	VPWR#2	B1#2	1.04645e-19
C96	C1	Y#1	3.19006e-17
C97	A3#4	A2#2	3.04238e-18
C98	C1#2	VNB	2.1178e-17
C99	A3#2	VNB	2.0009e-17
C100	C1#4	a_462_368#	3.09476e-17
C101	A1#3	a_231_74#	1.80988e-17
C102	B1#1	a_462_368#	3.02816e-17
C103	VGND#3	A1#2	8.48314e-20
C104	A2#3	a_231_74#	1.80988e-17
C105	B1	Y#1	4.49441e-17
C106	VGND#3	A2#2	8.68753e-20
C107	A2#3	a_159_74#	1.45628e-17
C108	A1#2	B1#2	3.4565e-17
C109	VGND#3	A3#3	1.71863e-21
C110	A3#1	a_159_74#	1.54251e-17
C111	A1	Y#1	4.03157e-17
C112	A2#2	A1#2	2.92361e-17
C113	C1	C1#4	1.48885e-18
C114	B1#2	a_462_368#	3.10657e-19
C115	A3#6	Y	1.50911e-17
C116	B1	C1#4	2.41038e-18
C117	A3#5	Y	1.49771e-17
C118	Y	Y#5	2.73244e-18
C119	B1	B1#1	6.18154e-19
C120	Y	VGND#6	6.80681e-17
C121	Y	Y#3	4.89128e-18
C122	B1	A1#1	8.40444e-19
C123	C1	VPWR#2	1.22098e-18
C124	VGND#7	Y	3.3564e-17
C125	A3	VPWR#4	1.13337e-17
C126	A1	B1#1	4.14867e-19
C127	Y	Y#1	8.61232e-18
C128	A1	A1#1	2.01761e-18
C129	A1	A2#1	4.87556e-19
C130	C1	C1#1	2.06288e-17
C131	Y	VPWR#1	8.01578e-19
C132	Y	a_156_368##2	5.93952e-17
C133	A2	A1#1	4.06737e-19
C134	Y	C1#3	7.85799e-19
C135	A2	A2#1	2.023e-18
C136	VPWR	Y#1	2.68937e-17
C137	Y	B1#3	2.46997e-17
C138	A2	A3#4	1.36152e-18
C139	B1	B1#2	6.42127e-18
C140	Y	A1#3	4.84164e-17
C141	VPWR	a_156_368#	1.72478e-17
C142	VGND	A3#5	6.41989e-18
C143	Y	A2#3	4.00874e-17
C144	VPWR	VPWR#1	2.17057e-17
C145	B1	A1#2	3.75542e-18
C146	VGND	Y#5	1.7166e-17
C147	Y	A3#1	1.93447e-17
C148	VPWR	a_156_368##2	1.72236e-17
C149	A1	B1#2	3.70606e-18
C150	A3	A3#4	2.48093e-18
C151	Y	C1#4	1.48823e-19
C152	A1	A1#2	1.48162e-17
C153	Y	B1#1	1.33899e-19
C154	Y	A1#1	3.38165e-19
C155	A1	A2#2	3.58926e-18
C156	Y	A2#1	1.70399e-17
C157	A2	A1#2	4.2962e-18
C158	Y	A3#4	2.03658e-17
C159	A3#6	VNB	5.53316e-18
C160	VPWR	C1#4	1.16405e-18
C161	A3#5	VNB	1.34019e-17
C162	A2	A2#2	1.43133e-17
C163	Y#5	VNB	4.38441e-17
C164	VGND	C1#3	7.08742e-19
C165	VPWR	B1#1	1.72408e-18
C166	VGND#6	VNB	1.28835e-18
C167	VGND	B1#3	6.65419e-19
C168	VPWR	A1#1	1.75762e-19
C169	VGND	A1#3	3.13556e-19
C170	VGND#3	Y	3.91516e-17
C171	VPWR	A2#1	5.02612e-21
C172	VGND#7	VNB	2.43853e-17
C173	VPWR	A3#4	2.85386e-18
C174	VGND	A3#1	7.49791e-19
C175	Y#1	VNB	5.08933e-17
C176	Y	B1#2	2.23208e-17
C177	A3	A3#3	5.44838e-18
C178	a_156_368#	VNB	2.09331e-18
C179	VPWR	VPWR#2	6.61141e-17
C180	VPWR#1	VNB	4.7531e-18
C181	Y	A1#2	3.99068e-18
C182	a_156_368##2	VNB	2.13373e-18
C183	B1	C1	3.77707e-17
C184	VPWR#4	VNB	3.50581e-17
C185	Y	A2#2	1.00263e-17
C186	C1#3	VNB	3.18425e-17
C187	B1#3	VNB	2.66482e-17
C188	VPWR	B1#2	1.15202e-18
C189	A1#3	VNB	3.11357e-17
C190	A2#3	VNB	2.46753e-17
C191	A3#1	VNB	3.29621e-17
C192	Y	a_462_368#	1.3028e-20
C193	A1	B1	3.78909e-17
C194	VGND	VGND#3	1.94552e-17
C195	C1#4	VNB	3.41322e-17
C196	B1#1	VNB	2.99217e-17
C197	VGND	C1#1	2.37236e-18
C198	A1#1	VNB	3.07187e-17
C199	VGND	B1#2	1.29582e-18
C200	A2#1	VNB	3.21286e-17
C201	Y	a_231_74#	1.14076e-18
C202	A3#4	VNB	5.44358e-17
C203	Y	a_159_74#	2.78376e-18
C204	A2	A1	3.04207e-17
C205	VPWR#2	VNB	2.41769e-16
C206	VGND	A3#3	1.12557e-18
C207	VGND#3	VNB	1.79721e-16
C208	C1#1	VNB	5.07587e-17
C209	B1#2	VNB	3.53334e-17
C210	Y	B1	1.20308e-17
C211	A1#2	VNB	2.73678e-17
C212	VPWR	C1	5.42156e-18
C213	A2#2	VNB	3.00512e-17
C214	Y	A1	4.51401e-17
C215	A3#3	VNB	4.74788e-17
C216	VPWR	B1	3.13077e-18
C217	Y	A2	1.12555e-16
C218	VPWR	A1	2.51368e-18
C219	VGND	C1	5.77804e-18
C220	A3	Y	2.27168e-17
C221	VGND	B1	3.21473e-18
C222	VPWR	A2	2.51368e-18
C223	VGND	A1	2.49498e-18
C224	VPWR	A3	5.99692e-18
C225	C1	VNB	2.71731e-17
C226	VGND	A2	2.16698e-18
C227	B1	VNB	3.20199e-18
C228	VPWR	Y	6.16929e-18
C229	A1	VNB	3.91699e-18
C230	A2	VNB	3.6993e-18
C231	VGND	Y	4.36937e-17
C232	A3	VNB	2.18558e-17
C233	Y	VNB	3.9333e-17
C234	VPWR	VNB	6.46285e-17
C235	VGND	VNB	6.13572e-17
C236	a_156_368##2	VPWR#3	7.73356e-18
C237	VPWR#2	VPWR#3	4.13405e-17
C238	VGND#2	Y#5	2.10084e-17
C239	VGND#4	A3#5	1.92935e-18
C240	VGND#3	VGND#4	4.93616e-17
C241	VGND#4	A1#3	2.5503e-19
C242	VGND#2	VNB	5.43236e-17
C243	VPWR#3	A1#1	7.3943e-20
C244	VGND#4	VNB	4.92177e-17
C245	VGND#2	A1#3	9.89141e-19
C246	VGND#2	Y	3.81927e-18
C247	VPWR#3	A3#3	4.49702e-19
C248	VPWR#3	VNB	4.02701e-17
C249	VGND#4	A2#3	4.64917e-18
C250	VGND#4	Y	4.6622e-18
C251	VPWR#3	A2#1	5.42211e-19
C252	VGND#4	A3#3	6.35421e-19
C253	VGND#3	VGND#2	5.90071e-17
C254	A3	VPWR#3	1.07906e-18
C255	VGND#2	A2#3	1.57495e-19
C256	VGND#4	VGND#6	9.29668e-20
C257	VPWR#3	A3#4	8.02422e-18
C258	VGND#2	C1#3	6.0389e-18
C259	VGND#4	A3#1	9.45794e-18
C260	Y	VPWR#3	9.2166e-19
C261	VGND#2	C1#2	1.36018e-20
C262	VGND#2	C1	1.28639e-18
C263	VGND#2	C1#1	4.34915e-19
C264	VGND#2	A3#1	1.24645e-19
C265	VPWR#3	VPWR#1	1.5607e-19
C266	VGND	VGND#2	6.17988e-17
C267	VGND#4	B1#3	9.15759e-20
C268	VGND#2	B1#3	5.0456e-18
C269	VGND	VGND#4	5.24781e-17
C270	VPWR	VPWR#3	4.5538e-17
C271	VGND#4	VGND#2	1.19433e-20
*
*
.ENDS sky130_fd_sc_hs__a311oi_1
*
