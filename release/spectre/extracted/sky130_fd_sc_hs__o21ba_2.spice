* Extracted by Quantus, converted by sky130cad/quantus.py
*
*
*
*                       LINUX           Wed Nov 18 08:56:08 2026
*
*
*
*  PROGRAM  advgen
*
*  Name           : advgen - Quantus - (64-bit)
*  Version        : 25.1.0-p047
*  Build Date     : Thu Dec 11 23:20:30 PST 2025
*
*  HSPICE LIBRARY
*
*  OPERATING_TEMPERATURE 150
*  QRC_TECH_DIR <path>/tech
*
*
*

*
.SUBCKT sky130_fd_sc_hs__o21ba_2 VNB VPB VGND VPWR X A2 A1 B1_N
*
*
*  caps2d version: 10
*
*
*       TRANSISTOR CARDS
*
*
XM3 a_27_74##7 B1_N#4 VGND#9 VNB sky130_fd_pr__nfet_01v8_lvt l=0.15 w=0.55 ad=0.15125 as=0.22625 pd=1.65 ps=2.13
XM6 X#1 a_177_48##4 VGND#9 VNB sky130_fd_pr__nfet_01v8_lvt l=0.15 w=0.74 ad=0.2072 as=0.22625 pd=2.04 ps=2.13
XM5 VGND#8 a_177_48##5 X#1 VNB sky130_fd_pr__nfet_01v8_lvt l=0.15 w=0.74 ad=0.2035 as=0.2072 pd=2.03 ps=2.04
XM7 a_177_48##7 a_27_74##4 a_487_74# VNB sky130_fd_pr__nfet_01v8_lvt l=0.15 w=0.74 ad=0.2035 as=0.2072 pd=2.03 ps=2.04
XM10 a_487_74# A2#3 VGND#7 VNB sky130_fd_pr__nfet_01v8_lvt l=0.15 w=0.74 ad=0.2072 as=0.3594 pd=2.04 ps=2.68
XM1 VGND#7 A1#4 a_487_74##2 VNB sky130_fd_pr__nfet_01v8_lvt l=0.15 w=0.74 ad=0.3594 as=0.1998 pd=2.68 ps=2.02
XM0 a_27_74##8 B1_N#1 VPWR#6 VPB sky130_fd_pr__pfet_01v8 l=0.15 w=0.84 ad=0.2478 as=0.4172 pd=2.27 ps=3.03
XM2 VPWR#6 a_177_48##6 X#3 VPB sky130_fd_pr__pfet_01v8 l=0.15 w=1.12 ad=0.4172 as=0.336 pd=3.03 ps=2.84
XM8 X#3 a_177_48# VPWR#5 VPB sky130_fd_pr__pfet_01v8 l=0.15 w=1.12 ad=0.336 as=0.8088 pd=2.84 ps=3.71
XM4 VPWR#5 a_27_74# a_177_48##9 VPB sky130_fd_pr__pfet_01v8 l=0.15 w=1 ad=0.8088 as=0.3 pd=3.71 ps=2.6
XM11 a_177_48##9 A2#1 a_582_368# VPB sky130_fd_pr__pfet_01v8 l=0.15 w=1 ad=0.3 as=0.36 pd=2.6 ps=2.72
XM9 a_582_368# A1#3 VPWR#1 VPB sky130_fd_pr__pfet_01v8 l=0.15 w=1 ad=0.36 as=0.285 pd=2.72 ps=2.57
*
*
*       RESISTOR AND CAP/DIODE CARDS
*
Rg1	B1_N#1	B1_N#2	392.079773
Rg2	B1_N#2	B1_N#3	24.690777
Rg3	B1_N#2	B1_N#4	424.147491
Rg4	a_177_48#	a_177_48##2	423.074677
Rg5	a_177_48##2	a_177_48##3	80.037224
Rg6	a_177_48##3	a_177_48##4	486.974609
Rg7	a_177_48##2	a_177_48##5	350.487976
Rg8	a_177_48##3	a_177_48##6	450.770844
Rg9	a_27_74#	a_27_74##2	416.208282
Rg10	a_27_74##2	a_27_74##3	47.331097
Rg11	a_27_74##2	a_27_74##4	399.275177
Rg12	A2#1	A2#2	457.627838
Rg13	A2#2	A2#3	307.937683
Rg14	A1#1	A1#2	26.676205
Rg15	A1#2	A1#3	482.189148
Rg16	A1#2	A1#4	329.212952
Rf1	B1_N#5	B1_N#3	160.919952
Rf2	B1_N	B1_N#7	0.687145
Rf3	B1_N#5	B1_N#7	7.873454
Rf4	X	X#2	7.282945
Rf5	X	X#3	89.353165
Rf6	X#2	X	7.282945
Rf7	X#1	X#2	7.500000
Rf8	a_27_74##3	a_27_74##6	286.222107
Rf9	a_27_74##6	a_27_74##7	131.024734
Rf10	a_27_74##6	a_27_74##8	18.631374
Rf11	a_177_48##7	a_177_48##8	21.339512
Rf12	a_177_48##8	a_177_48##10	95.890747
Rf13	a_177_48##8	a_177_48##2	214.228760
Rf14	a_177_48##9	a_177_48##10	5.000000
Rf15	A2#4	A2#2	161.388290
Rf16	A2	A2#6	1.155488
Rf17	A2#4	A2#6	8.471592
Rf18	A1	A1#1	163.775864
Rf19	a_487_74#	a_487_74##2	79.218887
Rf20	VPWR#1	VPWR#2	159.826050
Rf21	VPWR#2	VPWR#3	83.289558
Rf23	VPWR#2	VPWR#5	19.771664
Rf24	VPWR#3	VPWR#6	34.704330
Rf26	VGND#2	VGND#3	84.348793
Rf27	VGND#3	VGND#4	20.121702
Rf28	VGND#4	VGND#5	72.020370
Rf30	VGND#2	VGND#7	24.862514
Rf31	VGND#4	VGND#8	43.422623
Rf32	VGND#5	VGND#9	41.887741
Re1	VPWR#2	VPWR	1.227783
Re2	VGND	VGND#3	1.227829
*
*       CAPACITOR CARDS
*
*
C1	VGND#4	a_177_48##8	3.18471e-19
C2	B1_N#5	a_177_48##3	7.29745e-19
C3	A1#2	a_487_74##2	6.54149e-18
C4	a_177_48##8	A2#4	3.49427e-17
C5	VGND#4	VGND#7	8.90702e-19
C6	a_487_74##2	A2#6	1.26118e-17
C7	VGND#3	a_177_48##3	1.65565e-20
C8	VGND#9	VGND#4	3.01664e-19
C9	a_487_74#	A2#6	3.75779e-18
C10	a_487_74#	A2#4	1.33065e-17
C11	a_177_48##8	a_487_74##2	1.44733e-18
C12	A2#2	A1#2	3.05903e-17
C13	X#1	a_177_48##3	5.83701e-18
C14	a_177_48##8	a_487_74#	2.492e-17
C15	a_177_48##8	a_177_48##7	1.68021e-18
C16	A2#6	VPWR#1	9.4913e-19
C17	a_27_74##3	a_177_48##3	7.82782e-20
C18	X#1	a_177_48##8	6.67081e-19
C19	a_487_74##2	VGND#7	3.55876e-17
C20	a_27_74##7	a_177_48##3	1.62732e-19
C21	a_177_48##3	a_177_48##2	4.54444e-18
C22	A2#6	VPWR#5	3.38564e-20
C23	VGND#4	A1#4	1.81887e-19
C24	A2#4	a_177_48##9	9.68112e-18
C25	a_487_74#	a_487_74##2	2.65318e-18
C26	VPWR#1	A1#2	5.8127e-18
C27	a_487_74#	VGND#7	3.46256e-17
C28	a_177_48##7	a_487_74##2	1.1235e-19
C29	VGND#4	A2#3	2.0105e-19
C30	A2#4	VPWR#5	5.68563e-19
C31	VGND#4	a_177_48##3	3.3212e-20
C32	B1_N#3	a_177_48##3	2.28316e-17
C33	VGND#4	a_27_74##4	1.65538e-18
C34	a_177_48##7	a_487_74#	4.18587e-17
C35	VGND#8	VGND#7	4.30249e-19
C36	a_177_48##8	VPWR#5	1.54798e-18
C37	VGND#4	a_177_48##5	8.66201e-18
C38	a_27_74##7	B1_N#5	3.06923e-17
C39	VGND#8	a_177_48##7	3.6108e-17
C40	VGND#4	a_177_48##4	1.01892e-18
C41	X#1	a_177_48##7	2.62748e-18
C42	VGND#4	B1_N#4	4.98551e-19
C43	X#1	VGND#8	2.18169e-17
C44	a_177_48##9	A1#2	5.22541e-19
C45	VGND#9	VGND#8	6.46423e-19
C46	a_177_48##8	A1#4	2.32969e-18
C47	A2#4	a_27_74##4	7.00113e-19
C48	VGND#9	X#1	1.6013e-17
C49	a_177_48##8	A2#3	4.44619e-18
C50	a_27_74##7	X#1	3.12724e-17
C51	a_487_74#	a_177_48##9	1.61827e-18
C52	a_27_74##7	VGND#9	5.56216e-17
C53	a_177_48##8	a_27_74##4	1.69152e-17
C54	B1_N#5	a_27_74##8	2.17898e-17
C55	a_177_48##8	a_177_48##5	2.82778e-19
C56	a_487_74##2	A1#4	4.90343e-17
C57	A1#4	VGND#7	2.67411e-17
C58	X#1	X#3	3.00354e-18
C59	a_487_74##2	A2#3	1.97625e-18
C60	a_487_74#	A1#4	8.47241e-19
C61	a_177_48##9	VPWR#1	2.91493e-17
C62	X#3	a_177_48##3	1.10766e-17
C63	A2#3	VGND#7	2.57289e-17
C64	a_487_74##2	a_27_74##4	4.23662e-19
C65	a_177_48##7	A1#4	2.96601e-20
C66	VPWR#5	VPWR#1	2.28617e-18
C67	a_487_74#	A2#3	4.73154e-17
C68	a_27_74##8	X#1	5.53292e-18
C69	VGND#7	a_27_74##4	1.49216e-18
C70	VGND#8	A1#4	6.12551e-20
C71	a_487_74##2	a_177_48##5	1.43265e-19
C72	a_177_48##7	A2#3	3.39035e-20
C73	a_487_74#	a_27_74##4	3.06595e-17
C74	VGND#7	a_177_48##5	3.76617e-19
C75	VGND#8	A2#3	5.57737e-20
C76	VPWR#5	a_177_48##9	3.94582e-17
C77	a_27_74##4	a_177_48##7	1.90593e-17
C78	a_27_74##7	a_27_74##8	2.1169e-18
C79	VPWR#6	a_177_48##3	2.26088e-19
C80	VGND#8	a_27_74##4	1.19015e-18
C81	a_177_48##7	a_177_48##5	1.89552e-18
C82	X#1	a_27_74##4	4.62862e-19
C83	a_177_48##5	VGND#8	2.1448e-17
C84	VGND#9	a_27_74##4	5.38194e-20
C85	VPWR#6	VPWR#5	1.54509e-17
C86	X#1	a_177_48##5	3.27243e-17
C87	VGND#8	a_177_48##4	2.23293e-19
C88	VGND#9	a_177_48##5	3.18727e-19
C89	a_27_74##8	VPWR#5	1.35037e-17
C90	X#1	a_177_48##4	2.93401e-17
C91	VGND#3	VGND#4	2.61922e-17
C92	VGND#8	B1_N#4	1.23924e-19
C93	a_27_74##8	a_177_48##3	7.77085e-18
C94	B1_N	a_177_48##3	3.8875e-19
C95	a_27_74##8	X#3	9.00467e-17
C96	a_177_48##4	VGND#9	1.25596e-17
C97	X#1	B1_N#4	1.92542e-18
C98	A2#6	A1#2	5.04942e-18
C99	a_27_74##7	a_177_48##4	6.18664e-18
C100	a_27_74##8	VPWR#6	5.67568e-17
C101	VGND#9	B1_N#4	2.69516e-17
C102	a_27_74##7	B1_N#4	2.43264e-17
C103	A1	A1#2	2.10839e-17
C104	A2#3	A1#4	2.28635e-17
C105	VPWR#1	A1#3	5.37711e-17
C106	VGND#3	a_177_48##8	1.85778e-18
C107	VPWR#1	A2#1	1.02586e-17
C108	a_27_74##4	A2#3	3.72408e-17
C109	a_177_48##9	A1#3	1.01308e-17
C110	A2#6	A2#2	5.91094e-18
C111	VGND#4	a_177_48##2	7.78837e-19
C112	VPWR#1	a_27_74#	6.93349e-19
C113	VPWR#5	A1#3	7.79689e-19
C114	A2#4	A2#2	1.5516e-17
C115	a_177_48##9	A2#1	6.05991e-17
C116	a_177_48##5	a_27_74##4	5.69837e-18
C117	VPWR#5	A2#1	7.30897e-18
C118	VPWR#1	a_177_48#	6.43384e-19
C119	a_177_48##9	a_27_74#	4.94803e-17
C120	a_177_48##8	A2#2	4.07397e-18
C121	A2#4	a_27_74##3	3.18081e-18
C122	a_27_74#	VPWR#5	2.60783e-17
C123	a_177_48##9	a_177_48#	1.90899e-18
C124	a_177_48##4	a_177_48##5	4.04499e-17
C125	X#3	a_27_74#	1.30652e-18
C126	VPWR#5	a_177_48#	5.61139e-17
C127	a_177_48##8	a_27_74##3	7.11288e-17
C128	VGND#3	a_487_74#	4.59618e-18
C129	a_177_48##9	a_177_48##6	3.42701e-19
C130	X#3	a_177_48#	3.68103e-17
C131	VGND#3	a_177_48##7	1.76356e-17
C132	VPWR#5	a_177_48##6	5.52919e-18
C133	a_27_74##8	a_27_74#	4.71339e-19
C134	B1_N#4	a_177_48##4	2.96501e-17
C135	VPWR#6	a_177_48#	4.67051e-18
C136	a_177_48##9	B1_N#1	3.19138e-19
C137	a_177_48##2	a_177_48##8	3.11808e-18
C138	X#3	a_177_48##6	3.68954e-17
C139	a_27_74##8	a_177_48#	2.55422e-17
C140	VPWR#6	a_177_48##6	3.62322e-17
C141	A2#2	VGND#7	1.73994e-18
C142	VPWR#2	VPWR#1	3.68206e-17
C143	X#3	B1_N#1	1.58311e-18
C144	a_487_74#	A2#2	2.21148e-18
C145	a_27_74##8	a_177_48##6	2.68298e-17
C146	B1_N#1	VPWR#6	2.58779e-17
C147	a_27_74##8	B1_N#1	5.57331e-17
C148	VPWR#2	VPWR#5	7.07586e-17
C149	B1_N#5	B1_N#3	1.62916e-17
C150	X#1	a_27_74##3	7.30959e-22
C151	VPWR#1	A2#2	4.94717e-19
C152	A2#1	A1#3	3.94581e-17
C153	a_177_48##2	VGND#8	2.07603e-17
C154	X#1	a_177_48##2	3.63038e-17
C155	a_177_48##9	A2#2	1.07636e-18
C156	VPWR#5	A2#2	1.23099e-19
C157	a_27_74#	A2#1	4.13937e-17
C158	a_177_48##9	a_27_74##3	7.19585e-17
C159	X#1	B1_N#3	1.11341e-18
C160	a_27_74##3	VPWR#5	7.24295e-17
C161	VGND#3	a_27_74##4	4.92138e-18
C162	a_487_74##2	a_582_368#	8.37955e-20
C163	a_177_48#	a_27_74#	9.65401e-18
C164	X#3	a_27_74##3	1.40332e-17
C165	a_27_74##7	B1_N#3	1.10573e-17
C166	a_177_48##9	a_177_48##2	1.65829e-19
C167	a_177_48##2	VPWR#5	8.45101e-19
C168	VGND	A1#2	6.64159e-19
C169	a_27_74##8	a_27_74##3	1.71751e-18
C170	VGND	a_177_48##3	5.89064e-19
C171	X#3	a_177_48##2	3.44228e-17
C172	a_177_48##6	a_177_48#	5.00224e-17
C173	a_27_74##4	A2#2	2.85018e-18
C174	a_177_48##8	A1#2	5.49687e-19
C175	a_177_48##2	a_27_74##8	5.31395e-18
C176	X#3	B1_N#3	1.86364e-18
C177	B1_N#1	a_177_48##6	2.62865e-17
C178	B1_N#3	a_27_74##8	1.34816e-17
C179	a_177_48##2	a_177_48##5	3.91115e-18
C180	A2#6	A1	3.21339e-17
C181	a_177_48##2	a_177_48##4	1.53655e-19
C182	B1_N#3	a_177_48##4	4.2553e-18
C183	a_27_74##3	A2#1	3.00023e-18
C184	a_27_74##3	a_27_74#	1.15124e-17
C185	a_27_74##3	a_177_48#	5.21846e-18
C186	a_177_48##2	a_27_74#	4.17835e-20
C187	VGND#4	X	9.54213e-18
C188	a_27_74##3	a_177_48##6	3.39812e-19
C189	a_487_74##2	A1	2.85409e-17
C190	a_27_74##3	B1_N#1	1.48063e-19
C191	a_177_48##6	a_177_48##2	2.1135e-18
C192	A1#3	a_582_368#	3.01117e-17
C193	B1_N#3	a_177_48##6	4.72286e-19
C194	A2#1	a_582_368#	2.95675e-17
C195	VGND#3	a_27_74##3	2.57908e-19
C196	A1	VPWR#1	2.40345e-17
C197	B1_N	a_27_74##8	5.10116e-17
C198	VPWR	A2#6	4.54969e-18
C199	A1#2	VNB	5.65096e-17
C200	a_27_74##3	A2#2	2.61212e-17
C201	a_177_48##3	VNB	2.49734e-17
C202	VPWR	A2#4	3.32562e-18
C203	VGND	VGND#4	3.62752e-17
C204	X	VGND#8	1.71121e-17
C205	a_177_48##2	a_27_74##3	6.54975e-17
C206	X	X#1	1.23759e-19
C207	VGND#9	X	1.54896e-17
C208	VGND	A2#6	3.03705e-18
C209	VGND	A2#4	2.9065e-18
C210	VGND	a_177_48##8	6.01098e-18
C211	B1_N	a_177_48##6	1.64685e-19
C212	VPWR	VPWR#1	4.86675e-17
C213	B1_N	B1_N#1	3.28894e-18
C214	VGND	B1_N#5	2.9644e-18
C215	VGND	a_487_74##2	1.78734e-17
C216	VPWR	a_177_48##9	1.49312e-17
C217	VGND	VGND#7	2.27578e-17
C218	VPWR	VPWR#5	7.98523e-17
C219	VGND	a_487_74#	1.7223e-17
C220	X	a_177_48##5	1.07441e-17
C221	VPWR	X#3	3.97819e-18
C222	VGND	a_177_48##7	1.44161e-17
C223	X	a_177_48##4	9.28587e-18
C224	VPWR	a_27_74##8	2.44301e-17
C225	X	B1_N#4	7.39564e-19
C226	VGND	a_27_74##7	1.48895e-17
C227	VGND	VPWR#1	3.28873e-18
C228	VGND	a_177_48##9	1.65369e-18
C229	VGND	X#3	1.28699e-18
C230	A1	A2#2	9.37424e-19
C231	VGND	A1#4	8.37906e-19
C232	VPWR	A1#3	4.00595e-18
C233	VGND#4	VNB	2.35196e-17
C234	VGND	A2#3	4.03148e-19
C235	VPWR	A2#1	9.36822e-18
C236	B1_N	B1_N#3	9.49424e-18
C237	VGND	a_27_74##4	1.62651e-18
C238	VPWR	a_27_74#	7.43629e-18
C239	VGND	a_177_48##5	2.21655e-18
C240	VPWR	a_177_48#	4.47616e-19
C241	A2#6	VNB	9.73087e-18
C242	VGND	a_177_48##4	4.39247e-18
C243	A2#4	VNB	2.24168e-18
C244	VGND	B1_N#4	1.61067e-18
C245	VPWR	a_177_48##6	5.88862e-19
C246	VPWR	B1_N#1	6.66191e-18
C247	a_177_48##8	VNB	9.22937e-18
C248	B1_N#5	VNB	1.25599e-17
C249	a_487_74##2	VNB	3.45809e-17
C250	VGND#7	VNB	6.16406e-18
C251	a_487_74#	VNB	1.93806e-18
C252	a_177_48##7	VNB	8.70667e-18
C253	VGND#8	VNB	5.95922e-18
C254	VPWR	A2#2	1.6e-18
C255	VGND#9	VNB	3.61486e-18
C256	a_27_74##7	VNB	4.00468e-17
C257	VPWR	a_27_74##3	6.93848e-18
C258	VPWR#1	VNB	9.39629e-17
C259	a_177_48##9	VNB	7.75904e-18
C260	VGND	VGND#3	1.44197e-17
C261	VPWR	a_177_48##2	3.04116e-18
C262	VPWR#5	VNB	6.07999e-17
C263	X#3	VNB	2.93805e-19
C264	VPWR#6	VNB	1.10642e-17
C265	a_27_74##8	VNB	4.90148e-17
C266	VGND	A2#2	5.53466e-20
C267	A1#4	VNB	3.13315e-17
C268	A2#3	VNB	2.66069e-17
C269	VGND	a_27_74##3	3.86465e-18
C270	a_27_74##4	VNB	3.1324e-17
C271	a_177_48##5	VNB	3.45126e-17
C272	VGND	a_177_48##2	5.15354e-18
C273	a_177_48##4	VNB	3.24213e-17
C274	B1_N#4	VNB	3.6507e-17
C275	A1#3	VNB	3.1891e-17
C276	A2#1	VNB	3.15291e-17
C277	a_27_74#	VNB	3.54308e-17
C278	a_177_48#	VNB	3.08874e-17
C279	a_177_48##6	VNB	3.66667e-17
C280	B1_N#1	VNB	4.65685e-17
C281	VPWR	B1_N	2.65032e-18
C282	VPWR#2	VNB	1.69012e-16
C283	VGND#3	VNB	1.89885e-16
C284	VPWR	A1	2.63526e-18
C285	A2#2	VNB	3.37486e-17
C286	a_27_74##3	VNB	5.76482e-17
C287	a_177_48##2	VNB	3.11186e-17
C288	VGND	A1	2.38553e-18
C289	B1_N#3	VNB	6.92513e-17
C290	VGND	X	1.66508e-17
C291	B1_N	VNB	1.07507e-17
C292	A1	VNB	1.78232e-17
C293	X	VNB	1.93959e-18
C294	VPWR	VNB	6.42725e-17
C295	VGND	VNB	6.452e-17
C296	VPWR#3	a_177_48##3	4.42379e-20
C297	VGND#2	A1#2	2.53477e-19
C298	VPWR#3	a_177_48##2	6.65605e-20
C299	VPWR#3	a_177_48##6	8.10191e-18
C300	VGND#2	a_487_74#	1.44449e-17
C301	a_27_74##8	VPWR#3	1.12132e-17
C302	VGND#2	A1#4	2.66639e-18
C303	VGND	VGND#2	2.8338e-17
C304	VGND#5	X	6.26669e-18
C305	VPWR#3	B1_N#3	3.08655e-19
C306	VGND#5	a_27_74##7	1.26788e-17
C307	VGND#5	B1_N#3	1.86471e-19
C308	VPWR#3	B1_N#1	3.30514e-18
C309	VGND#5	a_27_74##4	9.06631e-20
C310	VGND#2	A2#3	2.63821e-18
C311	VPWR#3	VNB	5.18715e-17
C312	VPWR#3	VPWR#5	9.53895e-19
C313	VGND#5	VGND#4	1.20915e-18
C314	VGND#5	a_177_48##5	8.56266e-19
C315	VGND	VGND#5	4.82609e-17
C316	VGND#5	a_177_48##3	2.58067e-20
C317	VGND#5	a_177_48##4	1.11249e-17
C318	VGND#2	VNB	5.07805e-17
C319	VGND#3	VGND#2	5.94107e-17
C320	VGND#5	B1_N#4	5.50213e-18
C321	VGND#5	VNB	4.77447e-17
C322	VPWR	VPWR#3	5.85029e-17
C323	VGND#3	VGND#5	5.01688e-17
C324	VPWR#2	VPWR#3	5.46757e-17
C325	VGND#2	a_487_74##2	2.11916e-17
C326	VPWR#3	a_177_48#	5.95015e-19
*
*
.ENDS sky130_fd_sc_hs__o21ba_2
*
