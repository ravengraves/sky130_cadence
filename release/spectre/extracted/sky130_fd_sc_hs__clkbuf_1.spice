* Extracted by Quantus, converted by sky130cad/quantus.py
*
*
*
*                       LINUX           Wed Nov 18 08:21:47 2026
*
*
*
*  PROGRAM  advgen
*
*  Name           : advgen - Quantus - (64-bit)
*  Version        : 25.1.0-p047
*  Build Date     : Thu Dec 11 23:20:30 PST 2025
*
*  HSPICE LIBRARY
*
*  OPERATING_TEMPERATURE 150
*  QRC_TECH_DIR <path>/tech
*
*
*

*
.SUBCKT sky130_fd_sc_hs__clkbuf_1 VPB VNB VGND VPWR X A
*
*
*  caps2d version: 10
*
*
*       TRANSISTOR CARDS
*
*
XM3 a_27_74##6 A#3 VGND#4 VNB sky130_fd_pr__nfet_01v8_lvt l=0.15 w=0.42 ad=0.1197 as=0.3276 pd=1.41 ps=2.4
XM0 VGND#4 a_27_74##3 X#1 VNB sky130_fd_pr__nfet_01v8_lvt l=0.15 w=0.42 ad=0.3276 as=0.119 pd=2.4 ps=1.41
XM2 a_27_74##4 A#1 VPWR#4 VPB sky130_fd_pr__pfet_01v8 l=0.15 w=1.12 ad=0.3304 as=0.448 pd=2.83 ps=3.04
XM1 VPWR#4 a_27_74# X#3 VPB sky130_fd_pr__pfet_01v8 l=0.15 w=1.12 ad=0.448 as=0.3304 pd=3.04 ps=2.83
*
*
*       RESISTOR AND CAP/DIODE CARDS
*
Rg1	A#1	A#2	488.497803
Rg2	A#2	A#3	468.170502
Rg3	a_27_74#	a_27_74##2	472.043427
Rg4	a_27_74##2	a_27_74##3	265.748077
Rf1	A#4	A	1.879015
Rf2	A#2	A#6	81.995415
Rf3	A#4	A#6	6.871449
Rf4	A#7	A	1.879015
Rf5	A#6	A#7	6.321734
Rf6	a_27_74##4	a_27_74##5	97.410629
Rf7	a_27_74##5	a_27_74##6	94.194756
Rf8	X	X#2	0.590509
Rf9	X#2	X	16.783667
Rf10	X	X#4	10.452959
Rf11	X#4	X	0.143191
Rf12	X#1	X#2	15.000000
Rf13	X#3	X#4	5.000000
Rf16	VGND#2	VGND#4	17.491138
Rf19	VPWR#2	VPWR#4	35.032631
Rf21	a_27_74##2	a_27_74##5	80.116402
Re1	VPWR#2	VPWR	2.455682
Re2	VGND	VGND#2	2.455774
*
*       CAPACITOR CARDS
*
*
C1	VGND	VNB	5.29453e-17
C2	VPWR	VNB	5.81412e-17
C3	X	VNB	1.06714e-16
C4	A	VNB	3.87097e-17
C5	VGND	X	2.02808e-18
C6	A#2	VNB	8.84626e-17
C7	VGND	A	4.23695e-18
C8	a_27_74##2	VNB	8.80708e-17
C9	VPWR	X	2.39408e-17
C10	VPWR	A	6.87362e-18
C11	VGND	A#2	2.52825e-20
C12	A#1	VNB	4.33447e-17
C13	a_27_74#	VNB	3.70487e-17
C14	VGND	a_27_74##2	8.01292e-18
C15	A#3	VNB	4.07115e-17
C16	a_27_74##3	VNB	2.8138e-17
C17	a_27_74##4	VNB	4.85507e-17
C18	VPWR#4	VNB	5.35885e-18
C19	VPWR	a_27_74##2	1.94918e-18
C20	a_27_74##6	VNB	4.2272e-17
C21	X	A#2	1.32858e-19
C22	VGND#4	VNB	4.81489e-17
C23	X#1	VNB	2.34743e-17
C24	a_27_74##2	X	1.12761e-16
C25	VGND	A#3	9.97727e-19
C26	A#6	VNB	2.42056e-18
C27	A	A#2	2.33108e-17
C28	VGND	a_27_74##3	6.00251e-18
C29	VPWR	A#1	1.26577e-18
C30	VPWR	a_27_74#	4.04772e-18
C31	a_27_74##2	A	7.4669e-17
C32	VGND	a_27_74##6	1.61775e-17
C33	VGND	VGND#4	6.77856e-17
C34	X	A#1	1.85109e-18
C35	VGND	X#1	1.87533e-17
C36	X	a_27_74#	3.57309e-17
C37	VPWR	a_27_74##4	1.95547e-17
C38	VGND	A#6	1.22297e-18
C39	VPWR	VPWR#4	2.23725e-17
C40	A	A#1	4.99858e-18
C41	X	A#3	5.64883e-19
C42	A#2	a_27_74##2	4.1218e-17
C43	A	a_27_74#	4.0048e-19
C44	X	a_27_74##3	1.9914e-18
C45	a_27_74##4	X	2.60636e-17
C46	VPWR#4	X	6.87013e-17
C47	VPWR	A#6	1.3476e-18
C48	X	X#3	5.15932e-18
C49	a_27_74##6	X	1.08082e-18
C50	A	a_27_74##4	2.78818e-17
C51	X#1	X	1.94659e-18
C52	a_27_74##6	A	2.36985e-17
C53	A#1	a_27_74##2	3.85169e-18
C54	a_27_74##2	a_27_74#	2.53773e-18
C55	A#3	a_27_74##2	3.48114e-18
C56	A#2	a_27_74##4	4.94173e-18
C57	a_27_74##2	a_27_74##4	2.04649e-18
C58	a_27_74##6	A#2	1.31684e-17
C59	a_27_74##2	VPWR#4	5.37043e-18
C60	VGND#4	A#2	1.42157e-18
C61	A#1	a_27_74#	3.11287e-17
C62	a_27_74##6	a_27_74##2	1.41461e-19
C63	a_27_74##2	VGND#4	5.65121e-17
C64	A#6	A#2	1.10165e-17
C65	a_27_74##4	A#1	6.20261e-17
C66	A#1	VPWR#4	3.87029e-17
C67	a_27_74##4	a_27_74#	5.82906e-18
C68	a_27_74#	VPWR#4	3.03438e-17
C69	A#3	a_27_74##3	4.62676e-18
C70	a_27_74#	X#3	1.18287e-17
C71	a_27_74##6	A#3	3.95473e-17
C72	a_27_74##4	VPWR#4	9.87093e-17
C73	A#3	VGND#4	2.89589e-17
C74	a_27_74##6	a_27_74##3	1.52656e-18
C75	X#1	A#3	1.76578e-18
C76	a_27_74##3	VGND#4	2.85774e-17
C77	X#1	a_27_74##3	2.6172e-17
C78	A#6	a_27_74##4	2.33295e-17
C79	VGND#4	a_27_74##6	4.26631e-17
C80	a_27_74##6	X#1	3.2016e-18
C81	VGND#4	X#1	3.9995e-17
C82	a_27_74##6	A#6	2.01737e-17
C83	a_27_74##4	VPWR#2	2.0924e-17
C84	VPWR#2	VNB	1.86766e-16
C85	VGND#2	X#1	1.37342e-17
C86	X	VPWR#2	2.73345e-17
C87	VGND#2	A#2	1.34404e-19
C88	VPWR#2	A#1	2.57816e-18
C89	VGND	VGND#2	2.25738e-17
C90	VGND#2	a_27_74##6	1.37292e-17
C91	A	VPWR#2	1.58849e-18
C92	VPWR#2	A#2	9.46326e-19
C93	VPWR#2	a_27_74#	4.63542e-18
C94	VPWR	VPWR#2	5.71477e-17
C95	VGND#2	VGND#4	5.35629e-17
C96	a_27_74##2	VPWR#2	3.73843e-19
C97	VGND#2	VNB	1.44684e-16
*
*
.ENDS sky130_fd_sc_hs__clkbuf_1
*
