* Extracted by Quantus, converted by sky130cad/quantus.py
*
*
*
*                       LINUX           Wed Nov 18 08:07:44 2026
*
*
*
*  PROGRAM  advgen
*
*  Name           : advgen - Quantus - (64-bit)
*  Version        : 25.1.0-p047
*  Build Date     : Thu Dec 11 23:20:30 PST 2025
*
*  HSPICE LIBRARY
*
*  OPERATING_TEMPERATURE 150
*  QRC_TECH_DIR <path>/tech
*
*
*

*
.SUBCKT sky130_fd_sc_hs__a222o_1 VPB VNB VGND VPWR X C1 C2 B1 A1 A2 B2
*
*
*  caps2d version: 10
*
*
*       TRANSISTOR CARDS
*
*
XM3 a_32_74##8 C1#1 a_119_74# VNB sky130_fd_pr__nfet_01v8_lvt l=0.15 w=0.64 ad=0.1824 as=0.1536 pd=1.85 ps=1.76
XM1 a_119_74# C2#3 VGND#7 VNB sky130_fd_pr__nfet_01v8_lvt l=0.15 w=0.64 ad=0.1536 as=0.5088 pd=1.76 ps=2.87
XM13 VGND#7 B2#1 a_386_74# VNB sky130_fd_pr__nfet_01v8_lvt l=0.15 w=0.64 ad=0.5088 as=0.1536 pd=2.87 ps=1.76
XM11 a_386_74# B1#4 a_32_74##5 VNB sky130_fd_pr__nfet_01v8_lvt l=0.15 w=0.64 ad=0.1536 as=0.5024 pd=1.76 ps=2.85
XM9 a_32_74##5 A1#3 a_651_74# VNB sky130_fd_pr__nfet_01v8_lvt l=0.15 w=0.64 ad=0.5024 as=0.1536 pd=2.85 ps=1.76
XM0 a_651_74# A2#3 VGND#6 VNB sky130_fd_pr__nfet_01v8_lvt l=0.15 w=0.64 ad=0.1536 as=0.3994 pd=1.76 ps=2.65
XM10 VGND#6 a_32_74# X#3 VNB sky130_fd_pr__nfet_01v8_lvt l=0.15 w=0.74 ad=0.3994 as=0.2109 pd=2.65 ps=2.05
XM4 a_27_390##3 C1#3 a_32_74##9 VPB sky130_fd_pr__pfet_01v8 l=0.15 w=1 ad=0.295 as=0.455 pd=2.59 ps=2.91
XM2 a_32_74##9 C2#1 a_27_390##4 VPB sky130_fd_pr__pfet_01v8 l=0.15 w=1 ad=0.455 as=0.35 pd=2.91 ps=2.7
XM8 a_27_390##4 B2#3 a_337_390##2 VPB sky130_fd_pr__pfet_01v8 l=0.15 w=1 ad=0.35 as=0.44 pd=2.7 ps=2.88
XM6 a_337_390##2 B1#3 a_27_390# VPB sky130_fd_pr__pfet_01v8 l=0.15 w=1 ad=0.44 as=0.295 pd=2.88 ps=2.59
XM12 VPWR#6 A1#1 a_337_390# VPB sky130_fd_pr__pfet_01v8 l=0.15 w=1 ad=0.345 as=0.3 pd=2.69 ps=2.6
XM5 a_337_390# A2#1 VPWR#5 VPB sky130_fd_pr__pfet_01v8 l=0.15 w=1 ad=0.3 as=0.4704 pd=2.6 ps=3.11
XM7 VPWR#5 a_32_74##3 X#1 VPB sky130_fd_pr__pfet_01v8 l=0.15 w=1.12 ad=0.4704 as=0.3304 pd=3.11 ps=2.83
*
*
*       RESISTOR AND CAP/DIODE CARDS
*
Rg1	C1#1	C1#2	274.662231
Rg2	C1#2	C1#3	544.400574
Rg3	C2#1	C2#2	540.554688
Rg4	C2#2	C2#3	332.607452
Rg5	B2#1	B2#2	340.529694
Rg6	B2#2	B2#3	564.994507
Rg7	B1#1	B1#2	18.801310
Rg8	B1#2	B1#3	625.930481
Rg9	B1#2	B1#4	309.864563
Rg10	A1#1	A1#2	599.053955
Rg11	A1#2	A1#3	279.244598
Rg12	A2#1	A2#2	533.757141
Rg13	A2#2	A2#3	279.244598
Rg14	a_32_74#	a_32_74##2	352.160645
Rg15	a_32_74##2	a_32_74##3	455.160828
Rf1	C1	C1#4	1.441604
Rf2	C1#4	C1#2	161.674408
Rf3	C1	C1#6	1.441604
Rf4	C1#4	C1#6	11.744272
Rf5	C2#2	C2	160.626480
Rf6	B2	B2#2	162.177765
Rf7	a_27_390#	a_27_390##2	90.441414
Rf8	a_27_390##2	a_27_390##3	99.822639
Rf9	a_27_390##2	a_27_390##4	22.932806
Rf10	B1#1	B1#6	162.768036
Rf11	B1#6	B1	2.535235
Rf12	B1#7	B1	2.535235
Rf13	B1#6	B1#7	9.403928
Rf14	A1#2	A1	161.215576
Rf15	a_337_390#	a_337_390##2	141.135925
Rf16	A2#2	A2	162.087158
Rf17	a_32_74##2	a_32_74##6	280.669128
Rf18	a_32_74##6	a_32_74##7	125.448135
Rf19	a_32_74##7	a_32_74##8	44.667953
Rf20	a_32_74##7	a_32_74##9	98.902779
Rf21	a_32_74##5	a_32_74##6	3.750000
Rf22	X	X#2	0.183608
Rf23	X#2	X	13.403392
Rf24	X	X#3	86.870316
Rf25	X#1	X#2	5.000000
Rf27	VPWR#2	VPWR#3	75.558197
Rf28	VPWR#3	VPWR#4	42.710007
Rf29	VPWR#2	VPWR#5	36.809769
Rf30	VPWR#3	VPWR#6	33.896767
Rf32	VGND#2	VGND#3	109.714699
Rf33	VGND#3	VGND#4	74.549141
Rf35	VGND#2	VGND#6	25.104856
Rf36	VGND#4	VGND#7	14.322456
Re1	VPWR#4	VPWR	0.982218
Re2	VGND	VGND#3	0.982254
*
*       CAPACITOR CARDS
*
*
C1	A2#2	B1#2	2.35029e-19
C2	a_337_390#	VPWR#3	7.83568e-18
C3	a_32_74##7	B1#2	8.26888e-20
C4	B1#6	a_32_74##5	6.70225e-17
C5	B1#2	A1#2	1.08566e-17
C6	a_27_390#	B1#2	1.08354e-18
C7	a_337_390##2	VPWR#3	5.69028e-19
C8	a_337_390##2	B1#2	1.16761e-18
C9	B2#2	B1#2	4.01696e-17
C10	a_32_74##5	X#3	1.56538e-18
C11	a_32_74##7	a_27_390##4	4.91484e-18
C12	a_32_74##7	a_32_74##9	3.24794e-18
C13	a_27_390##2	a_337_390##2	1.86489e-17
C14	a_27_390##2	a_27_390##4	2.15032e-18
C15	a_27_390##2	a_32_74##9	1.96375e-17
C16	a_32_74##7	B1#4	1.38799e-19
C17	a_32_74##7	B2#1	5.79921e-19
C18	a_32_74##5	a_337_390#	8.89771e-18
C19	C1#6	a_32_74##9	2.63417e-17
C20	a_32_74##7	C2#3	1.96763e-17
C21	C1#6	a_27_390##3	3.53359e-17
C22	a_32_74##7	C1#1	9.24961e-19
C23	VPWR#3	a_32_74##3	2.88821e-19
C24	B1#6	B1#2	2.2776e-17
C25	a_32_74##5	a_337_390##2	5.74036e-18
C26	VPWR#3	A1#1	2.44748e-18
C27	X#3	a_32_74#	3.39413e-17
C28	a_337_390#	VPWR#5	7.7822e-17
C29	a_32_74#	VGND#6	7.22423e-18
C30	X#3	A2#3	2.1959e-18
C31	VPWR#6	VPWR#5	2.62609e-18
C32	A2#3	VGND#6	1.78054e-17
C33	X#3	A1#3	3.42332e-19
C34	a_32_74##5	a_32_74#	6.45249e-19
C35	a_337_390#	VPWR#6	1.01763e-16
C36	a_32_74##5	A2#3	2.25917e-17
C37	a_32_74##8	a_32_74##9	1.36168e-19
C38	a_27_390#	VPWR#6	5.73986e-17
C39	a_337_390##2	a_337_390#	1.279e-18
C40	a_32_74##5	A1#3	6.24975e-17
C41	B2#1	B1#2	1.76412e-18
C42	a_32_74##5	B1#4	6.26454e-17
C43	a_27_390#	a_337_390##2	8.7531e-17
C44	a_32_74##5	B2#1	2.64199e-17
C45	a_27_390##4	a_27_390#	4.15344e-18
C46	a_32_74##5	C2#3	5.66691e-19
C47	a_27_390##4	a_337_390##2	7.16868e-17
C48	B2#1	VGND#7	2.04128e-17
C49	a_32_74##8	B1#4	2.7598e-19
C50	VPWR#4	VPWR#3	3.40651e-17
C51	a_32_74##5	C1#1	4.36664e-19
C52	C2#3	VGND#7	2.04128e-17
C53	a_32_74##9	a_27_390##4	7.01829e-17
C54	a_32_74##8	B2#1	4.38895e-19
C55	a_27_390##2	B2#3	2.61312e-17
C56	a_27_390##3	a_27_390##4	3.70324e-18
C57	a_32_74##8	C2#3	4.25525e-18
C58	a_27_390##2	C2#1	1.81595e-17
C59	a_27_390##3	a_32_74##9	5.94417e-17
C60	a_32_74##8	C1#1	4.22654e-17
C61	C1#6	C2#1	2.88159e-19
C62	VPWR#3	A2#2	4.14184e-20
C63	a_32_74##5	A1#1	1.45322e-18
C64	C1#6	C1#3	8.7491e-18
C65	a_32_74##3	X#1	1.20142e-17
C66	A2#3	a_32_74#	1.04263e-17
C67	a_27_390##2	VPWR#4	7.46419e-17
C68	a_32_74##3	VPWR#5	3.34913e-17
C69	a_337_390#	a_32_74##3	2.03086e-18
C70	A2#1	VPWR#5	3.41763e-17
C71	A1#3	A2#3	4.34417e-17
C72	VPWR#6	a_32_74##3	5.22281e-19
C73	a_337_390#	A2#1	6.03672e-17
C74	VPWR#5	A1#1	1.33221e-18
C75	a_27_390#	a_32_74##3	1.99431e-19
C76	VPWR#6	A2#1	8.46402e-19
C77	a_337_390#	A1#1	7.0573e-17
C78	B1#4	A1#3	4.17662e-18
C79	VPWR#5	B1#3	1.66232e-19
C80	A1#1	VPWR#6	3.05416e-17
C81	a_337_390#	B1#3	3.9041e-19
C82	a_27_390#	A1#1	1.46483e-18
C83	a_32_74##7	B2#2	6.80055e-18
C84	VPWR#6	B1#3	2.69081e-18
C85	B2#1	B1#4	4.34818e-17
C86	B1#6	A1#2	5.57617e-18
C87	a_337_390#	B2#3	1.23417e-19
C88	a_337_390##2	A1#1	3.27346e-19
C89	A1	B1#2	1.09606e-18
C90	a_27_390#	B1#3	6.97788e-17
C91	VPWR#6	B2#3	3.50987e-19
C92	a_32_74##2	X#3	6.69785e-17
C93	a_337_390##2	B1#3	3.92761e-17
C94	a_32_74##7	C2#2	1.81028e-17
C95	a_27_390#	B2#3	1.5579e-18
C96	VGND#3	a_32_74##5	4.18804e-17
C97	a_32_74##2	VGND#6	7.57665e-18
C98	C2#3	B2#1	4.19991e-18
C99	a_27_390##4	B1#3	2.17625e-18
C100	VPWR#6	C2#1	1.99661e-19
C101	B2#3	a_337_390##2	3.0297e-17
C102	X#3	A2#2	4.87591e-19
C103	a_32_74##9	B1#3	4.68575e-19
C104	a_27_390##4	B2#3	5.24613e-17
C105	a_32_74##7	C1#2	6.02256e-18
C106	A2#2	VGND#6	1.951e-18
C107	B2#2	B1#6	2.09334e-17
C108	C1#1	C2#3	4.38786e-17
C109	B2#2	a_27_390##2	2.29688e-18
C110	a_32_74##9	B2#3	2.39447e-18
C111	B1	B1#2	7.14752e-18
C112	C2#1	a_27_390##4	1.73545e-17
C113	a_32_74##5	A2#2	2.59539e-17
C114	a_27_390##3	B2#3	2.94425e-19
C115	a_32_74##9	C2#1	6.35079e-17
C116	a_27_390##4	C1#3	1.42514e-18
C117	B1#2	A1#1	5.79681e-19
C118	a_27_390##2	C2#2	1.11183e-19
C119	a_27_390##3	C2#1	2.67221e-18
C120	a_32_74##5	A1#2	3.46132e-18
C121	C1#3	a_32_74##9	2.66496e-17
C122	a_27_390#	VPWR#4	5.01048e-17
C123	a_32_74##2	VPWR#5	2.67616e-17
C124	a_27_390##3	C1#3	6.03023e-17
C125	C1#6	C2#2	3.67651e-19
C126	a_337_390##2	VPWR#4	4.87181e-19
C127	C2	B1#2	1.77918e-19
C128	C1#6	C1#2	7.91585e-18
C129	a_32_74##5	B2#2	2.25806e-17
C130	A2#2	a_337_390#	1.77344e-17
C131	a_27_390##3	VPWR#4	5.80544e-17
C132	A2#1	a_32_74##3	3.28609e-17
C133	B2#2	VGND#7	1.8969e-18
C134	a_337_390#	A1#2	2.19157e-18
C135	VPWR#6	A1#2	7.64617e-19
C136	a_32_74##5	B1#2	4.34884e-18
C137	A1#1	A2#1	4.95579e-17
C138	B1#3	a_32_74##3	8.32903e-20
C139	a_32_74##2	a_32_74#	6.92931e-18
C140	B1#3	A1#1	7.66214e-18
C141	a_32_74##2	A2#3	7.28871e-19
C142	VGND#3	B1#4	5.38163e-18
C143	A2#2	a_32_74#	4.74149e-18
C144	a_32_74##2	A1#3	2.14926e-19
C145	a_32_74##8	C1#2	4.7797e-18
C146	a_27_390#	B2#2	4.70208e-19
C147	a_32_74##2	B1#4	1.12615e-19
C148	B2#2	a_337_390##2	2.97675e-17
C149	B2#3	B1#3	3.15455e-17
C150	a_32_74##7	a_119_74#	4.69104e-18
C151	a_32_74##2	B2#1	1.14001e-19
C152	C2#1	B2#3	3.96297e-17
C153	a_27_390##4	C2#2	1.28599e-18
C154	a_32_74##9	C2#2	1.71588e-18
C155	C1#3	C2#1	2.57016e-17
C156	a_32_74##5	a_651_74#	4.53314e-18
C157	VPWR#4	B1#3	4.29944e-18
C158	a_32_74##9	C1#2	1.92538e-18
C159	A2#1	a_32_74##2	1.92231e-18
C160	a_27_390##3	C1#2	1.12787e-18
C161	VPWR#4	B2#3	4.30879e-18
C162	a_32_74##2	A1#1	3.18905e-19
C163	A2#2	A2#1	4.22647e-18
C164	a_32_74##5	a_386_74#	4.54703e-18
C165	VPWR#4	C2#1	4.31331e-18
C166	A1#1	A2#2	3.08216e-18
C167	C2#2	B2#1	1.55694e-19
C168	VPWR#4	C1#3	4.31346e-18
C169	C1#2	C2#3	9.4022e-19
C170	B2#2	B1#3	1.15906e-18
C171	B2#2	B2#3	5.83103e-18
C172	C1#6	a_32_74##7	6.80459e-18
C173	A2#3	a_651_74#	1.22404e-17
C174	C2#1	B2#2	1.34285e-18
C175	B1#6	A1	3.08795e-17
C176	A1#3	a_651_74#	1.22404e-17
C177	A2#2	a_32_74##2	9.60343e-17
C178	VGND#3	A1#2	2.06553e-19
C179	a_32_74##2	A1#2	4.34087e-19
C180	VPWR#4	B2#2	1.50226e-19
C181	B1#4	a_386_74#	1.22404e-17
C182	a_32_74##7	C2	7.51814e-17
C183	B2#1	a_386_74#	1.22404e-17
C184	A1#2	A2#2	3.46198e-17
C185	VPWR#4	C2#2	1.1235e-19
C186	A1	a_32_74##5	4.46895e-17
C187	VPWR#4	C1#2	6.80241e-20
C188	C2#3	a_119_74#	1.19787e-17
C189	C2	B1#6	1.36458e-18
C190	C2	a_27_390##2	3.5311e-18
C191	C1#1	a_119_74#	1.1397e-17
C192	C1	a_32_74##7	3.14138e-17
C193	A1	a_337_390#	1.3803e-17
C194	B1#2	VNB	4.08725e-17
C195	C2#2	B2#2	3.85258e-17
C196	B1	a_337_390#	1.05294e-17
C197	C2	VGND#7	5.302e-18
C198	VPWR#4	B1#2	9.87969e-20
C199	B1	a_337_390##2	5.0119e-17
C200	C1#2	C2#2	2.3923e-17
C201	a_32_74##9	B1	1.38461e-18
C202	VPWR	VPWR#3	2.38375e-17
C203	C1	a_32_74##8	4.11572e-17
C204	C2	a_27_390##4	3.18942e-17
C205	a_32_74##9	C2	2.35512e-17
C206	X#3	X	3.90241e-18
C207	VPWR	a_27_390##2	2.76488e-17
C208	B1	a_32_74##3	4.44097e-19
C209	VPWR	C1#6	3.67925e-18
C210	X	X#1	5.78548e-18
C211	B1	A2#1	1.01982e-18
C212	VPWR#5	X	9.59869e-17
C213	B1	A1#1	5.64364e-18
C214	VGND	a_32_74##7	1.39017e-17
C215	B1	B1#3	6.47032e-18
C216	B1	C2#1	2.79438e-19
C217	VGND#3	B1#2	2.59515e-19
C218	VGND	B1#6	5.60367e-18
C219	B1	C1#3	3.7772e-19
C220	VPWR	VPWR#5	2.08542e-17
C221	C2	B2#3	1.49885e-18
C222	VPWR	a_337_390#	1.78363e-17
C223	VPWR	VPWR#6	1.98681e-17
C224	A1	A2#2	3.10563e-17
C225	C2	C2#1	9.56979e-18
C226	VPWR	a_27_390#	2.35429e-17
C227	VGND	X#3	1.91921e-17
C228	VPWR	a_337_390##2	1.24529e-17
C229	C2	C1#3	2.32279e-19
C230	A1	A1#2	2.24791e-17
C231	VPWR#3	VNB	2.82754e-17
C232	B1	a_32_74##2	2.98183e-18
C233	VGND	a_32_74##5	4.76528e-17
C234	VPWR	a_32_74##9	8.87538e-18
C235	a_32_74##7	VNB	5.13227e-18
C236	VPWR	a_27_390##3	2.55948e-17
C237	B1	A2#2	3.5612e-18
C238	VGND	a_32_74##8	1.75052e-17
C239	X	a_32_74##3	3.96745e-17
C240	B1	A1#2	1.61238e-18
C241	X	A2#1	1.39875e-18
C242	VGND	VPWR#5	3.4857e-18
C243	B1#6	VNB	2.43849e-18
C244	VGND	a_337_390#	3.79506e-18
C245	X	A1#1	1.94214e-18
C246	a_27_390##2	VNB	5.07694e-18
C247	X	B1#3	4.00324e-19
C248	B2#2	B1	1.77939e-17
C249	C1#6	VNB	1.58475e-17
C250	VGND	a_337_390##2	1.84548e-18
C251	VGND	a_27_390##4	2.28996e-18
C252	VGND	a_32_74##9	1.14773e-18
C253	X#3	VNB	5.20853e-17
C254	VPWR	a_32_74##3	3.67511e-18
C255	VGND	a_32_74#	8.73264e-19
C256	C2	B2#2	5.58589e-17
C257	VPWR	A2#1	7.7892e-18
C258	a_32_74##5	VNB	5.59767e-18
C259	VGND	A2#3	5.15958e-19
C260	VPWR	A1#1	8.65252e-18
C261	VGND	A1#3	3.16812e-19
C262	C2	C2#2	1.93111e-17
C263	VPWR	B1#3	4.10723e-18
C264	VGND	B1#4	1.25423e-19
C265	a_32_74##8	VNB	3.32147e-17
C266	VGND	B2#1	3.59865e-19
C267	VPWR	B2#3	4.71143e-18
C268	C2	C1#2	6.34401e-19
C269	VPWR#5	VNB	8.80832e-18
C270	VGND	C2#3	1.13452e-18
C271	a_32_74##2	X	3.16637e-17
C272	VPWR	C2#1	4.10979e-18
C273	a_337_390#	VNB	8.00151e-18
C274	VGND	C1#1	1.66885e-18
C275	VPWR#6	VNB	9.70934e-18
C276	VPWR	C1#3	4.11089e-18
C277	a_27_390#	VNB	1.2862e-17
C278	C1	C2#2	3.07544e-18
C279	a_337_390##2	VNB	8.90028e-18
C280	a_27_390##4	VNB	3.98183e-18
C281	VPWR	VPWR#4	5.36934e-17
C282	C1	C1#2	2.30751e-17
C283	a_32_74##9	VNB	1.09207e-17
C284	a_27_390##3	VNB	5.84446e-17
C285	a_32_74#	VNB	3.06886e-17
C286	VPWR	a_32_74##2	3.28248e-18
C287	A2#3	VNB	2.12336e-17
C288	A1#3	VNB	2.35193e-17
C289	VPWR	A2#2	4.68975e-18
C290	B1#4	VNB	2.31767e-17
C291	B2#1	VNB	2.35857e-17
C292	C2#3	VNB	2.32464e-17
C293	C1#1	VNB	3.02026e-17
C294	a_32_74##2	B1#2	2.62503e-19
C295	VPWR	B2#2	4.11417e-18
C296	a_32_74##3	VNB	4.24434e-17
C297	VGND	VGND#3	2.17838e-17
C298	A2#1	VNB	4.40323e-17
C299	VGND	a_32_74##2	7.68078e-18
C300	A1#1	VNB	5.01009e-17
C301	a_32_74##7	VGND#7	5.60066e-18
C302	VGND	A2#2	3.39797e-18
C303	B1#3	VNB	3.8813e-17
C304	B2#3	VNB	3.40973e-17
C305	C2#1	VNB	3.67888e-17
C306	C1#3	VNB	5.09763e-17
C307	B1	A1	6.20425e-18
C308	VGND	B2#2	4.05466e-18
C309	VPWR#4	VNB	2.94084e-16
C310	VGND#3	VNB	2.34184e-16
C311	a_32_74##2	VNB	4.23938e-17
C312	A2#2	VNB	3.2463e-17
C313	A1#2	VNB	2.20685e-17
C314	B2#2	VNB	3.51686e-17
C315	C2#2	VNB	3.94417e-17
C316	C1#2	VNB	5.60436e-17
C317	VPWR	A1	2.87812e-18
C318	VPWR	B1	4.10927e-18
C319	VGND	A1	2.77448e-18
C320	VPWR	C2	4.00614e-18
C321	VGND	C2	3.72721e-18
C322	A1	VNB	2.18114e-18
C323	VPWR	X	1.98452e-17
C324	VGND	C1	5.81182e-18
C325	B1	VNB	9.50872e-18
C326	C2	VNB	1.75964e-18
C327	VGND	X	1.42469e-18
C328	C1	VNB	1.67464e-17
C329	X	VNB	7.02744e-17
C330	VPWR	VNB	8.3231e-17
C331	VGND	VNB	6.72242e-17
C332	VPWR#3	VPWR#5	3.35015e-19
C333	VPWR#4	VPWR#2	5.56386e-17
C334	VGND#2	A1#3	9.16847e-18
C335	VGND#4	a_32_74##5	3.04567e-17
C336	VGND#4	C2#2	2.48854e-18
C337	VGND#4	a_32_74##8	3.24544e-17
C338	VGND#2	X#3	5.41749e-17
C339	VGND#4	A1#3	5.05318e-19
C340	VGND#4	a_32_74##7	5.67808e-17
C341	VGND#4	C1#1	1.236e-17
C342	VGND#2	A2#3	2.14309e-17
C343	VPWR#2	VNB	4.94783e-17
C344	VGND#4	B2#2	1.00964e-18
C345	VGND#2	A1#1	7.69723e-20
C346	VGND#2	A2#2	9.90437e-19
C347	VGND#4	A2#3	3.00145e-19
C348	VGND#4	C2#3	2.07954e-17
C349	VGND#2	a_32_74#	1.81929e-17
C350	a_337_390#	VPWR#2	6.40061e-18
C351	VPWR	VPWR#2	3.8581e-17
C352	VGND#2	a_32_74##5	3.03124e-17
C353	VPWR#3	VPWR#2	8.86394e-19
C354	VGND#3	VGND#4	8.78861e-17
C355	VGND#4	VGND#7	8.85966e-18
C356	VGND#2	a_32_74##2	4.39587e-17
C357	VGND#2	VNB	6.81148e-17
C358	X	VPWR#2	2.21097e-17
C359	VGND#2	B2#1	2.56716e-19
C360	VGND#4	C1	9.10131e-19
C361	A2#2	VPWR#2	5.74153e-19
C362	VGND#4	VNB	7.75051e-17
C363	VGND#4	B2#1	2.20053e-17
C364	VPWR#2	A2#1	1.37266e-17
C365	a_32_74##2	VPWR#2	2.51872e-19
C366	VGND#3	VGND#2	7.48785e-17
C367	VGND	VGND#2	7.43438e-17
C368	VGND#4	C1#2	2.91451e-19
C369	VGND#2	B1#4	4.49855e-19
C370	VPWR#2	a_32_74##3	4.63558e-18
C371	VGND	VGND#4	9.50547e-17
C372	VGND#2	VGND#6	7.72046e-18
C373	VGND#4	B1#4	4.57141e-18
*
*
.ENDS sky130_fd_sc_hs__a222o_1
*
