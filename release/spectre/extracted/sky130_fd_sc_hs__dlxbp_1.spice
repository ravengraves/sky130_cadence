* Extracted by Quantus, converted by sky130cad/quantus.py
*
*
*
*                       LINUX           Wed Nov 18 08:33:20 2026
*
*
*
*  PROGRAM  advgen
*
*  Name           : advgen - Quantus - (64-bit)
*  Version        : 25.1.0-p047
*  Build Date     : Thu Dec 11 23:20:30 PST 2025
*
*  HSPICE LIBRARY
*
*  OPERATING_TEMPERATURE 150
*  QRC_TECH_DIR <path>/tech
*
*
*

*
.SUBCKT sky130_fd_sc_hs__dlxbp_1 VPB VNB VGND VPWR Q_N Q GATE D
*
*
*  caps2d version: 10
*
*
*       TRANSISTOR CARDS
*
*
XM16 a_27_413##7 D#3 VGND#13 VNB sky130_fd_pr__nfet_01v8_lvt l=0.15 w=0.55 ad=0.15675 as=0.30395 pd=1.67 ps=2.34
XM14 VGND#13 GATE#3 a_231_74##10 VNB sky130_fd_pr__nfet_01v8_lvt l=0.15 w=0.74 ad=0.30395 as=0.2109 pd=2.34 ps=2.05
XM5 a_373_82##8 a_231_74##4 VGND#12 VNB sky130_fd_pr__nfet_01v8_lvt l=0.15 w=0.74 ad=0.2109 as=0.41945 pd=2.05 ps=2.93
XM12 VGND#12 a_27_413# a_589_80# VNB sky130_fd_pr__nfet_01v8_lvt l=0.15 w=0.64 ad=0.41945 as=0.1536 pd=2.93 ps=1.76
XM8 a_589_80# a_373_82##2 a_664_392##7 VNB sky130_fd_pr__nfet_01v8_lvt l=0.15 w=0.64 ad=0.1536 as=0.3028 pd=1.76 ps=2.46
XM7 a_664_392##7 a_231_74##6 a_815_124# VNB sky130_fd_pr__nfet_01v8_lvt l=0.15 w=0.42 ad=0.3028 as=0.1008 pd=2.46 ps=1.32
XM21 a_815_124# a_863_98# VGND#11 VNB sky130_fd_pr__nfet_01v8_lvt l=0.15 w=0.42 ad=0.1008 as=0.2942 pd=1.32 ps=2.34
XM3 VGND#11 a_664_392##3 a_863_98##11 VNB sky130_fd_pr__nfet_01v8_lvt l=0.15 w=0.74 ad=0.2942 as=0.2109 pd=2.34 ps=2.05
XM2 Q#1 a_863_98##9 VGND#10 VNB sky130_fd_pr__nfet_01v8_lvt l=0.15 w=0.74 ad=0.2072 as=0.24 pd=2.04 ps=2.18
XM15 VGND#10 a_863_98##4 a_1347_424##8 VNB sky130_fd_pr__nfet_01v8_lvt l=0.15 w=0.55 ad=0.24 as=0.15675 pd=2.18 ps=1.67
XM1 VGND#9 a_1347_424# Q_N#3 VNB sky130_fd_pr__nfet_01v8_lvt l=0.15 w=0.74 ad=0.2109 as=0.2109 pd=2.05 ps=2.05
XM18 a_27_413##5 D#1 VPWR#11 VPB sky130_fd_pr__pfet_01v8 l=0.15 w=0.84 ad=0.2436 as=0.4676 pd=2.26 ps=3.18
XM13 VPWR#11 GATE#1 a_231_74##12 VPB sky130_fd_pr__pfet_01v8 l=0.15 w=0.84 ad=0.4676 as=0.2478 pd=3.18 ps=2.27
XM9 a_373_82##9 a_231_74# VPWR#9 VPB sky130_fd_pr__pfet_01v8 l=0.15 w=0.84 ad=0.2478 as=0.48765 pd=2.27 ps=3.19
XM10 VPWR#9 a_27_413##3 a_586_392# VPB sky130_fd_pr__pfet_01v8 l=0.15 w=1 ad=0.48765 as=0.24 pd=3.19 ps=2.48
XM17 a_586_392# a_231_74##7 a_664_392##6 VPB sky130_fd_pr__pfet_01v8 l=0.15 w=1 ad=0.24 as=0.3278 pd=2.48 ps=2.76
XM20 a_664_392##6 a_373_82##3 a_770_508# VPB sky130_fd_pr__pfet_01v8 l=0.15 w=0.42 ad=0.3278 as=0.2121 pd=2.76 ps=1.85
XM0 a_770_508# a_863_98##3 VPWR#6 VPB sky130_fd_pr__pfet_01v8 l=0.15 w=0.42 ad=0.2121 as=0.4228 pd=1.85 ps=3.37
XM6 VPWR#6 a_664_392# a_863_98##13 VPB sky130_fd_pr__pfet_01v8 l=0.15 w=1.12 ad=0.4228 as=0.3304 pd=3.37 ps=2.83
XM11 Q#3 a_863_98##10 VPWR#4 VPB sky130_fd_pr__pfet_01v8 l=0.15 w=1.12 ad=0.3304 as=0.3724 pd=2.83 ps=2.95
XM4 VPWR#4 a_863_98##8 a_1347_424##7 VPB sky130_fd_pr__pfet_01v8 l=0.15 w=0.84 ad=0.3724 as=0.2436 pd=2.95 ps=2.26
XM19 VPWR#1 a_1347_424##4 Q_N#1 VPB sky130_fd_pr__pfet_01v8 l=0.15 w=1.12 ad=0.3248 as=0.3248 pd=2.82 ps=2.82
*
*
*       RESISTOR AND CAP/DIODE CARDS
*
Rg1	D#1	D#2	388.914764
Rg2	D#2	D#3	281.374695
Rg3	GATE#1	GATE#2	509.599396
Rg4	GATE#2	GATE#3	307.937683
Rg5	a_231_74#	a_231_74##2	369.314545
Rg6	a_231_74##2	a_231_74##3	30.596949
Rg7	a_231_74##2	a_231_74##4	443.464691
Rg8	a_27_413#	a_27_413##2	456.270325
Rg9	a_27_413##2	a_27_413##3	393.597412
Rg10	a_373_82#	a_373_82##2	279.244598
Rg11	a_231_74##5	a_231_74##6	216.119781
Rg12	a_231_74##6	a_231_74##7	1244.802856
Rg13	a_373_82##3	a_373_82##4	226.096359
Rg14	a_863_98#	a_863_98##2	630.305725
Rg15	a_863_98##2	a_863_98##3	260.436676
Rg16	a_664_392#	a_664_392##2	517.471497
Rg17	a_664_392##2	a_664_392##3	313.109222
Rg18	a_863_98##4	a_863_98##5	314.345734
Rg19	a_863_98##5	a_863_98##6	77.197716
Rg20	a_863_98##6	a_863_98##7	262.942200
Rg21	a_863_98##5	a_863_98##8	505.039276
Rg22	a_863_98##6	a_863_98##9	365.684052
Rg23	a_863_98##6	a_863_98##10	460.522949
Rg24	a_1347_424#	a_1347_424##2	380.339874
Rg25	a_1347_424##2	a_1347_424##3	81.783760
Rg26	a_1347_424##2	a_1347_424##4	462.979767
Rf1	D#2	D#5	81.918137
Rf2	D#6	D	1.801737
Rf3	D#5	D#6	2.386103
Rf4	GATE	GATE#2	163.775864
Rf5	a_27_413##2	a_27_413##6	367.660889
Rf6	a_27_413##6	a_27_413##7	118.644516
Rf7	a_27_413##5	a_27_413##6	7.500000
Rf8	a_231_74##5	a_231_74##9	319.043152
Rf9	a_231_74##9	a_231_74##10	13.981527
Rf10	a_231_74##9	a_231_74##11	43.648670
Rf11	a_231_74##11	a_231_74##12	53.545078
Rf12	a_231_74##11	a_231_74##3	93.387688
Rf13	a_373_82##4	a_373_82##6	224.358398
Rf14	a_373_82##6	a_373_82##7	75.707298
Rf15	a_373_82##7	a_373_82##8	96.338699
Rf16	a_373_82##6	a_373_82##9	89.653847
Rf17	a_373_82##7	a_373_82#	167.136765
Rf18	a_664_392##2	a_664_392##5	239.755844
Rf19	a_664_392##5	a_664_392##6	66.218102
Rf20	a_664_392##5	a_664_392##7	93.135406
Rf21	a_863_98##11	a_863_98##7	46.196674
Rf22	a_863_98##7	a_863_98##14	34.196754
Rf23	a_863_98##14	a_863_98##2	191.050812
Rf24	a_863_98##13	a_863_98##14	5.000000
Rf25	Q#2	Q	6.495600
Rf26	Q	Q#3	90.173256
Rf27	Q#2	Q	8.070291
Rf28	Q#1	Q#2	7.500000
Rf29	a_1347_424##3	a_1347_424##6	165.370300
Rf30	a_1347_424##6	a_1347_424##7	48.794235
Rf31	a_1347_424##6	a_1347_424##8	39.298279
Rf32	Q_N	Q_N#2	0.194040
Rf33	Q_N#2	Q_N	14.164948
Rf34	Q_N	Q_N#4	7.179494
Rf35	Q_N#4	Q_N	7.179494
Rf36	Q_N#1	Q_N#2	5.000000
Rf37	Q_N#3	Q_N#4	7.500000
Rf39	VGND#2	VGND#3	75.676605
Rf40	VGND#3	VGND#4	126.750893
Rf41	VGND#4	VGND#5	96.767372
Rf42	VGND#5	VGND#6	59.302742
Rf43	VGND#6	VGND#7	127.945679
Rf45	VGND#2	VGND#9	45.656124
Rf46	VGND#3	VGND#10	54.422604
Rf47	VGND#4	VGND#11	31.928404
Rf48	VGND#6	VGND#12	23.173229
Rf49	VGND#7	VGND#13	32.617332
Rf50	VPWR#1	VPWR#2	52.877037
Rf51	VPWR#2	VPWR#3	75.786179
Rf52	VPWR#3	VPWR#4	43.597031
Rf53	VPWR#3	VPWR#5	121.062553
Rf54	VPWR#5	VPWR#6	28.016689
Rf55	VPWR#5	VPWR#7	102.401855
Rf56	VPWR#7	VPWR#8	59.511623
Rf57	VPWR#8	VPWR#9	26.830879
Rf58	VPWR#8	VPWR#10	127.058792
Rf59	VPWR#10	VPWR#11	22.697315
Re1	VPWR#2	VPWR	4.549932
Re2	VPWR	VPWR#7	0.974985
Re3	VGND#2	VGND	4.549932
Re4	VGND	VGND#5	0.974985
*
*       CAPACITOR CARDS
*
*
C1	VGND#4	a_664_392##5	9.3452e-19
C2	a_231_74##10	a_373_82##2	5.01493e-20
C3	a_373_82##7	a_27_413##3	9.62444e-19
C4	a_863_98##5	a_1347_424##2	4.39759e-19
C5	a_373_82##8	a_27_413#	6.63475e-19
C6	a_373_82##6	a_27_413##3	2.89567e-17
C7	a_373_82##9	VPWR#9	3.11413e-17
C8	a_231_74##4	VGND#12	1.78996e-17
C9	Q#1	a_863_98##6	1.87102e-17
C10	a_1347_424##6	VPWR#1	1.52351e-17
C11	a_231_74##10	a_27_413#	7.04103e-19
C12	a_373_82##8	a_231_74##4	4.01177e-17
C13	a_373_82##7	VGND#12	9.24957e-19
C14	VGND#13	a_27_413#	4.78455e-19
C15	a_373_82##6	a_231_74#	6.71546e-19
C16	Q#1	a_863_98##5	2.30426e-19
C17	a_231_74##10	a_231_74##4	1.65752e-17
C18	a_231_74##11	a_27_413##3	2.23585e-19
C19	VPWR#9	VPWR#11	5.44713e-20
C20	a_373_82##8	GATE#3	5.97683e-19
C21	a_1347_424##6	VPWR#2	3.89332e-18
C22	a_863_98##6	a_863_98##5	2.62539e-18
C23	VGND#13	a_231_74##4	7.78196e-19
C24	a_231_74##10	GATE#3	5.1592e-17
C25	a_373_82##6	GATE#1	1.38496e-19
C26	a_27_413##7	a_231_74##4	1.19015e-19
C27	a_231_74##11	a_231_74#	3.68217e-18
C28	GATE#3	VGND#13	2.69583e-17
C29	a_27_413##5	a_373_82##9	3.19053e-17
C30	a_231_74##10	D#3	8.72805e-19
C31	a_231_74##10	a_373_82##7	7.475e-18
C32	a_27_413##7	GATE#3	3.61938e-19
C33	a_231_74##11	GATE#1	4.52647e-18
C34	D#3	VGND#13	2.48828e-17
C35	a_27_413##5	a_231_74##12	3.6787e-17
C36	a_27_413##7	D#3	2.74136e-17
C37	Q#3	a_1347_424##6	7.53379e-18
C38	a_863_98##7	VPWR#5	3.3411e-19
C39	a_27_413##5	VPWR#11	4.52385e-18
C40	a_373_82##9	VPWR#8	1.02773e-17
C41	a_863_98##7	VPWR#3	5.03837e-19
C42	a_1347_424##8	VGND#9	4.12752e-17
C43	a_373_82##8	a_231_74##11	3.25596e-17
C44	VGND#4	a_863_98##7	1.00599e-18
C45	VGND#3	a_863_98##7	1.96217e-18
C46	a_1347_424##4	Q_N#1	1.18708e-17
C47	VGND#10	VGND#9	3.49934e-18
C48	a_231_74##10	a_231_74##11	5.90581e-18
C49	a_1347_424##6	a_1347_424##3	2.8069e-17
C50	a_1347_424##4	VPWR#1	2.37883e-17
C51	a_863_98##4	a_1347_424#	4.67702e-18
C52	a_863_98##2	VPWR#5	1.42033e-18
C53	VGND#4	a_664_392##2	7.95956e-19
C54	a_1347_424##7	a_1347_424##4	1.72621e-18
C55	VGND#10	a_1347_424##8	4.98749e-17
C56	a_863_98##9	a_1347_424#	5.73278e-19
C57	VPWR#1	a_863_98##8	2.69684e-18
C58	VPWR#4	a_1347_424##4	5.69544e-19
C59	a_373_82##6	VPWR#7	7.26269e-18
C60	a_664_392##7	a_231_74##7	1.60703e-18
C61	a_1347_424##7	a_863_98##8	6.11683e-17
C62	a_863_98##9	a_863_98##4	2.60121e-17
C63	Q#1	a_1347_424##8	1.49691e-19
C64	a_373_82##4	VPWR#5	4.86816e-18
C65	VPWR#1	a_863_98##10	2.76085e-19
C66	a_27_413##5	VPWR#8	2.31355e-18
C67	a_863_98##8	VPWR#4	2.10788e-17
C68	a_1347_424##7	a_863_98##10	2.00976e-18
C69	Q#3	a_863_98##8	2.70404e-18
C70	Q#1	VGND#10	5.38279e-17
C71	a_863_98##10	VPWR#4	2.91393e-17
C72	a_664_392##3	a_863_98##9	3.13416e-18
C73	VGND#4	a_373_82##4	2.33361e-19
C74	a_664_392##5	a_863_98##7	2.40007e-19
C75	Q#3	a_863_98##10	8.31834e-17
C76	VPWR#6	a_863_98##8	1.75723e-19
C77	VPWR#4	a_664_392#	3.37297e-19
C78	a_863_98##13	a_863_98##10	2.12144e-18
C79	Q#3	a_664_392#	2.55847e-18
C80	a_863_98#	a_664_392##3	1.80218e-17
C81	VGND#6	a_231_74##5	3.42256e-17
C82	VPWR#6	a_863_98##10	4.59071e-19
C83	VPWR#4	a_863_98##3	1.05039e-19
C84	a_664_392##5	a_664_392##2	8.78216e-18
C85	VGND#4	a_231_74##5	1.28815e-17
C86	a_863_98##11	Q#1	2.26539e-17
C87	a_863_98##13	a_664_392#	8.85074e-17
C88	a_863_98##4	a_1347_424##2	5.51706e-20
C89	a_664_392#	VPWR#6	2.2472e-17
C90	a_231_74##6	a_863_98#	4.95943e-17
C91	a_863_98##13	a_863_98##3	1.2606e-18
C92	a_27_413##2	VPWR#8	9.0881e-19
C93	a_664_392##5	a_863_98##2	1.50661e-17
C94	VPWR#6	a_863_98##3	2.89475e-17
C95	a_664_392##6	a_664_392#	3.84275e-20
C96	a_863_98##13	a_373_82##3	1.63275e-19
C97	VGND#11	a_863_98##11	6.23787e-17
C98	a_373_82##2	a_231_74##6	6.63032e-18
C99	a_373_82##7	a_863_98##2	1.07367e-20
C100	VPWR#6	a_373_82##3	4.24492e-18
C101	a_664_392##5	a_373_82##4	3.58238e-17
C102	VGND#6	a_27_413##2	9.66519e-19
C103	VPWR#8	a_231_74##3	2.15928e-19
C104	a_373_82##6	a_863_98##2	6.1416e-20
C105	VPWR#6	a_231_74##7	1.54119e-18
C106	a_373_82##3	a_664_392##6	1.04575e-17
C107	a_27_413#	a_373_82##2	4.12591e-17
C108	VPWR#9	a_863_98##3	1.11841e-18
C109	VGND#3	a_1347_424#	1.52187e-18
C110	D#5	VGND#13	5.34654e-18
C111	VPWR#3	a_863_98##6	2.29704e-20
C112	a_231_74##5	a_664_392##5	1.3654e-18
C113	VGND#9	a_1347_424##3	7.965e-18
C114	a_373_82##6	a_373_82##4	4.26812e-18
C115	VPWR#6	a_27_413##3	1.08098e-18
C116	VGND#6	a_231_74##3	1.74526e-19
C117	a_664_392##6	a_231_74##7	3.85416e-17
C118	a_664_392##7	a_863_98##11	1.40926e-18
C119	a_1347_424##3	a_1347_424##8	1.19206e-19
C120	VPWR#9	a_373_82##3	2.34266e-18
C121	a_231_74##5	a_373_82##7	2.55881e-17
C122	a_231_74##4	a_27_413#	1.93919e-17
C123	a_27_413##7	D#5	3.5602e-17
C124	a_373_82##9	a_373_82##3	2.77067e-19
C125	a_373_82##7	a_664_392##6	4.14826e-17
C126	VGND#3	a_863_98##4	3.90246e-18
C127	a_664_392##5	a_373_82#	3.55054e-18
C128	VPWR#9	a_231_74##7	3.78619e-18
C129	a_664_392##7	VGND#11	1.42682e-17
C130	GATE#3	a_27_413#	1.61054e-19
C131	a_373_82##9	a_231_74##7	4.28887e-19
C132	a_373_82##6	a_664_392##6	4.28194e-17
C133	a_27_413##3	VPWR#9	3.48422e-17
C134	a_373_82##7	a_373_82#	2.13124e-17
C135	a_863_98##7	Q#1	4.1589e-17
C136	GATE#3	a_231_74##4	3.92491e-18
C137	a_373_82##6	a_373_82#	5.02815e-19
C138	a_664_392##5	a_27_413##2	2.05631e-19
C139	a_863_98##7	a_863_98##11	2.32554e-19
C140	a_1347_424##7	VPWR#2	2.71929e-17
C141	a_373_82##9	a_27_413##3	1.19522e-18
C142	VGND#3	a_863_98##9	1.17491e-17
C143	a_373_82##7	a_664_392##5	1.74247e-17
C144	a_231_74#	VPWR#9	2.68128e-17
C145	a_231_74##12	a_27_413##3	5.72311e-20
C146	Q#1	a_664_392##2	1.14031e-19
C147	VPWR#5	VPWR#3	2.93804e-19
C148	a_373_82##9	a_231_74#	4.67024e-17
C149	VGND#4	a_664_392##3	4.71691e-18
C150	D#3	GATE#3	1.93071e-17
C151	a_1347_424##6	a_1347_424#	6.52077e-19
C152	a_231_74##11	a_373_82#	1.90221e-19
C153	a_373_82##7	a_27_413##2	7.03081e-17
C154	a_863_98##11	a_664_392##2	1.29898e-17
C155	VPWR#9	GATE#1	1.77899e-18
C156	a_664_392##7	a_863_98##7	1.50144e-18
C157	a_27_413##2	a_373_82##6	4.53235e-17
C158	a_231_74##12	a_231_74#	5.73208e-19
C159	a_664_392##2	VGND#11	2.95591e-17
C160	VGND#3	a_664_392##3	7.34454e-19
C161	a_373_82##9	GATE#1	1.847e-18
C162	VPWR#9	D#1	9.59831e-19
C163	a_373_82##6	VPWR#9	1.6782e-17
C164	a_231_74##12	GATE#1	3.51724e-17
C165	a_231_74##11	a_27_413##2	1.00562e-16
C166	a_664_392##7	a_664_392##2	9.63032e-21
C167	a_373_82##7	a_231_74##3	4.3946e-19
C168	a_27_413##5	a_231_74#	1.55316e-18
C169	a_1347_424##6	a_863_98##4	2.38346e-18
C170	VGND#4	a_863_98#	3.8395e-18
C171	a_373_82##9	D#1	4.5159e-19
C172	VGND#9	VPWR#1	6.87792e-18
C173	VGND#11	a_863_98##2	1.61159e-18
C174	GATE#1	VPWR#11	2.53882e-17
C175	a_231_74##12	D#1	4.06605e-18
C176	a_27_413##5	GATE#1	4.12626e-17
C177	VPWR#1	a_1347_424##3	8.69381e-18
C178	D#1	VPWR#11	2.57905e-17
C179	a_231_74##11	a_231_74##3	3.8191e-17
C180	a_373_82##7	GATE#2	3.59153e-19
C181	a_1347_424##6	a_863_98##9	5.23143e-19
C182	a_27_413##5	D#1	5.86251e-17
C183	a_373_82##8	a_664_392##7	1.08475e-18
C184	a_863_98##11	a_231_74##5	2.45298e-19
C185	a_863_98##8	a_1347_424##4	6.60562e-18
C186	a_231_74##5	VGND#11	1.99439e-17
C187	a_231_74##11	GATE#2	1.35897e-17
C188	a_231_74##10	a_664_392##7	1.3654e-18
C189	a_231_74##5	a_664_392##7	7.00481e-17
C190	a_373_82##7	a_373_82##6	2.41974e-18
C191	a_863_98##7	Q#3	2.18026e-17
C192	a_863_98##7	a_863_98##13	2.75077e-19
C193	a_863_98##10	a_863_98##8	3.59089e-17
C194	a_373_82##8	VGND#12	5.22491e-19
C195	a_231_74##11	D#2	3.24323e-18
C196	VGND#6	a_27_413#	7.69978e-18
C197	a_373_82#	a_664_392##7	4.34583e-18
C198	VGND#3	VGND#9	4.29671e-18
C199	VGND#10	VPWR#4	6.38873e-18
C200	a_231_74##10	a_231_74##5	1.75101e-18
C201	a_664_392##2	a_863_98##13	1.87739e-17
C202	a_231_74##10	VGND#12	4.19407e-18
C203	a_664_392#	a_863_98##10	5.51539e-18
C204	VPWR#6	a_664_392##2	1.30865e-18
C205	a_863_98##13	a_863_98##2	4.49673e-19
C206	VGND#6	a_231_74##4	1.25792e-17
C207	a_231_74##10	a_373_82##8	8.70717e-17
C208	a_863_98##2	VPWR#6	4.10202e-17
C209	VGND#3	a_1347_424##8	4.92117e-18
C210	a_863_98##3	a_664_392#	1.03739e-17
C211	D#5	D#2	1.91282e-17
C212	a_373_82##8	a_27_413##2	1.02119e-17
C213	a_373_82##4	a_863_98##13	2.96714e-18
C214	Q#1	Q#3	2.84877e-18
C215	a_231_74##10	a_27_413##2	7.60387e-19
C216	a_664_392##6	a_863_98##2	2.70899e-18
C217	a_373_82##4	VPWR#6	8.87284e-18
C218	a_863_98##5	a_1347_424##3	2.64634e-17
C219	a_373_82##6	a_586_392#	2.558e-18
C220	a_373_82##3	a_863_98##3	1.33078e-17
C221	VGND#6	GATE#3	1.11697e-18
C222	a_231_74##11	a_373_82##7	1.89217e-18
C223	a_373_82##8	a_231_74##3	4.32808e-18
C224	VPWR#1	a_1347_424##2	2.5108e-18
C225	a_373_82##4	a_664_392##6	2.95319e-17
C226	a_27_413##5	a_231_74##11	2.35714e-18
C227	VGND#3	VGND#10	2.61878e-19
C228	VGND#3	a_863_98##6	6.34835e-20
C229	a_231_74##10	a_231_74##3	1.70117e-18
C230	VGND#13	a_231_74##10	6.05017e-17
C231	a_231_74##7	a_373_82##3	2.02435e-17
C232	a_863_98##7	a_863_98##9	5.13251e-19
C233	a_863_98##11	a_863_98##13	2.12282e-18
C234	VGND#5	a_373_82##2	4.07902e-18
C235	GATE#2	a_231_74##10	5.72676e-18
C236	a_863_98##7	a_664_392##3	2.02562e-18
C237	a_664_392##5	a_863_98#	1.00507e-18
C238	a_27_413##7	a_231_74##10	7.17298e-19
C239	a_863_98##7	a_863_98##6	2.83144e-19
C240	a_664_392##2	a_863_98##9	2.39608e-19
C241	a_664_392##6	a_373_82#	3.37584e-18
C242	a_863_98##7	a_863_98#	3.33258e-19
C243	VPWR#1	a_863_98##5	9.12127e-20
C244	VPWR#2	a_1347_424##4	1.38016e-17
C245	a_27_413##3	a_231_74##7	5.95452e-17
C246	VGND#4	a_863_98##11	2.21314e-17
C247	a_863_98##7	a_231_74##6	1.83024e-19
C248	VPWR#2	a_863_98##8	2.819e-18
C249	a_27_413##7	VGND#13	4.1526e-17
C250	VGND#13	D#2	8.40487e-18
C251	a_863_98#	a_664_392##2	1.7892e-17
C252	VPWR#3	a_1347_424##4	3.45056e-19
C253	a_27_413##7	D#2	6.07548e-18
C254	VPWR#2	a_863_98##10	1.3013e-19
C255	a_664_392##5	a_231_74##6	2.03237e-17
C256	a_1347_424##6	VGND#9	7.15031e-18
C257	a_664_392##2	a_231_74##6	1.13857e-18
C258	a_231_74#	a_27_413##3	2.10822e-17
C259	a_863_98##11	VGND#3	2.08169e-18
C260	a_27_413##2	VPWR#9	5.65267e-18
C261	GATE#1	a_27_413##3	3.76821e-19
C262	VPWR#5	a_863_98##8	1.30313e-19
C263	a_27_413##2	a_373_82##9	5.98148e-17
C264	a_231_74##6	a_863_98##2	2.29969e-17
C265	a_231_74##12	a_27_413##2	3.244e-17
C266	GATE#1	a_231_74#	5.61515e-18
C267	a_664_392##2	a_863_98##6	2.37267e-19
C268	VPWR#3	a_863_98##8	7.23877e-18
C269	a_231_74##6	a_373_82##4	1.64509e-17
C270	a_231_74##5	a_664_392##3	4.95613e-18
C271	a_1347_424##7	a_863_98##5	2.7515e-19
C272	a_231_74##3	a_373_82##9	1.70472e-18
C273	a_27_413##5	a_27_413##2	8.91983e-19
C274	VGND#11	VGND#3	6.58072e-19
C275	a_231_74##5	a_863_98#	1.08598e-17
C276	a_373_82##7	a_231_74##6	3.89706e-18
C277	D#1	GATE#1	2.07609e-17
C278	a_231_74##5	a_231_74##6	4.24421e-19
C279	VPWR#5	a_863_98##10	5.63793e-19
C280	D#5	VPWR#11	1.63178e-19
C281	VPWR#7	a_373_82##3	8.3804e-18
C282	a_231_74##5	a_373_82##2	3.02272e-17
C283	VPWR#7	a_231_74##7	8.16755e-18
C284	a_231_74##5	a_27_413#	2.62416e-17
C285	a_373_82#	a_231_74##6	1.14788e-17
C286	a_863_98##7	a_863_98##10	5.63946e-19
C287	VPWR#3	a_863_98##10	7.517e-18
C288	VPWR#4	a_863_98##6	4.81256e-18
C289	a_231_74##5	a_231_74##4	1.17855e-18
C290	a_27_413##5	GATE#2	3.1043e-19
C291	a_863_98##7	a_664_392#	2.27205e-18
C292	VGND#5	a_231_74##7	1.09752e-19
C293	a_373_82##7	a_373_82##2	5.79013e-18
C294	a_231_74##12	D#2	1.12541e-19
C295	a_27_413##5	D#5	4.29104e-17
C296	a_27_413#	a_373_82#	8.54845e-18
C297	a_231_74##5	GATE#3	4.26109e-19
C298	a_27_413##2	a_231_74##6	8.49513e-19
C299	a_664_392##2	a_664_392#	2.51512e-18
C300	VGND#4	VGND#3	2.63465e-19
C301	VPWR#5	a_664_392#	5.96814e-18
C302	VPWR#4	a_863_98##5	2.49699e-18
C303	a_27_413##5	D#2	1.06539e-17
C304	a_664_392##7	a_664_392##6	1.08072e-18
C305	Q#1	a_1347_424##6	1.13055e-17
C306	a_863_98##2	a_664_392#	2.01706e-17
C307	VPWR#3	a_664_392#	1.78418e-19
C308	a_231_74##4	a_27_413##2	1.65652e-18
C309	a_373_82##7	a_27_413#	2.121e-17
C310	a_373_82##4	a_664_392#	3.54238e-19
C311	a_373_82##4	a_863_98##3	4.30336e-18
C312	Q_N	a_1347_424##2	2.04261e-17
C313	a_1347_424##7	VPWR#1	8.12243e-17
C314	a_1347_424#	Q_N#3	7.72375e-18
C315	a_231_74##7	a_863_98##2	1.29647e-18
C316	VPWR#5	a_863_98##3	8.01629e-18
C317	Q_N	a_863_98##5	4.52999e-19
C318	Q#3	a_863_98##6	8.90517e-18
C319	a_373_82##4	a_373_82##3	9.22981e-18
C320	VGND#6	VGND#12	8.92175e-18
C321	GATE#2	a_231_74##4	1.19145e-18
C322	a_1347_424##6	a_1347_424##4	1.316e-18
C323	a_231_74##7	a_373_82##4	3.14165e-17
C324	VPWR#3	a_863_98##3	2.65262e-20
C325	a_373_82##7	a_231_74##4	3.66167e-19
C326	a_1347_424#	VGND#9	2.12499e-17
C327	VPWR#2	a_1347_424##3	1.43165e-18
C328	VPWR#4	VPWR#1	2.16294e-18
C329	Q#3	a_863_98##5	5.95352e-19
C330	a_231_74##5	a_231_74##7	1.62374e-18
C331	a_1347_424##8	a_1347_424#	1.31498e-18
C332	VPWR#5	a_373_82##3	9.08411e-19
C333	a_373_82#	a_231_74##7	2.37731e-17
C334	VPWR#4	a_1347_424##7	8.03567e-17
C335	VGND#9	a_863_98##4	2.88822e-18
C336	a_231_74##11	a_27_413#	2.73268e-20
C337	a_27_413##2	a_231_74##7	2.11718e-17
C338	VGND#10	a_1347_424#	8.07408e-19
C339	VPWR	a_863_98##6	3.59456e-19
C340	a_27_413##2	a_27_413##3	1.20269e-17
C341	a_1347_424##8	a_863_98##4	3.73042e-17
C342	Q#3	a_1347_424##7	6.51929e-18
C343	a_27_413##2	a_231_74#	2.33451e-17
C344	a_1347_424##6	a_1347_424##2	7.35726e-19
C345	VGND#9	a_863_98##9	1.6243e-18
C346	a_27_413##2	GATE#1	2.15159e-18
C347	VPWR#5	a_231_74##7	2.45736e-19
C348	a_231_74##11	a_231_74##4	8.53479e-19
C349	a_1347_424##6	a_863_98##10	9.2655e-19
C350	a_373_82##4	VPWR#7	6.09751e-18
C351	a_863_98##4	VGND#10	1.7592e-17
C352	a_27_413##2	D#1	3.38108e-19
C353	VGND#6	a_231_74##10	4.85792e-17
C354	D	a_231_74##11	1.43197e-17
C355	GATE#1	a_231_74##3	3.39048e-19
C356	Q#3	VPWR#4	8.27876e-17
C357	a_863_98##7	a_664_392##2	9.34339e-17
C358	a_1347_424##8	a_863_98##9	9.73388e-19
C359	a_863_98##7	a_863_98##2	2.43304e-20
C360	VGND#5	a_231_74##5	7.55942e-17
C361	Q#1	a_863_98##4	1.23607e-18
C362	a_863_98#	a_815_124#	9.87534e-18
C363	VPWR#8	a_27_413##3	8.02755e-18
C364	a_863_98##3	a_770_508#	1.21045e-17
C365	a_1347_424##6	a_863_98##6	5.15637e-19
C366	VGND#3	Q	2.14024e-17
C367	a_664_392##2	a_863_98##2	8.16136e-17
C368	a_231_74##6	a_815_124#	9.87534e-18
C369	a_863_98##9	VGND#10	2.2227e-17
C370	VGND#5	a_373_82#	1.3842e-19
C371	a_373_82##3	a_770_508#	1.20889e-17
C372	D#2	GATE#1	8.90224e-18
C373	GATE	a_231_74##11	4.66054e-17
C374	VPWR#5	a_27_413##3	1.5827e-19
C375	a_863_98##5	a_1347_424##4	1.03782e-18
C376	VGND#13	VGND#6	7.5284e-19
C377	VGND	a_863_98##6	1.03374e-18
C378	VGND	a_863_98##5	1.52536e-18
C379	a_373_82##4	a_863_98##2	6.36771e-17
C380	Q#1	a_863_98##9	4.67275e-17
C381	a_231_74##7	a_586_392#	1.85115e-17
C382	a_863_98##13	Q#3	8.49405e-17
C383	VPWR#6	VPWR#4	8.36498e-19
C384	a_27_413##3	a_586_392#	9.98118e-18
C385	a_1347_424##6	a_863_98##5	2.07741e-17
C386	VPWR#8	a_231_74#	2.51412e-18
C387	a_373_82##2	a_589_80#	7.12687e-18
C388	a_863_98##11	a_863_98##9	3.59105e-18
C389	D	VGND#13	1.7596e-17
C390	a_27_413#	a_589_80#	1.07624e-17
C391	a_1347_424##6	Q_N	2.08638e-17
C392	Q#1	a_664_392##3	2.35703e-18
C393	a_231_74##5	a_373_82#	5.26349e-19
C394	VGND#11	a_863_98##9	5.04109e-19
C395	a_231_74##5	a_27_413##2	2.3471e-19
C396	a_231_74##10	GATE	3.44775e-17
C397	VPWR	VPWR#8	7.46962e-17
C398	VPWR	VPWR#5	1.33711e-16
C399	VPWR	VPWR#3	7.07409e-17
C400	a_863_98##11	a_664_392##3	5.18619e-17
C401	Q	VGND#10	1.50451e-17
C402	a_27_413##7	GATE	2.79341e-18
C403	a_27_413##2	a_373_82#	1.41929e-17
C404	Q	Q#1	1.0566e-18
C405	a_863_98##13	VPWR#6	5.22432e-17
C406	VGND#9	a_1347_424##2	2.89406e-18
C407	a_863_98##11	Q	1.04723e-17
C408	a_1347_424##2	VNB	3.83253e-17
C409	a_863_98##6	VNB	2.67836e-17
C410	a_863_98##5	VNB	3.40589e-17
C411	a_231_74##3	a_27_413##2	3.96972e-17
C412	D	VPWR#11	1.69705e-18
C413	a_664_392##3	VGND#11	2.42479e-17
C414	D	a_27_413##5	5.00151e-18
C415	Q_N	Q_N#3	3.83747e-18
C416	VGND#9	Q_N	7.0514e-17
C417	VPWR	a_664_392##5	7.8086e-18
C418	a_1347_424##8	Q_N	6.97607e-19
C419	a_863_98##11	a_863_98#	1.29369e-18
C420	a_1347_424##7	VPWR#3	9.64199e-18
C421	a_373_82##4	a_770_508#	4.32291e-18
C422	a_664_392##5	VPWR#5	1.14029e-18
C423	VPWR	a_373_82##7	8.00112e-19
C424	GATE#2	a_231_74##3	1.53048e-17
C425	VPWR	a_373_82##6	1.7707e-17
C426	VPWR	a_231_74##11	4.13527e-18
C427	GATE	a_27_413##5	4.60284e-18
C428	VGND	VGND#6	9.36089e-17
C429	VGND	VGND#4	9.69833e-17
C430	a_863_98#	VGND#11	1.98261e-17
C431	VGND	VGND#3	8.28915e-17
C432	VPWR#5	VPWR#4	3.32045e-19
C433	D#2	GATE#2	3.67169e-17
C434	VGND#13	a_27_413##5	2.55536e-18
C435	a_664_392##6	a_863_98##13	3.2112e-19
C436	VPWR	D#5	2.18669e-18
C437	Q_N	Q_N#1	5.86299e-18
C438	VPWR#1	Q_N	8.91357e-17
C439	a_863_98##11	a_231_74##6	1.80752e-19
C440	a_664_392##7	a_664_392##3	1.70486e-18
C441	VGND	a_664_392##5	6.1032e-18
C442	Q	a_1347_424#	1.38412e-19
C443	VGND	a_373_82##7	8.70708e-18
C444	GATE	a_231_74##4	8.22959e-20
C445	Q	a_863_98##4	2.84878e-19
C446	a_27_413##7	a_27_413##5	2.22998e-18
C447	Q	a_863_98##9	1.21659e-17
C448	a_863_98##10	a_863_98##5	6.01344e-18
C449	VGND	a_231_74##11	6.67319e-18
C450	Q	a_664_392##3	1.11803e-18
C451	VGND#11	a_231_74##6	2.43645e-18
C452	VPWR#8	VNB	3.99866e-17
C453	VPWR#5	VNB	5.54813e-17
C454	VPWR#3	VNB	3.85757e-17
C455	VGND	D#5	2.92366e-18
C456	a_664_392##7	a_863_98#	4.86594e-18
C457	VGND#6	VNB	4.69976e-17
C458	Q_N	a_1347_424#	2.65593e-17
C459	VGND#4	VNB	5.1338e-17
C460	VPWR	Q#3	2.05215e-17
C461	VGND#3	VNB	4.94979e-17
C462	Q_N	a_863_98##4	5.54954e-19
C463	VPWR	a_863_98##13	2.05022e-17
C464	D	GATE#1	2.08517e-18
C465	a_231_74##5	a_589_80#	6.29928e-19
C466	VGND	a_863_98##11	2.02084e-17
C467	a_1347_424##6	VNB	1.2177e-17
C468	VGND	VGND#11	2.00245e-17
C469	VPWR	a_664_392##6	3.43974e-18
C470	VGND	a_664_392##7	1.14382e-17
C471	VPWR	VPWR#9	2.18472e-17
C472	a_664_392##5	VNB	1.31575e-17
C473	VPWR	a_373_82##9	1.41909e-17
C474	VGND	a_373_82##8	6.53153e-18
C475	VPWR	a_231_74##12	4.20522e-18
C476	VGND	a_231_74##10	4.0635e-17
C477	a_664_392##7	a_664_392##5	3.2822e-18
C478	a_373_82##7	VNB	3.47619e-18
C479	VGND	VGND#13	2.0472e-17
C480	VGND	a_27_413##7	1.61833e-17
C481	VPWR	a_27_413##5	4.44403e-17
C482	VGND#11	a_373_82##2	2.21073e-19
C483	a_231_74##11	VNB	1.65043e-17
C484	Q_N	a_1347_424##4	3.62316e-17
C485	VGND	Q#3	1.04546e-18
C486	a_664_392##7	a_231_74##6	3.39442e-17
C487	Q#3	VPWR#3	2.2163e-17
C488	D#5	VNB	1.9865e-18
C489	VGND#9	VNB	1.13783e-17
C490	VGND	a_664_392##6	1.78204e-18
C491	a_1347_424##8	VNB	1.00788e-17
C492	VGND#10	VNB	3.86725e-18
C493	Q#1	VNB	8.58008e-18
C494	a_863_98##11	VNB	1.21449e-17
C495	a_664_392#	a_863_98##6	2.99448e-19
C496	VGND#11	VNB	6.17439e-18
C497	a_664_392##7	VNB	6.87293e-19
C498	a_373_82##8	VNB	5.97704e-18
C499	VGND	a_863_98##4	3.11383e-18
C500	a_231_74##10	VNB	1.5771e-17
C501	VPWR	a_863_98##8	3.31104e-18
C502	VGND#13	VNB	1.02649e-17
C503	VGND	a_863_98##9	9.35138e-18
C504	a_27_413##7	VNB	4.65508e-17
C505	VPWR	a_863_98##10	4.01405e-18
C506	VGND	a_664_392##3	2.00451e-18
C507	VGND	a_863_98#	8.79382e-18
C508	VPWR	a_664_392#	7.2335e-20
C509	a_863_98##13	VPWR#5	2.09794e-17
C510	VPWR#1	VNB	1.42653e-17
C511	VGND#11	a_27_413#	1.00217e-19
C512	a_1347_424##7	VNB	1.59415e-17
C513	VPWR	a_863_98##3	9.64639e-19
C514	VPWR#4	VNB	3.19826e-18
C515	Q#3	VNB	1.40698e-17
C516	VPWR	a_373_82##3	7.53513e-19
C517	Q_N	VPWR#2	4.21741e-17
C518	VGND	a_27_413#	3.17676e-18
C519	a_863_98##13	VNB	1.38722e-17
C520	D	a_231_74##3	2.0552e-19
C521	a_664_392##5	a_231_74##7	9.72873e-18
C522	VPWR	a_231_74##7	4.06435e-18
C523	VPWR#6	VNB	1.16441e-18
C524	VGND	a_231_74##4	9.57326e-18
C525	VGND	GATE#3	1.72992e-18
C526	VPWR	a_27_413##3	5.37205e-19
C527	a_664_392##6	VNB	1.92441e-18
C528	D	GATE#2	7.01644e-18
C529	VGND	D#3	9.10762e-18
C530	VPWR	a_231_74#	8.26372e-18
C531	a_664_392##7	a_373_82##2	2.31607e-17
C532	VPWR#9	VNB	8.1015e-18
C533	VPWR	GATE#1	9.04102e-18
C534	a_373_82##9	VNB	3.23026e-18
C535	D	D#2	1.05931e-17
C536	a_231_74##12	VNB	6.50918e-19
C537	VPWR	D#1	8.69406e-18
C538	GATE	a_231_74##3	1.5408e-18
C539	a_27_413##5	VNB	7.68142e-17
C540	a_1347_424#	VNB	3.45812e-17
C541	GATE	GATE#2	2.34873e-17
C542	a_863_98##4	VNB	3.75083e-17
C543	a_863_98##9	VNB	3.92082e-17
C544	a_664_392##3	VNB	3.46621e-17
C545	GATE	D#2	4.44671e-18
C546	a_863_98#	VNB	3.84907e-17
C547	VPWR	VPWR#7	6.21088e-17
C548	a_231_74##6	VNB	4.43887e-17
C549	a_373_82##2	VNB	2.39449e-17
C550	a_27_413#	VNB	3.06043e-17
C551	a_231_74##4	VNB	4.60382e-17
C552	GATE#3	VNB	3.79697e-17
C553	VPWR	a_863_98##7	4.70337e-18
C554	D#3	VNB	3.56124e-17
C555	VPWR	a_664_392##2	4.2099e-18
C556	a_1347_424##4	VNB	4.24366e-17
C557	VPWR	a_863_98##2	5.88781e-18
C558	a_863_98##8	VNB	4.80085e-17
C559	VPWR#2	VPWR#3	1.44485e-17
C560	a_863_98##10	VNB	3.86324e-17
C561	VPWR	a_373_82##4	1.56001e-17
C562	a_664_392#	VNB	3.78568e-17
C563	a_863_98##3	VNB	2.64561e-17
C564	VGND	VGND#5	5.15778e-17
C565	a_373_82##3	VNB	2.09306e-17
C566	a_373_82##6	VPWR#8	2.3615e-18
C567	VPWR	a_373_82#	6.46658e-19
C568	a_231_74##7	VNB	6.1788e-17
C569	a_27_413##3	VNB	3.41061e-17
C570	VGND	a_863_98##7	1.36786e-17
C571	VPWR	a_27_413##2	8.71016e-18
C572	a_231_74#	VNB	4.12825e-17
C573	VGND	a_664_392##2	5.70105e-18
C574	VGND#10	a_863_98##6	3.80223e-18
C575	GATE#1	VNB	5.03631e-17
C576	a_664_392##7	a_27_413#	1.63553e-18
C577	a_373_82##8	a_231_74##6	1.44777e-19
C578	D#1	VNB	3.73319e-17
C579	VGND	a_373_82##4	4.6107e-19
C580	VPWR#2	VNB	1.49795e-16
C581	VGND	a_231_74##5	4.66037e-17
C582	VGND	a_373_82#	1.09973e-18
C583	VPWR#7	VNB	3.15711e-17
C584	VGND#5	VNB	2.97897e-17
C585	VGND	a_27_413##2	4.33886e-18
C586	a_1347_424##3	VNB	4.60116e-17
C587	a_863_98##7	VNB	6.03785e-17
C588	VGND	GATE#2	3.32079e-19
C589	a_664_392##2	VNB	4.41845e-17
C590	a_863_98##2	VNB	5.86876e-17
C591	VGND	D#2	3.63384e-19
C592	a_373_82##7	a_231_74##7	1.3576e-17
C593	a_373_82##4	VNB	3.63527e-17
C594	a_231_74##5	VNB	5.18219e-17
C595	a_373_82#	VNB	1.93484e-17
C596	a_27_413##2	VNB	5.71851e-17
C597	D	GATE	3.58946e-17
C598	a_231_74##3	VNB	6.84342e-17
C599	GATE#2	VNB	2.67616e-17
C600	a_373_82##7	a_664_392##7	3.74817e-17
C601	D#2	VNB	6.37684e-17
C602	VPWR	D	3.25559e-18
C603	a_373_82##6	a_231_74##7	3.45724e-17
C604	VPWR	GATE	3.65083e-18
C605	VGND	D	2.49461e-18
C606	a_373_82##8	a_373_82##2	1.89602e-19
C607	VGND	GATE	5.2087e-18
C608	a_664_392##7	a_231_74##4	4.24254e-19
C609	VGND#10	a_863_98##5	8.63789e-18
C610	VGND	Q	1.8779e-17
C611	D	VNB	5.14734e-19
C612	GATE	VNB	1.95881e-18
C613	Q	VNB	5.35507e-18
C614	Q_N	VNB	1.12847e-16
C615	VPWR	VNB	2.9513e-16
C616	VGND	VNB	3.16506e-16
C617	a_27_413#	VGND#12	1.64677e-17
C618	VPWR#10	D#1	1.14231e-17
C619	VGND#2	a_1347_424##6	3.06846e-18
C620	VPWR#10	VNB	6.87349e-17
C621	VPWR#10	a_27_413##3	9.90094e-19
C622	VGND#2	VPWR#1	2.49677e-18
C623	VPWR#10	a_231_74##3	4.16785e-20
C624	a_27_413##5	VPWR#10	7.6446e-17
C625	VGND#7	a_27_413##7	1.1747e-17
C626	VGND#2	a_1347_424#	1.37319e-17
C627	VGND#2	a_863_98##4	5.74815e-18
C628	VPWR#10	GATE#1	1.40487e-17
C629	VGND#2	a_1347_424##2	8.51831e-19
C630	VPWR#10	D#2	6.5492e-19
C631	VPWR#10	VPWR#11	1.04549e-17
C632	VGND#7	D#5	5.68545e-19
C633	VGND#2	a_1347_424##3	3.06999e-18
C634	VPWR#10	VPWR#9	2.9502e-18
C635	VGND#2	Q_N	4.22714e-17
C636	VGND#7	VGND#6	3.01651e-19
C637	VGND#7	D#3	3.55848e-18
C638	VGND#2	VGND#3	1.62919e-17
C639	VGND#7	VNB	6.31669e-17
C640	VGND#7	a_231_74##10	2.61993e-17
C641	VPWR#10	a_231_74#	1.08361e-18
C642	VGND#7	GATE	1.08315e-18
C643	VPWR#10	GATE#2	8.95115e-20
C644	VGND#2	VNB	1.55192e-16
C645	VPWR	VPWR#10	1.21271e-16
C646	VGND#7	GATE#2	1.57414e-19
C647	VGND#7	GATE#3	7.46402e-18
C648	VGND	VGND#7	1.08937e-16
C649	VGND#2	a_1347_424##8	1.98392e-17
*
*
.ENDS sky130_fd_sc_hs__dlxbp_1
*
