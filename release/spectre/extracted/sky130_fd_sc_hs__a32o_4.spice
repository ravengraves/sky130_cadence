* Extracted by Quantus, converted by sky130cad/quantus.py
*
*
*
*                       LINUX           Wed Nov 18 08:14:14 2026
*
*
*
*  PROGRAM  advgen
*
*  Name           : advgen - Quantus - (64-bit)
*  Version        : 25.1.0-p047
*  Build Date     : Thu Dec 11 23:20:30 PST 2025
*
*  HSPICE LIBRARY
*
*  OPERATING_TEMPERATURE 150
*  QRC_TECH_DIR <path>/tech
*
*
*

*
.SUBCKT sky130_fd_sc_hs__a32o_4 VPB VNB VGND VPWR X B2 A2 B1 A1 A3
*
*
*  caps2d version: 10
*
*
*       TRANSISTOR CARDS
*
*
XM1 VGND#7 a_83_283##6 X#3 VNB sky130_fd_pr__nfet_01v8_lvt l=0.15 w=0.74 ad=0.2109 as=0.2183 pd=2.05 ps=2.07
XM5 VGND#11 a_83_283##10 X#3 VNB sky130_fd_pr__nfet_01v8_lvt l=0.15 w=0.74 ad=0.3182 as=0.2183 pd=2.34 ps=2.07
XM10 X#1 a_83_283##8 VGND#11 VNB sky130_fd_pr__nfet_01v8_lvt l=0.15 w=0.74 ad=0.2072 as=0.3182 pd=2.04 ps=2.34
XM26 X#1 a_83_283# VGND#10 VNB sky130_fd_pr__nfet_01v8_lvt l=0.15 w=0.74 ad=0.2072 as=0.5114 pd=2.04 ps=3
XM12 a_587_110##2 B2#4 VGND#10 VNB sky130_fd_pr__nfet_01v8_lvt l=0.15 w=0.64 ad=0.1792 as=0.5114 pd=1.84 ps=3
XM2 a_83_283##18 B1#4 a_587_110##2 VNB sky130_fd_pr__nfet_01v8_lvt l=0.15 w=0.64 ad=0.255775 as=0.1792 pd=2.29 ps=1.84
XM6 a_587_110# B1#5 a_83_283##18 VNB sky130_fd_pr__nfet_01v8_lvt l=0.15 w=0.64 ad=0.1792 as=0.255775 pd=1.84 ps=2.29
XM23 VGND#9 B2#7 a_587_110# VNB sky130_fd_pr__nfet_01v8_lvt l=0.15 w=0.64 ad=0.192025 as=0.1792 pd=1.99 ps=1.84
XM7 a_1079_122##2 A2#1 a_992_122##4 VNB sky130_fd_pr__nfet_01v8_lvt l=0.15 w=0.64 ad=0.1792 as=0.1824 pd=1.84 ps=1.85
XM17 a_1079_122##2 A1#5 a_83_283##13 VNB sky130_fd_pr__nfet_01v8_lvt l=0.15 w=0.64 ad=0.1792 as=0.1792 pd=1.84 ps=1.84
XM22 a_83_283##13 A1#4 a_1079_122# VNB sky130_fd_pr__nfet_01v8_lvt l=0.15 w=0.64 ad=0.1792 as=0.2304 pd=1.84 ps=2
XM11 a_992_122##2 A2#6 a_1079_122# VNB sky130_fd_pr__nfet_01v8_lvt l=0.15 w=0.64 ad=0.192 as=0.2304 pd=1.88 ps=2
XM3 VGND#8 A3#5 a_992_122##2 VNB sky130_fd_pr__nfet_01v8_lvt l=0.15 w=0.64 ad=0.24 as=0.192 pd=2.03 ps=1.88
XM18 a_992_122# A3#1 VGND#8 VNB sky130_fd_pr__nfet_01v8_lvt l=0.15 w=0.64 ad=0.1824 as=0.24 pd=1.85 ps=2.03
XM0 VPWR#8 a_83_283##12 X#5 VPB sky130_fd_pr__pfet_01v8 l=0.15 w=1.12 ad=0.3304 as=0.336 pd=2.83 ps=2.84
XM13 X#5 a_83_283##11 VPWR#13 VPB sky130_fd_pr__pfet_01v8 l=0.15 w=1.12 ad=0.336 as=0.392 pd=2.84 ps=2.94
XM19 X#6 a_83_283##9 VPWR#13 VPB sky130_fd_pr__pfet_01v8 l=0.15 w=1.12 ad=0.336 as=0.392 pd=2.84 ps=2.94
XM24 VPWR#12 a_83_283##7 X#6 VPB sky130_fd_pr__pfet_01v8 l=0.15 w=1.12 ad=0.3304 as=0.336 pd=2.83 ps=2.84
XM14 a_83_283##20 B2#1 a_509_392##10 VPB sky130_fd_pr__pfet_01v8 l=0.15 w=1 ad=0.35 as=0.295 pd=2.7 ps=2.59
XM8 a_509_392##9 B1#6 a_83_283##20 VPB sky130_fd_pr__pfet_01v8 l=0.15 w=1 ad=0.35 as=0.35 pd=2.7 ps=2.7
XM27 a_83_283##19 B1#1 a_509_392##9 VPB sky130_fd_pr__pfet_01v8 l=0.15 w=1 ad=0.35 as=0.35 pd=2.7 ps=2.7
XM21 a_509_392##5 B2#5 a_83_283##19 VPB sky130_fd_pr__pfet_01v8 l=0.15 w=1 ad=0.545 as=0.35 pd=3.09 ps=2.7
XM20 VPWR#11 A2#3 a_509_392##5 VPB sky130_fd_pr__pfet_01v8 l=0.15 w=1 ad=0.465 as=0.545 pd=2.93 ps=3.09
XM4 VPWR#11 A1#6 a_509_392##7 VPB sky130_fd_pr__pfet_01v8 l=0.15 w=1 ad=0.465 as=0.32 pd=2.93 ps=2.64
XM25 a_509_392##7 A1#1 VPWR#10 VPB sky130_fd_pr__pfet_01v8 l=0.15 w=1 ad=0.32 as=0.36 pd=2.64 ps=2.72
XM16 a_509_392##2 A2#4 VPWR#10 VPB sky130_fd_pr__pfet_01v8 l=0.15 w=1 ad=0.3 as=0.36 pd=2.6 ps=2.72
XM9 a_509_392##2 A3#7 VPWR#9 VPB sky130_fd_pr__pfet_01v8 l=0.15 w=1 ad=0.3 as=0.35 pd=2.6 ps=2.7
XM15 VPWR#9 A3#6 a_509_392# VPB sky130_fd_pr__pfet_01v8 l=0.15 w=1 ad=0.35 as=0.295 pd=2.7 ps=2.59
*
*
*       RESISTOR AND CAP/DIODE CARDS
*
Rg1	a_83_283#	a_83_283##2	399.309723
Rg2	a_83_283##2	a_83_283##3	60.557339
Rg3	a_83_283##3	a_83_283##4	104.192024
Rg4	a_83_283##4	a_83_283##5	58.247906
Rg5	a_83_283##5	a_83_283##6	388.364594
Rg6	a_83_283##2	a_83_283##7	499.522186
Rg7	a_83_283##3	a_83_283##8	342.845093
Rg8	a_83_283##3	a_83_283##9	440.853546
Rg9	a_83_283##4	a_83_283##10	385.028137
Rg10	a_83_283##4	a_83_283##11	531.814880
Rg11	a_83_283##5	a_83_283##12	535.151306
Rg12	B2#1	B2#2	428.152496
Rg13	B2#2	B2#3	190.829758
Rg14	B2#2	B2#4	394.071777
Rg15	B1#1	B1#2	411.292023
Rg16	B1#2	B1#3	50.893330
Rg17	B1#3	B1#4	436.894867
Rg18	B1#2	B1#5	267.948181
Rg19	B1#3	B1#6	388.394775
Rg20	B2#5	B2#6	1337.467896
Rg21	B2#6	B2#7	273.732178
Rg22	A2#1	A2#2	369.222809
Rg23	A2#2	A2#3	417.171356
Rg24	A1#1	A1#2	424.106537
Rg25	A1#2	A1#3	60.127804
Rg26	A1#2	A1#4	345.908142
Rg27	A1#3	A1#5	350.123199
Rg28	A1#3	A1#6	423.839417
Rg29	A2#4	A2#5	421.710602
Rg30	A2#5	A2#6	337.572174
Rg31	A3#1	A3#2	340.338165
Rg32	A3#2	A3#3	24.690777
Rg33	A3#3	A3#4	38.488544
Rg34	A3#4	A3#5	345.908142
Rg35	A3#2	A3#6	425.535919
Rg36	A3#4	A3#7	424.106537
Rf1	X#1	X#2	63.746216
Rf2	X#2	X	32.504993
Rf3	X#2	X#3	16.284164
Rf4	X	X#4	56.026054
Rf5	X#4	X#5	28.792690
Rf6	X#4	X#6	85.984665
Rf7	B1	B1#7	4.330400
Rf8	B1#7	B1	14.565889
Rf9	a_587_110#	a_587_110##2	82.680542
Rf10	B2#6	B2#3	355.451477
Rf11	B2#3	B2	1.968364
Rf12	A1#3	A1#8	160.919952
Rf13	A1#9	A1	0.687145
Rf14	A1#8	A1#9	7.873454
Rf15	a_83_283##13	a_83_283##14	155.006897
Rf16	a_83_283##14	a_83_283##15	56.244293
Rf17	a_83_283##15	a_83_283##16	62.849579
Rf18	a_83_283##16	a_83_283##3	183.706726
Rf19	a_83_283##14	a_83_283##18	42.424694
Rf20	a_83_283##15	a_83_283##19	12.442291
Rf21	a_83_283##16	a_83_283##20	16.968842
Rf22	a_1079_122#	a_1079_122##2	94.827797
Rf23	A2#5	A2#8	296.769592
Rf24	A2#8	A2	5.877638
Rf25	A3	A3#3	80.116402
Rf26	a_509_392#	a_509_392##3	94.878357
Rf27	a_509_392##3	a_509_392##4	71.328186
Rf28	a_509_392##4	a_509_392##6	85.228943
Rf29	a_509_392##4	a_509_392##7	12.835279
Rf30	a_509_392##6	a_509_392##8	92.415871
Rf31	a_509_392##8	a_509_392##9	19.134041
Rf32	a_509_392##8	a_509_392##10	88.944084
Rf33	a_509_392##2	a_509_392##3	5.000000
Rf34	a_509_392##5	a_509_392##6	5.000000
Rf35	a_992_122#	a_992_122##3	92.401321
Rf36	a_992_122##3	a_992_122##4	187.433411
Rf37	a_992_122##2	a_992_122##3	7.500000
Rf39	VPWR#2	VPWR#3	72.462212
Rf40	VPWR#3	VPWR#4	76.788109
Rf41	VPWR#4	VPWR#5	149.879013
Rf42	VPWR#5	VPWR#6	89.827576
Rf43	VPWR#6	VPWR#7	69.348907
Rf44	VPWR#7	VPWR#8	116.941498
Rf45	VPWR#2	VPWR#9	39.243774
Rf46	VPWR#3	VPWR#10	31.324541
Rf47	VPWR#4	VPWR#11	30.878517
Rf48	VPWR#6	VPWR#12	32.518913
Rf49	VPWR#7	VPWR#13	34.684113
Rf51	VGND#2	VGND#3	204.274170
Rf52	VGND#3	VGND#4	95.794189
Rf53	VGND#4	VGND#5	82.157272
Rf54	VGND#5	VGND#6	75.889542
Rf55	VGND#6	VGND#7	99.780998
Rf56	VGND#2	VGND#8	42.874294
Rf57	VGND#3	VGND#9	69.903687
Rf58	VGND#5	VGND#10	38.424004
Rf59	VGND#6	VGND#11	31.332411
Rf66	A2#2	A2#8	160.232803
Rf60	B1#3	B1#7	160.232803
Re1	VPWR#2	VPWR	4.549932
Re2	VPWR	VPWR#5	0.974985
Re3	VGND#2	VGND	4.549932
Re4	VGND	VGND#4	0.974985
*
*       CAPACITOR CARDS
*
*
C1	a_992_122#	VGND#8	5.17559e-17
C2	a_509_392##8	B1#1	2.09203e-17
C3	a_587_110##2	B2#4	3.26206e-17
C4	X#6	VPWR#12	6.33075e-17
C5	a_83_283##18	a_83_283#	5.65286e-20
C6	a_509_392##4	VPWR#3	7.27027e-18
C7	a_992_122##2	a_992_122#	2.56509e-18
C8	B2#4	VGND#10	2.22936e-17
C9	VPWR#13	VPWR#12	1.49128e-18
C10	a_509_392##8	B1#6	1.60053e-17
C11	a_83_283##15	A2#3	1.62839e-18
C12	a_83_283#	VGND#10	1.94009e-17
C13	a_992_122##2	VGND#8	5.3781e-17
C14	VPWR#6	a_83_283##7	4.2039e-18
C15	X#6	VPWR#13	7.64517e-17
C16	VGND#11	B2#4	6.62708e-20
C17	X#6	a_83_283##2	9.45833e-19
C18	a_83_283##16	B2#5	1.98955e-19
C19	X#1	a_83_283#	4.5009e-17
C20	X#5	X#6	5.24055e-19
C21	VGND#10	a_83_283##8	8.34957e-19
C22	a_83_283##15	B2#5	2.96481e-17
C23	VPWR#7	a_83_283##9	2.52947e-18
C24	VGND#11	a_83_283#	1.44404e-18
C25	a_83_283##14	B2#5	2.62352e-17
C26	X#1	a_83_283##8	5.52256e-17
C27	a_509_392##4	a_509_392##2	2.39121e-18
C28	X#5	VPWR#13	5.87417e-17
C29	a_83_283##16	B1#1	1.58292e-18
C30	VPWR#13	a_83_283##4	5.52641e-19
C31	a_509_392##5	VPWR#4	4.39324e-17
C32	VGND#10	a_83_283##10	3.83553e-19
C33	a_83_283##8	VGND#11	2.22566e-17
C34	a_83_283##15	B1#1	2.39118e-17
C35	a_992_122##2	a_1079_122#	1.0124e-16
C36	VPWR#8	VPWR#13	1.7987e-18
C37	X#1	a_83_283##10	9.00016e-19
C38	VPWR#7	a_83_283##11	1.85478e-18
C39	X#3	a_83_283##8	1.27448e-18
C40	a_509_392##4	VPWR#10	4.37426e-17
C41	a_83_283##16	B1#6	3.82153e-17
C42	VGND#11	a_83_283##10	3.63602e-17
C43	VPWR#8	X#5	5.93308e-17
C44	a_83_283##2	B2#3	9.12768e-18
C45	a_83_283##15	B1#6	4.35441e-19
C46	a_83_283##5	X#5	2.39747e-19
C47	X#1	a_83_283##6	2.99429e-19
C48	a_83_283##10	X#3	1.73663e-17
C49	VGND#3	a_83_283##14	3.66894e-19
C50	VPWR#7	a_83_283##12	1.60515e-18
C51	VGND#11	a_83_283##6	2.19074e-18
C52	a_83_283##4	X#5	2.36551e-19
C53	VGND#7	a_83_283##10	2.01109e-18
C54	a_83_283##16	B2#1	2.73609e-17
C55	a_509_392##4	a_509_392##7	6.53392e-18
C56	a_1079_122#	a_83_283##13	4.14486e-17
C57	a_83_283##6	X#3	2.15838e-17
C58	a_83_283##15	B2#1	2.32366e-20
C59	a_83_283##16	VPWR#6	4.93171e-19
C60	VGND#7	a_83_283##6	2.99115e-17
C61	a_83_283##3	a_83_283##5	2.13118e-20
C62	a_83_283##3	a_83_283##4	1.46741e-17
C63	a_1079_122##2	a_1079_122#	2.34428e-18
C64	a_83_283##16	a_83_283##7	3.72746e-19
C65	a_992_122##4	a_992_122##2	9.31377e-19
C66	a_509_392##4	VPWR#11	5.42505e-17
C67	a_83_283##3	a_83_283##2	1.87378e-17
C68	a_83_283##18	a_83_283##2	9.10207e-20
C69	a_83_283##15	a_83_283##7	4.60168e-20
C70	A3#5	A3#1	2.29494e-17
C71	a_83_283##13	a_1079_122##2	5.37145e-17
C72	a_509_392##8	a_83_283##19	7.02495e-19
C73	a_992_122##4	a_1079_122#	3.43952e-18
C74	a_509_392##10	VPWR#6	2.14974e-17
C75	a_83_283##16	a_83_283##9	1.14617e-19
C76	a_509_392##5	a_509_392##4	2.01383e-18
C77	A2#6	A3#5	3.1239e-17
C78	a_509_392#	A3#6	5.26366e-17
C79	a_83_283##13	a_992_122##4	2.93906e-17
C80	a_509_392##8	a_509_392##9	1.26724e-18
C81	A3#6	VPWR#9	3.07353e-17
C82	a_509_392#	A3#7	1.84939e-18
C83	a_509_392##2	A3#6	2.0087e-18
C84	a_992_122##4	a_1079_122##2	8.39063e-17
C85	X#6	VPWR#7	8.03766e-18
C86	VGND#9	B2#5	7.51149e-19
C87	A1#4	A2#6	2.58588e-17
C88	A3#7	VPWR#9	3.21025e-17
C89	VPWR#10	A3#6	3.90625e-19
C90	X#4	a_83_283##7	1.45445e-19
C91	a_509_392##8	a_83_283##20	2.69038e-19
C92	X#6	VPWR#6	8.5632e-18
C93	a_509_392##2	A3#7	6.92808e-17
C94	VPWR#9	A2#4	1.12907e-18
C95	VPWR#10	A3#7	1.48197e-18
C96	A1#5	A1#4	3.53529e-17
C97	X#2	VGND#11	1.80254e-17
C98	X#4	a_83_283##9	8.81631e-19
C99	a_509_392##2	A2#4	4.43819e-17
C100	VGND#9	a_992_122##4	3.91868e-17
C101	VPWR#10	A2#4	3.99552e-17
C102	a_83_283##16	a_509_392##8	1.70406e-17
C103	a_509_392##2	A1#1	1.68438e-18
C104	X#2	X#3	1.62828e-19
C105	X#5	VPWR#7	1.36817e-17
C106	X#4	a_83_283##11	1.94604e-17
C107	a_509_392##8	VPWR#5	7.92738e-17
C108	A2#1	A1#5	3.39074e-17
C109	A1#1	VPWR#10	3.50168e-17
C110	X#1	a_83_283##4	1.50448e-19
C111	VPWR#11	A2#4	3.39042e-19
C112	a_509_392##2	A1#6	6.57209e-19
C113	a_83_283##15	a_509_392##8	3.25574e-17
C114	A1#1	a_509_392##7	1.20931e-17
C115	a_509_392##5	A2#4	2.36667e-19
C116	VGND#7	X#2	3.48961e-18
C117	X#4	a_83_283##12	8.80177e-18
C118	VPWR#10	A1#6	1.64887e-18
C119	a_587_110#	VGND#9	1.56244e-17
C120	X#1	a_83_283##2	2.07506e-18
C121	VPWR#11	A1#1	7.41683e-19
C122	a_83_283##15	a_509_392##5	5.31141e-17
C123	VPWR#8	VPWR#7	9.86498e-19
C124	a_509_392##2	A2#3	2.78639e-19
C125	VGND#6	X#2	2.70127e-19
C126	A1#6	a_509_392##7	2.15432e-17
C127	a_509_392##5	A1#1	3.32349e-19
C128	VPWR#10	A2#3	4.38047e-19
C129	a_83_283##14	a_83_283##2	2.29165e-19
C130	a_83_283##14	a_509_392##8	2.13137e-19
C131	a_83_283##14	a_509_392##5	3.93761e-19
C132	A1#6	VPWR#11	2.95895e-17
C133	A1#8	a_509_392##7	1.18556e-18
C134	VGND#6	a_83_283##5	7.08096e-20
C135	a_83_283##15	a_83_283##19	2.49666e-18
C136	a_509_392##5	A1#6	1.90469e-18
C137	VGND#11	a_83_283##4	7.48323e-19
C138	B1#5	B2#7	3.07228e-17
C139	a_83_283##16	a_509_392##9	5.09419e-17
C140	A2#3	VPWR#11	3.21263e-17
C141	a_992_122#	a_509_392#	3.93609e-19
C142	VGND#3	A1#3	1.5732e-20
C143	a_587_110#	a_83_283##18	2.06844e-17
C144	a_587_110##2	VGND#9	1.99297e-18
C145	a_509_392##5	A2#3	4.40852e-17
C146	a_83_283##15	a_509_392##9	6.05345e-17
C147	VGND#6	a_83_283##4	5.23991e-20
C148	VPWR#11	B2#5	6.75528e-19
C149	B1#4	B1#5	2.61987e-17
C150	a_83_283##16	a_83_283##20	3.14398e-18
C151	VPWR#4	A1#3	4.52096e-20
C152	a_509_392##5	B2#5	5.36961e-17
C153	a_509_392##9	A2#3	3.00989e-19
C154	VPWR#3	A1#3	2.51366e-20
C155	VGND#3	A2#2	4.18229e-20
C156	A2#5	a_509_392##4	4.26921e-17
C157	X#4	VPWR#7	2.71689e-19
C158	B2#5	a_83_283##19	2.26517e-17
C159	a_509_392##5	B1#1	6.33214e-19
C160	B2#4	B1#4	3.59215e-17
C161	a_509_392##9	B2#5	1.55051e-18
C162	VGND#6	a_83_283##2	1.30702e-20
C163	a_587_110##2	a_83_283##18	3.25006e-17
C164	a_83_283##16	a_509_392##10	9.25174e-17
C165	B1#1	a_83_283##19	8.91869e-18
C166	VGND#5	B2#6	1.46164e-19
C167	a_509_392##4	A1#3	8.62349e-19
C168	a_509_392##9	B1#1	4.57952e-17
C169	VGND#3	B2#6	5.86667e-17
C170	a_83_283#	B2#4	6.04788e-18
C171	VPWR#12	B2#5	4.19848e-20
C172	B1#6	a_509_392##9	2.10803e-17
C173	a_509_392##10	B1#1	3.30616e-19
C174	a_992_122##2	a_509_392##2	9.41442e-18
C175	VGND#3	A1#5	1.13643e-18
C176	a_509_392##4	A2#2	1.04902e-18
C177	B1#6	a_83_283##20	2.26517e-17
C178	VPWR#12	B1#1	6.37535e-20
C179	VGND#5	a_83_283##2	3.5605e-20
C180	a_83_283##8	a_83_283#	3.80797e-17
C181	a_509_392##9	B2#1	1.26411e-18
C182	a_509_392##10	B1#6	1.54142e-18
C183	A1#8	A2#5	1.24019e-19
C184	X#6	a_83_283##16	1.26383e-18
C185	B2#1	a_83_283##20	8.91869e-18
C186	VPWR#12	B1#6	2.05041e-19
C187	a_83_283##14	A1#3	2.11763e-19
C188	a_992_122#	A3#3	5.00919e-18
C189	a_509_392##10	B2#1	7.0358e-17
C190	VGND#3	A2#1	1.13714e-18
C191	X#6	B1#6	1.12563e-19
C192	VGND#5	B2#3	2.78682e-20
C193	a_83_283##10	a_83_283##8	1.89861e-17
C194	VGND#8	A3#3	1.97924e-18
C195	VPWR#12	B2#1	2.25927e-18
C196	A1#8	A1#3	1.36611e-17
C197	a_992_122##2	A3#3	7.22232e-19
C198	X#1	VGND#10	6.76194e-17
C199	a_509_392##10	a_83_283##7	1.41111e-18
C200	X#6	B2#1	4.53506e-19
C201	a_509_392##8	B1#3	8.95695e-20
C202	a_83_283##14	A2#2	1.9653e-19
C203	A3	A3#4	1.08438e-17
C204	VPWR#6	B2#3	1.74226e-19
C205	VPWR#12	a_83_283##7	5.99832e-17
C206	a_83_283##6	a_83_283##10	3.46295e-17
C207	VGND#6	a_83_283##3	2.27224e-20
C208	VGND#5	a_83_283##3	4.71524e-19
C209	B2#6	a_83_283##16	6.20021e-20
C210	a_83_283##7	X#6	2.04894e-17
C211	VGND#11	VGND#10	3.50919e-18
C212	a_992_122##2	A2#5	2.51243e-17
C213	A1#8	A2#2	5.35305e-18
C214	a_83_283##15	B2#6	1.51113e-19
C215	A2#5	a_1079_122#	2.74693e-17
C216	VPWR#12	a_83_283##9	1.9489e-18
C217	VPWR#13	a_83_283##7	1.04525e-18
C218	a_83_283##16	a_83_283##15	2.59148e-18
C219	B2#6	a_83_283##14	6.10001e-18
C220	VPWR#7	a_83_283##3	1.34557e-20
C221	a_83_283##13	A2#5	1.91344e-18
C222	X#6	a_83_283##9	6.51061e-17
C223	a_83_283##3	VPWR#6	1.05654e-18
C224	VGND#3	a_83_283##13	1.01074e-19
C225	X#1	VGND#11	5.2489e-17
C226	B2#5	A2#1	8.45868e-18
C227	VPWR#12	a_83_283##11	2.60881e-19
C228	a_83_283##9	VPWR#13	2.56438e-17
C229	B1#3	a_83_283##16	1.4355e-17
C230	a_1079_122#	A1#3	3.74715e-20
C231	a_83_283##15	B1#3	1.05613e-17
C232	X#6	a_83_283##11	1.74354e-18
C233	B2#7	B2#5	1.74396e-17
C234	X#5	a_83_283##9	8.75781e-20
C235	VPWR#7	a_83_283##5	2.05187e-20
C236	a_83_283##13	A1#3	2.23978e-18
C237	a_83_283##14	B1#3	3.74969e-18
C238	X#3	X#1	3.57093e-18
C239	VPWR#13	a_83_283##11	5.20926e-17
C240	VGND#6	VGND#5	1.27052e-18
C241	a_1079_122##2	A1#3	3.50215e-19
C242	A1	A1#2	9.84154e-18
C243	a_992_122##4	A1#3	2.78567e-19
C244	X#6	a_83_283##12	3.31035e-19
C245	a_83_283##11	X#5	1.60767e-17
C246	A1#8	B1#3	2.23025e-19
C247	a_83_283##16	B2#3	4.77129e-18
C248	VPWR#13	a_83_283##12	3.06482e-18
C249	VPWR#8	a_83_283##11	1.17456e-18
C250	a_83_283##15	B2#3	1.90118e-19
C251	a_83_283##13	A2#2	3.345e-18
C252	X#3	VGND#11	3.28502e-17
C253	a_83_283##14	a_83_283##15	8.60489e-18
C254	a_83_283##14	B2#3	1.10721e-19
C255	VPWR#7	a_83_283##4	2.02451e-20
C256	A3#7	A3#6	3.41563e-17
C257	X#5	a_83_283##12	4.57526e-17
C258	a_509_392#	A3#3	2.89643e-18
C259	a_992_122##4	A2#2	1.34163e-18
C260	a_992_122##2	B2#6	1.69176e-19
C261	VPWR#8	a_83_283##12	3.20905e-17
C262	VGND#5	B2#4	1.11018e-18
C263	VPWR#9	A3#3	1.72018e-18
C264	VGND#3	a_992_122##4	9.40855e-17
C265	VGND#7	VGND#11	3.41266e-18
C266	a_83_283##13	B2#6	7.53955e-19
C267	a_509_392##2	A3#3	2.13822e-18
C268	a_83_283##3	a_83_283##15	7.33469e-19
C269	a_1079_122##2	B2#6	6.7029e-19
C270	A2#4	A3#7	4.23086e-17
C271	a_992_122##4	B2#6	1.31755e-17
C272	X#4	B2#3	2.88087e-20
C273	VPWR#3	A1#2	8.49941e-21
C274	VGND#9	B2#6	6.5432e-17
C275	X#4	X#6	1.82837e-18
C276	a_509_392##10	VPWR#5	2.7953e-17
C277	VGND#7	X#3	3.25068e-17
C278	A2#5	a_509_392##2	4.59706e-17
C279	B2#6	a_587_110#	4.30752e-17
C280	VGND#5	a_83_283#	8.06448e-18
C281	a_509_392##8	B2#7	1.3575e-18
C282	A2#5	VPWR#10	1.26354e-18
C283	A1#1	A2#4	3.08576e-17
C284	VGND#3	VGND#9	1.16349e-18
C285	A2#5	a_509_392##7	9.01547e-19
C286	B2#6	a_587_110##2	4.7303e-17
C287	VGND#10	B2#6	1.07987e-19
C288	X#4	a_83_283##3	5.26295e-17
C289	X#4	VPWR#13	2.64005e-17
C290	VGND#6	a_83_283##8	2.4714e-18
C291	a_587_110#	B1#3	5.958e-19
C292	X#2	a_83_283##3	1.94505e-17
C293	X#4	a_83_283##5	1.18764e-17
C294	B1#3	a_83_283##18	1.28589e-17
C295	A1#6	A1#1	3.93444e-17
C296	a_587_110##2	B1#3	2.72638e-18
C297	VPWR#6	a_83_283##2	1.3415e-20
C298	A2	A1#2	6.47676e-20
C299	X#4	X#5	9.02705e-19
C300	A2#3	A1#6	2.17243e-17
C301	X#4	a_83_283##4	8.41566e-18
C302	VGND#6	a_83_283##10	8.18123e-19
C303	A2#2	VPWR#11	1.41762e-18
C304	a_587_110##2	B2#3	2.64783e-18
C305	a_509_392##5	A2#2	8.68566e-19
C306	a_83_283##14	A1#8	1.01801e-18
C307	B2#5	A2#3	1.60962e-17
C308	X#4	VPWR#8	2.74837e-17
C309	X#4	a_83_283##2	1.99986e-20
C310	X#2	a_83_283##5	3.39032e-18
C311	a_509_392#	VPWR#9	7.51118e-17
C312	VGND#10	a_83_283##3	2.84437e-17
C313	VPWR#5	B2#7	2.21934e-19
C314	a_83_283##3	X#1	7.43051e-17
C315	VGND#6	a_83_283##6	2.40624e-20
C316	B1#1	B2#5	3.05645e-17
C317	a_83_283##3	VGND#11	6.13408e-18
C318	a_83_283##2	B2#4	4.57475e-19
C319	a_83_283##14	A1#5	4.23187e-21
C320	A2#5	A3#5	2.02962e-19
C321	a_509_392##2	a_509_392#	2.81393e-18
C322	X#2	a_83_283##4	4.79597e-18
C323	VGND#4	B1#5	9.164e-19
C324	B2	a_83_283##4	1.41003e-19
C325	B2	a_83_283##2	4.816e-18
C326	A1#4	A2#5	1.70259e-19
C327	a_509_392##9	B1#3	1.13998e-18
C328	B1#6	B1#1	2.99863e-17
C329	VGND#4	B1#4	2.61219e-18
C330	a_509_392##2	VPWR#9	7.75505e-17
C331	a_83_283##14	A2#1	4.32367e-20
C332	VGND#4	B2#4	1.4846e-18
C333	VGND#6	X#1	6.62318e-18
C334	a_992_122#	A3#1	4.49756e-17
C335	B2#1	B1#6	2.94427e-17
C336	a_83_283##15	B2#7	6.48432e-18
C337	A2#1	A1#3	4.33956e-19
C338	a_509_392##10	B2#3	1.63289e-18
C339	VPWR#10	VPWR#9	1.21091e-18
C340	A3#1	VGND#8	2.06389e-17
C341	VGND#5	X#1	6.32274e-18
C342	a_83_283##14	B2#7	2.4604e-17
C343	X#6	B2#3	9.42624e-20
C344	a_83_283##7	B2#1	5.53478e-18
C345	a_992_122#	A3#5	1.54063e-18
C346	X	a_83_283##5	1.3769e-17
C347	a_509_392##2	VPWR#10	5.48502e-17
C348	a_992_122##2	A3#1	8.13506e-19
C349	X	a_83_283##2	5.45068e-20
C350	a_83_283##3	VPWR#12	3.92955e-17
C351	a_83_283##3	X#6	7.22142e-17
C352	B2#6	A2#1	2.38781e-17
C353	a_83_283##9	a_83_283##7	4.61318e-17
C354	VGND#8	A3#5	3.31083e-17
C355	a_83_283##3	VPWR#13	3.69281e-18
C356	B2#7	B2#6	1.14974e-17
C357	a_83_283##14	B1#5	7.26785e-18
C358	B1#5	B2#6	2.60188e-17
C359	a_992_122#	A2#6	2.16635e-19
C360	VGND#11	VGND#5	2.21904e-19
C361	B2#6	B1#4	1.34529e-17
C362	a_83_283##4	a_83_283##8	1.5034e-18
C363	a_992_122##2	A3#5	2.77187e-17
C364	B1#3	B2#7	6.55754e-18
C365	A2#5	A3#6	5.14412e-19
C366	a_83_283##11	a_83_283##9	3.68551e-17
C367	B2#6	B2#4	1.19435e-18
C368	VPWR#7	VPWR#6	1.07949e-18
C369	A1#8	B2#7	2.85817e-19
C370	VGND#6	X#3	1.003e-17
C371	B1#3	B1#5	2.98664e-18
C372	a_83_283##13	A3#1	4.25804e-19
C373	A2#5	A3#7	7.72252e-19
C374	VGND#8	A2#6	1.02539e-18
C375	a_83_283#	B2#6	2.60301e-19
C376	A2#5	A2#4	5.68268e-18
C377	A3	a_992_122#	5.90437e-17
C378	VPWR#5	B1#1	4.47948e-18
C379	a_83_283##12	a_83_283##11	4.64339e-17
C380	A3	VGND#8	4.78967e-18
C381	A2#5	A1#1	1.77868e-17
C382	a_992_122##2	A3	2.08715e-17
C383	a_992_122##2	A2#6	4.38038e-17
C384	VPWR#5	B1#6	4.48079e-18
C385	A2#5	A1#6	3.09812e-20
C386	a_83_283##13	A3#5	4.67342e-19
C387	VPWR#5	B2#1	4.4496e-18
C388	VPWR#11	VPWR#10	4.17329e-18
C389	a_1079_122#	A1#2	6.7737e-20
C390	A2#5	A2#3	3.00865e-21
C391	VGND#7	VGND#6	1.73359e-18
C392	B1	a_83_283##16	4.66909e-17
C393	A2#6	a_1079_122#	1.5029e-17
C394	B1	a_83_283##15	2.49824e-17
C395	B1	a_83_283##14	1.58837e-17
C396	a_992_122##2	A1#4	1.43855e-17
C397	A2#2	A1#6	2.16619e-19
C398	A3#4	A3#3	2.95489e-18
C399	A1	a_83_283##13	2.05447e-17
C400	a_509_392##5	VPWR#10	1.09874e-19
C401	A2	a_509_392##4	4.1127e-17
C402	a_83_283##13	A2#6	1.46763e-18
C403	B2#5	A2#2	2.67319e-17
C404	VGND#5	B2	2.75005e-17
C405	a_1079_122#	A1#4	3.65972e-17
C406	A3	a_509_392#	5.42254e-17
C407	A3	VPWR#9	3.85703e-18
C408	a_83_283##15	A2	1.4632e-17
C409	a_1079_122##2	A2#6	1.90524e-19
C410	A3	a_509_392##2	3.03748e-17
C411	a_83_283##14	A2	4.55017e-17
C412	B2#6	B2#5	1.62591e-18
C413	a_992_122##2	A1#5	2.06164e-19
C414	a_509_392##4	A1#2	1.04191e-19
C415	A2	A1#8	4.33185e-17
C416	a_83_283##13	A1#4	3.07182e-17
C417	B1#3	B2#5	8.6607e-18
C418	a_992_122##4	A2#6	1.36568e-19
C419	a_83_283##13	A1#2	3.91337e-19
C420	a_1079_122#	A1#5	4.33532e-19
C421	B1	a_83_283##18	2.00751e-17
C422	a_509_392##5	VPWR#11	4.18975e-17
C423	a_587_110##2	B1	2.4736e-17
C424	B1#6	B1#3	6.55992e-19
C425	a_1079_122##2	A1#4	4.33532e-19
C426	B2	a_83_283##16	3.64774e-17
C427	A1	a_509_392##7	2.26047e-18
C428	a_992_122##2	A2#1	1.2407e-19
C429	B2	a_83_283##14	4.06413e-19
C430	B2#1	B1#3	6.76925e-19
C431	a_83_283##13	A2	3.8497e-17
C432	VPWR#4	A2#4	1.11007e-19
C433	a_83_283##13	A1#5	3.45739e-17
C434	A2#5	A3#4	3.91562e-17
C435	a_992_122##4	A1#4	2.06164e-19
C436	a_1079_122#	A2#1	1.89459e-19
C437	VPWR#3	A2#4	1.45853e-18
C438	a_83_283##7	B2#3	1.80688e-18
C439	a_1079_122##2	A1#5	2.76637e-17
C440	a_83_283##3	B2#1	1.01533e-19
C441	A1#2	A2#5	4.34106e-17
C442	a_83_283##3	a_83_283##7	6.56849e-18
C443	A2#5	A3#3	1.56276e-19
C444	a_83_283##13	A2#1	2.44648e-17
C445	A3#4	VNB	1.75568e-17
C446	a_83_283##3	a_83_283##9	8.93015e-19
C447	A1#2	VNB	2.40941e-17
C448	VPWR#4	VPWR#3	1.00802e-18
C449	a_83_283##5	VNB	2.94482e-17
C450	VPWR	VPWR#7	6.64494e-17
C451	a_83_283##4	VNB	2.31106e-17
C452	a_83_283##2	VNB	2.32359e-17
C453	a_83_283##3	a_83_283##11	1.42974e-19
C454	a_992_122##4	A1#5	1.07311e-17
C455	VPWR	VPWR#6	6.77056e-17
C456	VPWR#4	A1#1	6.12069e-19
C457	B2	a_83_283##18	2.9941e-18
C458	VPWR	VPWR#4	1.17157e-16
C459	B2	a_587_110##2	5.5139e-17
C460	VPWR	VPWR#3	4.49234e-17
C461	B2	VGND#10	8.85439e-17
C462	A2	VPWR#11	6.22686e-19
C463	a_83_283##3	a_83_283##12	1.54995e-19
C464	X#2	X	1.85149e-18
C465	A2	a_509_392##5	6.8276e-17
C466	A2#5	A1#3	1.70795e-18
C467	a_83_283##5	a_83_283##4	8.83352e-19
C468	VPWR	a_509_392##8	3.3187e-17
C469	VGND#4	B2#6	8.11957e-17
C470	a_509_392##4	A3#7	1.92612e-19
C471	a_1079_122##2	A2#1	2.61188e-17
C472	VPWR	a_509_392##4	1.94337e-17
C473	VPWR#5	B1#3	7.31413e-20
C474	VPWR#3	A1#1	9.53551e-19
C475	A2#5	A2#2	1.88919e-19
C476	a_509_392##9	a_509_392##5	3.91997e-18
C477	VGND#4	B1#3	9.31831e-20
C478	a_83_283##13	B2#7	2.42289e-19
C479	VPWR	a_83_283##16	1.32991e-17
C480	A2#2	A1#3	3.07826e-17
C481	VPWR	a_83_283##15	1.19819e-17
C482	VGND#4	B2#3	1.41304e-20
C483	A2#1	a_992_122##4	2.37045e-17
C484	VPWR	A1#8	1.1088e-18
C485	VGND	VGND#6	7.17444e-17
C486	B1	B2#7	3.31811e-19
C487	VGND	VGND#5	8.57602e-17
C488	VGND	VGND#3	1.2175e-16
C489	VPWR	X#4	2.5833e-18
C490	VPWR#4	A1#6	5.23517e-18
C491	VGND#7	VPWR#8	2.62231e-19
C492	X	VGND#7	3.05877e-17
C493	B2	a_509_392##10	3.7938e-18
C494	a_509_392##4	A2#4	7.62544e-19
C495	VGND#9	A2#1	8.03944e-19
C496	A1#3	A1#2	3.64339e-18
C497	a_83_283##13	B1#5	2.69171e-19
C498	B2#6	B1#3	7.9541e-19
C499	VGND	a_83_283##14	8.99774e-18
C500	B2#6	B2#3	1.43284e-19
C501	VGND	A1#8	1.2841e-18
C502	VGND#3	B2#5	1.19358e-19
C503	B2#3	B1#3	3.22277e-17
C504	VGND	X#4	3.92218e-18
C505	B2	B2#7	3.31668e-20
C506	VGND	X#2	2.53455e-18
C507	VPWR	a_509_392##2	1.46745e-18
C508	B2	B1#5	4.00608e-19
C509	VGND#6	VNB	3.76828e-17
C510	VPWR	VPWR#10	1.92685e-17
C511	X	VPWR#8	2.74362e-17
C512	a_83_283##3	B1#3	2.12509e-19
C513	X#2	X#4	2.29014e-17
C514	VGND#5	VNB	3.67036e-17
C515	B2	B1#4	9.74876e-19
C516	VGND	a_992_122##2	1.82606e-17
C517	VGND#3	VNB	6.38419e-17
C518	B2#7	VGND#9	1.03438e-17
C519	VGND	a_1079_122#	1.0409e-17
C520	B2	B2#4	3.37572e-17
C521	a_992_122##4	A1#2	4.86715e-20
C522	VPWR#7	VNB	3.43958e-17
C523	VGND	a_83_283##13	7.78764e-18
C524	VPWR#4	A2#3	7.5577e-18
C525	VPWR#6	VNB	3.64095e-17
C526	VPWR	a_509_392##5	2.65521e-17
C527	VGND	a_1079_122##2	8.84253e-18
C528	B2	a_83_283#	1.32602e-18
C529	VPWR#4	VNB	5.09671e-17
C530	B1	B2#5	1.77207e-19
C531	a_83_283##3	B2#3	5.15203e-18
C532	VGND	a_992_122##4	3.41858e-17
C533	VPWR#3	VNB	3.10712e-17
C534	VGND	VGND#9	2.99346e-18
C535	B2	a_83_283##8	8.72991e-20
C536	A2	A2#4	1.93476e-20
C537	VGND	a_587_110#	6.44879e-18
C538	a_509_392##8	VNB	6.02147e-18
C539	a_509_392##4	A1#1	2.40912e-17
C540	VGND	a_83_283##18	2.38562e-18
C541	A2	A1#1	2.4567e-20
C542	VPWR	a_509_392##10	2.52613e-17
C543	VGND	a_587_110##2	1.14631e-17
C544	VPWR	VPWR#12	2.12306e-17
C545	A2	A1#6	1.41582e-17
C546	VGND	X#1	1.75829e-17
C547	VPWR	X#6	1.69436e-17
C548	VGND	VGND#11	2.26929e-17
C549	A2	A2#3	5.13584e-18
C550	VPWR	VPWR#13	2.10976e-17
C551	VGND	X#3	1.31984e-17
C552	a_83_283##16	VNB	5.60652e-18
C553	VPWR	X#5	1.43371e-17
C554	VGND	VGND#7	6.03426e-17
C555	A2	B2#5	3.16533e-17
C556	a_83_283##15	VNB	1.81939e-18
C557	a_83_283##14	VNB	4.85635e-18
C558	VPWR	VPWR#8	5.52687e-17
C559	a_587_110#	B2#7	2.24733e-17
C560	X	a_83_283#	6.02443e-20
C561	A1#8	VNB	2.79785e-19
C562	X	a_83_283##8	9.16794e-20
C563	X#4	VNB	3.53811e-18
C564	X	a_83_283##6	6.97085e-18
C565	A3	A3#3	2.92057e-17
C566	a_587_110##2	A2#1	3.17141e-19
C567	a_992_122#	VNB	3.91547e-17
C568	VGND#8	VNB	8.80418e-18
C569	VGND#9	B1#5	1.0902e-19
C570	a_992_122##2	VNB	2.0087e-17
C571	a_1079_122#	VNB	3.49572e-18
C572	A2#5	A3	2.69049e-17
C573	a_83_283##13	VNB	5.08556e-18
C574	a_1079_122##2	VNB	3.83265e-19
C575	a_509_392##10	a_509_392##9	4.30643e-18
C576	a_992_122##4	VNB	2.51784e-17
C577	a_587_110##2	VNB	9.53136e-19
C578	a_509_392##8	VPWR#4	3.44306e-18
C579	A1#8	a_83_283##13	2.9351e-17
C580	VGND#10	VNB	4.49084e-18
C581	VGND	VPWR#8	1.31916e-18
C582	A1	A2#5	4.03367e-17
C583	B2	a_83_283##7	3.33389e-19
C584	X#1	VNB	2.23256e-18
C585	VGND#11	VNB	3.4497e-18
C586	VPWR#4	B2#5	5.11212e-18
C587	X#3	VNB	5.93021e-18
C588	A1	A1#3	3.48847e-18
C589	VGND#7	VNB	5.04018e-17
C590	a_509_392#	VNB	5.08325e-17
C591	X#2	a_83_283##10	2.18416e-17
C592	VPWR#9	VNB	3.2655e-18
C593	a_509_392##4	A1#6	3.28558e-17
C594	a_509_392##2	VNB	6.33998e-18
C595	a_587_110#	B1#5	2.88151e-17
C596	VPWR#10	VNB	9.90052e-19
C597	VGND	B2#7	1.20362e-18
C598	VPWR#11	VNB	3.0497e-18
C599	VPWR	A2#4	5.13446e-21
C600	a_509_392##5	VNB	4.51903e-18
C601	VPWR	A1#1	1.59095e-19
C602	a_83_283##14	VGND#9	5.19093e-17
C603	VGND	B2#4	1.74073e-20
C604	VPWR	A1#6	4.42899e-20
C605	VGND	a_83_283#	8.64553e-18
C606	a_509_392##10	VNB	1.25885e-17
C607	VPWR	A2#3	9.05555e-19
C608	a_587_110##2	B2#7	7.95259e-19
C609	VPWR#12	VNB	8.50216e-18
C610	VGND	a_83_283##8	9.0023e-18
C611	A2	A2#5	1.53502e-18
C612	a_509_392##10	a_83_283##20	7.06526e-19
C613	VPWR	B2#5	4.17187e-18
C614	X#6	VNB	2.4748e-18
C615	VGND	a_83_283##10	3.37354e-18
C616	VPWR#13	VNB	7.63749e-19
C617	VPWR	B1#1	1.61503e-18
C618	VGND#9	B1#4	1.53173e-19
C619	VGND	a_83_283##6	3.37354e-18
C620	A2	A1#3	5.30957e-18
C621	X#5	VNB	2.25687e-18
C622	VGND#4	B2	4.48253e-18
C623	VPWR#8	VNB	7.92474e-17
C624	VPWR	B1#6	1.57527e-18
C625	B1	B1#3	2.44816e-17
C626	A3#1	VNB	3.88585e-17
C627	A2	A2#2	2.09565e-17
C628	VPWR	B2#1	2.01172e-18
C629	A3#5	VNB	2.53004e-17
C630	A2#6	VNB	2.72447e-17
C631	B1	B2#3	1.05166e-17
C632	VPWR	a_83_283##7	3.06102e-18
C633	A1#4	VNB	3.00968e-17
C634	A2	B2#6	5.47545e-19
C635	A1#5	VNB	2.89339e-17
C636	VPWR	a_83_283##9	2.03382e-19
C637	a_83_283##18	B1#5	2.16008e-17
C638	A2#1	VNB	2.8503e-17
C639	VPWR	a_83_283##11	1.07898e-18
C640	A2	B1#3	4.03783e-18
C641	A2#4	A3#4	1.71475e-19
C642	B2#7	VNB	3.15585e-17
C643	B1#5	VNB	2.83244e-17
C644	VPWR	a_83_283##12	3.61039e-18
C645	B1#4	VNB	3.14161e-17
C646	B2#4	VNB	3.37556e-17
C647	a_83_283#	VNB	3.09333e-17
C648	B2	B2#6	2.2786e-18
C649	a_83_283##8	VNB	2.99693e-17
C650	a_83_283##10	VNB	2.38531e-17
C651	B2	B1#3	1.35235e-18
C652	a_83_283##6	VNB	3.35682e-17
C653	VPWR	VPWR#5	8.1092e-17
C654	B2	B2#3	2.53543e-17
C655	X#2	a_83_283##6	1.19339e-17
C656	A3#6	VNB	3.65236e-17
C657	A3#7	VNB	2.96744e-17
C658	A2#4	VNB	2.7847e-17
C659	a_83_283##3	B2	2.60925e-17
C660	A1#1	VNB	2.68009e-17
C661	A1#6	VNB	2.93851e-17
C662	VPWR	A2#5	5.03941e-18
C663	VPWR#4	B1#1	1.03985e-19
C664	A2#3	VNB	3.23212e-17
C665	B2#5	VNB	7.55735e-17
C666	a_509_392##4	A2#3	5.59004e-19
C667	a_587_110##2	B1#5	2.55661e-18
C668	B1#1	VNB	3.07014e-17
C669	B1#6	VNB	3.13167e-17
C670	X	a_83_283##3	2.52049e-18
C671	B2#1	VNB	3.50588e-17
C672	VGND	VGND#4	5.97009e-17
C673	a_83_283##7	VNB	3.35382e-17
C674	a_83_283##14	a_587_110#	3.14559e-17
C675	VGND#9	B2#4	1.9532e-20
C676	VPWR	B1#3	5.41229e-19
C677	a_83_283##9	VNB	2.94307e-17
C678	a_83_283##11	VNB	2.99271e-17
C679	VGND	A2#5	3.0726e-18
C680	a_83_283##12	VNB	3.84398e-17
C681	VPWR	a_83_283##3	1.15342e-17
C682	VGND	B2#6	5.22059e-17
C683	a_83_283##18	a_83_283##15	1.3763e-18
C684	B1#4	a_83_283##18	1.80956e-17
C685	VPWR#5	VNB	4.82869e-17
C686	a_509_392##8	B2#5	7.28364e-18
C687	VGND	B1#3	8.58119e-19
C688	VGND#4	VNB	3.69828e-17
C689	VGND	B2#3	9.8107e-19
C690	A1#2	A2#4	1.44175e-19
C691	A3#3	VNB	6.7209e-17
C692	A2#5	VNB	3.98574e-17
C693	VGND	a_83_283##3	9.04696e-18
C694	A1#3	VNB	3.5216e-17
C695	A2#2	VNB	3.78755e-17
C696	a_587_110##2	a_83_283##16	2.5292e-18
C697	B2#6	VNB	1.14603e-16
C698	B2	B1	2.9191e-17
C699	VPWR#12	a_509_392##10	5.82114e-17
C700	B1#3	VNB	5.92944e-17
C701	B2#3	VNB	5.09835e-17
C702	a_83_283##3	VNB	2.8965e-17
C703	a_509_392##2	VPWR#3	9.04681e-18
C704	VPWR	A1	1.05915e-18
C705	VPWR	B1	2.80423e-18
C706	VGND	A1	1.12574e-18
C707	VPWR	A2	8.48478e-18
C708	VGND	B1	3.02217e-18
C709	VPWR	B2	2.51561e-18
C710	A3	VNB	2.1396e-17
C711	VGND	A2	6.92743e-18
C712	a_587_110##2	B1#4	4.45081e-17
C713	A1	VNB	8.63001e-19
C714	VPWR	X	2.52126e-18
C715	VGND	B2	1.35398e-17
C716	B1	VNB	7.85603e-19
C717	A2	VNB	1.12551e-17
C718	VGND	X	4.30747e-18
C719	B2	VNB	1.14559e-17
C720	X	VNB	3.84128e-17
C721	VPWR	VNB	2.92887e-16
C722	a_509_392##4	VPWR#4	6.65774e-18
C723	VGND	VNB	3.06593e-16
C724	VPWR#4	VPWR#10	2.21825e-19
C725	VPWR#4	B1#6	5.70997e-20
C726	a_509_392##4	B2#5	1.47592e-19
C727	a_83_283##18	B2#4	6.42343e-19
C728	VPWR#2	A3	4.01974e-18
C729	VPWR#2	VNB	1.48313e-16
C730	VPWR#2	A2#5	7.30313e-19
C731	VPWR#2	A3#3	2.53582e-20
C732	VPWR#2	A2#4	6.88584e-19
C733	VPWR#2	A3#7	2.72892e-18
C734	VPWR#2	A3#6	3.47834e-18
C735	VGND#2	A3#5	5.3611e-18
C736	VPWR#10	VPWR#2	1.94284e-19
C737	a_509_392##2	VPWR#2	2.63107e-17
C738	VPWR#2	VPWR#9	1.76772e-17
C739	a_509_392#	VPWR#2	3.95619e-17
C740	VPWR#2	VPWR#3	1.65421e-17
C741	VGND#2	A2#6	1.14848e-18
C742	VGND#2	A1#4	1.13825e-18
C743	VGND#2	a_992_122##4	5.39361e-18
C744	VGND#2	A3#3	4.41671e-20
C745	VGND#2	A2#5	7.52652e-19
C746	VGND#2	A1#3	8.45035e-21
C747	VGND#2	A1#2	4.22517e-21
C748	VGND#2	A3	5.20538e-18
C749	VGND	VGND#2	3.51115e-17
C750	VGND#2	a_992_122#	2.56043e-17
C751	VGND#2	VNB	1.87579e-16
C752	VGND#2	a_992_122##2	9.91115e-17
C753	VGND#2	A3#1	1.02097e-17
*
*
.ENDS sky130_fd_sc_hs__a32o_4
*
