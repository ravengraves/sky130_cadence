* Extracted by Quantus, converted by sky130cad/quantus.py
*
*
*
*                       LINUX           Wed Nov 18 08:46:16 2026
*
*
*
*  PROGRAM  advgen
*
*  Name           : advgen - Quantus - (64-bit)
*  Version        : 25.1.0-p047
*  Build Date     : Thu Dec 11 23:20:30 PST 2025
*
*  HSPICE LIBRARY
*
*  OPERATING_TEMPERATURE 150
*  QRC_TECH_DIR <path>/tech
*
*
*

*
.SUBCKT sky130_fd_sc_hs__nand3_4 VPB VNB VGND VPWR Y C A B
*
*
*  caps2d version: 10
*
*
*       TRANSISTOR CARDS
*
*
XM1 Y#7 A#6 a_27_82##5 VNB sky130_fd_pr__nfet_01v8_lvt l=0.15 w=0.74 ad=0.2072 as=0.19525 pd=2.04 ps=2.03
XM2 a_27_82##8 A#9 Y#7 VNB sky130_fd_pr__nfet_01v8_lvt l=0.15 w=0.74 ad=0.2072 as=0.2072 pd=2.04 ps=2.04
XM5 a_27_82##8 A#8 Y#8 VNB sky130_fd_pr__nfet_01v8_lvt l=0.15 w=0.74 ad=0.2072 as=0.2072 pd=2.04 ps=2.04
XM12 Y#8 A#1 a_27_82##7 VNB sky130_fd_pr__nfet_01v8_lvt l=0.15 w=0.74 ad=0.2072 as=0.2072 pd=2.04 ps=2.04
XM9 a_27_82##7 B#11 a_456_82##5 VNB sky130_fd_pr__nfet_01v8_lvt l=0.15 w=0.74 ad=0.2072 as=0.2072 pd=2.04 ps=2.04
XM13 a_456_82##5 B#9 a_27_82##6 VNB sky130_fd_pr__nfet_01v8_lvt l=0.15 w=0.74 ad=0.2072 as=0.2072 pd=2.04 ps=2.04
XM15 a_456_82##3 B#8 a_27_82##6 VNB sky130_fd_pr__nfet_01v8_lvt l=0.15 w=0.74 ad=0.2072 as=0.2072 pd=2.04 ps=2.04
XM6 a_27_82# B#1 a_456_82##3 VNB sky130_fd_pr__nfet_01v8_lvt l=0.15 w=0.74 ad=0.19525 as=0.2072 pd=2.03 ps=2.04
XM7 a_456_82##6 C#7 VGND#6 VNB sky130_fd_pr__nfet_01v8_lvt l=0.15 w=0.74 ad=0.2072 as=0.2035 pd=2.04 ps=2.03
XM11 VGND#5 C#5 a_456_82##6 VNB sky130_fd_pr__nfet_01v8_lvt l=0.15 w=0.74 ad=0.2072 as=0.2072 pd=2.04 ps=2.04
XM16 a_456_82# C#4 VGND#5 VNB sky130_fd_pr__nfet_01v8_lvt l=0.15 w=0.74 ad=0.2072 as=0.2072 pd=2.04 ps=2.04
XM8 VGND#1 C#1 a_456_82# VNB sky130_fd_pr__nfet_01v8_lvt l=0.15 w=0.74 ad=0.2035 as=0.2072 pd=2.03 ps=2.04
XM0 VPWR#5 A#10 Y#3 VPB sky130_fd_pr__pfet_01v8 l=0.15 w=1.12 ad=0.3304 as=0.9184 pd=2.83 ps=3.88
XM10 Y#3 A#7 VPWR#8 VPB sky130_fd_pr__pfet_01v8 l=0.15 w=1.12 ad=0.9184 as=0.392 pd=3.88 ps=2.94
XM3 Y#5 B#7 VPWR#8 VPB sky130_fd_pr__pfet_01v8 l=0.15 w=1.12 ad=0.336 as=0.392 pd=2.84 ps=2.94
XM14 VPWR#7 B#10 Y#5 VPB sky130_fd_pr__pfet_01v8 l=0.15 w=1.12 ad=1.484 as=0.336 pd=4.89 ps=2.84
XM4 VPWR#7 C#9 Y#1 VPB sky130_fd_pr__pfet_01v8 l=0.15 w=1.12 ad=1.484 as=0.336 pd=4.89 ps=2.84
XM17 Y#1 C#10 VPWR#6 VPB sky130_fd_pr__pfet_01v8 l=0.15 w=1.12 ad=0.336 as=1.484 pd=2.84 ps=4.89
*
*
*       RESISTOR AND CAP/DIODE CARDS
*
Rg1	A#1	A#2	415.132324
Rg2	A#2	A#3	19.620436
Rg3	A#3	A#4	36.782627
Rg4	A#4	A#5	55.716167
Rg5	A#5	A#6	320.164062
Rg6	A#2	A#7	420.665405
Rg7	A#3	A#8	289.660583
Rg8	A#4	A#9	314.123260
Rg9	A#5	A#10	467.069489
Rg10	B#1	B#2	415.789917
Rg11	B#2	B#3	30.375311
Rg12	B#3	B#4	30.375311
Rg13	B#4	B#5	27.693617
Rg14	B#5	B#6	31.632906
Rg15	B#6	B#7	486.762024
Rg16	B#2	B#8	351.497711
Rg17	B#4	B#9	351.497711
Rg18	B#5	B#10	388.798737
Rg19	B#6	B#11	347.624908
Rg20	C#1	C#2	421.761841
Rg21	C#2	C#3	63.826347
Rg22	C#2	C#4	342.058960
Rg23	C#3	C#5	348.334229
Rg24	C#3	C#6	89.967590
Rg25	C#6	C#7	359.320251
Rg26	C#6	C#8	21.767113
Rg27	C#8	C#9	512.670593
Rg28	C#8	C#10	423.996338
Rf1	A#11	A	0.997598
Rf2	A#4	A#13	54.408531
Rf3	A#11	A#13	9.473685
Rf4	A#14	A	0.997598
Rf5	A#13	A#14	5.195247
Rf6	B#3	B	48.309475
Rf7	a_27_82#	a_27_82##2	86.017212
Rf8	a_27_82##2	a_27_82##3	63.004017
Rf9	a_27_82##3	a_27_82##4	63.019512
Rf10	a_27_82##4	a_27_82##5	89.565117
Rf11	a_27_82##2	a_27_82##6	25.151917
Rf12	a_27_82##3	a_27_82##7	34.515343
Rf13	a_27_82##4	a_27_82##8	29.962008
Rf14	Y#1	Y#2	152.095474
Rf15	Y#2	Y#4	65.757149
Rf16	Y#4	Y	47.623798
Rf17	Y#2	Y#5	16.043533
Rf18	Y	Y#6	39.276531
Rf19	Y#6	Y#7	13.819461
Rf20	Y#6	Y#8	73.402428
Rf21	Y#3	Y#4	2.500000
Rf22	a_456_82#	a_456_82##2	65.492065
Rf23	a_456_82##2	a_456_82##4	66.975212
Rf24	a_456_82##4	a_456_82##5	42.231007
Rf25	a_456_82##2	a_456_82##6	19.086887
Rf26	a_456_82##3	a_456_82##4	7.500000
Rf27	C#3	C	33.690598
Rf28	VGND#1	VGND#2	94.023415
Rf29	VGND#2	VGND#3	62.774361
Rf30	VGND#3	VGND#4	82.522530
Rf31	VGND#2	VGND#5	34.704330
Rf32	VGND#3	VGND#6	34.704330
Rf34	VPWR#2	VPWR#3	151.532578
Rf35	VPWR#3	VPWR#4	107.980621
Rf36	VPWR#4	VPWR#5	134.323151
Rf37	VPWR#2	VPWR#6	9.315102
Rf38	VPWR#3	VPWR#7	9.976208
Rf39	VPWR#4	VPWR#8	31.534731
Re1	VPWR#3	VPWR	0.755546
Re2	VGND	VGND#4	0.755573
*
*       CAPACITOR CARDS
*
*
C1	VGND#3	a_456_82##6	5.00413e-18
C2	VGND#2	a_456_82##6	4.96109e-18
C3	a_27_82##7	B#6	3.0598e-19
C4	VGND#3	a_27_82#	1.89883e-17
C5	VGND#2	C#2	9.42779e-20
C6	a_456_82##2	VGND#5	1.80603e-17
C7	C#9	C#8	1.33666e-18
C8	a_456_82##2	a_456_82##6	3.18435e-19
C9	VGND#3	a_456_82##3	1.64068e-18
C10	a_456_82##2	VGND#6	3.57401e-17
C11	Y#8	A#3	5.95327e-18
C12	a_456_82##2	C#8	7.6715e-18
C13	A#3	B#7	1.10817e-17
C14	a_27_82##2	a_456_82##3	1.82333e-17
C15	Y#6	Y#8	3.22697e-18
C16	a_456_82#	VGND#1	6.64093e-17
C17	C#8	VPWR#6	5.8875e-19
C18	a_27_82##7	Y#2	9.14005e-18
C19	a_27_82##2	a_27_82##6	2.02429e-19
C20	a_27_82##3	a_456_82##5	1.47135e-17
C21	VGND#5	VGND#1	3.48007e-18
C22	Y#6	a_27_82##8	3.09113e-17
C23	VPWR#4	VPWR#7	1.02334e-18
C24	a_27_82##4	a_27_82##7	6.25631e-19
C25	Y#8	Y#2	2.56924e-18
C26	C#2	VPWR#6	1.46697e-18
C27	a_27_82##2	a_456_82##5	1.63547e-17
C28	a_456_82#	VGND#5	4.34672e-17
C29	a_27_82##3	a_27_82##7	1.64139e-19
C30	a_27_82##4	Y#8	1.60531e-17
C31	Y#5	VPWR#4	8.51154e-18
C32	a_27_82##5	A#5	7.29062e-20
C33	a_456_82##6	a_456_82#	3.25746e-18
C34	Y#1	C#8	5.19679e-18
C35	a_27_82##3	Y#8	1.50724e-17
C36	Y#6	a_27_82##5	3.28164e-17
C37	a_27_82##4	a_27_82##8	7.02865e-19
C38	a_456_82##6	VGND#5	3.32474e-17
C39	a_27_82##4	Y#7	4.75615e-19
C40	VGND#6	VGND#5	3.48007e-18
C41	a_456_82##2	Y#1	3.65844e-18
C42	Y#3	VPWR#4	2.62665e-17
C43	VGND#6	a_456_82##6	3.32325e-17
C44	VPWR#7	C#8	2.27145e-20
C45	VPWR#5	VPWR#4	4.60988e-19
C46	Y#6	A#5	3.1124e-18
C47	Y#2	Y#1	6.02465e-19
C48	a_27_82#	VGND#6	4.02684e-17
C49	a_456_82##3	a_456_82##6	1.9758e-18
C50	Y#2	B#6	4.65578e-18
C51	VPWR#7	B#6	2.98745e-20
C52	Y#2	VPWR#7	6.6475e-17
C53	Y#2	B#5	1.93039e-18
C54	B#5	VPWR#7	1.82535e-18
C55	a_27_82#	a_456_82##3	6.24883e-17
C56	Y#2	Y#5	2.68731e-19
C57	a_27_82##6	a_27_82#	3.3625e-18
C58	VGND#2	C#1	2.37574e-18
C59	Y#6	Y#3	2.16017e-18
C60	Y#2	VPWR#8	1.82084e-17
C61	a_456_82##3	a_27_82##6	2.65859e-17
C62	VGND#4	B#6	2.38828e-21
C63	VGND#2	C#4	1.15276e-18
C64	VGND#4	B#5	3.72418e-20
C65	a_456_82##5	a_456_82##3	3.22697e-18
C66	VGND#4	A#5	5.91791e-20
C67	VGND#4	A#3	1.01166e-19
C68	VGND#2	C#5	8.90773e-19
C69	a_456_82##5	a_27_82##6	2.58437e-17
C70	C#3	C#8	3.24104e-17
C71	VGND#3	C#7	8.90773e-19
C72	a_27_82##7	a_27_82##6	3.20225e-18
C73	C#3	C#2	2.1006e-17
C74	B#6	B#5	2.11554e-18
C75	a_27_82##3	B#5	2.0192e-19
C76	a_456_82##2	C#5	1.94705e-17
C77	a_27_82##7	a_456_82##5	4.97251e-17
C78	a_27_82##4	A#5	1.82928e-19
C79	a_456_82##2	C#7	2.25745e-17
C80	a_27_82##4	A#3	1.53053e-19
C81	Y#8	a_27_82##7	4.77829e-17
C82	A#13	Y#3	2.30798e-17
C83	B#3	B#6	1.51611e-17
C84	a_27_82##8	a_27_82##7	2.53488e-18
C85	VPWR#8	A#3	1.7755e-19
C86	a_27_82##2	B#5	1.71326e-19
C87	B#3	B#5	1.92887e-17
C88	Y#8	a_27_82##8	3.06429e-17
C89	B#3	A#3	3.07253e-18
C90	a_456_82##3	Y#1	8.17079e-18
C91	a_27_82##3	A#3	2.08534e-19
C92	A#5	Y#3	1.27503e-18
C93	VGND#1	C#1	3.83726e-17
C94	A#3	Y#3	2.68008e-18
C95	a_27_82##5	a_27_82##8	2.6177e-18
C96	C#1	a_456_82#	1.69574e-17
C97	VGND#1	C#4	2.9392e-18
C98	VGND#5	C#1	2.36891e-18
C99	a_27_82##5	Y#7	1.71643e-19
C100	a_456_82#	C#4	3.44368e-17
C101	a_27_82##2	B#8	7.52191e-18
C102	C#2	C#1	1.82026e-18
C103	a_456_82##6	C#1	6.02588e-19
C104	VPWR#5	A#5	1.71836e-20
C105	VGND#5	C#4	3.36097e-17
C106	a_456_82#	C#5	5.79938e-19
C107	a_27_82##2	B#9	7.44494e-18
C108	a_27_82##4	B#11	4.8148e-20
C109	a_456_82##6	C#4	1.0673e-18
C110	VGND#5	C#5	2.99034e-17
C111	a_27_82##3	B#11	9.89894e-18
C112	Y#2	A#1	2.13067e-18
C113	a_456_82#	C#7	2.44406e-19
C114	Y#6	A#8	1.42087e-18
C115	C#5	a_456_82##6	1.59203e-17
C116	a_27_82##4	A#1	1.14138e-19
C117	VGND#5	C#7	2.12265e-18
C118	VGND#6	C#5	1.68073e-18
C119	a_27_82##3	A#1	1.00385e-17
C120	Y#8	Y#3	3.87088e-18
C121	C#7	a_456_82##6	1.9056e-17
C122	Y#6	A#9	2.55544e-17
C123	a_27_82##4	A#8	8.62358e-18
C124	VGND#6	C#7	4.68796e-17
C125	a_456_82##3	C#5	1.77205e-19
C126	a_456_82##6	B#1	5.00227e-19
C127	A#3	B#6	2.39324e-18
C128	Y#1	VPWR#7	1.3351e-16
C129	a_27_82#	C#7	1.17535e-18
C130	Y#6	A#6	2.9945e-17
C131	a_27_82##4	A#9	7.99343e-18
C132	VGND#6	B#1	9.91591e-19
C133	a_456_82##3	C#7	6.35505e-19
C134	Y#5	Y#1	1.09318e-18
C135	a_27_82#	B#1	2.97416e-17
C136	a_27_82##6	C#7	8.30528e-20
C137	Y#5	VPWR#7	7.5127e-17
C138	a_456_82##3	B#1	4.80912e-17
C139	a_27_82##5	VPWR#5	1.65865e-19
C140	VGND#3	C#9	2.47876e-19
C141	a_27_82#	B#8	6.38452e-19
C142	a_27_82##6	B#1	1.03631e-18
C143	VPWR#8	VPWR#7	2.16015e-18
C144	a_456_82##3	B#8	4.2721e-17
C145	a_27_82#	B#9	2.75131e-19
C146	VPWR#8	Y#5	6.22435e-17
C147	B#8	a_27_82##6	1.59178e-17
C148	C#1	VPWR#6	3.72875e-19
C149	VPWR#4	B#7	2.59756e-18
C150	a_456_82##3	B#9	1.14792e-18
C151	a_456_82##2	C#9	7.70871e-19
C152	a_456_82##5	B#8	9.17952e-19
C153	Y#3	Y#5	3.12884e-18
C154	Y#8	B#1	2.42222e-19
C155	B#9	a_27_82##6	1.76433e-17
C156	a_27_82##7	B#8	2.40264e-19
C157	Y#3	VPWR#8	8.12124e-17
C158	a_456_82##5	B#9	4.47315e-17
C159	Y#2	C#9	7.15024e-19
C160	VPWR#4	A#7	9.77087e-19
C161	Y#8	B#8	2.74463e-19
C162	a_27_82##6	B#11	6.01325e-19
C163	VPWR#5	VPWR#8	6.75516e-19
C164	a_27_82##7	B#9	5.70108e-19
C165	B	C#8	1.54088e-19
C166	a_456_82##5	B#11	3.30147e-17
C167	Y#8	B#9	5.05984e-19
C168	Y#3	VPWR#5	1.13479e-16
C169	a_27_82##6	A#1	2.50969e-19
C170	Y#2	B#10	2.97067e-17
C171	B#11	a_27_82##7	1.48292e-17
C172	a_456_82##5	A#1	1.30108e-18
C173	B#1	C#8	4.8683e-19
C174	Y#8	B#11	1.93143e-18
C175	A#1	a_27_82##7	1.87097e-17
C176	Y#1	B#1	3.54888e-18
C177	a_27_82##8	B#11	1.95082e-19
C178	Y#2	B#7	2.59318e-17
C179	Y#8	A#1	3.61696e-17
C180	B#1	VPWR#7	3.14167e-18
C181	a_27_82##7	A#8	5.76596e-19
C182	a_27_82##8	A#1	4.62457e-19
C183	Y#8	A#8	3.73378e-17
C184	Y#2	A#7	1.24902e-18
C185	C#4	C#1	4.03365e-17
C186	a_27_82##7	A#9	2.4323e-19
C187	A	B#6	2.34651e-18
C188	A#8	a_27_82##8	1.49741e-17
C189	VPWR#3	VPWR#4	5.38261e-17
C190	VGND#3	VGND#2	1.96834e-18
C191	Y#8	A#9	1.0807e-18
C192	A	A#5	1.22608e-17
C193	A	A#3	1.9666e-17
C194	Y#2	A#10	5.6356e-19
C195	A#9	a_27_82##8	1.71767e-17
C196	a_456_82#	C#2	4.76596e-18
C197	a_27_82##5	A#8	2.1825e-19
C198	C#5	C#4	3.88199e-17
C199	A#9	Y#7	1.46487e-17
C200	a_27_82##8	A#6	9.75171e-19
C201	a_27_82#	C#9	9.0005e-19
C202	a_27_82##5	A#9	9.8656e-19
C203	a_456_82##3	C#9	6.97509e-18
C204	A#6	Y#7	1.51359e-17
C205	C#7	C#5	3.98344e-17
C206	VGND#4	VGND#3	4.173e-17
C207	a_27_82##5	A#6	2.47825e-17
C208	VGND#4	VGND#2	4.08219e-17
C209	A#5	A#3	1.33911e-19
C210	VPWR#8	A#1	9.26864e-19
C211	Y#3	A#1	4.03084e-19
C212	B#1	C#7	3.75422e-18
C213	VGND#5	C#2	1.52216e-20
C214	VGND#2	C#3	3.60339e-19
C215	VGND#3	a_456_82##2	2.76158e-19
C216	Y#2	VPWR#4	1.6661e-19
C217	VGND#4	a_27_82##4	6.69879e-17
C218	C#10	VPWR#6	3.96124e-18
C219	B#8	B#1	3.82049e-17
C220	a_456_82##2	C#3	9.61078e-17
C221	VGND#4	a_27_82##3	6.28913e-17
C222	Y#1	C#10	5.66515e-17
C223	a_27_82##7	B#7	3.20723e-18
C224	VGND#4	a_27_82##2	6.54169e-17
C225	VGND#2	a_456_82##2	2.64438e-19
C226	VPWR#7	C#10	1.18717e-18
C227	VPWR#4	A#4	1.15886e-19
C228	B#9	B#8	3.99788e-17
C229	Y	B#6	1.65099e-19
C230	Y#1	C#9	7.95051e-17
C231	Y	A#5	2.01409e-17
C232	C#9	VPWR#7	4.16491e-17
C233	Y#1	B#10	1.06281e-18
C234	Y#5	C#9	3.47785e-19
C235	B#3	Y#2	8.43206e-17
C236	B#11	B#9	3.81679e-17
C237	VGND#4	VGND#1	2.57523e-17
C238	B#10	VPWR#7	4.80769e-17
C239	VPWR#8	C#9	6.75973e-20
C240	a_27_82##3	B#3	2.65334e-18
C241	Y#5	B#10	5.42015e-17
C242	Y#6	A#4	3.87572e-18
C243	a_27_82##2	B#3	2.14157e-19
C244	VPWR#7	B#7	6.21076e-19
C245	VPWR#8	B#10	1.33738e-18
C246	VGND#6	C#8	1.45536e-18
C247	VGND#1	C#3	3.74034e-17
C248	A#1	B#11	4.08963e-17
C249	Y#5	B#7	4.65296e-17
C250	a_27_82##4	A#4	1.63045e-19
C251	C#3	a_456_82#	5.30086e-17
C252	VGND#4	a_27_82#	2.47983e-17
C253	C#3	VGND#5	3.2266e-18
C254	VPWR#7	A#7	2.66736e-19
C255	B#7	VPWR#8	2.67117e-17
C256	C#3	a_456_82##6	2.51339e-18
C257	Y#5	A#7	2.03339e-18
C258	Y#3	B#7	9.38695e-19
C259	A#8	A#1	3.61337e-17
C260	C#3	VGND#6	3.01395e-18
C261	VPWR#8	A#7	4.96501e-17
C262	A#13	A#4	1.16232e-17
C263	Y#3	A#7	5.27627e-17
C264	Y#5	A#10	1.71853e-19
C265	VPWR#8	A#10	1.15247e-18
C266	VPWR#5	A#7	1.11452e-18
C267	B#1	C#9	2.91665e-17
C268	A#9	A#8	3.70443e-17
C269	a_27_82#	B#3	1.5093e-19
C270	Y#3	A#10	6.34296e-17
C271	a_456_82##3	B#3	1.88355e-17
C272	VPWR#5	A#10	3.9299e-17
C273	VGND#4	a_27_82##5	4.68235e-17
C274	B#3	a_27_82##6	4.495e-18
C275	VPWR#3	VPWR#7	7.94637e-17
C276	A#6	A#9	3.61179e-17
C277	B#3	a_456_82##5	6.04533e-17
C278	A#1	B#6	1.08956e-17
C279	VGND	C#2	9.54175e-20
C280	C#3	VPWR#6	1.65014e-18
C281	VPWR#3	VPWR#5	3.80644e-17
C282	C#3	Y#1	2.05773e-17
C283	VGND	A#3	1.00512e-18
C284	Y#8	A#4	2.18016e-18
C285	a_27_82##8	A#4	1.54142e-18
C286	B	Y#2	1.66948e-17
C287	Y#1	B#3	2.13739e-18
C288	VGND#4	C#1	3.61871e-20
C289	B#3	VPWR#7	8.17726e-18
C290	VGND#4	C#4	3.61871e-20
C291	VGND#4	C#5	3.61871e-20
C292	C#3	C#1	1.76648e-17
C293	Y#6	A	3.34989e-17
C294	C#9	C#10	4.57226e-17
C295	VGND#4	C#7	3.61871e-20
C296	VGND#4	B#1	4.02408e-18
C297	VGND#4	B#8	4.00844e-18
C298	A#4	Y#3	1.09922e-17
C299	B#10	C#9	1.81962e-18
C300	C#8	VNB	4.58301e-17
C301	C#2	VNB	2.43704e-17
C302	VGND#4	B#9	4.00844e-18
C303	B#6	VNB	2.20879e-17
C304	C#3	B#1	5.54394e-18
C305	VPWR#5	A#4	5.62346e-20
C306	B#5	VNB	2.71762e-17
C307	A#5	VNB	3.66768e-17
C308	A#3	VNB	3.05841e-17
C309	VGND#4	B#11	4.00844e-18
C310	B	a_456_82##3	6.13484e-17
C311	VGND#4	A#1	3.99592e-18
C312	B#3	B#1	2.11554e-18
C313	B#7	B#10	4.54907e-17
C314	a_27_82##4	Y#6	2.01846e-17
C315	VGND#4	A#8	3.97257e-18
C316	VGND#4	A#9	3.9964e-18
C317	A#7	B#7	3.62816e-17
C318	VGND#4	A#6	3.97257e-18
C319	VPWR#4	B#6	3.83914e-20
C320	B#3	A#1	4.08948e-18
C321	Y	Y#2	1.57926e-18
C322	B	Y#1	4.88349e-17
C323	VPWR	VPWR#4	3.09483e-17
C324	Y#8	A	4.15169e-17
C325	A#10	A#7	6.7447e-18
C326	C#3	C#10	3.0021e-18
C327	C#3	C#9	6.52588e-19
C328	VGND#4	B#7	3.51005e-20
C329	VPWR	Y#2	5.01631e-18
C330	A	Y#3	7.68599e-17
C331	VPWR	A#13	1.31145e-18
C332	B	B#1	1.3298e-17
C333	VGND	VGND#3	4.39627e-17
C334	VGND	VGND#2	4.19749e-17
C335	VGND	a_456_82##2	4.77284e-18
C336	B#3	A#7	1.697e-19
C337	VGND	Y#6	8.74587e-18
C338	Y	a_27_82##5	2.48533e-17
C339	VGND	Y#2	2.39994e-18
C340	VGND	a_27_82##4	2.50731e-17
C341	VGND	a_27_82##3	2.53401e-17
C342	a_27_82##3	Y#2	8.57313e-19
C343	VGND	a_27_82##2	2.3901e-17
C344	VGND	A#13	1.0469e-18
C345	VGND	VGND#1	3.91948e-17
C346	VPWR#4	VNB	4.15571e-17
C347	VGND	a_456_82#	1.18897e-17
C348	Y	VPWR#5	1.86126e-18
C349	VGND#4	B#3	8.05889e-20
C350	VGND#3	VNB	3.46767e-17
C351	VGND	a_456_82##6	1.09736e-17
C352	VGND#2	VNB	3.25548e-17
C353	B	C#10	5.45728e-19
C354	VPWR	Y#1	1.92597e-17
C355	VGND	a_27_82#	1.87741e-17
C356	a_456_82##2	VNB	2.059e-18
C357	VPWR	VPWR#7	1.21772e-16
C358	VGND	a_456_82##3	1.28668e-17
C359	VGND#4	A#4	1.40742e-19
C360	Y#6	VNB	2.39028e-18
C361	B	C#9	1.33348e-17
C362	VPWR	Y#5	1.60394e-17
C363	Y#2	VNB	1.55049e-19
C364	VGND	a_456_82##5	8.29379e-18
C365	VPWR	VPWR#8	2.14696e-17
C366	a_27_82##4	VNB	6.43837e-18
C367	a_27_82##3	VNB	5.80574e-18
C368	VPWR	Y#3	3.4901e-17
C369	a_27_82##2	VNB	6.18039e-18
C370	VGND	Y#8	8.37468e-18
C371	VPWR	VPWR#5	4.77913e-17
C372	A#13	VNB	2.11247e-18
C373	VGND	a_27_82##5	1.89803e-17
C374	Y	B#11	3.33534e-21
C375	VGND#1	VNB	7.12567e-17
C376	VGND	Y#1	3.03203e-18
C377	a_456_82#	VNB	5.16837e-18
C378	VGND#5	VNB	1.89671e-19
C379	A	B#7	3.25284e-18
C380	a_456_82##6	VNB	4.8031e-18
C381	VGND#6	VNB	4.26516e-18
C382	A	A#7	3.10674e-18
C383	a_27_82#	VNB	9.11025e-18
C384	a_456_82##3	VNB	6.86981e-18
C385	A	A#10	1.31506e-18
C386	a_456_82##5	VNB	5.59111e-19
C387	VGND	C#1	4.18017e-18
C388	a_27_82##7	VNB	2.6048e-18
C389	Y#8	VNB	3.90569e-19
C390	VGND	C#4	3.97849e-18
C391	VGND	C#5	3.97849e-18
C392	VGND	C#7	3.97849e-18
C393	a_27_82##5	VNB	3.38248e-17
C394	B	C#3	1.79504e-17
C395	VGND#3	C#8	3.85822e-20
C396	VGND#2	VGND#1	1.96834e-18
C397	Y	B#10	4.7991e-20
C398	Y#1	VNB	7.00688e-18
C399	VPWR#7	VNB	6.65397e-17
C400	Y	B#7	2.55777e-19
C401	B	B#3	1.67315e-17
C402	Y#5	VNB	2.13537e-18
C403	VPWR#8	VNB	9.63551e-19
C404	VPWR	C#10	2.77962e-18
C405	Y	A#7	8.28458e-19
C406	Y#3	VNB	1.89271e-17
C407	VGND	A#1	3.65633e-18
C408	VPWR#5	VNB	7.05754e-17
C409	Y	A#10	5.41123e-18
C410	A	B#3	1.35097e-17
C411	C#1	VNB	6.09969e-17
C412	C#4	VNB	2.70945e-17
C413	C#5	VNB	2.73161e-17
C414	VPWR	B#7	2.44133e-19
C415	A	A#4	1.22656e-17
C416	C#7	VNB	2.91748e-17
C417	VPWR	A#7	5.63645e-19
C418	B#1	VNB	4.45485e-17
C419	B#8	VNB	2.62098e-17
C420	VPWR	A#10	5.68776e-19
C421	B#9	VNB	2.60132e-17
C422	VGND	C#9	6.50574e-21
C423	B#11	VNB	2.6405e-17
C424	A#1	VNB	3.24783e-17
C425	A#8	VNB	2.32302e-17
C426	A#9	VNB	2.32049e-17
C427	A#6	VNB	3.48239e-17
C428	VPWR	C#3	1.56013e-17
C429	C#10	VNB	3.67031e-17
C430	VPWR	B#3	4.67368e-18
C431	C#9	VNB	5.77003e-17
C432	B#10	VNB	3.24501e-17
C433	VGND	VGND#4	6.46401e-17
C434	B#7	VNB	3.83725e-17
C435	VGND#2	a_456_82#	9.48956e-18
C436	A#7	VNB	2.83967e-17
C437	VGND	C#3	1.2631e-17
C438	A#10	VNB	4.2097e-17
C439	VGND	B#3	5.72913e-18
C440	VPWR#3	VNB	2.46976e-16
C441	VGND#4	VNB	3.71156e-16
C442	Y	A	4.15398e-17
C443	C#3	VNB	7.42505e-17
C444	VPWR	B	3.98361e-18
C445	B#3	VNB	5.28529e-17
C446	Y#6	A#13	1.95596e-17
C447	VPWR	A	4.60065e-18
C448	A#4	VNB	3.23623e-17
C449	VGND	B	4.02292e-18
C450	VGND	A	4.11154e-18
C451	B	VNB	6.76296e-18
C452	A	VNB	6.02319e-18
C453	VGND	Y	3.40288e-18
C454	VPWR#4	A#3	2.83062e-20
C455	Y	VNB	4.59707e-17
C456	VPWR	VNB	6.74133e-17
C457	VGND	VNB	9.66063e-17
C458	a_456_82##5	B#5	3.39825e-18
C459	VPWR#2	C#8	3.09005e-18
C460	VPWR	VPWR#2	1.3737e-16
C461	VPWR#2	VPWR#6	6.90065e-17
C462	VPWR#2	C#10	3.43633e-17
C463	VPWR#2	C#1	3.85493e-18
C464	VPWR#3	VPWR#2	9.1192e-17
C465	Y#1	VPWR#2	1.08214e-16
C466	VPWR#2	C#2	8.82252e-18
C467	VPWR#2	C#9	1.13765e-18
C468	VPWR#2	VNB	1.38996e-16
C469	VPWR#7	VPWR#2	3.48502e-18
C470	VPWR#2	B#10	1.38646e-19
C471	C#3	VPWR#2	1.48742e-16
*
*
.ENDS sky130_fd_sc_hs__nand3_4
*
