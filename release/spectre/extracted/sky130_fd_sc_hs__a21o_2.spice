* Extracted by Quantus, converted by sky130cad/quantus.py
*
*
*
*                       LINUX           Wed Nov 18 08:05:08 2026
*
*
*
*  PROGRAM  advgen
*
*  Name           : advgen - Quantus - (64-bit)
*  Version        : 25.1.0-p047
*  Build Date     : Thu Dec 11 23:20:30 PST 2025
*
*  HSPICE LIBRARY
*
*  OPERATING_TEMPERATURE 150
*  QRC_TECH_DIR <path>/tech
*
*
*

*
.SUBCKT sky130_fd_sc_hs__a21o_2 VPB VNB VGND VPWR X B1 A1 A2
*
*
*  caps2d version: 10
*
*
*       TRANSISTOR CARDS
*
*
XM0 VGND#6 a_84_244##7 X#1 VNB sky130_fd_pr__nfet_01v8_lvt l=0.15 w=0.74 ad=0.1961 as=0.2072 pd=2.01 ps=2.04
XM8 X#1 a_84_244# VGND#5 VNB sky130_fd_pr__nfet_01v8_lvt l=0.15 w=0.74 ad=0.2072 as=0.4884 pd=2.04 ps=2.8
XM5 VGND#5 B1#3 a_84_244##8 VNB sky130_fd_pr__nfet_01v8_lvt l=0.15 w=0.74 ad=0.4884 as=0.2072 pd=2.8 ps=2.04
XM9 a_84_244##8 A1#3 a_484_74# VNB sky130_fd_pr__nfet_01v8_lvt l=0.15 w=0.74 ad=0.2072 as=0.2368 pd=2.04 ps=2.12
XM1 a_484_74# A2#3 VGND#1 VNB sky130_fd_pr__nfet_01v8_lvt l=0.15 w=0.74 ad=0.2368 as=0.2109 pd=2.12 ps=2.05
XM4 X#2 a_84_244##5 VPWR#5 VPB sky130_fd_pr__pfet_01v8 l=0.15 w=1.12 ad=0.336 as=0.308 pd=2.84 ps=2.79
XM6 VPWR#7 a_84_244##6 X#2 VPB sky130_fd_pr__pfet_01v8 l=0.15 w=1.12 ad=0.308 as=0.336 pd=2.79 ps=2.84
XM2 a_84_244##10 B1#1 a_401_392##2 VPB sky130_fd_pr__pfet_01v8 l=0.15 w=1 ad=0.275 as=0.3 pd=2.55 ps=2.6
XM7 a_401_392##2 A1#1 VPWR#6 VPB sky130_fd_pr__pfet_01v8 l=0.15 w=1 ad=0.3 as=0.3 pd=2.6 ps=2.6
XM3 VPWR#6 A2#4 a_401_392# VPB sky130_fd_pr__pfet_01v8 l=0.15 w=1 ad=0.3 as=0.275 pd=2.6 ps=2.55
*
*
*       RESISTOR AND CAP/DIODE CARDS
*
Rg1	a_84_244#	a_84_244##2	302.430511
Rg2	a_84_244##2	a_84_244##3	43.318764
Rg3	a_84_244##3	a_84_244##4	49.175148
Rg4	a_84_244##4	a_84_244##5	510.253723
Rg5	a_84_244##3	a_84_244##6	476.975128
Rg6	a_84_244##4	a_84_244##7	296.149994
Rg7	B1#1	B1#2	548.543640
Rg8	B1#2	B1#3	307.937683
Rg9	A1#1	A1#2	518.009277
Rg10	A1#2	A1#3	320.356293
Rg11	A2#1	A2#2	33.566738
Rg12	A2#2	A2#3	325.883820
Rg13	A2#2	A2#4	569.775879
Rf1	X#1	X	66.789536
Rf2	X	X#3	16.788086
Rf3	X#3	X	0.229974
Rf4	X#2	X#3	5.000000
Rf5	B1	B1#4	1.390769
Rf6	B1#5	B1#2	161.623566
Rf7	B1#4	B1#5	5.324635
Rf8	a_84_244##8	a_84_244##9	95.046127
Rf9	a_84_244##9	a_84_244##10	74.812943
Rf10	A1#4	A1#2	161.307495
Rf11	A1	A1#6	1.074685
Rf12	A1#4	A1#6	9.707032
Rf13	a_401_392#	a_401_392##2	137.625000
Rf14	A2	A2#1	163.775864
Rf15	VGND#1	VGND#2	128.320740
Rf16	VGND#2	VGND#3	95.400238
Rf18	VGND#2	VGND#5	19.311165
Rf19	VGND#3	VGND#6	41.038895
Rf21	VPWR#2	VPWR#3	67.547173
Rf22	VPWR#3	VPWR#4	36.135464
Rf23	VPWR#4	VPWR#5	116.990257
Rf24	VPWR#2	VPWR#6	34.546150
Rf25	VPWR#4	VPWR#7	35.431915
Rf27	a_84_244##2	a_84_244##9	160.232803
Re1	VPWR#3	VPWR	1.403190
Re2	VGND	VGND#2	1.403242
*
*       CAPACITOR CARDS
*
*
C1	VGND	VNB	5.6552e-17
C2	VPWR	VNB	5.9454e-17
C3	X	VNB	1.58484e-17
C4	VGND	X	2.50334e-18
C5	A2	VNB	2.1525e-17
C6	VPWR	X	1.84313e-17
C7	VGND	A2	2.07086e-18
C8	a_84_244##2	VNB	7.20065e-18
C9	B1#2	VNB	3.7211e-17
C10	A1#2	VNB	3.30689e-17
C11	VPWR	A2	3.26792e-18
C12	VGND#2	VNB	1.53336e-16
C13	VPWR#3	VNB	1.72307e-16
C14	a_84_244##8	A1#4	2.35218e-17
C15	VGND	a_84_244##2	6.00532e-18
C16	a_84_244##5	VNB	4.42265e-17
C17	a_84_244##6	VNB	3.73089e-17
C18	VGND	B1#2	1.15354e-19
C19	a_84_244##3	B1#2	1.69202e-17
C20	B1#1	VNB	4.26403e-17
C21	VGND	A1#2	3.35883e-19
C22	A1#1	VNB	3.37988e-17
C23	A2#4	VNB	4.05994e-17
C24	a_84_244##7	VNB	3.12319e-17
C25	VPWR	a_84_244##2	2.64456e-18
C26	a_84_244#	VNB	2.85776e-17
C27	B1#3	VNB	2.75804e-17
C28	A1#3	VNB	2.38609e-17
C29	A2#3	VNB	2.38236e-17
C30	VPWR#5	VNB	8.43747e-17
C31	X	a_84_244##2	5.31932e-17
C32	VPWR#7	VNB	1.06496e-17
C33	a_84_244##10	VNB	2.01826e-17
C34	a_401_392##2	VNB	7.30822e-18
C35	X	B1#2	2.00249e-19
C36	VPWR	VPWR#3	1.21529e-17
C37	VPWR#6	VNB	2.7166e-18
C38	a_401_392#	VNB	6.03168e-17
C39	VGND#6	VNB	4.09593e-17
C40	VGND	a_84_244##7	7.65723e-20
C41	X#1	VNB	5.47749e-18
C42	VPWR#4	VPWR#6	6.53369e-20
C43	VPWR	a_84_244##5	5.23888e-18
C44	VGND#5	VNB	5.465e-17
C45	VGND	a_84_244#	1.59376e-18
C46	a_84_244##8	VNB	1.27995e-18
C47	VPWR	a_84_244##6	4.24385e-18
C48	VGND	B1#3	1.69364e-19
C49	VGND#1	VNB	7.28633e-17
C50	VGND	A1#3	1.34382e-18
C51	VPWR	B1#1	2.08073e-18
C52	B1#4	VNB	1.67093e-18
C53	VGND	A2#3	2.87321e-18
C54	B1#5	VNB	1.75782e-18
C55	VPWR	A1#1	1.35743e-18
C56	VGND	VPWR#5	5.50442e-18
C57	VPWR	A2#4	2.10327e-18
C58	A1#4	VNB	7.21334e-19
C59	X	a_84_244##5	2.25293e-17
C60	A1#6	VNB	6.9977e-19
C61	VGND	a_84_244##10	2.82847e-18
C62	X	a_84_244##6	1.43808e-17
C63	VGND	a_401_392##2	4.2255e-18
C64	X	B1#1	2.80808e-19
C65	VGND	a_401_392#	3.31883e-18
C66	VPWR#4	VNB	3.01352e-17
C67	VGND	X#1	1.67937e-17
C68	VGND	VGND#5	6.95028e-17
C69	VGND	a_84_244##8	1.7769e-17
C70	VPWR	VPWR#5	3.27238e-17
C71	VGND	VGND#1	4.96902e-17
C72	VPWR	VPWR#7	2.07457e-17
C73	VGND#1	A1#4	3.21113e-19
C74	VGND	B1#4	1.56918e-18
C75	VPWR	a_84_244##10	1.44731e-17
C76	VGND	B1#5	1.83344e-18
C77	VPWR	a_401_392##2	1.52103e-17
C78	VPWR	VPWR#6	2.27655e-17
C79	VGND	A1#4	4.0086e-18
C80	VPWR	a_401_392#	1.53536e-17
C81	A1#2	a_484_74#	5.52821e-19
C82	VGND	A1#6	5.17998e-18
C83	VPWR#5	X	5.1399e-17
C84	X	X#2	3.11115e-18
C85	X	VPWR#7	4.67971e-17
C86	X	a_84_244##10	2.17285e-18
C87	VPWR	B1#4	1.09245e-18
C88	a_84_244##2	B1#2	4.07218e-18
C89	VPWR	B1#5	3.95905e-18
C90	a_84_244##2	A1#2	3.7426e-19
C91	VPWR	A1#4	1.50124e-18
C92	VPWR	A1#6	1.36942e-18
C93	B1#2	A1#2	3.79704e-17
C94	A1#2	A2#2	3.22722e-17
C95	VGND#1	A1#6	2.04065e-18
C96	VPWR	VPWR#4	2.16436e-17
C97	VPWR#3	B1#2	1.11903e-19
C98	a_84_244##2	a_84_244##6	6.47899e-18
C99	B1#5	A1#4	2.65503e-17
C100	X	VPWR#4	1.51864e-17
C101	a_84_244##3	VNB	3.38879e-17
C102	a_84_244##4	VNB	4.93183e-17
C103	A1#3	a_484_74#	2.06918e-17
C104	A2#2	VNB	6.7818e-17
C105	a_84_244##6	B1#2	4.83659e-19
C106	A2	a_401_392#	3.3948e-17
C107	A2#3	a_484_74#	2.11762e-17
C108	a_84_244##2	a_84_244##7	1.65059e-19
C109	VGND#1	A2	4.22902e-17
C110	a_84_244##2	a_84_244#	5.02216e-18
C111	A2#2	VGND#1	8.35215e-18
C112	a_84_244##2	B1#3	1.23875e-18
C113	VPWR#4	a_84_244##4	7.79823e-20
C114	a_84_244##2	A1#3	3.46564e-19
C115	a_84_244##2	A2#3	2.71212e-19
C116	VPWR#3	B1#1	8.43618e-18
C117	A1#6	A2	3.20265e-17
C118	a_84_244##5	a_84_244##6	4.98125e-17
C119	a_84_244##2	VPWR#7	2.875e-17
C120	VGND	a_84_244##4	1.19639e-18
C121	VGND	A2#2	6.05356e-19
C122	a_84_244##2	a_84_244##10	3.0912e-18
C123	a_84_244##6	B1#1	8.14656e-18
C124	VGND#2	a_84_244##3	1.11125e-22
C125	a_84_244##10	B1#2	8.32506e-18
C126	a_401_392##2	B1#2	4.65986e-18
C127	B1#1	A1#1	5.28701e-17
C128	X#1	a_84_244##2	4.52868e-17
C129	a_84_244##10	A1#2	9.81024e-19
C130	a_84_244##2	VGND#5	3.27647e-17
C131	a_401_392##2	A1#2	8.35035e-18
C132	A1#1	A2#4	5.00934e-17
C133	VPWR#3	VPWR#5	2.46229e-17
C134	a_84_244##2	VGND#1	8.21078e-21
C135	B1#2	VGND#5	1.89664e-18
C136	B1#4	a_84_244##3	6.47468e-18
C137	a_84_244##8	B1#2	2.54965e-18
C138	VPWR	A2#2	7.96482e-19
C139	a_84_244##2	B1#4	3.4717e-17
C140	VGND#5	A1#2	6.86164e-20
C141	a_84_244##10	VPWR#3	1.76425e-17
C142	A1#2	a_84_244##8	1.79216e-18
C143	VPWR#5	a_84_244##5	3.232e-17
C144	B1#4	B1#2	5.62794e-18
C145	a_401_392##2	VPWR#3	8.58263e-18
C146	a_84_244##2	A1#4	8.64933e-19
C147	X#2	a_84_244##5	3.50492e-17
C148	B1#5	B1#2	1.5947e-17
C149	VGND#1	A1#2	4.30228e-19
C150	VPWR#5	a_84_244##6	1.20836e-18
C151	VPWR#7	a_84_244##5	3.14747e-18
C152	a_84_244##6	X#2	8.51531e-18
C153	VGND#2	VGND#5	6.44076e-17
C154	a_84_244##10	a_84_244##5	2.38693e-19
C155	A1#4	B1#2	4.59242e-18
C156	B1#5	A1#2	4.22963e-18
C157	VPWR#7	a_84_244##6	6.92568e-17
C158	a_84_244##7	a_84_244#	3.66642e-17
C159	a_84_244##10	a_84_244##6	2.43975e-18
C160	X	a_84_244##3	8.79486e-18
C161	X	a_84_244##4	1.64439e-17
C162	VPWR#7	B1#1	3.64268e-18
C163	VGND#2	VGND#1	3.98775e-17
C164	A1#4	A1#2	1.52493e-17
C165	a_401_392##2	a_84_244##6	8.43087e-21
C166	a_84_244##2	VPWR#4	1.64311e-19
C167	B1#1	a_84_244##10	2.29336e-17
C168	a_84_244#	B1#3	9.13008e-18
C169	VPWR#6	a_84_244##6	3.78392e-19
C170	VPWR#7	A1#1	2.73527e-19
C171	A1#6	A1#2	5.34429e-18
C172	a_401_392##2	B1#1	5.01392e-17
C173	VPWR#6	B1#1	3.31973e-18
C174	a_401_392##2	A1#1	2.62909e-17
C175	VPWR#7	a_84_244##3	2.12535e-18
C176	B1#3	A1#3	3.75311e-17
C177	a_401_392#	B1#1	2.82695e-19
C178	VPWR#6	A1#1	4.95934e-17
C179	a_401_392##2	A2#4	7.98813e-19
C180	a_401_392#	A1#1	7.95126e-19
C181	VPWR#6	A2#4	5.07753e-17
C182	A1#3	A2#3	3.53456e-17
C183	a_401_392#	A2#4	3.59265e-17
C184	VGND#6	a_84_244##7	2.1029e-17
C185	VPWR#5	X#2	3.46018e-17
C186	X#1	a_84_244##7	3.77101e-17
C187	a_84_244##10	A2#2	6.19933e-19
C188	VPWR#5	VPWR#7	1.7987e-18
C189	VPWR#3	VPWR#4	3.80775e-17
C190	VGND#6	a_84_244#	7.63177e-19
C191	VGND#5	a_84_244##7	1.57078e-18
C192	X#1	a_84_244#	4.10616e-17
C193	X#2	VPWR#7	4.06346e-17
C194	VGND#6	B1#3	1.93793e-19
C195	a_84_244#	VGND#5	2.88724e-17
C196	X#1	B1#3	7.0086e-19
C197	a_84_244##8	a_84_244#	5.4176e-19
C198	B1#3	VGND#5	3.18258e-17
C199	VPWR#7	a_84_244##10	7.89533e-17
C200	A1#4	a_84_244##3	7.25555e-20
C201	VPWR#4	a_84_244##5	2.30519e-18
C202	a_84_244##8	B1#3	5.56038e-17
C203	a_84_244##4	a_84_244##3	3.89437e-18
C204	VGND#5	A1#3	8.24599e-18
C205	VGND#1	a_84_244#	1.52308e-19
C206	A2	A2#2	2.10354e-17
C207	VGND#6	VPWR#5	7.4924e-18
C208	VPWR#7	VPWR#6	8.50299e-19
C209	a_84_244##8	A1#3	4.17358e-17
C210	a_84_244##10	a_401_392##2	9.15712e-17
C211	VGND#5	A2#3	5.84716e-19
C212	VGND#1	B1#3	5.72892e-19
C213	a_84_244##8	A2#3	7.28147e-18
C214	VGND#1	A1#3	7.93742e-18
C215	a_401_392##2	VPWR#6	8.62686e-17
C216	X#1	VPWR#7	4.22898e-18
C217	VGND#1	A2#3	4.49006e-17
C218	a_401_392##2	a_401_392#	2.20892e-18
C219	VPWR#6	A2#2	6.47509e-19
C220	a_401_392#	VPWR#6	8.62136e-17
C221	a_84_244##8	a_84_244##10	1.12114e-19
C222	a_84_244##8	a_401_392##2	7.30744e-18
C223	a_401_392#	A2#2	1.37405e-17
C224	VGND#6	X#1	7.00181e-17
C225	VGND#6	VGND#5	2.3616e-18
C226	A1#6	A2#2	1.4687e-17
C227	B1#4	a_84_244##10	1.69942e-17
C228	VGND#5	X#1	4.58931e-17
C229	B1#5	a_84_244##10	1.12149e-17
C230	VGND#6	a_84_244##4	5.08447e-18
C231	VGND#1	a_401_392#	3.70893e-18
C232	X#1	a_84_244##8	1.92844e-18
C233	a_84_244##8	VGND#5	7.00431e-17
C234	X#1	a_84_244##3	3.98596e-18
C235	X#1	a_84_244##4	2.30854e-18
C236	A1#4	a_401_392##2	2.69535e-17
C237	VGND#5	VGND#1	1.0606e-18
C238	a_84_244##8	VGND#1	2.08908e-17
C239	VPWR#5	VPWR#4	9.86498e-19
C240	A1#6	a_401_392##2	8.17482e-18
C241	a_84_244##3	VGND#5	2.2526e-18
C242	a_84_244##8	B1#4	1.62709e-17
C243	a_84_244##2	a_84_244##3	2.72655e-17
C244	a_84_244##8	B1#5	2.65216e-17
C245	A1#6	a_401_392#	1.94066e-17
C246	a_84_244##2	A2#2	9.49786e-20
C247	a_84_244##10	VPWR#4	1.38814e-19
C248	VGND#5	A1#4	6.44731e-19
C249	VGND#3	a_84_244##3	5.95125e-20
C250	VGND#3	B1#3	5.00606e-20
C251	VPWR#4	VPWR#2	3.88392e-19
C252	VGND#3	a_84_244#	6.11633e-19
C253	VPWR#2	A2#4	1.8696e-18
C254	VGND#2	VGND#3	3.93731e-17
C255	VPWR#2	A1#1	1.87144e-18
C256	VGND#3	a_84_244##7	8.17998e-18
C257	VPWR#3	VPWR#2	5.40337e-17
C258	VGND#3	X	5.99584e-19
C259	VPWR#2	A1#2	5.62763e-20
C260	VGND	VGND#3	4.08658e-17
C261	A2	VPWR#2	3.53284e-19
C262	VGND#3	VNB	3.88309e-17
C263	a_401_392#	VPWR#2	1.78179e-17
C264	a_401_392##2	VPWR#2	8.03792e-18
C265	VGND#3	VGND#5	1.33635e-18
C266	VPWR	VPWR#2	3.38987e-17
C267	VGND#3	X#1	8.28079e-18
C268	VPWR#2	VNB	4.78055e-17
C269	VPWR#2	A2#2	6.48128e-19
*
*
.ENDS sky130_fd_sc_hs__a21o_2
*
