* Extracted by Quantus, converted by sky130cad/quantus.py
*
*
*
*                       LINUX           Wed Nov 18 08:27:38 2026
*
*
*
*  PROGRAM  advgen
*
*  Name           : advgen - Quantus - (64-bit)
*  Version        : 25.1.0-p047
*  Build Date     : Thu Dec 11 23:20:30 PST 2025
*
*  HSPICE LIBRARY
*
*  OPERATING_TEMPERATURE 150
*  QRC_TECH_DIR <path>/tech
*
*
*

*
.SUBCKT sky130_fd_sc_hs__dfsbp_1 VPB VNB VGND SET_B VPWR Q_N Q D CLK
*
*
*  caps2d version: 10
*
*
*       TRANSISTOR CARDS
*
*
XM6 a_27_80##4 D#2 VGND#18 VNB sky130_fd_pr__nfet_01v8_lvt l=0.15 w=0.42 ad=0.1197 as=0.1197 pd=1.41 ps=1.41
XM27 a_225_74##14 CLK#3 VGND#17 VNB sky130_fd_pr__nfet_01v8_lvt l=0.15 w=0.74 ad=0.2109 as=0.2072 pd=2.05 ps=2.04
XM21 VGND#17 a_225_74##7 a_398_74##11 VNB sky130_fd_pr__nfet_01v8_lvt l=0.15 w=0.74 ad=0.2072 as=0.2109 pd=2.04 ps=2.05
XM24 a_27_80##5 a_225_74##9 a_596_81##10 VNB sky130_fd_pr__nfet_01v8_lvt l=0.15 w=0.42 ad=0.1197 as=0.2562 pd=1.41 ps=2.06
XM26 a_596_81##10 a_398_74# a_748_81# VNB sky130_fd_pr__nfet_01v8_lvt l=0.15 w=0.42 ad=0.2562 as=0.1008 pd=2.06 ps=1.32
XM9 a_748_81# a_779_380# VGND#16 VNB sky130_fd_pr__nfet_01v8_lvt l=0.15 w=0.42 ad=0.1008 as=0.1197 pd=1.32 ps=1.41
XM3 a_779_380##5 a_596_81# a_1061_74# VNB sky130_fd_pr__nfet_01v8_lvt l=0.15 w=0.42 ad=0.1113 as=0.1008 pd=1.37 ps=1.32
XM28 a_1061_74# SET_B#1 VGND#15 VNB sky130_fd_pr__nfet_01v8_lvt l=0.15 w=0.42 ad=0.1008 as=0.258 pd=1.32 ps=2.21
XM20 VGND#15 a_596_81##4 a_1262_74# VNB sky130_fd_pr__nfet_01v8_lvt l=0.15 w=0.64 ad=0.258 as=0.2176 pd=2.21 ps=1.96
XM22 a_1262_74# a_398_74##6 a_1355_377##16 VNB sky130_fd_pr__nfet_01v8_lvt l=0.15 w=0.64 ad=0.2176 as=0.2139 pd=1.96 ps=2
XM2 a_1355_377##16 a_225_74# a_1462_74# VNB sky130_fd_pr__nfet_01v8_lvt l=0.15 w=0.42 ad=0.2139 as=0.1008 pd=2 ps=1.32
XM1 a_1462_74# a_1510_48##3 a_1540_74# VNB sky130_fd_pr__nfet_01v8_lvt l=0.15 w=0.42 ad=0.1008 as=0.1008 pd=1.32 ps=1.32
XM11 a_1540_74# SET_B#4 VGND#14 VNB sky130_fd_pr__nfet_01v8_lvt l=0.15 w=0.42 ad=0.1008 as=0.2982 pd=1.32 ps=2.26
XM32 VGND#14 a_1355_377##5 a_1510_48##7 VNB sky130_fd_pr__nfet_01v8_lvt l=0.15 w=0.42 ad=0.2982 as=0.1197 pd=2.26 ps=1.41
XM5 VGND#13 a_1355_377##7 Q_N#3 VNB sky130_fd_pr__nfet_01v8_lvt l=0.15 w=0.74 ad=0.2627 as=0.2109 pd=2.19 ps=2.05
XM15 a_2113_74##6 a_1355_377##6 VGND#12 VNB sky130_fd_pr__nfet_01v8_lvt l=0.15 w=0.55 ad=0.15675 as=0.30395 pd=1.67 ps=2.34
XM18 VGND#12 a_2113_74# Q#3 VNB sky130_fd_pr__nfet_01v8_lvt l=0.15 w=0.74 ad=0.30395 as=0.2109 pd=2.34 ps=2.05
XM33 a_27_80##6 D#3 VPWR#18 VPB sky130_fd_pr__pfet_01v8 l=0.15 w=0.42 ad=0.1239 as=0.1239 pd=1.43 ps=1.43
XM8 a_225_74##12 CLK#1 VPWR#17 VPB sky130_fd_pr__pfet_01v8 l=0.15 w=1.12 ad=0.3304 as=0.336 pd=2.83 ps=2.84
XM30 VPWR#17 a_225_74##10 a_398_74##15 VPB sky130_fd_pr__pfet_01v8 l=0.15 w=1.12 ad=0.336 as=0.3304 pd=2.84 ps=2.83
XM23 a_27_80# a_398_74##5 a_596_81##11 VPB sky130_fd_pr__pfet_01v8 l=0.15 w=0.42 ad=0.1239 as=0.147 pd=1.43 ps=1.54
XM31 a_596_81##11 a_225_74##8 a_728_463# VPB sky130_fd_pr__pfet_01v8 l=0.15 w=0.42 ad=0.147 as=0.1134 pd=1.54 ps=1.38
XM17 a_728_463# a_779_380##4 VPWR#16 VPB sky130_fd_pr__pfet_01v8 l=0.15 w=0.42 ad=0.1134 as=0.3171 pd=1.38 ps=2.35
XM12 VPWR#16 a_596_81##3 a_779_380##7 VPB sky130_fd_pr__pfet_01v8 l=0.15 w=0.42 ad=0.3171 as=0.1512 pd=2.35 ps=1.56
XM29 a_779_380##7 SET_B#3 VPWR#15 VPB sky130_fd_pr__pfet_01v8 l=0.15 w=0.42 ad=0.1512 as=0.44505 pd=1.56 ps=3.43
XM19 VPWR#15 a_596_81##6 a_1254_341# VPB sky130_fd_pr__pfet_01v8 l=0.15 w=1 ad=0.44505 as=0.3865 pd=3.43 ps=3.07
XM25 a_1254_341# a_225_74##2 a_1355_377##13 VPB sky130_fd_pr__pfet_01v8 l=0.15 w=1 ad=0.3865 as=0.4408 pd=3.07 ps=3.47
XM7 a_1355_377##13 a_398_74##8 a_1517_508# VPB sky130_fd_pr__pfet_01v8 l=0.15 w=0.42 ad=0.4408 as=0.1134 pd=3.47 ps=1.38
XM0 a_1517_508# a_1510_48# VPWR#14 VPB sky130_fd_pr__pfet_01v8 l=0.15 w=0.42 ad=0.1134 as=0.126 pd=1.38 ps=1.44
XM14 VPWR#14 SET_B#6 a_1355_377##15 VPB sky130_fd_pr__pfet_01v8 l=0.15 w=0.42 ad=0.126 as=0.1239 pd=1.44 ps=1.43
XM13 a_1510_48##4 a_1355_377##10 VPWR#13 VPB sky130_fd_pr__pfet_01v8 l=0.15 w=0.42 ad=0.1596 as=0.3346 pd=1.6 ps=2.95
XM16 VPWR#13 a_1355_377##8 Q_N#1 VPB sky130_fd_pr__pfet_01v8 l=0.15 w=1.12 ad=0.3346 as=0.3304 pd=2.95 ps=2.83
XM4 a_2113_74##7 a_1355_377# VPWR#12 VPB sky130_fd_pr__pfet_01v8 l=0.15 w=0.84 ad=0.2478 as=0.3724 pd=2.27 ps=2.95
XM10 VPWR#12 a_2113_74##3 Q#1 VPB sky130_fd_pr__pfet_01v8 l=0.15 w=1.12 ad=0.3724 as=0.3304 pd=2.95 ps=2.83
*
*
*       RESISTOR AND CAP/DIODE CARDS
*
Rg1	D#1	D#2	311.105377
Rg2	D#1	D#3	440.340118
Rg3	CLK#1	CLK#2	478.349915
Rg4	CLK#2	CLK#3	320.356293
Rg5	a_398_74#	a_398_74##2	446.945709
Rg6	a_398_74##2	a_398_74##3	141.586166
Rg7	a_398_74##2	a_398_74##4	29.309698
Rg8	a_398_74##3	a_398_74##5	288.164215
Rg9	a_779_380#	a_779_380##2	403.540253
Rg10	a_779_380##2	a_779_380##3	315.050232
Rg11	a_779_380##3	a_779_380##4	394.262299
Rg12	a_596_81#	a_596_81##2	331.921783
Rg13	a_596_81##2	a_596_81##3	607.187378
Rg14	SET_B#1	SET_B#2	659.023071
Rg15	SET_B#2	SET_B#3	338.623413
Rg16	a_596_81##4	a_596_81##5	274.662231
Rg17	a_596_81##5	a_596_81##6	437.819611
Rg18	a_398_74##6	a_398_74##7	279.244598
Rg19	a_225_74#	a_225_74##2	1234.062500
Rg20	a_225_74##2	a_225_74##3	2138.766113
Rg21	a_225_74##3	a_225_74##4	1470.029297
Rg22	a_225_74##4	a_225_74##5	43.393650
Rg23	a_225_74##5	a_225_74##6	42.414452
Rg24	a_225_74##6	a_225_74##7	370.459167
Rg25	a_225_74##3	a_225_74##8	283.919525
Rg26	a_225_74##4	a_225_74##9	580.221252
Rg27	a_225_74##6	a_225_74##10	450.102234
Rg28	a_398_74##8	a_398_74##9	264.075958
Rg29	a_1510_48#	a_1510_48##2	431.428619
Rg30	a_1510_48##2	a_1510_48##3	676.124695
Rg31	SET_B#4	SET_B#5	572.829590
Rg32	SET_B#5	SET_B#6	667.860535
Rg33	a_1355_377#	a_1355_377##2	510.069489
Rg34	a_1355_377##2	a_1355_377##3	133.355804
Rg35	a_1355_377##3	a_1355_377##4	70.630836
Rg36	a_1355_377##4	a_1355_377##5	433.304230
Rg37	a_1355_377##2	a_1355_377##6	389.360535
Rg38	a_1355_377##3	a_1355_377##7	326.333160
Rg39	a_1355_377##3	a_1355_377##8	490.935455
Rg40	a_1355_377##4	a_1355_377##9	41.034409
Rg41	a_1355_377##9	a_1355_377##10	378.612030
Rg42	a_2113_74#	a_2113_74##2	307.937683
Rg43	a_2113_74##2	a_2113_74##3	492.059540
Rf1	D#4	D	0.532052
Rf2	D#1	D#6	53.942986
Rf3	D#4	D#6	8.660800
Rf4	D#7	D	0.532052
Rf5	D#6	D#7	5.905091
Rf6	CLK#4	CLK#2	161.469666
Rf7	CLK	CLK#6	1.236861
Rf8	CLK#4	CLK#6	7.589135
Rf9	a_225_74##5	a_225_74##13	229.716675
Rf10	a_225_74##13	a_225_74##14	88.222649
Rf11	a_225_74##12	a_225_74##13	15.000000
Rf12	a_27_80#	a_27_80##2	39.762878
Rf13	a_27_80##2	a_27_80##3	159.854645
Rf14	a_27_80##3	a_27_80##4	133.223618
Rf15	a_27_80##2	a_27_80##5	116.559288
Rf16	a_27_80##3	a_27_80##6	39.304317
Rf17	a_398_74##3	a_398_74##11	262.701141
Rf18	a_779_380##5	a_779_380##2	203.115387
Rf19	a_779_380##7	a_779_380##3	241.466614
Rf20	SET_B#2	SET_B#8	165.794876
Rf21	a_596_81##5	a_596_81##8	225.776733
Rf22	a_596_81##8	a_596_81##9	148.283279
Rf23	a_596_81##9	a_596_81##10	33.670567
Rf24	a_596_81##9	a_596_81##11	123.122986
Rf25	a_398_74##9	a_398_74##13	418.697510
Rf26	a_398_74##13	a_398_74##14	335.527161
Rf27	a_398_74##14	a_398_74##15	194.474060
Rf28	a_398_74##13	a_398_74##7	164.583908
Rf29	a_398_74##14	a_398_74##4	199.247894
Rf30	SET_B#9	SET_B#5	161.395157
Rf31	SET_B	SET_B#12	10.940138
Rf32	SET_B#9	SET_B#12	9.344830
Rf33	a_1355_377##9	a_1355_377##12	107.378983
Rf34	a_1355_377##12	a_1355_377##14	75.866913
Rf35	a_1355_377##12	a_1355_377##15	26.966669
Rf36	a_1355_377##14	a_1355_377##16	124.505272
Rf37	a_1355_377##14	a_1355_377##13	19.708614
Rf38	a_1355_377##13	a_1355_377##14	7.500000
Rf39	a_1510_48##4	a_1510_48##5	198.858414
Rf40	a_1510_48##5	a_1510_48##2	270.518158
Rf41	a_1510_48##5	a_1510_48##7	25.256187
Rf42	Q_N	Q_N#2	0.205730
Rf43	Q_N#2	Q_N	15.018257
Rf44	Q_N	Q_N#3	34.638489
Rf45	Q_N#1	Q_N#2	5.000000
Rf46	a_2113_74##2	a_2113_74##5	181.707642
Rf47	a_2113_74##5	a_2113_74##6	57.689816
Rf48	a_2113_74##5	a_2113_74##7	83.354927
Rf49	Q	Q#2	0.196836
Rf50	Q#2	Q	14.369054
Rf51	Q	Q#3	91.762497
Rf52	Q#1	Q#2	5.000000
Rf54	VGND#2	VGND#3	114.640213
Rf55	VGND#3	VGND#4	21.160110
Rf56	VGND#4	VGND#5	69.438911
Rf57	VGND#5	VGND#6	174.607101
Rf58	VGND#6	VGND#7	127.789307
Rf59	VGND#7	VGND#8	66.451416
Rf60	VGND#8	VGND#9	118.731796
Rf61	VGND#9	VGND#10	77.856331
Rf63	VGND#2	VGND#12	30.353714
Rf64	VGND#3	VGND#13	33.326477
Rf65	VGND#5	VGND#14	16.591099
Rf66	VGND#6	VGND#15	30.845804
Rf67	VGND#7	VGND#16	33.326477
Rf68	VGND#9	VGND#17	36.622520
Rf69	VGND#10	VGND#18	41.887741
Rf71	VPWR#2	VPWR#3	108.054688
Rf72	VPWR#3	VPWR#4	27.358418
Rf73	VPWR#4	VPWR#5	88.123894
Rf74	VPWR#5	VPWR#6	166.257706
Rf75	VPWR#6	VPWR#7	119.535782
Rf76	VPWR#7	VPWR#8	64.412888
Rf77	VPWR#8	VPWR#9	118.317268
Rf78	VPWR#9	VPWR#10	73.731934
Rf80	VPWR#2	VPWR#12	39.408188
Rf81	VPWR#3	VPWR#13	31.024939
Rf82	VPWR#5	VPWR#14	47.494125
Rf83	VPWR#6	VPWR#15	38.552784
Rf84	VPWR#7	VPWR#16	36.734741
Rf85	VPWR#9	VPWR#17	36.672695
Rf86	VPWR#10	VPWR#18	34.310661
Rf95	a_596_81##2	a_596_81##8	160.232803
Re2	SET_B	SET_B#8	14.521620
Re3	VPWR#4	VPWR	2.179561
Re4	VPWR	VPWR#8	1.712512
Re5	VGND#4	VGND	2.179561
Re6	VGND	VGND#8	1.712512
*
*       CAPACITOR CARDS
*
*
C1	a_225_74##10	a_225_74##3	9.27545e-18
C2	a_779_380##5	a_596_81##2	3.30813e-17
C3	a_398_74##15	a_27_80#	8.07844e-17
C4	a_27_80##3	CLK#2	4.64313e-19
C5	VGND#9	a_225_74##7	3.2377e-18
C6	VPWR#9	a_398_74##15	4.03205e-17
C7	a_398_74##11	a_398_74#	2.93146e-18
C8	VGND#7	VGND#15	1.15759e-19
C9	a_27_80##3	VPWR#18	2.62105e-17
C10	a_27_80##2	a_225_74##6	3.02989e-17
C11	VGND#16	a_596_81##2	2.61494e-18
C12	a_398_74##14	a_398_74##5	2.31083e-19
C13	a_398_74##15	VPWR#8	4.00276e-17
C14	a_596_81##9	a_225_74##8	2.19408e-19
C15	a_27_80##5	a_225_74##9	2.77179e-17
C16	SET_B#6	a_1355_377##10	5.34762e-18
C17	a_1510_48##5	a_1510_48##4	9.08428e-19
C18	a_596_81##2	a_225_74##3	8.83327e-19
C19	a_225_74##14	VGND#17	5.79429e-17
C20	VPWR#14	a_1510_48##2	3.11959e-19
C21	VGND#4	a_2113_74#	2.45329e-18
C22	a_596_81##2	a_398_74##2	7.30019e-18
C23	CLK#1	a_225_74##6	2.17201e-18
C24	a_398_74##11	a_225_74##9	3.20623e-17
C25	Q_N#3	a_2113_74##6	4.86095e-17
C26	VGND#13	VGND#12	4.79506e-19
C27	a_398_74##13	SET_B#4	1.60595e-18
C28	a_27_80##3	D#1	3.05041e-17
C29	VGND#4	a_1355_377##6	3.09014e-19
C30	a_779_380##2	VGND#16	3.8033e-17
C31	VGND#4	VGND#6	2.41247e-17
C32	a_1510_48##5	Q_N#3	1.84652e-17
C33	a_27_80##5	a_225_74##7	1.19109e-18
C34	a_27_80##2	D#1	3.45298e-19
C35	a_1355_377##13	a_1510_48##2	3.62195e-17
C36	VPWR#13	a_1355_377##4	4.33642e-19
C37	VGND#9	CLK#3	9.2848e-18
C38	VPWR#17	a_398_74##15	4.02695e-17
C39	a_1510_48#	SET_B#6	3.26644e-17
C40	a_398_74##14	a_225_74##10	9.06026e-20
C41	VGND#4	a_1355_377##7	5.16663e-18
C42	VGND#18	VGND#17	9.71756e-19
C43	VGND#17	a_225_74##9	3.16059e-19
C44	VGND#4	VGND#5	1.4188e-16
C45	VPWR#7	VPWR#6	2.85181e-19
C46	D#7	CLK#2	7.44424e-20
C47	a_596_81##10	a_779_380##2	1.44194e-18
C48	VGND#4	a_1355_377##5	3.04522e-18
C49	a_225_74##7	a_398_74##11	1.7293e-17
C50	VGND#4	VGND#3	5.9639e-17
C51	D#6	CLK#2	4.04572e-19
C52	a_1355_377##13	a_398_74##9	1.52008e-16
C53	a_1355_377##12	a_1510_48##4	1.59624e-17
C54	VPWR#13	a_1355_377##3	1.29812e-18
C55	a_27_80##5	CLK#3	5.8315e-20
C56	a_398_74##13	a_1510_48##3	9.88951e-18
C57	D#4	CLK#2	4.78466e-19
C58	VGND#18	a_225_74##14	4.58358e-17
C59	a_779_380##2	a_225_74##3	7.51224e-19
C60	VPWR#18	a_225_74##3	8.57011e-20
C61	a_398_74##8	a_1510_48#	2.80061e-17
C62	VGND#17	a_225_74##7	4.31736e-17
C63	VPWR#4	a_2113_74##5	1.30465e-18
C64	SET_B#8	VGND#6	5.09032e-18
C65	a_1510_48##5	VGND#13	2.91546e-17
C66	VGND#4	a_1510_48##3	3.22274e-18
C67	a_398_74##2	a_779_380##2	6.65255e-18
C68	D#7	D#1	1.94418e-17
C69	a_398_74##13	a_1254_341#	2.09654e-18
C70	a_27_80##2	a_779_380##4	2.7389e-19
C71	a_398_74##11	CLK#3	5.36468e-19
C72	a_225_74##12	VPWR#17	5.57796e-19
C73	a_27_80##6	a_225_74##6	4.60517e-20
C74	VGND#7	a_779_380##5	1.32629e-17
C75	a_1355_377##13	a_398_74##7	3.44031e-18
C76	a_225_74##14	a_225_74##7	1.66934e-18
C77	SET_B#9	a_1355_377##4	6.73751e-18
C78	VGND#13	Q_N#3	3.62293e-17
C79	D#6	D#1	6.86029e-18
C80	a_1355_377##12	VPWR#5	5.59981e-19
C81	a_27_80##4	a_225_74##14	2.59987e-18
C82	a_1510_48##4	a_1355_377##4	7.74179e-18
C83	CLK#3	VGND#17	1.52249e-17
C84	D#4	D#1	1.71939e-17
C85	a_225_74##2	a_398_74##8	1.03871e-17
C86	a_1355_377##16	a_1355_377##13	1.04515e-18
C87	a_398_74##13	a_225_74#	2.19516e-17
C88	VPWR#18	VPWR#17	1.25153e-17
C89	a_1355_377##13	a_225_74#	1.79338e-18
C90	a_27_80##6	a_398_74##15	1.6803e-22
C91	VGND#18	a_225_74##7	1.37157e-19
C92	D#3	a_225_74##3	1.40658e-19
C93	a_1355_377##13	a_596_81##5	1.99892e-19
C94	a_398_74##14	a_728_463#	9.47222e-18
C95	VGND#6	a_779_380##5	3.28009e-18
C96	VGND#4	a_2113_74##5	8.1416e-19
C97	a_27_80##2	a_225_74##8	3.25268e-19
C98	a_225_74##14	CLK#3	5.19845e-17
C99	D#7	a_225_74##12	3.77909e-17
C100	VGND#9	a_225_74##6	3.996e-19
C101	a_1355_377##2	a_2113_74#	3.3517e-18
C102	a_1510_48##7	Q_N#3	3.05719e-18
C103	a_1510_48##4	a_1355_377##3	6.95115e-19
C104	a_27_80##4	VGND#18	3.76178e-17
C105	VGND#17	D#2	8.39133e-19
C106	a_779_380##3	a_225_74##3	2.56275e-18
C107	a_27_80##6	VPWR#17	7.69774e-19
C108	VPWR#15	a_596_81##5	5.19246e-19
C109	a_596_81##6	a_225_74##2	5.52758e-17
C110	VPWR#18	VPWR#9	8.53311e-19
C111	a_398_74##3	a_596_81##10	1.66684e-17
C112	VGND#18	CLK#3	1.12817e-18
C113	a_1355_377##13	SET_B#2	2.50457e-19
C114	a_398_74##2	a_779_380##3	1.64217e-17
C115	a_27_80##5	a_398_74##3	5.32987e-17
C116	a_1355_377##12	VPWR#14	1.88964e-17
C117	a_398_74##13	a_398_74##6	2.50012e-17
C118	a_225_74##14	D#2	1.31594e-18
C119	a_1355_377##12	VPWR#4	7.0791e-18
C120	SET_B#3	a_225_74##2	1.95992e-17
C121	a_1510_48##4	a_1355_377##2	8.6946e-20
C122	a_398_74##11	a_398_74##3	2.81521e-18
C123	a_27_80##2	a_398_74##5	2.96201e-18
C124	a_27_80##4	CLK#3	1.65806e-19
C125	a_1510_48##7	VGND#13	2.19265e-17
C126	a_1355_377##2	a_2113_74##3	9.49549e-18
C127	VPWR#5	a_1355_377##8	6.27008e-20
C128	SET_B#3	a_596_81##6	8.25544e-18
C129	VGND#18	D#2	2.88142e-17
C130	VGND#4	a_1510_48##5	1.44424e-17
C131	a_779_380##7	SET_B#2	5.49174e-18
C132	D#6	a_225_74##12	1.5213e-17
C133	a_225_74##5	a_27_80##5	1.93996e-17
C134	VPWR#4	SET_B#12	4.07521e-18
C135	a_27_80##6	VPWR#18	3.13169e-17
C136	a_398_74##11	a_27_80##2	8.64026e-19
C137	a_27_80##3	a_225_74##10	3.29419e-19
C138	VPWR#3	a_1355_377##8	2.41547e-18
C139	a_225_74##5	a_398_74##11	2.87981e-17
C140	a_27_80##4	D#2	1.43176e-17
C141	a_398_74##13	a_596_81##4	1.17636e-17
C142	a_27_80##3	a_27_80##2	1.91052e-18
C143	VGND#17	a_225_74##5	1.88509e-18
C144	D#4	a_225_74##12	7.44115e-19
C145	a_779_380##7	a_596_81##2	2.94683e-17
C146	a_27_80##2	a_225_74##10	2.41804e-17
C147	a_1510_48##2	a_1355_377##7	1.05151e-19
C148	a_596_81##3	SET_B#3	1.92085e-17
C149	a_398_74##4	a_398_74##2	1.99865e-17
C150	a_1510_48##3	SET_B#5	4.82641e-18
C151	a_27_80##5	CLK#2	6.38368e-20
C152	a_1355_377##4	a_1355_377##7	1.80843e-18
C153	VPWR#5	a_1355_377##10	2.51111e-19
C154	a_1510_48##2	SET_B#4	1.82929e-17
C155	VPWR#8	a_225_74##9	7.7749e-20
C156	VPWR#5	SET_B#5	1.12339e-19
C157	a_27_80##3	CLK#1	1.3943e-17
C158	CLK#2	VGND#17	1.91538e-18
C159	VPWR#4	a_2113_74##3	4.13452e-18
C160	VGND#8	a_398_74#	5.22725e-18
C161	a_398_74##13	SET_B#1	3.89894e-19
C162	a_1510_48##2	a_1510_48##3	5.14215e-18
C163	a_398_74##9	a_1355_377##5	2.11902e-19
C164	a_779_380##4	a_596_81##3	5.48963e-18
C165	CLK#2	a_225_74##14	4.67305e-17
C166	a_27_80##2	CLK#1	1.19803e-17
C167	VPWR#5	VPWR#3	2.89327e-19
C168	VGND#8	a_225_74##9	4.01094e-18
C169	VPWR#4	a_1355_377#	5.53123e-18
C170	a_27_80##5	D#1	5.03465e-20
C171	a_1355_377##16	a_225_74##2	9.54523e-19
C172	a_225_74#	a_1510_48##2	1.2366e-17
C173	a_398_74##9	SET_B#4	2.9134e-18
C174	a_225_74##6	a_398_74##3	3.58539e-17
C175	VGND#4	SET_B#9	4.47906e-18
C176	a_398_74##11	D#1	2.9239e-19
C177	VPWR#4	a_1355_377##3	2.23014e-19
C178	a_398_74##9	a_1510_48##3	1.53629e-17
C179	VPWR#4	a_1355_377##8	5.8238e-18
C180	a_1355_377##7	a_1355_377##2	6.30415e-19
C181	a_1355_377##4	a_1355_377##8	1.4862e-17
C182	VPWR#16	a_779_380##3	1.07306e-18
C183	VPWR#4	a_398_74##13	6.80032e-19
C184	a_398_74##3	a_225_74##3	1.71371e-18
C185	a_27_80##3	D#3	1.60936e-17
C186	VPWR#4	a_1355_377##2	2.40491e-18
C187	a_398_74##9	a_225_74#	1.14279e-17
C188	a_225_74##14	D#1	6.60968e-18
C189	a_225_74##8	a_779_380##4	3.39377e-17
C190	VPWR#5	SET_B#6	5.48093e-18
C191	VPWR#4	a_1355_377##10	6.21401e-18
C192	a_2113_74##3	Q#1	1.20601e-17
C193	a_398_74##3	a_398_74##2	3.73808e-19
C194	VPWR#5	a_1510_48##2	7.05116e-20
C195	VGND#18	D#1	6.51714e-18
C196	a_398_74##9	a_398_74##6	4.02574e-19
C197	a_1355_377##6	a_2113_74#	1.7683e-17
C198	a_596_81##11	a_779_380##3	8.83352e-19
C199	a_27_80##4	D#1	1.10989e-17
C200	a_398_74##5	a_779_380##4	5.53771e-19
C201	a_398_74##9	a_596_81##4	1.62901e-19
C202	a_2113_74##3	VPWR#12	2.18021e-17
C203	a_398_74##7	a_225_74#	1.91224e-17
C204	a_398_74##13	a_1462_74#	3.18776e-19
C205	VGND#3	a_1355_377##3	3.93338e-19
C206	VGND#9	a_398_74##11	4.07848e-17
C207	a_1355_377##8	a_1355_377##2	1.01317e-18
C208	a_398_74##14	a_779_380#	5.93943e-19
C209	a_398_74##5	a_225_74##8	2.48059e-17
C210	VPWR#6	a_1510_48#	1.65861e-19
C211	a_2113_74##5	a_2113_74##2	5.81284e-19
C212	VGND#4	a_398_74##13	3.74107e-17
C213	a_596_81##11	a_398_74##4	1.63996e-17
C214	VGND#4	a_1355_377##4	4.57756e-19
C215	a_2113_74##7	a_2113_74##3	7.34845e-19
C216	a_2113_74##7	VPWR#12	6.56214e-17
C217	a_27_80##4	a_27_80##3	2.33267e-19
C218	a_225_74##5	a_225_74##6	2.66371e-17
C219	a_596_81##9	a_596_81#	1.46571e-19
C220	VPWR#5	a_1510_48#	7.79406e-18
C221	VPWR#12	a_1355_377#	4.76969e-17
C222	VGND#4	a_1355_377##3	2.85558e-18
C223	VPWR#5	a_398_74##9	3.59284e-19
C224	VPWR#4	a_225_74##2	3.26177e-18
C225	a_1355_377##7	a_1355_377##6	4.12631e-18
C226	VGND#5	SET_B#5	2.93628e-18
C227	D#7	CLK#1	5.17549e-19
C228	a_398_74##3	a_596_81##11	5.15274e-17
C229	Q#3	a_2113_74#	3.3657e-17
C230	VGND#4	a_1355_377##2	3.66259e-18
C231	VGND#7	a_398_74##2	2.19551e-19
C232	a_1355_377#	a_2113_74##7	2.68052e-17
C233	a_398_74##3	a_27_80#	1.55734e-17
C234	VGND#4	a_225_74##2	2.43223e-20
C235	a_596_81##5	SET_B#1	1.82579e-17
C236	VPWR#13	a_2113_74##3	5.85421e-19
C237	SET_B#4	a_1355_377##4	6.65557e-19
C238	SET_B#8	a_398_74##13	1.27032e-16
C239	VPWR#12	a_1355_377##8	9.73049e-19
C240	a_2113_74##5	a_2113_74##3	1.25379e-18
C241	a_398_74##3	a_398_74##15	4.42295e-18
C242	VPWR#6	a_398_74##8	3.03133e-19
C243	a_2113_74#	VGND#12	2.5764e-17
C244	SET_B#8	a_225_74##2	4.25606e-18
C245	CLK#1	a_225_74##10	4.63647e-17
C246	a_596_81##9	a_779_380#	2.16927e-17
C247	VPWR#6	a_398_74##7	8.24919e-20
C248	a_398_74##14	VPWR#7	6.93229e-17
C249	a_1355_377##9	a_1355_377##8	6.0579e-19
C250	a_2113_74##7	a_1355_377##8	1.25092e-18
C251	Q#3	a_1355_377##6	1.53034e-18
C252	VPWR#5	a_398_74##8	6.30824e-18
C253	VPWR#13	VPWR#12	1.26866e-18
C254	SET_B#8	a_596_81##6	1.29541e-18
C255	a_1355_377##5	a_1355_377##7	5.39838e-18
C256	VGND#5	a_1510_48##2	1.89299e-17
C257	a_398_74##13	a_1262_74#	1.35781e-17
C258	a_225_74##5	a_398_74##15	1.07209e-18
C259	VPWR#13	a_1355_377#	5.45735e-19
C260	a_398_74##14	VPWR#8	3.74121e-17
C261	a_1355_377##9	a_1355_377##10	4.72439e-18
C262	CLK#2	a_225_74##6	3.4171e-17
C263	a_2113_74##6	a_2113_74#	5.33484e-19
C264	a_225_74##5	VPWR#17	3.0267e-19
C265	a_1355_377##8	Q_N#1	1.68182e-17
C266	a_596_81##2	SET_B#1	2.26203e-17
C267	a_779_380##2	a_398_74##6	9.84375e-20
C268	D#3	CLK#1	4.69248e-18
C269	a_1355_377##4	a_1355_377##3	1.80035e-18
C270	a_225_74##12	a_225_74##5	1.88705e-18
C271	a_1355_377##6	VGND#12	2.33069e-17
C272	SET_B#6	a_1355_377##4	1.97459e-18
C273	VGND#9	a_225_74##14	1.18645e-17
C274	a_1510_48##4	a_1355_377#	8.00553e-19
C275	SET_B#8	a_596_81##3	3.44882e-19
C276	a_1510_48##5	a_1355_377##9	6.92092e-17
C277	a_779_380##2	a_596_81##4	1.58767e-19
C278	VGND#5	a_1510_48##5	5.1593e-17
C279	a_596_81##9	a_398_74#	1.6727e-17
C280	VPWR#6	a_225_74##2	5.75387e-17
C281	VPWR#13	a_1355_377##8	3.7216e-17
C282	a_398_74##14	VPWR#6	4.19876e-17
C283	a_779_380##2	SET_B#1	2.51513e-19
C284	a_2113_74##6	a_1355_377##6	4.50019e-17
C285	a_225_74##12	CLK#2	4.55959e-17
C286	a_1355_377##13	a_1517_508#	2.26225e-18
C287	SET_B#4	a_1355_377##5	6.96336e-18
C288	a_398_74##14	a_225_74##6	1.21258e-19
C289	VPWR#5	a_225_74##2	5.06921e-19
C290	a_398_74##9	VGND#5	7.05924e-18
C291	a_1510_48##4	a_1355_377##8	1.30657e-17
C292	a_1510_48##2	SET_B#6	8.52182e-18
C293	a_779_380##2	a_779_380#	3.40255e-18
C294	VGND#13	a_2113_74#	3.32761e-19
C295	VGND#12	a_1355_377##7	1.01331e-18
C296	a_27_80##3	D#7	7.09777e-17
C297	VPWR#15	a_1517_508#	2.37734e-20
C298	a_1355_377##10	VPWR#13	2.17484e-17
C299	a_779_380##2	a_398_74#	2.51756e-19
C300	Q_N#3	a_1355_377##6	1.31257e-18
C301	a_225_74##12	D#1	8.54118e-18
C302	a_2113_74##5	a_1355_377##8	1.69236e-19
C303	a_1510_48##5	SET_B#5	9.37701e-18
C304	a_596_81##9	a_225_74##9	1.29744e-18
C305	SET_B#12	a_1355_377##9	1.19351e-17
C306	a_27_80#	a_225_74##9	9.41383e-19
C307	a_779_380#	a_779_380##3	2.24948e-18
C308	VPWR#18	D#1	1.48524e-18
C309	VPWR#8	a_398_74##5	7.40226e-19
C310	a_1510_48##4	a_1355_377##10	5.1064e-17
C311	SET_B#8	a_398_74##2	1.77445e-18
C312	a_2113_74##6	a_1355_377##7	1.22239e-18
C313	VPWR#6	a_596_81##6	4.26065e-18
C314	a_398_74##9	a_1510_48#	1.26222e-17
C315	VGND#8	a_596_81##9	5.01871e-19
C316	a_398_74##13	VPWR#6	2.34962e-18
C317	a_398_74##13	a_1355_377##13	4.06466e-17
C318	VPWR#14	a_1355_377##8	2.41038e-19
C319	a_225_74##2	a_1510_48##2	1.8274e-17
C320	VGND#6	a_398_74##7	1.64203e-19
C321	VPWR#13	SET_B#6	6.77381e-19
C322	VGND#13	a_1355_377##6	5.4761e-19
C323	VPWR#6	SET_B#2	3.39817e-19
C324	a_398_74##15	a_225_74##9	6.96745e-20
C325	a_1510_48##3	SET_B#4	4.83686e-17
C326	a_1355_377##12	SET_B#5	3.61621e-18
C327	SET_B#9	a_1355_377##9	1.38932e-17
C328	a_1355_377##15	a_1355_377##10	7.12197e-19
C329	Q_N#3	a_1355_377##7	4.62954e-17
C330	CLK	a_225_74##6	9.61478e-18
C331	a_225_74##2	a_398_74##9	2.8325e-17
C332	VPWR#8	a_225_74##6	9.088e-20
C333	a_1510_48##4	SET_B#6	1.61155e-18
C334	a_1510_48##4	VPWR#13	4.88789e-17
C335	a_1510_48##2	a_1510_48##5	1.23245e-18
C336	VPWR#14	a_1355_377##10	4.74776e-19
C337	SET_B#12	SET_B#5	1.11106e-17
C338	a_596_81##11	a_596_81##10	5.56938e-19
C339	VPWR#13	a_1510_48#	2.38731e-19
C340	a_398_74##7	a_225_74##2	2.00014e-17
C341	a_1355_377##15	SET_B#6	3.06715e-17
C342	a_398_74##3	a_398_74#	7.02342e-19
C343	a_1355_377##7	VGND#13	1.34209e-17
C344	VPWR#8	a_225_74##3	2.52472e-17
C345	VPWR#6	SET_B#3	6.99828e-19
C346	a_398_74##14	a_225_74##3	3.64889e-17
C347	VPWR#7	a_596_81##2	4.36211e-20
C348	a_225_74##9	a_398_74##3	2.2203e-17
C349	VGND#6	a_596_81##5	1.56035e-18
C350	a_1510_48##2	a_1355_377##12	1.61915e-17
C351	a_225_74#	a_1510_48##3	5.03438e-17
C352	a_596_81##5	a_225_74##2	1.29999e-18
C353	Q_N#3	a_1355_377##5	7.38652e-19
C354	a_27_80##3	D#6	9.44792e-18
C355	SET_B#9	SET_B#5	1.94e-17
C356	SET_B#8	VPWR#4	5.04714e-18
C357	VPWR#6	a_596_81##2	7.97284e-19
C358	SET_B#6	VPWR#14	1.31662e-17
C359	a_398_74##3	a_225_74##7	5.7987e-20
C360	a_398_74##14	VPWR#15	1.0228e-17
C361	VPWR#8	a_398_74##2	1.27195e-19
C362	a_1510_48##7	a_1355_377##7	1.86213e-18
C363	a_1355_377##3	a_1355_377##2	4.00802e-19
C364	a_1355_377##15	a_1510_48#	1.26459e-18
C365	VGND#4	SET_B#8	4.55506e-18
C366	SET_B#2	a_225_74##2	8.41676e-19
C367	a_398_74##14	a_398_74##13	3.62764e-18
C368	a_1510_48##2	SET_B#12	2.06027e-17
C369	VGND#13	a_1355_377##5	3.33286e-18
C370	SET_B#2	a_596_81##6	1.39339e-17
C371	VPWR#7	a_596_81##3	1.14618e-18
C372	D#4	a_225_74##14	3.88593e-17
C373	a_1355_377##15	a_1510_48##4	3.2075e-17
C374	a_398_74##13	VPWR#15	8.03152e-17
C375	VPWR#14	VPWR#13	1.01008e-18
C376	a_1510_48#	VPWR#14	1.24169e-17
C377	a_596_81##2	a_225_74##2	9.75774e-19
C378	VGND#8	a_225_74##6	1.62668e-19
C379	a_398_74##14	a_398_74##2	3.73484e-19
C380	a_27_80##5	a_27_80#	2.18032e-18
C381	a_1355_377##13	SET_B#6	2.32743e-18
C382	a_1355_377##12	a_1355_377##8	5.86302e-20
C383	VPWR#4	a_2113_74##2	4.26631e-18
C384	a_398_74##6	a_225_74#	2.35444e-17
C385	VGND#6	a_225_74##2	3.06033e-20
C386	a_1510_48##2	SET_B#9	2.90239e-17
C387	CLK#2	a_225_74##7	1.39478e-18
C388	VGND#6	SET_B#2	3.08091e-19
C389	a_596_81##3	SET_B#2	1.02461e-17
C390	a_1510_48##7	a_1355_377##5	3.08686e-17
C391	a_398_74##14	a_779_380##7	7.65489e-17
C392	VPWR#5	VPWR#13	9.13942e-20
C393	VGND#4	a_2113_74##2	5.02969e-18
C394	VPWR#4	a_1355_377##9	4.55573e-18
C395	VGND#4	Q#3	1.94063e-17
C396	VGND#13	SET_B#4	3.44855e-19
C397	VPWR#14	a_398_74##8	2.37087e-18
C398	D#4	VGND#18	3.53915e-17
C399	a_1355_377##13	a_1510_48#	2.70983e-17
C400	VGND#4	a_1355_377##9	4.99792e-18
C401	a_1355_377##5	VGND#14	4.72374e-18
C402	VGND#8	a_398_74##2	5.15843e-20
C403	VGND#4	VGND#12	2.33838e-17
C404	D#1	CLK#3	3.49409e-18
C405	a_27_80##4	D#6	4.21982e-18
C406	a_779_380##7	a_398_74##13	5.66533e-17
C407	VPWR#7	a_779_380##4	3.83655e-19
C408	a_1510_48##7	SET_B#4	9.24512e-19
C409	VGND#7	a_596_81##2	3.96942e-19
C410	VPWR#4	a_1510_48##2	2.41496e-18
C411	VGND#4	a_2113_74##6	1.77875e-17
C412	a_1355_377##12	a_1355_377##10	4.77732e-19
C413	a_596_81##4	a_398_74##6	2.54309e-17
C414	a_1355_377##2	a_2113_74##2	3.05676e-17
C415	VPWR#14	a_1355_377##15	2.64975e-17
C416	a_398_74##13	a_1510_48##2	1.66099e-20
C417	VPWR#14	a_225_74##2	7.83613e-19
C418	a_398_74##14	VPWR#16	1.24881e-16
C419	Q	a_1355_377##3	6.88074e-20
C420	VGND#6	a_596_81##2	2.30939e-18
C421	a_779_380##3	a_596_81##3	2.48067e-17
C422	Q	a_1355_377##2	1.62462e-18
C423	VGND#4	a_1510_48##2	7.98632e-18
C424	a_1355_377##13	a_398_74##8	3.78607e-17
C425	VPWR#7	a_779_380##3	2.80896e-19
C426	VPWR#4	a_398_74##9	4.9457e-18
C427	VGND#4	Q_N#3	2.09546e-17
C428	Q#3	a_1355_377##2	2.28197e-19
C429	VPWR#15	a_1510_48#	1.79533e-19
C430	a_596_81##9	a_398_74##14	4.57556e-19
C431	a_27_80##4	D#4	3.58498e-17
C432	a_27_80##5	a_225_74##6	2.83251e-17
C433	SET_B#4	VGND#14	1.34734e-17
C434	a_596_81##9	a_225_74##6	2.05081e-19
C435	VGND#4	a_398_74##9	3.70427e-20
C436	VGND#4	VGND#13	1.48676e-17
C437	VGND#5	a_1355_377##7	8.04681e-19
C438	a_2113_74##5	a_1355_377##3	6.76068e-20
C439	a_1510_48##7	a_1510_48##3	1.67665e-19
C440	SET_B#4	a_1540_74#	8.35249e-18
C441	a_1355_377##13	a_225_74##2	8.62153e-17
C442	VPWR#15	a_225_74##3	4.5082e-20
C443	VGND#4	a_1510_48##7	2.63907e-17
C444	a_398_74##3	a_596_81##3	1.78292e-19
C445	a_1510_48##3	a_1540_74#	9.87534e-18
C446	VPWR#15	a_398_74##8	1.28293e-19
C447	a_1355_377##9	a_1355_377##4	5.89664e-17
C448	a_1355_377##12	SET_B#6	3.21054e-17
C449	a_398_74##13	a_1355_377##16	1.07791e-16
C450	SET_B#1	a_596_81##4	1.69228e-17
C451	a_398_74##13	a_398_74##9	2.7472e-18
C452	VGND#7	a_779_380##2	1.02215e-17
C453	VGND#3	a_1355_377##7	2.87256e-18
C454	a_1355_377##9	SET_B#5	7.28152e-18
C455	a_1355_377##9	a_1355_377##3	7.45466e-20
C456	a_596_81##5	SET_B#8	2.50065e-17
C457	a_1355_377##13	a_1355_377##15	7.13939e-18
C458	a_1355_377##13	a_596_81##6	6.84589e-18
C459	a_1355_377##15	VPWR#5	1.58825e-17
C460	a_1510_48##2	a_1355_377##9	3.96953e-18
C461	VPWR#15	a_225_74##2	5.02806e-18
C462	Q_N	a_1355_377##4	2.20936e-18
C463	SET_B#8	SET_B#2	2.26927e-17
C464	Q_N	a_1355_377##3	4.19786e-17
C465	a_2113_74##5	a_1355_377##2	4.96475e-17
C466	Q_N	a_1355_377##2	6.80803e-19
C467	VGND#5	a_1355_377##5	1.76163e-17
C468	a_2113_74##5	a_2113_74#	5.08532e-19
C469	a_1510_48##2	SET_B#5	7.17631e-17
C470	a_398_74##9	a_1355_377##9	1.39499e-18
C471	a_779_380##5	VGND#15	1.51116e-17
C472	VGND#12	a_1355_377##2	3.14041e-19
C473	a_398_74##11	a_225_74##6	1.54581e-17
C474	a_1510_48#	a_1517_508#	8.32237e-18
C475	a_596_81##2	SET_B#8	3.82272e-17
C476	a_1355_377##13	VPWR#14	6.44192e-18
C477	a_398_74##13	a_398_74##7	1.92188e-17
C478	a_596_81#	SET_B#1	3.96227e-17
C479	a_1510_48##3	a_1462_74#	7.45287e-18
C480	a_398_74##9	SET_B#5	1.71683e-18
C481	VPWR#9	a_225_74##6	8.77558e-20
C482	a_596_81##11	a_398_74##14	1.06319e-16
C483	a_225_74##5	a_225_74##10	7.80537e-18
C484	VGND#4	a_1355_377##16	9.03947e-18
C485	a_398_74##8	a_1517_508#	8.32237e-18
C486	a_1355_377##13	SET_B#3	1.33416e-18
C487	a_225_74#	a_1462_74#	9.92024e-19
C488	a_596_81##6	VPWR#15	1.66594e-17
C489	a_398_74##9	a_1510_48##2	9.96585e-17
C490	a_779_380##7	a_225_74##3	1.17433e-18
C491	SET_B#5	a_1355_377##4	2.2243e-17
C492	SET_B#8	a_779_380##3	1.70657e-18
C493	a_27_80##5	a_398_74##2	2.01282e-19
C494	VGND#16	VGND#15	1.80578e-18
C495	a_779_380##7	a_596_81##6	1.59562e-19
C496	a_225_74##2	a_1254_341#	2.65192e-17
C497	a_2113_74##2	Q#3	3.2052e-17
C498	a_1355_377##16	a_1510_48##3	2.75988e-18
C499	a_225_74##14	a_225_74##12	2.78462e-18
C500	a_2113_74##5	a_1355_377##6	6.85334e-19
C501	a_596_81##6	a_1254_341#	2.52676e-17
C502	VGND#5	SET_B#4	2.38855e-17
C503	a_398_74##4	SET_B#8	3.39885e-18
C504	SET_B#3	VPWR#15	1.52232e-17
C505	SET_B#8	a_1355_377##16	1.43481e-18
C506	D#1	CLK#1	6.69572e-18
C507	VGND#15	a_398_74##13	4.46493e-17
C508	a_779_380#	a_596_81#	2.71996e-18
C509	a_596_81##5	a_398_74##13	7.72169e-17
C510	a_2113_74##2	VGND#12	2.66448e-17
C511	VPWR#9	a_225_74##10	3.70366e-18
C512	VGND#15	SET_B#4	4.03789e-20
C513	a_779_380##7	SET_B#3	8.90366e-18
C514	Q_N#3	a_1355_377##4	1.51888e-19
C515	a_596_81##5	a_398_74##7	2.50606e-17
C516	a_398_74##6	a_1262_74#	1.46939e-17
C517	a_596_81##9	a_398_74##2	2.16377e-17
C518	VPWR#8	a_398_74##3	3.12649e-19
C519	VPWR	a_225_74##3	2.77014e-17
C520	a_2113_74##6	a_1355_377##2	5.76556e-18
C521	VPWR	a_398_74##2	4.82627e-19
C522	SET_B#8	VGND#15	3.70509e-18
C523	VGND#8	a_398_74##3	3.6479e-19
C524	a_1355_377##16	a_225_74#	3.20584e-17
C525	a_779_380##4	a_728_463#	8.27123e-18
C526	a_596_81##5	SET_B#2	2.83188e-17
C527	VGND#15	a_1510_48##3	5.53782e-20
C528	a_779_380##7	a_596_81##3	2.95576e-17
C529	a_2113_74##5	a_1355_377##7	6.49578e-19
C530	a_2113_74##5	Q	3.25268e-18
C531	VGND#3	VGND#12	1.52737e-19
C532	a_398_74#	a_779_380#	4.28306e-17
C533	VGND#5	a_1510_48##3	8.45749e-18
C534	a_398_74##13	SET_B#2	1.72242e-17
C535	a_596_81##2	a_596_81##5	4.47797e-18
C536	a_398_74##15	a_398_74##14	1.04206e-18
C537	SET_B#1	a_1061_74#	9.87534e-18
C538	a_1510_48##2	a_1355_377##4	1.37235e-18
C539	a_1355_377##3	Q_N#3	9.39551e-19
C540	a_596_81#	a_1061_74#	9.87534e-18
C541	VPWR#9	CLK#1	3.64259e-18
C542	a_596_81##2	SET_B#2	4.46849e-17
C543	a_596_81##3	VPWR#16	2.52413e-18
C544	Q_N	VPWR#3	1.77941e-17
C545	a_1355_377##13	VPWR#6	1.39769e-17
C546	a_1355_377##16	a_398_74##6	2.41964e-17
C547	VPWR#9	a_225_74##3	7.44449e-18
C548	a_779_380##7	a_779_380##4	3.67947e-19
C549	VPWR#15	a_1355_377##13	1.62296e-17
C550	VGND#15	a_225_74#	2.39945e-19
C551	a_596_81##2	a_779_380##2	1.01981e-16
C552	a_596_81##2	a_398_74##14	6.63395e-18
C553	VGND#3	Q_N	1.17475e-18
C554	VPWR#15	a_225_74##8	3.46636e-20
C555	VPWR#9	CLK#2	2.30914e-19
C556	a_1355_377##4	VGND#13	2.56702e-18
C557	VPWR#16	a_779_380##4	2.61504e-17
C558	a_225_74##9	a_398_74#	1.01331e-17
C559	a_596_81##2	a_779_380##3	9.71073e-17
C560	a_398_74##4	SET_B#2	2.59596e-19
C561	Q_N#3	a_1355_377##2	1.55285e-19
C562	a_596_81##2	a_398_74##13	2.59848e-18
C563	Q_N	a_2113_74##5	4.60134e-17
C564	a_1355_377##13	VPWR#5	2.17881e-17
C565	a_225_74##14	a_225_74##6	1.97978e-19
C566	a_596_81##11	a_596_81##3	5.00426e-22
C567	VGND#5	a_225_74#	4.77317e-18
C568	CLK	a_27_80##5	3.23662e-18
C569	a_779_380##2	a_779_380##3	3.28596e-18
C570	a_1510_48##5	Q_N	2.62451e-17
C571	a_398_74##4	a_596_81##2	2.29092e-17
C572	a_1355_377##16	a_596_81##4	8.73417e-19
C573	VGND#17	CLK	2.09657e-17
C574	a_779_380#	a_748_81#	8.35249e-18
C575	a_398_74#	a_748_81#	8.35249e-18
C576	VPWR	VPWR#9	1.02364e-16
C577	VGND#9	a_225_74##5	6.11805e-19
C578	a_398_74##4	a_779_380##2	3.00062e-19
C579	VPWR	VPWR#7	1.06242e-16
C580	VPWR#9	D#3	6.46757e-19
C581	VGND#15	a_398_74##6	3.50316e-18
C582	a_596_81##9	a_596_81##2	2.7073e-18
C583	VPWR	VPWR#6	1.21281e-16
C584	VPWR#16	a_225_74##8	9.67458e-19
C585	a_27_80##3	VPWR#9	1.79039e-18
C586	a_398_74##4	a_779_380##3	2.09117e-17
C587	VGND#6	a_398_74##13	5.11203e-17
C588	a_596_81##11	a_779_380##4	1.23451e-18
C589	a_398_74##9	a_1355_377##4	2.50479e-19
C590	a_1355_377##3	VGND#13	1.93315e-18
C591	VGND#6	a_398_74##6	4.4876e-18
C592	Q#3	Q	2.74873e-18
C593	a_398_74##14	a_779_380##2	3.0186e-19
C594	a_596_81##11	a_225_74##6	3.17051e-19
C595	a_1510_48##5	a_1355_377##4	2.61188e-17
C596	a_398_74##3	a_779_380##3	5.00124e-18
C597	VPWR#3	a_1355_377##3	3.89713e-19
C598	a_225_74##7	a_225_74##9	3.9119e-18
C599	VPWR#7	a_225_74##3	4.34585e-17
C600	a_225_74##6	a_225_74##3	1.16817e-19
C601	a_779_380##2	a_398_74##13	9.91431e-19
C602	a_398_74##4	a_398_74##3	2.13114e-19
C603	a_2113_74##5	VPWR#12	1.54492e-18
C604	a_1510_48##5	a_1355_377##7	4.27193e-18
C605	D#4	CLK#3	2.77332e-19
C606	VGND#3	Q_N#3	2.02818e-17
C607	VGND#15	a_596_81##4	4.21058e-17
C608	VGND#5	a_398_74##6	9.45617e-20
C609	a_596_81##11	a_225_74##8	3.12612e-17
C610	VPWR#4	a_2113_74##7	1.37264e-17
C611	a_398_74##15	a_779_380##4	4.19021e-20
C612	VGND	a_225_74##6	2.4512e-18
C613	a_596_81##9	a_779_380##2	4.48875e-17
C614	a_596_81##3	a_225_74##3	1.9195e-17
C615	a_596_81##10	VGND#16	1.23099e-17
C616	VGND#5	VGND#13	3.48875e-18
C617	VGND	a_398_74##2	2.3131e-19
C618	VGND#9	CLK#2	7.45638e-19
C619	VGND#8	a_596_81##10	1.2026e-17
C620	VPWR	a_398_74##14	6.44461e-17
C621	VGND#5	a_398_74##13	4.11215e-17
C622	a_27_80#	a_225_74##8	7.64597e-19
C623	VPWR	a_398_74##13	1.06485e-17
C624	a_27_80##2	VPWR#9	8.26734e-19
C625	a_398_74##14	a_779_380##3	6.96699e-17
C626	CLK	a_225_74##12	1.40852e-17
C627	CLK#3	a_225_74##7	3.87402e-17
C628	a_225_74##5	CLK#2	1.87098e-18
C629	VGND#6	a_596_81##4	3.87087e-18
C630	a_596_81##11	a_398_74##5	1.12151e-17
C631	a_1510_48##5	a_1355_377##3	8.70174e-18
C632	a_398_74##14	a_225_74##2	8.84228e-18
C633	VGND#7	a_596_81##9	2.56396e-18
C634	Q	Q#1	5.93566e-18
C635	a_398_74##15	a_225_74##8	2.05228e-19
C636	a_596_81##11	a_225_74##3	8.41925e-19
C637	VPWR#12	Q	8.49262e-17
C638	VPWR	a_27_80##3	1.14084e-17
C639	VGND#15	SET_B#1	1.45549e-17
C640	VPWR#4	VPWR#13	1.51668e-17
C641	VPWR	a_27_80##2	6.54785e-18
C642	a_2113_74##7	Q	3.97599e-18
C643	a_225_74##5	D#1	1.57952e-19
C644	VPWR#3	a_1355_377##2	1.63441e-19
C645	VGND#8	a_398_74##11	5.27295e-17
C646	a_2113_74##5	Q#3	3.52497e-18
C647	a_1510_48##5	a_1355_377##5	3.25544e-17
C648	a_27_80#	a_398_74##5	2.29445e-17
C649	D#1	CLK#2	1.16334e-17
C650	a_779_380##5	a_596_81##4	1.78007e-18
C651	VPWR	D#7	4.30817e-18
C652	a_398_74##13	a_225_74##2	1.4858e-17
C653	a_27_80#	a_225_74##6	1.38616e-17
C654	a_1510_48##4	VPWR#4	4.55878e-17
C655	VGND#5	a_596_81##4	5.30322e-20
C656	a_596_81##9	a_779_380##3	2.32884e-19
C657	a_398_74##9	a_1462_74#	9.15408e-19
C658	a_398_74##9	a_1510_48##7	1.34193e-18
C659	VGND#16	a_596_81##9	2.72748e-17
C660	VPWR#6	a_225_74##3	3.27683e-18
C661	a_225_74##6	a_398_74##2	6.344e-19
C662	a_398_74##15	a_398_74##5	6.47578e-18
C663	VGND#5	a_1510_48##7	2.99949e-17
C664	a_1355_377##15	VPWR#4	2.40006e-17
C665	Q_N	VPWR#12	3.62001e-18
C666	a_1355_377##16	a_1510_48##2	5.2642e-19
C667	Q_N	a_2113_74##7	7.05147e-17
C668	VGND#16	a_596_81##4	2.33728e-19
C669	D#2	CLK#3	3.66943e-18
C670	Q_N	Q_N#1	1.21579e-17
C671	VGND#15	a_596_81#	2.31553e-18
C672	a_27_80#	a_225_74##10	1.16439e-18
C673	VPWR#13	Q_N	2.51122e-17
C674	VGND#7	VGND#6	2.33703e-19
C675	a_1510_48##4	Q_N	3.97301e-17
C676	a_1355_377##4	VNB	9.9872e-17
C677	CLK	a_225_74##7	2.44456e-18
C678	a_1510_48##5	a_1355_377##2	3.83381e-21
C679	a_1355_377##3	VNB	4.71873e-17
C680	a_1355_377##2	VNB	6.28527e-17
C681	a_225_74##6	VNB	1.28138e-16
C682	VGND#6	SET_B#1	8.47668e-18
C683	a_779_380#	a_398_74##2	2.99983e-18
C684	a_225_74##3	VNB	1.88642e-16
C685	a_779_380##4	a_225_74##3	1.67677e-17
C686	a_398_74##11	VGND#16	2.29931e-18
C687	a_779_380##5	SET_B#1	4.08723e-18
C688	a_398_74##2	VNB	5.90032e-17
C689	VGND	VGND#9	9.61513e-17
C690	VGND	VGND#7	8.71369e-17
C691	a_1510_48##5	a_1355_377##12	5.76335e-18
C692	VGND	VGND#6	9.20115e-17
C693	a_398_74##7	a_1262_74#	4.67816e-19
C694	VGND#13	VPWR#13	9.27981e-19
C695	a_225_74##10	a_398_74##15	2.66779e-17
C696	a_1510_48##5	SET_B#4	1.02516e-19
C697	VGND#12	a_2113_74##5	2.10344e-18
C698	a_1355_377##12	a_1355_377##5	2.43533e-18
C699	a_398_74##13	a_596_81##6	3.05741e-17
C700	a_596_81##9	a_398_74##4	4.68357e-17
C701	a_27_80#	CLK#1	1.9908e-19
C702	a_1355_377##16	a_398_74##9	6.52672e-17
C703	VGND#16	SET_B#1	6.68952e-19
C704	VPWR#17	a_225_74##10	4.01423e-17
C705	a_27_80#	a_225_74##3	1.97546e-18
C706	VGND#15	a_779_380#	4.37822e-19
C707	VPWR#4	a_1355_377##13	4.32772e-17
C708	VGND	a_398_74##13	1.69199e-17
C709	VGND	a_596_81##9	9.41734e-18
C710	VGND#5	VGND#14	1.15084e-17
C711	a_27_80##2	a_596_81##11	4.56484e-18
C712	a_398_74##14	a_398_74##3	5.68724e-19
C713	Q_N	a_1355_377##7	4.98174e-18
C714	a_398_74##15	CLK#1	1.6747e-18
C715	a_779_380##5	a_596_81#	3.87635e-17
C716	VPWR	a_779_380##7	7.81648e-18
C717	a_225_74##12	a_225_74##10	8.02376e-19
C718	a_225_74##6	a_398_74##15	9.75298e-18
C719	a_398_74##14	SET_B#3	7.67078e-19
C720	VPWR	a_596_81##11	9.9537e-18
C721	VPWR#9	VNB	4.3815e-17
C722	VPWR	a_27_80#	1.21928e-17
C723	VPWR#7	VNB	3.27224e-17
C724	VPWR#6	VNB	5.18431e-17
C725	VPWR	a_398_74##15	3.5306e-17
C726	VPWR#5	VNB	5.38443e-17
C727	Q	a_2113_74##3	3.8975e-17
C728	VPWR#3	VNB	3.11506e-17
C729	VPWR#17	CLK#1	3.68368e-17
C730	VPWR	a_225_74##12	5.81722e-18
C731	Q	a_1355_377#	4.57717e-18
C732	VGND#6	a_596_81#	5.7678e-18
C733	VGND	D#4	4.49691e-18
C734	Q	a_1355_377##8	3.17676e-19
C735	VGND#9	VNB	4.40488e-17
C736	VGND#7	VNB	4.64678e-17
C737	VPWR	a_27_80##6	1.66012e-17
C738	VGND#6	VNB	6.30978e-17
C739	VGND#5	VNB	6.213e-17
C740	VGND#3	VNB	3.20632e-17
C741	VGND#4	a_1355_377##13	1.01264e-18
C742	a_398_74##13	SET_B#3	2.19907e-17
C743	VGND#16	a_596_81#	3.10857e-18
C744	a_1355_377##16	a_398_74##7	4.65235e-18
C745	a_2113_74##5	VNB	2.47917e-18
C746	a_398_74##15	D#3	1.07124e-18
C747	a_596_81##9	a_398_74##3	8.58237e-17
C748	a_1510_48##5	VNB	1.49882e-17
C749	a_225_74##12	CLK#1	3.36496e-17
C750	VGND	VGND#15	1.83274e-17
C751	a_596_81##9	a_596_81##10	4.96267e-19
C752	a_1355_377##12	VNB	1.72129e-17
C753	a_398_74##11	a_596_81##10	2.95689e-17
C754	SET_B#12	VNB	7.67789e-19
C755	VGND	a_779_380##5	1.33195e-17
C756	VGND	VGND#16	1.75793e-17
C757	a_225_74##3	a_225_74##8	6.06216e-19
C758	SET_B#9	VNB	3.96583e-18
C759	Q_N	a_1355_377#	6.33948e-18
C760	a_2113_74##2	VPWR#12	1.78479e-17
C761	a_27_80##6	a_225_74##10	3.65752e-20
C762	VGND	a_596_81##10	1.35011e-17
C763	Q_N	a_1355_377##8	2.64515e-17
C764	a_398_74##14	VNB	3.17954e-17
C765	VGND	a_27_80##5	7.97241e-18
C766	a_398_74##13	VNB	1.22944e-17
C767	VGND	a_398_74##11	4.59214e-17
C768	Q_N	a_1355_377##10	2.16431e-18
C769	a_596_81##9	VNB	1.7316e-17
C770	VPWR	a_779_380#	6.92022e-19
C771	a_27_80##2	a_27_80#	3.44114e-18
C772	VPWR#4	VPWR#6	2.26574e-17
C773	Q_N	SET_B#6	6.88078e-20
C774	VGND	a_225_74##14	2.26709e-17
C775	VPWR#17	D#3	3.80048e-18
C776	VGND	a_27_80##4	1.60941e-17
C777	VGND#7	a_779_380#	3.55781e-18
C778	VPWR#18	CLK#1	6.21941e-18
C779	a_27_80##3	VNB	6.06573e-17
C780	a_27_80##2	VNB	7.48237e-21
C781	a_398_74##14	a_596_81##3	2.05433e-17
C782	SET_B#8	a_1355_377##13	1.51735e-17
C783	a_398_74##2	a_225_74##8	5.09061e-18
C784	D#7	VNB	3.94718e-18
C785	D#6	VNB	5.20468e-19
C786	VPWR#4	VPWR#5	1.06917e-16
C787	D#4	VNB	1.78253e-18
C788	a_27_80##3	a_398_74##15	1.07059e-21
C789	Q#3	VNB	4.9677e-17
C790	VGND#12	VNB	6.55435e-18
C791	VGND#16	a_779_380#	3.27516e-17
C792	a_398_74##15	a_225_74##3	2.3155e-17
C793	a_2113_74##6	VNB	1.11388e-17
C794	VPWR#4	Q	1.96956e-17
C795	Q_N#3	VNB	1.00025e-17
C796	VGND	a_779_380##7	2.07898e-18
C797	VGND#13	VNB	5.84048e-18
C798	VGND#4	Q	1.68264e-18
C799	a_1510_48##7	VNB	3.3926e-18
C800	VGND#12	Q#3	5.37595e-17
C801	a_27_80##6	CLK#1	4.0716e-19
C802	VPWR	a_225_74##2	8.03361e-18
C803	a_398_74##11	a_27_80##5	7.39867e-17
C804	VGND#15	VNB	1.8353e-18
C805	VPWR	a_596_81##6	3.92112e-18
C806	VGND	a_225_74##12	2.43414e-18
C807	a_398_74##13	a_596_81##3	2.68348e-18
C808	a_596_81##10	a_596_81#	1.48528e-19
C809	a_779_380##5	VNB	3.21849e-18
C810	VGND#16	VNB	3.1293e-18
C811	VPWR#4	VPWR#3	5.86391e-17
C812	a_2113_74##2	Q	1.95077e-17
C813	a_596_81##10	VNB	9.77914e-19
C814	a_27_80##5	VNB	5.42946e-18
C815	a_225_74##6	a_398_74##5	1.70451e-17
C816	VPWR#18	D#3	2.87644e-17
C817	a_398_74##11	VNB	1.65089e-17
C818	VPWR	a_779_380##4	2.52836e-18
C819	VPWR#4	Q_N	1.90552e-17
C820	VGND#17	VNB	6.73668e-19
C821	Q_N#3	a_2113_74##5	4.2097e-18
C822	VPWR#17	a_225_74##6	4.9433e-19
C823	a_225_74##14	VNB	1.84517e-17
C824	VGND#4	Q_N	3.64013e-18
C825	VGND#18	VNB	2.87317e-18
C826	a_27_80##4	VNB	5.2394e-17
C827	a_1355_377#	a_2113_74##3	3.82559e-17
C828	VPWR#12	VNB	3.25482e-18
C829	VPWR	a_225_74##10	3.37269e-18
C830	SET_B#8	VPWR#15	3.24218e-18
C831	a_2113_74##7	VNB	6.63828e-18
C832	VPWR	CLK#1	4.97433e-18
C833	VPWR#13	VNB	1.48669e-18
C834	VGND	a_596_81##4	6.0354e-19
C835	a_225_74##9	a_225_74##3	1.20235e-19
C836	a_1510_48##4	VNB	1.56155e-17
C837	VPWR	D#3	2.03758e-18
C838	a_398_74##2	a_225_74##3	4.28043e-19
C839	a_596_81##5	VGND#15	4.71206e-17
C840	a_1355_377##15	VNB	7.56363e-18
C841	a_27_80##2	a_398_74##15	3.41099e-17
C842	VPWR#14	VNB	3.19277e-18
C843	VGND	a_596_81#	2.8201e-19
C844	CLK	a_225_74##5	2.98123e-17
C845	VGND	a_779_380#	5.34542e-18
C846	a_1355_377##13	VNB	5.9663e-18
C847	VGND	a_398_74#	1.11422e-17
C848	CLK	CLK#2	5.77062e-18
C849	VPWR#15	VNB	6.36605e-18
C850	VGND	a_225_74##9	1.67592e-18
C851	a_27_80##6	D#3	1.27588e-17
C852	a_779_380##7	VNB	5.60841e-19
C853	VGND	a_225_74##7	5.03024e-18
C854	VPWR#16	VNB	3.3075e-18
C855	VGND	CLK#3	1.35769e-18
C856	a_596_81##11	VNB	6.80301e-18
C857	VGND	D#2	5.06382e-18
C858	SET_B#8	VPWR	2.37646e-17
C859	a_27_80#	VNB	9.48477e-19
C860	a_779_380##7	SET_B#8	1.98233e-17
C861	a_398_74##15	VNB	1.7201e-17
C862	VPWR	VPWR#8	6.85682e-17
C863	VGND#16	a_398_74#	4.23539e-18
C864	a_225_74##12	VNB	9.15377e-18
C865	VPWR#18	VNB	4.83201e-18
C866	a_27_80##6	VNB	2.40834e-17
C867	a_398_74##14	a_779_380##4	2.48426e-17
C868	a_1355_377##8	a_2113_74##3	3.19786e-19
C869	a_2113_74#	VNB	3.16214e-17
C870	a_1355_377##6	VNB	3.20259e-17
C871	a_1355_377##7	VNB	3.06768e-17
C872	a_1355_377##5	VNB	5.33848e-17
C873	a_2113_74##6	Q#3	1.83328e-18
C874	SET_B#4	VNB	3.28055e-17
C875	a_27_80##2	a_398_74##3	6.54464e-17
C876	a_1510_48##3	VNB	2.94309e-17
C877	a_596_81##10	a_779_380#	3.98569e-18
C878	a_225_74#	VNB	4.50614e-17
C879	a_225_74##9	a_398_74##2	1.64231e-18
C880	a_398_74##6	VNB	2.69987e-17
C881	a_596_81##4	VNB	2.50805e-17
C882	a_225_74##3	a_398_74##5	1.45907e-17
C883	SET_B#1	VNB	3.85447e-17
C884	a_596_81#	VNB	2.90142e-17
C885	a_779_380#	VNB	3.8123e-17
C886	a_398_74#	VNB	3.3728e-17
C887	a_225_74##7	a_225_74##6	6.67824e-18
C888	a_225_74##9	VNB	5.3328e-17
C889	a_225_74##7	VNB	2.77166e-17
C890	CLK#3	VNB	3.4076e-17
C891	VPWR	a_596_81##2	7.42816e-18
C892	D#2	VNB	3.32106e-17
C893	VPWR	a_779_380##2	2.00416e-19
C894	a_398_74##13	a_779_380##4	1.23622e-19
C895	a_398_74##11	a_596_81#	2.43917e-19
C896	a_27_80##3	a_225_74##6	2.93415e-19
C897	a_2113_74##3	VNB	4.59798e-17
C898	a_1355_377#	VNB	4.64856e-17
C899	VPWR	a_779_380##3	3.78999e-18
C900	a_1355_377##8	VNB	4.32422e-17
C901	a_1355_377##10	VNB	4.95825e-17
C902	a_1355_377##8	a_1355_377#	6.76088e-18
C903	SET_B#6	VNB	4.53185e-17
C904	a_1510_48#	VNB	3.21095e-17
C905	VPWR	a_398_74##3	5.64282e-18
C906	a_1355_377##9	a_1510_48##4	8.55055e-17
C907	VGND	SET_B#8	2.35439e-17
C908	a_398_74##8	VNB	2.27327e-17
C909	a_225_74##2	VNB	1.48076e-16
C910	VPWR	a_225_74##5	4.22829e-18
C911	a_596_81##6	VNB	2.79295e-17
C912	VGND	VGND#8	6.41447e-17
C913	SET_B#3	VNB	2.74986e-17
C914	VPWR	CLK#2	1.67712e-18
C915	a_27_80#	a_596_81##11	3.8187e-17
C916	a_596_81##3	VNB	4.05234e-17
C917	a_779_380##4	VNB	2.63335e-17
C918	a_1510_48##4	a_1355_377##5	1.19123e-19
C919	a_225_74##8	VNB	2.66525e-17
C920	a_27_80##2	VPWR#17	3.45535e-17
C921	a_398_74##5	VNB	2.93042e-17
C922	a_225_74##10	VNB	3.28154e-17
C923	CLK#1	VNB	4.21611e-17
C924	VGND#16	a_225_74##9	7.88008e-19
C925	D#3	VNB	4.42977e-17
C926	VPWR#17	a_225_74##3	3.783e-19
C927	VGND	a_596_81##5	3.79459e-18
C928	VPWR#4	VNB	2.74895e-16
C929	VGND#4	VNB	2.51433e-16
C930	VGND	a_596_81##2	1.19301e-17
C931	SET_B#8	VNB	6.07768e-18
C932	VGND	a_779_380##2	1.03595e-17
C933	VPWR#8	VNB	2.93822e-17
C934	VGND#17	a_398_74##11	6.1907e-17
C935	a_225_74##14	a_27_80##5	5.05179e-19
C936	VGND#8	VNB	3.78047e-17
C937	VGND	a_779_380##3	3.88583e-18
C938	a_2113_74##2	VNB	4.27381e-17
C939	VGND	a_398_74##4	4.04071e-18
C940	a_1355_377##9	VNB	5.93845e-18
C941	a_596_81##10	a_398_74#	3.2525e-17
C942	VGND	a_398_74##3	4.80142e-18
C943	SET_B#5	VNB	7.67642e-17
C944	a_1510_48##2	VNB	7.05094e-17
C945	VGND	a_225_74##5	3.91006e-18
C946	a_398_74##9	VNB	3.43118e-17
C947	VGND	CLK#2	3.65271e-18
C948	a_2113_74##6	VGND#12	5.10573e-17
C949	a_398_74##7	VNB	2.05122e-17
C950	VGND	D#1	8.60728e-19
C951	a_596_81##5	VNB	3.30351e-17
C952	a_27_80##3	a_225_74##12	5.46639e-17
C953	SET_B#2	VNB	4.33363e-17
C954	a_398_74##14	a_225_74##8	1.33842e-17
C955	a_596_81##2	VNB	7.8443e-17
C956	a_225_74##10	a_225_74##6	3.35808e-17
C957	a_779_380##2	VNB	5.95456e-17
C958	a_225_74##5	a_27_80##2	8.99453e-17
C959	a_779_380##3	VNB	6.06844e-17
C960	a_225_74##12	a_225_74##6	4.81899e-19
C961	a_398_74##4	VNB	4.93708e-18
C962	a_398_74##3	VNB	4.96943e-17
C963	a_398_74##11	a_779_380#	3.8171e-19
C964	a_225_74##5	VNB	3.4608e-18
C965	CLK#2	VNB	3.62214e-17
C966	D#1	VNB	1.08484e-16
C967	SET_B#8	VPWR#6	5.46767e-18
C968	a_596_81##11	a_398_74##15	8.4801e-18
C969	SET_B#12	a_1355_377##4	3.33022e-18
C970	a_1355_377##10	a_1355_377##8	3.06903e-17
C971	VPWR	CLK	1.55405e-18
C972	SET_B#12	a_1355_377##12	2.158e-17
C973	a_398_74##13	a_225_74##8	4.34369e-20
C974	a_27_80##5	a_398_74#	1.64977e-19
C975	a_1510_48##5	SET_B#9	4.3063e-17
C976	VGND	CLK	1.60028e-18
C977	VGND#5	VGND#3	1.12507e-18
C978	CLK	VNB	5.93093e-19
C979	Q	VNB	6.77474e-17
C980	a_225_74##12	a_27_80##2	2.94703e-17
C981	a_225_74##14	a_398_74##11	2.3496e-18
C982	Q_N	VNB	2.56261e-17
C983	VPWR	VNB	2.80398e-16
C984	VGND	VNB	3.12873e-16
C985	a_225_74##9	a_596_81##10	1.49851e-18
C986	VPWR#14	SET_B#5	5.48432e-19
C987	VPWR#10	VPWR#9	1.34865e-18
C988	VPWR#10	VNB	4.99904e-17
C989	VPWR	VPWR#10	1.01738e-16
C990	VPWR#10	D#3	5.29748e-18
C991	a_27_80##3	VPWR#10	3.36789e-18
C992	VPWR#10	a_225_74##3	5.11327e-20
C993	a_27_80##6	VPWR#10	1.76169e-17
C994	SET_B	a_1355_377##13	3.51144e-17
C995	VGND#2	Q#3	2.08536e-17
C996	VGND#10	a_27_80##4	1.57634e-17
C997	VGND#2	a_2113_74#	4.79548e-18
C998	SET_B	a_1510_48##5	5.51421e-18
C999	SET_B	VPWR#14	1.48368e-18
C1000	SET_B	a_398_74##9	3.65124e-17
C1001	Q	VPWR#2	2.08684e-17
C1002	VGND#2	a_1355_377##2	6.94238e-19
C1003	SET_B	VNB	2.35869e-18
C1004	VGND#2	VNB	5.92441e-17
C1005	VPWR#4	VPWR#2	1.18751e-16
C1006	SET_B	a_1510_48##2	3.89386e-17
C1007	SET_B	a_398_74##13	1.48074e-18
C1008	VGND#2	a_1355_377##6	3.02668e-18
C1009	SET_B	a_1355_377##3	4.59372e-21
C1010	SET_B	a_1510_48##4	5.47208e-19
C1011	SET_B	SET_B#5	1.6806e-18
C1012	VGND	VGND#10	9.91379e-17
C1013	VPWR#2	a_2113_74##3	8.34724e-18
C1014	VGND#2	a_2113_74##2	8.35957e-19
C1015	SET_B	a_1355_377##9	5.79968e-18
C1016	VGND#4	VGND#2	1.00422e-16
C1017	VGND#3	VGND#2	3.08356e-19
C1018	VGND#10	VGND#9	1.00735e-18
C1019	VPWR#3	VPWR#2	3.94235e-19
C1020	VPWR#2	a_1355_377#	3.52059e-18
C1021	VGND#10	a_225_74##7	2.6975e-19
C1022	VGND#2	a_2113_74##6	2.0793e-17
C1023	VGND#10	VNB	5.24304e-17
C1024	SET_B	Q_N	2.0035e-18
C1025	VPWR#2	a_1355_377##8	5.79804e-19
C1026	VGND#10	VGND#17	1.22009e-18
C1027	SET_B	VPWR#5	5.03306e-18
C1028	a_2113_74##7	VPWR#2	7.48271e-18
C1029	VGND#2	a_2113_74##5	2.1385e-19
C1030	VGND#10	CLK#3	1.43175e-18
C1031	VPWR#2	VNB	5.89553e-17
C1032	SET_B	VPWR#6	4.25254e-19
C1033	VGND#10	a_225_74##14	1.22026e-17
C1034	a_2113_74##2	VPWR#2	3.89716e-19
C1035	SET_B	SET_B#12	2.29762e-17
C1036	VGND#10	D#2	9.89523e-18
C1037	VGND#4	SET_B	2.69065e-17
C1038	a_2113_74##5	VPWR#2	2.61146e-19
C1039	VPWR#13	VPWR#2	2.22118e-20
C1040	VPWR#2	a_1355_377##2	1.20606e-18
C1041	SET_B	a_1355_377##16	2.72179e-19
C1042	SET_B	a_225_74##2	2.75558e-18
C1043	SET_B	VGND#5	8.11804e-18
C1044	SET_B	VPWR#4	2.78844e-17
C1045	SET_B	a_1355_377##12	1.15664e-17
C1046	VGND#2	a_1355_377##3	1.41701e-19
*
*
.ENDS sky130_fd_sc_hs__dfsbp_1
*
