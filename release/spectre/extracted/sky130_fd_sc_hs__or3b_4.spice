* Extracted by Quantus, converted by sky130cad/quantus.py
*
*
*
*                       LINUX           Wed Nov 18 09:06:57 2026
*
*
*
*  PROGRAM  advgen
*
*  Name           : advgen - Quantus - (64-bit)
*  Version        : 25.1.0-p047
*  Build Date     : Thu Dec 11 23:20:30 PST 2025
*
*  HSPICE LIBRARY
*
*  OPERATING_TEMPERATURE 150
*  QRC_TECH_DIR <path>/tech
*
*
*

*
.SUBCKT sky130_fd_sc_hs__or3b_4 VNB VPB VGND VPWR X C_N A B
*
*
*  caps2d version: 10
*
*
*       TRANSISTOR CARDS
*
*
XM6 a_27_392##8 C_N#2 VGND#10 VNB sky130_fd_pr__nfet_01v8_lvt l=0.15 w=0.64 ad=0.1824 as=0.66075 pd=1.85 ps=3.58
XM11 a_409_392##18 a_27_392# VGND#9 VNB sky130_fd_pr__nfet_01v8_lvt l=0.15 w=0.74 ad=0.2072 as=0.259 pd=2.04 ps=2.18
XM8 VGND#9 B#3 a_409_392##17 VNB sky130_fd_pr__nfet_01v8_lvt l=0.15 w=0.74 ad=0.259 as=0.2072 pd=2.18 ps=2.04
XM12 a_409_392##17 A#5 VGND#6 VNB sky130_fd_pr__nfet_01v8_lvt l=0.15 w=0.74 ad=0.2072 as=0.2664 pd=2.04 ps=2.2
XM1 VGND#6 a_409_392##10 X#3 VNB sky130_fd_pr__nfet_01v8_lvt l=0.15 w=0.74 ad=0.2664 as=0.2257 pd=2.2 ps=2.09
XM2 VGND#5 a_409_392##8 X#3 VNB sky130_fd_pr__nfet_01v8_lvt l=0.15 w=0.74 ad=0.2442 as=0.2257 pd=2.14 ps=2.09
XM4 X#1 a_409_392##6 VGND#5 VNB sky130_fd_pr__nfet_01v8_lvt l=0.15 w=0.74 ad=0.2072 as=0.2442 pd=2.04 ps=2.14
XM13 X#1 a_409_392##5 VGND#1 VNB sky130_fd_pr__nfet_01v8_lvt l=0.15 w=0.74 ad=0.2072 as=0.2109 pd=2.04 ps=2.05
XM10 a_27_392##10 C_N#1 VPWR#9 VPB sky130_fd_pr__pfet_01v8 l=0.15 w=1 ad=0.29 as=0.36 pd=2.58 ps=2.72
XM3 a_217_392##2 A#1 VPWR#9 VPB sky130_fd_pr__pfet_01v8 l=0.15 w=1 ad=0.3 as=0.36 pd=2.6 ps=2.72
XM9 a_307_392##2 B#1 a_217_392##2 VPB sky130_fd_pr__pfet_01v8 l=0.15 w=1 ad=0.36 as=0.3 pd=2.72 ps=2.6
XM18 a_409_392##15 a_27_392##6 a_307_392##2 VPB sky130_fd_pr__pfet_01v8 l=0.15 w=1 ad=0.325 as=0.36 pd=2.65 ps=2.72
XM14 a_307_392# a_27_392##5 a_409_392##15 VPB sky130_fd_pr__pfet_01v8 l=0.15 w=1 ad=0.3 as=0.325 pd=2.6 ps=2.65
XM17 a_217_392# B#5 a_307_392# VPB sky130_fd_pr__pfet_01v8 l=0.15 w=1 ad=0.36 as=0.3 pd=2.72 ps=2.6
XM7 VPWR#8 A#3 a_217_392# VPB sky130_fd_pr__pfet_01v8 l=0.15 w=1 ad=0.3918 as=0.36 pd=2.96 ps=2.72
XM16 VPWR#8 a_409_392##12 X#5 VPB sky130_fd_pr__pfet_01v8 l=0.15 w=1.12 ad=0.3918 as=0.336 pd=2.96 ps=2.84
XM5 X#5 a_409_392##11 VPWR#7 VPB sky130_fd_pr__pfet_01v8 l=0.15 w=1.12 ad=0.336 as=0.336 pd=2.84 ps=2.84
XM15 VPWR#7 a_409_392##7 X#6 VPB sky130_fd_pr__pfet_01v8 l=0.15 w=1.12 ad=0.336 as=0.336 pd=2.84 ps=2.84
XM0 X#6 a_409_392# VPWR#1 VPB sky130_fd_pr__pfet_01v8 l=0.15 w=1.12 ad=0.336 as=0.3192 pd=2.84 ps=2.81
*
*
*       RESISTOR AND CAP/DIODE CARDS
*
Rg1	C_N#1	C_N#2	774.737183
Rg2	C_N#2	C_N#3	261.256744
Rg3	A#1	A#2	417.973633
Rg4	B#1	B#2	400.207520
Rg5	a_27_392#	a_27_392##2	277.445038
Rg6	a_27_392##2	a_27_392##3	188.481201
Rg7	a_27_392##3	a_27_392##4	199.210983
Rg8	a_27_392##2	a_27_392##5	592.953552
Rg9	a_27_392##3	a_27_392##6	592.953552
Rg10	B#3	B#4	463.821777
Rg11	B#4	B#5	408.386017
Rg12	A#3	A#4	509.830780
Rg13	A#4	A#5	307.937683
Rg14	a_409_392#	a_409_392##2	471.862823
Rg15	a_409_392##2	a_409_392##3	66.369736
Rg16	a_409_392##3	a_409_392##4	57.428749
Rg17	a_409_392##2	a_409_392##5	368.862610
Rg18	a_409_392##3	a_409_392##6	365.684052
Rg19	a_409_392##3	a_409_392##7	469.405975
Rg20	a_409_392##4	a_409_392##8	349.977234
Rg21	a_409_392##4	a_409_392##9	90.033310
Rg22	a_409_392##9	a_409_392##10	368.862610
Rg23	a_409_392##4	a_409_392##11	451.334412
Rg24	a_409_392##9	a_409_392##12	471.862823
Rf1	C_N#4	C_N	1.491315
Rf2	C_N#3	C_N#6	81.607719
Rf3	C_N#4	C_N#6	6.796240
Rf4	a_27_392##4	a_27_392##9	189.069473
Rf5	a_27_392##9	a_27_392##10	73.143150
Rf6	a_27_392##8	a_27_392##9	15.000000
Rf7	a_307_392#	a_307_392##2	72.545151
Rf8	B#4	B	174.046738
Rf9	B	B#2	167.637314
Rf10	a_217_392#	a_217_392##2	144.370605
Rf11	A#2	A	323.644623
Rf12	A	A#4	176.227142
Rf13	a_409_392##4	a_409_392##14	64.288757
Rf14	a_409_392##14	a_409_392##15	167.699295
Rf15	a_409_392##14	a_409_392##16	79.618042
Rf16	a_409_392##16	a_409_392##17	12.899405
Rf17	a_409_392##16	a_409_392##18	79.330132
Rf18	X#1	X#2	18.781376
Rf19	X#2	X#3	88.603584
Rf20	X#2	X	45.989067
Rf21	X	X#4	41.843651
Rf22	X#4	X#5	103.578354
Rf23	X#4	X#6	21.948624
Rf24	VPWR#1	VPWR#2	112.878075
Rf25	VPWR#2	VPWR#3	64.292725
Rf26	VPWR#3	VPWR#4	57.685360
Rf27	VPWR#4	VPWR#5	157.399292
Rf29	VPWR#2	VPWR#7	42.573776
Rf30	VPWR#3	VPWR#8	31.141060
Rf31	VPWR#5	VPWR#9	35.924004
Rf32	VGND#1	VGND#2	102.053383
Rf33	VGND#2	VGND#3	62.095512
Rf34	VGND#3	VGND#4	58.410175
Rf35	VGND#2	VGND#5	41.120300
Rf36	VGND#3	VGND#6	31.473843
Rf37	VGND#4	VGND#7	126.494568
Rf39	VGND#4	VGND#9	36.233871
Rf40	VGND#7	VGND#10	26.067745
Re1	VPWR#4	VPWR	0.818510
Re2	VGND	VGND#4	0.818540
*
*       CAPACITOR CARDS
*
*
C1	X#3	X#1	2.40193e-18
C2	a_409_392##15	a_27_392##2	2.50603e-19
C3	a_409_392##14	X#5	7.0963e-17
C4	X#3	VGND#5	4.41354e-17
C5	a_409_392##14	VPWR#8	4.58705e-17
C6	VGND#6	VGND#5	1.56089e-18
C7	a_307_392##2	a_27_392##3	8.09124e-20
C8	a_409_392##14	a_217_392#	2.02679e-17
C9	VGND#6	X#3	2.03783e-17
C10	VPWR#4	a_27_392##3	2.36886e-20
C11	VPWR#4	a_27_392##2	2.34179e-20
C12	a_217_392##2	a_27_392##3	1.28329e-19
C13	VGND#2	a_409_392##5	7.55837e-19
C14	VGND#9	VGND#6	1.89244e-18
C15	VGND#2	a_409_392##6	8.03482e-18
C16	VGND#4	a_27_392##3	1.00697e-19
C17	VGND#1	VPWR#1	1.99913e-19
C18	VGND#4	a_27_392##2	1.04949e-19
C19	VGND#2	a_409_392##8	5.24585e-18
C20	a_409_392##9	a_409_392##4	4.18679e-18
C21	VGND#3	a_409_392##10	2.78423e-18
C22	a_409_392##4	a_409_392##2	4.2911e-18
C23	a_409_392##18	VGND#9	4.7146e-17
C24	VGND#2	a_409_392##10	6.09314e-19
C25	VGND#3	A#5	2.71372e-18
C26	VGND#10	VGND#9	2.73013e-19
C27	X#2	a_409_392##5	1.94821e-17
C28	a_27_392##3	a_27_392##2	1.11904e-17
C29	A#4	a_409_392##9	4.01899e-17
C30	X#2	a_409_392##6	2.14801e-17
C31	a_409_392##14	a_409_392##5	7.56998e-21
C32	VGND#3	VGND#2	1.20399e-18
C33	A#4	a_27_392##3	1.34864e-19
C34	A#4	a_27_392##2	9.46192e-20
C35	a_409_392##14	a_409_392##6	1.42085e-20
C36	a_27_392##8	VGND#10	1.98838e-17
C37	a_409_392##16	a_409_392##8	2.64658e-19
C38	B#4	a_409_392##9	4.70279e-19
C39	a_409_392##14	a_409_392##8	6.54435e-19
C40	a_409_392##16	a_409_392##10	1.14562e-18
C41	a_27_392##2	B#4	2.12121e-17
C42	a_409_392##14	a_409_392##10	9.19169e-18
C43	a_409_392##16	A#5	3.40297e-17
C44	a_409_392##14	A#5	1.50448e-18
C45	X#6	VPWR#1	6.2273e-17
C46	a_409_392##16	B#3	1.99569e-17
C47	VPWR#7	VPWR#1	2.00319e-18
C48	a_409_392##14	B#3	5.58676e-19
C49	VPWR#7	X#6	6.23622e-17
C50	a_409_392##16	a_27_392#	4.04506e-19
C51	a_409_392##14	a_27_392#	2.84211e-19
C52	X#5	X#6	9.27108e-19
C53	VGND#1	a_409_392##5	3.2183e-17
C54	VPWR#2	a_409_392#	2.16581e-18
C55	X#5	VPWR#7	6.16751e-17
C56	a_409_392##5	X#1	1.33201e-17
C57	B#2	a_27_392##3	1.43478e-17
C58	VGND#1	a_409_392##6	2.52015e-18
C59	VGND#5	a_409_392##5	3.57278e-19
C60	VPWR#8	VPWR#7	2.55929e-18
C61	X#4	a_409_392#	2.4337e-17
C62	X#1	a_409_392##6	3.15886e-17
C63	VPWR#2	a_409_392##7	5.27282e-18
C64	VGND#1	a_409_392##8	3.21332e-19
C65	VPWR#8	X#5	4.65355e-17
C66	a_409_392##6	VGND#5	1.52649e-17
C67	X#1	a_409_392##8	2.64492e-18
C68	X#4	a_409_392##7	1.81637e-17
C69	X#3	a_409_392##6	3.65195e-19
C70	VPWR#3	VPWR#2	1.14381e-18
C71	VPWR#2	a_409_392##11	5.72092e-18
C72	VGND#2	X#2	4.09583e-19
C73	A#2	a_27_392##3	2.35554e-17
C74	VGND#5	a_409_392##8	2.94519e-17
C75	VGND#3	a_409_392##16	4.38656e-18
C76	A#2	a_27_392##2	1.32379e-19
C77	X#1	a_409_392##10	1.94512e-19
C78	VPWR#3	a_409_392##12	3.33486e-18
C79	a_217_392#	VPWR#8	6.03715e-17
C80	X#3	a_409_392##8	2.5105e-17
C81	X#4	a_409_392##11	5.35548e-18
C82	VPWR#2	a_409_392##12	3.99722e-19
C83	VGND#5	a_409_392##10	1.02984e-18
C84	a_27_392##8	VPWR#9	6.08893e-18
C85	VGND#6	a_409_392##8	1.46525e-18
C86	VGND#3	a_409_392##14	5.16466e-19
C87	X#5	a_409_392##15	1.68727e-22
C88	a_409_392##10	X#3	1.96864e-17
C89	VGND#3	a_409_392##9	8.14004e-20
C90	X#3	a_409_392##9	3.20107e-18
C91	VPWR#3	A#3	4.35912e-18
C92	X#4	a_409_392##12	1.31417e-19
C93	a_217_392#	a_307_392#	8.11921e-17
C94	VPWR#2	A#3	1.01368e-19
C95	VGND#6	a_409_392##10	3.37423e-17
C96	a_409_392##14	a_409_392##11	5.90721e-19
C97	X#3	A#5	5.08523e-19
C98	a_217_392#	a_409_392##15	7.56329e-17
C99	A#5	VGND#6	1.80448e-17
C100	a_409_392##14	a_409_392##12	9.70247e-18
C101	X#4	VPWR#2	2.5317e-19
C102	VGND#9	a_409_392##10	3.21738e-19
C103	a_307_392#	a_409_392##15	2.2478e-18
C104	a_217_392#	a_307_392##2	3.48611e-19
C105	A#5	a_409_392##17	1.49857e-17
C106	VGND#6	B#3	7.33702e-19
C107	a_27_392##2	B#3	4.59707e-18
C108	VGND#2	a_409_392##9	6.77917e-21
C109	VGND#9	A#5	2.04712e-18
C110	a_217_392##2	a_217_392#	9.5606e-19
C111	a_409_392##14	A#3	2.35836e-17
C112	B#3	a_409_392##17	6.0804e-18
C113	a_409_392##18	A#5	2.02452e-19
C114	a_307_392##2	a_409_392##15	7.38684e-19
C115	VGND#9	B#3	3.47095e-17
C116	a_409_392##14	B#5	4.36829e-19
C117	a_217_392##2	a_409_392##15	2.35475e-17
C118	a_409_392##18	B#3	1.03772e-18
C119	a_409_392##14	VPWR#3	8.15277e-19
C120	a_27_392##3	a_27_392#	2.71786e-18
C121	a_27_392#	VGND#9	2.0825e-17
C122	VGND#10	B#3	1.05832e-19
C123	a_217_392##2	a_307_392##2	8.22364e-17
C124	a_409_392##18	a_27_392#	4.82895e-17
C125	VGND#2	a_409_392##2	5.24649e-20
C126	a_409_392##14	a_27_392##5	2.74746e-19
C127	X#2	X#4	3.9547e-18
C128	VGND#10	a_27_392#	6.9798e-19
C129	a_27_392##8	a_27_392#	1.64386e-19
C130	VPWR#9	a_217_392##2	8.49562e-17
C131	a_409_392##14	a_27_392##6	2.76197e-19
C132	C_N#2	VGND#10	9.25746e-18
C133	C_N#2	a_27_392##3	9.01454e-19
C134	a_27_392##8	C_N#2	5.25478e-17
C135	a_27_392##10	VPWR#9	8.29987e-17
C136	a_409_392##14	X#4	6.8162e-17
C137	X#2	a_409_392##14	6.00245e-17
C138	a_409_392#	VPWR#1	3.3666e-17
C139	X#6	a_409_392#	4.9928e-17
C140	VGND#4	VGND#3	3.59383e-17
C141	VPWR#4	VPWR#3	3.58707e-17
C142	a_409_392##16	a_409_392##14	2.22121e-18
C143	VPWR#1	a_409_392##7	1.23306e-18
C144	VPWR#3	a_409_392##9	3.96166e-20
C145	VGND#4	VGND#2	4.21336e-17
C146	a_409_392##6	a_409_392##5	3.91497e-17
C147	VPWR#7	a_409_392#	7.14071e-19
C148	VPWR#4	VPWR#2	4.33939e-17
C149	X#6	a_409_392##7	4.82853e-17
C150	VPWR#1	a_409_392##11	2.59902e-19
C151	a_409_392##7	VPWR#7	2.09722e-17
C152	X#6	a_409_392##11	1.85252e-18
C153	VGND#2	a_409_392##4	9.17508e-20
C154	a_409_392##8	a_409_392##6	2.70376e-17
C155	X#5	a_409_392##7	3.66711e-19
C156	VPWR#7	a_409_392##11	4.59559e-17
C157	X#6	a_409_392##12	7.76085e-20
C158	X#5	a_409_392##11	5.58815e-17
C159	VPWR#7	a_409_392##12	1.88891e-18
C160	VPWR#2	a_409_392##9	5.48537e-21
C161	VPWR#2	a_409_392##4	9.08134e-20
C162	a_409_392##10	a_409_392##8	3.59519e-17
C163	VGND#4	a_409_392##16	9.95977e-18
C164	VPWR#8	a_409_392##11	2.55638e-18
C165	a_27_392##3	a_409_392##18	2.45107e-18
C166	X#5	a_409_392##12	1.56553e-17
C167	X#4	a_409_392##4	3.63167e-18
C168	VPWR#7	A#3	1.87259e-19
C169	a_27_392##10	C_N#2	1.295e-18
C170	a_409_392##12	VPWR#8	3.05801e-17
C171	X#2	a_409_392##4	4.92724e-18
C172	a_27_392##2	a_409_392##18	2.69455e-18
C173	X#5	A#3	1.57083e-18
C174	A#5	a_409_392##10	2.61627e-17
C175	a_217_392#	a_409_392##12	1.08624e-18
C176	a_409_392##14	a_409_392##4	3.47898e-17
C177	A#3	VPWR#8	3.23243e-17
C178	X#5	B#5	4.12692e-19
C179	a_217_392#	A#3	5.40311e-17
C180	VGND#2	VGND#1	1.10966e-18
C181	VPWR#2	a_409_392##2	4.5102e-20
C182	a_409_392##16	A#4	3.30687e-17
C183	VPWR#8	B#5	1.20861e-18
C184	B#3	A#5	3.74633e-17
C185	a_307_392#	A#3	5.64913e-19
C186	A#4	a_409_392##14	6.71081e-17
C187	X#5	a_27_392##5	2.22751e-19
C188	a_217_392#	B#5	3.42939e-17
C189	B	a_27_392##3	9.3339e-18
C190	VPWR#8	a_27_392##5	5.98904e-19
C191	B	a_27_392##2	1.18213e-17
C192	a_307_392#	B#5	3.47343e-17
C193	VGND#2	X#1	1.36893e-17
C194	X#5	a_27_392##6	2.40023e-19
C195	a_409_392##16	B#4	2.82068e-19
C196	a_27_392#	B#3	2.73771e-17
C197	a_217_392#	a_27_392##5	1.29168e-17
C198	a_409_392##15	B#5	1.53139e-17
C199	B#4	a_409_392##14	1.09256e-17
C200	a_217_392##2	A#3	3.07559e-19
C201	VPWR#8	a_27_392##6	3.25379e-19
C202	VGND#4	VGND#1	2.73666e-17
C203	a_307_392#	a_27_392##5	4.14217e-17
C204	a_217_392#	a_27_392##6	2.20034e-19
C205	a_409_392##15	a_27_392##5	3.7125e-17
C206	a_217_392##2	B#5	4.47222e-19
C207	VPWR#8	B#1	2.8517e-19
C208	a_409_392##14	a_27_392##4	7.25927e-20
C209	VGND#3	X#3	4.62992e-18
C210	VPWR#9	B#5	1.93215e-19
C211	a_27_392##8	a_27_392##3	7.49788e-19
C212	a_217_392#	B#1	1.29386e-19
C213	a_409_392##15	a_27_392##6	3.1595e-17
C214	VGND#4	VGND#6	2.05364e-19
C215	a_217_392##2	a_27_392##5	8.0682e-19
C216	A	a_27_392##3	2.91831e-18
C217	VGND#5	a_409_392##4	1.36063e-18
C218	a_307_392##2	a_27_392##6	4.71608e-17
C219	A	a_27_392##2	1.50052e-17
C220	VPWR#9	a_27_392##5	2.99003e-19
C221	X#3	a_409_392##4	2.04744e-18
C222	a_409_392##15	B#1	2.26907e-18
C223	VGND#2	X#3	6.13135e-18
C224	a_217_392##2	a_27_392##6	2.28728e-17
C225	a_27_392##10	a_27_392##5	4.36392e-19
C226	VGND#4	a_409_392##18	1.77762e-17
C227	B#1	a_307_392##2	2.37094e-17
C228	VPWR#4	VPWR#1	2.55859e-17
C229	VPWR#9	a_27_392##6	6.65493e-19
C230	VGND#10	VGND#4	9.44699e-20
C231	a_217_392##2	B#1	6.79707e-17
C232	a_27_392##10	a_27_392##6	2.37268e-19
C233	VPWR#9	B#1	1.21584e-18
C234	A#4	VGND#6	9.41621e-19
C235	VGND#6	VGND#2	4.97341e-19
C236	X#4	a_409_392##2	1.45938e-18
C237	a_217_392##2	A#1	5.03034e-17
C238	a_27_392##10	B#1	3.00015e-19
C239	VPWR#9	A#1	1.95651e-17
C240	a_409_392##7	a_409_392#	4.68352e-17
C241	a_217_392##2	C_N#1	2.30224e-18
C242	a_217_392#	VPWR#4	1.65022e-17
C243	a_27_392##10	A#1	6.74091e-19
C244	a_307_392#	VPWR#4	3.0876e-17
C245	VPWR#9	C_N#1	5.8368e-17
C246	VGND#9	B#4	5.65326e-19
C247	VPWR#7	a_409_392##4	7.87338e-19
C248	a_27_392##10	C_N#1	3.38934e-17
C249	a_409_392##11	a_409_392##7	4.81638e-17
C250	a_409_392##18	B#4	3.04939e-19
C251	X#2	VGND#1	3.41504e-18
C252	X#5	a_409_392##4	1.06193e-18
C253	a_307_392##2	VPWR#4	1.56054e-17
C254	a_27_392##4	VGND#9	2.48897e-18
C255	a_27_392##4	a_409_392##18	7.34774e-17
C256	a_409_392##12	a_409_392##11	4.88408e-17
C257	X#2	a_409_392##2	1.67585e-18
C258	a_27_392##4	VGND#10	8.27114e-17
C259	VPWR#8	A#4	6.0758e-19
C260	X#2	X#1	6.74586e-19
C261	X	a_409_392##9	6.92051e-20
C262	a_27_392##8	a_27_392##4	1.77842e-19
C263	X	a_409_392##2	1.78026e-17
C264	A#3	a_409_392##12	4.06355e-17
C265	VGND#10	B#2	8.06137e-19
C266	B#4	a_217_392#	9.00975e-19
C267	X#2	VGND#5	1.57158e-17
C268	B#4	a_409_392##15	3.02742e-17
C269	B#5	A#3	3.23663e-17
C270	A#2	VGND#10	9.93693e-18
C271	a_27_392##8	A#2	4.71652e-17
C272	a_409_392##14	X#1	2.51339e-18
C273	VGND#9	C_N#3	3.68087e-19
C274	a_409_392##14	a_409_392##9	1.55773e-17
C275	C_N#3	VGND#10	4.60818e-17
C276	a_27_392##5	B#5	4.23177e-17
C277	X#5	a_409_392##9	1.07629e-18
C278	a_307_392##2	a_27_392##4	1.81475e-19
C279	VGND#4	B#3	1.23513e-18
C280	C_N#3	a_27_392##8	7.4663e-17
C281	a_217_392##2	a_27_392##4	2.74142e-19
C282	VGND#4	a_27_392#	2.74361e-18
C283	a_409_392##14	VGND#5	4.26802e-18
C284	A#4	a_409_392##10	1.85772e-18
C285	B#2	a_307_392##2	1.22604e-18
C286	a_409_392##16	X#3	3.10602e-18
C287	a_27_392##6	a_27_392##5	4.70863e-17
C288	A#4	A#5	2.11066e-18
C289	B#2	a_217_392##2	3.4652e-17
C290	B#3	A#4	7.43003e-18
C291	a_27_392##10	B#2	2.73977e-18
C292	B#1	a_27_392##6	3.27162e-17
C293	a_409_392##14	X#3	7.44908e-17
C294	A#2	a_217_392##2	1.25079e-17
C295	a_409_392##16	VGND#6	4.18292e-17
C296	A#2	VPWR#9	2.15804e-17
C297	a_27_392##10	A#2	8.78856e-18
C298	a_409_392##14	a_409_392##2	8.91356e-18
C299	a_27_392##4	B#3	2.56024e-19
C300	A#1	B#1	4.13086e-17
C301	VPWR#9	C_N#3	1.52355e-18
C302	VPWR#4	B#5	4.43616e-18
C303	VGND	a_409_392##9	2.44724e-19
C304	a_27_392##4	a_27_392#	2.99161e-17
C305	a_409_392##14	VGND#6	1.18285e-17
C306	VPWR#4	a_27_392##5	5.34919e-18
C307	C_N#2	a_27_392##4	3.77182e-18
C308	a_409_392##16	a_409_392##17	3.46987e-18
C309	C_N#1	A#1	3.32396e-17
C310	VPWR#4	a_27_392##6	5.35738e-18
C311	A#4	a_409_392##12	7.2408e-19
C312	a_409_392##14	a_27_392##3	1.46502e-19
C313	a_409_392##16	A	3.61645e-17
C314	A	a_409_392##14	7.83514e-19
C315	B#4	a_409_392##12	2.87818e-19
C316	C_N#2	A#2	2.66559e-17
C317	B#4	A#3	9.35181e-18
C318	a_409_392##16	VGND#9	4.16667e-17
C319	C_N#3	a_27_392#	2.18184e-19
C320	a_409_392##14	a_27_392##2	6.99338e-21
C321	C_N#3	C_N#2	2.39499e-18
C322	a_27_392##5	B#4	1.56649e-17
C323	a_409_392##18	a_409_392##16	2.49329e-18
C324	VPWR#2	VPWR#1	7.06672e-19
C325	X	X#4	5.32109e-19
C326	B#2	a_27_392##6	2.05495e-17
C327	a_409_392##18	A	5.45028e-17
C328	a_409_392##14	X	2.66924e-17
C329	a_409_392##14	a_409_392##18	8.62514e-22
C330	A#1	B#2	1.08601e-18
C331	B	a_409_392##15	6.54203e-17
C332	VPWR#4	B#4	3.07899e-20
C333	B	a_217_392##2	2.63695e-18
C334	VPWR	VPWR#3	2.22961e-17
C335	X#6	VPWR#2	1.67068e-17
C336	VPWR	VPWR#2	4.04292e-17
C337	VPWR	X#4	3.5918e-18
C338	C_N#1	A#2	1.72408e-17
C339	X	VGND#1	3.08626e-17
C340	VGND#4	a_27_392##4	2.72585e-18
C341	A	a_409_392##15	2.68044e-18
C342	VPWR	a_409_392##14	1.11778e-17
C343	X#4	VPWR#1	3.06697e-19
C344	B#4	A#4	3.29713e-17
C345	a_217_392#	a_27_392##3	6.22199e-21
C346	VGND#4	A#2	1.84641e-19
C347	VGND	VGND#3	1.87093e-17
C348	VGND	VGND#2	3.94545e-17
C349	a_409_392##9	VNB	2.71462e-17
C350	A#4	B#2	1.87449e-19
C351	a_409_392##2	VNB	3.59407e-17
C352	a_27_392##3	VNB	3.09111e-17
C353	X	VPWR#1	2.61536e-17
C354	a_27_392##2	VNB	2.46999e-17
C355	VGND	X#4	4.03853e-18
C356	a_217_392#	a_27_392##2	1.34551e-19
C357	VGND	X#2	3.09588e-18
C358	VGND	a_409_392##16	1.71329e-17
C359	A	B#3	7.96351e-18
C360	VGND	a_409_392##14	9.3818e-18
C361	a_27_392##4	B#2	6.69548e-18
C362	A#2	B#4	2.02521e-19
C363	X#4	X#6	2.08835e-19
C364	X#5	VPWR#3	4.76404e-18
C365	a_27_392##4	A#2	8.76687e-17
C366	VPWR	VPWR#1	3.42631e-17
C367	VPWR	X#6	1.6164e-17
C368	A#2	B#2	1.15155e-16
C369	C_N#3	a_27_392##4	4.9733e-18
C370	VPWR	X#5	1.21597e-17
C371	VGND	VGND#1	3.87958e-17
C372	X	a_409_392##5	2.20099e-19
C373	B	a_27_392##5	1.23495e-17
C374	VGND	X#1	1.31891e-17
C375	VPWR	VPWR#8	2.17023e-17
C376	X	a_409_392##6	6.21668e-20
C377	VPWR	a_217_392#	2.18288e-17
C378	VGND	X#3	1.17598e-17
C379	X	a_409_392##8	1.36505e-20
C380	B	a_27_392##6	9.36696e-18
C381	VPWR	a_307_392#	1.9215e-17
C382	VGND	VGND#6	1.63452e-17
C383	X#5	VPWR#2	6.03873e-18
C384	X	a_409_392##10	7.88792e-21
C385	VPWR	a_409_392##15	5.80427e-18
C386	VGND	VGND#9	1.60353e-17
C387	VPWR	a_307_392##2	1.93563e-17
C388	VGND	a_409_392##18	1.71913e-17
C389	VPWR	a_217_392##2	2.30995e-17
C390	VGND	VGND#10	2.41593e-17
C391	VPWR	VPWR#9	2.10845e-17
C392	VGND	a_27_392##8	1.0998e-17
C393	VPWR	a_27_392##10	1.50208e-17
C394	X#4	VPWR#7	2.41648e-17
C395	VGND	X#5	1.25543e-18
C396	X#1	VGND#1	3.83514e-17
C397	VGND	VPWR#9	2.79442e-18
C398	VGND	a_409_392##5	1.54511e-19
C399	VGND#4	A	8.74362e-20
C400	VPWR	a_409_392#	1.54345e-18
C401	VGND#3	VNB	2.66489e-17
C402	VGND#2	VNB	3.30029e-17
C403	VGND	a_409_392##6	2.90868e-20
C404	VPWR	a_409_392##7	8.66318e-19
C405	VGND	a_409_392##8	6.9149e-19
C406	VPWR#3	VNB	2.71771e-17
C407	VPWR	a_409_392##11	1.5574e-18
C408	VPWR#8	VPWR#2	3.50107e-19
C409	VPWR#2	VNB	3.20491e-17
C410	X#4	VNB	2.8435e-18
C411	VGND	A#5	1.25053e-19
C412	VPWR	a_409_392##12	3.25713e-18
C413	X#2	VNB	1.06545e-18
C414	a_409_392##16	VNB	2.09003e-18
C415	VGND	B#3	6.14326e-19
C416	VPWR	A#3	1.51665e-18
C417	a_409_392##14	VNB	1.65324e-18
C418	VGND	a_27_392#	4.92591e-19
C419	A	B#4	3.68641e-17
C420	a_307_392#	a_27_392##2	8.09124e-20
C421	VPWR	B#5	1.33499e-18
C422	VPWR	a_27_392##5	9.13957e-19
C423	A#2	B	9.0664e-18
C424	X#5	X#4	1.5699e-18
C425	VPWR	a_27_392##6	9.03395e-19
C426	a_409_392##14	X#6	2.35532e-18
C427	VPWR	B#1	2.34106e-19
C428	a_217_392#	VPWR#3	5.36077e-18
C429	VGND#1	VNB	5.16425e-17
C430	X#1	VNB	2.39239e-18
C431	VPWR	A#1	1.9733e-18
C432	VGND#5	VNB	1.9777e-19
C433	X#3	VNB	4.86408e-18
C434	X	a_409_392##4	6.50779e-19
C435	VPWR	C_N#1	5.77876e-18
C436	VGND#5	VGND#1	1.32567e-18
C437	VGND#6	VNB	9.73309e-19
C438	VGND#9	VNB	6.74558e-19
C439	VGND#10	VNB	4.41438e-18
C440	VPWR	VPWR#4	3.2461e-17
C441	a_27_392##8	VNB	3.73614e-17
C442	VPWR#1	VNB	6.59665e-17
C443	X#6	VNB	3.08937e-18
C444	VPWR#7	VNB	4.09278e-19
C445	X#5	VNB	5.13397e-18
C446	VPWR#8	VNB	4.07717e-18
C447	a_217_392#	VNB	2.77834e-18
C448	a_307_392#	VNB	3.26818e-18
C449	VPWR	A#4	2.4667e-18
C450	a_307_392##2	VNB	3.68868e-18
C451	VPWR	B#4	1.39398e-18
C452	a_217_392##2	VNB	2.14641e-18
C453	VPWR#9	VNB	8.74044e-18
C454	a_27_392##10	VNB	6.38045e-17
C455	a_409_392##5	VNB	3.19414e-17
C456	VGND	VGND#4	3.01688e-17
C457	a_409_392##6	VNB	2.93741e-17
C458	VPWR	B#2	3.42485e-18
C459	a_409_392##8	VNB	2.51047e-17
C460	a_409_392##10	VNB	2.70419e-17
C461	A#5	VNB	2.46206e-17
C462	VGND	A#4	2.46423e-18
C463	VPWR	A#2	3.34538e-18
C464	B#3	VNB	2.74252e-17
C465	a_27_392#	VNB	2.72162e-17
C466	VGND	B#4	1.33966e-18
C467	C_N#2	VNB	3.80638e-17
C468	VGND	a_27_392##4	2.67377e-17
C469	A	B	4.13119e-17
C470	a_409_392#	VNB	4.05072e-17
C471	a_409_392##7	VNB	3.21908e-17
C472	VGND	B#2	2.97117e-18
C473	a_409_392##11	VNB	3.05107e-17
C474	a_409_392##12	VNB	3.41877e-17
C475	VGND	A#2	9.06728e-18
C476	A#3	VNB	3.48014e-17
C477	VGND#5	X#1	3.04181e-17
C478	B#5	VNB	2.83883e-17
C479	VGND	C_N#3	3.12359e-17
C480	a_409_392##14	VPWR#7	2.37113e-18
C481	a_27_392##5	VNB	4.05527e-17
C482	a_27_392##6	VNB	3.98612e-17
C483	B#1	VNB	2.87881e-17
C484	A#1	VNB	3.18548e-17
C485	C_N#1	VNB	4.94887e-17
C486	VPWR#4	VNB	2.76168e-16
C487	VPWR	B	3.06772e-18
C488	VGND#4	VNB	2.74257e-16
C489	a_409_392##4	VNB	6.79337e-17
C490	A#4	VNB	3.27091e-17
C491	B#4	VNB	3.40971e-17
C492	a_27_392##4	VNB	8.90064e-17
C493	VGND	B	3.26017e-18
C494	B#2	VNB	3.40443e-17
C495	a_409_392##15	a_27_392##3	2.53501e-19
C496	A#2	VNB	3.8628e-17
C497	VGND	A	5.34887e-18
C498	C_N#3	VNB	1.05501e-16
C499	VPWR	X	2.47669e-18
C500	VGND	X	3.79167e-18
C501	B	VNB	3.33492e-18
C502	A	VNB	7.18574e-18
C503	X	VNB	5.32887e-17
C504	VPWR	VNB	7.66893e-17
C505	VGND	VNB	6.01749e-17
C506	a_307_392##2	VPWR#5	1.65003e-17
C507	VGND#7	VNB	6.93751e-17
C508	VGND	VGND#7	5.37256e-17
C509	a_217_392##2	VPWR#5	2.0246e-17
C510	VPWR#5	B#1	5.54987e-18
C511	VPWR#5	B#2	3.9587e-20
C512	VPWR#5	A#1	4.88246e-18
C513	A#2	VPWR#5	3.33076e-19
C514	a_27_392##10	VPWR#5	1.76409e-17
C515	VPWR#5	C_N#1	1.20848e-18
C516	VPWR	VPWR#5	4.86285e-17
C517	VGND#7	C_N#3	6.57205e-17
C518	VGND#7	A#2	6.24294e-19
C519	VGND#7	B#2	3.47419e-20
C520	VGND#7	a_27_392##4	2.69072e-17
C521	VPWR#4	VPWR#5	7.75462e-17
C522	VGND#4	VGND#7	8.5171e-17
C523	VPWR#5	VNB	6.69191e-17
C524	VGND#7	a_27_392##8	1.4058e-18
*
*
.ENDS sky130_fd_sc_hs__or3b_4
*
