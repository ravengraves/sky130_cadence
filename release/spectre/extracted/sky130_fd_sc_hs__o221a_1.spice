* Extracted by Quantus, converted by sky130cad/quantus.py
*
*
*
*                       LINUX           Wed Nov 18 08:57:17 2026
*
*
*
*  PROGRAM  advgen
*
*  Name           : advgen - Quantus - (64-bit)
*  Version        : 25.1.0-p047
*  Build Date     : Thu Dec 11 23:20:30 PST 2025
*
*  HSPICE LIBRARY
*
*  OPERATING_TEMPERATURE 150
*  QRC_TECH_DIR <path>/tech
*
*
*

*
.SUBCKT sky130_fd_sc_hs__o221a_1 VNB VPB VGND VPWR X C1 A1 A2 B2 B1
*
*
*  caps2d version: 10
*
*
*       TRANSISTOR CARDS
*
*
XM3 X#1 a_83_264# VGND#6 VNB sky130_fd_pr__nfet_01v8_lvt l=0.15 w=0.74 ad=0.2109 as=0.3107 pd=2.05 ps=2.34
XM4 VGND#6 A1#3 a_245_94##2 VNB sky130_fd_pr__nfet_01v8_lvt l=0.15 w=0.64 ad=0.3107 as=0.224 pd=2.34 ps=1.98
XM2 a_245_94##2 A2#3 VGND#5 VNB sky130_fd_pr__nfet_01v8_lvt l=0.15 w=0.64 ad=0.224 as=0.1824 pd=1.98 ps=1.85
XM9 a_456_74##2 B2#1 a_245_94# VNB sky130_fd_pr__nfet_01v8_lvt l=0.15 w=0.64 ad=0.2336 as=0.1792 pd=2.01 ps=1.84
XM1 a_245_94# B1#1 a_456_74# VNB sky130_fd_pr__nfet_01v8_lvt l=0.15 w=0.64 ad=0.1792 as=0.224 pd=1.84 ps=1.98
XM10 a_456_74# C1#3 a_83_264##4 VNB sky130_fd_pr__nfet_01v8_lvt l=0.15 w=0.64 ad=0.224 as=0.2944 pd=1.98 ps=2.2
XM0 X#3 a_83_264##3 VPWR#7 VPB sky130_fd_pr__pfet_01v8 l=0.15 w=1.12 ad=0.3304 as=0.6218 pd=2.83 ps=3.42
XM8 VPWR#7 A1#1 a_264_392# VPB sky130_fd_pr__pfet_01v8 l=0.15 w=1 ad=0.6218 as=0.27 pd=3.42 ps=2.54
XM11 a_264_392# A2#1 a_83_264##9 VPB sky130_fd_pr__pfet_01v8 l=0.15 w=1 ad=0.27 as=0.42 pd=2.54 ps=2.84
XM5 a_83_264##9 B2#3 a_462_392# VPB sky130_fd_pr__pfet_01v8 l=0.15 w=1 ad=0.42 as=0.42 pd=2.84 ps=2.84
XM6 a_462_392# B1#3 VPWR#6 VPB sky130_fd_pr__pfet_01v8 l=0.15 w=1 ad=0.42 as=0.86 pd=2.84 ps=3.72
XM7 VPWR#6 C1#1 a_83_264##8 VPB sky130_fd_pr__pfet_01v8 l=0.15 w=1 ad=0.86 as=0.295 pd=3.72 ps=2.59
*
*
*       RESISTOR AND CAP/DIODE CARDS
*
Rg1	a_83_264#	a_83_264##2	361.185791
Rg2	a_83_264##2	a_83_264##3	443.825714
Rg3	A1#1	A1#2	409.090576
Rg4	A1#2	A1#3	411.232849
Rg5	A2#1	A2#2	409.090576
Rg6	A2#2	A2#3	411.232849
Rg7	B2#1	B2#2	470.569611
Rg8	B2#2	B2#3	409.090576
Rg9	B1#1	B1#2	481.131470
Rg10	B1#2	B1#3	467.131866
Rg11	C1#1	C1#2	423.212891
Rg12	C1#2	C1#3	297.808441
Rf1	X#2	X	5.988583
Rf2	X	X#3	92.059135
Rf3	X#2	X	5.988583
Rf4	X#1	X#2	7.500000
Rf5	A1#2	A1	162.201172
Rf6	A2#4	A2	0.956614
Rf7	A2#2	A2#6	161.189423
Rf8	A2#4	A2#6	2.362036
Rf9	B2	B2#2	173.223999
Rf10	a_245_94#	a_245_94##2	154.766022
Rf11	B1#2	B1	161.807495
Rf12	a_456_74#	a_456_74##2	96.122261
Rf13	C1	C1#4	8.035555
Rf14	C1#4	C1	6.122327
Rf15	a_83_264##4	a_83_264##5	97.930710
Rf16	a_83_264##5	a_83_264##6	148.272171
Rf17	a_83_264##6	a_83_264##2	276.838196
Rf18	a_83_264##5	a_83_264##8	22.503469
Rf19	a_83_264##6	a_83_264##9	18.208733
Rf21	VPWR#2	VPWR#3	82.395180
Rf22	VPWR#3	VPWR#4	94.186211
Rf24	VPWR#2	VPWR#6	14.039328
Rf25	VPWR#4	VPWR#7	29.195755
Rf26	VGND#1	VGND#2	21.525364
Rf27	VGND#2	VGND#3	73.731934
Rf29	VGND#2	VGND#5	40.609421
Rf30	VGND#3	VGND#6	33.306259
Rf35	C1#2	C1#4	80.116402
Re1	VPWR#3	VPWR	1.091357
Re2	VGND	VGND#1	1.091398
*
*       CAPACITOR CARDS
*
*
C1	VGND#2	a_456_74##2	7.47052e-18
C2	VGND#2	a_245_94##2	6.94584e-18
C3	VGND#6	VGND#2	1.30507e-18
C4	a_83_264##4	a_83_264##5	2.7757e-18
C5	a_456_74#	a_83_264##5	5.31713e-18
C6	a_245_94#	a_83_264##6	4.41808e-18
C7	a_245_94##2	a_83_264##6	1.44754e-17
C8	a_83_264##5	a_83_264##8	2.91842e-18
C9	a_456_74#	a_83_264##4	5.31336e-17
C10	a_83_264##5	VPWR#6	9.02534e-18
C11	a_245_94#	a_83_264##4	1.82866e-18
C12	VGND#2	C1#3	7.77518e-20
C13	a_456_74#	a_245_94#	5.86509e-17
C14	a_83_264##6	a_83_264##9	2.0348e-18
C15	a_456_74##2	a_456_74#	2.52246e-18
C16	VGND#2	B1#1	1.63712e-19
C17	a_456_74##2	a_245_94#	7.20268e-17
C18	VGND#2	B2#1	1.15088e-18
C19	a_83_264##6	VPWR#7	1.38468e-18
C20	X#3	a_83_264##6	1.06672e-18
C21	VGND#2	A2#3	7.98416e-19
C22	VGND#5	a_456_74##2	4.46711e-17
C23	a_245_94##2	a_245_94#	1.31216e-18
C24	a_245_94##2	VGND#5	8.52394e-17
C25	VGND#2	a_83_264#	9.52308e-19
C26	VGND#6	VGND#5	2.76617e-18
C27	a_83_264##6	B2#1	1.33138e-18
C28	VGND#6	a_245_94##2	5.87361e-17
C29	a_83_264##4	C1#3	1.7671e-17
C30	a_456_74#	C1#3	3.86667e-17
C31	a_83_264##4	B1#1	2.51374e-19
C32	a_83_264##6	C1#1	7.12709e-20
C33	a_245_94#	C1#3	1.07692e-18
C34	a_83_264##5	C1#1	2.48983e-17
C35	a_456_74#	B1#1	2.9644e-17
C36	a_456_74##2	C1#3	1.99457e-19
C37	a_83_264##6	B1#3	2.27972e-17
C38	a_245_94#	B1#1	3.80621e-17
C39	a_456_74#	B2#1	7.99705e-19
C40	a_83_264##5	B1#3	2.80549e-19
C41	a_456_74##2	B1#1	4.4819e-19
C42	a_245_94#	B2#1	3.4486e-17
C43	a_83_264##6	B2#3	2.35071e-17
C44	a_456_74#	A2#3	6.59334e-20
C45	a_83_264##5	B2#3	6.60867e-20
C46	a_456_74##2	B2#1	5.2284e-17
C47	a_245_94#	A2#3	5.08324e-19
C48	a_83_264##6	A2#1	1.87373e-17
C49	VGND#5	B2#1	9.49947e-19
C50	a_456_74##2	A2#3	1.16446e-18
C51	a_245_94#	A1#3	1.15258e-19
C52	a_245_94##2	B2#1	3.35663e-19
C53	VGND#5	A2#3	4.24891e-17
C54	a_83_264##6	A1#1	2.60514e-17
C55	VGND#6	B2#1	1.59256e-19
C56	a_245_94##2	A2#3	2.63299e-17
C57	VPWR#7	a_83_264##9	1.9125e-17
C58	VGND#5	A1#3	1.73728e-18
C59	a_456_74##2	a_83_264#	2.12755e-19
C60	a_83_264##6	a_83_264##3	4.68182e-19
C61	VGND#6	A2#3	1.22546e-18
C62	X#3	a_83_264##9	9.52426e-19
C63	a_245_94##2	A1#3	4.39574e-17
C64	VGND#1	VGND#2	2.79074e-17
C65	VGND#5	a_83_264#	3.21974e-19
C66	A1#3	VGND#6	2.06563e-17
C67	a_245_94##2	a_83_264#	1.27211e-19
C68	X#3	VPWR#7	4.71907e-17
C69	a_83_264#	VGND#6	3.14863e-17
C70	a_83_264##6	VPWR#3	2.56714e-18
C71	a_83_264#	X#1	7.64262e-18
C72	B1#1	C1#3	2.47375e-17
C73	a_83_264##8	C1#1	3.39482e-17
C74	a_83_264##5	C1#2	1.7009e-17
C75	C1#1	VPWR#6	1.17497e-17
C76	a_83_264##8	B1#3	2.19523e-18
C77	a_83_264##6	B1#2	1.211e-19
C78	B2#1	B1#1	4.20778e-17
C79	B1#3	VPWR#6	3.2876e-17
C80	a_83_264##5	B1#2	4.42041e-18
C81	a_83_264##8	B2#3	2.14566e-19
C82	a_83_264##9	C1#1	4.48743e-19
C83	B2#2	a_83_264##6	3.15773e-17
C84	a_83_264##9	B1#3	5.31308e-18
C85	A2#3	B2#1	3.60075e-18
C86	a_83_264##5	B2#2	2.08055e-19
C87	VGND#1	a_83_264##4	2.57423e-17
C88	B2#3	a_83_264##9	2.2432e-17
C89	A2#2	a_83_264##6	2.83887e-17
C90	VGND#1	a_456_74#	5.65421e-17
C91	VPWR#7	B1#3	3.77689e-19
C92	A1#3	A2#3	2.7457e-17
C93	a_83_264#	B2#1	5.45245e-20
C94	VGND#1	a_245_94#	2.78936e-19
C95	a_83_264##9	A2#1	5.32926e-17
C96	a_83_264##4	C1#2	1.44043e-17
C97	VPWR#7	B2#3	6.21714e-19
C98	VGND#1	a_456_74##2	4.68501e-17
C99	a_456_74#	C1#2	1.90849e-18
C100	a_83_264##9	A1#1	8.41946e-18
C101	a_245_94#	C1#2	3.80486e-18
C102	a_83_264#	A1#3	2.16454e-17
C103	VPWR#7	A2#1	4.04537e-18
C104	VGND#1	a_245_94##2	8.94966e-19
C105	a_456_74#	B1#2	3.13771e-19
C106	a_83_264##9	a_83_264##3	3.42205e-18
C107	X#3	A2#1	4.49755e-19
C108	A1#1	VPWR#7	3.42422e-17
C109	a_245_94#	B1#2	5.91964e-18
C110	a_456_74##2	B1#2	6.8124e-20
C111	X#3	A1#1	3.14813e-18
C112	a_83_264##3	VPWR#7	4.17895e-17
C113	a_245_94#	B2#2	2.58863e-17
C114	X#3	a_83_264##3	4.82616e-17
C115	a_83_264##9	VPWR#3	2.06508e-17
C116	a_456_74##2	B2#2	6.44265e-18
C117	a_245_94##2	B2#2	2.07454e-17
C118	a_83_264##6	a_462_392#	8.04645e-18
C119	VGND#5	A2#2	9.62528e-19
C120	B1#3	C1#1	4.83156e-18
C121	a_245_94##2	A2#2	2.56745e-17
C122	a_83_264##6	a_264_392#	4.08698e-18
C123	VGND#1	C1#3	7.23518e-18
C124	a_245_94##2	A1#2	2.30602e-18
C125	B2#3	B1#3	2.88563e-17
C126	VPWR#3	B2#1	6.63986e-20
C127	VGND#6	A1#2	1.34003e-18
C128	VGND#1	B1#1	4.48047e-18
C129	VGND#1	B2#1	4.48191e-18
C130	a_245_94##2	a_83_264##2	1.1926e-18
C131	B1#1	C1#2	1.28774e-17
C132	A2#1	B2#3	2.55769e-17
C133	a_83_264##2	VGND#6	3.30846e-17
C134	VGND#1	A2#3	3.49357e-20
C135	A2#2	a_83_264##9	1.42267e-18
C136	B2#1	B1#2	3.38687e-18
C137	A1#1	A2#1	5.39697e-17
C138	B2#2	B1#1	1.52146e-19
C139	VPWR#7	A1#2	9.96253e-19
C140	X#3	A1#2	1.26065e-19
C141	A2#3	B2#2	6.83577e-18
C142	a_83_264##3	A1#1	1.62445e-17
C143	VPWR#3	B2#3	8.5857e-18
C144	a_83_264##2	VPWR#7	4.00664e-17
C145	VPWR#3	A2#1	5.67627e-18
C146	X#3	a_83_264##2	5.3338e-17
C147	B1#3	C1#2	3.81085e-19
C148	B1	a_83_264##6	1.03349e-17
C149	B1	a_83_264##5	3.09221e-17
C150	B2#2	B1#3	6.43537e-19
C151	B2	a_83_264##6	2.71586e-17
C152	a_83_264##2	A1#3	2.03731e-18
C153	a_456_74#	B1	2.12534e-18
C154	A2	a_83_264##6	1.89352e-17
C155	a_245_94#	B1	1.83113e-17
C156	a_83_264##2	B1#3	6.58972e-20
C157	VGND#1	C1#2	2.87486e-19
C158	a_83_264##2	B2#3	2.60627e-20
C159	VGND#1	B1#2	4.31179e-20
C160	VPWR#3	B2#2	1.78791e-19
C161	a_83_264##2	A2#1	4.66805e-20
C162	a_245_94#	B2	2.51564e-17
C163	a_83_264##3	A1#2	3.0828e-18
C164	A1	a_83_264##6	2.57597e-17
C165	B1#2	C1#2	2.65269e-17
C166	a_83_264##2	A1#1	1.66698e-19
C167	VGND#1	B2#2	1.17856e-18
C168	VPWR#3	A2#2	4.92247e-20
C169	B1#3	a_462_392#	2.99111e-17
C170	B1	VPWR#6	4.7745e-18
C171	a_83_264##2	a_83_264##3	5.58466e-18
C172	B2#3	a_462_392#	2.99111e-17
C173	B2#2	B1#2	2.2107e-17
C174	C1	a_83_264##5	6.23355e-17
C175	a_245_94##2	A2	1.10272e-17
C176	A2#1	a_264_392#	2.44902e-17
C177	A1#1	a_264_392#	2.44902e-17
C178	A2#2	B2#2	6.13392e-17
C179	a_83_264##2	B1#2	1.45915e-19
C180	a_245_94##2	A1	2.69663e-17
C181	VGND#6	A1	3.21467e-18
C182	A1#2	A2#2	3.3079e-17
C183	C1	a_83_264##4	3.9306e-17
C184	a_83_264##2	B2#2	6.26059e-19
C185	C1	a_456_74#	2.03345e-17
C186	B2	B2#1	4.332e-18
C187	a_245_94#	C1	1.01491e-17
C188	a_83_264##2	A2#2	1.27704e-18
C189	a_83_264##2	A1#2	3.65693e-17
C190	B2#2	a_462_392#	7.83824e-19
C191	A1	VPWR#7	1.42267e-18
C192	VPWR	a_83_264##6	1.6719e-17
C193	VPWR	a_83_264##5	4.25534e-18
C194	C1	VPWR#6	2.95086e-18
C195	X	a_245_94##2	3.80203e-18
C196	X	VGND#6	6.86004e-17
C197	VGND	VGND#2	4.02157e-17
C198	X	X#1	3.55433e-18
C199	C1	B1#1	2.68452e-18
C200	B1	C1#2	4.30352e-18
C201	B1	B1#2	1.95846e-17
C202	X	X#3	4.04273e-18
C203	B1	B2#2	4.07913e-19
C204	VPWR	a_83_264##8	1.72529e-17
C205	B2	B1#2	1.08308e-17
C206	VGND	a_83_264##4	2.1797e-17
C207	A1	a_83_264##3	6.38587e-19
C208	VPWR	a_83_264##9	1.57264e-17
C209	VGND	a_456_74#	2.42133e-17
C210	X	A1#3	1.12826e-18
C211	B2	B2#2	5.49291e-18
C212	B1	A1#2	2.249e-19
C213	VGND	a_245_94#	1.009e-17
C214	VPWR	VPWR#7	2.70166e-17
C215	VGND	a_456_74##2	2.17986e-17
C216	X	a_83_264#	3.08253e-17
C217	VPWR	X#3	1.63901e-17
C218	VGND	a_245_94##2	1.91289e-17
C219	VGND	VGND#6	1.96607e-17
C220	A2	A2#2	7.91379e-18
C221	A2	A1#2	3.60206e-18
C222	VGND#1	C1	1.01072e-18
C223	C1	C1#2	3.01258e-17
C224	VGND	X#3	1.33569e-18
C225	VPWR	C1#1	5.58196e-19
C226	A1	A2#2	4.09557e-18
C227	B2	a_462_392#	6.69516e-19
C228	VGND	C1#3	2.34382e-18
C229	VPWR	B1#3	7.4836e-19
C230	C1	B1#2	4.78402e-18
C231	VGND	B1#1	1.61578e-18
C232	A1	A1#2	1.71693e-17
C233	VPWR	B2#3	1.50201e-18
C234	VGND	B2#1	2.06663e-18
C235	C1	B2#2	6.21282e-19
C236	VPWR	A2#1	4.4395e-19
C237	VGND	A2#3	4.11639e-18
C238	a_83_264##2	A1	3.92098e-17
C239	VGND#2	VNB	2.53853e-17
C240	VGND	A1#3	8.13922e-18
C241	VPWR	A1#1	1.5723e-18
C242	C1	A2#2	2.37472e-19
C243	VGND	a_83_264#	2.39501e-18
C244	VPWR	a_83_264##3	4.41442e-18
C245	a_83_264##6	VNB	6.44368e-18
C246	a_83_264##5	VNB	3.50638e-17
C247	X	B2#2	1.36972e-19
C248	VPWR	VPWR#3	2.4894e-17
C249	X	A2#2	9.14045e-20
C250	B2	B1	2.81767e-17
C251	a_83_264##4	VNB	5.27053e-17
C252	X	a_83_264##2	4.75532e-17
C253	a_456_74#	VNB	9.0953e-18
C254	VPWR	B2#2	1.20068e-18
C255	a_245_94#	VNB	1.62499e-18
C256	a_456_74##2	VNB	1.19976e-17
C257	VGND#5	VNB	6.84619e-18
C258	VPWR	A2#2	1.02499e-18
C259	a_245_94##2	VNB	1.09348e-17
C260	VGND#6	VNB	1.05081e-17
C261	VGND	VGND#1	5.13138e-17
C262	a_83_264##8	VNB	3.48585e-17
C263	VPWR	a_83_264##2	2.90236e-18
C264	a_83_264##9	VNB	2.76501e-18
C265	VGND	B2#2	2.62387e-18
C266	VPWR#7	VNB	5.6344e-18
C267	X#3	VNB	6.06612e-17
C268	VGND	A2#2	1.11458e-18
C269	C1#3	VNB	3.17559e-17
C270	B1	C1	2.75515e-17
C271	B1#1	VNB	3.5116e-17
C272	B2#1	VNB	4.13351e-17
C273	A2#3	VNB	3.17679e-17
C274	VGND	a_83_264##2	3.29858e-18
C275	A1	A2	2.19085e-17
C276	A1#3	VNB	3.5874e-17
C277	B2	C1	8.34023e-19
C278	a_83_264#	VNB	3.79502e-17
C279	C1#1	VNB	3.32506e-17
C280	B1#3	VNB	2.90071e-17
C281	B2#3	VNB	3.02618e-17
C282	A2#1	VNB	2.8107e-17
C283	A1#1	VNB	2.98832e-17
C284	VPWR	B1	2.05118e-18
C285	a_83_264##3	VNB	3.94053e-17
C286	VPWR#3	VNB	2.16309e-16
C287	VPWR	B2	1.48717e-18
C288	VGND#1	VNB	2.67303e-16
C289	C1#2	VNB	6.64878e-17
C290	VPWR	A2	7.81528e-19
C291	B1#2	VNB	3.59967e-17
C292	VGND	B1	3.41233e-18
C293	B2#2	VNB	4.96238e-17
C294	A2#2	VNB	4.61959e-17
C295	VGND	B2	1.67679e-18
C296	VPWR	A1	1.97043e-18
C297	A1#2	VNB	3.6639e-17
C298	a_83_264##2	VNB	5.19324e-17
C299	VGND	A2	8.31347e-19
C300	VPWR	C1	2.77259e-18
C301	VGND	A1	2.73655e-18
C302	VGND	C1	5.12552e-18
C303	VGND	X	1.86476e-17
C304	B1	VNB	1.50062e-18
C305	B2	VNB	7.99241e-19
C306	A1	VNB	1.27388e-18
C307	C1	VNB	3.826e-18
C308	X	VNB	5.95623e-17
C309	VPWR	VNB	5.56781e-17
C310	VGND	VNB	8.01996e-17
C311	VPWR#2	B2#1	2.15457e-19
C312	VGND#3	a_83_264##2	4.78472e-19
C313	a_83_264##9	VPWR#2	1.84459e-17
C314	VGND#3	A1#3	4.3042e-18
C315	VPWR#2	B2#3	5.98412e-18
C316	VGND#3	VGND#2	9.30861e-19
C317	VGND#3	a_83_264#	4.74518e-18
C318	VPWR	VPWR#2	1.02558e-16
C319	VPWR#4	A1#1	8.62614e-18
C320	VPWR#2	C1#2	1.79439e-18
C321	VPWR#2	A2#1	2.67487e-18
C322	VPWR	VPWR#4	4.54714e-17
C323	a_83_264##6	VPWR#4	2.34649e-18
C324	VPWR#4	a_83_264##3	4.65802e-18
C325	VGND#3	a_245_94##2	5.72425e-18
C326	VPWR#2	B1#2	1.9041e-18
C327	VPWR#2	A1#1	4.4238e-19
C328	VPWR#2	a_83_264##8	8.52437e-17
C329	VGND#3	A1	4.00657e-19
C330	a_83_264##2	VPWR#4	4.4965e-19
C331	X#3	VPWR#4	2.0818e-17
C332	a_83_264##6	VPWR#2	1.13154e-17
C333	VPWR#3	VPWR#4	6.71981e-17
C334	VPWR#2	VNB	7.08566e-17
C335	VGND#3	X	2.44965e-17
C336	VGND#1	VGND#3	5.8543e-17
C337	VPWR#2	VPWR#6	2.31347e-17
C338	VPWR#4	VNB	5.97194e-17
C339	a_83_264##5	VPWR#2	6.36261e-17
C340	VGND	VGND#3	3.89779e-17
C341	VPWR#2	C1#1	2.56143e-17
C342	VGND#3	VNB	5.24041e-17
C343	VPWR#3	VPWR#2	7.58762e-17
C344	VGND#3	A1#2	4.83569e-20
C345	VPWR#2	B1#3	3.91356e-17
*
*
.ENDS sky130_fd_sc_hs__o221a_1
*
