* Extracted by Quantus, converted by sky130cad/quantus.py
*
*
*
*                       LINUX           Wed Nov 18 08:26:02 2026
*
*
*
*  PROGRAM  advgen
*
*  Name           : advgen - Quantus - (64-bit)
*  Version        : 25.1.0-p047
*  Build Date     : Thu Dec 11 23:20:30 PST 2025
*
*  HSPICE LIBRARY
*
*  OPERATING_TEMPERATURE 150
*  QRC_TECH_DIR <path>/tech
*
*
*

*
.SUBCKT sky130_fd_sc_hs__dfbbp_1 VPB VNB VGND VPWR Q_N Q RESET_B CLK SET_B D
*
*
*  caps2d version: 10
*
*
*       TRANSISTOR CARDS
*
*
XM34 a_27_74##14 CLK#3 VGND#20 VNB sky130_fd_pr__nfet_01v8_lvt l=0.15 w=0.74 ad=0.2109 as=0.259 pd=2.05 ps=2.18
XM27 VGND#20 a_27_74##5 a_214_74##9 VNB sky130_fd_pr__nfet_01v8_lvt l=0.15 w=0.74 ad=0.259 as=0.2109 pd=2.18 ps=2.05
XM36 VGND#19 D#3 a_422_125##2 VNB sky130_fd_pr__nfet_01v8_lvt l=0.15 w=0.42 ad=0.1197 as=0.17605 pd=1.41 ps=1.9
XM26 a_422_125##2 a_27_74##8 a_520_87##6 VNB sky130_fd_pr__nfet_01v8_lvt l=0.15 w=0.42 ad=0.17605 as=0.1176 pd=1.9 ps=1.4
XM23 a_520_87##6 a_214_74##3 a_606_87# VNB sky130_fd_pr__nfet_01v8_lvt l=0.15 w=0.42 ad=0.1176 as=0.1645 pd=1.4 ps=1.81
XM20 a_606_87# a_671_93##3 VGND#18 VNB sky130_fd_pr__nfet_01v8_lvt l=0.15 w=0.42 ad=0.1645 as=0.475675 pd=1.81 ps=3.04
XM29 VGND#18 SET_B#3 a_872_119##2 VNB sky130_fd_pr__nfet_01v8_lvt l=0.15 w=0.55 ad=0.475675 as=0.38405 pd=3.04 ps=2.67
XM15 a_872_119##2 a_520_87##3 a_671_93##9 VNB sky130_fd_pr__nfet_01v8_lvt l=0.15 w=0.55 ad=0.38405 as=0.154 pd=2.67 ps=1.66
XM14 a_671_93##9 a_1062_93##3 a_872_119# VNB sky130_fd_pr__nfet_01v8_lvt l=0.15 w=0.55 ad=0.154 as=0.26245 pd=1.66 ps=2.29
XM30 VGND#15 a_671_93##4 a_1318_119# VNB sky130_fd_pr__nfet_01v8_lvt l=0.15 w=0.55 ad=0.26105 as=0.1155 pd=2.28 ps=1.52
XM1 a_1318_119# a_214_74##5 a_1311_424##7 VNB sky130_fd_pr__nfet_01v8_lvt l=0.15 w=0.55 ad=0.1155 as=0.2317 pd=1.52 ps=2.33
XM18 a_1311_424##7 a_27_74##11 a_1498_74# VNB sky130_fd_pr__nfet_01v8_lvt l=0.15 w=0.42 ad=0.2317 as=0.1638 pd=2.33 ps=1.62
XM24 a_1498_74# a_1474_446# VGND#14 VNB sky130_fd_pr__nfet_01v8_lvt l=0.15 w=0.42 ad=0.1638 as=0.2424 pd=1.62 ps=2.2
XM5 VGND#14 SET_B#6 a_1708_74##2 VNB sky130_fd_pr__nfet_01v8_lvt l=0.15 w=0.74 ad=0.2424 as=0.259 pd=2.2 ps=2.18
XM38 a_1708_74##2 a_1311_424##3 a_1474_446##14 VNB sky130_fd_pr__nfet_01v8_lvt l=0.15 w=0.74 ad=0.259 as=0.2109 pd=2.18 ps=2.05
XM2 a_1474_446##14 a_1062_93##6 a_1708_74# VNB sky130_fd_pr__nfet_01v8_lvt l=0.15 w=0.74 ad=0.2109 as=0.2294 pd=2.05 ps=2.1
XM16 a_1062_93##15 RESET_B#3 VGND#13 VNB sky130_fd_pr__nfet_01v8_lvt l=0.15 w=0.42 ad=0.1197 as=0.2606 pd=1.41 ps=2.34
XM21 VGND#13 a_1474_446##9 Q_N#3 VNB sky130_fd_pr__nfet_01v8_lvt l=0.15 w=0.74 ad=0.2606 as=0.2109 pd=2.34 ps=2.05
XM12 a_2320_410##8 a_1474_446##4 VGND#12 VNB sky130_fd_pr__nfet_01v8_lvt l=0.15 w=0.42 ad=0.1197 as=0.2165 pd=1.41 ps=2.13
XM32 VGND#12 a_2320_410# Q#3 VNB sky130_fd_pr__nfet_01v8_lvt l=0.15 w=0.74 ad=0.2165 as=0.1998 pd=2.13 ps=2.02
XM10 a_27_74##15 CLK#1 VPWR#18 VPB sky130_fd_pr__pfet_01v8 l=0.15 w=1.12 ad=0.3304 as=0.4816 pd=2.83 ps=3.1
XM19 VPWR#18 a_27_74##9 a_214_74##10 VPB sky130_fd_pr__pfet_01v8 l=0.15 w=1.12 ad=0.4816 as=0.308 pd=3.1 ps=2.79
XM22 VPWR#16 D#1 a_422_125# VPB sky130_fd_pr__pfet_01v8 l=0.15 w=0.42 ad=0.2604 as=0.126 pd=2.08 ps=1.44
XM6 a_422_125# a_214_74##4 a_520_87##7 VPB sky130_fd_pr__pfet_01v8 l=0.15 w=0.42 ad=0.126 as=0.2289 pd=1.44 ps=2.42
XM4 a_520_87##7 a_27_74# a_713_379# VPB sky130_fd_pr__pfet_01v8 l=0.15 w=0.42 ad=0.2289 as=0.1008 pd=2.42 ps=1.32
XM11 a_713_379# a_671_93# VPWR#13 VPB sky130_fd_pr__pfet_01v8 l=0.15 w=0.42 ad=0.1008 as=0.2961 pd=1.32 ps=2.56
XM28 VPWR#13 SET_B#1 a_671_93##7 VPB sky130_fd_pr__pfet_01v8 l=0.15 w=0.84 ad=0.2961 as=0.3276 pd=2.56 ps=2.46
XM0 a_671_93##7 a_520_87# a_1017_379# VPB sky130_fd_pr__pfet_01v8 l=0.15 w=0.84 ad=0.3276 as=0.2268 pd=2.46 ps=2.22
XM8 a_1017_379# a_1062_93# VPWR#11 VPB sky130_fd_pr__pfet_01v8 l=0.15 w=0.84 ad=0.2268 as=0.3024 pd=2.22 ps=2.4
XM3 VPWR#11 a_671_93##6 a_1203_379# VPB sky130_fd_pr__pfet_01v8 l=0.15 w=0.84 ad=0.3024 as=0.3591 pd=2.4 ps=2.91
XM35 a_1203_379# a_27_74##6 a_1311_424##6 VPB sky130_fd_pr__pfet_01v8 l=0.15 w=0.84 ad=0.3591 as=0.2856 pd=2.91 ps=2.45
XM39 a_1311_424##6 a_214_74##6 a_1418_508# VPB sky130_fd_pr__pfet_01v8 l=0.15 w=0.42 ad=0.2856 as=0.1239 pd=2.45 ps=1.43
XM25 a_1418_508# a_1474_446##3 VPWR#9 VPB sky130_fd_pr__pfet_01v8 l=0.15 w=0.42 ad=0.1239 as=0.5191 pd=1.43 ps=3.74
XM9 VPWR#9 SET_B#4 a_1474_446##12 VPB sky130_fd_pr__pfet_01v8 l=0.15 w=1 ad=0.5191 as=0.365 pd=3.74 ps=2.73
XM37 a_1474_446##12 a_1311_424# a_1814_392# VPB sky130_fd_pr__pfet_01v8 l=0.15 w=1 ad=0.365 as=0.265 pd=2.73 ps=2.53
XM7 a_1814_392# a_1062_93##7 VPWR#7 VPB sky130_fd_pr__pfet_01v8 l=0.15 w=1 ad=0.265 as=0.295 pd=2.53 ps=2.59
XM17 a_1062_93##12 RESET_B#1 VPWR#6 VPB sky130_fd_pr__pfet_01v8 l=0.15 w=0.64 ad=0.176 as=0.3656 pd=1.83 ps=2.97
XM31 VPWR#6 a_1474_446##7 Q_N#1 VPB sky130_fd_pr__pfet_01v8 l=0.15 w=1.12 ad=0.3656 as=0.308 pd=2.97 ps=2.79
XM33 a_2320_410##7 a_1474_446##8 VPWR#5 VPB sky130_fd_pr__pfet_01v8 l=0.15 w=0.84 ad=0.231 as=0.3836 pd=2.23 ps=2.97
XM13 VPWR#5 a_2320_410##4 Q#1 VPB sky130_fd_pr__pfet_01v8 l=0.15 w=1.12 ad=0.3836 as=0.3192 pd=2.97 ps=2.81
*
*
*       RESISTOR AND CAP/DIODE CARDS
*
Rg1	CLK#1	CLK#2	492.059540
Rg2	CLK#2	CLK#3	307.937683
Rg3	D#1	D#2	340.867371
Rg4	D#2	D#3	595.094910
Rg5	a_671_93#	a_671_93##2	408.798279
Rg6	a_671_93##2	a_671_93##3	244.673935
Rg7	SET_B#1	SET_B#2	389.028503
Rg8	SET_B#2	SET_B#3	343.399017
Rg9	a_520_87#	a_520_87##2	420.419403
Rg10	a_520_87##2	a_520_87##3	253.420792
Rg11	a_1062_93#	a_1062_93##2	420.419403
Rg12	a_1062_93##2	a_1062_93##3	253.420792
Rg13	a_671_93##4	a_671_93##5	406.692566
Rg14	a_671_93##5	a_671_93##6	414.906952
Rg15	a_27_74#	a_27_74##2	466.629761
Rg16	a_27_74##2	a_27_74##3	1998.512085
Rg17	a_27_74##3	a_27_74##4	164.581238
Rg18	a_27_74##4	a_27_74##5	345.418396
Rg19	a_27_74##2	a_27_74##6	1974.578125
Rg20	a_27_74##6	a_27_74##7	358.168671
Rg21	a_27_74##3	a_27_74##8	1383.111328
Rg22	a_27_74##4	a_27_74##9	448.418579
Rg23	a_214_74#	a_214_74##2	174.068161
Rg24	a_214_74##2	a_214_74##3	372.132294
Rg25	a_214_74##2	a_214_74##4	550.515564
Rg26	a_214_74##3	a_214_74##5	2804.694092
Rg27	a_214_74##5	a_214_74##6	1031.795776
Rg28	a_27_74##10	a_27_74##11	216.119781
Rg29	a_1474_446#	a_1474_446##2	883.341858
Rg30	a_1474_446##2	a_1474_446##3	298.939301
Rg31	SET_B#4	SET_B#5	400.207520
Rg32	SET_B#5	SET_B#6	451.403168
Rg33	a_1311_424#	a_1311_424##2	518.009277
Rg34	a_1311_424##2	a_1311_424##3	320.356293
Rg35	a_1062_93##4	a_1062_93##5	322.823730
Rg36	a_1062_93##5	a_1062_93##6	297.530212
Rg37	a_1062_93##5	a_1062_93##7	577.727722
Rg38	RESET_B#1	RESET_B#2	343.705231
Rg39	RESET_B#2	RESET_B#3	295.497040
Rg40	a_1474_446##4	a_1474_446##5	540.050903
Rg41	a_1474_446##5	a_1474_446##6	130.112946
Rg42	a_1474_446##6	a_1474_446##7	457.936249
Rg43	a_1474_446##5	a_1474_446##8	553.278259
Rg44	a_1474_446##6	a_1474_446##9	386.316772
Rg45	a_2320_410#	a_2320_410##2	343.038818
Rg46	a_2320_410##2	a_2320_410##3	36.503117
Rg47	a_2320_410##2	a_2320_410##4	491.849670
Rf1	CLK#4	CLK#2	161.781219
Rf2	CLK	CLK#6	1.548413
Rf3	CLK#4	CLK#6	7.059660
Rf4	a_27_74##4	a_27_74##13	223.073929
Rf5	a_27_74##13	a_27_74##14	76.435287
Rf6	a_27_74##13	a_27_74##15	23.009480
Rf7	D#2	D#5	160.921738
Rf8	D#6	D	0.688927
Rf9	D#5	D#6	1.771527
Rf10	a_214_74#	a_214_74##8	196.470367
Rf11	a_214_74##8	a_214_74##9	40.510826
Rf12	a_214_74##8	a_214_74##10	55.917782
Rf13	a_422_125#	a_422_125##2	175.917938
Rf14	a_520_87##2	a_520_87##5	305.126770
Rf15	a_520_87##5	a_520_87##6	107.488655
Rf16	a_520_87##5	a_520_87##7	35.098614
Rf17	a_1062_93##8	a_1062_93##9	0.728341
Rf18	a_1062_93##2	a_1062_93##11	160.961151
Rf19	a_1062_93##8	a_1062_93##11	4.920908
Rf20	a_872_119#	a_872_119##2	96.334999
Rf21	a_671_93##7	a_671_93##8	128.629242
Rf22	a_671_93##8	a_671_93##10	77.583061
Rf23	a_671_93##10	a_671_93##2	289.348450
Rf24	a_671_93##9	a_671_93##10	15.000000
Rf25	a_27_74##10	a_27_74##7	497.125183
Rf26	SET_B#2	SET_B	711.586975
Rf27	SET_B	SET_B#5	161.413818
Rf28	a_1311_424##2	a_1311_424##5	301.834259
Rf29	a_1311_424##5	a_1311_424##6	81.673332
Rf30	a_1311_424##5	a_1311_424##7	54.769058
Rf31	a_1708_74#	a_1708_74##2	107.494057
Rf32	a_1062_93##12	a_1062_93##4	47.948086
Rf33	a_1062_93##4	a_1062_93##14	3.304946
Rf34	a_1062_93##14	a_1062_93##15	61.171638
Rf35	RESET_B	RESET_B#2	82.005402
Rf36	a_1474_446##6	a_1474_446##11	337.968689
Rf37	a_1474_446##11	a_1474_446##13	6.477841
Rf38	a_1474_446##11	a_1474_446##14	103.699585
Rf39	a_1474_446##11	a_1474_446##2	214.400421
Rf40	a_1474_446##12	a_1474_446##13	5.000000
Rf41	Q_N#2	Q_N	0.870462
Rf42	Q_N	Q_N#3	89.711594
Rf43	Q_N#1	Q_N#2	5.000000
Rf44	a_2320_410##3	a_2320_410##6	172.653183
Rf45	a_2320_410##6	a_2320_410##7	73.098579
Rf46	a_2320_410##6	a_2320_410##8	61.232555
Rf47	Q	Q#2	0.194040
Rf48	Q#2	Q	14.164948
Rf49	Q	Q#4	7.179494
Rf50	Q#4	Q	7.179494
Rf51	Q#1	Q#2	5.000000
Rf52	Q#3	Q#4	7.500000
Rf54	VPWR#2	VPWR#3	105.566254
Rf55	VPWR#3	VPWR#4	66.816673
Rf56	VPWR#2	VPWR#5	48.259808
Rf57	VPWR#3	VPWR#6	34.704330
Rf58	VPWR#4	VPWR#7	36.824379
Rf59	VPWR#4	VPWR#8	135.815475
Rf60	VPWR#8	VPWR#9	14.698244
Rf61	VPWR#8	VPWR#10	170.688736
Rf62	VPWR#10	VPWR#11	38.138847
Rf63	VPWR#10	VPWR#12	118.329742
Rf64	VPWR#12	VPWR#13	71.050484
Rf65	VPWR#12	VPWR#14	51.533413
Rf66	VPWR#14	VPWR#15	91.472603
Rf67	VPWR#15	VPWR#16	21.896482
Rf68	VPWR#15	VPWR#17	90.352318
Rf69	VPWR#17	VPWR#18	34.939823
Rf72	VGND#2	VGND#3	105.931503
Rf73	VGND#3	VGND#4	64.990410
Rf74	VGND#4	VGND#5	116.125755
Rf75	VGND#5	VGND#6	146.396835
Rf76	VGND#6	VGND#7	174.334305
Rf77	VGND#7	VGND#8	36.313747
Rf78	VGND#8	VGND#9	115.452599
Rf79	VGND#9	VGND#10	73.058777
Rf81	VGND#2	VGND#12	40.352859
Rf82	VGND#3	VGND#13	34.507496
Rf83	VGND#5	VGND#14	31.141060
Rf84	VGND#6	VGND#16	14.843747
Rf86	VGND#7	VGND#18	23.716663
Rf87	VGND#9	VGND#19	53.399349
Rf88	VGND#10	VGND#20	32.518913
Rf89	VGND#15	VGND#16	7.500000
Rf96	a_671_93##5	a_671_93##8	160.232803
Re1	a_1062_93##14	a_1062_93##9	26.769386
Re2	VPWR#4	VPWR	2.042809
Re3	VPWR	VPWR#14	1.896894
Re4	VGND#4	VGND	2.042809
Re5	VGND	VGND#8	1.896894
*
*       CAPACITOR CARDS
*
*
C1	a_1311_424##2	SET_B#6	2.08207e-17
C2	a_27_74##4	a_214_74##9	1.88756e-17
C3	a_1474_446#	SET_B#6	3.18888e-17
C4	a_27_74##4	a_27_74##3	9.33947e-18
C5	VPWR#8	SET_B#5	6.59414e-19
C6	a_1474_446##11	RESET_B#2	7.91129e-19
C7	VPWR#8	a_214_74##5	1.43341e-19
C8	SET_B#2	a_1311_424##6	2.0036e-17
C9	VPWR#7	a_1311_424#	5.2954e-18
C10	VGND#20	a_27_74##4	2.95644e-18
C11	a_1062_93##15	a_1062_93##12	1.8559e-18
C12	VPWR#18	a_27_74##3	2.57175e-18
C13	a_1311_424##2	a_1474_446#	1.74661e-17
C14	VGND#8	a_27_74##8	2.25336e-18
C15	VPWR#4	a_1474_446##8	1.01049e-17
C16	SET_B#1	a_520_87#	2.56056e-17
C17	a_520_87##2	a_671_93##7	3.26392e-17
C18	VGND#9	a_214_74##3	4.55325e-19
C19	VGND#7	a_27_74##3	2.6378e-19
C20	SET_B#2	VPWR#11	8.05906e-17
C21	VPWR#4	a_1474_446##7	3.91625e-18
C22	VGND#14	a_27_74##11	2.81275e-18
C23	a_520_87##2	VPWR#13	2.60394e-18
C24	a_1474_446##11	SET_B#4	3.89487e-17
C25	VGND#20	VGND#9	2.46378e-18
C26	VGND#6	a_27_74##7	1.01392e-18
C27	a_520_87##5	a_520_87##7	1.37493e-19
C28	VGND#4	a_1474_446##8	6.54275e-21
C29	a_214_74##9	CLK#2	5.52069e-20
C30	a_1474_446#	SET_B#5	1.70103e-18
C31	a_1311_424##2	a_214_74##5	5.84336e-19
C32	a_1062_93##14	a_1062_93##7	8.54513e-19
C33	a_520_87##5	VPWR#14	6.83735e-19
C34	VPWR#10	a_1062_93#	4.47559e-19
C35	VPWR#7	SET_B#4	3.58463e-19
C36	VPWR#4	RESET_B#1	6.87113e-18
C37	VGND#7	a_214_74##3	5.73194e-17
C38	a_2320_410##6	a_1474_446##5	2.02474e-17
C39	CLK#2	VGND#20	2.87285e-18
C40	a_1311_424#	a_1474_446##12	2.37136e-17
C41	SET_B#2	a_671_93##7	1.69033e-16
C42	a_27_74##11	a_1474_446#	1.50494e-17
C43	VGND#13	Q_N#3	4.30572e-17
C44	a_27_74##10	a_1062_93##6	1.02708e-19
C45	a_671_93#	SET_B#1	1.43482e-17
C46	a_1474_446##11	a_1062_93##4	3.06099e-18
C47	a_27_74##14	CLK#2	5.30708e-18
C48	a_1474_446##2	VPWR#8	5.61673e-17
C49	VPWR#4	a_1062_93##7	4.48819e-18
C50	SET_B#2	VPWR#13	7.34562e-17
C51	a_27_74##3	a_27_74##2	2.64781e-19
C52	a_1708_74#	a_1474_446##11	1.23554e-18
C53	a_27_74##10	a_1311_424##3	1.71897e-19
C54	VGND#14	a_214_74##5	2.39013e-19
C55	VGND#3	a_1474_446##5	1.18053e-19
C56	a_1474_446##5	a_2320_410#	1.68118e-18
C57	a_1474_446##6	a_1474_446##5	1.35095e-18
C58	a_27_74#	SET_B#1	1.82168e-18
C59	VPWR#4	a_1311_424#	6.54109e-18
C60	a_27_74##10	SET_B#6	2.47529e-18
C61	VGND#9	a_27_74##8	4.49723e-17
C62	a_214_74##5	a_1474_446#	1.09143e-18
C63	a_422_125#	a_520_87##5	3.32752e-17
C64	a_27_74##11	a_1311_424##7	7.61634e-18
C65	a_520_87##7	SET_B#2	8.899e-19
C66	SET_B#4	a_1474_446##12	7.39717e-18
C67	a_27_74##15	a_27_74##3	4.7689e-19
C68	a_1474_446##11	a_1474_446##3	1.00035e-18
C69	VGND#8	a_520_87##5	2.82279e-19
C70	a_1474_446##11	a_1062_93##12	8.50928e-17
C71	a_214_74##5	a_1474_446##2	4.54761e-18
C72	a_27_74#	a_671_93#	4.32623e-17
C73	VGND#6	a_671_93##5	3.37166e-18
C74	a_27_74##10	a_1474_446#	4.31008e-17
C75	VPWR#4	SET_B#4	5.4606e-19
C76	VPWR#10	a_520_87#	1.54473e-18
C77	a_1062_93##15	Q_N#3	1.67377e-18
C78	a_1062_93##14	Q_N#3	7.25276e-19
C79	VGND#7	a_27_74##8	8.32528e-19
C80	SET_B#4	VPWR#9	2.361e-17
C81	a_27_74##10	a_27_74##11	2.08859e-17
C82	a_214_74##5	a_27_74##11	1.84705e-17
C83	a_1311_424##2	a_1474_446##11	3.42872e-17
C84	VPWR#8	a_27_74##10	1.59132e-19
C85	a_422_125##2	a_520_87##6	6.50003e-17
C86	a_27_74##10	a_214_74##5	4.83002e-17
C87	a_27_74##8	a_27_74##3	2.30644e-18
C88	a_1474_446##14	a_1474_446##11	1.07012e-18
C89	a_1311_424##7	a_214_74##5	2.74221e-17
C90	a_2320_410##3	a_1474_446##8	4.45451e-18
C91	a_422_125#	a_671_93##2	8.48095e-20
C92	VPWR#4	a_214_74##6	1.97183e-18
C93	a_1474_446##11	VPWR#8	4.47048e-17
C94	a_214_74##4	a_27_74#	3.11747e-17
C95	a_27_74##10	a_671_93##4	1.21403e-18
C96	a_27_74##7	a_27_74##11	4.64407e-19
C97	VPWR#12	SET_B#1	3.91861e-18
C98	a_1474_446##11	a_214_74##6	2.07422e-19
C99	a_1474_446##3	VPWR#9	4.62147e-18
C100	a_1062_93##15	VGND#13	3.95944e-17
C101	VGND#9	D#3	4.85051e-18
C102	a_214_74##8	a_422_125#	1.11873e-18
C103	a_1474_446##11	VPWR#7	5.2839e-17
C104	a_214_74##5	a_27_74##7	3.96617e-17
C105	a_1708_74#	a_1062_93##14	2.11085e-17
C106	VGND#19	a_520_87##6	5.18793e-18
C107	a_214_74#	a_422_125#	1.581e-17
C108	VPWR#10	a_27_74##7	2.23661e-20
C109	a_671_93##4	a_27_74##7	3.27112e-17
C110	a_1474_446##11	SET_B#5	1.0246e-18
C111	a_214_74##5	a_671_93##4	7.4143e-17
C112	a_1062_93##5	RESET_B#2	1.65277e-18
C113	a_1474_446##6	a_1474_446##7	1.94636e-17
C114	a_1311_424##5	a_1311_424##2	3.38743e-18
C115	a_1311_424##7	a_671_93##4	1.02327e-18
C116	a_1062_93##14	a_1474_446##14	4.3377e-17
C117	D#1	a_214_74##4	2.37184e-17
C118	a_1062_93##9	a_214_74##6	6.2688e-19
C119	a_214_74#	VPWR#16	5.51725e-18
C120	VGND#4	a_2320_410##8	1.50541e-17
C121	VPWR#8	a_27_74##7	1.82303e-20
C122	a_27_74##7	a_1062_93##3	2.45774e-19
C123	D#3	a_214_74##2	1.1756e-18
C124	a_214_74##5	a_671_93##5	1.04351e-17
C125	a_1708_74##2	a_1474_446##11	1.28837e-19
C126	a_422_125##2	a_520_87##5	3.47384e-17
C127	a_520_87#	a_27_74##2	1.15924e-17
C128	VGND#15	a_214_74##5	1.17172e-18
C129	a_1474_446##6	RESET_B#1	2.94316e-17
C130	a_1474_446##11	VPWR#3	1.0805e-18
C131	a_1062_93##14	a_1708_74##2	8.3144e-18
C132	a_1311_424##6	a_1474_446##3	1.4171e-18
C133	a_1062_93##9	a_27_74##6	6.25491e-19
C134	a_1708_74#	VGND#13	2.43289e-18
C135	a_671_93##5	a_671_93##4	1.69053e-18
C136	VGND#4	Q_N#3	2.15323e-17
C137	a_214_74##5	a_1062_93##3	1.91392e-17
C138	a_422_125#	D#2	6.02984e-18
C139	a_671_93##7	a_1311_424##6	1.43438e-18
C140	a_214_74##8	VPWR#16	6.53004e-18
C141	VPWR#12	a_671_93#	1.63183e-18
C142	a_1474_446##6	a_1062_93##7	3.34848e-19
C143	VGND#19	a_422_125##2	3.84471e-17
C144	a_27_74##3	D#3	3.88747e-17
C145	a_671_93##5	a_1062_93##3	1.63835e-18
C146	a_1062_93##14	VGND#14	8.01081e-18
C147	VPWR#16	D#2	1.01001e-17
C148	a_214_74##5	a_1062_93##2	8.35e-19
C149	VGND#9	a_27_74##5	1.18594e-18
C150	a_872_119#	a_214_74##5	2.01111e-17
C151	D#6	a_422_125#	5.07154e-18
C152	a_214_74##10	D#2	2.733e-18
C153	a_671_93##5	a_520_87##3	2.0816e-19
C154	a_1062_93##7	RESET_B#2	5.26269e-19
C155	a_1474_446##11	a_1474_446##2	6.26504e-19
C156	a_1062_93##3	a_671_93##4	2.88507e-18
C157	VPWR#10	a_671_93##5	8.16646e-20
C158	a_1311_424##5	SET_B#5	3.71097e-18
C159	a_1311_424##6	a_214_74##6	2.9251e-17
C160	a_214_74##5	a_520_87##3	7.01772e-18
C161	VGND#4	a_1062_93##15	4.0812e-17
C162	a_671_93##4	VGND#15	1.13452e-17
C163	a_422_125#	a_27_74##4	8.26097e-20
C164	a_1474_446##9	a_1474_446##5	2.63902e-18
C165	a_214_74##5	a_520_87##2	7.46183e-19
C166	a_1708_74#	a_1062_93##15	5.82882e-17
C167	a_671_93##9	a_214_74##5	2.18614e-18
C168	a_214_74##9	a_422_125##2	2.03669e-18
C169	VGND#4	a_1708_74#	6.00001e-17
C170	a_520_87##2	a_671_93##4	3.69177e-19
C171	CLK#1	a_27_74##9	2.76231e-17
C172	a_1062_93##5	a_1062_93##4	1.27125e-17
C173	a_27_74##4	a_214_74##10	1.30488e-17
C174	VGND#3	Q_N#3	2.41097e-17
C175	a_872_119#	a_671_93##4	5.0414e-19
C176	a_1311_424##6	a_27_74##6	3.54949e-17
C177	a_520_87##2	a_1062_93##3	1.78902e-18
C178	VGND#4	a_1474_446##14	4.96016e-18
C179	a_27_74##4	VPWR#18	1.85806e-17
C180	a_1474_446##11	a_1474_446##12	6.5002e-18
C181	a_27_74##2	SET_B#1	2.09633e-17
C182	D#6	VPWR#16	2.55338e-17
C183	SET_B#2	a_214_74##5	8.91893e-19
C184	a_872_119##2	a_214_74##5	8.50825e-19
C185	a_1311_424##2	a_1062_93##7	4.99463e-18
C186	VGND#15	a_1062_93##3	9.43998e-19
C187	a_520_87##2	a_520_87##3	7.66346e-18
C188	VGND#7	SET_B#2	1.16437e-19
C189	a_2320_410##7	a_1474_446##4	1.51084e-19
C190	VGND#4	a_1708_74##2	3.36276e-17
C191	a_1311_424##5	a_1474_446##2	2.62544e-17
C192	a_520_87##3	a_1062_93##3	3.08576e-17
C193	D#5	a_422_125#	7.06855e-18
C194	a_214_74##9	VGND#19	5.61361e-17
C195	a_671_93##9	a_671_93##4	1.96664e-19
C196	a_27_74##5	a_27_74##3	2.7316e-17
C197	a_520_87##2	SET_B#3	1.70731e-17
C198	VGND#4	VGND#14	1.73368e-17
C199	a_1311_424##6	a_671_93##6	3.21831e-18
C200	a_1062_93##3	a_872_119#	2.285e-17
C201	a_214_74##2	a_671_93#	9.33182e-19
C202	VPWR#11	a_27_74##6	8.51479e-19
C203	SET_B#5	a_1311_424#	5.2636e-18
C204	a_214_74##3	a_520_87##2	2.5335e-18
C205	a_872_119##2	a_671_93##4	1.10441e-19
C206	VGND#19	a_214_74##8	2.48438e-17
C207	a_214_74##10	D#6	6.63368e-18
C208	a_1474_446##4	a_1474_446##8	1.33704e-18
C209	Q_N#3	a_1474_446##5	8.43498e-18
C210	a_671_93##2	a_1062_93##3	4.06911e-20
C211	VPWR#12	a_214_74##4	4.6117e-19
C212	a_671_93##9	a_1062_93##3	3.92853e-17
C213	a_1708_74#	a_1474_446##14	5.98755e-17
C214	a_671_93##2	a_520_87##3	8.64289e-20
C215	VPWR#14	a_214_74##4	4.0971e-18
C216	VGND#4	a_1311_424##7	3.22774e-18
C217	a_1311_424##2	a_1062_93##5	3.18237e-17
C218	a_1311_424##6	a_1062_93#	3.56359e-19
C219	VGND#8	a_27_74#	8.59951e-19
C220	VPWR#12	a_520_87##2	1.41667e-19
C221	a_27_74##10	a_1311_424##5	4.06892e-17
C222	SET_B#3	a_520_87##3	1.20461e-17
C223	a_214_74##3	SET_B#2	9.58399e-19
C224	VGND#7	a_671_93##2	6.73997e-17
C225	VPWR#11	a_671_93##6	3.47942e-17
C226	a_671_93##2	SET_B#3	1.94669e-17
C227	a_872_119#	a_520_87##3	5.70389e-19
C228	a_671_93#	a_27_74##2	3.31234e-18
C229	a_1474_446##2	SET_B#4	1.20403e-17
C230	VPWR#10	a_520_87##2	1.08745e-20
C231	a_2320_410##3	VGND#12	2.06206e-17
C232	a_1311_424##5	a_1474_446#	5.91034e-19
C233	a_671_93##7	a_27_74##6	3.29162e-19
C234	a_671_93##2	a_671_93##3	1.13494e-17
C235	a_872_119##2	a_1062_93##3	1.19094e-18
C236	VGND#20	a_214_74##9	5.69534e-17
C237	VPWR#15	D#1	2.12474e-18
C238	a_214_74##3	a_671_93##2	6.16429e-18
C239	a_1311_424##6	a_520_87#	2.20513e-19
C240	a_671_93##9	a_520_87##3	3.3715e-17
C241	a_520_87##6	a_214_74##2	4.00184e-19
C242	a_1708_74##2	a_1708_74#	2.56478e-18
C243	a_214_74##6	a_1474_446##2	2.15562e-17
C244	VPWR#11	a_1062_93#	3.11597e-17
C245	VGND#4	a_1062_93##14	6.19727e-17
C246	a_214_74##10	D#5	8.50864e-18
C247	VGND#3	a_1062_93##15	7.08225e-18
C248	a_671_93##7	a_671_93##6	1.26373e-19
C249	VPWR#12	D#1	2.2912e-19
C250	a_214_74##2	a_27_74#	3.63944e-18
C251	a_872_119#	SET_B#3	2.90055e-19
C252	a_422_125#	VPWR#15	5.36893e-18
C253	a_671_93##3	SET_B#3	5.75352e-18
C254	a_27_74##7	a_1311_424##5	6.27765e-17
C255	a_214_74##3	a_520_87##3	1.20577e-17
C256	VGND#9	a_214_74#	8.59216e-19
C257	a_671_93##7	a_1017_379#	1.91682e-19
C258	SET_B#2	VPWR#12	6.68392e-17
C259	a_520_87##3	a_872_119##2	2.28162e-17
C260	a_27_74##8	a_214_74#	1.39888e-17
C261	a_27_74##14	a_214_74##9	2.50248e-18
C262	SET_B#2	VPWR#10	4.28381e-17
C263	a_1062_93##9	VGND#15	3.81875e-18
C264	VPWR#11	a_520_87#	8.16546e-19
C265	a_671_93##9	SET_B#3	1.37692e-17
C266	a_520_87##6	a_27_74##3	9.83171e-19
C267	a_214_74#	D#3	3.18017e-17
C268	a_671_93##7	a_1062_93#	6.59602e-18
C269	a_214_74##3	SET_B#3	2.36332e-17
C270	a_27_74##7	a_214_74##6	8.77788e-18
C271	a_1708_74##2	a_1474_446##14	4.37335e-17
C272	a_422_125#	VPWR#12	1.72676e-18
C273	Q_N#3	a_1474_446##6	1.96666e-17
C274	a_1062_93##9	a_872_119#	3.234e-18
C275	VPWR#15	a_27_74##9	1.25745e-18
C276	a_872_119#	a_671_93##3	9.10787e-20
C277	VGND#4	a_1062_93##9	2.3389e-17
C278	a_27_74##8	D#2	4.23249e-19
C279	VPWR#15	VPWR#12	1.45153e-18
C280	a_520_87##6	a_1062_93##3	9.39325e-20
C281	SET_B#3	a_872_119##2	2.01781e-17
C282	a_1474_446##6	VGND#13	1.11708e-17
C283	a_1062_93##9	a_671_93##9	8.60046e-18
C284	a_27_74##14	VGND#20	5.81104e-17
C285	a_214_74##3	a_671_93##3	4.02267e-17
C286	a_671_93##6	a_27_74##7	1.16201e-17
C287	a_1311_424##5	a_671_93##5	3.83443e-19
C288	a_671_93##7	a_520_87#	6.08519e-17
C289	a_422_125##2	a_214_74##2	1.92753e-17
C290	a_1474_446##5	a_2320_410##4	1.9375e-18
C291	a_671_93##5	a_27_74##6	1.5587e-18
C292	a_671_93##9	a_671_93##3	6.67649e-19
C293	VPWR#12	a_671_93##2	3.00514e-19
C294	VGND#9	D#2	2.32372e-19
C295	a_1311_424##5	a_214_74##5	3.42852e-17
C296	a_27_74##13	VPWR#18	1.50278e-17
C297	VPWR#4	a_2320_410##3	2.63333e-18
C298	a_671_93##5	a_671_93##6	8.70563e-18
C299	a_1062_93##14	a_1474_446##6	3.49855e-18
C300	SET_B#3	VGND#18	1.00623e-17
C301	Q_N#3	RESET_B#2	2.18886e-18
C302	a_520_87##7	VPWR#13	1.5023e-17
C303	a_1062_93##2	a_27_74##6	3.61711e-19
C304	a_671_93##5	a_1062_93#	6.42104e-18
C305	a_520_87##6	a_520_87##3	3.4325e-19
C306	VGND#4	a_2320_410##3	3.74913e-18
C307	VPWR#16	VPWR#12	2.65355e-18
C308	a_872_119##2	a_671_93##3	2.75129e-19
C309	VPWR#4	a_1474_446##6	9.04706e-18
C310	a_1062_93##14	RESET_B#2	6.71238e-18
C311	a_1062_93##14	VGND#5	4.20341e-18
C312	a_671_93##7	SET_B#1	1.11171e-17
C313	VGND#13	RESET_B#2	2.64589e-18
C314	VPWR#15	CLK#1	5.62307e-19
C315	a_671_93##5	a_520_87#	3.38724e-20
C316	a_422_125##2	a_27_74##3	1.46167e-18
C317	a_671_93##9	a_214_74##3	2.542e-18
C318	VGND#4	a_1474_446##6	5.12615e-18
C319	a_27_74##8	a_214_74##3	3.99278e-17
C320	VPWR#4	RESET_B#2	1.06908e-19
C321	a_1062_93##14	a_1062_93##4	2.27332e-17
C322	a_1062_93##15	RESET_B#2	3.71164e-18
C323	CLK#2	a_27_74##5	9.40008e-19
C324	a_214_74##4	a_27_74##2	2.65296e-17
C325	a_1062_93##11	a_27_74##6	8.75863e-20
C326	a_214_74#	VPWR#15	7.60729e-19
C327	SET_B#1	VPWR#13	2.64188e-17
C328	a_422_125#	VPWR#13	6.92534e-18
C329	VGND#9	VGND#7	1.91589e-18
C330	a_1474_446##11	a_1062_93##5	6.1979e-18
C331	VGND#14	a_1708_74##2	6.27531e-17
C332	a_671_93##3	VGND#18	1.3493e-17
C333	a_214_74##10	VPWR#15	9.66479e-18
C334	a_27_74##13	a_27_74##15	2.30887e-19
C335	SET_B	a_1062_93##5	1.37316e-19
C336	a_1311_424##5	a_671_93##4	6.43315e-19
C337	VPWR#4	a_1062_93##4	2.32216e-19
C338	a_1708_74#	RESET_B#2	3.18115e-19
C339	SET_B#2	a_27_74##6	1.53095e-17
C340	a_1062_93##14	a_1311_424##2	6.84561e-17
C341	a_520_87##6	SET_B#3	1.13229e-18
C342	VGND#9	a_27_74##4	3.16467e-20
C343	a_872_119##2	a_214_74##3	1.68977e-17
C344	D#3	a_214_74##3	5.29214e-19
C345	VGND#5	a_1708_74##2	3.74023e-17
C346	a_520_87##5	a_214_74##2	1.13639e-17
C347	SET_B#2	a_671_93##6	1.43994e-17
C348	VGND#4	a_1062_93##4	1.74986e-18
C349	a_1474_446##14	RESET_B#2	4.88381e-19
C350	VPWR#4	a_1311_424##2	2.77363e-18
C351	a_422_125##2	a_27_74##2	1.05968e-19
C352	a_1062_93##14	SET_B#5	4.20568e-18
C353	VPWR#13	a_671_93#	3.20932e-17
C354	SET_B#2	a_1062_93#	2.53975e-17
C355	VGND#6	VGND#14	7.22927e-20
C356	a_520_87##7	SET_B#1	1.22081e-19
C357	VGND#4	a_1311_424##2	5.86875e-18
C358	a_27_74##8	D#3	3.02072e-17
C359	SET_B#2	a_520_87#	2.08879e-17
C360	a_1062_93##14	a_1474_446##2	4.43601e-18
C361	VPWR#12	VPWR#10	2.62561e-19
C362	VGND#9	a_214_74##8	1.53576e-19
C363	a_520_87##6	a_671_93##3	1.03926e-17
C364	a_1062_93##4	a_1708_74#	4.94855e-18
C365	a_27_74##3	D#1	9.64388e-18
C366	SET_B#2	SET_B#1	2.38353e-17
C367	VPWR#4	a_2320_410##7	1.37552e-17
C368	a_422_125#	SET_B#1	7.28182e-19
C369	VGND#3	a_1474_446##4	3.22744e-19
C370	VPWR#4	a_1474_446##2	6.69691e-18
C371	VPWR#18	VPWR#15	1.44383e-18
C372	a_422_125#	a_520_87##7	4.17525e-17
C373	VGND#19	a_27_74##3	1.47507e-17
C374	VPWR#13	a_27_74#	7.10158e-18
C375	a_1062_93##11	a_671_93##5	3.48125e-17
C376	a_27_74##5	a_27_74##8	3.39517e-18
C377	a_671_93#	SET_B#2	9.2004e-18
C378	a_520_87##7	a_671_93#	2.15997e-18
C379	VGND#4	a_1474_446##2	6.68954e-19
C380	D#1	a_27_74##2	2.26917e-17
C381	VPWR#16	SET_B#1	3.09696e-19
C382	a_1062_93##8	a_671_93##5	1.17371e-17
C383	VGND#4	VPWR#5	3.4062e-18
C384	a_422_125##2	a_671_93##3	5.6706e-19
C385	SET_B#2	a_27_74#	3.51718e-19
C386	RESET_B#2	a_1474_446##6	3.39996e-17
C387	VGND#8	a_520_87##6	2.41082e-17
C388	VGND#4	VGND#6	3.18206e-17
C389	a_1062_93##9	a_1474_446##2	2.30166e-18
C390	CLK	a_27_74##3	5.19419e-19
C391	a_1062_93##14	VPWR#7	3.63312e-18
C392	VGND#4	a_27_74##10	4.02776e-17
C393	a_422_125#	a_671_93#	2.70491e-19
C394	a_520_87##6	a_214_74##3	4.28569e-17
C395	VPWR#4	a_27_74##7	1.93288e-18
C396	a_1708_74#	a_1062_93##5	4.03937e-18
C397	VPWR#13	a_214_74##4	8.17237e-19
C398	a_671_93##2	a_27_74#	1.01329e-17
C399	VGND#4	VGND#5	1.06747e-16
C400	a_520_87##7	a_27_74#	2.10486e-17
C401	a_1062_93##9	a_27_74##10	2.26776e-17
C402	a_214_74##9	a_214_74##2	1.62199e-19
C403	VGND#19	a_27_74##2	4.42186e-19
C404	a_1474_446##7	a_1474_446##5	1.54211e-18
C405	VGND#20	a_27_74##13	1.05308e-18
C406	VPWR#4	a_1062_93##12	7.57361e-18
C407	a_1062_93##4	RESET_B#2	3.13362e-17
C408	a_1062_93##7	a_1814_392#	2.25158e-17
C409	a_1311_424##2	a_1474_446##14	2.79066e-17
C410	a_1062_93##11	a_1062_93##2	1.13192e-17
C411	VGND#4	VGND#3	9.46e-17
C412	a_520_87##5	a_27_74##2	1.06913e-18
C413	a_422_125##2	a_214_74##3	6.76827e-18
C414	a_1062_93##9	a_27_74##7	4.4167e-17
C415	a_1311_424#	a_1814_392#	2.23208e-17
C416	VGND#3	a_1474_446##9	6.8334e-18
C417	a_422_125#	a_27_74#	3.11848e-18
C418	a_1062_93##14	a_1474_446##12	2.83453e-19
C419	a_1311_424##2	a_1708_74##2	4.50031e-17
C420	VPWR#4	VPWR#7	1.53977e-17
C421	VPWR#16	a_422_125#	3.28383e-17
C422	a_1062_93##8	a_1062_93##2	6.3551e-18
C423	a_520_87##6	a_27_74##8	2.32696e-17
C424	a_27_74##9	a_27_74##3	4.91094e-17
C425	VPWR#11	a_27_74##2	1.00117e-19
C426	a_214_74##4	a_520_87##7	1.33978e-17
C427	a_1062_93##9	a_671_93##5	4.60576e-17
C428	VGND#14	a_1311_424##2	3.57323e-17
C429	CLK#3	a_27_74##5	2.8237e-17
C430	a_214_74##9	a_27_74##3	3.37392e-17
C431	VGND#4	a_1062_93##12	1.1199e-18
C432	a_1062_93##9	VGND#6	4.25829e-18
C433	D#2	a_214_74##4	9.80018e-18
C434	a_1062_93##14	VPWR#8	7.46132e-18
C435	a_520_87##6	a_606_87#	8.67302e-18
C436	a_1062_93##9	a_1062_93##2	3.65539e-20
C437	a_27_74##14	a_27_74##13	3.21265e-18
C438	a_422_125#	a_214_74##4	4.13237e-17
C439	a_422_125##2	a_27_74##8	2.12035e-17
C440	RESET_B	a_1474_446##5	1.49124e-19
C441	VPWR#4	a_1474_446##12	1.95213e-19
C442	a_214_74##10	a_422_125#	5.30829e-18
C443	a_1474_446##3	a_1418_508#	8.87166e-18
C444	RESET_B	a_1062_93##5	2.07367e-19
C445	a_1062_93##9	VGND#5	4.25782e-19
C446	a_2320_410##7	VPWR#5	7.77442e-17
C447	a_520_87##2	a_1062_93##11	1.89251e-17
C448	a_1311_424##2	SET_B#5	3.63494e-17
C449	a_1062_93##9	a_520_87##2	8.96296e-18
C450	VPWR#15	a_214_74##2	8.82976e-20
C451	a_214_74##6	a_1418_508#	1.15214e-18
C452	a_520_87##6	D#3	2.41572e-18
C453	VPWR#16	a_214_74##4	9.42707e-19
C454	a_1474_446##14	a_1062_93##5	4.45974e-18
C455	a_27_74##11	a_1498_74#	1.02744e-17
C456	a_214_74##8	a_214_74##2	1.67094e-19
C457	a_520_87##2	a_1062_93##8	1.40947e-17
C458	a_1311_424##2	a_1474_446##2	4.66736e-19
C459	VGND#3	RESET_B#3	7.07087e-18
C460	VGND#14	SET_B#5	8.18577e-19
C461	VGND#19	a_27_74##8	1.19098e-18
C462	a_1062_93##9	SET_B#2	9.00863e-18
C463	a_422_125#	D#1	2.74858e-17
C464	a_27_74##4	a_27_74##9	7.31059e-18
C465	a_520_87##5	a_520_87##2	2.43213e-18
C466	a_214_74##10	VPWR#16	4.0956e-17
C467	a_214_74##10	a_214_74##4	9.08732e-20
C468	VPWR#4	VPWR#10	3.98403e-18
C469	a_1474_446##2	SET_B#5	3.54117e-17
C470	a_27_74##10	a_1311_424##2	1.55573e-17
C471	a_422_125##2	D#3	2.84733e-17
C472	CLK#1	a_27_74##4	1.03836e-18
C473	a_27_74##6	a_1203_379#	5.18258e-18
C474	a_1062_93##9	a_671_93##2	6.83256e-21
C475	VPWR#10	SET_B	5.73998e-17
C476	a_2320_410#	Q#3	7.35092e-18
C477	D#1	VPWR#16	1.72014e-17
C478	SET_B	VPWR#8	9.86494e-17
C479	a_671_93##6	a_1203_379#	1.23232e-17
C480	VPWR#4	VPWR#8	1.72587e-16
C481	a_214_74##9	a_27_74##8	1.25534e-19
C482	VPWR#4	a_1311_424##6	9.16304e-18
C483	VPWR#14	a_671_93##2	2.56536e-19
C484	a_422_125#	a_27_74##9	5.10978e-19
C485	VGND#20	a_27_74##3	1.69883e-18
C486	a_27_74##10	a_1474_446##2	3.13287e-18
C487	D#3	VGND#19	1.27843e-17
C488	a_214_74##10	D#1	1.29739e-18
C489	VGND#8	a_671_93##2	7.05086e-19
C490	a_214_74##8	a_27_74##3	3.95569e-17
C491	VPWR#4	VPWR#3	9.45288e-17
C492	VPWR#15	a_27_74##3	4.42562e-18
C493	a_2320_410##3	VPWR#5	2.52843e-17
C494	a_2320_410#	VGND#12	1.33168e-17
C495	VGND#20	a_27_74##8	6.23534e-19
C496	VPWR#3	a_2320_410##4	1.25605e-19
C497	a_214_74##5	a_1318_119#	2.20467e-18
C498	VPWR#16	a_27_74##9	1.04319e-18
C499	Q	a_1474_446##5	1.87655e-18
C500	a_520_87##5	SET_B#1	8.25895e-20
C501	a_1062_93#	a_1017_379#	1.60914e-17
C502	VGND#8	a_214_74#	1.16829e-19
C503	a_520_87##5	SET_B#2	4.12975e-17
C504	VPWR#6	VPWR#5	1.33694e-18
C505	SET_B	a_1474_446##11	3.3209e-17
C506	a_671_93##4	a_1318_119#	4.3174e-18
C507	a_27_74##10	a_1474_446##14	1.08153e-18
C508	VGND#3	a_1062_93##6	3.06479e-19
C509	a_520_87#	a_1017_379#	5.34203e-18
C510	a_1062_93##9	VPWR#9	3.32486e-19
C511	a_214_74##9	D#3	1.5909e-18
C512	a_27_74##7	a_27_74##10	3.26954e-18
C513	VGND#6	VGND#5	1.03225e-19
C514	VPWR#18	a_214_74##10	5.22983e-17
C515	a_27_74##13	CLK#4	4.22021e-17
C516	a_27_74##9	a_214_74##10	3.22299e-17
C517	a_1311_424##5	SET_B	9.64626e-17
C518	a_1062_93##8	a_214_74##5	1.49869e-19
C519	VGND#20	CLK#4	8.93214e-18
C520	a_2320_410##8	a_2320_410#	9.58939e-19
C521	a_27_74##10	VGND#14	3.26065e-17
C522	a_1062_93##14	a_1814_392#	8.61514e-19
C523	a_27_74##9	VPWR#18	3.36207e-17
C524	a_214_74##8	a_27_74##2	6.37034e-19
C525	a_671_93##5	a_27_74##7	4.72976e-17
C526	VGND#5	a_1311_424##3	4.43427e-18
C527	VGND#12	a_1474_446##4	2.43028e-17
C528	a_1062_93##9	a_1311_424##6	3.33576e-18
C529	VPWR#4	a_1814_392#	1.12039e-19
C530	a_671_93#	a_713_379#	9.87534e-18
C531	a_27_74##15	a_214_74##10	3.70312e-18
C532	a_214_74##10	CLK#1	2.96215e-18
C533	a_1474_446##8	a_2320_410##4	3.77874e-17
C534	a_520_87##5	a_671_93#	1.09844e-17
C535	a_214_74##9	a_27_74##5	1.48691e-17
C536	VPWR#15	a_27_74##2	5.07835e-17
C537	a_671_93##9	a_671_93##7	5.0918e-18
C538	a_520_87##5	a_671_93##2	8.97732e-17
C539	a_671_93##7	a_27_74##2	1.72507e-18
C540	a_27_74#	a_713_379#	9.87534e-18
C541	a_27_74##15	a_27_74##9	1.50362e-18
C542	a_27_74##10	a_1311_424##7	7.46013e-17
C543	VPWR#4	a_1418_508#	3.09959e-18
C544	a_1474_446##6	Q_N#1	5.62249e-19
C545	a_27_74##14	a_27_74##3	6.99267e-20
C546	VGND#3	RESET_B	7.90304e-19
C547	a_1062_93##2	a_671_93##5	4.11278e-17
C548	CLK#1	VPWR#18	4.24027e-17
C549	a_27_74##14	CLK#4	2.18503e-17
C550	a_1062_93##8	a_671_93##4	5.0685e-20
C551	VGND#6	SET_B#6	1.55161e-20
C552	a_2320_410##8	a_1474_446##4	2.02838e-17
C553	a_1474_446##7	a_2320_410##4	2.30657e-19
C554	a_520_87##2	a_671_93##5	4.05289e-18
C555	VGND#20	a_27_74##5	4.9384e-17
C556	a_1474_446##6	VPWR#6	4.09458e-17
C557	a_1062_93##9	VPWR#11	4.18572e-18
C558	a_1062_93##9	a_1418_508#	3.05049e-18
C559	Q_N	a_1474_446##5	1.21139e-17
C560	a_27_74##15	VPWR#18	8.29172e-17
C561	VGND#15	a_27_74##10	1.57647e-17
C562	a_27_74##15	CLK#1	4.91958e-17
C563	a_1311_424##6	a_214_74##5	1.10685e-18
C564	a_520_87##2	a_1062_93##2	4.1056e-17
C565	a_671_93##5	SET_B#2	5.76491e-17
C566	VGND#12	a_1474_446##9	4.31801e-19
C567	a_1062_93##9	VPWR#8	1.33758e-18
C568	a_214_74##9	CLK#3	1.09945e-18
C569	a_1474_446##6	a_1062_93##12	1.51481e-17
C570	VPWR#4	a_2320_410##6	7.77504e-19
C571	a_1062_93##9	a_1203_379#	5.51027e-18
C572	a_1062_93##14	a_1062_93##5	4.78572e-18
C573	a_1474_446##7	a_1474_446##8	1.05001e-17
C574	SET_B#2	a_1062_93##2	4.13347e-19
C575	VGND#5	SET_B#6	3.74459e-18
C576	a_520_87##5	a_27_74#	1.14452e-17
C577	a_27_74##14	a_27_74##5	1.46783e-18
C578	a_27_74##7	a_1311_424##7	4.42431e-17
C579	Q_N#3	a_1474_446##4	4.94092e-18
C580	a_1062_93##9	a_671_93##7	1.07185e-18
C581	VGND#6	a_872_119#	5.56476e-17
C582	SET_B#2	a_520_87##2	9.14002e-17
C583	CLK	a_214_74##8	3.719e-18
C584	CLK#3	VGND#20	2.06976e-17
C585	VPWR#3	a_1474_446##7	6.2606e-18
C586	a_2320_410##8	a_1474_446##9	7.92373e-19
C587	a_1062_93##8	a_1062_93##3	2.12382e-18
C588	a_1474_446##11	a_1062_93##14	3.02366e-17
C589	a_520_87##2	a_671_93##2	6.11933e-17
C590	CLK	a_27_74##13	1.33907e-17
C591	VGND#15	a_27_74##7	2.60037e-17
C592	a_1062_93##12	RESET_B#2	2.70267e-18
C593	VGND#3	SET_B#6	2.97961e-20
C594	VPWR#12	a_27_74##2	4.87312e-17
C595	VPWR#3	a_1474_446##5	1.27365e-19
C596	VGND#7	a_671_93##9	1.69674e-18
C597	VPWR#13	a_27_74##2	7.45312e-19
C598	VGND#13	a_1474_446##4	4.70965e-19
C599	VGND#6	a_1474_446#	3.31259e-20
C600	VGND#12	RESET_B#3	1.39537e-19
C601	a_671_93##2	SET_B#2	2.64043e-17
C602	a_671_93##3	a_606_87#	1.08186e-18
C603	a_27_74##14	CLK#3	3.42547e-17
C604	a_214_74##3	a_606_87#	6.94804e-18
C605	a_2320_410##6	a_2320_410##4	1.17023e-18
C606	RESET_B#1	a_1474_446##7	2.51475e-17
C607	D#6	a_27_74##3	2.36526e-18
C608	VGND#4	a_2320_410##6	1.13079e-19
C609	Q_N#3	a_1474_446##9	4.63339e-17
C610	a_520_87##5	a_214_74##4	8.72087e-19
C611	VPWR#4	a_1474_446##5	1.02698e-18
C612	a_2320_410##6	Q	9.86124e-18
C613	VGND#5	a_1474_446#	5.89011e-18
C614	VPWR	a_27_74##3	6.12734e-18
C615	VPWR	a_27_74##2	3.49249e-17
C616	a_1062_93##7	a_1474_446##7	9.57247e-19
C617	a_214_74#	D#5	2.2299e-17
C618	VGND#15	a_671_93##5	7.27263e-18
C619	a_1062_93##8	a_520_87##3	9.16691e-19
C620	VPWR#3	RESET_B#1	2.06689e-18
C621	a_214_74##8	D#2	3.88386e-19
C622	a_1474_446##11	VPWR#4	4.5979e-17
C623	a_1474_446##9	VGND#13	1.71189e-17
C624	VPWR#7	a_1062_93##4	8.29826e-19
C625	a_214_74#	D#2	3.75644e-17
C626	a_520_87##2	a_27_74##2	1.61535e-18
C627	a_671_93##5	a_872_119#	1.60661e-17
C628	a_2320_410##7	a_1474_446##5	1.50709e-19
C629	VGND#3	a_1474_446##6	5.37767e-19
C630	a_872_119#	VGND#15	2.91415e-17
C631	VPWR#7	VPWR#6	1.37503e-17
C632	a_1062_93##7	RESET_B#1	4.1361e-18
C633	a_520_87##7	VPWR#14	3.5817e-18
C634	a_1062_93##14	a_1311_424##5	1.43231e-17
C635	D#6	a_27_74##2	1.10215e-18
C636	VGND#7	a_872_119##2	7.18799e-17
C637	Q_N#3	RESET_B#3	4.00912e-20
C638	RESET_B	Q_N#3	9.76706e-18
C639	a_671_93##9	a_671_93##5	4.36453e-19
C640	VGND#6	a_27_74##11	1.34558e-19
C641	D#6	D#2	1.07223e-17
C642	RESET_B	VGND#13	1.14495e-17
C643	a_671_93##7	a_214_74##5	7.71019e-19
C644	RESET_B	a_1062_93##15	2.7128e-17
C645	a_2320_410##6	a_1474_446##8	1.90747e-18
C646	a_1474_446##11	a_1814_392#	3.86321e-18
C647	CLK	a_214_74##9	1.08546e-18
C648	a_1474_446##4	a_2320_410#	2.7001e-17
C649	Q_N	VPWR#3	1.89993e-17
C650	VGND#20	CLK	2.03702e-17
C651	a_422_125#	VPWR#14	3.78425e-18
C652	VPWR#10	a_27_74##2	4.21277e-18
C653	SET_B	a_1311_424##6	1.00243e-16
C654	a_1062_93##15	a_1474_446##9	1.07771e-19
C655	VPWR#8	a_1062_93##7	3.28008e-19
C656	VPWR#4	a_1474_446##4	4.83607e-19
C657	VPWR#11	SET_B	4.13706e-17
C658	Q_N	a_2320_410##6	3.5999e-17
C659	D#5	D#2	1.30784e-17
C660	CLK#2	a_27_74##4	4.11201e-17
C661	RESET_B#3	VGND#13	1.72841e-17
C662	a_214_74##8	a_27_74##4	5.1037e-17
C663	a_872_119#	a_1062_93##2	3.33004e-19
C664	VGND#5	a_27_74##11	4.45322e-18
C665	D#6	a_214_74##4	7.13224e-19
C666	VGND#4	a_2320_410#	4.69476e-18
C667	SET_B#2	a_1203_379#	4.19824e-18
C668	VGND#7	a_214_74##5	2.42423e-18
C669	a_671_93##9	VGND#15	1.72463e-18
C670	VPWR#3	a_1062_93##7	2.87817e-19
C671	Q	Q#3	3.68207e-18
C672	a_1062_93##14	a_1062_93##6	1.11125e-18
C673	VGND#12	Q	3.35627e-17
C674	a_1311_424#	a_1062_93##7	5.97576e-17
C675	a_520_87##5	VPWR#12	7.25543e-19
C676	a_671_93##9	a_1062_93##2	1.9897e-18
C677	a_2320_410##8	Q	3.8087e-18
C678	VGND#4	a_1474_446##5	1.26955e-18
C679	a_1708_74#	a_1474_446##9	3.08854e-19
C680	Q_N#3	a_2320_410##6	3.0787e-17
C681	Q_N#3	a_1062_93##6	7.52059e-20
C682	SET_B#2	a_1017_379#	1.09576e-17
C683	a_2320_410##4	Q#1	1.16721e-17
C684	VGND	a_214_74##2	2.35784e-19
C685	VGND#4	a_1474_446##4	1.58111e-18
C686	VPWR#4	a_1311_424##5	4.2111e-18
C687	a_2320_410##6	a_2320_410#	1.57541e-18
C688	VGND#3	RESET_B#2	1.83546e-19
C689	D#5	a_214_74##2	7.18788e-19
C690	a_1062_93##15	RESET_B#3	4.17054e-17
C691	VGND#4	a_1062_93##5	4.08283e-20
C692	VGND#7	VGND#18	1.06716e-17
C693	VPWR	VPWR#15	1.245e-16
C694	SET_B#2	a_27_74##2	1.50392e-17
C695	VGND#6	a_214_74##5	6.06689e-17
C696	VPWR	VPWR#12	8.871e-17
C697	VGND#4	a_1474_446##9	1.36685e-18
C698	VPWR	VPWR#10	1.29046e-16
C699	RESET_B	a_1062_93##12	1.90919e-17
C700	a_27_74##10	a_1498_74#	2.09899e-18
C701	D#5	a_214_74##4	5.37037e-19
C702	a_2320_410##4	VPWR#5	2.70576e-17
C703	a_1474_446##9	a_1474_446##4	7.41348e-18
C704	VPWR#8	a_1311_424#	4.17018e-18
C705	VGND#13	a_1062_93##6	5.25759e-19
C706	a_671_93##9	a_872_119#	4.85058e-17
C707	VPWR#8	VPWR#7	9.30833e-19
C708	a_214_74##8	CLK#2	5.44975e-19
C709	a_27_74##13	a_27_74##4	3.13839e-18
C710	VGND#4	RESET_B#3	1.19533e-18
C711	SET_B	a_214_74##5	3.57505e-18
C712	a_671_93##9	a_520_87##2	6.68199e-17
C713	SET_B#4	a_1311_424#	3.07743e-17
C714	SET_B	a_671_93##4	6.85095e-20
C715	a_1708_74#	RESET_B#3	2.02599e-18
C716	Q_N#3	Q_N	3.85416e-18
C717	VGND#5	a_214_74##5	2.48241e-19
C718	a_1062_93##14	a_1474_446#	7.15197e-19
C719	a_214_74##8	a_27_74##9	1.06358e-19
C720	Q	Q#1	5.74789e-18
C721	a_520_87##7	a_27_74##2	4.26038e-18
C722	a_2320_410##7	a_2320_410##4	1.35322e-18
C723	a_520_87##2	a_872_119##2	1.37592e-18
C724	VPWR#5	Q	8.71621e-17
C725	a_2320_410##7	Q	2.99547e-19
C726	VGND#4	a_1062_93##6	3.54788e-18
C727	SET_B#5	VPWR#9	5.28666e-19
C728	a_27_74##7	a_1318_119#	1.57049e-17
C729	a_1062_93##15	a_1062_93##6	1.27216e-18
C730	VGND#4	a_1311_424##5	1.83401e-18
C731	a_2320_410##6	a_2320_410##7	1.34516e-18
C732	D#5	a_27_74##3	2.84562e-18
C733	a_422_125#	a_214_74##2	1.04148e-17
C734	a_520_87##2	VGND#18	8.5216e-19
C735	a_1474_446##8	VPWR#5	3.30066e-17
C736	VPWR	a_1062_93##11	2.97009e-18
C737	VGND	VGND#9	9.73904e-17
C738	VGND	VGND#7	1.26963e-16
C739	a_214_74##8	VPWR#15	2.3381e-19
C740	VPWR	a_520_87##5	6.4613e-18
C741	VGND	VGND#6	1.12084e-16
C742	a_2320_410##6	a_1474_446##4	6.97354e-18
C743	a_520_87##6	a_520_87##7	1.08199e-20
C744	VPWR	a_214_74##8	2.76153e-18
C745	VPWR#7	VPWR#3	1.19096e-19
C746	VPWR	D#6	3.31348e-18
C747	VGND#13	a_1311_424##3	1.04377e-20
C748	a_214_74##2	a_671_93##2	2.1893e-17
C749	a_872_119##2	a_872_119#	2.21131e-18
C750	RESET_B	a_1474_446##9	2.31453e-18
C751	VPWR	a_27_74##13	2.47549e-18
C752	a_1474_446##5	VNB	4.74688e-17
C753	a_1062_93##5	VNB	1.86114e-17
C754	a_671_93##9	SET_B#2	4.58599e-19
C755	a_214_74##2	VNB	4.58216e-17
C756	a_27_74##3	VNB	1.76669e-16
C757	RESET_B	a_1062_93##6	2.679e-19
C758	VGND#6	a_671_93##4	2.10927e-18
C759	a_27_74##2	VNB	2.1345e-16
C760	VPWR	CLK#4	1.37734e-18
C761	D#6	a_27_74##9	6.06245e-19
C762	a_27_74##13	CLK#2	1.32282e-17
C763	RESET_B#3	a_1474_446##9	1.50495e-17
C764	a_1474_446##3	SET_B#4	3.97906e-18
C765	a_2320_410##7	a_1474_446##8	7.9123e-17
C766	VPWR#8	SET_B#4	2.80478e-17
C767	a_1708_74#	a_1062_93##6	2.62121e-17
C768	Q_N	VPWR#5	2.5544e-18
C769	SET_B	a_1062_93##7	7.39342e-19
C770	a_1474_446##2	VPWR#9	8.9117e-18
C771	Q_N	a_2320_410##7	9.34903e-17
C772	CLK	a_27_74##5	1.98964e-18
C773	a_872_119##2	SET_B#2	4.1375e-19
C774	SET_B	a_1311_424#	2.38407e-18
C775	Q_N	Q_N#1	1.33826e-17
C776	VPWR#6	Q_N	3.26156e-17
C777	a_422_125#	a_27_74##3	1.08385e-18
C778	SET_B	SET_B#4	3.43476e-18
C779	a_671_93##2	a_27_74##2	3.70586e-19
C780	VPWR#6	a_2320_410##4	3.89358e-19
C781	SET_B	a_1474_446##3	2.13467e-17
C782	a_1474_446##6	VPWR#3	1.8204e-18
C783	VPWR#5	a_1474_446##7	9.77345e-19
C784	SET_B	a_214_74##6	3.08876e-17
C785	Q	a_2320_410#	2.72814e-17
C786	VGND#9	a_520_87##6	1.79475e-18
C787	a_1708_74##2	RESET_B#3	6.8622e-20
C788	Q	a_1474_446##4	3.96132e-18
C789	SET_B	a_27_74##6	3.38387e-17
C790	SET_B	a_671_93##6	7.35312e-18
C791	a_520_87##5	a_214_74##3	4.23607e-19
C792	SET_B	a_1062_93#	1.52077e-19
C793	a_1062_93##9	a_1311_424##5	3.50589e-17
C794	SET_B	a_520_87#	5.81737e-20
C795	VGND	a_1062_93##8	2.50389e-18
C796	a_671_93##9	a_872_119##2	6.54764e-17
C797	VGND	a_520_87##5	2.94631e-18
C798	a_1311_424##6	a_1474_446##2	2.47743e-18
C799	a_1474_446##14	a_1062_93##6	3.21581e-17
C800	VGND#13	SET_B#6	1.37968e-20
C801	VGND	a_214_74##8	2.74619e-18
C802	VGND#5	a_1311_424##2	1.58781e-18
C803	D#5	a_27_74##9	7.29368e-19
C804	a_671_93##2	a_671_93##9	1.71585e-18
C805	a_2320_410##6	a_1474_446##9	2.92816e-19
C806	a_2320_410##7	a_1474_446##7	1.1288e-18
C807	VGND	D#5	3.08863e-18
C808	VPWR#10	a_1474_446##3	6.25666e-20
C809	CLK#4	CLK#2	1.11399e-17
C810	a_1474_446##4	a_2320_410##3	7.37854e-18
C811	VGND	a_27_74##13	2.98346e-18
C812	a_422_125#	a_27_74##2	6.15795e-18
C813	VGND#9	VNB	3.39484e-17
C814	VGND#7	VNB	4.29163e-17
C815	a_214_74##6	a_1474_446##3	2.32461e-17
C816	VGND#6	VNB	5.62177e-17
C817	VGND#5	VNB	5.81611e-17
C818	VGND	CLK#4	1.98819e-18
C819	VGND#3	VNB	3.97707e-17
C820	a_1708_74#	a_1311_424##3	3.57207e-19
C821	VGND#14	RESET_B#3	7.61932e-20
C822	a_671_93##9	a_27_74##6	3.34763e-19
C823	a_1474_446##11	a_1474_446##7	3.95656e-19
C824	VPWR#6	a_1474_446##8	6.15161e-19
C825	a_2320_410##6	a_2320_410##3	6.65183e-19
C826	VPWR#15	VNB	3.47077e-17
C827	VPWR#12	VNB	2.91853e-17
C828	a_1062_93##11	a_671_93##7	1.11e-17
C829	VPWR#10	VNB	4.78174e-17
C830	VPWR#8	VNB	7.20868e-17
C831	VPWR#3	VNB	3.94655e-17
C832	a_422_125##2	a_422_125#	1.51487e-18
C833	a_520_87##6	VGND#7	1.22974e-17
C834	VPWR	a_1311_424##6	3.64439e-18
C835	a_1062_93##14	SET_B	1.663e-17
C836	VGND#6	a_1062_93##3	1.97168e-18
C837	a_671_93##2	VGND#18	2.94066e-18
C838	a_1062_93##6	RESET_B#3	2.79584e-18
C839	VPWR#4	SET_B	3.32386e-17
C840	a_2320_410##6	VNB	7.34542e-19
C841	VPWR#8	a_1474_446##3	1.54713e-17
C842	a_1708_74##2	a_1062_93##6	1.26606e-18
C843	a_1474_446##7	Q_N#1	1.04027e-18
C844	Q	a_2320_410##4	3.72373e-17
C845	VPWR	a_671_93##7	9.74172e-18
C846	VGND	a_872_119#	2.34789e-17
C847	VGND#5	a_1311_424##5	1.02369e-18
C848	Q	a_1474_446##8	2.65919e-18
C849	VGND	a_671_93##9	1.57072e-17
C850	a_1474_446##11	VNB	7.23162e-18
C851	a_27_74##10	a_1311_424##6	8.10415e-20
C852	VGND	a_872_119##2	2.10946e-17
C853	a_1062_93##9	SET_B	1.42062e-17
C854	a_214_74#	a_214_74##2	1.21311e-17
C855	VPWR	a_520_87##7	9.42523e-18
C856	a_1311_424##5	VNB	7.78863e-18
C857	VPWR	a_422_125#	1.57269e-17
C858	VGND	a_520_87##6	2.76209e-17
C859	VGND	a_422_125##2	1.78009e-17
C860	VPWR	a_214_74##10	1.71246e-17
C861	VPWR#3	RESET_B#2	3.06866e-20
C862	VGND	a_214_74##9	2.0522e-17
C863	VPWR	VPWR#18	2.28015e-17
C864	a_671_93##7	a_214_74##3	5.74702e-20
C865	VGND	VGND#20	1.98836e-17
C866	a_1311_424##3	a_1474_446##14	1.42583e-17
C867	VPWR	a_27_74##15	2.25988e-17
C868	VGND	a_27_74##14	2.01043e-17
C869	VGND#9	a_422_125##2	6.41358e-18
C870	a_1062_93##8	VNB	1.04027e-18
C871	a_1062_93##9	a_214_74##5	3.09022e-18
C872	a_520_87##5	VNB	1.19995e-17
C873	a_520_87##6	a_671_93##2	3.20148e-17
C874	a_214_74##8	VNB	6.40166e-18
C875	D#6	VNB	6.75312e-19
C876	VPWR#6	a_1474_446##7	4.9042e-17
C877	a_27_74##6	a_214_74##6	3.43309e-17
C878	Q_N	a_2320_410##4	4.95089e-19
C879	VPWR#16	a_27_74##3	1.41745e-17
C880	a_27_74##13	VNB	2.90836e-17
C881	Q_N	a_1474_446##8	7.12191e-18
C882	a_1311_424##2	SET_B	3.92144e-17
C883	a_214_74#	a_27_74##2	9.01145e-19
C884	Q_N	a_1474_446##7	2.2291e-17
C885	VGND#14	a_1062_93##6	2.32015e-19
C886	CLK#4	VNB	8.65918e-19
C887	a_1062_93##14	RESET_B	6.58289e-17
C888	SET_B	SET_B#5	1.86241e-17
C889	Q_N	RESET_B#1	7.3674e-19
C890	a_422_125##2	a_671_93##2	7.33297e-19
C891	VGND#12	VNB	1.04136e-18
C892	VPWR	a_671_93##4	5.72338e-20
C893	VGND#7	a_520_87##3	2.33797e-18
C894	a_2320_410##8	VNB	6.90739e-18
C895	Q_N	a_1062_93##7	3.32004e-19
C896	VPWR#4	RESET_B	3.95079e-18
C897	SET_B	a_1474_446##2	1.32593e-16
C898	Q_N#3	VNB	1.24565e-17
C899	VGND#13	VNB	7.4057e-18
C900	Q_N	a_1311_424#	2.06444e-19
C901	a_1062_93##9	a_671_93##4	6.11063e-18
C902	VGND	a_671_93##7	4.56959e-18
C903	VGND#4	RESET_B	5.32035e-18
C904	a_1062_93##15	VNB	1.5616e-17
C905	a_1708_74#	VNB	3.58731e-18
C906	SET_B	a_27_74##10	1.90605e-18
C907	VPWR#10	a_214_74##6	1.97858e-19
C908	a_1708_74##2	VNB	3.87788e-18
C909	VPWR#13	a_214_74##3	6.55807e-19
C910	VGND#14	VNB	4.42492e-19
C911	a_27_74##7	a_1311_424##6	4.57888e-17
C912	a_27_74##7	SET_B	2.91798e-18
C913	a_27_74##13	CLK#1	2.60786e-17
C914	a_1474_446##11	RESET_B#1	1.13673e-18
C915	SET_B	a_671_93##5	3.38239e-19
C916	VGND#15	VNB	4.91322e-18
C917	a_1708_74##2	a_1311_424##3	5.28113e-17
C918	a_872_119#	VNB	1.1077e-17
C919	a_2320_410##6	a_1474_446##6	5.36154e-20
C920	a_872_119##2	VNB	1.15535e-17
C921	a_1062_93##12	a_1474_446##7	1.68127e-18
C922	a_2320_410##8	VGND#12	3.91523e-17
C923	RESET_B	a_1474_446##6	3.77852e-17
C924	a_520_87##6	VNB	4.57951e-18
C925	a_422_125##2	VNB	2.28073e-18
C926	VPWR#4	Q	2.11672e-17
C927	RESET_B	RESET_B#2	3.21547e-17
C928	VGND#19	VNB	1.18022e-17
C929	a_1062_93##9	a_1062_93##3	6.69753e-20
C930	a_214_74##9	VNB	4.4756e-18
C931	VGND#4	Q	2.11052e-17
C932	SET_B#2	SET_B	7.8027e-19
C933	VGND#20	VNB	1.52848e-18
C934	RESET_B	a_1062_93##4	4.05967e-18
C935	a_27_74##14	VNB	4.32392e-17
C936	RESET_B#2	a_1474_446##9	1.17341e-17
C937	VPWR#5	VNB	5.75705e-18
C938	a_1311_424##3	a_1062_93##6	3.45564e-17
C939	a_2320_410##7	VNB	3.13289e-18
C940	VPWR#16	a_27_74##2	1.54738e-18
C941	VGND	a_214_74##5	8.2672e-18
C942	a_1474_446##14	SET_B#6	2.94275e-19
C943	VPWR#6	VNB	1.02413e-17
C944	VPWR#8	a_214_74##6	4.90307e-18
C945	a_1062_93##12	VNB	7.02203e-18
C946	VGND	a_671_93##4	1.80151e-18
C947	a_520_87##6	a_214_74#	5.6119e-19
C948	VPWR#7	VNB	9.22913e-18
C949	Q	a_2320_410##3	6.13502e-17
C950	RESET_B#1	VPWR#6	1.01611e-17
C951	a_214_74##8	a_27_74##8	5.52357e-19
C952	VPWR#8	VPWR#9	1.19601e-17
C953	VGND	SET_B#3	4.34961e-18
C954	VPWR	a_27_74##6	1.13988e-17
C955	a_671_93##9	a_1062_93##8	2.74265e-17
C956	VGND	a_671_93##3	4.09395e-18
C957	a_1311_424##6	VNB	3.06057e-19
C958	VPWR	a_671_93##6	2.24152e-18
C959	a_1062_93##14	Q_N	2.72155e-19
C960	VGND	a_214_74##3	1.91706e-17
C961	VPWR	a_1062_93#	1.53235e-18
C962	VPWR#11	VNB	3.01932e-18
C963	VGND	a_27_74##8	1.14441e-17
C964	VPWR#4	Q_N	2.18376e-17
C965	a_671_93##6	a_27_74##6	4.0695e-17
C966	VGND	D#3	5.90336e-18
C967	a_671_93##7	VNB	4.72842e-18
C968	VGND#4	Q_N	1.50508e-18
C969	VGND	a_27_74##5	2.05881e-18
C970	VPWR#13	VNB	2.78673e-18
C971	VGND	CLK#3	2.08021e-18
C972	VPWR#7	a_1474_446##7	2.44955e-18
C973	a_422_125##2	a_214_74#	8.03343e-17
C974	VPWR	a_671_93#	2.60974e-18
C975	VGND#14	a_1311_424##3	1.62802e-18
C976	a_422_125#	VNB	1.30891e-18
C977	a_214_74##10	a_214_74##2	4.24816e-20
C978	VPWR#16	VNB	1.13705e-17
C979	a_671_93##5	a_1311_424##6	3.16914e-18
C980	a_214_74##10	VNB	1.74201e-17
C981	VPWR	a_214_74##4	5.00653e-18
C982	VPWR#14	a_27_74##2	2.25081e-17
C983	VPWR#18	VNB	4.28495e-18
C984	CLK	a_27_74##4	3.58767e-17
C985	VPWR	D#1	3.99149e-18
C986	a_27_74##15	VNB	5.43472e-17
C987	a_2320_410#	VNB	3.55778e-17
C988	VPWR	a_27_74##9	5.51552e-18
C989	SET_B	a_1418_508#	2.05903e-19
C990	a_1474_446##4	VNB	4.26655e-17
C991	Q_N	a_1474_446##6	1.03722e-16
C992	CLK	CLK#2	5.34429e-18
C993	a_1474_446##9	VNB	3.41052e-17
C994	VPWR	CLK#1	2.692e-18
C995	RESET_B#3	VNB	2.9189e-17
C996	SET_B	a_1203_379#	1.12608e-17
C997	a_1062_93##6	VNB	3.02349e-17
C998	a_1311_424##3	VNB	2.72131e-17
C999	SET_B#6	VNB	2.97493e-17
C1000	a_1062_93##6	RESET_B#2	2.44542e-18
C1001	a_1474_446#	VNB	4.64136e-17
C1002	a_1062_93##12	RESET_B#1	3.12106e-17
C1003	D#2	a_214_74##2	3.25432e-18
C1004	a_27_74##11	VNB	2.32786e-17
C1005	a_214_74##5	VNB	1.91668e-16
C1006	a_671_93##4	VNB	3.46967e-17
C1007	SET_B#6	a_1708_74##2	1.68681e-17
C1008	a_1062_93##3	VNB	1.78776e-17
C1009	a_1062_93#	a_27_74##6	2.16653e-17
C1010	a_520_87##3	VNB	1.86083e-17
C1011	VPWR	VPWR#14	5.20476e-17
C1012	SET_B#3	VNB	2.38818e-17
C1013	a_671_93##3	VNB	2.06616e-17
C1014	a_214_74##3	VNB	1.47235e-16
C1015	a_27_74##8	VNB	8.5092e-17
C1016	D#3	VNB	2.84709e-17
C1017	a_27_74##5	VNB	2.95736e-17
C1018	VGND#7	SET_B#3	8.62919e-18
C1019	CLK#3	VNB	3.22516e-17
C1020	a_27_74##3	D#2	5.19927e-17
C1021	VPWR#10	a_27_74##6	4.03101e-17
C1022	a_1474_446##11	a_1062_93##7	4.05368e-17
C1023	VGND#5	a_1474_446##2	1.99844e-19
C1024	a_2320_410##4	VNB	4.74517e-17
C1025	VPWR#6	a_1062_93##7	1.77836e-18
C1026	a_1474_446##8	VNB	6.01744e-17
C1027	a_1474_446##7	VNB	3.87848e-17
C1028	a_671_93##5	VPWR#11	5.39593e-19
C1029	RESET_B#1	VNB	3.15224e-17
C1030	a_1062_93##7	VNB	4.01267e-17
C1031	a_1311_424#	VNB	3.51374e-17
C1032	a_1474_446##14	a_1474_446#	1.43826e-19
C1033	SET_B#4	VNB	3.02601e-17
C1034	VGND	a_1062_93##9	3.11123e-17
C1035	a_1474_446##3	VNB	2.73353e-17
C1036	a_214_74##10	a_27_74##3	2.29017e-17
C1037	VPWR	a_27_74##7	3.4001e-18
C1038	a_214_74##6	VNB	4.80139e-17
C1039	a_27_74##6	VNB	1.0677e-16
C1040	VGND	VGND#8	5.45961e-17
C1041	VPWR	a_671_93##5	6.17228e-18
C1042	D#2	a_27_74##2	3.02035e-18
C1043	a_671_93##6	VNB	2.88325e-17
C1044	VPWR#7	RESET_B#1	1.82675e-18
C1045	a_1062_93#	VNB	2.79867e-17
C1046	a_520_87##5	VPWR#13	1.39718e-17
C1047	a_520_87#	VNB	2.95393e-17
C1048	a_1062_93#	a_671_93##6	2.99079e-17
C1049	VPWR	a_520_87##2	3.27208e-18
C1050	SET_B#1	VNB	2.79818e-17
C1051	a_520_87#	a_27_74##6	7.51538e-18
C1052	a_671_93#	VNB	2.51572e-17
C1053	VPWR	SET_B#2	4.15003e-17
C1054	a_422_125##2	D#2	2.62291e-19
C1055	a_27_74#	VNB	3.52613e-17
C1056	a_214_74##4	VNB	3.0376e-17
C1057	D#1	VNB	2.67926e-17
C1058	VPWR	a_214_74#	6.35788e-18
C1059	a_27_74##9	VNB	3.70805e-17
C1060	SET_B#6	a_1311_424##3	2.75096e-17
C1061	a_214_74##2	a_671_93##3	5.11796e-19
C1062	VPWR#8	a_1311_424##2	8.03404e-20
C1063	CLK#1	VNB	4.34677e-17
C1064	VPWR	D#2	1.75911e-18
C1065	VGND#14	SET_B#6	4.09642e-17
C1066	VGND	a_27_74##10	6.61156e-18
C1067	a_1062_93##14	VNB	1.05179e-17
C1068	VPWR	a_27_74##4	2.76781e-18
C1069	VPWR#8	a_27_74##6	8.3362e-19
C1070	VGND	a_27_74##7	1.36977e-18
C1071	VGND#9	a_27_74##3	3.6593e-18
C1072	VPWR#4	VNB	3.3339e-16
C1073	VGND	a_671_93##5	8.09814e-18
C1074	VGND#4	VNB	3.1007e-16
C1075	a_1062_93##9	VNB	5.42959e-18
C1076	VGND	a_1062_93##2	4.29252e-20
C1077	a_1474_446##11	a_1474_446##6	1.4611e-18
C1078	a_1062_93##12	a_1062_93##7	6.67069e-18
C1079	VPWR#14	VNB	2.28656e-17
C1080	VGND#8	a_214_74##2	3.8802e-20
C1081	VGND	a_520_87##2	1.10418e-17
C1082	VGND#8	VNB	2.61319e-17
C1083	VGND	SET_B#2	2.07152e-18
C1084	a_2320_410##3	VNB	6.53655e-17
C1085	a_1474_446##6	VNB	3.84659e-17
C1086	VGND	a_671_93##2	1.04428e-17
C1087	RESET_B#2	VNB	6.43097e-17
C1088	VGND	a_214_74#	7.76353e-18
C1089	a_1062_93##4	VNB	4.12582e-17
C1090	a_1311_424##2	VNB	3.63278e-17
C1091	SET_B#5	VNB	3.04115e-17
C1092	VGND	a_27_74##4	6.56175e-18
C1093	a_1474_446##2	VNB	7.70708e-17
C1094	VGND	CLK#2	1.15115e-18
C1095	a_27_74##10	VNB	2.80964e-17
C1096	a_27_74##7	VNB	4.07904e-17
C1097	a_1062_93##9	a_1062_93##11	1.35796e-17
C1098	a_671_93##5	VNB	4.45898e-17
C1099	a_1062_93##2	VNB	2.71731e-17
C1100	a_520_87##2	VNB	3.94457e-17
C1101	VPWR#11	a_1062_93##2	2.0135e-19
C1102	SET_B#2	VNB	5.99921e-17
C1103	a_671_93##2	VNB	4.2717e-17
C1104	a_214_74##10	a_27_74##2	1.50915e-19
C1105	a_214_74#	VNB	3.69425e-17
C1106	D#2	VNB	4.96713e-17
C1107	a_27_74##4	VNB	3.90284e-17
C1108	Q_N#3	a_2320_410##8	5.01943e-17
C1109	CLK#2	VNB	4.11008e-17
C1110	VGND#13	VGND#12	8.08133e-19
C1111	a_1311_424##2	a_1062_93##6	9.21811e-19
C1112	VGND#9	a_214_74##9	1.67378e-17
C1113	VPWR#7	a_1062_93##7	5.09499e-17
C1114	VGND#6	a_27_74##10	5.26139e-17
C1115	a_1062_93##9	a_1062_93##8	1.47259e-17
C1116	a_520_87#	a_1062_93#	4.7419e-17
C1117	VPWR#7	a_1062_93##5	1.10519e-19
C1118	a_1474_446##11	a_1311_424#	5.28858e-17
C1119	VGND#8	a_671_93##3	1.89753e-18
C1120	VPWR	SET_B	2.24232e-17
C1121	VPWR	CLK	1.34881e-18
C1122	VPWR#10	a_671_93##6	4.28369e-19
C1123	a_1311_424##2	a_1311_424##3	2.52717e-18
C1124	VGND#7	a_671_93##3	5.74377e-18
C1125	VGND	CLK	1.56537e-18
C1126	VGND#5	a_27_74##10	3.11579e-17
C1127	VGND#14	a_1474_446#	1.715e-17
C1128	SET_B	VNB	2.07238e-17
C1129	a_214_74##8	a_27_74##5	1.61473e-19
C1130	RESET_B	VNB	2.97392e-18
C1131	Q	VNB	1.12803e-16
C1132	Q_N	VNB	2.21788e-17
C1133	a_214_74##2	a_27_74##2	7.54229e-20
C1134	a_1062_93##9	a_520_87##5	9.10967e-19
C1135	VPWR	VNB	2.91435e-16
C1136	D#5	a_27_74##8	1.70259e-19
C1137	VGND	VNB	2.79511e-16
C1138	VPWR#4	a_2320_410##4	5.52481e-18
C1139	a_1474_446##5	a_2320_410##3	2.13916e-17
C1140	VGND#8	a_214_74##3	1.67023e-17
C1141	VGND#10	a_27_74##14	2.2313e-17
C1142	VGND#10	a_27_74##5	4.92531e-18
C1143	VPWR#3	VPWR#2	2.19068e-19
C1144	VPWR#2	VNB	5.6437e-17
C1145	VGND#16	a_27_74##7	3.24442e-17
C1146	VGND	VGND#10	8.77114e-17
C1147	VPWR#2	a_1474_446##5	2.05905e-19
C1148	Q	VPWR#2	2.11441e-17
C1149	VGND#2	a_1474_446##9	6.71292e-19
C1150	VGND#3	VGND#2	2.1486e-19
C1151	VGND#10	a_27_74##4	1.24908e-18
C1152	VPWR#2	a_1474_446##7	5.02714e-19
C1153	VPWR#2	a_1474_446##8	4.87349e-18
C1154	VGND#16	VGND#15	5.56886e-18
C1155	VPWR#2	a_2320_410##4	1.13742e-17
C1156	a_27_74##15	VPWR#17	2.67716e-17
C1157	VGND#2	Q	2.11084e-17
C1158	VGND#2	a_1474_446##5	3.98992e-19
C1159	VGND#2	a_2320_410##6	3.39264e-20
C1160	VGND#2	a_1474_446##4	6.51227e-18
C1161	a_27_74##13	VPWR#17	6.61394e-19
C1162	VPWR#17	VNB	5.19834e-17
C1163	a_1062_93##9	VGND#16	1.72358e-17
C1164	VGND#16	a_1062_93##3	3.05933e-19
C1165	VPWR#17	a_27_74##3	7.09192e-19
C1166	VGND#10	VGND#9	5.64405e-19
C1167	a_214_74##10	VPWR#17	6.27102e-18
C1168	VGND#2	a_2320_410#	1.10305e-17
C1169	VGND#2	a_1474_446##8	1.33756e-19
C1170	VGND#2	VNB	5.76349e-17
C1171	VPWR#17	CLK#1	4.60087e-18
C1172	VGND#10	a_214_74##9	9.71207e-18
C1173	VGND#4	VGND#2	1.1038e-16
C1174	VPWR	VPWR#17	9.17406e-17
C1175	VGND#10	a_27_74##8	8.38872e-19
C1176	VGND#13	VGND#2	5.25286e-19
C1177	VPWR#17	a_27_74##9	4.54331e-18
C1178	VGND#16	a_671_93##4	7.69304e-18
C1179	VPWR#17	CLK#2	8.57805e-20
C1180	VPWR#17	VPWR#15	4.80791e-19
C1181	VGND#10	CLK#3	4.67428e-18
C1182	VGND#16	a_27_74##6	2.91513e-19
C1183	a_27_74##4	VPWR#17	4.65132e-19
C1184	a_2320_410##3	VPWR#2	1.38359e-19
C1185	a_671_93##5	VGND#16	3.66219e-17
C1186	VGND#10	VNB	4.97007e-17
C1187	VGND#2	a_2320_410##3	2.77723e-19
C1188	VPWR#4	VPWR#2	1.11036e-16
C1189	VPWR#6	VPWR#2	6.06322e-20
C1190	VGND#10	CLK#2	6.45801e-20
C1191	VGND#16	SET_B#2	1.19537e-18
C1192	a_2320_410##6	VPWR#2	1.48242e-19
C1193	a_2320_410##7	VPWR#2	1.07376e-17
C1194	VGND#2	RESET_B#3	1.31549e-19
C1195	VGND#16	a_214_74##5	5.86986e-19
C1196	VGND#10	CLK#4	5.26101e-19
C1197	VGND#2	a_2320_410##8	1.68959e-17
*
*
.ENDS sky130_fd_sc_hs__dfbbp_1
*
