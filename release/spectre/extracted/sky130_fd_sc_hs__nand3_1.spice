* Extracted by Quantus, converted by sky130cad/quantus.py
*
*
*
*                       LINUX           Wed Nov 18 08:45:46 2026
*
*
*
*  PROGRAM  advgen
*
*  Name           : advgen - Quantus - (64-bit)
*  Version        : 25.1.0-p047
*  Build Date     : Thu Dec 11 23:20:30 PST 2025
*
*  HSPICE LIBRARY
*
*  OPERATING_TEMPERATURE 150
*  QRC_TECH_DIR <path>/tech
*
*
*

*
.SUBCKT sky130_fd_sc_hs__nand3_1 VPB VNB VGND VPWR Y B C A
*
*
*  caps2d version: 10
*
*
*       TRANSISTOR CARDS
*
*
XM2 VGND#4 C#1 a_155_74# VNB sky130_fd_pr__nfet_01v8_lvt l=0.15 w=0.74 ad=0.2109 as=0.1776 pd=2.05 ps=1.96
XM1 a_155_74# B#3 a_233_74# VNB sky130_fd_pr__nfet_01v8_lvt l=0.15 w=0.74 ad=0.1776 as=0.3108 pd=1.96 ps=2.32
XM4 a_233_74# A#3 Y#1 VNB sky130_fd_pr__nfet_01v8_lvt l=0.15 w=0.74 ad=0.3108 as=0.2109 pd=2.32 ps=2.05
XM3 VPWR#4 C#4 Y#3 VPB sky130_fd_pr__pfet_01v8 l=0.15 w=1.12 ad=0.42 as=0.336 pd=2.99 ps=2.84
XM0 Y#3 B#1 VPWR#3 VPB sky130_fd_pr__pfet_01v8 l=0.15 w=1.12 ad=0.336 as=0.4704 pd=2.84 ps=3.08
XM5 VPWR#3 A#1 Y#5 VPB sky130_fd_pr__pfet_01v8 l=0.15 w=1.12 ad=0.4704 as=0.3304 pd=3.08 ps=2.83
*
*
*       RESISTOR AND CAP/DIODE CARDS
*
Rg1	C#1	C#2	320.354431
Rg2	C#2	C#3	104.807175
Rg3	C#2	C#4	506.680298
Rg4	B#1	B#2	492.059540
Rg5	B#2	B#3	307.937683
Rg6	A#1	A#2	492.059540
Rg7	A#2	A#3	307.937683
Rf1	C	C#3	9.883524
Rf2	C#3	C	7.059660
Rf3	B	B#2	163.775864
Rf4	A	A#4	1.235440
Rf5	A#5	A#2	161.468246
Rf6	A#4	A#5	3.349972
Rf7	Y#1	Y#2	86.884918
Rf8	Y#2	Y	69.626366
Rf9	Y	Y#4	10.910419
Rf10	Y#4	Y	0.149458
Rf11	Y#2	Y#5	20.719784
Rf12	Y#3	Y#4	5.000000
Rf14	VPWR#2	VPWR#3	38.437725
Rf15	VPWR#2	VPWR#4	113.994179
Rf16	VGND#1	VGND#2	52.206570
Rf18	VGND#2	VGND#4	31.829987
Re1	VPWR#2	VPWR	1.964508
Re2	VGND	VGND#1	1.964582
*
*       CAPACITOR CARDS
*
*
C1	VGND	VNB	6.44666e-17
C2	VPWR	VNB	5.89458e-17
C3	Y	VNB	1.3971e-17
C4	B	VNB	2.34392e-18
C5	C	VNB	2.78105e-17
C6	VGND	Y	6.19809e-18
C7	VGND	B	1.45051e-17
C8	VPWR	Y	2.0982e-17
C9	VGND	C	9.39949e-18
C10	C#3	VNB	7.6681e-17
C11	VPWR	B	2.47622e-18
C12	B#2	VNB	2.43423e-17
C13	A#2	VNB	4.25992e-17
C14	VPWR	C	5.87414e-18
C15	VGND#1	VNB	1.83636e-16
C16	B	Y	4.40066e-17
C17	C	Y	3.56101e-17
C18	C#4	VNB	4.55169e-17
C19	VGND	C#3	5.57194e-19
C20	B#1	VNB	3.47599e-17
C21	VGND	B#2	3.32079e-19
C22	A#1	VNB	4.16182e-17
C23	C	B	3.99224e-17
C24	VGND	A#2	3.32079e-19
C25	C#1	VNB	4.37362e-17
C26	VGND	VGND#1	4.32866e-17
C27	B#3	VNB	2.59246e-17
C28	A#3	VNB	3.22448e-17
C29	VPWR	C#3	1.57692e-18
C30	VPWR#4	VNB	8.28211e-17
C31	VPWR#3	VNB	4.19353e-18
C32	B	a_155_74#	1.92314e-20
C33	Y#5	VNB	5.86385e-17
C34	VGND#4	VNB	3.21749e-17
C35	B	a_233_74#	3.5489e-18
C36	Y#1	VNB	5.0857e-17
C37	Y	B#2	2.51801e-18
C38	VGND	C#1	4.85951e-19
C39	VGND	B#3	9.39756e-19
C40	A#4	VNB	4.0709e-18
C41	VPWR	C#4	3.35355e-19
C42	A#5	VNB	4.7984e-18
C43	VGND	A#3	2.25044e-18
C44	B	C#3	3.91092e-18
C45	VGND#1	Y	7.53746e-19
C46	VGND	VPWR#4	2.89261e-18
C47	VPWR	B#1	2.60287e-19
C48	Y#2	VNB	3.25023e-17
C49	B	B#2	1.85085e-17
C50	VPWR	A#1	3.0747e-18
C51	C	C#3	3.34407e-17
C52	B	A#2	4.0957e-18
C53	VGND	VGND#4	2.21966e-17
C54	Y	C#4	4.35572e-17
C55	VGND#1	B	1.20823e-17
C56	C	B#2	6.47068e-18
C57	Y	B#1	5.68891e-17
C58	VGND	Y#1	2.08278e-17
C59	VPWR	VPWR#4	3.59674e-17
C60	Y	A#1	1.45703e-18
C61	VGND	A#4	5.16209e-18
C62	VPWR	VPWR#3	2.20033e-17
C63	VPWR	Y#5	2.41349e-17
C64	VGND	Y#2	4.71803e-18
C65	VPWR#4	Y	1.0319e-16
C66	Y	Y#3	8.94437e-19
C67	B#2	a_233_74#	8.66223e-19
C68	B	C#1	1.11293e-17
C69	Y	VPWR#3	9.91548e-17
C70	B	B#3	2.6981e-17
C71	Y	Y#5	4.59994e-18
C72	VPWR	A#5	2.0461e-18
C73	B	A#3	1.07556e-17
C74	VPWR	Y#2	2.96562e-18
C75	C#3	B#2	3.02114e-17
C76	VGND#4	B	2.74183e-17
C77	C	VPWR#4	2.54076e-17
C78	VGND#1	C#3	1.71863e-21
C79	B#2	A#2	3.0068e-17
C80	B	Y#1	3.01146e-17
C81	VGND#1	B#2	1.69024e-19
C82	C#1	a_155_74#	1.68915e-18
C83	VGND#4	C	4.02542e-17
C84	B#3	a_155_74#	1.34218e-17
C85	B	A#4	1.72948e-17
C86	VGND#1	A#2	1.57414e-19
C87	B	A#5	1.44193e-17
C88	B#3	a_233_74#	1.87487e-17
C89	A#3	a_233_74#	2.22744e-18
C90	VPWR#4	C#3	1.08133e-17
C91	C#4	B#1	4.77899e-17
C92	VGND#1	B#3	6.10598e-18
C93	C#3	VGND#4	7.45143e-18
C94	VPWR#3	B#2	9.36707e-19
C95	VGND#1	A#3	7.46402e-18
C96	B#1	A#1	2.8754e-17
C97	A#2	Y#1	8.39685e-18
C98	VPWR#4	C#4	2.5153e-17
C99	A#4	B#2	1.73918e-18
C100	Y#2	C#3	1.64402e-19
C101	C#4	Y#3	2.44129e-17
C102	A#5	B#2	1.86405e-18
C103	VPWR#4	B#1	1.07806e-18
C104	VGND#1	Y#1	2.66418e-17
C105	VPWR#3	C#4	1.54328e-18
C106	A#4	A#2	8.00673e-18
C107	B#1	Y#3	2.37392e-17
C108	Y#2	B#2	2.59765e-19
C109	VPWR#4	A#1	4.57007e-19
C110	A#5	A#2	8.97383e-18
C111	C#1	B#3	4.84835e-17
C112	B#1	VPWR#3	3.81934e-17
C113	VGND#1	A#4	1.13042e-18
C114	Y#5	B#1	2.9383e-18
C115	Y#2	A#2	1.16895e-17
C116	A#1	VPWR#3	3.55987e-17
C117	B#3	A#3	2.1728e-17
C118	Y#5	A#1	4.64097e-17
C119	VGND#1	Y#2	7.20228e-19
C120	VGND#4	C#1	3.58158e-17
C121	VGND#4	B#3	7.09178e-18
C122	VPWR#4	VPWR#3	1.18533e-18
C123	VGND#4	A#3	1.62555e-18
C124	Y#1	C#1	8.97745e-19
C125	Y#1	B#3	5.27895e-18
C126	VPWR#3	Y#5	7.58833e-17
C127	Y#2	A#1	2.47691e-17
C128	Y#1	A#3	3.57726e-17
C129	VGND#4	Y#1	2.77985e-18
C130	Y#2	VPWR#3	1.69008e-17
C131	Y#2	Y#5	2.12269e-19
C132	Y#1	A#4	3.6715e-17
C133	Y#1	Y#2	4.34966e-18
C134	A#5	Y#2	5.71292e-17
C135	Y#5	VPWR#2	3.02679e-17
C136	VGND#2	C#1	3.78324e-18
C137	VPWR#2	C#4	3.61117e-18
C138	VPWR#2	VPWR#4	2.8531e-17
C139	VGND#2	C#3	7.75846e-19
C140	VPWR#2	A#1	5.18129e-18
C141	VGND#2	VNB	3.9383e-17
C142	Y	VPWR#2	2.02708e-17
C143	C	VPWR#2	3.30393e-21
C144	VGND#1	VGND#2	3.92722e-17
C145	VPWR#2	B#1	2.6036e-18
C146	VPWR#2	VNB	1.86292e-16
C147	VPWR#2	A#2	9.46869e-20
C148	Y#2	VPWR#2	7.32131e-19
C149	VGND#2	C	3.01101e-18
C150	VGND#2	Y	2.04983e-19
C151	VGND	VGND#2	2.89358e-17
C152	VPWR	VPWR#2	4.86073e-17
*
*
.ENDS sky130_fd_sc_hs__nand3_1
*
