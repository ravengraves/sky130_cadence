* Extracted by Quantus, converted by sky130cad/quantus.py
*
*
*
*                       LINUX           Wed Nov 18 08:57:31 2026
*
*
*
*  PROGRAM  advgen
*
*  Name           : advgen - Quantus - (64-bit)
*  Version        : 25.1.0-p047
*  Build Date     : Thu Dec 11 23:20:30 PST 2025
*
*  HSPICE LIBRARY
*
*  OPERATING_TEMPERATURE 150
*  QRC_TECH_DIR <path>/tech
*
*
*

*
.SUBCKT sky130_fd_sc_hs__o221a_2 VNB VPB VGND VPWR X C1 B1 B2 A2 A1
*
*
*  caps2d version: 10
*
*
*       TRANSISTOR CARDS
*
*
XM6 a_27_368##12 C1#1 a_165_74##2 VNB sky130_fd_pr__nfet_01v8_lvt l=0.15 w=0.74 ad=0.2109 as=0.2553 pd=2.05 ps=2.17
XM5 a_165_74##2 B1#3 a_264_74##2 VNB sky130_fd_pr__nfet_01v8_lvt l=0.15 w=0.74 ad=0.2553 as=0.2627 pd=2.17 ps=2.19
XM13 a_264_74##2 B2#3 a_165_74# VNB sky130_fd_pr__nfet_01v8_lvt l=0.15 w=0.74 ad=0.2627 as=0.2109 pd=2.19 ps=2.05
XM10 VGND#5 A2#1 a_264_74# VNB sky130_fd_pr__nfet_01v8_lvt l=0.15 w=0.74 ad=0.2109 as=0.2072 pd=2.05 ps=2.04
XM8 a_264_74# A1#1 VGND#4 VNB sky130_fd_pr__nfet_01v8_lvt l=0.15 w=0.74 ad=0.2072 as=0.3108 pd=2.04 ps=2.32
XM3 X#1 a_27_368##4 VGND#4 VNB sky130_fd_pr__nfet_01v8_lvt l=0.15 w=0.74 ad=0.2072 as=0.3108 pd=2.04 ps=2.32
XM4 VGND#1 a_27_368##5 X#1 VNB sky130_fd_pr__nfet_01v8_lvt l=0.15 w=0.74 ad=0.3108 as=0.2072 pd=2.32 ps=2.04
XM0 a_27_368##10 C1#4 VPWR#7 VPB sky130_fd_pr__pfet_01v8 l=0.15 w=1 ad=0.295 as=0.93 pd=2.59 ps=3.86
XM2 VPWR#7 B1#1 a_332_368# VPB sky130_fd_pr__pfet_01v8 l=0.15 w=1 ad=0.93 as=0.27 pd=3.86 ps=2.54
XM9 a_332_368# B2#1 a_27_368##11 VPB sky130_fd_pr__pfet_01v8 l=0.15 w=1 ad=0.27 as=0.42 pd=2.54 ps=2.84
XM11 a_27_368##11 A2#3 a_530_368# VPB sky130_fd_pr__pfet_01v8 l=0.15 w=1 ad=0.42 as=0.42 pd=2.84 ps=2.84
XM1 a_530_368# A1#3 VPWR#6 VPB sky130_fd_pr__pfet_01v8 l=0.15 w=1 ad=0.42 as=0.5914 pd=2.84 ps=3.34
XM12 VPWR#6 a_27_368##6 X#2 VPB sky130_fd_pr__pfet_01v8 l=0.15 w=1.12 ad=0.5914 as=0.336 pd=3.34 ps=2.84
XM7 X#2 a_27_368# VPWR#1 VPB sky130_fd_pr__pfet_01v8 l=0.15 w=1.12 ad=0.336 as=0.3304 pd=2.84 ps=2.83
*
*
*       RESISTOR AND CAP/DIODE CARDS
*
Rg1	C1#1	C1#2	338.718506
Rg2	C1#2	C1#3	42.441788
Rg3	C1#2	C1#4	442.543427
Rg4	B1#1	B1#2	482.806549
Rg5	B1#2	B1#3	391.006989
Rg6	B2#1	B2#2	400.207520
Rg7	B2#2	B2#3	419.008698
Rg8	A2#1	A2#2	382.539734
Rg9	A2#2	A2#3	400.207520
Rg10	A1#1	A1#2	382.539734
Rg11	A1#2	A1#3	400.207520
Rg12	a_27_368#	a_27_368##2	545.104797
Rg13	a_27_368##2	a_27_368##3	138.899704
Rg14	a_27_368##3	a_27_368##4	359.018188
Rg15	a_27_368##2	a_27_368##5	353.074890
Rg16	a_27_368##3	a_27_368##6	441.658081
Rf1	C1	C1#3	163.775864
Rf2	B1#2	B1	166.137894
Rf3	a_165_74#	a_165_74##2	110.391571
Rf4	B2#4	B2	1.409262
Rf5	B2#2	B2#6	161.642059
Rf6	B2#4	B2#6	12.224110
Rf7	B2#7	B2	1.409262
Rf8	B2#6	B2#7	2.444822
Rf9	A2	A2#2	166.137894
Rf10	a_264_74#	a_264_74##2	143.058167
Rf11	A1#4	A1#2	161.760818
Rf12	A1	A1#6	1.528014
Rf13	A1#4	A1#6	5.161376
Rf14	a_27_368##3	a_27_368##8	293.279541
Rf15	a_27_368##8	a_27_368##9	112.787170
Rf16	a_27_368##9	a_27_368##10	32.485363
Rf17	a_27_368##8	a_27_368##11	15.059351
Rf18	a_27_368##9	a_27_368##12	83.304176
Rf19	X	X#1	9.642479
Rf20	X	X#2	92.318321
Rf21	VPWR#1	VPWR#2	119.237267
Rf22	VPWR#2	VPWR#3	85.444542
Rf23	VPWR#3	VPWR#4	97.473030
Rf25	VPWR#2	VPWR#6	31.534731
Rf26	VPWR#4	VPWR#7	14.072834
Rf27	VGND#1	VGND#2	120.417152
Rf28	VGND#2	VGND#3	79.162201
Rf29	VGND#2	VGND#4	33.306259
Rf30	VGND#3	VGND#5	41.351616
Re1	VPWR#3	VPWR	0.982218
Re2	VGND	VGND#3	0.982254
*
*       CAPACITOR CARDS
*
*
C1	a_264_74#	a_27_368##8	8.86999e-18
C2	VGND#2	a_27_368##2	9.66125e-21
C3	VGND#4	A1#4	1.10933e-17
C4	a_264_74##2	a_27_368##9	5.6733e-19
C5	a_27_368##3	a_27_368##2	9.47422e-18
C6	a_264_74##2	a_27_368##8	4.89071e-18
C7	a_264_74#	A1#4	2.61385e-17
C8	a_165_74##2	a_27_368##9	3.27852e-18
C9	X#2	a_27_368##2	2.39645e-19
C10	VPWR#2	VPWR#1	8.80709e-19
C11	a_27_368##12	a_27_368##9	8.34929e-19
C12	X#2	VPWR#2	1.70987e-17
C13	VPWR#2	a_27_368##2	5.56794e-20
C14	VGND#4	VGND#1	1.13194e-18
C15	a_264_74##2	B2#6	1.98956e-17
C16	a_27_368##9	a_27_368##11	1.10884e-19
C17	a_27_368##8	a_27_368##11	5.95174e-18
C18	a_264_74#	VGND#4	7.01494e-17
C19	VGND#2	a_27_368##5	3.18721e-18
C20	a_27_368##9	VPWR#7	1.25022e-17
C21	VGND#5	VGND#4	1.61669e-18
C22	VGND#2	a_27_368##4	4.70245e-18
C23	a_264_74#	VGND#5	6.89178e-17
C24	VGND#2	A1#1	4.75596e-18
C25	a_165_74#	VGND#5	3.71769e-17
C26	a_264_74##2	a_264_74#	1.34728e-18
C27	VGND#1	VPWR#1	1.03343e-17
C28	a_165_74#	a_264_74##2	5.59492e-17
C29	a_165_74##2	a_165_74#	4.98845e-18
C30	a_165_74##2	a_264_74##2	3.54104e-17
C31	a_27_368##12	a_264_74##2	2.67119e-18
C32	a_27_368##8	B2#3	6.9997e-19
C33	a_27_368##12	a_165_74##2	6.76854e-17
C34	VPWR#2	a_27_368#	2.0084e-18
C35	a_27_368##5	VGND#1	2.90152e-17
C36	X#2	VPWR#1	1.07463e-16
C37	a_27_368##5	X#1	1.5442e-17
C38	VPWR#2	a_27_368##6	4.64443e-18
C39	VGND#1	a_27_368##4	1.04612e-18
C40	VPWR#6	VPWR#1	1.47878e-18
C41	VGND#4	a_27_368##5	1.53354e-18
C42	a_27_368##4	X#1	1.4935e-17
C43	VPWR#2	A1#3	6.81851e-18
C44	VGND#1	A1#1	2.04715e-19
C45	VPWR#6	X#2	6.79451e-17
C46	a_27_368##4	VGND#4	2.28155e-17
C47	A1#1	VGND#4	2.75427e-17
C48	A1#6	a_27_368##6	2.20796e-19
C49	a_27_368##8	A1#3	1.26568e-17
C50	VGND#5	a_27_368##4	1.3208e-19
C51	a_27_368##11	X#2	1.29079e-18
C52	a_264_74#	A1#1	4.77995e-17
C53	a_27_368##9	A2#3	1.6574e-19
C54	VGND#4	A2#1	1.18242e-18
C55	a_27_368##11	VPWR#6	1.19943e-17
C56	A1#6	A1#3	2.23813e-18
C57	VGND#5	A1#1	1.44154e-18
C58	a_27_368##8	A2#3	2.25705e-17
C59	a_27_368##12	a_27_368##10	1.38774e-18
C60	a_264_74#	A2#1	2.98831e-17
C61	a_27_368##9	B2#1	2.35812e-19
C62	VGND#5	A2#1	4.57967e-17
C63	A1#6	A2#3	3.94627e-19
C64	a_264_74#	B2#3	3.88711e-19
C65	a_27_368##8	B2#1	1.66293e-17
C66	a_264_74##2	A1#1	1.24536e-19
C67	a_165_74#	A2#1	9.6757e-19
C68	VGND#5	B2#3	1.65277e-18
C69	a_27_368##9	B1#1	6.86525e-19
C70	a_264_74#	B1#3	1.17665e-19
C71	a_264_74##2	A2#1	4.02029e-19
C72	a_165_74#	B2#3	5.38451e-17
C73	a_27_368##8	B1#1	2.03841e-17
C74	VGND#5	B1#3	2.69353e-19
C75	a_264_74##2	B2#3	3.35427e-17
C76	a_27_368##9	C1#4	1.96068e-17
C77	a_165_74#	B1#3	1.27429e-18
C78	a_27_368##12	A2#1	7.48421e-20
C79	VGND#5	C1#1	2.02611e-19
C80	a_27_368##10	a_27_368##11	1.19129e-18
C81	a_165_74##2	B2#3	7.91021e-19
C82	a_264_74##2	B1#3	3.32146e-17
C83	a_165_74#	C1#1	4.16523e-19
C84	a_27_368##12	B2#3	1.34298e-18
C85	a_165_74##2	B1#3	5.27139e-17
C86	VPWR#3	VPWR#2	5.26224e-17
C87	a_264_74##2	C1#1	1.78696e-18
C88	VGND#3	VGND#2	4.99269e-17
C89	a_27_368##12	B1#3	3.45129e-18
C90	B2#6	B2#1	2.00185e-18
C91	a_165_74##2	C1#1	1.20885e-17
C92	a_27_368##8	VPWR#3	2.88708e-18
C93	a_27_368##12	C1#1	3.75944e-17
C94	VGND#2	a_27_368##3	4.97322e-19
C95	a_27_368##3	VPWR#2	1.245e-18
C96	a_27_368##4	a_27_368##5	3.90485e-17
C97	VPWR#1	a_27_368#	3.23917e-17
C98	VPWR#2	A1#2	4.1858e-20
C99	X#2	a_27_368#	6.07247e-17
C100	VPWR#1	a_27_368##6	1.26546e-18
C101	A1#6	a_27_368##3	4.10613e-17
C102	A1#1	a_27_368##4	2.28246e-17
C103	VPWR#6	a_27_368#	1.51094e-18
C104	X#2	a_27_368##6	5.47197e-17
C105	A1#4	a_27_368##3	2.25954e-17
C106	a_27_368##6	VPWR#6	3.05189e-17
C107	A1#6	A1#2	5.93911e-18
C108	X#2	A1#3	1.79484e-18
C109	a_165_74#	B1#1	2.71931e-19
C110	A2#1	A1#1	3.9127e-17
C111	a_27_368##8	A2#2	4.11543e-18
C112	A1#3	VPWR#6	3.77332e-17
C113	a_264_74##2	B1#1	2.63788e-18
C114	A1#4	A1#2	1.06654e-17
C115	X#2	A2#3	2.14815e-19
C116	a_27_368##11	a_27_368##6	1.14193e-18
C117	A1#6	A2#2	1.69851e-18
C118	VPWR#6	A2#3	3.66202e-18
C119	B2#3	A2#1	3.32422e-18
C120	a_27_368##8	B2#2	2.92298e-18
C121	a_27_368##11	A1#3	3.84851e-18
C122	VGND#3	VGND#1	2.78711e-17
C123	X#2	B2#1	1.28199e-19
C124	A1#4	A2#2	3.18022e-18
C125	VPWR#6	B2#1	1.48046e-18
C126	A2#3	a_27_368##11	2.41744e-17
C127	a_27_368##9	B1#2	9.50076e-18
C128	VGND#3	VGND#4	2.47009e-19
C129	B1#3	B2#3	3.19545e-17
C130	a_27_368##8	B1#2	1.21349e-18
C131	VGND#3	a_264_74#	7.26945e-18
C132	VPWR#6	B1#1	4.6604e-19
C133	a_27_368##3	X#1	7.9575e-19
C134	a_27_368##11	B2#1	5.02888e-17
C135	a_27_368##3	VGND#4	2.47899e-17
C136	a_27_368##9	C1#3	1.27705e-17
C137	VGND#3	a_165_74#	3.42091e-17
C138	a_27_368##11	B1#1	7.25341e-18
C139	C1#1	B1#3	2.94325e-17
C140	VGND#3	a_264_74##2	2.09787e-18
C141	B2#6	B2#2	1.33902e-17
C142	VGND#4	A1#2	3.96959e-18
C143	VPWR#3	VPWR#1	2.53853e-17
C144	VGND#3	a_165_74##2	2.37783e-17
C145	a_27_368##10	B2#1	3.63087e-19
C146	a_27_368##11	C1#4	6.51784e-19
C147	B1#1	VPWR#7	2.95292e-17
C148	VGND#3	a_27_368##12	2.66599e-17
C149	a_27_368##10	B1#1	1.55959e-18
C150	C1#4	VPWR#7	3.52352e-17
C151	a_264_74#	A2#2	2.85383e-18
C152	VGND#5	A2#2	9.45942e-19
C153	a_27_368##10	C1#4	4.13178e-17
C154	a_27_368##11	VPWR#3	1.3609e-17
C155	a_27_368##8	a_530_368#	8.93235e-18
C156	a_27_368##3	X#2	4.67553e-17
C157	VGND#1	a_27_368##2	2.43629e-19
C158	a_27_368##3	VPWR#6	4.71641e-17
C159	a_165_74#	B2#2	4.50401e-18
C160	X#2	A1#2	1.5932e-20
C161	a_27_368##6	a_27_368#	4.6166e-17
C162	a_27_368##8	a_332_368#	4.19719e-18
C163	a_27_368##12	A2#2	1.786e-19
C164	a_264_74##2	B2#2	1.19378e-17
C165	A1#2	VPWR#6	5.29945e-19
C166	a_27_368##8	VPWR#2	8.84112e-19
C167	a_165_74#	B1#2	2.67668e-19
C168	A1#3	a_27_368##6	1.83241e-17
C169	a_264_74##2	B1#2	1.9044e-18
C170	a_165_74##2	B1#2	2.12425e-18
C171	X	a_27_368##2	2.1525e-17
C172	VGND#3	a_27_368##4	1.97356e-19
C173	VGND#3	A1#1	1.02385e-18
C174	A2#3	A1#3	3.00195e-17
C175	VGND#3	A2#1	5.76468e-18
C176	a_27_368##12	C1#3	1.35331e-17
C177	B2#2	a_27_368##11	5.29945e-19
C178	A1#1	a_27_368##3	4.77425e-19
C179	VGND#3	B2#3	6.77882e-18
C180	B2#1	A2#3	2.57083e-17
C181	VGND#3	B1#3	5.74467e-18
C182	VGND#2	A1#4	4.12191e-19
C183	VGND#3	C1#1	3.31925e-18
C184	B1#2	VPWR#7	2.07171e-18
C185	B1#1	B2#1	5.27842e-17
C186	B2#2	A2#1	4.46491e-18
C187	a_27_368##3	a_27_368#	4.37787e-18
C188	a_27_368##10	C1#3	5.31006e-18
C189	C1#4	B1#1	3.79755e-18
C190	VPWR#3	A2#3	6.84131e-18
C191	a_27_368##3	a_27_368##6	5.73598e-18
C192	VPWR#3	B2#1	4.62993e-18
C193	a_27_368##3	A1#3	1.94007e-17
C194	A1#2	a_27_368##6	2.61455e-19
C195	B1#2	B2#3	4.5965e-18
C196	A2	a_27_368##8	4.03157e-17
C197	a_27_368##3	A2#3	2.95121e-19
C198	A2	A1#6	1.50183e-17
C199	VGND#3	B1#1	7.67338e-20
C200	a_27_368##3	B2#1	1.2682e-19
C201	A1#6	a_27_368##8	1.73795e-17
C202	A2	A1#4	1.88174e-17
C203	C1#3	B1#3	5.13572e-18
C204	a_27_368##3	B1#1	9.17016e-20
C205	VGND	a_27_368##2	1.86138e-18
C206	B2	a_27_368##8	5.54438e-17
C207	a_27_368##9	B1	5.35853e-17
C208	B1#1	B2#2	1.42747e-17
C209	a_264_74#	A2	4.10671e-17
C210	VPWR#3	A2#2	1.66531e-19
C211	C1#4	B1#2	2.37251e-18
C212	A1#2	a_27_368##3	3.62504e-17
C213	VPWR#3	B2#2	5.64319e-20
C214	C1	a_27_368##9	1.89438e-17
C215	A1#3	a_530_368#	2.92558e-17
C216	A2#3	a_530_368#	2.92558e-17
C217	VGND#3	B2#2	9.70695e-19
C218	a_264_74##2	B2	5.35343e-17
C219	A2#2	A1#2	3.04764e-17
C220	a_27_368##3	B2#2	4.13054e-19
C221	VGND#3	B1#2	9.94212e-20
C222	VGND#2	X	1.97387e-17
C223	B2#1	a_332_368#	2.38236e-17
C224	VGND#3	C1#3	1.3887e-18
C225	B1#1	a_332_368#	2.38236e-17
C226	B2#2	A2#2	3.11854e-17
C227	a_264_74##2	B1	1.79787e-17
C228	a_165_74##2	B1	8.47895e-18
C229	B1#2	B2#2	4.66801e-18
C230	VPWR	VPWR#2	3.50676e-17
C231	VPWR	a_27_368##9	5.72596e-18
C232	VPWR	a_27_368##8	1.52758e-17
C233	a_27_368##12	C1	2.92084e-17
C234	X	VGND#1	9.07144e-17
C235	a_27_368##3	a_332_368#	1.06553e-21
C236	X	X#1	4.68449e-19
C237	C1#3	B1#2	2.2513e-17
C238	VPWR	A1#6	2.78408e-18
C239	VGND#4	X	6.92679e-17
C240	A2#2	a_530_368#	5.29945e-19
C241	B2	B2#3	6.28517e-18
C242	a_27_368##2	VNB	3.79658e-17
C243	VPWR	B2#6	1.08151e-18
C244	A2	A1#3	5.45132e-19
C245	VGND	VGND#2	3.16268e-17
C246	A2	A2#3	2.05625e-18
C247	C1	a_27_368##10	2.01246e-17
C248	A2	B2#1	3.52633e-19
C249	X	X#2	3.29975e-18
C250	VGND	a_27_368##9	2.20352e-19
C251	B2	A2#3	8.94288e-19
C252	VGND	A1#4	3.39918e-18
C253	B2	B1#1	1.36357e-17
C254	VGND#2	VGND#1	7.13379e-19
C255	VGND	B2#6	1.0469e-18
C256	X	a_27_368##5	3.39977e-17
C257	VPWR	VPWR#1	3.31213e-17
C258	C1	C1#1	1.30146e-18
C259	B2#6	a_27_368##8	1.53323e-17
C260	VPWR	X#2	1.91279e-17
C261	X	a_27_368##4	2.50926e-17
C262	VPWR	VPWR#6	2.1768e-17
C263	X	A1#1	2.59725e-19
C264	VGND	VGND#1	3.29432e-17
C265	X	A2#1	1.65877e-19
C266	VPWR	a_27_368##11	1.44002e-17
C267	VGND	VGND#4	2.01238e-17
C268	VGND	a_264_74#	1.61792e-17
C269	A2	A1#2	2.47034e-18
C270	B1	C1#4	2.01836e-19
C271	VGND	a_165_74#	2.20182e-17
C272	VPWR	a_27_368##10	1.43811e-17
C273	A2	A2#2	1.70717e-17
C274	VGND	a_264_74##2	1.07195e-17
C275	VGND	a_165_74##2	1.51387e-17
C276	VGND	a_27_368##12	1.89111e-17
C277	A2	B2#2	3.83485e-18
C278	X	a_27_368#	9.48322e-19
C279	VGND	VPWR#1	4.09786e-18
C280	VGND	X#2	6.9297e-19
C281	B2	A2#2	3.55115e-18
C282	B2	B2#2	7.95299e-18
C283	B2	B1#2	2.52807e-18
C284	VGND	a_27_368##10	2.76692e-18
C285	VGND#3	C1	2.88178e-18
C286	VPWR	a_27_368#	2.66966e-18
C287	VGND	a_27_368##4	1.34964e-18
C288	VPWR	a_27_368##6	3.21095e-18
C289	B1	B2#2	4.12626e-19
C290	VGND	A1#1	1.32177e-18
C291	VPWR	A1#3	9.00216e-18
C292	VGND	A2#1	6.87612e-19
C293	B1	B1#2	2.21335e-17
C294	VGND#2	VNB	3.73781e-17
C295	VPWR	A2#3	9.00216e-18
C296	VGND	B2#3	1.48207e-18
C297	VPWR#2	VNB	4.19512e-17
C298	VPWR	B2#1	8.9998e-18
C299	VGND	B1#3	1.07236e-18
C300	B1	C1#3	5.11254e-18
C301	a_27_368##9	VNB	5.70404e-18
C302	VGND	C1#1	3.43979e-18
C303	VPWR	B1#1	4.25615e-18
C304	X	a_27_368##3	5.32831e-17
C305	A1#6	VNB	3.11414e-18
C306	VPWR	C1#4	7.37508e-18
C307	A1#4	VNB	1.24692e-18
C308	X	A1#2	1.62328e-19
C309	X	A2#2	1.37806e-19
C310	C1	C1#3	2.19932e-17
C311	VPWR	VPWR#3	2.51091e-17
C312	B2#6	VNB	7.08858e-19
C313	X	B2#2	7.90015e-19
C314	VGND#1	VNB	7.10362e-17
C315	VPWR	a_27_368##3	7.15845e-18
C316	VGND#4	VNB	8.94259e-18
C317	a_264_74#	VNB	9.19303e-18
C318	VGND#5	VNB	4.62424e-18
C319	a_165_74#	VNB	9.12239e-18
C320	a_264_74##2	VNB	7.08083e-18
C321	a_165_74##2	VNB	7.26135e-18
C322	a_27_368##12	VNB	3.73861e-17
C323	VPWR#1	VNB	8.05853e-17
C324	X#2	VNB	5.48839e-18
C325	VGND	VGND#3	9.74395e-17
C326	VPWR	B1#2	1.15097e-20
C327	VPWR#6	VNB	7.53296e-18
C328	VGND	a_27_368##3	4.95785e-18
C329	a_27_368##11	VNB	3.39519e-18
C330	VPWR	C1#3	1.00712e-18
C331	B2	A2	3.15224e-17
C332	a_27_368##10	VNB	5.10561e-17
C333	a_27_368##5	VNB	3.36846e-17
C334	a_27_368##4	VNB	3.11043e-17
C335	VGND	B2#2	9.28377e-21
C336	A1#1	VNB	3.18021e-17
C337	A2#1	VNB	2.63462e-17
C338	B2#3	VNB	4.71246e-17
C339	B1#3	VNB	3.47022e-17
C340	VGND	C1#3	8.34277e-19
C341	B1	B2	3.82429e-17
C342	C1#1	VNB	3.47444e-17
C343	a_27_368#	VNB	4.81707e-17
C344	a_27_368##6	VNB	3.51425e-17
C345	A1#3	VNB	3.43406e-17
C346	A2#3	VNB	3.16908e-17
C347	B2#1	VNB	3.0361e-17
C348	B1#1	VNB	3.81667e-17
C349	C1#4	VNB	5.32075e-17
C350	VPWR#3	VNB	2.34348e-16
C351	VPWR	A2	2.51368e-18
C352	VGND#3	VNB	3.09528e-16
C353	a_27_368##3	VNB	3.42615e-17
C354	VPWR	B2	3.23041e-18
C355	A1#2	VNB	2.76881e-17
C356	A2#2	VNB	2.38329e-17
C357	B2#2	VNB	5.17643e-17
C358	VGND	A2	2.49498e-18
C359	VPWR	B1	2.74362e-18
C360	B1#2	VNB	2.87669e-17
C361	C1#3	VNB	7.90998e-17
C362	VGND	B2	3.23316e-18
C363	VPWR	C1	3.48574e-18
C364	VGND	B1	2.65984e-18
C365	VGND	C1	6.74388e-18
C366	VGND#2	a_264_74#	6.70407e-18
C367	VGND	X	2.25288e-17
C368	A2	VNB	3.91405e-18
C369	B2	VNB	6.62413e-18
C370	B1	VNB	4.52842e-18
C371	C1	VNB	2.51905e-17
C372	X	VNB	1.70402e-17
C373	VPWR	VNB	6.32354e-17
C374	VGND	VNB	8.44295e-17
C375	VPWR#4	B2#1	4.67263e-18
C376	a_27_368##10	VPWR#4	6.85298e-17
C377	a_27_368##9	VPWR#4	7.40516e-17
C378	VPWR#4	B1#2	2.32308e-18
C379	VPWR#4	a_27_368##11	2.09379e-17
C380	VPWR#3	VPWR#4	8.22985e-17
C381	VPWR#4	VNB	8.91285e-17
C382	VPWR#4	B1#1	3.73148e-17
C383	VPWR	VPWR#4	1.12153e-16
C384	a_27_368##8	VPWR#4	1.16327e-17
C385	VPWR#4	C1#3	2.03234e-18
C386	VPWR#4	A1#3	4.70116e-19
C387	VPWR#4	B2#3	3.58975e-19
C388	VPWR#4	C1#4	2.22324e-17
C389	VPWR#4	A2#3	9.73282e-19
C390	VPWR#4	VPWR#7	2.20402e-17
C391	C1	VPWR#4	2.79683e-19
C392	VPWR#4	B2#2	2.09402e-20
*
*
.ENDS sky130_fd_sc_hs__o221a_2
*
