* Extracted by Quantus, converted by sky130cad/quantus.py
*
*
*
*                       LINUX           Wed Nov 18 08:25:03 2026
*
*
*
*  PROGRAM  advgen
*
*  Name           : advgen - Quantus - (64-bit)
*  Version        : 25.1.0-p047
*  Build Date     : Thu Dec 11 23:20:30 PST 2025
*
*  HSPICE LIBRARY
*
*  OPERATING_TEMPERATURE 150
*  QRC_TECH_DIR <path>/tech
*
*
*
*
.SUBCKT sky130_fd_sc_hs__conb_1 VGND VPWR HI LO VPB VNB
*
*
*  caps2d version: 10
*
*
*       CANONICAL RESISTOR AND CAP/DIODE CARDS
*
R0	HI#2	VPWR#2	0.000e+00
R1	VGND#2	LO#2	0.000e+00
*
*       PARASITIC RESISTOR AND CAP/DIODE CARDS
*
Rg1	VPWR#1	VPWR#2	152.026657
Rg2	HI#1	HI#2	111.628799
Rg3	LO#1	LO#2	152.026657
Rg4	VGND#1	VGND#2	114.005142
Rf1	HI#1	HI	81.240204
Rf2	LO	LO#1	80.116402
Rf4	VGND#4	VGND#5	19.699100
Rf5	VGND#4	VGND#1	96.080841
Rf6	VPWR#3	VPWR#4	19.699100
Rf8	VPWR#4	VPWR#1	98.639717
Re1	VPWR#3	VPWR	3.274347
Re2	VGND	VGND#5	3.274471
*
*       CAPACITOR CARDS
*
*
C1	VGND	HI	2.46763e-17
C2	VGND	VNB	4.82004e-17
C3	VPWR	HI	5.66431e-18
C4	VGND	HI#1	3.64579e-18
C5	VPWR	VNB	4.91499e-17
C6	VGND	VGND#1	3.28143e-17
C7	VGND	LO#1	5.56578e-18
C8	VGND	VGND#5	2.4067e-17
C9	HI	VNB	7.37684e-17
C10	HI	HI#2	2.15275e-17
C11	VPWR	VPWR#1	2.95563e-17
C12	HI	VPWR#2	3.2228e-17
C13	VPWR	LO#1	2.83317e-17
C14	HI	VGND#2	3.74947e-18
C15	HI	LO#2	5.46842e-18
C16	VPWR	VPWR#3	2.42883e-17
C17	HI	HI#1	6.68172e-17
C18	HI	VPWR#1	5.34321e-17
C19	HI	VGND#1	6.36656e-17
C20	HI	LO#1	3.90708e-17
C21	HI#2	VNB	3.36138e-17
C22	VGND#5	HI	4.42079e-17
C23	VPWR#2	VNB	5.03218e-17
C24	VGND#2	VNB	3.45787e-17
C25	LO#2	VNB	5.02986e-17
C26	HI#1	VNB	1.20255e-16
C27	VPWR#1	VNB	1.6142e-16
C28	HI#2	VGND#2	2.70803e-17
C29	VGND#1	VNB	1.40602e-16
C30	LO#1	VNB	2.13375e-16
C31	VGND#5	VNB	1.24009e-16
C32	VPWR#2	LO#2	4.05408e-17
C33	VPWR#3	VNB	1.23788e-16
C34	HI#1	VGND#2	7.16831e-19
C35	LO#1	HI#2	3.5594e-18
C36	LO#1	VPWR#2	5.32863e-18
C37	LO#1	VGND#2	1.99997e-17
C38	LO#1	LO#2	2.90926e-17
C39	HI#1	VGND#1	8.14601e-17
C40	LO#1	HI#1	2.30838e-18
C41	VGND#5	HI#1	1.18411e-17
C42	VPWR#1	LO#1	1.58198e-16
C43	LO#1	VGND#1	3.37382e-17
C44	LO#1	VPWR#3	5.59723e-17
C45	VPWR#4	VNB	2.69511e-17
C46	VPWR#4	VPWR#1	6.03397e-18
C47	VGND#4	LO#1	1.08324e-18
C48	VGND#4	VNB	2.65321e-17
C49	VGND#4	VGND#1	6.03397e-18
C50	HI	VPWR#4	1.4237e-18
C51	VPWR#3	VPWR#4	2.86894e-17
C52	VGND	VGND#4	1.45186e-17
C53	VPWR	VPWR#4	1.59654e-17
C54	VGND#5	VGND#4	2.88335e-17
*
*
.ENDS sky130_fd_sc_hs__conb_1
*
