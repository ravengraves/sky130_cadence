* Extracted by Quantus, converted by sky130cad/quantus.py
*
*
*
*                       LINUX           Wed Nov 18 08:52:23 2026
*
*
*
*  PROGRAM  advgen
*
*  Name           : advgen - Quantus - (64-bit)
*  Version        : 25.1.0-p047
*  Build Date     : Thu Dec 11 23:20:30 PST 2025
*
*  HSPICE LIBRARY
*
*  OPERATING_TEMPERATURE 150
*  QRC_TECH_DIR <path>/tech
*
*
*

*
.SUBCKT sky130_fd_sc_hs__nor4bb_4 VNB VPB VGND VPWR Y A B D_N C_N
*
*
*  caps2d version: 10
*
*
*       TRANSISTOR CARDS
*
*
XM5 VGND#18 B#1 Y#10 VNB sky130_fd_pr__nfet_01v8_lvt l=0.15 w=0.74 ad=0.2627 as=0.2072 pd=2.19 ps=2.04
XM27 Y#10 A#10 VGND#21 VNB sky130_fd_pr__nfet_01v8_lvt l=0.15 w=0.74 ad=0.2072 as=0.2775 pd=2.04 ps=2.23
XM17 VGND#21 A#7 Y#19 VNB sky130_fd_pr__nfet_01v8_lvt l=0.15 w=0.74 ad=0.2775 as=0.2405 pd=2.23 ps=2.13
XM13 Y#19 A#5 VGND#20 VNB sky130_fd_pr__nfet_01v8_lvt l=0.15 w=0.74 ad=0.2405 as=0.2886 pd=2.13 ps=2.26
XM34 VGND#20 A#1 Y#18 VNB sky130_fd_pr__nfet_01v8_lvt l=0.15 w=0.74 ad=0.2886 as=0.222 pd=2.26 ps=2.08
XM8 Y#18 B#10 VGND#19 VNB sky130_fd_pr__nfet_01v8_lvt l=0.15 w=0.74 ad=0.222 as=0.2442 pd=2.08 ps=2.14
XM19 VGND#19 B#8 Y#17 VNB sky130_fd_pr__nfet_01v8_lvt l=0.15 w=0.74 ad=0.2442 as=0.259 pd=2.14 ps=2.18
XM31 Y#17 B#4 VGND#15 VNB sky130_fd_pr__nfet_01v8_lvt l=0.15 w=0.74 ad=0.259 as=0.2072 pd=2.18 ps=2.04
XM32 Y#16 a_864_48##7 VGND#15 VNB sky130_fd_pr__nfet_01v8_lvt l=0.15 w=0.74 ad=0.259 as=0.2072 pd=2.18 ps=2.04
XM2 VGND#14 a_864_48##5 Y#16 VNB sky130_fd_pr__nfet_01v8_lvt l=0.15 w=0.74 ad=0.259 as=0.259 pd=2.18 ps=2.18
XM6 VGND#14 a_864_48##4 Y#15 VNB sky130_fd_pr__nfet_01v8_lvt l=0.15 w=0.74 ad=0.259 as=0.2516 pd=2.18 ps=2.16
XM22 VGND#13 a_1162_48##6 Y#15 VNB sky130_fd_pr__nfet_01v8_lvt l=0.15 w=0.74 ad=0.2664 as=0.2516 pd=2.2 ps=2.16
XM28 Y#11 a_1162_48##10 VGND#13 VNB sky130_fd_pr__nfet_01v8_lvt l=0.15 w=0.74 ad=0.2072 as=0.2664 pd=2.04 ps=2.2
XM3 Y#11 a_1162_48##8 VGND#12 VNB sky130_fd_pr__nfet_01v8_lvt l=0.15 w=0.74 ad=0.2072 as=0.5032 pd=2.04 ps=2.84
XM15 VGND#12 a_1162_48# Y#1 VNB sky130_fd_pr__nfet_01v8_lvt l=0.15 w=0.74 ad=0.5032 as=0.2257 pd=2.84 ps=2.09
XM37 Y#1 a_864_48##10 VGND#11 VNB sky130_fd_pr__nfet_01v8_lvt l=0.15 w=0.74 ad=0.2257 as=0.6993 pd=2.09 ps=3.37
XM24 VGND#11 C_N#4 a_864_48##14 VNB sky130_fd_pr__nfet_01v8_lvt l=0.15 w=0.74 ad=0.6993 as=0.2109 pd=3.37 ps=2.05
XM16 VGND#10 D_N#1 a_1162_48##16 VNB sky130_fd_pr__nfet_01v8_lvt l=0.15 w=0.74 ad=0.2627 as=0.2109 pd=2.19 ps=2.05
XM7 a_116_368##5 B#3 a_27_368##8 VPB sky130_fd_pr__pfet_01v8 l=0.15 w=1.12 ad=0.392 as=0.3304 pd=2.94 ps=2.83
XM11 a_116_368##5 A#12 VPWR#11 VPB sky130_fd_pr__pfet_01v8 l=0.15 w=1.12 ad=0.392 as=0.392 pd=2.94 ps=2.94
XM12 VPWR#11 A#11 a_116_368##6 VPB sky130_fd_pr__pfet_01v8 l=0.15 w=1.12 ad=0.392 as=0.336 pd=2.94 ps=2.84
XM4 a_116_368##6 A#8 VPWR#10 VPB sky130_fd_pr__pfet_01v8 l=0.15 w=1.12 ad=0.336 as=0.4368 pd=2.84 ps=3.02
XM21 VPWR#10 A#4 a_116_368##2 VPB sky130_fd_pr__pfet_01v8 l=0.15 w=1.12 ad=0.4368 as=0.414225 pd=3.02 ps=3.14
XM33 a_27_368##6 B#12 a_116_368##2 VPB sky130_fd_pr__pfet_01v8 l=0.15 w=1.12 ad=0.336 as=0.414225 pd=2.84 ps=3.14
XM14 a_116_368# B#11 a_27_368##6 VPB sky130_fd_pr__pfet_01v8 l=0.15 w=1.12 ad=0.392 as=0.336 pd=2.94 ps=2.84
XM0 a_27_368##4 B#7 a_116_368# VPB sky130_fd_pr__pfet_01v8 l=0.15 w=1.12 ad=0.3472 as=0.392 pd=2.86 ps=2.94
XM10 a_27_368##4 a_864_48##9 a_897_349# VPB sky130_fd_pr__pfet_01v8 l=0.15 w=1.12 ad=0.3472 as=0.336 pd=2.86 ps=2.84
XM23 a_27_368##2 a_864_48##8 a_897_349# VPB sky130_fd_pr__pfet_01v8 l=0.15 w=1.12 ad=0.6047 as=0.336 pd=3.72 ps=2.84
XM1 a_897_349##6 a_864_48# a_27_368##2 VPB sky130_fd_pr__pfet_01v8 l=0.15 w=1.12 ad=0.336 as=0.6047 pd=2.84 ps=3.72
XM35 a_897_349##6 a_1162_48##12 Y#12 VPB sky130_fd_pr__pfet_01v8 l=0.15 w=1.12 ad=0.336 as=0.336 pd=2.84 ps=2.84
XM26 Y#12 a_1162_48##11 a_897_349##4 VPB sky130_fd_pr__pfet_01v8 l=0.15 w=1.12 ad=0.336 as=0.3472 pd=2.84 ps=2.86
XM9 a_897_349##4 a_1162_48##9 Y#14 VPB sky130_fd_pr__pfet_01v8 l=0.15 w=1.12 ad=0.3472 as=0.336 pd=2.86 ps=2.84
XM18 Y#14 a_1162_48##7 a_897_349##2 VPB sky130_fd_pr__pfet_01v8 l=0.15 w=1.12 ad=0.336 as=0.7336 pd=2.84 ps=3.55
XM25 a_897_349##2 a_864_48##12 a_27_368# VPB sky130_fd_pr__pfet_01v8 l=0.15 w=1.12 ad=0.7336 as=0.364 pd=3.55 ps=2.89
XM36 VPWR#9 C_N#3 a_864_48##18 VPB sky130_fd_pr__pfet_01v8 l=0.15 w=0.84 ad=0.2898 as=0.252 pd=2.37 ps=2.28
XM20 a_864_48##18 C_N#1 VPWR#8 VPB sky130_fd_pr__pfet_01v8 l=0.15 w=0.84 ad=0.252 as=0.252 pd=2.28 ps=2.28
XM30 a_1162_48##13 D_N#4 VPWR#8 VPB sky130_fd_pr__pfet_01v8 l=0.15 w=0.84 ad=0.252 as=0.252 pd=2.28 ps=2.28
XM29 VPWR#1 D_N#5 a_1162_48##13 VPB sky130_fd_pr__pfet_01v8 l=0.15 w=0.84 ad=0.2478 as=0.252 pd=2.27 ps=2.28
*
*
*       RESISTOR AND CAP/DIODE CARDS
*
Rg1	B#1	B#2	368.883942
Rg2	B#2	B#3	442.451355
Rg3	A#1	A#2	320.850525
Rg4	A#2	A#3	81.783760
Rg5	A#2	A#4	506.650146
Rg6	A#3	A#5	309.740967
Rg7	A#3	A#6	81.790932
Rg8	A#6	A#7	365.484741
Rg9	A#3	A#8	488.224884
Rg10	A#6	A#9	73.239426
Rg11	A#9	A#10	377.236847
Rg12	A#6	A#11	454.433350
Rg13	A#9	A#12	561.358704
Rg14	B#4	B#5	343.038818
Rg15	B#5	B#6	83.513847
Rg16	B#5	B#7	449.655212
Rg17	B#6	B#8	325.796478
Rg18	B#6	B#9	64.081955
Rg19	B#9	B#10	343.038818
Rg20	B#6	B#11	429.126801
Rg21	B#9	B#12	449.655212
Rg22	a_864_48#	a_864_48##2	441.337158
Rg23	a_864_48##2	a_864_48##3	94.751320
Rg24	a_864_48##2	a_864_48##4	371.664124
Rg25	a_864_48##3	a_864_48##5	333.803070
Rg26	a_864_48##3	a_864_48##6	69.003761
Rg27	a_864_48##6	a_864_48##7	343.038818
Rg28	a_864_48##3	a_864_48##8	429.126801
Rg29	a_864_48##6	a_864_48##9	449.655212
Rg30	a_1162_48#	a_1162_48##2	338.914246
Rg31	a_1162_48##2	a_1162_48##3	81.198303
Rg32	a_1162_48##3	a_1162_48##4	200.502869
Rg33	a_1162_48##4	a_1162_48##5	180.577667
Rg34	a_1162_48##5	a_1162_48##6	316.433228
Rg35	a_1162_48##2	a_1162_48##7	442.451355
Rg36	a_1162_48##3	a_1162_48##8	322.828552
Rg37	a_1162_48##3	a_1162_48##9	459.985352
Rg38	a_1162_48##4	a_1162_48##10	363.485107
Rg39	a_1162_48##4	a_1162_48##11	432.348541
Rg40	a_1162_48##5	a_1162_48##12	504.425171
Rg41	a_864_48##10	a_864_48##11	320.826660
Rg42	a_864_48##11	a_864_48##12	469.735809
Rg43	a_864_48##11	a_864_48##13	267.781097
Rg44	C_N#1	C_N#2	494.270752
Rg45	C_N#2	C_N#3	393.155731
Rg46	C_N#2	C_N#4	480.322479
Rg47	D_N#1	D_N#2	509.225098
Rg48	D_N#2	D_N#3	30.596949
Rg49	D_N#3	D_N#4	462.649445
Rg50	D_N#2	D_N#5	502.769287
Rf1	A	A#13	6.159882
Rf2	A#13	A	11.232725
Rf3	a_116_368#	a_116_368##3	107.603065
Rf4	a_116_368##3	a_116_368##4	70.051720
Rf5	a_116_368##4	a_116_368##5	80.003792
Rf6	a_116_368##4	a_116_368##6	11.876151
Rf7	a_116_368##2	a_116_368##3	15.000000
Rf8	B#6	B	212.383270
Rf9	B	B#2	194.895828
Rf11	a_897_349##3	a_897_349##5	92.847176
Rf12	a_897_349##5	a_897_349##7	66.110695
Rf13	a_897_349##7	a_897_349#	93.156845
Rf14	a_897_349##2	a_897_349##3	5.000000
Rf15	a_897_349##4	a_897_349##5	15.000000
Rf16	a_897_349##6	a_897_349##7	15.000000
Rf17	Y	Y#2	5.806673
Rf18	Y#2	Y	8.840339
Rf19	Y	Y#3	88.495773
Rf20	Y#3	Y#4	53.546860
Rf21	Y#4	Y#5	51.217522
Rf22	Y#5	Y#6	64.534019
Rf23	Y#6	Y#7	70.136757
Rf24	Y#7	Y#8	67.998032
Rf25	Y#8	Y#9	73.784721
Rf26	Y#9	Y#10	81.267464
Rf27	Y#3	Y#11	18.633333
Rf28	Y#4	Y#13	16.889572
Rf29	Y#13	Y#14	51.158836
Rf30	Y#5	Y#15	20.804337
Rf31	Y#6	Y#16	15.295733
Rf32	Y#7	Y#17	17.631954
Rf33	Y#8	Y#18	13.794752
Rf34	Y#9	Y#19	12.244770
Rf35	Y#1	Y#2	7.500000
Rf36	Y#12	Y#13	15.000000
Rf37	a_27_368#	a_27_368##3	256.726929
Rf38	a_27_368##3	a_27_368##5	116.865509
Rf39	a_27_368##5	a_27_368##7	108.875481
Rf40	a_27_368##7	a_27_368##8	215.261719
Rf41	a_27_368##2	a_27_368##3	15.000000
Rf42	a_27_368##4	a_27_368##5	5.000000
Rf43	a_27_368##6	a_27_368##7	5.000000
Rf44	a_864_48##14	a_864_48##13	78.939514
Rf45	a_864_48##13	a_864_48##16	17.333679
Rf46	a_864_48##16	a_864_48##3	393.175964
Rf47	a_864_48##16	a_864_48##18	87.149574
Rf48	C_N	C_N#2	164.169525
Rf49	D_N#3	D_N	162.201172
Rf50	a_1162_48##13	a_1162_48##14	125.888985
Rf51	a_1162_48##14	a_1162_48##2	377.531006
Rf52	a_1162_48##14	a_1162_48##16	30.461123
Rf53	VPWR#1	VPWR#2	94.902809
Rf54	VPWR#2	VPWR#3	73.440742
Rf55	VPWR#3	VPWR#4	403.896179
Rf56	VPWR#4	VPWR#5	81.041168
Rf57	VPWR#5	VPWR#6	70.789574
Rf59	VPWR#2	VPWR#8	60.083012
Rf60	VPWR#3	VPWR#9	35.032631
Rf61	VPWR#5	VPWR#10	30.196730
Rf62	VPWR#6	VPWR#11	31.948624
Rf64	VGND#2	VGND#3	103.310745
Rf65	VGND#3	VGND#4	29.351362
Rf66	VGND#4	VGND#5	90.316933
Rf67	VGND#5	VGND#6	82.490936
Rf68	VGND#6	VGND#7	67.887894
Rf69	VGND#7	VGND#8	73.001427
Rf70	VGND#8	VGND#9	59.876873
Rf71	VGND#2	VGND#10	27.172388
Rf72	VGND#4	VGND#11	17.964474
Rf73	VGND#5	VGND#12	17.188660
Rf74	VGND#6	VGND#13	33.306259
Rf75	VGND#7	VGND#14	34.507496
Rf76	VGND#8	VGND#15	34.507496
Rf77	VGND#9	VGND#16	80.878891
Rf78	VGND#16	VGND#17	73.001427
Rf79	VGND#17	VGND#18	104.232445
Rf80	VGND#9	VGND#19	38.005394
Rf81	VGND#16	VGND#20	33.326477
Rf82	VGND#17	VGND#21	33.326477
Rf83	A#3	A#13	53.410934
Re1	VPWR#3	VPWR	2.377092
Re2	VPWR	VPWR#4	1.528131
Re3	VGND#3	VGND	2.377092
Re4	VGND	VGND#9	1.528131
*
*       CAPACITOR CARDS
*
*
C1	a_864_48##18	C_N#1	5.45963e-17
C2	B#6	B#9	1.56504e-17
C3	Y#6	VGND#15	5.34229e-17
C4	B#6	B#5	1.59754e-17
C5	Y#7	Y#17	1.07553e-18
C6	VPWR#8	C_N#3	6.05867e-19
C7	B#6	A#9	3.77119e-20
C8	a_116_368#	B#9	4.00406e-20
C9	VPWR#9	C_N#1	2.2091e-18
C10	a_1162_48##10	a_1162_48##8	3.68924e-17
C11	B#6	A#6	5.22378e-20
C12	Y#8	VGND#19	5.33982e-17
C13	B#6	A#2	1.45129e-17
C14	a_1162_48##13	a_864_48##12	2.64352e-19
C15	a_864_48##18	C_N#3	2.62777e-17
C16	VGND#16	A#5	2.73034e-18
C17	a_27_368#	C_N#1	1.71289e-19
C18	a_1162_48##14	a_1162_48##13	4.28683e-18
C19	a_864_48##18	VPWR#2	6.58232e-18
C20	a_116_368#	B#5	4.83092e-19
C21	VPWR#9	C_N#3	5.03739e-17
C22	Y#17	Y#6	2.77482e-18
C23	VGND#3	VGND#5	1.04569e-16
C24	Y#7	VGND#19	1.40508e-17
C25	VPWR#3	VPWR#2	6.99587e-17
C26	VGND#3	VGND#4	8.86065e-17
C27	a_864_48##18	a_864_48##12	2.63866e-19
C28	a_1162_48##13	VPWR#1	8.90197e-17
C29	a_27_368#	C_N#3	2.52019e-18
C30	A#3	a_864_48##6	1.34405e-19
C31	a_1162_48##6	a_1162_48##10	2.60571e-17
C32	VGND#17	A#7	9.56465e-19
C33	Y#8	Y#18	4.62049e-18
C34	Y#3	a_864_48##10	7.69395e-20
C35	A#3	B#9	3.9116e-18
C36	VPWR#9	a_864_48##12	1.17565e-18
C37	Y#9	VGND#20	4.97152e-17
C38	A#3	B#5	3.1336e-20
C39	VPWR#9	VPWR#2	5.06096e-20
C40	a_27_368##6	B#9	6.58992e-19
C41	a_27_368#	a_864_48##12	3.12705e-17
C42	VPWR#8	VPWR#1	2.28687e-18
C43	A#3	A#6	2.48747e-17
C44	A#3	A#2	2.07997e-17
C45	VGND#10	a_1162_48##16	5.16436e-17
C46	a_864_48##4	a_1162_48##6	2.92111e-17
C47	a_897_349##2	a_864_48##12	5.08059e-17
C48	Y#8	VGND#20	3.83887e-17
C49	Y#3	a_1162_48#	1.06267e-18
C50	VGND#17	A#10	2.71574e-18
C51	a_27_368##6	B#5	1.4207e-18
C52	VGND#16	VGND#9	1.30753e-18
C53	a_27_368#	a_1162_48##7	9.04953e-18
C54	Y#9	Y#19	4.15935e-18
C55	Y#14	a_864_48##12	6.91305e-19
C56	VPWR#8	a_1162_48##13	6.46729e-17
C57	VGND#9	VGND#8	8.24523e-19
C58	a_864_48##16	VPWR#3	2.01649e-17
C59	Y#9	Y#8	2.34774e-18
C60	VGND#3	a_1162_48##14	3.84705e-17
C61	a_897_349##2	a_1162_48##7	2.92381e-17
C62	a_864_48##5	a_864_48##4	2.50752e-17
C63	a_27_368#	a_1162_48##9	7.45163e-18
C64	Y#14	a_1162_48##7	3.72014e-17
C65	Y#5	a_1162_48##10	3.6933e-19
C66	A#2	VGND#20	1.15704e-18
C67	Y#12	a_864_48##12	5.23357e-20
C68	Y#3	a_1162_48##8	4.31111e-17
C69	a_864_48##18	a_1162_48##13	3.21046e-18
C70	VGND#8	a_864_48##6	5.48226e-20
C71	a_864_48##16	a_1162_48##13	1.31382e-18
C72	B#2	A#9	2.43139e-17
C73	A#2	B#10	8.8796e-19
C74	Y#9	VGND#21	4.7067e-17
C75	a_897_349##2	a_1162_48##9	5.54747e-19
C76	a_897_349##4	a_1162_48##7	4.02817e-18
C77	VGND#3	a_864_48##16	4.8675e-18
C78	Y#6	a_1162_48##6	2.46166e-19
C79	a_27_368#	a_1162_48##11	1.71138e-19
C80	Y#14	a_1162_48##9	4.27733e-17
C81	Y#12	a_1162_48##7	3.77178e-20
C82	a_864_48##18	VPWR#8	6.53588e-17
C83	a_864_48##7	a_864_48##5	2.73942e-17
C84	A#6	Y#19	3.77027e-19
C85	a_27_368##6	A#2	3.03897e-19
C86	a_897_349##2	a_1162_48##11	2.81746e-19
C87	Y#5	a_1162_48##6	5.39628e-18
C88	a_897_349##4	a_1162_48##9	3.60917e-17
C89	Y#3	a_1162_48##10	2.23717e-17
C90	VGND#6	a_1162_48##4	4.90309e-20
C91	Y#10	Y#9	2.59023e-18
C92	Y#12	a_1162_48##9	6.71275e-20
C93	VPWR#9	VPWR#8	2.26956e-18
C94	Y#6	a_864_48##4	1.29803e-18
C95	a_897_349##2	a_1162_48##12	1.94227e-19
C96	a_897_349##4	a_1162_48##11	3.60903e-17
C97	B#4	a_864_48##7	3.80475e-17
C98	VGND#21	A#9	1.13815e-18
C99	Y#5	a_864_48##4	1.57964e-17
C100	Y#3	a_1162_48##6	1.53956e-18
C101	Y#12	a_1162_48##11	4.06487e-17
C102	VPWR#9	a_864_48##18	5.20812e-17
C103	D_N#1	a_1162_48##16	1.71441e-17
C104	VPWR#2	D_N#3	4.47497e-20
C105	a_897_349#	a_1162_48##9	2.48854e-19
C106	VGND#6	a_1162_48##3	4.39587e-21
C107	VGND#4	a_864_48##11	5.64724e-19
C108	Y#6	a_864_48##5	4.29902e-17
C109	Y#12	a_1162_48##12	3.73481e-17
C110	VGND#21	A#6	7.11838e-19
C111	VGND#17	A#6	5.44894e-20
C112	a_27_368##2	a_1162_48##11	7.16481e-18
C113	a_116_368##2	A#2	2.11831e-19
C114	VGND#10	D_N#1	5.27388e-17
C115	B#8	B#4	2.80422e-17
C116	a_27_368#	a_864_48##18	2.24823e-18
C117	a_1162_48##14	D_N#3	2.85729e-17
C118	A#2	B#12	2.94207e-18
C119	Y#3	a_864_48##4	8.94566e-20
C120	Y#5	a_864_48##5	2.14195e-19
C121	a_897_349##6	a_1162_48##12	3.87913e-17
C122	a_897_349#	a_1162_48##11	2.27442e-19
C123	VGND#7	a_864_48##2	7.88889e-20
C124	a_1162_48##16	C_N#4	1.13319e-19
C125	VGND#3	Y#3	9.01453e-18
C126	a_864_48##14	D_N#1	1.50506e-18
C127	Y#12	a_864_48#	2.62449e-18
C128	a_864_48##16	VPWR#9	2.6371e-17
C129	a_27_368##2	a_1162_48##12	7.11643e-18
C130	VPWR#2	C_N#2	1.10589e-20
C131	VGND#4	VGND#11	1.38157e-17
C132	Y#6	a_864_48##7	2.80768e-17
C133	a_27_368#	VPWR#9	4.09657e-17
C134	Y#8	B#4	2.25387e-19
C135	VGND#10	C_N#4	8.03423e-19
C136	a_897_349##6	a_864_48#	4.00269e-17
C137	Y#10	A#9	3.06016e-18
C138	a_897_349#	a_1162_48##12	3.97385e-19
C139	VGND#8	B#5	6.30104e-20
C140	a_864_48##16	D_N#3	2.61015e-19
C141	B#10	B#8	2.78776e-17
C142	VGND#4	a_864_48##13	2.24119e-18
C143	VGND#5	Y#1	4.10887e-17
C144	a_27_368##2	a_864_48#	2.43356e-17
C145	Y#12	a_864_48##8	1.0836e-18
C146	Y#5	a_864_48##7	1.18188e-19
C147	a_27_368##4	a_1162_48##12	1.83309e-19
C148	a_864_48##11	VGND#11	6.21744e-19
C149	a_1162_48##14	C_N#2	1.09592e-18
C150	Y#7	B#4	2.03289e-17
C151	VGND#9	Y#8	8.09817e-18
C152	a_864_48##14	C_N#4	3.6042e-17
C153	VGND#5	a_1162_48##3	4.17561e-19
C154	VGND#9	Y#7	3.40627e-19
C155	a_897_349#	a_864_48#	3.57866e-18
C156	Y#10	A#6	3.06053e-19
C157	a_864_48##16	a_27_368#	5.37642e-17
C158	VPWR#10	A#2	1.8052e-19
C159	Y#6	B#4	5.14514e-19
C160	a_1162_48##5	a_1162_48##4	5.46772e-18
C161	Y#8	B#8	1.14797e-18
C162	a_27_368##2	a_864_48##8	3.0114e-17
C163	a_27_368##4	a_864_48#	3.9111e-19
C164	A#1	B#10	3.43884e-17
C165	VGND#4	Y#1	4.71235e-17
C166	C_N#4	VGND#11	6.85431e-18
C167	VGND#5	a_1162_48##2	2.67551e-18
C168	a_864_48##16	C_N#2	5.10026e-18
C169	VGND#4	a_1162_48##2	9.10661e-17
C170	a_897_349#	a_864_48##8	6.67388e-17
C171	a_897_349##2	a_27_368#	1.0575e-16
C172	Y#5	B#4	6.43019e-20
C173	VGND#5	VGND#12	1.95844e-17
C174	a_864_48##14	a_864_48##10	2.7747e-19
C175	Y#7	B#8	1.78966e-17
C176	a_1162_48##14	a_864_48##13	1.02896e-19
C177	Y#9	B#10	1.93355e-19
C178	a_27_368##4	a_864_48##8	6.73507e-19
C179	Y#1	C_N#4	4.42608e-19
C180	a_27_368##2	a_864_48##9	4.369e-18
C181	VGND#8	a_864_48##3	5.12627e-20
C182	a_864_48##16	a_897_349##2	5.10757e-17
C183	VGND#3	a_1162_48##16	1.59537e-17
C184	A#5	A#1	2.42248e-17
C185	Y#6	B#8	2.25394e-19
C186	a_116_368##6	A#6	3.87348e-19
C187	a_897_349#	a_864_48##9	5.0481e-17
C188	a_864_48##10	VGND#11	1.3714e-17
C189	VGND#7	a_864_48##3	6.33664e-20
C190	Y#8	B#10	3.97413e-17
C191	VGND#7	VGND#13	6.05632e-20
C192	a_864_48##13	a_864_48##16	4.8939e-18
C193	a_27_368##4	a_864_48##9	2.63958e-17
C194	VGND#3	a_864_48##14	8.58486e-18
C195	Y#5	B#8	6.92458e-20
C196	A#6	A#8	2.55136e-18
C197	a_864_48##10	Y#1	1.42666e-17
C198	a_116_368#	a_864_48##9	1.67203e-18
C199	a_897_349#	B#7	1.93449e-18
C200	Y#9	A#1	5.43802e-19
C201	a_1162_48##2	a_1162_48##14	4.22714e-18
C202	a_897_349##4	a_27_368#	3.73597e-17
C203	VGND#3	Y#1	1.67875e-17
C204	A#7	A#5	3.07715e-17
C205	a_27_368##6	a_864_48##9	2.17014e-19
C206	a_27_368##4	B#7	4.67775e-17
C207	a_864_48##16	Y#14	8.42904e-17
C208	Y#8	A#1	3.05213e-17
C209	VPWR#11	A#9	2.98025e-19
C210	a_116_368#	B#7	5.8684e-17
C211	VGND#7	Y#15	6.98903e-18
C212	a_1162_48##2	a_864_48##16	1.0107e-16
C213	Y#1	a_1162_48#	3.31957e-17
C214	VGND#17	Y#9	9.47826e-18
C215	a_27_368##6	B#7	1.81812e-18
C216	a_1162_48##14	a_1162_48##16	2.22518e-18
C217	a_27_368##4	B#11	3.69192e-19
C218	VPWR#2	D_N#5	5.13236e-19
C219	Y#9	A#5	3.54881e-17
C220	A#10	A#7	2.55911e-17
C221	VPWR#11	A#6	1.97874e-19
C222	VGND#13	VGND#5	2.02184e-18
C223	a_116_368##2	B#7	1.87621e-19
C224	a_116_368#	B#11	2.83573e-17
C225	a_1162_48#	VGND#12	1.62705e-17
C226	VGND#17	A#3	4.5595e-20
C227	a_864_48##16	a_897_349##4	4.8501e-17
C228	Y#14	a_897_349##4	1.75549e-18
C229	Y#8	A#5	1.66885e-18
C230	a_897_349##2	Y#12	3.89881e-20
C231	VGND#16	A#3	6.37522e-20
C232	a_27_368##6	B#11	6.52441e-17
C233	VGND#6	Y#15	7.43435e-18
C234	Y#1	a_1162_48##8	1.06919e-18
C235	B#1	A#9	2.56978e-18
C236	a_116_368##2	B#11	4.41591e-19
C237	a_116_368#	B#12	4.64174e-19
C238	VGND#16	Y#9	8.71444e-18
C239	a_1162_48##4	a_1162_48##3	1.16589e-17
C240	B#1	A#10	3.51215e-17
C241	a_1162_48##14	VGND#10	1.00852e-16
C242	Y#9	A#7	2.34347e-17
C243	a_27_368##6	B#12	6.19045e-17
C244	VPWR#2	D_N#4	9.92391e-18
C245	a_1162_48##8	VGND#12	1.881e-17
C246	a_27_368##4	A#4	2.61026e-19
C247	VGND#10	D_N#3	2.2072e-18
C248	a_116_368##5	A#9	3.10326e-19
C249	VGND#13	a_1162_48#	1.78856e-19
C250	a_864_48##14	D_N#3	9.57488e-19
C251	a_116_368##2	B#12	2.82256e-17
C252	Y#5	Y#3	2.51476e-18
C253	a_116_368#	A#4	1.99719e-19
C254	Y#8	A#7	4.14981e-19
C255	Y#12	a_864_48##16	2.64036e-19
C256	Y#4	a_1162_48##2	2.44913e-17
C257	a_1162_48##8	Y#11	1.38199e-17
C258	VPWR#10	B#12	6.18537e-19
C259	a_27_368##6	A#4	1.66706e-17
C260	a_897_349##4	Y#12	1.65694e-18
C261	a_116_368##5	A#6	6.47637e-20
C262	Y#3	a_1162_48##2	4.37862e-17
C263	VPWR#5	A#3	2.81191e-20
C264	VPWR#3	VPWR#1	6.7695e-17
C265	a_116_368##6	B#12	1.81381e-19
C266	a_116_368##2	A#4	4.48459e-17
C267	Y#9	A#10	4.68127e-19
C268	VGND#16	Y#8	6.72684e-18
C269	a_1162_48##14	a_864_48##14	7.98597e-17
C270	Y#8	B#9	8.89695e-19
C271	VGND#13	a_1162_48##8	1.28846e-18
C272	VPWR#3	a_1162_48##13	2.05602e-17
C273	a_864_48##14	C_N#2	6.10001e-18
C274	VPWR#10	A#4	4.08056e-17
C275	VPWR#2	C_N#1	7.04092e-18
C276	Y#6	a_864_48##3	8.24672e-17
C277	a_27_368##6	A#8	1.4472e-17
C278	A#12	A#6	2.60318e-18
C279	Y#5	a_1162_48##5	2.74336e-19
C280	Y#5	a_864_48##3	4.7348e-17
C281	Y#8	A#10	2.78417e-19
C282	a_1162_48##10	Y#11	1.49382e-17
C283	VGND#9	Y#17	8.9736e-18
C284	a_116_368##6	A#4	5.13442e-19
C285	a_864_48##16	a_897_349##6	1.48392e-20
C286	a_116_368##2	A#8	4.25126e-19
C287	Y#4	a_864_48##3	4.15368e-18
C288	a_864_48##18	VPWR#3	2.55919e-17
C289	a_864_48##2	a_1162_48##5	2.21778e-17
C290	VPWR#11	A#4	3.11565e-19
C291	A#8	VPWR#10	3.00727e-17
C292	VPWR#3	VPWR#9	2.21721e-17
C293	a_27_368##8	A#9	4.45199e-19
C294	a_27_368##6	A#11	5.44478e-19
C295	Y#8	B#6	5.10867e-17
C296	VGND#13	a_1162_48##10	1.73454e-17
C297	a_864_48##11	a_27_368#	7.75559e-19
C298	a_897_349##6	Y#12	1.17394e-18
C299	a_27_368#	VPWR#3	1.79429e-16
C300	a_897_349##4	a_27_368##2	4.84185e-17
C301	a_116_368##6	A#8	5.45381e-17
C302	Y#7	B#6	6.65757e-17
C303	VGND#20	VGND#9	1.2967e-19
C304	a_864_48##13	VGND#11	2.20768e-18
C305	VPWR#3	a_897_349##2	1.21145e-17
C306	D_N#4	D_N#5	4.05159e-17
C307	a_27_368##8	A#4	6.12526e-19
C308	Y#5	a_1162_48##4	8.09009e-20
C309	VPWR#11	A#8	2.03224e-18
C310	VPWR#2	C_N#3	4.89283e-19
C311	Y#5	B#6	2.67581e-20
C312	VPWR#10	A#11	7.57064e-19
C313	a_27_368##8	A#6	5.86501e-19
C314	Y#9	A#6	2.37485e-18
C315	a_27_368##6	A#12	5.32332e-19
C316	VPWR#3	Y#14	3.21213e-18
C317	Y#6	a_864_48##6	1.38525e-18
C318	a_116_368##5	A#8	2.00227e-19
C319	Y#15	VGND#13	4.52569e-17
C320	VGND#8	Y#17	5.41872e-18
C321	a_116_368##6	A#11	3.4632e-17
C322	VPWR#3	a_897_349##4	6.30618e-18
C323	VGND#13	a_1162_48##6	4.04398e-17
C324	Y#9	A#3	7.987e-17
C325	a_864_48##16	D_N#4	1.56498e-20
C326	a_1162_48##4	Y#11	2.7816e-19
C327	a_27_368##8	A#8	5.37386e-19
C328	VPWR#11	A#11	4.10117e-17
C329	Y#8	A#3	2.19025e-17
C330	a_1162_48##2	a_864_48##14	3.85807e-17
C331	C_N#1	D_N#4	4.15854e-17
C332	a_1162_48##2	VGND#11	1.7281e-17
C333	Y#4	a_1162_48##5	1.6893e-17
C334	VGND#3	Y#14	3.36529e-18
C335	a_116_368##5	A#11	9.552e-19
C336	a_116_368##2	VPWR#5	1.90735e-17
C337	a_116_368##6	A#12	6.54185e-19
C338	VGND#8	Y#7	2.63212e-19
C339	a_1162_48##2	Y#1	1.06235e-17
C340	a_1162_48##6	Y#15	1.24345e-17
C341	a_897_349##6	a_27_368##2	8.4844e-17
C342	a_27_368##2	VPWR#3	4.92961e-17
C343	C_N	a_864_48##11	1.27785e-19
C344	a_27_368##8	A#11	1.45141e-17
C345	VGND#14	VGND#13	2.84166e-18
C346	a_1162_48##2	VGND#12	8.86917e-18
C347	Y#9	A#2	5.20273e-19
C348	A#12	VPWR#11	2.93049e-17
C349	Y#6	a_864_48##2	6.75892e-19
C350	VGND#13	a_864_48##4	1.97003e-18
C351	VGND#18	a_27_368##8	6.1018e-18
C352	a_1162_48##3	Y#11	4.4122e-20
C353	a_116_368##5	A#12	6.02724e-17
C354	VGND#13	a_1162_48##5	2.89596e-18
C355	VGND#14	a_1162_48##6	1.17749e-18
C356	C_N#3	C_N#1	3.82103e-17
C357	Y#7	B#5	2.8094e-18
C358	VGND#17	VGND#16	1.21609e-18
C359	a_864_48##16	C_N#1	6.45175e-20
C360	a_27_368##8	A#12	2.3474e-17
C361	a_1162_48##13	D_N#3	5.25962e-18
C362	a_27_368#	a_1162_48##3	4.29865e-20
C363	VPWR#11	B#3	1.38888e-18
C364	Y#4	a_1162_48##4	1.715e-17
C365	a_864_48##4	Y#15	2.0212e-17
C366	VGND#14	Y#15	3.47403e-17
C367	B#3	a_116_368##5	2.78217e-17
C368	Y#5	a_864_48##6	4.60731e-20
C369	VPWR#3	a_864_48##11	4.11516e-20
C370	VGND#8	Y#6	9.459e-18
C371	a_27_368##8	B#3	6.24498e-17
C372	a_864_48##12	C_N#3	4.98918e-18
C373	a_897_349#	a_27_368##2	5.59487e-17
C374	VGND#14	a_864_48##4	3.54241e-17
C375	VGND#13	a_1162_48##4	2.75994e-18
C376	VPWR#3	a_1162_48##5	1.46755e-20
C377	a_27_368##2	VPWR#4	1.2347e-16
C378	a_1162_48##13	C_N#2	8.23875e-19
C379	VPWR#3	a_1162_48##4	3.74725e-20
C380	Y#3	a_1162_48##5	9.40546e-20
C381	Y#15	a_864_48##5	4.95718e-19
C382	a_864_48##3	VGND#14	4.15214e-18
C383	a_864_48##16	C_N#3	1.60609e-17
C384	VPWR#3	a_1162_48##3	3.85934e-20
C385	Y#4	a_1162_48##3	4.94097e-18
C386	a_27_368##4	VPWR#4	3.09299e-17
C387	a_864_48##18	C_N#2	1.84875e-18
C388	a_864_48##3	Y#16	3.77799e-18
C389	Y#8	A#2	1.27028e-18
C390	a_1162_48##7	a_864_48##12	1.20819e-17
C391	a_116_368#	VPWR#4	6.33434e-17
C392	Y#5	a_864_48##2	1.36398e-17
C393	a_864_48##5	VGND#14	1.79998e-17
C394	VGND#7	Y#6	8.69228e-18
C395	a_116_368##6	VPWR#5	7.55926e-18
C396	VGND#15	a_864_48##4	2.04819e-19
C397	a_116_368##2	VPWR#4	1.97449e-17
C398	a_27_368##4	a_897_349#	7.19093e-17
C399	Y#3	a_1162_48##4	1.20833e-18
C400	a_864_48##5	Y#16	1.71955e-17
C401	VPWR#9	a_864_48##13	1.04279e-18
C402	a_1162_48##9	a_1162_48##7	4.71653e-17
C403	a_864_48##16	a_864_48##12	2.34232e-17
C404	a_864_48##13	a_27_368#	5.85784e-19
C405	B#6	Y#17	4.09414e-18
C406	VGND#14	a_864_48##7	4.1636e-19
C407	Y#3	Y#14	4.33152e-18
C408	B#6	VGND#19	4.61824e-18
C409	VGND#15	a_864_48##5	1.16102e-18
C410	VGND#3	D_N#1	1.34078e-18
C411	VGND#3	C_N#4	6.23239e-18
C412	VGND#7	Y#5	3.40627e-19
C413	a_1162_48##11	a_1162_48##9	4.41096e-17
C414	a_864_48##7	Y#16	4.52419e-18
C415	VGND#15	VGND#14	2.54569e-18
C416	VGND#3	a_1162_48##3	1.0687e-18
C417	a_27_368#	a_1162_48##2	5.54807e-19
C418	Y#3	a_1162_48##3	2.69758e-18
C419	VGND#3	a_864_48##10	7.19951e-19
C420	Y#17	a_864_48##5	2.13879e-19
C421	a_1162_48##2	a_897_349##2	6.20644e-18
C422	Y#4	a_864_48##2	4.72793e-19
C423	a_864_48##16	a_1162_48##7	2.23419e-17
C424	a_27_368##4	a_116_368#	7.95032e-17
C425	a_1162_48##2	Y#14	5.11413e-17
C426	VGND#15	a_864_48##7	3.13435e-17
C427	Y#5	B#5	1.61319e-19
C428	a_897_349##4	a_1162_48##2	2.13596e-19
C429	a_1162_48##12	a_1162_48##11	4.69271e-17
C430	B	B#9	1.81444e-19
C431	A#3	VGND#20	1.39943e-18
C432	B	A#9	2.37089e-17
C433	Y#12	a_1162_48##2	1.77812e-19
C434	Y#14	a_1162_48##3	2.07325e-18
C435	B	A#6	1.76984e-17
C436	A#3	Y#19	5.25834e-19
C437	B	A#2	1.19696e-19
C438	Y#4	Y#12	1.43132e-17
C439	Y#17	a_864_48##7	4.97389e-19
C440	a_27_368##6	a_27_368##4	2.75983e-18
C441	VGND#4	D_N#1	1.03738e-19
C442	a_864_48##3	Y#14	3.45598e-20
C443	a_897_349##4	a_1162_48##5	1.54084e-20
C444	VGND#15	B#4	2.7202e-17
C445	a_864_48##3	a_897_349##4	3.76648e-17
C446	a_864_48#	a_1162_48##12	4.71897e-17
C447	VPWR#4	a_1162_48##5	1.06861e-20
C448	a_864_48##16	a_1162_48##9	1.33498e-17
C449	a_864_48##3	Y#12	6.9832e-17
C450	C_N#4	D_N#3	1.41959e-19
C451	a_27_368##6	a_116_368#	1.08068e-16
C452	a_864_48##3	a_897_349##6	8.27795e-17
C453	VGND#17	Y#10	1.51835e-17
C454	B#4	Y#17	1.73535e-17
C455	VGND#5	C_N#4	1.50219e-19
C456	a_864_48##3	a_27_368##2	1.96199e-17
C457	Y#10	B#2	2.50888e-17
C458	a_897_349##4	a_1162_48##4	1.76192e-19
C459	a_864_48##3	a_897_349#	7.91251e-17
C460	a_864_48##8	a_864_48#	2.36112e-17
C461	VGND#8	VGND#7	9.62091e-19
C462	B#2	VGND#18	4.09272e-17
C463	VGND#15	B#8	1.14332e-18
C464	VPWR#4	a_864_48##6	1.69746e-20
C465	Y#3	a_864_48##2	1.95952e-20
C466	a_864_48##3	a_27_368##4	1.3327e-18
C467	VGND#6	Y#4	3.87525e-19
C468	a_864_48##2	Y#15	3.64486e-19
C469	VGND#19	B#4	1.16479e-18
C470	a_116_368##2	a_116_368#	2.46324e-18
C471	VPWR#4	a_864_48##2	7.06673e-20
C472	VGND#4	C_N#4	2.58978e-18
C473	Y#12	a_864_48##11	7.52325e-20
C474	Y#17	VGND#15	3.6591e-17
C475	VPWR#4	B#9	1.246e-20
C476	a_864_48##16	a_1162_48##11	3.98337e-19
C477	B#8	Y#17	2.05525e-17
C478	B#6	a_897_349#	4.47049e-21
C479	a_864_48##9	a_864_48##8	4.63395e-17
C480	a_897_349##4	a_1162_48##3	1.86396e-19
C481	a_864_48##13	C_N#4	1.78315e-17
C482	VPWR#4	B#5	3.57549e-20
C483	B#6	a_27_368##4	1.40448e-17
C484	a_27_368##6	a_116_368##2	9.45901e-17
C485	VGND#9	B#4	3.58378e-19
C486	VGND#18	VGND#17	1.22054e-18
C487	B#6	a_116_368#	3.76655e-18
C488	VGND#5	a_864_48##10	1.33721e-18
C489	a_1162_48##10	a_1162_48##3	6.20913e-19
C490	VGND#19	B#8	3.49172e-17
C491	a_1162_48##2	D_N#1	1.16188e-19
C492	Y#7	a_27_368##4	6.44784e-18
C493	B#6	a_27_368##6	1.5995e-16
C494	VGND#9	B#8	4.16205e-18
C495	a_1162_48##2	C_N#4	3.01864e-17
C496	B#6	a_116_368##2	1.43387e-18
C497	B#7	a_864_48##9	4.47305e-17
C498	VGND#19	VGND#15	2.84823e-18
C499	C_N	VPWR#2	4.46651e-19
C500	VGND#9	B#10	4.18431e-18
C501	VGND#6	Y#3	8.49471e-18
C502	Y#17	B#10	4.47005e-19
C503	B#6	VPWR#10	1.00883e-18
C504	a_1162_48##2	a_864_48##10	7.29462e-18
C505	a_27_368##6	VPWR#10	1.71201e-18
C506	VGND#9	A#1	3.17563e-19
C507	VPWR#3	D_N#5	2.66365e-19
C508	VGND#4	a_864_48##10	1.8705e-17
C509	a_1162_48##14	C_N	1.95774e-17
C510	a_1162_48##2	a_1162_48#	9.34023e-19
C511	a_864_48##16	a_1162_48##12	2.34365e-19
C512	a_27_368##6	A#3	9.85245e-19
C513	VGND#9	A#5	8.01545e-20
C514	Y#6	a_27_368##4	5.34591e-18
C515	B#5	a_864_48##6	2.33985e-17
C516	a_1162_48##2	a_1162_48##8	9.93457e-20
C517	VPWR#3	D_N#4	4.3607e-18
C518	Y#12	a_1162_48##4	2.91355e-18
C519	B#10	VGND#19	1.79634e-17
C520	B#11	B#7	3.27698e-17
C521	a_864_48##16	C_N	2.44434e-17
C522	a_1162_48##2	a_1162_48##10	2.61562e-20
C523	VGND#14	a_864_48##2	5.95579e-19
C524	VGND#20	B#8	2.85947e-19
C525	VPWR#3	C_N#1	2.57723e-18
C526	VPWR#10	A#3	5.05347e-19
C527	VGND#19	Y#17	3.47403e-17
C528	a_116_368##2	VPWR#10	4.60606e-17
C529	a_27_368##6	a_116_368##6	4.18016e-17
C530	a_116_368##6	A#3	7.98279e-19
C531	VGND#5	a_1162_48#	1.58282e-17
C532	VPWR#3	C_N#3	4.4868e-18
C533	B#10	Y#18	1.57129e-17
C534	VGND#5	Y#3	6.50406e-17
C535	Y#12	a_1162_48##3	6.26946e-19
C536	VGND#7	VGND#6	1.13178e-18
C537	D_N	VPWR#2	3.20171e-19
C538	VPWR#3	a_864_48##12	3.44884e-18
C539	B#12	B#11	4.60289e-17
C540	VGND#9	B#5	3.8803e-20
C541	a_27_368##8	A#3	8.32329e-20
C542	VGND#19	A#1	4.61728e-19
C543	a_1162_48##14	D_N	5.46813e-17
C544	VPWR#3	a_1162_48##7	3.44766e-18
C545	a_116_368##6	a_116_368##2	2.21398e-18
C546	VGND#4	a_1162_48#	2.04616e-18
C547	a_864_48##16	a_864_48#	1.58185e-19
C548	VGND#20	B#10	1.4432e-18
C549	a_1162_48##4	a_1162_48##9	1.10385e-18
C550	VPWR#3	a_1162_48##9	3.44927e-18
C551	a_897_349##6	a_1162_48##5	1.03839e-19
C552	A#4	B#12	4.07872e-17
C553	A#1	Y#18	4.24086e-18
C554	VPWR#3	a_1162_48##11	3.43813e-18
C555	B#2	a_27_368##8	4.48596e-17
C556	a_116_368##6	VPWR#10	4.64028e-17
C557	VGND#5	a_1162_48##8	1.58132e-17
C558	VGND#19	A#5	2.06688e-19
C559	C_N#1	D_N#3	1.02885e-18
C560	A#1	VGND#20	2.39673e-17
C561	A#8	A#4	3.26689e-17
C562	a_1162_48##14	D_N#1	1.65794e-17
C563	Y#12	a_864_48##2	6.44788e-19
C564	VPWR#11	VPWR#10	1.80502e-18
C565	VGND#4	a_1162_48##8	2.53076e-19
C566	C_N#2	C_N#1	3.31324e-18
C567	a_864_48##14	C_N	3.34301e-17
C568	VPWR#4	a_1162_48##12	3.46453e-18
C569	VGND#6	a_1162_48##10	5.61442e-18
C570	A#3	a_864_48##7	1.62602e-19
C571	A#11	A#8	4.68226e-17
C572	Y#10	B#10	3.29286e-19
C573	A#3	B#4	2.35702e-19
C574	VPWR#4	a_864_48#	3.4642e-18
C575	a_864_48##12	C_N#2	2.22711e-18
C576	A#5	VGND#20	2.49559e-17
C577	A#3	B#8	4.53275e-19
C578	VGND#20	VGND#19	2.60152e-18
C579	Y#9	B	4.90316e-18
C580	VGND#21	A#1	2.91388e-19
C581	VPWR#4	a_864_48##8	3.44588e-18
C582	a_116_368##6	VPWR#11	3.57492e-17
C583	A#3	B#10	7.97661e-19
C584	VGND#5	a_1162_48##10	8.36179e-19
C585	A#12	A#11	3.78097e-17
C586	VPWR#4	a_864_48##9	3.43606e-18
C587	a_27_368##2	a_1162_48##5	7.47177e-20
C588	a_864_48##11	C_N#2	5.49449e-19
C589	a_1162_48##14	C_N#4	3.49724e-18
C590	VGND#7	a_1162_48##6	3.59927e-19
C591	A#5	Y#19	1.64942e-17
C592	VGND#6	VGND#5	9.83479e-19
C593	VPWR#4	B#7	8.48516e-18
C594	Y#10	A#1	3.40737e-19
C595	a_1162_48##2	a_864_48##12	2.20664e-19
C596	a_116_368##5	a_116_368##6	2.41843e-18
C597	VPWR#4	B#11	3.44588e-18
C598	VGND#20	A#7	7.07799e-19
C599	B#3	A#12	3.88268e-17
C600	VGND#21	A#5	1.37011e-18
C601	A#3	B#1	7.92865e-19
C602	VGND#6	a_1162_48##6	9.47213e-19
C603	VPWR#4	B#12	3.44755e-18
C604	a_27_368##2	a_1162_48##4	1.10397e-19
C605	Y#4	a_1162_48##12	6.21119e-19
C606	VGND#8	a_864_48##4	8.00859e-20
C607	C_N	a_1162_48##13	2.63633e-18
C608	a_897_349##6	a_864_48##2	2.82016e-19
C609	A#7	Y#19	6.01434e-18
C610	C_N	VPWR#8	1.49278e-17
C611	a_864_48##3	a_1162_48##7	1.78092e-19
C612	VGND	a_1162_48##4	5.9892e-21
C613	VGND#5	Y	2.40484e-17
C614	VGND	a_1162_48##3	4.35644e-19
C615	a_116_368##5	VPWR#11	4.47076e-17
C616	C_N	a_864_48##18	3.8258e-17
C617	Y#10	A#5	7.68714e-19
C618	a_27_368##8	a_116_368##6	3.64367e-17
C619	VGND	a_864_48##6	1.531e-19
C620	VGND	a_864_48##2	3.30439e-21
C621	a_864_48##3	a_1162_48##9	2.3355e-19
C622	VGND	B#5	2.27504e-19
C623	VGND#5	a_1162_48##6	3.40554e-19
C624	VGND	A#6	3.1198e-19
C625	a_1162_48##14	a_864_48##10	9.36457e-20
C626	VGND#20	A#10	2.65696e-19
C627	a_864_48##3	a_1162_48##11	1.29342e-17
C628	VGND#7	a_864_48##4	4.14923e-18
C629	A#7	VGND#21	2.80185e-17
C630	a_27_368##2	a_1162_48##3	7.26189e-20
C631	a_864_48##3	a_1162_48##12	2.06683e-17
C632	D_N	a_1162_48##13	2.92714e-17
C633	a_864_48##3	a_864_48#	1.82641e-17
C634	a_27_368##8	VPWR#11	1.75249e-18
C635	a_1162_48##12	a_1162_48##4	4.36051e-18
C636	a_864_48##3	a_864_48##8	1.02411e-17
C637	Y#10	A#7	2.21555e-18
C638	a_864_48##13	a_864_48##11	1.41416e-18
C639	a_864_48##3	a_864_48##9	6.12682e-19
C640	a_27_368##2	a_864_48##6	5.45481e-20
C641	VGND#8	a_864_48##5	3.71742e-19
C642	B#6	a_864_48##8	2.1355e-19
C643	a_864_48##3	B#7	3.37655e-19
C644	A#10	VGND#21	2.46255e-17
C645	Y#10	B	2.6858e-17
C646	a_27_368##8	a_116_368##5	1.14578e-16
C647	VGND#18	A#7	2.90575e-19
C648	B#6	a_864_48##9	2.79612e-19
C649	a_864_48##3	B#11	2.1383e-19
C650	a_864_48##13	a_1162_48##4	1.27509e-19
C651	VPWR	VPWR#5	6.32453e-17
C652	B#6	B#7	5.01234e-19
C653	a_864_48##3	B#12	1.41743e-19
C654	a_864_48##16	a_864_48##11	2.00849e-18
C655	a_864_48##13	a_1162_48##3	1.50053e-20
C656	VPWR#5	A#4	1.78655e-18
C657	Y#10	A#10	5.58672e-17
C658	B#6	B#11	8.87913e-19
C659	VGND#7	a_864_48##5	4.54721e-18
C660	VGND#5	VGND#4	3.36853e-18
C661	a_864_48##2	a_27_368##2	6.80806e-19
C662	VPWR	a_864_48##16	2.59833e-19
C663	B#6	B#12	6.02389e-18
C664	a_864_48##2	a_1162_48##12	4.93429e-18
C665	B#6	A#4	1.88189e-17
C666	VPWR#3	C_N#2	3.40855e-20
C667	VGND#21	B#1	1.465e-18
C668	VGND#21	VGND#20	1.56774e-18
C669	Y	Y#1	1.73634e-18
C670	VGND#18	A#10	1.37281e-18
C671	Y	VGND#12	1.5744e-18
C672	VGND#3	C_N#2	4.20424e-20
C673	VPWR#3	a_864_48##13	5.27386e-19
C674	VPWR	Y#5	3.21685e-18
C675	VPWR	Y#4	3.48969e-18
C676	VGND	VGND#17	6.79272e-17
C677	VGND	VGND#16	6.03725e-17
C678	B	a_27_368##6	2.45245e-17
C679	VGND	VGND#8	7.33551e-17
C680	VGND#3	a_864_48##13	5.57107e-18
C681	VGND#8	a_864_48##7	3.86485e-18
C682	Y#10	B#1	3.90487e-17
C683	VGND	VGND#7	7.6687e-17
C684	VGND	VGND#6	5.76577e-17
C685	VPWR#3	a_1162_48##2	8.91876e-18
C686	VGND	VGND#5	3.07965e-18
C687	B	a_116_368##6	5.28099e-19
C688	B	VPWR#11	6.32669e-19
C689	VGND#3	a_1162_48##2	6.60977e-17
C690	VPWR#5	A#8	2.55393e-18
C691	B	a_27_368##8	6.5015e-17
C692	C_N#2	D_N#3	1.9534e-17
C693	a_1162_48##2	a_864_48##11	5.83514e-17
C694	VGND#18	B#1	2.8268e-17
C695	VGND#7	a_864_48##7	2.76879e-19
C696	a_897_349#	a_864_48##6	8.97757e-19
C697	Y#3	Y#1	3.32966e-18
C698	a_864_48##13	D_N#3	6.25696e-19
C699	B#2	A#12	2.34393e-18
C700	VPWR#4	a_864_48##3	9.70208e-20
C701	VGND	Y#9	2.06741e-17
C702	a_864_48##13	C_N#2	2.19859e-17
C703	VGND	Y#8	1.83026e-17
C704	VGND	Y#7	3.48843e-18
C705	a_1162_48##2	a_1162_48##4	7.306e-19
C706	VGND	Y#6	2.03698e-17
C707	VPWR#4	B#6	7.7469e-20
C708	VGND	Y#5	1.71624e-18
C709	VGND	Y#4	4.00715e-18
C710	VGND	Y#3	1.0692e-17
C711	a_1162_48##2	C_N#2	2.36026e-19
C712	a_1162_48##2	a_1162_48##3	1.43286e-17
C713	VGND#9	B#6	7.11982e-20
C714	a_1162_48##2	a_864_48##13	1.01027e-16
C715	C_N#4	D_N#1	2.8077e-18
C716	C_N	a_864_48##12	4.54016e-19
C717	VGND#8	B#4	3.86077e-18
C718	a_864_48##11	VNB	2.01302e-17
C719	a_1162_48##5	VNB	1.95816e-17
C720	a_1162_48##4	VNB	2.37822e-17
C721	a_1162_48##3	VNB	2.14939e-17
C722	a_864_48##6	VNB	1.91233e-17
C723	a_864_48##16	a_1162_48##4	6.37545e-20
C724	a_864_48##2	VNB	2.42379e-17
C725	B#9	VNB	1.82777e-17
C726	B#5	VNB	2.04427e-17
C727	A#9	VNB	2.61903e-17
C728	A#6	VNB	2.79308e-17
C729	A#2	VNB	2.92187e-17
C730	VPWR	Y#14	1.90911e-19
C731	VGND	VGND#13	2.19442e-17
C732	VPWR	a_897_349##4	5.70607e-18
C733	VGND	Y#15	1.57885e-17
C734	Y#3	VGND#12	1.5938e-18
C735	VPWR	Y#12	5.12782e-18
C736	Y	C_N#4	1.54261e-19
C737	VPWR	a_897_349##6	1.1615e-17
C738	Y	a_864_48##10	8.45658e-18
C739	VPWR	a_27_368##2	6.14367e-17
C740	VGND	Y#17	1.4437e-17
C741	VPWR	a_897_349#	1.21383e-17
C742	Y	a_1162_48#	2.08437e-17
C743	VPWR	a_27_368##4	1.50661e-17
C744	VGND	VGND#20	1.62875e-17
C745	VPWR	a_116_368#	2.9055e-17
C746	B#6	a_864_48##3	1.58023e-17
C747	VPWR	a_27_368##6	1.59592e-17
C748	VGND	VGND#21	1.62145e-17
C749	Y#5	VGND#13	2.55231e-17
C750	VPWR	a_116_368##2	2.20082e-17
C751	VGND	Y#10	1.83872e-17
C752	VPWR	VPWR#10	1.83714e-17
C753	VGND	VGND#18	6.81469e-17
C754	VPWR	a_116_368##6	1.83003e-17
C755	VGND#19	B#9	3.26939e-19
C756	Y#10	VGND#21	4.59539e-17
C757	VPWR	VPWR#11	1.59269e-17
C758	Y#6	Y#15	3.05551e-18
C759	VPWR	a_116_368##5	1.86068e-17
C760	VPWR	a_27_368##8	2.46741e-17
C761	A#3	B#6	6.52236e-17
C762	VGND	Y#14	2.53984e-19
C763	VGND	Y#12	1.34114e-18
C764	a_864_48##10	C_N#4	3.76542e-18
C765	VGND	a_897_349#	3.37199e-18
C766	VPWR#1	D_N#5	4.10197e-17
C767	VGND	a_27_368##4	4.50564e-18
C768	A#3	B#2	6.99586e-19
C769	VPWR#2	VPWR#1	9.47412e-19
C770	VGND#17	VNB	3.64919e-17
C771	a_864_48##16	a_1162_48##3	3.02608e-19
C772	a_864_48##3	a_1162_48##5	3.76116e-19
C773	VGND#16	VNB	3.10496e-17
C774	VGND	a_27_368##6	4.51655e-18
C775	VGND#8	VNB	2.85605e-17
C776	VGND#7	VNB	3.04445e-17
C777	VGND#8	B#8	3.58378e-19
C778	VGND#6	VNB	3.01248e-17
C779	VGND#5	VNB	4.51753e-17
C780	VGND#4	VNB	3.34e-17
C781	Y#3	Y#11	5.70645e-19
C782	VPWR#5	VNB	3.34487e-17
C783	a_864_48##3	a_1162_48##4	2.87144e-19
C784	VPWR#2	VNB	2.95065e-17
C785	VPWR#3	C_N	4.72006e-18
C786	VGND	a_27_368##8	2.58526e-18
C787	A#2	B#9	2.20398e-17
C788	a_1162_48##14	VNB	7.21679e-17
C789	VGND#3	C_N	5.22843e-18
C790	VGND#13	Y#4	3.48834e-17
C791	a_864_48##16	VNB	1.61149e-17
C792	VGND#18	VGND#21	1.57663e-18
C793	B	A#8	1.65701e-17
C794	a_1162_48##13	D_N#5	3.76624e-17
C795	a_864_48##3	a_1162_48##3	4.69475e-20
C796	B	A#11	7.86636e-18
C797	Y#9	VNB	2.60443e-18
C798	Y#8	VNB	2.27995e-18
C799	VPWR#3	D_N	2.5994e-18
C800	Y#5	Y#15	2.28307e-18
C801	Y#6	VNB	2.61501e-18
C802	VGND	a_1162_48##6	4.87341e-19
C803	B	A#12	5.43124e-18
C804	Y#5	VNB	5.505e-18
C805	Y#4	VNB	1.5609e-18
C806	VGND	a_864_48##4	1.15064e-18
C807	VGND#3	D_N	2.01908e-18
C808	Y#3	VNB	2.18709e-18
C809	a_864_48##3	a_864_48##6	2.24739e-17
C810	VGND	a_864_48##5	1.07237e-19
C811	B	B#3	2.07974e-18
C812	C_N	D_N#3	1.21864e-17
C813	VGND	a_864_48##7	5.35798e-19
C814	VGND	B#4	5.15925e-19
C815	C_N	C_N#2	2.90465e-17
C816	VGND	B#8	6.81286e-19
C817	Y#6	VGND#14	5.38776e-17
C818	VGND	B#10	2.80736e-20
C819	a_864_48##3	a_864_48##2	1.48917e-17
C820	VPWR#1	D_N#4	2.79067e-18
C821	a_1162_48##16	VNB	2.96319e-17
C822	VGND	A#1	1.34181e-18
C823	a_864_48##13	C_N	1.84525e-17
C824	VGND#10	VNB	8.46279e-18
C825	a_864_48##14	VNB	7.6582e-18
C826	VGND	A#5	8.33815e-20
C827	D_N	D_N#3	1.98696e-17
C828	VPWR#8	D_N#5	6.4272e-19
C829	Y#1	VNB	2.9582e-18
C830	VGND	A#7	3.62398e-20
C831	VGND	A#10	6.38453e-20
C832	D_N	C_N#2	1.10044e-18
C833	VGND#13	VNB	1.17203e-18
C834	Y#15	VNB	5.02444e-18
C835	VGND	B#1	1.26745e-18
C836	VGND#14	VNB	5.61793e-19
C837	a_864_48##3	B#9	1.94897e-20
C838	VGND#15	VNB	4.98624e-20
C839	a_864_48##13	D_N	2.49178e-18
C840	Y#17	VNB	4.94475e-18
C841	VGND#19	VNB	5.87024e-19
C842	a_1162_48#	a_864_48##10	3.38885e-17
C843	VGND#20	VNB	3.59616e-18
C844	VPWR	a_864_48##9	1.53447e-20
C845	VGND#21	VNB	2.8558e-18
C846	VPWR	B#7	3.2124e-18
C847	Y#10	VNB	3.1695e-18
C848	VGND#18	VNB	7.10489e-17
C849	a_864_48##3	B#5	6.3066e-18
C850	VPWR#1	VNB	6.23936e-17
C851	a_1162_48##13	VNB	2.02477e-17
C852	VPWR#8	VNB	4.92861e-18
C853	a_864_48##18	VNB	3.31573e-18
C854	VGND#18	Y#10	7.20035e-17
C855	a_1162_48##13	D_N#4	4.81814e-17
C856	VPWR#9	VNB	1.79217e-18
C857	a_27_368#	VNB	2.20962e-17
C858	VPWR	A#4	1.9199e-18
C859	a_897_349##2	VNB	2.26849e-19
C860	Y#14	VNB	4.98577e-19
C861	VGND#13	Y#3	7.0958e-17
C862	a_1162_48##13	VPWR#2	1.36977e-17
C863	Y#12	VNB	4.41989e-19
C864	VGND#3	Y	2.58546e-18
C865	VPWR	A#11	9.41615e-19
C866	a_27_368##2	VNB	2.1612e-17
C867	a_27_368##4	VNB	5.2985e-18
C868	a_116_368#	VNB	8.56186e-18
C869	B	B#6	1.49619e-18
C870	VPWR	B#3	1.05167e-18
C871	a_116_368##2	VNB	5.12244e-18
C872	VPWR#10	VNB	1.84992e-18
C873	a_116_368##6	VNB	2.16814e-18
C874	B	A#3	7.54087e-17
C875	VPWR#11	VNB	3.32344e-18
C876	a_116_368##5	VNB	2.68384e-18
C877	VPWR	VPWR#3	2.77614e-17
C878	a_27_368##8	VNB	5.51631e-17
C879	D_N#1	VNB	3.62835e-17
C880	B	B#2	3.70898e-19
C881	C_N#4	VNB	4.36998e-17
C882	a_864_48##10	VNB	2.93544e-17
C883	VPWR#1	C_N#1	3.06214e-19
C884	a_1162_48#	VNB	2.62575e-17
C885	VPWR	VPWR#4	1.66243e-16
C886	a_1162_48##8	VNB	2.68208e-17
C887	a_1162_48##10	VNB	2.85814e-17
C888	Y	a_1162_48##2	9.54916e-17
C889	Y#5	VGND#14	1.41102e-17
C890	D_N#4	VPWR#8	1.73123e-17
C891	a_1162_48##6	VNB	2.4575e-17
C892	a_864_48##4	VNB	2.40587e-17
C893	a_864_48##5	VNB	2.57499e-17
C894	a_864_48##7	VNB	2.33973e-17
C895	B#4	VNB	2.34405e-17
C896	B#8	VNB	2.39382e-17
C897	B#10	VNB	2.44946e-17
C898	A#1	VNB	2.49706e-17
C899	A#5	VNB	2.62321e-17
C900	A#7	VNB	2.31382e-17
C901	A#10	VNB	2.57619e-17
C902	Y#6	Y#16	3.54577e-18
C903	B#1	VNB	3.43889e-17
C904	VGND	VGND#9	7.76519e-17
C905	VPWR	a_864_48##3	1.9661e-17
C906	D_N#5	VNB	4.00302e-17
C907	D_N#4	VNB	3.58274e-17
C908	VPWR	B#6	9.33913e-18
C909	C_N#1	VNB	3.50151e-17
C910	C_N#3	VNB	3.1946e-17
C911	a_864_48##12	VNB	4.13347e-17
C912	VPWR	A#3	5.34952e-18
C913	C_N	D_N	3.17853e-17
C914	a_1162_48##7	VNB	3.55431e-17
C915	a_1162_48##9	VNB	3.408e-17
C916	VPWR	B#2	3.8993e-18
C917	a_1162_48##11	VNB	3.30392e-17
C918	a_1162_48##13	C_N#1	3.47528e-18
C919	a_1162_48##12	VNB	3.65255e-17
C920	a_864_48#	VNB	3.45887e-17
C921	VGND	a_864_48##3	8.29617e-18
C922	a_864_48##8	VNB	3.5368e-17
C923	Y#7	VGND#15	1.68069e-17
C924	a_864_48##18	D_N#4	2.70116e-18
C925	a_864_48##9	VNB	3.22569e-17
C926	VGND	B#6	9.60244e-18
C927	B#7	VNB	3.15579e-17
C928	B#11	VNB	3.28962e-17
C929	VGND	A#3	6.78879e-18
C930	B#12	VNB	3.48833e-17
C931	A#4	VNB	3.53735e-17
C932	VGND	B#2	3.97875e-18
C933	A#9	A#6	3.14141e-18
C934	A#8	VNB	3.24248e-17
C935	A#11	VNB	2.76273e-17
C936	A#12	VNB	3.39603e-17
C937	a_1162_48##8	a_1162_48#	7.65867e-18
C938	B#3	VNB	4.24811e-17
C939	VPWR#3	VNB	3.23722e-16
C940	VGND#3	VNB	2.31662e-16
C941	VPWR#4	VNB	9.90639e-17
C942	VGND#16	A#1	2.35153e-18
C943	Y#8	Y#17	2.85613e-18
C944	VGND#9	VNB	3.13052e-17
C945	D_N#3	VNB	8.07395e-17
C946	C_N#2	VNB	5.91378e-17
C947	a_864_48##13	VNB	4.28594e-17
C948	a_1162_48##2	VNB	5.8232e-17
C949	a_864_48##3	VNB	2.39645e-17
C950	VPWR	B	5.92129e-18
C951	B#6	VNB	2.60805e-17
C952	C_N#1	VPWR#8	2.20156e-17
C953	A#3	VNB	3.793e-17
C954	B#2	VNB	7.41003e-17
C955	VGND	B	5.4246e-18
C956	VPWR#9	D_N#4	3.0416e-19
C957	B#6	a_864_48##6	5.48471e-18
C958	C_N	VNB	6.7681e-18
C959	D_N	VNB	7.66275e-18
C960	B	VNB	3.20437e-18
C961	VPWR	VNB	3.2799e-16
C962	VGND	VNB	2.86324e-16
C963	VPWR#6	A#3	1.80766e-20
C964	VGND#3	VGND#2	1.18464e-16
C965	VGND#2	a_1162_48##16	1.80831e-17
C966	VPWR#6	B#3	5.62845e-18
C967	a_897_349##3	a_1162_48##7	6.58319e-19
C968	VPWR#6	VPWR#5	9.1206e-19
C969	VPWR#6	VPWR#10	1.53431e-19
C970	VPWR	VPWR#6	1.0773e-16
C971	VGND#2	a_1162_48##14	3.37078e-17
C972	VPWR#6	B#2	4.51204e-20
C973	a_897_349##3	a_864_48##12	9.48669e-18
C974	VGND#4	VGND#2	4.58403e-19
C975	a_116_368##6	VPWR#6	7.07423e-18
C976	a_897_349##3	a_1162_48##2	8.17998e-19
C977	VGND#2	D_N#3	1.46591e-19
C978	a_897_349##3	C_N#3	1.28234e-19
C979	VGND#2	C_N#2	8.77715e-20
C980	a_864_48##16	a_897_349##3	5.10525e-17
C981	VPWR#6	A#6	3.87355e-20
C982	a_897_349##3	a_897_349##2	4.30818e-18
C983	VGND#2	D_N#1	3.93648e-18
C984	a_116_368##5	VPWR#6	2.09432e-17
C985	VPWR#6	VNB	6.22242e-17
C986	VGND#2	C_N#4	6.98097e-19
C987	VGND#2	VNB	5.72776e-17
C988	a_897_349##3	a_27_368#	2.07278e-17
C989	VPWR#6	A#11	1.7701e-18
C990	a_27_368##8	VPWR#6	2.37533e-17
C991	VGND#2	a_864_48##10	7.52832e-20
C992	VPWR#6	A#12	2.55802e-18
*
*
.ENDS sky130_fd_sc_hs__nor4bb_4
*
