* Extracted by Quantus, converted by sky130cad/quantus.py
*
*
*
*                       LINUX           Wed Nov 18 08:42:50 2026
*
*
*
*  PROGRAM  advgen
*
*  Name           : advgen - Quantus - (64-bit)
*  Version        : 25.1.0-p047
*  Build Date     : Thu Dec 11 23:20:30 PST 2025
*
*  HSPICE LIBRARY
*
*  OPERATING_TEMPERATURE 150
*  QRC_TECH_DIR <path>/tech
*
*
*

*
.SUBCKT sky130_fd_sc_hs__mux2_1 VPB VNB VGND VPWR X A1 A0 S
*
*
*  caps2d version: 10
*
*
*       TRANSISTOR CARDS
*
*
XM7 a_27_112##7 S#5 VGND#7 VNB sky130_fd_pr__nfet_01v8_lvt l=0.15 w=0.55 ad=0.15675 as=0.28915 pd=1.67 ps=2.3
XM5 VGND#7 S#1 a_226_74# VNB sky130_fd_pr__nfet_01v8_lvt l=0.15 w=0.74 ad=0.28915 as=0.1776 pd=2.3 ps=1.96
XM3 a_226_74# A1#1 a_304_74##5 VNB sky130_fd_pr__nfet_01v8_lvt l=0.15 w=0.74 ad=0.1776 as=0.4033 pd=1.96 ps=2.57
XM10 a_304_74##5 A0#1 a_443_74# VNB sky130_fd_pr__nfet_01v8_lvt l=0.15 w=0.74 ad=0.4033 as=0.5994 pd=2.57 ps=3.1
XM2 a_443_74# a_27_112##3 VGND#6 VNB sky130_fd_pr__nfet_01v8_lvt l=0.15 w=0.74 ad=0.5994 as=0.4181 pd=3.1 ps=2.61
XM8 VGND#6 a_304_74# X#1 VNB sky130_fd_pr__nfet_01v8_lvt l=0.15 w=0.74 ad=0.4181 as=0.2109 pd=2.61 ps=2.05
XM0 a_27_112##5 S#6 VPWR#7 VPB sky130_fd_pr__pfet_01v8 l=0.15 w=0.84 ad=0.2478 as=0.3706 pd=2.27 ps=2.77
XM4 VPWR#7 S#4 a_223_368# VPB sky130_fd_pr__pfet_01v8 l=0.15 w=1 ad=0.3706 as=0.815 pd=2.77 ps=3.63
XM9 a_223_368# A0#3 a_304_74##7 VPB sky130_fd_pr__pfet_01v8 l=0.15 w=1 ad=0.815 as=0.39 pd=3.63 ps=2.78
XM1 a_304_74##7 A1#3 a_524_368# VPB sky130_fd_pr__pfet_01v8 l=0.15 w=1 ad=0.39 as=0.42 pd=2.78 ps=2.84
XM6 a_524_368# a_27_112# VPWR#6 VPB sky130_fd_pr__pfet_01v8 l=0.15 w=1 ad=0.42 as=0.5114 pd=2.84 ps=3.18
XM11 VPWR#6 a_304_74##3 X#2 VPB sky130_fd_pr__pfet_01v8 l=0.15 w=1.12 ad=0.5114 as=0.3304 pd=3.18 ps=2.83
*
*
*       RESISTOR AND CAP/DIODE CARDS
*
Rg1	S#1	S#2	397.555725
Rg2	S#2	S#3	55.205994
Rg3	S#2	S#4	415.223511
Rg4	S#3	S#5	346.629700
Rg5	S#3	S#6	371.262421
Rg6	A1#1	A1#2	307.937683
Rg7	A0#1	A0#2	307.937683
Rg8	A0#2	A0#3	457.627838
Rg9	A1#3	A1#4	457.627838
Rg10	a_27_112#	a_27_112##2	413.532104
Rg11	a_27_112##2	a_27_112##3	365.323883
Rg12	a_304_74#	a_304_74##2	353.846649
Rg13	a_304_74##2	a_304_74##3	456.846832
Rf1	S#3	S#8	160.996811
Rf2	S#9	S	0.764007
Rf3	S#8	S#9	5.905091
Rf4	A0#4	A0#2	161.743164
Rf5	A0	A0#6	1.510368
Rf6	A0#4	A0#6	3.882813
Rf7	A1	A1#2	262.848267
Rf8	A1	A1#4	163.775864
Rf9	a_27_112##2	a_27_112##6	503.533997
Rf10	a_27_112##6	a_27_112##7	103.785164
Rf11	a_27_112##5	a_27_112##6	7.500000
Rf12	a_304_74##2	a_304_74##6	314.118591
Rf13	a_304_74##6	a_304_74##7	216.676895
Rf14	a_304_74##5	a_304_74##6	15.000000
Rf15	X#1	X	86.662857
Rf16	X	X#3	10.910419
Rf17	X#3	X	0.149458
Rf18	X#2	X#3	5.000000
Rf20	VPWR#2	VPWR#3	94.941109
Rf21	VPWR#3	VPWR#4	98.228386
Rf23	VPWR#2	VPWR#6	38.286041
Rf24	VPWR#4	VPWR#7	43.955643
Rf26	VGND#2	VGND#3	94.941109
Rf27	VGND#3	VGND#4	98.203995
Rf29	VGND#2	VGND#6	37.066368
Rf30	VGND#4	VGND#8	14.813920
Rf32	VGND#7	VGND#8	7.500000
Re1	VPWR#3	VPWR	1.091357
Re2	VGND	VGND#3	1.091398
*
*       CAPACITOR CARDS
*
*
C1	a_304_74##5	S#2	7.14443e-18
C2	a_27_112##2	S#2	2.05332e-19
C3	VGND#7	S#2	3.1892e-19
C4	a_27_112##7	S#2	3.6546e-19
C5	S#2	A0#2	7.26455e-19
C6	S#2	A1#2	2.86011e-17
C7	VGND#6	X#1	3.18914e-17
C8	S#3	S#2	2.48155e-18
C9	S#8	a_304_74##5	2.15642e-17
C10	VGND#6	a_304_74##5	3.00844e-20
C11	a_27_112##7	S#8	1.37765e-17
C12	A0#6	a_304_74##7	2.31782e-17
C13	A0#4	a_304_74##7	2.50968e-17
C14	X#1	X#2	4.03994e-18
C15	a_304_74##7	S#2	6.92642e-18
C16	S#9	a_304_74##7	1.79604e-17
C17	VGND#7	a_304_74##5	4.36815e-17
C18	a_27_112##7	a_304_74##5	3.25813e-18
C19	S#8	a_304_74##7	4.89397e-18
C20	a_27_112##7	VGND#7	3.0703e-17
C21	A0#6	a_27_112##3	1.29524e-19
C22	a_27_112##5	S#9	3.49131e-17
C23	a_27_112##5	S#8	7.47865e-18
C24	a_304_74##5	a_304_74##7	3.68856e-18
C25	VPWR#7	S#2	4.60869e-20
C26	VPWR#6	X#2	1.01695e-16
C27	X#1	a_304_74#	3.60244e-17
C28	a_304_74#	VGND#6	2.22011e-17
C29	X#1	a_27_112##3	2.09706e-18
C30	a_27_112##3	VGND#6	2.61939e-17
C31	VGND#6	A0#1	7.37835e-19
C32	VGND#7	a_27_112##5	2.01446e-18
C33	a_304_74##5	a_27_112##3	1.297e-19
C34	a_27_112##7	a_27_112##5	2.64452e-18
C35	VGND#6	A1#1	2.77785e-19
C36	a_304_74##5	A0#1	4.65507e-17
C37	VGND#7	a_27_112##3	6.13922e-19
C38	a_304_74##5	A1#1	5.00935e-17
C39	VGND#7	A0#1	1.17083e-18
C40	a_304_74##5	S#1	1.65914e-17
C41	VGND#7	A1#1	2.66997e-18
C42	a_27_112##5	a_304_74##7	6.08013e-17
C43	a_304_74##5	S#5	1.01414e-18
C44	VGND#7	S#1	4.14133e-17
C45	a_27_112##7	S#1	1.12799e-18
C46	a_27_112##5	VPWR#7	1.07411e-16
C47	S#5	VGND#7	1.4296e-17
C48	a_27_112##7	S#5	2.96502e-17
C49	S#9	S#4	1.12393e-18
C50	S#9	S#6	2.03815e-18
C51	a_27_112##3	a_304_74#	1.34171e-17
C52	X#2	a_304_74##3	4.83631e-17
C53	a_304_74##3	VPWR#6	3.65628e-17
C54	X#2	a_27_112#	3.41087e-20
C55	A0#1	a_27_112##3	6.39772e-18
C56	a_27_112#	VPWR#6	3.19088e-17
C57	a_304_74##7	a_27_112#	5.39129e-18
C58	A1#1	A0#1	1.39326e-17
C59	A0#6	a_27_112##2	4.31748e-21
C60	A1#3	a_304_74##7	2.77969e-17
C61	S#1	A1#1	4.73521e-17
C62	a_304_74##7	A0#3	6.92934e-17
C63	a_27_112##5	a_27_112#	8.69216e-20
C64	A0#6	A1#4	4.96721e-18
C65	a_304_74##2	X#1	4.46942e-17
C66	a_304_74##7	S#4	9.97449e-18
C67	a_27_112##5	A1#3	1.62909e-19
C68	VGND#3	a_304_74##5	4.79045e-17
C69	a_304_74##2	VGND#6	7.60887e-17
C70	S#5	S#1	2.16407e-17
C71	VPWR#7	A0#3	4.5803e-19
C72	A0#6	A0#2	6.94483e-18
C73	X#1	a_27_112##2	3.11992e-20
C74	a_304_74##7	S#6	1.93835e-18
C75	a_27_112##5	A0#3	1.90057e-17
C76	VPWR#7	S#4	4.56231e-17
C77	a_304_74##5	a_304_74##2	8.79746e-19
C78	a_27_112##2	VGND#6	3.02861e-18
C79	A0#4	A0#2	1.07915e-17
C80	a_27_112##5	S#4	3.36604e-17
C81	S#6	VPWR#7	2.57473e-17
C82	a_27_112##5	S#6	5.08034e-17
C83	A1#2	A0#4	3.97113e-17
C84	a_304_74##2	X#2	4.86657e-17
C85	a_304_74##5	A1#4	1.54877e-18
C86	a_304_74##2	VPWR#6	2.37324e-17
C87	a_27_112##2	X#2	1.68915e-18
C88	a_27_112##5	VPWR#3	3.98325e-17
C89	S#9	S#3	7.56908e-18
C90	A0#2	a_304_74##5	1.31396e-18
C91	a_27_112#	a_304_74##3	2.32488e-17
C92	a_27_112##2	VPWR#6	1.23202e-16
C93	S#8	S#3	1.58452e-17
C94	A1#2	a_304_74##5	1.00749e-16
C95	a_304_74##7	a_27_112##2	6.26949e-17
C96	A1#3	a_27_112#	2.593e-17
C97	a_304_74##7	A1#4	1.03065e-19
C98	a_304_74##2	a_304_74#	7.12671e-18
C99	a_304_74##5	S#3	6.06461e-19
C100	VGND#3	A0#1	5.70876e-18
C101	a_27_112##5	a_27_112##2	8.90204e-19
C102	a_304_74##2	a_27_112##3	4.2304e-17
C103	A0#3	A1#3	3.0573e-17
C104	a_304_74##7	A0#2	3.54648e-18
C105	a_304_74##2	A0#1	1.19233e-18
C106	a_27_112##7	S#3	5.75668e-18
C107	a_304_74##2	A1#1	1.37624e-19
C108	a_304_74##7	A1#2	5.5106e-17
C109	S#4	A0#3	5.8611e-18
C110	a_304_74##2	S#1	6.65521e-20
C111	a_304_74##7	S#3	4.82198e-20
C112	A0#2	a_27_112##3	3.79838e-19
C113	a_27_112##5	A1#2	2.42487e-18
C114	S#6	S#4	2.73538e-17
C115	VPWR#3	A1#3	3.1941e-18
C116	S#3	VPWR#7	1.58745e-18
C117	VPWR#3	A0#3	3.18356e-18
C118	A1#2	a_27_112##3	1.83575e-19
C119	a_27_112##5	S#3	7.59641e-18
C120	a_27_112##2	a_304_74##3	1.78366e-18
C121	A1#2	A0#1	1.43296e-18
C122	a_304_74##5	a_443_74#	1.17872e-17
C123	A1#2	A1#1	8.92909e-18
C124	a_27_112##2	a_27_112#	3.22541e-17
C125	VGND	S#2	2.05832e-18
C126	S#1	A1#2	6.6066e-18
C127	a_27_112##2	A1#3	3.39848e-17
C128	a_304_74##7	a_223_368#	9.72195e-18
C129	a_27_112##2	A0#3	4.48282e-18
C130	a_27_112##2	S#4	1.16391e-19
C131	a_27_112##5	a_223_368#	1.1523e-17
C132	a_304_74##5	a_226_74#	7.01001e-18
C133	a_27_112##2	VPWR#3	5.05833e-17
C134	a_27_112##3	a_443_74#	2.48824e-17
C135	VPWR#3	A1#4	2.63675e-20
C136	A0#1	a_443_74#	1.45864e-17
C137	a_27_112##2	a_304_74##2	1.1034e-16
C138	VGND#3	A1#4	3.70242e-19
C139	S#2	VNB	2.07679e-17
C140	VPWR#3	A0#2	1.08639e-19
C141	a_27_112#	a_524_368#	2.07193e-17
C142	a_304_74##2	A1#4	4.35609e-19
C143	VGND#3	A0#2	1.59096e-19
C144	VPWR#3	A1#2	7.78719e-20
C145	A1#4	a_27_112##2	3.43175e-17
C146	a_304_74##2	A0#2	2.81113e-21
C147	VGND#3	A1#2	1.40795e-19
C148	A1	A0#6	4.28314e-17
C149	A0#2	a_27_112##2	1.016e-18
C150	A1	A0#4	1.03761e-17
C151	A0#3	a_223_368#	1.34836e-17
C152	A1#1	a_226_74#	8.51001e-18
C153	A0#2	A1#4	3.03097e-17
C154	S#4	a_223_368#	2.28562e-17
C155	S#1	a_226_74#	5.056e-18
C156	A1	a_304_74##5	7.21563e-17
C157	A1#2	A0#2	2.68158e-17
C158	A1	a_304_74##7	6.00929e-18
C159	VPWR	A0#6	1.03676e-18
C160	a_304_74##2	a_443_74#	2.5264e-18
C161	VPWR	A0#4	1.16853e-18
C162	VPWR	S#9	3.20764e-18
C163	A1#4	a_443_74#	2.32507e-18
C164	A1	a_27_112##3	3.25087e-18
C165	A1	A0#1	2.37017e-17
C166	A1	A1#1	3.53351e-19
C167	VGND	A0#6	1.5819e-18
C168	VPWR	X#2	2.23232e-17
C169	VGND	A0#4	2.01566e-18
C170	VPWR	VPWR#6	2.16085e-17
C171	S#9	S#2	2.66933e-19
C172	VGND	S#8	3.55458e-18
C173	VPWR	a_304_74##7	1.54804e-17
C174	VGND	X#1	1.9682e-17
C175	VGND	a_304_74##5	4.86933e-17
C176	VPWR	a_27_112##5	4.69293e-17
C177	VGND	VGND#7	2.21743e-17
C178	S#2	A0#3	4.95127e-19
C179	VGND	a_27_112##7	1.36214e-17
C180	VGND	X#2	1.91982e-18
C181	VGND	VPWR#6	2.14624e-18
C182	A0#6	VNB	1.31615e-18
C183	A0#4	VNB	1.54741e-18
C184	VGND	a_304_74##7	6.38285e-18
C185	S#9	VNB	2.32864e-18
C186	S#8	VNB	4.44426e-18
C187	X#1	VNB	4.89519e-17
C188	VPWR	a_304_74##3	3.70317e-18
C189	A1	a_304_74##2	4.29519e-17
C190	VGND#6	VNB	3.45446e-18
C191	VGND	a_304_74#	2.25763e-18
C192	VPWR	a_27_112#	1.80111e-18
C193	VGND	a_27_112##3	6.60364e-19
C194	a_304_74##5	VNB	6.13424e-20
C195	A1	a_27_112##2	4.60116e-17
C196	VGND	A0#1	7.98371e-19
C197	VGND#7	VNB	8.4393e-18
C198	VGND	A1#1	8.06956e-19
C199	VPWR	A0#3	1.27156e-20
C200	A1	A1#4	2.7567e-17
C201	a_27_112##7	VNB	4.50633e-17
C202	VGND	S#1	1.06118e-18
C203	X#2	VNB	7.83525e-17
C204	VPWR	S#4	2.64634e-18
C205	A1	A0#2	3.46556e-18
C206	VPWR#6	VNB	6.83517e-18
C207	VGND	S#5	7.79466e-18
C208	VPWR	S#6	6.62697e-18
C209	a_304_74##7	VNB	1.20272e-17
C210	A1#2	A1	3.01658e-18
C211	VPWR#7	VNB	6.60476e-18
C212	VPWR	VPWR#3	2.06379e-17
C213	a_27_112##5	VNB	7.76757e-17
C214	a_304_74#	VNB	3.38359e-17
C215	a_27_112##3	VNB	3.03238e-17
C216	VPWR	a_304_74##2	2.99613e-18
C217	A0#1	VNB	2.94564e-17
C218	A1#1	VNB	2.71226e-17
C219	VPWR	a_27_112##2	3.6788e-17
C220	S#1	VNB	3.00823e-17
C221	S#5	VNB	3.86043e-17
C222	a_304_74##3	VNB	3.94508e-17
C223	VGND	VGND#3	2.91961e-17
C224	A1	a_443_74#	5.38615e-18
C225	a_27_112#	VNB	3.48128e-17
C226	VPWR	A1#2	2.0268e-18
C227	VGND	a_304_74##2	1.53117e-17
C228	A1#3	VNB	3.75952e-17
C229	A0#3	VNB	3.41324e-17
C230	VGND	a_27_112##2	4.07181e-18
C231	S#4	VNB	3.57286e-17
C232	VGND	A1#4	3.32079e-19
C233	S#6	VNB	3.96358e-17
C234	VGND	A0#2	3.29866e-19
C235	VPWR#3	VNB	2.25067e-16
C236	VGND	A1#2	6.59497e-18
C237	VGND#3	VNB	2.2669e-16
C238	VGND	S#3	1.07042e-18
C239	a_304_74##2	VNB	5.13641e-17
C240	a_27_112##2	VNB	5.18029e-17
C241	A1#4	VNB	2.58232e-17
C242	A0#2	VNB	2.8971e-17
C243	A1#2	VNB	3.70726e-17
C244	S#3	VNB	4.50009e-17
C245	VPWR	A1	4.99985e-18
C246	VGND	A1	8.83328e-18
C247	A1	VNB	4.22846e-18
C248	VPWR	VNB	8.1422e-17
C249	VGND	VNB	6.44859e-17
C250	VGND#4	S#5	2.40638e-18
C251	VGND#2	A0#1	5.05292e-19
C252	a_27_112##5	VPWR#4	5.22194e-17
C253	VPWR#3	VPWR#4	6.49072e-17
C254	X#2	VPWR#2	2.63081e-17
C255	VGND#8	S#8	2.22551e-17
C256	VGND#2	X#1	2.28257e-17
C257	VGND#4	S#1	9.57165e-19
C258	VGND#8	a_304_74##5	2.53189e-17
C259	VGND#2	a_27_112##3	6.33632e-18
C260	VPWR#2	A1#4	3.12894e-20
C261	VGND#4	S#8	5.74889e-19
C262	VGND#2	a_304_74##2	1.13666e-17
C263	VPWR#2	VNB	5.63034e-17
C264	VPWR#4	A1#2	2.0382e-19
C265	VPWR#4	VNB	6.47518e-17
C266	a_27_112##2	VPWR#2	2.8308e-17
C267	VPWR#4	S#6	3.36471e-18
C268	VPWR#2	a_27_112#	1.70702e-18
C269	VGND#4	a_304_74##5	1.50015e-17
C270	VGND#4	A1#1	5.70876e-18
C271	VGND#2	a_304_74#	8.12743e-18
C272	a_304_74##2	VPWR#2	2.92851e-19
C273	VGND#3	VGND#2	6.61707e-17
C274	VPWR#4	S#4	6.0394e-18
C275	VPWR#2	a_304_74##3	4.63558e-18
C276	a_27_112##7	VGND#8	1.77577e-17
C277	VPWR	VPWR#2	3.93444e-17
C278	VGND#8	S#5	5.10702e-18
C279	VGND#2	VNB	5.97879e-17
C280	VGND#4	VNB	5.80428e-17
C281	VGND#2	a_304_74##5	3.65752e-18
C282	VPWR	VPWR#4	6.20364e-17
C283	VGND#8	VNB	2.81888e-18
C284	VPWR#3	VPWR#2	6.57699e-17
C285	VGND	VGND#2	6.26646e-17
C286	VGND#8	VGND#7	6.44587e-18
C287	VGND#8	S#1	3.55529e-18
C288	VGND#4	a_27_112##7	1.09327e-17
C289	VGND	VGND#4	4.09094e-17
C290	VGND#2	A1#1	1.1265e-19
C291	VGND#8	S#3	6.69956e-18
C292	VGND#3	VGND#4	6.63342e-17
C293	VGND#2	A1#4	7.37106e-20
*
*
.ENDS sky130_fd_sc_hs__mux2_1
*
