* Extracted by Quantus, converted by sky130cad/quantus.py
*
*
*
*                       LINUX           Wed Nov 18 08:03:25 2026
*
*
*
*  PROGRAM  advgen
*
*  Name           : advgen - Quantus - (64-bit)
*  Version        : 25.1.0-p047
*  Build Date     : Thu Dec 11 23:20:30 PST 2025
*
*  HSPICE LIBRARY
*
*  OPERATING_TEMPERATURE 150
*  QRC_TECH_DIR <path>/tech
*
*
*

*
.SUBCKT sky130_fd_sc_hs__a211oi_1 VPB VNB VGND VPWR Y C1 A2 A1 B1
*
*
*  caps2d version: 10
*
*
*       TRANSISTOR CARDS
*
*
XM7 VGND#7 A2#1 a_159_74# VNB sky130_fd_pr__nfet_01v8_lvt l=0.15 w=0.74 ad=0.1961 as=0.1554 pd=2.01 ps=1.9
XM6 a_159_74# A1#3 Y#2 VNB sky130_fd_pr__nfet_01v8_lvt l=0.15 w=0.74 ad=0.1554 as=0.2886 pd=1.9 ps=2.26
XM3 Y#2 B1#3 VGND#6 VNB sky130_fd_pr__nfet_01v8_lvt l=0.15 w=0.74 ad=0.2886 as=0.2886 pd=2.26 ps=2.26
XM4 VGND#6 C1#3 Y#4 VNB sky130_fd_pr__nfet_01v8_lvt l=0.15 w=0.74 ad=0.2886 as=0.1961 pd=2.26 ps=2.01
XM2 a_71_368##2 A2#3 VPWR#4 VPB sky130_fd_pr__pfet_01v8 l=0.15 w=1.12 ad=0.308 as=0.4368 pd=2.79 ps=3.02
XM5 VPWR#4 A1#1 a_71_368# VPB sky130_fd_pr__pfet_01v8 l=0.15 w=1.12 ad=0.4368 as=0.336 pd=3.02 ps=2.84
XM1 a_71_368# B1#1 a_354_368# VPB sky130_fd_pr__pfet_01v8 l=0.15 w=1.12 ad=0.336 as=0.3696 pd=2.84 ps=2.9
XM0 a_354_368# C1#4 Y#1 VPB sky130_fd_pr__pfet_01v8 l=0.15 w=1.12 ad=0.3696 as=0.308 pd=2.9 ps=2.79
*
*
*       RESISTOR AND CAP/DIODE CARDS
*
Rg1	A2#1	A2#2	382.539734
Rg2	A2#2	A2#3	434.639221
Rg3	A1#1	A1#2	434.639221
Rg4	A1#2	A1#3	382.539734
Rg5	B1#1	B1#2	434.639221
Rg6	B1#2	B1#3	382.539734
Rg7	C1#1	C1#2	68.019402
Rg8	C1#2	C1#3	322.953644
Rg9	C1#2	C1#4	507.075531
Rf1	A2#2	A2#5	161.608017
Rf2	A2#6	A2	1.375212
Rf3	A2#5	A2#6	5.294745
Rf4	A1#2	A1	166.137894
Rf5	a_71_368#	a_71_368##2	99.503059
Rf6	B1#2	B1	166.137894
Rf7	Y#1	Y	71.771278
Rf8	Y	Y#3	11.372873
Rf9	Y#3	Y	1.854724
Rf10	Y	Y#4	12.000052
Rf11	Y#2	Y#3	7.500000
Rf12	C1	C1#1	163.775864
Rf14	VGND#2	VGND#3	30.271076
Rf15	VGND#3	VGND#4	68.277679
Rf17	VGND#2	VGND#6	30.902695
Rf18	VGND#4	VGND#7	33.306259
Rf19	VPWR#1	VPWR#2	33.950016
Rf21	VPWR#2	VPWR#4	32.450638
Re1	VPWR#1	VPWR	1.637070
Re2	VGND	VGND#3	1.637131
*
*       CAPACITOR CARDS
*
*
C1	VGND	VNB	7.12451e-17
C2	VPWR	VNB	7.1551e-17
C3	Y	VNB	4.45735e-17
C4	C1	VNB	2.95396e-17
C5	VGND	Y	2.93243e-17
C6	A1	VNB	3.49332e-18
C7	B1	VNB	3.26495e-18
C8	VGND	C1	7.2063e-18
C9	VGND	A1	3.85074e-18
C10	VPWR	C1	5.32694e-18
C11	VGND	B1	2.89013e-18
C12	A2#2	VNB	4.69649e-17
C13	A1#2	VNB	2.86697e-17
C14	Y	C1	3.98629e-17
C15	B1#2	VNB	2.89828e-17
C16	VPWR	A1	2.51368e-18
C17	C1#1	VNB	6.03791e-17
C18	VGND#3	VNB	1.55637e-16
C19	VPWR	B1	5.70703e-18
C20	VPWR#1	VNB	1.96537e-16
C21	Y	A1	2.70617e-17
C22	A2#3	VNB	4.08523e-17
C23	A1#1	VNB	3.07117e-17
C24	Y	B1	1.78003e-17
C25	VGND	A1#2	5.71353e-21
C26	B1#1	VNB	3.46184e-17
C27	C1#4	VNB	4.45052e-17
C28	VGND	C1#1	2.04759e-18
C29	A2#1	VNB	2.7433e-17
C30	A1#3	VNB	2.55936e-17
C31	VGND	VGND#3	1.34119e-17
C32	B1#3	VNB	2.53269e-17
C33	C1#3	VNB	3.3164e-17
C34	B1#3	C1#2	1.82852e-18
C35	a_71_368##2	VNB	4.9993e-17
C36	VPWR#4	VNB	4.61444e-18
C37	a_71_368#	VNB	2.15003e-18
C38	Y#1	VNB	6.38123e-17
C39	VPWR	C1#1	3.37682e-18
C40	VGND#7	VNB	3.94688e-17
C41	Y	A2#2	2.81042e-19
C42	A1	B1	3.02588e-17
C43	Y#2	VNB	5.47238e-18
C44	Y	A1#2	1.76248e-18
C45	VGND#6	VNB	2.19005e-18
C46	VPWR	VPWR#1	4.43578e-17
C47	VGND	A2#1	4.58439e-19
C48	A2#5	VNB	1.2444e-17
C49	Y	B1#2	3.88027e-18
C50	VGND	A1#3	6.79719e-19
C51	VPWR	A2#3	1.2323e-18
C52	A2#6	VNB	1.00573e-17
C53	VGND	B1#3	5.40617e-19
C54	Y	C1#1	6.04134e-18
C55	VGND	C1#3	3.98261e-19
C56	VPWR	A1#1	4.82271e-19
C57	VGND#3	Y	1.0622e-17
C58	VPWR	B1#1	2.27435e-18
C59	VPWR	C1#4	8.35873e-19
C60	C1	C1#1	2.22791e-17
C61	VGND	Y#1	1.99364e-18
C62	VGND	VGND#7	2.09442e-17
C63	VGND	Y#2	1.17137e-17
C64	A1	A2#2	4.0794e-18
C65	VGND	VGND#6	1.90305e-17
C66	C1	VPWR#1	8.6849e-19
C67	A1	A1#2	1.6421e-17
C68	VPWR	a_71_368##2	1.762e-17
C69	VGND	A2#5	4.68706e-18
C70	VPWR	VPWR#4	1.9657e-17
C71	VPWR	a_71_368#	1.73808e-17
C72	A1	B1#2	4.31692e-18
C73	Y	A2#1	1.0584e-17
C74	Y	A1#3	3.69137e-17
C75	B1	A1#2	2.99613e-18
C76	VPWR	Y#1	2.33704e-17
C77	Y	B1#3	8.96646e-19
C78	B1	B1#2	1.57095e-17
C79	VGND#3	A1	2.88938e-19
C80	Y	C1#3	3.72675e-17
C81	VPWR	A2#6	2.73316e-18
C82	A1	A2#3	8.58454e-19
C83	Y	Y#1	2.73973e-18
C84	B1	VPWR#1	1.06442e-18
C85	VGND#7	Y	3.46006e-17
C86	A1	A1#1	1.96303e-18
C87	A1	B1#1	4.88561e-19
C88	Y	Y#2	3.61508e-18
C89	Y	VGND#6	4.69359e-17
C90	B1#2	a_354_368#	2.94601e-19
C91	Y	Y#4	3.46792e-18
C92	B1	A1#1	6.79868e-19
C93	Y#1	C1	1.81253e-17
C94	B1	B1#1	4.6395e-18
C95	A2#2	A1#2	3.54791e-17
C96	B1	C1#4	1.43074e-18
C97	A1#2	B1#2	3.46081e-17
C98	A1	a_71_368#	3.27056e-17
C99	A2#1	a_159_74#	1.596e-17
C100	A1#3	a_159_74#	1.50905e-17
C101	VGND#3	A1#2	8.43964e-20
C102	C1#2	VNB	2.19916e-17
C103	C1#4	a_354_368#	2.55339e-17
C104	B1	a_71_368#	1.74472e-17
C105	Y#2	A1	1.08327e-17
C106	VPWR#1	B1#2	1.28942e-19
C107	B1	Y#1	2.91237e-17
C108	B1#2	C1#2	3.28972e-17
C109	A2#5	A1	2.04246e-17
C110	VPWR#1	C1#1	1.44383e-18
C111	Y#2	B1	3.49427e-17
C112	A2#6	A1	1.63245e-17
C113	B1#2	C1#4	2.65878e-18
C114	Y#1	a_354_368#	3.13098e-19
C115	VPWR#1	A1#1	1.60161e-18
C116	A2#2	a_71_368##2	3.15925e-18
C117	VGND	C1#2	1.32832e-18
C118	VPWR#1	B1#1	7.80173e-18
C119	VPWR#1	C1#4	5.35905e-18
C120	A2#3	A1#1	3.18075e-17
C121	A1#2	VPWR#4	1.54111e-18
C122	a_71_368#	A1#2	4.09176e-18
C123	VGND#3	A1#3	4.67126e-18
C124	VGND#7	A2#2	3.61793e-18
C125	VGND#3	B1#3	8.18235e-19
C126	A1#1	B1#1	4.61701e-17
C127	Y#1	B1#2	2.88431e-18
C128	B1#1	C1#4	4.14208e-17
C129	Y#2	A1#2	1.99477e-18
C130	A2#5	A2#2	1.33357e-17
C131	Y#1	C1#1	6.31247e-18
C132	A2#6	A2#2	7.39692e-18
C133	Y#2	B1#2	1.81267e-18
C134	A2#5	A1#2	3.55555e-18
C135	a_71_368#	VPWR#1	1.93756e-17
C136	VGND#6	B1#2	7.54884e-19
C137	a_71_368##2	A2#3	5.8327e-17
C138	A2#6	A1#2	1.93158e-18
C139	Y#1	VPWR#1	3.19887e-17
C140	A2#3	VPWR#4	3.97661e-17
C141	a_71_368##2	A1#1	8.39181e-19
C142	C1#1	Y#4	3.07207e-19
C143	VGND#3	Y#2	1.11573e-17
C144	a_71_368#	A2#3	8.49563e-19
C145	A1#1	VPWR#4	3.21011e-17
C146	Y	C1#2	1.02115e-17
C147	A2#1	A1#3	6.27433e-17
C148	a_71_368#	A1#1	6.41098e-17
C149	VPWR#4	B1#1	1.24693e-18
C150	Y#1	A2#3	6.42108e-19
C151	VPWR#1	C1#2	1.72158e-20
C152	a_71_368#	B1#1	5.12718e-17
C153	VPWR#4	C1#4	9.27084e-19
C154	Y#1	A1#1	8.49992e-19
C155	A1#3	B1#3	2.34018e-17
C156	a_71_368#	C1#4	7.42292e-18
C157	Y#1	B1#1	1.5398e-17
C158	B1#3	C1#3	2.28242e-17
C159	Y#1	C1#4	6.07666e-17
C160	A2#6	A2#3	2.83811e-18
C161	Y#1	C1#2	5.59131e-18
C162	VGND#7	A2#1	4.54103e-17
C163	A2#6	A1#1	5.71284e-19
C164	a_71_368##2	VPWR#4	8.47031e-17
C165	VGND#7	A1#3	8.84143e-18
C166	a_71_368##2	a_71_368#	2.67264e-18
C167	VGND#7	B1#3	4.10105e-19
C168	VGND#6	A2#1	7.39524e-19
C169	a_71_368#	VPWR#4	7.90583e-17
C170	A1#3	Y#2	1.81025e-17
C171	VGND#6	A1#3	1.5186e-18
C172	Y#2	B1#3	3.77249e-17
C173	VGND#7	a_71_368##2	4.25696e-18
C174	VGND#6	B1#3	3.36758e-17
C175	Y#2	C1#3	8.1723e-19
C176	a_71_368#	Y#1	4.51496e-17
C177	C1#3	VGND#6	2.37562e-17
C178	C1#3	Y#4	6.9947e-18
C179	Y#2	a_71_368#	6.78167e-18
C180	A2#6	a_71_368##2	4.7146e-17
C181	B1	C1#2	3.47339e-18
C182	VGND#7	VGND#6	8.30477e-19
C183	VGND#7	A2#5	2.47746e-17
C184	Y#2	VGND#6	4.74261e-17
C185	VGND#2	VNB	5.21211e-17
C186	VGND#2	Y	2.14975e-17
C187	VGND#4	VNB	4.56469e-17
C188	VPWR	VPWR#2	3.99694e-17
C189	VGND#2	B1#3	9.70787e-20
C190	VGND#3	VGND#4	4.45187e-17
C191	VGND#4	A2#1	3.85188e-18
C192	a_71_368#	VPWR#2	2.05812e-19
C193	VPWR#2	VNB	5.23549e-17
C194	VGND#2	C1#1	1.23602e-18
C195	VGND#2	Y#2	3.28689e-20
C196	a_71_368##2	VPWR#2	2.0924e-17
C197	VGND#4	A1	3.73801e-19
C198	VGND	VGND#2	3.73894e-17
C199	VGND#2	C1	2.63477e-18
C200	VPWR#2	A2#2	4.50366e-20
C201	VPWR#2	A2#3	2.57874e-18
C202	VGND	VGND#4	3.49502e-17
C203	VGND#4	A2#5	7.24149e-19
C204	VGND#2	C1#3	5.43193e-18
C205	VGND#2	C1#2	4.84351e-20
C206	VGND#4	A1#3	2.40252e-18
C207	VPWR#1	VPWR#2	5.35723e-17
C208	VGND#3	VGND#2	5.53749e-17
C209	VGND#4	VGND#2	5.32511e-19
C210	VPWR#2	A1#1	1.20695e-18
*
*
.ENDS sky130_fd_sc_hs__a211oi_1
*
