* Extracted by Quantus, converted by sky130cad/quantus.py
*
*
*
*                       LINUX           Wed Nov 18 08:23:07 2026
*
*
*
*  PROGRAM  advgen
*
*  Name           : advgen - Quantus - (64-bit)
*  Version        : 25.1.0-p047
*  Build Date     : Thu Dec 11 23:20:30 PST 2025
*
*  HSPICE LIBRARY
*
*  OPERATING_TEMPERATURE 150
*  QRC_TECH_DIR <path>/tech
*
*
*

*
.SUBCKT sky130_fd_sc_hs__clkdlyinv3sd2_1 VPB VNB VGND VPWR Y A
*
*
*  caps2d version: 10
*
*
*       TRANSISTOR CARDS
*
*
XM1 a_28_74##7 A#3 VGND#7 VNB sky130_fd_pr__nfet_01v8_lvt l=0.15 w=0.42 ad=0.1113 as=0.2961 pd=1.37 ps=2.25
XM4 VGND#7 a_28_74# a_288_74##6 VNB sky130_fd_pr__nfet_01v8_lvt l=0.18 w=0.42 ad=0.2961 as=0.1113 pd=2.25 ps=1.37
XM3 VGND#6 a_288_74##3 Y#3 VNB sky130_fd_pr__nfet_01v8_lvt l=0.15 w=0.42 ad=0.1113 as=0.1113 pd=1.37 ps=1.37
XM2 a_28_74##5 A#1 VPWR#7 VPB sky130_fd_pr__pfet_01v8 l=0.15 w=1.12 ad=0.3136 as=0.6568 pd=2.8 ps=3.49
XM5 VPWR#7 a_28_74##4 a_288_74##7 VPB sky130_fd_pr__pfet_01v8 l=0.25 w=1 ad=0.6568 as=0.26 pd=3.49 ps=2.52
XM0 VPWR#6 a_288_74# Y#1 VPB sky130_fd_pr__pfet_01v8 l=0.15 w=1.12 ad=0.308 as=0.3136 pd=2.79 ps=2.8
*
*
*       RESISTOR AND CAP/DIODE CARDS
*
Rg1	A#1	A#2	505.110291
Rg2	A#2	A#3	382.539764
Rg3	a_28_74#	a_28_74##2	318.793396
Rg4	a_28_74##2	a_28_74##3	172.287720
Rg5	a_28_74##2	a_28_74##4	289.968964
Rg6	a_288_74#	a_288_74##2	467.246124
Rg7	a_288_74##2	a_288_74##3	455.213867
Rf1	A	A#4	3.280892
Rf2	A#5	A#2	163.513702
Rf3	A#4	A#5	1.266811
Rf4	A	A#7	3.280892
Rf5	A#5	A#7	6.545189
Rf6	a_28_74##5	a_28_74##3	99.886612
Rf7	a_28_74##3	a_28_74##7	87.592514
Rf8	a_288_74##2	a_288_74##5	187.949219
Rf9	a_288_74##5	a_288_74##6	60.177593
Rf10	a_288_74##5	a_288_74##7	17.895864
Rf11	Y	Y#2	0.271759
Rf12	Y#2	Y	13.135041
Rf13	Y	Y#4	15.111293
Rf14	Y#4	Y	1.268211
Rf15	Y#1	Y#2	5.000000
Rf16	Y#3	Y#4	15.000000
Rf18	VPWR#2	VPWR#3	48.188797
Rf19	VPWR#3	VPWR#4	51.110813
Rf21	VPWR#2	VPWR#6	38.384460
Rf22	VPWR#4	VPWR#7	30.944223
Rf24	VGND#2	VGND#3	48.188797
Rf25	VGND#3	VGND#4	50.380310
Rf27	VGND#2	VGND#6	34.704330
Rf28	VGND#4	VGND#7	33.916985
Re1	VPWR	VPWR#3	1.814012
Re2	VGND	VGND#3	1.814012
*
*       CAPACITOR CARDS
*
*
C1	VGND	VNB	2.00319e-16
C2	VPWR	VNB	1.92559e-16
C3	Y	VNB	9.18806e-17
C4	A	VNB	1.91191e-17
C5	VGND	Y	1.1615e-18
C6	A#2	VNB	6.59963e-17
C7	VPWR	Y	2.46636e-17
C8	a_28_74##3	VNB	9.00534e-17
C9	a_288_74##2	VNB	5.62012e-17
C10	VPWR	A	5.56552e-18
C11	VGND#3	VNB	1.89328e-17
C12	VPWR#3	VNB	1.87261e-17
C13	VGND	A#2	6.43288e-18
C14	A#1	VNB	5.75786e-17
C15	VGND	a_28_74##3	1.31006e-17
C16	a_28_74##4	VNB	6.13506e-17
C17	a_288_74#	VNB	3.87981e-17
C18	VGND	a_288_74##2	4.61402e-18
C19	VGND	VGND#3	3.31176e-17
C20	A#3	VNB	3.79862e-17
C21	a_28_74#	VNB	3.59262e-17
C22	a_288_74##3	VNB	4.46985e-17
C23	VPWR	a_28_74##3	9.63854e-18
C24	a_28_74##5	VNB	3.55693e-17
C25	VPWR#7	VNB	5.50953e-18
C26	VPWR	a_288_74##2	3.53087e-18
C27	a_288_74##7	VNB	4.92081e-18
C28	VPWR#6	VNB	9.89739e-18
C29	Y#1	VNB	2.03372e-17
C30	Y	a_28_74##3	2.04601e-18
C31	a_28_74##7	VNB	3.80407e-17
C32	VPWR	VPWR#3	3.62539e-17
C33	VGND#7	VNB	2.36614e-18
C34	VGND	A#3	1.08819e-18
C35	A	A#2	7.92757e-18
C36	a_288_74##6	VNB	1.07686e-17
C37	a_288_74##2	Y	6.11558e-17
C38	VGND#6	VNB	6.99608e-18
C39	VGND	a_28_74#	5.82204e-18
C40	VPWR	A#1	1.30244e-18
C41	Y#3	VNB	2.64043e-17
C42	VGND	a_288_74##3	1.97503e-18
C43	A	a_28_74##3	2.84713e-17
C44	A#5	VNB	7.31546e-18
C45	VPWR	a_28_74##4	5.90104e-18
C46	VPWR	a_288_74#	4.57891e-18
C47	a_288_74##5	VNB	2.00477e-17
C48	VGND	VPWR#6	4.04438e-18
C49	VGND	a_28_74##7	1.87578e-17
C50	Y	a_28_74##4	3.81835e-19
C51	VGND	VGND#7	1.50108e-17
C52	VGND	a_288_74##6	1.8798e-17
C53	Y	a_288_74#	2.03931e-17
C54	VPWR	a_28_74##5	1.62672e-17
C55	A	A#1	8.02207e-18
C56	VPWR	VPWR#7	2.27528e-17
C57	VGND	Y#3	2.08377e-17
C58	VPWR	a_288_74##7	1.70358e-17
C59	A	a_28_74##4	9.3706e-19
C60	VPWR	VPWR#6	1.99623e-17
C61	Y	a_28_74#	8.16148e-19
C62	A#2	a_28_74##3	6.45745e-17
C63	Y	a_288_74##3	7.14369e-18
C64	VGND	a_288_74##5	4.35632e-18
C65	VPWR#6	Y	6.0904e-17
C66	a_28_74##3	a_288_74##2	7.90296e-18
C67	Y	Y#1	8.79026e-18
C68	A	a_28_74##5	5.8611e-17
C69	VGND#3	a_28_74##3	2.3186e-18
C70	A	VPWR#7	3.29202e-19
C71	a_288_74##6	Y	3.9842e-18
C72	a_28_74##3	VPWR#3	1.22697e-18
C73	VPWR	a_288_74##5	1.98962e-18
C74	Y#3	Y	5.468e-19
C75	A#1	a_28_74##3	6.53945e-18
C76	a_28_74##3	a_28_74##4	2.20418e-17
C77	a_288_74##5	Y	1.07868e-17
C78	a_28_74##3	a_288_74#	1.67826e-18
C79	A#3	a_28_74##3	2.85271e-19
C80	a_28_74##5	A#2	1.74609e-18
C81	a_28_74##3	a_28_74#	8.47231e-18
C82	VPWR#3	a_28_74##4	1.0927e-17
C83	VPWR#7	A#2	6.29041e-19
C84	a_28_74##3	a_288_74##3	1.39268e-18
C85	a_28_74##3	a_28_74##5	7.24492e-18
C86	a_28_74##3	VPWR#7	3.35838e-18
C87	A#1	a_28_74##4	1.42725e-17
C88	VGND#3	a_28_74#	6.89572e-18
C89	a_28_74##7	A#2	6.21166e-17
C90	VGND#7	A#2	8.77831e-19
C91	a_28_74##4	a_288_74#	7.36189e-18
C92	a_288_74##2	VPWR#6	2.54752e-17
C93	VGND#7	a_28_74##3	2.26944e-17
C94	a_28_74##3	a_288_74##6	1.76089e-17
C95	A#5	A#2	1.02069e-17
C96	a_288_74##7	VPWR#3	1.19857e-17
C97	a_28_74##5	A#1	4.30511e-17
C98	VGND#6	a_288_74##2	1.48519e-17
C99	A#5	a_28_74##3	1.43758e-17
C100	A#1	VPWR#7	4.51613e-17
C101	VGND#3	a_288_74##6	1.71263e-17
C102	a_28_74##5	a_28_74##4	1.84296e-18
C103	a_288_74##7	A#1	3.57585e-18
C104	a_28_74##4	VPWR#7	3.29205e-17
C105	a_28_74##5	a_288_74#	2.99955e-19
C106	VPWR#6	A#1	5.26472e-19
C107	A#3	a_28_74#	6.93519e-18
C108	a_288_74##7	a_28_74##4	3.63732e-17
C109	a_28_74##3	a_288_74##5	1.29221e-16
C110	VPWR#7	a_288_74#	9.75577e-19
C111	VPWR#6	a_28_74##4	5.44922e-18
C112	a_288_74##7	a_288_74#	2.07773e-18
C113	a_28_74#	a_288_74##3	4.67737e-18
C114	VPWR#6	a_288_74#	5.22686e-17
C115	a_288_74##5	a_288_74##2	1.99513e-18
C116	a_288_74#	Y#1	1.11868e-17
C117	a_28_74##5	VPWR#7	7.21519e-17
C118	a_28_74##7	A#3	4.00636e-17
C119	a_28_74##5	a_288_74##7	3.50209e-19
C120	A#3	VGND#7	2.1631e-17
C121	a_28_74##7	a_28_74#	1.7208e-18
C122	VPWR#7	a_288_74##7	1.76183e-17
C123	a_288_74##6	A#3	3.0678e-18
C124	a_28_74#	VGND#7	1.60993e-17
C125	a_28_74##7	a_288_74##3	2.91419e-19
C126	VGND#6	A#3	1.75263e-19
C127	VPWR#7	VPWR#6	2.37098e-18
C128	a_288_74##5	A#1	5.91513e-19
C129	a_288_74##6	a_28_74#	1.65695e-17
C130	VGND#7	a_288_74##3	5.337e-19
C131	a_28_74##7	a_28_74##5	1.1762e-19
C132	a_288_74##7	VPWR#6	4.77996e-17
C133	VGND#6	a_28_74#	1.71822e-18
C134	a_288_74##6	a_288_74##3	3.91311e-18
C135	a_288_74##5	a_28_74##4	9.97838e-18
C136	Y#3	a_28_74#	5.8197e-19
C137	VGND#6	a_288_74##3	3.69332e-17
C138	VPWR#6	Y#1	4.14983e-17
C139	a_288_74##5	a_288_74#	2.55726e-18
C140	Y#3	a_288_74##3	1.38724e-17
C141	a_28_74##7	VGND#7	4.43527e-17
C142	a_28_74##7	a_288_74##6	1.50063e-18
C143	a_288_74##5	a_288_74##3	6.13679e-19
C144	VGND#7	a_288_74##6	1.17317e-17
C145	a_28_74##5	a_288_74##5	1.16498e-18
C146	VGND#7	VGND#6	9.52172e-19
C147	a_288_74##6	VGND#6	3.5724e-17
C148	a_288_74##6	Y#3	2.22946e-18
C149	a_288_74##5	a_288_74##7	4.27803e-18
C150	VGND#6	Y#3	3.5506e-17
C151	a_288_74##5	VPWR#6	3.86576e-17
C152	VGND#2	a_288_74##2	4.88605e-19
C153	a_288_74##2	VPWR#2	2.74607e-19
C154	VPWR#4	VPWR#2	4.25267e-19
C155	a_288_74##7	VPWR#2	1.34866e-18
C156	Y	VPWR#2	3.28847e-17
C157	VPWR#2	a_288_74#	4.55309e-18
C158	VPWR#7	VPWR#2	9.14125e-20
C159	VGND#4	VGND#2	7.1065e-19
C160	VPWR	VPWR#2	7.48845e-17
C161	VGND#2	a_288_74##3	6.9653e-18
C162	VGND#4	a_28_74##3	3.02103e-18
C163	VGND#2	a_28_74#	9.91713e-19
C164	VPWR	VPWR#4	7.61655e-17
C165	VGND#4	a_28_74##7	2.46863e-17
C166	VGND#2	A#3	6.56088e-20
C167	a_28_74##3	VPWR#4	1.5999e-18
C168	VGND#2	Y#3	2.253e-17
C169	VPWR#2	VNB	4.6209e-17
C170	VPWR#4	VNB	4.66763e-17
C171	VGND#4	a_288_74##3	5.70416e-20
C172	VGND	VGND#2	9.75822e-17
C173	VGND#7	VGND#2	1.32908e-20
C174	VGND#4	a_28_74#	1.27177e-18
C175	VPWR#4	A#1	1.11819e-18
C176	VGND	VGND#4	7.70896e-17
C177	VGND#2	VNB	4.83548e-17
C178	VGND#4	A#3	4.84508e-18
C179	a_28_74##5	VPWR#4	9.48505e-18
C180	VGND#4	VNB	4.67876e-17
C181	a_288_74##5	VPWR#2	4.91947e-19
C182	VGND#2	a_288_74##5	1.39269e-18
*
*
.ENDS sky130_fd_sc_hs__clkdlyinv3sd2_1
*
