* Extracted by Quantus, converted by sky130cad/quantus.py
*
*
*
*                       LINUX           Wed Nov 18 08:58:12 2026
*
*
*
*  PROGRAM  advgen
*
*  Name           : advgen - Quantus - (64-bit)
*  Version        : 25.1.0-p047
*  Build Date     : Thu Dec 11 23:20:30 PST 2025
*
*  HSPICE LIBRARY
*
*  OPERATING_TEMPERATURE 150
*  QRC_TECH_DIR <path>/tech
*
*
*

*
.SUBCKT sky130_fd_sc_hs__o22a_1 VNB VPB VGND VPWR X B2 B1 A2 A1
*
*
*  caps2d version: 10
*
*
*       TRANSISTOR CARDS
*
*
XM8 X#3 a_83_260##3 VGND#7 VNB sky130_fd_pr__nfet_01v8_lvt l=0.15 w=0.74 ad=0.2109 as=0.2109 pd=2.05 ps=2.05
XM9 a_299_139##4 B1#4 a_83_260##6 VNB sky130_fd_pr__nfet_01v8_lvt l=0.15 w=0.64 ad=0.1705 as=0.2048 pd=1.85 ps=1.92
XM7 a_83_260##6 B2#2 a_299_139##2 VNB sky130_fd_pr__nfet_01v8_lvt l=0.15 w=0.64 ad=0.2048 as=0.1792 pd=1.92 ps=1.84
XM6 a_299_139##2 A2#3 VGND#6 VNB sky130_fd_pr__nfet_01v8_lvt l=0.15 w=0.64 ad=0.1792 as=0.289475 pd=1.84 ps=2.25
XM2 VGND#6 A1#1 a_299_139# VNB sky130_fd_pr__nfet_01v8_lvt l=0.15 w=0.64 ad=0.289475 as=0.18205 pd=2.25 ps=1.85
XM0 X#1 a_83_260##4 VPWR#3 VPB sky130_fd_pr__pfet_01v8 l=0.15 w=1.12 ad=0.3304 as=1.2918 pd=2.83 ps=4.76
XM3 VPWR#3 B1#1 a_398_392# VPB sky130_fd_pr__pfet_01v8 l=0.15 w=1 ad=1.2918 as=0.27 pd=4.76 ps=2.54
XM1 a_398_392# B2#1 a_83_260##5 VPB sky130_fd_pr__pfet_01v8 l=0.15 w=1 ad=0.27 as=0.3 pd=2.54 ps=2.6
XM4 a_83_260##5 A2#1 a_572_392# VPB sky130_fd_pr__pfet_01v8 l=0.15 w=1 ad=0.3 as=0.39 pd=2.6 ps=2.78
XM5 a_572_392# A1#3 VPWR#1 VPB sky130_fd_pr__pfet_01v8 l=0.15 w=1 ad=0.39 as=0.295 pd=2.78 ps=2.59
*
*
*       RESISTOR AND CAP/DIODE CARDS
*
Rg1	a_83_260#	a_83_260##2	32.582375
Rg2	a_83_260##2	a_83_260##3	368.862610
Rg3	a_83_260##2	a_83_260##4	471.862823
Rg4	B1#1	B1#2	419.763397
Rg5	B1#2	B1#3	30.596947
Rg6	B1#2	B1#4	325.456085
Rg7	B2#1	B2#2	766.568787
Rg8	B2#2	B2#3	279.244598
Rg9	A2#1	A2#2	400.207520
Rg10	A2#2	A2#3	293.591156
Rg11	A1#1	A1#2	319.414948
Rg12	A1#2	A1#3	400.207520
Rf1	X	X#2	0.181173
Rf2	X#2	X	13.225628
Rf3	X	X#3	88.968201
Rf4	X#1	X#2	5.000000
Rf5	B1#3	B1	80.510071
Rf6	B2#3	B2	203.221664
Rf7	a_83_260##5	a_83_260##7	100.087173
Rf8	a_83_260##7	a_83_260#	174.440796
Rf9	a_83_260##6	a_83_260##7	15.000000
Rf10	A2#2	A2	167.712585
Rf11	A1	A1#2	168.106262
Rf12	a_299_139#	a_299_139##3	101.949905
Rf13	a_299_139##3	a_299_139##4	77.408112
Rf14	a_299_139##2	a_299_139##3	15.000000
Rf15	VPWR#1	VPWR#2	150.749374
Rf16	VPWR#2	VPWR#3	10.844586
Rf19	VGND#2	VGND#3	82.882095
Rf20	VGND#3	VGND#4	88.366570
Rf22	VGND#2	VGND#6	42.187916
Rf23	VGND#4	VGND#7	31.534731
Re1	VPWR#2	VPWR	1.227783
Re2	VGND	VGND#3	1.227829
*
*       CAPACITOR CARDS
*
*
C1	a_83_260##2	B1#3	1.79882e-17
C2	a_83_260##6	a_83_260##2	2.63538e-19
C3	a_83_260#	a_83_260##2	3.18867e-17
C4	a_299_139#	VGND#6	6.21762e-17
C5	VGND#7	a_83_260##2	5.39885e-18
C6	a_299_139##2	a_299_139#	2.43249e-18
C7	a_299_139##2	VGND#6	2.83964e-17
C8	a_299_139##2	a_83_260##6	4.32409e-17
C9	X#3	a_83_260##2	4.46737e-18
C10	a_299_139##2	a_299_139##4	4.27143e-19
C11	a_83_260##6	a_299_139##4	4.41953e-17
C12	VGND#7	a_299_139##2	2.75572e-20
C13	VGND#7	a_299_139##4	7.44185e-18
C14	X#3	a_83_260##6	5.76716e-20
C15	X#3	VGND#7	5.21925e-17
C16	a_299_139##2	a_83_260##5	2.19054e-18
C17	a_299_139#	A1#1	4.21287e-17
C18	A1#1	VGND#6	2.4875e-17
C19	a_299_139#	A2#3	1.6733e-18
C20	a_299_139##2	A1#1	9.0379e-19
C21	a_83_260##5	VPWR#1	2.72621e-17
C22	A2#3	VGND#6	2.20214e-17
C23	a_83_260##6	A1#1	5.43983e-19
C24	a_299_139##2	A2#3	4.43503e-17
C25	VGND#6	B2#2	8.25074e-19
C26	a_83_260##6	A2#3	2.48077e-18
C27	a_299_139##2	B2#2	2.84924e-17
C28	VPWR#3	VPWR#1	6.01486e-19
C29	VGND#6	B1#4	5.71666e-19
C30	a_83_260##6	B2#2	2.76856e-17
C31	a_299_139##2	B1#4	1.08298e-18
C32	VGND#7	A2#3	1.56863e-19
C33	VPWR#3	a_83_260##5	6.05447e-17
C34	a_83_260##6	B1#4	3.20039e-17
C35	a_299_139##2	a_83_260##3	5.29639e-19
C36	VGND#7	B2#2	2.29102e-19
C37	a_299_139##4	B1#4	3.44219e-17
C38	X#3	B2#2	2.59516e-19
C39	VGND#7	B1#4	1.66107e-18
C40	a_299_139##4	a_83_260##3	2.49931e-18
C41	X#3	B1#4	7.40691e-19
C42	VGND#7	a_83_260##3	5.04774e-17
C43	X#1	VPWR#3	4.60239e-17
C44	X#3	a_83_260##3	2.20829e-17
C45	VPWR#3	a_83_260##2	1.16838e-17
C46	B1	a_83_260##2	4.53466e-18
C47	a_83_260##6	B2#1	1.70613e-18
C48	A2#3	A1#1	1.86201e-17
C49	VPWR#1	A1#3	5.33783e-17
C50	VPWR#1	A2#1	1.29242e-17
C51	a_83_260##5	A1#3	1.06563e-17
C52	B2#2	A2#3	3.18275e-17
C53	VPWR#1	B2#1	2.80151e-19
C54	B2	a_83_260##2	1.86906e-18
C55	a_83_260##5	A2#1	6.09519e-17
C56	VPWR#3	A1#3	3.95247e-19
C57	VPWR#1	B1#1	3.41172e-19
C58	B1#4	B2#2	2.57843e-17
C59	a_83_260##5	B2#1	6.49915e-17
C60	VPWR#3	A2#1	5.61125e-18
C61	a_83_260##5	B1#1	1.24899e-17
C62	a_299_139#	A1#2	2.86821e-17
C63	VPWR#3	B2#1	1.16552e-17
C64	a_83_260##3	B1#4	2.56282e-18
C65	a_83_260##5	a_83_260##4	3.78047e-19
C66	VPWR#3	B1#1	8.47608e-17
C67	a_299_139#	A2#2	1.20399e-17
C68	X	a_83_260##2	6.86739e-18
C69	a_83_260##6	A1#2	1.9969e-19
C70	X#1	B1#1	3.4473e-19
C71	A2#2	VGND#6	2.53186e-18
C72	a_83_260##4	VPWR#3	7.19871e-17
C73	a_299_139##2	A2#2	1.52206e-17
C74	X#1	a_83_260##4	2.33434e-17
C75	a_83_260##6	A2#2	1.57892e-18
C76	B2#3	VGND#6	1.60131e-17
C77	B2#3	a_299_139##2	3.6996e-17
C78	A1#2	VPWR#1	1.9995e-17
C79	a_83_260##6	B2#3	7.9724e-19
C80	B2#3	a_299_139##4	2.91328e-17
C81	A2#2	VPWR#1	1.06567e-18
C82	a_83_260##5	A1#2	1.33968e-19
C83	VGND#7	B2#3	4.9117e-19
C84	A2#1	A1#3	3.3191e-17
C85	a_83_260##6	B1#3	6.67809e-18
C86	a_299_139##4	B1#3	1.51158e-18
C87	a_83_260##5	A2#2	7.97867e-19
C88	a_83_260#	a_83_260##6	1.67563e-18
C89	B2#1	A2#1	4.12912e-17
C90	a_83_260#	a_299_139##4	7.67499e-18
C91	a_83_260##5	B2#3	7.77264e-19
C92	A2#2	VPWR#3	2.33603e-19
C93	a_83_260#	VGND#7	2.70584e-17
C94	A2#3	A1#2	7.69944e-19
C95	X#3	a_83_260#	2.20321e-17
C96	VGND#3	B1#4	9.164e-19
C97	B1#1	B2#1	5.40815e-17
C98	a_83_260##5	B1#3	1.59718e-18
C99	VPWR#3	B1#3	1.34182e-17
C100	B2#3	A1#1	2.42955e-18
C101	B2#2	A2#2	1.3808e-17
C102	a_83_260##4	B1#1	2.94003e-18
C103	B2#3	A2#3	1.31457e-17
C104	VGND	a_83_260##2	4.1342e-19
C105	a_83_260#	VPWR#3	4.16606e-17
C106	B2#3	B1#4	2.62271e-17
C107	B1#3	B2#2	1.38815e-17
C108	a_83_260##3	B2#3	7.49093e-19
C109	a_83_260#	B2#2	7.7725e-20
C110	a_83_260#	B1#4	2.92132e-19
C111	a_83_260##5	a_398_392#	2.16431e-18
C112	B2#1	A2#2	1.35293e-17
C113	a_83_260##2	B1#4	2.60332e-18
C114	a_83_260#	a_83_260##3	1.73763e-18
C115	A1	a_299_139#	2.43342e-17
C116	B1#3	B2#1	1.2664e-17
C117	a_83_260##4	B1#3	1.47975e-18
C118	a_299_139##2	A2	2.12433e-17
C119	A1	VPWR#1	2.64258e-17
C120	a_83_260##6	A2	2.35241e-17
C121	A1#3	a_572_392#	3.10318e-17
C122	A2#2	A1#2	5.30674e-17
C123	A2#1	a_572_392#	3.05556e-17
C124	VGND#3	B2#3	5.67124e-17
C125	VGND#3	B1#3	7.91731e-20
C126	B1	a_83_260##6	6.49412e-17
C127	B1	a_299_139##4	3.00342e-18
C128	a_83_260##5	A2	3.33272e-17
C129	B2#1	a_398_392#	2.44158e-17
C130	B1#1	a_398_392#	2.08439e-17
C131	A2	VPWR#3	1.64619e-19
C132	B2	VGND#6	9.69225e-19
C133	B2#3	B1#3	2.07506e-19
C134	B1	a_83_260##5	1.19625e-17
C135	B2	a_299_139##4	2.3945e-17
C136	a_83_260##2	VNB	6.17549e-17
C137	VGND#7	B2	3.65517e-17
C138	B1	VPWR#3	6.50866e-17
C139	A2	B2#2	3.26096e-18
C140	a_83_260#	B1#3	7.6413e-18
C141	A2#2	a_572_392#	9.4845e-19
C142	B1	B2#2	1.72039e-18
C143	X#3	X	5.03012e-18
C144	B2	A1#1	8.91576e-20
C145	A2	B2#1	2.92555e-18
C146	B2	A2#3	1.15079e-19
C147	B2	B2#2	2.02055e-19
C148	B2	B1#4	1.40389e-18
C149	X	VPWR#3	5.55947e-17
C150	X	X#1	3.16086e-18
C151	B2	a_83_260##3	2.07784e-18
C152	B1	B2#1	1.73154e-18
C153	VPWR	VPWR#1	5.30157e-17
C154	A1	A1#2	1.10351e-17
C155	B1	a_83_260##4	1.15962e-18
C156	VPWR	a_83_260##5	1.93923e-17
C157	VGND	a_299_139#	1.48557e-17
C158	VGND	a_299_139##2	1.0675e-17
C159	VPWR	VPWR#3	1.38775e-16
C160	VGND	a_83_260##6	5.44839e-18
C161	VGND	a_299_139##4	5.87096e-18
C162	A2	A2#2	9.00968e-18
C163	VGND	VGND#7	2.23923e-17
C164	VGND	X#3	1.46659e-17
C165	X	B2#1	4.5455e-19
C166	X	B1#1	9.17412e-19
C167	VGND#3	B2	2.75932e-17
C168	X	a_83_260##4	2.69947e-17
C169	VPWR	A1#3	1.28123e-18
C170	VGND	A1#1	6.80713e-18
C171	B1	B1#3	2.79714e-17
C172	VPWR	A2#1	2.53036e-18
C173	VGND	A2#3	7.25546e-18
C174	VPWR	B2#1	4.19184e-19
C175	a_83_260#	B1	3.36811e-17
C176	VPWR	B1#1	1.40018e-18
C177	VGND	a_83_260##3	1.47378e-18
C178	VPWR	a_83_260##4	3.77702e-18
C179	B2	B1#3	1.56492e-18
C180	B2	a_83_260#	1.52913e-17
C181	X	B1#3	5.70861e-19
C182	VPWR	A1#2	2.35824e-18
C183	X	a_83_260#	2.89523e-17
C184	VPWR	A2#2	4.96558e-18
C185	a_299_139#	VNB	4.30351e-17
C186	VGND#6	VNB	1.28578e-17
C187	a_299_139##2	VNB	1.24886e-18
C188	a_83_260##6	VNB	1.80078e-19
C189	a_299_139##4	VNB	1.69912e-18
C190	VGND#7	VNB	9.10493e-18
C191	VGND	VGND#3	2.09358e-17
C192	X#3	VNB	5.18331e-17
C193	VPWR#1	VNB	8.72955e-17
C194	VGND	A1#2	1.33412e-18
C195	VPWR	a_83_260#	5.27111e-18
C196	a_83_260##5	VNB	3.25689e-18
C197	VGND	A2#2	1.48411e-18
C198	VPWR#3	VNB	8.56983e-17
C199	VGND	B2#3	2.931e-17
C200	X#1	VNB	1.98603e-17
C201	A1#1	VNB	3.80758e-17
C202	A2#3	VNB	2.90097e-17
C203	B2#2	VNB	2.28436e-17
C204	VGND	a_83_260#	1.15674e-17
C205	B1#4	VNB	3.09395e-17
C206	a_83_260##3	VNB	3.47553e-17
C207	A1#3	VNB	2.49205e-17
C208	A2#1	VNB	2.57319e-17
C209	B2#1	VNB	3.63611e-17
C210	B1#1	VNB	3.06524e-17
C211	VPWR	A1	1.35805e-18
C212	a_83_260##4	VNB	4.85429e-17
C213	X	B1	4.13354e-18
C214	VPWR	A2	1.69002e-18
C215	VGND#3	VNB	2.03766e-16
C216	A1#2	VNB	4.29961e-17
C217	VGND	A1	1.40739e-18
C218	VPWR	B1	4.90364e-18
C219	A2#2	VNB	2.60028e-17
C220	B2#3	VNB	6.06554e-17
C221	VGND	A2	9.45454e-19
C222	B1#3	VNB	4.21281e-17
C223	a_83_260#	VNB	1.69822e-17
C224	VGND	B1	3.42575e-18
C225	VPWR	X	1.76916e-17
C226	VGND	B2	2.23131e-17
C227	VGND	X	2.06205e-18
C228	A1	VNB	1.72525e-17
C229	B1	VNB	3.36541e-18
C230	B2	VNB	2.11772e-17
C231	X	VNB	5.13285e-17
C232	VPWR	VNB	6.79931e-17
C233	VGND	VNB	7.17201e-17
C234	VGND#4	a_83_260##2	3.96814e-19
C235	VGND#3	VGND#4	5.83412e-17
C236	VPWR#2	VNB	1.87161e-16
C237	VGND#2	VNB	6.14394e-17
C238	VGND#2	A1#1	1.79586e-18
C239	VGND#4	VNB	5.45076e-17
C240	VGND#4	B2	2.20152e-17
C241	VGND	VGND#2	6.25136e-17
C242	VPWR#2	VPWR#3	1.04683e-16
C243	VGND	VGND#4	3.7381e-17
C244	VGND#3	VGND#2	5.99152e-17
C245	VGND#4	X#3	1.90259e-17
C246	X	VPWR#2	1.52777e-17
C247	VGND#4	B1#3	1.68109e-20
C248	VGND#2	A2#3	1.91908e-18
C249	VGND#4	a_83_260##3	4.08527e-18
C250	VGND#2	B2#3	1.33072e-17
C251	VGND#2	a_299_139##2	3.69644e-18
C252	VPWR#2	VPWR#1	4.32203e-17
C253	VGND#2	A1#2	7.76153e-20
C254	VGND#4	a_83_260#	2.7691e-18
C255	VGND#2	a_299_139#	8.81499e-18
C256	VPWR	VPWR#2	1.09942e-17
*
*
.ENDS sky130_fd_sc_hs__o22a_1
*
