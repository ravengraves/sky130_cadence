* Extracted by Quantus, converted by sky130cad/quantus.py
*
*
*
*                       LINUX           Wed Nov 18 09:08:26 2026
*
*
*
*  PROGRAM  advgen
*
*  Name           : advgen - Quantus - (64-bit)
*  Version        : 25.1.0-p047
*  Build Date     : Thu Dec 11 23:20:30 PST 2025
*
*  HSPICE LIBRARY
*
*  OPERATING_TEMPERATURE 150
*  QRC_TECH_DIR <path>/tech
*
*
*

*
.SUBCKT sky130_fd_sc_hs__or4bb_4 VNB VPB VGND VPWR X A D_N C_N B
*
*
*  caps2d version: 10
*
*
*       TRANSISTOR CARDS
*
*
XM7 a_27_94##10 D_N#3 VGND#15 VNB sky130_fd_pr__nfet_01v8_lvt l=0.15 w=0.64 ad=0.1824 as=0.297 pd=1.85 ps=2.33
XM4 VGND#15 a_193_277##13 X#2 VNB sky130_fd_pr__nfet_01v8_lvt l=0.15 w=0.74 ad=0.297 as=0.2072 pd=2.33 ps=2.04
XM10 X#2 a_193_277##11 VGND#14 VNB sky130_fd_pr__nfet_01v8_lvt l=0.15 w=0.74 ad=0.2072 as=0.3807 pd=2.04 ps=2.74
XM17 X#1 a_193_277##9 VGND#14 VNB sky130_fd_pr__nfet_01v8_lvt l=0.15 w=0.74 ad=0.4847 as=0.3807 pd=2.79 ps=2.74
XM19 VGND#13 a_193_277# X#1 VNB sky130_fd_pr__nfet_01v8_lvt l=0.15 w=0.74 ad=0.2589 as=0.4847 pd=2.2 ps=2.79
XM14 VGND#13 C_N#1 a_678_368##6 VNB sky130_fd_pr__nfet_01v8_lvt l=0.15 w=0.64 ad=0.2589 as=0.1719 pd=2.2 ps=1.85
XM23 VGND#12 a_27_94##5 a_193_277##19 VNB sky130_fd_pr__nfet_01v8_lvt l=0.15 w=0.74 ad=0.327 as=1.0693 pd=3.11 ps=4.37
XM20 a_193_277##19 a_678_368# VGND#11 VNB sky130_fd_pr__nfet_01v8_lvt l=0.15 w=0.74 ad=1.0693 as=0.3663 pd=4.37 ps=2.47
XM21 VGND#11 B#4 a_193_277##14 VNB sky130_fd_pr__nfet_01v8_lvt l=0.15 w=0.74 ad=0.3663 as=0.3441 pd=2.47 ps=2.41
XM15 a_193_277##14 A#4 VGND#10 VNB sky130_fd_pr__nfet_01v8_lvt l=0.15 w=0.74 ad=0.3441 as=0.4625 pd=2.41 ps=2.73
XM0 a_27_94##8 D_N#1 VPWR#10 VPB sky130_fd_pr__pfet_01v8 l=0.15 w=1 ad=0.295 as=0.4372 pd=2.59 ps=3.04
XM9 X#4 a_193_277##7 VPWR#10 VPB sky130_fd_pr__pfet_01v8 l=0.15 w=1.12 ad=0.336 as=0.4372 pd=2.84 ps=3.04
XM11 X#4 a_193_277##12 VPWR#8 VPB sky130_fd_pr__pfet_01v8 l=0.15 w=1.12 ad=0.336 as=0.4424 pd=2.84 ps=3.03
XM12 VPWR#8 a_193_277##10 X#6 VPB sky130_fd_pr__pfet_01v8 l=0.15 w=1.12 ad=0.4424 as=0.6496 pd=3.03 ps=3.4
XM22 VPWR#6 a_193_277##8 X#6 VPB sky130_fd_pr__pfet_01v8 l=0.15 w=1.12 ad=0.4204 as=0.6496 pd=3.01 ps=3.4
XM6 VPWR#6 C_N#3 a_678_368##8 VPB sky130_fd_pr__pfet_01v8 l=0.15 w=1 ad=0.4204 as=0.295 pd=3.01 ps=2.59
XM5 a_791_392##4 a_27_94##6 a_193_277##16 VPB sky130_fd_pr__pfet_01v8 l=0.15 w=1 ad=0.295 as=0.3 pd=2.59 ps=2.6
XM16 a_193_277##16 a_27_94# a_791_392##2 VPB sky130_fd_pr__pfet_01v8 l=0.15 w=1 ad=0.3 as=0.3 pd=2.6 ps=2.6
XM1 a_1060_392# a_678_368##4 a_791_392##2 VPB sky130_fd_pr__pfet_01v8 l=0.15 w=1 ad=0.35 as=0.3 pd=2.7 ps=2.6
XM18 a_791_392# a_678_368##5 a_1060_392# VPB sky130_fd_pr__pfet_01v8 l=0.15 w=1 ad=0.295 as=0.35 pd=2.59 ps=2.7
XM2 a_1273_392##4 B#5 a_1060_392##2 VPB sky130_fd_pr__pfet_01v8 l=0.15 w=1 ad=0.295 as=0.3 pd=2.59 ps=2.6
XM13 a_1060_392##2 B#1 a_1273_392##2 VPB sky130_fd_pr__pfet_01v8 l=0.15 w=1 ad=0.3 as=0.3 pd=2.6 ps=2.6
XM3 a_1273_392##2 A#5 VPWR#3 VPB sky130_fd_pr__pfet_01v8 l=0.15 w=1 ad=0.3 as=0.35 pd=2.6 ps=2.7
XM8 VPWR#3 A#1 a_1273_392# VPB sky130_fd_pr__pfet_01v8 l=0.15 w=1 ad=0.35 as=0.295 pd=2.7 ps=2.59
*
*
*       RESISTOR AND CAP/DIODE CARDS
*
Rg1	D_N#1	D_N#2	399.063721
Rg2	D_N#2	D_N#3	352.702850
Rg3	a_193_277#	a_193_277##2	346.946259
Rg4	a_193_277##2	a_193_277##3	58.191574
Rg5	a_193_277##3	a_193_277##4	71.253860
Rg6	a_193_277##4	a_193_277##5	93.915619
Rg7	a_193_277##5	a_193_277##6	62.111103
Rg8	a_193_277##6	a_193_277##7	554.833374
Rg9	a_193_277##2	a_193_277##8	470.449768
Rg10	a_193_277##4	a_193_277##9	385.349548
Rg11	a_193_277##4	a_193_277##10	465.690216
Rg12	a_193_277##5	a_193_277##11	368.352448
Rg13	a_193_277##5	a_193_277##12	448.693115
Rg14	a_193_277##6	a_193_277##13	385.844788
Rg15	C_N#1	C_N#2	387.208069
Rg16	C_N#2	C_N#3	428.814117
Rg17	a_27_94#	a_27_94##2	555.397827
Rg18	a_27_94##2	a_27_94##3	72.356873
Rg19	a_27_94##3	a_27_94##4	41.535755
Rg20	a_27_94##2	a_27_94##5	302.537231
Rg21	a_27_94##3	a_27_94##6	563.169067
Rg22	a_678_368#	a_678_368##2	624.852905
Rg23	a_678_368##2	a_678_368##3	49.340549
Rg24	a_678_368##3	a_678_368##4	529.484009
Rg25	a_678_368##2	a_678_368##5	473.997864
Rg26	B#1	B#2	430.740753
Rg27	B#2	B#3	29.373684
Rg28	B#2	B#4	428.138245
Rg29	B#3	B#5	426.054413
Rg30	A#1	A#2	526.209167
Rg31	A#2	A#3	60.144505
Rg32	A#3	A#4	320.354431
Rg33	A#3	A#5	524.451538
Rf1	D_N#2	D_N#5	162.219223
Rf2	D_N#6	D_N	1.986418
Rf3	D_N#5	D_N#6	4.798750
Rf4	X#1	X#3	84.512695
Rf5	X#3	X	21.767656
Rf6	X	X#5	13.286183
Rf7	X#5	X	0.561388
Rf8	X#5	X#6	92.216301
Rf9	X#2	X#3	7.500000
Rf10	X#4	X#5	15.000000
Rf11	C_N#2	C_N#5	161.149612
Rf12	C_N#6	C_N	0.916808
Rf13	C_N#5	C_N#6	5.739682
Rf14	a_27_94##4	a_27_94##9	670.270569
Rf15	a_27_94##9	a_27_94##10	100.456627
Rf16	a_27_94##8	a_27_94##9	7.500000
Rf17	a_678_368##6	a_678_368##7	120.795303
Rf18	a_678_368##7	a_678_368##8	117.134682
Rf19	a_678_368##7	a_678_368##3	117.724228
Rf20	a_791_392#	a_791_392##3	97.903442
Rf21	a_791_392##3	a_791_392##4	47.693913
Rf22	a_791_392##2	a_791_392##3	15.000000
Rf23	a_1060_392#	a_1060_392##3	106.507027
Rf24	a_1060_392##2	a_1060_392##3	7.500000
Rf25	B	B#6	5.905091
Rf26	B#6	B	12.991199
Rf27	a_193_277##14	a_193_277##15	87.125572
Rf28	a_193_277##15	a_193_277##17	162.281860
Rf29	a_193_277##17	a_193_277##3	248.621628
Rf30	a_193_277##15	a_193_277##19	23.636614
Rf31	a_193_277##16	a_193_277##17	15.000000
Rf32	a_1273_392#	a_1273_392##3	69.794250
Rf33	a_1273_392##3	a_1273_392##4	103.046272
Rf34	a_1273_392##2	a_1273_392##3	5.000000
Rf35	A	A#6	13.060371
Rf36	A#6	A	3.882813
Rf38	VGND#2	VGND#3	77.774246
Rf39	VGND#3	VGND#4	168.325272
Rf40	VGND#4	VGND#5	69.366379
Rf41	VGND#5	VGND#6	18.238092
Rf42	VGND#6	VGND#7	96.012337
Rf43	VGND#7	VGND#8	75.212219
Rf45	VGND#2	VGND#10	17.860954
Rf46	VGND#3	VGND#11	30.353714
Rf47	VGND#4	VGND#12	20.412741
Rf48	VGND#6	VGND#13	33.326477
Rf49	VGND#7	VGND#14	24.468842
Rf50	VGND#8	VGND#15	37.903248
Rf52	VPWR#2	VPWR#3	33.851616
Rf53	VPWR#2	VPWR#4	315.578125
Rf54	VPWR#4	VPWR#5	25.908394
Rf55	VPWR#5	VPWR#6	31.948624
Rf56	VPWR#5	VPWR#7	89.583260
Rf57	VPWR#7	VPWR#8	28.305641
Rf58	VPWR#7	VPWR#9	69.668610
Rf59	VPWR#9	VPWR#10	31.246290
Rf67	A#2	A#6	53.410934
Rf65	B#3	B#6	160.232803
Re1	VPWR#2	VPWR	3.735117
Re2	VPWR	VPWR#4	1.067176
Re3	VGND#2	VGND	3.735117
Re4	VGND	VGND#5	1.067176
*
*       CAPACITOR CARDS
*
*
C1	a_193_277##16	a_1060_392#	3.32091e-17
C2	a_193_277##19	a_27_94##5	5.66326e-17
C3	VGND#7	VGND#14	1.00187e-17
C4	a_193_277##15	B#1	5.06119e-19
C5	a_791_392##2	a_193_277##16	2.33407e-17
C6	a_1060_392#	a_791_392##4	2.66819e-19
C7	a_27_94##5	VGND#12	3.30023e-18
C8	a_193_277##15	a_193_277##14	2.87847e-18
C9	VGND#15	a_27_94##8	2.736e-18
C10	a_193_277##19	C_N#1	4.98905e-19
C11	VGND#7	a_193_277##6	1.07299e-20
C12	a_678_368##6	a_27_94##5	1.32004e-18
C13	a_27_94##4	a_27_94##3	2.1916e-17
C14	VGND#7	X#2	4.32846e-17
C15	a_193_277##15	B#5	1.62492e-18
C16	a_27_94##10	a_27_94##8	3.23633e-18
C17	VGND#13	a_27_94##5	1.01091e-18
C18	a_193_277##15	VGND#11	7.65942e-17
C19	a_193_277##19	a_193_277#	4.58576e-20
C20	a_27_94##4	a_193_277##5	2.02147e-17
C21	a_193_277##16	a_791_392##4	6.31442e-17
C22	a_678_368##6	C_N#1	3.4992e-17
C23	a_27_94##4	a_193_277##4	1.30902e-17
C24	VGND#7	a_193_277##5	9.82147e-19
C25	VPWR#7	a_193_277##8	3.98431e-19
C26	a_193_277##15	a_678_368##5	1.11265e-17
C27	VGND#15	VGND#7	1.56989e-18
C28	C_N#1	VGND#13	1.96913e-17
C29	a_193_277##16	a_678_368##8	8.45634e-17
C30	VPWR#5	a_193_277##8	3.95946e-18
C31	VPWR#6	a_791_392##2	3.62542e-19
C32	a_791_392##2	a_27_94##2	9.43434e-20
C33	VGND#4	a_27_94##3	3.39477e-18
C34	a_678_368##6	a_193_277#	6.28282e-19
C35	a_193_277##15	a_193_277##19	4.97561e-18
C36	D_N#6	a_193_277##6	1.04768e-18
C37	C_N#2	a_27_94##3	2.06042e-17
C38	VGND#13	a_193_277#	3.43834e-17
C39	VGND#7	a_193_277##4	9.16128e-19
C40	VPWR#7	a_193_277##10	7.08241e-18
C41	a_193_277#	X#1	2.1495e-17
C42	VPWR#6	a_791_392##4	1.26662e-17
C43	VGND#4	a_27_94##2	1.83344e-19
C44	a_193_277##16	a_27_94##3	2.10325e-18
C45	X#2	C_N#1	2.40266e-19
C46	VGND#13	a_193_277##9	1.61125e-18
C47	a_791_392##4	X#6	3.16996e-19
C48	VPWR#7	a_193_277##12	7.02826e-18
C49	X#1	a_193_277##9	5.31523e-17
C50	a_193_277##16	a_27_94##2	1.04207e-18
C51	A#3	VGND#10	1.92558e-18
C52	X#2	a_193_277#	3.40233e-19
C53	VGND#13	a_193_277##11	2.83495e-19
C54	a_193_277##9	VGND#14	1.77602e-17
C55	a_193_277##3	a_27_94##3	9.83726e-19
C56	VGND#7	VGND#6	6.92106e-19
C57	X#1	a_193_277##11	1.08056e-18
C58	X#2	a_193_277##9	1.6795e-18
C59	a_1060_392##2	a_678_368#	1.55731e-18
C60	a_193_277##3	a_193_277##5	1.98861e-20
C61	VPWR#7	a_193_277##7	5.82359e-19
C62	a_193_277##11	VGND#14	1.37207e-17
C63	a_791_392##4	a_27_94##3	8.38028e-19
C64	a_193_277##3	a_193_277##4	1.64129e-17
C65	VGND#15	a_193_277##9	1.78839e-19
C66	a_1273_392##4	a_678_368#	5.05617e-19
C67	VPWR#8	VPWR#6	7.15221e-18
C68	X#2	a_193_277##11	5.22109e-17
C69	a_27_94##8	a_193_277##16	1.52994e-19
C70	a_791_392##4	a_27_94##2	3.20248e-20
C71	a_193_277##14	A#3	3.78446e-18
C72	a_791_392#	a_678_368#	1.42009e-19
C73	VGND#15	a_193_277##11	5.16919e-19
C74	X#6	VPWR#8	2.47277e-19
C75	a_678_368##7	a_193_277##19	6.61775e-17
C76	D_N#5	a_193_277##6	4.72365e-18
C77	X#2	a_193_277##13	3.46886e-17
C78	a_1060_392#	a_678_368#	7.99828e-19
C79	D_N#2	a_193_277##6	3.10862e-17
C80	a_193_277##13	VGND#15	2.02824e-17
C81	VGND#6	VGND#4	1.09303e-18
C82	X#2	D_N#3	1.44708e-18
C83	a_678_368##7	VGND#12	6.76681e-18
C84	X#4	VPWR#8	1.26804e-18
C85	a_27_94##8	VPWR#6	2.32727e-17
C86	D_N#3	VGND#15	2.80648e-17
C87	C_N#6	a_27_94##6	7.57179e-20
C88	VPWR#10	VPWR#8	1.04039e-17
C89	a_27_94##8	X#6	1.15584e-16
C90	a_27_94##10	D_N#3	3.49335e-17
C91	a_678_368##6	a_678_368##7	1.54021e-18
C92	a_27_94##8	VPWR#8	5.30113e-17
C93	C_N#6	C_N#3	2.30576e-18
C94	a_27_94##8	X#4	8.09718e-17
C95	C_N#6	a_193_277##8	1.89303e-19
C96	a_27_94##8	VPWR#10	5.47434e-17
C97	a_1273_392#	A#1	4.08214e-17
C98	a_678_368##7	X#1	3.44475e-21
C99	VPWR#3	A#1	4.56276e-17
C100	a_1273_392#	A#5	7.56691e-19
C101	a_1273_392##2	A#1	2.15812e-18
C102	A#5	VPWR#3	2.42943e-17
C103	a_1273_392##2	A#5	7.37977e-17
C104	VPWR#3	B#1	5.09322e-19
C105	B#4	A#4	1.69631e-17
C106	a_1273_392##2	B#1	6.44474e-17
C107	a_193_277##19	a_27_94##3	9.41443e-19
C108	VPWR#3	B#5	2.31371e-19
C109	B#1	a_1060_392##2	2.0671e-17
C110	a_1273_392##2	B#5	1.93168e-18
C111	a_678_368#	B#4	1.84895e-17
C112	a_1273_392##4	B#1	1.13489e-18
C113	VPWR#7	VPWR#6	3.47318e-20
C114	a_27_94##3	a_27_94##2	8.94831e-18
C115	X#4	a_193_277##9	1.57129e-19
C116	VPWR#3	a_678_368##5	7.66033e-20
C117	a_1060_392##2	B#5	4.27777e-17
C118	X#6	a_193_277##4	2.85218e-19
C119	a_193_277##14	VGND#10	3.89765e-17
C120	a_1273_392##4	B#5	6.69191e-17
C121	X#4	a_193_277##11	3.74018e-18
C122	D_N#6	a_193_277##7	2.0088e-18
C123	a_1060_392#	B#1	1.18737e-19
C124	a_1060_392##2	a_678_368##5	2.03515e-18
C125	a_27_94##5	a_678_368#	1.0968e-18
C126	a_791_392#	B#5	1.14882e-18
C127	a_27_94##3	VGND#12	6.52055e-19
C128	a_193_277##15	a_1060_392##2	1.86667e-18
C129	VGND#11	VGND#10	1.2309e-18
C130	X#4	a_193_277##13	2.79807e-18
C131	a_1273_392##4	a_678_368##5	1.18699e-18
C132	a_193_277##15	A#3	2.46161e-19
C133	a_1060_392#	B#5	4.11646e-19
C134	VPWR#8	a_193_277##5	3.26826e-19
C135	a_1060_392##2	a_678_368##4	5.23526e-19
C136	D_N#6	D_N#1	2.24771e-18
C137	a_791_392#	a_678_368##5	3.86353e-17
C138	X#4	D_N#3	1.38801e-18
C139	a_791_392##2	B#5	7.48307e-20
C140	a_27_94##2	VGND#12	3.04293e-19
C141	C_N#1	a_27_94##5	1.73096e-18
C142	a_193_277##14	VGND#11	4.99815e-17
C143	a_1060_392#	a_678_368##5	6.00047e-17
C144	VPWR#8	a_193_277##4	2.42785e-19
C145	a_193_277##16	B#5	2.10672e-19
C146	a_1060_392##2	a_27_94#	3.64368e-19
C147	a_791_392#	a_678_368##4	3.97021e-19
C148	a_193_277#	a_27_94##5	1.76835e-19
C149	a_791_392##2	a_678_368##5	1.05315e-18
C150	a_678_368##4	a_1060_392#	2.47334e-17
C151	X#4	a_193_277##6	1.78807e-17
C152	a_193_277##16	a_678_368##5	1.40314e-18
C153	a_193_277#	C_N#1	2.65393e-17
C154	a_678_368##6	a_27_94##3	6.53412e-18
C155	VGND#3	B#3	2.87699e-20
C156	a_791_392##2	a_678_368##4	5.33162e-17
C157	a_1060_392#	a_27_94#	3.70835e-18
C158	X#4	a_193_277##5	1.8769e-17
C159	a_193_277##16	a_678_368##4	1.70841e-17
C160	a_791_392##2	a_27_94#	5.19447e-17
C161	VGND#4	a_678_368##3	3.23699e-19
C162	a_193_277##9	a_193_277#	9.76568e-18
C163	X#4	a_193_277##4	4.65703e-19
C164	a_1060_392#	a_27_94##6	8.30154e-19
C165	a_193_277##15	a_1060_392#	5.80148e-17
C166	VGND#3	a_678_368##3	3.93148e-19
C167	a_193_277##16	a_27_94#	4.96253e-17
C168	a_193_277##15	a_27_94##3	9.31157e-20
C169	a_791_392##2	a_27_94##6	5.11109e-19
C170	VGND#3	a_193_277##15	1.71751e-17
C171	VPWR#6	a_678_368##4	4.84861e-20
C172	a_193_277##15	B#3	3.96023e-18
C173	a_1060_392#	C_N#3	4.30191e-19
C174	VGND#6	a_27_94##4	1.44398e-18
C175	a_193_277##16	a_27_94##6	5.2533e-17
C176	a_193_277##11	a_193_277##9	1.96205e-17
C177	a_791_392##4	a_27_94##6	5.36022e-17
C178	VPWR#6	a_27_94#	8.60643e-20
C179	a_193_277##15	a_27_94##2	9.61369e-19
C180	a_193_277##16	C_N#3	1.29179e-17
C181	a_678_368##8	a_27_94##6	6.98745e-18
C182	a_193_277##4	a_193_277##8	8.83503e-19
C183	a_193_277##15	a_678_368##3	8.01898e-17
C184	a_791_392##2	a_193_277##8	2.19244e-19
C185	a_27_94##8	VPWR#7	6.91577e-18
C186	a_791_392##4	C_N#3	6.04836e-18
C187	VPWR#7	a_193_277##3	1.41992e-19
C188	a_193_277##13	a_193_277##11	3.70411e-17
C189	VGND#6	C_N#2	1.10253e-19
C190	VPWR#6	a_27_94##6	1.90581e-18
C191	VPWR#5	a_193_277##3	1.50801e-19
C192	a_193_277##16	a_193_277##8	1.23107e-19
C193	a_678_368##6	a_193_277##19	3.30213e-18
C194	a_678_368##8	C_N#3	3.64063e-17
C195	a_27_94##8	VPWR#5	4.80297e-18
C196	a_791_392##4	a_193_277##8	1.72389e-18
C197	C_N#3	VPWR#6	1.45381e-17
C198	a_27_94##8	a_193_277##6	2.25407e-19
C199	a_678_368##8	a_193_277##8	9.57151e-20
C200	VGND#7	a_193_277##3	1.9056e-19
C201	D_N#3	a_193_277##13	2.06534e-17
C202	a_678_368##7	a_678_368##3	2.53612e-19
C203	VGND#13	a_193_277##19	5.29702e-19
C204	VGND#6	a_193_277##3	2.43596e-19
C205	a_791_392##4	a_193_277##10	3.84627e-19
C206	VPWR#6	a_193_277##8	4.26858e-17
C207	a_27_94##8	a_27_94#	4.38704e-19
C208	VGND#15	D_N#5	2.59026e-17
C209	a_27_94##8	a_193_277##5	5.42861e-19
C210	a_193_277##8	X#6	3.64093e-17
C211	A#2	VGND#10	1.3041e-17
C212	a_193_277##6	a_193_277##5	3.61472e-18
C213	VPWR#6	a_193_277##10	3.31521e-18
C214	a_27_94##8	a_27_94##6	8.9868e-19
C215	B#4	A#3	2.28528e-18
C216	a_27_94##8	a_193_277##4	3.07095e-19
C217	a_27_94##4	a_678_368##7	6.89893e-17
C218	VPWR#8	a_193_277##8	2.40297e-18
C219	a_27_94##10	D_N#5	1.81235e-17
C220	X#6	a_193_277##10	4.1105e-17
C221	X#4	a_193_277##8	5.92587e-20
C222	a_27_94##8	C_N#3	5.22447e-18
C223	B	A#3	3.41493e-18
C224	VPWR#8	a_193_277##10	3.92535e-17
C225	VGND#13	a_678_368##6	2.69072e-17
C226	a_193_277##14	B#3	2.09329e-17
C227	X#4	a_193_277##10	2.91603e-19
C228	a_678_368##7	C_N#2	5.48288e-18
C229	a_27_94##8	a_193_277##8	4.31938e-17
C230	a_27_94##4	C_N#5	2.14909e-17
C231	VGND#11	B#3	1.32529e-18
C232	VGND#4	a_678_368##7	2.41226e-17
C233	VPWR#8	a_193_277##12	3.70669e-17
C234	X#4	a_193_277##12	4.48867e-17
C235	a_678_368##7	a_193_277##16	5.28634e-17
C236	C_N#6	C_N#2	8.65159e-18
C237	a_27_94##8	a_193_277##10	2.42196e-17
C238	A#5	A#1	3.91897e-17
C239	VPWR#8	a_193_277##7	3.2869e-18
C240	VPWR#10	a_193_277##12	3.202e-18
C241	a_193_277##3	a_678_368##7	3.48435e-18
C242	C_N#5	C_N#2	1.31775e-17
C243	X#4	a_193_277##7	3.9377e-17
C244	X#1	a_193_277##4	2.77743e-19
C245	a_678_368##3	a_193_277##19	1.06191e-16
C246	a_27_94##8	a_193_277##12	1.81172e-17
C247	X#1	VGND#13	3.17564e-17
C248	VPWR#10	a_193_277##7	4.46955e-17
C249	a_193_277##3	C_N#6	2.26027e-17
C250	B#1	A#5	4.35449e-17
C251	X#4	D_N#1	4.07887e-18
C252	a_27_94##8	a_193_277##7	3.01987e-17
C253	a_1273_392#	A#2	5.60216e-18
C254	a_193_277##3	C_N#5	2.5497e-17
C255	VPWR#3	A#2	6.25863e-19
C256	D_N#1	VPWR#10	3.47689e-17
C257	a_193_277##7	a_193_277##5	2.89927e-18
C258	a_791_392##2	VPWR#4	6.24975e-17
C259	a_1273_392##2	A#2	1.71722e-18
C260	a_193_277##5	VGND#14	8.07103e-19
C261	a_27_94##8	D_N#1	5.91406e-17
C262	B#5	B#1	4.28514e-17
C263	a_27_94##4	a_678_368##6	7.7249e-17
C264	a_193_277##16	VPWR#4	6.40745e-18
C265	a_193_277##5	a_193_277##4	4.44406e-18
C266	a_27_94##4	VGND#13	4.31018e-17
C267	a_791_392##4	VPWR#4	3.27241e-17
C268	X#2	VGND#13	1.056e-19
C269	a_27_94##4	X#1	7.99471e-17
C270	a_1273_392##2	B#3	5.84054e-21
C271	a_27_94##2	a_678_368#	2.40227e-19
C272	a_27_94##4	VGND#14	1.96187e-18
C273	B#3	a_1060_392##2	1.57547e-17
C274	a_678_368##6	C_N#2	8.196e-19
C275	a_678_368##5	B#5	4.97407e-18
C276	a_193_277##14	a_1273_392##2	8.84719e-18
C277	X#2	a_27_94##4	3.73212e-17
C278	D_N#6	D_N#2	7.0157e-18
C279	a_1273_392##4	B#3	2.11719e-19
C280	a_193_277##6	X#2	3.72925e-19
C281	VGND#13	C_N#2	4.70706e-19
C282	X#2	X#1	4.81082e-18
C283	VGND#3	B#4	5.57021e-18
C284	D_N#5	D_N#2	1.02098e-17
C285	a_678_368##4	a_678_368##5	3.83357e-17
C286	a_193_277##5	X#2	1.56022e-18
C287	VGND#4	a_678_368#	7.17831e-19
C288	C_N#6	a_678_368##8	3.84125e-17
C289	a_791_392#	a_678_368##3	5.20462e-19
C290	X#2	VGND#14	2.12464e-18
C291	X#1	a_193_277##3	2.44238e-18
C292	a_27_94##3	a_27_94##5	9.02849e-18
C293	a_1060_392#	a_678_368##3	1.48136e-18
C294	VGND#3	a_678_368#	2.8108e-18
C295	a_791_392##2	a_678_368##3	2.13997e-19
C296	a_27_94#	a_678_368##4	4.88347e-17
C297	X#2	a_193_277##4	3.69001e-19
C298	a_193_277##16	a_678_368##3	5.65456e-17
C299	a_678_368##7	a_27_94##3	3.72339e-17
C300	VGND#4	a_27_94##5	1.51726e-17
C301	A	A#3	1.88951e-17
C302	a_27_94##6	a_27_94#	4.94649e-17
C303	VGND#15	D_N#2	7.68307e-18
C304	VGND#15	X#2	5.13587e-17
C305	VGND#6	C_N#1	4.20066e-18
C306	a_27_94##10	D_N#2	4.25794e-18
C307	a_27_94##4	a_678_368##8	1.94751e-18
C308	a_678_368##7	a_27_94##2	2.3015e-17
C309	a_193_277##16	C_N#2	1.16721e-18
C310	C_N#3	a_27_94##6	4.54117e-18
C311	C_N#1	a_27_94##3	8.86864e-18
C312	VGND#4	C_N#1	3.02169e-18
C313	VGND#7	a_193_277#	1.36735e-18
C314	a_27_94##4	X#6	3.06589e-17
C315	a_193_277##8	a_27_94##6	3.12494e-19
C316	C_N#2	a_678_368##8	4.74287e-18
C317	a_27_94##4	VPWR#8	6.93416e-19
C318	a_193_277##3	a_193_277##16	1.29627e-18
C319	X#4	a_27_94##4	9.4358e-17
C320	a_678_368#	B#3	6.40402e-18
C321	VGND#6	a_193_277#	3.71746e-18
C322	a_193_277##8	C_N#3	3.25839e-17
C323	a_27_94##10	a_193_277##6	1.10051e-18
C324	a_193_277##3	a_678_368##8	3.15014e-17
C325	a_27_94##10	VGND#15	5.94593e-17
C326	a_193_277##15	B#4	5.44134e-19
C327	VGND#4	a_193_277#	1.37187e-18
C328	VPWR#3	A#3	9.03046e-20
C329	a_193_277##3	VPWR#6	2.58385e-17
C330	VGND#7	a_193_277##9	1.11072e-17
C331	a_193_277##10	a_193_277##8	1.7879e-17
C332	X#6	a_193_277##3	1.56925e-18
C333	a_678_368##7	a_193_277##15	5.46841e-19
C334	a_27_94##8	C_N#2	3.82138e-19
C335	a_27_94##4	a_27_94##5	6.08938e-19
C336	a_193_277##12	a_193_277##10	3.12703e-17
C337	a_27_94##4	C_N#1	2.82933e-17
C338	a_193_277##15	a_678_368#	6.31201e-17
C339	a_193_277##3	a_27_94##8	1.32029e-16
C340	a_27_94##4	a_193_277#	2.27799e-17
C341	X#4	D_N#2	3.48278e-18
C342	VGND#7	a_193_277##11	9.57568e-18
C343	D_N#2	VPWR#10	1.00727e-18
C344	a_27_94##4	a_193_277##9	2.05211e-17
C345	a_193_277##7	a_193_277##12	4.88371e-17
C346	a_193_277##15	B	5.23638e-17
C347	a_27_94##8	D_N#2	6.95599e-18
C348	VPWR#4	a_678_368##4	4.45016e-18
C349	a_27_94##4	a_193_277##11	5.64673e-18
C350	B#3	A#5	5.31073e-18
C351	VPWR#4	a_27_94#	3.87628e-18
C352	a_1273_392##2	A#3	3.2488e-19
C353	a_193_277##3	C_N#1	2.40491e-18
C354	B#3	B#1	1.17174e-18
C355	VPWR#4	a_27_94##6	5.34615e-18
C356	D_N#1	a_193_277##7	2.97912e-17
C357	VGND#7	a_193_277##13	1.25139e-18
C358	VPWR#4	C_N#3	6.60004e-18
C359	a_678_368##5	B#3	5.93217e-19
C360	a_1273_392#	VPWR#3	6.40614e-17
C361	VPWR#7	a_193_277##6	4.58039e-21
C362	a_193_277##14	B	2.17382e-17
C363	VPWR#4	a_27_94##3	2.06929e-19
C364	a_27_94#	a_678_368##3	2.24179e-18
C365	VGND#7	D_N#3	3.37578e-19
C366	D_N#6	X#4	1.29893e-17
C367	C_N#6	a_27_94##3	1.26203e-19
C368	a_1273_392##2	a_1273_392#	2.52696e-18
C369	VPWR#4	a_27_94##2	3.56824e-20
C370	a_678_368##7	a_678_368#	1.57412e-20
C371	VGND	a_193_277##6	8.1492e-21
C372	VGND	a_193_277##5	5.34192e-19
C373	VGND	a_193_277##4	1.79174e-19
C374	a_1273_392##2	VPWR#3	8.3093e-17
C375	C_N#2	a_27_94##6	2.98956e-19
C376	VPWR#7	a_193_277##5	4.68609e-20
C377	a_678_368##7	a_27_94##5	1.09497e-17
C378	a_193_277##15	A	1.63276e-18
C379	a_27_94##4	a_193_277##10	1.10388e-17
C380	B	a_1273_392##2	2.61501e-18
C381	D_N#5	X#4	1.62234e-17
C382	a_193_277##3	a_27_94##6	4.89112e-19
C383	B	a_1060_392##2	4.67246e-17
C384	a_193_277##8	C_N#2	1.8473e-18
C385	a_27_94##4	a_193_277##12	2.14172e-18
C386	a_193_277##3	C_N#3	2.06003e-17
C387	a_193_277##3	a_193_277##8	7.67868e-18
C388	a_27_94##8	D_N#6	3.06842e-17
C389	a_678_368##7	C_N#1	8.61743e-19
C390	VPWR#7	a_193_277##4	8.281e-21
C391	a_1273_392##2	a_1060_392##2	6.44071e-17
C392	VPWR#7	VPWR#5	6.90517e-19
C393	VGND#10	A	6.28014e-17
C394	a_193_277##14	A	1.81995e-17
C395	VPWR#4	a_678_368##3	5.25665e-20
C396	VPWR	VPWR#7	9.22555e-17
C397	VPWR	VPWR#5	5.24478e-17
C398	D_N#2	a_193_277##7	1.74667e-18
C399	a_1273_392##4	a_1273_392##2	3.01982e-18
C400	a_27_94##8	D_N#5	1.26109e-17
C401	B	a_678_368#	4.93083e-18
C402	VPWR#4	C_N#2	2.59566e-19
C403	A#3	A#2	6.88827e-18
C404	a_678_368##7	a_193_277#	2.56499e-19
C405	a_678_368##3	B#3	2.7975e-18
C406	A	a_1273_392#	2.68004e-17
C407	VPWR	a_193_277##15	4.70835e-18
C408	a_193_277##3	VPWR#4	1.16116e-18
C409	VGND#3	a_193_277##14	8.76426e-18
C410	A	a_1273_392##2	1.84221e-17
C411	VPWR	a_678_368##7	4.44372e-18
C412	a_1060_392##2	a_1273_392##4	8.11532e-17
C413	VPWR	C_N#6	3.20768e-18
C414	VGND	VGND#7	8.05404e-17
C415	VGND	VGND#6	8.06328e-17
C416	VPWR	D_N#6	4.75356e-18
C417	B	A#1	7.02366e-19
C418	VGND	VGND#4	1.26487e-16
C419	C_N#5	a_27_94##3	2.81599e-18
C420	VGND	VGND#3	6.58783e-17
C421	B	A#5	1.0437e-18
C422	a_27_94##4	C_N#2	4.07788e-18
C423	a_27_94##4	a_193_277##3	1.72522e-16
C424	VGND	a_193_277##15	1.75401e-17
C425	B	a_678_368##5	1.7792e-19
C426	A#3	VNB	2.62915e-17
C427	VGND#10	A#4	4.2918e-17
C428	a_193_277##3	C_N#2	3.35822e-17
C429	a_27_94##3	VNB	6.92956e-17
C430	a_27_94##2	VNB	2.75088e-17
C431	VGND	a_678_368##7	7.81546e-18
C432	a_193_277##6	VNB	2.23763e-17
C433	a_193_277##5	VNB	3.10287e-17
C434	A	B#4	5.10378e-19
C435	a_193_277##4	VNB	2.63142e-17
C436	A	a_678_368#	9.8539e-19
C437	VGND#4	a_193_277##19	4.57762e-17
C438	VGND	C_N#5	3.05013e-18
C439	C_N#6	a_678_368##7	1.00519e-17
C440	VPWR	a_1060_392##2	3.33846e-18
C441	VGND	D_N#5	4.47645e-18
C442	VPWR	a_1273_392##4	1.50004e-17
C443	VPWR	a_791_392#	1.96364e-17
C444	a_193_277##14	A#4	1.64879e-17
C445	VGND	a_193_277##14	7.02027e-20
C446	VPWR	a_1060_392#	1.30479e-17
C447	VGND	VGND#11	1.44921e-17
C448	a_791_392#	a_1273_392##4	4.73875e-17
C449	a_1060_392#	a_1060_392##2	1.26297e-18
C450	VGND	a_193_277##19	4.2359e-17
C451	VPWR	a_791_392##2	3.31078e-17
C452	B#3	A#3	2.89036e-17
C453	VPWR	a_193_277##16	2.22032e-17
C454	VGND	a_678_368##6	1.88033e-17
C455	VPWR	a_791_392##4	2.02512e-17
C456	VGND	VGND#13	1.82725e-17
C457	VPWR	a_678_368##8	5.3386e-18
C458	VGND	X#1	2.30785e-17
C459	VPWR	VPWR#6	1.48091e-17
C460	VGND#10	B#4	2.80403e-18
C461	VGND	X#2	2.15795e-17
C462	VPWR	X#6	3.612e-18
C463	VGND	a_27_94##10	1.78237e-17
C464	VPWR	X#4	6.80444e-18
C465	VGND#3	a_193_277##19	2.02683e-17
C466	VPWR	a_27_94##8	5.03178e-17
C467	VGND#11	A#4	1.24956e-18
C468	VGND#4	VGND#12	1.19108e-17
C469	a_1060_392##2	a_791_392##2	3.74837e-20
C470	VGND	a_193_277##16	6.05074e-18
C471	a_193_277##14	B#4	6.8967e-17
C472	B	A#2	9.27896e-19
C473	B	B#3	2.6078e-17
C474	VPWR#7	VNB	3.78863e-17
C475	VPWR#5	VNB	2.72279e-17
C476	VGND#6	a_678_368##6	9.33408e-18
C477	VGND	a_27_94##8	2.57586e-18
C478	B	a_678_368##3	1.0139e-18
C479	VGND#7	VNB	3.96599e-17
C480	D_N#3	a_193_277##6	1.74654e-18
C481	VGND#10	a_678_368#	4.47817e-19
C482	VGND#6	VNB	4.19995e-17
C483	VGND#4	VNB	5.89745e-17
C484	VGND#3	VNB	5.33103e-17
C485	VGND	a_678_368#	2.06102e-18
C486	VGND	a_27_94##5	1.23523e-18
C487	VGND	C_N#1	8.86823e-18
C488	VPWR	B#5	6.47991e-20
C489	a_193_277##15	VNB	1.36872e-17
C490	VGND	a_193_277#	3.27941e-19
C491	VPWR	a_678_368##5	1.65153e-18
C492	VGND#7	VGND#13	3.22694e-18
C493	B#4	VGND#11	2.37033e-17
C494	VGND	a_193_277##9	2.06738e-19
C495	a_791_392#	a_1060_392#	6.3176e-17
C496	VPWR	a_678_368##4	1.60575e-18
C497	a_678_368##7	VNB	7.04884e-18
C498	VGND	a_193_277##11	1.66962e-19
C499	VPWR	a_27_94#	4.09438e-19
C500	VGND	a_193_277##13	2.85671e-18
C501	C_N#6	VNB	3.30329e-18
C502	VGND	D_N#3	9.57682e-18
C503	VPWR	a_27_94##6	1.62487e-18
C504	C_N#5	VNB	2.50253e-18
C505	VPWR	C_N#3	8.52713e-18
C506	D_N#6	VNB	3.20037e-18
C507	VPWR	a_193_277##8	3.44875e-19
C508	D_N#5	VNB	2.80999e-18
C509	A	A#2	3.615e-17
C510	C_N#5	a_678_368##7	1.97512e-17
C511	VGND#10	VNB	3.46055e-17
C512	VPWR	a_193_277##10	4.45243e-19
C513	a_193_277##14	a_678_368#	1.8213e-18
C514	a_193_277##14	VNB	6.16055e-18
C515	VGND#11	VNB	2.59691e-18
C516	A	B#3	5.16629e-18
C517	a_193_277##19	VNB	8.46813e-18
C518	VPWR	a_193_277##12	3.48829e-19
C519	a_193_277##15	A#1	5.66946e-19
C520	a_678_368##6	VNB	1.19221e-17
C521	VPWR	a_193_277##7	3.17507e-19
C522	VGND#13	VNB	1.40104e-18
C523	VPWR	D_N#1	8.71169e-18
C524	X#2	VNB	2.03174e-18
C525	VGND#4	a_678_368##6	3.77799e-17
C526	VGND#15	VNB	1.31102e-17
C527	a_27_94##10	VNB	4.87112e-17
C528	a_1273_392#	VNB	5.1649e-17
C529	VPWR#3	VNB	3.58302e-18
C530	a_1273_392##2	VNB	1.11426e-17
C531	a_1060_392##2	VNB	5.80417e-18
C532	a_1273_392##4	VNB	1.13428e-17
C533	a_791_392#	VNB	9.35718e-18
C534	a_1060_392#	VNB	4.94252e-18
C535	VPWR	VPWR#4	1.30335e-16
C536	a_791_392##2	VNB	5.54162e-18
C537	a_193_277##16	VNB	1.13791e-17
C538	a_791_392##2	a_791_392#	2.8314e-18
C539	a_791_392##4	VNB	1.02469e-17
C540	a_678_368##8	VNB	6.90115e-18
C541	VPWR#6	VNB	1.26416e-18
C542	X#4	X#2	4.78986e-19
C543	VPWR#8	VNB	1.18723e-19
C544	X#4	VNB	1.77026e-18
C545	a_678_368#	VGND#11	3.1645e-17
C546	VPWR#10	VNB	4.91357e-18
C547	a_27_94##8	VNB	6.91859e-17
C548	VPWR	a_678_368##3	4.5662e-18
C549	A#4	VNB	3.11917e-17
C550	B#4	VNB	3.52042e-17
C551	VPWR	a_27_94##4	3.43934e-18
C552	a_678_368#	VNB	5.17595e-17
C553	a_27_94##5	VNB	2.97179e-17
C554	C_N#1	VNB	3.72145e-17
C555	a_193_277#	VNB	2.82637e-17
C556	a_193_277##9	VNB	2.76598e-17
C557	VPWR	a_193_277##3	1.20007e-17
C558	a_193_277##11	VNB	2.68378e-17
C559	a_193_277##13	VNB	3.12797e-17
C560	D_N#3	VNB	4.05234e-17
C561	VGND	a_678_368##3	7.36932e-18
C562	A#1	VNB	4.50943e-17
C563	VGND#7	X#1	2.8549e-17
C564	A#5	VNB	3.34488e-17
C565	VGND	a_27_94##4	2.35684e-17
C566	B#1	VNB	3.20566e-17
C567	B#5	VNB	3.4231e-17
C568	a_678_368##5	VNB	3.80969e-17
C569	a_678_368##4	VNB	3.40762e-17
C570	VGND	a_193_277##3	9.7985e-18
C571	a_27_94#	VNB	3.4992e-17
C572	a_27_94##6	VNB	4.20258e-17
C573	VGND	D_N#2	1.48143e-19
C574	C_N#3	VNB	4.64542e-17
C575	B	A	6.1477e-18
C576	a_193_277##8	VNB	3.77357e-17
C577	a_193_277##10	VNB	2.96799e-17
C578	a_193_277##12	VNB	2.83997e-17
C579	a_193_277##7	VNB	3.51488e-17
C580	VGND#15	X#4	1.3407e-17
C581	a_678_368#	a_193_277##19	2.5918e-17
C582	a_791_392##2	a_1060_392#	4.07772e-17
C583	D_N#1	VNB	4.11354e-17
C584	a_193_277##15	A#5	4.67897e-19
C585	VPWR#4	VNB	7.34669e-17
C586	VPWR	B	1.57742e-18
C587	A#2	VNB	8.14338e-17
C588	B#3	VNB	6.99198e-17
C589	a_678_368##3	VNB	6.55805e-17
C590	a_27_94##4	VNB	1.38185e-17
C591	VGND#13	VGND#4	3.98345e-18
C592	C_N#2	VNB	3.88834e-17
C593	VGND	B	1.74432e-18
C594	a_193_277##3	VNB	5.71678e-17
C595	a_27_94##2	a_678_368##3	2.63413e-17
C596	D_N#2	VNB	4.44441e-17
C597	VGND#11	a_27_94##5	7.53161e-19
C598	B	VNB	7.07194e-18
C599	A	VNB	3.1945e-17
C600	VPWR	VNB	3.06324e-16
C601	VGND#6	X#1	1.2938e-17
C602	VGND	VNB	2.97921e-16
C603	a_27_94##10	X#4	5.04785e-18
C604	VGND#2	VGND#3	3.13743e-17
C605	VGND#2	VNB	1.77676e-16
C606	VPWR#2	VNB	2.2317e-16
C607	VGND#2	B	1.69147e-18
C608	VPWR#9	D_N#1	4.50577e-18
C609	VGND#8	a_193_277##6	5.17334e-20
C610	VPWR#2	B#5	5.9027e-18
C611	VGND#8	VNB	5.24124e-17
C612	VPWR#2	B#3	4.98672e-19
C613	VGND#2	a_1273_392#	3.40386e-18
C614	VPWR#2	A#5	2.42621e-18
C615	VGND#2	A#2	1.31079e-18
C616	VGND#8	VGND#7	1.2283e-18
C617	VGND#2	VGND#11	8.38921e-18
C618	VPWR#9	a_193_277##7	7.99338e-18
C619	VPWR#2	B	2.12836e-18
C620	VGND#2	VGND#10	4.35456e-17
C621	VGND	VGND#8	1.03009e-16
C622	VPWR#9	VNB	5.04719e-17
C623	VGND#8	D_N#5	4.20522e-19
C624	a_1060_392#	VPWR#2	1.45025e-18
C625	a_27_94##8	VPWR#9	1.80114e-17
C626	VPWR#9	VPWR#7	9.01848e-19
C627	VGND#8	D_N#3	4.04008e-18
C628	a_1273_392##4	VPWR#2	6.61004e-17
C629	VPWR#9	a_193_277##12	6.31627e-19
C630	VGND#8	a_27_94##10	1.58715e-17
C631	a_1273_392##2	VPWR#2	6.48724e-17
C632	VGND#8	a_193_277##13	1.05139e-17
C633	VPWR#2	a_678_368#	4.38005e-19
C634	VGND#2	A#4	4.86488e-18
C635	a_1273_392#	VPWR#2	3.75332e-17
C636	VGND#8	a_193_277##11	7.47127e-19
C637	VGND#2	A	1.39314e-17
C638	VGND#8	X#2	6.76429e-18
C639	VPWR#2	a_678_368##5	4.45016e-18
C640	VPWR#2	a_678_368##3	8.6842e-20
C641	VGND#8	a_193_277##9	1.77427e-19
C642	VPWR	VPWR#2	6.17938e-17
C643	VPWR#2	B#1	5.82842e-18
C644	VPWR#2	A#2	1.24116e-18
C645	A	VPWR#2	8.87528e-18
C646	VGND#2	B#3	8.01336e-19
C647	VPWR#2	A#1	3.10117e-18
C648	VPWR#9	a_193_277##6	5.28507e-20
C649	VGND#2	a_193_277##14	2.92167e-17
C650	VGND#2	A#3	4.42773e-20
C651	a_791_392##2	VPWR#2	6.34113e-18
C652	VPWR	VPWR#9	1.01811e-16
C653	a_791_392#	VPWR#2	4.2577e-17
C654	a_1060_392##2	VPWR#2	7.46399e-18
C655	VPWR#2	VPWR#3	2.33359e-17
*
*
.ENDS sky130_fd_sc_hs__or4bb_4
*
