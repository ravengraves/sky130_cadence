* Extracted by Quantus, converted by sky130cad/quantus.py
*
*
*
*                       LINUX           Wed Nov 18 08:44:50 2026
*
*
*
*  PROGRAM  advgen
*
*  Name           : advgen - Quantus - (64-bit)
*  Version        : 25.1.0-p047
*  Build Date     : Thu Dec 11 23:20:30 PST 2025
*
*  HSPICE LIBRARY
*
*  OPERATING_TEMPERATURE 150
*  QRC_TECH_DIR <path>/tech
*
*
*

*
.SUBCKT sky130_fd_sc_hs__nand2_2 VPB VNB VGND VPWR Y B A
*
*
*  caps2d version: 10
*
*
*       TRANSISTOR CARDS
*
*
XM2 VGND#4 B#5 a_27_74##4 VNB sky130_fd_pr__nfet_01v8_lvt l=0.15 w=0.74 ad=0.2442 as=0.2109 pd=2.14 ps=2.05
XM7 a_27_74##2 B#1 VGND#4 VNB sky130_fd_pr__nfet_01v8_lvt l=0.15 w=0.74 ad=0.2072 as=0.2442 pd=2.04 ps=2.14
XM1 a_27_74##2 A#5 Y#4 VNB sky130_fd_pr__nfet_01v8_lvt l=0.15 w=0.74 ad=0.2072 as=0.2442 pd=2.04 ps=2.14
XM4 Y#4 A#1 a_27_74# VNB sky130_fd_pr__nfet_01v8_lvt l=0.15 w=0.74 ad=0.2442 as=0.2257 pd=2.14 ps=2.09
XM3 Y#3 B#7 VPWR#3 VPB sky130_fd_pr__pfet_01v8 l=0.15 w=1.12 ad=0.336 as=0.3304 pd=2.84 ps=2.83
XM6 VPWR#4 B#6 Y#3 VPB sky130_fd_pr__pfet_01v8 l=0.15 w=1.12 ad=0.3472 as=0.336 pd=2.86 ps=2.84
XM5 VPWR#4 A#7 Y#1 VPB sky130_fd_pr__pfet_01v8 l=0.15 w=1.12 ad=0.3472 as=0.336 pd=2.86 ps=2.84
XM0 Y#1 A#6 VPWR#1 VPB sky130_fd_pr__pfet_01v8 l=0.15 w=1.12 ad=0.336 as=0.3304 pd=2.84 ps=2.83
*
*
*       RESISTOR AND CAP/DIODE CARDS
*
Rg1	B#1	B#2	397.555725
Rg2	B#2	B#3	19.768967
Rg3	B#3	B#4	33.566738
Rg4	B#4	B#5	397.555725
Rg5	B#2	B#6	449.655212
Rg6	B#4	B#7	449.655212
Rg7	A#1	A#2	397.555725
Rg8	A#2	A#3	25.675138
Rg9	A#3	A#4	27.660566
Rg10	A#4	A#5	397.555725
Rg11	A#2	A#6	449.655212
Rg12	A#4	A#7	449.655212
Rf1	B#8	B	1.409262
Rf2	B#3	B#10	161.642059
Rf3	B#8	B#10	1.528014
Rf4	B#11	B	1.409262
Rf5	B#10	B#11	13.140918
Rf6	A#3	A	166.137894
Rf7	Y#1	Y#2	31.284834
Rf8	Y#2	Y#3	91.147858
Rf9	Y#2	Y	53.056202
Rf10	Y	Y#4	62.854965
Rf11	a_27_74#	a_27_74##3	110.450302
Rf12	a_27_74##3	a_27_74##4	110.881973
Rf13	a_27_74##2	a_27_74##3	7.500000
Rf14	VPWR#1	VPWR#2	94.354248
Rf15	VPWR#2	VPWR#3	119.425453
Rf16	VPWR#2	VPWR#4	35.032631
Rf17	VGND#1	VGND#2	35.770210
Rf19	VGND#2	VGND#4	35.098007
Re1	VPWR#2	VPWR	1.964508
Re2	VGND	VGND#1	1.964582
*
*       CAPACITOR CARDS
*
*
C1	VGND	VNB	6.02769e-17
C2	VPWR	VNB	5.01801e-17
C3	Y	VNB	5.86175e-17
C4	B	VNB	1.84011e-17
C5	A	VNB	6.87429e-18
C6	VGND	Y	3.9246e-18
C7	VGND	B	2.81885e-18
C8	B#3	VNB	4.00107e-17
C9	VPWR	Y	1.93287e-18
C10	VGND	A	2.66177e-18
C11	VGND#1	VNB	1.75049e-16
C12	VPWR	B	3.42574e-18
C13	VPWR#2	VNB	1.58793e-16
C14	VPWR	A	2.43703e-18
C15	B#7	VNB	4.09708e-17
C16	VGND	B#3	1.22404e-18
C17	B#6	VNB	2.82565e-17
C18	A#7	VNB	2.92962e-17
C19	A	Y	2.99606e-17
C20	A#6	VNB	3.88654e-17
C21	VGND	VGND#1	3.01623e-17
C22	B#5	VNB	3.40167e-17
C23	VPWR	B#3	1.15815e-18
C24	B#1	VNB	2.573e-17
C25	B	A	3.79515e-17
C26	A#5	VNB	2.96911e-17
C27	A#1	VNB	3.38969e-17
C28	VPWR#3	VNB	8.28525e-17
C29	Y#3	VNB	2.29714e-18
C30	Y	B#3	3.75381e-19
C31	VPWR#4	VNB	2.33881e-19
C32	VPWR	VPWR#2	2.87454e-17
C33	Y#1	VNB	4.72623e-18
C34	VPWR#1	VNB	6.39703e-17
C35	a_27_74##4	VNB	4.48382e-17
C36	VGND	B#5	1.6266e-18
C37	VPWR	B#7	5.15136e-18
C38	B	B#3	2.14121e-17
C39	VGND#4	VNB	2.79685e-18
C40	a_27_74##2	VNB	3.66543e-18
C41	VGND	B#1	1.10853e-18
C42	VPWR	B#6	1.00571e-18
C43	Y#4	VNB	3.79252e-19
C44	VGND	A#5	1.51545e-18
C45	a_27_74#	VNB	3.81228e-17
C46	VPWR	A#7	1.25401e-18
C47	VGND	A#1	2.17762e-18
C48	A	B#3	1.48514e-18
C49	VPWR	A#6	5.01731e-19
C50	VGND	VPWR#3	4.00752e-18
C51	Y	B#7	1.8173e-19
C52	Y#2	VNB	1.67901e-19
C53	Y	B#6	1.06476e-19
C54	Y	A#7	4.8775e-19
C55	VGND	a_27_74##4	1.55453e-17
C56	B	B#7	2.3307e-18
C57	Y	A#6	3.47344e-18
C58	VGND	a_27_74##2	1.70062e-17
C59	VPWR	VPWR#3	3.44964e-17
C60	B	B#6	7.09295e-19
C61	VGND	Y#4	7.91277e-18
C62	VGND	a_27_74#	2.57108e-17
C63	VPWR	Y#3	1.43698e-17
C64	B	A#7	1.46978e-18
C65	VPWR	VPWR#4	2.15787e-17
C66	VPWR	Y#1	1.10857e-17
C67	VPWR	VPWR#1	4.4092e-17
C68	A	B#6	1.26712e-19
C69	A	A#7	1.30923e-18
C70	VPWR#3	Y	1.17677e-18
C71	A	A#6	9.62751e-19
C72	VPWR#2	B#3	5.6364e-20
C73	Y	VPWR#1	2.74588e-17
C74	B	Y#3	1.85479e-17
C75	VPWR	Y#2	3.93894e-18
C76	B#3	B#6	1.37931e-18
C77	Y	a_27_74#	3.118e-17
C78	a_27_74##4	B	1.80168e-17
C79	a_27_74##2	B	2.59933e-17
C80	Y	Y#2	1.18872e-18
C81	VPWR#2	B#7	3.12093e-18
C82	VPWR#2	B#6	1.83922e-18
C83	VPWR#2	A#7	2.12998e-18
C84	Y#4	A	3.11068e-17
C85	B	Y#2	2.94768e-17
C86	B#7	B#6	4.67041e-17
C87	B#3	Y#3	2.37882e-17
C88	VGND#1	B#1	1.16773e-18
C89	VGND#1	A#5	4.43427e-18
C90	B#4	VNB	3.55835e-17
C91	B#6	A#7	4.44186e-17
C92	A	Y#2	3.64993e-17
C93	A#4	VNB	6.2856e-17
C94	VGND#1	A#1	4.48038e-18
C95	a_27_74##4	B#3	1.79136e-18
C96	VGND#4	B#3	1.32568e-18
C97	A#7	A#6	4.76901e-17
C98	a_27_74##2	B#3	2.17401e-17
C99	VPWR#2	VPWR#3	2.56094e-17
C100	Y#3	VPWR#2	1.40113e-17
C101	Y#1	VPWR#2	1.05092e-17
C102	VPWR#3	B#7	3.15046e-17
C103	VPWR#2	VPWR#1	2.99886e-17
C104	VGND#1	a_27_74##2	2.98469e-17
C105	Y#3	B#7	5.52596e-17
C106	VPWR#3	B#6	1.70461e-18
C107	VPWR#4	B#7	2.90342e-18
C108	VGND#1	a_27_74#	6.2569e-17
C109	Y#3	B#6	3.20223e-17
C110	Y#1	B#7	1.54103e-19
C111	VPWR#3	A#7	1.13594e-19
C112	VPWR#4	B#6	4.67415e-17
C113	B#5	B#1	2.75975e-17
C114	Y#3	A#7	3.99616e-19
C115	Y#1	B#6	2.82087e-19
C116	VPWR#3	A#6	1.88709e-19
C117	VPWR#4	A#7	5.21367e-17
C118	Y#3	A#6	1.79423e-19
C119	A#7	Y#1	2.60792e-17
C120	B#1	A#5	4.02524e-17
C121	VPWR#4	A#6	2.7163e-18
C122	VPWR#1	A#7	2.66594e-18
C123	A#6	Y#1	2.28999e-17
C124	VPWR#1	A#6	4.15189e-17
C125	A#5	A#1	2.77427e-17
C126	Y#2	VPWR#2	3.62621e-19
C127	a_27_74##4	B#5	4.17506e-17
C128	Y#2	B#7	2.44984e-19
C129	VGND#4	B#5	3.38132e-17
C130	VPWR#3	Y#3	7.80689e-17
C131	Y#4	A#4	4.95453e-18
C132	a_27_74##4	B#1	7.55035e-19
C133	a_27_74##2	B#5	1.85489e-18
C134	VPWR#3	VPWR#4	1.7987e-18
C135	Y#2	B#6	4.48446e-19
C136	B#1	VGND#4	1.76134e-17
C137	a_27_74##4	A#5	1.79043e-19
C138	Y#3	VPWR#4	5.6734e-17
C139	a_27_74##2	B#1	3.39704e-17
C140	VGND#4	A#5	2.31302e-18
C141	Y#2	A#7	2.11859e-17
C142	Y#4	B#1	1.35993e-18
C143	Y#3	Y#1	8.06243e-19
C144	Y	B#4	1.61628e-19
C145	a_27_74##2	A#5	4.79108e-17
C146	Y	A#4	1.46535e-17
C147	a_27_74#	B#1	2.02452e-19
C148	a_27_74##4	VPWR#3	1.39691e-17
C149	Y#2	A#6	1.97537e-17
C150	VPWR#4	Y#1	4.83975e-17
C151	Y#4	A#5	3.92967e-17
C152	a_27_74##2	A#1	7.04839e-19
C153	a_27_74##4	Y#3	1.34217e-18
C154	a_27_74#	A#5	1.34473e-18
C155	VPWR#4	VPWR#1	2.00249e-18
C156	Y#4	A#1	3.63648e-17
C157	a_27_74#	A#4	5.58937e-19
C158	Y#1	VPWR#1	5.05943e-17
C159	a_27_74#	A#1	3.72709e-17
C160	B	B#4	5.53541e-19
C161	B	A#4	1.16329e-17
C162	a_27_74##4	VGND#4	5.87245e-17
C163	a_27_74##4	a_27_74##2	2.10478e-18
C164	a_27_74##2	VGND#4	5.26672e-17
C165	A	A#4	2.01631e-17
C166	Y#3	Y#2	1.28172e-18
C167	a_27_74##2	Y#4	5.3868e-17
C168	Y#2	VPWR#4	3.04114e-17
C169	a_27_74##2	a_27_74#	2.41391e-18
C170	Y#2	Y#1	5.44276e-18
C171	a_27_74#	Y#4	5.43936e-17
C172	Y#2	VPWR#1	1.07639e-17
C173	a_27_74##2	Y#2	8.72622e-19
C174	Y#4	Y#2	4.90486e-18
C175	B#4	B#3	3.56886e-18
C176	B#3	A#4	2.49924e-17
C177	Y#2	A#4	2.47193e-18
C178	VGND#1	A#4	5.51314e-20
C179	VPWR#2	A#4	4.09423e-20
C180	A#4	Y#1	5.48219e-19
C181	VGND#1	VGND#2	4.38124e-17
C182	VGND#2	A#5	5.50481e-19
C183	VGND#2	a_27_74##4	1.7841e-17
C184	VGND	VGND#2	5.12923e-17
C185	VGND#2	A#1	2.97955e-19
C186	VGND#2	B#5	4.10921e-18
C187	VGND#2	B#1	3.36008e-18
C188	VGND#2	a_27_74##2	1.95075e-18
C189	VGND#2	VNB	4.1563e-17
*
*
.ENDS sky130_fd_sc_hs__nand2_2
*
