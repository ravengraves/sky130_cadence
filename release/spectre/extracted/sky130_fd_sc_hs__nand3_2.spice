* Extracted by Quantus, converted by sky130cad/quantus.py
*
*
*
*                       LINUX           Wed Nov 18 08:46:07 2026
*
*
*
*  PROGRAM  advgen
*
*  Name           : advgen - Quantus - (64-bit)
*  Version        : 25.1.0-p047
*  Build Date     : Thu Dec 11 23:20:30 PST 2025
*
*  HSPICE LIBRARY
*
*  OPERATING_TEMPERATURE 150
*  QRC_TECH_DIR <path>/tech
*
*
*

*
.SUBCKT sky130_fd_sc_hs__nand3_2 VPB VNB VGND VPWR Y C B A
*
*
*  caps2d version: 10
*
*
*       TRANSISTOR CARDS
*
*
XM3 VGND#4 C#4 a_27_74##4 VNB sky130_fd_pr__nfet_01v8_lvt l=0.15 w=0.74 ad=0.2072 as=0.1998 pd=2.04 ps=2.02
XM4 a_27_74##2 C#5 VGND#4 VNB sky130_fd_pr__nfet_01v8_lvt l=0.15 w=0.74 ad=0.2072 as=0.2072 pd=2.04 ps=2.04
XM5 a_27_74##2 B#3 a_283_74##2 VNB sky130_fd_pr__nfet_01v8_lvt l=0.15 w=0.74 ad=0.2072 as=0.35395 pd=2.04 ps=2.75
XM9 a_283_74##2 A#5 Y#6 VNB sky130_fd_pr__nfet_01v8_lvt l=0.15 w=0.74 ad=0.35395 as=0.2072 pd=2.75 ps=2.04
XM11 Y#6 A#6 a_283_74# VNB sky130_fd_pr__nfet_01v8_lvt l=0.15 w=0.74 ad=0.2072 as=0.35835 pd=2.04 ps=2.75
XM8 a_283_74# B#4 a_27_74# VNB sky130_fd_pr__nfet_01v8_lvt l=0.15 w=0.74 ad=0.35835 as=0.1998 pd=2.75 ps=2.02
XM0 VPWR#5 C#6 Y#2 VPB sky130_fd_pr__pfet_01v8 l=0.15 w=1.12 ad=0.3304 as=0.336 pd=2.83 ps=2.84
XM7 Y#2 C#1 VPWR#7 VPB sky130_fd_pr__pfet_01v8 l=0.15 w=1.12 ad=0.336 as=0.392 pd=2.84 ps=2.94
XM10 VPWR#7 B#1 Y#4 VPB sky130_fd_pr__pfet_01v8 l=0.15 w=1.12 ad=0.392 as=0.3416 pd=2.94 ps=2.85
XM2 Y#4 A#7 VPWR#6 VPB sky130_fd_pr__pfet_01v8 l=0.15 w=1.12 ad=0.3416 as=0.3864 pd=2.85 ps=2.93
XM6 VPWR#6 A#1 Y#1 VPB sky130_fd_pr__pfet_01v8 l=0.15 w=1.12 ad=0.3864 as=0.336 pd=2.93 ps=2.84
XM1 Y#1 B#6 VPWR#1 VPB sky130_fd_pr__pfet_01v8 l=0.15 w=1.12 ad=0.336 as=0.3304 pd=2.84 ps=2.83
*
*
*       RESISTOR AND CAP/DIODE CARDS
*
Rg1	C#1	C#2	520.436951
Rg2	C#2	C#3	52.646652
Rg3	C#3	C#4	302.425262
Rg4	C#2	C#5	338.557648
Rg5	C#3	C#6	486.547119
Rg6	B#1	B#2	434.639221
Rg7	B#2	B#3	382.539734
Rg8	A#1	A#2	456.635498
Rg9	A#2	A#3	36.503120
Rg10	A#3	A#4	25.691843
Rg11	A#4	A#5	365.993317
Rg12	A#2	A#6	401.193207
Rg13	A#4	A#7	449.655212
Rg14	B#4	B#5	333.761475
Rg15	B#5	B#6	447.963806
Rf1	C	C#7	0.980415
Rf2	C#8	C#3	161.213211
Rf3	C#7	C#8	11.648439
Rf4	A#3	A	166.137894
Rf5	a_283_74#	a_283_74##2	101.589485
Rf6	Y#1	Y	84.823212
Rf7	Y	Y#3	59.576561
Rf8	Y	Y#5	8.280250
Rf9	Y#5	Y	6.397182
Rf10	Y#3	Y#6	155.207840
Rf11	Y#2	Y#3	5.000000
Rf12	Y#4	Y#5	7.500000
Rf13	B#5	B	277.235504
Rf14	B	B#2	165.770813
Rf15	a_27_74#	a_27_74##3	138.344925
Rf16	a_27_74##3	a_27_74##4	71.961494
Rf17	a_27_74##2	a_27_74##3	7.500000
Rf18	VPWR#1	VPWR#2	115.584740
Rf19	VPWR#2	VPWR#3	36.500717
Rf20	VPWR#3	VPWR#4	35.827560
Rf21	VPWR#4	VPWR#5	117.729355
Rf22	VPWR#2	VPWR#6	32.735970
Rf23	VPWR#4	VPWR#7	38.050537
Rf24	VGND#1	VGND#2	71.930206
Rf26	VGND#2	VGND#4	31.161278
Re1	VPWR#3	VPWR	1.403190
Re2	VGND	VGND#1	1.403242
*
*       CAPACITOR CARDS
*
*
C1	A#4	B#6	7.01695e-19
C2	VPWR#4	VPWR#2	1.0194e-18
C3	a_27_74#	A#4	1.70775e-18
C4	C#8	VPWR#4	4.73563e-20
C5	a_283_74#	A#4	3.4984e-19
C6	VGND#1	A#4	5.92547e-20
C7	Y#6	A#4	1.6784e-17
C8	A#4	B#5	3.7647e-17
C9	Y#6	C#2	3.98743e-18
C10	B#5	C#2	6.53527e-19
C11	a_283_74##2	A#4	2.27715e-19
C12	VPWR#2	VPWR#1	1.14185e-18
C13	a_27_74##2	A#4	4.8803e-19
C14	Y#1	VPWR#2	1.50277e-17
C15	C#8	Y#6	1.24741e-17
C16	VPWR#4	VPWR#6	1.42429e-19
C17	B#2	A#4	3.9798e-17
C18	a_27_74#	a_283_74#	5.89095e-17
C19	C#2	B#2	3.39676e-17
C20	Y#4	VPWR#4	6.01944e-19
C21	a_27_74#	Y#6	1.82638e-17
C22	Y#4	VPWR#2	4.68179e-19
C23	a_27_74##2	C#8	3.75654e-18
C24	a_283_74#	Y#6	6.58394e-19
C25	Y#2	VPWR#4	1.69972e-17
C26	a_27_74##2	a_27_74#	2.1885e-18
C27	a_27_74##4	C#8	1.99156e-17
C28	C#3	C#2	4.74226e-18
C29	Y#6	a_283_74##2	2.09704e-18
C30	a_283_74#	a_27_74##2	3.96468e-18
C31	VPWR#5	VPWR#4	7.43786e-19
C32	a_27_74##4	C#7	2.68518e-17
C33	Y#6	a_27_74##2	9.77892e-17
C34	a_27_74##2	a_283_74##2	6.52958e-17
C35	a_27_74#	VPWR#1	7.46995e-18
C36	VGND#4	a_283_74##2	3.16541e-18
C37	a_27_74##4	Y#6	2.54528e-18
C38	a_27_74##2	VGND#4	3.77193e-17
C39	a_27_74##4	a_27_74##2	2.99273e-18
C40	a_27_74##4	VGND#4	3.58193e-17
C41	C#8	Y#2	3.68903e-17
C42	C#8	VPWR#5	3.16899e-19
C43	Y#1	A#4	1.61734e-19
C44	C#7	VPWR#5	1.75116e-17
C45	Y#6	Y#2	1.6126e-18
C46	Y#1	VPWR#1	5.42329e-17
C47	a_27_74#	B#4	4.81464e-17
C48	VPWR#6	VPWR#1	1.56532e-18
C49	B#4	a_283_74#	2.69357e-17
C50	a_27_74##2	Y#2	3.33652e-18
C51	a_27_74#	A#6	2.48453e-17
C52	A#4	VPWR#6	1.32464e-18
C53	Y#6	B#4	3.70445e-18
C54	Y#1	VPWR#6	4.55262e-17
C55	VPWR#2	B#6	2.46493e-18
C56	a_283_74#	A#6	2.79457e-17
C57	a_27_74#	A#5	6.03352e-19
C58	VPWR#4	A#1	1.00303e-19
C59	Y#4	Y#1	2.50552e-18
C60	VPWR#1	VPWR#7	1.35227e-20
C61	Y#6	A#6	2.5364e-17
C62	VPWR#2	A#1	1.23851e-18
C63	a_27_74##2	B#4	9.00143e-19
C64	A	A#4	2.1112e-17
C65	a_27_74#	B#3	3.76347e-19
C66	Y#4	VPWR#6	3.30342e-17
C67	Y#6	A#5	3.00876e-17
C68	a_27_74##4	VPWR#5	3.09931e-19
C69	VPWR#4	A#7	3.365e-19
C70	a_27_74##2	A#6	6.95068e-19
C71	VPWR#7	VPWR#6	1.92059e-18
C72	a_283_74##2	A#5	2.69534e-17
C73	VPWR#2	A#7	1.57426e-18
C74	a_27_74#	C#5	2.52088e-19
C75	Y#6	B#3	9.29806e-18
C76	Y#4	A#4	4.50178e-19
C77	a_27_74##2	A#5	1.67272e-17
C78	Y#4	VPWR#7	1.31449e-17
C79	VPWR#4	B#1	4.12898e-18
C80	B#3	a_283_74##2	2.30313e-17
C81	Y#6	C#5	6.21833e-18
C82	VGND#4	A#5	2.51493e-19
C83	Y#2	Y#4	2.81393e-18
C84	a_27_74##2	B#3	3.73141e-17
C85	a_283_74##2	C#5	1.22913e-18
C86	a_27_74##4	A#5	2.36263e-19
C87	VPWR#4	C#1	4.76138e-18
C88	Y#2	VPWR#7	6.17389e-17
C89	VGND#4	B#3	1.85104e-18
C90	Y#6	C#4	2.553e-18
C91	a_27_74##2	C#5	3.24007e-17
C92	a_27_74##4	B#3	5.62129e-19
C93	VPWR#5	VPWR#7	1.86516e-18
C94	VGND#4	C#5	2.70584e-17
C95	VPWR#4	C#6	2.97024e-18
C96	a_27_74##2	C#4	7.97941e-19
C97	VPWR#5	Y#2	8.79934e-17
C98	a_27_74##4	C#5	2.69366e-18
C99	VGND#4	C#4	2.75712e-17
C100	a_27_74##4	C#4	3.27034e-17
C101	VPWR#3	VPWR#4	3.65729e-17
C102	VPWR#3	VPWR#2	3.81778e-17
C103	A#6	B#4	2.31572e-17
C104	VPWR#1	B#6	3.14917e-17
C105	Y#2	A#4	2.41555e-19
C106	Y#1	B#6	4.54979e-17
C107	VPWR#1	A#1	1.92452e-18
C108	A#5	A#6	3.90493e-17
C109	VPWR#6	B#6	2.30548e-18
C110	Y#1	A#1	3.16848e-17
C111	Y#4	B#6	3.06192e-19
C112	Y#2	C#2	8.58388e-18
C113	VPWR#1	A#7	4.66066e-19
C114	B#5	VPWR#2	5.71064e-19
C115	VPWR#6	A#1	4.48206e-17
C116	Y#1	A#7	4.16081e-19
C117	B#3	A#5	2.3468e-17
C118	Y#4	A#1	6.76297e-19
C119	VPWR#1	B#1	2.52004e-19
C120	A#7	VPWR#6	2.85793e-17
C121	Y#2	B#6	3.28767e-19
C122	VPWR#7	A#1	1.51349e-19
C123	Y#4	A#7	4.55836e-17
C124	VPWR#1	C#1	2.95459e-19
C125	Y#2	A#1	3.65384e-19
C126	VPWR#6	B#1	7.7746e-19
C127	C#5	B#3	3.81992e-17
C128	VPWR#7	A#7	3.27546e-19
C129	Y#4	B#1	4.86163e-17
C130	VGND#1	a_27_74#	1.91636e-17
C131	Y#2	A#7	6.94423e-19
C132	VPWR#6	C#1	2.81749e-19
C133	B#1	VPWR#7	1.79697e-17
C134	VGND#1	a_283_74#	5.38632e-17
C135	Y#4	C#1	6.8781e-19
C136	C#4	C#5	3.85528e-17
C137	Y#2	B#1	6.00671e-18
C138	VPWR#4	C#3	8.32097e-20
C139	B#5	a_27_74#	3.80117e-17
C140	C#1	VPWR#7	3.07617e-17
C141	VGND#1	a_283_74##2	4.92896e-17
C142	VPWR#5	B#1	2.54733e-19
C143	B#5	a_283_74#	3.22436e-19
C144	VGND#1	a_27_74##2	3.45197e-18
C145	Y#2	C#1	7.50862e-17
C146	Y#6	B#5	1.08216e-18
C147	VPWR#3	VPWR#1	2.43822e-17
C148	VPWR#7	C#6	6.97137e-19
C149	VPWR#5	C#1	1.22325e-18
C150	Y#2	C#6	5.85241e-17
C151	VPWR#5	C#6	3.52818e-17
C152	C#8	C#3	3.12437e-17
C153	B#5	VPWR#1	5.78463e-17
C154	Y#6	B#2	5.41573e-17
C155	B#5	Y#1	4.78495e-17
C156	a_283_74##2	B#2	3.50503e-19
C157	A#1	B#6	4.61459e-17
C158	VPWR#3	VPWR#5	2.54254e-17
C159	a_27_74##2	B#2	1.36426e-18
C160	A#7	A#1	3.78603e-17
C161	a_27_74##2	C#3	2.0956e-18
C162	Y#2	B#5	1.13337e-18
C163	VGND#1	B#4	5.70155e-18
C164	C#3	VGND#4	1.63189e-18
C165	B#2	Y#1	3.30567e-18
C166	VGND#1	A#6	3.82681e-18
C167	a_27_74##4	C#3	1.25092e-18
C168	B#2	VPWR#6	1.86236e-18
C169	VGND#1	A#5	3.82681e-18
C170	B#1	A#7	4.51543e-17
C171	B#2	Y#4	6.99243e-17
C172	A#6	B#5	5.59263e-19
C173	VGND#1	B#3	7.14969e-18
C174	B#2	VPWR#7	1.00395e-18
C175	Y#2	B#2	5.22217e-17
C176	C#1	B#1	3.75882e-17
C177	A#4	VNB	4.886e-17
C178	Y#2	C#3	4.42343e-18
C179	C#2	VNB	1.77384e-17
C180	B#2	A#5	7.01663e-19
C181	C#6	C#1	4.9098e-17
C182	a_27_74#	A	2.0028e-18
C183	VPWR#3	A#7	1.51597e-18
C184	B#5	B#6	1.24696e-17
C185	Y#6	A	2.64447e-17
C186	VPWR#3	B#1	1.60802e-18
C187	B#5	A#1	2.1195e-17
C188	B#5	A#7	3.53957e-19
C189	B#5	B#1	7.74369e-20
C190	B#2	B#6	1.13652e-19
C191	B#2	A#1	2.4998e-19
C192	B#2	A#7	1.6569e-17
C193	B#2	B#1	1.01027e-17
C194	C#1	B#2	5.21186e-18
C195	VPWR	VPWR#4	3.4522e-17
C196	VPWR	VPWR#2	2.43137e-17
C197	VGND#1	B#5	8.72083e-20
C198	VPWR	C#8	2.98578e-18
C199	VGND#1	B#2	3.77185e-20
C200	VPWR	C#7	1.75392e-18
C201	A	B#6	5.0859e-19
C202	B#2	B#5	2.21285e-18
C203	Y	VPWR#6	2.04072e-17
C204	Y	Y#4	1.67159e-19
C205	A	A#1	1.62361e-18
C206	VPWR#7	Y	1.73962e-17
C207	A	A#7	9.06811e-19
C208	A	B#1	1.30102e-19
C209	VPWR	VPWR#1	3.57226e-17
C210	VGND	C#8	2.40673e-18
C211	VPWR	Y#1	1.52281e-17
C212	VGND	C#7	2.19922e-18
C213	VPWR	VPWR#6	1.72368e-17
C214	VGND	a_27_74#	2.60397e-17
C215	VPWR#4	C#2	2.14386e-21
C216	VGND	a_283_74#	2.27219e-17
C217	VPWR	Y#4	3.06837e-18
C218	VGND	Y#6	1.06406e-17
C219	VGND	a_283_74##2	2.1212e-17
C220	VPWR#4	VNB	2.83709e-17
C221	VPWR	Y#2	1.91587e-17
C222	VPWR#2	VNB	2.95437e-17
C223	VGND	a_27_74##2	2.59951e-17
C224	VPWR	VPWR#5	3.45237e-17
C225	VGND	VGND#4	1.58187e-17
C226	C#2	B#3	4.39193e-18
C227	VGND	a_27_74##4	1.54151e-17
C228	VGND	VPWR#1	2.56213e-18
C229	Y	A#1	3.93337e-19
C230	A	B#5	2.95581e-17
C231	C#7	VNB	2.59568e-17
C232	a_27_74#	VNB	3.89745e-17
C233	Y	A#7	1.15212e-17
C234	VGND	Y#2	2.60686e-18
C235	a_283_74#	VNB	8.41232e-18
C236	Y#6	VNB	4.17099e-18
C237	VGND	VPWR#5	3.31662e-18
C238	Y	B#1	9.14852e-18
C239	a_283_74##2	VNB	3.13599e-18
C240	VGND	B#4	7.7441e-18
C241	a_27_74##2	VNB	4.94953e-18
C242	Y	C#1	4.3359e-19
C243	B#2	A	5.11984e-17
C244	VPWR	B#6	2.86912e-18
C245	VGND#4	VNB	2.41253e-18
C246	a_27_74##4	VNB	3.53271e-17
C247	VPWR	A#1	5.75353e-19
C248	VPWR#1	VNB	8.13458e-17
C249	VGND	B#3	2.27682e-18
C250	VPWR	A#7	4.46209e-19
C251	Y#1	VNB	2.36613e-18
C252	VGND	C#5	8.46878e-19
C253	VPWR#6	VNB	7.15677e-19
C254	VPWR	B#1	6.24539e-19
C255	VGND	C#4	1.54944e-18
C256	Y	VPWR#3	1.66842e-17
C257	VPWR#7	VNB	2.74344e-18
C258	VPWR	C#1	5.8113e-21
C259	Y#2	VNB	2.80535e-18
C260	VPWR	C#6	2.12769e-18
C261	VPWR#5	VNB	7.96274e-17
C262	B#4	VNB	3.60899e-17
C263	A#6	VNB	2.42599e-17
C264	A#5	VNB	2.64952e-17
C265	VPWR	VPWR#3	8.28358e-18
C266	B#3	VNB	3.0731e-17
C267	C#5	VNB	2.16699e-17
C268	C#4	VNB	3.07794e-17
C269	VPWR	B#5	6.92092e-18
C270	B#6	VNB	4.03414e-17
C271	A#1	VNB	2.97836e-17
C272	VPWR	B#2	5.82986e-18
C273	A#7	VNB	3.09782e-17
C274	VGND	VGND#1	4.63495e-17
C275	B#1	VNB	3.39079e-17
C276	VGND	B#5	4.21219e-18
C277	C#1	VNB	3.50814e-17
C278	C#6	VNB	4.75176e-17
C279	VGND	B#2	3.92551e-18
C280	VPWR#3	VNB	1.66394e-16
C281	VGND	C#3	1.99248e-20
C282	VGND#1	VNB	2.30594e-16
C283	B#5	VNB	5.91108e-17
C284	VPWR	A	1.91025e-18
C285	B#2	VNB	3.12285e-17
C286	C#3	VNB	4.2279e-17
C287	VGND	A	2.52889e-18
C288	VPWR	Y	1.53472e-17
C289	A	VNB	2.89515e-18
C290	Y	VNB	2.12858e-18
C291	VPWR	VNB	5.74554e-17
C292	VGND	VNB	6.89479e-17
C293	VGND#2	C#5	1.2017e-18
C294	VGND	VGND#2	3.11581e-17
C295	VGND#1	VGND#2	5.31956e-17
C296	VGND#2	C#4	1.2017e-18
C297	VGND#2	a_27_74##4	1.79732e-17
C298	VGND#2	VNB	4.8099e-17
C299	VGND#2	a_27_74##2	1.17217e-17
*
*
.ENDS sky130_fd_sc_hs__nand3_2
*
