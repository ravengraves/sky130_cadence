* Extracted by Quantus, converted by sky130cad/quantus.py
*
*
*
*                       LINUX           Wed Nov 18 09:14:08 2026
*
*
*
*  PROGRAM  advgen
*
*  Name           : advgen - Quantus - (64-bit)
*  Version        : 25.1.0-p047
*  Build Date     : Thu Dec 11 23:20:30 PST 2025
*
*  HSPICE LIBRARY
*
*  OPERATING_TEMPERATURE 150
*  QRC_TECH_DIR <path>/tech
*
*
*

*
.SUBCKT sky130_fd_sc_hs__xnor2_1 VNB VPB VGND VPWR Y A B
*
*
*  caps2d version: 10
*
*
*       TRANSISTOR CARDS
*
*
XM4 VGND#4 A#4 a_112_119# VNB sky130_fd_pr__nfet_01v8_lvt l=0.15 w=0.64 ad=0.176 as=0.1344 pd=1.83 ps=1.7
XM2 a_112_119# B#3 a_138_385##7 VNB sky130_fd_pr__nfet_01v8_lvt l=0.15 w=0.64 ad=0.1344 as=0.176 pd=1.7 ps=1.83
XM6 a_293_74##2 A#3 VGND#5 VNB sky130_fd_pr__nfet_01v8_lvt l=0.15 w=0.74 ad=0.2035 as=0.364 pd=2.03 ps=2.69
XM3 VGND#5 B#4 a_293_74# VNB sky130_fd_pr__nfet_01v8_lvt l=0.15 w=0.74 ad=0.364 as=0.2072 pd=2.69 ps=2.04
XM1 a_293_74# a_138_385# Y#1 VNB sky130_fd_pr__nfet_01v8_lvt l=0.15 w=0.74 ad=0.2072 as=0.2294 pd=2.04 ps=2.1
XM5 VPWR#4 A#5 a_138_385##6 VPB sky130_fd_pr__pfet_01v8 l=0.15 w=0.84 ad=0.2898 as=0.252 pd=2.37 ps=2.28
XM7 a_138_385##6 B#1 VPWR#3 VPB sky130_fd_pr__pfet_01v8 l=0.15 w=0.84 ad=0.252 as=0.57565 pd=2.28 ps=3.42
XM0 VPWR#3 A#1 a_376_368# VPB sky130_fd_pr__pfet_01v8 l=0.15 w=1.12 ad=0.57565 as=0.3024 pd=3.42 ps=2.78
XM8 a_376_368# B#6 Y#2 VPB sky130_fd_pr__pfet_01v8 l=0.15 w=1.12 ad=0.3024 as=0.4704 pd=2.78 ps=3.08
XM9 Y#2 a_138_385##3 VPWR#1 VPB sky130_fd_pr__pfet_01v8 l=0.15 w=1.12 ad=0.4704 as=0.3304 pd=3.08 ps=2.83
*
*
*       RESISTOR AND CAP/DIODE CARDS
*
Rg1	B#1	B#2	354.298584
Rg2	B#2	B#3	345.139679
Rg3	A#1	A#2	429.626282
Rg4	A#2	A#3	377.526794
Rg5	A#3	A#4	1415.437500
Rg6	A#4	A#5	816.221252
Rg7	B#4	B#5	382.539734
Rg8	B#5	B#6	434.639221
Rg9	a_138_385#	a_138_385##2	353.846649
Rg10	a_138_385##2	a_138_385##3	456.846832
Rf1	A	A#2	166.137894
Rf2	B#5	B	276.972473
Rf3	B	B#2	162.362122
Rf4	a_293_74#	a_293_74##2	92.300278
Rf5	a_138_385##2	a_138_385##5	302.875122
Rf6	a_138_385##5	a_138_385##6	102.485260
Rf7	a_138_385##5	a_138_385##7	14.213134
Rf8	Y#1	Y#3	142.179001
Rf9	Y#3	Y	7.034359
Rf10	Y#2	Y#3	5.000000
Rf11	VPWR#1	VPWR#2	128.816925
Rf12	VPWR#2	VPWR#3	35.819977
Rf13	VPWR#2	VPWR#4	142.915268
Rf15	VGND#2	VGND#3	30.656675
Rf16	VGND#3	VGND#4	141.000763
Rf17	VGND#2	VGND#5	26.240368
Re1	VPWR#2	VPWR	1.403190
Re2	VGND	VGND#3	1.403242
*
*       CAPACITOR CARDS
*
*
C1	a_138_385##5	Y#1	1.47988e-21
C2	a_138_385##5	a_293_74##2	7.56832e-17
C3	a_138_385##5	a_138_385##7	1.84384e-18
C4	a_293_74#	Y#1	2.782e-17
C5	VGND#4	a_138_385##5	4.9409e-17
C6	VGND#5	Y#1	4.50651e-18
C7	a_293_74#	VGND#5	1.74253e-17
C8	a_293_74##2	a_293_74#	2.3772e-18
C9	a_293_74##2	VGND#5	2.42825e-17
C10	a_138_385##5	a_138_385##6	2.91366e-18
C11	VGND#4	VGND#5	3.59029e-18
C12	VGND#4	a_293_74##2	2.67268e-18
C13	a_138_385##5	a_138_385#	3.33411e-19
C14	a_138_385##5	B#4	4.99595e-19
C15	a_138_385##5	A#3	3.14793e-17
C16	a_138_385##5	B#3	3.37773e-17
C17	Y#1	a_138_385#	2.25901e-17
C18	a_293_74#	a_138_385#	2.96719e-17
C19	a_138_385##5	A#4	1.69526e-17
C20	Y#1	B#4	2.70531e-18
C21	VGND#5	a_138_385#	3.85473e-18
C22	a_293_74#	B#4	3.95571e-17
C23	Y#1	A#3	1.29516e-18
C24	B#4	VGND#5	2.56499e-17
C25	VPWR#3	VPWR#1	6.509e-19
C26	a_293_74#	A#3	9.53806e-19
C27	Y#1	B#3	4.20047e-19
C28	a_293_74##2	B#4	9.53806e-19
C29	A#3	VGND#5	2.97217e-17
C30	VGND#4	VPWR#4	1.35936e-17
C31	a_293_74##2	A#3	5.29637e-17
C32	VGND#5	B#3	1.0573e-18
C33	a_293_74##2	B#3	2.26312e-18
C34	VGND#4	B#4	4.66552e-19
C35	VGND#5	A#4	1.12092e-18
C36	a_138_385##6	VPWR#3	2.17888e-17
C37	B#3	a_138_385##7	2.032e-17
C38	a_293_74##2	A#4	7.07629e-19
C39	VGND#4	A#3	1.09753e-18
C40	VPWR#4	VPWR#3	5.54224e-18
C41	VGND#4	B#3	7.54913e-18
C42	VPWR#4	a_138_385##6	8.62394e-17
C43	a_138_385##5	A#5	3.24922e-18
C44	VGND#4	A#4	6.07656e-17
C45	VPWR#3	A#3	3.71951e-19
C46	B#4	a_138_385#	4.04276e-17
C47	VPWR#1	a_138_385##3	4.19803e-17
C48	a_138_385##3	Y#2	1.14923e-17
C49	VPWR#1	B#6	1.85324e-18
C50	VGND#3	a_138_385##5	8.49681e-18
C51	A#3	B#4	2.28093e-17
C52	B#6	Y#2	1.72309e-17
C53	VPWR#1	A#1	4.85563e-19
C54	VPWR#3	a_138_385##3	8.24008e-19
C55	a_138_385##5	a_138_385##2	1.40746e-18
C56	a_138_385##6	a_138_385##3	1.06797e-19
C57	VPWR#3	B#6	5.08445e-18
C58	B#3	A#3	4.93926e-18
C59	VGND#4	A#5	5.82009e-19
C60	a_138_385##6	B#6	1.52524e-19
C61	a_138_385##5	B#5	1.06724e-17
C62	A#4	A#3	1.15774e-18
C63	VPWR#3	A#1	5.80289e-17
C64	a_138_385##6	A#1	2.52337e-18
C65	A#4	B#3	7.15843e-17
C66	a_138_385##2	Y#1	7.57616e-17
C67	B#1	VPWR#3	2.00301e-17
C68	VGND#3	a_293_74##2	1.16077e-17
C69	VPWR#4	A#1	1.31521e-18
C70	a_138_385##5	A#2	6.17291e-18
C71	a_138_385##2	a_293_74#	5.46103e-17
C72	a_138_385##6	B#1	4.62846e-17
C73	a_138_385##2	VGND#5	8.50244e-19
C74	VPWR#3	A#5	1.11165e-18
C75	B#5	Y#1	1.33909e-18
C76	VPWR#4	B#1	1.57442e-18
C77	VPWR#2	VPWR#1	3.98554e-17
C78	a_293_74##2	a_138_385##2	6.52254e-18
C79	a_138_385##6	A#5	5.20037e-17
C80	a_293_74#	B#5	6.06979e-19
C81	a_138_385##5	B#2	8.03112e-17
C82	VGND#3	VGND#4	3.47723e-17
C83	VGND#5	B#5	5.93689e-19
C84	VPWR#4	A#5	3.17528e-17
C85	VPWR#1	a_138_385##2	7.08215e-19
C86	a_138_385##6	VPWR#2	1.05603e-18
C87	a_293_74##2	A#2	4.99083e-19
C88	VPWR#2	VPWR#4	4.27934e-17
C89	B#6	a_138_385##3	2.73501e-17
C90	B#5	Y#2	1.55061e-18
C91	A#4	A#5	3.00117e-19
C92	A#1	B#6	5.46355e-17
C93	B#5	VPWR#3	8.68422e-18
C94	a_138_385##2	a_138_385#	8.25752e-18
C95	VGND#3	A#3	1.98091e-17
C96	A#2	VPWR#3	1.73954e-18
C97	a_138_385##2	B#4	1.81668e-17
C98	B#1	A#1	1.51681e-17
C99	VGND#3	B#3	1.68097e-18
C100	VGND#3	A#4	5.64653e-18
C101	B#2	VPWR#3	3.74441e-17
C102	a_138_385##2	B#3	9.27172e-21
C103	a_138_385##6	B#2	4.74166e-17
C104	A#5	B#1	3.54248e-17
C105	VPWR#2	B#6	5.33885e-18
C106	VPWR#4	B#2	9.51978e-20
C107	a_138_385##5	a_112_119#	1.00832e-18
C108	VPWR#2	A#1	4.08065e-18
C109	A#3	A#2	1.29399e-18
C110	B#3	A#2	1.58013e-19
C111	VPWR#2	B#1	3.27019e-18
C112	A#3	B#2	2.3299e-18
C113	B#5	a_138_385##3	2.48044e-18
C114	B#5	B#6	7.19596e-18
C115	A#4	B#2	1.62212e-17
C116	B#5	A#1	1.55528e-17
C117	B#5	B#1	2.80323e-19
C118	a_138_385##5	A	3.81325e-17
C119	B#2	B#6	1.10265e-19
C120	B#2	A#1	7.11762e-18
C121	B#2	B#1	5.27137e-18
C122	B#5	VPWR#2	1.30484e-18
C123	A#5	B#2	1.87372e-17
C124	B#6	a_376_368#	2.16863e-17
C125	A#1	a_376_368#	6.71487e-18
C126	B#5	a_138_385##2	1.08703e-16
C127	VGND#3	A#2	4.09071e-19
C128	B#2	VPWR#2	2.52492e-18
C129	Y#1	Y	2.12711e-18
C130	a_138_385##2	A#2	2.27101e-20
C131	B#3	a_112_119#	1.22731e-17
C132	VGND#3	B#2	3.481e-19
C133	A#4	a_112_119#	1.05681e-17
C134	A#2	B#5	2.99571e-17
C135	B#2	B#5	2.56665e-18
C136	Y	VPWR#1	1.27301e-16
C137	Y	Y#2	1.62673e-17
C138	B#2	A#2	3.40976e-17
C139	VPWR#3	Y	3.91297e-17
C140	A	A#3	2.13431e-19
C141	a_138_385##6	Y	1.18555e-18
C142	VGND	a_138_385##5	2.30635e-17
C143	B#5	a_376_368#	3.45616e-18
C144	VPWR	VPWR#1	4.80227e-17
C145	VGND	Y#1	1.69287e-17
C146	VGND	a_293_74#	1.41751e-17
C147	VPWR	VPWR#3	2.22054e-17
C148	VGND	VGND#5	2.07104e-17
C149	A	B#6	3.79899e-19
C150	VPWR	a_138_385##6	1.495e-17
C151	VGND	a_293_74##2	1.42908e-17
C152	A	A#1	1.93086e-18
C153	VPWR	VPWR#4	4.65403e-17
C154	VGND	VGND#4	4.24322e-17
C155	Y	a_138_385##3	4.19972e-17
C156	Y	B#6	4.34755e-17
C157	Y	A#1	1.22236e-17
C158	Y	B#1	2.03469e-19
C159	VGND	VPWR#4	3.55563e-18
C160	VPWR	a_138_385##3	6.36973e-19
C161	VGND	a_138_385#	1.82401e-18
C162	VGND	B#4	3.2799e-19
C163	VPWR	B#6	2.19373e-19
C164	VGND	A#3	1.03593e-17
C165	VPWR	A#1	6.47831e-19
C166	Y	VPWR#2	1.99364e-17
C167	VGND	B#3	5.37047e-18
C168	A	B#5	5.15443e-17
C169	VPWR	B#1	8.33453e-18
C170	VGND	A#4	1.28053e-17
C171	VPWR	A#5	8.24688e-18
C172	A	A#2	1.97418e-17
C173	a_138_385##2	Y	3.13474e-17
C174	a_138_385##5	VNB	1.6701e-17
C175	B#2	A	5.93074e-17
C176	B#5	Y	6.31576e-17
C177	VPWR	VPWR#2	3.8803e-17
C178	Y#1	VNB	6.39108e-17
C179	VPWR	a_138_385##2	2.43103e-18
C180	VGND#5	VNB	4.49263e-18
C181	a_293_74##2	VNB	2.99021e-18
C182	VPWR	B#5	6.27914e-18
C183	VGND#4	VNB	7.34307e-17
C184	VPWR#1	VNB	7.60148e-17
C185	VGND	VGND#3	2.81563e-17
C186	VPWR	B#2	7.91938e-18
C187	VPWR#3	VNB	4.78846e-18
C188	VGND	a_138_385##2	9.79977e-18
C189	a_138_385##6	VNB	8.27684e-18
C190	VPWR#4	VNB	9.70051e-17
C191	VGND	B#5	3.79854e-18
C192	a_138_385#	VNB	3.15455e-17
C193	B#4	VNB	2.64806e-17
C194	A#3	VNB	7.81605e-17
C195	B#3	VNB	1.92845e-17
C196	VGND	B#2	3.06855e-18
C197	A#4	VNB	8.30408e-17
C198	a_138_385##3	VNB	3.7453e-17
C199	B#6	VNB	3.26187e-17
C200	A#1	VNB	3.63383e-17
C201	B#1	VNB	3.61112e-17
C202	A#5	VNB	7.25673e-17
C203	VPWR#2	VNB	2.01935e-16
C204	VGND#3	VNB	1.82365e-16
C205	VPWR	A	2.43307e-18
C206	a_138_385##2	VNB	4.50505e-17
C207	B#5	VNB	2.97619e-17
C208	A#2	VNB	2.99394e-17
C209	VPWR	Y	3.0821e-17
C210	B#2	VNB	3.97288e-17
C211	VGND	A	2.54674e-18
C212	VGND	Y	2.8722e-18
C213	A	VNB	2.87371e-18
C214	Y	VNB	2.38782e-17
C215	VPWR	VNB	6.24971e-17
C216	VGND	VNB	5.38204e-17
C217	VGND#2	VNB	5.4493e-17
C218	VGND	VGND#2	3.47951e-17
C219	VGND#2	a_138_385##2	2.02176e-18
C220	VGND#3	VGND#2	6.45564e-17
C221	VGND#2	A#3	5.29214e-19
C222	VGND#2	B#4	3.21752e-18
C223	VGND#2	a_138_385#	7.73749e-18
C224	VGND#2	a_293_74##2	2.08766e-19
C225	VGND#2	a_293_74#	1.09585e-17
C226	VGND#2	Y#1	2.0163e-17
*
*
.ENDS sky130_fd_sc_hs__xnor2_1
*
