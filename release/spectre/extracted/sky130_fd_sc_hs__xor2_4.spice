* Extracted by Quantus, converted by sky130cad/quantus.py
*
*
*
*                       LINUX           Wed Nov 18 09:15:26 2026
*
*
*
*  PROGRAM  advgen
*
*  Name           : advgen - Quantus - (64-bit)
*  Version        : 25.1.0-p047
*  Build Date     : Thu Dec 11 23:20:30 PST 2025
*
*  HSPICE LIBRARY
*
*  OPERATING_TEMPERATURE 150
*  QRC_TECH_DIR <path>/tech
*
*
*

*
.SUBCKT sky130_fd_sc_hs__xor2_4 VNB VPB VGND VPWR X A B
*
*
*  caps2d version: 10
*
*
*       TRANSISTOR CARDS
*
*
XM16 a_160_98##14 A#5 VGND#8 VNB sky130_fd_pr__nfet_01v8_lvt l=0.15 w=0.74 ad=0.2072 as=0.3811 pd=2.04 ps=2.51
XM20 VGND#13 A#1 a_160_98##14 VNB sky130_fd_pr__nfet_01v8_lvt l=0.15 w=0.74 ad=0.4155 as=0.2072 pd=2.98 ps=2.04
XM21 VGND#13 B#7 a_160_98##11 VNB sky130_fd_pr__nfet_01v8_lvt l=0.15 w=0.74 ad=0.4155 as=0.2886 pd=2.98 ps=2.26
XM27 a_160_98##11 B#1 VGND#12 VNB sky130_fd_pr__nfet_01v8_lvt l=0.15 w=0.74 ad=0.2886 as=0.4155 pd=2.26 ps=2.98
XM28 X#8 a_160_98##5 VGND#12 VNB sky130_fd_pr__nfet_01v8_lvt l=0.15 w=0.74 ad=0.4181 as=0.4155 pd=2.61 ps=2.98
XM29 VGND#11 a_160_98##7 X#8 VNB sky130_fd_pr__nfet_01v8_lvt l=0.15 w=0.74 ad=0.44175 as=0.4181 pd=2.96 ps=2.61
XM2 a_877_74##8 A#19 VGND#10 VNB sky130_fd_pr__nfet_01v8_lvt l=0.15 w=0.74 ad=0.2109 as=0.3778 pd=2.05 ps=2.72
XM25 a_877_74##6 A#17 VGND#10 VNB sky130_fd_pr__nfet_01v8_lvt l=0.15 w=0.74 ad=0.2072 as=0.3778 pd=2.04 ps=2.72
XM9 VGND#9 A#15 a_877_74##6 VNB sky130_fd_pr__nfet_01v8_lvt l=0.15 w=0.74 ad=0.3778 as=0.2072 pd=2.72 ps=2.04
XM10 VGND#9 A#7 a_877_74##3 VNB sky130_fd_pr__nfet_01v8_lvt l=0.15 w=0.74 ad=0.3778 as=0.2072 pd=2.72 ps=2.04
XM5 a_877_74##3 B#15 X#7 VNB sky130_fd_pr__nfet_01v8_lvt l=0.15 w=0.74 ad=0.2072 as=0.2072 pd=2.04 ps=2.04
XM13 a_877_74##5 B#14 X#7 VNB sky130_fd_pr__nfet_01v8_lvt l=0.15 w=0.74 ad=0.259 as=0.2072 pd=2.18 ps=2.04
XM11 X#1 B#12 a_877_74##5 VNB sky130_fd_pr__nfet_01v8_lvt l=0.15 w=0.74 ad=0.2072 as=0.259 pd=2.04 ps=2.18
XM12 X#1 B#11 a_877_74# VNB sky130_fd_pr__nfet_01v8_lvt l=0.15 w=0.74 ad=0.2072 as=0.2109 pd=2.04 ps=2.05
XM14 VPWR#14 A#6 a_36_392##4 VPB sky130_fd_pr__pfet_01v8 l=0.15 w=1 ad=0.35 as=0.295 pd=2.7 ps=2.59
XM6 a_36_392##2 A#4 VPWR#14 VPB sky130_fd_pr__pfet_01v8 l=0.15 w=1 ad=0.3 as=0.35 pd=2.6 ps=2.7
XM17 a_160_98##15 B#5 a_36_392##2 VPB sky130_fd_pr__pfet_01v8 l=0.15 w=1 ad=0.3 as=0.3 pd=2.6 ps=2.6
XM0 a_36_392# B#6 a_160_98##15 VPB sky130_fd_pr__pfet_01v8 l=0.15 w=1 ad=0.275 as=0.3 pd=2.55 ps=2.6
XM18 a_514_368##12 a_160_98##9 X#5 VPB sky130_fd_pr__pfet_01v8 l=0.15 w=1.12 ad=0.3136 as=0.336 pd=2.8 ps=2.84
XM3 X#5 a_160_98##8 a_514_368##11 VPB sky130_fd_pr__pfet_01v8 l=0.15 w=1.12 ad=0.336 as=0.336 pd=2.84 ps=2.84
XM22 a_514_368##11 a_160_98##6 X#3 VPB sky130_fd_pr__pfet_01v8 l=0.15 w=1.12 ad=0.336 as=0.336 pd=2.84 ps=2.84
XM7 X#3 a_160_98# a_514_368##8 VPB sky130_fd_pr__pfet_01v8 l=0.15 w=1.12 ad=0.336 as=0.336 pd=2.84 ps=2.84
XM15 VPWR#13 A#13 a_514_368##8 VPB sky130_fd_pr__pfet_01v8 l=0.15 w=1.12 ad=0.5539 as=0.336 pd=3.59 ps=2.84
XM26 a_514_368##6 A#18 VPWR#13 VPB sky130_fd_pr__pfet_01v8 l=0.15 w=1.12 ad=0.336 as=0.5539 pd=2.84 ps=3.59
XM23 VPWR#12 A#16 a_514_368##6 VPB sky130_fd_pr__pfet_01v8 l=0.15 w=1.12 ad=0.54035 as=0.336 pd=3.57 ps=2.84
XM8 a_514_368##3 A#14 VPWR#12 VPB sky130_fd_pr__pfet_01v8 l=0.15 w=1.12 ad=0.336 as=0.54035 pd=2.84 ps=3.57
XM19 VPWR#11 B#16 a_514_368##3 VPB sky130_fd_pr__pfet_01v8 l=0.15 w=1.12 ad=0.336 as=0.336 pd=2.84 ps=2.84
XM1 a_514_368##5 B#18 VPWR#11 VPB sky130_fd_pr__pfet_01v8 l=0.15 w=1.12 ad=0.336 as=0.336 pd=2.84 ps=2.84
XM4 a_514_368##5 B#17 VPWR#10 VPB sky130_fd_pr__pfet_01v8 l=0.15 w=1.12 ad=0.336 as=0.336 pd=2.84 ps=2.84
XM24 VPWR#10 B#8 a_514_368# VPB sky130_fd_pr__pfet_01v8 l=0.15 w=1.12 ad=0.336 as=0.3192 pd=2.84 ps=2.81
*
*
*       RESISTOR AND CAP/DIODE CARDS
*
Rg1	A#1	A#2	418.483002
Rg2	A#2	A#3	53.277996
Rg3	A#2	A#4	403.983215
Rg4	A#3	A#5	348.334229
Rg5	A#3	A#6	448.944031
Rg6	B#1	B#2	400.968689
Rg7	B#2	B#3	35.674755
Rg8	B#3	B#4	34.841248
Rg9	B#4	B#5	451.650787
Rg10	B#3	B#6	366.409058
Rg11	B#4	B#7	370.253540
Rg12	a_160_98#	a_160_98##2	619.053833
Rg13	a_160_98##2	a_160_98##3	126.999847
Rg14	a_160_98##3	a_160_98##4	65.165756
Rg15	a_160_98##4	a_160_98##5	294.476837
Rg16	a_160_98##2	a_160_98##6	405.599640
Rg17	a_160_98##3	a_160_98##7	313.208832
Rg18	a_160_98##3	a_160_98##8	455.591705
Rg19	a_160_98##4	a_160_98##9	415.439758
Rg20	A#7	A#8	389.065216
Rg21	A#8	A#9	117.581406
Rg22	A#9	A#10	79.564171
Rg23	A#10	A#11	36.112568
Rg24	A#11	A#12	57.191422
Rg25	A#12	A#13	448.070740
Rg26	A#8	A#14	467.813843
Rg27	A#9	A#15	394.561310
Rg28	A#9	A#16	446.660797
Rg29	A#10	A#17	394.166779
Rg30	A#10	A#18	446.384979
Rg31	A#12	A#19	394.591675
Rg32	B#8	B#9	449.655212
Rg33	B#9	B#10	73.670235
Rg34	B#9	B#11	397.555725
Rg35	B#10	B#12	381.619690
Rg36	B#10	B#13	64.081955
Rg37	B#13	B#14	387.837799
Rg38	B#14	B#15	758.666138
Rg39	B#15	B#16	875.371155
Rg40	B#10	B#17	429.126801
Rg41	B#13	B#18	449.655212
Rf1	a_36_392#	a_36_392##3	106.897369
Rf2	a_36_392##3	a_36_392##4	100.486130
Rf3	a_36_392##2	a_36_392##3	5.000000
Rf4	a_160_98##4	a_160_98##12	124.455406
Rf5	a_160_98##12	a_160_98##13	16.795691
Rf6	a_160_98##13	a_160_98##14	51.081966
Rf7	a_160_98##13	a_160_98##15	67.341843
Rf8	a_160_98##11	a_160_98##12	15.000000
Rf9	A	A#20	12.671452
Rf10	A#20	A	2.163419
Rf11	A	A#3	433.366913
Rf12	B	B#19	7.945672
Rf13	B#19	B	6.723260
Rf14	B	B#2	474.820068
Rf15	X#1	X#2	31.057766
Rf16	X#2	X	424.824005
Rf17	X	X#4	0.877545
Rf18	X#4	X#5	61.695694
Rf19	X#2	X#6	68.010475
Rf20	X#6	X#7	24.862514
Rf21	X#6	X#8	287.987213
Rf22	X#3	X#4	15.000000
Rf23	a_877_74#	a_877_74##2	84.004982
Rf24	a_877_74##2	a_877_74##4	82.625839
Rf25	a_877_74##2	a_877_74##5	24.862514
Rf26	a_877_74##4	a_877_74##7	68.109215
Rf27	a_877_74##7	a_877_74##8	77.211792
Rf28	a_877_74##3	a_877_74##4	15.000000
Rf29	a_877_74##6	a_877_74##7	15.000000
Rf30	a_514_368#	a_514_368##2	76.474457
Rf31	a_514_368##2	a_514_368##4	79.950478
Rf32	a_514_368##2	a_514_368##5	14.409969
Rf33	a_514_368##4	a_514_368##7	69.683716
Rf34	a_514_368##7	a_514_368##9	71.183586
Rf35	a_514_368##9	a_514_368##10	72.846909
Rf36	a_514_368##10	a_514_368##11	23.752716
Rf37	a_514_368##10	a_514_368##12	91.638283
Rf38	a_514_368##3	a_514_368##4	7.500000
Rf39	a_514_368##6	a_514_368##7	15.000000
Rf40	a_514_368##8	a_514_368##9	15.000000
Rf42	VPWR#2	VPWR#3	17.630161
Rf43	VPWR#3	VPWR#4	51.168163
Rf44	VPWR#4	VPWR#5	67.579994
Rf45	VPWR#5	VPWR#6	75.558197
Rf46	VPWR#6	VPWR#7	121.239288
Rf47	VPWR#7	VPWR#8	185.946335
Rf49	VPWR#2	VPWR#10	48.224632
Rf50	VPWR#4	VPWR#11	37.538910
Rf51	VPWR#5	VPWR#12	22.697315
Rf52	VPWR#6	VPWR#13	22.697315
Rf53	VPWR#8	VPWR#14	39.504013
Rf54	VGND#1	VGND#2	118.317276
Rf55	VGND#2	VGND#3	74.462440
Rf56	VGND#3	VGND#4	81.184509
Rf57	VGND#4	VGND#5	41.396519
Rf58	VGND#5	VGND#6	56.954857
Rf59	VGND#6	VGND#7	82.497993
Rf60	VGND#7	VGND#8	136.850281
Rf61	VGND#2	VGND#9	24.862514
Rf62	VGND#3	VGND#10	24.862514
Rf63	VGND#4	VGND#11	23.238022
Rf64	VGND#6	VGND#12	24.862514
Rf65	VGND#7	VGND#13	24.468842
Rf67	A#11	A#20	53.410934
Rf69	B#10	B#19	53.410934
Re1	VPWR#3	VPWR	3.735117
Re2	VPWR	VPWR#7	1.067176
Re3	VGND#1	VGND	3.735117
Re4	VGND	VGND#5	1.067176
*
*       CAPACITOR CARDS
*
*
C1	a_514_368##8	a_160_98##2	7.02313e-20
C2	X#7	A#17	3.20555e-19
C3	A#15	VGND#9	2.49964e-17
C4	VGND#10	A#7	2.81896e-19
C5	a_160_98##13	B#1	6.91665e-19
C6	VPWR#5	B#16	1.02729e-18
C7	a_514_368##8	X#3	4.1329e-19
C8	X#6	a_877_74##6	6.74231e-17
C9	a_877_74##6	A#15	4.37575e-17
C10	a_514_368##2	B#8	1.64797e-18
C11	VGND#8	a_36_392##4	1.2145e-17
C12	a_877_74##3	A#8	6.59386e-19
C13	a_514_368##2	B#9	1.28622e-20
C14	VPWR#4	B#16	5.85685e-18
C15	X#7	A#19	3.67772e-19
C16	VGND#9	A#17	1.25129e-18
C17	VGND#10	A#15	1.25129e-18
C18	a_514_368##11	a_514_368##8	3.79726e-18
C19	a_160_98##13	B#7	2.34064e-17
C20	VPWR#6	A#14	2.71749e-19
C21	a_877_74##6	A#17	4.21843e-17
C22	VPWR#5	A#14	8.81665e-18
C23	a_514_368##2	B#17	3.50982e-17
C24	VGND#9	A#19	3.80214e-19
C25	X#8	A#7	3.52699e-19
C26	a_160_98##2	X#3	5.6712e-19
C27	A#17	VGND#10	2.41231e-17
C28	VGND#9	A#9	8.6893e-19
C29	VPWR#4	A#14	4.35261e-19
C30	a_160_98##13	A#1	1.03974e-18
C31	VPWR#7	a_160_98##3	2.29302e-20
C32	a_877_74##6	A#19	8.23788e-19
C33	VPWR#6	A#16	1.20535e-18
C34	VPWR#7	a_160_98##2	2.16153e-20
C35	a_877_74##8	A#17	7.64836e-19
C36	X#8	A#15	3.13842e-19
C37	a_514_368##2	B#18	3.15357e-17
C38	VPWR#5	A#16	8.56291e-18
C39	A#19	VGND#10	2.57374e-17
C40	VGND#9	A#8	8.09387e-19
C41	VPWR#7	B#3	2.29389e-19
C42	X#2	B#8	1.94909e-17
C43	X#5	a_514_368##11	2.07947e-17
C44	VPWR#4	A#16	1.15672e-19
C45	a_160_98##13	A#5	3.09926e-19
C46	a_514_368##11	a_160_98##3	4.47665e-19
C47	a_877_74##8	A#19	5.1172e-17
C48	X#8	A#17	7.17235e-19
C49	VPWR#6	A#18	8.8001e-18
C50	a_514_368##12	a_514_368##11	3.35726e-18
C51	a_514_368##2	B#16	1.24917e-18
C52	VPWR#5	A#18	7.32263e-19
C53	a_877_74##6	A#9	1.04066e-18
C54	X#2	B#17	1.28883e-17
C55	a_877_74##8	a_160_98##7	1.52569e-18
C56	VGND#5	a_160_98##3	8.74706e-20
C57	X#8	A#19	2.10022e-17
C58	a_514_368##12	X#5	5.81219e-17
C59	VGND#10	A#12	9.46232e-21
C60	a_160_98##7	VGND#11	1.52334e-17
C61	VPWR#5	VPWR#11	2.27296e-18
C62	VGND#4	a_160_98#	3.87951e-19
C63	VGND#12	A#19	6.96439e-19
C64	VPWR#6	A#13	7.86303e-18
C65	a_877_74##6	A#8	1.35956e-20
C66	a_514_368##2	A#14	2.11095e-19
C67	a_160_98##15	a_514_368##11	1.67007e-21
C68	X#2	B#18	1.26209e-17
C69	X#8	a_160_98##7	4.94257e-17
C70	VPWR#5	A#13	2.72954e-19
C71	B#13	B#10	5.64332e-18
C72	X#5	a_160_98##3	1.68871e-19
C73	B#10	B#9	4.03955e-18
C74	a_877_74#	X#1	2.799e-17
C75	VGND#12	a_160_98##7	1.49256e-18
C76	a_36_392#	a_514_368##12	7.3639e-17
C77	a_514_368##3	VPWR#5	2.2529e-17
C78	a_160_98##5	X#8	2.47558e-17
C79	VPWR#6	a_160_98#	4.97707e-18
C80	B#4	B#3	3.04722e-18
C81	X#2	B#16	5.39429e-18
C82	a_877_74##5	a_877_74#	4.03371e-18
C83	a_514_368##3	B#15	2.9131e-20
C84	a_160_98##5	VGND#12	1.75259e-17
C85	a_877_74##8	A#12	3.29037e-19
C86	a_514_368##3	VPWR#4	7.33452e-18
C87	X#8	B#1	1.33268e-18
C88	a_36_392#	a_160_98##15	7.45523e-17
C89	VPWR#5	VPWR#12	5.21851e-18
C90	a_877_74##2	B#9	1.06612e-19
C91	X#2	A#14	1.43742e-19
C92	VPWR#6	a_160_98##6	2.03279e-19
C93	B#1	VGND#12	2.38011e-17
C94	a_877_74##5	X#1	2.24509e-17
C95	a_36_392##2	a_36_392#	2.59773e-18
C96	a_514_368##6	VPWR#6	3.03688e-17
C97	X#8	B#7	5.6548e-19
C98	A#12	A#11	2.55906e-18
C99	a_160_98##11	B#1	4.23978e-17
C100	a_514_368##2	a_514_368#	3.01982e-18
C101	A#11	A#9	4.08372e-18
C102	VGND#12	B#7	1.72205e-18
C103	a_36_392##2	a_160_98##15	6.23317e-17
C104	X#6	B#13	8.66896e-19
C105	X#7	X#1	2.58478e-18
C106	a_514_368##6	VPWR#5	3.42285e-17
C107	VPWR#6	a_160_98##8	6.99797e-20
C108	X#8	A#1	5.74427e-19
C109	B#7	a_160_98##11	1.74351e-17
C110	VPWR#6	VPWR#13	5.4277e-18
C111	a_514_368##2	VPWR#4	3.08573e-18
C112	VGND#12	A#1	6.64133e-19
C113	B#7	VGND#13	1.84942e-17
C114	a_514_368##2	VPWR#10	3.91385e-17
C115	VGND#8	B#1	3.34303e-19
C116	X#7	a_877_74##5	2.44207e-17
C117	a_514_368##10	a_160_98##6	1.53929e-17
C118	a_36_392##2	VPWR#14	8.02721e-17
C119	VPWR#6	a_160_98##9	4.3135e-20
C120	VGND#12	A#5	3.32137e-19
C121	a_160_98##4	A#12	3.97697e-20
C122	A#1	VGND#13	1.7613e-17
C123	VGND#8	B#7	6.26395e-19
C124	a_36_392##4	a_36_392##2	2.73903e-18
C125	a_514_368##8	VPWR#6	6.84097e-17
C126	a_877_74##3	a_877_74##5	3.06397e-18
C127	a_514_368##2	a_514_368##5	1.06368e-18
C128	a_160_98##14	A#1	3.69404e-17
C129	a_514_368##10	a_160_98##8	1.52735e-17
C130	a_160_98##4	a_160_98##3	1.69422e-17
C131	a_36_392##4	VPWR#14	7.001e-17
C132	a_36_392#	B#4	2.33979e-19
C133	X#8	A#12	1.10706e-18
C134	VGND#8	A#1	1.66715e-18
C135	B#16	B#13	1.32919e-17
C136	a_160_98##4	B#4	2.03156e-19
C137	a_877_74##3	X#7	3.0765e-17
C138	B#3	a_160_98##4	3.49234e-17
C139	A#5	a_160_98##14	1.74974e-17
C140	B#3	a_36_392#	3.64358e-18
C141	a_514_368##2	VPWR#11	4.76905e-17
C142	A#5	VGND#8	2.63579e-17
C143	X#6	A#9	3.43849e-18
C144	X#2	B#13	7.01857e-19
C145	a_514_368##3	a_514_368##2	2.56425e-18
C146	B#2	a_160_98##3	4.62156e-18
C147	A#8	B#16	1.18509e-17
C148	X#2	a_514_368#	5.48483e-17
C149	B#2	a_160_98##2	1.60615e-18
C150	a_160_98##15	B#4	1.33692e-17
C151	a_877_74##3	VGND#9	4.25612e-17
C152	B#2	B#4	5.22302e-20
C153	B#12	B#11	4.0044e-17
C154	B#2	B#3	2.54678e-17
C155	a_160_98##15	B#3	2.50441e-18
C156	X#2	B#9	1.73817e-17
C157	X#6	A#8	2.65077e-18
C158	a_514_368#	B#8	4.52328e-17
C159	a_160_98##13	VGND#13	3.43779e-18
C160	a_877_74##6	a_877_74##3	2.50837e-18
C161	X#2	VPWR#10	1.11029e-18
C162	B#8	VPWR#10	2.73393e-17
C163	X#8	a_160_98##3	8.04657e-19
C164	B#14	B#12	3.15895e-17
C165	a_514_368#	B#17	1.58151e-18
C166	A#9	A#14	7.8687e-19
C167	a_877_74##6	VGND#9	3.33089e-17
C168	B#17	VPWR#10	2.77301e-17
C169	VPWR#11	B#8	2.55839e-19
C170	X#2	a_514_368##5	6.62017e-19
C171	X#8	a_160_98##2	1.70826e-18
C172	A#3	B#4	3.99176e-17
C173	A#3	B#3	7.45685e-19
C174	B#17	a_514_368##5	2.32435e-17
C175	B#15	B#14	3.76346e-17
C176	a_514_368##10	X#3	4.18259e-19
C177	VPWR#10	B#18	6.18947e-19
C178	VGND#10	VGND#9	3.03882e-18
C179	VPWR#11	B#17	3.51409e-19
C180	X#2	VPWR#11	1.11029e-18
C181	B#18	a_514_368##5	2.32435e-17
C182	VPWR#10	B#16	1.45657e-19
C183	B#18	VPWR#11	2.40452e-17
C184	A#7	B#15	4.46793e-17
C185	a_877_74##6	VGND#10	3.37493e-17
C186	a_514_368##10	a_514_368##11	1.08658e-19
C187	a_514_368##3	B#18	6.98866e-19
C188	X#2	a_514_368##3	8.23979e-18
C189	VPWR#11	B#16	3.50482e-17
C190	a_877_74##8	a_877_74##6	2.50837e-18
C191	A#15	A#7	2.01832e-17
C192	a_514_368##3	B#16	4.13738e-17
C193	VPWR#3	VPWR#4	5.23272e-17
C194	a_514_368##10	X#5	1.74825e-17
C195	X#2	A#8	6.15298e-20
C196	X#8	a_160_98#	1.55694e-18
C197	VPWR#11	A#14	1.1196e-18
C198	a_877_74##8	VGND#10	3.31129e-17
C199	a_514_368##3	A#14	4.09659e-17
C200	a_514_368##6	B#16	1.84209e-19
C201	X#8	VGND#9	6.96686e-20
C202	VGND#3	A#12	3.53028e-20
C203	A#17	A#15	3.9033e-17
C204	VPWR#11	A#16	1.83563e-19
C205	A#14	VPWR#12	2.52145e-17
C206	a_514_368##3	A#16	1.26495e-18
C207	a_514_368##6	A#14	5.45141e-19
C208	a_877_74##6	X#8	1.27724e-17
C209	A#16	VPWR#12	2.36708e-17
C210	a_514_368##2	VPWR#3	3.54273e-17
C211	A#19	A#17	2.02338e-17
C212	a_514_368##3	A#18	3.43337e-19
C213	a_514_368##6	A#16	4.73062e-17
C214	a_877_74#	a_514_368#	2.90184e-19
C215	VGND#7	B#4	4.37499e-19
C216	X#8	VGND#10	1.4871e-18
C217	a_514_368##6	A#18	4.68697e-17
C218	a_514_368##3	A#13	2.20776e-19
C219	a_160_98##7	A#19	3.87049e-18
C220	A#18	VPWR#13	2.77239e-17
C221	a_160_98##11	B#3	4.0699e-18
C222	X#8	a_877_74##8	7.55877e-17
C223	a_514_368##10	VPWR#7	6.29268e-17
C224	VPWR#3	X#2	9.36985e-18
C225	VGND#3	A#9	2.94706e-21
C226	VGND#7	B#3	8.28838e-20
C227	a_514_368##6	A#13	7.61456e-19
C228	a_514_368##8	A#18	7.4547e-19
C229	VGND#1	a_877_74##2	1.05609e-16
C230	A#13	VPWR#13	2.77239e-17
C231	VGND#1	X#6	1.61181e-18
C232	a_160_98##5	a_160_98##7	1.2729e-17
C233	X#8	VGND#11	5.37223e-18
C234	a_514_368##8	A#13	5.05827e-17
C235	VGND#1	X#2	5.92073e-18
C236	X#5	A#18	2.30633e-19
C237	a_160_98#	A#12	1.73558e-17
C238	a_514_368##8	a_160_98#	3.84239e-17
C239	a_514_368##11	A#13	2.56775e-19
C240	B#1	a_160_98##5	1.90642e-17
C241	VGND#3	A#11	3.28711e-20
C242	VGND#4	a_160_98##2	1.19264e-18
C243	a_514_368#	B#9	2.21873e-19
C244	a_160_98#	X#3	2.27437e-17
C245	X#5	A#13	3.09843e-19
C246	B#15	B#13	1.65806e-17
C247	VGND#2	A#9	3.58181e-20
C248	VGND#6	B#3	6.3142e-20
C249	a_514_368##11	a_160_98#	5.95277e-19
C250	VPWR#6	A#11	5.03369e-19
C251	a_514_368##8	a_160_98##6	6.09367e-19
C252	X#8	VGND#12	1.47812e-20
C253	VPWR#5	A#11	1.0918e-21
C254	B#7	B#1	2.60616e-17
C255	X#5	a_160_98#	5.93285e-19
C256	a_160_98##6	X#3	2.27437e-17
C257	a_160_98##6	a_514_368##11	2.23417e-17
C258	a_514_368##8	a_160_98##8	2.92243e-19
C259	a_514_368##2	B#10	7.12772e-19
C260	VGND#1	a_877_74#	6.73597e-17
C261	X#5	a_160_98##6	1.86621e-18
C262	VGND#1	X#1	5.8676e-18
C263	A#1	B#7	2.17288e-17
C264	a_877_74##2	B#10	1.4491e-19
C265	a_514_368##12	a_160_98##6	2.87429e-19
C266	a_160_98##8	a_514_368##11	2.43828e-17
C267	X#2	a_514_368##2	7.81495e-17
C268	VGND#1	X#7	8.10296e-18
C269	X#6	B#10	9.87859e-19
C270	X#5	a_160_98##8	4.79846e-17
C271	VPWR#6	A#12	1.29299e-20
C272	VGND#1	a_877_74##3	3.18742e-17
C273	B#9	VPWR#10	4.85886e-19
C274	a_160_98##11	VGND#12	2.48602e-18
C275	X#8	VGND#13	1.51097e-20
C276	X#2	B#10	5.13293e-18
C277	a_514_368##12	a_160_98##8	6.42576e-19
C278	a_160_98##15	a_160_98##6	1.37784e-19
C279	a_514_368##11	a_160_98##9	1.05979e-18
C280	A#5	A#1	4.08386e-17
C281	a_514_368##10	a_160_98##4	1.39068e-19
C282	X#5	a_160_98##9	3.84464e-17
C283	a_877_74##2	X#6	6.8868e-19
C284	A#8	B#15	1.266e-17
C285	X#6	A#11	1.39779e-18
C286	a_160_98##15	a_160_98##8	2.12762e-19
C287	a_514_368##12	a_160_98##9	4.0175e-17
C288	a_514_368##11	B#6	9.34803e-20
C289	VGND#7	A#3	4.88694e-17
C290	VGND#6	A#3	1.62966e-18
C291	a_36_392#	a_160_98##9	1.57224e-18
C292	VGND#2	A#7	2.62909e-18
C293	B#13	a_514_368##5	1.2609e-19
C294	a_160_98##15	a_160_98##9	6.44975e-19
C295	a_514_368##12	B#6	1.51341e-18
C296	a_36_392#	B#6	8.03708e-17
C297	B	B#13	1.65746e-17
C298	B	B#9	1.27362e-17
C299	VPWR#3	a_514_368#	1.82285e-17
C300	B	A#12	8.76277e-20
C301	B#6	a_160_98##15	1.76368e-17
C302	B	A#9	1.49818e-17
C303	B	A#8	2.05662e-17
C304	a_877_74##5	B#10	7.60708e-19
C305	a_36_392##2	B#6	4.00009e-19
C306	VGND#2	A#15	2.89336e-18
C307	a_36_392#	B#5	8.02336e-18
C308	VGND#4	A#17	3.48898e-19
C309	a_160_98##15	B#5	4.19924e-17
C310	a_877_74##2	X#2	8.91233e-19
C311	VPWR#3	a_514_368##3	1.4395e-18
C312	VGND#5	X#8	1.31742e-17
C313	a_36_392##2	B#5	2.48142e-17
C314	B#17	B#8	4.69934e-17
C315	a_36_392#	A#4	2.11095e-19
C316	a_160_98##13	a_160_98##4	5.39259e-18
C317	VGND#3	A#17	2.91947e-18
C318	VGND#2	a_877_74##3	1.2523e-17
C319	a_160_98##15	A#4	2.27395e-18
C320	VGND#8	a_160_98##11	1.04978e-19
C321	a_36_392##2	A#4	5.95907e-17
C322	B#18	B#17	4.5782e-17
C323	VGND#4	A#19	4.03717e-18
C324	A#4	VPWR#14	2.50221e-17
C325	a_877_74##6	A#11	9.24252e-19
C326	a_160_98##15	A#6	6.5021e-19
C327	a_160_98##13	B#2	1.02865e-17
C328	A	A#12	1.93993e-17
C329	VGND#10	A#11	1.42489e-18
C330	a_36_392##4	A#4	1.9897e-18
C331	a_36_392##2	A#6	2.219e-18
C332	A	A#9	7.3228e-18
C333	a_877_74##8	A#11	5.55291e-19
C334	VGND#3	A#19	2.91947e-18
C335	A	a_160_98##3	6.1711e-18
C336	VPWR#5	A#9	2.44226e-19
C337	A	a_160_98##2	1.3286e-17
C338	A#6	VPWR#14	3.13408e-17
C339	B#16	B#18	4.68595e-17
C340	A	B#3	2.86632e-19
C341	X#8	A#11	4.15304e-18
C342	a_36_392##4	A#6	5.56202e-17
C343	VGND#3	a_877_74##6	8.95252e-18
C344	A#3	a_160_98##13	5.57776e-17
C345	VGND#4	a_160_98##7	8.72896e-18
C346	a_514_368##8	VPWR#7	7.21577e-18
C347	VGND#4	VGND#10	2.95156e-18
C348	B#10	VPWR#10	5.17659e-19
C349	B#10	a_514_368##5	4.14819e-19
C350	A#14	B#16	4.74227e-17
C351	a_514_368##2	B#14	4.15754e-20
C352	VGND#7	a_160_98##5	3.63373e-19
C353	X#8	a_160_98##4	6.51703e-19
C354	VPWR#5	A#8	2.215e-19
C355	a_160_98##4	VGND#12	2.7265e-18
C356	VGND#2	a_877_74##6	8.90389e-18
C357	B#3	a_160_98##9	5.10194e-18
C358	VGND#6	a_160_98##5	3.86497e-18
C359	a_877_74##2	B#12	1.59807e-17
C360	a_514_368##12	VPWR#7	5.04045e-17
C361	A#16	A#14	2.71867e-17
C362	X	A#12	2.29152e-20
C363	a_36_392#	VPWR#7	2.42021e-17
C364	a_160_98##13	B#4	1.71123e-17
C365	X	A#9	4.92937e-19
C366	VGND#4	a_160_98##5	1.04434e-18
C367	X	A#8	1.8005e-18
C368	VGND#4	a_877_74##8	1.5795e-17
C369	X	a_160_98##3	2.2291e-19
C370	a_514_368##2	B#15	5.13196e-20
C371	X	a_160_98##2	4.98806e-19
C372	a_160_98##13	a_36_392##2	1.47449e-18
C373	a_160_98##11	B#2	2.35372e-17
C374	X#2	B#11	1.78135e-17
C375	VGND#7	B#1	1.42132e-18
C376	VGND#1	B#11	6.62455e-18
C377	a_160_98##3	A#12	9.4133e-19
C378	A#11	a_514_368##6	7.60122e-19
C379	A#18	A#16	4.65452e-17
C380	VGND#1	B#12	6.59064e-18
C381	A#11	VPWR#13	1.02996e-18
C382	a_877_74##2	B#14	1.44338e-17
C383	VGND#6	B#1	3.89822e-18
C384	VGND#1	B#14	1.18558e-17
C385	a_514_368##8	A#11	2.77612e-19
C386	a_160_98##13	B#3	4.48442e-19
C387	VGND#3	a_877_74##8	1.01196e-17
C388	VGND#1	B#15	1.15656e-17
C389	A#3	a_160_98##11	2.33549e-17
C390	A#13	A#18	2.61082e-17
C391	A#3	VGND#13	4.12891e-18
C392	VGND#4	B#1	3.46516e-19
C393	X#6	B#14	1.31974e-17
C394	VGND#4	VGND#11	9.53354e-18
C395	X#2	B#12	1.68148e-17
C396	A#3	a_160_98##14	1.02235e-16
C397	a_877_74#	B#9	7.55601e-20
C398	A#3	VGND#8	7.71046e-17
C399	VGND#7	B#7	8.98185e-18
C400	a_514_368#	VPWR#10	3.77123e-17
C401	a_877_74##2	B#15	1.64879e-18
C402	a_160_98##4	a_514_368##11	1.11405e-18
C403	a_160_98#	A#13	4.52684e-17
C404	a_160_98##4	X#5	3.91999e-18
C405	VGND#7	VGND#12	4.0706e-18
C406	a_160_98##4	a_514_368##12	5.19549e-18
C407	VPWR	B#4	4.17935e-19
C408	X#6	B#15	1.02004e-17
C409	X#2	B#14	1.70822e-19
C410	B#2	X#3	6.23462e-19
C411	A#9	A#8	3.39159e-18
C412	VGND#4	B#7	8.4842e-20
C413	B#2	a_514_368##11	3.07121e-18
C414	a_160_98##6	a_160_98#	4.59073e-17
C415	VGND#4	X#8	5.23772e-17
C416	B#2	X#5	5.82318e-17
C417	B#2	a_514_368##12	3.58871e-17
C418	VGND#7	A#1	1.04736e-17
C419	a_514_368##3	A#8	1.80136e-19
C420	B#2	a_36_392#	2.66927e-17
C421	VGND#5	a_160_98##7	1.55057e-18
C422	a_160_98##15	B#2	3.23087e-17
C423	a_160_98##8	a_160_98##6	4.65109e-17
C424	a_160_98##7	A#12	3.23823e-19
C425	VPWR#3	B#8	1.35443e-18
C426	X#6	A#7	1.6958e-17
C427	X#2	B#15	3.27535e-19
C428	B#5	B#3	2.32853e-18
C429	VPWR#3	B#17	5.6889e-18
C430	VGND#6	A	6.79829e-18
C431	VPWR#3	B#18	5.02181e-19
C432	A#3	a_160_98##15	8.4702e-18
C433	a_160_98##9	a_160_98##8	4.54552e-17
C434	VGND#12	VGND#4	5.06253e-18
C435	VPWR#11	VPWR#10	1.836e-18
C436	A#3	a_36_392##2	2.63472e-17
C437	X#6	B	1.46602e-16
C438	VPWR#3	B#16	5.84955e-19
C439	A#3	VPWR#14	4.51886e-18
C440	VGND#7	A#5	7.26123e-18
C441	VGND	A#8	1.13417e-20
C442	B	X#2	2.11099e-16
C443	A#3	a_36_392##4	4.44341e-17
C444	B#6	a_160_98##9	6.39019e-18
C445	X#6	A#15	1.78428e-17
C446	a_160_98##4	a_160_98##7	1.74569e-19
C447	VGND#7	VGND#13	5.31101e-18
C448	a_160_98##4	a_160_98##5	4.45264e-18
C449	a_877_74##5	B#13	2.82799e-19
C450	B#1	a_160_98##4	3.12927e-18
C451	B#5	B#6	4.34983e-17
C452	X#6	A	4.34826e-17
C453	a_160_98##4	B#7	4.27898e-19
C454	X#6	A#17	1.75117e-17
C455	a_877_74#	B#11	3.69891e-17
C456	A#4	B#5	4.74772e-17
C457	X	a_514_368##10	1.69232e-17
C458	A#3	B#1	1.80246e-19
C459	A#3	B#7	2.1558e-17
C460	VPWR#7	a_160_98##6	4.4526e-18
C461	A#6	A#4	3.51316e-17
C462	B#11	X#1	1.6273e-17
C463	a_514_368##3	VPWR#11	3.73485e-17
C464	A#3	A#1	1.14689e-17
C465	VPWR#7	a_160_98##8	4.4526e-18
C466	A#3	A#5	2.09206e-17
C467	A#9	a_514_368##6	6.85819e-19
C468	VPWR	VPWR#6	8.65046e-17
C469	a_877_74#	B#12	1.64163e-18
C470	VPWR	VPWR#5	6.41538e-17
C471	VPWR#7	a_160_98##9	4.46413e-18
C472	VPWR	VPWR#4	7.02307e-18
C473	A	VGND#11	2.3907e-18
C474	A	X#8	2.13243e-16
C475	a_877_74##5	B#11	1.72679e-18
C476	A	VGND#12	4.76798e-17
C477	B	VPWR#12	2.11374e-18
C478	VPWR	a_514_368##10	2.36661e-17
C479	A	a_160_98##11	3.54141e-17
C480	B	a_514_368##6	8.90519e-19
C481	B	VPWR#13	3.70252e-18
C482	B	a_514_368##8	8.4001e-19
C483	B#12	X#1	1.74437e-17
C484	B#2	A#16	3.17591e-19
C485	A#12	VPWR#13	2.74413e-20
C486	a_514_368##6	A#8	7.09626e-20
C487	a_877_74##2	X#1	1.35355e-17
C488	B#2	A#18	2.97158e-19
C489	X#7	B#11	5.96211e-19
C490	VGND#8	VGND#7	3.1816e-18
C491	B#2	A#13	4.83187e-19
C492	VGND	VGND#7	9.98651e-17
C493	VGND	VGND#6	5.38286e-17
C494	VGND	VGND#4	7.54368e-17
C495	B#2	a_160_98#	7.02098e-18
C496	VGND	VGND#3	5.47487e-17
C497	VGND	VGND#2	5.1337e-17
C498	a_877_74##5	B#12	3.177e-17
C499	a_514_368##3	VPWR#12	9.24582e-19
C500	B#2	a_160_98##6	2.06016e-17
C501	B#2	a_160_98##8	1.34692e-17
C502	X#1	B#14	7.52823e-19
C503	B#2	a_160_98##9	2.58279e-17
C504	B	B#14	1.34518e-19
C505	X	a_514_368##3	7.28907e-17
C506	B	B#15	7.16304e-18
C507	X#7	B#12	1.60305e-18
C508	B#2	B#6	3.56312e-18
C509	X	VPWR#12	4.19913e-18
C510	a_877_74##2	a_877_74##5	3.99103e-19
C511	B#13	VNB	2.60122e-17
C512	B#9	VNB	3.49466e-17
C513	VGND	X#6	7.87454e-18
C514	X	a_514_368##6	8.7025e-17
C515	VPWR#3	B#10	3.12527e-20
C516	A#12	VNB	2.65031e-17
C517	A#9	VNB	3.35549e-17
C518	X	VPWR#13	2.34693e-18
C519	B#2	B#5	7.99506e-19
C520	a_514_368##6	a_514_368##3	2.09079e-18
C521	A#8	VNB	3.17763e-17
C522	a_160_98##3	VNB	1.92868e-17
C523	a_36_392#	a_160_98##11	1.84144e-18
C524	a_160_98##2	VNB	1.47293e-17
C525	X	a_514_368##8	8.08376e-17
C526	VGND#9	B#11	5.02633e-20
C527	B#4	VNB	2.44746e-17
C528	B#3	VNB	3.47623e-17
C529	X	X#3	5.23636e-19
C530	VGND#1	B#10	4.99246e-20
C531	B#14	a_877_74##5	1.54107e-17
C532	X	a_514_368##11	2.0664e-17
C533	VGND	a_160_98##13	6.19505e-18
C534	X#5	X	3.01982e-18
C535	A#3	B#5	1.02561e-18
C536	VPWR#6	VPWR#5	2.05615e-18
C537	a_877_74##3	B#12	2.36491e-19
C538	A	A#15	9.82231e-20
C539	VPWR	a_514_368##3	1.57356e-17
C540	X#2	a_877_74#	3.17564e-17
C541	VGND	a_877_74##3	1.48368e-17
C542	A	A#17	1.43034e-19
C543	A#6	A#3	1.91341e-19
C544	VGND	VGND#9	2.18231e-17
C545	VPWR	a_514_368##6	2.0549e-17
C546	A	A#19	9.92967e-19
C547	VGND	a_877_74##6	2.09333e-17
C548	VGND	VGND#10	2.1436e-17
C549	a_514_368##6	VPWR#12	1.95862e-18
C550	A	a_160_98##7	2.41278e-17
C551	X#7	B#14	2.84315e-17
C552	VGND	a_877_74##8	1.604e-17
C553	VPWR	a_514_368##8	2.27465e-17
C554	VPWR#7	a_160_98##4	7.32829e-20
C555	X#6	a_877_74##5	1.56237e-17
C556	A	a_160_98##5	3.60519e-17
C557	VGND	X#8	2.88139e-17
C558	B	B#8	1.9641e-18
C559	a_514_368##8	A#12	1.52534e-20
C560	a_160_98##11	a_160_98##15	3.06033e-20
C561	VGND	VGND#12	1.98293e-17
C562	A	B#1	2.14894e-17
C563	VPWR	X#5	9.26004e-18
C564	VGND	a_160_98##11	5.19246e-18
C565	B	B#17	2.26102e-18
C566	VGND#5	a_160_98##4	1.70257e-19
C567	a_877_74##2	X#7	2.08985e-17
C568	A	B#7	3.72676e-19
C569	VPWR	a_514_368##12	2.32899e-17
C570	B#2	VPWR#7	1.32559e-18
C571	VGND#9	B#12	7.00297e-20
C572	VGND	a_160_98##14	3.99842e-18
C573	B	B#18	2.36023e-18
C574	VPWR	a_36_392#	3.20897e-17
C575	A	A#1	1.91248e-19
C576	VGND	VGND#8	5.68172e-17
C577	VPWR	a_160_98##15	8.86639e-18
C578	B	B#16	1.40041e-17
C579	A	A#5	1.50228e-19
C580	a_877_74##5	B#15	5.78667e-19
C581	VPWR	a_36_392##2	1.85692e-17
C582	B	A#14	1.01415e-17
C583	VPWR#3	B#13	9.41674e-21
C584	VPWR	a_36_392##4	1.94e-17
C585	B	A#16	1.85581e-17
C586	a_877_74##3	B#14	5.41336e-19
C587	B	A#18	1.40207e-17
C588	B	A#13	1.36624e-17
C589	B	a_160_98#	6.276e-18
C590	X#2	X#1	6.89747e-19
C591	B	a_160_98##6	7.67335e-20
C592	B#2	a_160_98##4	1.25716e-16
C593	VGND#7	VNB	5.30546e-17
C594	A	A#16	1.06783e-18
C595	VGND#6	VNB	2.94044e-17
C596	X#7	B#15	2.64358e-17
C597	VGND#4	VNB	3.63435e-17
C598	X	B#8	2.62525e-19
C599	VGND#3	VNB	3.04082e-17
C600	A	A#18	2.04429e-18
C601	VGND#2	VNB	2.88446e-17
C602	VPWR#4	B#8	1.62536e-19
C603	VGND	a_36_392##2	3.10829e-18
C604	X	B#17	2.50058e-19
C605	VPWR#6	VNB	4.66168e-17
C606	VPWR#5	VNB	3.34748e-17
C607	A	A#13	2.05069e-18
C608	VPWR#4	VNB	2.36243e-17
C609	X	B#18	4.97729e-19
C610	VGND	a_36_392##4	3.20823e-18
C611	A	a_160_98#	1.35322e-17
C612	X#6	X#7	8.95752e-20
C613	X	B#16	8.48684e-18
C614	a_514_368##10	VNB	4.47295e-18
C615	X	A#14	2.33774e-17
C616	A	a_160_98##6	1.48832e-18
C617	a_514_368##2	VNB	2.08637e-18
C618	X	A#16	1.83277e-17
C619	A	a_160_98##8	2.96292e-19
C620	a_877_74##5	A#7	2.53065e-19
C621	a_877_74##2	VNB	5.45849e-18
C622	VGND	A#7	1.03928e-18
C623	X#6	VNB	4.9682e-18
C624	X	A#18	1.49048e-17
C625	VGND	A#15	2.18128e-19
C626	A	a_160_98##9	1.69068e-19
C627	X#2	VNB	5.47039e-17
C628	VGND	A#17	1.12333e-19
C629	X	A#13	1.5288e-17
C630	a_514_368##6	VPWR#13	1.45348e-18
C631	VGND	A#19	2.11746e-19
C632	X	a_160_98#	1.99415e-17
C633	a_877_74##3	B#15	2.69586e-17
C634	VGND	a_160_98##7	8.73586e-18
C635	VGND	a_160_98##5	9.47289e-18
C636	X	a_160_98##6	2.0551e-17
C637	a_877_74#	VNB	3.39239e-17
C638	VGND	B#1	9.06351e-18
C639	VPWR#3	B	9.29567e-18
C640	VPWR	A#14	1.23554e-18
C641	X#1	VNB	2.84364e-19
C642	X	a_160_98##8	1.19069e-18
C643	VGND	B#7	8.91407e-18
C644	VPWR	A#16	6.18309e-20
C645	a_877_74##3	VNB	2.38822e-18
C646	VGND	A#1	9.49414e-18
C647	VGND#1	B	8.03403e-18
C648	VGND#9	VNB	4.48611e-18
C649	VPWR	A#18	1.94826e-19
C650	a_160_98##3	a_160_98##2	6.85957e-19
C651	a_877_74##6	VNB	1.93806e-18
C652	VGND	A#5	1.10094e-17
C653	VGND#10	VNB	5.08469e-18
C654	a_877_74##8	VNB	2.53952e-18
C655	VPWR	A#13	5.58251e-19
C656	X#8	VNB	1.5727e-17
C657	VPWR	a_160_98#	1.48504e-18
C658	VGND#12	VNB	1.00219e-17
C659	a_160_98##11	VNB	2.08522e-20
C660	X#7	A#7	1.80139e-18
C661	VPWR	a_160_98##6	1.56212e-18
C662	a_160_98##14	VNB	2.31903e-19
C663	VGND#8	VNB	8.40181e-17
C664	VPWR	a_160_98##8	1.64161e-18
C665	a_514_368#	VNB	4.07397e-17
C666	B	B#10	1.97524e-17
C667	X#2	a_877_74##5	1.39998e-17
C668	VPWR#10	VNB	2.70024e-18
C669	VPWR	a_160_98##9	1.64802e-18
C670	VPWR#11	VNB	3.91088e-19
C671	a_514_368##3	VNB	4.54939e-18
C672	B	A#11	4.22769e-18
C673	VPWR	B#6	1.51838e-18
C674	VPWR#5	VPWR#4	1.00443e-18
C675	VGND#9	B#15	3.18478e-18
C676	VGND#5	A	2.15611e-18
C677	a_514_368##6	VNB	2.09779e-18
C678	VPWR#3	X	6.24068e-19
C679	VPWR	B#5	1.51281e-18
C680	a_514_368##8	VNB	3.14796e-18
C681	VPWR	A#4	5.7186e-19
C682	a_514_368##8	a_514_368##6	2.86264e-18
C683	a_514_368##12	VNB	1.39357e-17
C684	VPWR	A#6	1.7412e-18
C685	A	A#11	2.64543e-17
C686	VPWR#4	B#17	3.20383e-19
C687	a_160_98##14	a_36_392##2	5.61473e-18
C688	a_36_392#	VNB	1.35362e-17
C689	X#6	a_877_74##3	5.04865e-17
C690	a_160_98##15	VNB	6.80983e-19
C691	a_36_392##2	VNB	5.12785e-18
C692	VPWR#14	VNB	2.95274e-18
C693	A	a_160_98##4	1.42237e-16
C694	a_36_392##4	VNB	5.41826e-17
C695	B#11	VNB	3.33681e-17
C696	B#12	VNB	2.98734e-17
C697	A	B#2	4.35711e-17
C698	B#14	VNB	3.89776e-17
C699	B#15	VNB	5.28286e-17
C700	X	A#11	1.09688e-18
C701	a_877_74##3	A#7	4.4201e-17
C702	A#7	VNB	2.85333e-17
C703	VPWR	VPWR#7	1.08822e-16
C704	A#15	VNB	2.90331e-17
C705	A#17	VNB	2.84968e-17
C706	A#19	VNB	3.64478e-17
C707	a_160_98##7	VNB	3.18634e-17
C708	a_160_98##5	VNB	3.27235e-17
C709	B#2	X	5.26971e-17
C710	B#1	VNB	3.31238e-17
C711	B#7	VNB	3.1453e-17
C712	A#1	VNB	3.06013e-17
C713	VGND	VGND#1	5.81111e-18
C714	A#5	VNB	3.67601e-17
C715	VPWR	a_160_98##4	7.04605e-18
C716	VGND#1	B#13	1.31703e-20
C717	B#8	VNB	4.1796e-17
C718	B#17	VNB	3.43413e-17
C719	VGND	VGND#5	3.27419e-17
C720	VPWR	B#2	1.46441e-17
C721	B#18	VNB	3.00394e-17
C722	B#16	VNB	4.13115e-17
C723	A#14	VNB	3.35699e-17
C724	VPWR	A#3	3.50707e-18
C725	A#16	VNB	3.28943e-17
C726	A#18	VNB	3.13166e-17
C727	X#7	A#15	7.2687e-19
C728	A#13	VNB	3.09992e-17
C729	VGND	a_160_98##4	5.83552e-18
C730	a_160_98#	VNB	5.00779e-17
C731	a_514_368##8	VPWR#13	1.46638e-18
C732	a_160_98##6	VNB	3.29823e-17
C733	VGND	B#2	6.3851e-18
C734	VGND#1	B#9	1.79688e-20
C735	a_160_98##8	VNB	3.18902e-17
C736	a_160_98##9	VNB	3.25114e-17
C737	VGND	A#3	3.7369e-17
C738	A	B	1.51907e-16
C739	B#6	VNB	3.39404e-17
C740	B#5	VNB	3.31152e-17
C741	A#7	VGND#9	2.3425e-17
C742	A#4	VNB	3.10282e-17
C743	a_514_368##10	a_160_98##2	6.66753e-20
C744	A#6	VNB	4.25853e-17
C745	B	X	2.20181e-16
C746	X#7	X#2	4.14987e-19
C747	VPWR#3	VNB	1.318e-16
C748	VGND#1	VNB	1.91507e-16
C749	a_160_98##13	a_160_98##5	7.26133e-20
C750	VPWR#7	VNB	6.43185e-17
C751	VPWR	B	1.20217e-17
C752	VGND#5	VNB	1.89824e-17
C753	B#10	VNB	3.23079e-17
C754	VPWR	A	1.23155e-17
C755	A#11	VNB	4.33869e-17
C756	a_160_98##4	VNB	3.70011e-17
C757	VGND	B	6.48751e-18
C758	VGND#10	B#15	7.96613e-20
C759	B#2	VNB	8.77743e-18
C760	VPWR	X	2.43473e-17
C761	A#3	VNB	9.6546e-17
C762	VGND	A	3.36451e-17
C763	X#6	VGND#9	5.13092e-19
C764	a_877_74##3	A#15	8.36931e-19
C765	B	VNB	2.22107e-17
C766	A	VNB	2.35748e-17
C767	X	VNB	1.94023e-19
C768	VPWR	VNB	3.0431e-16
C769	VGND	VNB	2.88079e-16
C770	VPWR#4	B#18	5.31799e-18
C771	a_514_368##2	B#13	1.42099e-19
C772	a_877_74##6	A#7	5.56888e-19
C773	VPWR#8	A#3	8.57183e-20
C774	VPWR#4	VPWR#2	7.0017e-19
C775	a_36_392##2	VPWR#8	3.19396e-17
C776	VPWR#8	a_160_98##9	7.28807e-20
C777	a_514_368#	VPWR#2	2.12999e-17
C778	VPWR#2	B#17	1.91981e-18
C779	VPWR#8	B#6	4.71211e-18
C780	a_36_392##4	VPWR#8	2.1121e-17
C781	VPWR#8	B#5	4.92387e-18
C782	VPWR#8	A#4	4.24332e-18
C783	VPWR#8	A#6	5.8663e-18
C784	VPWR#2	B#18	5.65677e-19
C785	VPWR#3	VPWR#2	6.60604e-17
C786	VPWR#2	B#16	9.00513e-20
C787	VPWR#2	VNB	3.59614e-17
C788	VPWR	VPWR#8	1.4207e-16
C789	VPWR#8	B#4	3.04267e-20
C790	VPWR#8	VNB	7.30204e-17
C791	VPWR#8	B#3	1.3006e-21
C792	VPWR#2	B#8	5.53368e-18
C793	a_36_392#	VPWR#8	4.16072e-17
*
*
.ENDS sky130_fd_sc_hs__xor2_4
*
