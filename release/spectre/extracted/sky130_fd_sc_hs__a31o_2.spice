* Extracted by Quantus, converted by sky130cad/quantus.py
*
*
*
*                       LINUX           Wed Nov 18 08:12:34 2026
*
*
*
*  PROGRAM  advgen
*
*  Name           : advgen - Quantus - (64-bit)
*  Version        : 25.1.0-p047
*  Build Date     : Thu Dec 11 23:20:30 PST 2025
*
*  HSPICE LIBRARY
*
*  OPERATING_TEMPERATURE 150
*  QRC_TECH_DIR <path>/tech
*
*
*

*
.SUBCKT sky130_fd_sc_hs__a31o_2 VPB VNB VGND VPWR X A3 A2 A1 B1
*
*
*  caps2d version: 10
*
*
*       TRANSISTOR CARDS
*
*
XM7 VGND#4 a_97_296##4 X#3 VNB sky130_fd_pr__nfet_01v8_lvt l=0.15 w=0.74 ad=0.2627 as=0.2072 pd=2.19 ps=2.04
XM11 X#3 a_97_296##5 VGND#5 VNB sky130_fd_pr__nfet_01v8_lvt l=0.15 w=0.74 ad=0.2072 as=0.4699 pd=2.04 ps=2.75
XM8 VGND#5 A3#1 a_371_74# VNB sky130_fd_pr__nfet_01v8_lvt l=0.15 w=0.74 ad=0.4699 as=0.1776 pd=2.75 ps=1.96
XM2 a_371_74# A2#3 a_449_74# VNB sky130_fd_pr__nfet_01v8_lvt l=0.15 w=0.74 ad=0.1776 as=0.3108 pd=1.96 ps=2.32
XM10 a_449_74# A1#3 a_97_296##9 VNB sky130_fd_pr__nfet_01v8_lvt l=0.15 w=0.74 ad=0.3108 as=0.3108 pd=2.32 ps=2.32
XM1 a_97_296##9 B1#3 VGND#1 VNB sky130_fd_pr__nfet_01v8_lvt l=0.15 w=0.74 ad=0.3108 as=0.2109 pd=2.32 ps=2.05
XM0 VPWR#5 a_97_296##6 X#1 VPB sky130_fd_pr__pfet_01v8 l=0.15 w=1.12 ad=0.3304 as=0.336 pd=2.83 ps=2.84
XM3 X#1 a_97_296# VPWR#7 VPB sky130_fd_pr__pfet_01v8 l=0.15 w=1.12 ad=0.336 as=0.6128 pd=2.84 ps=3.36
XM4 VPWR#7 A3#3 a_362_368##2 VPB sky130_fd_pr__pfet_01v8 l=0.15 w=1 ad=0.6128 as=0.3 pd=3.36 ps=2.6
XM9 a_362_368##2 A2#1 VPWR#6 VPB sky130_fd_pr__pfet_01v8 l=0.15 w=1 ad=0.3 as=0.49 pd=2.6 ps=2.98
XM5 VPWR#6 A1#1 a_362_368# VPB sky130_fd_pr__pfet_01v8 l=0.15 w=1 ad=0.49 as=0.35 pd=2.98 ps=2.7
XM6 a_362_368# B1#4 a_97_296##7 VPB sky130_fd_pr__pfet_01v8 l=0.15 w=1 ad=0.35 as=0.305 pd=2.7 ps=2.61
*
*
*       RESISTOR AND CAP/DIODE CARDS
*
Rg1	a_97_296#	a_97_296##2	449.793182
Rg2	a_97_296##2	a_97_296##3	83.494759
Rg3	a_97_296##3	a_97_296##4	423.145813
Rg4	a_97_296##2	a_97_296##5	347.279205
Rg5	a_97_296##3	a_97_296##6	526.145996
Rg6	A3#1	A3#2	307.937683
Rg7	A3#2	A3#3	457.627838
Rg8	A2#1	A2#2	457.627838
Rg9	A2#2	A2#3	307.937683
Rg10	A1#1	A1#2	459.376984
Rg11	A1#2	A1#3	440.886749
Rg12	B1#1	B1#2	30.613651
Rg13	B1#2	B1#3	322.953644
Rg14	B1#2	B1#4	472.643829
Rf1	X	X#2	0.205730
Rf2	X#2	X	15.018257
Rf3	X	X#3	88.049339
Rf4	X#1	X#2	5.000000
Rf5	A3#2	A3	163.775864
Rf6	A2	A2#4	1.548413
Rf7	A2#5	A2#2	161.781219
Rf8	A2#4	A2#5	3.529830
Rf9	a_362_368#	a_362_368##2	103.540985
Rf10	A1#4	A1#2	161.280029
Rf11	A1	A1#6	1.047223
Rf12	A1#4	A1#6	10.236507
Rf13	a_97_296##7	a_97_296##8	203.035767
Rf14	a_97_296##8	a_97_296##9	169.320145
Rf15	B1	B1#1	163.775864
Rf16	VGND#1	VGND#2	144.730667
Rf17	VGND#2	VGND#3	38.374992
Rf18	VGND#3	VGND#4	112.681267
Rf19	VGND#3	VGND#5	16.060398
Rf21	VPWR#2	VPWR#3	43.440514
Rf22	VPWR#3	VPWR#4	41.036175
Rf23	VPWR#4	VPWR#5	125.444901
Rf24	VPWR#2	VPWR#6	41.790440
Rf25	VPWR#4	VPWR#8	10.159110
Rf26	VPWR#8	VPWR#7	24.575554
Rf27	VPWR#7	VPWR#8	15.000000
Rf31	a_97_296##2	a_97_296##8	160.232803
Re1	VPWR#3	VPWR	1.227783
Re2	VGND	VGND#2	1.227829
*
*       CAPACITOR CARDS
*
*
C1	B1#2	VGND#1	8.3001e-18
C2	VGND#3	VGND#1	4.2919e-19
C3	A2#5	A1#4	2.47145e-17
C4	VGND#3	a_97_296##9	6.68604e-18
C5	VGND#1	A1#6	1.15271e-18
C6	A1#2	B1#2	3.04881e-17
C7	a_97_296##9	A1#6	2.80126e-17
C8	VGND#3	VGND#5	4.94009e-18
C9	VGND#3	X#3	3.80675e-17
C10	a_97_296##9	A1#4	3.29103e-17
C11	X#3	a_97_296##3	6.45938e-18
C12	VGND#4	VGND#3	3.19064e-18
C13	a_97_296##9	A2#5	2.46523e-17
C14	VPWR#4	VPWR#6	3.13673e-18
C15	a_97_296##9	A2#4	1.98582e-17
C16	VPWR#4	a_362_368##2	3.96907e-17
C17	VPWR#4	VPWR#7	7.92027e-18
C18	A1#6	a_97_296##7	2.92024e-17
C19	VGND#1	a_97_296##9	7.80795e-17
C20	a_97_296##7	B1#2	7.57432e-18
C21	a_97_296##2	B1#2	9.90897e-20
C22	X#1	VPWR#4	1.77362e-17
C23	a_97_296##3	a_97_296##2	3.88127e-18
C24	A1#4	a_97_296##7	3.22982e-17
C25	VPWR#5	VPWR#4	2.58355e-18
C26	A2#5	a_97_296##7	1.73736e-17
C27	a_97_296##9	VGND#5	3.67478e-19
C28	VGND#3	B1#3	9.8944e-19
C29	VGND#1	a_97_296##7	3.45338e-18
C30	VGND#3	A1#3	1.57862e-18
C31	a_97_296##9	a_97_296##7	6.21228e-18
C32	VGND#3	A2#3	3.22982e-18
C33	VGND#3	A3#1	2.1588e-17
C34	VGND#4	X#3	7.56135e-17
C35	VGND#3	a_97_296##5	2.55355e-17
C36	VGND#3	a_97_296##4	4.36603e-18
C37	a_97_296##7	a_362_368#	1.30074e-16
C38	VGND#1	B1#3	4.10938e-17
C39	VPWR#4	A1#1	4.33502e-19
C40	B1#3	a_97_296##9	2.16414e-17
C41	a_97_296##7	VPWR#6	1.99658e-18
C42	VGND#1	A1#3	2.57487e-18
C43	VPWR#4	A2#1	9.3594e-19
C44	a_362_368#	VPWR#6	5.56061e-17
C45	a_97_296##7	a_362_368##2	1.75482e-17
C46	a_97_296##9	A1#3	4.57076e-17
C47	VGND#1	A2#3	2.73503e-19
C48	a_362_368##2	a_362_368#	2.33146e-18
C49	a_97_296##9	A2#3	2.50896e-17
C50	VPWR#4	A3#3	1.36387e-17
C51	VGND#1	A3#1	1.98094e-19
C52	a_362_368##2	VPWR#6	5.21846e-17
C53	a_97_296##3	X#1	9.17838e-20
C54	VGND#4	VPWR#5	1.3848e-17
C55	a_97_296##9	A3#1	1.29983e-18
C56	VPWR#4	a_97_296#	2.71403e-17
C57	X#3	A1#3	3.79118e-19
C58	a_97_296##9	a_97_296##5	4.41842e-19
C59	VPWR#7	a_362_368##2	3.28408e-17
C60	VPWR#4	a_97_296##6	5.41408e-18
C61	X#3	A2#3	4.5297e-19
C62	B1	B1#2	2.102e-17
C63	A3#1	VGND#5	2.18054e-17
C64	X#3	A3#1	1.8743e-18
C65	X#1	VPWR#7	2.15089e-17
C66	a_97_296##5	VGND#5	1.46029e-17
C67	VPWR#4	a_97_296##3	4.57114e-20
C68	X#3	a_97_296##5	1.49583e-17
C69	VPWR#3	VPWR#4	4.66131e-17
C70	VGND#4	a_97_296##5	1.31984e-18
C71	VPWR#5	X#1	3.78454e-17
C72	X#3	a_97_296##4	3.85288e-17
C73	VGND#4	a_97_296##4	2.64862e-17
C74	VGND#2	VGND#3	4.77419e-17
C75	A1#3	B1#3	2.26967e-17
C76	a_97_296##7	B1#4	5.40343e-17
C77	B1#4	a_362_368#	2.23536e-17
C78	a_97_296##7	A1#1	1.9472e-17
C79	A2#3	A1#3	2.46609e-17
C80	VPWR#6	B1#4	1.63949e-18
C81	a_362_368#	A1#1	6.18863e-17
C82	a_97_296##7	A2#1	4.70134e-19
C83	A1#1	VPWR#6	3.15091e-17
C84	a_362_368#	A2#1	5.57422e-19
C85	A3#1	A2#3	4.97223e-17
C86	a_362_368##2	A1#1	1.23548e-18
C87	a_97_296##7	A3#3	2.214e-19
C88	A2#1	VPWR#6	3.44309e-17
C89	A1#6	A1#2	6.15314e-18
C90	a_362_368##2	A2#1	6.17301e-17
C91	VPWR#6	A3#3	1.26242e-18
C92	A1#4	A1#2	1.58358e-17
C93	a_97_296##5	A3#1	1.01523e-17
C94	VGND#2	VGND#1	4.50232e-17
C95	a_362_368##2	A3#3	4.4178e-17
C96	VGND#3	A3#2	1.07165e-18
C97	VGND#2	a_97_296##9	8.58822e-18
C98	A2#5	A1#2	2.84952e-18
C99	VPWR#6	a_97_296#	2.48881e-19
C100	a_97_296##2	VPWR#4	5.54513e-19
C101	A3#3	VPWR#7	1.45865e-17
C102	VGND#3	a_97_296##3	5.89493e-20
C103	A1#4	A2#2	3.76609e-18
C104	a_97_296##4	a_97_296##5	3.93997e-17
C105	VGND#3	a_97_296##2	4.97065e-17
C106	VPWR#7	a_97_296#	4.42977e-17
C107	A2#5	A2#2	9.48436e-18
C108	A2#4	A2#2	7.87804e-18
C109	VGND#1	A1#2	1.54797e-19
C110	a_97_296#	X#1	7.08967e-18
C111	VPWR#7	a_97_296##6	7.50006e-19
C112	A1#2	a_97_296##9	4.1401e-18
C113	VPWR#5	a_97_296#	1.21669e-18
C114	VGND#2	VGND#4	2.87186e-17
C115	X#1	a_97_296##6	3.44693e-17
C116	X	a_97_296##3	1.80604e-17
C117	A3#2	A2#4	1.73584e-17
C118	VPWR#5	a_97_296##6	3.13666e-17
C119	a_97_296##9	A2#2	2.76961e-18
C120	a_362_368##2	VPWR#3	1.06628e-17
C121	A2#5	a_97_296##2	7.20737e-18
C122	A2#4	a_97_296##2	1.98582e-17
C123	a_97_296##7	A1#2	2.35114e-18
C124	VPWR#3	VPWR#5	2.73313e-17
C125	A1#1	B1#4	3.57643e-17
C126	a_362_368#	A1#2	7.02039e-19
C127	a_97_296##9	a_97_296##2	2.91904e-18
C128	A3#2	VGND#5	6.74146e-19
C129	VPWR#6	A1#2	2.87765e-19
C130	a_97_296##7	A2#2	2.21764e-18
C131	X#3	A3#2	1.66147e-19
C132	VPWR	B1#2	6.15463e-19
C133	A2#1	A1#1	2.06228e-17
C134	VPWR#6	A2#2	9.71791e-19
C135	a_97_296##2	VGND#5	7.2028e-18
C136	VGND#2	A1#3	8.33879e-18
C137	X#3	a_97_296##2	3.34813e-17
C138	a_362_368##2	A2#2	5.85451e-19
C139	VGND#2	A2#3	8.33879e-18
C140	A3#3	A2#1	4.32774e-17
C141	VGND#2	A3#1	4.10118e-18
C142	VPWR#7	A3#2	7.22121e-19
C143	a_97_296#	A3#3	1.73458e-17
C144	a_97_296##2	a_362_368##2	4.71167e-17
C145	a_97_296##9	a_449_74#	9.12977e-18
C146	a_97_296##2	VPWR#7	5.6319e-17
C147	A1#6	B1#2	1.75623e-17
C148	VGND	B1#2	3.43175e-19
C149	VGND	a_97_296##3	1.89619e-19
C150	a_97_296##6	a_97_296#	4.79551e-17
C151	VPWR#3	A2#1	1.39724e-18
C152	a_97_296##9	a_371_74#	3.99846e-18
C153	X#3	a_449_74#	2.01669e-19
C154	A1#6	B1	3.2293e-17
C155	a_97_296##2	B1#3	1.98078e-19
C156	VPWR#3	A3#3	2.88803e-18
C157	a_97_296##2	A1#3	2.0229e-19
C158	a_97_296##2	A2#3	3.58798e-19
C159	a_97_296##5	A3#2	5.26358e-19
C160	a_97_296##2	A3#1	2.7432e-17
C161	a_97_296##2	a_97_296##5	6.28175e-18
C162	VGND#1	B1	4.37789e-17
C163	a_97_296##2	a_97_296##4	6.68421e-19
C164	B1#2	VNB	6.10348e-17
C165	A1#3	a_449_74#	2.12899e-17
C166	a_97_296##3	VNB	3.93776e-17
C167	A2#3	a_449_74#	2.12899e-17
C168	a_97_296##2	A2#1	1.44792e-17
C169	B1	a_97_296##7	2.93732e-17
C170	a_97_296##2	A3#3	2.51521e-17
C171	A2#3	a_371_74#	1.58629e-17
C172	a_97_296##2	a_97_296#	2.53551e-18
C173	A3#1	a_371_74#	1.58629e-17
C174	X	VPWR#4	4.87939e-17
C175	a_97_296##2	a_97_296##6	3.54561e-19
C176	VGND#2	A2#2	5.26394e-19
C177	A3	A2#4	1.58772e-17
C178	a_97_296##2	VPWR#3	2.31908e-19
C179	A2#2	A1#2	2.54536e-17
C180	VGND#2	a_97_296##2	1.24003e-18
C181	VPWR	VPWR#4	6.15435e-17
C182	A3#2	A2#2	3.12545e-17
C183	a_97_296##2	A1#2	1.07443e-19
C184	VPWR	A1#6	1.40411e-18
C185	a_97_296##2	A2#2	2.8318e-19
C186	VPWR	A1#4	1.53589e-18
C187	a_97_296##2	A3#2	8.87898e-17
C188	VPWR	A2#5	1.18919e-18
C189	X#3	X	1.15703e-18
C190	VPWR	A2#4	9.71624e-19
C191	X	VPWR#6	1.87662e-19
C192	VGND	VGND#3	5.85011e-17
C193	X	VPWR#7	1.18169e-17
C194	A2#2	a_449_74#	9.77477e-19
C195	VGND	A1#6	3.46535e-18
C196	X	X#1	4.33024e-18
C197	VGND	A1#4	2.02273e-18
C198	A3	a_97_296##5	2.26667e-19
C199	VPWR#5	X	6.05652e-17
C200	VGND	A2#5	1.70003e-18
C201	VPWR	a_97_296##7	1.93454e-17
C202	VGND	A2#4	1.31981e-18
C203	VPWR	a_362_368#	1.58095e-17
C204	VGND	VGND#1	5.13598e-17
C205	VPWR	a_362_368##2	1.59539e-17
C206	VGND	a_97_296##9	2.92266e-17
C207	VPWR#4	VNB	3.9417e-17
C208	a_97_296##2	a_371_74#	1.74187e-18
C209	B1	A1#2	7.87818e-19
C210	VPWR	VPWR#5	3.16871e-17
C211	VGND#3	VNB	3.84574e-17
C212	VGND	X#3	1.51859e-17
C213	VGND	VGND#4	3.71391e-17
C214	A1#6	VNB	1.04536e-18
C215	VGND	a_97_296##7	6.4177e-18
C216	A1#4	VNB	7.34556e-19
C217	X	A1#1	2.2171e-19
C218	A2#5	VNB	2.16604e-18
C219	X	A2#1	3.27779e-19
C220	A2#4	VNB	5.25125e-19
C221	X	A3#3	9.61859e-19
C222	VGND#1	VNB	7.60803e-17
C223	X	a_97_296#	1.20621e-17
C224	VGND	VPWR#5	4.09786e-18
C225	a_97_296##9	VNB	6.14099e-18
C226	VPWR	B1#4	9.37033e-18
C227	VGND	B1#3	2.05665e-18
C228	X	a_97_296##6	2.11019e-17
C229	VGND	A1#3	1.21032e-18
C230	VPWR	A1#1	7.69116e-18
C231	VGND	A2#3	1.32834e-18
C232	X#3	VNB	7.76109e-18
C233	VPWR	A2#1	9.36822e-18
C234	VGND#4	VNB	7.16646e-17
C235	VGND	A3#1	6.17714e-19
C236	VPWR	A3#3	7.37508e-18
C237	a_97_296##7	VNB	6.28776e-17
C238	VGND	a_97_296##5	1.59035e-18
C239	a_362_368#	VNB	3.32431e-18
C240	A3	A2#2	1.89766e-18
C241	VPWR	a_97_296#	2.80639e-18
C242	VGND	a_97_296##4	4.90124e-18
C243	VPWR#6	VNB	6.17532e-18
C244	a_362_368##2	VNB	2.56032e-18
C245	VPWR	a_97_296##6	4.10503e-18
C246	A3	A3#2	1.04107e-17
C247	a_97_296##2	A3	5.18743e-17
C248	VPWR#5	VNB	8.25879e-17
C249	VPWR	VPWR#3	1.06925e-17
C250	B1#3	VNB	3.0695e-17
C251	A1#3	VNB	2.82497e-17
C252	A2#3	VNB	2.43464e-17
C253	A3#1	VNB	2.56255e-17
C254	a_97_296##5	VNB	2.62219e-17
C255	X	a_97_296##2	4.93001e-17
C256	a_97_296##4	VNB	3.30766e-17
C257	B1#4	VNB	4.64313e-17
C258	VPWR	A3#2	1.96447e-18
C259	A1#1	VNB	3.61098e-17
C260	VGND	VGND#2	3.01739e-17
C261	A2#1	VNB	3.96463e-17
C262	VPWR	a_97_296##2	6.96816e-18
C263	A3#3	VNB	3.55253e-17
C264	VGND	A1#2	3.44663e-19
C265	a_97_296#	VNB	3.68645e-17
C266	a_97_296##6	VNB	4.13797e-17
C267	VGND	A2#2	3.32079e-19
C268	VGND	A3#2	6.64159e-20
C269	VPWR#3	VNB	1.82997e-16
C270	VGND	a_97_296##2	1.62084e-17
C271	VGND#2	VNB	2.03521e-16
C272	A1#2	VNB	3.4682e-17
C273	A2#2	VNB	3.40873e-17
C274	A3#2	VNB	2.36361e-17
C275	VPWR	B1	2.97196e-18
C276	a_97_296##2	VNB	4.10654e-17
C277	VGND	B1	2.15815e-18
C278	B1	VNB	2.10831e-17
C279	VPWR	X	1.57861e-17
C280	VGND	A3	2.63375e-18
C281	VGND	X	1.86853e-18
C282	A3	VNB	1.15242e-18
C283	X	VNB	1.2436e-17
C284	VPWR	VNB	7.15241e-17
C285	VGND	VNB	5.69001e-17
C286	VPWR#2	A1#2	6.54783e-20
C287	VPWR#2	a_97_296#	5.21141e-19
C288	VPWR#4	VPWR#2	2.56251e-18
C289	VPWR	VPWR#2	6.81349e-17
C290	a_97_296##7	VPWR#2	1.59281e-17
C291	B1	VPWR#2	2.79683e-19
C292	VPWR#2	VNB	6.75358e-17
C293	VPWR#2	B1#4	4.69499e-18
C294	a_362_368#	VPWR#2	1.39873e-17
C295	VPWR#2	B1#2	5.67156e-19
C296	VPWR#3	VPWR#2	7.02838e-17
C297	VPWR#2	A1#1	4.62072e-18
C298	VPWR#2	A2#1	3.54415e-18
C299	a_362_368##2	VPWR#2	4.82174e-19
*
*
.ENDS sky130_fd_sc_hs__a31o_2
*
