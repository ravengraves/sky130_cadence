* Extracted by Quantus, converted by sky130cad/quantus.py
*
*
*
*                       LINUX           Wed Nov 18 08:30:39 2026
*
*
*
*  PROGRAM  advgen
*
*  Name           : advgen - Quantus - (64-bit)
*  Version        : 25.1.0-p047
*  Build Date     : Thu Dec 11 23:20:30 PST 2025
*
*  HSPICE LIBRARY
*
*  OPERATING_TEMPERATURE 150
*  QRC_TECH_DIR <path>/tech
*
*
*

*
.SUBCKT sky130_fd_sc_hs__dlclkp_4 VPB VNB VGND VPWR GCLK CLK GATE
*
*
*  caps2d version: 10
*
*
*       TRANSISTOR CARDS
*
*
XM24 a_27_74##10 a_84_48##3 VGND#13 VNB sky130_fd_pr__nfet_01v8_lvt l=0.15 w=0.74 ad=0.2109 as=0.48195 pd=2.05 ps=2.9
XM17 VGND#13 GATE#1 a_286_80# VNB sky130_fd_pr__nfet_01v8_lvt l=0.15 w=0.64 ad=0.48195 as=0.1536 pd=2.9 ps=1.76
XM14 a_286_80# a_334_54##2 a_84_48##6 VNB sky130_fd_pr__nfet_01v8_lvt l=0.15 w=0.64 ad=0.1536 as=0.2587 pd=1.76 ps=2.25
XM25 a_84_48##6 a_334_338# a_491_124# VNB sky130_fd_pr__nfet_01v8_lvt l=0.15 w=0.42 ad=0.2587 as=0.23775 pd=2.25 ps=2.39
XM22 a_491_124# a_27_74##2 VGND#12 VNB sky130_fd_pr__nfet_01v8_lvt l=0.15 w=0.42 ad=0.23775 as=0.3285 pd=2.39 ps=2.61
XM16 VGND#12 a_334_54##6 a_334_338##5 VNB sky130_fd_pr__nfet_01v8_lvt l=0.15 w=0.74 ad=0.3285 as=0.2675 pd=2.61 ps=2.66
XM3 a_334_54##14 CLK#5 VGND#9 VNB sky130_fd_pr__nfet_01v8_lvt l=0.15 w=0.74 ad=0.2333 as=0.2072 pd=2.19 ps=2.04
XM8 VGND#9 CLK#1 a_1047_74# VNB sky130_fd_pr__nfet_01v8_lvt l=0.15 w=0.74 ad=0.2072 as=0.1776 pd=2.04 ps=1.96
XM0 a_1047_74# a_27_74##6 a_1044_368##14 VNB sky130_fd_pr__nfet_01v8_lvt l=0.15 w=0.74 ad=0.1776 as=0.2109 pd=1.96 ps=2.05
XM5 VGND#8 a_1044_368##12 GCLK#1 VNB sky130_fd_pr__nfet_01v8_lvt l=0.15 w=0.74 ad=0.2977 as=0.2072 pd=2.9 ps=2.04
XM9 GCLK#1 a_1044_368##10 VGND#7 VNB sky130_fd_pr__nfet_01v8_lvt l=0.15 w=0.74 ad=0.2072 as=0.259 pd=2.04 ps=2.18
XM11 GCLK#4 a_1044_368##8 VGND#7 VNB sky130_fd_pr__nfet_01v8_lvt l=0.15 w=0.74 ad=0.2072 as=0.259 pd=2.04 ps=2.18
XM12 VGND#1 a_1044_368# GCLK#4 VNB sky130_fd_pr__nfet_01v8_lvt l=0.15 w=0.74 ad=0.2109 as=0.2072 pd=2.05 ps=2.04
XM4 a_27_74##11 a_84_48# VPWR#12 VPB sky130_fd_pr__pfet_01v8 l=0.15 w=1.12 ad=0.3304 as=0.6218 pd=2.83 ps=3.42
XM7 VPWR#12 GATE#3 a_283_392# VPB sky130_fd_pr__pfet_01v8 l=0.15 w=1 ad=0.6218 as=0.27 pd=3.42 ps=2.54
XM13 a_283_392# a_334_338##3 a_84_48##4 VPB sky130_fd_pr__pfet_01v8 l=0.15 w=1 ad=0.27 as=0.4204 pd=2.54 ps=3.27
XM23 a_84_48##4 a_334_54##3 a_524_508# VPB sky130_fd_pr__pfet_01v8 l=0.15 w=0.42 ad=0.4204 as=0.1134 pd=3.27 ps=1.38
XM1 a_524_508# a_27_74# VPWR#10 VPB sky130_fd_pr__pfet_01v8 l=0.15 w=0.42 ad=0.1134 as=0.3696 pd=1.38 ps=3.04
XM18 VPWR#10 a_334_54##8 a_334_338##4 VPB sky130_fd_pr__pfet_01v8 l=0.15 w=0.84 ad=0.3696 as=0.2478 pd=3.04 ps=2.27
XM21 a_334_54##13 CLK#6 VPWR#9 VPB sky130_fd_pr__pfet_01v8 l=0.15 w=0.84 ad=0.2478 as=0.4228 pd=2.27 ps=3.04
XM10 VPWR#9 CLK#4 a_1044_368##16 VPB sky130_fd_pr__pfet_01v8 l=0.15 w=1.12 ad=0.4228 as=0.3752 pd=3.04 ps=2.91
XM6 a_1044_368##16 a_27_74##4 VPWR#8 VPB sky130_fd_pr__pfet_01v8 l=0.15 w=1.12 ad=0.3752 as=1.0696 pd=2.91 ps=4.15
XM15 VPWR#8 a_1044_368##13 GCLK#3 VPB sky130_fd_pr__pfet_01v8 l=0.15 w=1.12 ad=1.0696 as=0.3528 pd=4.15 ps=2.87
XM19 GCLK#3 a_1044_368##11 VPWR#7 VPB sky130_fd_pr__pfet_01v8 l=0.15 w=1.12 ad=0.3528 as=0.3752 pd=2.87 ps=2.91
XM20 VPWR#7 a_1044_368##9 GCLK#5 VPB sky130_fd_pr__pfet_01v8 l=0.15 w=1.12 ad=0.3752 as=0.336 pd=2.91 ps=2.84
XM2 GCLK#5 a_1044_368##7 VPWR#1 VPB sky130_fd_pr__pfet_01v8 l=0.15 w=1.12 ad=0.336 as=0.3304 pd=2.84 ps=2.83
*
*
*       RESISTOR AND CAP/DIODE CARDS
*
Rg1	a_84_48#	a_84_48##2	485.005890
Rg2	a_84_48##2	a_84_48##3	399.088348
Rg3	GATE#1	GATE#2	462.880432
Rg4	GATE#2	GATE#3	400.207520
Rg5	a_334_54#	a_334_54##2	273.016113
Rg6	a_334_54##3	a_334_54##4	394.020355
Rg7	a_334_338#	a_334_338##2	397.112518
Rg8	a_334_338##2	a_334_338##3	665.943787
Rg9	a_27_74#	a_27_74##2	777.930420
Rg10	a_27_74##2	a_27_74##3	555.191162
Rg11	a_334_54##5	a_334_54##6	361.100891
Rg12	a_334_54##6	a_334_54##7	447.214294
Rg13	a_334_54##7	a_334_54##8	347.244904
Rg14	CLK#1	CLK#2	397.555725
Rg15	CLK#2	CLK#3	63.080887
Rg16	CLK#2	CLK#4	449.655212
Rg17	CLK#3	CLK#5	404.651337
Rg18	CLK#3	CLK#6	473.982239
Rg19	a_27_74##4	a_27_74##5	456.846832
Rg20	a_27_74##5	a_27_74##6	353.846649
Rg21	a_1044_368#	a_1044_368##2	462.592560
Rg22	a_1044_368##2	a_1044_368##3	76.088158
Rg23	a_1044_368##3	a_1044_368##4	101.927917
Rg24	a_1044_368##4	a_1044_368##5	93.030113
Rg25	a_1044_368##5	a_1044_368##6	217.872910
Rg26	a_1044_368##2	a_1044_368##7	485.998962
Rg27	a_1044_368##3	a_1044_368##8	444.535370
Rg28	a_1044_368##3	a_1044_368##9	430.188812
Rg29	a_1044_368##4	a_1044_368##10	438.382172
Rg30	a_1044_368##4	a_1044_368##11	424.035614
Rg31	a_1044_368##5	a_1044_368##12	457.682709
Rg32	a_1044_368##5	a_1044_368##13	443.336151
Rf1	GATE#4	GATE	0.566040
Rf2	GATE#2	GATE#6	160.798843
Rf3	GATE#4	GATE#6	3.093828
Rf4	a_84_48##4	a_84_48##5	165.912933
Rf5	a_84_48##5	a_84_48##6	115.849274
Rf6	a_334_338##4	a_334_338##6	67.170151
Rf7	a_334_338##6	a_334_338##2	273.610046
Rf8	a_334_338##5	a_334_338##6	15.000000
Rf9	a_334_54##7	a_334_54##10	186.336380
Rf10	a_334_54##10	a_334_54##4	36.005322
Rf11	a_334_54##4	a_334_54#	218.024200
Rf12	a_334_54##10	a_334_54##13	94.365570
Rf13	a_334_54##14	a_334_54##5	204.428360
Rf14	CLK#7	CLK	1.491315
Rf15	CLK#3	CLK#9	81.607719
Rf16	CLK#7	CLK#9	5.470429
Rf17	a_27_74##5	a_27_74##3	381.163055
Rf18	a_27_74##3	a_27_74##9	229.001160
Rf19	a_27_74##9	a_27_74##10	17.478760
Rf20	a_27_74##9	a_27_74##11	70.331825
Rf21	a_1044_368##14	a_1044_368##6	17.335651
Rf22	a_1044_368##6	a_1044_368##16	90.860840
Rf23	GCLK#1	GCLK#2	80.831947
Rf24	GCLK#2	GCLK	21.619350
Rf25	GCLK	GCLK#3	95.611565
Rf26	GCLK#2	GCLK#4	36.136055
Rf27	GCLK	GCLK#5	42.625946
Rf28	VPWR#1	VPWR#2	83.319763
Rf29	VPWR#2	VPWR#3	19.025946
Rf30	VPWR#3	VPWR#4	90.710625
Rf31	VPWR#4	VPWR#5	93.575294
Rf32	VPWR#5	VPWR#6	112.838478
Rf33	VPWR#3	VPWR#7	46.469112
Rf34	VPWR#4	VPWR#8	14.472533
Rf35	VPWR#5	VPWR#9	35.471458
Rf36	VPWR#6	VPWR#10	27.179398
Rf37	VPWR#6	VPWR#11	176.187363
Rf38	VPWR#11	VPWR#12	29.559616
Rf40	VGND#1	VGND#2	77.552643
Rf41	VGND#2	VGND#3	16.103926
Rf42	VGND#3	VGND#4	76.854980
Rf43	VGND#4	VGND#5	106.748337
Rf44	VGND#5	VGND#6	117.842438
Rf45	VGND#3	VGND#7	38.736572
Rf46	VGND#4	VGND#8	21.683937
Rf47	VGND#5	VGND#9	38.641060
Rf48	VGND#6	VGND#10	191.527969
Rf50	VGND#6	VGND#12	45.288342
Rf51	VGND#10	VGND#13	30.002884
Rf53	a_84_48##2	a_84_48##5	160.232803
Re1	VPWR#2	VPWR	3.735117
Re2	VPWR	VPWR#6	1.067176
Re3	VGND#2	VGND	3.735117
Re4	VGND	VGND#6	1.067176
*
*       CAPACITOR CARDS
*
*
C1	GCLK#1	VGND#7	7.17246e-17
C2	VPWR#9	VPWR#4	2.00382e-18
C3	a_84_48##6	a_84_48##3	1.37483e-18
C4	a_334_54##10	a_27_74#	2.10004e-17
C5	a_27_74##11	VPWR#12	4.48814e-17
C6	GATE#1	VGND#13	1.26404e-17
C7	a_334_54##13	VPWR#5	2.02488e-17
C8	VGND#2	VGND#4	1.83548e-17
C9	a_1044_368##14	a_1044_368##13	3.57081e-18
C10	VGND#13	a_84_48##3	3.81627e-17
C11	a_334_54##10	a_334_54##3	6.10381e-19
C12	VGND#2	VGND#3	5.4195e-17
C13	VPWR#2	VPWR#4	1.57712e-17
C14	a_84_48##3	a_27_74##10	1.77574e-18
C15	VPWR#2	VPWR#3	5.01577e-17
C16	a_1044_368##14	a_27_74##4	2.11391e-18
C17	a_334_54##10	a_334_338##3	1.63653e-20
C18	a_1044_368##14	GCLK#1	3.09061e-17
C19	VPWR#10	VPWR#5	3.34133e-19
C20	a_1044_368##14	CLK#4	2.39459e-19
C21	a_1044_368##8	a_1044_368#	4.15249e-17
C22	VGND#6	VGND#5	2.52882e-19
C23	a_334_54##10	GATE#3	2.22469e-20
C24	a_1044_368##14	VGND#8	2.84243e-18
C25	VGND#2	GCLK#2	2.48787e-18
C26	a_334_338##5	a_27_74##4	2.74906e-20
C27	VPWR#1	a_1044_368##7	4.90645e-17
C28	a_1044_368##10	a_1044_368##8	3.04195e-17
C29	GCLK#5	a_1044_368##7	1.96839e-17
C30	VPWR#1	a_1044_368##9	3.33941e-18
C31	a_334_338##5	CLK#4	4.92601e-20
C32	VGND#4	a_1044_368##6	1.3028e-17
C33	VPWR#7	a_1044_368##7	6.75994e-19
C34	GCLK#5	a_1044_368##9	5.24465e-17
C35	VPWR#1	a_1044_368##11	3.02316e-19
C36	a_1044_368##12	a_1044_368##10	4.07097e-17
C37	a_1044_368##9	VPWR#7	2.65288e-17
C38	VGND#5	a_27_74##5	3.87843e-18
C39	GCLK#5	a_1044_368##11	2.0676e-18
C40	VGND#4	a_27_74##5	1.12999e-19
C41	GCLK#3	a_1044_368##9	1.90784e-18
C42	VGND#9	a_1044_368##14	1.90215e-17
C43	VPWR#4	a_1044_368##6	7.12675e-18
C44	a_1044_368##11	VPWR#7	3.39407e-17
C45	a_27_74##6	a_1044_368##12	1.5477e-18
C46	GCLK#5	a_1044_368##13	1.53801e-19
C47	GCLK#3	a_1044_368##11	2.36071e-17
C48	VGND#5	CLK#3	5.22559e-20
C49	VPWR#7	a_1044_368##13	2.11276e-18
C50	VPWR#4	a_27_74##5	5.85628e-19
C51	GCLK#3	a_1044_368##13	5.64388e-17
C52	CLK#1	a_27_74##6	5.22472e-17
C53	VPWR#7	a_27_74##4	5.79963e-20
C54	a_1044_368##13	VPWR#8	1.45567e-17
C55	VGND#3	a_1044_368#	5.59748e-19
C56	VGND#5	a_334_54##5	1.75206e-18
C57	VGND#4	a_1044_368##5	2.5948e-18
C58	GCLK#3	a_27_74##4	6.80694e-19
C59	CLK#3	VPWR#5	1.05893e-19
C60	VGND#4	a_334_54##5	9.4672e-20
C61	a_1044_368##16	a_1044_368##13	4.92732e-19
C62	VGND#4	a_1044_368##8	3.13167e-19
C63	a_27_74##4	VPWR#8	2.55759e-17
C64	a_334_54##14	VGND#9	4.73697e-17
C65	VPWR#9	a_1044_368##13	1.24749e-19
C66	CLK#5	CLK#1	3.97907e-17
C67	a_1044_368##16	a_27_74##4	8.14295e-17
C68	VGND#3	a_1044_368##8	1.85414e-18
C69	VGND#4	a_1044_368##4	9.49412e-21
C70	VPWR#9	a_27_74##4	2.72116e-18
C71	VGND#4	a_1044_368##10	1.28846e-18
C72	a_1044_368##16	CLK#4	2.12865e-17
C73	a_334_54##6	CLK#5	3.56973e-18
C74	a_84_48##6	a_334_338##3	2.75936e-19
C75	VGND#2	VGND#1	6.10137e-17
C76	VGND#1	VPWR#1	3.09145e-19
C77	CLK#4	VPWR#9	3.4553e-17
C78	VGND#3	a_1044_368##10	4.7142e-18
C79	VGND#5	a_1044_368##12	2.01137e-19
C80	VGND#2	GCLK#4	2.94171e-17
C81	a_334_338##4	a_27_74##4	2.09377e-19
C82	a_1044_368##16	CLK#6	1.44202e-18
C83	a_334_54##13	CLK#4	1.23668e-18
C84	CLK#6	VPWR#9	2.96964e-17
C85	VGND#4	a_1044_368##12	1.47825e-17
C86	a_334_54##10	a_334_54##13	2.38988e-18
C87	VGND#2	GCLK#1	1.79954e-17
C88	a_27_74##2	a_334_54##6	1.02757e-17
C89	a_334_338##4	CLK#4	2.86112e-19
C90	VGND#12	a_334_54##14	7.51358e-18
C91	a_1044_368##16	a_334_54##8	2.67303e-19
C92	VGND#3	a_1044_368##4	4.1974e-20
C93	a_334_54##13	CLK#6	6.48035e-17
C94	VPWR#10	CLK#4	3.14063e-19
C95	VGND#3	a_1044_368##12	5.76895e-19
C96	VGND#5	a_27_74##6	5.98033e-18
C97	VPWR#9	a_334_54##8	5.96992e-19
C98	a_334_338##4	CLK#6	2.32099e-18
C99	a_334_338##5	VGND#12	1.63778e-18
C100	a_334_54##13	a_334_54##8	4.75283e-18
C101	a_334_54##10	a_334_338##4	3.45939e-17
C102	VGND#3	VGND#1	1.15638e-18
C103	a_334_338#	a_27_74##2	1.16481e-17
C104	VGND#4	a_27_74##6	2.47281e-18
C105	VPWR#10	CLK#6	2.12627e-18
C106	GCLK#2	a_1044_368#	5.39471e-18
C107	VPWR#9	a_27_74#	1.5862e-19
C108	a_27_74##9	a_27_74##11	2.28074e-18
C109	a_334_338##4	a_334_54##8	2.19838e-17
C110	VGND#3	a_27_74##6	1.49773e-20
C111	a_334_54##13	a_27_74#	9.67593e-19
C112	VGND#5	CLK#1	8.24117e-18
C113	a_334_54##8	VPWR#10	2.76517e-17
C114	a_84_48##4	CLK#6	6.32595e-19
C115	a_334_54##10	VPWR#10	3.36973e-17
C116	a_334_338##4	a_27_74#	6.06762e-20
C117	a_334_54##2	a_334_338#	1.4219e-17
C118	a_27_74##9	a_27_74##3	1.66175e-18
C119	VGND#4	CLK#1	2.92599e-19
C120	GCLK#2	a_1044_368##8	1.23837e-17
C121	a_334_54##13	a_334_54##3	2.43852e-19
C122	VGND#4	VGND#7	2.31892e-18
C123	a_27_74#	VPWR#10	2.49292e-17
C124	a_84_48##4	a_334_54##8	1.47804e-18
C125	GCLK#1	a_1044_368##6	4.38904e-18
C126	VGND#5	CLK#5	7.86964e-18
C127	VPWR#10	a_334_54##3	1.12398e-17
C128	GATE#1	a_334_54##2	4.21027e-17
C129	a_1044_368##14	a_1044_368##6	5.3589e-17
C130	a_84_48##4	a_27_74#	2.46069e-18
C131	VGND#6	a_334_54##14	2.33849e-18
C132	VPWR#2	a_1044_368##5	4.79373e-23
C133	a_334_54##7	a_334_54##10	3.09805e-18
C134	GCLK#2	a_1044_368##10	8.67406e-19
C135	VPWR#2	VPWR#1	6.03844e-17
C136	VGND#4	GCLK#1	2.93634e-17
C137	a_1044_368##3	GCLK#5	2.15773e-19
C138	GCLK#5	VPWR#2	3.13296e-17
C139	VPWR#10	a_334_338##3	1.21384e-18
C140	a_84_48##4	a_334_54##3	3.3721e-17
C141	a_84_48##4	a_334_54##10	6.22379e-18
C142	VPWR#2	a_1044_368##3	1.82349e-20
C143	GCLK#1	GCLK#3	4.88358e-17
C144	VPWR#12	a_27_74#	4.96547e-19
C145	a_27_74##5	a_1044_368##14	8.91598e-17
C146	a_84_48##3	GATE#1	9.00228e-18
C147	VPWR#2	a_1044_368##2	2.2017e-20
C148	a_334_54##10	a_27_74##3	2.35191e-19
C149	a_1044_368##2	GCLK#5	2.60526e-19
C150	VPWR#2	GCLK#3	1.90346e-17
C151	VPWR#10	GATE#3	8.28037e-19
C152	VGND#3	GCLK#1	8.85533e-18
C153	a_84_48##4	a_334_338##3	5.71567e-17
C154	VPWR#12	a_334_54##3	8.06313e-19
C155	a_27_74##5	VGND#9	3.59345e-17
C156	VGND#4	VGND#8	8.10599e-18
C157	a_1044_368##4	VPWR#7	2.4276e-18
C158	a_27_74##5	a_334_54##14	4.28651e-17
C159	CLK#3	a_1044_368##14	4.86951e-18
C160	VGND#5	a_1044_368##14	1.94492e-18
C161	VGND#2	GCLK#3	4.8548e-18
C162	a_84_48##4	GATE#3	1.89085e-17
C163	a_27_74##5	a_334_338##5	1.84434e-17
C164	VPWR#12	a_334_338##3	3.73384e-18
C165	a_334_54##10	a_334_54##4	8.38574e-20
C166	a_27_74##9	a_334_54#	5.47677e-20
C167	a_1044_368##14	GCLK#3	2.23519e-17
C168	VGND#9	CLK#3	5.34479e-19
C169	a_27_74##5	VGND#12	2.44542e-22
C170	a_1044_368##3	VPWR#7	1.72587e-18
C171	a_27_74##11	a_334_338##3	2.82828e-19
C172	a_334_54##14	CLK#3	1.48445e-18
C173	a_84_48##4	a_84_48#	2.13941e-18
C174	VGND#2	a_1044_368##3	3.33247e-20
C175	GATE#3	VPWR#12	2.91211e-17
C176	VGND#4	a_1044_368##14	5.65931e-17
C177	GCLK#3	a_1044_368##5	1.49698e-17
C178	a_334_338##5	CLK#3	9.67519e-18
C179	VGND#2	a_1044_368##2	6.78448e-20
C180	a_27_74##11	GATE#3	2.60017e-18
C181	a_1044_368##14	VPWR#8	3.34951e-18
C182	a_334_338##2	a_334_54##10	7.49886e-18
C183	a_27_74##9	GATE#2	1.25872e-18
C184	a_84_48#	VPWR#12	3.84503e-17
C185	GCLK#3	a_1044_368##4	1.4707e-17
C186	VPWR#4	a_1044_368##5	2.20926e-18
C187	a_334_54##5	a_334_338##5	2.19774e-18
C188	a_27_74##11	a_84_48#	5.13443e-17
C189	a_1044_368##9	a_1044_368##7	4.7148e-17
C190	VGND#12	a_334_54##5	2.17463e-17
C191	a_1044_368##14	a_1044_368##16	3.05097e-18
C192	VGND#5	VGND#4	3.41043e-19
C193	GCLK#2	VGND#1	3.39797e-18
C194	a_27_74##9	a_84_48##2	1.18819e-16
C195	a_1044_368##6	VPWR#8	1.34846e-18
C196	a_334_338##5	a_334_54##7	6.42858e-17
C197	a_1044_368##11	a_1044_368##9	4.08136e-17
C198	VGND#12	a_334_54##7	1.21587e-18
C199	a_27_74##3	VGND#9	1.40036e-20
C200	VGND#9	VGND#4	8.41713e-19
C201	a_27_74##5	VPWR#8	3.95187e-19
C202	a_1044_368##5	a_1044_368##4	4.77836e-18
C203	GCLK#2	GCLK#4	2.54791e-18
C204	a_27_74##3	a_334_338##5	6.56204e-17
C205	a_27_74##5	a_1044_368##16	4.95425e-17
C206	VGND#5	a_334_54##14	3.77127e-17
C207	VPWR#3	a_1044_368##5	3.71307e-21
C208	a_27_74##3	VGND#12	9.55035e-17
C209	a_1044_368##13	a_1044_368##11	4.38166e-17
C210	a_334_338##3	a_27_74##2	3.53495e-20
C211	VGND#2	a_1044_368#	1.48116e-18
C212	a_27_74##5	a_334_54##13	5.98953e-18
C213	a_27_74##3	a_84_48##6	7.60551e-17
C214	a_1044_368##16	CLK#3	2.9629e-19
C215	VGND#2	a_1044_368##8	5.54846e-18
C216	VGND#7	GCLK#2	2.07399e-17
C217	CLK#3	VPWR#9	3.17732e-17
C218	VGND#4	VGND#3	1.32407e-18
C219	VGND#2	a_1044_368##10	1.81115e-19
C220	a_27_74##4	a_1044_368##13	4.30044e-18
C221	VGND#13	a_27_74##3	1.37415e-19
C222	VPWR#3	a_1044_368##4	1.99909e-20
C223	a_334_54##13	CLK#3	1.75043e-18
C224	a_334_338##5	a_1044_368##16	1.94619e-18
C225	VGND#2	a_1044_368##12	3.63277e-18
C226	a_84_48##6	a_334_54##4	2.98788e-18
C227	a_334_338##2	a_334_338##5	1.50642e-18
C228	a_334_338##4	CLK#3	4.29648e-19
C229	a_1044_368##14	VPWR#4	4.29523e-17
C230	a_334_338##2	VGND#12	2.34181e-19
C231	CLK#4	a_27_74##4	3.91484e-17
C232	a_334_54##13	a_334_54##5	4.12741e-19
C233	GCLK#1	GCLK#2	2.82911e-18
C234	a_1044_368##16	a_334_54##7	1.10092e-18
C235	a_84_48##6	a_334_338##2	4.63064e-18
C236	a_1044_368##6	a_1044_368##5	2.86798e-18
C237	a_334_54##13	a_334_54##7	9.27687e-19
C238	CLK#6	CLK#4	3.37906e-17
C239	a_334_54##7	a_334_338##4	1.86853e-17
C240	a_334_54#	a_84_48##6	7.09577e-17
C241	a_334_338##5	a_334_54##13	3.64732e-18
C242	a_1044_368##6	a_1044_368##12	2.25341e-17
C243	a_334_54##7	VPWR#10	1.18452e-18
C244	a_334_54##8	CLK#4	2.81181e-20
C245	GCLK#5	VPWR#1	7.76586e-17
C246	a_27_74##6	a_1044_368##6	1.70641e-17
C247	VGND#6	CLK#5	2.95969e-19
C248	a_27_74##9	a_334_338#	3.36865e-19
C249	a_334_54##8	CLK#6	5.12612e-18
C250	a_1044_368##4	a_1044_368##3	4.01349e-18
C251	a_84_48##6	GATE#2	5.68782e-18
C252	a_334_338##5	a_334_338##4	2.27415e-18
C253	a_27_74##5	a_27_74##6	3.19177e-18
C254	VPWR#7	VPWR#1	2.35578e-18
C255	VGND#1	a_1044_368#	3.85657e-17
C256	a_1044_368##14	GCLK#2	1.27537e-19
C257	a_27_74##5	CLK#1	2.16866e-17
C258	VGND#6	a_334_338#	1.11547e-18
C259	a_27_74#	a_334_54##8	2.36117e-17
C260	a_334_54##4	VPWR#10	3.57877e-18
C261	VPWR#2	a_1044_368##7	4.20818e-18
C262	a_27_74##5	CLK#5	2.60848e-17
C263	a_27_74##9	a_334_54##2	1.48723e-18
C264	a_1044_368#	GCLK#4	1.13335e-17
C265	VPWR#7	GCLK#5	8.05902e-17
C266	VPWR#2	a_1044_368##9	5.95892e-18
C267	a_27_74##5	a_334_54##6	1.34451e-19
C268	a_334_54##4	a_84_48##4	1.15699e-16
C269	a_84_48##2	VGND#13	2.58266e-18
C270	VGND#1	a_1044_368##8	2.82602e-18
C271	GCLK#2	a_1044_368##4	8.56803e-19
C272	VPWR#10	a_334_338##2	6.20953e-20
C273	VPWR#2	a_1044_368##11	4.83754e-19
C274	a_334_54##3	a_27_74#	2.93302e-17
C275	VGND#7	a_1044_368#	7.00712e-19
C276	a_334_54##6	CLK#3	3.98082e-18
C277	VGND#7	a_1044_368##4	7.37724e-19
C278	VPWR#2	a_1044_368##13	5.28097e-18
C279	CLK#2	a_27_74##5	3.96836e-17
C280	GCLK#3	GCLK#5	1.32125e-18
C281	a_334_338##3	a_27_74#	4.54831e-19
C282	a_334_338##2	a_84_48##4	1.09155e-18
C283	GCLK#4	a_1044_368##8	3.32975e-17
C284	a_334_54##5	CLK#5	8.15794e-18
C285	a_27_74##9	GATE#1	2.42096e-17
C286	VGND#4	VPWR#4	4.02796e-18
C287	a_334_338##3	a_334_54##3	9.33065e-18
C288	VGND#1	a_1044_368##10	3.17337e-19
C289	CLK#2	VPWR#9	5.78199e-19
C290	GCLK#2	a_1044_368##3	1.2889e-17
C291	a_1044_368##8	VGND#7	1.91823e-17
C292	a_84_48##4	a_334_54#	3.46654e-19
C293	GCLK#3	VPWR#7	1.05479e-16
C294	CLK#3	a_1044_368##5	2.47181e-19
C295	VGND#7	a_1044_368##3	1.13749e-18
C296	a_27_74##3	CLK#1	1.93197e-19
C297	GCLK#1	a_1044_368##5	4.75542e-18
C298	GCLK#4	a_1044_368##10	9.80465e-19
C299	GATE#3	a_334_338##3	5.08706e-17
C300	a_27_74##2	a_334_54##7	2.56879e-17
C301	a_27_74##9	a_84_48##3	3.59835e-17
C302	a_27_74##3	CLK#5	3.73479e-19
C303	GCLK#1	a_1044_368##8	1.5471e-18
C304	GATE#2	a_84_48##4	9.3877e-18
C305	a_27_74##3	a_334_54##6	2.95295e-17
C306	VPWR#3	a_1044_368##7	5.32686e-19
C307	a_1044_368##10	VGND#7	2.34264e-17
C308	a_27_74##3	a_27_74##2	1.86107e-17
C309	GCLK#2	a_1044_368##2	6.48084e-18
C310	VPWR#12	GATE#2	1.10796e-18
C311	GCLK#1	a_1044_368##4	1.25328e-17
C312	CLK#3	CLK#2	1.6576e-17
C313	a_84_48#	GATE#3	1.59319e-17
C314	a_1044_368##3	a_1044_368##2	4.58776e-18
C315	a_334_338#	a_27_74##3	3.11332e-17
C316	a_27_74##11	GATE#2	2.22332e-19
C317	VPWR#4	a_1044_368##9	3.43186e-19
C318	GCLK#1	a_1044_368##10	5.28615e-17
C319	a_27_74##3	a_334_54##2	1.67174e-17
C320	a_334_54##4	a_27_74##2	6.03807e-20
C321	a_84_48##2	VPWR#12	4.63799e-17
C322	a_27_74##3	GATE#1	4.12106e-19
C323	VGND#7	a_1044_368##12	6.97499e-19
C324	a_84_48##2	a_27_74##11	4.66092e-17
C325	VPWR#3	a_1044_368##9	1.84223e-18
C326	a_84_48##6	a_84_48##4	6.44678e-18
C327	a_334_338##2	a_27_74##2	5.25365e-17
C328	CLK#3	a_27_74##4	9.95486e-19
C329	a_1044_368##16	GCLK#3	1.36448e-18
C330	GCLK#1	a_1044_368##12	4.04693e-17
C331	a_27_74##9	a_286_80#	5.15817e-20
C332	a_334_54#	a_334_54##6	3.21238e-19
C333	a_1044_368##3	a_1044_368##7	2.31808e-19
C334	CLK#3	CLK#4	6.34375e-18
C335	VPWR#4	a_1044_368##11	7.30962e-19
C336	a_334_54#	a_27_74##2	1.07351e-18
C337	GCLK	a_1044_368##4	2.02417e-18
C338	VGND#7	a_27_74##6	5.60639e-20
C339	GCLK	a_1044_368##3	1.69455e-17
C340	GCLK	a_1044_368##2	1.644e-17
C341	a_334_54#	a_334_338#	1.1664e-17
C342	a_1044_368##16	VPWR#8	7.02014e-19
C343	VPWR#12	a_524_508#	8.18738e-20
C344	VPWR#3	a_1044_368##11	2.98605e-18
C345	a_84_48##4	a_283_392#	1.54458e-17
C346	GATE#1	a_334_54#	9.03259e-18
C347	GCLK#1	a_27_74##6	2.5892e-19
C348	a_1044_368##14	a_1044_368##12	7.72396e-18
C349	a_334_54##7	CLK#6	2.43298e-18
C350	VPWR#4	a_1044_368##13	2.56319e-17
C351	VPWR#5	VPWR#4	1.00423e-18
C352	a_27_74#	a_334_54##7	4.45731e-18
C353	VPWR#3	a_1044_368##13	5.80544e-19
C354	a_1044_368##14	a_1044_368##5	2.45843e-18
C355	a_84_48##2	GATE#1	1.14631e-17
C356	VPWR#9	a_1044_368##16	8.46235e-17
C357	a_1044_368##14	a_27_74##6	4.42835e-17
C358	a_334_54##7	a_334_338##3	1.12532e-19
C359	VGND#9	a_1044_368##12	9.69301e-20
C360	VPWR#4	a_27_74##4	2.4333e-17
C361	a_334_54##4	a_27_74#	4.2579e-17
C362	VPWR#3	a_27_74##4	1.62725e-20
C363	a_1044_368##14	CLK#1	5.10269e-18
C364	a_334_54##4	a_334_338##3	2.21262e-17
C365	a_84_48##6	a_286_80#	1.12076e-18
C366	VPWR#5	CLK#4	5.09811e-18
C367	VGND#9	a_27_74##6	3.41544e-18
C368	a_334_54##4	GATE#3	1.78331e-18
C369	a_334_54##13	VPWR#9	6.58371e-17
C370	a_27_74##6	a_1047_74#	1.52833e-17
C371	a_27_74##5	a_1044_368##6	3.76083e-17
C372	a_334_338##4	a_1044_368##16	3.24274e-18
C373	a_334_54##4	a_84_48#	1.9784e-20
C374	CLK#1	a_1047_74#	1.68773e-17
C375	VPWR#4	CLK#4	7.1311e-19
C376	VGND#6	a_334_54##5	5.45112e-17
C377	a_334_54#	a_334_338##3	3.48378e-17
C378	a_1044_368##14	CLK#5	7.9426e-19
C379	VPWR#4	VPWR#3	8.41701e-19
C380	CLK	VPWR#5	3.44122e-19
C381	a_27_74##5	CLK#3	6.97462e-17
C382	VGND#9	CLK#1	3.26866e-17
C383	GATE#2	a_334_338##3	1.88835e-17
C384	VGND	a_1044_368##5	3.95632e-18
C385	a_334_54#	a_84_48#	8.96435e-20
C386	a_334_54##5	a_27_74##5	6.28428e-18
C387	VGND#6	a_27_74##3	9.93455e-17
C388	VPWR#5	CLK#6	1.3384e-17
C389	a_84_48##2	a_334_338##3	4.20381e-19
C390	a_27_74##2	a_491_124#	8.35778e-18
C391	a_84_48#	GATE#2	4.25032e-18
C392	a_1044_368##14	a_334_54##6	3.91431e-19
C393	a_84_48##2	GATE#3	1.33761e-17
C394	VPWR#4	CLK#6	4.8933e-19
C395	a_334_54##13	a_334_338##4	5.5824e-17
C396	VPWR#10	VPWR#9	6.12137e-19
C397	a_334_54##7	CLK#3	5.41327e-18
C398	a_27_74#	a_524_508#	1.06762e-17
C399	a_84_48##2	a_84_48#	7.12729e-18
C400	VGND#9	CLK#5	2.83732e-17
C401	VGND#6	a_334_338##2	8.15641e-20
C402	a_27_74##9	a_84_48##6	4.0731e-17
C403	a_334_54##3	a_524_508#	1.06762e-17
C404	VGND#4	GCLK#3	3.84342e-19
C405	a_1044_368##14	CLK#2	2.38232e-19
C406	a_27_74##3	a_334_54##5	2.11842e-17
C407	GCLK#2	GCLK	2.6993e-17
C408	CLK#5	a_334_54##14	2.39738e-17
C409	a_334_54##13	VPWR#10	1.22414e-17
C410	a_27_74##3	a_334_54##7	1.42247e-18
C411	a_334_338##3	a_283_392#	6.17329e-18
C412	a_334_338##2	CLK#3	3.5917e-19
C413	VGND#9	a_334_54##6	2.86083e-19
C414	GATE#3	a_283_392#	1.33603e-17
C415	a_334_54##4	a_334_54##7	2.31476e-18
C416	VPWR#4	a_334_54##8	7.61533e-21
C417	a_334_54##4	a_27_74##3	3.20937e-19
C418	a_334_338##2	a_334_54##7	6.56803e-18
C419	a_1044_368##5	VNB	2.59223e-17
C420	a_1044_368##4	VNB	2.9221e-17
C421	a_1044_368##3	VNB	2.55168e-17
C422	a_334_338##5	CLK	2.88877e-17
C423	a_1044_368##2	VNB	3.73661e-17
C424	CLK#2	VNB	2.25628e-17
C425	VPWR	VPWR#5	7.73525e-17
C426	VPWR#3	VPWR#1	9.54295e-19
C427	a_334_54##14	a_334_54##6	3.73701e-18
C428	VPWR	VPWR#4	1.31989e-16
C429	a_27_74##3	a_334_338##2	4.3534e-17
C430	a_334_54##2	a_286_80#	1.08205e-17
C431	a_334_54#	a_334_54##7	1.27853e-18
C432	GATE#1	a_286_80#	1.15469e-17
C433	VGND#1	GCLK	1.20681e-17
C434	a_334_338##2	a_334_54##4	6.71232e-17
C435	a_334_54#	a_27_74##3	4.09823e-18
C436	VGND#12	CLK#5	1.07421e-18
C437	GCLK#1	GCLK	3.02145e-18
C438	a_1044_368##14	GCLK	1.35508e-19
C439	a_334_338##5	a_334_54##6	2.98843e-17
C440	a_27_74##4	a_1044_368##5	1.71799e-19
C441	GATE	VPWR#12	1.42267e-18
C442	a_334_54#	a_334_338##2	6.95418e-17
C443	VPWR	a_334_54##10	1.28665e-17
C444	a_27_74##9	VGND#13	1.14078e-16
C445	CLK	a_334_54##13	1.22885e-17
C446	VGND	VGND#5	1.07364e-16
C447	GATE#2	a_334_338##2	1.58726e-18
C448	VGND	VGND#4	8.12536e-17
C449	a_84_48##2	a_334_54##4	3.80805e-19
C450	VGND#12	a_334_54##6	2.33162e-17
C451	GCLK	VPWR#1	3.18568e-17
C452	GATE#2	a_334_54#	3.7351e-17
C453	a_84_48##2	a_334_338##2	1.22504e-19
C454	GCLK	VPWR#7	1.76718e-17
C455	GCLK#3	GCLK	1.53265e-18
C456	VGND	a_27_74##9	3.65667e-17
C457	VPWR	a_1044_368##14	4.60573e-18
C458	a_84_48##2	a_334_54#	4.06482e-18
C459	a_334_338##5	a_27_74##2	1.49783e-19
C460	a_27_74##5	a_1047_74#	4.06657e-18
C461	VPWR#4	VPWR#7	2.51385e-18
C462	VPWR	a_334_338##5	4.03066e-18
C463	a_84_48##2	GATE#2	5.49791e-17
C464	a_84_48##4	VPWR#10	1.22657e-17
C465	CLK	a_334_54##6	3.97615e-19
C466	a_27_74##2	VGND#12	1.27645e-17
C467	a_27_74##9	a_27_74##10	8.78217e-18
C468	VGND#5	VNB	4.53008e-17
C469	VGND#4	VNB	4.76524e-17
C470	VPWR	a_1044_368##16	1.9171e-17
C471	GCLK#4	VGND#1	5.47451e-17
C472	VGND#3	VNB	1.9984e-17
C473	VPWR	VPWR#9	2.09508e-17
C474	VGND	a_1044_368##14	2.57611e-17
C475	VPWR	a_334_54##13	2.62866e-17
C476	VPWR#5	VNB	3.98037e-17
C477	VPWR#4	VNB	5.31076e-17
C478	VPWR	a_334_338##4	5.17272e-18
C479	VPWR#3	VNB	1.85963e-17
C480	VGND	a_334_54##14	1.8535e-17
C481	VPWR	VPWR#10	1.39572e-16
C482	CLK#2	a_27_74##4	1.13982e-18
C483	GCLK#2	VNB	6.36887e-18
C484	VGND	a_334_338##5	5.22578e-18
C485	a_27_74##9	VNB	6.53681e-17
C486	VPWR	a_84_48##4	3.50508e-17
C487	VGND	a_84_48##6	1.73232e-17
C488	a_334_338##2	a_491_124#	4.45746e-18
C489	VGND	VGND#13	1.89161e-17
C490	VPWR	a_27_74##11	2.17394e-17
C491	VPWR#4	GCLK#3	9.12484e-17
C492	a_334_54##10	VNB	5.30057e-18
C493	VGND	a_1044_368##16	4.12065e-18
C494	GCLK	a_1044_368##7	7.68106e-18
C495	GATE	a_84_48#	9.93029e-19
C496	VGND#9	CLK#2	3.32835e-19
C497	a_334_338##5	a_334_54##10	2.05619e-19
C498	GCLK	a_1044_368##9	9.45609e-19
C499	VGND#1	VNB	5.94803e-17
C500	GCLK#4	VNB	2.24153e-18
C501	GCLK	a_1044_368##11	2.94939e-19
C502	a_27_74##3	a_286_80#	1.06521e-18
C503	a_84_48##6	a_27_74##2	2.10311e-18
C504	VGND#7	VNB	3.0111e-18
C505	GCLK#1	VNB	2.9113e-18
C506	GCLK	a_1044_368##13	1.17888e-19
C507	VGND#7	VGND#1	2.49656e-18
C508	a_1044_368##14	VNB	1.08555e-17
C509	VGND#9	VNB	2.80476e-20
C510	a_334_54##14	VNB	7.45536e-18
C511	a_334_338##5	VNB	6.0989e-18
C512	VGND	a_27_74##11	1.38524e-18
C513	VGND#12	VNB	3.31774e-18
C514	a_84_48##6	VNB	3.81785e-18
C515	GCLK#3	VPWR#3	9.27695e-18
C516	VGND#13	VNB	2.99238e-18
C517	VGND	a_27_74##6	1.50672e-18
C518	VPWR#1	VNB	7.19582e-17
C519	GCLK#5	VNB	2.72967e-18
C520	VGND	CLK#1	4.68862e-19
C521	VPWR#7	VNB	2.98972e-18
C522	VGND	CLK#5	1.15988e-18
C523	GCLK#3	VNB	5.64796e-18
C524	a_1044_368##16	VNB	4.53115e-18
C525	VPWR	CLK#4	4.70091e-18
C526	VPWR#9	VNB	4.03036e-18
C527	a_334_54##13	VNB	1.90701e-17
C528	VPWR	CLK#6	8.96301e-18
C529	VGND	a_334_54##2	1.55129e-18
C530	a_334_338##4	VNB	4.29968e-18
C531	VPWR	a_334_54##8	1.08244e-18
C532	VPWR#10	VNB	6.64306e-17
C533	GCLK	VPWR#2	5.65336e-18
C534	a_27_74##5	CLK	2.78055e-17
C535	VGND	a_84_48##3	2.97311e-18
C536	VPWR	a_27_74#	9.09222e-19
C537	a_84_48##4	VNB	1.59956e-18
C538	VGND#2	GCLK	4.53605e-18
C539	VPWR#4	VPWR#8	3.43185e-17
C540	CLK	CLK#3	1.6019e-17
C541	VPWR	a_334_54##3	1.74478e-18
C542	a_84_48##6	a_334_338#	2.57479e-17
C543	VPWR#12	VNB	4.72373e-18
C544	VPWR	a_334_338##3	3.24323e-18
C545	a_27_74##11	VNB	6.44997e-17
C546	a_1044_368#	VNB	3.32439e-17
C547	VPWR	GATE#3	1.19827e-18
C548	a_1044_368##8	VNB	3.16846e-17
C549	CLK	a_334_54##7	9.83711e-19
C550	a_1044_368##10	VNB	2.9234e-17
C551	VPWR	a_84_48#	4.22691e-18
C552	a_1044_368##12	VNB	4.36416e-17
C553	a_27_74##6	VNB	2.77227e-17
C554	VGND#7	GCLK#4	5.38375e-17
C555	CLK#1	VNB	2.46935e-17
C556	CLK#5	VNB	3.05721e-17
C557	GATE	GATE#2	4.61596e-18
C558	a_334_54##6	VNB	2.97752e-17
C559	a_27_74##2	VNB	4.17776e-17
C560	a_84_48##2	GATE	5.37345e-17
C561	a_334_338#	VNB	3.55692e-17
C562	a_334_54##2	VNB	2.61699e-17
C563	a_1044_368##16	VPWR#5	9.21769e-18
C564	GATE#1	VNB	3.4127e-17
C565	VGND	a_334_338##3	6.62335e-19
C566	a_84_48##3	VNB	3.21023e-17
C567	VPWR	a_27_74##5	4.27301e-18
C568	a_1044_368##7	VNB	3.57309e-17
C569	a_334_54##10	CLK#6	7.17193e-19
C570	a_1044_368##9	VNB	3.42843e-17
C571	VPWR	CLK#3	3.75284e-18
C572	a_1044_368##11	VNB	2.95803e-17
C573	a_1044_368##13	VNB	3.278e-17
C574	a_27_74##4	VNB	3.6196e-17
C575	VPWR	a_334_54##7	9.86271e-19
C576	CLK#4	VNB	3.45416e-17
C577	CLK#6	VNB	4.61797e-17
C578	VPWR#12	a_84_48##4	3.40799e-17
C579	VGND	VGND#6	1.43693e-16
C580	a_334_54##8	VNB	4.94972e-17
C581	a_27_74#	VNB	4.55206e-17
C582	VGND	a_1044_368##6	6.55799e-18
C583	VPWR	a_334_54##4	1.60214e-17
C584	a_334_54##3	VNB	2.29987e-17
C585	VGND	a_27_74##5	1.65384e-17
C586	VPWR	a_334_338##2	9.37771e-18
C587	a_334_338##3	VNB	4.34445e-17
C588	a_84_48##6	a_334_54##2	4.61827e-17
C589	VGND	CLK#3	3.36272e-18
C590	GATE#3	VNB	2.97756e-17
C591	VPWR	a_334_54#	8.47285e-19
C592	a_84_48#	VNB	4.32692e-17
C593	VGND	a_334_54##5	1.87379e-17
C594	VPWR	GATE#2	8.17626e-19
C595	VGND	a_334_54##7	3.01625e-18
C596	VPWR#2	VNB	1.3106e-16
C597	VGND	a_27_74##3	6.03538e-17
C598	VPWR	a_84_48##2	7.8603e-18
C599	VGND#2	VNB	1.29108e-16
C600	VGND#6	VNB	6.37777e-17
C601	VGND	a_334_338##2	7.83421e-18
C602	a_1044_368##6	VNB	8.13802e-17
C603	VGND	a_334_54#	4.57434e-18
C604	a_27_74##5	VNB	4.14526e-17
C605	CLK#3	VNB	5.65429e-17
C606	VGND	GATE#2	8.39764e-19
C607	a_1044_368##16	VPWR#4	1.01715e-16
C608	a_334_54##5	VNB	6.86032e-17
C609	VGND	a_84_48##2	6.69044e-18
C610	a_334_54##7	VNB	4.93449e-17
C611	a_27_74##3	VNB	7.13306e-17
C612	a_334_54##4	VNB	4.24259e-17
C613	a_334_338##2	VNB	5.12931e-17
C614	a_334_54#	VNB	3.25469e-17
C615	GATE#2	VNB	3.91126e-17
C616	a_84_48##2	VNB	5.67755e-17
C617	a_27_74##11	a_84_48##4	1.83742e-18
C618	a_334_54##10	a_334_54##8	2.12431e-17
C619	VPWR	GATE	8.70021e-19
C620	VPWR	CLK	3.45175e-18
C621	VGND	GATE	8.65242e-19
C622	a_84_48##6	GATE#1	9.09364e-18
C623	VGND	CLK	2.37394e-18
C624	GATE	VNB	1.85771e-18
C625	CLK	VNB	1.00969e-18
C626	GCLK	VNB	1.96276e-17
C627	VPWR	VNB	2.92649e-16
C628	VGND	VNB	3.02708e-16
C629	VPWR#11	VNB	7.73784e-17
C630	VPWR	VPWR#11	1.62939e-16
C631	VGND#10	a_27_74##3	4.65712e-17
C632	a_27_74##11	VPWR#11	2.55362e-17
C633	VPWR#11	a_84_48#	7.08486e-18
C634	VPWR#11	GATE#3	6.97789e-18
C635	a_84_48##4	VPWR#11	2.09583e-17
C636	VPWR#11	a_334_338##3	6.88441e-18
C637	VPWR#11	a_334_54##3	7.64332e-20
C638	VGND#10	a_84_48##3	1.36297e-18
C639	VGND#10	GATE#2	3.43993e-20
C640	VPWR#11	a_27_74#	3.14583e-20
C641	VGND#10	GATE#1	4.11443e-18
C642	VGND#10	a_334_54#	1.8456e-19
C643	VGND#10	VNB	7.69195e-17
C644	a_84_48##2	VPWR#11	1.28708e-18
C645	VGND#10	a_27_74##9	4.7505e-17
C646	VGND#10	a_334_54##2	4.07902e-18
C647	VGND#10	a_334_338##2	1.20427e-20
C648	VPWR#11	a_334_338##2	4.28053e-20
C649	VGND	VGND#10	1.25359e-16
*
*
.ENDS sky130_fd_sc_hs__dlclkp_4
*
