* Extracted by Quantus, converted by sky130cad/quantus.py
*
*
*
*                       LINUX           Wed Nov 18 09:10:21 2026
*
*
*
*  PROGRAM  advgen
*
*  Name           : advgen - Quantus - (64-bit)
*  Version        : 25.1.0-p047
*  Build Date     : Thu Dec 11 23:20:30 PST 2025
*
*  HSPICE LIBRARY
*
*  OPERATING_TEMPERATURE 150
*  QRC_TECH_DIR <path>/tech
*
*
*

*
.SUBCKT sky130_fd_sc_hs__sdfsbp_1 VNB VPB VGND SET_B VPWR Q_N Q SCD CLK SCE D
*
*
*  caps2d version: 10
*
*
*       TRANSISTOR CARDS
*
*
XM38 a_27_74##8 SCE#3 VGND#19 VNB sky130_fd_pr__nfet_01v8_lvt l=0.15 w=0.42 ad=0.1197 as=0.1764 pd=1.41 ps=1.68
XM8 VGND#19 a_27_74# a_228_74# VNB sky130_fd_pr__nfet_01v8_lvt l=0.15 w=0.42 ad=0.1764 as=0.1008 pd=1.68 ps=1.32
XM6 a_228_74# D#1 a_290_464##4 VNB sky130_fd_pr__nfet_01v8_lvt l=0.15 w=0.42 ad=0.1008 as=0.1176 pd=1.32 ps=1.4
XM17 a_290_464##4 SCE#5 a_392_74# VNB sky130_fd_pr__nfet_01v8_lvt l=0.15 w=0.42 ad=0.1176 as=0.1008 pd=1.4 ps=1.32
XM14 a_392_74# SCD#3 VGND#18 VNB sky130_fd_pr__nfet_01v8_lvt l=0.15 w=0.42 ad=0.1008 as=0.1197 pd=1.32 ps=1.41
XM34 a_594_74##13 CLK#3 VGND#17 VNB sky130_fd_pr__nfet_01v8_lvt l=0.15 w=0.74 ad=0.2109 as=0.259 pd=2.05 ps=2.18
XM27 VGND#17 a_594_74##6 a_781_74##9 VNB sky130_fd_pr__nfet_01v8_lvt l=0.15 w=0.74 ad=0.259 as=0.2109 pd=2.18 ps=2.05
XM28 a_290_464##5 a_594_74##8 a_995_74##10 VNB sky130_fd_pr__nfet_01v8_lvt l=0.15 w=0.42 ad=0.18665 as=0.189 pd=1.8 ps=1.74
XM41 a_995_74##10 a_781_74# a_1115_74# VNB sky130_fd_pr__nfet_01v8_lvt l=0.15 w=0.42 ad=0.189 as=0.1008 pd=1.74 ps=1.32
XM37 a_1115_74# a_1163_48# VGND#13 VNB sky130_fd_pr__nfet_01v8_lvt l=0.15 w=0.42 ad=0.1008 as=0.17255 pd=1.32 ps=1.68
XM32 a_1163_48##5 a_995_74# a_1411_74# VNB sky130_fd_pr__nfet_01v8_lvt l=0.15 w=0.42 ad=0.1197 as=0.1008 pd=1.41 ps=1.32
XM15 a_1411_74# SET_B#1 VGND#12 VNB sky130_fd_pr__nfet_01v8_lvt l=0.15 w=0.42 ad=0.1008 as=0.5115 pd=1.32 ps=2.93
XM25 VGND#12 a_995_74##4 a_1684_74# VNB sky130_fd_pr__nfet_01v8_lvt l=0.15 w=0.64 ad=0.5115 as=0.1536 pd=2.93 ps=1.76
XM22 a_1684_74# a_781_74##7 a_1762_74##16 VNB sky130_fd_pr__nfet_01v8_lvt l=0.15 w=0.64 ad=0.1536 as=0.2391 pd=1.76 ps=2.12
XM33 a_1762_74##16 a_594_74# a_1876_74# VNB sky130_fd_pr__nfet_01v8_lvt l=0.15 w=0.42 ad=0.2391 as=0.1008 pd=2.12 ps=1.32
XM30 a_1876_74# a_1924_48##3 a_1954_74# VNB sky130_fd_pr__nfet_01v8_lvt l=0.15 w=0.42 ad=0.1008 as=0.1638 pd=1.32 ps=1.62
XM11 a_1954_74# SET_B#4 VGND#11 VNB sky130_fd_pr__nfet_01v8_lvt l=0.15 w=0.42 ad=0.1638 as=0.2646 pd=1.62 ps=2.1
XM26 VGND#11 a_1762_74##7 a_1924_48##7 VNB sky130_fd_pr__nfet_01v8_lvt l=0.15 w=0.42 ad=0.2646 as=0.1197 pd=2.1 ps=1.41
XM23 VGND#10 a_1762_74##10 Q_N#2 VNB sky130_fd_pr__nfet_01v8_lvt l=0.15 w=0.74 ad=0.2627 as=0.2109 pd=2.19 ps=2.05
XM3 a_2556_94##7 a_1762_74##8 VGND#9 VNB sky130_fd_pr__nfet_01v8_lvt l=0.15 w=0.64 ad=0.1824 as=0.4291 pd=1.85 ps=2.71
XM12 VGND#9 a_2556_94# Q#3 VNB sky130_fd_pr__nfet_01v8_lvt l=0.15 w=0.74 ad=0.4291 as=0.2109 pd=2.71 ps=2.05
XM31 a_27_74##9 SCE#4 VPWR#20 VPB sky130_fd_pr__pfet_01v8 l=0.15 w=0.64 ad=0.1888 as=0.192 pd=1.87 ps=1.88
XM13 VPWR#20 SCE#1 a_206_464# VPB sky130_fd_pr__pfet_01v8 l=0.15 w=0.64 ad=0.192 as=0.1728 pd=1.88 ps=1.82
XM2 a_206_464# D#3 a_290_464##6 VPB sky130_fd_pr__pfet_01v8 l=0.15 w=0.64 ad=0.1728 as=0.3072 pd=1.82 ps=2.24
XM19 a_290_464##6 a_27_74##3 a_416_464# VPB sky130_fd_pr__pfet_01v8 l=0.15 w=0.64 ad=0.3072 as=0.1728 pd=2.24 ps=1.82
XM5 a_416_464# SCD#4 VPWR#19 VPB sky130_fd_pr__pfet_01v8 l=0.15 w=0.64 ad=0.1728 as=0.208 pd=1.82 ps=1.93
XM40 a_594_74##11 CLK#1 VPWR#18 VPB sky130_fd_pr__pfet_01v8 l=0.15 w=1.12 ad=0.3248 as=0.336 pd=2.82 ps=2.84
XM21 VPWR#18 a_594_74##9 a_781_74##12 VPB sky130_fd_pr__pfet_01v8 l=0.15 w=1.12 ad=0.336 as=0.3192 pd=2.84 ps=2.81
XM1 a_290_464# a_781_74##4 a_995_74##11 VPB sky130_fd_pr__pfet_01v8 l=0.15 w=0.42 ad=0.1197 as=0.211725 pd=1.41 ps=1.9
XM24 a_995_74##11 a_594_74##7 a_1133_478# VPB sky130_fd_pr__pfet_01v8 l=0.15 w=0.42 ad=0.211725 as=0.1674 pd=1.9 ps=1.73
XM36 a_1133_478# a_1163_48##4 VPWR#17 VPB sky130_fd_pr__pfet_01v8 l=0.15 w=0.42 ad=0.1674 as=0.2247 pd=1.73 ps=1.91
XM10 VPWR#17 a_995_74##3 a_1163_48##7 VPB sky130_fd_pr__pfet_01v8 l=0.15 w=0.42 ad=0.2247 as=0.1848 pd=1.91 ps=1.72
XM7 a_1163_48##7 SET_B#3 VPWR#16 VPB sky130_fd_pr__pfet_01v8 l=0.15 w=0.42 ad=0.1848 as=0.3175 pd=1.72 ps=2.78
XM9 VPWR#16 a_995_74##6 a_1600_347##2 VPB sky130_fd_pr__pfet_01v8 l=0.15 w=1 ad=0.3175 as=0.29 pd=2.78 ps=2.58
XM35 a_1712_374##2 a_781_74##5 a_1762_74##14 VPB sky130_fd_pr__pfet_01v8 l=0.15 w=0.42 ad=0.2526 as=0.3175 pd=3.03 ps=2.78
XM4 a_1762_74##14 a_594_74##2 a_1600_347# VPB sky130_fd_pr__pfet_01v8 l=0.15 w=1 ad=0.3175 as=0.29 pd=2.78 ps=2.58
XM18 a_1712_374# a_1924_48# VPWR#15 VPB sky130_fd_pr__pfet_01v8 l=0.15 w=0.42 ad=0.1218 as=0.126 pd=1.42 ps=1.44
XM0 VPWR#15 SET_B#6 a_1762_74##17 VPB sky130_fd_pr__pfet_01v8 l=0.15 w=0.42 ad=0.126 as=0.1218 pd=1.44 ps=1.42
XM16 a_1924_48##4 a_1762_74##11 VPWR#14 VPB sky130_fd_pr__pfet_01v8 l=0.15 w=0.42 ad=0.1218 as=0.3346 pd=1.42 ps=2.95
XM20 VPWR#14 a_1762_74##9 Q_N#1 VPB sky130_fd_pr__pfet_01v8 l=0.15 w=1.12 ad=0.3346 as=0.3248 pd=2.95 ps=2.82
XM29 a_2556_94##8 a_1762_74# VPWR#13 VPB sky130_fd_pr__pfet_01v8 l=0.15 w=0.84 ad=0.2436 as=0.3724 pd=2.26 ps=2.95
XM39 VPWR#13 a_2556_94##4 Q#1 VPB sky130_fd_pr__pfet_01v8 l=0.15 w=1.12 ad=0.3724 as=0.3248 pd=2.95 ps=2.82
*
*
*       RESISTOR AND CAP/DIODE CARDS
*
Rg1	SCE#1	SCE#2	529.730408
Rg2	SCE#2	SCE#3	560.622192
Rg3	SCE#2	SCE#4	421.345062
Rg4	a_27_74#	a_27_74##2	244.812881
Rg5	D#1	D#2	739.275574
Rg6	D#2	D#3	322.856964
Rg7	a_27_74##3	a_27_74##4	296.912354
Rg8	SCE#5	SCE#6	422.710083
Rg9	SCD#1	SCD#2	61.920815
Rg10	SCD#2	SCD#3	476.413788
Rg11	SCD#2	SCD#4	443.553528
Rg12	CLK#1	CLK#2	493.462799
Rg13	CLK#2	CLK#3	307.937683
Rg14	a_781_74#	a_781_74##2	660.105225
Rg15	a_781_74##2	a_781_74##3	247.143234
Rg16	a_781_74##3	a_781_74##4	318.597321
Rg17	a_1163_48#	a_1163_48##2	250.336044
Rg18	a_1163_48##2	a_1163_48##3	298.906769
Rg19	a_1163_48##3	a_1163_48##4	322.215088
Rg20	a_995_74#	a_995_74##2	409.393127
Rg21	a_995_74##2	a_995_74##3	535.601379
Rg22	SET_B#1	SET_B#2	414.102173
Rg23	SET_B#2	SET_B#3	486.968872
Rg24	a_995_74##4	a_995_74##5	333.535889
Rg25	a_995_74##5	a_995_74##6	472.416565
Rg26	a_781_74##5	a_781_74##6	256.260681
Rg27	a_781_74##6	a_781_74##7	438.086243
Rg28	a_594_74#	a_594_74##2	1017.307373
Rg29	a_594_74##2	a_594_74##3	2555.739746
Rg30	a_594_74##3	a_594_74##4	1536.023438
Rg31	a_594_74##4	a_594_74##5	63.474628
Rg32	a_594_74##5	a_594_74##6	346.540833
Rg33	a_594_74##3	a_594_74##7	251.292694
Rg34	a_594_74##4	a_594_74##8	557.266785
Rg35	a_594_74##5	a_594_74##9	485.753845
Rg36	a_1924_48#	a_1924_48##2	1052.093872
Rg37	a_1924_48##2	a_1924_48##3	227.762360
Rg38	SET_B#4	SET_B#5	588.187195
Rg39	SET_B#5	SET_B#6	459.947205
Rg40	a_1762_74#	a_1762_74##2	448.073578
Rg41	a_1762_74##2	a_1762_74##3	373.688049
Rg42	a_1762_74##3	a_1762_74##4	147.369965
Rg43	a_1762_74##4	a_1762_74##5	94.572243
Rg44	a_1762_74##5	a_1762_74##6	56.656227
Rg45	a_1762_74##6	a_1762_74##7	729.072510
Rg46	a_1762_74##2	a_1762_74##8	498.342834
Rg47	a_1762_74##3	a_1762_74##9	371.735809
Rg48	a_1762_74##4	a_1762_74##10	509.462677
Rg49	a_1762_74##5	a_1762_74##11	407.075928
Rg50	a_2556_94#	a_2556_94##2	322.953644
Rg51	a_2556_94##2	a_2556_94##3	37.487480
Rg52	a_2556_94##2	a_2556_94##4	507.075531
Rf1	D#4	D	1.056901
Rf2	D#2	D#6	161.289703
Rf3	D#4	D#6	8.660800
Rf4	a_27_74##4	a_27_74##6	290.276123
Rf5	a_27_74##6	a_27_74##7	71.197502
Rf6	a_27_74##7	a_27_74##8	36.640656
Rf7	a_27_74##6	a_27_74##9	21.234451
Rf8	a_27_74##7	a_27_74##2	181.699478
Rf9	SCE#6	SCE	245.990692
Rf10	SCE	SCE#2	161.870743
Rf11	SCD	SCD#1	1.203563
Rf12	SCD#1	SCD	21.062357
Rf13	CLK#4	CLK#2	161.577927
Rf14	CLK	CLK#6	1.345120
Rf15	CLK#4	CLK#6	7.765626
Rf16	a_594_74##5	a_594_74##12	223.682480
Rf17	a_594_74##12	a_594_74##13	100.151855
Rf18	a_594_74##11	a_594_74##12	15.000000
Rf19	a_290_464#	a_290_464##2	35.005302
Rf20	a_290_464##2	a_290_464##3	153.712418
Rf21	a_290_464##3	a_290_464##4	168.816620
Rf22	a_290_464##2	a_290_464##5	119.462509
Rf23	a_290_464##3	a_290_464##6	71.837265
Rf24	a_781_74##3	a_781_74##9	248.088623
Rf25	a_1163_48##5	a_1163_48##2	137.667908
Rf26	a_1163_48##7	a_1163_48##3	267.645355
Rf27	SET_B#2	SET_B#8	170.271454
Rf28	a_995_74##5	a_995_74##8	251.789429
Rf29	a_995_74##8	a_995_74##9	102.286301
Rf30	a_995_74##9	a_995_74##10	59.251919
Rf31	a_995_74##9	a_995_74##11	91.720383
Rf32	a_781_74##6	a_781_74##11	513.993713
Rf33	a_781_74##11	a_781_74##12	185.609863
Rf34	a_781_74##11	a_781_74##2	180.798630
Rf35	a_1600_347#	a_1600_347##2	130.999939
Rf36	a_1712_374#	a_1712_374##2	137.056519
Rf37	SET_B	SET_B#5	134.377625
Rf38	a_1762_74##6	a_1762_74##13	114.995483
Rf39	a_1762_74##13	a_1762_74##15	131.862839
Rf40	a_1762_74##15	a_1762_74##16	87.189034
Rf41	a_1762_74##13	a_1762_74##17	51.875237
Rf42	a_1762_74##14	a_1762_74##15	15.000000
Rf43	a_1924_48##4	a_1924_48##5	213.727310
Rf44	a_1924_48##5	a_1924_48##2	251.462067
Rf45	a_1924_48##5	a_1924_48##7	31.546333
Rf46	Q_N#1	Q_N#3	101.480820
Rf47	Q_N#3	Q_N	0.856991
Rf48	Q_N#2	Q_N#3	7.500000
Rf49	a_2556_94##3	a_2556_94##6	174.621536
Rf50	a_2556_94##6	a_2556_94##7	39.163589
Rf51	a_2556_94##6	a_2556_94##8	61.029316
Rf52	Q	Q#2	0.194040
Rf53	Q#2	Q	14.164948
Rf54	Q	Q#4	7.179494
Rf55	Q#4	Q	7.179494
Rf56	Q#1	Q#2	5.000000
Rf57	Q#3	Q#4	7.500000
Rf58	VPWR#1	VPWR#2	21.890615
Rf59	VPWR#2	VPWR#3	109.891930
Rf60	VPWR#3	VPWR#4	105.996727
Rf61	VPWR#4	VPWR#5	42.832584
Rf62	VPWR#5	VPWR#6	173.958221
Rf63	VPWR#6	VPWR#7	102.401550
Rf64	VPWR#7	VPWR#8	187.017548
Rf65	VPWR#8	VPWR#9	27.734655
Rf66	VPWR#9	VPWR#10	49.147236
Rf67	VPWR#10	VPWR#11	142.992599
Rf69	VPWR#2	VPWR#13	39.408188
Rf70	VPWR#3	VPWR#14	34.507496
Rf71	VPWR#4	VPWR#15	52.242409
Rf72	VPWR#6	VPWR#16	68.678772
Rf73	VPWR#7	VPWR#17	48.538895
Rf74	VPWR#8	VPWR#18	33.326477
Rf75	VPWR#10	VPWR#19	35.371117
Rf76	VPWR#11	VPWR#20	32.342297
Rf77	VGND#1	VGND#2	21.890615
Rf78	VGND#2	VGND#3	133.633331
Rf79	VGND#3	VGND#4	87.615936
Rf80	VGND#4	VGND#5	37.235626
Rf81	VGND#5	VGND#6	159.587158
Rf82	VGND#6	VGND#7	124.487411
Rf83	VGND#7	VGND#8	209.619415
Rf84	VGND#2	VGND#9	31.731567
Rf85	VGND#3	VGND#10	33.306259
Rf86	VGND#4	VGND#11	16.879604
Rf87	VGND#6	VGND#12	15.667846
Rf88	VGND#7	VGND#13	29.722172
Rf89	VGND#8	VGND#14	63.529400
Rf90	VGND#14	VGND#15	124.867279
Rf92	VGND#8	VGND#17	34.245285
Rf93	VGND#14	VGND#18	33.326477
Rf94	VGND#15	VGND#19	33.916985
Rf108	a_995_74##2	a_995_74##8	160.232803
Re2	SET_B	SET_B#8	13.698293
Re3	VPWR#1	VPWR#22	6.363944
Re4	VPWR#22	VPWR	1.106290
Re5	VPWR	VPWR#9	2.173466
Re6	VGND#1	VGND#21	6.363944
Re7	VGND#21	VGND	1.106290
Re8	VGND	VGND#8	2.173466
Re12	VPWR#5	VPWR#22	0.698413
Re15	VGND#5	VGND#21	0.698413
*
*       CAPACITOR CARDS
*
*
C1	a_781_74##11	a_594_74##3	4.30741e-17
C2	a_2556_94##6	a_1762_74##10	4.59267e-19
C3	SCD#3	CLK#3	4.79778e-18
C4	VPWR#9	a_1163_48##4	2.90545e-18
C5	a_290_464##3	CLK#1	1.02366e-18
C6	a_290_464##4	SCE#5	3.7722e-17
C7	VPWR#2	a_1762_74##2	2.8883e-19
C8	a_1924_48##5	a_1762_74##13	1.84411e-18
C9	VGND#14	SCE#6	4.55154e-19
C10	D#2	a_290_464##6	1.41529e-18
C11	a_290_464##4	a_290_464##3	4.22044e-19
C12	a_781_74##12	a_781_74##4	6.45822e-18
C13	VPWR#3	a_1762_74##11	5.62735e-18
C14	SET_B#5	a_594_74##2	5.14681e-19
C15	a_290_464##3	VPWR#10	9.93817e-18
C16	a_2556_94##6	a_1762_74#	9.90163e-19
C17	VGND#6	a_995_74#	9.92686e-18
C18	a_290_464##2	a_1163_48##3	2.92418e-20
C19	VGND#19	SCD#3	2.8588e-19
C20	a_781_74##3	a_781_74#	8.5523e-19
C21	a_995_74##9	a_781_74##2	9.59418e-17
C22	VGND#8	a_1163_48##5	7.3481e-18
C23	VGND#10	a_1762_74##10	2.08634e-17
C24	VGND#4	a_1924_48##5	2.94579e-17
C25	a_290_464##2	CLK#1	2.51639e-17
C26	a_781_74##3	a_594_74##8	3.19908e-17
C27	a_1924_48##7	VGND#10	3.52988e-17
C28	VGND#8	VGND#13	1.80368e-17
C29	VPWR#2	a_1762_74##11	9.64046e-20
C30	VGND#18	a_27_74#	1.70374e-19
C31	a_594_74##2	a_1924_48##2	3.10101e-17
C32	VPWR#10	a_27_74##4	1.23328e-19
C33	a_594_74##8	a_594_74##3	2.00348e-20
C34	VPWR#15	a_1762_74##17	3.42334e-17
C35	SET_B#4	a_1924_48#	2.28135e-18
C36	a_290_464##2	a_781_74##12	9.15505e-17
C37	a_1762_74##13	a_1762_74##17	9.8585e-18
C38	a_594_74##9	a_781_74##12	2.49883e-17
C39	a_290_464##4	D#1	3.42218e-17
C40	VPWR#4	SET_B#6	7.9032e-18
C41	a_781_74##11	a_781_74##3	1.5949e-19
C42	VGND#7	a_1163_48#	5.71399e-18
C43	a_1924_48##7	a_1762_74##10	7.48928e-19
C44	VPWR#9	a_594_74##9	1.24779e-18
C45	SCE#5	SCD#3	4.73199e-17
C46	VGND#17	a_781_74##9	6.70541e-17
C47	a_594_74##13	a_290_464##5	1.09129e-18
C48	a_290_464##3	SCD#4	3.3144e-17
C49	VGND#19	SCE#5	2.35222e-19
C50	a_781_74##6	a_594_74##2	3.65146e-17
C51	a_1163_48##3	a_594_74##3	1.41765e-18
C52	VPWR#20	VPWR#19	1.09293e-18
C53	VGND#18	SCD#2	2.91152e-18
C54	VPWR#18	a_594_74##9	3.6105e-17
C55	VGND#8	a_995_74##10	1.51036e-17
C56	VGND#10	a_1762_74##7	6.52604e-18
C57	a_1924_48##5	a_1762_74##8	2.16336e-19
C58	VPWR#9	CLK#1	4.68909e-18
C59	VPWR#3	SET_B#6	3.76983e-19
C60	a_2556_94##6	a_1762_74##9	4.11159e-20
C61	a_995_74##9	a_781_74##3	9.25161e-17
C62	a_781_74##6	a_781_74##5	9.90428e-18
C63	a_594_74##4	a_594_74##3	1.1264e-19
C64	VGND#18	SCE#3	2.23224e-19
C65	VGND#6	a_1163_48#	4.85948e-19
C66	SET_B#8	VPWR#6	3.23971e-18
C67	a_290_464##2	SCD#4	2.98983e-19
C68	a_781_74##12	CLK#1	1.52601e-18
C69	VGND#3	a_1924_48##5	1.08754e-18
C70	a_995_74##5	a_594_74##2	4.65055e-19
C71	VGND#8	a_290_464##5	7.85936e-18
C72	a_594_74##11	a_594_74##9	1.10295e-18
C73	VPWR#9	SCD#4	2.92389e-19
C74	a_290_464##4	a_27_74#	3.77512e-18
C75	a_1762_74##16	SET_B#5	3.24362e-18
C76	a_1762_74##16	a_1876_74#	1.20555e-20
C77	a_781_74##6	a_995_74##6	3.90129e-17
C78	a_594_74##6	a_594_74##4	5.8955e-18
C79	a_290_464##2	VPWR#18	3.49673e-17
C80	VPWR#20	SCE#2	7.67486e-19
C81	a_1924_48##7	a_1762_74##7	3.16756e-17
C82	VGND#19	D#1	3.30446e-18
C83	VPWR#18	CLK#1	3.4312e-17
C84	VGND#8	a_781_74##9	1.1829e-16
C85	a_1762_74##13	VPWR#15	2.29607e-17
C86	a_1600_347##2	a_995_74##4	8.16323e-19
C87	VPWR#9	a_27_74##3	7.41915e-19
C88	a_995_74##9	a_594_74##4	3.39295e-19
C89	a_781_74##6	SET_B#3	2.40552e-17
C90	SET_B#2	a_594_74##2	3.08121e-19
C91	VGND#4	VGND#3	8.75042e-19
C92	VPWR#4	a_1924_48#	6.32636e-18
C93	D#1	SCE#5	3.20182e-17
C94	a_290_464##3	a_27_74##3	3.33355e-18
C95	a_781_74##12	SCD#4	6.27338e-19
C96	VGND#7	a_781_74#	5.5733e-18
C97	a_290_464##3	a_594_74##11	5.75344e-17
C98	VGND#10	SET_B#4	2.21305e-19
C99	VGND#8	VGND#17	2.2758e-17
C100	VPWR#3	VPWR#2	3.8643e-19
C101	a_1712_374#	VPWR#15	3.80692e-17
C102	a_1600_347#	a_1762_74##17	4.43536e-19
C103	a_781_74##6	a_995_74##3	1.49657e-18
C104	a_594_74##11	CLK#1	4.4337e-17
C105	VPWR#9	D#3	1.45544e-18
C106	VGND#6	a_1762_74##16	3.69027e-17
C107	a_27_74##8	D#1	1.26264e-19
C108	VPWR#20	a_290_464##6	1.16801e-17
C109	a_1924_48##5	a_1762_74##10	1.6816e-17
C110	a_290_464##2	VPWR#8	7.70194e-19
C111	a_290_464##4	SCE#3	2.18651e-18
C112	a_1762_74##7	VGND#11	4.13848e-18
C113	VPWR#3	a_1924_48#	4.20641e-20
C114	a_1762_74##16	a_594_74##2	2.61209e-18
C115	VGND#8	a_594_74##13	2.91666e-17
C116	a_1762_74##16	a_1924_48##2	3.53083e-17
C117	VPWR#18	SCD#4	1.70209e-18
C118	SET_B#2	a_995_74##6	1.73426e-17
C119	VPWR#9	SCE#1	7.88669e-19
C120	a_1163_48##2	a_594_74##3	7.60757e-19
C121	a_594_74##13	a_594_74##11	2.73151e-18
C122	a_27_74#	VGND#19	1.67904e-17
C123	VPWR#19	CLK#1	4.59879e-18
C124	VGND#8	VGND#14	8.51206e-17
C125	a_594_74##13	VGND#17	5.51179e-17
C126	VPWR#6	a_594_74##2	4.37264e-17
C127	a_1924_48##7	SET_B#4	1.10898e-18
C128	a_781_74##12	a_27_74##3	5.55667e-20
C129	a_290_464##2	a_594_74##11	3.26357e-17
C130	VGND#8	VGND#18	1.54013e-17
C131	VPWR#6	a_995_74##4	2.58288e-19
C132	VPWR#9	SCE#4	1.87558e-18
C133	VGND#8	VGND#7	1.11432e-16
C134	a_1762_74##13	a_1712_374#	1.27459e-17
C135	a_995_74##9	a_594_74##3	2.15516e-19
C136	a_27_74#	D#1	3.59098e-17
C137	a_995_74##3	SET_B#2	7.09622e-19
C138	a_290_464##3	D#3	4.88622e-19
C139	a_27_74##8	a_27_74#	1.59302e-18
C140	a_995_74##4	a_594_74##2	4.06014e-19
C141	a_290_464##3	VPWR#19	4.82534e-17
C142	VPWR#4	a_594_74##2	8.53247e-19
C143	a_1762_74##16	VGND#4	1.11692e-17
C144	SCD#4	VPWR#19	2.71637e-17
C145	SET_B#4	VGND#11	1.29303e-17
C146	a_290_464##2	a_781_74##3	7.19357e-17
C147	VGND#7	a_594_74##8	2.68697e-18
C148	a_1762_74##16	a_781_74##6	2.29365e-17
C149	SCE#3	VGND#19	1.87335e-17
C150	VGND#8	a_290_464##4	2.46872e-17
C151	a_290_464##6	CLK#1	1.39619e-19
C152	VGND#18	VGND#17	1.22434e-18
C153	a_1924_48##5	a_1762_74##7	2.87467e-17
C154	a_1924_48##7	a_1924_48##3	2.31485e-19
C155	a_1600_347#	a_1712_374#	4.6331e-17
C156	SCE#6	SCD#3	1.98584e-19
C157	a_594_74##4	a_781_74##2	8.69412e-19
C158	a_27_74##8	SCE#3	2.41458e-17
C159	a_2556_94##6	a_1762_74##4	3.07584e-19
C160	VPWR#19	a_27_74##3	1.75128e-18
C161	a_1163_48##5	a_1684_74#	1.98274e-20
C162	a_1163_48##3	a_995_74##3	7.64562e-18
C163	VPWR#9	VPWR#10	9.52965e-17
C164	SCE#3	a_27_74#	1.51056e-17
C165	VGND#8	VGND#19	1.83541e-17
C166	a_290_464##6	SCD#4	1.73705e-18
C167	a_1600_347#	a_1762_74##13	2.83786e-18
C168	a_781_74##2	a_594_74##3	1.29455e-18
C169	a_290_464##3	SCE#1	1.97518e-19
C170	a_1762_74##13	a_1762_74##9	2.15666e-19
C171	a_290_464##4	SCD#2	9.17485e-18
C172	a_1762_74##16	a_1762_74##7	2.53445e-19
C173	a_27_74##9	VPWR#20	2.84205e-17
C174	a_995_74##5	a_1762_74##16	1.04443e-17
C175	VPWR#1	a_2556_94##3	3.45139e-18
C176	SCD#2	CLK#3	3.01915e-18
C177	D#1	SCE#6	1.43304e-17
C178	VGND#18	a_594_74##13	2.74565e-17
C179	VPWR#9	VPWR#8	9.26869e-17
C180	a_594_74##5	a_290_464##2	6.52769e-17
C181	SET_B#3	a_594_74##3	1.98172e-17
C182	a_1762_74##14	a_1712_374#	1.41675e-17
C183	VGND#8	a_27_74##8	1.96365e-17
C184	VGND#3	VGND#2	2.46341e-19
C185	a_1924_48##7	a_594_74#	1.37266e-19
C186	a_781_74##2	SET_B#3	5.43237e-20
C187	VGND#1	a_2556_94##3	2.48975e-18
C188	VPWR#19	D#3	2.69225e-19
C189	a_1924_48##5	SET_B#4	6.01825e-18
C190	VPWR#9	VPWR#7	1.21612e-16
C191	a_1762_74##13	a_1762_74##7	8.88079e-19
C192	a_290_464##6	a_27_74##3	4.34808e-17
C193	a_781_74##4	a_1163_48##3	2.51173e-19
C194	VGND#6	VGND#12	1.12823e-17
C195	a_995_74##5	VGND#12	3.76872e-18
C196	VPWR#20	SCD#4	3.9388e-19
C197	SET_B#8	a_594_74##3	9.69137e-21
C198	a_1762_74##16	a_1924_48##7	1.45254e-18
C199	a_2556_94##6	a_1762_74##3	5.2537e-20
C200	a_1712_374#	VPWR#5	6.60767e-17
C201	VPWR#6	a_995_74##6	2.85765e-18
C202	a_1762_74##16	SET_B#4	3.34073e-18
C203	a_1600_347#	a_1762_74##14	8.00374e-17
C204	a_1712_374##2	a_1712_374#	1.61595e-18
C205	a_290_464##3	CLK#2	5.25995e-19
C206	a_1762_74##16	SET_B#2	1.12718e-19
C207	a_781_74##12	VPWR#8	6.60742e-17
C208	a_290_464##3	SCE#4	2.27901e-19
C209	VPWR#19	SCE#1	1.35927e-19
C210	a_27_74##9	SCD#4	1.27758e-19
C211	a_1762_74##13	a_1762_74##11	3.7169e-19
C212	a_27_74##2	D#1	3.31281e-17
C213	a_781_74##2	a_594_74##7	1.31305e-17
C214	a_290_464##6	D#3	3.4036e-17
C215	SET_B#8	a_1712_374##2	3.38502e-19
C216	a_594_74##4	a_781_74##3	5.56719e-17
C217	VGND#2	a_2556_94##3	2.33535e-19
C218	VPWR#20	a_27_74##3	4.06457e-19
C219	a_27_74##7	a_27_74##6	2.3883e-18
C220	a_781_74##3	a_594_74##3	1.93768e-18
C221	VPWR#10	VPWR#18	3.33122e-20
C222	SET_B#8	a_1600_347##2	7.75751e-18
C223	a_1924_48##5	a_1924_48##3	1.38079e-20
C224	SCE#3	a_27_74##2	1.58767e-17
C225	a_27_74##6	SCD#4	3.8679e-20
C226	a_1762_74##13	SET_B#4	5.00933e-19
C227	a_2556_94##3	VPWR#13	1.96678e-17
C228	SCE#2	D#1	1.40096e-19
C229	a_781_74##12	VPWR#7	1.70445e-17
C230	a_1600_347#	a_1712_374##2	2.25147e-17
C231	a_27_74##9	a_27_74##3	1.31834e-19
C232	a_995_74##3	a_594_74##3	1.91872e-17
C233	a_290_464##4	a_594_74##13	9.41622e-18
C234	a_2556_94##4	Q#1	1.18708e-17
C235	a_1762_74##16	a_1924_48##3	8.36915e-18
C236	a_290_464##6	SCE#1	2.56187e-18
C237	VGND#3	a_1762_74##4	6.7128e-21
C238	VGND#14	SCD#2	1.17345e-18
C239	SET_B#8	VPWR#16	2.80958e-18
C240	a_1712_374##2	VPWR#5	3.78468e-17
C241	VPWR#20	D#3	4.23289e-18
C242	a_2556_94##6	a_1762_74##2	3.33039e-17
C243	VPWR#6	SET_B#3	8.97103e-19
C244	VGND#3	a_1762_74##6	1.29389e-19
C245	a_1762_74##13	SET_B#6	1.66876e-17
C246	SET_B#8	a_1163_48##7	6.38532e-18
C247	VGND#7	a_1163_48##5	1.72315e-17
C248	a_2556_94##4	VPWR#13	2.16061e-17
C249	a_27_74##9	D#3	2.28442e-19
C250	VPWR#5	a_1924_48##2	8.29838e-20
C251	VGND#14	SCD#3	3.80699e-18
C252	a_1600_347##2	a_1600_347#	1.4756e-18
C253	a_1924_48##5	a_1924_48#	9.87526e-21
C254	SET_B#8	a_781_74##6	3.25692e-17
C255	a_594_74##5	a_594_74##9	1.16308e-17
C256	a_1762_74##8	a_2556_94#	1.08165e-17
C257	a_290_464##4	VGND#18	2.49945e-17
C258	a_27_74##6	a_27_74##3	3.99131e-20
C259	VPWR#20	SCE#1	3.18883e-17
C260	VGND#5	a_1924_48##2	7.99577e-18
C261	a_1924_48##5	a_594_74#	4.77366e-20
C262	a_1762_74##16	a_594_74#	4.38417e-17
C263	a_594_74##5	CLK#1	5.01123e-19
C264	SET_B#8	a_995_74##5	2.10296e-17
C265	a_594_74##5	a_594_74##4	6.78666e-18
C266	a_2556_94##8	a_2556_94##4	8.22845e-19
C267	a_290_464##4	a_290_464##6	4.55512e-19
C268	SCE	SCD#2	1.07827e-19
C269	VPWR#7	a_995_74##3	1.07415e-18
C270	a_1762_74#	a_2556_94##4	4.03011e-17
C271	a_1163_48##7	a_594_74##3	1.41162e-18
C272	a_1163_48##5	a_995_74##2	2.444e-17
C273	a_27_74##9	SCE#1	4.00714e-19
C274	Q_N#1	a_1762_74##6	8.41559e-19
C275	a_27_74##4	a_290_464##3	6.90642e-17
C276	VPWR#13	a_1762_74#	4.88208e-17
C277	VGND#3	a_1762_74##3	1.82993e-19
C278	SET_B#8	SET_B#2	2.87825e-17
C279	a_1163_48##5	VGND#6	1.3073e-17
C280	VGND#4	SET_B#5	1.51953e-18
C281	a_1762_74##10	a_2556_94#	1.79983e-19
C282	VPWR#20	SCE#4	2.85e-17
C283	a_290_464##3	a_290_464##2	1.89968e-18
C284	a_594_74##5	SCD#2	4.73586e-19
C285	a_1163_48##4	a_594_74##3	1.67294e-17
C286	a_1762_74##13	a_1924_48#	1.4568e-17
C287	a_1762_74##9	a_2556_94##4	3.24739e-19
C288	SET_B#8	a_995_74##2	8.97913e-18
C289	a_27_74##6	D#3	7.28141e-20
C290	a_2556_94##8	a_1762_74#	1.60364e-17
C291	SET_B#5	a_1762_74##6	8.65729e-17
C292	SET_B#4	a_1954_74#	1.26474e-17
C293	a_1762_74##16	a_781_74##7	4.30498e-17
C294	SCE#4	a_27_74##9	1.24589e-17
C295	VGND#14	SCE#5	5.51589e-18
C296	a_1924_48##4	a_1762_74##6	7.82529e-17
C297	a_1924_48##3	a_1954_74#	1.26474e-17
C298	VPWR#14	a_2556_94##4	4.59502e-19
C299	a_1762_74##10	a_1762_74##8	5.27615e-18
C300	SET_B#8	a_1163_48##3	1.98918e-18
C301	a_1600_347##2	a_1712_374##2	4.30759e-17
C302	VPWR#13	a_1762_74##9	1.02891e-18
C303	a_1762_74##9	a_1762_74#	5.70313e-18
C304	a_2556_94##6	VPWR#2	7.57768e-20
C305	a_1762_74##6	a_1924_48##2	1.61868e-19
C306	VGND#7	a_995_74##9	1.4003e-18
C307	Q_N#1	a_1762_74#	2.99612e-18
C308	VPWR#7	a_1163_48##4	1.68489e-18
C309	SCE#6	a_290_464##3	2.71921e-17
C310	a_2556_94##3	VPWR#2	7.10407e-20
C311	a_27_74##4	SCD#4	1.79289e-18
C312	a_1924_48##2	SET_B#5	3.42918e-17
C313	VGND#19	VGND#18	3.78565e-19
C314	VPWR#9	a_995_74##2	2.76769e-18
C315	a_2556_94##6	a_2556_94##7	6.0513e-19
C316	a_2556_94##8	a_1762_74##9	3.96865e-18
C317	VGND#13	VGND#6	1.32761e-18
C318	VGND#4	a_1924_48##2	2.11911e-17
C319	a_27_74##4	a_27_74##3	7.18444e-18
C320	a_1924_48##4	SET_B#5	2.36775e-19
C321	a_1762_74##16	a_1600_347#	3.71591e-19
C322	VPWR#17	a_594_74##3	1.38009e-19
C323	a_1762_74##13	a_594_74##2	9.39554e-20
C324	a_1762_74##16	a_995_74##4	7.77445e-18
C325	SET_B#8	a_781_74##2	1.7505e-18
C326	a_27_74##6	SCE#1	1.92811e-17
C327	VPWR#14	a_1762_74#	5.09891e-19
C328	VPWR#16	a_1712_374##2	4.22321e-18
C329	VGND#8	a_995_74##2	3.11718e-18
C330	VPWR#9	a_1163_48##3	3.28065e-18
C331	VPWR#13	a_1762_74##11	2.17218e-19
C332	a_27_74##4	D#3	1.8379e-17
C333	VGND#2	a_1762_74##3	1.62865e-19
C334	VPWR#4	a_1762_74##6	6.93692e-20
C335	a_27_74##7	a_290_464##4	1.13577e-18
C336	SCD#2	CLK#2	1.67663e-17
C337	Q_N#1	a_1762_74##9	6.30266e-17
C338	a_1762_74##11	a_1762_74##9	2.65223e-17
C339	a_594_74##3	a_594_74##7	4.80272e-19
C340	a_27_74##4	SCE#1	9.80116e-20
C341	VGND#8	a_1163_48##3	2.33052e-18
C342	a_1163_48##2	VGND#13	4.20959e-17
C343	a_1762_74##7	a_1762_74##10	8.89374e-18
C344	a_1762_74##6	VPWR#3	1.01236e-18
C345	VPWR#15	SET_B#5	1.42605e-18
C346	a_594_74#	a_1876_74#	7.56735e-18
C347	a_781_74##12	a_594_74##8	9.56795e-21
C348	a_27_74##4	SCE#4	1.43751e-19
C349	D#2	a_290_464##3	3.01899e-18
C350	VGND#8	a_1163_48##2	1.12036e-17
C351	a_1762_74##14	a_1762_74##6	5.09121e-18
C352	VPWR#16	a_1600_347##2	3.56383e-17
C353	VPWR#9	a_781_74##2	2.82339e-18
C354	a_1762_74##9	VPWR#14	1.4005e-17
C355	VPWR#9	a_995_74##11	9.68938e-18
C356	a_1762_74##16	a_1762_74##14	1.64005e-18
C357	VGND#6	a_781_74##6	1.98396e-18
C358	a_995_74##5	a_781_74##6	2.05139e-17
C359	a_1762_74##16	SET_B#1	5.10896e-19
C360	a_2556_94##6	a_2556_94##3	7.4294e-19
C361	VPWR#9	a_594_74##3	2.4538e-17
C362	a_995_74##10	a_1163_48##2	1.46278e-17
C363	a_27_74##6	SCE#4	2.00421e-17
C364	VGND#8	a_781_74##2	3.26736e-18
C365	Q_N#1	a_1762_74##11	1.43035e-18
C366	VPWR#9	a_781_74##3	7.65294e-18
C367	SCE#1	D#2	1.14065e-17
C368	a_995_74##4	VGND#12	1.76989e-17
C369	SET_B#2	a_781_74##6	3.85805e-17
C370	a_27_74##7	D#1	1.31876e-19
C371	VPWR#6	a_594_74##7	1.2175e-20
C372	SET_B#6	a_1762_74##11	4.26955e-18
C373	a_1924_48##4	a_1762_74##9	9.20318e-18
C374	a_27_74##6	a_27_74##4	1.01469e-18
C375	VGND#19	a_290_464##4	1.41442e-17
C376	VGND#1	a_2556_94#	1.36515e-17
C377	VGND#8	a_781_74##3	3.79243e-18
C378	VGND#2	a_1762_74##2	2.45217e-19
C379	SCD	SCD#2	3.93049e-17
C380	a_1163_48##5	a_781_74##7	3.02805e-19
C381	VPWR#9	a_594_74##5	4.48327e-18
C382	a_995_74##5	SET_B#2	8.54371e-17
C383	a_995_74##2	a_781_74##6	2.65459e-18
C384	a_1762_74##14	SET_B#5	4.54593e-18
C385	a_594_74##4	a_781_74##4	2.34304e-17
C386	a_1924_48##5	a_1762_74##4	1.60622e-17
C387	VPWR#9	a_781_74##12	3.78188e-17
C388	VGND#7	a_995_74##10	1.37172e-17
C389	D#4	SCE#1	3.46797e-18
C390	VPWR#14	a_1762_74##11	2.39825e-17
C391	VPWR#8	a_781_74##4	5.0937e-19
C392	a_1712_374#	a_1924_48##2	2.62955e-19
C393	VGND#8	a_594_74##5	7.89883e-18
C394	SET_B#4	a_1762_74##7	2.08291e-17
C395	a_995_74##2	a_995_74##5	2.84581e-18
C396	a_27_74##6	D#4	1.72959e-17
C397	VPWR#9	CLK#2	1.97798e-18
C398	a_1762_74##16	a_995_74#	2.84369e-19
C399	a_781_74##11	a_594_74##2	2.22119e-19
C400	VPWR#9	VPWR#18	1.62616e-17
C401	Q_N#1	SET_B#6	8.63253e-20
C402	a_594_74##3	a_781_74##4	1.60043e-17
C403	a_781_74##7	a_1684_74#	1.50481e-17
C404	a_1600_347#	a_1924_48##2	7.50279e-19
C405	a_290_464##6	VPWR#10	1.17365e-17
C406	SCE#2	SCE#1	1.36254e-18
C407	VPWR#9	a_781_74##11	3.34505e-17
C408	VPWR#7	a_781_74##4	2.33565e-19
C409	a_995_74##2	SET_B#2	1.00712e-16
C410	VGND#8	CLK#2	3.24449e-18
C411	a_995_74##4	a_1684_74#	1.50481e-17
C412	SET_B#1	VGND#12	2.27022e-18
C413	a_1924_48##4	a_1762_74##11	2.35793e-17
C414	a_27_74##7	SCE#6	4.25805e-19
C415	VGND#6	a_995_74##5	7.23077e-17
C416	a_290_464##5	a_781_74##2	5.60798e-20
C417	a_27_74##8	a_290_464##4	1.07223e-18
C418	a_594_74##7	a_1133_478#	9.07553e-18
C419	a_27_74##7	a_27_74#	1.81447e-19
C420	VPWR#9	a_594_74##11	7.29305e-18
C421	a_1762_74##14	a_1924_48##2	1.39771e-17
C422	VGND#8	a_594_74##4	5.32364e-18
C423	a_1924_48#	SET_B#6	3.99767e-17
C424	D#4	a_27_74##4	1.01209e-17
C425	VGND#19	a_27_74##7	3.19321e-18
C426	SET_B#2	a_1163_48##3	8.71754e-19
C427	a_1163_48##5	a_995_74##4	9.39827e-19
C428	VPWR#14	SET_B#6	7.02466e-19
C429	a_995_74##11	a_594_74##4	1.84615e-19
C430	a_2556_94##8	a_1762_74##2	1.32304e-17
C431	VPWR#9	a_27_74##4	1.21623e-17
C432	D#4	SCE#4	1.03065e-18
C433	a_1762_74##17	a_1762_74##11	1.19087e-18
C434	VPWR#9	a_995_74##9	3.27401e-18
C435	a_995_74##2	a_1163_48##3	1.00597e-16
C436	a_781_74##6	a_1600_347#	7.08881e-19
C437	VGND#8	a_27_74##4	3.11573e-18
C438	a_781_74##3	a_995_74##10	3.23364e-17
C439	SET_B#1	a_1411_74#	9.87534e-18
C440	a_781_74##11	VPWR#16	1.46281e-17
C441	a_290_464##3	SCE#2	3.68931e-19
C442	VPWR#9	SCE#6	4.38975e-18
C443	VPWR#8	a_594_74##9	4.01515e-18
C444	a_1924_48##4	SET_B#6	1.62237e-18
C445	Q	a_1762_74##2	2.19674e-18
C446	VGND#8	a_594_74##11	4.93089e-18
C447	a_995_74##2	a_1163_48##2	8.35178e-17
C448	VGND#8	SCD#2	4.23597e-18
C449	a_995_74#	a_1411_74#	9.87534e-18
C450	SET_B#2	a_781_74##2	1.22843e-19
C451	VGND#13	a_995_74##4	1.61394e-19
C452	a_1924_48##3	SET_B#4	2.05463e-17
C453	a_781_74##6	a_1762_74##14	4.5283e-17
C454	a_290_464##5	a_781_74##3	6.79072e-17
C455	VGND#8	SCE#6	6.93177e-18
C456	VPWR#15	a_1762_74##11	1.84563e-19
C457	a_594_74##9	a_594_74##4	3.50671e-17
C458	a_27_74##7	D#2	2.22504e-19
C459	a_995_74##11	a_594_74##3	1.15145e-18
C460	VPWR#14	a_1924_48#	2.40772e-19
C461	VPWR#9	D#2	2.04625e-18
C462	a_1163_48##2	a_1163_48##3	4.74565e-18
C463	a_995_74##2	a_781_74##2	9.18269e-20
C464	a_27_74##7	SCE#3	1.96845e-17
C465	a_594_74##2	a_1924_48#	1.67291e-17
C466	VPWR#9	a_290_464##6	2.05434e-17
C467	a_1163_48##5	SET_B#1	6.34688e-18
C468	Q_N#1	a_1762_74##3	1.34645e-17
C469	a_781_74##6	a_1712_374##2	2.04344e-18
C470	a_781_74##9	a_781_74##3	2.74712e-18
C471	a_27_74##6	D#2	7.12267e-20
C472	a_1762_74##17	SET_B#6	3.25288e-17
C473	SCD#4	a_416_464#	1.26481e-17
C474	VGND#8	D#2	1.71694e-18
C475	a_1924_48##5	a_1762_74##6	9.10229e-17
C476	VGND#6	SET_B#2	9.44484e-19
C477	a_781_74##2	a_1163_48##3	5.4364e-17
C478	a_27_74##4	SCD#2	3.13937e-17
C479	VPWR#9	a_27_74##2	3.28584e-19
C480	a_594_74##9	a_594_74##3	1.27125e-17
C481	a_1762_74##2	a_2556_94##3	1.24168e-17
C482	a_27_74##3	a_416_464#	6.51599e-18
C483	a_781_74##6	VPWR#6	8.69271e-19
C484	a_781_74##6	a_1600_347##2	6.93935e-17
C485	VPWR#10	CLK#1	6.59769e-19
C486	VGND#8	a_27_74##2	5.28481e-18
C487	a_781_74##2	a_1163_48##2	4.44892e-18
C488	a_781_74##3	a_1163_48##3	5.24822e-19
C489	VGND#8	a_995_74##9	6.4693e-18
C490	a_27_74##8	VGND#19	4.01349e-17
C491	SET_B#6	VPWR#15	9.48787e-18
C492	VGND#13	SET_B#1	5.30903e-19
C493	VPWR#9	SCE#2	2.00481e-18
C494	SCE	a_290_464##3	1.18016e-18
C495	a_1924_48##5	a_1762_74##2	1.70479e-19
C496	a_781_74##6	VPWR#16	5.96343e-17
C497	a_594_74##5	a_290_464##5	2.26914e-17
C498	VPWR#9	VPWR#20	1.81616e-17
C499	a_781_74##11	a_1163_48##7	7.53108e-17
C500	a_2556_94##8	VPWR#2	1.02242e-17
C501	VGND#14	SCD	8.3354e-19
C502	a_1600_347#	a_1762_74##11	3.41939e-19
C503	a_1762_74##13	a_1762_74##6	1.11669e-18
C504	Q_N#1	a_1762_74##2	2.31648e-18
C505	a_1762_74##4	VPWR#14	2.04641e-18
C506	a_781_74##11	a_995_74##6	4.65122e-19
C507	a_1762_74##17	a_1924_48#	9.54088e-19
C508	D#3	a_206_464#	1.54554e-17
C509	a_27_74##7	a_27_74##2	1.77021e-19
C510	a_1163_48##5	a_995_74#	2.99505e-17
C511	VGND#7	a_781_74##9	1.78567e-17
C512	a_594_74##5	a_781_74##9	3.64516e-17
C513	a_781_74##5	a_594_74##2	2.11429e-17
C514	a_290_464##3	a_594_74##4	2.80921e-19
C515	a_594_74#	a_1924_48##3	3.13481e-17
C516	a_781_74##6	a_1163_48##7	7.96837e-17
C517	a_1163_48#	a_1115_74#	8.24968e-18
C518	D#4	D#2	5.49094e-18
C519	VPWR#9	a_27_74##9	1.66382e-17
C520	a_781_74##3	a_781_74##2	2.03788e-17
C521	SCE#1	a_206_464#	1.54554e-17
C522	a_1712_374#	SET_B#6	1.13535e-18
C523	a_1762_74##13	VPWR#4	1.6065e-18
C524	a_781_74#	a_1115_74#	8.58214e-18
C525	a_1600_347##2	a_995_74##5	5.55981e-19
C526	a_27_74##6	a_27_74##2	1.96e-18
C527	Q_N	a_1762_74##4	1.16909e-18
C528	Q_N#1	VPWR#3	1.39177e-17
C529	Q_N	a_1762_74##3	1.9499e-17
C530	VPWR#20	VPWR#10	7.8638e-21
C531	VGND#7	a_995_74##2	2.77751e-19
C532	Q_N	a_1762_74##2	1.16645e-18
C533	a_1762_74##4	a_1762_74##6	2.39813e-18
C534	a_1924_48##5	SET_B#5	6.39776e-17
C535	VGND#14	VGND#17	2.89943e-19
C536	a_27_74##7	SCE	4.25588e-17
C537	a_1924_48#	VPWR#15	1.14867e-17
C538	a_995_74##6	a_594_74##2	2.33447e-17
C539	a_27_74##6	SCE	2.51008e-17
C540	VGND#13	a_995_74#	2.59316e-18
C541	VGND#6	a_995_74##2	4.8062e-18
C542	a_995_74##9	a_781_74##11	5.48472e-18
C543	a_1600_347#	SET_B#6	7.59259e-19
C544	VPWR#6	a_995_74##5	2.68159e-19
C545	VPWR#4	VPWR#14	4.87738e-19
C546	VPWR#14	a_1762_74##3	3.4933e-19
C547	a_1762_74##17	a_594_74##2	3.89212e-20
C548	SCE	D#4	2.66743e-17
C549	VPWR#10	SCD#4	5.40937e-18
C550	a_290_464##3	VPWR#9	2.83397e-17
C551	a_1762_74##2	a_2556_94##4	2.18376e-18
C552	a_1163_48##5	a_1163_48#	1.36591e-18
C553	SCE#6	SCD#2	3.51053e-17
C554	a_781_74##11	VPWR#17	9.95842e-17
C555	a_1712_374#	a_1924_48#	4.46264e-17
C556	a_995_74##6	a_781_74##5	3.40575e-18
C557	a_27_74##7	SCE#2	2.29672e-17
C558	a_1762_74##13	SET_B#5	6.34704e-17
C559	D#4	a_27_74##2	9.74317e-19
C560	a_781_74##11	SET_B#3	6.82977e-18
C561	CLK#2	VGND#17	2.02736e-17
C562	CLK#2	a_594_74##5	3.46414e-17
C563	VGND#5	SET_B#4	4.01914e-18
C564	a_290_464##2	VPWR#9	1.93549e-17
C565	a_27_74##6	SCE#2	1.16042e-17
C566	SET_B#2	VPWR#16	8.36219e-19
C567	a_781_74##7	a_594_74#	2.13072e-17
C568	SET_B#8	a_995_74##4	4.74231e-18
C569	SCD#2	CLK#1	7.69646e-18
C570	a_594_74##13	CLK#2	1.93332e-17
C571	a_1600_347#	a_1924_48#	7.57566e-18
C572	a_1163_48#	VGND#13	1.76296e-17
C573	a_781_74##12	a_594_74##4	5.96626e-18
C574	a_1163_48##7	SET_B#2	1.35045e-17
C575	VGND#5	a_1924_48##3	8.40115e-18
C576	VPWR#10	VPWR#8	1.01795e-18
C577	a_1924_48##4	a_1762_74##4	7.18431e-18
C578	a_1924_48##2	a_1924_48##5	2.12055e-18
C579	a_290_464##2	a_594_74##4	3.78055e-17
C580	a_1712_374#	a_594_74##2	1.86182e-17
C581	a_995_74##10	a_995_74#	3.93373e-19
C582	VGND#14	a_594_74##13	2.64156e-18
C583	a_1163_48##5	a_781_74#	1.6046e-19
C584	a_1924_48##5	VGND#10	5.82088e-17
C585	VPWR	a_1762_74##4	7.97842e-21
C586	a_290_464##3	SCD	8.7228e-17
C587	VGND#5	a_594_74#	5.36674e-18
C588	SET_B#3	a_995_74##6	2.66145e-17
C589	a_1762_74##14	a_1924_48#	1.70321e-17
C590	VPWR	a_1762_74##3	1.22565e-18
C591	VPWR#6	SET_B#2	5.81515e-20
C592	VPWR	a_1762_74##2	2.95571e-18
C593	SET_B#5	a_1762_74##4	8.50961e-20
C594	VPWR	a_594_74##3	6.61024e-18
C595	a_2556_94##6	Q	8.03268e-18
C596	VPWR#10	a_27_74##3	5.77579e-18
C597	D#4	SCE#2	9.27845e-18
C598	a_1762_74##8	a_2556_94##3	1.18182e-17
C599	VGND#1	VGND#9	2.24445e-17
C600	VGND#2	a_1762_74##8	5.40948e-18
C601	VGND#4	a_1762_74##10	8.58039e-19
C602	a_781_74##12	a_594_74##3	2.79374e-17
C603	a_1600_347#	a_594_74##2	3.9288e-17
C604	a_290_464##3	SCD#2	2.50418e-17
C605	a_781_74##11	a_995_74##3	2.96989e-17
C606	a_995_74##2	a_1163_48##7	2.06003e-17
C607	VPWR#14	VPWR#2	3.04674e-19
C608	a_27_74##6	VPWR#20	3.75751e-17
C609	VGND#13	a_781_74#	2.6146e-18
C610	a_1712_374##2	a_1924_48#	2.7571e-19
C611	a_995_74##4	a_781_74##7	5.39027e-17
C612	D#2	SCD#2	2.8038e-18
C613	SCE#6	a_27_74##4	4.90961e-17
C614	a_995_74##10	a_1163_48#	4.60092e-18
C615	VGND#3	Q_N	2.89358e-17
C616	a_1762_74##14	a_594_74##2	5.21493e-17
C617	a_1924_48##4	VPWR#3	1.80409e-17
C618	a_290_464##2	a_594_74##3	1.56514e-18
C619	a_995_74##3	SET_B#3	1.99859e-17
C620	VGND#3	a_1762_74##10	4.75482e-18
C621	a_781_74##11	VPWR#7	8.7305e-17
C622	D#2	a_27_74##4	8.52368e-17
C623	a_1600_347##2	a_1924_48#	1.19106e-19
C624	CLK	a_290_464##5	2.96897e-18
C625	SCD#3	a_392_74#	9.87534e-18
C626	VPWR#7	a_995_74##2	2.15535e-19
C627	VGND#7	a_1163_48##2	4.5159e-18
C628	a_781_74##9	a_995_74#	2.85239e-19
C629	a_1600_347#	a_781_74##5	9.21743e-18
C630	SCE#5	a_392_74#	9.87534e-18
C631	VGND#17	CLK	2.18915e-17
C632	a_1762_74##6	a_1762_74##10	1.66124e-18
C633	SCE#6	D#2	6.58172e-17
C634	VPWR#18	a_594_74##4	4.00263e-19
C635	a_1712_374##2	a_594_74##2	3.99057e-17
C636	VPWR#6	a_995_74##2	3.72571e-19
C637	a_1762_74##17	VPWR#4	2.0716e-17
C638	a_995_74##11	a_781_74##11	6.66887e-17
C639	Q_N	a_2556_94##6	3.51303e-17
C640	a_1712_374#	a_995_74##6	1.59169e-19
C641	VPWR#17	a_1163_48##3	5.42481e-19
C642	VGND#13	a_594_74##8	6.08732e-19
C643	a_27_74##2	SCE#6	3.44913e-18
C644	a_27_74##6	a_27_74##9	1.4007e-18
C645	VPWR#10	D#3	7.04715e-20
C646	a_1762_74##6	a_1762_74##7	1.83156e-18
C647	a_781_74##11	a_1163_48##4	2.37114e-17
C648	Q_N	a_1924_48##5	4.69549e-17
C649	a_781_74##5	a_1762_74##14	9.93004e-18
C650	VGND#4	a_1762_74##7	1.68597e-17
C651	a_995_74##10	a_781_74#	3.19663e-17
C652	SCE#6	SCE#2	1.4296e-19
C653	a_1600_347##2	a_594_74##2	1.01719e-17
C654	SET_B#1	a_995_74##4	4.32745e-18
C655	a_1163_48##4	a_995_74##3	1.06311e-17
C656	a_1600_347#	a_995_74##6	3.42585e-19
C657	SCE#2	D#2	2.80567e-17
C658	VPWR#18	a_594_74##3	8.2525e-19
C659	Q	Q#3	3.83747e-18
C660	a_781_74##9	a_1163_48#	3.71394e-19
C661	a_290_464##2	SCD#2	3.83401e-19
C662	a_290_464##4	a_27_74##4	1.11079e-18
C663	a_995_74##11	a_1163_48##3	7.93919e-20
C664	VGND#9	Q	6.85943e-17
C665	a_781_74##5	a_1712_374##2	1.69608e-17
C666	a_2556_94##7	Q	5.30364e-19
C667	SCD	a_594_74##13	1.96734e-17
C668	VGND#13	a_1163_48##5	1.90385e-17
C669	VGND#18	SCD	7.25773e-18
C670	SCE#2	a_27_74##2	1.9988e-17
C671	a_1762_74##7	SET_B#5	6.5291e-18
C672	a_781_74##11	VPWR#6	4.4925e-17
C673	VPWR#17	a_1163_48##2	1.79231e-19
C674	a_290_464##4	SCD	2.47164e-17
C675	a_290_464##3	a_416_464#	3.39491e-18
C676	VPWR#16	a_594_74##2	1.31087e-19
C677	a_290_464##5	a_781_74#	4.43212e-20
C678	VGND#3	a_1762_74##7	3.90738e-19
C679	a_1762_74##9	a_1762_74##2	3.12861e-18
C680	a_27_74##2	SCD#2	1.56795e-19
C681	D#1	a_228_74#	9.87534e-18
C682	VGND#6	SET_B#4	3.93604e-19
C683	VPWR	VPWR#7	1.47904e-17
C684	a_1762_74##14	a_995_74##6	6.51157e-19
C685	VPWR	VPWR#6	1.56823e-16
C686	VGND#7	a_781_74##2	6.92095e-19
C687	VPWR	VPWR#4	7.00046e-17
C688	a_27_74#	a_228_74#	9.87534e-18
C689	Q_N#1	a_2556_94##6	3.13711e-18
C690	VPWR	VPWR#3	1.07706e-16
C691	VPWR	VPWR#2	2.886e-17
C692	SET_B#5	SET_B#4	2.40061e-18
C693	a_1600_347##2	a_781_74##5	1.12054e-17
C694	a_594_74##8	a_995_74##10	1.85405e-17
C695	VPWR	a_2556_94##6	3.66322e-19
C696	a_781_74##2	a_1163_48##7	7.01437e-19
C697	a_781_74##11	a_594_74##7	2.48789e-17
C698	a_2556_94##8	VPWR#13	6.67972e-17
C699	VPWR	a_1924_48##5	6.36366e-19
C700	VPWR#10	SCE#1	1.10449e-20
C701	a_995_74##11	a_781_74##12	2.31211e-17
C702	a_594_74##7	a_1163_48##4	1.80863e-17
C703	VPWR#10	a_594_74##3	4.1271e-20
C704	a_1924_48##2	a_1762_74##7	3.00204e-19
C705	a_781_74##11	a_781_74##6	1.98089e-19
C706	a_1712_374##2	a_995_74##6	2.70643e-18
C707	a_995_74##9	a_995_74##11	2.66824e-19
C708	VPWR	a_1762_74##13	5.4986e-18
C709	a_781_74##9	a_781_74#	2.28793e-18
C710	a_290_464##4	SCE#6	6.72968e-17
C711	a_594_74##11	a_594_74##4	4.54621e-19
C712	a_27_74##4	a_206_464#	1.21725e-18
C713	CLK	a_594_74##11	1.41299e-17
C714	VGND#4	SET_B#4	2.9361e-17
C715	VGND#8	a_1163_48#	1.07622e-18
C716	a_290_464##5	a_594_74##4	3.10114e-17
C717	VPWR	a_781_74##11	2.47413e-17
C718	Q_N	VGND#9	6.70956e-18
C719	a_995_74#	SET_B#1	4.22142e-17
C720	Q_N	a_2556_94##7	4.21537e-17
C721	VPWR#1	a_2556_94##4	1.388e-17
C722	Q_N	Q_N#2	1.67522e-18
C723	a_1924_48##2	SET_B#4	3.33045e-17
C724	SET_B#5	a_594_74#	1.26073e-19
C725	VGND#10	Q_N	6.94209e-17
C726	VPWR#9	a_27_74##6	7.91969e-18
C727	VPWR#8	a_594_74##4	1.10743e-20
C728	a_594_74##8	a_290_464##5	7.7224e-18
C729	a_781_74##4	a_1163_48##4	6.31919e-19
C730	a_1600_347##2	a_995_74##6	4.60183e-17
C731	Q	Q#1	5.86299e-18
C732	a_1762_74##4	a_1762_74##2	1.22547e-18
C733	VGND#8	a_781_74#	1.4071e-19
C734	VGND	a_1762_74##3	1.60358e-18
C735	VPWR#13	Q	9.28297e-17
C736	a_1163_48##7	a_781_74##3	4.06511e-21
C737	VGND	a_1762_74##2	9.64958e-19
C738	a_2556_94##8	Q	4.33188e-18
C739	VGND#17	a_781_74#	5.78977e-20
C740	a_995_74##11	a_781_74##2	1.53555e-17
C741	VPWR#1	a_1762_74#	1.30437e-18
C742	a_1163_48##7	a_781_74##5	1.23229e-19
C743	VGND#2	a_1762_74#	1.40059e-19
C744	VPWR#7	a_1163_48##2	2.0052e-19
C745	a_1712_374##2	SET_B#3	6.66721e-19
C746	Q_N#1	VPWR#13	2.98948e-18
C747	a_995_74##9	a_594_74##7	9.53363e-19
C748	VGND#6	a_1924_48##3	4.24143e-19
C749	SCD	a_594_74##11	7.05019e-17
C750	VGND#8	a_594_74##8	2.81972e-18
C751	a_781_74##4	a_594_74##7	1.47264e-17
C752	a_781_74##12	a_781_74##11	1.13201e-18
C753	SCD	VPWR#19	3.17683e-18
C754	VGND#7	a_781_74##3	5.14155e-19
C755	a_781_74##9	a_594_74##8	2.55887e-17
C756	a_594_74#	a_1924_48##2	2.77502e-17
C757	a_995_74##6	VPWR#16	2.18024e-17
C758	a_995_74##9	a_781_74#	6.0536e-18
C759	VGND#8	a_27_74##7	6.00337e-19
C760	a_1712_374#	VPWR#4	6.28843e-18
C761	a_781_74##11	a_781_74##4	9.47332e-19
C762	VGND#14	a_290_464##4	1.29124e-17
C763	a_995_74##10	a_1163_48##5	1.52965e-18
C764	a_781_74##12	a_781_74##2	4.06142e-20
C765	VGND#8	a_594_74##6	1.37566e-17
C766	a_1600_347##2	SET_B#3	7.0233e-19
C767	a_290_464##5	a_594_74##6	1.27841e-18
C768	a_781_74##3	a_995_74##11	1.72215e-17
C769	a_1163_48##7	a_995_74##6	3.90198e-19
C770	a_1163_48#	a_995_74#	2.82914e-18
C771	VGND#4	a_1924_48##3	4.0197e-18
C772	a_594_74##11	SCD#2	1.33275e-17
C773	Q_N	VPWR#14	2.25922e-18
C774	VGND#17	a_594_74##8	3.0149e-19
C775	VGND#8	CLK#3	5.70617e-18
C776	a_1924_48##4	Q_N	1.25267e-18
C777	a_781_74##6	a_594_74#	2.08372e-18
C778	a_1163_48##2	a_1115_74#	1.5787e-21
C779	Q_N#1	a_2556_94##8	6.08877e-17
C780	a_290_464##5	a_290_464##2	1.95323e-18
C781	VPWR#14	VPWR#13	1.09432e-18
C782	VPWR#8	a_594_74##3	1.68669e-17
C783	a_1762_74##17	a_1762_74##7	9.80541e-20
C784	SET_B#3	VPWR#16	1.23322e-17
C785	VPWR#9	D#4	1.7548e-18
C786	a_27_74##2	a_290_464##4	1.69796e-17
C787	a_781_74##9	a_594_74##4	6.213e-18
C788	a_781_74##9	a_594_74##6	4.80817e-17
C789	VGND	VGND#7	9.44924e-18
C790	a_781_74##6	a_594_74##3	1.01176e-19
C791	VGND	VGND#6	1.6896e-16
C792	VGND#8	SCD#3	2.87163e-18
C793	VGND	VGND#4	9.64613e-17
C794	Q	a_2556_94#	2.50213e-17
C795	a_2556_94##7	VGND#9	4.83854e-17
C796	a_781_74##3	a_781_74##12	4.52207e-18
C797	VGND	VGND#3	8.59966e-17
C798	VGND	VGND#2	3.99664e-17
C799	Q	a_1762_74##8	9.12325e-19
C800	a_290_464##5	SCD#2	1.52257e-19
C801	VPWR#7	VPWR#6	3.11219e-19
C802	VPWR#7	a_781_74##2	5.45459e-19
C803	a_995_74##10	VGND#13	7.4365e-18
C804	SCD	CLK#3	1.3763e-19
C805	VPWR#18	a_781_74##12	3.30989e-17
C806	a_995_74##9	a_594_74##8	1.57016e-18
C807	a_290_464##5	CLK#3	1.498e-19
C808	a_1762_74##3	a_1762_74##2	1.71563e-19
C809	VGND#6	a_594_74#	1.03607e-18
C810	SET_B#3	a_1163_48##7	1.73624e-17
C811	a_995_74##5	a_594_74#	4.01768e-19
C812	a_995_74##4	a_781_74##6	2.64183e-17
C813	a_27_74##2	VGND#19	3.66002e-17
C814	VGND#8	SCE#5	1.24207e-19
C815	a_781_74##11	a_594_74##9	9.37223e-20
C816	VPWR	a_2556_94##8	1.43597e-17
C817	VGND	a_2556_94##6	7.211e-19
C818	VPWR	Q_N#1	1.52901e-17
C819	VPWR	a_1924_48##4	1.94264e-17
C820	VGND	a_1924_48##5	1.01548e-17
C821	VPWR	a_1762_74##17	1.82234e-17
C822	a_594_74##6	VGND#17	1.72388e-17
C823	VPWR	a_1712_374#	3.27983e-17
C824	a_995_74##5	a_781_74##7	1.11137e-18
C825	VPWR	a_1600_347#	9.38553e-18
C826	VPWR	a_1762_74##14	7.80073e-18
C827	Q_N	a_2556_94#	9.41606e-19
C828	VGND#8	D#1	1.24434e-18
C829	VPWR	a_1712_374##2	3.3628e-17
C830	Q_N	a_1762_74##8	6.703e-18
C831	VPWR	a_1600_347##2	1.66079e-17
C832	a_781_74#	a_1163_48#	3.56947e-17
C833	a_594_74##5	a_781_74##12	2.83815e-19
C834	CLK#1	a_594_74##9	5.02543e-17
C835	Q_N	a_1762_74##10	3.10588e-17
C836	Q_N	a_1762_74##7	7.95296e-20
C837	VPWR	a_1163_48##7	6.67324e-18
C838	a_781_74##9	CLK#3	1.22549e-18
C839	a_27_74##6	a_206_464#	1.92878e-18
C840	VGND#8	D#4	1.55395e-18
C841	VGND#4	a_594_74#	1.73483e-18
C842	a_995_74##5	a_995_74##4	4.8977e-18
C843	a_594_74##5	VPWR#18	5.55349e-19
C844	VGND#8	a_27_74#	1.03602e-18
C845	a_995_74##9	SET_B#2	7.81789e-20
C846	a_1163_48##7	a_995_74##3	1.11429e-17
C847	a_594_74##13	a_594_74##6	5.04223e-19
C848	Q	a_2556_94##4	3.85528e-17
C849	a_2556_94#	Q#3	7.72375e-18
C850	Q	a_1762_74#	5.05164e-18
C851	VGND#19	SCE#2	1.22592e-18
C852	VPWR#8	a_781_74##3	1.88313e-19
C853	a_995_74##5	SET_B#1	1.01573e-17
C854	VPWR#19	SCD#2	1.92108e-18
C855	a_594_74##11	a_594_74##5	6.93305e-18
C856	a_1762_74##16	a_1924_48##5	8.66429e-20
C857	VGND	a_2556_94##7	1.87245e-17
C858	VPWR#14	Q_N#1	4.74015e-17
C859	VGND#8	SCE#3	1.0566e-18
C860	VPWR#7	a_594_74##3	5.24429e-17
C861	VGND	VGND#10	2.23012e-17
C862	VGND#17	CLK#3	4.09478e-17
C863	VGND	a_1924_48##7	1.71509e-17
C864	a_290_464##2	a_1163_48##4	1.90428e-19
C865	SCD	CLK#1	3.74527e-19
C866	VPWR#7	a_781_74##3	1.00815e-19
C867	VPWR#9	SCE	5.31289e-18
C868	VGND	a_1762_74##16	3.02272e-17
C869	a_995_74##3	VPWR#17	1.50047e-17
C870	VGND#8	SCE	5.52881e-18
C871	SET_B#2	a_995_74##4	2.61757e-19
C872	VGND#2	a_2556_94##7	1.07595e-17
C873	SCD#4	CLK#1	4.26678e-18
C874	VGND#6	a_781_74##7	1.22277e-17
C875	VGND	a_1163_48##5	6.886e-18
C876	a_995_74##2	a_781_74##11	1.74842e-18
C877	a_594_74##11	VPWR#18	1.25878e-18
C878	VPWR#3	a_2556_94##4	1.09602e-19
C879	a_995_74##11	a_995_74##10	6.90777e-19
C880	a_2556_94#	VGND#9	2.29978e-17
C881	VPWR#9	CLK	1.93906e-18
C882	VGND#8	CLK	1.27441e-18
C883	a_594_74##8	a_781_74#	1.92423e-17
C884	a_1762_74##4	VNB	1.85211e-17
C885	CLK#3	a_594_74##13	1.601e-17
C886	a_594_74##11	CLK#2	4.70529e-17
C887	a_1762_74##3	VNB	2.21468e-17
C888	a_1762_74##2	VNB	4.54368e-17
C889	a_594_74##4	VNB	8.64197e-17
C890	a_781_74##9	VGND#13	3.64645e-18
C891	a_594_74##3	VNB	2.0784e-16
C892	VGND#10	VGND#9	6.76193e-19
C893	SCD#2	VNB	9.99506e-17
C894	VGND	Q_N#1	2.27072e-18
C895	VPWR#16	a_594_74##7	9.45355e-20
C896	VGND#1	VGND#2	2.91933e-17
C897	VPWR#9	SCD	3.83037e-18
C898	SET_B#8	a_594_74##2	1.913e-19
C899	a_1924_48##4	Q_N#1	4.6563e-17
C900	VPWR	a_1762_74#	4.23585e-18
C901	VPWR#6	a_1712_374##2	3.12218e-17
C902	a_995_74##9	a_995_74##2	2.59348e-18
C903	VGND	a_1762_74##14	6.33393e-19
C904	Q	VPWR#1	4.21741e-17
C905	VGND#8	SCD	5.50918e-18
C906	VGND#4	a_781_74##7	3.90636e-19
C907	VGND#7	VGND#6	2.93071e-19
C908	VPWR	a_1762_74##9	5.7149e-18
C909	VGND#4	VGND#10	1.94089e-18
C910	VPWR#17	a_1163_48##4	2.49775e-17
C911	VGND#1	Q	4.22206e-17
C912	VPWR#2	a_2556_94##4	3.58428e-18
C913	VPWR	a_1762_74##11	9.22673e-19
C914	VGND#17	SCD#3	1.13422e-18
C915	VPWR#5	a_1924_48#	1.78347e-18
C916	VGND	a_1163_48##7	1.01652e-18
C917	VPWR	SET_B#6	2.34582e-18
C918	VPWR	a_1924_48#	3.49952e-18
C919	VPWR#19	VPWR#18	1.00418e-17
C920	VGND#5	a_1762_74##16	1.36745e-17
C921	a_995_74##2	SET_B#1	1.11517e-17
C922	a_2556_94##7	a_2556_94#	1.00032e-18
C923	a_27_74##3	SCD#4	3.93217e-17
C924	VPWR	a_995_74##6	4.02755e-18
C925	VPWR#8	a_594_74##5	6.76765e-20
C926	VPWR	SET_B#3	6.14033e-19
C927	a_290_464##2	a_594_74##7	1.89328e-19
C928	VPWR#3	a_1762_74##3	1.86467e-19
C929	VGND#18	CLK#3	2.47288e-18
C930	a_2556_94##3	VGND#9	4.50381e-17
C931	Q	a_2556_94##3	5.42386e-17
C932	VGND#14	VNB	4.52802e-17
C933	VGND#7	VNB	6.51553e-17
C934	VGND#6	VNB	7.22039e-17
C935	VPWR#5	a_594_74##2	1.59561e-17
C936	VGND#4	VNB	3.5224e-17
C937	VGND#3	VNB	4.58187e-17
C938	VGND#2	VNB	3.74138e-17
C939	VGND	a_1762_74##8	1.14392e-17
C940	CLK	a_594_74##5	3.75092e-17
C941	VGND	a_1762_74##10	2.14861e-18
C942	VPWR#10	VNB	4.30219e-17
C943	a_995_74##2	a_995_74#	7.74134e-18
C944	VPWR#8	VNB	4.48427e-17
C945	VGND	a_1762_74##7	6.18544e-20
C946	VPWR#7	VNB	5.01469e-17
C947	CLK	CLK#2	6.03579e-18
C948	VPWR#6	VNB	4.85812e-17
C949	VGND	SET_B#4	7.05197e-19
C950	SCE	D#2	3.47412e-18
C951	VPWR#4	VNB	2.96812e-17
C952	VPWR#3	VNB	4.68991e-17
C953	VGND#5	a_1924_48#	4.14958e-20
C954	a_1762_74##8	VGND#9	3.155e-17
C955	a_781_74##11	a_1163_48##3	7.51232e-17
C956	VPWR#2	VNB	3.12157e-17
C957	a_27_74##2	SCE	5.22398e-17
C958	a_2556_94##6	VNB	8.98395e-18
C959	a_594_74##13	SCD#3	2.77811e-18
C960	VGND	a_995_74##4	2.6964e-18
C961	a_2556_94##6	a_2556_94#	9.04607e-19
C962	a_1924_48##5	VNB	1.2603e-17
C963	SCE	SCE#2	3.12143e-17
C964	SET_B#8	a_995_74##6	3.82446e-18
C965	VGND	a_995_74#	1.06521e-18
C966	a_2556_94##3	a_1762_74#	6.09799e-18
C967	a_1762_74##13	VNB	8.39203e-18
C968	VGND#2	a_2556_94##6	2.49104e-19
C969	VGND#6	a_995_74##4	3.78801e-17
C970	a_781_74##11	VNB	2.67166e-17
C971	a_1924_48##4	VPWR#14	7.47739e-17
C972	a_995_74##9	VNB	8.62329e-18
C973	VPWR#17	a_594_74##7	3.30595e-18
C974	SCD	CLK#2	8.95035e-19
C975	VPWR#6	a_594_74##3	1.58532e-17
C976	a_594_74##6	a_594_74##8	2.88843e-18
C977	a_290_464##3	VNB	1.04882e-17
C978	a_290_464##2	VNB	2.77088e-18
C979	SET_B#8	VPWR	2.25592e-17
C980	a_1762_74##14	SET_B#4	4.38186e-19
C981	VPWR	VPWR#5	8.07304e-17
C982	VGND#5	a_594_74##2	4.04738e-19
C983	a_995_74##11	a_1163_48##4	2.37016e-19
C984	a_27_74##7	VNB	4.21145e-17
C985	a_594_74##13	a_594_74##4	1.56401e-19
C986	a_27_74##6	VNB	3.77936e-17
C987	SET_B#2	a_594_74##3	2.1725e-19
C988	VGND#18	a_290_464##3	1.02001e-18
C989	VPWR	a_2556_94##3	3.37703e-19
C990	D#3	a_27_74##3	1.42459e-17
C991	VGND#9	VNB	7.83857e-18
C992	a_995_74##2	a_781_74#	1.92119e-19
C993	VPWR	a_1762_74##6	7.67728e-18
C994	VGND#10	VNB	1.21096e-17
C995	a_1924_48##7	VNB	8.1099e-18
C996	VPWR	SET_B#5	5.51291e-18
C997	a_995_74##9	a_1163_48##3	1.20349e-17
C998	a_1762_74##16	VNB	5.75604e-18
C999	VGND#18	SCD#3	4.03642e-17
C1000	a_1924_48##5	a_1924_48##4	2.13793e-18
C1001	VPWR	a_781_74##6	8.602e-18
C1002	a_2556_94##7	a_1762_74##8	4.61858e-17
C1003	a_1163_48##5	VNB	8.98346e-18
C1004	VGND#13	VNB	5.19563e-18
C1005	VPWR	a_995_74##5	2.35508e-18
C1006	a_1600_347##2	VPWR#6	8.53258e-18
C1007	a_995_74##10	VNB	3.26729e-18
C1008	a_290_464##5	VNB	4.42709e-18
C1009	VPWR	SET_B#2	1.51908e-18
C1010	VPWR#2	a_1762_74#	1.58397e-18
C1011	a_781_74##9	VNB	1.41191e-17
C1012	VGND#17	VNB	1.2956e-18
C1013	a_594_74##13	VNB	1.11258e-17
C1014	VPWR	a_995_74##2	2.96571e-18
C1015	VGND#4	a_995_74##4	2.54529e-19
C1016	VGND#18	VNB	5.37709e-18
C1017	VGND#4	a_1924_48##7	4.26399e-17
C1018	a_290_464##4	VNB	4.83447e-18
C1019	VPWR	a_1163_48##3	4.89602e-19
C1020	VGND#19	VNB	3.93064e-18
C1021	a_27_74##8	VNB	2.44079e-17
C1022	SET_B#8	VGND#6	1.39802e-17
C1023	a_290_464##2	a_781_74##4	2.39549e-17
C1024	VPWR#13	VNB	2.87125e-18
C1025	a_2556_94##8	VNB	1.71452e-17
C1026	Q_N#1	VNB	5.86231e-19
C1027	a_290_464##4	CLK#3	1.24955e-18
C1028	VPWR#14	VNB	1.4605e-18
C1029	a_1924_48##4	VNB	1.38954e-17
C1030	a_1762_74##17	VNB	9.53921e-18
C1031	VPWR#15	VNB	4.75874e-18
C1032	a_1712_374#	VNB	1.17035e-17
C1033	a_594_74##13	SCE#5	1.60004e-19
C1034	a_1600_347#	VNB	3.70837e-18
C1035	a_1762_74##14	VNB	3.25298e-18
C1036	a_1762_74##6	a_1762_74##9	1.49507e-17
C1037	a_1712_374##2	VNB	1.67975e-17
C1038	VGND#10	a_2556_94#	4.68942e-19
C1039	a_1600_347##2	VNB	1.01431e-17
C1040	VGND#9	a_1762_74##10	1.14802e-18
C1041	VPWR#3	a_1762_74##2	2.73765e-19
C1042	VPWR#16	VNB	4.98533e-18
C1043	a_1163_48##7	VNB	6.30041e-18
C1044	a_781_74##9	a_995_74##10	2.94648e-17
C1045	VPWR#17	VNB	2.04555e-18
C1046	VGND	SET_B#8	2.66177e-17
C1047	a_995_74##11	VNB	6.30437e-18
C1048	a_781_74##12	VNB	1.59909e-17
C1049	VGND	VGND#5	6.53263e-17
C1050	a_594_74##11	VNB	1.06525e-17
C1051	a_594_74##7	a_995_74##11	1.36541e-17
C1052	VPWR#19	VNB	2.16614e-18
C1053	a_594_74##4	a_781_74#	3.25428e-19
C1054	a_1163_48##2	a_995_74#	4.6612e-18
C1055	a_781_74##11	a_1163_48##2	1.44522e-18
C1056	VPWR#20	VNB	2.41137e-18
C1057	VGND	a_2556_94##3	6.21304e-19
C1058	a_27_74##9	VNB	2.38756e-17
C1059	a_290_464##2	a_995_74##11	4.54813e-17
C1060	a_2556_94#	VNB	3.47106e-17
C1061	VGND	a_1762_74##6	5.71078e-18
C1062	a_1762_74##8	VNB	4.88436e-17
C1063	a_1762_74##10	VNB	4.32161e-17
C1064	VGND	SET_B#5	5.14476e-18
C1065	a_1762_74##7	VNB	5.82913e-17
C1066	SET_B#4	VNB	4.67916e-17
C1067	VGND	a_1924_48##2	1.21344e-17
C1068	a_1924_48##3	VNB	2.93703e-17
C1069	a_594_74#	VNB	4.04871e-17
C1070	VGND	a_781_74##6	2.29297e-18
C1071	a_781_74##7	VNB	2.90422e-17
C1072	a_995_74##4	VNB	4.55064e-17
C1073	VGND	a_995_74##5	7.2055e-18
C1074	SET_B#1	VNB	2.82521e-17
C1075	a_995_74#	VNB	2.98619e-17
C1076	VGND	SET_B#2	2.03379e-18
C1077	a_27_74##4	a_290_464##6	5.89621e-17
C1078	SCE#1	D#3	3.71734e-17
C1079	a_1163_48#	VNB	2.74959e-17
C1080	a_2556_94##6	a_1762_74##8	9.21133e-18
C1081	a_781_74#	VNB	3.83418e-17
C1082	VGND	a_995_74##2	1.15477e-17
C1083	a_594_74##8	VNB	4.03094e-17
C1084	a_594_74##6	VNB	2.9524e-17
C1085	VGND	a_1163_48##3	4.038e-19
C1086	CLK#3	VNB	2.86591e-17
C1087	SCD#3	VNB	3.94865e-17
C1088	a_781_74##11	a_594_74##4	8.33841e-20
C1089	SCE#5	VNB	2.5185e-17
C1090	D#1	VNB	3.72585e-17
C1091	a_1163_48##2	a_1163_48#	1.01846e-17
C1092	a_27_74#	VNB	2.23523e-17
C1093	CLK#3	a_594_74##6	2.85295e-17
C1094	SCE#3	VNB	4.69347e-17
C1095	a_2556_94##4	VNB	4.88587e-17
C1096	VPWR#3	a_1762_74##9	5.01652e-18
C1097	a_1762_74#	VNB	4.15378e-17
C1098	VGND#6	SET_B#1	2.39996e-17
C1099	VPWR#1	VPWR#2	4.66208e-17
C1100	a_1762_74##9	VNB	3.67166e-17
C1101	a_290_464##3	a_594_74##9	2.61196e-19
C1102	VGND#18	SCE#5	3.57481e-18
C1103	a_1762_74##11	VNB	3.57272e-17
C1104	SET_B#6	VNB	4.20715e-17
C1105	a_1924_48#	VNB	8.58332e-17
C1106	a_594_74##2	VNB	1.87529e-16
C1107	a_781_74##5	VNB	2.35576e-17
C1108	a_995_74##6	VNB	4.42652e-17
C1109	a_2556_94##6	a_2556_94##4	1.55186e-18
C1110	SET_B#3	VNB	3.36238e-17
C1111	a_995_74##3	VNB	3.77407e-17
C1112	a_1163_48##4	VNB	2.23264e-17
C1113	a_594_74##7	VNB	2.68127e-17
C1114	a_781_74##4	VNB	3.22564e-17
C1115	SET_B#6	a_1762_74##6	6.51361e-19
C1116	a_594_74##9	VNB	3.68955e-17
C1117	a_2556_94##7	a_1762_74##10	7.6632e-19
C1118	CLK#1	VNB	3.84903e-17
C1119	SCD#4	VNB	2.75647e-17
C1120	a_27_74##3	VNB	2.32112e-17
C1121	D#3	VNB	2.39089e-17
C1122	a_781_74#	a_1163_48##2	2.50398e-17
C1123	SCE#1	VNB	2.93419e-17
C1124	SCE#4	VNB	3.69666e-17
C1125	a_995_74##9	a_1163_48##2	4.53353e-17
C1126	VPWR#1	VNB	1.08534e-16
C1127	VGND#3	a_1924_48##7	7.66457e-18
C1128	a_290_464##4	SCD#3	1.97056e-17
C1129	VGND#10	a_1762_74##6	2.80774e-18
C1130	VGND#1	VNB	1.07355e-16
C1131	SET_B#8	VNB	1.19341e-17
C1132	VPWR#5	VNB	4.33162e-17
C1133	a_1762_74##17	a_1924_48##4	3.99451e-17
C1134	VGND#5	VNB	3.25532e-17
C1135	VPWR#15	VPWR#14	7.50366e-19
C1136	VPWR#9	VNB	3.05837e-16
C1137	VGND#8	VNB	3.8364e-16
C1138	a_781_74##4	a_995_74##11	1.78117e-17
C1139	a_2556_94##3	VNB	5.52489e-17
C1140	a_1762_74##6	VNB	1.05344e-16
C1141	SET_B#5	VNB	9.52101e-17
C1142	a_1924_48##2	VNB	9.00759e-17
C1143	a_781_74##6	VNB	5.2553e-17
C1144	a_995_74##5	VNB	3.45683e-17
C1145	a_781_74##9	a_290_464##5	6.93704e-17
C1146	SET_B#2	VNB	5.48782e-17
C1147	a_995_74##2	VNB	7.13296e-17
C1148	a_290_464##2	a_594_74##9	2.48507e-17
C1149	a_1163_48##3	VNB	4.30307e-17
C1150	a_1163_48##2	VNB	7.09694e-17
C1151	VGND#10	a_1762_74##8	4.01787e-19
C1152	a_781_74##2	VNB	6.81653e-17
C1153	a_781_74##3	VNB	5.29046e-17
C1154	VPWR#2	a_1762_74##9	5.87468e-19
C1155	a_594_74##5	VNB	3.71336e-17
C1156	CLK#2	VNB	4.03724e-17
C1157	a_781_74##12	a_594_74##7	1.88036e-19
C1158	a_290_464##6	SCE#6	1.32889e-19
C1159	a_27_74##4	VNB	2.41291e-17
C1160	SCE#6	VNB	4.30522e-17
C1161	D#2	VNB	5.04032e-17
C1162	a_27_74##2	VNB	3.24808e-17
C1163	SCE#2	VNB	9.1579e-17
C1164	VGND#4	VGND#11	7.95403e-18
C1165	a_290_464##2	a_594_74##8	2.80799e-19
C1166	a_995_74##2	a_594_74##3	1.92461e-18
C1167	SCE#4	SCE#1	3.73459e-17
C1168	a_594_74##13	SCD#2	3.36811e-18
C1169	a_781_74##9	a_781_74##12	2.5897e-19
C1170	VGND#7	a_995_74#	1.93182e-18
C1171	VPWR#4	a_1762_74##11	4.07165e-19
C1172	a_1762_74##13	a_1924_48##4	2.24851e-17
C1173	a_781_74##4	a_290_464#	4.61924e-18
C1174	a_290_464##2	a_290_464#	4.14204e-18
C1175	a_1762_74##10	Q_N#2	2.36614e-17
C1176	a_781_74##2	a_781_74##11	2.53042e-18
C1177	VGND	Q_N	2.53385e-17
C1178	VGND#18	D#1	3.52527e-19
C1179	a_290_464##6	VPWR#19	3.20341e-18
C1180	SCE	VNB	1.27491e-17
C1181	CLK	VNB	7.79359e-19
C1182	SCD	VNB	2.81174e-18
C1183	Q	VNB	1.12594e-16
C1184	VPWR#4	VPWR#3	3.64404e-19
C1185	Q_N	VNB	2.2018e-17
C1186	VPWR	VNB	2.53563e-16
C1187	a_1924_48#	SET_B#5	3.89043e-18
C1188	VGND	VNB	2.5785e-16
C1189	VPWR#11	D#2	1.1066e-19
C1190	VGND#15	D#2	3.59887e-19
C1191	SET_B	SET_B#5	1.82776e-18
C1192	SET_B	a_1712_374#	1.11855e-18
C1193	VPWR#11	D#3	7.4589e-18
C1194	VGND#15	SCE#3	4.93121e-18
C1195	SET_B	a_1762_74##4	1.15009e-19
C1196	VGND#8	VGND#15	1.10172e-16
C1197	VGND#15	a_27_74##8	2.0862e-17
C1198	VGND#15	VGND#14	3.77527e-19
C1199	SET_B	a_1762_74##6	2.75186e-18
C1200	VGND#15	a_27_74##2	1.56017e-18
C1201	a_27_74##6	VPWR#11	2.63853e-18
C1202	VGND#15	SCE	9.97539e-19
C1203	VPWR#11	VNB	6.42656e-17
C1204	a_27_74##4	VPWR#11	2.15968e-18
C1205	SET_B	VNB	4.41176e-18
C1206	VGND#15	VGND#18	4.60426e-21
C1207	a_290_464##6	VPWR#11	1.31583e-17
C1208	VPWR#11	a_27_74##2	9.65593e-20
C1209	VPWR#11	SCE#1	3.95139e-18
C1210	VGND#15	SCD#3	4.8014e-20
C1211	SET_B	a_1600_347##2	2.13461e-18
C1212	a_27_74##9	VPWR#11	1.7614e-17
C1213	VGND	SET_B	2.58928e-17
C1214	SET_B	a_594_74##2	7.20618e-18
C1215	SET_B	a_1762_74##16	6.50591e-18
C1216	VGND#15	SCE#5	7.96585e-20
C1217	SET_B	a_1712_374##2	2.42677e-18
C1218	VGND#15	a_290_464##4	6.75054e-18
C1219	VGND#15	VNB	6.24882e-17
C1220	SET_B	a_1924_48#	7.23063e-19
C1221	VPWR#11	VPWR#10	2.0355e-19
C1222	SET_B	VGND#5	5.53085e-18
C1223	VGND#15	D#1	8.12912e-18
C1224	SET_B	a_781_74##6	4.0555e-17
C1225	a_1762_74##14	SET_B	1.03192e-16
C1226	VPWR#11	SCE#4	1.79144e-18
C1227	SET_B	VGND#6	2.23113e-18
C1228	SET_B	SET_B#4	2.02064e-18
C1229	VPWR	SET_B	2.47497e-17
C1230	SET_B	a_1762_74##13	1.2524e-18
C1231	VPWR#9	VPWR#11	1.13583e-16
C1232	VGND#15	SCE#6	4.9017e-19
C1233	SET_B	VPWR#5	1.97306e-18
C1234	SET_B	a_1600_347#	8.11162e-18
C1235	VGND#15	a_27_74#	7.49921e-18
C1236	SET_B	a_1924_48##2	5.81464e-17
C1237	VGND#15	a_27_74##7	2.50217e-19
*
*
.ENDS sky130_fd_sc_hs__sdfsbp_1
*
