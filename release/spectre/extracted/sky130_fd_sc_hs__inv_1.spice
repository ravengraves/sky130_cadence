* Extracted by Quantus, converted by sky130cad/quantus.py
*
*
*
*                       LINUX           Wed Nov 18 08:41:24 2026
*
*
*
*  PROGRAM  advgen
*
*  Name           : advgen - Quantus - (64-bit)
*  Version        : 25.1.0-p047
*  Build Date     : Thu Dec 11 23:20:30 PST 2025
*
*  HSPICE LIBRARY
*
*  OPERATING_TEMPERATURE 150
*  QRC_TECH_DIR <path>/tech
*
*
*

*
.SUBCKT sky130_fd_sc_hs__inv_1 VPB VNB VGND VPWR Y A
*
*
*  caps2d version: 10
*
*
*       TRANSISTOR CARDS
*
*
XM1 VGND#4 A#1 Y#3 VNB sky130_fd_pr__nfet_01v8_lvt l=0.15 w=0.74 ad=0.2627 as=0.2109 pd=2.19 ps=2.05
XM0 VPWR#4 A#4 Y#1 VPB sky130_fd_pr__pfet_01v8 l=0.15 w=1.12 ad=0.3864 as=0.3304 pd=2.93 ps=2.83
*
*
*       RESISTOR AND CAP/DIODE CARDS
*
Rg1	A#1	A#2	368.862610
Rg2	A#2	A#3	69.971420
Rg3	A#2	A#4	471.862823
Rf1	A#5	A	1.932170
Rf2	A#3	A#7	82.048569
Rf3	A#5	A#7	6.596592
Rf4	Y	Y#2	0.196836
Rf5	Y#2	Y	14.369054
Rf6	Y	Y#4	7.282945
Rf7	Y#4	Y	7.282945
Rf8	Y#1	Y#2	5.000000
Rf9	Y#3	Y#4	7.500000
Rf12	VPWR#2	VPWR#4	39.225067
Rf15	VGND#2	VGND#4	36.804161
Re1	VPWR#2	VPWR	3.274347
Re2	VGND	VGND#2	3.274471
*
*       CAPACITOR CARDS
*
*
C1	VGND	VNB	5.46473e-17
C2	VPWR	VNB	5.46236e-17
C3	Y	VNB	1.20504e-16
C4	A	VNB	3.39853e-17
C5	VGND	Y	2.04417e-17
C6	A#3	VNB	7.40858e-17
C7	VGND	A	5.9463e-18
C8	VPWR	Y	2.04802e-17
C9	A#4	VNB	4.77837e-17
C10	VPWR	A	5.46321e-18
C11	VGND	A#3	4.11312e-18
C12	A#1	VNB	3.69886e-17
C13	VPWR#4	VNB	4.83618e-17
C14	VPWR	A#3	5.38505e-20
C15	VGND#4	VNB	4.02612e-17
C16	A#7	VNB	7.88151e-18
C17	VGND	A#1	5.29432e-18
C18	A	A#3	1.34772e-17
C19	VPWR	A#4	5.70075e-18
C20	VGND	VGND#4	2.2487e-17
C21	VPWR	VPWR#4	2.24862e-17
C22	Y	A#4	3.73724e-17
C23	VGND	A#7	3.47056e-18
C24	Y	A#1	2.68314e-17
C25	VPWR#4	Y	9.65518e-17
C26	Y	Y#1	5.94628e-18
C27	VPWR	A#7	3.29953e-18
C28	VGND#4	Y	7.53271e-17
C29	Y	Y#3	3.85735e-18
C30	A#7	Y	5.68069e-17
C31	A#3	VPWR#4	8.42757e-18
C32	VGND#4	A#3	9.70784e-18
C33	A#7	A#3	2.24576e-17
C34	A#4	VPWR#4	3.6954e-17
C35	A#4	Y#1	1.206e-17
C36	A#2	VNB	3.12596e-17
C37	VGND#4	A#1	2.90043e-17
C38	A#7	A#4	3.18873e-18
C39	A#1	Y#3	7.72968e-18
C40	A#7	VPWR#4	4.08329e-17
C41	A#7	VGND#4	4.37303e-17
C42	Y	A#2	1.87608e-17
C43	A#7	A#2	1.34908e-18
C44	VGND#2	A#1	5.12874e-18
C45	A	VPWR#2	1.66141e-18
C46	VGND	VGND#2	4.56604e-17
C47	A#7	VPWR#2	2.91657e-19
C48	VGND#2	A#3	6.68674e-19
C49	VPWR	VPWR#2	4.60441e-17
C50	VGND#2	Y	2.08972e-17
C51	VGND#2	A#7	2.95343e-19
C52	VPWR#2	A#3	1.05348e-18
C53	Y	VPWR#2	2.08958e-17
C54	VGND#2	VNB	1.55988e-16
C55	VPWR#2	A#4	4.91908e-18
C56	VGND#2	A	1.52462e-18
C57	VPWR#2	VNB	1.56363e-16
*
*
.ENDS sky130_fd_sc_hs__inv_1
*
