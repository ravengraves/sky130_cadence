* Extracted by Quantus, converted by sky130cad/quantus.py
*
*
*
*                       LINUX           Wed Nov 18 08:50:17 2026
*
*
*
*  PROGRAM  advgen
*
*  Name           : advgen - Quantus - (64-bit)
*  Version        : 25.1.0-p047
*  Build Date     : Thu Dec 11 23:20:30 PST 2025
*
*  HSPICE LIBRARY
*
*  OPERATING_TEMPERATURE 150
*  QRC_TECH_DIR <path>/tech
*
*
*

*
.SUBCKT sky130_fd_sc_hs__nor3_4 VPB VNB VGND VPWR Y A C B
*
*
*  caps2d version: 10
*
*
*       TRANSISTOR CARDS
*
*
XM16 VGND#5 A#5 Y#4 VNB sky130_fd_pr__nfet_01v8_lvt l=0.15 w=0.74 ad=0.2109 as=0.2146 pd=2.05 ps=2.06
XM17 Y#4 A#6 VGND#7 VNB sky130_fd_pr__nfet_01v8_lvt l=0.15 w=0.74 ad=0.2146 as=0.3034 pd=2.06 ps=2.3
XM7 VGND#7 B#5 Y#8 VNB sky130_fd_pr__nfet_01v8_lvt l=0.15 w=0.74 ad=0.3034 as=0.2072 pd=2.3 ps=2.04
XM11 Y#8 B#1 VGND#6 VNB sky130_fd_pr__nfet_01v8_lvt l=0.15 w=0.74 ad=0.2072 as=0.3108 pd=2.04 ps=2.32
XM0 VGND#6 C#12 Y#1 VNB sky130_fd_pr__nfet_01v8_lvt l=0.15 w=0.74 ad=0.3108 as=0.2072 pd=2.32 ps=2.04
XM3 Y#1 C#10 VGND#1 VNB sky130_fd_pr__nfet_01v8_lvt l=0.15 w=0.74 ad=0.2072 as=0.40425 pd=2.04 ps=2.58
XM1 a_27_368# A#7 VPWR#7 VPB sky130_fd_pr__pfet_01v8 l=0.15 w=1.12 ad=0.3248 as=0.336 pd=2.82 ps=2.84
XM12 VPWR#7 A#1 a_27_368##7 VPB sky130_fd_pr__pfet_01v8 l=0.15 w=1.12 ad=0.336 as=0.336 pd=2.84 ps=2.84
XM10 a_27_368##7 B#4 a_295_368##6 VPB sky130_fd_pr__pfet_01v8 l=0.15 w=1.12 ad=0.336 as=0.5426 pd=2.84 ps=3.39
XM6 Y#9 C#7 a_295_368##6 VPB sky130_fd_pr__pfet_01v8 l=0.15 w=1.12 ad=0.5229 as=0.5426 pd=3.28 ps=3.39
XM8 a_295_368##4 C#11 Y#9 VPB sky130_fd_pr__pfet_01v8 l=0.15 w=1.12 ad=0.5488 as=0.5229 pd=3.4 ps=3.28
XM9 Y#6 C#9 a_295_368##4 VPB sky130_fd_pr__pfet_01v8 l=0.15 w=1.12 ad=0.5229 as=0.5488 pd=3.28 ps=3.4
XM14 a_295_368##2 C#8 Y#6 VPB sky130_fd_pr__pfet_01v8 l=0.15 w=1.12 ad=0.5488 as=0.5229 pd=3.4 ps=3.28
XM13 a_295_368##2 B#9 a_27_368##5 VPB sky130_fd_pr__pfet_01v8 l=0.15 w=1.12 ad=0.5488 as=0.336 pd=3.4 ps=2.84
XM2 a_295_368# B#10 a_27_368##5 VPB sky130_fd_pr__pfet_01v8 l=0.15 w=1.12 ad=0.336 as=0.336 pd=2.84 ps=2.84
XM4 a_27_368##11 B#6 a_295_368# VPB sky130_fd_pr__pfet_01v8 l=0.15 w=1.12 ad=0.336 as=0.336 pd=2.84 ps=2.84
XM15 VPWR#6 A#10 a_27_368##11 VPB sky130_fd_pr__pfet_01v8 l=0.15 w=1.12 ad=0.336 as=0.336 pd=2.84 ps=2.84
XM5 a_27_368##2 A#8 VPWR#6 VPB sky130_fd_pr__pfet_01v8 l=0.15 w=1.12 ad=0.3192 as=0.336 pd=2.81 ps=2.84
*
*
*       RESISTOR AND CAP/DIODE CARDS
*
Rg1	A#1	A#2	449.655212
Rg2	A#2	A#3	17.800245
Rg3	A#3	A#4	35.535461
Rg4	A#4	A#5	451.838898
Rg5	A#2	A#6	397.555725
Rg6	A#4	A#7	503.938385
Rg7	B#1	B#2	425.561096
Rg8	B#2	B#3	49.580112
Rg9	B#3	B#4	434.639221
Rg10	B#2	B#5	269.511658
Rg11	B#6	B#7	577.647095
Rg12	B#7	B#8	44.410511
Rg13	B#8	B#9	534.409607
Rg14	B#7	B#10	494.376099
Rg15	C#1	C#2	751.560303
Rg16	C#2	C#3	280.322235
Rg17	C#3	C#4	126.343689
Rg18	C#4	C#5	143.559540
Rg19	C#5	C#6	45.748947
Rg20	C#6	C#7	628.536743
Rg21	C#2	C#8	417.569458
Rg22	C#3	C#9	398.937378
Rg23	C#4	C#10	469.292358
Rg24	C#5	C#11	398.937378
Rg25	C#6	C#12	492.674774
Rg26	A#8	A#9	481.953613
Rg27	A#9	A#10	494.557465
Rf1	B#8	B	158.347137
Rf2	B	B#3	203.797394
Rf3	a_295_368#	a_295_368##3	85.089096
Rf4	a_295_368##3	a_295_368##5	68.302216
Rf5	a_295_368##5	a_295_368##6	83.019966
Rf6	a_295_368##2	a_295_368##3	15.000000
Rf7	a_295_368##4	a_295_368##5	15.000000
Rf8	Y#1	Y#2	12.243755
Rf9	Y#2	Y#3	65.044708
Rf10	Y#3	Y#5	80.178947
Rf11	Y#2	Y#7	354.353607
Rf12	Y#3	Y#8	14.766976
Rf13	Y#5	Y	7.282945
Rf14	Y#7	Y#9	75.153381
Rf15	Y#4	Y#5	7.500000
Rf16	Y#6	Y#7	15.000000
Rf17	C	C#1	16.140581
Rf18	C#1	C	2.755709
Rf19	A#9	A	402.948395
Rf20	A	A#3	180.937012
Rf22	a_27_368##3	a_27_368##4	64.278748
Rf23	a_27_368##4	a_27_368##6	65.098358
Rf24	a_27_368##6	a_27_368##8	246.938950
Rf25	a_27_368##8	a_27_368##10	71.822639
Rf26	a_27_368##4	a_27_368##11	16.617970
Rf28	a_27_368##2	a_27_368##3	5.000000
Rf29	a_27_368##5	a_27_368##6	15.000000
Rf30	a_27_368##7	a_27_368##8	7.500000
Rf31	a_27_368#	a_27_368##10	5.000000
Rf33	VPWR#2	VPWR#3	192.828766
Rf34	VPWR#3	VPWR#4	192.463531
Rf36	VPWR#2	VPWR#6	32.539131
Rf37	VPWR#4	VPWR#7	32.932804
Rf38	VGND#1	VGND#2	36.291130
Rf39	VGND#2	VGND#3	86.211578
Rf40	VGND#3	VGND#4	73.001427
Rf41	VGND#4	VGND#5	111.912102
Rf42	VGND#3	VGND#6	33.326477
Rf43	VGND#4	VGND#7	38.247387
Re1	VPWR#3	VPWR	0.701577
Re2	VGND	VGND#2	0.701602
*
*       CAPACITOR CARDS
*
*
C1	C#7	C#6	2.52291e-19
C2	B#2	C#7	1.33095e-17
C3	a_27_368##5	C#4	2.81182e-19
C4	a_27_368##5	C#3	3.32264e-19
C5	Y#2	VGND#1	7.49652e-17
C6	a_27_368##4	VPWR#6	1.49356e-17
C7	a_27_368##5	C#2	3.26781e-19
C8	Y#2	Y#1	1.39485e-18
C9	Y#3	VGND#6	4.91215e-17
C10	a_27_368##4	a_27_368##11	1.91979e-18
C11	Y#2	VGND#6	4.9248e-17
C12	Y#3	Y#8	4.68449e-19
C13	a_27_368##4	a_295_368#	1.52002e-17
C14	a_295_368##2	C#2	2.13926e-19
C15	Y#3	VGND#7	6.63204e-17
C16	Y#6	C#4	4.01885e-18
C17	Y#6	C#3	9.27259e-18
C18	a_295_368##4	C#6	2.35152e-19
C19	Y#6	C#2	1.20488e-17
C20	a_295_368##4	C#4	3.47876e-19
C21	VGND#6	VGND#1	2.37016e-18
C22	a_295_368##4	C#3	2.17515e-19
C23	C#6	C#4	6.88713e-18
C24	Y#9	C#6	1.03997e-17
C25	Y#9	C#4	9.8635e-19
C26	VPWR#3	C#6	4.06584e-20
C27	VPWR#3	C#4	3.83612e-20
C28	VGND#4	C#12	1.78955e-19
C29	VPWR#3	C#3	2.15491e-20
C30	VGND#7	VGND#6	1.31479e-18
C31	C#6	C#3	2.43273e-19
C32	a_295_368##6	C#6	1.74443e-19
C33	VPWR#3	C#2	2.11935e-20
C34	VGND#3	C#12	2.71574e-18
C35	VGND#4	B#1	5.2065e-19
C36	VGND#3	B#1	2.7264e-18
C37	Y#9	B#2	4.0115e-19
C38	VGND#2	C#6	1.61111e-20
C39	VGND#2	C#4	4.70502e-21
C40	VGND#4	B#5	5.70982e-18
C41	VGND#2	C#3	6.34482e-20
C42	a_27_368##7	C#6	6.25797e-19
C43	VGND#2	C#2	1.98235e-19
C44	Y#2	Y#6	2.30583e-18
C45	VGND#5	VGND#7	1.26069e-18
C46	VGND#4	A#6	5.56191e-18
C47	a_27_368##7	C#4	2.6231e-19
C48	a_295_368##6	B#2	3.31379e-19
C49	VGND#4	A#5	3.1628e-18
C50	C#2	A#9	8.05045e-19
C51	Y#3	C#6	6.57262e-20
C52	Y#6	VGND#1	2.04404e-20
C53	VGND#4	VGND#3	1.21609e-18
C54	a_27_368##7	B#2	3.47198e-19
C55	a_27_368##2	VPWR#6	2.1489e-17
C56	C#4	C#2	1.24852e-18
C57	B#8	C#2	4.91936e-17
C58	B#2	C#6	6.65669e-19
C59	a_27_368##11	a_27_368##2	3.3048e-18
C60	Y#2	C#6	9.654e-19
C61	a_27_368##11	VPWR#6	2.43635e-17
C62	Y#3	C#10	9.0233e-19
C63	a_295_368#	VPWR#6	2.94655e-18
C64	Y#2	C#10	3.72065e-17
C65	a_27_368##2	a_27_368##5	9.29175e-21
C66	Y#3	C#12	2.102e-18
C67	C#3	C#2	2.52291e-19
C68	Y#3	C#2	6.42525e-19
C69	a_295_368#	a_27_368##11	2.57736e-17
C70	Y#2	C#12	3.13533e-17
C71	Y#2	C#4	6.87601e-20
C72	Y#3	B#1	4.36807e-17
C73	a_27_368##5	a_27_368##11	3.3048e-18
C74	Y#2	B#1	8.45626e-19
C75	Y#2	C#3	1.31671e-18
C76	a_295_368#	a_27_368##5	3.94292e-17
C77	Y#3	B#5	3.1046e-17
C78	Y#3	B#2	9.03504e-18
C79	C#10	VGND#1	2.31328e-17
C80	Y#2	C#2	2.57115e-17
C81	C#10	C#2	3.40136e-18
C82	a_27_368##4	A#10	1.31143e-17
C83	Y#3	A#6	5.44109e-19
C84	B#3	B#2	2.36351e-17
C85	C#10	Y#1	1.4951e-17
C86	a_27_368##5	a_295_368##2	8.36457e-17
C87	Y#6	a_295_368#	4.64145e-19
C88	VGND#1	C#12	7.65002e-19
C89	VGND#6	C#10	1.29819e-18
C90	a_27_368##4	B#6	1.48612e-17
C91	a_27_368##5	Y#6	2.80703e-18
C92	C#12	Y#1	1.4951e-17
C93	A#3	C#6	1.22289e-19
C94	VGND#1	B#1	1.94209e-19
C95	C#12	VGND#6	2.36145e-17
C96	a_295_368##2	Y#6	1.93999e-18
C97	a_27_368##5	a_295_368##4	4.96331e-17
C98	VGND#5	a_27_368#	9.75842e-18
C99	B#1	C#6	6.44324e-19
C100	B#1	VGND#6	2.55415e-17
C101	A#3	B#2	3.38356e-17
C102	A#4	A#3	4.43508e-18
C103	VGND#7	C#12	1.09125e-19
C104	B#1	Y#8	1.49295e-17
C105	Y#6	a_295_368##4	1.80049e-18
C106	VGND#6	B#5	7.57597e-19
C107	VGND#7	B#1	2.36947e-19
C108	B#5	Y#8	1.49295e-17
C109	VGND#6	A#6	2.88895e-19
C110	B#5	VGND#7	2.00189e-17
C111	a_295_368##4	Y#9	1.1383e-18
C112	A#6	VGND#7	2.32409e-17
C113	VGND#5	B#5	2.6562e-19
C114	a_295_368##6	Y#9	9.9305e-19
C115	A#6	Y#4	1.53228e-17
C116	a_27_368##7	a_295_368##4	4.99088e-17
C117	VGND#7	A#5	4.67336e-19
C118	VGND#5	A#6	1.30151e-18
C119	a_27_368##7	Y#9	2.45618e-18
C120	A#5	Y#4	1.57978e-17
C121	a_27_368##7	a_295_368##6	8.13945e-17
C122	VGND#5	A#5	2.67762e-17
C123	VPWR#7	a_295_368##6	3.38491e-18
C124	a_27_368##7	VPWR#7	4.06489e-17
C125	a_27_368#	a_27_368##7	3.20053e-18
C126	a_27_368##2	A#8	4.24325e-17
C127	a_27_368#	VPWR#7	2.2178e-17
C128	VPWR#6	A#8	3.01712e-17
C129	a_27_368##2	A#10	2.50996e-18
C130	a_27_368##11	A#8	1.2145e-18
C131	VGND#1	C#4	8.34477e-21
C132	a_295_368##6	B#1	1.07058e-19
C133	VPWR#6	A#10	3.59984e-17
C134	A#6	B#2	6.71775e-18
C135	Y#3	C#7	9.40375e-19
C136	a_27_368##2	B#6	6.23067e-19
C137	a_27_368##7	B#1	1.73041e-19
C138	A#10	a_27_368##11	2.42966e-17
C139	VGND#1	C#3	1.2901e-18
C140	VPWR#6	B#6	1.83684e-18
C141	a_295_368#	A#10	1.45806e-18
C142	B	C#6	1.94999e-17
C143	a_27_368##2	B#10	2.07391e-19
C144	B#6	a_27_368##11	2.66964e-17
C145	B	C#4	1.18766e-17
C146	VGND#2	VGND#4	4.7481e-17
C147	a_27_368##5	A#10	2.82938e-19
C148	B	C#3	9.70954e-18
C149	C#12	C#10	4.37646e-17
C150	VGND#3	C#6	2.4238e-20
C151	VPWR#6	B#10	2.59347e-19
C152	B	C#2	9.00674e-19
C153	VGND#2	VGND#3	4.17061e-17
C154	a_295_368#	B#6	3.71011e-17
C155	a_27_368##2	B#9	1.41217e-19
C156	a_27_368##11	B#10	5.85975e-19
C157	B	A#4	2.01171e-19
C158	a_27_368##5	B#6	1.22892e-18
C159	VPWR#6	B#9	7.04347e-20
C160	Y#6	A#10	1.3741e-18
C161	a_295_368#	B#10	4.31299e-17
C162	B#1	C#12	2.52106e-17
C163	a_27_368##11	B#9	2.52763e-19
C164	a_27_368##5	B#10	3.67224e-17
C165	Y#6	B#6	1.09647e-17
C166	VGND#6	C#6	5.85919e-19
C167	VPWR#6	C#8	4.44543e-20
C168	a_295_368#	B#9	1.25116e-18
C169	VGND#6	C#7	8.30354e-19
C170	a_27_368##5	B#9	4.53384e-17
C171	Y#6	B#10	1.64254e-17
C172	B#5	B#1	3.59454e-17
C173	a_295_368#	C#8	5.89907e-19
C174	a_295_368##2	B#9	3.93016e-17
C175	VGND#4	Y#3	8.7079e-18
C176	a_27_368##5	C#8	1.63342e-17
C177	Y#6	B#9	1.92391e-17
C178	a_295_368#	C#9	2.79317e-19
C179	a_295_368##2	C#8	4.90296e-17
C180	A#6	B#5	2.11411e-17
C181	A#9	a_27_368##4	7.19448e-17
C182	a_27_368##5	C#9	1.56219e-17
C183	Y#6	C#8	3.53657e-17
C184	VGND#3	Y#3	8.73271e-18
C185	a_27_368##5	C#11	3.93577e-19
C186	Y#6	C#9	4.28379e-17
C187	A#5	A#6	3.61532e-17
C188	a_27_368##4	B#8	1.64326e-19
C189	A	C#6	9.93169e-19
C190	a_295_368##4	C#9	4.75835e-17
C191	A	C#4	8.81152e-19
C192	A	C#3	5.26433e-19
C193	VGND#2	Y#2	1.26566e-17
C194	VGND#4	B#2	6.85597e-20
C195	VGND#3	Y#2	8.63153e-18
C196	A	C#2	5.17746e-19
C197	A	B#2	3.2468e-18
C198	a_295_368##4	C#11	4.75789e-17
C199	a_27_368##4	C#1	1.72061e-19
C200	Y#9	C#11	4.30093e-17
C201	a_27_368##7	C#9	6.1785e-19
C202	VGND#4	A#3	9.13589e-20
C203	C#7	Y#9	3.09141e-17
C204	a_27_368##7	C#11	1.61459e-17
C205	a_295_368##6	C#7	4.35798e-17
C206	VGND#6	VGND#2	1.16044e-19
C207	VPWR#7	C#11	5.925e-20
C208	Y#2	B#8	1.2942e-16
C209	Y#9	B#4	9.474e-19
C210	a_27_368##7	C#7	1.79911e-17
C211	A#10	A#8	4.61857e-17
C212	B#4	a_295_368##6	2.92827e-17
C213	VGND#3	B#2	6.12752e-20
C214	VPWR#7	C#7	4.5661e-19
C215	Y#9	A#1	2.01002e-19
C216	a_27_368##7	B#4	5.73635e-17
C217	C#1	Y#2	1.29774e-16
C218	a_27_368#	C#7	9.75068e-20
C219	VGND#2	VGND#5	2.51873e-17
C220	a_295_368##6	A#1	7.12278e-19
C221	VPWR#7	B#4	2.08201e-18
C222	a_295_368#	VPWR#3	5.02918e-18
C223	B#6	A#10	5.14077e-17
C224	a_27_368##7	A#1	3.38991e-17
C225	a_27_368#	B#4	3.38607e-19
C226	Y#3	B#3	5.49073e-17
C227	VPWR#7	A#1	3.70904e-17
C228	a_295_368##2	VPWR#3	7.41017e-17
C229	B#1	C#7	7.77236e-18
C230	VGND#1	C#1	2.55206e-17
C231	A#9	a_27_368##2	4.66824e-17
C232	a_27_368##7	A#7	7.74846e-19
C233	a_27_368#	A#1	2.01344e-18
C234	B#10	B#6	4.94301e-17
C235	A#9	VPWR#6	3.24467e-18
C236	VPWR#7	A#7	3.09378e-17
C237	VGND#6	C#1	2.57349e-19
C238	a_295_368##4	VPWR#3	8.45914e-17
C239	A#9	a_27_368##11	4.80738e-18
C240	a_27_368#	A#7	3.80441e-17
C241	A#9	a_295_368#	1.16527e-18
C242	a_295_368##6	VPWR#3	1.65115e-17
C243	A#9	a_27_368##5	7.35181e-17
C244	B#9	B#10	4.87295e-17
C245	A#9	a_295_368##2	2.39024e-18
C246	a_295_368#	B#8	3.40571e-19
C247	Y#6	A#9	1.53261e-16
C248	a_27_368##5	B#8	5.30562e-19
C249	C#8	B#9	2.55164e-17
C250	Y#6	B#8	1.78595e-16
C251	a_27_368##5	C#1	3.20307e-19
C252	VGND#7	B#2	8.59013e-19
C253	VGND#2	C#10	5.38634e-18
C254	C#9	C#8	2.58152e-17
C255	C#1	Y#6	2.73898e-17
C256	VGND#2	C#12	5.65631e-19
C257	VGND#2	B#1	8.43559e-20
C258	C#11	C#9	2.45924e-17
C259	VGND#4	VGND#6	2.36461e-19
C260	B#3	a_295_368##6	1.44619e-18
C261	C#7	C#11	2.58684e-17
C262	Y#3	B	2.55441e-17
C263	C#10	C#1	7.8004e-18
C264	Y#2	B	1.12533e-16
C265	A#3	Y#9	2.89328e-18
C266	B#4	C#7	2.54985e-17
C267	a_27_368##7	A#3	2.17299e-19
C268	A#9	A#8	1.14628e-17
C269	A#3	VPWR#7	1.25684e-18
C270	VPWR#3	B#9	4.46645e-18
C271	A#9	A#10	1.54882e-17
C272	a_27_368#	A#3	4.50292e-19
C273	B#3	B#1	2.06151e-18
C274	VPWR#3	C#8	4.43515e-18
C275	A#9	B#6	3.05617e-17
C276	A#1	B#4	4.62253e-17
C277	C#6	VNB	3.82809e-17
C278	C#4	VNB	2.12634e-17
C279	VGND#4	Y	1.7053e-17
C280	C#3	VNB	2.20823e-17
C281	VPWR#3	C#9	4.48045e-18
C282	C#2	B#9	2.07162e-18
C283	A#9	B#10	1.32303e-17
C284	C#2	VNB	6.2872e-17
C285	B#2	VNB	4.9244e-17
C286	A#4	VNB	3.68158e-17
C287	B#8	B#6	6.22649e-18
C288	A#9	B#9	1.70318e-17
C289	VPWR#3	C#11	4.49137e-18
C290	A#7	A#1	4.62507e-17
C291	A#9	C#8	1.70566e-19
C292	VPWR#3	C#7	4.26715e-21
C293	Y#3	A	3.47978e-18
C294	B	Y#6	4.9712e-17
C295	B	Y#9	5.3231e-17
C296	Y	Y#3	3.58899e-18
C297	VPWR	a_27_368##4	5.44833e-18
C298	B	C#10	1.03967e-17
C299	B	C#12	1.08061e-17
C300	A	a_27_368##5	9.55306e-17
C301	B#3	C#7	4.75051e-18
C302	B	B#1	8.08528e-18
C303	VGND	VGND#4	4.88357e-17
C304	Y	VGND#7	5.75594e-17
C305	A	a_295_368##2	2.38058e-18
C306	VGND	VGND#3	2.43679e-17
C307	A#3	C#11	4.25944e-20
C308	Y	Y#4	5.29708e-19
C309	A	Y#6	1.01257e-16
C310	VGND#5	Y	7.17533e-17
C311	A	a_295_368##4	1.87982e-18
C312	B	A#6	1.98246e-19
C313	A#3	C#7	2.44145e-19
C314	A	Y#9	7.09311e-17
C315	B	A#5	5.32511e-19
C316	VGND#2	A#9	3.6726e-17
C317	VPWR#3	B#8	1.91393e-20
C318	A	a_295_368##6	7.38532e-18
C319	VGND#5	VGND#4	1.35842e-18
C320	A#3	B#4	9.23495e-19
C321	A	a_27_368##7	1.7751e-16
C322	A	VPWR#7	9.76924e-19
C323	A#3	A#1	9.23978e-19
C324	a_27_368#	A	3.91236e-17
C325	A#3	A#7	2.0869e-18
C326	B#8	A#9	2.47426e-17
C327	VGND#2	C#1	9.95126e-17
C328	VGND	Y#3	1.91117e-17
C329	VPWR	a_27_368##2	2.48287e-18
C330	A	B#1	1.91983e-18
C331	VGND	Y#2	3.47545e-17
C332	VPWR	VPWR#6	1.60306e-17
C333	C#1	A#9	3.66492e-17
C334	VPWR	a_27_368##11	1.08226e-17
C335	VGND#4	VNB	3.91628e-17
C336	VGND#3	VNB	3.18963e-17
C337	VPWR	a_295_368#	2.14134e-17
C338	VPWR	a_27_368##5	2.29862e-17
C339	Y	a_27_368#	1.76088e-18
C340	C#1	B#8	3.18878e-17
C341	VPWR	a_295_368##2	2.73122e-17
C342	VPWR	Y#6	9.81872e-18
C343	VGND	VGND#6	1.62337e-17
C344	VPWR	a_295_368##4	3.19038e-17
C345	VPWR	Y#9	3.84446e-18
C346	A	A#10	4.35015e-19
C347	Y	B#5	5.28942e-19
C348	B	C#7	9.51939e-18
C349	VPWR	a_295_368##6	2.25693e-17
C350	VGND	VGND#5	3.2997e-17
C351	VPWR	a_27_368##7	3.24475e-17
C352	Y	A#6	4.41161e-17
C353	A	B#6	6.20439e-19
C354	VGND	a_27_368##2	8.19308e-18
C355	VPWR	VPWR#7	1.61471e-17
C356	Y	A#5	3.21574e-17
C357	A	B#10	1.09758e-18
C358	VPWR	a_27_368#	2.41548e-18
C359	A	B#9	3.21464e-18
C360	Y#3	VNB	5.32776e-18
C361	Y#2	VNB	2.53035e-17
C362	A	C#8	2.25067e-17
C363	VGND	Y#6	9.94523e-18
C364	A	C#9	1.6862e-17
C365	A#3	B#3	2.34756e-17
C366	VGND#1	VNB	4.63427e-18
C367	VGND	Y#9	3.36131e-18
C368	A	C#11	1.67693e-17
C369	VGND#6	VNB	3.64461e-18
C370	A	C#7	2.88147e-17
C371	VGND#7	VNB	2.02996e-18
C372	A	B#4	2.34905e-17
C373	VGND	a_27_368#	2.97937e-18
C374	VPWR	A#8	1.64379e-18
C375	VGND#5	VNB	7.01643e-17
C376	a_27_368##2	VNB	5.0278e-17
C377	VGND	C#10	2.68552e-19
C378	VPWR	A#10	1.00765e-18
C379	A	A#1	1.57339e-17
C380	VPWR#6	VNB	2.29644e-18
C381	VGND	C#12	1.4793e-19
C382	a_27_368##11	VNB	4.98402e-18
C383	VPWR	B#6	1.92447e-18
C384	VGND	B#1	1.72355e-19
C385	a_295_368#	VNB	3.95646e-18
C386	A	A#7	8.93479e-18
C387	VPWR	B#10	1.53843e-18
C388	VGND	B#5	2.49878e-19
C389	VGND#2	C	8.6151e-18
C390	a_295_368##2	VNB	2.49313e-18
C391	VGND	A#6	1.04683e-19
C392	VPWR	B#9	1.68559e-18
C393	Y#6	VNB	1.58643e-17
C394	VGND	A#5	4.89666e-18
C395	C	A#9	5.24354e-17
C396	a_295_368##4	VNB	3.8104e-18
C397	VPWR	C#8	1.60621e-18
C398	Y#9	VNB	6.38905e-19
C399	VPWR	C#9	1.59814e-18
C400	a_295_368##6	VNB	2.62362e-18
C401	a_27_368##7	VNB	2.21429e-18
C402	VPWR	C#11	1.58011e-18
C403	VPWR#7	VNB	2.15161e-18
C404	a_27_368#	VNB	4.09044e-17
C405	VPWR	C#7	1.49814e-18
C406	C#10	VNB	3.55302e-17
C407	B	A#3	2.24678e-19
C408	VPWR	B#4	1.46317e-19
C409	C#12	VNB	3.23672e-17
C410	B#1	VNB	3.80623e-17
C411	VPWR	A#1	1.02684e-18
C412	B#5	VNB	2.54297e-17
C413	A#6	VNB	2.83897e-17
C414	VPWR	A#7	1.81525e-18
C415	A	C#1	9.48674e-20
C416	A#5	VNB	3.53923e-17
C417	B#3	A	3.31261e-17
C418	A#8	VNB	3.6914e-17
C419	VPWR	VPWR#3	4.62889e-17
C420	A#10	VNB	2.72898e-17
C421	B#6	VNB	3.96409e-17
C422	B#10	VNB	3.51479e-17
C423	VPWR	A#9	1.29628e-17
C424	B#9	VNB	3.6947e-17
C425	C#8	VNB	3.37667e-17
C426	C#9	VNB	3.3429e-17
C427	Y	A#3	4.90447e-17
C428	C#11	VNB	3.36543e-17
C429	C#7	VNB	5.49485e-17
C430	VGND	VGND#2	1.14548e-16
C431	VPWR	B#3	3.14766e-18
C432	B#4	VNB	3.11988e-17
C433	VGND	A#9	2.92674e-17
C434	A#1	VNB	2.75428e-17
C435	VGND	B#8	1.18219e-17
C436	A#7	VNB	3.98059e-17
C437	B	A	5.74188e-18
C438	Y#3	Y#2	2.65318e-18
C439	VGND	C#1	6.93315e-17
C440	VPWR#3	VNB	3.47049e-16
C441	VGND	B#3	2.56701e-18
C442	VGND#2	VNB	4.00588e-16
C443	VGND	A#3	3.662e-18
C444	A#9	VNB	2.37497e-16
C445	B#8	VNB	1.03521e-16
C446	C#1	VNB	1.56997e-16
C447	VPWR	B	7.0018e-18
C448	B#3	VNB	3.31754e-18
C449	Y	A	3.48115e-18
C450	A#3	VNB	4.95052e-17
C451	VGND	B	9.16198e-18
C452	VPWR	A	2.2517e-17
C453	VGND	C	7.44652e-18
C454	VGND	A	3.02115e-18
C455	B	VNB	1.80063e-17
C456	C	VNB	6.85847e-18
C457	VGND	Y	1.6848e-17
C458	Y	VNB	7.98611e-18
C459	VPWR	VNB	8.37013e-17
C460	VGND	VNB	7.79278e-17
C461	VPWR#3	VPWR#4	8.7176e-17
C462	a_27_368##3	A#8	6.59666e-18
C463	VPWR#4	A#7	1.7905e-18
C464	a_27_368##10	a_27_368#	2.96324e-18
C465	a_27_368##3	VNB	1.46543e-17
C466	a_27_368#	VPWR#4	5.84607e-19
C467	VPWR#2	B#8	6.89013e-20
C468	VPWR#4	B#4	5.18652e-18
C469	a_27_368##3	VPWR#2	1.75927e-17
C470	a_27_368##7	VPWR#4	1.60983e-17
C471	VPWR#6	a_27_368##3	1.77329e-17
C472	VPWR	a_27_368##10	1.30524e-17
C473	VPWR#2	B#6	5.04674e-18
C474	VPWR#2	A#8	1.79107e-18
C475	a_27_368##10	VNB	1.50216e-17
C476	a_27_368##11	VPWR#2	1.12955e-17
C477	a_27_368##2	VPWR#2	6.06352e-19
C478	a_27_368##10	A#7	6.83915e-18
C479	VPWR#2	VNB	7.33348e-17
C480	VPWR	VPWR#2	5.15246e-17
C481	VPWR#4	B#1	3.54681e-20
C482	a_27_368##10	VPWR#7	1.8591e-17
C483	VPWR#4	VNB	7.46702e-17
C484	VPWR#4	B#2	4.62982e-20
C485	VPWR#4	A#1	1.79279e-18
C486	a_27_368##3	a_27_368##2	2.76195e-18
C487	VPWR	VPWR#4	5.27142e-17
C488	VPWR#3	VPWR#2	8.70355e-17
C489	a_27_368##10	VPWR#4	1.73395e-17
C490	VPWR#4	C#7	4.49037e-18
C491	a_27_368##4	VPWR#2	1.85725e-18
C492	a_295_368##6	VPWR#4	4.00666e-17
C493	VPWR#2	B#10	4.46645e-18
C494	VPWR#2	A#10	1.78751e-18
C495	VPWR	a_27_368##3	1.41235e-17
C496	a_295_368#	VPWR#2	4.54387e-17
*
*
.ENDS sky130_fd_sc_hs__nor3_4
*
