* Extracted by Quantus, converted by sky130cad/quantus.py
*
*
*
*                       LINUX           Wed Nov 18 08:50:51 2026
*
*
*
*  PROGRAM  advgen
*
*  Name           : advgen - Quantus - (64-bit)
*  Version        : 25.1.0-p047
*  Build Date     : Thu Dec 11 23:20:30 PST 2025
*
*  HSPICE LIBRARY
*
*  OPERATING_TEMPERATURE 150
*  QRC_TECH_DIR <path>/tech
*
*
*

*
.SUBCKT sky130_fd_sc_hs__nor3b_4 VNB VPB VGND VPWR Y A C_N B
*
*
*  caps2d version: 10
*
*
*       TRANSISTOR CARDS
*
*
XM2 VGND#11 B#11 Y#7 VNB sky130_fd_pr__nfet_01v8_lvt l=0.15 w=0.74 ad=0.2442 as=0.2257 pd=2.14 ps=2.09
XM5 VGND#14 B#9 Y#7 VNB sky130_fd_pr__nfet_01v8_lvt l=0.15 w=0.74 ad=0.3108 as=0.2257 pd=2.32 ps=2.09
XM10 Y#14 B#7 VGND#14 VNB sky130_fd_pr__nfet_01v8_lvt l=0.15 w=0.74 ad=0.2072 as=0.3108 pd=2.04 ps=2.32
XM21 Y#14 B#1 VGND#13 VNB sky130_fd_pr__nfet_01v8_lvt l=0.15 w=0.74 ad=0.2072 as=0.259 pd=2.04 ps=2.18
XM0 Y#10 a_468_264##13 VGND#13 VNB sky130_fd_pr__nfet_01v8_lvt l=0.15 w=0.74 ad=0.2072 as=0.259 pd=2.04 ps=2.18
XM3 VGND#12 a_468_264##11 Y#10 VNB sky130_fd_pr__nfet_01v8_lvt l=0.15 w=0.74 ad=0.259 as=0.2072 pd=2.18 ps=2.04
XM4 VGND#12 a_468_264##9 Y#9 VNB sky130_fd_pr__nfet_01v8_lvt l=0.15 w=0.74 ad=0.259 as=0.2072 pd=2.18 ps=2.04
XM11 Y#9 a_468_264# VGND#8 VNB sky130_fd_pr__nfet_01v8_lvt l=0.15 w=0.74 ad=0.2072 as=0.3108 pd=2.04 ps=2.32
XM14 Y#8 A#12 VGND#8 VNB sky130_fd_pr__nfet_01v8_lvt l=0.15 w=0.74 ad=0.2072 as=0.3108 pd=2.04 ps=2.32
XM16 VGND#7 A#10 Y#8 VNB sky130_fd_pr__nfet_01v8_lvt l=0.15 w=0.74 ad=0.407 as=0.2072 pd=2.58 ps=2.04
XM25 VGND#7 A#8 Y#1 VNB sky130_fd_pr__nfet_01v8_lvt l=0.15 w=0.74 ad=0.407 as=0.259 pd=2.58 ps=2.18
XM17 Y#1 A#6 VGND#6 VNB sky130_fd_pr__nfet_01v8_lvt l=0.15 w=0.74 ad=0.259 as=0.259 pd=2.18 ps=2.18
XM12 VGND#6 C_N#4 a_468_264##14 VNB sky130_fd_pr__nfet_01v8_lvt l=0.15 w=0.74 ad=0.259 as=0.6771 pd=2.18 ps=3.31
XM15 a_126_368##6 B#13 a_27_368##8 VPB sky130_fd_pr__pfet_01v8 l=0.15 w=1.12 ad=0.336 as=0.3864 pd=2.84 ps=2.93
XM9 a_126_368##6 B#12 a_27_368##7 VPB sky130_fd_pr__pfet_01v8 l=0.15 w=1.12 ad=0.336 as=0.336 pd=2.84 ps=2.84
XM18 a_27_368##7 B#8 a_126_368##4 VPB sky130_fd_pr__pfet_01v8 l=0.15 w=1.12 ad=0.336 as=0.42 pd=2.84 ps=2.99
XM23 a_27_368##4 B#6 a_126_368##4 VPB sky130_fd_pr__pfet_01v8 l=0.15 w=1.12 ad=0.336 as=0.42 pd=2.84 ps=2.99
XM8 a_27_368##4 a_468_264##7 Y#11 VPB sky130_fd_pr__pfet_01v8 l=0.15 w=1.12 ad=0.336 as=0.336 pd=2.84 ps=2.84
XM20 Y#11 a_468_264##12 a_27_368##2 VPB sky130_fd_pr__pfet_01v8 l=0.15 w=1.12 ad=0.336 as=0.336 pd=2.84 ps=2.84
XM22 Y#13 a_468_264##10 a_27_368##2 VPB sky130_fd_pr__pfet_01v8 l=0.15 w=1.12 ad=0.336 as=0.336 pd=2.84 ps=2.84
XM7 a_27_368# a_468_264##8 Y#13 VPB sky130_fd_pr__pfet_01v8 l=0.15 w=1.12 ad=0.3304 as=0.336 pd=2.83 ps=2.84
XM1 a_126_368##2 A#13 VPWR#8 VPB sky130_fd_pr__pfet_01v8 l=0.15 w=1.12 ad=0.336 as=0.3304 pd=2.84 ps=2.83
XM13 VPWR#6 A#11 a_126_368##2 VPB sky130_fd_pr__pfet_01v8 l=0.15 w=1.12 ad=0.336 as=0.336 pd=2.84 ps=2.84
XM24 VPWR#6 A#7 a_126_368# VPB sky130_fd_pr__pfet_01v8 l=0.15 w=1.12 ad=0.336 as=0.336 pd=2.84 ps=2.84
XM26 a_126_368# A#1 VPWR#4 VPB sky130_fd_pr__pfet_01v8 l=0.15 w=1.12 ad=0.336 as=0.462 pd=2.84 ps=3.11
XM19 a_468_264##18 C_N#5 VPWR#4 VPB sky130_fd_pr__pfet_01v8 l=0.15 w=0.84 ad=0.252 as=0.462 pd=2.28 ps=3.11
XM6 VPWR#1 C_N#1 a_468_264##18 VPB sky130_fd_pr__pfet_01v8 l=0.15 w=0.84 ad=0.2478 as=0.252 pd=2.27 ps=2.28
*
*
*       RESISTOR AND CAP/DIODE CARDS
*
Rg1	B#1	B#2	397.555725
Rg2	B#2	B#3	56.789066
Rg3	B#3	B#4	21.384537
Rg4	B#4	B#5	58.191574
Rg5	B#2	B#6	449.655212
Rg6	B#3	B#7	391.786469
Rg7	B#4	B#8	419.554810
Rg8	B#5	B#9	378.670319
Rg9	B#5	B#10	90.033310
Rg10	B#10	B#11	397.555725
Rg11	B#5	B#12	429.126801
Rg12	B#10	B#13	449.655212
Rg13	a_468_264#	a_468_264##2	375.418884
Rg14	a_468_264##2	a_468_264##3	43.823471
Rg15	a_468_264##3	a_468_264##4	33.307503
Rg16	a_468_264##4	a_468_264##5	63.728664
Rg17	a_468_264##5	a_468_264##6	66.386436
Rg18	a_468_264##6	a_468_264##7	468.193665
Rg19	a_468_264##2	a_468_264##8	463.819061
Rg20	a_468_264##3	a_468_264##9	390.565155
Rg21	a_468_264##4	a_468_264##10	442.451355
Rg22	a_468_264##5	a_468_264##11	380.374634
Rg23	a_468_264##5	a_468_264##12	462.815369
Rg24	a_468_264##6	a_468_264##13	400.923340
Rg25	A#1	A#2	498.757477
Rg26	A#2	A#3	53.346508
Rg27	A#3	A#4	29.518005
Rg28	A#4	A#5	47.783939
Rg29	A#2	A#6	351.578949
Rg30	A#3	A#7	395.076172
Rg31	A#4	A#8	302.809296
Rg32	A#5	A#9	81.189171
Rg33	A#9	A#10	404.697784
Rg34	A#5	A#11	486.547119
Rg35	A#9	A#12	373.502258
Rg36	A#9	A#13	493.646362
Rg37	C_N#1	C_N#2	346.149445
Rg38	C_N#2	C_N#3	24.087767
Rg39	C_N#3	C_N#4	365.290985
Rg40	C_N#3	C_N#5	307.245483
Rf1	B	B#14	1.833616
Rf2	B#14	B	12.835315
Rf3	a_27_368#	a_27_368##3	69.629982
Rf4	a_27_368##3	a_27_368##5	61.393047
Rf5	a_27_368##5	a_27_368##6	73.985306
Rf6	a_27_368##6	a_27_368##7	28.306047
Rf7	a_27_368##6	a_27_368##8	88.622383
Rf8	a_27_368##2	a_27_368##3	15.000000
Rf9	a_27_368##4	a_27_368##5	15.000000
Rf10	Y#1	Y#2	91.898216
Rf11	Y#2	Y#3	72.735176
Rf12	Y#3	Y#4	67.744217
Rf13	Y#4	Y#5	39.759983
Rf14	Y#5	Y#6	24.663881
Rf15	Y#6	Y#7	87.012566
Rf16	Y#2	Y#8	13.032116
Rf17	Y#3	Y#9	13.032116
Rf18	Y#4	Y#10	26.114532
Rf19	Y#5	Y	27.051138
Rf20	Y	Y#12	35.701805
Rf21	Y#12	Y#13	61.046436
Rf22	Y#6	Y#14	16.968842
Rf23	Y#11	Y#12	15.000000
Rf24	a_126_368#	a_126_368##3	96.985573
Rf25	a_126_368##3	a_126_368##5	234.285477
Rf26	a_126_368##5	a_126_368##6	84.416260
Rf27	a_126_368##2	a_126_368##3	5.000000
Rf28	a_126_368##4	a_126_368##5	7.500000
Rf29	A#5	A	78.732300
Rf30	C_N	C_N#2	163.775864
Rf31	a_468_264##15	a_468_264##16	110.037369
Rf32	a_468_264##16	a_468_264##4	284.584106
Rf33	a_468_264##15	a_468_264##14	20.282764
Rf34	a_468_264##16	a_468_264##18	25.136322
Rf35	a_468_264##14	a_468_264##15	7.500000
Rf36	VPWR#1	VPWR#2	46.318741
Rf37	VPWR#2	VPWR#3	57.320107
Rf38	VPWR#3	VPWR#4	34.939823
Rf39	VPWR#3	VPWR#5	69.348907
Rf40	VPWR#5	VPWR#6	30.747387
Rf41	VPWR#5	VPWR#7	65.696381
Rf42	VPWR#7	VPWR#8	34.704330
Rf43	VPWR#7	VPWR#9	88.001312
Rf44	VGND#1	VGND#2	67.912430
Rf45	VGND#2	VGND#3	77.708900
Rf46	VGND#3	VGND#4	77.708900
Rf47	VGND#4	VGND#5	56.954853
Rf48	VGND#2	VGND#6	32.518913
Rf49	VGND#3	VGND#7	27.329292
Rf50	VGND#4	VGND#8	32.539131
Rf51	VGND#5	VGND#9	81.682449
Rf52	VGND#9	VGND#10	73.001427
Rf53	VGND#10	VGND#11	104.232445
Rf54	VGND#5	VGND#12	40.564270
Rf55	VGND#9	VGND#13	37.066368
Rf56	VGND#10	VGND#14	38.247387
Rf57	B#5	B#14	40.058201
Re1	VPWR#2	VPWR	6.179563
Re2	VPWR	VPWR#9	0.882795
Re3	VGND#1	VGND	6.179563
Re4	VGND	VGND#5	0.882795
*
*       CAPACITOR CARDS
*
*
C1	VGND	VNB	2.7971e-16
C2	VPWR	VNB	2.95701e-16
C3	Y	VNB	9.29363e-19
C4	A	VNB	2.71483e-18
C5	C_N	VNB	3.1506e-18
C6	B	VNB	4.28698e-17
C7	VPWR#1	C_N#1	3.63195e-17
C8	B#5	VNB	3.54442e-17
C9	a_468_264##4	VNB	8.65599e-17
C10	A#5	VNB	9.14002e-17
C11	VGND	Y	9.46501e-21
C12	VGND#5	VNB	3.2253e-17
C13	VPWR#9	VNB	1.29021e-16
C14	VGND	A	3.77644e-18
C15	VGND#1	VNB	1.32603e-16
C16	VPWR#2	VNB	1.25269e-16
C17	VPWR	Y	3.37922e-18
C18	B#13	VNB	4.12456e-17
C19	Y#7	VGND#14	5.52709e-17
C20	B#12	VNB	3.16809e-17
C21	B#8	VNB	3.20078e-17
C22	VGND	B	1.07168e-17
C23	VPWR	A	2.21261e-18
C24	B#6	VNB	3.39002e-17
C25	a_468_264##7	VNB	3.01696e-17
C26	a_468_264##12	VNB	2.98095e-17
C27	a_468_264##10	VNB	3.00532e-17
C28	a_468_264##8	VNB	3.64985e-17
C29	A#13	VNB	2.89052e-17
C30	A#11	VNB	3.14958e-17
C31	A#7	VNB	2.7026e-17
C32	VPWR	B	1.18141e-17
C33	A#1	VNB	3.75301e-17
C34	C_N#5	VNB	3.20337e-17
C35	C_N#1	VNB	6.25001e-17
C36	B#11	VNB	3.71316e-17
C37	B#9	VNB	2.95405e-17
C38	B#7	VNB	2.8962e-17
C39	B#1	VNB	2.79865e-17
C40	B	Y	2.67732e-17
C41	a_468_264##13	VNB	2.69134e-17
C42	a_468_264##11	VNB	2.54322e-17
C43	A	C_N	3.33698e-17
C44	VGND	a_468_264##4	1.35025e-17
C45	a_468_264##9	VNB	2.70702e-17
C46	a_468_264#	VNB	2.8705e-17
C47	A#12	VNB	5.25639e-17
C48	VGND	A#5	1.16575e-17
C49	A#10	VNB	2.67174e-17
C50	A#8	VNB	2.62968e-17
C51	A#6	VNB	2.60285e-17
C52	C_N#4	VNB	3.30476e-17
C53	a_27_368##8	VNB	5.48261e-17
C54	VGND	VGND#5	8.13423e-17
C55	Y#5	B#10	1.52652e-19
C56	a_126_368##4	VNB	2.45366e-19
C57	a_27_368##4	VNB	3.66888e-18
C58	Y#11	VNB	4.47318e-19
C59	VPWR	a_468_264##4	1.69203e-17
C60	VGND#4	A#12	2.76737e-18
C61	Y#13	VNB	5.05809e-19
C62	VGND	VGND#1	5.36819e-19
C63	a_27_368#	VNB	4.32618e-18
C64	VPWR#8	VNB	5.86384e-18
C65	a_126_368##2	VNB	1.06963e-17
C66	VPWR	A#5	9.12395e-18
C67	VPWR#6	VNB	3.3993e-19
C68	a_126_368#	VNB	2.444e-18
C69	VPWR#4	VNB	7.83374e-18
C70	VGND#11	VGND#10	1.46984e-18
C71	a_468_264##18	VNB	3.92829e-18
C72	VPWR#1	VNB	4.05322e-17
C73	VGND#11	VNB	7.18258e-17
C74	Y#7	VNB	3.56913e-18
C75	VGND#14	VNB	2.04021e-18
C76	Y#14	VNB	1.96561e-18
C77	VGND#13	VNB	4.11852e-19
C78	Y	a_468_264##4	1.47475e-17
C79	Y#10	VNB	4.54572e-18
C80	VGND#12	VNB	4.09641e-19
C81	VPWR	VPWR#9	2.21117e-16
C82	VGND#8	VNB	3.95836e-18
C83	VGND#7	VNB	5.91068e-18
C84	Y#1	VNB	2.60821e-18
C85	VGND#6	VNB	1.69714e-18
C86	a_468_264##14	VNB	6.29216e-17
C87	a_27_368##8	B#10	8.58444e-20
C88	a_27_368##6	VNB	4.27116e-18
C89	Y#2	VNB	1.94665e-18
C90	VGND#10	Y#6	2.25448e-19
C91	Y#3	VNB	2.81434e-18
C92	A#6	C_N#4	2.84495e-17
C93	Y#4	VNB	4.14207e-19
C94	Y#5	VNB	8.57851e-19
C95	VPWR	B#13	2.46614e-18
C96	Y#6	VNB	1.29628e-18
C97	Y#7	Y#14	2.66619e-18
C98	VPWR	B#12	1.64174e-18
C99	a_468_264##16	VNB	2.02141e-17
C100	VPWR	B#8	1.64689e-18
C101	VPWR#3	VNB	2.74339e-17
C102	VPWR#5	VNB	2.78536e-17
C103	VPWR#7	VNB	3.64464e-17
C104	B#5	B#4	3.04815e-18
C105	VPWR	B#6	1.60152e-18
C106	VGND#2	VNB	2.75698e-17
C107	VGND#3	VNB	3.44617e-17
C108	VGND#4	VNB	2.83494e-17
C109	VGND#9	VNB	2.86678e-17
C110	B	B#5	2.16559e-17
C111	VGND#10	VNB	3.78116e-17
C112	VPWR	a_468_264##7	5.67406e-19
C113	a_468_264##16	C_N#3	1.68128e-17
C114	C_N	A#5	1.49399e-18
C115	VPWR	a_468_264##12	3.59467e-19
C116	Y	B#13	5.35549e-19
C117	VGND	B#11	7.07916e-19
C118	VPWR	a_468_264##10	2.86985e-19
C119	B#10	B#5	3.78489e-18
C120	VGND#3	A#10	2.73301e-18
C121	VGND	B#9	9.41717e-20
C122	Y	B#12	5.53113e-19
C123	VPWR	a_468_264##8	7.91783e-19
C124	VGND	B#7	1.71792e-19
C125	VGND	B#1	4.98646e-19
C126	VPWR	A#13	9.60185e-19
C127	Y	B#8	1.41557e-18
C128	VGND	a_468_264##13	1.85615e-18
C129	VPWR	A#11	1.05156e-18
C130	Y	B#6	8.75724e-18
C131	a_126_368##2	A#9	6.71165e-19
C132	VGND	a_468_264##11	7.22712e-19
C133	Y#4	a_468_264##5	2.60918e-18
C134	VPWR	A#7	7.39369e-19
C135	VGND	a_468_264##9	1.67432e-19
C136	Y	a_468_264##7	1.5694e-19
C137	Y#6	a_126_368##4	2.75786e-18
C138	VGND	a_468_264#	1.15311e-19
C139	VPWR	A#1	1.69286e-18
C140	VGND#1	C_N	4.09438e-18
C141	VGND	A#12	1.67765e-18
C142	Y	a_468_264##12	2.59106e-20
C143	VPWR	C_N#5	1.29353e-18
C144	VGND	A#10	4.81981e-20
C145	VPWR#2	C_N	2.28307e-18
C146	Y	a_468_264##10	1.35273e-20
C147	VGND	A#8	4.71108e-21
C148	VGND	A#6	3.23814e-19
C149	Y	a_468_264##8	8.15519e-21
C150	B#2	a_468_264##7	6.51725e-19
C151	VGND	C_N#4	2.77694e-18
C152	a_468_264##16	VPWR#3	1.17964e-18
C153	Y#6	B#4	3.43865e-18
C154	VGND#14	Y#14	4.526e-17
C155	VGND	Y#11	1.47339e-18
C156	VGND#10	Y#7	1.51132e-17
C157	VGND#11	B#11	2.96143e-17
C158	Y#2	A#9	3.27955e-18
C159	B	B#13	5.68124e-18
C160	B#2	VNB	2.48423e-17
C161	B#4	VNB	2.71092e-17
C162	B#10	VNB	3.89976e-17
C163	B	B#12	2.06457e-18
C164	a_468_264##5	VNB	2.58458e-17
C165	a_468_264##6	VNB	2.69632e-17
C166	A#9	VNB	2.84757e-17
C167	B	B#8	2.09144e-18
C168	C_N#3	VNB	4.04648e-17
C169	Y#4	Y#11	2.79423e-18
C170	VGND	VGND#11	6.95503e-17
C171	VPWR	a_27_368##8	2.64425e-17
C172	B	B#6	1.16685e-18
C173	VGND	Y#7	1.81762e-17
C174	VPWR	a_126_368##6	9.62595e-18
C175	VGND	Y#14	1.72013e-17
C176	a_468_264##4	A#5	1.12787e-16
C177	VPWR	a_126_368##4	1.97116e-17
C178	B#11	Y#7	4.24621e-17
C179	VGND	Y#10	1.17973e-17
C180	VGND#3	A#8	2.71842e-18
C181	Y#4	a_468_264##6	4.71666e-19
C182	VPWR	a_27_368##4	2.77442e-17
C183	VPWR	Y#11	3.55473e-18
C184	VGND	VGND#8	1.8194e-17
C185	VPWR	a_27_368##2	2.21797e-17
C186	VGND#14	VGND#13	1.31479e-18
C187	VGND	VGND#7	2.81024e-17
C188	VPWR	Y#13	3.30461e-18
C189	VGND	Y#1	1.89024e-17
C190	VPWR	a_27_368#	1.77882e-17
C191	VGND	VGND#6	2.21039e-17
C192	VPWR#9	B#5	3.61115e-20
C193	VGND	a_468_264##14	4.67615e-18
C194	VGND#5	a_468_264##4	8.50476e-20
C195	VPWR	a_126_368##2	2.50518e-17
C196	VGND#11	B#9	2.63796e-18
C197	VPWR	VPWR#6	2.21541e-17
C198	C_N	C_N#1	5.6807e-18
C199	VPWR	a_126_368#	1.65317e-17
C200	VGND#14	B#11	4.3031e-19
C201	Y#5	Y#11	2.33548e-18
C202	VPWR	VPWR#4	2.25487e-17
C203	VGND	Y#2	2.06019e-17
C204	VPWR#9	a_468_264##4	9.24236e-20
C205	a_468_264##4	B#2	4.90884e-18
C206	VGND	Y#3	1.97629e-17
C207	VGND	Y#4	2.83694e-18
C208	VGND	Y#5	4.06161e-18
C209	VGND	Y#6	1.70471e-18
C210	a_126_368##4	Y	4.40313e-17
C211	B#10	a_126_368##6	1.4151e-18
C212	VGND#2	A#6	3.76802e-18
C213	Y	a_27_368##4	1.44546e-18
C214	Y#7	B#9	5.89008e-17
C215	a_27_368##8	a_126_368##6	8.59923e-17
C216	VGND	a_468_264##16	4.30857e-18
C217	Y#14	VGND#13	4.26831e-17
C218	VGND	VGND#2	5.55271e-17
C219	VGND	VGND#3	6.44336e-17
C220	VGND	VGND#4	5.43451e-17
C221	VGND#9	Y#14	8.44746e-18
C222	VGND#11	B#7	2.8808e-19
C223	VPWR#7	a_468_264##7	3.16267e-20
C224	VGND	VGND#9	7.80402e-17
C225	VGND	VGND#10	8.87238e-17
C226	Y#5	a_468_264##5	2.71516e-19
C227	B#9	VGND#14	2.32203e-17
C228	VPWR	a_27_368##6	2.71695e-17
C229	a_27_368##8	a_27_368##7	3.78447e-18
C230	a_468_264##4	a_468_264##5	1.88884e-17
C231	Y#3	Y#2	2.65318e-18
C232	Y#7	B#7	7.44491e-19
C233	a_468_264##4	a_468_264##6	7.72127e-18
C234	Y#14	B#9	5.48995e-19
C235	a_468_264##4	a_468_264##7	1.08029e-20
C236	Y#14	Y#10	2.1935e-18
C237	VGND#2	C_N#4	4.68592e-18
C238	VGND#10	Y#14	8.48245e-18
C239	a_468_264##4	a_468_264##12	1.46652e-20
C240	VPWR	a_468_264##16	4.37667e-18
C241	a_126_368##6	a_27_368##7	4.64017e-17
C242	B#7	VGND#14	2.01716e-17
C243	VPWR	VPWR#3	4.55494e-17
C244	VPWR#8	A#12	7.77614e-19
C245	VPWR	VPWR#5	5.46052e-17
C246	a_468_264##4	a_468_264##10	2.7743e-20
C247	VGND#13	B#9	1.38225e-19
C248	VPWR	VPWR#7	8.68959e-17
C249	VPWR#9	B#13	4.46413e-18
C250	B	a_27_368##8	4.0333e-17
C251	Y#5	a_468_264##6	5.82986e-18
C252	VGND#9	B#2	3.53553e-20
C253	a_468_264##4	a_468_264##8	1.17775e-18
C254	VPWR#7	a_468_264##12	5.85706e-20
C255	a_468_264##4	A#9	1.28318e-17
C256	B	a_126_368##6	6.38636e-17
C257	VPWR#9	B#12	4.46413e-18
C258	a_468_264##4	A#13	1.01121e-17
C259	B	a_126_368##4	4.77161e-17
C260	Y#14	B#7	3.28717e-17
C261	VPWR#9	B#8	4.4526e-18
C262	VGND#2	a_468_264##16	2.57197e-20
C263	a_126_368##2	A#12	2.44835e-18
C264	a_468_264##4	A#11	1.65491e-17
C265	Y#5	Y	3.4774e-20
C266	a_126_368##6	a_126_368##4	3.45827e-18
C267	VGND#13	Y#10	3.92402e-17
C268	VPWR#5	VPWR#3	9.91908e-19
C269	VPWR#9	B#6	4.4526e-18
C270	VGND#14	B#1	2.36947e-19
C271	VGND#13	B#7	3.00133e-19
C272	A#11	A#5	2.45093e-18
C273	VGND#6	A	2.81501e-17
C274	VPWR#9	a_468_264##7	4.69659e-18
C275	B#2	a_126_368##4	1.37427e-18
C276	VGND#10	VGND#13	3.5061e-19
C277	VPWR#9	a_468_264##12	5.15837e-18
C278	a_126_368##4	a_27_368##7	3.99013e-17
C279	Y#14	B#1	3.78915e-17
C280	A#5	A#1	2.53667e-18
C281	C_N#1	a_468_264##14	1.68768e-17
C282	VPWR#9	a_468_264##10	5.15837e-18
C283	VPWR#7	a_468_264##10	1.72545e-19
C284	B#13	B#12	4.58488e-17
C285	VGND#13	VGND#12	2.1355e-18
C286	Y#4	Y#3	2.67535e-19
C287	VGND#9	Y#10	5.24783e-18
C288	VGND#14	a_468_264##13	1.0753e-19
C289	VPWR#9	a_468_264##8	5.15837e-18
C290	A#5	a_468_264##5	3.34113e-19
C291	VGND#11	B	2.87125e-17
C292	B#1	VGND#13	1.67271e-17
C293	Y#7	B	6.08775e-17
C294	A#5	a_468_264##6	2.31255e-19
C295	a_27_368##7	a_27_368##4	3.80816e-18
C296	B#12	B#8	4.71225e-17
C297	a_468_264##14	C_N	6.10555e-17
C298	Y#14	a_468_264##13	1.41841e-18
C299	A	a_468_264##16	3.72506e-17
C300	VGND	A#9	4.62697e-19
C301	Y#10	B#1	3.41401e-19
C302	VGND	C_N#3	6.51149e-20
C303	Y#10	VGND#12	3.9266e-17
C304	B#4	a_126_368##4	2.93117e-18
C305	VGND#10	B#2	6.2655e-21
C306	a_27_368##4	a_126_368##4	8.78793e-17
C307	A#5	A#9	2.09543e-17
C308	B#8	B#6	3.149e-17
C309	VGND#2	A	9.1294e-19
C310	VGND#13	a_468_264##13	3.628e-17
C311	VPWR#7	a_468_264##8	8.82229e-19
C312	A#5	C_N#3	2.11529e-17
C313	a_468_264##4	A#12	2.92297e-17
C314	Y#14	a_468_264##11	2.61005e-19
C315	VPWR#7	VPWR#5	1.12731e-18
C316	a_468_264##13	Y#10	1.742e-17
C317	a_126_368##4	Y#11	6.11363e-17
C318	B#6	a_468_264##7	4.60009e-17
C319	a_27_368##8	B#5	1.60243e-20
C320	a_27_368##4	B#2	7.32539e-20
C321	VPWR#2	A#1	1.09071e-18
C322	B#5	a_126_368##6	2.69476e-18
C323	C_N	a_468_264##16	3.84743e-17
C324	VGND#1	C_N#1	2.1252e-19
C325	VGND#13	a_468_264##11	1.24816e-18
C326	A#5	A#12	9.79996e-18
C327	B#5	a_27_368##7	1.63759e-18
C328	B#1	a_468_264##6	4.29467e-19
C329	VPWR#2	C_N#5	7.15231e-18
C330	VGND#12	a_468_264##13	1.24816e-18
C331	a_126_368##4	B#5	6.88525e-19
C332	B	Y#5	6.50367e-18
C333	VGND#5	a_468_264##13	5.56728e-19
C334	VPWR#2	C_N#1	6.73262e-18
C335	a_126_368##4	a_27_368##2	5.55366e-17
C336	a_468_264##7	a_468_264##12	4.91719e-17
C337	Y#11	a_27_368##4	3.65901e-19
C338	VPWR#7	A#13	4.91535e-18
C339	Y#6	B	5.2153e-17
C340	a_468_264##14	a_468_264##16	1.12842e-17
C341	VGND#5	a_468_264##11	4.98857e-18
C342	a_468_264##11	Y#10	1.41799e-17
C343	VGND#5	a_468_264##9	5.28869e-18
C344	a_126_368##4	a_468_264##4	4.56993e-19
C345	VGND#5	a_468_264#	4.52951e-19
C346	Y#13	a_126_368##4	1.8423e-17
C347	a_468_264##12	a_468_264##10	4.8212e-17
C348	VGND#12	a_468_264##11	3.20309e-17
C349	a_27_368##4	a_27_368##2	3.55703e-18
C350	a_27_368##4	B#4	7.75983e-20
C351	VPWR#4	C_N#3	6.70444e-19
C352	VGND#5	A#12	1.47776e-19
C353	a_468_264##4	Y#11	4.91105e-17
C354	VPWR#5	A#11	1.82888e-18
C355	a_468_264##16	A#7	6.3116e-18
C356	VPWR#7	A#9	3.61525e-20
C357	a_468_264##6	a_468_264##5	4.3254e-18
C358	a_468_264##4	a_27_368##2	2.9735e-18
C359	Y#10	a_468_264##9	3.41401e-19
C360	a_126_368##4	a_468_264##5	2.28497e-19
C361	VGND#10	B#4	2.94706e-20
C362	VGND#12	VGND#8	1.69044e-18
C363	a_468_264##4	Y#13	6.91442e-17
C364	VGND#7	VGND#2	4.81886e-19
C365	VPWR#7	A#11	5.89728e-19
C366	a_468_264##4	a_27_368#	1.81743e-18
C367	a_468_264##10	a_468_264##8	4.9032e-17
C368	a_27_368##2	Y#11	1.86559e-18
C369	a_468_264##4	VPWR#8	1.13623e-18
C370	a_468_264##9	VGND#12	1.67496e-17
C371	a_468_264##4	a_126_368##2	1.02039e-16
C372	VGND#8	a_468_264##11	2.84905e-19
C373	a_126_368##4	a_468_264##6	2.18733e-19
C374	a_468_264##4	VPWR#6	2.82172e-19
C375	a_468_264##16	A#1	2.18638e-17
C376	VPWR#5	A#7	1.25474e-18
C377	a_468_264##8	A#13	3.93694e-18
C378	Y#7	B#5	3.45993e-18
C379	a_468_264##9	Y#9	1.49295e-17
C380	VGND#14	B#5	1.46543e-18
C381	VGND#5	a_468_264##5	4.18903e-20
C382	VGND#10	B#10	4.76064e-20
C383	VGND#2	Y#1	9.14462e-18
C384	Y	B#2	5.95059e-18
C385	a_27_368##8	VPWR#9	5.56435e-17
C386	a_126_368##2	A#5	7.67997e-19
C387	VGND#12	a_468_264#	3.04646e-19
C388	Y	B#4	2.73815e-20
C389	VGND#7	A#9	9.41375e-20
C390	VPWR#6	A#5	5.845e-19
C391	VGND#8	a_468_264##9	7.57597e-19
C392	Y#13	a_27_368##2	1.89408e-18
C393	Y#7	B#10	1.98655e-18
C394	A#13	A#11	4.78805e-17
C395	Y	a_468_264##5	9.62395e-20
C396	a_126_368#	A#5	7.6479e-19
C397	VPWR#3	A#1	4.57287e-18
C398	Y	a_468_264##6	6.54105e-18
C399	a_468_264#	Y#9	1.49295e-17
C400	VGND#4	VGND#7	5.95012e-19
C401	C_N#3	a_468_264##18	1.01612e-18
C402	a_468_264##16	C_N#5	1.49337e-17
C403	a_27_368##4	VPWR#9	5.77456e-17
C404	VPWR#9	B#2	9.69029e-21
C405	VGND#12	A#12	1.40304e-19
C406	VGND#3	Y#1	8.75633e-18
C407	VPWR#8	Y#11	3.51054e-21
C408	a_27_368##2	a_27_368#	2.72376e-18
C409	a_468_264#	VGND#8	2.56998e-17
C410	A#11	A#7	4.66404e-17
C411	a_468_264##4	Y#10	2.53779e-18
C412	a_468_264##8	A#9	1.21487e-19
C413	a_468_264##4	VGND#12	5.3567e-18
C414	a_27_368##2	VPWR#9	2.29422e-17
C415	VPWR#9	B#4	2.36053e-20
C416	a_468_264##4	Y#9	2.53466e-18
C417	VGND#9	a_468_264##5	2.86339e-20
C418	B#4	B#2	3.8409e-18
C419	VPWR#9	B#10	1.13558e-20
C420	a_27_368##4	a_468_264##6	1.54232e-19
C421	VPWR#3	C_N#5	4.65582e-18
C422	VGND#3	VGND#2	4.74237e-19
C423	VGND#11	a_27_368##8	3.4362e-19
C424	a_27_368#	Y#13	1.61282e-18
C425	VGND#14	B#4	4.99851e-19
C426	a_27_368#	VPWR#9	9.46309e-18
C427	A#7	A#1	4.69252e-17
C428	a_468_264##16	C_N#1	2.09201e-17
C429	A#12	VGND#8	2.35177e-17
C430	Y#6	B#9	1.95496e-19
C431	VGND#7	a_468_264#	3.15438e-19
C432	a_27_368##6	B#5	6.7531e-20
C433	VPWR#9	a_468_264##5	2.09691e-20
C434	VGND#8	VGND#7	1.81737e-18
C435	a_126_368##2	a_27_368##2	1.7471e-17
C436	VPWR#9	a_468_264##6	2.03467e-20
C437	VGND#2	a_468_264##14	1.9433e-18
C438	a_27_368##8	B#13	4.45694e-17
C439	A#12	Y#8	1.49424e-17
C440	a_126_368##6	B#13	4.51273e-17
C441	A#1	C_N#5	2.38149e-17
C442	A#5	Y#8	2.7709e-18
C443	VGND#9	a_468_264##6	1.33763e-20
C444	Y#5	B#5	2.35161e-19
C445	VGND#8	A#10	7.6211e-19
C446	A#5	VGND#7	8.97326e-18
C447	a_27_368##7	B#13	1.27932e-18
C448	Y#6	B#5	1.40398e-18
C449	a_27_368##8	B#12	1.43044e-18
C450	A	C_N#3	2.31477e-17
C451	a_126_368##2	Y#13	4.33368e-17
C452	VGND#7	A#12	7.99145e-19
C453	A#5	Y#1	8.0716e-17
C454	a_27_368#	VPWR#8	2.6216e-17
C455	VGND#3	A#9	7.5403e-20
C456	Y#11	a_468_264##5	1.13061e-18
C457	Y#6	B#7	2.26103e-17
C458	a_468_264##16	a_126_368##2	5.81711e-18
C459	VGND#6	A#5	1.34644e-17
C460	a_126_368##6	B#12	5.71029e-17
C461	Y#4	B#1	1.43942e-19
C462	Y#2	a_468_264##4	8.64162e-18
C463	A#10	Y#8	1.49424e-17
C464	a_468_264##14	A#5	2.76736e-20
C465	C_N#5	C_N#1	3.69239e-17
C466	Y#3	a_468_264##4	8.47352e-17
C467	B#12	a_27_368##7	2.73349e-17
C468	a_27_368##8	B#8	3.28804e-19
C469	Y#4	a_468_264##4	5.00179e-17
C470	VGND#5	Y#10	5.19844e-18
C471	a_27_368#	VPWR#7	1.01069e-17
C472	VGND#8	A#8	2.4739e-19
C473	Y#5	B#1	1.08446e-17
C474	a_126_368##2	a_27_368#	5.98691e-17
C475	Y#11	a_468_264##6	1.12921e-18
C476	Y#5	a_468_264##4	7.20366e-18
C477	Y#3	a_468_264##13	2.11846e-19
C478	a_126_368##4	B#12	1.57623e-18
C479	a_126_368##6	B#8	1.37974e-18
C480	A#10	VGND#7	2.89909e-17
C481	VGND#4	VGND#3	4.72958e-19
C482	a_27_368##4	B#12	3.19496e-19
C483	B#8	a_27_368##7	2.3993e-17
C484	Y#6	B#1	9.31017e-18
C485	VGND#5	VGND#8	2.69543e-19
C486	Y#4	a_468_264##13	1.42121e-17
C487	Y#2	A#5	7.45652e-17
C488	VPWR#4	VPWR#2	2.68379e-18
C489	a_468_264##16	VPWR#6	5.81258e-19
C490	a_126_368##4	B#8	6.01614e-17
C491	a_126_368##2	VPWR#8	7.21754e-17
C492	Y#1	A#10	7.37645e-19
C493	a_468_264##18	VPWR#2	1.74164e-17
C494	a_27_368##4	B#8	1.15705e-18
C495	a_27_368##7	B#6	6.36484e-19
C496	Y#5	a_468_264##13	6.21641e-18
C497	Y#3	a_468_264##11	1.25215e-18
C498	A#8	VGND#7	2.66517e-17
C499	Y#1	VGND#7	5.23202e-17
C500	VGND#6	A#10	2.4739e-19
C501	a_126_368##4	B#6	3.85331e-17
C502	VPWR#8	VPWR#6	2.59053e-18
C503	C_N	C_N#3	1.58001e-17
C504	Y#4	a_468_264##11	1.76531e-17
C505	a_126_368##2	VPWR#5	5.77097e-18
C506	VGND#4	A#9	5.15413e-20
C507	a_27_368##2	a_468_264##5	1.62241e-19
C508	a_27_368##4	B#6	4.87178e-17
C509	VGND#10	B#5	3.58492e-20
C510	Y#1	A#8	5.39085e-17
C511	a_468_264##16	a_126_368#	4.87319e-17
C512	Y#7	Y#6	9.49423e-19
C513	a_126_368##4	a_468_264##7	1.47387e-17
C514	VGND#7	A#6	7.30433e-19
C515	VGND#1	C_N#3	2.85551e-19
C516	Y#5	a_468_264##11	2.15978e-19
C517	A#9	A#11	2.59382e-18
C518	Y#3	a_468_264##9	3.85325e-17
C519	a_126_368##2	VPWR#6	6.84372e-17
C520	VGND#7	VGND#6	1.63769e-18
C521	VGND#6	A#8	2.46599e-18
C522	Y#14	Y#4	9.24828e-19
C523	a_27_368##4	a_468_264##7	5.07757e-17
C524	B#11	B#9	3.52713e-17
C525	a_126_368##2	VPWR#7	7.84386e-18
C526	a_468_264##16	A#5	7.78776e-17
C527	A#6	Y#1	1.32501e-17
C528	Y#2	a_468_264#	7.78741e-19
C529	Y#11	a_468_264##7	3.89563e-17
C530	a_126_368##4	a_468_264##12	1.37974e-17
C531	Y#4	a_468_264##9	3.1372e-20
C532	B	B#2	8.17279e-18
C533	VGND#5	Y#3	1.33963e-17
C534	a_468_264##14	A#8	1.73757e-19
C535	Y#6	VGND#14	2.01632e-17
C536	a_468_264##16	VPWR#4	4.23092e-17
C537	a_126_368##2	a_126_368#	5.17705e-18
C538	VPWR#3	A#5	2.751e-20
C539	B	B#4	1.81238e-17
C540	a_27_368##2	a_468_264##7	9.05104e-19
C541	a_27_368##4	a_468_264##12	2.87182e-18
C542	VGND#5	Y#4	3.0608e-19
C543	B	B#10	2.32791e-17
C544	VPWR#5	A#5	9.97765e-20
C545	Y#1	VGND#6	5.93222e-17
C546	Y#3	a_468_264#	4.28639e-17
C547	Y#5	a_468_264##9	1.23075e-19
C548	VGND#6	A#6	4.08529e-17
C549	a_126_368#	VPWR#3	7.50321e-18
C550	B#9	B#7	2.16766e-17
C551	a_126_368##4	a_468_264##10	7.11544e-18
C552	Y#11	a_468_264##12	3.90345e-17
C553	VPWR#7	A#5	3.72728e-21
C554	a_27_368##6	VPWR#9	6.24602e-17
C555	VGND#2	A#5	6.60125e-19
C556	VGND#1	a_468_264##14	8.41602e-17
C557	Y#10	Y#3	2.36813e-18
C558	a_27_368##6	B#4	8.80141e-20
C559	VPWR#7	VPWR#6	6.6699e-20
C560	a_27_368##2	a_468_264##12	4.55833e-17
C561	a_27_368##4	a_468_264##10	1.45425e-18
C562	Y#2	A#12	4.16411e-17
C563	VGND#3	A#5	6.51464e-20
C564	a_126_368#	VPWR#6	6.08503e-17
C565	a_468_264##14	A#6	1.35759e-18
C566	VPWR#8	a_468_264##7	2.89985e-19
C567	a_126_368##4	a_468_264##8	5.87623e-19
C568	Y#6	Y#14	1.05401e-19
C569	a_126_368#	VPWR#5	8.01648e-18
C570	a_468_264##16	a_468_264##18	1.63738e-18
C571	a_468_264##14	Y#1	3.01953e-20
C572	C_N#4	VGND#6	2.06976e-17
C573	Y#5	VGND#13	3.2199e-17
C574	Y#3	A#12	1.5772e-18
C575	B#7	B#1	3.9067e-17
C576	Y#5	a_468_264#	6.5896e-20
C577	a_27_368##4	a_468_264##8	9.8333e-19
C578	C_N#3	a_468_264##14	8.29586e-18
C579	a_27_368##2	a_468_264##10	4.56355e-17
C580	Y#4	Y#10	1.1615e-18
C581	VPWR#2	C_N#3	7.78243e-20
C582	VPWR#6	VPWR#4	1.57611e-18
C583	VGND#10	B#11	9.28275e-19
C584	Y#3	VGND#12	5.89794e-17
C585	VPWR#8	a_468_264##12	4.24894e-19
C586	Y#13	a_468_264##10	3.90234e-17
C587	Y#2	A#10	4.19506e-17
C588	a_468_264##14	C_N#4	4.84535e-17
C589	a_126_368##2	a_468_264##12	5.24939e-19
C590	a_27_368#	a_468_264##10	9.05104e-19
C591	a_27_368##2	a_468_264##8	1.34185e-18
C592	VGND#6	a_468_264##14	6.11177e-17
C593	a_126_368#	VPWR#4	8.10685e-17
C594	B#1	a_468_264##13	2.59121e-17
C595	a_468_264##16	VPWR#1	3.49306e-17
C596	Y#3	A#10	5.47513e-19
C597	VGND#10	VGND#9	1.35051e-18
C598	VGND#9	B#9	1.47776e-19
C599	Y#5	A#12	8.80964e-19
C600	VPWR#8	a_468_264##10	6.77791e-19
C601	Y#13	a_468_264##8	3.50586e-17
C602	Y#4	VGND#12	1.38259e-17
C603	Y#3	Y#9	4.68449e-19
C604	a_468_264##18	VPWR#3	1.13824e-18
C605	a_126_368##2	a_468_264##10	6.8276e-18
C606	Y#2	A#8	7.37645e-19
C607	a_27_368#	a_468_264##8	6.12101e-17
C608	Y#2	VGND#8	5.25401e-17
C609	VGND#3	Y#2	8.70697e-18
C610	VGND#10	B#9	5.69784e-18
C611	Y#13	A#13	1.88261e-18
C612	VPWR#8	a_468_264##8	2.80066e-18
C613	a_468_264##13	a_468_264##11	4.04492e-17
C614	Y#3	A#8	3.35084e-19
C615	VGND#5	VGND#4	1.06595e-18
C616	a_126_368##2	a_468_264##8	2.34045e-17
C617	a_27_368#	A#13	7.20706e-19
C618	VGND#9	B#7	4.52951e-19
C619	VGND#9	VGND#5	1.21535e-18
C620	VGND#13	a_468_264##6	4.21871e-19
C621	Y#3	VGND#8	5.23655e-17
C622	VPWR#4	a_468_264##18	4.85803e-17
C623	Y#2	Y#8	5.51956e-19
C624	Y#13	A#11	4.77019e-19
C625	VGND#4	Y#2	7.62056e-18
C626	VPWR#8	A#13	5.59452e-17
C627	VGND#10	B#7	5.69968e-18
C628	a_126_368##2	A#13	5.06415e-17
C629	A#1	C_N#3	1.2357e-18
C630	VGND#1	a_468_264##16	3.91743e-18
C631	a_468_264##11	a_468_264##9	2.40002e-17
C632	Y#13	A#7	3.34033e-19
C633	VPWR#4	VPWR#1	7.00142e-18
C634	VPWR#8	A#11	1.51556e-18
C635	VPWR#6	A#13	2.30095e-18
C636	Y#2	VGND#7	5.2456e-17
C637	VGND#9	B#1	5.77917e-18
C638	a_126_368##2	A#11	3.5889e-17
C639	a_126_368#	A#13	3.01779e-19
C640	VGND#4	Y#3	3.9943e-18
C641	VPWR#6	A#11	4.28357e-17
C642	a_468_264##9	a_468_264#	3.76695e-17
C643	a_468_264##18	VPWR#1	5.44584e-17
C644	VGND#10	B#1	5.16137e-19
C645	a_468_264##16	VPWR#2	9.20592e-18
C646	a_27_368##6	B#12	1.57331e-17
C647	a_468_264##18	A#13	4.3439e-19
C648	a_126_368##2	A#7	6.33136e-19
C649	a_126_368#	A#11	6.97579e-19
C650	B#2	a_468_264##6	2.4534e-17
C651	Y#2	Y#1	2.87112e-18
C652	VPWR#2	VPWR#3	1.17762e-17
C653	VPWR#6	A#7	4.8225e-17
C654	VGND#9	a_468_264##13	6.86318e-18
C655	a_27_368##6	a_126_368##6	1.45565e-17
C656	a_468_264#	A#12	2.27672e-17
C657	a_126_368##2	A#1	3.64309e-19
C658	a_126_368#	A#7	3.33415e-17
C659	a_468_264##18	A#11	4.27414e-19
C660	a_27_368##6	B#8	1.66796e-17
C661	VGND#10	a_468_264##13	1.75327e-19
C662	VPWR#6	A#1	2.32021e-18
C663	VPWR#4	A#7	7.01838e-19
C664	a_126_368#	A#1	5.74238e-17
C665	a_468_264##18	A#7	6.7434e-19
C666	a_27_368##6	a_27_368##7	5.47123e-20
C667	VGND#9	Y#4	7.37376e-19
C668	Y#5	B#2	3.53303e-18
C669	VGND#9	a_468_264##11	5.56729e-19
C670	A#12	A#10	3.69597e-17
C671	A#1	VPWR#4	3.70944e-17
C672	a_468_264##18	A#1	2.38642e-18
C673	a_27_368##6	a_126_368##4	1.49455e-17
C674	C_N#5	VPWR#4	2.53568e-17
C675	VPWR#1	A#1	1.35616e-18
C676	VGND#11	Y#7	7.43301e-17
C677	VGND#9	Y#5	3.41335e-19
C678	A#10	A#8	1.33509e-17
C679	a_468_264##18	C_N#5	4.03741e-17
C680	VPWR#8	A#9	1.508e-19
C681	VPWR#4	C_N#1	1.34836e-18
C682	VPWR#1	C_N#5	2.77208e-18
C683	VGND#11	VGND#14	1.31249e-18
C684	VGND#4	a_468_264#	2.74092e-18
C685	Y#5	B#4	4.02539e-19
C686	Y#6	B#2	3.08606e-18
C687	C_N#1	a_468_264##18	1.71861e-17
C688	A#8	A#6	2.74756e-17
*
*
.ENDS sky130_fd_sc_hs__nor3b_4
*
