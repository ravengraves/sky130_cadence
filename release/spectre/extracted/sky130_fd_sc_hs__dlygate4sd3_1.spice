* Extracted by Quantus, converted by sky130cad/quantus.py
*
*
*
*                       LINUX           Wed Nov 18 08:34:45 2026
*
*
*
*  PROGRAM  advgen
*
*  Name           : advgen - Quantus - (64-bit)
*  Version        : 25.1.0-p047
*  Build Date     : Thu Dec 11 23:20:30 PST 2025
*
*  HSPICE LIBRARY
*
*  OPERATING_TEMPERATURE 150
*  QRC_TECH_DIR <path>/tech
*
*
*

*
.SUBCKT sky130_fd_sc_hs__dlygate4sd3_1 VPB VNB VGND VPWR X A
*
*
*  caps2d version: 10
*
*
*       TRANSISTOR CARDS
*
*
XM3 a_28_74##6 A#1 VGND#7 VNB sky130_fd_pr__nfet_01v8_lvt l=0.15 w=0.42 ad=0.1113 as=0.2982 pd=1.37 ps=2.26
XM4 VGND#7 a_28_74# a_289_74##6 VNB sky130_fd_pr__nfet_01v8_lvt l=0.18 w=0.42 ad=0.2982 as=0.1092 pd=2.26 ps=1.36
XM0 a_405_138##6 a_289_74# VGND#6 VNB sky130_fd_pr__nfet_01v8_lvt l=0.18 w=0.42 ad=0.2436 as=0.2297 pd=2 ps=2.17
XM2 VGND#6 a_405_138##3 X#3 VNB sky130_fd_pr__nfet_01v8_lvt l=0.15 w=0.74 ad=0.2297 as=0.1961 pd=2.17 ps=2.01
XM5 a_28_74##4 A#3 VPWR#7 VPB sky130_fd_pr__pfet_01v8 l=0.15 w=0.42 ad=0.1176 as=0.3025 pd=1.4 ps=2.75
XM1 VPWR#7 a_28_74##3 a_289_74##8 VPB sky130_fd_pr__pfet_01v8 l=0.5 w=1 ad=0.3025 as=0.26 pd=2.75 ps=2.52
XM6 a_405_138##4 a_289_74##3 VPWR#6 VPB sky130_fd_pr__pfet_01v8 l=0.5 w=1 ad=0.26 as=0.388 pd=2.52 ps=2.95
XM7 VPWR#6 a_405_138# X#1 VPB sky130_fd_pr__pfet_01v8 l=0.15 w=1.12 ad=0.388 as=0.3136 pd=2.95 ps=2.8
*
*
*       RESISTOR AND CAP/DIODE CARDS
*
Rg1	A#1	A#2	382.539764
Rg2	A#2	A#3	519.595703
Rg3	a_28_74#	a_28_74##2	311.401489
Rg4	a_28_74##2	a_28_74##3	120.885841
Rg5	a_289_74#	a_289_74##2	187.414276
Rg6	a_289_74##2	a_289_74##3	99.664764
Rg7	a_405_138#	a_405_138##2	467.246124
Rg8	a_405_138##2	a_405_138##3	363.395935
Rf1	A	A#4	3.280892
Rf2	A#5	A#2	163.513702
Rf3	A#4	A#5	1.266811
Rf4	A	A#7	3.280892
Rf5	A#5	A#7	6.545189
Rf6	a_28_74##4	a_28_74##5	110.133453
Rf7	a_28_74##5	a_28_74##6	94.284950
Rf8	a_289_74##2	a_289_74##5	119.414703
Rf9	a_289_74##5	a_289_74##7	47.645889
Rf10	a_289_74##5	a_289_74##8	68.863724
Rf11	a_289_74##6	a_289_74##7	15.000000
Rf12	a_405_138##4	a_405_138##5	91.106712
Rf13	a_405_138##5	a_405_138##6	89.469757
Rf14	X	X#2	0.237160
Rf15	X#2	X	11.462756
Rf16	X	X#4	5.929011
Rf17	X#4	X	5.770905
Rf18	X#1	X#2	5.000000
Rf19	X#3	X#4	7.500000
Rf21	VPWR#2	VPWR#3	78.139503
Rf22	VPWR#3	VPWR#4	86.175049
Rf24	VPWR#2	VPWR#6	35.274620
Rf25	VPWR#4	VPWR#7	42.577789
Rf27	VGND#2	VGND#3	78.139503
Rf28	VGND#3	VGND#4	85.444542
Rf30	VGND#2	VGND#6	36.082184
Rf31	VGND#4	VGND#7	33.916985
Rf33	a_28_74##2	a_28_74##5	80.116402
Rf35	a_405_138##2	a_405_138##5	160.232803
Re1	VPWR#3	VPWR	1.227783
Re2	VGND	VGND#3	1.227829
*
*       CAPACITOR CARDS
*
*
C1	VGND	VNB	6.28843e-17
C2	VPWR	VNB	6.28391e-17
C3	X	VNB	1.42606e-16
C4	A	VNB	1.69608e-17
C5	VGND	X	2.53887e-17
C6	VPWR	X	2.61865e-17
C7	A#2	VNB	8.42006e-17
C8	a_28_74##2	VNB	8.79561e-17
C9	VPWR	A	4.81075e-18
C10	a_289_74##2	VNB	7.75196e-17
C11	a_405_138##2	VNB	4.1122e-17
C12	VGND#3	VNB	2.05648e-16
C13	VPWR#3	VNB	2.06525e-16
C14	VGND	A#2	5.38596e-18
C15	A#3	VNB	5.34824e-17
C16	VGND	a_28_74##2	1.13455e-17
C17	a_28_74##3	VNB	9.56913e-17
C18	VGND	a_289_74##2	4.62135e-18
C19	a_289_74##3	VNB	1.09997e-16
C20	a_405_138#	VNB	3.88028e-17
C21	VGND	a_405_138##2	7.44276e-18
C22	VGND	VGND#3	2.3751e-17
C23	A#1	VNB	3.67754e-17
C24	a_28_74#	VNB	4.09981e-17
C25	VPWR	a_28_74##2	8.63418e-18
C26	a_289_74#	VNB	3.48321e-17
C27	a_405_138##3	VNB	3.23752e-17
C28	VPWR	a_289_74##2	4.86383e-18
C29	a_28_74##4	VNB	3.82768e-17
C30	VPWR#7	VNB	6.90695e-18
C31	VPWR	a_405_138##2	4.82199e-18
C32	a_289_74##8	VNB	1.41596e-18
C33	a_405_138##4	VNB	7.14172e-18
C34	VPWR#6	VNB	5.48796e-18
C35	VPWR	VPWR#3	2.63127e-17
C36	a_28_74##6	VNB	3.80326e-17
C37	A	A#2	1.75824e-17
C38	VGND#7	VNB	3.31285e-18
C39	VGND	A#1	1.12217e-18
C40	a_289_74##6	VNB	1.43392e-17
C41	a_405_138##2	X	1.12121e-16
C42	VGND	a_28_74#	6.11394e-18
C43	a_405_138##6	VNB	8.5872e-18
C44	A	a_28_74##2	3.51197e-17
C45	VPWR	A#3	5.50216e-18
C46	VGND#6	VNB	8.54105e-18
C47	VGND	a_289_74#	8.00268e-18
C48	VPWR	a_28_74##3	1.08223e-17
C49	VGND	a_405_138##3	1.10367e-18
C50	A#5	VNB	7.31546e-18
C51	VPWR	a_289_74##3	1.96323e-17
C52	VPWR	a_405_138#	3.88902e-18
C53	a_289_74##5	VNB	1.57682e-17
C54	VGND	a_405_138##4	3.3629e-18
C55	VGND	a_28_74##6	1.72241e-17
C56	X	a_289_74##3	1.06799e-18
C57	VGND	VGND#7	1.50216e-17
C58	VGND	a_289_74##6	1.66269e-17
C59	X	a_405_138#	2.88756e-17
C60	VPWR	a_28_74##4	1.3535e-17
C61	VGND	a_405_138##6	1.4963e-17
C62	VPWR	a_289_74##8	1.24908e-17
C63	VPWR	a_405_138##4	1.16724e-17
C64	X	a_28_74#	2.85447e-19
C65	VPWR	VPWR#6	2.21295e-17
C66	X	a_289_74#	9.34461e-19
C67	X	a_405_138##3	2.14579e-17
C68	A#2	a_28_74##2	7.40374e-17
C69	VGND	a_289_74##5	2.52608e-18
C70	a_405_138##4	X	1.70182e-18
C71	VPWR#6	X	7.86307e-17
C72	a_28_74##2	a_289_74##2	7.55074e-18
C73	X	X#1	1.5152e-17
C74	A	a_28_74##4	5.32157e-17
C75	a_405_138##2	a_28_74##2	1.97407e-19
C76	a_405_138##6	X	1.78899e-18
C77	VPWR	a_289_74##5	2.10455e-18
C78	a_405_138##2	a_289_74##2	8.13861e-17
C79	VGND#6	X	5.33144e-17
C80	X	X#3	9.0914e-18
C81	VGND#3	a_289_74##2	9.44463e-19
C82	a_289_74##2	VPWR#3	6.62112e-19
C83	A#2	a_28_74##3	2.80139e-18
C84	a_28_74##2	A#3	4.35866e-19
C85	a_28_74##2	a_28_74##3	3.19724e-17
C86	a_28_74##2	a_289_74##3	1.27055e-18
C87	A#1	a_28_74##2	1.35525e-19
C88	a_405_138##2	a_289_74##3	1.23212e-17
C89	a_28_74##2	a_28_74#	8.23919e-18
C90	a_405_138##2	a_405_138#	6.83508e-18
C91	a_28_74##4	A#2	1.78985e-19
C92	a_28_74##2	a_289_74#	9.08474e-19
C93	VPWR#3	a_28_74##3	3.91953e-18
C94	VPWR#7	A#2	6.55715e-19
C95	VPWR#3	a_289_74##3	3.10643e-18
C96	a_28_74##2	VPWR#7	2.60858e-17
C97	A#3	a_28_74##3	3.26879e-17
C98	a_28_74##2	a_289_74##8	2.55395e-17
C99	a_405_138##2	a_289_74#	9.36869e-18
C100	VGND#3	a_28_74#	2.97762e-18
C101	a_405_138##4	a_28_74##2	3.99142e-19
C102	a_28_74##6	A#2	6.21758e-17
C103	a_405_138##2	a_405_138##3	4.35983e-18
C104	VGND#7	A#2	8.77831e-19
C105	a_28_74##3	a_289_74##3	1.06416e-17
C106	a_289_74##2	a_405_138##4	5.56612e-17
C107	a_28_74##3	a_405_138#	1.88181e-19
C108	VGND#7	a_28_74##2	2.26944e-17
C109	a_289_74##3	a_405_138#	3.99982e-17
C110	a_28_74##2	a_289_74##6	2.34158e-17
C111	a_405_138##6	a_28_74##2	8.05036e-19
C112	a_405_138##2	VPWR#6	3.27683e-17
C113	A#5	A#2	1.02069e-17
C114	a_289_74##8	VPWR#3	9.62592e-18
C115	a_405_138##6	a_289_74##2	7.56236e-17
C116	A#5	a_28_74##2	1.43758e-17
C117	a_405_138##4	VPWR#3	3.66216e-18
C118	a_28_74##4	A#3	2.87205e-17
C119	A#3	VPWR#7	2.19289e-17
C120	a_28_74##4	a_28_74##3	1.71626e-18
C121	a_405_138##2	VGND#6	3.27441e-17
C122	a_289_74##8	A#3	2.61212e-18
C123	VGND#3	a_289_74##6	2.36606e-17
C124	a_28_74##3	VPWR#7	2.82322e-17
C125	a_28_74##2	a_289_74##5	9.76984e-17
C126	VGND#3	a_405_138##6	8.13597e-18
C127	a_28_74##4	a_289_74##3	1.97811e-19
C128	a_289_74##8	a_28_74##3	4.96574e-17
C129	A#1	a_28_74#	6.98691e-18
C130	VPWR#7	a_289_74##3	1.99966e-18
C131	a_405_138##4	a_28_74##3	1.05803e-18
C132	a_289_74##8	a_289_74##3	8.3322e-18
C133	a_289_74##5	a_289_74##2	3.74786e-18
C134	VPWR#6	a_28_74##3	3.9919e-18
C135	a_405_138##4	a_289_74##3	7.13739e-17
C136	a_28_74#	a_289_74#	1.88837e-18
C137	a_289_74##8	a_405_138#	1.61131e-18
C138	a_289_74##3	VPWR#6	3.70361e-17
C139	a_28_74#	a_405_138##3	4.25512e-19
C140	a_289_74##5	a_405_138##2	2.37499e-18
C141	a_405_138##4	a_405_138#	8.4854e-19
C142	a_289_74#	a_405_138##3	2.24645e-17
C143	VPWR#6	a_405_138#	5.05914e-17
C144	a_405_138#	X#1	2.106e-20
C145	VGND#3	a_289_74##5	9.2056e-19
C146	a_289_74##5	VPWR#3	6.12968e-19
C147	a_28_74##4	VPWR#7	4.3393e-17
C148	a_28_74##6	A#1	3.94009e-17
C149	A#1	VGND#7	2.17217e-17
C150	a_28_74##4	a_289_74##8	1.51355e-18
C151	a_28_74##6	a_28_74#	1.79649e-18
C152	a_289_74##6	A#1	3.87246e-18
C153	VPWR#7	a_289_74##8	1.31245e-17
C154	a_28_74#	VGND#7	1.45944e-17
C155	a_289_74##6	a_28_74#	3.11289e-17
C156	a_289_74##5	a_28_74##3	3.08081e-18
C157	a_405_138##6	a_28_74#	6.47553e-19
C158	a_289_74##8	a_405_138##4	1.76991e-17
C159	a_289_74##6	a_289_74#	1.82467e-18
C160	VGND#6	a_28_74#	1.69456e-18
C161	a_28_74##6	a_28_74##4	1.1762e-19
C162	a_289_74##8	VPWR#6	9.43127e-18
C163	a_405_138##6	a_289_74#	1.98072e-17
C164	a_289_74##5	a_289_74##3	6.09319e-19
C165	a_289_74##6	a_405_138##3	2.01843e-18
C166	a_289_74#	VGND#6	1.75656e-17
C167	a_405_138##4	VPWR#6	4.45992e-18
C168	a_405_138##6	a_405_138##3	1.74065e-18
C169	a_289_74##5	a_405_138#	4.81234e-20
C170	VGND#6	a_405_138##3	3.74285e-17
C171	a_28_74##6	VGND#7	4.43527e-17
C172	a_289_74##5	a_289_74#	1.56724e-19
C173	a_28_74##6	a_289_74##6	1.49963e-18
C174	VGND#7	a_289_74##6	1.18849e-17
C175	a_289_74##6	a_405_138##6	2.33799e-17
C176	a_289_74##6	VGND#6	7.18613e-18
C177	a_289_74##5	a_289_74##8	4.14991e-19
C178	a_405_138##6	VGND#6	9.3811e-18
C179	a_289_74##5	a_405_138##4	1.3952e-17
C180	a_289_74##5	a_405_138##6	1.28932e-17
C181	a_405_138##4	VPWR#2	1.30348e-18
C182	VPWR#2	a_405_138#	4.46779e-18
C183	VPWR#2	a_289_74##3	7.85042e-18
C184	VPWR#3	VPWR#2	6.07544e-17
C185	a_405_138##2	VPWR#2	4.72003e-19
C186	X	VPWR#2	3.67722e-17
C187	VPWR	VPWR#2	3.83077e-17
C188	VPWR#2	VNB	5.17131e-17
C189	VGND#2	a_405_138##3	7.18834e-18
C190	VGND#2	a_289_74##2	2.48244e-19
C191	VPWR#4	VNB	6.0152e-17
C192	VPWR	VPWR#4	6.47322e-17
C193	VGND#2	a_405_138##2	1.20147e-18
C194	VGND#4	a_28_74##6	2.46863e-17
C195	VGND#3	VGND#2	6.11259e-17
C196	VGND#4	a_28_74##2	5.29037e-18
C197	VGND#2	VNB	5.64459e-17
C198	a_28_74##2	VPWR#4	2.35479e-18
C199	VGND#4	A#1	4.9002e-18
C200	VGND#4	VNB	5.47396e-17
C201	VGND	VGND#2	6.04444e-17
C202	VPWR#3	VPWR#4	5.85877e-17
C203	VGND#4	a_28_74#	6.87242e-18
C204	VPWR#4	A#3	7.28778e-19
C205	VPWR#4	a_28_74##3	1.99061e-17
C206	VGND	VGND#4	4.02564e-17
C207	VGND#2	X	2.53754e-17
C208	VGND#3	VGND#4	5.91484e-17
C209	a_28_74##4	VPWR#4	9.49445e-18
C210	VGND#2	a_405_138##6	1.85633e-18
C211	VGND#2	a_28_74#	3.81886e-19
C212	VGND#2	a_289_74#	3.17273e-18
*
*
.ENDS sky130_fd_sc_hs__dlygate4sd3_1
*
