* Extracted by Quantus, converted by sky130cad/quantus.py
*
*
*
*                       LINUX           Wed Nov 18 08:54:22 2026
*
*
*
*  PROGRAM  advgen
*
*  Name           : advgen - Quantus - (64-bit)
*  Version        : 25.1.0-p047
*  Build Date     : Thu Dec 11 23:20:30 PST 2025
*
*  HSPICE LIBRARY
*
*  OPERATING_TEMPERATURE 150
*  QRC_TECH_DIR <path>/tech
*
*
*

*
.SUBCKT sky130_fd_sc_hs__o211ai_2 VNB VPB VGND VPWR Y A1 A2 C1 B1
*
*
*  caps2d version: 10
*
*
*       TRANSISTOR CARDS
*
*
XM5 a_30_84# C1#5 Y#4 VNB sky130_fd_pr__nfet_01v8_lvt l=0.15 w=0.74 ad=0.2109 as=0.2072 pd=2.05 ps=2.04
XM10 Y#4 C1#4 a_30_84##4 VNB sky130_fd_pr__nfet_01v8_lvt l=0.15 w=0.74 ad=0.2072 as=0.259 pd=2.04 ps=2.18
XM6 a_30_84##4 B1#7 a_303_84##3 VNB sky130_fd_pr__nfet_01v8_lvt l=0.15 w=0.74 ad=0.259 as=0.259 pd=2.18 ps=2.18
XM1 a_303_84##3 B1#1 a_30_84##2 VNB sky130_fd_pr__nfet_01v8_lvt l=0.15 w=0.74 ad=0.259 as=0.2183 pd=2.18 ps=2.07
XM13 a_303_84##4 A2#5 VGND#6 VNB sky130_fd_pr__nfet_01v8_lvt l=0.15 w=0.74 ad=0.2072 as=0.2109 pd=2.04 ps=2.05
XM14 VGND#5 A2#1 a_303_84##4 VNB sky130_fd_pr__nfet_01v8_lvt l=0.15 w=0.74 ad=0.2109 as=0.2072 pd=2.05 ps=2.04
XM7 a_303_84# A1#8 VGND#5 VNB sky130_fd_pr__nfet_01v8_lvt l=0.15 w=0.74 ad=0.2405 as=0.2109 pd=2.13 ps=2.05
XM15 VGND#1 A1#6 a_303_84# VNB sky130_fd_pr__nfet_01v8_lvt l=0.15 w=0.74 ad=0.2294 as=0.2405 pd=2.1 ps=2.13
XM0 Y#6 C1#6 VPWR#6 VPB sky130_fd_pr__pfet_01v8 l=0.15 w=1.12 ad=0.336 as=0.3304 pd=2.84 ps=2.83
XM8 VPWR#9 C1#1 Y#6 VPB sky130_fd_pr__pfet_01v8 l=0.15 w=1.12 ad=0.336 as=0.336 pd=2.84 ps=2.84
XM11 VPWR#9 B1#5 Y#5 VPB sky130_fd_pr__pfet_01v8 l=0.15 w=1.12 ad=0.336 as=0.336 pd=2.84 ps=2.84
XM2 Y#5 B1#6 VPWR#8 VPB sky130_fd_pr__pfet_01v8 l=0.15 w=1.12 ad=0.336 as=0.3304 pd=2.84 ps=2.83
XM3 a_505_368##4 A2#6 Y#1 VPB sky130_fd_pr__pfet_01v8 l=0.15 w=1.12 ad=0.3304 as=0.336 pd=2.83 ps=2.84
XM12 Y#1 A2#4 a_505_368##2 VPB sky130_fd_pr__pfet_01v8 l=0.15 w=1.12 ad=0.336 as=0.336 pd=2.84 ps=2.84
XM4 a_505_368##2 A1#5 VPWR#7 VPB sky130_fd_pr__pfet_01v8 l=0.15 w=1.12 ad=0.336 as=0.392 pd=2.84 ps=2.94
XM9 VPWR#7 A1#7 a_505_368# VPB sky130_fd_pr__pfet_01v8 l=0.15 w=1.12 ad=0.392 as=0.3304 pd=2.94 ps=2.83
*
*
*       RESISTOR AND CAP/DIODE CARDS
*
Rg1	C1#1	C1#2	467.258240
Rg2	C1#2	C1#3	97.083176
Rg3	C1#2	C1#4	369.786682
Rg4	C1#3	C1#5	359.648865
Rg5	C1#3	C1#6	428.130829
Rg6	B1#1	B1#2	365.539856
Rg7	B1#2	B1#3	22.722054
Rg8	B1#3	B1#4	30.613651
Rg9	B1#4	B1#5	449.655212
Rg10	B1#2	B1#6	449.668243
Rg11	B1#4	B1#7	368.862610
Rg12	A2#1	A2#2	379.528015
Rg13	A2#2	A2#3	62.096523
Rg14	A2#2	A2#4	462.555450
Rg15	A2#3	A2#5	394.294495
Rg16	A2#3	A2#6	449.261597
Rg17	A1#1	A1#2	201.775070
Rg18	A1#2	A1#3	46.611591
Rg19	A1#3	A1#4	24.861496
Rg20	A1#4	A1#5	465.179230
Rg21	A1#2	A1#6	368.612183
Rg22	A1#2	A1#7	462.729340
Rg23	A1#4	A1#8	369.872040
Rf1	C1#7	C1#3	162.448425
Rf2	C1	C1#9	2.215620
Rf3	C1#7	C1#9	4.635897
Rf4	B1#8	B1	1.081872
Rf5	B1#3	B1#10	81.198273
Rf6	B1#10	B1	1.081872
Rf7	B1#8	B1#10	14.668931
Rf8	a_30_84#	a_30_84##3	101.173935
Rf9	a_30_84##3	a_30_84##4	9.888189
Rf10	a_30_84##2	a_30_84##3	15.000000
Rf11	Y#1	Y#2	119.252678
Rf12	Y#2	Y#3	56.949951
Rf13	Y#3	Y#4	83.279182
Rf14	Y#2	Y#5	18.602406
Rf15	Y#3	Y	15.168479
Rf16	Y	Y#7	2.362036
Rf17	Y#7	Y	12.203854
Rf18	Y#6	Y#7	5.000000
Rf19	A2	A2#7	8.591474
Rf20	A2#7	A2	5.154884
Rf21	a_303_84#	a_303_84##2	85.842216
Rf22	a_303_84##2	a_303_84##3	115.096054
Rf23	a_303_84##2	a_303_84##4	26.114532
Rf24	a_505_368#	a_505_368##3	118.299248
Rf25	a_505_368##3	a_505_368##4	127.318336
Rf26	a_505_368##2	a_505_368##3	5.000000
Rf27	A1	A1#1	6.986497
Rf28	A1#1	A1#3	100.528336
Rf29	VGND#1	VGND#2	93.568184
Rf30	VGND#2	VGND#3	62.774361
Rf31	VGND#3	VGND#4	23.716879
Rf32	VGND#2	VGND#5	36.475861
Rf33	VGND#3	VGND#6	36.475861
Rf35	VPWR#2	VPWR#3	118.317268
Rf36	VPWR#3	VPWR#4	18.295441
Rf37	VPWR#4	VPWR#5	68.798325
Rf38	VPWR#5	VPWR#6	114.031120
Rf39	VPWR#2	VPWR#7	34.093605
Rf40	VPWR#4	VPWR#8	38.736572
Rf41	VPWR#5	VPWR#9	53.143215
Rf44	A2#3	A2#7	53.410934
Re1	VPWR#3	VPWR	0.982218
Re2	VGND	VGND#4	0.982254
*
*       CAPACITOR CARDS
*
*
C1	VGND	VNB	7.8051e-17
C2	VPWR	VNB	7.33143e-17
C3	Y	VNB	2.19739e-18
C4	A1	VNB	2.57439e-17
C5	A2	VNB	1.0681e-17
C6	B1	VNB	4.50843e-18
C7	a_303_84##4	A1#6	4.27526e-19
C8	C1#3	VNB	4.79155e-17
C9	A2#3	VNB	6.46677e-17
C10	A1#3	VNB	5.22789e-19
C11	VGND	A1	2.52613e-18
C12	VGND#4	VNB	2.91428e-16
C13	VPWR#3	VNB	2.3025e-16
C14	VPWR	Y	1.60837e-17
C15	VGND	A2	4.681e-18
C16	C1#6	VNB	4.33947e-17
C17	C1#1	VNB	3.65495e-17
C18	B1#5	VNB	3.20001e-17
C19	VPWR	A1	3.16902e-18
C20	B1#4	A2#6	1.06791e-19
C21	B1#6	VNB	3.2876e-17
C22	VPWR#4	A2#4	7.96674e-20
C23	A2#6	VNB	3.50542e-17
C24	A2#4	VNB	3.47535e-17
C25	VGND	B1	5.84707e-18
C26	A1#5	VNB	2.8837e-17
C27	VPWR	A2	5.8707e-18
C28	a_303_84#	A1#8	3.32554e-17
C29	A1#7	VNB	3.88184e-17
C30	C1#5	VNB	3.30993e-17
C31	C1#4	VNB	2.68499e-17
C32	B1#7	VNB	2.73693e-17
C33	B1#1	VNB	3.11912e-17
C34	A2#5	VNB	2.94335e-17
C35	A2#1	VNB	2.47113e-17
C36	VPWR	B1	5.56663e-18
C37	A1#8	VNB	2.43391e-17
C38	A1#6	VNB	3.27288e-17
C39	VPWR#6	VNB	7.51548e-17
C40	VPWR#9	VNB	2.92383e-18
C41	Y#5	VNB	2.1429e-18
C42	VGND	C1#3	1.08433e-18
C43	VPWR#8	VNB	8.91866e-18
C44	a_505_368##4	VNB	1.4172e-17
C45	Y#1	VNB	2.10823e-18
C46	a_505_368##2	VNB	5.33586e-18
C47	VPWR#7	VNB	1.79318e-18
C48	VGND#5	A1#6	1.41573e-18
C49	a_505_368#	VNB	5.52164e-17
C50	VGND	A2#3	1.68471e-18
C51	a_303_84##3	B1#4	5.21899e-18
C52	a_30_84#	VNB	4.78997e-17
C53	Y#4	VNB	2.20094e-18
C54	a_30_84##4	VNB	2.69744e-18
C55	VGND	A1#3	4.29653e-18
C56	a_303_84##3	VNB	6.14231e-18
C57	a_30_84##2	VNB	1.66599e-17
C58	VGND#6	VNB	2.86232e-18
C59	a_303_84##4	VNB	4.54572e-18
C60	VGND#5	VNB	4.21172e-20
C61	VGND#2	a_303_84#	1.3553e-17
C62	VGND	VGND#4	4.90074e-17
C63	a_303_84#	VNB	5.90827e-18
C64	VGND#1	VNB	6.11019e-17
C65	C1#7	VNB	1.23452e-17
C66	C1#9	VNB	1.12207e-17
C67	B1	A2	2.09323e-17
C68	VPWR	A2#3	1.57235e-18
C69	VGND#1	A1#8	2.53132e-18
C70	Y#2	VNB	5.80167e-18
C71	Y#3	VNB	4.38181e-18
C72	VPWR	A1#3	3.49296e-18
C73	a_303_84##2	VNB	4.1625e-18
C74	VPWR#4	B1#4	2.01982e-20
C75	VGND#2	VNB	3.214e-17
C76	VGND#3	VNB	2.04605e-17
C77	VPWR#5	C1#2	4.17154e-20
C78	VPWR#4	VNB	1.97754e-17
C79	VPWR#5	VNB	3.15601e-17
C80	VPWR	VPWR#3	1.79873e-17
C81	a_505_368##2	VPWR#7	7.83621e-17
C82	A1#6	a_303_84#	2.25756e-17
C83	VPWR	C1#6	3.41664e-18
C84	VPWR	C1#1	8.10565e-19
C85	VPWR	B1#5	8.15937e-19
C86	VGND	C1#4	1.49732e-19
C87	A1	A2#3	1.28871e-19
C88	VPWR	B1#6	7.8198e-19
C89	VPWR#4	A1#5	2.36762e-20
C90	a_30_84##2	C1#2	8.71309e-20
C91	VPWR	A2#6	1.71216e-18
C92	VGND	A2#5	6.78415e-19
C93	VGND	A2#1	6.59288e-19
C94	VPWR	A2#4	1.44266e-18
C95	Y	C1#6	2.15117e-17
C96	VGND	A1#8	7.28229e-19
C97	A2	A2#3	1.83106e-17
C98	VPWR	A1#5	1.33495e-18
C99	VGND	A1#6	1.62048e-18
C100	Y	C1#1	2.81658e-17
C101	VPWR	A1#7	6.45081e-19
C102	C1#2	Y#6	1.132e-19
C103	A2	A1#3	2.41129e-17
C104	Y	B1#5	1.58761e-18
C105	VGND#1	A1#6	3.80848e-17
C106	B1	C1#3	1.17733e-19
C107	a_505_368##2	a_505_368#	2.34568e-18
C108	VGND#2	VGND#1	9.18442e-19
C109	VGND	a_505_368##2	2.51022e-18
C110	B1	A2#3	5.38999e-18
C111	C1#3	C1#2	4.02518e-18
C112	VGND	a_30_84#	2.01753e-17
C113	VGND	Y#4	8.52894e-18
C114	VPWR	VPWR#6	3.6216e-17
C115	VGND	a_303_84##3	8.62281e-18
C116	C1#2	VNB	2.4904e-17
C117	VGND	a_30_84##2	5.44677e-17
C118	B1#4	VNB	5.24333e-17
C119	A2#2	VNB	2.20138e-17
C120	A1#2	VNB	5.23654e-17
C121	A1#4	VNB	4.73849e-17
C122	VGND	a_303_84##4	1.1227e-17
C123	VPWR	Y#5	1.5835e-17
C124	VGND	a_303_84#	1.36345e-17
C125	VGND	VGND#1	4.37995e-17
C126	A2	B1#6	9.57007e-19
C127	a_505_368#	VPWR#7	9.36041e-17
C128	VPWR	a_505_368##4	2.65595e-17
C129	VGND	C1#7	4.88968e-18
C130	VPWR	Y#1	1.05585e-17
C131	VPWR	a_505_368##2	1.27627e-17
C132	VPWR	VPWR#7	2.19207e-17
C133	A2	A2#4	2.33773e-18
C134	VPWR	a_505_368#	1.7623e-17
C135	VPWR#6	Y	5.61712e-17
C136	A2	A1#5	9.24219e-19
C137	B1	C1#6	2.26746e-19
C138	Y	Y#6	5.86575e-19
C139	A2	A1#7	6.29882e-19
C140	Y	VPWR#9	5.19797e-17
C141	B1	C1#1	1.82399e-18
C142	Y	Y#5	1.9392e-18
C143	VGND	a_303_84##2	5.01511e-18
C144	A1	A2#5	4.2599e-19
C145	B1	B1#5	2.04346e-18
C146	A1	A2#1	5.04749e-19
C147	Y#2	B1#4	2.51275e-18
C148	VGND	VGND#2	4.36255e-17
C149	A1	A1#8	8.82169e-19
C150	B1	B1#6	2.02285e-18
C151	VGND	VGND#3	3.68635e-17
C152	A1	A1#6	3.65479e-18
C153	VPWR#5	B1#4	2.04712e-20
C154	B1	A2#6	3.91949e-19
C155	VPWR	C1#9	3.52932e-18
C156	Y#3	C1#2	4.92944e-18
C157	a_303_84##3	Y#1	3.81208e-19
C158	Y#3	Y#2	6.21728e-19
C159	VPWR	Y#2	5.29486e-18
C160	VGND#4	C1#3	6.9894e-20
C161	VPWR	Y#3	1.20617e-18
C162	A1	a_505_368#	2.5243e-17
C163	C1#9	VPWR#6	3.48804e-17
C164	a_303_84##2	B1#1	2.66659e-20
C165	VGND#4	A2#3	3.04332e-19
C166	A2	a_505_368##4	3.72756e-19
C167	VPWR	VPWR#4	3.10841e-17
C168	A2	Y#1	5.15255e-17
C169	VPWR	VPWR#5	3.29083e-17
C170	VPWR#3	A2#3	2.42591e-19
C171	A2	a_505_368##2	1.21526e-18
C172	VGND#1	A1	3.07271e-17
C173	Y#4	A2	1.33255e-18
C174	a_303_84##3	A2	1.09375e-17
C175	a_30_84#	Y#4	5.93599e-17
C176	a_303_84##2	A2#5	1.93096e-17
C177	A2	VGND#6	2.64776e-18
C178	Y#3	B1#4	4.51282e-19
C179	A2	a_303_84##4	2.52587e-18
C180	Y	VPWR#5	1.66935e-17
C181	A2#3	A2#6	2.5332e-18
C182	a_303_84##2	A2#1	1.67515e-17
C183	Y#4	B1	1.2156e-17
C184	a_30_84##4	B1	3.90356e-17
C185	B1	a_303_84##3	5.27385e-17
C186	Y#4	a_30_84##4	4.47217e-17
C187	VGND	A1#2	1.21776e-20
C188	a_303_84##2	A2	6.14517e-17
C189	VGND	A1#4	1.96646e-19
C190	B1#4	A2#3	1.33347e-17
C191	C1#6	C1#1	4.7496e-17
C192	VGND#2	A2#5	7.36312e-19
C193	a_303_84##2	A1#8	6.72596e-20
C194	A2#3	A2#2	3.96567e-18
C195	a_30_84#	a_30_84##2	2.88685e-18
C196	B1#4	Y#5	5.48219e-19
C197	VPWR#3	A2#6	4.45505e-18
C198	VPWR#6	Y#3	2.18872e-17
C199	a_303_84#	a_505_368##2	5.1956e-19
C200	B1#1	A2#3	5.79891e-19
C201	VGND#3	A2#5	5.66618e-18
C202	C1#3	VPWR#6	6.98348e-18
C203	C1#1	B1#5	4.75354e-17
C204	C1#3	Y#6	6.11892e-20
C205	a_30_84##2	Y#4	2.76048e-17
C206	a_30_84##4	a_303_84##3	8.82521e-17
C207	a_303_84##2	A1#6	3.38044e-20
C208	VGND#2	A2#1	4.7744e-18
C209	VGND#4	C1#5	3.8754e-18
C210	B1	Y#2	7.56186e-17
C211	Y#3	Y#6	2.83793e-18
C212	B1#5	B1#6	4.58915e-17
C213	Y#3	B1	3.69045e-17
C214	VGND#4	C1#4	3.8754e-18
C215	VGND#3	A2#1	7.85566e-19
C216	a_30_84##2	a_30_84##4	2.88814e-18
C217	Y#2	VPWR#9	1.04688e-17
C218	VGND#4	B1#7	3.90812e-18
C219	C1#2	B1#4	1.97384e-17
C220	VGND#4	B1#1	3.89644e-18
C221	B1#6	A2#6	5.083e-18
C222	VPWR	A1#2	6.51024e-19
C223	VGND#2	A1#8	4.99995e-18
C224	Y#3	VPWR#9	1.0881e-17
C225	a_30_84##4	VGND#6	5.45656e-18
C226	A1#3	A2#2	5.24024e-18
C227	a_30_84##2	a_303_84##3	6.00704e-18
C228	a_30_84#	C1#3	4.47824e-18
C229	A1#3	A1#2	8.97423e-18
C230	Y#2	Y#5	1.36226e-18
C231	Y#4	C1#3	4.53104e-18
C232	A2#6	A2#4	4.69347e-17
C233	A2#3	a_505_368##4	2.09851e-18
C234	A1#3	A1#4	1.95379e-17
C235	A2#3	Y#1	3.31903e-17
C236	a_30_84##4	a_303_84##4	8.62981e-19
C237	VGND#2	A1#6	7.97303e-19
C238	Y#3	Y#5	3.99683e-19
C239	a_30_84##2	C1#3	1.33667e-19
C240	A2#4	A1#5	4.73693e-17
C241	Y#2	VPWR#8	3.88555e-17
C242	a_303_84##3	a_303_84##4	1.11654e-18
C243	VPWR#3	VPWR#6	2.7231e-17
C244	a_30_84##2	VGND#6	3.12532e-17
C245	A1#3	a_505_368##2	2.29871e-17
C246	A1#3	VPWR#7	3.7222e-18
C247	Y#4	A2#3	5.3101e-19
C248	Y#3	VPWR#8	6.47117e-20
C249	C1#7	a_30_84#	3.56683e-17
C250	A1#5	A1#7	3.76648e-17
C251	A1#3	a_505_368#	3.23686e-17
C252	C1#7	C1#3	2.27595e-17
C253	a_303_84##3	A2#3	1.83128e-18
C254	C1#9	C1#3	9.31232e-18
C255	C1#6	VPWR#6	3.37448e-17
C256	A2#3	VGND#6	2.65427e-18
C257	C1#7	Y#4	1.82796e-17
C258	C1#6	Y#6	2.32753e-17
C259	a_505_368##4	VPWR#3	4.93474e-17
C260	a_505_368##4	A2#2	3.16559e-20
C261	Y#2	Y#1	3.08802e-19
C262	VGND#6	a_303_84##4	3.80688e-17
C263	VPWR#6	C1#1	1.23306e-18
C264	Y#1	VPWR#3	6.53982e-19
C265	VPWR#9	C1#6	6.79311e-19
C266	C1#1	Y#6	2.20025e-17
C267	VGND#4	a_30_84#	4.83253e-17
C268	a_303_84##2	A2#2	1.39441e-18
C269	VPWR#6	B1#5	2.59902e-19
C270	Y#3	C1#3	4.40117e-18
C271	VGND#4	C1#2	8.85024e-21
C272	C1#1	VPWR#9	2.84458e-17
C273	VGND#6	VGND#5	2.37277e-18
C274	Y#5	C1#1	1.84306e-18
C275	a_303_84#	A1#3	4.82755e-17
C276	A1	A2#2	1.06938e-19
C277	A1	A1#2	2.09544e-17
C278	VGND#4	B1#4	5.70251e-20
C279	B1#5	VPWR#9	2.47104e-17
C280	A1	A1#4	2.7267e-19
C281	VGND#1	A1#3	3.03894e-18
C282	Y#2	VPWR#4	3.13618e-19
C283	VGND#4	a_303_84##3	1.58421e-18
C284	VPWR#8	C1#1	1.72497e-19
C285	C1#5	C1#4	3.90059e-17
C286	a_303_84##4	VGND#5	3.80939e-17
C287	VPWR#6	VPWR#5	7.0017e-19
C288	VGND#4	a_30_84##2	1.24689e-16
C289	Y#5	B1#5	4.59312e-17
C290	VGND#2	a_303_84##2	3.0608e-19
C291	a_303_84#	A1#4	7.65467e-18
C292	VPWR#9	B1#6	6.1269e-19
C293	VPWR#8	B1#5	3.71489e-19
C294	A2#2	Y#1	4.7838e-19
C295	Y#5	B1#6	5.25131e-17
C296	Y#2	VPWR#5	3.13618e-19
C297	a_303_84##4	a_303_84#	2.35256e-18
C298	C1#4	B1#7	2.85295e-17
C299	VPWR#9	A2#6	5.6282e-20
C300	B1#6	VPWR#8	4.24163e-17
C301	VGND#3	a_303_84##2	3.0608e-19
C302	Y#5	A2#6	3.20173e-19
C303	a_505_368##4	B1#6	1.36503e-18
C304	VGND#4	VGND#1	2.76693e-17
C305	a_505_368##2	B1#5	1.6275e-19
C306	VPWR#5	C1#3	4.4995e-20
C307	a_303_84#	VGND#5	4.48433e-17
C308	VPWR#8	A2#6	1.26648e-18
C309	a_303_84##2	A2#3	3.29169e-17
C310	VGND#4	C1#7	5.97387e-19
C311	B1#7	B1#1	2.92575e-17
C312	Y#1	B1#6	4.04218e-19
C313	A2	B1#4	4.87993e-18
C314	A1#2	VGND#1	7.06603e-18
C315	Y#3	VPWR#5	3.13618e-19
C316	A2	A2#2	1.79051e-17
C317	a_303_84##2	a_505_368##2	8.68071e-18
C318	A2	A1#2	1.72389e-19
C319	a_505_368##4	A2#6	4.72415e-17
C320	A2	A1#4	6.37946e-18
C321	a_505_368##2	B1#6	2.55948e-19
C322	VPWR#3	A2#2	5.30931e-22
C323	VGND#5	VGND#1	2.2091e-18
C324	Y#1	A2#6	5.81568e-17
C325	VPWR#7	B1#6	3.50549e-20
C326	VGND#2	A2#3	5.08301e-21
C327	a_505_368##4	A2#4	8.23226e-18
C328	B1#1	A2#5	4.61952e-18
C329	Y#5	VPWR#4	8.43957e-18
C330	a_505_368##2	A2#6	8.58593e-19
C331	VGND#3	A2#3	4.28043e-20
C332	Y#1	A2#4	5.27075e-17
C333	VPWR#7	A2#6	2.35392e-19
C334	a_303_84#	VGND#1	5.94119e-17
C335	a_505_368##4	A1#5	1.83236e-19
C336	Y#5	VPWR#5	8.48902e-18
C337	a_505_368##2	A2#4	2.44548e-17
C338	VGND#2	A1#3	2.2508e-19
C339	A2#5	A2#1	4.04463e-17
C340	Y#1	A1#5	1.60785e-18
C341	VPWR#7	A2#4	2.37679e-18
C342	Y#4	Y#3	1.54687e-18
C343	a_505_368##2	A1#5	5.9625e-17
C344	a_505_368#	A2#4	2.00227e-19
C345	a_505_368##2	A1#4	3.05629e-19
C346	VPWR#7	A1#5	5.2642e-17
C347	Y#2	VPWR#3	9.4635e-19
C348	VGND#4	a_303_84##2	4.38299e-19
C349	A2#1	A1#8	3.77587e-17
C350	a_505_368##2	A1#7	6.97159e-19
C351	a_30_84##4	Y#3	1.13419e-18
C352	C1#9	C1#6	8.47816e-18
C353	a_505_368#	A1#5	2.08473e-18
C354	a_303_84##3	Y#2	1.00056e-17
C355	VPWR#4	a_505_368##4	1.77757e-18
C356	A1#7	VPWR#7	2.87647e-17
C357	C1#9	C1#2	1.14583e-19
C358	VGND#3	VGND#2	1.15097e-18
C359	a_505_368#	A1#7	5.69278e-17
C360	C1#9	C1#1	2.20678e-19
C361	VGND#4	VGND#2	4.23354e-17
C362	A1#8	A1#6	3.23585e-17
C363	VGND#4	VGND#3	2.5486e-17
C364	B1	C1#2	8.95697e-18
C365	B1	B1#4	3.5041e-17
C366	VPWR#7	A1#4	1.24093e-18
C367	a_30_84##2	Y#3	4.61571e-19
C368	Y#3	C1#6	1.03722e-17
C369	Y#2	C1#1	1.56509e-19
C370	a_30_84#	C1#5	3.00524e-17
C371	Y#3	C1#1	2.373e-17
C372	Y#4	C1#5	3.55817e-17
C373	a_303_84##3	a_303_84##2	1.08464e-19
C374	VPWR#3	VPWR#4	2.54385e-17
C375	a_30_84#	C1#4	8.54052e-19
C376	VPWR#3	VPWR#5	4.29927e-17
C377	A1#2	a_505_368#	6.76903e-18
C378	VGND#2	A2#2	3.63226e-20
C379	Y#2	B1#5	1.75337e-17
C380	VPWR#4	VPWR#7	5.76365e-20
C381	A2#2	A1#4	2.84063e-17
C382	VPWR#6	VPWR#9	1.94092e-18
C383	Y#4	C1#4	3.62282e-17
C384	Y#3	B1#5	7.11082e-19
C385	a_30_84#	B1#7	1.89192e-19
C386	C1#1	B1#4	1.06751e-18
C387	a_505_368#	A1#4	3.07159e-18
C388	C1#4	a_30_84##4	9.09718e-18
C389	a_30_84##2	C1#5	7.95965e-19
C390	Y#2	B1#6	2.33941e-17
C391	Y#4	B1#7	1.46687e-18
C392	Y#3	B1#6	3.02677e-19
C393	a_30_84##4	B1#7	3.91589e-17
C394	a_30_84##2	C1#4	1.19355e-17
C395	a_303_84##2	VGND#6	3.32447e-17
C396	Y#4	B1#1	4.13907e-19
C397	Y#4	C1#2	5.17961e-18
C398	B1#7	a_303_84##3	1.7883e-17
C399	Y#2	A2#6	8.40454e-20
C400	VPWR#9	Y#5	5.21059e-17
C401	VGND#2	A1#4	1.85348e-19
C402	a_30_84##4	B1#1	8.00003e-18
C403	VPWR#5	C1#6	2.3606e-18
C404	Y#3	A2#6	1.39778e-19
C405	A2#1	A1#4	4.26579e-19
C406	a_30_84##2	B1#7	1.53537e-17
C407	Y#4	A2#5	1.28749e-19
C408	A1#4	A1#2	3.19875e-18
C409	VPWR#9	VPWR#8	1.94092e-18
C410	a_303_84##3	B1#1	4.011e-17
C411	a_303_84##2	a_303_84##4	8.2185e-19
C412	a_30_84##4	A2#5	4.00017e-19
C413	VPWR#4	C1#1	8.74044e-20
C414	a_30_84##2	B1#1	3.95686e-17
C415	Y#5	VPWR#8	5.29637e-17
C416	Y#4	B1#4	8.3436e-19
C417	a_303_84##4	B1#7	1.01346e-19
C418	VPWR#5	C1#1	5.10975e-18
C419	a_303_84##3	A2#5	3.99198e-19
C420	VGND#6	B1#1	7.85771e-19
C421	a_30_84##4	A2#1	8.79303e-20
C422	a_303_84##2	VGND#5	2.17248e-17
C423	a_30_84##2	A2#5	1.2363e-18
C424	a_303_84##4	B1#1	3.56854e-19
C425	VPWR#4	B1#5	5.45681e-19
C426	a_303_84##3	A2#1	1.12891e-19
C427	C1#7	Y#3	8.45895e-18
C428	VGND#6	A2#5	4.40183e-17
C429	Y#5	Y#1	1.17639e-18
C430	VPWR#8	a_505_368##4	5.52566e-17
C431	a_30_84##2	VGND#3	2.64828e-18
C432	VPWR#5	B1#5	5.10124e-18
C433	a_303_84##2	a_303_84#	1.86016e-19
C434	A2#5	a_303_84##4	1.81188e-17
C435	a_505_368##2	Y#5	2.07242e-22
C436	VGND#6	A2#1	1.26363e-18
C437	VPWR#4	B1#6	5.77581e-18
C438	VGND#5	A2#5	1.44278e-18
C439	a_30_84##4	B1#4	1.31486e-18
C440	VPWR#5	B1#6	5.03407e-19
C441	Y#1	a_505_368##4	9.62681e-17
C442	A2#1	a_303_84##4	1.4494e-17
C443	VGND#2	a_303_84##4	5.20928e-18
C444	a_303_84#	A2#5	2.07083e-19
C445	VPWR#5	VPWR#4	6.99578e-19
C446	C1#9	Y#3	2.27322e-17
C447	VGND#5	A2#1	2.80915e-17
C448	a_505_368##4	a_505_368##2	2.14025e-18
C449	VPWR#4	A2#6	8.90181e-19
C450	a_303_84##4	A1#8	8.50636e-19
C451	VGND#3	a_303_84##4	5.24783e-18
C452	a_303_84#	A2#1	4.78799e-19
C453	VPWR#5	A2#6	1.76788e-20
C454	Y#1	a_505_368##2	6.16586e-17
C455	VGND#5	A1#8	3.23054e-17
C456	VPWR#2	A2#4	4.4402e-18
C457	VPWR#2	A2#2	3.64067e-21
C458	VPWR#4	VPWR#2	2.13734e-19
C459	a_505_368#	VPWR#2	2.09564e-17
C460	VPWR#3	VPWR#2	6.89798e-17
C461	a_505_368##2	VPWR#2	2.46545e-17
C462	a_505_368##4	VPWR#2	1.06922e-17
C463	A1	VPWR#2	4.23299e-19
C464	VPWR	VPWR#2	4.10674e-17
C465	VPWR#2	A1#7	2.59352e-18
C466	VPWR#2	VNB	5.98414e-17
C467	VPWR#2	A1#5	1.85655e-18
C468	VPWR#2	A1#2	4.23702e-19
*
*
.ENDS sky130_fd_sc_hs__o211ai_2
*
