* Extracted by Quantus, converted by sky130cad/quantus.py
*
*
*
*                       LINUX           Wed Nov 18 09:11:39 2026
*
*
*
*  PROGRAM  advgen
*
*  Name           : advgen - Quantus - (64-bit)
*  Version        : 25.1.0-p047
*  Build Date     : Thu Dec 11 23:20:30 PST 2025
*
*  HSPICE LIBRARY
*
*  OPERATING_TEMPERATURE 150
*  QRC_TECH_DIR <path>/tech
*
*
*

*
.SUBCKT sky130_fd_sc_hs__sdfxtp_2 VNB VPB VGND VPWR Q SCE D CLK SCD
*
*
*  caps2d version: 10
*
*
*       TRANSISTOR CARDS
*
*
XM3 a_27_74##9 SCE#5 VGND#15 VNB sky130_fd_pr__nfet_01v8_lvt l=0.15 w=0.42 ad=0.1386 as=0.147 pd=1.5 ps=1.54
XM32 VGND#15 a_27_74# a_223_74# VNB sky130_fd_pr__nfet_01v8_lvt l=0.15 w=0.42 ad=0.147 as=0.1008 pd=1.54 ps=1.32
XM28 a_223_74# D#1 a_300_453##6 VNB sky130_fd_pr__nfet_01v8_lvt l=0.15 w=0.42 ad=0.1008 as=0.2331 pd=1.32 ps=1.95
XM0 a_300_453##6 SCE#6 a_442_74# VNB sky130_fd_pr__nfet_01v8_lvt l=0.15 w=0.42 ad=0.2331 as=0.1008 pd=1.95 ps=1.32
XM18 a_442_74# SCD#3 VGND#14 VNB sky130_fd_pr__nfet_01v8_lvt l=0.15 w=0.42 ad=0.1008 as=0.2676 pd=1.32 ps=2.32
XM4 VGND#14 CLK#3 a_634_74##14 VNB sky130_fd_pr__nfet_01v8_lvt l=0.15 w=0.74 ad=0.2676 as=0.2109 pd=2.32 ps=2.05
XM14 VGND#13 a_634_74##7 a_846_74##13 VNB sky130_fd_pr__nfet_01v8_lvt l=0.15 w=0.74 ad=0.2627 as=0.2109 pd=2.19 ps=2.05
XM23 a_300_453##5 a_634_74##6 a_1044_100##7 VNB sky130_fd_pr__nfet_01v8_lvt l=0.15 w=0.42 ad=0.1197 as=0.3045 pd=1.41 ps=2.29
XM17 a_1044_100##7 a_846_74##4 a_1219_100# VNB sky130_fd_pr__nfet_01v8_lvt l=0.15 w=0.42 ad=0.3045 as=0.1764 pd=2.29 ps=1.68
XM16 a_1219_100# a_1287_320##4 VGND#12 VNB sky130_fd_pr__nfet_01v8_lvt l=0.15 w=0.42 ad=0.1764 as=0.45145 pd=1.68 ps=2.9
XM25 VGND#12 a_1044_100# a_1287_320##5 VNB sky130_fd_pr__nfet_01v8_lvt l=0.15 w=0.55 ad=0.45145 as=0.3795 pd=2.9 ps=2.48
XM9 a_1287_320##5 a_846_74##5 a_1592_424##7 VNB sky130_fd_pr__nfet_01v8_lvt l=0.15 w=0.55 ad=0.3795 as=0.18825 pd=2.48 ps=1.82
XM33 a_1592_424##7 a_634_74##9 a_1787_74# VNB sky130_fd_pr__nfet_01v8_lvt l=0.15 w=0.42 ad=0.18825 as=0.1008 pd=1.82 ps=1.32
XM30 a_1787_74# a_1829_398# VGND#11 VNB sky130_fd_pr__nfet_01v8_lvt l=0.15 w=0.42 ad=0.1008 as=0.227 pd=1.32 ps=2.18
XM21 VGND#11 a_1592_424##3 a_1829_398##16 VNB sky130_fd_pr__nfet_01v8_lvt l=0.15 w=0.74 ad=0.227 as=0.2109 pd=2.18 ps=2.05
XM27 VGND#4 a_1829_398##9 Q#3 VNB sky130_fd_pr__nfet_01v8_lvt l=0.15 w=0.74 ad=0.2627 as=0.2405 pd=2.19 ps=2.13
XM5 Q#3 a_1829_398##8 VGND#1 VNB sky130_fd_pr__nfet_01v8_lvt l=0.15 w=0.74 ad=0.2405 as=0.2294 pd=2.13 ps=2.1
XM13 a_27_74##7 SCE#3 VPWR#14 VPB sky130_fd_pr__pfet_01v8 l=0.15 w=0.64 ad=0.1888 as=0.224 pd=1.87 ps=1.98
XM26 VPWR#14 SCE#1 a_216_453# VPB sky130_fd_pr__pfet_01v8 l=0.15 w=0.64 ad=0.224 as=0.1728 pd=1.98 ps=1.82
XM10 a_216_453# D#3 a_300_453##4 VPB sky130_fd_pr__pfet_01v8 l=0.15 w=0.64 ad=0.1728 as=0.3488 pd=1.82 ps=2.37
XM11 a_300_453##4 a_27_74##3 a_439_453# VPB sky130_fd_pr__pfet_01v8 l=0.15 w=0.64 ad=0.3488 as=0.1728 pd=2.37 ps=1.82
XM22 a_439_453# SCD#1 VPWR#12 VPB sky130_fd_pr__pfet_01v8 l=0.15 w=0.64 ad=0.1728 as=0.575125 pd=1.82 ps=3.7
XM15 VPWR#12 CLK#4 a_634_74##12 VPB sky130_fd_pr__pfet_01v8 l=0.15 w=1.12 ad=0.575125 as=0.3304 pd=3.7 ps=2.83
XM7 VPWR#9 a_634_74##8 a_846_74##16 VPB sky130_fd_pr__pfet_01v8 l=0.15 w=1.12 ad=0.6426 as=0.3304 pd=3.56 ps=2.83
XM12 a_300_453# a_846_74# a_1044_100##8 VPB sky130_fd_pr__pfet_01v8 l=0.15 w=0.42 ad=0.1239 as=0.126 pd=1.43 ps=1.44
XM2 a_1044_100##8 a_634_74# a_1210_508# VPB sky130_fd_pr__pfet_01v8 l=0.15 w=0.42 ad=0.126 as=0.168 pd=1.44 ps=1.64
XM31 a_1210_508# a_1287_320##3 VPWR#7 VPB sky130_fd_pr__pfet_01v8 l=0.15 w=0.42 ad=0.168 as=0.3339 pd=1.64 ps=2.74
XM6 VPWR#7 a_1044_100##4 a_1287_320##8 VPB sky130_fd_pr__pfet_01v8 l=0.15 w=0.84 ad=0.3339 as=0.4452 pd=2.74 ps=2.74
XM1 a_1287_320##8 a_634_74##11 a_1592_424##6 VPB sky130_fd_pr__pfet_01v8 l=0.15 w=0.84 ad=0.4452 as=0.2943 pd=2.74 ps=2.5
XM19 a_1592_424##6 a_846_74##7 a_1704_496# VPB sky130_fd_pr__pfet_01v8 l=0.15 w=0.42 ad=0.2943 as=0.2688 pd=2.5 ps=2.12
XM24 a_1704_496# a_1829_398##3 VPWR#5 VPB sky130_fd_pr__pfet_01v8 l=0.15 w=0.42 ad=0.2688 as=0.4267 pd=2.12 ps=3.3
XM20 VPWR#5 a_1592_424# a_1829_398##11 VPB sky130_fd_pr__pfet_01v8 l=0.15 w=1 ad=0.4267 as=0.295 pd=3.3 ps=2.59
XM29 VPWR#4 a_1829_398##10 Q#1 VPB sky130_fd_pr__pfet_01v8 l=0.15 w=1.12 ad=0.3304 as=0.336 pd=2.83 ps=2.84
XM8 Q#1 a_1829_398##4 VPWR#1 VPB sky130_fd_pr__pfet_01v8 l=0.15 w=1.12 ad=0.336 as=0.3304 pd=2.84 ps=2.83
*
*
*       RESISTOR AND CAP/DIODE CARDS
*
Rg1	SCE#1	SCE#2	484.685455
Rg2	SCE#2	SCE#3	234.008942
Rg3	SCE#2	SCE#4	675.896790
Rg4	SCE#4	SCE#5	210.607346
Rg5	a_27_74#	a_27_74##2	746.917175
Rg6	D#1	D#2	428.426666
Rg7	D#2	D#3	454.185822
Rg8	a_27_74##3	a_27_74##4	296.912354
Rg9	SCE#6	SCE#7	215.537628
Rg10	SCD#1	SCD#2	346.737671
Rg11	SCD#2	SCD#3	581.441467
Rg12	CLK#1	CLK#2	30.629444
Rg13	CLK#2	CLK#3	412.192505
Rg14	CLK#2	CLK#4	419.554810
Rg15	a_846_74#	a_846_74##2	462.513947
Rg16	a_634_74#	a_634_74##2	285.594727
Rg17	a_634_74##2	a_634_74##3	688.743286
Rg18	a_634_74##3	a_634_74##4	321.071167
Rg19	a_634_74##4	a_634_74##5	14.123409
Rg20	a_634_74##3	a_634_74##6	300.003082
Rg21	a_634_74##4	a_634_74##7	282.399872
Rg22	a_634_74##5	a_634_74##8	452.765808
Rg23	a_846_74##3	a_846_74##4	216.119781
Rg24	a_1287_320#	a_1287_320##2	30.613651
Rg25	a_1287_320##2	a_1287_320##3	712.420044
Rg26	a_1287_320##2	a_1287_320##4	251.281769
Rg27	a_1044_100#	a_1044_100##2	614.449951
Rg28	a_1044_100##2	a_1044_100##3	34.566891
Rg29	a_1044_100##2	a_1044_100##4	339.214142
Rg30	a_846_74##5	a_846_74##6	413.653595
Rg31	a_846_74##7	a_846_74##8	227.952118
Rg32	a_634_74##9	a_634_74##10	1038.651123
Rg33	a_634_74##10	a_634_74##11	372.084137
Rg34	a_1829_398#	a_1829_398##2	600.270935
Rg35	a_1829_398##2	a_1829_398##3	427.071411
Rg36	a_1592_424#	a_1592_424##2	417.171356
Rg37	a_1592_424##2	a_1592_424##3	449.065155
Rg38	a_1829_398##4	a_1829_398##5	507.075531
Rg39	a_1829_398##5	a_1829_398##6	66.369736
Rg40	a_1829_398##6	a_1829_398##7	61.366196
Rg41	a_1829_398##5	a_1829_398##8	322.953644
Rg42	a_1829_398##6	a_1829_398##9	321.855652
Rg43	a_1829_398##6	a_1829_398##10	506.463013
Rf1	D#4	D	1.601727
Rf2	D#2	D#6	81.718132
Rf3	D#4	D#6	6.098412
Rf4	SCE#7	SCE	247.705109
Rf5	SCE	SCE#4	164.296555
Rf6	a_27_74##4	a_27_74##6	243.236816
Rf7	a_27_74##6	a_27_74##7	27.930332
Rf8	a_27_74##6	a_27_74##2	7.798740
Rf9	a_27_74##2	a_27_74##9	90.212082
Rf10	SCD	SCD#4	10.432326
Rf11	SCD#4	SCD	4.133563
Rf12	CLK#1	CLK#6	162.448425
Rf13	CLK#7	CLK	2.215620
Rf14	CLK#6	CLK#7	4.973462
Rf15	a_634_74##12	a_634_74##13	58.004807
Rf16	a_634_74##13	a_634_74##14	88.248245
Rf17	a_300_453#	a_300_453##2	83.281937
Rf18	a_300_453##2	a_300_453##3	99.811157
Rf19	a_300_453##3	a_300_453##4	65.642296
Rf20	a_300_453##2	a_300_453##5	155.144882
Rf21	a_300_453##3	a_300_453##6	204.632446
Rf22	a_1044_100##3	a_1044_100##6	246.784271
Rf23	a_1044_100##6	a_1044_100##7	69.246063
Rf24	a_1044_100##6	a_1044_100##8	85.362946
Rf25	a_1287_320##5	a_1287_320##6	45.152573
Rf26	a_1287_320##6	a_1287_320#	104.733025
Rf27	a_1287_320##6	a_1287_320##8	92.793877
Rf28	a_634_74##10	a_634_74##2	571.738647
Rf29	a_846_74##8	a_846_74##6	232.851791
Rf30	a_846_74##6	a_846_74##11	223.228073
Rf31	a_846_74##11	a_846_74##12	82.560844
Rf32	a_846_74##12	a_846_74##13	82.548958
Rf33	a_846_74##11	a_846_74##3	176.188629
Rf34	a_846_74##12	a_846_74##2	102.006912
Rf35	a_846_74##2	a_846_74##16	28.634605
Rf36	a_1592_424##2	a_1592_424##5	241.647552
Rf37	a_1592_424##5	a_1592_424##6	96.828224
Rf38	a_1592_424##5	a_1592_424##7	134.897827
Rf39	a_1829_398##11	a_1829_398##12	94.796745
Rf40	a_1829_398##12	a_1829_398##13	31.543482
Rf41	a_1829_398##13	a_1829_398##2	221.452316
Rf42	a_1829_398##12	a_1829_398##7	95.172516
Rf43	a_1829_398##13	a_1829_398##16	20.511896
Rf44	Q	Q#2	0.196836
Rf45	Q#2	Q	14.369054
Rf46	Q	Q#3	88.745026
Rf47	Q#1	Q#2	5.000000
Rf48	VPWR#1	VPWR#2	118.564102
Rf49	VPWR#2	VPWR#3	107.891876
Rf50	VPWR#2	VPWR#4	48.259808
Rf51	VPWR#3	VPWR#5	19.688698
Rf52	VPWR#3	VPWR#6	193.616623
Rf53	VPWR#6	VPWR#7	40.352859
Rf54	VPWR#6	VPWR#8	188.072479
Rf55	VPWR#8	VPWR#9	23.149088
Rf56	VPWR#8	VPWR#10	56.548763
Rf57	VPWR#10	VPWR#11	32.807861
Rf58	VPWR#11	VPWR#12	23.498108
Rf59	VPWR#11	VPWR#13	155.508148
Rf60	VPWR#13	VPWR#14	32.518913
Rf62	VGND#1	VGND#2	100.525673
Rf63	VGND#2	VGND#3	103.529419
Rf64	VGND#2	VGND#4	36.797676
Rf65	VGND#3	VGND#5	180.775436
Rf66	VGND#5	VGND#6	220.198181
Rf67	VGND#6	VGND#7	37.231220
Rf68	VGND#7	VGND#8	37.645748
Rf69	VGND#8	VGND#9	147.562210
Rf71	VGND#3	VGND#11	38.005394
Rf72	VGND#5	VGND#12	26.830879
Rf73	VGND#6	VGND#13	35.098007
Rf74	VGND#8	VGND#14	39.437531
Rf75	VGND#9	VGND#15	32.735970
Rf83	a_634_74##5	a_634_74##13	160.232803
Rf81	SCD#2	SCD#4	80.116402
Re1	VPWR#3	VPWR	2.179561
Re2	VPWR	VPWR#10	1.712512
Re3	VGND#3	VGND	2.179561
Re4	VGND	VGND#7	1.712512
*
*       CAPACITOR CARDS
*
*
C1	a_634_74##5	a_300_453##5	2.97428e-17
C2	VGND#8	a_27_74#	8.35461e-20
C3	a_1592_424##5	a_1704_496#	4.66484e-18
C4	VGND#15	CLK#3	3.42534e-19
C5	VGND#3	a_1829_398#	8.98295e-18
C6	a_634_74##5	a_846_74##13	1.90735e-17
C7	a_300_453##3	CLK#4	4.0072e-17
C8	D#2	a_27_74##6	5.7752e-18
C9	VGND#14	D#1	3.05852e-19
C10	a_634_74##11	a_846_74##7	1.99843e-17
C11	a_1592_424##5	a_1829_398##11	4.66521e-18
C12	a_634_74##5	VGND#13	3.13046e-17
C13	a_634_74##5	a_634_74##4	2.34213e-17
C14	VGND#3	a_634_74##9	5.73535e-18
C15	a_634_74##14	a_300_453##3	1.81775e-17
C16	a_300_453##6	SCE#6	4.03554e-17
C17	a_1287_320##8	a_1044_100##3	2.47968e-17
C18	a_300_453##2	CLK#4	9.11918e-19
C19	a_634_74##5	a_634_74##3	1.26268e-19
C20	VGND#3	a_846_74##5	6.22918e-18
C21	a_300_453##2	CLK#2	4.2513e-20
C22	VGND#15	SCD#3	2.50499e-19
C23	a_846_74##11	a_1044_100#	9.47593e-18
C24	a_1044_100##3	VPWR#7	3.00342e-18
C25	VGND#1	Q#3	7.74606e-17
C26	a_634_74##5	CLK#2	2.90069e-18
C27	VGND#14	a_27_74#	1.6391e-19
C28	VGND#3	a_1044_100#	1.82064e-18
C29	a_27_74##6	a_27_74##2	3.02938e-17
C30	a_300_453##3	a_300_453##2	1.5361e-18
C31	a_300_453##3	SCD#1	2.25652e-17
C32	a_1044_100##4	a_634_74##11	1.48141e-17
C33	VGND#15	a_300_453##6	1.17709e-17
C34	a_300_453##6	D#1	3.02839e-17
C35	a_634_74##14	CLK#1	2.80315e-17
C36	D#4	D#2	8.23238e-18
C37	a_1592_424##3	a_1829_398##7	4.43097e-18
C38	a_300_453##3	VGND#14	8.04918e-18
C39	VGND#15	SCE#6	7.45217e-19
C40	a_300_453##2	SCD#1	1.57426e-19
C41	VGND#4	VGND#1	2.38322e-18
C42	VPWR#14	a_300_453##4	2.17599e-17
C43	a_846_74##11	a_1287_320##4	2.87787e-17
C44	a_27_74##9	a_300_453##6	8.43176e-20
C45	CLK#1	a_634_74##4	4.36606e-18
C46	a_27_74##9	SCE#6	1.17961e-19
C47	a_1287_320##3	a_1044_100##4	1.90177e-17
C48	a_300_453##6	a_27_74#	1.92782e-18
C49	a_27_74##6	SCE#4	6.47334e-17
C50	a_1592_424##2	a_1592_424##3	2.09677e-18
C51	a_1287_320##6	a_634_74##9	4.89166e-19
C52	a_300_453##3	a_27_74##3	3.49583e-19
C53	VPWR#14	SCE#2	2.42349e-18
C54	a_1592_424##5	VPWR#3	4.85804e-17
C55	VGND#15	D#1	3.52214e-18
C56	D#4	a_27_74##2	1.9651e-17
C57	a_846_74##12	a_846_74##4	1.099e-18
C58	VGND#14	SCD#2	1.32904e-18
C59	CLK#1	CLK#2	1.09833e-17
C60	VGND#2	a_1829_398##7	1.63805e-18
C61	a_1044_100##8	VPWR#6	2.08601e-17
C62	VGND#4	Q#3	6.05714e-17
C63	a_634_74##2	a_1287_320##8	5.14967e-17
C64	a_1829_398##2	a_1592_424##3	1.01487e-17
C65	VGND#3	a_1829_398##13	1.15922e-17
C66	a_27_74##6	VPWR#14	4.03712e-17
C67	a_27_74##9	D#1	1.87534e-19
C68	a_300_453##6	SCE#5	1.42885e-19
C69	a_1829_398##12	Q#3	6.20144e-18
C70	a_300_453##6	SCD#2	1.06265e-17
C71	a_634_74##2	VPWR#7	7.89376e-17
C72	a_634_74#	a_1287_320##3	2.14415e-17
C73	a_846_74##11	a_846_74##4	2.10039e-17
C74	VGND#3	a_1829_398##12	6.1535e-18
C75	VGND#15	a_27_74#	2.76318e-17
C76	a_300_453#	VPWR#8	3.15232e-17
C77	a_300_453##3	D#3	1.81298e-19
C78	D#4	SCE#4	2.72482e-18
C79	a_634_74##9	a_1829_398##2	2.01671e-17
C80	a_1287_320##8	a_846_74##2	1.16659e-20
C81	a_1287_320##5	a_1287_320##2	2.27746e-20
C82	a_1044_100##8	a_634_74##2	2.14224e-17
C83	a_846_74##12	a_634_74##6	2.5779e-17
C84	a_300_453##6	a_300_453##3	1.3909e-18
C85	a_27_74##9	VGND#15	2.32526e-17
C86	a_27_74##9	a_27_74#	1.1719e-18
C87	a_27_74##7	VPWR#14	5.04335e-17
C88	VGND#6	a_846_74##13	5.17954e-17
C89	a_300_453##6	a_27_74##4	1.60273e-18
C90	VGND#2	a_1592_424##2	3.01226e-20
C91	a_27_74##6	a_27_74##7	2.58165e-19
C92	a_846_74#	a_634_74#	2.46856e-17
C93	SCE#5	VGND#15	1.63237e-17
C94	SCE#2	a_27_74##7	1.40607e-18
C95	VGND#7	CLK#3	2.34368e-18
C96	a_846_74##11	a_634_74##6	1.11822e-18
C97	VGND#8	VGND#13	3.39901e-19
C98	a_1044_100##8	a_846_74##2	1.10498e-17
C99	SCD#2	CLK#2	2.59378e-17
C100	a_846_74##6	a_1829_398#	3.2018e-19
C101	a_1287_320##6	a_1044_100#	2.06493e-17
C102	a_300_453##3	SCE#1	1.06716e-19
C103	a_1829_398##13	a_1829_398##16	1.26161e-19
C104	a_27_74##6	SCD#1	1.60949e-19
C105	a_27_74##9	SCE#5	2.16362e-17
C106	a_846_74##2	a_300_453#	3.84953e-17
C107	a_1829_398##16	VGND#4	2.711e-17
C108	a_1829_398##7	VPWR#2	9.87062e-19
C109	a_846_74##6	a_634_74##9	2.10521e-17
C110	SCE#7	a_300_453##6	1.14788e-16
C111	a_846_74##12	a_634_74##7	4.89369e-19
C112	a_634_74##8	a_846_74#	4.96456e-18
C113	a_846_74##6	a_846_74##5	1.31109e-17
C114	VPWR#3	a_1829_398##4	5.44288e-18
C115	a_300_453##3	VPWR#11	5.48694e-17
C116	VGND#3	a_1829_398##6	1.1956e-18
C117	VGND#12	a_1287_320##2	1.68779e-18
C118	a_846_74##6	a_1044_100#	3.15007e-17
C119	VPWR#3	a_1829_398##10	5.05553e-18
C120	VGND#3	a_846_74##11	1.08797e-17
C121	D#2	a_300_453##6	5.45757e-18
C122	VGND#11	VGND#4	1.81114e-18
C123	a_27_74##6	a_27_74##3	1.79202e-19
C124	a_1829_398##13	VGND#11	2.53771e-17
C125	a_846_74##6	a_1287_320##4	5.75741e-20
C126	VGND#3	a_1829_398##5	2.87134e-19
C127	VPWR#8	VPWR#9	1.11114e-17
C128	CLK#4	a_634_74##8	4.23446e-18
C129	VPWR#3	a_1592_424#	2.73397e-17
C130	a_1592_424##5	a_1787_74#	7.3385e-19
C131	a_634_74##5	VPWR#9	4.25838e-19
C132	a_300_453##3	a_216_453#	3.06648e-21
C133	a_1044_100##3	a_634_74##9	6.69701e-19
C134	a_634_74##5	a_634_74##12	2.31278e-18
C135	VPWR#3	a_1829_398##3	3.0215e-17
C136	a_300_453##3	VPWR#8	7.33626e-19
C137	a_27_74##4	SCE#2	3.02381e-19
C138	VGND#2	a_1829_398##6	1.03198e-19
C139	VGND#6	a_634_74##14	6.97604e-19
C140	a_1829_398##9	a_1829_398##8	3.0163e-17
C141	VGND#11	a_1829_398##16	4.27102e-17
C142	VPWR#3	a_1287_320##6	3.96517e-19
C143	VPWR#3	a_846_74##7	1.91442e-17
C144	SCD#1	CLK#4	1.49668e-17
C145	a_27_74##6	D#3	1.00932e-17
C146	VPWR#1	a_1829_398##4	3.14381e-17
C147	a_1829_398##12	a_1829_398##7	9.46862e-18
C148	VGND#15	a_27_74##2	2.7395e-19
C149	VPWR#3	a_634_74##11	3.01404e-18
C150	Q#1	VPWR#1	3.27905e-17
C151	a_300_453#	a_1044_100##7	1.314e-19
C152	VPWR#11	VPWR#8	6.72377e-18
C153	Q#1	a_1829_398##4	3.52736e-17
C154	VPWR#3	a_1044_100##4	1.68099e-18
C155	VGND#5	a_846_74##6	5.35033e-17
C156	a_27_74##3	SCD#1	3.65181e-17
C157	a_300_453##2	VPWR#8	6.08471e-17
C158	VPWR#1	a_1829_398##10	1.26838e-18
C159	a_634_74##12	SCD#2	5.24553e-19
C160	VPWR#11	VPWR#12	1.4626e-17
C161	VGND#2	a_1829_398##5	5.97366e-20
C162	a_1829_398##13	a_1592_424##2	4.01977e-17
C163	a_27_74##6	SCE#1	1.19613e-17
C164	VGND#3	a_1287_320##6	3.40719e-18
C165	SCE#4	VGND#15	3.00618e-18
C166	VPWR#4	a_1829_398##4	7.14071e-19
C167	a_1592_424##3	a_1829_398##9	3.1146e-18
C168	a_846_74##3	a_1044_100#	3.16464e-19
C169	VPWR#4	VPWR#1	2.00319e-18
C170	a_27_74##9	SCE#4	4.18261e-17
C171	a_1592_424##2	a_1829_398##10	1.36358e-18
C172	VGND#6	a_634_74##4	3.27554e-19
C173	a_1592_424##2	a_1829_398##12	6.0047e-17
C174	Q#1	a_1829_398##10	3.42312e-17
C175	a_846_74##3	a_1287_320##4	8.81793e-19
C176	a_1592_424##7	a_1829_398##13	1.88941e-17
C177	a_1592_424##2	a_1592_424#	1.42226e-17
C178	D#3	a_27_74##3	1.01617e-17
C179	a_1592_424##5	a_1592_424##2	2.42952e-18
C180	a_846_74##3	a_846_74##4	5.75518e-19
C181	VPWR#1	a_1592_424#	1.45169e-19
C182	VPWR#2	a_1829_398##4	2.41575e-18
C183	a_1592_424##7	a_1829_398##16	5.66654e-18
C184	VGND#5	a_1287_320##2	1.45162e-19
C185	a_1829_398##10	VPWR#4	2.55421e-17
C186	VPWR#4	Q#1	3.28374e-17
C187	a_634_74##6	a_846_74##3	1.07606e-18
C188	a_27_74##6	SCE#3	2.70409e-18
C189	a_300_453##5	a_846_74##16	1.45624e-17
C190	VGND#5	a_634_74##10	5.89384e-20
C191	a_1829_398##2	a_1592_424#	8.14499e-18
C192	a_1829_398##13	a_1829_398##2	2.50118e-18
C193	a_27_74##4	a_300_453##4	7.43008e-17
C194	a_1829_398#	a_1592_424##3	2.6245e-17
C195	a_1829_398##11	a_1829_398##10	1.41741e-18
C196	SCE#1	D#3	4.69321e-17
C197	a_1829_398##2	a_1829_398##12	3.54971e-18
C198	VPWR#10	CLK#2	9.06356e-20
C199	VGND#6	a_634_74##3	1.52454e-19
C200	VPWR#4	a_1592_424#	3.54164e-18
C201	a_1592_424##7	VGND#11	2.21261e-17
C202	VGND#1	a_1829_398##8	2.86003e-17
C203	a_1592_424##5	a_1829_398##2	9.47761e-17
C204	VGND#8	a_300_453##6	3.18116e-17
C205	D#2	CLK#2	1.27372e-19
C206	a_846_74##8	a_1829_398##3	6.24036e-18
C207	a_300_453##4	SCE#7	2.01893e-19
C208	VPWR#2	a_1829_398##10	8.01473e-18
C209	SCE#2	D#2	7.8377e-19
C210	a_300_453##3	VPWR#10	6.56226e-18
C211	a_1829_398##11	a_1592_424#	5.17143e-17
C212	a_846_74##12	a_846_74##11	2.79391e-18
C213	a_1592_424##7	a_1592_424##5	8.82749e-19
C214	SCE#3	SCE#1	2.47005e-17
C215	VGND#5	a_1044_100##3	1.69377e-20
C216	D#4	SCE#1	1.71658e-18
C217	a_846_74##11	a_1219_100#	4.43177e-18
C218	a_846_74##2	a_634_74##7	3.72408e-20
C219	VPWR#10	CLK#4	5.96066e-18
C220	a_300_453##4	VPWR#11	2.05735e-17
C221	VPWR#4	a_1829_398##3	2.5087e-19
C222	a_1829_398##8	Q#3	1.68473e-17
C223	a_1829_398##11	VPWR#4	6.6288e-17
C224	a_634_74##11	a_846_74##8	1.78232e-17
C225	a_634_74##9	a_1829_398#	5.12087e-17
C226	a_300_453##4	D#2	9.49745e-19
C227	a_1592_424#	VPWR#5	1.49065e-17
C228	VGND#1	a_1829_398##9	3.30096e-18
C229	VGND#6	CLK#2	1.80127e-19
C230	a_634_74##10	VPWR#6	5.10164e-17
C231	a_634_74##10	a_1829_398##3	5.6159e-19
C232	a_1044_100##7	a_634_74##3	8.81188e-18
C233	a_1829_398##11	a_1829_398##3	1.16421e-18
C234	a_634_74##5	a_634_74##7	5.60729e-18
C235	a_1829_398##7	a_1829_398##6	1.64782e-17
C236	a_846_74##8	a_1592_424##5	6.01774e-17
C237	VGND#4	a_1829_398##8	7.60185e-19
C238	a_1592_424##6	a_1704_496#	2.18776e-18
C239	a_846_74##11	a_1287_320##2	6.90481e-18
C240	a_634_74##10	a_846_74##7	2.00504e-18
C241	VGND#7	CLK#2	1.51041e-19
C242	VGND#5	a_634_74##3	2.48235e-19
C243	Q#3	a_1829_398##9	4.47291e-17
C244	a_1829_398##3	VPWR#5	1.30759e-17
C245	a_634_74##10	a_634_74##11	3.33411e-17
C246	VPWR#7	a_1287_320##2	7.31688e-19
C247	a_1592_424##7	a_1787_74#	1.11262e-18
C248	a_1829_398##11	a_846_74##7	1.64956e-19
C249	VGND#1	a_1592_424##3	1.57154e-19
C250	a_846_74##12	a_634_74##3	4.26461e-18
C251	a_300_453##5	a_634_74##4	3.19662e-17
C252	a_1829_398##12	a_1829_398##4	1.59145e-19
C253	a_846_74##5	a_634_74##9	1.94863e-17
C254	SCE#2	a_27_74##2	2.20686e-17
C255	a_634_74##10	a_1044_100##4	1.61117e-17
C256	a_300_453##3	CLK#3	1.44662e-17
C257	a_1044_100##3	a_634_74##11	5.1808e-18
C258	a_1829_398##9	VGND#4	1.66787e-17
C259	VPWR#6	a_1044_100##3	1.81529e-19
C260	a_846_74##6	a_1592_424##5	9.65505e-18
C261	SCD#2	CLK#3	1.04063e-18
C262	Q#3	a_1592_424##3	7.50049e-19
C263	a_1592_424##6	a_1829_398##3	1.11461e-18
C264	a_1287_320##3	a_1044_100##3	2.15705e-18
C265	VGND#2	a_1829_398##13	1.46265e-18
C266	a_300_453##5	a_634_74##3	1.19966e-17
C267	a_1829_398##16	a_1829_398##9	2.92474e-18
C268	a_1592_424##2	a_1829_398##6	7.16179e-19
C269	VGND#5	a_846_74##3	7.70054e-19
C270	a_1829_398##12	a_1829_398##10	8.13827e-19
C271	VGND#4	a_1592_424##3	3.59546e-18
C272	a_1044_100#	a_846_74##5	6.47212e-18
C273	a_1592_424##6	a_846_74##7	4.04655e-17
C274	VGND#11	a_1829_398##9	3.38825e-19
C275	a_1592_424##5	a_634_74##10	1.85104e-17
C276	a_634_74##2	a_634_74##11	1.2053e-18
C277	VGND#2	a_1829_398##8	5.20033e-19
C278	a_1592_424##5	a_1829_398##10	3.66623e-20
C279	a_846_74##13	a_634_74##4	8.41118e-18
C280	SCE#4	SCE#2	1.92004e-18
C281	a_1829_398##16	a_1592_424##3	5.09114e-17
C282	SCD	CLK#2	3.08269e-18
C283	VPWR#3	a_1829_398##7	6.04434e-18
C284	SCE#7	SCD#3	2.25469e-17
C285	a_634_74##2	a_1044_100##4	3.00129e-17
C286	a_846_74##11	a_846_74##6	2.42052e-18
C287	a_27_74##9	a_27_74##6	2.63642e-18
C288	VGND#2	a_1829_398##12	3.02179e-18
C289	a_634_74##11	a_1592_424##6	1.15845e-17
C290	VGND#4	a_1829_398#	1.43083e-19
C291	a_634_74##2	a_1287_320##3	5.24825e-17
C292	VGND#3	a_1829_398##7	7.394e-18
C293	a_1592_424##2	VPWR#3	2.64789e-17
C294	a_1287_320##2	a_1044_100#	1.84747e-17
C295	SCE#7	D#1	1.92328e-17
C296	a_1829_398##12	a_1592_424#	3.11584e-18
C297	VGND#5	a_634_74##2	5.1012e-20
C298	a_27_74##6	SCE#2	3.93882e-17
C299	a_1287_320##4	a_1044_100#	5.35826e-18
C300	a_634_74##2	a_634_74#	1.7362e-19
C301	a_1592_424##3	VGND#11	1.65794e-17
C302	VGND#3	a_1592_424##2	4.03494e-18
C303	a_1044_100##6	a_1287_320##8	7.83748e-20
C304	a_846_74##13	a_634_74##3	2.44848e-19
C305	a_634_74##11	a_1287_320##8	2.74339e-17
C306	SCE#7	a_27_74#	1.50923e-19
C307	VPWR#3	a_1829_398##2	6.16941e-18
C308	VPWR#6	a_634_74##11	5.33522e-18
C309	a_634_74##2	a_846_74#	8.50429e-20
C310	a_1592_424##5	a_1044_100##3	9.25664e-20
C311	a_1829_398##16	a_1829_398#	2.10019e-18
C312	VGND#3	VGND#1	6.38863e-17
C313	a_1829_398##6	a_1829_398##5	3.91632e-18
C314	VPWR#6	a_846_74##3	2.16878e-19
C315	a_1592_424##5	a_1592_424#	8.2988e-19
C316	a_300_453##4	a_439_453#	6.33269e-18
C317	a_846_74##2	a_634_74#	1.45051e-18
C318	VGND#3	a_1829_398##2	9.00027e-20
C319	VGND#2	a_1829_398##9	6.9425e-18
C320	VPWR#3	a_846_74##8	7.53782e-18
C321	a_27_74#	D#2	4.95999e-18
C322	VGND#3	Q#3	2.09117e-17
C323	a_1044_100##4	a_1287_320##8	1.08104e-17
C324	VGND#11	a_1829_398#	2.75957e-17
C325	CLK	a_634_74##4	1.5014e-18
C326	a_634_74##8	a_846_74##2	1.65417e-17
C327	a_634_74##4	VGND#13	2.71702e-18
C328	CLK	CLK#2	7.88113e-18
C329	a_1592_424##2	a_1829_398##7	1.79828e-17
C330	a_846_74##4	a_1287_320##4	1.38194e-17
C331	VGND#3	a_846_74##6	4.24314e-17
C332	a_1829_398##16	a_634_74##9	5.03142e-19
C333	a_634_74##10	VPWR#3	3.24566e-17
C334	a_1592_424##7	a_1592_424##3	1.48236e-18
C335	a_1044_100##4	VPWR#7	2.24334e-17
C336	a_846_74##6	a_1287_320##6	3.66537e-17
C337	VPWR#6	a_1044_100##4	6.0692e-18
C338	a_634_74##5	a_634_74##8	1.29299e-18
C339	VGND#3	a_1829_398##16	3.2724e-17
C340	a_1829_398##2	a_1829_398##7	2.99172e-19
C341	VGND#3	a_634_74##10	5.25972e-18
C342	a_1592_424##5	a_1829_398##3	1.64733e-17
C343	a_634_74##2	VPWR#6	2.75637e-17
C344	a_1287_320##8	a_1287_320##3	3.38428e-19
C345	VPWR#3	a_1044_100##3	2.93102e-18
C346	a_846_74##11	a_1287_320##5	2.9645e-17
C347	a_634_74##5	CLK#4	7.14054e-19
C348	SCE#4	a_27_74#	2.10534e-17
C349	VGND#2	a_1592_424##3	4.02163e-19
C350	a_846_74##11	a_1044_100##3	4.56938e-18
C351	a_1829_398##2	a_1592_424##2	6.58174e-17
C352	VGND#11	a_634_74##9	3.40459e-18
C353	SCE#4	SCE#5	3.74137e-18
C354	VGND#3	a_1044_100##3	3.3846e-18
C355	VPWR#7	a_1287_320##3	2.7492e-17
C356	a_1592_424##2	a_846_74##8	2.53061e-19
C357	VPWR#8	a_1287_320##3	3.0425e-19
C358	a_1592_424##7	a_1829_398#	1.06367e-17
C359	VGND#6	a_634_74##5	5.54481e-19
C360	a_1044_100##8	a_1044_100##4	1.01075e-19
C361	VGND#3	a_1287_320#	3.52648e-18
C362	a_634_74##6	a_846_74##4	5.13726e-18
C363	a_846_74##8	a_1829_398##2	6.48499e-18
C364	a_1287_320##6	a_634_74##10	4.42189e-17
C365	SCD#2	CLK#4	9.3024e-18
C366	VGND#3	a_1592_424##7	5.06259e-17
C367	VPWR#8	a_846_74##2	7.66989e-19
C368	VPWR#6	a_1287_320##3	7.83918e-18
C369	VPWR#3	a_634_74##2	1.03168e-17
C370	a_1592_424##5	a_846_74##7	1.26239e-18
C371	VGND#11	a_846_74##5	2.78242e-19
C372	a_1592_424##2	a_634_74##10	8.8732e-20
C373	a_846_74##11	VGND#12	8.03778e-17
C374	VPWR#7	a_634_74#	2.73965e-18
C375	VGND#3	a_1287_320##5	9.31251e-18
C376	a_846_74##11	a_1287_320#	5.70026e-17
C377	a_27_74##4	CLK#4	5.44713e-19
C378	a_1044_100##8	a_1287_320##3	3.26855e-18
C379	VGND#2	a_1829_398#	2.49609e-20
C380	VPWR#2	a_1829_398##6	4.30395e-20
C381	a_1592_424##7	a_634_74##9	5.12468e-17
C382	a_634_74##10	a_1829_398##2	1.90035e-17
C383	a_27_74##4	SCD#1	7.31255e-18
C384	a_300_453##6	a_300_453##4	4.19839e-18
C385	VGND#3	VGND#12	2.20371e-17
C386	a_300_453#	a_634_74##4	6.35206e-21
C387	a_1044_100##6	a_1044_100##8	2.94951e-18
C388	a_846_74##8	a_634_74##10	8.48583e-17
C389	VPWR#8	a_634_74#	3.17888e-19
C390	a_634_74##7	a_634_74##6	3.93383e-18
C391	a_1829_398##7	Q#3	1.99043e-17
C392	a_1829_398#	a_1787_74#	5.87385e-18
C393	VPWR#7	a_846_74#	2.50949e-19
C394	a_1287_320##6	a_1044_100##3	4.1314e-17
C395	a_27_74##4	D#3	1.7728e-17
C396	a_634_74##9	a_1787_74#	7.56811e-18
C397	a_846_74##6	a_634_74##10	5.81644e-17
C398	VGND#11	a_1044_100#	1.39844e-19
C399	VGND#6	a_846_74##12	3.83013e-17
C400	a_1044_100##8	a_634_74#	3.11156e-17
C401	a_846_74##12	a_846_74##3	1.51536e-19
C402	VPWR#6	a_634_74#	8.44091e-18
C403	a_1044_100##6	a_1044_100##3	2.95043e-18
C404	a_1829_398##7	VGND#4	4.79464e-17
C405	a_846_74##11	a_1287_320##6	2.35152e-17
C406	a_1592_424##5	a_634_74##11	1.86649e-19
C407	a_1829_398##3	a_1704_496#	9.16893e-18
C408	a_1592_424##7	a_846_74##5	2.93655e-17
C409	a_300_453#	a_634_74##3	3.55726e-19
C410	a_1044_100##3	a_846_74##6	2.92282e-18
C411	a_846_74##7	a_1704_496#	1.2977e-17
C412	a_846_74##12	a_1044_100##7	7.60681e-17
C413	VPWR#2	a_1829_398##5	4.24656e-20
C414	VPWR#7	a_634_74##8	1.76867e-19
C415	VGND#12	a_634_74##9	5.03266e-20
C416	a_1044_100##3	a_634_74##10	3.38369e-17
C417	a_634_74##14	CLK#2	9.16432e-18
C418	a_1044_100##8	a_846_74#	2.58223e-17
C419	VPWR#8	a_634_74##4	1.78671e-18
C420	a_846_74##5	a_1287_320##5	2.29532e-18
C421	CLK#3	a_634_74##7	4.38619e-18
C422	VPWR#8	a_846_74#	5.33167e-18
C423	VGND#5	a_846_74##12	3.05395e-17
C424	a_846_74#	a_300_453#	1.46498e-17
C425	a_1592_424##7	a_1044_100#	3.58246e-19
C426	a_1287_320#	a_1044_100##3	4.77368e-17
C427	a_1044_100##6	a_1287_320#	1.49767e-18
C428	a_300_453##6	a_442_74#	3.47158e-18
C429	a_846_74##16	a_634_74##4	1.9543e-18
C430	a_846_74##11	a_1044_100##6	1.16857e-18
C431	a_846_74##11	a_1044_100##7	3.3993e-17
C432	a_27_74##2	SCE#1	1.74839e-17
C433	VPWR#6	a_846_74#	3.98341e-18
C434	a_1044_100##8	a_634_74##8	1.12366e-18
C435	a_846_74##11	a_634_74##2	3.84843e-19
C436	a_1287_320##3	a_1210_508#	1.27583e-17
C437	VGND#12	a_846_74##5	1.49604e-19
C438	VPWR#11	CLK#2	4.48217e-19
C439	a_634_74##2	a_634_74##10	6.91786e-18
C440	a_846_74##12	a_300_453##5	5.74657e-17
C441	a_634_74#	a_1210_508#	1.27583e-17
C442	VPWR#11	a_634_74##8	1.41488e-18
C443	a_846_74##3	a_1287_320#	3.00537e-17
C444	a_1287_320##5	a_1044_100#	2.79863e-17
C445	a_1044_100##3	a_634_74##2	6.14477e-17
C446	a_300_453##2	a_1044_100##8	1.40452e-18
C447	a_300_453#	a_634_74##8	4.50591e-18
C448	VPWR#8	a_634_74##3	2.74008e-19
C449	SCD#3	CLK#3	2.28117e-17
C450	a_846_74##16	a_634_74##3	1.63073e-18
C451	a_1044_100##3	a_846_74##2	1.76433e-19
C452	SCD	a_300_453##3	8.41221e-17
C453	VPWR#8	a_634_74##8	2.1751e-17
C454	a_1287_320##4	a_1219_100#	4.29123e-18
C455	Q	a_1829_398##6	6.36316e-18
C456	a_1044_100##6	a_846_74##3	4.00652e-17
C457	a_634_74##8	a_846_74##16	2.34246e-17
C458	Q	a_1829_398##5	9.53363e-18
C459	a_846_74##12	a_846_74##2	3.03728e-18
C460	a_846_74##3	a_634_74##2	1.37373e-17
C461	a_1044_100##8	VPWR#7	1.22136e-17
C462	a_846_74##4	a_1219_100#	1.06396e-17
C463	a_1044_100#	VGND#12	1.03504e-17
C464	VGND#1	VPWR#1	1.3848e-17
C465	VGND#5	a_846_74##11	4.70871e-17
C466	VGND#5	a_1044_100#	4.44617e-18
C467	a_300_453#	CLK#4	5.15887e-19
C468	VPWR#6	a_634_74##8	2.20078e-19
C469	a_846_74##2	a_846_74##3	5.26233e-20
C470	a_1287_320##5	a_1287_320##4	3.15515e-19
C471	VGND#11	a_1829_398##2	1.10534e-18
C472	a_634_74##8	VPWR#9	3.58925e-17
C473	a_846_74##13	a_846_74##12	2.66851e-18
C474	SCD#1	a_439_453#	1.26549e-17
C475	a_846_74##2	a_634_74##2	4.4223e-17
C476	VPWR#11	CLK#4	1.37252e-17
C477	a_27_74##3	a_439_453#	1.26549e-17
C478	a_634_74##4	VPWR#9	4.36873e-19
C479	SCE#6	SCD#3	2.98018e-17
C480	a_634_74##12	a_634_74##8	3.02105e-18
C481	a_1829_398##12	a_1829_398##8	3.94961e-19
C482	a_300_453##3	CLK	1.87034e-17
C483	a_1287_320##4	VGND#12	1.81288e-17
C484	Q#3	a_1829_398##6	4.35869e-18
C485	a_846_74##13	a_300_453##5	9.94207e-17
C486	a_1592_424##7	a_1829_398##2	1.0653e-17
C487	a_1044_100##6	a_634_74##2	8.6764e-17
C488	VGND#2	VGND#1	1.33753e-18
C489	VPWR#8	CLK#4	5.6644e-18
C490	VGND#8	SCE#7	3.19425e-19
C491	VGND#7	a_634_74##14	1.86815e-17
C492	VPWR#3	VPWR#1	5.37069e-17
C493	VPWR#11	a_27_74##4	1.27851e-19
C494	D#3	a_216_453#	1.62684e-17
C495	a_1287_320##5	a_846_74##4	2.18047e-20
C496	a_1287_320##6	a_1287_320##2	8.72729e-19
C497	VPWR#6	a_634_74##3	1.76989e-19
C498	SCE#1	a_216_453#	1.62684e-17
C499	VGND#5	a_1287_320##4	4.30584e-18
C500	a_634_74##12	CLK#4	4.40217e-17
C501	a_300_453##2	a_846_74##16	6.56396e-17
C502	a_634_74##5	CLK#1	2.76241e-17
C503	VGND#12	a_846_74##4	1.46356e-18
C504	a_634_74##7	a_634_74##3	6.37299e-19
C505	D#1	SCE#6	9.3236e-18
C506	VPWR	a_634_74##3	2.09435e-19
C507	a_634_74##5	SCD#2	1.12783e-19
C508	VPWR#11	SCD#1	1.85712e-17
C509	Q#3	a_1829_398##5	5.91015e-18
C510	VPWR#2	VPWR#1	7.06672e-19
C511	VPWR#3	VPWR#4	3.97089e-18
C512	a_1592_424##7	a_846_74##8	5.94829e-18
C513	VPWR	SCE#2	1.51767e-22
C514	CLK#4	VPWR#12	1.23153e-17
C515	VGND#3	VPWR#1	4.93889e-18
C516	a_1829_398##12	a_1829_398##9	1.11849e-18
C517	a_1044_100##3	a_1287_320##2	8.16003e-17
C518	a_1044_100##6	a_846_74##2	8.39275e-17
C519	a_846_74##8	a_1704_496#	1.97594e-18
C520	a_300_453#	a_1044_100##8	5.47811e-17
C521	a_300_453##6	SCD	3.25943e-17
C522	a_846_74##6	VGND#11	1.68429e-18
C523	a_634_74##12	SCD#1	4.96223e-19
C524	VPWR#3	a_1829_398##11	5.87556e-17
C525	VPWR#8	SCD#1	8.61177e-19
C526	VGND#2	Q#3	1.50197e-17
C527	VPWR#11	SCE#7	3.43681e-20
C528	VGND#8	VGND#6	1.18494e-18
C529	a_1829_398##13	a_1592_424##3	2.4707e-17
C530	a_27_74##4	SCD#2	2.6728e-17
C531	SCD#1	VPWR#12	1.6817e-17
C532	VPWR#3	VPWR#5	1.25389e-17
C533	a_300_453##2	VPWR#9	6.94911e-18
C534	VGND#3	VPWR#4	3.40291e-18
C535	CLK#2	a_634_74##8	2.80273e-19
C536	VGND#13	a_846_74##13	5.27891e-17
C537	VGND#5	a_846_74##4	3.10741e-18
C538	SCD#3	a_442_74#	7.43778e-18
C539	a_300_453##4	CLK#4	1.41157e-18
C540	a_846_74##6	a_1592_424##7	6.75594e-17
C541	SCE#7	SCD#2	6.5958e-18
C542	SCE#6	a_442_74#	5.46879e-18
C543	a_27_74##6	D#4	6.4642e-17
C544	a_300_453##2	a_846_74##2	4.61342e-18
C545	a_27_74#	D#1	4.54661e-17
C546	a_1044_100##7	a_846_74##4	6.00598e-18
C547	CLK#3	a_634_74##4	2.86293e-18
C548	a_300_453##3	a_634_74##12	6.33701e-17
C549	a_1044_100##6	a_1287_320##2	1.29192e-18
C550	SCE#7	a_27_74##4	2.76657e-17
C551	D#2	SCD#2	8.69041e-18
C552	VPWR#11	a_27_74##3	8.16708e-18
C553	Q	VPWR#2	1.6705e-17
C554	a_846_74##6	a_1287_320##5	8.10907e-17
C555	a_1829_398##12	a_1592_424##3	7.11345e-19
C556	D#2	a_27_74##4	5.38458e-17
C557	a_1592_424##6	VPWR#3	4.29984e-17
C558	a_1829_398##12	Q	5.9586e-18
C559	VGND#6	a_634_74##6	3.06761e-18
C560	SCE	a_27_74##6	1.91794e-17
C561	a_300_453##4	SCD#1	1.52408e-17
C562	a_1287_320##6	a_634_74##3	2.35557e-19
C563	D#2	SCE#7	5.46427e-17
C564	VGND	a_634_74##4	1.07451e-18
C565	a_634_74##14	a_846_74##13	2.51378e-18
C566	VGND	a_634_74##3	6.98049e-18
C567	a_300_453#	a_846_74##16	1.61899e-17
C568	a_634_74##12	a_300_453##2	7.86995e-17
C569	a_300_453##3	a_634_74##5	4.44166e-18
C570	SCE	D#4	2.91077e-17
C571	a_1592_424##7	a_634_74##10	2.23184e-18
C572	VPWR#3	a_1287_320##8	7.1632e-18
C573	SCD	a_300_453##4	5.55252e-18
C574	a_1829_398##13	a_1829_398#	5.64921e-18
C575	CLK#2	a_634_74##12	4.35537e-18
C576	a_1287_320#	a_1287_320##2	3.04435e-17
C577	a_634_74##6	a_1044_100##7	1.65297e-17
C578	a_634_74##5	a_300_453##2	2.05898e-17
C579	SCE#5	a_27_74#	1.88924e-17
C580	a_27_74##2	D#2	4.63061e-17
C581	D#1	a_223_74#	9.87534e-18
C582	a_300_453##3	VPWR#12	1.42774e-17
C583	a_27_74#	a_223_74#	8.35249e-18
C584	a_300_453##4	a_27_74##3	5.72151e-17
C585	VGND#8	a_634_74##7	3.51812e-19
C586	a_1044_100##6	a_634_74##4	1.4689e-19
C587	D#4	SCE#2	4.11993e-19
C588	CLK	a_634_74##12	3.49354e-17
C589	VPWR	VPWR#11	1.03111e-16
C590	VPWR	VPWR#8	1.28341e-16
C591	VPWR#14	SCD#1	4.85981e-19
C592	a_300_453#	VPWR#9	5.61564e-19
C593	VPWR	VPWR#6	7.64653e-17
C594	VPWR#11	D#3	7.86121e-19
C595	a_634_74##14	VGND#13	3.94989e-17
C596	SCE#4	a_27_74##2	3.01274e-17
C597	a_1287_320#	a_634_74##3	9.42517e-19
C598	a_300_453##5	a_634_74##6	1.01356e-17
C599	a_1592_424##7	a_1044_100##3	2.26561e-20
C600	VGND#6	a_634_74##7	7.34746e-18
C601	VGND#15	SCE	4.07559e-17
C602	a_300_453##3	CLK#1	2.09498e-17
C603	Q#3	Q	3.45924e-18
C604	a_300_453##4	D#3	4.58187e-17
C605	VGND#2	a_1829_398##16	1.36999e-18
C606	VPWR#14	a_27_74##3	7.8749e-19
C607	a_1829_398##13	a_634_74##9	1.13027e-18
C608	a_846_74##13	a_634_74##6	1.71741e-18
C609	a_1829_398##7	VPWR#4	3.02015e-17
C610	VPWR	a_1044_100##6	2.1525e-18
C611	VPWR	a_300_453##3	2.03209e-17
C612	VPWR	a_300_453##2	1.6994e-17
C613	a_1044_100##6	a_634_74##3	1.13979e-17
C614	VGND#14	VGND#13	1.39602e-18
C615	a_300_453##5	a_634_74##7	1.31654e-18
C616	VGND	VGND#8	9.3787e-17
C617	VGND	VGND#6	1.23013e-16
C618	VGND	VGND#5	6.94812e-17
C619	a_846_74##3	a_1219_100#	6.36151e-19
C620	VGND#8	CLK#3	4.82222e-18
C621	VPWR	a_27_74##6	1.00786e-17
C622	a_1044_100##6	a_1287_320##6	1.11311e-18
C623	a_300_453##4	SCE#1	5.49149e-18
C624	CLK#2	VPWR#12	5.04036e-19
C625	a_1829_398##11	VPWR#2	7.13432e-18
C626	a_846_74##3	a_1287_320##2	3.38336e-17
C627	VPWR#11	SCE#1	4.29022e-19
C628	VPWR#14	D#3	4.99612e-18
C629	a_1044_100##6	a_1287_320##3	1.09235e-20
C630	VPWR	D#4	2.60799e-18
C631	Q	VPWR#1	5.24756e-17
C632	Q	Q#1	5.30673e-19
C633	VPWR#4	Q	5.25508e-17
C634	a_300_453##3	SCD#2	7.39448e-18
C635	a_846_74##13	a_634_74##7	5.44073e-17
C636	VGND	a_846_74##12	3.00431e-17
C637	VGND	a_846_74##11	2.20871e-17
C638	VGND#6	CLK#3	8.80514e-19
C639	VPWR	a_300_453##5	3.24966e-18
C640	VGND#14	a_634_74##14	4.37901e-17
C641	a_1287_320#	VGND#12	6.79722e-18
C642	a_1592_424##2	a_1829_398##11	3.0335e-17
C643	VGND	a_1044_100##6	2.12361e-18
C644	a_634_74##3	a_846_74##3	2.08461e-17
C645	a_300_453##5	CLK#3	1.97589e-20
C646	a_1592_424##5	a_634_74##9	2.97529e-18
C647	VGND	a_300_453##3	2.7943e-18
C648	SCD	CLK#4	6.03572e-19
C649	VPWR#14	SCE#1	4.15805e-17
C650	SCD	SCD#1	4.68035e-18
C651	a_634_74##12	VPWR#9	5.79571e-18
C652	a_634_74##7	VGND#13	1.49333e-17
C653	VGND	a_27_74##6	5.71227e-18
C654	a_634_74##3	a_1287_320##2	1.9966e-18
C655	a_1592_424##2	VPWR#5	2.78439e-18
C656	CLK	a_634_74##8	1.61874e-19
C657	VGND	D#4	2.73376e-18
C658	CLK	CLK#4	2.56403e-18
C659	a_27_74##7	SCE#1	1.20927e-18
C660	VGND#8	SCD#3	5.25077e-18
C661	D#1	SCE	6.70711e-18
C662	a_846_74##13	CLK#3	6.74645e-19
C663	a_846_74##3	a_1287_320##5	7.37302e-19
C664	SCE	a_27_74#	2.0447e-17
C665	SCE	SCE#5	3.75748e-19
C666	VPWR	a_1044_100##8	1.85159e-17
C667	VPWR	a_300_453#	1.92055e-17
C668	a_27_74##4	a_300_453##3	1.71832e-18
C669	SCE#3	VPWR#14	1.98823e-17
C670	VPWR	a_846_74##16	3.77359e-18
C671	a_1829_398##6	VNB	2.17939e-17
C672	VGND	a_1044_100##7	8.13918e-18
C673	a_1829_398##5	VNB	4.20654e-17
C674	VGND	a_300_453##5	1.19082e-17
C675	a_1287_320##2	VNB	6.70327e-17
C676	a_634_74##14	a_634_74##7	1.8398e-18
C677	VPWR	a_634_74##12	9.1865e-18
C678	a_634_74##4	VNB	6.50084e-17
C679	VGND	a_846_74##13	2.5526e-17
C680	a_634_74##3	VNB	5.41674e-17
C681	CLK#2	VNB	5.00642e-17
C682	SCE#2	VNB	5.21003e-17
C683	a_1829_398##10	a_1829_398##4	4.93451e-17
C684	VGND	a_634_74##14	1.87455e-17
C685	VPWR	a_300_453##4	3.25765e-17
C686	VGND	a_300_453##6	3.93526e-17
C687	VPWR	VPWR#14	2.07014e-17
C688	VGND	VGND#15	1.60128e-17
C689	VPWR	a_27_74##7	1.89525e-17
C690	VGND	a_27_74##9	1.96656e-17
C691	VGND#6	SCD#3	1.04553e-19
C692	VGND#13	CLK#3	1.69696e-18
C693	a_27_74##7	SCE#3	2.80217e-17
C694	a_634_74##2	a_1287_320##2	1.83963e-17
C695	Q	a_1829_398##4	2.24863e-17
C696	Q	a_1829_398##10	2.43805e-17
C697	a_1829_398##12	a_1829_398##6	8.90321e-19
C698	VGND#14	a_634_74##7	3.09762e-19
C699	a_634_74##4	a_634_74##2	2.00963e-19
C700	a_1044_100##7	a_846_74##3	2.61599e-17
C701	a_300_453##3	a_634_74##4	5.94185e-19
C702	VGND	a_846_74##16	2.80446e-18
C703	a_1829_398##11	a_846_74##8	1.16662e-19
C704	SCE	SCE#1	3.73831e-19
C705	a_300_453##6	a_634_74##14	6.19403e-18
C706	a_634_74##14	CLK#3	4.76061e-17
C707	VGND#8	VNB	4.07709e-17
C708	VGND#6	VNB	5.89709e-17
C709	VGND#5	VNB	8.68291e-17
C710	VGND#2	VNB	4.18568e-17
C711	VPWR#11	VNB	4.71473e-17
C712	VPWR#8	VNB	6.23595e-17
C713	VGND#8	SCE#6	5.87511e-18
C714	VPWR#6	VNB	8.00018e-17
C715	SCD	SCD#2	2.75157e-17
C716	VPWR#2	VNB	3.62592e-17
C717	a_1592_424#	a_1829_398##10	6.39523e-18
C718	a_27_74##4	SCD	3.49895e-17
C719	a_1829_398##13	VNB	6.8605e-18
C720	a_1829_398##12	VNB	1.02673e-17
C721	VGND	a_1287_320##4	8.12615e-18
C722	CLK	a_634_74##5	1.86807e-17
C723	a_1592_424##5	VNB	5.87309e-18
C724	VGND#13	SCD#3	1.36418e-19
C725	a_846_74##12	VNB	1.78223e-17
C726	VPWR	a_1287_320##3	6.73205e-19
C727	a_634_74##4	a_634_74##3	7.29029e-19
C728	a_846_74##11	VNB	9.88275e-18
C729	VGND	a_634_74##7	4.34638e-18
C730	VGND	CLK#3	2.20755e-18
C731	VPWR	a_634_74#	2.07111e-18
C732	VPWR#3	Q	1.75096e-17
C733	D#2	SCD	1.17032e-17
C734	CLK	SCD#2	4.26411e-20
C735	VGND	SCD#3	1.93623e-19
C736	VPWR	a_846_74#	2.95618e-18
C737	VGND#3	Q	1.06911e-18
C738	a_1287_320##6	VNB	7.56327e-18
C739	VGND	SCE#6	5.01613e-19
C740	a_1044_100##6	VNB	6.11415e-18
C741	VPWR	a_634_74##8	6.14415e-19
C742	VGND	D#1	1.71693e-18
C743	a_300_453##3	VNB	2.82354e-18
C744	VPWR	CLK#4	1.94254e-18
C745	a_300_453##2	VNB	4.75397e-18
C746	VGND	a_27_74#	3.91265e-19
C747	VGND	SCE#5	1.90131e-18
C748	VPWR	SCD#1	8.54992e-18
C749	CLK#3	VGND#14	1.8938e-17
C750	a_1829_398##7	Q	2.31635e-17
C751	VPWR	a_27_74##3	8.44403e-18
C752	a_27_74##6	VNB	4.93612e-17
C753	VPWR	D#3	8.50378e-18
C754	Q	a_1592_424##2	7.3679e-19
C755	a_1592_424##6	VPWR#6	2.01865e-18
C756	VPWR	SCE#1	4.47089e-18
C757	VPWR	SCE#3	8.37867e-18
C758	VGND#1	VNB	7.2003e-17
C759	Q#3	VNB	8.76281e-18
C760	VGND#4	VNB	2.31844e-18
C761	a_1829_398##16	VNB	1.2327e-17
C762	VGND#11	VNB	1.12691e-18
C763	a_300_453##6	VGND#14	5.42654e-17
C764	a_1592_424##7	VNB	1.49783e-18
C765	a_846_74##8	a_1592_424##6	3.70728e-17
C766	a_1287_320##5	VNB	1.04899e-18
C767	VGND#12	VNB	4.85026e-18
C768	VPWR	VPWR#10	2.99141e-17
C769	a_1829_398##12	a_1829_398##5	2.38717e-19
C770	a_634_74##14	SCD#3	1.16829e-18
C771	a_300_453##6	a_634_74##7	2.34133e-20
C772	a_1044_100##7	VNB	4.53006e-18
C773	a_300_453##5	VNB	1.04993e-17
C774	a_846_74##13	VNB	8.96067e-18
C775	VGND#13	VNB	7.71501e-18
C776	a_634_74##14	VNB	1.25312e-17
C777	VGND#14	VNB	3.80462e-18
C778	a_300_453##6	VNB	1.23656e-17
C779	a_27_74##6	a_27_74##4	2.36867e-18
C780	VGND#15	VNB	1.62399e-18
C781	a_300_453##5	a_300_453##2	1.03079e-18
C782	SCE	SCE#7	1.82136e-18
C783	a_27_74##9	VNB	3.22658e-17
C784	VPWR#1	VNB	8.12583e-17
C785	VPWR#4	VNB	1.36002e-17
C786	SCE	D#2	5.80016e-19
C787	a_1829_398##11	VNB	1.28203e-17
C788	SCE	a_27_74##2	5.87396e-18
C789	a_1592_424##6	VNB	2.00615e-18
C790	a_1287_320##8	VNB	1.65015e-18
C791	VPWR	a_1044_100##3	1.51273e-18
C792	VPWR#7	VNB	2.45719e-18
C793	SCE	SCE#4	8.33172e-18
C794	a_1044_100##8	VNB	2.20376e-18
C795	a_1829_398##12	VPWR#4	1.77866e-17
C796	a_300_453#	VNB	1.1812e-17
C797	D#2	a_300_453##3	1.58353e-18
C798	a_1829_398##3	a_1592_424#	1.09068e-17
C799	a_846_74##16	VNB	2.52494e-18
C800	VGND	VGND#7	2.44042e-17
C801	a_634_74##12	VNB	5.83255e-18
C802	VPWR	a_634_74##2	1.14596e-17
C803	VGND#3	VGND#5	7.72601e-17
C804	a_300_453##4	VNB	4.13933e-18
C805	VPWR	a_846_74##2	4.67366e-18
C806	a_300_453##2	a_846_74#	7.76512e-20
C807	VPWR#14	VNB	3.77888e-18
C808	a_27_74##7	VNB	3.01032e-17
C809	a_1829_398##8	VNB	2.58682e-17
C810	a_1829_398##9	VNB	3.15321e-17
C811	a_1592_424##3	VNB	4.48881e-17
C812	a_1829_398#	VNB	3.39496e-17
C813	a_634_74##9	VNB	5.18934e-17
C814	SCD#3	VGND#14	1.453e-17
C815	a_846_74##5	VNB	2.38686e-17
C816	a_1044_100#	VNB	4.43253e-17
C817	VGND	a_1044_100##3	1.80295e-18
C818	VPWR	a_27_74##4	6.72551e-18
C819	VGND#8	D#1	2.16527e-19
C820	a_1287_320##4	VNB	2.84527e-17
C821	a_846_74##4	VNB	2.21286e-17
C822	VGND	a_1287_320#	1.67104e-18
C823	a_634_74##6	VNB	3.31931e-17
C824	a_634_74##4	a_846_74##2	4.95284e-18
C825	a_634_74##7	VNB	3.59544e-17
C826	VGND	a_846_74##3	1.94062e-20
C827	a_300_453##2	a_634_74##4	1.00137e-17
C828	CLK#3	VNB	3.53729e-17
C829	VPWR	D#2	2.55122e-18
C830	a_846_74##2	a_1044_100##7	7.74191e-18
C831	SCD#3	VNB	3.81751e-17
C832	SCE#6	VNB	2.32416e-17
C833	VGND#8	a_300_453##3	9.41616e-19
C834	D#1	VNB	2.54147e-17
C835	VGND	a_846_74##2	1.88382e-18
C836	a_846_74##6	a_1592_424##6	3.41703e-18
C837	a_27_74#	VNB	2.88505e-17
C838	SCE#5	VNB	2.99258e-17
C839	VGND	a_634_74##5	6.43591e-18
C840	a_1829_398##13	a_1829_398##11	1.5763e-18
C841	a_27_74##9	SCE#2	5.6992e-20
C842	a_1829_398##4	VNB	4.28248e-17
C843	VGND	CLK#1	2.60279e-18
C844	a_1829_398##10	VNB	4.04906e-17
C845	a_1592_424#	VNB	4.31965e-17
C846	VGND#3	VGND#2	9.45505e-17
C847	a_1829_398##3	VNB	3.39991e-17
C848	a_846_74##7	VNB	2.9365e-17
C849	VGND	a_27_74##4	4.43708e-18
C850	a_300_453##6	CLK#3	1.87497e-18
C851	a_634_74##11	VNB	3.60028e-17
C852	a_1044_100##4	VNB	3.54077e-17
C853	VGND	SCE#7	1.21712e-17
C854	a_1287_320##3	VNB	4.06092e-17
C855	a_634_74#	VNB	2.73742e-17
C856	VGND	D#2	2.97685e-18
C857	a_846_74#	VNB	3.05121e-17
C858	a_846_74##2	a_634_74##3	4.89592e-17
C859	a_634_74##8	VNB	4.85564e-17
C860	VGND	a_27_74##2	1.66569e-21
C861	VGND#3	a_1829_398##8	4.84386e-18
C862	CLK#4	VNB	4.80564e-17
C863	a_300_453##5	a_846_74##2	2.09173e-17
C864	SCD#1	VNB	3.07427e-17
C865	VGND	SCE#4	3.64474e-18
C866	a_27_74##3	VNB	2.38055e-17
C867	D#3	VNB	3.05129e-17
C868	SCE#1	VNB	3.09628e-17
C869	SCE#3	VNB	3.58803e-17
C870	VPWR#3	a_1592_424##3	7.03596e-19
C871	VPWR#3	VNB	3.16491e-16
C872	VGND#3	VNB	3.09303e-16
C873	a_300_453##3	CLK#2	1.61425e-17
C874	VPWR#10	VNB	1.52449e-17
C875	a_300_453##3	a_634_74##8	4.36183e-19
C876	VGND#7	VNB	1.44803e-17
C877	a_1829_398##7	VNB	5.96583e-17
C878	a_1592_424##2	VNB	4.1797e-17
C879	a_1829_398##2	VNB	5.84758e-17
C880	a_846_74##8	VNB	3.91209e-17
C881	a_846_74##6	VNB	4.08292e-17
C882	a_634_74##10	VNB	6.66736e-17
C883	a_1044_100##3	VNB	6.64939e-17
C884	a_1287_320#	VNB	1.96005e-18
C885	a_846_74##3	VNB	2.24445e-17
C886	a_846_74##13	a_300_453##2	1.73526e-18
C887	a_634_74##2	VNB	6.99867e-17
C888	CLK#2	a_634_74##4	2.81317e-17
C889	a_846_74##2	VNB	6.77161e-17
C890	a_634_74##5	VNB	6.71345e-18
C891	SCE#2	D#3	1.08899e-20
C892	CLK#1	VNB	4.81035e-18
C893	SCD#2	VNB	5.21194e-17
C894	VGND#3	a_1829_398##9	1.56573e-18
C895	a_27_74##4	VNB	3.86705e-17
C896	SCE#7	VNB	3.76055e-17
C897	a_846_74##7	a_1829_398##3	7.96257e-18
C898	D#2	VNB	7.37205e-17
C899	a_27_74##2	VNB	5.15583e-17
C900	SCE#4	VNB	6.69409e-17
C901	VPWR#3	VPWR#6	8.61578e-17
C902	VGND#14	SCE#6	5.64769e-19
C903	VPWR	SCD	4.52158e-18
C904	VPWR	CLK	4.00303e-18
C905	a_634_74##10	a_1592_424##6	4.8216e-17
C906	VGND	SCD	3.30302e-18
C907	a_300_453##2	a_634_74##8	4.94877e-17
C908	a_1829_398##12	a_1829_398##11	1.24583e-18
C909	VGND	SCE	8.99713e-18
C910	SCD	VNB	4.70405e-18
C911	CLK	VNB	2.91436e-18
C912	VGND#3	a_1592_424##3	9.3012e-18
C913	a_300_453##6	SCD#3	3.11674e-17
C914	a_846_74##11	a_846_74##5	3.71353e-19
C915	SCE	VNB	7.05952e-18
C916	Q	VNB	1.17078e-17
C917	VPWR	VNB	3.05157e-16
C918	VGND	VNB	3.10466e-16
C919	VPWR#3	VPWR#2	8.45041e-17
C920	a_634_74##10	a_1287_320##8	8.45887e-17
C921	VGND#9	a_27_74#	3.71624e-18
C922	VGND#9	D#1	5.22088e-18
C923	VGND#9	VNB	6.95634e-17
C924	VGND	VGND#9	1.22758e-16
C925	VPWR#13	a_27_74##2	1.28823e-19
C926	VGND#9	SCE#4	1.4341e-18
C927	VGND#9	D#2	1.56427e-19
C928	VGND#9	SCE	3.14314e-18
C929	VGND#9	SCE#7	1.07365e-18
C930	a_27_74##7	VPWR#13	1.84738e-17
C931	VGND#9	a_27_74##9	2.0834e-17
C932	VGND#9	a_300_453##6	1.80111e-17
C933	VGND#9	SCE#5	5.33942e-18
C934	VPWR#13	SCE#1	7.62878e-18
C935	a_27_74##6	VPWR#13	2.1493e-18
C936	VPWR#13	SCE#3	3.33705e-18
C937	a_27_74##4	VPWR#13	4.71788e-19
C938	a_300_453##4	VPWR#13	1.44554e-17
C939	VPWR#13	VNB	6.75251e-17
C940	VPWR#13	SCE#2	2.32171e-19
C941	VPWR#13	D#2	6.49905e-20
C942	VPWR#13	D#3	1.26947e-17
C943	VPWR	VPWR#13	1.18428e-16
*
*
.ENDS sky130_fd_sc_hs__sdfxtp_2
*
