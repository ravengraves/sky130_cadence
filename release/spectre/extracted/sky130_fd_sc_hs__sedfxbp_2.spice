* Extracted by Quantus, converted by sky130cad/quantus.py
*
*
*
*                       LINUX           Wed Nov 18 09:12:27 2026
*
*
*
*  PROGRAM  advgen
*
*  Name           : advgen - Quantus - (64-bit)
*  Version        : 25.1.0-p047
*  Build Date     : Thu Dec 11 23:20:30 PST 2025
*
*  HSPICE LIBRARY
*
*  OPERATING_TEMPERATURE 150
*  QRC_TECH_DIR <path>/tech
*
*
*

*
.SUBCKT sky130_fd_sc_hs__sedfxbp_2 VNB VPB VGND VPWR Q Q_N D SCE SCD CLK DE
*
*
*  caps2d version: 10
*
*
*       TRANSISTOR CARDS
*
*
XM35 a_32_74##6 D#3 a_141_74# VNB sky130_fd_pr__nfet_01v8_lvt l=0.15 w=0.42 ad=0.1659 as=0.1008 pd=1.63 ps=1.32
XM7 a_141_74# DE#6 VGND#25 VNB sky130_fd_pr__nfet_01v8_lvt l=0.15 w=0.42 ad=0.1008 as=0.1197 pd=1.32 ps=1.41
XM40 a_183_290##9 DE#7 VGND#24 VNB sky130_fd_pr__nfet_01v8_lvt l=0.15 w=0.42 ad=0.1197 as=0.147 pd=1.41 ps=1.54
XM5 VGND#24 a_183_290##3 a_527_113# VNB sky130_fd_pr__nfet_01v8_lvt l=0.15 w=0.42 ad=0.147 as=0.1008 pd=1.54 ps=1.32
XM29 a_527_113# a_575_87##3 a_32_74# VNB sky130_fd_pr__nfet_01v8_lvt l=0.15 w=0.42 ad=0.1008 as=0.1176 pd=1.32 ps=1.4
XM46 a_32_74# a_661_87##3 a_691_113##7 VNB sky130_fd_pr__nfet_01v8_lvt l=0.15 w=0.42 ad=0.1176 as=0.1491 pd=1.4 ps=1.55
XM12 a_661_87##6 SCE#2 VGND#23 VNB sky130_fd_pr__nfet_01v8_lvt l=0.15 w=0.42 ad=0.1197 as=0.1638 pd=1.41 ps=1.62
XM37 VGND#23 SCD#3 a_1091_125# VNB sky130_fd_pr__nfet_01v8_lvt l=0.15 w=0.42 ad=0.1638 as=0.1008 pd=1.62 ps=1.32
XM8 a_1091_125# SCE#1 a_691_113##9 VNB sky130_fd_pr__nfet_01v8_lvt l=0.15 w=0.42 ad=0.1008 as=0.1197 pd=1.32 ps=1.41
XM32 VGND#22 CLK#1 a_1374_368##13 VNB sky130_fd_pr__nfet_01v8_lvt l=0.15 w=0.74 ad=0.2627 as=0.2109 pd=2.19 ps=2.05
XM21 VGND#21 a_1374_368##9 a_1586_74##13 VNB sky130_fd_pr__nfet_01v8_lvt l=0.15 w=0.74 ad=0.2109 as=0.2109 pd=2.05 ps=2.05
XM9 a_691_113##8 a_1374_368# a_1784_97##6 VNB sky130_fd_pr__nfet_01v8_lvt l=0.15 w=0.42 ad=0.1197 as=0.2226 pd=1.41 ps=1.9
XM25 a_1784_97##6 a_1586_74##4 a_1920_97# VNB sky130_fd_pr__nfet_01v8_lvt l=0.15 w=0.42 ad=0.2226 as=0.1953 pd=1.9 ps=1.77
XM45 a_1920_97# a_2013_71##3 VGND#20 VNB sky130_fd_pr__nfet_01v8_lvt l=0.15 w=0.42 ad=0.1953 as=0.343975 pd=1.77 ps=2.5
XM41 VGND#20 a_1784_97# a_2013_71##8 VNB sky130_fd_pr__nfet_01v8_lvt l=0.15 w=0.64 ad=0.343975 as=0.1824 pd=2.5 ps=1.85
XM13 VGND#19 a_2013_71##4 a_2417_74# VNB sky130_fd_pr__nfet_01v8_lvt l=0.15 w=0.64 ad=0.1824 as=0.1344 pd=1.85 ps=1.7
XM26 a_2417_74# a_1586_74##5 a_2489_74##12 VNB sky130_fd_pr__nfet_01v8_lvt l=0.15 w=0.64 ad=0.1344 as=0.2139 pd=1.7 ps=2
XM17 a_2489_74##12 a_1374_368##10 a_2591_74# VNB sky130_fd_pr__nfet_01v8_lvt l=0.15 w=0.42 ad=0.2139 as=0.1008 pd=2 ps=1.32
XM3 a_2591_74# a_575_87##4 VGND#17 VNB sky130_fd_pr__nfet_01v8_lvt l=0.15 w=0.42 ad=0.1008 as=0.5515 pd=1.32 ps=3.55
XM10 VGND#17 a_2489_74##8 a_575_87##20 VNB sky130_fd_pr__nfet_01v8_lvt l=0.15 w=0.74 ad=0.5515 as=0.2109 pd=3.55 ps=2.05
XM19 VGND#16 a_2489_74##6 Q#3 VNB sky130_fd_pr__nfet_01v8_lvt l=0.15 w=0.74 ad=0.2109 as=0.2072 pd=2.05 ps=2.04
XM33 Q#3 a_2489_74##5 VGND#4 VNB sky130_fd_pr__nfet_01v8_lvt l=0.15 w=0.74 ad=0.2072 as=0.2072 pd=2.04 ps=2.04
XM42 Q_N#3 a_575_87##10 VGND#4 VNB sky130_fd_pr__nfet_01v8_lvt l=0.15 w=0.74 ad=0.2072 as=0.2072 pd=2.04 ps=2.04
XM28 VGND#1 a_575_87##11 Q_N#3 VNB sky130_fd_pr__nfet_01v8_lvt l=0.15 w=0.74 ad=0.2109 as=0.2072 pd=2.05 ps=2.04
XM16 a_32_74##4 D#1 a_132_464# VPB sky130_fd_pr__pfet_01v8 l=0.15 w=0.64 ad=0.1888 as=0.1728 pd=1.87 ps=1.82
XM4 a_132_464# a_183_290# VPWR#23 VPB sky130_fd_pr__pfet_01v8 l=0.15 w=0.64 ad=0.1728 as=0.1888 pd=1.82 ps=1.87
XM34 a_183_290##8 DE#4 VPWR#21 VPB sky130_fd_pr__pfet_01v8 l=0.15 w=0.64 ad=0.1888 as=0.3392 pd=1.87 ps=2.34
XM38 VPWR#21 DE#1 a_578_462# VPB sky130_fd_pr__pfet_01v8 l=0.15 w=0.64 ad=0.3392 as=0.1536 pd=2.34 ps=1.76
XM6 a_578_462# a_575_87# a_32_74##5 VPB sky130_fd_pr__pfet_01v8 l=0.15 w=0.64 ad=0.1536 as=0.192 pd=1.76 ps=1.88
XM27 a_32_74##5 SCE#5 a_691_113##5 VPB sky130_fd_pr__pfet_01v8 l=0.15 w=0.64 ad=0.192 as=0.1888 pd=1.88 ps=1.87
XM24 a_661_87##9 SCE#4 VPWR#18 VPB sky130_fd_pr__pfet_01v8 l=0.15 w=0.64 ad=0.1952 as=0.3456 pd=1.89 ps=2.36
XM43 VPWR#18 SCD#1 a_1088_453# VPB sky130_fd_pr__pfet_01v8 l=0.15 w=0.64 ad=0.3456 as=0.1728 pd=2.36 ps=1.82
XM20 a_1088_453# a_661_87##5 a_691_113##10 VPB sky130_fd_pr__pfet_01v8 l=0.15 w=0.64 ad=0.1728 as=0.1888 pd=1.82 ps=1.87
XM2 VPWR#16 CLK#3 a_1374_368##15 VPB sky130_fd_pr__pfet_01v8 l=0.15 w=1.12 ad=0.3304 as=0.3304 pd=2.83 ps=2.83
XM30 VPWR#14 a_1374_368##8 a_1586_74##17 VPB sky130_fd_pr__pfet_01v8 l=0.15 w=1.12 ad=0.3304 as=0.3304 pd=2.83 ps=2.83
XM31 a_691_113# a_1586_74# a_1784_97##7 VPB sky130_fd_pr__pfet_01v8 l=0.15 w=0.42 ad=0.1239 as=0.126 pd=1.43 ps=1.44
XM14 a_1784_97##7 a_1374_368##7 a_1944_508# VPB sky130_fd_pr__pfet_01v8 l=0.15 w=0.42 ad=0.126 as=0.1512 pd=1.44 ps=1.56
XM39 a_1944_508# a_2013_71# VPWR#11 VPB sky130_fd_pr__pfet_01v8 l=0.15 w=0.42 ad=0.1512 as=0.29995 pd=1.56 ps=2.73
XM11 VPWR#11 a_1784_97##3 a_2013_71##12 VPB sky130_fd_pr__pfet_01v8 l=0.15 w=0.84 ad=0.29995 as=0.2478 pd=2.73 ps=2.27
XM15 VPWR#9 a_2013_71##7 a_2374_392# VPB sky130_fd_pr__pfet_01v8 l=0.15 w=1 ad=0.4032 as=0.805 pd=2.92 ps=3.61
XM36 a_2374_392# a_1374_368##12 a_2489_74##13 VPB sky130_fd_pr__pfet_01v8 l=0.15 w=1 ad=0.805 as=0.3328 pd=3.61 ps=2.77
XM44 a_2489_74##13 a_1586_74##7 a_2672_508# VPB sky130_fd_pr__pfet_01v8 l=0.15 w=0.42 ad=0.3328 as=0.1134 pd=2.77 ps=1.38
XM0 a_2672_508# a_575_87##6 VPWR#7 VPB sky130_fd_pr__pfet_01v8 l=0.15 w=0.42 ad=0.1134 as=0.4207 pd=1.38 ps=3.36
XM23 VPWR#7 a_2489_74##9 a_575_87##16 VPB sky130_fd_pr__pfet_01v8 l=0.15 w=1.12 ad=0.4207 as=0.3304 pd=3.36 ps=2.83
XM18 Q#1 a_2489_74##7 VPWR#5 VPB sky130_fd_pr__pfet_01v8 l=0.15 w=1.12 ad=0.336 as=0.3304 pd=2.84 ps=2.83
XM47 VPWR#4 a_2489_74# Q#1 VPB sky130_fd_pr__pfet_01v8 l=0.15 w=1.12 ad=0.336 as=0.336 pd=2.84 ps=2.84
XM22 Q_N#1 a_575_87##12 VPWR#4 VPB sky130_fd_pr__pfet_01v8 l=0.15 w=1.12 ad=0.336 as=0.336 pd=2.84 ps=2.84
XM1 VPWR#1 a_575_87##7 Q_N#1 VPB sky130_fd_pr__pfet_01v8 l=0.15 w=1.12 ad=0.3304 as=0.336 pd=2.83 ps=2.84
*
*
*       RESISTOR AND CAP/DIODE CARDS
*
Rg1	D#1	D#2	446.848755
Rg2	D#2	D#3	353.802551
Rg3	a_183_290#	a_183_290##2	411.956299
Rg4	a_183_290##3	a_183_290##4	457.141815
Rg5	DE#1	DE#2	587.980652
Rg6	DE#2	DE#3	380.472107
Rg7	DE#2	DE#4	234.008942
Rg8	DE#3	DE#5	204.397659
Rg9	DE#5	DE#6	608.065796
Rg10	DE#5	DE#7	369.913055
Rg11	a_575_87#	a_575_87##2	447.425812
Rg12	a_575_87##2	a_575_87##3	483.995209
Rg14	a_661_87#	a_661_87##3	544.136475
Rg15	SCD#1	SCD#2	556.619080
Rg16	SCD#2	SCD#3	230.466324
Rg17	SCE#1	SCE#2	1177.795410
Rg18	SCE#2	SCE#3	230.466324
Rg19	SCE#3	SCE#4	556.619080
Rg20	SCE#4	SCE#5	1027.373779
Rg21	a_661_87##4	a_661_87##5	335.918091
Rg22	CLK#1	CLK#2	320.356293
Rg23	CLK#2	CLK#3	508.416565
Rg24	a_1586_74#	a_1586_74##2	488.276428
Rg25	a_1374_368#	a_1374_368##2	518.070618
Rg26	a_1374_368##2	a_1374_368##3	338.672607
Rg27	a_1374_368##3	a_1374_368##4	157.680145
Rg28	a_1374_368##4	a_1374_368##5	63.507835
Rg29	a_1374_368##2	a_1374_368##6	606.117981
Rg30	a_1374_368##6	a_1374_368##7	242.670593
Rg31	a_1374_368##3	a_1374_368##8	381.171265
Rg32	a_1374_368##4	a_1374_368##9	433.443176
Rg33	a_1586_74##3	a_1586_74##4	245.658295
Rg34	a_2013_71#	a_2013_71##2	608.775696
Rg35	a_2013_71##2	a_2013_71##3	316.545624
Rg36	a_1784_97#	a_1784_97##2	524.165527
Rg37	a_1784_97##2	a_1784_97##3	371.262421
Rg38	a_2013_71##4	a_2013_71##5	349.235596
Rg39	a_2013_71##5	a_2013_71##6	37.804382
Rg40	a_2013_71##5	a_2013_71##7	507.442535
Rg41	a_1586_74##5	a_1586_74##6	477.886505
Rg42	a_1374_368##10	a_1374_368##11	555.066406
Rg43	a_1374_368##11	a_1374_368##12	415.953644
Rg44	a_1586_74##7	a_1586_74##8	593.549866
Rg45	a_575_87##4	a_575_87##5	1122.952148
Rg46	a_575_87##5	a_575_87##6	233.787552
Rg47	a_2489_74#	a_2489_74##2	471.862823
Rg48	a_2489_74##2	a_2489_74##3	66.369736
Rg49	a_2489_74##3	a_2489_74##4	205.142670
Rg50	a_2489_74##2	a_2489_74##5	368.862610
Rg51	a_2489_74##3	a_2489_74##6	365.684052
Rg52	a_2489_74##3	a_2489_74##7	469.405975
Rg53	a_2489_74##4	a_2489_74##8	349.667542
Rg54	a_2489_74##4	a_2489_74##9	450.541138
Rg55	a_575_87##7	a_575_87##8	474.329895
Rg56	a_575_87##8	a_575_87##9	51.662289
Rg57	a_575_87##9	a_575_87##10	348.334229
Rg58	a_575_87##8	a_575_87##11	375.249298
Rg59	a_575_87##9	a_575_87##12	451.207672
Rf1	D#4	D	1.197118
Rf2	D#2	D#6	54.608051
Rf3	D#4	D#6	6.078417
Rf4	D#7	D	1.197118
Rf5	D#6	D#7	5.758500
Rf6	DE#8	DE	0.956614
Rf7	DE#3	DE#10	161.189423
Rf8	DE#8	DE#10	2.362036
Rf9	a_183_290##4	a_183_290##6	208.232559
Rf10	a_183_290##6	a_183_290##2	57.455780
Rf11	a_183_290##6	a_183_290##8	44.572105
Rf12	a_183_290##2	a_183_290##9	90.546631
Rf13	a_575_87##13	a_575_87##2	163.382187
Rf14	a_32_74#	a_32_74##2	123.610909
Rf15	a_32_74##2	a_32_74##3	277.993622
Rf16	a_32_74##3	a_32_74##4	16.027058
Rf17	a_32_74##2	a_32_74##5	19.790504
Rf18	a_32_74##3	a_32_74##6	147.456863
Rf19	SCE	SCE#6	0.747289
Rf20	SCE#7	SCE#3	160.980087
Rf21	SCE#6	SCE#7	7.479781
Rf22	SCD#4	SCD#2	160.880829
Rf23	SCD	SCD#6	0.648029
Rf24	SCD#4	SCD#6	9.054472
Rf25	a_661_87##6	a_661_87##7	43.649902
Rf26	a_661_87##7	a_661_87##8	28.397335
Rf27	a_661_87##8	a_661_87##9	58.776031
Rf28	a_661_87##8	a_661_87##4	195.877136
Rf29	CLK#4	CLK	1.588424
Rf30	CLK#2	CLK#6	161.821228
Rf31	CLK#4	CLK#6	3.443809
Rf32	a_1374_368##13	a_1374_368##14	61.438446
Rf33	a_1374_368##14	a_1374_368##15	28.476147
Rf34	a_1374_368##14	a_1374_368##5	84.225677
Rf35	a_691_113#	a_691_113##2	90.482544
Rf36	a_691_113##2	a_691_113##3	116.740288
Rf37	a_691_113##3	a_691_113##4	19.012981
Rf38	a_691_113##4	a_691_113##6	212.016983
Rf39	a_691_113##6	a_691_113##7	139.260986
Rf40	a_691_113##2	a_691_113##8	145.409622
Rf41	a_691_113##3	a_691_113##9	127.529144
Rf42	a_691_113##4	a_691_113##10	10.665055
Rf43	a_691_113##5	a_691_113##6	7.500000
Rf44	a_1784_97##2	a_1784_97##5	256.567169
Rf45	a_1784_97##5	a_1784_97##6	89.244301
Rf46	a_1784_97##5	a_1784_97##7	81.874123
Rf47	a_2013_71##8	a_2013_71##9	44.206856
Rf48	a_2013_71##9	a_2013_71##2	219.422806
Rf49	a_2013_71##9	a_2013_71##11	14.237452
Rf50	a_2013_71##11	a_2013_71##12	85.838791
Rf51	a_2013_71##11	a_2013_71##6	90.560806
Rf52	a_1374_368##11	a_1374_368##6	591.157532
Rf53	a_1586_74##8	a_1586_74##10	234.675659
Rf54	a_1586_74##10	a_1586_74##11	253.179321
Rf55	a_1586_74##11	a_1586_74##12	86.615425
Rf56	a_1586_74##12	a_1586_74##13	82.548958
Rf57	a_1586_74##10	a_1586_74##6	178.913635
Rf58	a_1586_74##11	a_1586_74##3	171.703110
Rf59	a_1586_74##12	a_1586_74##2	116.234344
Rf60	a_1586_74##2	a_1586_74##17	32.416031
Rf61	a_2489_74##4	a_2489_74##11	178.558273
Rf62	a_2489_74##11	a_2489_74##12	134.719025
Rf63	a_2489_74##11	a_2489_74##13	137.236511
Rf64	Q	Q#2	1.913227
Rf65	Q#2	Q	12.244655
Rf66	Q	Q#4	7.078941
Rf67	Q#4	Q	7.078941
Rf68	Q#1	Q#2	15.000000
Rf69	Q#3	Q#4	7.500000
Rf70	a_575_87##9	a_575_87##17	299.133728
Rf71	a_575_87##17	a_575_87##5	197.467255
Rf72	a_575_87##17	a_575_87##19	9.722255
Rf73	a_575_87##19	a_575_87##20	62.116383
Rf74	a_575_87##16	a_575_87##17	5.000000
Rf75	Q_N	Q_N#2	2.765272
Rf76	Q_N#2	Q_N	60.080021
Rf77	Q_N	Q_N#4	7.282945
Rf78	Q_N#4	Q_N	7.282945
Rf79	Q_N#1	Q_N#2	15.000000
Rf80	Q_N#3	Q_N#4	7.500000
Rf81	VPWR#1	VPWR#2	98.323288
Rf82	VPWR#2	VPWR#3	54.032833
Rf83	VPWR#2	VPWR#4	33.326477
Rf84	VPWR#3	VPWR#5	36.824379
Rf85	VPWR#3	VPWR#6	99.112900
Rf86	VPWR#6	VPWR#7	25.558413
Rf87	VPWR#6	VPWR#8	186.201080
Rf88	VPWR#8	VPWR#9	28.799242
Rf89	VPWR#8	VPWR#10	79.941223
Rf90	VPWR#10	VPWR#11	31.948624
Rf91	VPWR#10	VPWR#12	22.621120
Rf92	VPWR#12	VPWR#13	154.842514
Rf93	VPWR#13	VPWR#14	31.948624
Rf94	VPWR#13	VPWR#15	98.626457
Rf95	VPWR#15	VPWR#16	37.027283
Rf96	VPWR#15	VPWR#17	105.242393
Rf97	VPWR#17	VPWR#18	38.110016
Rf98	VPWR#17	VPWR#19	132.238266
Rf99	VPWR#19	VPWR#20	53.359676
Rf100	VPWR#20	VPWR#21	37.794724
Rf101	VPWR#20	VPWR#22	105.258347
Rf102	VPWR#22	VPWR#23	37.538910
Rf104	VGND#1	VGND#2	105.512398
Rf105	VGND#2	VGND#3	53.424904
Rf106	VGND#2	VGND#4	56.430489
Rf107	VGND#3	VGND#5	114.596512
Rf108	VGND#5	VGND#6	146.077576
Rf109	VGND#6	VGND#7	105.258347
Rf110	VGND#7	VGND#8	23.043722
Rf111	VGND#8	VGND#9	178.341248
Rf112	VGND#9	VGND#10	77.507034
Rf113	VGND#10	VGND#11	106.239403
Rf114	VGND#11	VGND#12	128.909592
Rf115	VGND#12	VGND#13	74.121719
Rf116	VGND#13	VGND#14	81.036987
Rf118	VGND#3	VGND#16	45.656124
Rf119	VGND#5	VGND#18	5.698580
Rf120	VGND#18	VGND#17	19.107914
Rf121	VGND#6	VGND#19	37.027283
Rf122	VGND#7	VGND#20	37.027283
Rf123	VGND#9	VGND#21	56.430489
Rf124	VGND#10	VGND#22	30.353714
Rf125	VGND#11	VGND#23	43.365131
Rf126	VGND#13	VGND#24	42.184113
Rf127	VGND#14	VGND#25	34.507496
Rf128	VGND#17	VGND#18	7.500000
Rf136	a_661_87#	a_661_87##7	32.046562
Re1	a_575_87##19	a_575_87##13	39.942635
Re2	VPWR#3	VPWR#26	3.250421
Re3	VPWR#26	VPWR	0.553145
Re4	VPWR	VPWR#19	2.726611
Re5	VGND#3	VGND#27	3.250421
Re6	VGND#27	VGND	0.553145
Re7	VGND	VGND#12	2.726611
Re11	VPWR#12	VPWR#26	0.698413
Re14	VGND#8	VGND#27	0.698413
*
*       CAPACITOR CARDS
*
*
C1	a_575_87##19	VGND#8	4.36974e-18
C2	a_575_87##12	a_575_87##7	4.84299e-17
C3	a_691_113##4	a_1374_368##8	9.65975e-19
C4	VPWR#19	D#1	1.96091e-18
C5	a_575_87##10	VGND#4	1.61089e-17
C6	VPWR#10	VPWR#8	2.92929e-19
C7	VPWR#6	a_575_87##6	2.4443e-17
C8	a_575_87##19	VGND#5	8.17294e-18
C9	a_1374_368##6	a_2013_71##7	4.73075e-19
C10	a_1374_368##13	SCE#1	1.30679e-18
C11	a_575_87##13	a_661_87##8	6.34593e-17
C12	a_1784_97##6	a_1586_74##11	5.71413e-17
C13	VGND#2	a_575_87##11	3.41734e-18
C14	a_2489_74##4	a_575_87##16	6.31959e-18
C15	VPWR#10	a_1784_97##2	3.49234e-20
C16	a_1586_74##10	a_575_87##4	3.868e-19
C17	a_691_113##9	CLK#1	4.66775e-18
C18	a_1374_368##6	a_1784_97##3	3.33604e-17
C19	a_575_87##13	a_691_113#	2.9216e-18
C20	a_575_87##6	VPWR#7	1.23391e-17
C21	a_1374_368##10	a_575_87##4	4.69562e-17
C22	Q_N#3	a_2489_74##5	1.19909e-18
C23	a_1586_74##12	a_691_113##8	5.95089e-17
C24	a_2489_74##4	VPWR#7	1.58075e-18
C25	VPWR#23	D#1	4.69045e-18
C26	VPWR#8	a_1784_97##2	4.45024e-20
C27	a_2489_74##13	a_2489_74##9	6.51127e-19
C28	a_1586_74##11	a_1586_74##10	3.09956e-18
C29	a_1374_368##6	a_2013_71#	5.78662e-17
C30	VGND#22	SCE#1	5.14029e-18
C31	VPWR#18	VPWR#16	1.55564e-18
C32	a_1586_74##10	a_1586_74##8	9.38886e-19
C33	a_575_87##16	a_1586_74##7	3.64682e-19
C34	a_575_87##13	a_1586_74##17	1.33917e-17
C35	a_1784_97##5	a_1784_97##7	1.93817e-18
C36	VGND#10	a_1374_368##13	1.19137e-17
C37	a_691_113##2	a_1374_368##8	2.91367e-17
C38	a_183_290##6	DE#2	2.42003e-17
C39	a_1374_368##6	a_1374_368##7	2.08437e-18
C40	a_2489_74##11	a_575_87##16	6.98429e-19
C41	a_2489_74#	a_575_87##12	4.76156e-17
C42	a_575_87##16	VPWR#7	5.55637e-19
C43	a_575_87##16	a_575_87##5	3.84621e-19
C44	a_2489_74##5	VGND#4	2.00588e-17
C45	a_575_87##13	VPWR#14	3.89804e-18
C46	VGND#13	a_183_290##3	2.65853e-18
C47	a_691_113##4	CLK#3	4.40988e-17
C48	a_1586_74#	a_1374_368##6	2.61063e-18
C49	a_1784_97##6	a_1586_74##3	4.9366e-18
C50	a_691_113##9	SCE#1	4.42589e-17
C51	VPWR#19	a_661_87##8	3.39586e-18
C52	D#1	a_32_74##4	6.77882e-18
C53	a_575_87##5	VPWR#7	3.41522e-18
C54	VGND#16	a_575_87##10	1.78186e-19
C55	a_575_87##13	VPWR#12	4.18276e-19
C56	a_2489_74##13	a_575_87##6	6.43091e-18
C57	VGND#11	VGND#22	1.93944e-18
C58	VPWR#6	a_1586_74##7	7.22773e-18
C59	a_575_87##13	a_1374_368##15	3.75466e-17
C60	a_575_87##19	a_575_87##9	3.17911e-18
C61	a_1374_368##8	a_1374_368##6	5.45883e-19
C62	VGND#23	CLK#1	6.26219e-19
C63	a_1586_74##10	a_1374_368##10	3.67052e-19
C64	VGND#2	a_575_87##10	9.16105e-18
C65	VGND#22	SCD#3	3.40159e-19
C66	a_1586_74##5	a_1374_368##10	2.75532e-17
C67	a_575_87##13	VGND#8	8.56966e-19
C68	a_2489_74##5	Q#3	1.49295e-17
C69	a_1586_74##13	a_1586_74##12	2.66851e-18
C70	VGND#9	a_1374_368##13	1.26483e-17
C71	VPWR#3	a_575_87##9	2.47256e-18
C72	a_575_87##13	VPWR#16	2.77872e-18
C73	a_575_87##16	a_1586_74##8	1.6577e-19
C74	a_575_87##19	a_2489_74##4	9.66481e-17
C75	a_2489_74##13	a_575_87##5	3.0973e-17
C76	a_1586_74##10	a_1374_368##11	2.48382e-17
C77	a_2489_74##7	a_2489_74#	4.93727e-17
C78	a_691_113##2	CLK#3	1.71586e-18
C79	VGND#4	a_2489_74##6	6.45296e-19
C80	VGND#3	a_575_87##9	7.97876e-18
C81	VPWR#3	a_2489_74##4	1.90947e-18
C82	a_691_113##9	SCD#3	3.09984e-18
C83	a_1586_74##2	a_1784_97##6	1.24683e-17
C84	a_2489_74##13	a_1586_74##7	4.59894e-17
C85	a_575_87##19	a_575_87##5	1.19952e-17
C86	a_183_290##6	a_32_74##3	7.38843e-18
C87	a_32_74#	a_691_113##7	9.24029e-17
C88	VPWR#8	a_1374_368##12	2.98735e-18
C89	VPWR#9	a_575_87##6	2.56597e-19
C90	VGND#16	a_2489_74##5	3.93154e-19
C91	a_1374_368##8	a_1586_74##2	1.22231e-17
C92	a_691_113##4	a_661_87##5	3.7308e-17
C93	VGND#23	SCE#1	6.93108e-18
C94	VGND#12	a_661_87##8	1.69813e-18
C95	a_575_87##13	VPWR#19	6.77452e-17
C96	a_691_113##8	a_1586_74##2	5.07083e-17
C97	VGND#3	a_2489_74##4	3.22242e-18
C98	VGND#22	SCE#2	4.94671e-19
C99	VPWR#3	a_575_87##5	6.303e-18
C100	VGND#13	DE#7	3.74274e-18
C101	a_575_87##19	a_1586_74##8	2.16956e-17
C102	a_2489_74##13	a_575_87##16	3.33139e-18
C103	a_1586_74##2	CLK#3	1.03898e-19
C104	DE#7	DE#3	2.56016e-18
C105	a_2489_74##6	Q#3	1.49295e-17
C106	a_2489_74##13	a_1586_74##8	2.44448e-18
C107	VGND#12	a_575_87##13	7.07078e-17
C108	VPWR#6	a_1374_368##12	4.51623e-18
C109	a_1586_74##10	a_1586_74##5	1.06545e-17
C110	VGND#11	a_691_113##9	1.79677e-18
C111	a_1374_368##5	a_1374_368##8	1.21012e-17
C112	a_575_87##13	VPWR#18	1.72964e-18
C113	VGND#3	a_575_87##5	1.86163e-19
C114	a_575_87##2	a_32_74##2	3.59811e-17
C115	VGND#3	VGND#5	1.25774e-16
C116	a_2013_71##4	a_1586_74##5	5.25089e-17
C117	a_575_87##19	a_1374_368##11	5.31106e-17
C118	VGND#2	a_2489_74##5	6.72639e-18
C119	a_1374_368##6	VPWR#10	3.5592e-18
C120	a_1374_368##12	a_2489_74##13	1.76038e-17
C121	a_2489_74##9	a_2489_74##7	5.46408e-18
C122	a_691_113##9	SCE#2	1.23035e-18
C123	a_575_87##19	VPWR#10	1.36755e-18
C124	CLK#3	a_1374_368##5	1.22551e-17
C125	VGND#4	a_2489_74##8	5.39835e-20
C126	VPWR#9	a_1586_74##7	7.14154e-19
C127	Q_N#3	VGND#1	5.96585e-17
C128	a_575_87##13	a_661_87##9	3.52148e-18
C129	VGND#3	a_1586_74##8	5.54545e-19
C130	VGND#22	VGND#9	3.99205e-19
C131	a_1586_74##10	a_1586_74##6	4.19234e-18
C132	a_575_87##13	a_32_74##2	1.9858e-17
C133	a_1374_368##6	VPWR#8	4.60455e-18
C134	VGND#3	VGND#2	7.44296e-17
C135	a_691_113##2	a_661_87##5	9.95631e-20
C136	a_661_87##8	SCE#2	6.63704e-20
C137	SCD#3	VGND#23	1.85705e-17
C138	a_575_87##19	a_1586_74##6	2.73895e-17
C139	a_183_290##6	a_32_74##2	6.06014e-18
C140	VGND#16	a_2489_74##6	1.64795e-17
C141	a_1586_74##11	a_2013_71##4	1.60788e-19
C142	a_183_290##2	DE#6	2.13958e-17
C143	a_575_87##19	VPWR#8	7.0519e-18
C144	VGND#2	VGND#1	1.25815e-18
C145	a_2013_71##11	a_1374_368##11	4.79408e-18
C146	a_575_87##13	a_691_113##5	1.7392e-17
C147	a_1374_368##11	a_2489_74##13	3.02049e-17
C148	a_691_113##4	SCD#1	2.70889e-17
C149	VPWR#8	a_2013_71##7	8.36531e-18
C150	a_2489_74##11	a_2489_74##9	1.16174e-18
C151	a_575_87##19	a_2013_71##6	6.3726e-18
C152	VGND#5	a_2489_74##6	7.73373e-19
C153	VGND#10	a_691_113##9	8.40428e-18
C154	a_2489_74##13	a_2013_71##7	3.28065e-18
C155	SCE#4	a_661_87##6	3.2982e-19
C156	VGND#16	a_575_87##19	1.12014e-17
C157	a_575_87##19	VPWR#6	1.14235e-17
C158	a_661_87##6	SCD#3	9.79727e-19
C159	VPWR#19	a_661_87##9	7.01668e-18
C160	VGND#21	a_1374_368##5	1.86606e-17
C161	VPWR#9	a_1374_368##12	2.73915e-18
C162	a_183_290##4	a_32_74##2	4.63476e-17
C163	a_661_87##4	CLK#3	8.42195e-18
C164	D#2	DE#6	9.56549e-18
C165	a_575_87##6	a_2489_74##9	1.03449e-17
C166	VPWR#19	a_32_74##3	5.07734e-17
C167	VGND#13	DE#6	9.27147e-19
C168	a_575_87##20	a_2489_74##6	2.11358e-18
C169	a_1586_74##10	a_2013_71##4	1.8425e-17
C170	a_575_87##19	a_1784_97##2	5.15093e-17
C171	a_691_113#	VPWR#13	2.09576e-17
C172	VPWR#6	a_2013_71##7	4.26136e-19
C173	a_1784_97#	a_2013_71##4	3.5926e-18
C174	a_1374_368##11	VPWR#9	2.00794e-17
C175	a_575_87##19	a_575_87##20	5.17583e-18
C176	VGND#9	a_1374_368##5	2.29623e-19
C177	VGND#4	VGND#1	2.10052e-18
C178	a_1586_74##11	a_2013_71##6	2.12737e-19
C179	SCE#2	VGND#23	1.8436e-17
C180	a_1374_368##4	a_1374_368##2	1.5985e-18
C181	VPWR#13	a_1374_368##4	7.59531e-21
C182	a_691_113##5	VPWR#19	9.06703e-17
C183	a_691_113##5	VPWR#18	3.85933e-17
C184	a_691_113##8	CLK#2	7.1309e-19
C185	VGND#3	a_575_87##11	1.22524e-18
C186	a_32_74##2	VPWR#19	5.54027e-17
C187	VGND#3	VGND#1	5.64463e-17
C188	VGND#2	a_2489_74##6	5.37955e-19
C189	VGND#16	a_2489_74##8	2.29676e-18
C190	a_32_74##2	a_691_113##5	1.03503e-16
C191	a_2013_71##12	a_1374_368##12	1.14443e-18
C192	SCD#1	a_661_87##4	1.99198e-17
C193	a_575_87##19	a_2013_71##2	1.92706e-17
C194	a_2013_71##12	a_1374_368##11	6.39799e-18
C195	a_1586_74##10	a_2013_71##6	2.41979e-17
C196	a_575_87##19	VGND#17	3.19436e-18
C197	VPWR#10	a_1784_97##3	6.39015e-18
C198	a_691_113##2	a_1784_97##7	4.21704e-18
C199	a_691_113##9	a_1374_368##5	1.71554e-19
C200	VGND#3	a_575_87##10	1.20789e-18
C201	a_1586_74##11	a_1784_97#	3.93229e-17
C202	VGND#3	Q_N#3	4.79398e-18
C203	VGND#5	a_2489_74##11	4.39458e-17
C204	a_661_87##4	SCE#4	7.28544e-19
C205	a_2013_71##7	VPWR#9	3.55397e-17
C206	a_2013_71##11	a_1586_74##6	2.2263e-17
C207	a_661_87##6	SCE#2	3.28355e-17
C208	a_691_113##4	SCE#4	1.32902e-17
C209	a_32_74##3	DE#3	1.0052e-18
C210	a_575_87##19	a_1374_368##6	2.24594e-17
C211	a_575_87##19	a_575_87##4	9.42275e-19
C212	VGND#2	Q_N#3	2.74845e-19
C213	VGND#24	a_32_74#	1.70167e-17
C214	a_1586_74##7	a_575_87##6	2.61681e-17
C215	a_575_87##20	a_2489_74##8	5.46285e-17
C216	a_691_113##5	a_661_87##9	1.1566e-16
C217	a_32_74##2	DE#3	1.44225e-19
C218	VGND#3	a_2489_74##5	5.27589e-18
C219	a_575_87##5	a_2489_74##4	3.13331e-17
C220	CLK#2	a_1374_368##13	2.35212e-18
C221	a_691_113##7	SCE#5	3.97155e-19
C222	VGND#5	a_2489_74##8	1.39407e-17
C223	a_2013_71##12	a_2013_71##7	6.65595e-18
C224	VPWR#3	VPWR#6	1.00634e-16
C225	VGND#4	Q_N#3	4.47001e-17
C226	a_575_87##19	a_1586_74##3	1.7617e-18
C227	a_575_87##19	a_2489_74##12	7.01661e-18
C228	a_1586_74##10	a_1784_97#	2.4587e-18
C229	CLK#2	VGND#22	2.04533e-18
C230	CLK	a_1374_368##4	4.98423e-20
C231	VPWR#2	a_575_87##8	8.60207e-22
C232	a_2013_71##3	a_1784_97#	9.07438e-18
C233	VGND#10	CLK#2	8.87976e-20
C234	VPWR#19	a_183_290##6	1.2752e-18
C235	VGND#16	a_575_87##4	5.87509e-20
C236	a_575_87##13	VGND#11	6.16136e-18
C237	VGND#3	a_2489_74##6	1.18599e-17
C238	VPWR#13	a_1586_74##2	7.34888e-19
C239	a_1586_74##11	a_1784_97##2	2.11115e-18
C240	a_32_74##2	a_32_74##5	2.95e-18
C241	VPWR#9	a_1784_97##3	4.60602e-18
C242	VPWR#3	VPWR#2	6.34349e-17
C243	a_575_87##4	a_2591_74#	8.30758e-18
C244	a_1784_97##5	a_1374_368##2	1.55309e-17
C245	a_575_87##19	a_1586_74##2	4.0609e-19
C246	a_691_113##9	CLK#2	2.2536e-17
C247	VPWR#19	a_183_290##8	6.23232e-18
C248	VPWR#13	a_1374_368##3	6.33065e-20
C249	a_2489_74##8	VGND#17	1.20348e-17
C250	VPWR#11	a_2013_71##7	1.90438e-18
C251	a_1374_368##6	VPWR#12	7.51526e-18
C252	a_183_290##6	DE#3	3.93473e-17
C253	a_1374_368##10	a_2591_74#	8.30758e-18
C254	a_1586_74##8	a_575_87##5	3.4436e-17
C255	VPWR#9	a_2013_71##6	8.80571e-19
C256	a_575_87##13	VGND#10	3.91635e-18
C257	a_32_74##2	a_527_113#	4.92136e-18
C258	VGND#2	a_2489_74##8	1.68261e-20
C259	VGND#23	a_661_87##8	3.00615e-18
C260	a_183_290##9	a_32_74#	7.17574e-18
C261	a_661_87##3	SCE#5	1.75841e-18
C262	VGND#6	a_575_87##4	8.65929e-20
C263	a_32_74##3	a_183_290##2	5.87054e-17
C264	DE#2	a_575_87##2	1.95334e-19
C265	a_1374_368##12	a_1586_74##7	2.99071e-17
C266	VGND#8	a_1374_368##6	1.18803e-20
C267	a_1586_74##11	a_2013_71##3	3.26862e-17
C268	a_2013_71##12	a_1784_97##3	4.0773e-17
C269	a_2013_71##11	a_2013_71##6	4.76497e-17
C270	a_575_87##20	a_575_87##4	1.50562e-18
C271	a_1374_368##11	a_575_87##5	8.87684e-20
C272	a_575_87##19	VGND#19	2.41113e-18
C273	a_575_87##13	VGND#9	3.50967e-18
C274	VPWR#15	VPWR#14	2.4982e-20
C275	a_2489_74##11	a_575_87##20	3.02124e-18
C276	VGND#3	a_575_87##4	1.61948e-20
C277	VGND#3	a_575_87##20	2.61707e-17
C278	a_183_290#	DE#2	1.74194e-19
C279	a_661_87##3	a_691_113##7	1.65889e-17
C280	VPWR#9	a_2013_71#	2.17274e-18
C281	VPWR#20	DE#2	2.49769e-19
C282	VGND#8	a_1586_74##3	7.30439e-19
C283	a_1586_74##8	a_1374_368##11	9.84266e-17
C284	a_575_87##2	SCE#4	6.42235e-20
C285	a_1784_97##3	VPWR#11	2.33612e-17
C286	a_691_113##9	a_661_87##4	6.07398e-17
C287	VGND#11	a_661_87##4	1.33385e-18
C288	VGND#5	a_575_87##4	3.06017e-17
C289	a_1586_74##4	a_2013_71##3	1.16351e-17
C290	a_2013_71##9	a_2013_71##6	2.79294e-18
C291	VPWR#9	a_2489_74##13	5.4825e-18
C292	a_575_87##6	a_2672_508#	1.06762e-17
C293	a_1586_74##12	a_1586_74##4	4.45006e-18
C294	a_575_87##4	VGND#17	2.22146e-17
C295	D#4	a_183_290##9	3.30593e-18
C296	a_1586_74##6	a_1586_74##8	1.49308e-18
C297	a_1586_74##11	a_2013_71##2	7.72171e-17
C298	a_2013_71##12	a_2013_71#	3.20293e-18
C299	a_183_290##6	a_183_290##2	3.14846e-19
C300	a_32_74#	a_661_87##3	4.34195e-17
C301	VGND#10	a_661_87##4	1.8013e-19
C302	a_575_87##19	VGND#20	1.56058e-18
C303	a_1586_74##7	a_2672_508#	1.06762e-17
C304	a_1784_97##2	a_2013_71##12	2.86965e-17
C305	VPWR#13	a_1374_368##5	1.65764e-18
C306	a_183_290##4	SCE#4	1.08984e-19
C307	a_2013_71##7	a_1374_368##12	8.66737e-18
C308	a_2489_74##12	a_2489_74##8	1.90653e-19
C309	a_1374_368##13	SCD#2	2.9148e-21
C310	a_575_87##13	a_1586_74##2	3.51439e-17
C311	a_661_87##6	a_661_87##8	1.86983e-18
C312	a_691_113##2	a_1586_74##17	6.0871e-17
C313	a_1586_74##6	a_1374_368##11	8.07303e-17
C314	VPWR#13	a_1374_368##2	8.23171e-20
C315	VGND#23	a_661_87##4	1.17559e-18
C316	a_32_74##3	D#2	8.77489e-18
C317	VPWR#19	D#7	5.74985e-18
C318	a_575_87##2	DE#1	9.34884e-18
C319	a_1586_74##5	a_2417_74#	1.01094e-17
C320	VGND#11	a_661_87##6	8.97945e-18
C321	a_1784_97##2	a_2013_71##11	2.13134e-17
C322	VPWR#11	a_2013_71#	2.47422e-17
C323	D#6	DE#3	6.50853e-20
C324	a_1586_74##11	a_1586_74##4	1.45613e-17
C325	VGND#3	a_2489_74##12	1.72445e-19
C326	a_2013_71##4	a_2417_74#	1.25411e-17
C327	a_183_290##4	a_575_87#	4.02717e-19
C328	a_1374_368##11	a_2013_71##6	1.75383e-18
C329	a_575_87##13	a_1374_368##5	2.80859e-17
C330	DE#5	a_183_290##4	5.84698e-19
C331	VGND#6	a_1374_368##10	1.38176e-19
C332	a_1784_97##7	a_1784_97##3	9.82956e-19
C333	a_691_113##9	SCD#2	2.13753e-18
C334	a_2489_74##11	VGND#17	2.9349e-17
C335	D#4	DE#3	6.50853e-20
C336	a_661_87##8	SCD#1	3.92408e-19
C337	VGND#10	CLK	5.26293e-19
C338	a_1374_368##12	a_2374_392#	3.38869e-17
C339	a_183_290##4	DE#1	1.95969e-17
C340	a_183_290##9	VGND#24	4.80981e-17
C341	a_183_290##4	DE#2	2.16202e-17
C342	a_2489_74##11	a_1374_368##12	1.18277e-18
C343	a_2013_71##6	a_1586_74##6	3.37286e-17
C344	a_1374_368##11	a_1784_97##2	1.67825e-19
C345	a_2013_71##12	a_2013_71##2	4.53826e-19
C346	a_575_87##19	a_2489_74##11	5.60172e-17
C347	a_575_87##13	CLK#2	2.15554e-17
C348	a_575_87##19	a_575_87##8	1.78435e-19
C349	VGND#17	a_1374_368##10	1.16901e-19
C350	a_2013_71##7	a_2374_392#	1.94339e-17
C351	a_32_74#	a_575_87##3	3.17148e-17
C352	a_32_74##2	VPWR#21	7.67204e-17
C353	a_1586_74##12	a_1374_368##6	2.17572e-19
C354	a_1374_368#	a_1586_74##4	9.32469e-18
C355	Q_N#3	a_575_87##8	1.2712e-17
C356	a_32_74##3	D#7	6.05721e-17
C357	a_32_74#	DE#5	6.76427e-20
C358	a_2013_71##9	a_1784_97##2	2.95272e-17
C359	D#7	a_183_290##2	4.52309e-17
C360	a_1784_97##3	a_2013_71##7	4.68154e-18
C361	VPWR#21	a_691_113##5	1.92742e-18
C362	a_691_113##4	a_1374_368##15	5.01212e-17
C363	a_1586_74##6	a_1784_97##2	6.74823e-19
C364	a_32_74##3	a_141_74#	2.32468e-19
C365	VPWR#11	a_2013_71##2	2.89243e-19
C366	VPWR#19	CLK#2	1.02566e-18
C367	a_1586_74##12	a_1374_368#	2.99811e-17
C368	VGND#24	a_661_87##3	4.53818e-19
C369	a_2489_74##12	a_575_87##4	1.98415e-17
C370	VGND#23	SCD#2	2.89641e-17
C371	VPWR#15	CLK#2	1.15776e-19
C372	a_691_113##4	a_691_113##2	1.31472e-18
C373	VGND#12	VGND#13	9.10064e-17
C374	VGND#5	a_1374_368##10	8.34373e-18
C375	VGND#9	a_1586_74##12	2.17931e-17
C376	a_575_87##13	a_661_87##4	6.15257e-17
C377	VPWR#11	a_1374_368##7	3.83681e-18
C378	VGND#11	SCD#2	2.35431e-19
C379	a_1586_74##11	a_1374_368##6	3.88781e-18
C380	a_575_87##19	a_2489_74##3	1.65913e-17
C381	VPWR#2	a_2489_74##2	6.70514e-21
C382	a_32_74##3	a_183_290##8	5.03863e-17
C383	a_1784_97##5	a_1784_97##2	2.16607e-18
C384	a_1374_368##6	VPWR#9	2.70658e-17
C385	a_691_113##7	a_661_87##8	1.52831e-17
C386	VGND#5	VGND#16	2.53639e-18
C387	a_1784_97##7	a_2013_71#	3.54162e-18
C388	a_691_113##2	VPWR#14	4.96905e-17
C389	VPWR#17	VPWR#16	3.50983e-19
C390	a_1784_97##2	a_2013_71##6	2.07086e-17
C391	a_1586_74##10	a_2013_71##11	6.94386e-17
C392	VPWR#19	a_661_87##4	4.74876e-18
C393	D#6	a_183_290##2	1.8692e-17
C394	VGND#16	VGND#4	2.06074e-18
C395	VGND#12	VGND#11	1.19454e-16
C396	a_2013_71#	a_2013_71##7	3.1678e-19
C397	a_575_87##13	SCD#2	1.3617e-17
C398	a_691_113##9	SCE#3	2.093e-20
C399	a_2013_71##9	a_2013_71##4	4.14337e-19
C400	a_1374_368##6	a_2013_71##12	6.97023e-17
C401	VGND#25	VGND#24	5.13894e-18
C402	a_2013_71##2	a_2013_71##11	3.08257e-18
C403	a_2013_71##2	a_2013_71##6	3.04571e-19
C404	D#4	a_183_290##2	3.35927e-17
C405	VGND#12	a_661_87##4	5.57496e-18
C406	a_1586_74##11	a_1374_368#	5.151e-19
C407	a_2013_71#	a_1944_508#	1.02925e-17
C408	a_575_87##13	VPWR#20	7.66881e-19
C409	a_32_74#	a_183_290##3	4.32193e-18
C410	a_661_87##8	SCE#4	1.26095e-18
C411	VGND#12	VGND#10	5.6972e-17
C412	VGND#17	a_1586_74##5	8.5286e-20
C413	a_1374_368##6	VPWR#11	4.26499e-17
C414	a_575_87##13	SCE#3	1.32824e-17
C415	a_1374_368##7	a_1944_508#	1.16932e-17
C416	a_1784_97##2	a_2013_71##2	9.75777e-17
C417	a_1374_368##6	a_2013_71##6	9.26333e-19
C418	VGND#6	a_1586_74##5	5.60385e-18
C419	VPWR#11	a_1586_74#	7.01243e-19
C420	a_32_74##2	a_183_290##8	5.03196e-17
C421	VGND#24	a_575_87##3	4.94361e-18
C422	a_2013_71##3	a_1920_97#	1.47366e-18
C423	a_2013_71#	a_1784_97##3	2.90736e-17
C424	VGND#12	SCD#2	1.12675e-18
C425	VGND#11	SCD	1.57288e-18
C426	a_575_87##13	VPWR#17	4.08928e-18
C427	D#7	D#2	1.38034e-17
C428	a_32_74##6	D#6	8.91461e-18
C429	a_2489_74##12	a_1374_368##10	2.63564e-17
C430	VPWR#3	a_2489_74##11	4.02151e-18
C431	a_1784_97##7	a_1374_368##7	2.77019e-17
C432	a_1586_74##4	a_1920_97#	1.12955e-17
C433	DE#5	DE#3	6.76193e-18
C434	D#1	a_183_290##2	1.84631e-17
C435	a_1374_368##9	a_1374_368#	5.19335e-18
C436	a_2013_71##12	VPWR#9	1.04984e-18
C437	a_1586_74##12	a_1586_74##3	2.89567e-19
C438	a_2013_71##9	a_2013_71##2	4.10029e-19
C439	a_1784_97##2	a_1374_368##6	2.26296e-17
C440	a_691_113##4	VPWR#16	6.40407e-17
C441	SCE#3	a_661_87##6	2.31242e-17
C442	VGND#12	D#4	1.01315e-17
C443	VPWR#15	a_1374_368##8	1.32973e-19
C444	VGND#12	SCE#3	2.91608e-18
C445	a_1586_74##12	a_1374_368##9	3.90791e-19
C446	VGND#19	a_575_87##4	1.16679e-19
C447	VGND#8	a_2013_71##3	6.65853e-18
C448	a_32_74##3	VPWR#23	7.54555e-17
C449	a_1784_97##7	a_1374_368##6	3.09401e-17
C450	a_1586_74##13	a_691_113##8	5.17998e-17
C451	a_575_87##13	VPWR#15	5.27157e-18
C452	a_1586_74##11	a_1586_74##3	1.73984e-17
C453	VGND#25	a_183_290##9	1.96462e-17
C454	D#6	D#2	6.45342e-18
C455	a_1784_97##5	a_2013_71##2	7.44366e-18
C456	VPWR#15	a_661_87##4	2.11701e-19
C457	a_1374_368##6	a_2013_71##2	1.34443e-17
C458	a_183_290##9	a_575_87##3	4.74323e-19
C459	a_1374_368##15	a_691_113##2	1.70971e-17
C460	a_575_87##13	a_575_87##2	3.0502e-17
C461	VGND#5	a_1586_74##5	1.07862e-18
C462	VGND#11	SCE#3	1.3373e-18
C463	a_32_74#	DE#7	1.24336e-18
C464	a_575_87##19	a_1586_74##12	2.32591e-18
C465	a_32_74##2	a_661_87##3	4.37707e-19
C466	a_1586_74##11	a_2013_71##9	1.35774e-17
C467	D#4	D#2	1.15534e-17
C468	VPWR#14	a_2013_71#	3.05605e-19
C469	a_691_113##4	a_1088_453#	2.57863e-18
C470	VGND#8	a_1586_74##4	3.22931e-18
C471	a_1586_74##12	a_1784_97##5	2.46391e-19
C472	VPWR#11	a_1374_368##8	4.6533e-19
C473	VGND#5	a_575_87##20	3.60212e-17
C474	VGND#7	a_2013_71##4	1.07693e-19
C475	a_575_87##13	VPWR#13	6.45937e-18
C476	a_2013_71##9	a_1784_97#	9.20916e-18
C477	VPWR#13	a_1374_368##8	9.57137e-19
C478	VPWR#19	a_575_87##2	3.88069e-18
C479	a_1586_74##3	a_2013_71##2	2.81059e-17
C480	VGND#24	a_183_290##3	3.84283e-17
C481	VPWR#3	a_2489_74##3	1.02083e-19
C482	a_1784_97##7	a_1586_74#	2.50581e-17
C483	a_2013_71##11	a_1374_368##6	5.49582e-19
C484	a_1374_368##7	a_2013_71#	1.85929e-17
C485	a_575_87##13	a_183_290##4	6.22185e-18
C486	D#4	a_32_74##6	4.99385e-17
C487	VPWR#11	VPWR#9	7.98157e-18
C488	Q_N#3	a_2489_74##2	9.18526e-20
C489	VGND#12	a_575_87##2	3.53165e-18
C490	a_661_87##5	a_1088_453#	1.53392e-17
C491	a_575_87##19	a_1586_74##11	2.00474e-17
C492	a_1586_74##3	a_1374_368##6	1.75761e-17
C493	a_2489_74##12	a_1586_74##5	3.4783e-17
C494	a_1586_74##2	a_2013_71##2	1.55979e-19
C495	VGND#8	a_1374_368#	1.45709e-18
C496	a_575_87##19	a_1374_368##2	9.67974e-19
C497	VPWR#19	VPWR#20	8.02191e-17
C498	VPWR#19	a_183_290##4	3.42256e-18
C499	a_32_74##3	D#6	6.33187e-18
C500	SCD#1	a_1088_453#	1.53392e-17
C501	VPWR#3	a_2489_74##2	5.08802e-20
C502	a_575_87##13	DE#3	2.44957e-18
C503	VPWR#17	CLK#3	2.75755e-19
C504	a_1586_74#	a_691_113#	1.27875e-17
C505	CLK#1	a_1374_368##9	4.71239e-18
C506	VGND#19	a_1374_368##10	2.2846e-19
C507	a_1586_74##2	a_1374_368##6	2.32975e-17
C508	VGND#12	a_183_290##4	5.1483e-18
C509	VGND#6	a_2013_71##4	6.88896e-18
C510	VGND#3	a_2489_74##11	8.75713e-18
C511	a_183_290##9	a_183_290##3	2.09747e-18
C512	a_575_87##19	a_1586_74##10	1.20983e-17
C513	a_691_113##4	a_691_113##10	1.12539e-18
C514	VPWR#2	VPWR#1	1.56089e-18
C515	a_1586_74##12	a_1586_74##2	8.06771e-19
C516	VPWR#19	VPWR#17	1.15289e-16
C517	VPWR#14	a_1374_368##7	3.48785e-19
C518	VPWR#19	DE#3	1.75647e-18
C519	VGND#11	VGND#10	2.27181e-19
C520	a_1586_74##2	a_1586_74##3	5.72388e-19
C521	a_1784_97##7	a_1374_368##8	1.14415e-18
C522	VGND#12	DE#3	2.49584e-18
C523	a_1784_97##5	a_1374_368##6	9.3978e-17
C524	a_691_113##2	VPWR#16	1.97567e-20
C525	VGND#24	DE#7	1.35206e-17
C526	VPWR#15	CLK#3	7.68284e-18
C527	a_183_290##2	DE#5	1.40132e-17
C528	a_575_87##4	a_2489_74##4	1.93416e-18
C529	VPWR#19	VPWR#15	5.70848e-17
C530	a_1586_74#	a_1374_368##7	2.09915e-17
C531	VPWR#19	a_183_290##2	5.34502e-18
C532	a_1586_74##11	VGND#7	2.7182e-17
C533	a_2013_71##9	a_1586_74##10	1.57925e-18
C534	a_183_290##2	DE#2	5.52702e-18
C535	VGND#25	a_183_290##3	3.36836e-19
C536	a_1784_97##7	a_1586_74##2	1.47166e-17
C537	a_1784_97##5	a_1586_74##11	1.95561e-17
C538	VGND#5	a_2013_71##4	1.64005e-19
C539	a_2013_71##9	a_2013_71##3	4.18397e-20
C540	a_575_87##9	Q_N#3	4.52943e-17
C541	VGND#12	a_183_290##2	5.36571e-18
C542	a_2489_74##12	a_2013_71##4	5.64959e-18
C543	a_691_113#	a_1374_368##8	3.68094e-18
C544	VGND#3	a_575_87##8	4.61406e-19
C545	VGND#5	VGND#17	9.2479e-18
C546	a_575_87#	a_578_462#	1.41674e-17
C547	VGND#7	a_1784_97#	6.43354e-18
C548	a_32_74##6	a_183_290##9	1.89839e-18
C549	a_1586_74##2	a_691_113#	4.0873e-17
C550	VPWR#14	a_1586_74#	2.68199e-18
C551	a_183_290##9	DE#7	4.03533e-17
C552	a_691_113##7	a_575_87##2	6.6935e-19
C553	VGND#21	a_1586_74##13	6.95935e-17
C554	a_1374_368##13	a_691_113##8	1.32102e-18
C555	VGND#19	a_1586_74##5	2.62983e-18
C556	DE#1	a_578_462#	1.41674e-17
C557	VGND#4	a_575_87##9	1.81539e-17
C558	a_575_87##4	a_575_87##5	1.33069e-18
C559	a_575_87##20	VGND#16	5.73587e-17
C560	SCE#1	CLK#1	4.99944e-18
C561	VGND#9	a_1374_368##4	3.34132e-21
C562	a_691_113##2	a_1374_368##4	1.54681e-17
C563	a_691_113##8	a_1374_368##4	2.0445e-18
C564	DE#7	DE#2	1.60652e-18
C565	a_32_74#	a_575_87##2	5.4157e-17
C566	VGND#3	a_2489_74##3	1.84944e-18
C567	a_1586_74##17	a_1374_368##8	3.04503e-17
C568	a_32_74##3	a_32_74##4	3.0196e-18
C569	VGND#24	DE#6	1.13477e-18
C570	a_2013_71##9	a_1586_74##3	1.25502e-19
C571	VPWR#17	a_661_87##5	5.07031e-18
C572	CLK#2	a_1374_368##5	1.43495e-17
C573	a_1374_368##8	a_1586_74#	3.85431e-18
C574	a_575_87##13	SCE#1	7.20159e-19
C575	a_1784_97##6	a_1374_368##2	9.25838e-20
C576	VGND#6	a_1784_97#	7.25249e-19
C577	VGND#25	DE#7	2.33969e-18
C578	VGND#3	a_2489_74##2	5.66918e-20
C579	Q_N	a_575_87##8	1.32483e-17
C580	VGND#2	a_575_87##9	6.63862e-19
C581	a_1784_97##5	a_1586_74##3	6.52226e-18
C582	VPWR#14	a_1374_368##8	4.07404e-17
C583	SCE#1	a_1091_125#	9.87534e-18
C584	Q_N	a_2489_74##2	8.53401e-20
C585	VPWR#17	SCE#3	3.11241e-20
C586	a_2489_74##12	a_1784_97#	3.32546e-19
C587	a_575_87##4	a_1586_74##8	3.4074e-17
C588	a_32_74##6	VGND#25	1.43163e-17
C589	VGND#24	DE#2	1.70103e-18
C590	a_183_290#	a_132_464#	1.53896e-17
C591	SCD#3	a_1091_125#	9.87534e-18
C592	a_183_290##9	DE#6	2.59822e-18
C593	a_183_290##9	a_575_87##2	2.16679e-19
C594	a_661_87##4	CLK#2	6.89557e-18
C595	D#1	a_132_464#	1.59113e-17
C596	a_2489_74##3	Q#3	1.59807e-19
C597	VGND#19	a_2013_71##4	4.33441e-17
C598	VGND#7	a_1586_74##10	6.66912e-18
C599	VGND#13	a_575_87##2	3.41263e-19
C600	a_575_87##19	a_2013_71##11	5.15127e-17
C601	D#2	DE#5	4.02581e-19
C602	a_32_74#	a_183_290##4	4.83869e-19
C603	VGND#13	DE#5	1.65643e-19
C604	a_691_113##8	a_1374_368##3	4.18927e-18
C605	SCD#2	CLK#2	1.11579e-18
C606	a_32_74##2	SCE#4	7.03494e-20
C607	a_575_87##19	a_575_87##7	1.87447e-19
C608	CLK#3	a_1374_368##8	2.16392e-18
C609	a_1374_368##2	a_2013_71##2	1.87794e-18
C610	SCE#1	SCD#3	4.75014e-17
C611	VGND#25	DE#6	3.46434e-17
C612	a_1374_368##11	a_575_87##4	6.54251e-19
C613	a_691_113##2	a_1374_368##3	8.0778e-18
C614	a_661_87##4	SCD#2	8.25542e-17
C615	VPWR#14	CLK#3	4.12932e-18
C616	a_1374_368##15	a_1374_368##5	1.56256e-17
C617	a_575_87##13	a_661_87##3	8.34939e-19
C618	a_183_290##9	DE#5	2.69173e-17
C619	VGND#24	a_183_290##4	1.32478e-17
C620	a_575_87##13	a_691_113##8	2.07491e-17
C621	a_691_113##4	VPWR#18	4.5641e-17
C622	VPWR#16	a_1374_368##8	1.5833e-18
C623	VGND#12	SCE#1	5.87103e-18
C624	a_32_74##6	DE#7	4.8292e-19
C625	a_2013_71##8	a_2013_71##4	4.17675e-19
C626	D#4	DE#5	6.61885e-20
C627	VGND#9	a_1374_368##3	7.55882e-20
C628	a_661_87##4	SCE#3	9.58839e-20
C629	a_1586_74##12	a_1374_368##2	1.90931e-18
C630	a_691_113##4	VPWR#17	5.92898e-18
C631	a_575_87##19	a_575_87##12	1.6806e-18
C632	VGND#5	a_2489_74##4	8.31526e-19
C633	a_183_290##9	D#3	1.13144e-18
C634	VGND#6	a_2489_74##12	1.11175e-17
C635	VPWR#17	SCD#1	3.58667e-18
C636	a_183_290##9	a_183_290##4	1.37492e-18
C637	a_1784_97##7	VPWR#11	7.90361e-18
C638	a_575_87##19	a_2013_71##9	1.06084e-17
C639	VPWR#3	a_575_87##7	1.97237e-18
C640	a_1586_74##13	a_1374_368##4	2.81388e-19
C641	a_1784_97##5	a_1586_74##2	8.21016e-17
C642	a_1374_368##15	CLK#3	3.39707e-17
C643	a_1374_368##13	VGND#21	6.97739e-17
C644	a_661_87##8	SCE	1.60343e-17
C645	a_575_87##13	a_1586_74##13	9.33147e-18
C646	SCE#3	SCD#2	6.37036e-17
C647	SCE#2	SCE#1	1.50035e-18
C648	VGND#12	SCD#3	2.37059e-18
C649	VGND#19	a_1784_97#	4.78069e-19
C650	DE#3	a_32_74#	1.7019e-18
C651	a_2489_74##2	Q#3	2.03183e-19
C652	a_1586_74##5	a_1374_368##11	3.42108e-18
C653	a_1374_368##13	CLK	1.87144e-17
C654	a_1374_368##11	a_2374_392#	1.39134e-17
C655	VPWR#19	a_661_87##3	3.15517e-19
C656	a_2489_74##4	a_575_87##20	1.0676e-18
C657	a_575_87##19	a_2489_74#	5.95059e-21
C658	VGND#22	CLK	5.8856e-18
C659	a_691_113##8	a_1374_368##2	1.18353e-17
C660	VGND#10	VGND#9	5.95704e-19
C661	a_575_87##19	a_1784_97##5	4.52651e-17
C662	a_691_113##9	CLK	1.19808e-17
C663	a_32_74##2	VPWR#20	3.57854e-17
C664	VGND#17	a_575_87##20	4.19906e-17
C665	a_661_87##5	CLK#3	4.45099e-18
C666	CLK#2	a_1374_368##15	3.96761e-17
C667	VPWR#3	a_575_87##12	3.42011e-18
C668	a_1586_74##6	a_2374_392#	4.63792e-18
C669	a_2013_71##11	a_1374_368##12	1.39334e-19
C670	VGND#25	D#3	5.97533e-18
C671	a_32_74##3	DE#6	1.19147e-18
C672	a_575_87##13	VGND#21	8.39143e-18
C673	VGND#6	a_1586_74##10	3.88234e-17
C674	VGND#12	SCE#2	3.4397e-18
C675	Q	a_575_87##8	1.33834e-19
C676	VPWR#16	CLK#3	3.32282e-17
C677	Q	a_2489_74##3	1.71634e-17
C678	VGND#2	Q_N	1.6805e-17
C679	Q	a_2489_74##2	1.9776e-17
C680	a_183_290##9	DE#2	1.195e-18
C681	a_2489_74##4	VGND#17	3.42678e-17
C682	a_32_74##2	SCE#5	1.21147e-17
C683	VGND#13	a_183_290##9	5.70882e-18
C684	a_32_74##6	DE#6	5.97998e-18
C685	a_575_87##19	a_2489_74##7	4.54171e-18
C686	VGND#13	a_183_290##4	4.74143e-19
C687	SCE#2	SCD#3	1.89629e-17
C688	VGND#13	DE#2	5.67248e-19
C689	a_1784_97#	a_2013_71##8	9.81351e-18
C690	VPWR#3	a_2489_74#	3.83096e-19
C691	a_575_87##13	a_1374_368##13	3.4279e-18
C692	VGND#12	a_661_87##3	1.05824e-17
C693	a_183_290##9	DE#3	4.04722e-17
C694	VGND#16	a_2489_74##3	1.24075e-17
C695	VGND#5	a_2489_74##12	2.86152e-17
C696	a_32_74##2	a_578_462#	2.50085e-18
C697	Q_N	VPWR#2	1.51724e-17
C698	a_661_87##9	a_691_113##4	3.58305e-17
C699	a_1586_74##13	a_1374_368##3	4.76412e-18
C700	VGND#22	VGND#21	1.98309e-18
C701	a_1586_74##10	a_2417_74#	2.75221e-18
C702	a_575_87##19	a_2489_74##9	5.49501e-18
C703	VGND#13	DE#1	1.64782e-18
C704	a_691_113##4	VPWR#15	2.32548e-17
C705	VGND#12	a_575_87##3	1.35251e-17
C706	a_575_87##13	VGND#22	7.6632e-18
C707	a_1374_368##15	a_661_87##4	2.0824e-18
C708	VPWR#3	a_2489_74##7	4.36266e-18
C709	VPWR#16	a_661_87##5	2.2617e-18
C710	VGND#9	a_1374_368##2	2.66419e-20
C711	SCD#1	a_661_87##5	3.63144e-17
C712	SCD	a_691_113##9	1.99763e-17
C713	SCE#4	CLK#3	1.28737e-19
C714	VGND#25	DE#5	5.01733e-18
C715	VPWR#17	SCE#4	1.6913e-17
C716	a_1784_97#	VGND#20	2.18757e-17
C717	a_691_113##2	a_1586_74##2	4.71268e-18
C718	a_2013_71##6	a_1586_74##5	9.82677e-18
C719	a_1374_368##6	a_1944_508#	3.90423e-18
C720	VGND#12	a_183_290##3	4.4635e-18
C721	VPWR#20	a_691_113##5	1.90302e-18
C722	VPWR#20	a_575_87##2	9.51591e-20
C723	a_575_87##13	a_691_113##9	2.38107e-17
C724	a_32_74##6	D#3	3.81575e-17
C725	a_183_290##4	a_575_87##2	6.79283e-17
C726	a_183_290##6	DE#7	1.62068e-18
C727	a_575_87##3	a_527_113#	9.87534e-18
C728	a_183_290##3	a_527_113#	9.87534e-18
C729	a_661_87##4	a_691_113##10	3.26357e-18
C730	a_2013_71##11	a_2013_71##7	1.50529e-18
C731	a_661_87##5	a_691_113##10	2.14377e-17
C732	VGND#8	a_1586_74##12	4.887e-17
C733	VGND#21	a_1374_368##4	4.53725e-20
C734	a_32_74##2	a_575_87#	3.53327e-17
C735	a_183_290##9	a_183_290##2	3.55068e-18
C736	DE#3	a_575_87##2	6.01718e-19
C737	VPWR#15	SCE#4	2.40475e-19
C738	VGND#9	a_1374_368#	1.79417e-18
C739	VGND#12	DE#7	7.63561e-18
C740	VPWR#18	CLK#3	3.46098e-19
C741	a_183_290##6	SCE#5	8.32126e-20
C742	a_32_74##3	a_132_464#	3.16339e-18
C743	VPWR#12	a_1374_368##2	1.80204e-19
C744	VGND#22	a_1374_368##13	5.29213e-17
C745	VGND#25	a_183_290##2	2.46537e-17
C746	a_1586_74##13	a_1374_368##2	4.94109e-20
C747	VGND#2	Q	3.97763e-18
C748	DE#3	a_183_290##4	3.51563e-17
C749	a_183_290##2	a_575_87##2	9.50769e-20
C750	VPWR#6	VPWR#5	1.63094e-18
C751	VPWR#16	SCD#1	3.07015e-19
C752	VGND#8	a_1586_74##11	2.13157e-17
C753	a_1784_97#	a_2013_71##6	1.19281e-17
C754	VGND#25	VGND#13	2.67911e-18
C755	a_691_113##4	a_1374_368##5	2.16095e-19
C756	SCE#4	SCD#1	2.21047e-17
C757	a_575_87##9	VPWR#2	3.04147e-19
C758	VGND#12	DE#6	2.23454e-18
C759	a_183_290##2	a_183_290##4	2.42422e-18
C760	a_575_87##13	VGND#23	8.57504e-18
C761	a_691_113##5	VPWR#17	4.82465e-17
C762	CLK	a_1374_368##15	1.11261e-17
C763	a_691_113#	a_1784_97##7	5.00553e-17
C764	VPWR#3	VPWR#1	6.52111e-17
C765	VPWR#17	VPWR#15	5.63572e-19
C766	VPWR#20	SCE#5	2.10245e-18
C767	SCE	a_661_87##6	1.89357e-17
C768	a_2013_71##3	VGND#20	1.23316e-17
C769	a_183_290##2	DE#3	6.52406e-17
C770	a_661_87##9	a_661_87##4	1.46052e-18
C771	VGND#12	D#3	2.27114e-18
C772	a_575_87##20	a_2489_74##3	2.22028e-19
C773	a_575_87##13	a_661_87##6	4.63253e-18
C774	VPWR#18	a_661_87##5	3.09483e-18
C775	a_1374_368##5	a_691_113##2	7.53519e-17
C776	D#2	DE#3	7.77817e-19
C777	a_691_113##5	CLK#3	1.34027e-19
C778	VPWR#16	SCE#4	1.75893e-19
C779	a_1374_368##2	a_1586_74##3	2.16383e-18
C780	a_32_74##2	DE#1	3.09192e-17
C781	D#2	a_183_290##2	4.78064e-17
C782	a_691_113##9	a_1374_368##13	5.56606e-18
C783	a_1586_74##13	a_691_113##2	1.18079e-17
C784	VPWR#18	SCD#2	4.1183e-19
C785	a_575_87##13	a_691_113##7	2.07547e-17
C786	DE#6	a_141_74#	9.7209e-18
C787	a_183_290##6	a_575_87#	3.6795e-19
C788	a_575_87##3	a_661_87##3	3.5096e-17
C789	a_575_87##13	a_1586_74##12	1.85274e-18
C790	a_575_87##19	VPWR#5	3.15557e-18
C791	SCE#5	SCE#4	4.32832e-18
C792	D#3	a_141_74#	1.01349e-17
C793	a_661_87##9	a_661_87##5	4.34612e-21
C794	VGND#12	VGND#22	1.45153e-17
C795	VPWR#3	VPWR#4	1.52186e-17
C796	a_691_113##8	a_1586_74##17	2.56248e-17
C797	VPWR#6	a_2489_74##4	6.93053e-19
C798	a_32_74##6	D#2	7.97882e-18
C799	a_2489_74##12	a_1586_74##8	4.76188e-17
C800	Q_N	VGND#1	1.98286e-17
C801	VGND#9	a_1374_368##9	5.41649e-18
C802	a_32_74##2	a_691_113##7	3.70801e-18
C803	a_575_87##13	a_32_74#	2.61658e-17
C804	Q_N	Q_N#3	5.6011e-18
C805	a_2489_74##3	a_2489_74##2	3.53734e-18
C806	CLK#2	a_691_113##4	2.88759e-18
C807	VPWR#18	SCD#1	3.40726e-17
C808	a_2013_71##2	a_1784_97#	5.07659e-18
C809	VGND#4	Q_N	1.84999e-17
C810	VGND#20	a_1586_74##4	2.02259e-18
C811	a_575_87##16	VPWR#6	5.18057e-17
C812	VGND#12	a_691_113##9	1.72104e-17
C813	a_575_87##19	a_575_87##16	5.85769e-18
C814	a_2489_74##12	VGND#17	7.28452e-19
C815	a_1586_74##11	a_1920_97#	1.24644e-18
C816	a_575_87#	SCE#4	2.89719e-19
C817	a_1374_368##15	a_1374_368#	4.79008e-20
C818	a_661_87##8	a_691_113##4	1.45398e-17
C819	a_32_74##3	DE#4	2.34064e-18
C820	VGND#11	CLK#1	4.85589e-19
C821	VGND#8	a_1374_368##2	5.39704e-20
C822	VPWR	VPWR#15	3.04768e-17
C823	VPWR#21	DE#2	4.45527e-19
C824	VPWR	VPWR#13	1.09297e-16
C825	a_1586_74##10	a_2489_74##11	5.52245e-19
C826	VPWR	VPWR#10	4.80364e-17
C827	VPWR	VPWR#8	1.08719e-16
C828	VPWR	VPWR#6	3.64646e-17
C829	a_575_87##9	a_575_87##7	8.99852e-19
C830	a_661_87##9	SCD#1	5.98151e-19
C831	VPWR#20	a_575_87#	7.43588e-19
C832	VPWR#1	a_575_87##7	4.38486e-17
C833	a_2489_74##11	a_2489_74##6	9.538e-21
C834	VGND#19	VGND#5	1.25684e-18
C835	a_691_113##9	VGND#22	3.42325e-17
C836	VPWR#3	VPWR#5	1.52489e-17
C837	a_691_113#	a_1586_74##17	5.06486e-18
C838	a_575_87#	SCE#5	4.56759e-17
C839	a_1586_74##3	a_1920_97#	1.2949e-18
C840	a_691_113##2	VPWR#15	9.54819e-19
C841	a_1586_74##2	a_1374_368##4	1.27129e-19
C842	a_32_74##2	DE#4	3.20631e-17
C843	a_32_74##3	DE#5	3.78881e-19
C844	CLK	a_1374_368##9	7.12032e-20
C845	SCE#4	VPWR#18	2.14527e-17
C846	a_1586_74##10	a_2489_74##12	4.22717e-17
C847	a_575_87##9	a_575_87##12	6.79434e-18
C848	a_183_290##3	a_575_87##3	4.69283e-17
C849	VPWR#4	VPWR#1	1.17452e-18
C850	VGND#21	a_691_113##2	8.2954e-19
C851	VGND#10	CLK#1	4.70195e-18
C852	a_691_113##5	SCD#1	5.89088e-19
C853	VPWR#17	a_575_87#	1.43031e-19
C854	a_575_87##16	VPWR#2	1.29327e-18
C855	a_575_87##16	VPWR#3	5.20365e-17
C856	VGND#5	a_1374_368##11	5.04183e-20
C857	a_1374_368##15	a_1374_368##9	1.00854e-18
C858	a_2489_74##12	a_1374_368##11	7.38663e-19
C859	a_575_87##7	Q_N#1	2.43736e-17
C860	Q	Q_N#3	2.0954e-18
C861	a_1784_97##5	a_1784_97##3	4.48599e-19
C862	Q	VGND#4	6.43643e-17
C863	a_32_74#	a_32_74##2	9.95005e-19
C864	VPWR	a_1784_97##5	1.91482e-18
C865	VGND#12	a_661_87##6	1.2715e-17
C866	a_575_87##9	a_2489_74#	8.5426e-18
C867	VGND#16	Q	7.4291e-17
C868	SCE#4	a_661_87##9	1.80394e-17
C869	a_1586_74##2	a_1374_368##2	5.1128e-17
C870	VPWR	a_691_113##4	5.78043e-18
C871	a_575_87##20	Q	2.50561e-18
C872	a_575_87##13	a_1374_368##4	3.05112e-18
C873	a_575_87##10	a_575_87##11	3.81248e-17
C874	a_661_87##4	a_691_113##4	1.13845e-16
C875	a_575_87##19	a_2489_74##13	3.32824e-18
C876	VPWR	a_691_113##2	1.98957e-17
C877	Q_N	VPWR#1	1.11178e-16
C878	a_1784_97##6	a_1586_74##4	6.11928e-18
C879	a_575_87##5	VPWR#6	3.27216e-17
C880	Q_N	Q_N#1	2.62798e-17
C881	VPWR#14	a_691_113#	7.86857e-18
C882	VPWR#1	a_575_87##12	2.96514e-18
C883	VPWR#4	Q_N	3.79802e-17
C884	a_32_74##3	a_183_290#	2.87677e-17
C885	VGND#22	a_691_113##4	9.05434e-19
C886	DE#1	a_575_87#	5.20763e-17
C887	SCD	SCE#1	2.99397e-18
C888	VGND#9	CLK#1	8.13155e-19
C889	VGND	VGND#10	2.22714e-17
C890	VGND#12	a_691_113##7	3.05721e-17
C891	a_575_87##9	a_2489_74##7	6.47512e-19
C892	VGND	VGND#9	1.01838e-16
C893	VPWR#12	a_2013_71#	5.28761e-18
C894	VPWR#6	VPWR#7	6.96119e-18
C895	a_575_87##16	Q_N	1.37745e-17
C896	VGND	VGND#7	6.43198e-17
C897	VGND	VGND#6	9.98326e-17
C898	VGND	VGND#5	4.88452e-17
C899	VPWR#4	a_575_87##7	2.09163e-18
C900	a_575_87##13	a_1374_368##3	1.37043e-18
C901	a_1586_74##3	a_2013_71##3	6.90302e-18
C902	a_691_113##5	SCE#4	3.36871e-17
C903	a_2489_74##11	VPWR#6	1.10108e-18
C904	VGND#11	SCE#1	1.57737e-17
C905	a_1374_368##15	a_691_113##8	5.34679e-18
C906	a_691_113##2	a_661_87##4	3.04639e-20
C907	a_32_74##2	a_183_290#	1.00991e-19
C908	a_575_87##9	a_2489_74##9	1.99052e-19
C909	VGND#12	a_32_74#	2.51505e-17
C910	a_32_74##3	DE#2	1.62405e-18
C911	a_2489_74##11	a_2489_74##8	7.48574e-19
C912	VPWR#12	a_1374_368##7	4.55511e-18
C913	a_691_113##2	VPWR#13	1.19806e-17
C914	VPWR#15	VPWR#13	4.74863e-19
C915	a_575_87##13	a_1374_368##2	3.03694e-18
C916	VPWR#20	DE#1	7.49095e-18
C917	DE#2	a_183_290##8	1.07066e-18
C918	a_661_87##9	SCE#5	4.34892e-18
C919	DE#7	a_183_290##3	2.79434e-17
C920	a_2489_74##3	Q#1	1.2171e-19
C921	a_575_87##19	VPWR#9	3.20993e-18
C922	VGND#6	a_1586_74##6	1.89271e-19
C923	a_1374_368#	a_1586_74##3	5.14235e-18
C924	VGND	a_1586_74##12	3.74103e-17
C925	VGND	a_1586_74##11	3.20893e-17
C926	VGND	a_1586_74##10	3.45083e-17
C927	a_691_113#	a_1374_368##2	4.12365e-19
C928	VPWR#12	a_1586_74#	7.7145e-18
C929	DE#4	DE#1	1.18479e-17
C930	a_1374_368#	a_1784_97##6	1.50799e-17
C931	VGND	a_2013_71##11	5.11105e-18
C932	a_691_113##5	a_575_87##2	1.07353e-18
C933	VGND#10	SCE#1	7.32425e-19
C934	a_575_87##16	Q	4.76276e-17
C935	VGND	a_2013_71##9	1.1665e-18
C936	a_691_113##5	SCE#5	6.43906e-17
C937	VGND	a_1784_97##5	1.61422e-18
C938	VGND#23	VGND#22	3.87614e-18
C939	a_575_87##19	a_2013_71##12	9.492e-18
C940	VPWR#4	a_575_87##12	3.96589e-17
C941	VPWR#2	a_575_87##12	4.22671e-18
C942	VGND	a_691_113##2	1.60398e-18
C943	a_691_113##4	SCD#2	1.33454e-18
C944	a_32_74##3	D#1	4.72148e-17
C945	a_2489_74##5	a_575_87##10	4.04532e-17
C946	Q_N	a_575_87##11	9.297e-18
C947	a_691_113##9	a_691_113##4	1.03554e-18
C948	Q_N	a_575_87##10	9.04265e-18
C949	a_661_87##9	a_575_87#	5.44446e-20
C950	D#4	DE#7	3.06631e-19
C951	Q_N	a_2489_74##5	4.93198e-19
C952	VPWR#6	a_1586_74##8	4.01883e-19
C953	a_1586_74##2	a_1374_368#	2.53776e-18
C954	a_575_87##19	VPWR#11	2.35461e-18
C955	a_575_87##5	a_2489_74##9	2.17414e-17
C956	a_2489_74##2	Q#1	1.20088e-19
C957	VGND#12	a_183_290##9	1.80295e-17
C958	VGND#7	VGND#6	5.42778e-19
C959	a_691_113##8	a_1374_368#	1.21868e-17
C960	VGND#9	SCE#1	7.26819e-20
C961	a_183_290##6	a_183_290#	1.37745e-19
C962	a_1586_74##2	a_1374_368##9	1.08648e-19
C963	DE#6	DE#7	3.27683e-18
C964	a_183_290#	DE#4	3.74426e-18
C965	a_691_113##5	a_575_87#	1.85342e-18
C966	a_1586_74##17	a_1374_368##3	3.42916e-18
C967	a_2489_74##12	a_2591_74#	2.12975e-18
C968	a_575_87##16	a_575_87##7	7.71074e-19
C969	a_691_113##4	SCE#1	2.14883e-19
C970	a_2489_74##11	a_575_87##4	2.80163e-17
C971	VGND#11	SCD#3	2.88738e-18
C972	VPWR	a_2489_74##13	2.2729e-17
C973	a_2489_74##11	a_2489_74##4	3.86674e-19
C974	VPWR#4	a_2489_74#	3.35201e-17
C975	Q	a_575_87##11	2.55858e-20
C976	VPWR	VPWR#9	2.52957e-17
C977	Q	a_575_87##10	1.45944e-18
C978	VGND	a_2489_74##12	2.61575e-17
C979	VGND#23	a_691_113##9	1.60488e-17
C980	VPWR	a_2013_71##12	5.39887e-18
C981	Q	a_2489_74##5	2.97128e-17
C982	VPWR#20	DE#4	5.96996e-18
C983	VPWR	VPWR#11	2.40801e-18
C984	a_1586_74##10	VGND#19	6.37402e-17
C985	Q	a_2489_74##6	2.3753e-17
C986	VGND	a_2013_71##8	5.62164e-18
C987	Q	a_2489_74##8	3.49456e-19
C988	VPWR	a_1784_97##7	2.0185e-17
C989	SCE	SCE#4	4.89984e-20
C990	VPWR	a_691_113#	2.10417e-17
C991	a_32_74##2	DE#2	4.9135e-18
C992	VGND	a_1784_97##6	6.23312e-18
C993	a_1586_74##7	a_575_87##5	3.31562e-17
C994	VGND	a_691_113##8	4.88161e-18
C995	VPWR	a_1586_74##17	2.40625e-18
C996	a_1586_74##13	a_1374_368#	1.99856e-18
C997	a_575_87#	a_32_74##5	1.35836e-17
C998	VGND	a_1586_74##13	3.04775e-17
C999	VPWR	VPWR#14	1.50556e-17
C1000	VGND#6	a_2013_71##6	4.85867e-19
C1001	VPWR	a_1374_368##15	4.93166e-18
C1002	VGND#12	CLK	8.49347e-19
C1003	VGND	a_1374_368##13	2.56963e-17
C1004	a_661_87##8	a_661_87##4	1.85543e-18
C1005	a_575_87##19	a_1784_97##7	1.11743e-18
C1006	VGND#19	a_2013_71##6	1.62417e-18
C1007	Q_N	a_575_87##7	4.4103e-17
C1008	VPWR#21	SCE#5	4.24521e-19
C1009	Q_N	a_575_87##12	1.9297e-17
C1010	a_1586_74##11	a_2013_71##8	3.68205e-17
C1011	a_2489_74##3	VPWR#5	1.28034e-18
C1012	a_2013_71##9	a_2013_71##12	3.57667e-18
C1013	Q_N	a_2489_74#	2.91568e-18
C1014	a_691_113##4	SCE#3	2.91362e-18
C1015	D#4	DE#6	5.92672e-18
C1016	Q_N	a_2489_74##7	2.02507e-19
C1017	a_575_87##13	SCD	1.00298e-17
C1018	a_1374_368##11	VPWR#8	1.23953e-17
C1019	Q_N	a_2489_74##9	1.32765e-19
C1020	a_2489_74#	Q#1	2.59374e-17
C1021	a_691_113##5	DE#1	3.7533e-19
C1022	a_691_113##8	a_1374_368##9	2.72793e-18
C1023	a_575_87##13	CLK#3	1.09746e-18
C1024	VPWR#2	a_2489_74#	3.97968e-18
C1025	a_1586_74##17	a_1374_368##2	1.90204e-18
C1026	D#1	a_183_290#	3.8344e-17
C1027	VGND#12	a_32_74##6	2.23168e-17
C1028	VGND#12	SCD	4.19731e-18
C1029	a_2489_74##6	a_2489_74##5	3.84533e-17
C1030	a_575_87##8	VNB	3.23465e-17
C1031	a_2489_74##3	VNB	4.43937e-17
C1032	a_2489_74##2	VNB	2.02513e-17
C1033	a_1374_368##4	VPWR#14	1.55148e-18
C1034	VGND#16	a_575_87##16	1.63244e-18
C1035	CLK#2	a_1374_368##4	1.16004e-18
C1036	a_575_87##16	a_575_87##12	4.4621e-18
C1037	a_1374_368##4	VNB	2.26641e-17
C1038	a_1374_368##3	VNB	2.69948e-17
C1039	a_1374_368##2	VNB	5.9433e-17
C1040	a_1374_368##13	a_1374_368##15	1.38807e-18
C1041	DE#5	VNB	3.70376e-17
C1042	DE#2	VNB	4.0066e-17
C1043	a_1374_368##9	a_1374_368##2	3.17092e-19
C1044	a_1374_368##11	VPWR#6	7.56366e-19
C1045	a_183_290##6	D#1	5.39971e-19
C1046	VPWR#4	a_2489_74##7	2.95157e-18
C1047	a_575_87##13	SCE	7.67948e-18
C1048	VGND#19	a_2489_74##12	1.3022e-17
C1049	D#3	DE#6	4.80417e-17
C1050	Q	a_575_87##12	7.91115e-19
C1051	CLK#2	a_1374_368##9	1.32733e-18
C1052	Q	a_2489_74#	1.41158e-17
C1053	VGND#12	SCE	1.50033e-18
C1054	a_661_87##8	a_661_87##9	1.04026e-17
C1055	VPWR#5	VPWR#4	1.03307e-17
C1056	Q	a_2489_74##7	1.03787e-17
C1057	a_2489_74##13	VPWR#6	3.99566e-17
C1058	Q	a_2489_74##9	3.80072e-19
C1059	a_1374_368##12	a_1586_74##8	5.77737e-18
C1060	VPWR#19	CLK#3	3.0015e-20
C1061	VGND	a_1374_368##15	1.22488e-18
C1062	VPWR#5	a_2489_74#	2.95157e-18
C1063	VPWR#21	a_575_87#	2.64898e-18
C1064	a_575_87##13	a_691_113##4	4.55043e-17
C1065	VGND#13	VNB	4.36875e-17
C1066	VGND#11	VNB	4.82022e-17
C1067	VGND#10	VNB	4.17551e-17
C1068	VPWR#16	VPWR#14	7.02459e-18
C1069	VGND#9	VNB	5.58219e-17
C1070	VGND#7	VNB	2.96213e-17
C1071	VGND#6	VNB	4.88891e-17
C1072	VGND#5	VNB	6.97148e-17
C1073	a_1586_74##13	a_1374_368##9	5.38826e-17
C1074	CLK	CLK#2	8.32821e-18
C1075	VGND#2	VNB	3.16515e-17
C1076	a_1374_368##11	a_1586_74##7	2.61229e-18
C1077	VPWR#20	VNB	3.52937e-17
C1078	VPWR#17	VNB	5.10684e-17
C1079	a_2489_74##11	a_1374_368##10	1.45945e-20
C1080	VPWR#15	VNB	4.7054e-17
C1081	VPWR#13	VNB	5.9684e-17
C1082	VPWR#10	VNB	2.43771e-17
C1083	VPWR#8	VNB	5.90957e-17
C1084	VPWR#6	VNB	6.32828e-17
C1085	VPWR#2	VNB	3.13604e-17
C1086	CLK	SCD#2	1.17042e-19
C1087	a_2489_74##11	a_575_87##5	6.33094e-17
C1088	a_2489_74##7	Q#1	2.59374e-17
C1089	a_575_87##19	Q_N	8.39523e-19
C1090	VPWR#19	a_661_87##5	9.70379e-18
C1091	a_1586_74##10	a_2013_71##8	5.62197e-17
C1092	a_2489_74##11	VNB	6.66899e-18
C1093	VPWR#3	Q_N	2.04186e-17
C1094	VGND#7	a_1784_97##2	8.86756e-20
C1095	VGND#11	SCE#2	3.01877e-17
C1096	a_1374_368##13	a_1374_368#	1.38747e-19
C1097	SCD	CLK#2	5.35679e-19
C1098	VPWR#6	a_2489_74##7	8.75661e-19
C1099	VGND#3	Q_N	2.00123e-17
C1100	a_1586_74##12	VNB	1.59261e-17
C1101	SCE#1	CLK#2	4.05004e-19
C1102	a_661_87##8	SCD#2	1.05243e-19
C1103	a_1586_74##11	VNB	1.00998e-17
C1104	a_1374_368##3	VPWR#14	1.87406e-19
C1105	a_1586_74##10	VNB	2.19617e-17
C1106	SCD	a_661_87##4	3.93947e-17
C1107	VPWR#20	a_183_290#	1.50827e-19
C1108	D#4	D#3	6.63934e-18
C1109	a_1374_368##11	a_1374_368##12	2.45693e-17
C1110	a_691_113##8	CLK#1	7.59297e-20
C1111	a_2013_71##11	VNB	7.21815e-18
C1112	a_575_87##16	a_2489_74#	2.03592e-17
C1113	SCD	SCD#2	5.80437e-18
C1114	a_2013_71##9	VNB	5.61418e-18
C1115	a_1784_97##5	VNB	8.3062e-18
C1116	VGND	a_2013_71##3	8.3053e-18
C1117	a_575_87##9	a_575_87##8	7.2821e-18
C1118	a_691_113##4	VNB	2.02922e-17
C1119	a_691_113##2	VNB	1.42782e-17
C1120	VGND	a_1374_368##9	3.93388e-18
C1121	VPWR	a_1784_97##3	7.24448e-18
C1122	a_575_87##9	Q_N	6.34885e-17
C1123	a_1586_74##11	VGND#20	8.23207e-17
C1124	a_661_87##8	VNB	5.64247e-18
C1125	VPWR#19	SCD#1	4.46898e-18
C1126	a_575_87##19	Q	3.38425e-17
C1127	a_1374_368##9	VGND#21	1.68789e-17
C1128	VPWR#21	DE#1	3.04738e-17
C1129	a_575_87##13	a_691_113##2	4.92554e-17
C1130	VPWR#3	Q	5.30239e-18
C1131	a_32_74##3	VNB	9.86939e-17
C1132	a_575_87##11	VGND#1	2.13645e-17
C1133	a_32_74##2	VNB	1.65326e-17
C1134	VGND#3	Q	3.2461e-17
C1135	a_1374_368##11	a_2013_71##7	4.97245e-17
C1136	a_575_87##16	VPWR#4	3.453e-17
C1137	a_183_290##6	VNB	3.37484e-18
C1138	SCE	SCE#3	5.43339e-18
C1139	VPWR#5	a_2489_74##7	3.561e-17
C1140	VPWR#8	a_1586_74##6	1.94301e-19
C1141	D#6	VNB	6.76538e-19
C1142	D#4	VNB	5.18768e-18
C1143	VGND#1	VNB	5.16987e-17
C1144	a_2489_74##8	a_2489_74##6	5.19483e-18
C1145	Q_N#3	VNB	2.71914e-17
C1146	VGND#4	VNB	6.21158e-18
C1147	a_575_87##13	SCE#5	1.95454e-18
C1148	VGND#16	VNB	1.01944e-17
C1149	a_575_87##20	VNB	1.2373e-17
C1150	VGND#17	VNB	2.34294e-18
C1151	Q	a_575_87##9	8.18294e-17
C1152	SCE#1	a_661_87##4	1.88709e-17
C1153	a_2489_74##12	VNB	2.70599e-18
C1154	Q	a_2489_74##4	1.50309e-19
C1155	VGND#19	VNB	6.60999e-19
C1156	a_2013_71##8	VNB	2.42903e-19
C1157	a_575_87##16	a_2489_74##3	2.39984e-19
C1158	VGND#20	VNB	3.02367e-18
C1159	a_1784_97##6	VNB	7.15148e-18
C1160	a_1586_74##13	CLK#1	2.67627e-19
C1161	a_691_113##8	VNB	1.85394e-17
C1162	a_575_87##19	VPWR	7.0041e-17
C1163	a_691_113##5	a_661_87##8	2.62057e-17
C1164	a_1374_368##11	a_1784_97##3	7.95812e-19
C1165	a_1586_74##13	VNB	1.17819e-17
C1166	VPWR#10	VPWR#9	4.86137e-19
C1167	a_575_87##9	Q_N#1	6.26771e-20
C1168	VGND#21	VNB	2.85565e-18
C1169	a_1374_368##13	VNB	1.64974e-17
C1170	VGND#22	VNB	6.93251e-18
C1171	a_691_113##9	VNB	2.0903e-17
C1172	a_1586_74##12	a_1586_74##11	3.09956e-18
C1173	VGND#23	VNB	5.49952e-18
C1174	VPWR	VPWR#12	6.72377e-17
C1175	a_661_87##6	VNB	6.88625e-18
C1176	a_691_113##7	VNB	1.69329e-17
C1177	a_32_74#	VNB	8.1831e-18
C1178	a_2489_74##11	a_2489_74##3	4.64056e-20
C1179	a_2489_74##2	a_575_87##9	3.53646e-17
C1180	VGND#24	VNB	7.01194e-18
C1181	a_575_87##13	VPWR	3.8375e-17
C1182	a_691_113##9	a_1374_368##15	3.39408e-19
C1183	a_183_290##9	VNB	1.19513e-17
C1184	a_183_290##2	VPWR#23	4.13438e-18
C1185	VPWR#19	a_691_113##4	3.39441e-17
C1186	VGND#25	VNB	8.60014e-18
C1187	a_2013_71##7	a_1586_74##6	1.11962e-17
C1188	a_32_74##6	VNB	5.21386e-17
C1189	VPWR#1	VNB	6.64201e-17
C1190	a_691_113##4	SCE#2	1.85951e-19
C1191	a_1374_368##13	a_1374_368##9	2.52121e-18
C1192	a_1374_368##15	a_1374_368##4	1.71452e-18
C1193	VPWR#5	VNB	2.91297e-18
C1194	a_575_87##16	a_2489_74##7	3.29211e-17
C1195	a_575_87##16	VNB	1.24342e-17
C1196	VPWR#19	SCE#5	1.5554e-17
C1197	a_2489_74##13	VNB	2.63005e-18
C1198	VPWR#9	VNB	6.82527e-18
C1199	a_2013_71##12	VNB	5.26616e-18
C1200	VPWR#11	VNB	2.51368e-18
C1201	DE#4	VPWR#21	2.30009e-17
C1202	VPWR	a_1374_368##11	2.62838e-17
C1203	a_575_87##9	VPWR#4	1.54409e-17
C1204	Q_N#3	a_575_87##11	4.62313e-17
C1205	a_1784_97##7	VNB	2.83089e-18
C1206	VGND#6	VGND#5	1.65296e-20
C1207	a_691_113#	VNB	1.04486e-17
C1208	VPWR	a_1586_74##6	2.71614e-18
C1209	a_1586_74##17	VNB	9.62018e-19
C1210	VGND	a_575_87##19	7.12644e-17
C1211	VPWR#14	VNB	4.14618e-18
C1212	a_1374_368##15	VNB	4.75808e-18
C1213	VPWR#16	VNB	1.19971e-18
C1214	a_2489_74##11	a_1586_74##5	7.2234e-20
C1215	a_661_87##4	SCE#2	5.88092e-20
C1216	VPWR	a_1784_97##2	3.82601e-18
C1217	VPWR#18	VNB	8.83023e-19
C1218	a_661_87##9	VNB	8.52931e-18
C1219	a_691_113##5	VNB	1.6134e-17
C1220	VGND	VGND#8	7.20861e-17
C1221	VPWR	a_1374_368##6	2.74899e-17
C1222	VGND	a_575_87##13	3.37009e-17
C1223	SCD#2	SCE#1	8.76272e-18
C1224	a_661_87##8	SCE#3	4.91219e-17
C1225	a_1784_97##7	VPWR#12	2.08007e-17
C1226	a_2489_74##11	a_1586_74##8	1.04186e-16
C1227	VPWR#21	VNB	3.21777e-19
C1228	VGND#12	DE#5	3.14319e-18
C1229	a_183_290##8	VNB	3.46273e-19
C1230	a_575_87##16	Q#1	3.68009e-18
C1231	VPWR#23	VNB	1.14508e-18
C1232	VPWR	a_1586_74##2	3.09845e-18
C1233	a_575_87##11	VNB	3.58638e-17
C1234	VPWR#5	a_2489_74##9	2.37762e-18
C1235	a_575_87##10	VNB	3.32456e-17
C1236	VPWR	a_1374_368##5	1.12754e-18
C1237	VGND#21	CLK#1	1.91884e-18
C1238	a_2489_74##5	VNB	3.04084e-17
C1239	a_2489_74##6	VNB	3.14805e-17
C1240	VPWR	CLK#2	3.30515e-19
C1241	a_2489_74##8	VNB	3.6104e-17
C1242	VGND#24	a_183_290##6	2.35765e-18
C1243	a_575_87##4	VNB	5.71338e-17
C1244	VPWR#19	a_575_87#	1.26291e-17
C1245	a_1374_368##10	VNB	2.99803e-17
C1246	VGND	a_1586_74##8	3.00936e-18
C1247	a_1586_74##5	VNB	2.83782e-17
C1248	a_1784_97##5	a_1374_368##8	1.38188e-19
C1249	a_2013_71##4	VNB	2.60614e-17
C1250	VGND	a_1374_368##11	2.38857e-18
C1251	D#7	D#1	4.25815e-18
C1252	a_1784_97#	VNB	4.52861e-17
C1253	a_2013_71##3	VNB	3.18755e-17
C1254	a_661_87##6	VGND#23	3.77559e-17
C1255	VPWR#6	a_2489_74##9	1.573e-17
C1256	a_1586_74##4	VNB	2.33261e-17
C1257	a_1374_368#	VNB	4.44777e-17
C1258	VGND#12	SCE#5	2.02609e-19
C1259	a_1374_368##9	VNB	4.04093e-17
C1260	VGND#1	a_575_87##10	1.38999e-18
C1261	CLK#1	VNB	3.85218e-17
C1262	VGND	a_1784_97##2	1.23194e-18
C1263	SCE#1	VNB	7.62262e-17
C1264	VGND#20	a_2013_71##2	8.99075e-19
C1265	DE#4	a_183_290##8	9.20703e-18
C1266	SCD#3	VNB	1.75669e-17
C1267	VGND	a_2013_71##2	2.62677e-18
C1268	SCE#2	VNB	6.62931e-17
C1269	a_661_87##3	VNB	4.84668e-17
C1270	VGND	a_1374_368##6	1.76467e-19
C1271	a_575_87##3	VNB	2.91687e-17
C1272	a_575_87##16	a_2489_74##2	2.36785e-19
C1273	a_183_290##3	VNB	2.48878e-17
C1274	a_575_87##19	VPWR#3	3.20413e-17
C1275	DE#7	VNB	4.04724e-17
C1276	DE#6	VNB	4.18358e-17
C1277	VGND#22	a_1374_368##9	6.62884e-19
C1278	D#3	VNB	3.91882e-17
C1279	VGND	a_1374_368##5	1.71071e-18
C1280	VGND#12	DE#2	1.00449e-18
C1281	a_575_87##7	VNB	4.04826e-17
C1282	a_575_87##12	VNB	3.2264e-17
C1283	a_2489_74#	VNB	3.16972e-17
C1284	a_2489_74##7	VNB	3.55447e-17
C1285	a_2489_74##9	VNB	3.65401e-17
C1286	VGND#9	a_1586_74##13	5.16316e-17
C1287	a_575_87##6	VNB	1.84656e-17
C1288	a_1586_74##7	VNB	3.75053e-17
C1289	a_1374_368##12	VNB	3.17012e-17
C1290	a_2013_71##7	VNB	4.23365e-17
C1291	a_32_74##3	a_32_74##2	3.10847e-18
C1292	a_1784_97##3	VNB	4.23861e-17
C1293	a_2013_71#	VNB	4.42292e-17
C1294	VPWR#19	DE#1	6.25311e-18
C1295	a_1374_368##7	VNB	1.79705e-17
C1296	a_1586_74#	VNB	2.29579e-17
C1297	SCE#2	SCD#2	1.19423e-18
C1298	a_1374_368##8	VNB	3.64696e-17
C1299	CLK#3	VNB	5.38721e-17
C1300	VGND#4	a_575_87##11	7.29042e-19
C1301	a_661_87##5	VNB	3.03737e-17
C1302	SCD#1	VNB	3.93232e-17
C1303	SCE#4	VNB	7.46603e-17
C1304	SCE#5	VNB	7.05058e-17
C1305	a_575_87#	VNB	3.19151e-17
C1306	a_575_87##16	a_2489_74##9	9.28433e-17
C1307	DE#1	VNB	4.6404e-17
C1308	DE#4	VNB	2.84156e-17
C1309	a_183_290#	VNB	2.74505e-17
C1310	D#1	VNB	4.66901e-17
C1311	a_575_87##4	a_2489_74##8	1.16391e-17
C1312	a_1784_97##2	a_2013_71##7	1.78702e-18
C1313	a_575_87##19	VNB	1.41587e-17
C1314	VPWR#23	DE#4	4.8684e-19
C1315	VPWR#8	a_2013_71##6	1.99157e-19
C1316	VPWR#3	VNB	2.09259e-16
C1317	VGND#3	VNB	2.13734e-16
C1318	a_1374_368##13	CLK#1	5.06113e-17
C1319	a_1586_74##12	a_1784_97##6	6.6877e-17
C1320	VPWR#12	VNB	3.42839e-17
C1321	VGND#3	a_575_87##19	3.61958e-17
C1322	VGND#8	VNB	4.32254e-17
C1323	a_575_87##13	VNB	3.83508e-18
C1324	VPWR#19	VNB	3.19139e-16
C1325	VGND#12	VNB	3.3208e-16
C1326	a_575_87##9	VNB	4.00897e-17
C1327	a_2489_74##4	VNB	5.84232e-17
C1328	a_575_87##5	VNB	6.50955e-17
C1329	a_1586_74##8	VNB	4.33353e-17
C1330	a_1374_368##11	VNB	4.21081e-17
C1331	a_1586_74##6	VNB	3.1579e-17
C1332	a_2013_71##6	VNB	8.55191e-17
C1333	a_575_87##19	VGND#7	1.16907e-18
C1334	a_1784_97##2	VNB	5.48015e-17
C1335	VPWR#19	DE#4	4.43795e-18
C1336	a_2013_71##2	VNB	6.29277e-17
C1337	a_1374_368##6	VNB	6.47352e-17
C1338	a_575_87##16	VPWR#5	7.13114e-17
C1339	a_1586_74##3	VNB	3.34869e-17
C1340	a_575_87##16	a_575_87##9	4.15565e-18
C1341	a_1586_74##2	VNB	5.52921e-17
C1342	a_1374_368##5	VNB	7.60957e-17
C1343	CLK#2	VNB	3.93085e-17
C1344	VGND#12	DE#1	2.1679e-18
C1345	Q_N#3	a_575_87##10	3.18587e-17
C1346	a_661_87##4	VNB	7.7263e-17
C1347	VPWR#5	a_575_87##6	1.93029e-19
C1348	SCD#2	VNB	4.63805e-17
C1349	SCE#3	VNB	4.27816e-17
C1350	a_691_113##9	a_1374_368##9	5.65108e-19
C1351	a_183_290##8	a_183_290#	4.29656e-19
C1352	a_575_87##2	VNB	8.14241e-17
C1353	a_183_290##4	VNB	5.21705e-17
C1354	a_2489_74##4	a_2489_74##3	5.45055e-19
C1355	DE#3	VNB	4.33471e-17
C1356	a_183_290##2	VNB	6.75037e-17
C1357	D#2	VNB	7.24259e-17
C1358	VGND#21	SCE#1	5.67815e-20
C1359	a_32_74##6	a_32_74##3	1.22089e-18
C1360	a_575_87##19	VPWR#12	4.94371e-18
C1361	a_2489_74##9	VPWR#7	1.40116e-17
C1362	VGND	CLK	1.56587e-18
C1363	VGND#13	a_575_87##3	1.85897e-18
C1364	VPWR#19	a_183_290#	6.01681e-19
C1365	a_575_87##19	VGND#6	3.70705e-18
C1366	a_691_113##2	a_1586_74#	2.10764e-19
C1367	a_183_290##9	a_183_290##6	6.65835e-18
C1368	a_1374_368##15	a_1374_368##2	6.80555e-19
C1369	CLK#1	VGND#22	1.85715e-17
C1370	VGND#1	a_2489_74##5	2.81284e-19
C1371	CLK	VNB	3.00104e-18
C1372	SCD	VNB	6.0799e-18
C1373	a_1374_368##11	a_2489_74##11	1.75168e-17
C1374	Q_N	VNB	3.14832e-17
C1375	VPWR#23	a_183_290#	3.43266e-17
C1376	Q	VNB	4.16305e-18
C1377	VPWR	VNB	2.14864e-16
C1378	VGND	VNB	2.18996e-16
C1379	a_2013_71##2	a_1784_97##3	5.66707e-18
C1380	a_575_87##16	a_575_87##6	1.5945e-18
C1381	VGND#14	a_183_290##2	5.87207e-19
C1382	a_661_87#	SCE#4	1.68885e-17
C1383	VGND#23	a_661_87#	6.28557e-18
C1384	VPWR#22	DE#1	2.12137e-19
C1385	a_661_87#	VNB	1.53367e-16
C1386	a_183_290##4	a_661_87#	9.76492e-19
C1387	VPWR#22	VNB	7.02655e-17
C1388	VPWR#22	D#1	8.02596e-18
C1389	VPWR#19	VPWR#22	1.33491e-16
C1390	a_661_87#	a_691_113##9	1.28402e-18
C1391	VPWR#22	DE#5	2.77575e-20
C1392	a_575_87##2	a_661_87#	7.74767e-18
C1393	a_32_74##2	VPWR#22	1.02041e-18
C1394	VGND#11	a_661_87#	6.20759e-18
C1395	VGND#12	a_661_87#	3.93014e-17
C1396	a_661_87#	a_183_290##3	2.04275e-19
C1397	a_691_113##5	a_661_87#	7.99633e-18
C1398	VGND#14	D#4	2.87085e-18
C1399	VPWR#19	a_661_87#	1.26256e-20
C1400	a_661_87#	a_575_87##3	3.31104e-19
C1401	VPWR#22	DE#4	8.44321e-19
C1402	a_661_87##9	a_661_87#	5.25455e-18
C1403	VGND#14	DE#5	1.22474e-18
C1404	a_661_87#	SCE#3	4.56256e-17
C1405	VGND#24	a_661_87#	3.0283e-18
C1406	VGND#14	VGND#13	1.11573e-18
C1407	VGND#14	a_183_290##9	4.73847e-18
C1408	a_575_87##13	a_661_87#	2.19653e-18
C1409	a_661_87##3	a_661_87#	1.27908e-17
C1410	VPWR#22	DE#3	3.02934e-20
C1411	VGND#12	VGND#14	1.38512e-16
C1412	a_661_87#	SCD#2	1.40582e-20
C1413	VPWR#22	VPWR#20	6.27269e-19
C1414	VPWR#22	DE#2	1.92979e-19
C1415	a_661_87#	SCE#2	2.3312e-17
C1416	a_661_87##8	a_661_87#	1.8641e-17
C1417	a_661_87##4	a_661_87#	4.54956e-19
C1418	a_32_74#	a_661_87#	6.35722e-19
C1419	a_32_74##2	a_661_87#	7.2529e-19
C1420	VGND#14	VNB	6.81219e-17
C1421	a_661_87#	SCD#3	3.08397e-19
C1422	VGND#14	DE#6	7.28316e-18
C1423	a_691_113##7	a_661_87#	1.12874e-16
C1424	VPWR#22	a_183_290#	7.15223e-18
C1425	a_661_87#	SCE#5	1.88009e-18
C1426	VGND#14	a_32_74##6	2.24022e-17
C1427	a_661_87#	SCE#1	4.59118e-19
C1428	VGND#14	D#3	8.63369e-18
C1429	a_661_87#	SCE	3.64328e-17
C1430	a_32_74##3	VPWR#22	6.5442e-17
*
*
.ENDS sky130_fd_sc_hs__sedfxbp_2
*
