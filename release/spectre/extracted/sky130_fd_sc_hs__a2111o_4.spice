* Extracted by Quantus, converted by sky130cad/quantus.py
*
*
*
*                       LINUX           Wed Nov 18 08:02:02 2026
*
*
*
*  PROGRAM  advgen
*
*  Name           : advgen - Quantus - (64-bit)
*  Version        : 25.1.0-p047
*  Build Date     : Thu Dec 11 23:20:30 PST 2025
*
*  HSPICE LIBRARY
*
*  OPERATING_TEMPERATURE 150
*  QRC_TECH_DIR <path>/tech
*
*
*

*
.SUBCKT sky130_fd_sc_hs__a2111o_4 VPB VNB VGND VPWR X D1 A2 C1 B1 A1
*
*
*  caps2d version: 10
*
*
*       TRANSISTOR CARDS
*
*
XM12 VGND#17 a_137_260##8 X#3 VNB sky130_fd_pr__nfet_01v8_lvt l=0.15 w=0.74 ad=0.2109 as=0.2072 pd=2.05 ps=2.04
XM0 X#3 a_137_260##6 VGND#16 VNB sky130_fd_pr__nfet_01v8_lvt l=0.15 w=0.74 ad=0.2072 as=0.2072 pd=2.04 ps=2.04
XM11 X#1 a_137_260##4 VGND#16 VNB sky130_fd_pr__nfet_01v8_lvt l=0.15 w=0.74 ad=0.2072 as=0.2072 pd=2.04 ps=2.04
XM19 VGND#15 a_137_260# X#1 VNB sky130_fd_pr__nfet_01v8_lvt l=0.15 w=0.74 ad=0.233 as=0.2072 pd=2.13 ps=2.04
XM2 a_137_260##20 D1#4 VGND#15 VNB sky130_fd_pr__nfet_01v8_lvt l=0.15 w=0.64 ad=0.1792 as=0.233 pd=1.84 ps=2.13
XM20 VGND#14 D1#5 a_137_260##20 VNB sky130_fd_pr__nfet_01v8_lvt l=0.15 w=0.64 ad=0.1856 as=0.1792 pd=1.86 ps=1.84
XM14 VGND#14 C1#4 a_137_260##19 VNB sky130_fd_pr__nfet_01v8_lvt l=0.15 w=0.64 ad=0.1856 as=0.1792 pd=1.86 ps=1.84
XM26 a_137_260##19 C1#5 VGND#13 VNB sky130_fd_pr__nfet_01v8_lvt l=0.15 w=0.64 ad=0.1792 as=0.1856 pd=1.84 ps=1.86
XM24 VGND#13 B1#4 a_137_260##18 VNB sky130_fd_pr__nfet_01v8_lvt l=0.15 w=0.64 ad=0.1856 as=0.1792 pd=1.86 ps=1.84
XM4 a_137_260##18 B1#6 VGND#12 VNB sky130_fd_pr__nfet_01v8_lvt l=0.15 w=0.64 ad=0.1792 as=0.1696 pd=1.84 ps=1.81
XM13 a_137_260##12 A1#5 a_1210_74##4 VNB sky130_fd_pr__nfet_01v8_lvt l=0.15 w=0.64 ad=0.1792 as=0.1696 pd=1.84 ps=1.81
XM16 a_1210_74##2 A1#1 a_137_260##12 VNB sky130_fd_pr__nfet_01v8_lvt l=0.15 w=0.64 ad=0.1792 as=0.1792 pd=1.84 ps=1.84
XM23 a_1210_74##2 A2#7 VGND#11 VNB sky130_fd_pr__nfet_01v8_lvt l=0.15 w=0.64 ad=0.1792 as=0.1792 pd=1.84 ps=1.84
XM3 VGND#11 A2#1 a_1210_74# VNB sky130_fd_pr__nfet_01v8_lvt l=0.15 w=0.64 ad=0.1792 as=0.1696 pd=1.84 ps=1.81
XM5 X#5 a_137_260##10 VPWR#13 VPB sky130_fd_pr__pfet_01v8 l=0.15 w=1.12 ad=0.336 as=0.308 pd=2.84 ps=2.79
XM17 VPWR#12 a_137_260##11 X#5 VPB sky130_fd_pr__pfet_01v8 l=0.15 w=1.12 ad=0.336 as=0.336 pd=2.84 ps=2.84
XM7 X#6 a_137_260##9 VPWR#12 VPB sky130_fd_pr__pfet_01v8 l=0.15 w=1.12 ad=0.336 as=0.336 pd=2.84 ps=2.84
XM21 VPWR#11 a_137_260##5 X#6 VPB sky130_fd_pr__pfet_01v8 l=0.15 w=1.12 ad=0.308 as=0.336 pd=2.79 ps=2.84
XM15 a_549_392##3 D1#6 a_137_260##21 VPB sky130_fd_pr__pfet_01v8 l=0.15 w=1 ad=0.275 as=0.3 pd=2.55 ps=2.6
XM18 a_137_260##21 D1#1 a_549_392##4 VPB sky130_fd_pr__pfet_01v8 l=0.15 w=1 ad=0.3 as=0.3 pd=2.6 ps=2.6
XM22 a_814_392##2 C1#6 a_549_392##4 VPB sky130_fd_pr__pfet_01v8 l=0.15 w=1 ad=0.3 as=0.3 pd=2.6 ps=2.6
XM6 a_549_392# C1#1 a_814_392##2 VPB sky130_fd_pr__pfet_01v8 l=0.15 w=1 ad=0.275 as=0.3 pd=2.55 ps=2.6
XM8 a_1013_392##5 B1#5 a_814_392# VPB sky130_fd_pr__pfet_01v8 l=0.15 w=1 ad=0.275 as=0.3 pd=2.55 ps=2.6
XM25 a_814_392# B1#1 a_1013_392##3 VPB sky130_fd_pr__pfet_01v8 l=0.15 w=1 ad=0.3 as=0.3 pd=2.6 ps=2.6
XM9 a_1013_392##3 A1#6 VPWR#10 VPB sky130_fd_pr__pfet_01v8 l=0.15 w=1 ad=0.3 as=0.3 pd=2.6 ps=2.6
XM27 VPWR#10 A1#4 a_1013_392##6 VPB sky130_fd_pr__pfet_01v8 l=0.15 w=1 ad=0.3 as=0.3 pd=2.6 ps=2.6
XM10 a_1013_392##6 A2#5 VPWR#9 VPB sky130_fd_pr__pfet_01v8 l=0.15 w=1 ad=0.3 as=0.3 pd=2.6 ps=2.6
XM1 VPWR#9 A2#6 a_1013_392# VPB sky130_fd_pr__pfet_01v8 l=0.15 w=1 ad=0.3 as=0.275 pd=2.6 ps=2.55
*
*
*       RESISTOR AND CAP/DIODE CARDS
*
Rg1	a_137_260#	a_137_260##2	424.223480
Rg2	a_137_260##2	a_137_260##3	67.272362
Rg3	a_137_260##2	a_137_260##4	365.684052
Rg4	a_137_260##2	a_137_260##5	469.405975
Rg5	a_137_260##3	a_137_260##6	355.649933
Rg6	a_137_260##3	a_137_260##7	94.894150
Rg7	a_137_260##7	a_137_260##8	374.534637
Rg8	a_137_260##3	a_137_260##9	453.012177
Rg9	a_137_260##7	a_137_260##10	529.673828
Rg10	a_137_260##7	a_137_260##11	473.258270
Rg11	D1#1	D1#2	486.917389
Rg12	D1#2	D1#3	66.432877
Rg13	D1#3	D1#4	374.636047
Rg14	D1#2	D1#5	354.072845
Rg15	D1#3	D1#6	507.281372
Rg16	C1#1	C1#2	394.407837
Rg17	C1#2	C1#3	50.683090
Rg18	C1#3	C1#4	499.092957
Rg19	C1#2	C1#5	442.046326
Rg20	C1#3	C1#6	427.171906
Rg21	B1#1	B1#2	448.711578
Rg22	B1#2	B1#3	113.811539
Rg23	B1#3	B1#4	447.384430
Rg24	B1#2	B1#5	411.021179
Rg25	B1#3	B1#6	236.878250
Rg26	A1#1	A1#2	487.133331
Rg27	A1#2	A1#3	60.132961
Rg28	A1#2	A1#4	425.023010
Rg29	A1#3	A1#5	486.092133
Rg30	A1#3	A1#6	419.452728
Rg31	A2#1	A2#2	374.601257
Rg32	A2#2	A2#3	32.565670
Rg33	A2#3	A2#4	20.770035
Rg34	A2#4	A2#5	509.458435
Rg35	A2#2	A2#6	507.445770
Rg36	A2#4	A2#7	379.205444
Rf1	X#1	X#2	74.477318
Rf2	X#2	X	79.932480
Rf3	X#2	X#3	18.783115
Rf4	X	X#4	39.065998
Rf5	X#4	X#5	21.948624
Rf6	X#4	X#6	84.453606
Rf7	D1#2	D1#8	161.886307
Rf8	D1#9	D1	1.653499
Rf9	D1#8	D1#9	9.448145
Rf10	a_549_392#	a_549_392##2	80.214348
Rf11	a_549_392##2	a_549_392##3	80.654846
Rf12	a_549_392##2	a_549_392##4	22.342297
Rf13	C1	C1#7	10.629163
Rf14	C1#7	C1	8.267126
Rf15	a_814_392#	a_814_392##2	142.834091
Rf16	B1	B1#7	16.927925
Rf17	B1#7	B1	1.968364
Rf18	a_137_260##12	a_137_260##13	148.720306
Rf19	a_137_260##13	a_137_260##14	72.866043
Rf20	a_137_260##14	a_137_260##15	55.224571
Rf21	a_137_260##15	a_137_260##16	33.940128
Rf22	a_137_260##16	a_137_260##3	82.654205
Rf23	a_137_260##13	a_137_260##18	39.263618
Rf24	a_137_260##14	a_137_260##19	30.608950
Rf25	a_137_260##15	a_137_260##20	21.447174
Rf26	a_137_260##16	a_137_260##21	75.929733
Rf27	A1	A1#3	161.413818
Rf28	A2#3	A2#9	162.264099
Rf29	A2#10	A2	2.031292
Rf30	A2#9	A2#10	0.763153
Rf31	A2#11	A2	2.031292
Rf32	A2#10	A2#11	12.210451
Rf33	a_1013_392#	a_1013_392##2	80.789467
Rf34	a_1013_392##2	a_1013_392##4	92.491631
Rf35	a_1013_392##4	a_1013_392##5	119.241737
Rf36	a_1013_392##2	a_1013_392##6	31.284834
Rf37	a_1013_392##3	a_1013_392##4	5.000000
Rf38	a_1210_74#	a_1210_74##3	101.969528
Rf39	a_1210_74##3	a_1210_74##4	94.795258
Rf40	a_1210_74##2	a_1210_74##3	7.500000
Rf42	VGND#2	VGND#3	147.464417
Rf43	VGND#3	VGND#4	63.133926
Rf44	VGND#4	VGND#5	63.493488
Rf45	VGND#5	VGND#6	24.806946
Rf46	VGND#6	VGND#7	44.593616
Rf47	VGND#7	VGND#8	60.032265
Rf48	VGND#8	VGND#9	62.896935
Rf50	VGND#2	VGND#11	38.202232
Rf51	VGND#3	VGND#12	31.141060
Rf52	VGND#4	VGND#13	30.096170
Rf53	VGND#5	VGND#14	32.813103
Rf54	VGND#7	VGND#15	38.480759
Rf55	VGND#8	VGND#16	55.529682
Rf56	VGND#9	VGND#17	36.279022
Rf58	VPWR#2	VPWR#3	66.926247
Rf59	VPWR#3	VPWR#4	232.276047
Rf60	VPWR#4	VPWR#5	70.891800
Rf61	VPWR#5	VPWR#6	68.798325
Rf62	VPWR#6	VPWR#7	68.798325
Rf64	VPWR#2	VPWR#9	43.353802
Rf65	VPWR#3	VPWR#10	32.617332
Rf66	VPWR#5	VPWR#11	48.259808
Rf67	VPWR#6	VPWR#12	58.622005
Rf68	VPWR#7	VPWR#13	42.573776
Rf70	C1#2	C1#7	80.116402
Rf71	B1#2	B1#7	160.232803
Re1	VPWR#2	VPWR	4.549932
Re2	VPWR	VPWR#4	0.974985
Re3	VGND#2	VGND	4.549932
Re4	VGND	VGND#6	0.974985
*
*       CAPACITOR CARDS
*
*
C1	X#2	a_137_260##6	2.01005e-17
C2	a_549_392##3	a_549_392##4	5.01824e-18
C3	VPWR#6	D1#6	1.82807e-20
C4	B1#3	a_137_260##18	7.26178e-19
C5	a_137_260##15	VGND#14	1.37046e-17
C6	a_137_260##20	C1#5	1.84702e-19
C7	C1#3	B1#2	6.78872e-18
C8	a_137_260##2	D1#3	6.75862e-19
C9	VPWR#5	D1#6	1.09109e-18
C10	VGND#14	C1#4	3.23972e-17
C11	a_549_392##3	a_137_260##21	4.62026e-17
C12	a_137_260##19	D1#5	3.79304e-19
C13	X#2	a_137_260##8	1.97438e-17
C14	a_137_260##14	VGND#14	1.58755e-17
C15	a_137_260##20	C1#4	4.17963e-19
C16	a_137_260##15	a_137_260##20	4.38688e-19
C17	VGND#14	D1#5	2.88008e-17
C18	VPWR#6	a_137_260##5	5.03407e-19
C19	VPWR#11	a_137_260##21	1.32776e-17
C20	a_1013_392##2	a_1013_392#	1.5081e-18
C21	VGND#15	a_137_260##16	3.39374e-18
C22	VPWR#5	a_137_260##5	7.85932e-18
C23	a_137_260##19	D1#4	1.59876e-19
C24	D1#5	a_137_260##20	1.0429e-17
C25	a_1210_74#	VGND#11	4.94113e-17
C26	VPWR#11	a_549_392##3	6.70471e-17
C27	VGND#14	D1#4	1.77843e-18
C28	VGND#15	a_137_260##15	1.77359e-17
C29	VGND#15	D1#5	3.34286e-19
C30	a_1013_392##2	VPWR#9	2.12862e-17
C31	VPWR#6	a_137_260##9	7.38948e-18
C32	a_137_260##20	D1#4	2.88008e-17
C33	a_1210_74##2	a_1210_74#	2.27239e-18
C34	VPWR#5	a_137_260##9	5.45681e-19
C35	VGND#14	a_137_260#	3.2335e-19
C36	VGND#13	C1#3	9.35856e-19
C37	VGND#15	D1#4	1.12934e-17
C38	X#6	VPWR#11	8.66889e-17
C39	X#1	a_137_260##15	4.52861e-18
C40	a_137_260##20	a_137_260#	9.48832e-19
C41	a_1013_392##2	a_1013_392##6	2.42942e-18
C42	X#1	D1#4	1.00599e-18
C43	VGND#7	a_137_260##16	8.66307e-21
C44	a_1210_74##2	VGND#11	5.40594e-17
C45	VPWR#6	a_137_260##11	5.12295e-18
C46	VPWR#12	VPWR#11	1.94092e-18
C47	VGND#15	a_137_260#	3.50013e-17
C48	VPWR#5	a_137_260##11	8.74044e-20
C49	D1#2	C1#3	3.70736e-17
C50	D1#3	D1#2	8.60808e-18
C51	X#1	a_137_260#	1.33903e-17
C52	X#6	VPWR#12	6.23799e-17
C53	VPWR#5	a_549_392##3	1.82798e-17
C54	VPWR#11	a_137_260##2	5.13135e-18
C55	a_1013_392##2	VPWR#10	2.69598e-17
C56	VGND#15	a_137_260##4	1.682e-18
C57	VGND#16	a_137_260#	1.41195e-19
C58	X#5	X#6	1.11023e-18
C59	VPWR#6	a_137_260##10	5.42375e-19
C60	X#1	a_137_260##4	4.78691e-17
C61	a_814_392#	B1#4	2.73475e-19
C62	a_1210_74##2	a_137_260##12	4.8043e-17
C63	VGND#15	a_137_260##6	1.90842e-19
C64	a_137_260##4	VGND#16	1.57436e-17
C65	X#5	VPWR#12	6.11996e-17
C66	a_1013_392##3	a_1013_392##2	1.23889e-18
C67	X#1	a_137_260##6	1.34787e-18
C68	X#3	a_137_260##4	1.70572e-18
C69	a_549_392#	B1#4	8.38365e-19
C70	VPWR#13	VPWR#12	1.94092e-18
C71	a_1210_74##4	a_1210_74##2	2.67476e-18
C72	a_137_260##16	D1#1	1.2849e-18
C73	VGND#12	VGND#11	3.17317e-19
C74	X#6	VPWR#6	8.7607e-18
C75	a_137_260##6	VGND#16	1.79782e-17
C76	a_137_260##3	a_137_260##7	2.4567e-17
C77	X#6	a_137_260##2	1.64739e-19
C78	VGND#17	a_137_260##4	1.68102e-19
C79	a_137_260##3	a_137_260##2	2.3459e-17
C80	a_814_392##2	B1#4	6.32498e-19
C81	VPWR#13	X#5	6.23622e-17
C82	X#3	a_137_260##6	3.50609e-17
C83	X#6	VPWR#5	8.44616e-18
C84	VGND#5	a_137_260##14	3.37781e-19
C85	a_137_260##16	C1#3	7.69519e-19
C86	VGND#16	a_137_260##8	2.69552e-19
C87	a_1210_74##4	a_137_260##12	8.53472e-17
C88	VGND#17	a_137_260##6	1.55692e-18
C89	a_137_260##16	D1#6	2.26956e-18
C90	a_549_392##2	C1#6	2.59387e-17
C91	a_137_260##8	X#3	1.33425e-17
C92	VPWR#12	a_137_260##7	3.77639e-19
C93	VPWR#6	a_137_260##7	4.5102e-20
C94	VGND#4	a_137_260##14	2.50007e-19
C95	VGND#17	a_137_260##8	2.59954e-17
C96	VPWR#3	B1#3	1.61433e-19
C97	a_137_260##16	D1#3	3.66452e-17
C98	a_137_260##16	a_137_260##5	4.50584e-19
C99	a_549_392##2	D1#1	2.5191e-17
C100	A2#9	a_1013_392##2	2.14619e-17
C101	D1#9	D1#1	5.60183e-18
C102	X#5	VPWR#6	8.44616e-18
C103	VGND#12	a_1210_74##4	3.28556e-17
C104	X#4	VPWR#6	2.5317e-19
C105	a_137_260##18	a_137_260##12	8.65374e-19
C106	A2#7	A2#1	3.57361e-17
C107	a_137_260##16	a_137_260##7	1.19707e-19
C108	VGND#4	a_137_260##13	2.50007e-19
C109	D1#9	D1#6	6.27701e-19
C110	a_1013_392#	A2#6	5.21371e-17
C111	a_137_260##15	D1#3	7.90668e-19
C112	VGND#3	a_137_260##13	1.89042e-18
C113	a_137_260##16	a_137_260##2	4.12851e-19
C114	A1#1	A2#7	3.64585e-17
C115	A2#6	VPWR#9	2.15152e-17
C116	a_137_260##18	VGND#12	4.94243e-17
C117	a_1013_392#	A2#5	2.21349e-18
C118	a_1013_392##6	A2#6	2.9183e-19
C119	a_137_260##14	C1#3	1.06793e-17
C120	VPWR#5	a_137_260##2	5.18063e-21
C121	VPWR#9	A2#5	4.02959e-17
C122	A1#5	A1#1	3.87089e-17
C123	a_1013_392#	A1#4	2.09026e-19
C124	VGND#13	VGND#12	2.3192e-18
C125	VPWR#6	VPWR#5	7.0017e-19
C126	A2#5	a_1013_392##6	1.84948e-17
C127	VPWR#9	A1#4	1.95044e-18
C128	VPWR#11	a_137_260#	2.75869e-18
C129	VPWR#10	A2#5	2.3551e-18
C130	a_137_260##13	B1#3	9.94616e-18
C131	X#2	VGND#16	1.50708e-17
C132	a_137_260##14	D1#3	1.48523e-19
C133	A1#4	a_1013_392##6	2.32004e-17
C134	VGND#13	a_137_260##18	4.9496e-17
C135	a_1013_392##3	A2#5	1.62089e-19
C136	B1#6	A1#5	2.76323e-18
C137	X#4	a_137_260##9	5.45335e-19
C138	VPWR#10	A1#4	4.92904e-17
C139	X#2	X#3	4.59562e-19
C140	a_137_260##13	C1#3	2.14108e-18
C141	a_1013_392##6	A1#6	1.48819e-19
C142	a_1013_392##3	A1#4	3.75768e-19
C143	VPWR#10	A1#6	4.27548e-17
C144	X#4	a_137_260##11	1.82884e-17
C145	B1#4	B1#6	3.39771e-17
C146	a_1013_392##6	B1#1	6.41938e-20
C147	a_137_260##13	a_814_392#	6.21187e-18
C148	a_1013_392##3	A1#6	5.35409e-17
C149	X#2	VGND#17	2.40757e-17
C150	a_137_260##19	VGND#13	4.06185e-17
C151	VPWR#10	B1#1	2.01946e-18
C152	A1#1	A2#4	5.04474e-18
C153	a_814_392#	A1#6	1.54724e-18
C154	X#4	a_137_260##10	2.48797e-17
C155	a_1013_392##3	B1#1	2.45205e-17
C156	a_1013_392##5	A1#6	1.97067e-19
C157	C1#5	B1#4	4.05978e-17
C158	VPWR#10	B1#5	2.78225e-19
C159	VGND#14	VGND#13	2.49208e-18
C160	a_814_392#	B1#1	4.75175e-17
C161	X#1	a_137_260##2	4.88885e-18
C162	a_1013_392##3	B1#5	3.78208e-19
C163	a_1013_392##5	B1#1	7.28227e-18
C164	VPWR#3	B1#2	2.48326e-20
C165	a_1210_74#	a_1013_392#	5.14003e-19
C166	VPWR#10	C1#1	7.27754e-20
C167	a_814_392#	B1#5	5.60904e-17
C168	C1#4	C1#5	4.1837e-17
C169	VGND#14	a_137_260##19	3.46276e-17
C170	VGND#8	X#2	3.16169e-19
C171	a_1013_392##3	C1#1	5.71611e-20
C172	a_1013_392##5	B1#5	3.57762e-17
C173	VGND#3	A1#3	3.25712e-20
C174	D1#1	C1#3	5.27725e-18
C175	a_814_392#	C1#1	4.3165e-19
C176	a_549_392#	B1#5	1.41599e-18
C177	a_137_260##20	a_137_260##19	2.18464e-18
C178	D1#5	C1#4	3.4176e-17
C179	a_1013_392##5	C1#1	1.40221e-18
C180	a_814_392##2	B1#5	3.25349e-19
C181	VGND#6	a_137_260##15	5.3354e-19
C182	a_814_392#	C1#6	1.2214e-19
C183	a_549_392#	C1#1	6.85053e-17
C184	VGND#16	a_137_260##2	2.25233e-19
C185	a_137_260##14	a_549_392##4	5.77913e-18
C186	a_549_392##2	VPWR#4	6.20136e-17
C187	a_1013_392##2	A1#3	2.01604e-18
C188	VGND#3	B1#2	1.76746e-18
C189	a_137_260##20	VGND#14	3.56493e-17
C190	a_814_392##2	C1#1	5.10024e-17
C191	a_137_260##15	a_137_260##21	2.04307e-18
C192	a_1013_392#	A2#4	1.34309e-19
C193	D1#4	D1#5	3.67432e-17
C194	a_549_392#	C1#6	1.72215e-18
C195	a_549_392##4	C1#1	2.69228e-18
C196	a_137_260##16	a_549_392##3	5.45966e-18
C197	A2#9	A1#3	4.69722e-18
C198	C1#6	a_814_392##2	1.75399e-17
C199	a_137_260##21	C1#1	3.88343e-20
C200	VGND#15	VGND#14	2.35827e-18
C201	a_549_392##4	C1#6	5.33556e-17
C202	a_137_260#	D1#4	2.84556e-17
C203	VPWR#3	B1#4	8.77234e-20
C204	a_137_260##21	C1#6	6.97561e-20
C205	a_549_392##2	a_814_392##2	9.56665e-18
C206	VPWR#6	a_137_260##3	6.70434e-20
C207	a_549_392##2	C1#3	1.27999e-19
C208	VPWR#11	a_137_260##16	2.12569e-18
C209	VGND#15	a_137_260##20	4.33001e-17
C210	a_137_260##3	VPWR#5	5.8208e-19
C211	a_549_392##4	D1#1	4.63319e-17
C212	A2#9	B1#2	6.13052e-19
C213	A1	A2#4	6.34904e-18
C214	D1#1	a_137_260##21	2.0843e-17
C215	a_137_260##4	a_137_260#	3.92257e-17
C216	VPWR#9	A2#4	9.36081e-19
C217	a_549_392##4	D1#6	2.69228e-18
C218	a_549_392##3	D1#1	1.72215e-18
C219	a_549_392##2	a_549_392##4	4.35239e-20
C220	VGND#8	a_137_260##3	2.28453e-20
C221	X#6	a_137_260##16	2.26453e-18
C222	a_137_260##21	D1#6	3.65238e-17
C223	VPWR#11	D1#1	1.85321e-19
C224	VGND#7	a_137_260##3	5.31189e-19
C225	VGND#17	a_137_260##7	1.64847e-18
C226	a_137_260##13	B1#2	2.82956e-17
C227	a_549_392##3	D1#6	4.38505e-17
C228	a_137_260##5	D1#3	4.60815e-19
C229	D1#9	a_549_392##4	2.68279e-17
C230	a_137_260##6	a_137_260##4	3.97624e-17
C231	X#1	VGND#15	5.75027e-17
C232	VGND#3	A1#5	3.33221e-18
C233	a_137_260##21	a_137_260##5	1.38047e-18
C234	VPWR#11	D1#6	6.08983e-18
C235	a_549_392##2	a_137_260##21	1.04906e-17
C236	VGND#8	a_137_260##2	2.35797e-20
C237	D1#9	C1#3	4.48917e-18
C238	a_549_392##3	a_137_260##5	1.41466e-18
C239	X#6	D1#6	9.73171e-19
C240	VGND#5	C1#3	2.55165e-20
C241	a_137_260##16	a_137_260##14	1.77435e-18
C242	a_137_260##12	a_1013_392##3	4.66848e-18
C243	VGND#16	VGND#15	9.55738e-19
C244	a_137_260##5	VPWR#11	4.01205e-17
C245	D1#9	a_137_260##21	1.08201e-17
C246	VPWR#12	D1#6	5.71556e-20
C247	a_137_260##8	a_137_260##6	3.91173e-17
C248	D1#8	B1#2	4.76517e-19
C249	X#6	a_137_260##5	6.7507e-17
C250	VGND#3	B1#6	1.24338e-18
C251	B1	C1#3	8.06571e-19
C252	D1#9	D1#3	8.74549e-19
C253	a_137_260##16	D1#2	1.05093e-18
C254	VGND#4	B1#3	4.29875e-20
C255	VPWR#11	a_137_260##9	3.71489e-19
C256	VGND#6	a_137_260##20	1.38021e-17
C257	VPWR#12	a_137_260##5	6.1269e-19
C258	a_137_260##15	D1#2	4.63639e-18
C259	a_137_260##12	A1#3	2.08074e-17
C260	X#1	VGND#16	3.84537e-17
C261	a_137_260##15	a_137_260##14	2.37324e-18
C262	a_137_260##14	D1#2	2.10198e-18
C263	a_1210_74##4	A1#3	7.49141e-19
C264	X#6	a_137_260##9	6.64848e-17
C265	C1#3	B1#4	3.93159e-18
C266	VGND#4	B1#4	1.29803e-18
C267	VPWR#11	a_137_260##11	1.72497e-19
C268	a_137_260##9	VPWR#12	2.42267e-17
C269	VGND#7	a_137_260##2	8.75954e-20
C270	a_137_260##16	a_137_260##3	1.50164e-19
C271	X#6	a_137_260##11	2.01285e-18
C272	X#3	X#1	3.08126e-18
C273	X#5	a_137_260##9	1.81843e-18
C274	a_137_260##12	B1#2	6.17146e-18
C275	a_549_392##2	D1#2	8.98786e-20
C276	VGND#4	C1#3	2.7192e-20
C277	D1#9	D1#2	6.01976e-18
C278	a_137_260##11	VPWR#12	2.88136e-17
C279	VPWR#13	a_137_260##9	1.72497e-19
C280	VGND#12	B1#2	8.91715e-18
C281	X#5	a_137_260##11	5.58067e-17
C282	D1#8	D1#2	1.18638e-17
C283	VGND#4	C1#5	1.243e-18
C284	C1	B1#3	3.52181e-18
C285	X#3	VGND#16	3.54117e-17
C286	C1	C1#3	4.07876e-17
C287	VPWR#12	a_137_260##10	6.79311e-19
C288	VPWR#13	a_137_260##11	6.87375e-19
C289	VGND#3	B1#3	8.70772e-20
C290	a_814_392#	VPWR#4	3.26991e-19
C291	A2#5	A2#6	4.70394e-17
C292	VGND#3	a_137_260##12	4.27696e-19
C293	X#5	a_137_260##10	4.91005e-17
C294	a_137_260##14	a_137_260##13	1.56109e-18
C295	VGND#5	C1#4	1.22997e-18
C296	VPWR#5	a_137_260#	6.65057e-19
C297	a_137_260##10	VPWR#13	2.51883e-17
C298	VGND#17	VGND#16	9.83368e-19
C299	a_549_392#	VPWR#4	5.0507e-17
C300	a_137_260##3	X#4	6.22038e-17
C301	a_814_392##2	VPWR#4	2.42358e-19
C302	D1#8	C1#3	6.03285e-18
C303	A1#4	A2#5	4.34717e-17
C304	X#2	a_137_260##3	9.19344e-17
C305	VGND#7	D1#5	2.62224e-19
C306	VGND#3	a_1210_74##4	2.83313e-17
C307	VGND#17	X#3	3.83136e-17
C308	A2	A2#4	2.84567e-17
C309	a_549_392##3	VPWR#4	2.96591e-17
C310	VPWR#10	A1#3	7.59179e-19
C311	A1#6	A1#4	4.23124e-17
C312	VGND#14	D1#2	5.09645e-19
C313	VGND#7	D1#4	4.46918e-18
C314	X#4	X#6	1.87999e-18
C315	VGND#8	VGND#7	1.10662e-18
C316	a_137_260##16	D1#9	2.15387e-17
C317	B1#1	A1#6	4.65306e-17
C318	a_137_260##10	a_137_260##7	2.48404e-18
C319	VGND#4	a_137_260##18	5.25165e-18
C320	a_814_392#	B1#2	3.19258e-18
C321	VGND#8	a_137_260#	4.95158e-19
C322	VGND#5	VGND#13	5.6858e-19
C323	a_1013_392##5	B1#2	2.62803e-19
C324	a_1210_74#	A2#4	1.5642e-18
C325	VGND#15	a_137_260##3	1.54063e-17
C326	X#4	VPWR#12	1.88131e-17
C327	B1#5	B1#1	4.19327e-17
C328	a_137_260##3	X#1	4.30691e-17
C329	VGND#7	a_137_260#	6.9047e-18
C330	a_1210_74##2	a_1013_392##2	3.22352e-18
C331	a_137_260##3	VGND#16	3.11416e-18
C332	VGND#3	a_137_260##18	5.20222e-18
C333	a_137_260##3	X#3	2.54097e-18
C334	a_137_260##3	VGND#17	3.55989e-18
C335	a_137_260##13	A1#1	9.17412e-21
C336	C1#1	B1#5	5.59972e-18
C337	VGND#8	a_137_260##4	5.6022e-18
C338	X#4	X#5	2.08835e-19
C339	VGND#5	a_137_260##19	5.25165e-18
C340	a_1013_392#	VPWR#9	5.80197e-17
C341	VPWR#4	B1#4	1.67516e-19
C342	a_137_260##16	D1#8	2.80692e-17
C343	VGND#7	a_137_260##4	4.34401e-19
C344	VGND#7	VGND#14	5.07517e-20
C345	VGND#7	VGND#5	1.20489e-18
C346	X#4	a_137_260##7	6.16155e-18
C347	VGND#13	VGND#3	2.46279e-19
C348	C1#6	C1#1	4.19284e-17
C349	a_137_260##13	A1#5	2.9483e-20
C350	VGND#4	a_137_260##19	5.20222e-18
C351	a_1013_392##6	a_1013_392#	9.88915e-19
C352	VGND#11	A2#4	9.18078e-19
C353	a_137_260##21	D1#2	2.87924e-18
C354	VGND#8	a_137_260##6	5.6022e-18
C355	a_137_260##14	B1#6	2.06406e-19
C356	A1	a_1013_392##2	5.65458e-17
C357	a_549_392##3	D1#2	7.91788e-20
C358	a_137_260##15	D1#8	2.57239e-17
C359	D1#1	C1#6	4.22798e-17
C360	VGND#6	D1#5	1.94279e-18
C361	VGND#7	a_137_260##6	1.12262e-19
C362	VGND#7	a_137_260##20	2.15902e-18
C363	a_814_392#	B1#3	1.99441e-18
C364	a_1013_392##6	VPWR#9	4.9707e-17
C365	A1	A2#9	3.25102e-17
C366	X	a_137_260##7	1.62993e-18
C367	VGND#6	D1#4	2.19563e-18
C368	a_137_260##13	B1#6	2.51624e-19
C369	X	a_137_260##2	1.91487e-19
C370	a_137_260##3	a_549_392##3	5.45637e-18
C371	B1#2	A1#5	6.29329e-18
C372	VGND#8	VGND#15	1.37626e-18
C373	D1#6	D1#1	4.69863e-17
C374	a_137_260##3	VPWR#11	2.89369e-17
C375	a_137_260##16	C1#5	5.30539e-20
C376	a_137_260##14	D1#8	6.76263e-18
C377	a_137_260##14	B1#4	3.23772e-19
C378	a_137_260##3	X#6	5.60681e-17
C379	VGND#8	a_137_260##8	9.26157e-19
C380	a_1013_392##2	A2#4	9.28614e-19
C381	VPWR#10	VPWR#9	2.66815e-18
C382	a_137_260##3	VPWR#12	2.74374e-18
C383	X#2	a_137_260##7	3.58918e-18
C384	a_137_260##3	X#5	2.82954e-18
C385	a_137_260##5	D1#6	7.82276e-18
C386	a_137_260##15	C1#5	1.3396e-19
C387	a_137_260##13	B1#4	9.79794e-18
C388	VGND#5	VGND#4	1.09425e-18
C389	a_1210_74##2	A2#9	1.66238e-17
C390	a_1210_74#	A2#1	3.03965e-17
C391	a_1210_74##2	A2#4	1.09819e-18
C392	VPWR#10	a_1013_392##6	5.05407e-17
C393	VGND#8	X#1	6.82108e-18
C394	a_137_260##16	C1#4	9.98097e-20
C395	a_137_260##14	C1#5	1.14723e-17
C396	a_1013_392##2	VPWR#3	3.13618e-19
C397	a_137_260##9	a_137_260##5	4.70564e-17
C398	a_137_260##13	B1	4.83153e-17
C399	X#2	a_137_260##2	4.63311e-19
C400	VGND#11	A2#1	2.66885e-17
C401	a_1210_74##2	A1	1.03844e-17
C402	a_1013_392##5	B1#3	1.19986e-18
C403	a_137_260##12	A1	4.85857e-17
C404	VPWR	a_137_260##2	2.41686e-19
C405	a_137_260##15	C1#4	2.51695e-19
C406	a_137_260##13	C1#5	6.34233e-19
C407	D1#2	C1#4	4.80376e-18
C408	a_1210_74#	A2#7	8.56418e-19
C409	a_1013_392##3	a_1013_392##6	8.12386e-19
C410	a_137_260##12	A2#9	2.9903e-18
C411	a_137_260##11	a_137_260##9	4.87041e-17
C412	VGND#7	X#1	7.17328e-18
C413	D1#9	a_549_392##2	3.04963e-18
C414	a_1210_74##2	A2#1	8.17166e-19
C415	A1#3	A2#5	5.32297e-18
C416	a_137_260##14	C1#4	1.86813e-17
C417	a_137_260##14	C1	4.68681e-17
C418	VPWR#4	C1#1	4.46217e-18
C419	a_137_260##13	C1	5.59784e-17
C420	VGND#11	A2#7	2.52664e-17
C421	VPWR#4	C1#6	4.46227e-18
C422	a_137_260#	D1#3	2.24806e-17
C423	A2	a_1013_392##2	5.46619e-18
C424	a_1013_392##3	VPWR#10	6.10226e-17
C425	a_137_260##12	B1	2.42899e-17
C426	a_137_260##10	a_137_260##11	4.68894e-17
C427	C1	a_549_392##2	2.42525e-18
C428	a_137_260##12	A2#1	3.39037e-19
C429	D1#9	C1	1.55747e-17
C430	a_137_260##13	C1#4	1.00399e-19
C431	a_1210_74#	A1#1	1.89459e-19
C432	a_137_260##15	D1#5	1.60209e-17
C433	VPWR#4	D1#1	4.47208e-18
C434	a_137_260##3	a_137_260#	1.27959e-17
C435	D1#8	C1	7.70123e-18
C436	B1#1	A1#3	1.75433e-18
C437	a_137_260##12	A2#4	3.46868e-18
C438	a_1210_74##2	A2#7	2.46793e-17
C439	VPWR#4	D1#6	4.46217e-18
C440	VGND#4	VGND#3	1.09219e-18
C441	a_137_260##14	D1#5	1.16449e-19
C442	B1#2	B1#1	1.84821e-18
C443	VGND#11	A1#1	1.26511e-18
C444	VPWR#3	A1#4	1.83284e-18
C445	A1	VPWR#10	2.37113e-18
C446	VGND	B1#3	1.75161e-20
C447	a_137_260##2	a_137_260#	1.16604e-18
C448	a_137_260##12	A2#7	1.28903e-18
C449	VGND	D1#3	4.0502e-19
C450	A1	a_1013_392##3	1.71665e-17
C451	VGND#8	X#3	6.45552e-18
C452	VGND	a_137_260##7	5.30196e-20
C453	VGND	a_137_260##2	1.78485e-19
C454	VPWR#4	C1#3	4.20631e-20
C455	a_137_260##15	D1#4	6.78534e-18
C456	a_1210_74##2	A1#1	3.35902e-17
C457	a_814_392#	a_1013_392##3	6.05308e-17
C458	a_1210_74#	A2	4.87857e-17
C459	a_1210_74##4	A2#7	2.16679e-19
C460	VGND#11	A1#5	1.81772e-19
C461	a_1210_74##2	A2	3.30745e-18
C462	a_549_392#	C1#3	6.13038e-19
C463	a_137_260##14	D1#4	6.46768e-20
C464	B1	a_1013_392##3	2.7474e-17
C465	a_137_260##16	a_137_260#	3.46537e-19
C466	B1	a_814_392#	5.17581e-17
C467	a_137_260##12	A1#1	3.12871e-17
C468	B1	a_1013_392##5	2.77946e-19
C469	VGND#12	A2#7	5.39423e-20
C470	a_1013_392##5	a_1013_392##3	2.26169e-18
C471	VPWR#3	A1#6	1.83284e-18
C472	a_1210_74##2	A1#5	6.42939e-19
C473	VGND#17	VGND#8	1.0227e-18
C474	a_137_260##15	a_137_260#	9.5946e-19
C475	a_1210_74##4	A1#1	1.1913e-18
C476	C1	a_814_392#	3.30896e-17
C477	VPWR	VPWR#6	6.11739e-17
C478	VGND#11	B1#6	1.16546e-19
C479	VPWR	VPWR#5	7.57813e-17
C480	VPWR	VPWR#3	9.82169e-17
C481	C1	a_549_392#	4.74225e-19
C482	a_137_260##12	A1#5	2.12191e-17
C483	A2#4	VNB	7.66562e-17
C484	C1	a_814_392##2	7.2359e-17
C485	a_137_260##16	a_137_260##4	5.03905e-20
C486	a_814_392#	a_1013_392##5	1.04576e-16
C487	A2	a_1013_392#	4.90169e-17
C488	a_1013_392##6	VPWR#3	5.25459e-18
C489	B1#3	VNB	1.42969e-17
C490	C1#3	VNB	8.71503e-17
C491	D1#3	VNB	2.82846e-17
C492	a_137_260##7	VNB	4.37517e-17
C493	VGND#12	A1#1	8.88637e-20
C494	a_137_260##2	VNB	3.73398e-17
C495	X	X#4	4.56855e-18
C496	a_137_260##15	a_137_260##4	1.98162e-19
C497	VPWR	a_1013_392##2	1.17903e-18
C498	a_1210_74##4	A1#5	5.70123e-17
C499	VPWR#3	B1#1	4.43451e-18
C500	VGND#6	D1#3	4.11995e-20
C501	a_137_260##3	a_137_260##10	5.32298e-18
C502	a_137_260##18	A1#1	7.18778e-20
C503	a_137_260##12	B1#6	3.06063e-19
C504	VPWR	a_137_260##16	1.71879e-18
C505	a_814_392##2	C1#3	4.33267e-18
C506	a_137_260##16	a_137_260##6	2.65922e-20
C507	VGND#12	A1#5	3.6814e-18
C508	VPWR	a_549_392##2	2.55002e-17
C509	a_1013_392##2	A2#6	4.4504e-19
C510	VPWR	D1#9	4.63189e-18
C511	VPWR#4	D1#2	5.72794e-20
C512	VGND	VGND#8	5.70585e-17
C513	VGND	VGND#7	6.16683e-17
C514	C1	B1#4	4.43411e-18
C515	VGND	VGND#5	4.12122e-17
C516	B1#2	A1#3	2.6338e-17
C517	VGND	VGND#4	5.0505e-17
C518	VPWR	X#4	2.74591e-18
C519	a_1210_74##4	B1#6	3.035e-18
C520	a_549_392#	a_1013_392##5	6.73669e-17
C521	VGND	VGND#3	8.57378e-17
C522	VGND#6	D1#2	6.91388e-20
C523	a_814_392##2	a_814_392#	1.31487e-18
C524	A1	A2#5	1.43401e-18
C525	X	VGND#17	1.09596e-17
C526	a_137_260##18	A1#5	2.41224e-19
C527	a_137_260##12	B1#4	9.69501e-20
C528	a_137_260##13	a_137_260##12	1.05664e-19
C529	VPWR#3	B1#5	4.43469e-18
C530	VGND	a_137_260##16	8.95443e-19
C531	VGND#12	B1#6	4.34376e-17
C532	VGND	a_137_260##15	2.42992e-18
C533	VGND	a_137_260##14	3.49483e-18
C534	VGND	a_137_260##13	7.96206e-18
C535	a_137_260##16	a_137_260##8	2.47082e-20
C536	VPWR#6	VNB	2.6414e-17
C537	VGND	D1#8	3.84193e-18
C538	a_1013_392##2	A2#5	1.66917e-17
C539	VPWR#5	VNB	3.18191e-17
C540	VGND	X#4	4.61558e-18
C541	VPWR#3	VNB	6.39505e-17
C542	VGND	X#2	3.73333e-18
C543	VPWR	VPWR#10	1.87804e-17
C544	VGND#8	VNB	2.60393e-17
C545	B1#6	a_137_260##18	1.43353e-17
C546	VGND#7	VNB	2.35766e-17
C547	VPWR	a_1013_392##3	1.62606e-17
C548	VGND#5	VNB	2.09748e-17
C549	VGND	a_137_260##12	8.1243e-18
C550	X	VPWR#13	3.73954e-17
C551	VGND#4	VNB	2.62823e-17
C552	VPWR	a_814_392#	1.30629e-17
C553	VGND	a_1210_74##4	2.34459e-17
C554	VGND#3	VNB	4.61676e-17
C555	a_1013_392##3	VPWR#3	2.64523e-17
C556	VGND	VGND#12	2.21209e-17
C557	VPWR	a_1013_392##5	2.90125e-17
C558	VGND	a_137_260##18	1.20308e-17
C559	A2	A2#6	2.32476e-18
C560	VPWR	a_549_392#	2.37898e-17
C561	VGND	VGND#13	2.35023e-17
C562	VPWR	a_814_392##2	8.69539e-18
C563	VPWR#5	C1#1	4.18202e-20
C564	VGND	a_137_260##19	1.22578e-17
C565	a_1013_392##2	VNB	3.52768e-18
C566	VGND	VGND#14	1.89175e-17
C567	a_549_392#	a_814_392##2	7.29488e-17
C568	VGND#12	B1#4	2.40058e-18
C569	VGND	a_137_260##20	1.65317e-17
C570	VPWR	a_137_260##21	8.56262e-18
C571	A2#9	VNB	9.1884e-19
C572	VPWR	a_549_392##3	2.41079e-17
C573	VGND	X#1	1.48132e-17
C574	a_137_260##16	VNB	4.78689e-18
C575	C1	D1#1	5.34383e-19
C576	VPWR	X#6	1.8522e-17
C577	VGND	X#3	1.42027e-17
C578	a_137_260##15	VNB	2.69994e-19
C579	a_137_260##14	VNB	3.40953e-18
C580	VGND#13	B1#6	2.48169e-18
C581	a_137_260##13	VNB	6.94106e-18
C582	VPWR	X#5	1.7612e-17
C583	A2#9	A2#4	1.57661e-17
C584	a_549_392##2	VNB	4.45184e-18
C585	D1#9	VNB	1.36849e-18
C586	X	a_137_260#	7.42406e-20
C587	D1#8	VNB	1.44896e-18
C588	X#4	VNB	3.09552e-18
C589	X	a_137_260##4	2.59182e-20
C590	X#2	VNB	1.07212e-18
C591	a_1210_74#	VNB	4.41833e-17
C592	X	a_137_260##6	4.48798e-20
C593	B1#4	a_137_260##18	1.70614e-17
C594	VGND#11	VNB	2.37559e-18
C595	a_1210_74##2	VNB	5.20625e-18
C596	X	a_137_260##8	2.1344e-19
C597	a_137_260##12	VNB	4.69469e-18
C598	a_1013_392##2	A1#4	1.53765e-17
C599	a_1210_74##4	VNB	1.33781e-17
C600	A1#3	A2#4	3.1283e-17
C601	a_549_392##4	a_549_392#	5.01824e-18
C602	VGND#12	VNB	8.10751e-18
C603	a_137_260##18	VNB	5.08596e-18
C604	VGND#13	VNB	3.95174e-19
C605	VGND	VPWR#11	3.0635e-18
C606	a_137_260##19	VNB	4.57052e-18
C607	VGND	X#6	3.03303e-18
C608	A1	A1#3	3.15449e-17
C609	a_137_260##20	VNB	1.98707e-18
C610	VGND#15	VNB	3.15359e-19
C611	VPWR	a_137_260#	1.26187e-18
C612	X#1	VNB	2.47645e-18
C613	VGND#16	VNB	1.48191e-18
C614	A1	B1#2	1.21778e-18
C615	X#3	VNB	2.38809e-18
C616	VGND#17	VNB	2.30309e-17
C617	a_1013_392#	VNB	5.29374e-17
C618	B1	A1#3	4.75424e-18
C619	a_814_392#	VPWR#3	8.77105e-19
C620	VPWR#9	VNB	1.3526e-18
C621	VGND#12	a_137_260##13	3.81661e-17
C622	VGND#13	B1#4	3.88635e-17
C623	a_1013_392##6	VNB	4.61348e-18
C624	VGND	A1#5	1.45022e-18
C625	VPWR#10	VNB	2.37019e-19
C626	VGND	B1#6	6.54185e-19
C627	a_1013_392##3	VNB	4.91478e-18
C628	B1	B1#2	3.31054e-17
C629	VGND	B1#4	7.47623e-19
C630	a_814_392#	VNB	7.14186e-18
C631	VPWR#5	C1#6	6.88782e-20
C632	A2#9	A2#5	1.8121e-18
C633	a_1013_392##5	VNB	1.38762e-17
C634	VGND	C1#5	7.92212e-19
C635	a_137_260##14	a_137_260##18	2.38132e-18
C636	a_549_392#	VNB	1.19291e-17
C637	VGND	C1#4	1.14537e-18
C638	a_814_392##2	VNB	2.3407e-18
C639	VGND	D1#5	1.14973e-18
C640	a_549_392##4	VNB	2.95342e-18
C641	VPWR	A1#6	1.31753e-18
C642	a_137_260##21	VNB	6.56864e-19
C643	a_549_392##4	a_814_392##2	5.90331e-17
C644	VPWR	B1#1	1.44273e-18
C645	a_549_392##3	VNB	1.36406e-17
C646	C1	B1#2	1.23399e-17
C647	VGND	a_137_260#	6.2618e-19
C648	VPWR#11	VNB	1.09702e-17
C649	VPWR	B1#5	1.55999e-18
C650	a_137_260##18	C1#5	6.59507e-19
C651	VGND	a_137_260##4	4.04357e-19
C652	X#6	VNB	2.65915e-18
C653	VPWR#12	VNB	2.92383e-18
C654	VGND	a_137_260##6	3.22137e-19
C655	VPWR	C1#1	1.58298e-18
C656	X#5	VNB	3.08215e-18
C657	VGND	a_137_260##8	6.72213e-19
C658	VPWR	C1#6	1.64032e-18
C659	VPWR#13	VNB	4.04634e-17
C660	X	a_137_260##10	2.65218e-17
C661	A2#1	VNB	2.82397e-17
C662	C1	D1#2	2.79523e-18
C663	VPWR	D1#1	1.56278e-18
C664	A2#7	VNB	2.28444e-17
C665	A1#1	VNB	3.27751e-17
C666	VPWR	D1#6	1.86952e-18
C667	A1#5	VNB	3.52896e-17
C668	VPWR	a_137_260##5	2.47259e-18
C669	B1#6	VNB	2.29628e-17
C670	B1#4	VNB	3.7494e-17
C671	VPWR	a_137_260##9	2.88244e-19
C672	C1#5	VNB	2.75352e-17
C673	a_1013_392##2	A1#6	2.26949e-19
C674	C1#4	VNB	2.93051e-17
C675	VPWR	a_137_260##11	8.42828e-19
C676	D1#5	VNB	2.44106e-17
C677	VPWR	a_137_260##10	2.51244e-19
C678	D1#4	VNB	2.898e-17
C679	a_137_260#	VNB	5.00395e-17
C680	a_137_260##4	VNB	2.7814e-17
C681	a_137_260##6	VNB	2.8299e-17
C682	VGND#13	C1#5	3.52078e-17
C683	a_137_260##8	VNB	3.43956e-17
C684	A2#6	VNB	4.40524e-17
C685	VPWR	VPWR#4	1.06916e-16
C686	A2#5	VNB	3.21245e-17
C687	A1#4	VNB	2.73475e-17
C688	a_137_260##21	C1#3	4.6717e-21
C689	A1#6	VNB	2.86198e-17
C690	VGND	a_137_260##10	7.24111e-20
C691	B1#1	VNB	3.28281e-17
C692	B1#5	VNB	3.05105e-17
C693	B1	A1	3.06069e-17
C694	C1#1	VNB	3.23165e-17
C695	X	a_137_260##3	3.79281e-17
C696	C1#6	VNB	3.1491e-17
C697	D1#1	VNB	3.66462e-17
C698	a_137_260##14	VGND#13	2.45276e-17
C699	a_137_260##18	C1#4	1.48817e-19
C700	D1#6	VNB	4.73147e-17
C701	a_1013_392##5	VPWR#3	6.38442e-17
C702	a_137_260##5	VNB	3.84946e-17
C703	VGND	VGND#6	2.30834e-17
C704	a_137_260##9	VNB	3.5669e-17
C705	a_137_260##11	VNB	3.39677e-17
C706	VPWR	a_137_260##3	1.38755e-17
C707	C1	B1	2.29688e-17
C708	a_137_260##10	VNB	7.64913e-17
C709	VGND	B1#2	5.24204e-18
C710	VPWR#5	D1#1	2.00733e-19
C711	C1#5	a_137_260##19	9.98212e-18
C712	VGND	D1#2	1.17267e-18
C713	VPWR#4	VNB	6.26214e-17
C714	VGND#6	VNB	1.25451e-17
C715	VGND	a_137_260##3	1.30681e-17
C716	A1#3	VNB	6.53267e-17
C717	B1#2	VNB	8.50451e-17
C718	a_137_260##21	a_549_392##4	5.78373e-17
C719	D1#2	VNB	3.82129e-17
C720	VPWR	A1	1.5977e-18
C721	a_137_260##3	VNB	5.07698e-17
C722	VGND#13	C1#4	2.03181e-18
C723	VPWR	B1	3.62189e-18
C724	VPWR	C1	6.82662e-18
C725	VGND	A1	1.7505e-18
C726	a_1013_392##2	B1#1	9.78956e-20
C727	VGND	B1	3.76089e-18
C728	VGND	C1	5.67835e-18
C729	A1	VNB	2.9415e-18
C730	VGND#14	C1#5	1.72144e-18
C731	B1	VNB	4.10466e-19
C732	VPWR	X	8.693e-18
C733	C1	VNB	7.83656e-18
C734	A2	VNB	2.98799e-17
C735	VGND	X	1.70526e-17
C736	VGND#13	a_137_260##13	1.7445e-17
C737	X	VNB	8.72218e-17
C738	VPWR	VNB	3.12776e-16
C739	VGND	VNB	3.00898e-16
C740	a_137_260##14	a_137_260##19	1.57305e-18
C741	C1#4	a_137_260##19	1.52607e-17
C742	VGND#2	B1#6	7.80758e-20
C743	VGND#9	a_137_260##6	8.5411e-19
C744	VPWR#2	A2	4.50511e-18
C745	VPWR#7	VNB	4.3447e-17
C746	VGND#9	a_137_260##7	1.76848e-20
C747	VGND#9	a_137_260##10	4.83486e-19
C748	VPWR#7	a_137_260##9	8.74044e-20
C749	X	VPWR#7	2.00084e-18
C750	VGND#2	a_1210_74#	3.39506e-17
C751	X#5	VPWR#7	8.49566e-18
C752	VPWR#2	VPWR#3	2.01671e-17
C753	VPWR#2	VPWR#10	3.03862e-18
C754	VGND#2	a_1210_74##2	4.65704e-17
C755	VGND#2	a_1210_74##4	1.46871e-17
C756	VGND#9	a_137_260##4	1.47953e-19
C757	VGND#9	X#2	3.16169e-19
C758	VPWR#2	A1#4	1.74034e-18
C759	VGND#2	A1	3.22149e-18
C760	VPWR#2	A2#6	6.56379e-18
C761	VPWR#7	a_137_260##10	8.18584e-18
C762	VGND#9	a_137_260##3	5.21341e-20
C763	VPWR#7	VPWR#6	7.0017e-19
C764	VGND#2	VNB	1.62544e-16
C765	VGND#9	X	9.0856e-18
C766	VGND#2	A2#7	5.00263e-18
C767	VGND#2	A1#5	1.6719e-18
C768	VPWR#2	A2#9	1.57358e-18
C769	VGND#2	A2#9	1.69914e-18
C770	VPWR#2	VNB	1.44112e-16
C771	a_1013_392##2	VPWR#2	3.20535e-18
C772	VPWR#2	A1	2.38977e-18
C773	VGND#9	X#3	7.22267e-18
C774	a_1013_392##6	VPWR#2	1.74448e-17
C775	VGND#2	a_137_260##12	2.93891e-18
C776	a_1013_392#	VPWR#2	3.916e-17
C777	VGND#12	VGND#2	8.53156e-21
C778	VGND#9	VNB	6.31322e-17
C779	VPWR#7	a_137_260##11	5.45681e-19
C780	VGND#2	A1#3	5.37064e-20
C781	VPWR	VPWR#7	8.44932e-17
C782	VGND#9	a_137_260##8	5.88375e-18
C783	VPWR#7	a_137_260##7	6.33865e-20
C784	VPWR#2	A2#5	5.9568e-18
C785	VGND#2	A2	5.05269e-18
C786	VGND#3	VGND#2	1.79207e-19
C787	VGND#9	VGND#8	1.1306e-18
C788	VGND	VGND#2	1.116e-17
C789	VGND#2	A2#1	5.37887e-18
C790	VGND	VGND#9	1.2266e-16
C791	VGND#2	A1#1	6.66587e-18
C792	X#4	VPWR#7	2.65037e-19
*
*
.ENDS sky130_fd_sc_hs__a2111o_4
*
