* Extracted by Quantus, converted by sky130cad/quantus.py
*
*
*
*                       LINUX           Wed Nov 18 08:48:04 2026
*
*
*
*  PROGRAM  advgen
*
*  Name           : advgen - Quantus - (64-bit)
*  Version        : 25.1.0-p047
*  Build Date     : Thu Dec 11 23:20:30 PST 2025
*
*  HSPICE LIBRARY
*
*  OPERATING_TEMPERATURE 150
*  QRC_TECH_DIR <path>/tech
*
*
*

*
.SUBCKT sky130_fd_sc_hs__nand4bb_1 VPB VNB VGND VPWR Y A_N C D B_N
*
*
*  caps2d version: 10
*
*
*       TRANSISTOR CARDS
*
*
XM11 a_27_398##6 A_N#2 VGND#5 VNB sky130_fd_pr__nfet_01v8_lvt l=0.15 w=0.55 ad=0.150975 as=0.244375 pd=1.67 ps=2.05
XM6 VGND#5 B_N#1 a_226_398##7 VNB sky130_fd_pr__nfet_01v8_lvt l=0.15 w=0.55 ad=0.244375 as=0.15055 pd=2.05 ps=1.69
XM9 Y#1 a_27_398# a_435_74# VNB sky130_fd_pr__nfet_01v8_lvt l=0.15 w=0.74 ad=0.19585 as=0.1776 pd=2.05 ps=1.96
XM3 a_435_74# a_226_398##3 a_513_74# VNB sky130_fd_pr__nfet_01v8_lvt l=0.15 w=0.74 ad=0.1776 as=0.3108 pd=1.96 ps=2.32
XM8 a_513_74# C#3 a_627_74# VNB sky130_fd_pr__nfet_01v8_lvt l=0.15 w=0.74 ad=0.3108 as=0.3108 pd=2.32 ps=2.32
XM5 a_627_74# D#3 VGND#1 VNB sky130_fd_pr__nfet_01v8_lvt l=0.15 w=0.74 ad=0.3108 as=0.266 pd=2.32 ps=2.34
XM1 a_27_398##8 A_N#1 VPWR#7 VPB sky130_fd_pr__pfet_01v8 l=0.15 w=0.84 ad=0.2478 as=0.336 pd=2.27 ps=2.48
XM2 VPWR#7 B_N#3 a_226_398##6 VPB sky130_fd_pr__pfet_01v8 l=0.15 w=0.84 ad=0.336 as=0.2478 pd=2.48 ps=2.27
XM0 Y#5 a_27_398##4 VPWR#5 VPB sky130_fd_pr__pfet_01v8 l=0.15 w=1.12 ad=0.3304 as=0.4928 pd=2.83 ps=3.12
XM4 VPWR#5 a_226_398# Y#3 VPB sky130_fd_pr__pfet_01v8 l=0.15 w=1.12 ad=0.4928 as=0.392 pd=3.12 ps=2.94
XM10 Y#3 C#1 VPWR#4 VPB sky130_fd_pr__pfet_01v8 l=0.15 w=1.12 ad=0.392 as=0.448 pd=2.94 ps=3.04
XM7 VPWR#4 D#1 Y#6 VPB sky130_fd_pr__pfet_01v8 l=0.15 w=1.12 ad=0.448 as=0.3304 pd=3.04 ps=2.83
*
*
*       RESISTOR AND CAP/DIODE CARDS
*
Rg1	A_N#1	A_N#2	756.318054
Rg2	A_N#2	A_N#3	280.149963
Rg3	B_N#1	B_N#2	345.238708
Rg4	B_N#2	B_N#3	367.623138
Rg5	a_27_398#	a_27_398##2	321.230103
Rg6	a_27_398##2	a_27_398##3	24.690777
Rg7	a_27_398##2	a_27_398##4	506.542023
Rg8	a_226_398#	a_226_398##2	492.059540
Rg9	a_226_398##2	a_226_398##3	307.937683
Rg10	C#1	C#2	495.178009
Rg11	C#2	C#3	404.323944
Rg12	D#1	D#2	434.639221
Rg13	D#2	D#3	382.539734
Rf1	A_N#4	A_N#3	161.418610
Rf2	A_N	A_N#6	1.185802
Rf3	A_N#4	A_N#6	4.957419
Rf4	B_N	B_N#4	7.479781
Rf5	B_N#4	B_N	11.416508
Rf6	a_27_398##3	a_27_398##7	270.889679
Rf7	a_27_398##7	a_27_398##8	89.645462
Rf8	a_27_398##6	a_27_398##7	15.000000
Rf9	a_226_398##2	a_226_398##5	169.110123
Rf10	a_226_398##5	a_226_398##6	131.409668
Rf11	a_226_398##5	a_226_398##7	114.025024
Rf12	C	C#2	163.775864
Rf13	D#4	D#2	162.066422
Rf14	D	D#6	1.833616
Rf15	D#4	D#6	4.913828
Rf16	Y#1	Y#2	231.426941
Rf17	Y#2	Y	68.982162
Rf18	Y	Y#4	8.747477
Rf19	Y#4	Y#5	77.270508
Rf20	Y#2	Y#6	17.917999
Rf21	Y#3	Y#4	5.000000
Rf22	VGND#1	VGND#2	165.123993
Rf23	VGND#2	VGND#3	98.228386
Rf25	VGND#3	VGND#5	42.971458
Rf27	VPWR#2	VPWR#3	95.927292
Rf28	VPWR#2	VPWR#4	31.534731
Rf29	VPWR#3	VPWR#5	31.206240
Rf30	VPWR#3	VPWR#6	100.785156
Rf31	VPWR#6	VPWR#7	40.392368
Rf34	B_N#2	B_N#4	160.232803
Re1	VPWR#3	VPWR	1.091357
Re2	VGND	VGND#2	1.091398
*
*       CAPACITOR CARDS
*
*
C1	VGND	VNB	7.27388e-17
C2	VPWR	VNB	7.34379e-17
C3	Y	VNB	8.8018e-18
C4	C	VNB	7.95937e-19
C5	VGND	Y	5.09389e-18
C6	D	VNB	3.84101e-18
C7	B_N	VNB	1.40579e-18
C8	VPWR	Y	2.14956e-17
C9	VGND	C	5.992e-18
C10	a_226_398##5	a_27_398#	2.35321e-17
C11	VGND	B_N	1.10159e-18
C12	VPWR	C	2.76328e-18
C13	A_N#3	VNB	5.28796e-17
C14	VPWR	D	2.89778e-18
C15	B_N#2	VNB	4.39446e-17
C16	C	Y	2.55047e-17
C17	a_27_398##3	VNB	6.10489e-17
C18	VPWR	B_N	6.79193e-19
C19	a_226_398##2	VNB	2.86663e-17
C20	C#2	VNB	2.88662e-17
C21	D#2	VNB	4.53451e-17
C22	VGND#2	VNB	2.39653e-16
C23	VPWR#3	VNB	2.30582e-16
C24	VGND	A_N#3	7.4641e-18
C25	A_N#1	VNB	5.76109e-17
C26	VGND	B_N#2	2.49224e-18
C27	B_N#3	VNB	3.92172e-17
C28	Y#2	D#4	5.6011e-17
C29	a_27_398##4	VNB	4.54878e-17
C30	VGND	a_27_398##3	6.97218e-18
C31	a_226_398#	VNB	3.44638e-17
C32	VGND	a_226_398##2	3.32079e-19
C33	C#1	VNB	3.68327e-17
C34	D#1	VNB	3.58694e-17
C35	VGND	C#2	3.32079e-19
C36	A_N#2	VNB	3.99911e-17
C37	B_N#1	VNB	3.50878e-17
C38	VGND	VGND#2	3.9793e-17
C39	a_27_398#	VNB	3.48286e-17
C40	VPWR	B_N#2	2.86387e-18
C41	a_226_398##3	VNB	3.44544e-17
C42	C#3	VNB	2.81028e-17
C43	VPWR	a_27_398##3	3.03305e-18
C44	D#3	VNB	3.52644e-17
C45	a_27_398##8	VNB	5.05728e-17
C46	VPWR#7	VNB	1.19494e-17
C47	a_226_398##6	VNB	1.72004e-17
C48	Y#5	VNB	8.74803e-18
C49	a_226_398##5	a_226_398##3	7.50489e-18
C50	VPWR#5	VNB	2.06766e-18
C51	VPWR#4	VNB	3.97506e-18
C52	a_27_398##6	VNB	4.72159e-17
C53	VPWR	VPWR#3	3.12326e-17
C54	VGND#5	VNB	7.42142e-18
C55	Y	a_226_398##2	5.99538e-19
C56	a_226_398##7	VNB	1.32314e-17
C57	Y#1	VNB	1.30012e-17
C58	C	a_627_74#	7.15113e-19
C59	VGND	B_N#1	6.80713e-18
C60	VPWR	A_N#1	7.46647e-18
C61	Y	C#2	2.68166e-18
C62	VGND	a_27_398#	2.21648e-18
C63	VPWR	B_N#3	6.9493e-18
C64	VGND	a_226_398##3	9.60772e-19
C65	VGND#1	VNB	7.57387e-17
C66	A_N#4	VNB	1.46973e-17
C67	VPWR	a_27_398##4	4.57574e-19
C68	VGND	C#3	9.2334e-19
C69	a_27_398##6	VGND#5	5.23289e-17
C70	VGND	D#3	1.15273e-19
C71	A_N#6	VNB	1.0417e-17
C72	VPWR	a_226_398#	3.76873e-19
C73	Y	VPWR#3	9.51671e-18
C74	VPWR	C#1	1.28377e-19
C75	VPWR	D#1	9.78607e-19
C76	a_226_398##5	VNB	7.36945e-18
C77	D#4	VNB	5.48705e-18
C78	Y	B_N#3	8.20219e-20
C79	Y#2	VNB	1.06263e-16
C80	C	a_226_398##2	4.28138e-18
C81	Y	a_27_398##4	1.96297e-18
C82	VGND	a_27_398##6	1.04437e-17
C83	Y	a_226_398#	3.97047e-17
C84	C	C#2	1.83989e-17
C85	a_226_398##5	C#3	2.13057e-18
C86	VGND	a_226_398##7	1.7029e-17
C87	D	a_27_398##3	1.46458e-19
C88	Y	C#1	5.79242e-17
C89	VGND	Y#1	5.99448e-17
C90	C	D#2	4.10324e-18
C91	Y	D#1	1.51524e-18
C92	VPWR	a_27_398##8	1.42743e-17
C93	D	a_226_398##2	2.48994e-19
C94	VGND	VGND#1	5.16858e-17
C95	VPWR	a_226_398##6	1.83959e-17
C96	D	C#2	1.17803e-18
C97	VGND	A_N#4	1.66939e-17
C98	VPWR	Y#5	1.6602e-17
C99	VPWR	VPWR#5	2.35507e-17
C100	D	D#2	6.50805e-18
C101	VPWR	VPWR#4	2.22219e-17
C102	VGND	a_226_398##5	8.971e-18
C103	VGND	D#4	3.14598e-18
C104	Y#2	a_27_398#	2.07987e-19
C105	VGND	Y#2	4.90198e-18
C106	a_226_398##6	Y	6.32745e-19
C107	VGND#5	a_226_398##7	3.08863e-17
C108	a_226_398##5	D#3	1.7797e-19
C109	Y#5	Y	2.27492e-18
C110	Y	VPWR#5	6.64206e-17
C111	Y	Y#3	3.81004e-18
C112	D	a_27_398##4	2.51072e-19
C113	Y	VPWR#4	8.42071e-17
C114	D	a_226_398#	4.21825e-19
C115	B_N	A_N#1	6.06754e-18
C116	D	C#1	2.50518e-18
C117	C	a_27_398#	8.96917e-19
C118	D	D#1	2.49071e-18
C119	VPWR	a_226_398##5	4.94025e-18
C120	Y#1	Y	5.499e-18
C121	C	a_226_398##3	4.45016e-18
C122	VGND#5	Y#1	9.12316e-18
C123	C	C#3	1.46889e-17
C124	Y#2	a_226_398##3	4.36493e-19
C125	C	D#3	4.6232e-18
C126	VPWR	Y#2	2.26542e-17
C127	C#2	a_627_74#	9.07418e-19
C128	B_N	A_N#2	5.31338e-18
C129	a_226_398##7	Y#1	2.48093e-17
C130	a_226_398##5	Y	6.07779e-17
C131	B_N#2	a_27_398##3	3.94269e-17
C132	B_N#2	a_226_398##2	1.92836e-19
C133	Y#2	C#3	2.31513e-18
C134	Y	Y#2	5.52627e-18
C135	a_27_398##3	a_226_398##2	2.42406e-17
C136	a_27_398##8	B_N	5.68062e-18
C137	Y#1	C	2.8583e-17
C138	B_N	VPWR#7	1.68735e-17
C139	VGND#2	A_N#3	1.752e-21
C140	a_226_398##2	C#2	3.07884e-17
C141	Y#2	D#3	2.71652e-17
C142	VGND#2	a_27_398##3	5.33084e-19
C143	a_27_398#	a_435_74#	1.143e-17
C144	a_27_398##6	B_N	3.40045e-17
C145	VPWR#3	a_27_398##3	1.75027e-19
C146	VGND#2	a_226_398##2	1.545e-19
C147	a_226_398##3	a_435_74#	8.20297e-18
C148	C#2	D#2	2.76698e-17
C149	A_N#1	B_N#2	1.46793e-17
C150	a_226_398##5	C	3.29317e-17
C151	VGND#2	C#2	9.75517e-21
C152	C	D#4	2.46505e-17
C153	a_226_398##5	Y#5	2.04721e-17
C154	a_226_398##3	a_513_74#	1.10436e-17
C155	B_N#2	a_27_398##4	3.02634e-18
C156	C	Y#2	4.63902e-17
C157	C#3	a_513_74#	1.79983e-17
C158	B_N#2	a_226_398#	3.30576e-19
C159	A_N#4	VGND#5	1.10828e-17
C160	a_226_398##5	D	3.86434e-18
C161	C#3	a_627_74#	1.39567e-17
C162	a_226_398##5	VPWR#5	3.4134e-18
C163	D#3	a_627_74#	1.88641e-17
C164	A_N#6	a_27_398##6	3.06499e-17
C165	A_N#3	B_N#1	4.82156e-18
C166	D	Y#2	6.09262e-17
C167	A_N#2	B_N#2	1.41275e-17
C168	A_N#3	a_27_398#	9.24711e-19
C169	VGND#1	Y#1	5.0903e-17
C170	a_27_398##3	A_N#2	9.37744e-20
C171	A_N#6	VGND#5	1.71997e-17
C172	Y#1	a_435_74#	6.41733e-19
C173	a_27_398##3	B_N#1	1.58167e-17
C174	a_27_398##8	A_N#3	1.80634e-19
C175	C#1	D#2	1.95147e-18
C176	a_27_398##3	a_27_398#	1.83047e-18
C177	VPWR#3	a_27_398##4	2.55938e-18
C178	a_27_398##3	a_226_398##3	2.10474e-19
C179	Y#1	a_513_74#	5.16728e-18
C180	VPWR#3	a_226_398#	9.54534e-19
C181	a_27_398##8	B_N#2	6.94602e-19
C182	A_N#1	B_N#3	2.43195e-17
C183	B_N#2	VPWR#7	2.64463e-17
C184	a_226_398##7	a_627_74#	1.68023e-20
C185	B_N#2	a_226_398##6	3.3266e-17
C186	Y#1	a_627_74#	3.83341e-18
C187	B_N#3	a_27_398##4	6.40971e-18
C188	a_27_398##3	a_226_398##6	2.43617e-17
C189	a_226_398##5	a_435_74#	3.33229e-18
C190	a_27_398##6	A_N#3	6.15786e-18
C191	Y#5	a_27_398##3	1.14867e-18
C192	C#2	D#3	4.73087e-18
C193	VGND#2	a_27_398#	5.3356e-18
C194	VGND#5	A_N#3	6.69224e-18
C195	a_27_398##4	a_226_398#	2.7628e-17
C196	a_226_398##7	A_N#3	2.46647e-19
C197	VGND#2	a_226_398##3	5.3356e-18
C198	a_27_398##6	B_N#2	2.89651e-17
C199	Y#1	A_N#3	3.14359e-18
C200	VGND#2	C#3	5.31202e-18
C201	a_226_398##5	a_513_74#	1.93775e-18
C202	VPWR#5	a_226_398##2	6.86575e-19
C203	VGND#5	B_N#2	9.83481e-19
C204	a_226_398#	C#1	3.94953e-17
C205	a_27_398##6	a_27_398##3	1.2832e-18
C206	Y#2	VPWR#4	8.13962e-17
C207	A_N#4	A_N#3	1.33926e-17
C208	a_27_398##3	a_226_398##7	8.14144e-17
C209	C#1	D#1	3.03823e-17
C210	VPWR#4	C#2	3.89529e-19
C211	a_27_398##3	Y#1	2.27094e-18
C212	A_N#6	A_N#3	6.70696e-18
C213	Y#2	Y#6	7.23996e-18
C214	a_226_398##6	VPWR#3	1.29522e-18
C215	Y#2	a_627_74#	3.47277e-18
C216	Y#1	a_226_398##2	2.2201e-18
C217	a_226_398##5	Y#1	4.79415e-17
C218	Y#5	VPWR#3	1.78799e-17
C219	D#2	Y#6	3.10657e-19
C220	a_27_398##8	A_N#1	4.18234e-17
C221	A_N#1	VPWR#7	3.27151e-17
C222	Y#1	C#2	5.93089e-19
C223	a_27_398##8	B_N#3	5.51468e-20
C224	B_N#3	VPWR#7	2.49694e-17
C225	Y#5	A_N#1	4.9759e-19
C226	a_27_398##8	a_27_398##4	1.12201e-19
C227	B_N#2	a_226_398##5	8.53532e-18
C228	a_226_398##6	B_N#3	5.76898e-17
C229	VPWR#7	a_27_398##4	1.31913e-18
C230	A_N#2	B_N#1	1.509e-17
C231	VGND#2	a_226_398##7	2.73026e-18
C232	VGND#1	C#2	1.41645e-19
C233	Y#5	B_N#3	2.81958e-18
C234	VGND#2	Y#1	6.54352e-17
C235	a_226_398##6	a_27_398##4	1.33234e-18
C236	VPWR#7	a_226_398#	1.69826e-19
C237	a_27_398##3	a_226_398##5	6.10856e-17
C238	Y#5	a_27_398##4	7.02415e-17
C239	VGND#1	D#2	1.09233e-18
C240	a_226_398##6	a_226_398#	6.46464e-20
C241	B_N#1	a_27_398#	3.54817e-18
C242	a_27_398##4	VPWR#5	2.60801e-17
C243	Y#5	a_226_398#	5.47625e-19
C244	a_27_398##6	A_N#1	3.09149e-18
C245	a_226_398##5	a_226_398##2	2.33856e-17
C246	VGND#2	VGND#1	4.85545e-17
C247	VPWR#5	a_226_398#	4.94869e-17
C248	Y#2	Y#1	2.63646e-20
C249	Y#5	C#1	1.80012e-19
C250	a_27_398#	a_226_398##3	4.65015e-17
C251	a_226_398#	Y#3	1.48579e-17
C252	VPWR#5	C#1	2.03357e-18
C253	a_226_398##5	C#2	4.0594e-18
C254	VPWR#4	a_226_398#	1.17163e-18
C255	C#1	Y#3	2.60143e-17
C256	a_226_398##3	C#3	2.24014e-17
C257	VPWR#5	D#1	6.56488e-19
C258	D#4	C#2	3.79071e-18
C259	C#1	VPWR#4	3.67823e-17
C260	a_226_398##5	D#2	6.56644e-19
C261	D#1	VPWR#4	3.55674e-17
C262	Y#2	C#2	5.54858e-19
C263	D#4	D#2	9.28062e-18
C264	C#3	D#3	2.07407e-17
C265	D#1	Y#6	1.06667e-17
C266	Y#2	D#2	1.58101e-17
C267	Y#2	VGND#1	5.96584e-17
C268	a_27_398##6	A_N#2	5.09093e-17
C269	a_27_398##8	VPWR#7	7.65536e-17
C270	A_N#2	VGND#5	1.95408e-17
C271	a_27_398##6	B_N#1	1.36058e-17
C272	a_226_398##5	A_N#1	1.16297e-19
C273	a_226_398##7	A_N#2	8.47651e-19
C274	B_N#1	VGND#5	1.97546e-17
C275	a_27_398##8	Y#5	3.50117e-19
C276	VPWR#7	a_226_398##6	7.76118e-17
C277	a_27_398##6	a_27_398#	1.26315e-19
C278	a_226_398##7	B_N#1	3.38489e-17
C279	a_226_398##5	B_N#3	4.18776e-20
C280	VGND#5	a_27_398#	8.58346e-19
C281	VPWR#7	Y#5	3.85321e-18
C282	a_27_398##6	a_226_398##3	4.81321e-20
C283	Y#1	B_N#1	2.62598e-18
C284	a_226_398##7	a_27_398#	2.30824e-18
C285	VPWR#7	VPWR#5	1.06528e-18
C286	a_226_398##6	Y#5	7.48195e-17
C287	a_226_398##5	a_27_398##4	2.86406e-17
C288	Y#1	a_27_398#	3.93e-17
C289	a_226_398##7	a_226_398##3	7.66114e-19
C290	a_226_398##5	a_226_398#	5.42926e-18
C291	Y#1	a_226_398##3	2.89887e-17
C292	Y#5	VPWR#5	4.22214e-17
C293	a_226_398##7	C#3	4.64294e-19
C294	a_27_398##6	a_27_398##8	2.72944e-18
C295	Y#1	C#3	2.4668e-17
C296	a_226_398##5	C#1	3.6394e-19
C297	a_226_398##7	D#3	4.62561e-19
C298	A_N#6	A_N#2	1.53743e-18
C299	VGND#1	a_27_398#	3.43317e-19
C300	Y#1	D#3	1.40784e-17
C301	a_226_398##5	D#1	2.05132e-19
C302	A_N#4	a_27_398#	2.63306e-19
C303	VPWR#5	VPWR#4	1.60593e-18
C304	A_N#6	B_N#1	6.8621e-19
C305	VGND#1	a_226_398##3	3.56759e-19
C306	A_N#6	a_27_398#	2.07468e-20
C307	VGND#1	C#3	1.12547e-18
C308	Y#2	C#1	1.19741e-18
C309	a_226_398##5	A_N#2	1.07334e-19
C310	D#3	VGND#1	1.84113e-17
C311	a_226_398##5	Y#2	2.04769e-18
C312	Y#2	D#1	4.86497e-17
C313	a_226_398##5	B_N#1	2.55236e-19
C314	VPWR#6	a_226_398#	1.28951e-19
C315	VPWR#6	a_27_398##4	6.85431e-19
C316	VPWR#6	B_N#3	3.70254e-18
C317	VPWR#6	A_N#1	6.87773e-18
C318	VPWR#3	VPWR#6	6.44476e-17
C319	B_N#2	VPWR#6	3.28336e-19
C320	VPWR#6	VPWR#5	1.94667e-19
C321	a_226_398##6	VPWR#6	1.11019e-17
C322	a_27_398##8	VPWR#6	1.32892e-17
C323	VGND#3	C#3	3.3313e-19
C324	VPWR	VPWR#6	6.52639e-17
C325	VPWR#6	VNB	6.02916e-17
C326	VGND#3	A_N#4	4.24649e-17
C327	VGND#3	a_226_398##3	2.99765e-19
C328	VGND#3	A_N#3	1.32186e-17
C329	VPWR#2	D#1	2.58793e-18
C330	Y#2	VPWR#2	2.74489e-17
C331	VPWR#2	C#1	2.59135e-18
C332	VGND#3	a_27_398#	1.61722e-18
C333	VGND#3	B_N#1	2.85713e-18
C334	VPWR#3	VPWR#2	5.99746e-17
C335	VPWR#2	D#2	2.86597e-20
C336	VPWR#2	C#2	4.8917e-20
C337	VGND#2	VGND#3	6.5303e-17
C338	VGND	VGND#3	6.76083e-17
C339	VGND#3	Y#1	9.2541e-19
C340	VGND#3	VNB	6.14063e-17
C341	VGND#3	a_226_398##7	8.40974e-18
C342	VPWR#5	VPWR#2	3.27494e-19
C343	Y	VPWR#2	8.6119e-18
C344	VPWR	VPWR#2	3.65024e-17
C345	VGND#3	a_27_398##6	2.09669e-18
C346	VPWR#2	VNB	5.22422e-17
C347	VGND#3	a_27_398##3	4.17572e-19
*
*
.ENDS sky130_fd_sc_hs__nand4bb_1
*
