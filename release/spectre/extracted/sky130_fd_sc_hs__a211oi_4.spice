* Extracted by Quantus, converted by sky130cad/quantus.py
*
*
*
*                       LINUX           Wed Nov 18 08:03:31 2026
*
*
*
*  PROGRAM  advgen
*
*  Name           : advgen - Quantus - (64-bit)
*  Version        : 25.1.0-p047
*  Build Date     : Thu Dec 11 23:20:30 PST 2025
*
*  HSPICE LIBRARY
*
*  OPERATING_TEMPERATURE 150
*  QRC_TECH_DIR <path>/tech
*
*
*

*
.SUBCKT sky130_fd_sc_hs__a211oi_4 VPB VNB VGND VPWR Y B1 A2 A1 C1
*
*
*  caps2d version: 10
*
*
*       TRANSISTOR CARDS
*
*
XM11 a_92_74##7 A2#10 VGND#11 VNB sky130_fd_pr__nfet_01v8_lvt l=0.15 w=0.74 ad=0.1961 as=0.2072 pd=2.01 ps=2.04
XM23 VGND#11 A2#8 a_92_74##8 VNB sky130_fd_pr__nfet_01v8_lvt l=0.15 w=0.74 ad=0.2072 as=0.2072 pd=2.04 ps=2.04
XM15 a_92_74##8 A2#6 VGND#10 VNB sky130_fd_pr__nfet_01v8_lvt l=0.15 w=0.74 ad=0.2072 as=0.2072 pd=2.04 ps=2.04
XM18 VGND#10 A2#1 a_92_74##4 VNB sky130_fd_pr__nfet_01v8_lvt l=0.15 w=0.74 ad=0.2072 as=0.2072 pd=2.04 ps=2.04
XM12 a_92_74##4 A1#7 Y#8 VNB sky130_fd_pr__nfet_01v8_lvt l=0.15 w=0.74 ad=0.2072 as=0.2072 pd=2.04 ps=2.04
XM25 a_92_74##2 A1#11 Y#8 VNB sky130_fd_pr__nfet_01v8_lvt l=0.15 w=0.74 ad=0.2072 as=0.2072 pd=2.04 ps=2.04
XM22 Y#6 A1#9 a_92_74##2 VNB sky130_fd_pr__nfet_01v8_lvt l=0.15 w=0.74 ad=0.2072 as=0.2072 pd=2.04 ps=2.04
XM19 Y#6 A1#8 a_92_74# VNB sky130_fd_pr__nfet_01v8_lvt l=0.15 w=0.74 ad=0.2072 as=0.2109 pd=2.04 ps=2.05
XM4 Y#13 B1#7 VGND#9 VNB sky130_fd_pr__nfet_01v8_lvt l=0.15 w=0.74 ad=0.1961 as=0.2072 pd=2.01 ps=2.04
XM13 VGND#9 B1#6 Y#12 VNB sky130_fd_pr__nfet_01v8_lvt l=0.15 w=0.74 ad=0.2072 as=0.2072 pd=2.04 ps=2.04
XM9 Y#12 C1#7 VGND#8 VNB sky130_fd_pr__nfet_01v8_lvt l=0.15 w=0.74 ad=0.2072 as=0.2072 pd=2.04 ps=2.04
XM7 VGND#8 C1#5 Y#10 VNB sky130_fd_pr__nfet_01v8_lvt l=0.15 w=0.74 ad=0.2072 as=0.1961 pd=2.04 ps=2.01
XM16 a_77_368##7 A2#12 VPWR#11 VPB sky130_fd_pr__pfet_01v8 l=0.15 w=1.12 ad=0.308 as=0.336 pd=2.79 ps=2.84
XM6 VPWR#11 A2#11 a_77_368##12 VPB sky130_fd_pr__pfet_01v8 l=0.15 w=1.12 ad=0.336 as=0.336 pd=2.84 ps=2.84
XM20 a_77_368##12 A2#7 VPWR#10 VPB sky130_fd_pr__pfet_01v8 l=0.15 w=1.12 ad=0.336 as=0.336 pd=2.84 ps=2.84
XM2 VPWR#10 A2#5 a_77_368##11 VPB sky130_fd_pr__pfet_01v8 l=0.15 w=1.12 ad=0.336 as=0.336 pd=2.84 ps=2.84
XM8 a_77_368##11 A1#13 VPWR#9 VPB sky130_fd_pr__pfet_01v8 l=0.15 w=1.12 ad=0.336 as=0.336 pd=2.84 ps=2.84
XM24 VPWR#9 A1#12 a_77_368##10 VPB sky130_fd_pr__pfet_01v8 l=0.15 w=1.12 ad=0.336 as=0.336 pd=2.84 ps=2.84
XM26 VPWR#8 A1#10 a_77_368##10 VPB sky130_fd_pr__pfet_01v8 l=0.15 w=1.12 ad=0.336 as=0.336 pd=2.84 ps=2.84
XM10 a_77_368##9 A1#1 VPWR#8 VPB sky130_fd_pr__pfet_01v8 l=0.15 w=1.12 ad=0.308 as=0.336 pd=2.79 ps=2.84
XM0 a_77_368##8 B1#5 a_901_368##5 VPB sky130_fd_pr__pfet_01v8 l=0.15 w=1.12 ad=0.336 as=0.308 pd=2.84 ps=2.79
XM1 a_77_368##8 B1#9 a_901_368##8 VPB sky130_fd_pr__pfet_01v8 l=0.15 w=1.12 ad=0.336 as=0.336 pd=2.84 ps=2.84
XM27 a_901_368##8 B1#8 a_77_368# VPB sky130_fd_pr__pfet_01v8 l=0.15 w=1.12 ad=0.336 as=0.336 pd=2.84 ps=2.84
XM14 a_901_368##7 B1#1 a_77_368# VPB sky130_fd_pr__pfet_01v8 l=0.15 w=1.12 ad=0.336 as=0.336 pd=2.84 ps=2.84
XM21 Y#1 C1#9 a_901_368##7 VPB sky130_fd_pr__pfet_01v8 l=0.15 w=1.12 ad=0.336 as=0.336 pd=2.84 ps=2.84
XM5 a_901_368##6 C1#8 Y#1 VPB sky130_fd_pr__pfet_01v8 l=0.15 w=1.12 ad=0.336 as=0.336 pd=2.84 ps=2.84
XM3 Y#9 C1#4 a_901_368##6 VPB sky130_fd_pr__pfet_01v8 l=0.15 w=1.12 ad=0.336 as=0.336 pd=2.84 ps=2.84
XM17 a_901_368# C1#1 Y#9 VPB sky130_fd_pr__pfet_01v8 l=0.15 w=1.12 ad=0.308 as=0.336 pd=2.79 ps=2.84
*
*
*       RESISTOR AND CAP/DIODE CARDS
*
Rg1	A2#1	A2#2	397.555725
Rg2	A2#2	A2#3	66.369736
Rg3	A2#3	A2#4	57.428749
Rg4	A2#2	A2#5	449.655212
Rg5	A2#3	A2#6	394.514160
Rg6	A2#3	A2#7	447.610504
Rg7	A2#4	A2#8	385.158295
Rg8	A2#4	A2#9	90.033310
Rg9	A2#9	A2#10	418.139221
Rg10	A2#4	A2#11	431.330811
Rg11	A2#9	A2#12	454.869080
Rg12	A1#1	A1#2	455.914490
Rg13	A1#2	A1#3	66.369736
Rg14	A1#3	A1#4	45.616405
Rg15	A1#4	A1#5	33.804066
Rg16	A1#5	A1#6	66.386436
Rg17	A1#6	A1#7	397.555725
Rg18	A1#2	A1#8	426.989899
Rg19	A1#3	A1#9	401.054016
Rg20	A1#3	A1#10	450.571655
Rg21	A1#5	A1#11	395.494293
Rg22	A1#5	A1#12	448.603302
Rg23	A1#6	A1#13	449.655212
Rg24	B1#1	B1#2	526.145996
Rg25	B1#2	B1#3	63.189835
Rg26	B1#3	B1#4	49.459267
Rg27	B1#4	B1#5	553.320679
Rg28	B1#2	B1#6	423.145813
Rg29	B1#3	B1#7	394.814545
Rg30	B1#3	B1#8	437.854187
Rg31	B1#4	B1#9	447.184967
Rg32	C1#1	C1#2	497.728577
Rg33	C1#2	C1#3	82.414566
Rg34	C1#2	C1#4	420.988159
Rg35	C1#3	C1#5	389.241455
Rg36	C1#3	C1#6	54.209194
Rg37	C1#6	C1#7	382.717896
Rg38	C1#3	C1#8	426.879181
Rg39	C1#6	C1#9	453.223267
Rf1	A2	A2#13	3.667233
Rf2	A2#13	A2	11.001698
Rf3	A1	A1#14	12.835315
Rf4	A1#14	A1	1.833616
Rf5	a_92_74#	a_92_74##3	56.659504
Rf6	a_92_74##3	a_92_74##5	54.605175
Rf7	a_92_74##5	a_92_74##6	84.090828
Rf8	a_92_74##6	a_92_74##7	86.158134
Rf9	a_92_74##6	a_92_74##8	28.306047
Rf10	a_92_74##2	a_92_74##3	15.000000
Rf11	a_92_74##4	a_92_74##5	7.500000
Rf12	B1	B1#10	2.198864
Rf13	B1#10	B1	10.994321
Rf14	a_77_368#	a_77_368##2	84.312019
Rf15	a_77_368##2	a_77_368##3	68.544899
Rf16	a_77_368##3	a_77_368##4	69.275406
Rf17	a_77_368##4	a_77_368##5	65.941528
Rf18	a_77_368##5	a_77_368##6	68.798325
Rf19	a_77_368##6	a_77_368##7	76.668030
Rf20	a_77_368##2	a_77_368##8	21.914129
Rf21	a_77_368##3	a_77_368##9	19.708424
Rf22	a_77_368##4	a_77_368##10	28.362816
Rf23	a_77_368##5	a_77_368##11	28.362816
Rf24	a_77_368##6	a_77_368##12	20.631947
Rf25	C1	C1#10	11.918507
Rf26	C1#10	C1	2.750425
Rf27	a_901_368#	a_901_368##2	83.560562
Rf28	a_901_368##2	a_901_368##3	63.903866
Rf29	a_901_368##3	a_901_368##4	67.556396
Rf30	a_901_368##4	a_901_368##5	81.835869
Rf31	a_901_368##2	a_901_368##6	18.149860
Rf32	a_901_368##3	a_901_368##7	25.262085
Rf33	a_901_368##4	a_901_368##8	18.937206
Rf34	Y#1	Y#2	86.326782
Rf35	Y#2	Y	20.003736
Rf36	Y	Y#3	5.135296
Rf37	Y#3	Y#4	66.422890
Rf38	Y#4	Y#5	65.983650
Rf39	Y#5	Y#7	136.913284
Rf40	Y#7	Y#8	47.452984
Rf41	Y#2	Y#9	27.172836
Rf42	Y#3	Y	1.845311
Rf43	Y	Y#11	1.869217
Rf44	Y#11	Y	1.869217
Rf45	Y#4	Y#12	25.077555
Rf46	Y#5	Y#13	18.783115
Rf47	Y#6	Y#7	15.000000
Rf48	Y#10	Y#11	7.500000
Rf49	VGND#1	VGND#2	61.703136
Rf50	VGND#2	VGND#3	62.774361
Rf51	VGND#3	VGND#4	191.002502
Rf52	VGND#4	VGND#5	108.455452
Rf53	VGND#5	VGND#6	62.774361
Rf55	VGND#2	VGND#8	38.247387
Rf56	VGND#3	VGND#9	36.279022
Rf57	VGND#5	VGND#10	38.247387
Rf58	VGND#6	VGND#11	38.247387
Rf59	VPWR#1	VPWR#2	293.638458
Rf60	VPWR#2	VPWR#3	21.890615
Rf61	VPWR#3	VPWR#4	43.805763
Rf62	VPWR#4	VPWR#5	65.696381
Rf63	VPWR#5	VPWR#6	65.818954
Rf65	VPWR#2	VPWR#8	32.420494
Rf66	VPWR#4	VPWR#9	32.420494
Rf67	VPWR#5	VPWR#10	32.420494
Rf68	VPWR#6	VPWR#11	53.143215
Rf70	A1#4	A1#14	40.058201
Rf71	B1#4	B1#10	40.058201
Rf72	C1#3	C1#10	53.410934
Rf69	A2#4	A2#13	40.058201
Re1	VPWR#1	VPWR	3.735117
Re2	VPWR	VPWR#3	1.067176
Re3	VGND#1	VGND	3.735117
Re4	VGND	VGND#4	1.067176
*
*       CAPACITOR CARDS
*
*
C1	VGND	VNB	3.21881e-16
C2	VPWR	VNB	3.03559e-16
C3	Y#3	a_901_368#	5.24619e-17
C4	Y	VNB	3.66861e-17
C5	B1	VNB	2.24493e-17
C6	C1#9	Y#1	1.9521e-17
C7	A2	VNB	5.6298e-17
C8	A1	VNB	1.41581e-17
C9	C1	VNB	6.71305e-18
C10	VGND	B1	1.07263e-17
C11	VGND	A2	1.81762e-17
C12	VGND	A1	8.24317e-18
C13	VPWR	B1	1.16417e-17
C14	VGND	C1	2.29526e-18
C15	A2#4	VNB	5.61006e-17
C16	VPWR	A2	1.82737e-17
C17	a_77_368##5	A2#7	1.5254e-19
C18	a_901_368##6	a_901_368#	5.01824e-18
C19	B1#4	VNB	7.19886e-17
C20	VPWR	A1	8.8993e-18
C21	C1#3	VNB	3.14946e-17
C22	VGND#4	VNB	6.47044e-17
C23	VPWR	C1	2.87875e-18
C24	VPWR#3	VNB	1.03086e-17
C25	VGND#1	VNB	1.76189e-16
C26	VPWR#1	VNB	2.3862e-16
C27	a_901_368##7	C1#8	2.25104e-18
C28	A2#12	VNB	4.17035e-17
C29	A2#11	VNB	3.20577e-17
C30	A1	B1	1.82211e-17
C31	a_901_368##6	C1#9	1.72215e-18
C32	A2#7	VNB	2.85856e-17
C33	VGND#5	A2#1	5.25553e-18
C34	A2#5	VNB	2.89219e-17
C35	a_77_368##6	A2#7	1.40747e-17
C36	A1#13	VNB	2.97586e-17
C37	VGND	VGND#4	1.15247e-16
C38	B1	C1	3.30847e-17
C39	B1#7	B1#6	3.89687e-17
C40	A1#12	VNB	3.08775e-17
C41	A2	A1	3.46075e-17
C42	A1#10	VNB	2.99349e-17
C43	A1#1	VNB	3.24653e-17
C44	B1#5	VNB	6.88841e-17
C45	B1#9	VNB	3.37602e-17
C46	B1#8	VNB	3.18926e-17
C47	B1#1	VNB	3.56413e-17
C48	a_77_368##3	A2#5	9.41412e-20
C49	C1#9	VNB	3.24085e-17
C50	C1#8	VNB	3.21198e-17
C51	C1#4	VNB	3.29408e-17
C52	VPWR	VPWR#3	2.0942e-17
C53	C1#1	VNB	7.52268e-17
C54	Y#1	C1#8	5.47706e-17
C55	A2#10	VNB	3.37999e-17
C56	A2#8	VNB	2.52294e-17
C57	Y#9	C1#9	1.70184e-19
C58	A2#6	VNB	2.53301e-17
C59	VPWR	VPWR#1	6.93074e-17
C60	A2#1	VNB	2.58416e-17
C61	A1#7	VNB	3.08771e-17
C62	A1#11	VNB	3.00969e-17
C63	VPWR	A2#12	1.86003e-18
C64	A1#9	VNB	3.0617e-17
C65	A1#8	VNB	4.09771e-17
C66	a_77_368##4	A2#5	6.57987e-20
C67	VPWR	A2#11	7.92239e-19
C68	B1#7	VNB	2.9031e-17
C69	B1	B1#4	4.40828e-17
C70	A2	A2#4	3.67598e-17
C71	B1#6	VNB	2.38026e-17
C72	a_901_368#	Y#9	6.03184e-17
C73	VPWR	A2#7	1.00981e-18
C74	C1#7	VNB	2.47519e-17
C75	VGND#1	Y	1.22665e-16
C76	C1#5	VNB	2.76799e-17
C77	a_77_368##7	VNB	5.10733e-17
C78	VPWR	A2#5	1.15118e-18
C79	VPWR#11	VNB	2.82484e-18
C80	a_77_368##12	VNB	2.24265e-18
C81	VPWR	A1#13	1.15118e-18
C82	VPWR#10	VNB	1.16033e-19
C83	a_77_368##11	VNB	4.61348e-18
C84	VPWR	A1#12	5.25319e-19
C85	a_92_74##6	A2#2	1.34991e-18
C86	VPWR#9	VNB	2.18747e-19
C87	a_901_368##6	C1#8	3.948e-17
C88	a_77_368##10	VNB	4.62062e-18
C89	VPWR	A1#10	1.9791e-18
C90	Y#6	a_77_368##3	1.63305e-17
C91	VPWR#8	VNB	2.40307e-19
C92	VGND	A2#10	1.80169e-18
C93	VPWR	A1#1	1.25621e-18
C94	a_77_368##9	VNB	1.00072e-17
C95	a_77_368##5	A2#5	1.38715e-17
C96	a_901_368##5	VNB	1.26917e-17
C97	VGND	A2#8	6.66852e-19
C98	VPWR	B1#5	1.36021e-18
C99	VGND	A2#6	6.66852e-19
C100	VPWR	B1#9	1.58088e-18
C101	VGND	A2#1	8.64956e-19
C102	VGND	A1#7	6.88239e-19
C103	VPWR	B1#8	1.59339e-18
C104	VGND	A1#11	7.6399e-19
C105	VPWR	B1#1	1.64189e-18
C106	VGND	A1#9	8.7675e-19
C107	a_901_368#	VNB	4.93122e-17
C108	a_92_74##7	VNB	4.44181e-17
C109	VPWR	C1#9	9.36606e-19
C110	VGND	A1#8	8.8008e-19
C111	VGND#11	VNB	1.3093e-18
C112	a_92_74##8	VNB	4.55126e-18
C113	VGND	B1#7	8.90194e-19
C114	C1	B1#4	2.46565e-19
C115	Y#1	C1#4	3.77629e-19
C116	VGND#10	VNB	3.01253e-20
C117	VGND	B1#6	6.27302e-19
C118	a_77_368##6	A2#5	1.6466e-19
C119	a_92_74##4	VNB	5.66924e-18
C120	Y#8	VNB	4.92726e-19
C121	VGND	C1#7	6.19755e-19
C122	Y#9	C1#8	3.88881e-19
C123	a_901_368##3	B1#2	5.33197e-20
C124	a_92_74##2	VNB	4.17547e-18
C125	a_901_368##2	C1#2	8.05518e-20
C126	C1	C1#3	2.05843e-17
C127	B1#6	C1#7	4.00694e-17
C128	Y#6	VNB	1.36716e-17
C129	a_92_74#	VNB	1.32781e-17
C130	Y#13	VNB	1.33492e-17
C131	VGND#5	A1#7	6.34496e-18
C132	VGND#9	VNB	1.8447e-18
C133	a_77_368##3	A1#13	1.42355e-19
C134	A2	A2#12	3.44822e-18
C135	Y#12	VNB	4.55126e-18
C136	VGND#8	VNB	1.3093e-18
C137	Y#10	VNB	3.10592e-17
C138	A2	A2#11	2.05823e-18
C139	A2	A2#7	2.1032e-18
C140	a_92_74##6	VNB	1.67225e-18
C141	VGND#1	C1	5.4167e-18
C142	B1	A1#1	8.45433e-19
C143	A2	A2#5	2.076e-18
C144	a_77_368##3	VNB	1.13817e-17
C145	a_901_368##6	C1#4	4.40815e-17
C146	B1	B1#5	2.17479e-17
C147	a_77_368##4	A1#13	1.5254e-19
C148	VPWR#1	C1	6.71069e-18
C149	A2	A1#13	8.52483e-19
C150	B1	B1#9	3.11113e-18
C151	a_901_368##2	VNB	4.45184e-18
C152	a_901_368##3	VNB	5.11369e-18
C153	a_901_368##4	VNB	4.71531e-18
C154	Y#3	VNB	5.86111e-17
C155	Y#4	VNB	3.01015e-18
C156	Y#5	VNB	1.95659e-17
C157	B1	B1#1	1.76931e-18
C158	VPWR	a_77_368##7	1.84094e-17
C159	A1	A2#5	4.46612e-19
C160	VGND	a_92_74##7	1.55586e-17
C161	B1	C1#9	3.26956e-19
C162	Y#1	C1#1	1.62892e-19
C163	VGND#2	VNB	2.8429e-17
C164	VGND#3	VNB	5.88254e-17
C165	a_77_368##5	A1#13	1.79159e-17
C166	VGND#5	VNB	3.67625e-17
C167	A1	A1#13	2.46594e-18
C168	VPWR	a_77_368##12	1.46854e-17
C169	VGND	a_92_74##8	1.18512e-17
C170	C1#4	Y#9	2.42159e-17
C171	VPWR	VPWR#10	2.15742e-17
C172	VPWR#2	VNB	5.89775e-17
C173	VGND	a_92_74##4	1.94726e-17
C174	A1	A1#12	2.1032e-18
C175	VPWR#4	VNB	2.41319e-17
C176	VPWR	a_77_368##11	1.24124e-17
C177	VGND	Y#8	6.27049e-18
C178	VPWR#5	VNB	2.82587e-17
C179	VPWR	VPWR#9	2.17984e-17
C180	VGND	a_92_74##2	2.37858e-17
C181	VGND	Y#6	1.57583e-17
C182	A1	A1#10	2.09146e-18
C183	VPWR	a_77_368##10	1.21891e-17
C184	VGND	a_92_74#	1.83293e-17
C185	VPWR	VPWR#8	2.18155e-17
C186	VGND	Y#13	1.45716e-17
C187	A1	A1#1	1.90353e-18
C188	VPWR	a_77_368##9	1.45327e-17
C189	a_77_368##6	A1#13	7.36537e-20
C190	VGND	Y#12	1.20906e-17
C191	VPWR	a_901_368##5	2.38194e-17
C192	VPWR	a_77_368##8	6.14543e-18
C193	A1	B1#5	4.0441e-18
C194	a_901_368##6	C1#1	2.42148e-18
C195	a_77_368##3	A1#12	2.84666e-19
C196	C1#7	C1#5	3.87819e-17
C197	Y	C1#5	7.23174e-18
C198	VPWR	a_77_368#	8.40334e-18
C199	a_901_368#	C1#4	2.53585e-18
C200	VGND	a_92_74##6	4.07016e-18
C201	VGND#5	A1#11	5.10498e-19
C202	VGND	a_77_368##3	4.04432e-18
C203	a_92_74##4	A1#6	1.57891e-19
C204	a_77_368##4	A1#12	1.39569e-17
C205	A2#4	A2#2	4.0818e-18
C206	C1#1	Y#9	2.04966e-17
C207	a_92_74##6	A2#9	3.81517e-19
C208	a_77_368##7	a_77_368##6	1.18264e-18
C209	Y#5	B1#7	1.92356e-17
C210	B1#2	C1#6	3.35594e-17
C211	VGND	Y#4	2.15074e-18
C212	VGND	Y#5	1.20945e-17
C213	C1	B1#1	1.50189e-18
C214	A2#9	A2#4	4.03955e-18
C215	a_77_368##5	A1#12	1.5254e-19
C216	C1	C1#9	5.50461e-18
C217	VGND#5	a_92_74##6	2.91756e-19
C218	VGND	VGND#2	1.32122e-17
C219	VGND	VGND#3	1.25845e-16
C220	VGND	VGND#5	9.25414e-17
C221	C1	C1#8	2.1032e-18
C222	a_901_368#	C1#1	5.03766e-17
C223	C1	C1#4	1.54209e-18
C224	VPWR#1	B1#4	8.12208e-20
C225	VGND#1	C1#3	1.65356e-20
C226	C1	C1#1	2.89946e-19
C227	a_77_368##3	A1#10	5.28302e-19
C228	a_901_368##4	B1#2	3.4277e-20
C229	Y#4	B1#6	1.88741e-17
C230	VPWR#1	C1#3	2.94521e-20
C231	VPWR	a_77_368##2	2.78513e-18
C232	B1#2	C1#7	4.882e-19
C233	A2	a_77_368##7	5.52942e-17
C234	VPWR	a_77_368##3	4.86407e-18
C235	A2#2	VNB	2.66466e-17
C236	VPWR	a_77_368##4	4.23277e-18
C237	a_77_368##4	A1#10	1.52072e-17
C238	A2#9	VNB	3.77777e-17
C239	VPWR	a_77_368##5	3.2415e-18
C240	A1#2	VNB	2.919e-17
C241	VGND#5	A1#9	2.02922e-19
C242	VPWR	a_77_368##6	3.03636e-18
C243	a_92_74##7	VGND#11	4.91213e-17
C244	A1#5	VNB	5.57295e-17
C245	A1#6	VNB	2.53886e-17
C246	B1#2	VNB	2.51699e-17
C247	B1	a_77_368#	4.60599e-17
C248	C1#2	VNB	3.80107e-17
C249	C1#6	VNB	2.45238e-17
C250	VPWR	a_901_368##3	1.84169e-17
C251	a_77_368##6	VPWR#11	1.58171e-17
C252	VPWR	a_901_368##4	2.9837e-17
C253	Y#8	A1#5	2.16838e-18
C254	a_77_368##5	A1#10	6.57987e-20
C255	VGND#8	Y	2.41083e-17
C256	Y#3	a_901_368##2	3.54799e-18
C257	Y	Y#10	2.59082e-18
C258	a_77_368##3	A1#1	1.83613e-17
C259	VGND#3	A1#8	1.88409e-19
C260	a_901_368##3	C1#6	2.63136e-20
C261	C1#2	C1#1	8.84842e-19
C262	VPWR	VPWR#2	1.07143e-16
C263	a_92_74##7	a_92_74##8	1.72657e-18
C264	VPWR	VPWR#4	4.90238e-17
C265	VPWR	VPWR#5	5.63015e-17
C266	Y#4	C1#7	1.65997e-17
C267	a_77_368##7	VPWR#11	5.51789e-17
C268	Y#6	B1	1.70218e-17
C269	a_77_368##4	A1#1	2.64947e-19
C270	Y#8	A1#6	1.58111e-18
C271	B1	Y#13	3.87284e-18
C272	B1	VGND#9	2.51339e-18
C273	a_77_368##6	a_77_368##12	2.06076e-18
C274	VGND#5	A1#8	1.75399e-19
C275	a_77_368##7	A2#9	6.07194e-20
C276	a_92_74##7	A2	5.26299e-17
C277	a_77_368##2	B1#5	2.03484e-17
C278	B1#5	B1#4	2.04109e-18
C279	a_77_368##3	a_77_368##11	4.75919e-21
C280	a_92_74##7	A2#10	3.0659e-17
C281	A2#2	A1#6	2.63141e-17
C282	Y#3	C1#5	1.6338e-17
C283	a_77_368##7	a_77_368##12	1.73069e-18
C284	B1#9	B1#4	1.39165e-18
C285	a_92_74##4	A2	3.39462e-17
C286	VGND#11	a_92_74##8	4.15829e-17
C287	a_77_368##5	VPWR#10	1.55915e-17
C288	a_77_368##3	B1#5	1.38511e-18
C289	VPWR#5	A2#7	1.83922e-18
C290	VGND#2	Y	6.8542e-18
C291	B1	a_77_368##2	7.78031e-17
C292	VGND#3	B1#7	4.57876e-18
C293	VGND#11	A2#10	2.91028e-17
C294	B1#4	B1#1	1.34526e-18
C295	B1	a_77_368##3	2.39438e-17
C296	VPWR#3	A1#10	3.07983e-18
C297	A2#12	A2#11	4.73924e-17
C298	a_77_368##4	B1#5	2.34207e-20
C299	Y#4	C1#5	6.39748e-19
C300	VPWR#11	a_77_368##12	5.11921e-17
C301	a_92_74##7	A2#8	8.48022e-19
C302	a_77_368##6	VPWR#10	1.56403e-17
C303	a_92_74##2	A1#5	8.98421e-19
C304	a_77_368##2	B1#9	1.31993e-17
C305	a_92_74##8	A2#10	6.43198e-19
C306	C1	a_901_368##7	3.78595e-17
C307	VGND#11	VGND#10	1.66094e-18
C308	a_92_74##4	A1	2.70775e-18
C309	C1	Y#1	4.75777e-17
C310	A2#11	A2#7	4.68073e-17
C311	Y#8	A1	4.27794e-17
C312	B1	Y#3	2.00474e-18
C313	VGND#2	B1#6	9.62831e-19
C314	Y#4	B1	1.88964e-17
C315	Y#5	B1	1.20663e-16
C316	VGND#11	A2#8	3.28956e-17
C317	a_77_368##5	a_77_368##11	5.60916e-18
C318	a_77_368##3	B1#9	3.23295e-19
C319	a_92_74##6	A2	8.74854e-17
C320	Y#6	A1	4.86429e-17
C321	Y#6	A1#2	5.11267e-19
C322	VPWR#11	VPWR#10	2.28687e-18
C323	VPWR#5	A2#5	1.83922e-18
C324	a_92_74##7	A2#6	1.87602e-19
C325	VGND#3	B1#6	4.77723e-18
C326	A2#7	A2#5	4.65914e-17
C327	a_77_368##4	VPWR#9	1.55915e-17
C328	A2	a_77_368##5	4.15269e-17
C329	A2#8	a_92_74##8	1.72195e-17
C330	A2	a_77_368##6	8.08429e-17
C331	a_92_74##2	A1#6	1.54884e-19
C332	a_92_74##8	VGND#10	4.16102e-17
C333	A2#9	VPWR#11	6.04058e-19
C334	VPWR#1	B1#9	1.54498e-18
C335	a_77_368##12	VPWR#10	5.30395e-17
C336	VGND#11	A2#6	1.37067e-18
C337	VPWR#1	B1#8	4.43427e-18
C338	A1#2	B1#4	4.43869e-20
C339	VGND#10	A2#8	1.37067e-18
C340	A2#5	A1#13	4.776e-17
C341	a_77_368##3	B1#8	3.6094e-19
C342	VGND#2	C1#7	5.36162e-18
C343	a_77_368##5	VPWR#9	1.56403e-17
C344	VPWR#1	B1#1	4.46728e-18
C345	Y#3	B1#2	8.66796e-19
C346	A2#6	a_92_74##8	1.38198e-17
C347	a_77_368##12	a_77_368##11	1.25897e-18
C348	VPWR#4	A1#13	1.84214e-18
C349	A1	a_77_368##3	2.23112e-17
C350	a_92_74##8	a_92_74##4	1.67195e-18
C351	VPWR#1	C1#9	5.17404e-18
C352	A1	a_77_368##4	7.34839e-17
C353	a_92_74##4	A2#8	1.67688e-19
C354	B1#2	a_77_368#	1.25477e-18
C355	A2#4	VPWR#11	6.13865e-19
C356	a_77_368##4	a_77_368##10	3.86047e-18
C357	A1	a_77_368##5	2.72136e-17
C358	A1#8	B1#4	1.18365e-19
C359	VPWR#1	C1#8	6.10584e-18
C360	A2#4	a_77_368##12	6.57862e-19
C361	A1#13	A1#12	4.65863e-17
C362	VGND#3	C1#7	7.64954e-19
C363	B1#4	B1#2	3.93179e-18
C364	VGND#1	C1#1	3.85042e-19
C365	VGND#10	A2#6	2.81866e-17
C366	A2#4	VPWR#10	6.47602e-19
C367	Y#6	A1#5	3.50481e-18
C368	a_77_368##3	VPWR#8	1.55915e-17
C369	VPWR#1	C1#4	6.09443e-18
C370	VPWR#10	a_77_368##11	5.20507e-17
C371	a_77_368##3	B1#1	2.42089e-19
C372	VPWR#1	C1#1	6.68643e-18
C373	a_92_74##8	A2#1	3.05025e-19
C374	a_92_74#	A1#2	3.99104e-19
C375	a_92_74##4	VGND#10	5.16148e-17
C376	VGND#4	A1#11	5.31202e-18
C377	a_92_74##4	A2#6	3.97516e-19
C378	A1#12	A1#10	4.77579e-17
C379	VGND#2	C1#5	5.36429e-18
C380	VGND#4	A1#9	5.31202e-18
C381	a_77_368##4	VPWR#8	1.56403e-17
C382	VPWR#10	VPWR#9	2.06267e-18
C383	a_901_368##4	B1#9	1.72627e-17
C384	VPWR#4	A1#12	4.08725e-18
C385	VGND#10	A2#1	2.71144e-17
C386	VGND#4	A1#8	5.31202e-18
C387	Y#5	B1#5	4.34929e-18
C388	a_77_368##3	a_77_368##9	2.17876e-18
C389	A1#10	A1#1	4.65714e-17
C390	a_92_74##8	A1#7	1.28671e-19
C391	C1	a_901_368##3	2.29723e-18
C392	a_92_74##4	A2#1	2.48778e-17
C393	VGND#5	a_92_74##8	5.19931e-18
C394	A1#5	A1#2	4.0818e-18
C395	a_77_368##11	VPWR#9	5.21059e-17
C396	a_77_368##2	a_901_368##5	1.48227e-17
C397	Y#3	C1	1.34184e-16
C398	Y#4	C1	4.18886e-17
C399	a_77_368##3	VPWR#2	1.25227e-18
C400	VGND#10	A1#7	1.43332e-18
C401	Y#4	B1#2	1.06178e-18
C402	Y#3	C1#2	2.83751e-17
C403	a_77_368##4	a_77_368##9	2.41303e-19
C404	Y#8	A2#1	9.65252e-19
C405	A1#1	B1#5	7.05575e-18
C406	A2#2	VPWR#10	6.13865e-19
C407	a_901_368##4	B1#8	1.83137e-17
C408	a_77_368##3	A1#2	8.21502e-19
C409	VPWR#4	VPWR#2	1.22366e-18
C410	a_77_368##11	a_77_368##10	1.21858e-18
C411	a_92_74##4	Y#8	4.86692e-17
C412	a_77_368##3	a_901_368##5	1.83479e-17
C413	a_92_74##4	A1#7	4.97611e-17
C414	a_92_74#	A1#5	1.82208e-19
C415	a_901_368##5	B1#4	9.24934e-20
C416	C1#3	C1#2	8.81379e-19
C417	a_77_368##2	a_77_368##8	2.46155e-18
C418	VGND#10	A1#11	2.90512e-19
C419	B1#4	a_77_368##8	3.10282e-19
C420	B1#5	B1#9	4.82664e-17
C421	VGND#11	A2#4	6.45351e-19
C422	VGND#1	C1#7	1.65829e-20
C423	a_901_368##3	B1#1	1.92523e-17
C424	C1#6	C1#3	3.23701e-18
C425	Y#8	A1#7	2.75885e-17
C426	Y#3	B1#8	1.95862e-19
C427	B1#4	a_901_368##8	8.69887e-19
C428	VPWR#9	a_77_368##10	5.20507e-17
C429	VGND#1	C1#5	1.73438e-18
C430	VGND#3	B1#5	6.0702e-19
C431	VGND#10	A2#4	3.36627e-19
C432	B1#4	a_77_368#	1.30883e-18
C433	Y#3	C1#6	5.86128e-20
C434	a_92_74##4	A1#11	1.75775e-18
C435	VPWR#2	A1#1	1.84453e-18
C436	a_77_368##5	A2#2	8.93875e-19
C437	a_901_368##4	B1#1	3.20168e-19
C438	a_77_368##3	a_77_368##8	1.10503e-18
C439	B1#9	B1#8	4.70394e-17
C440	VGND#10	A1#9	1.55626e-19
C441	VPWR#9	VPWR#8	2.06267e-18
C442	VGND#4	A1#2	5.2026e-20
C443	a_77_368##2	a_901_368##8	1.86719e-17
C444	Y#8	A1#11	3.92063e-17
C445	a_901_368##3	C1#9	2.20962e-17
C446	VGND#5	a_92_74##4	2.07373e-17
C447	a_77_368##10	VPWR#3	1.05092e-17
C448	Y#3	B1#1	2.00702e-19
C449	VGND#4	A1#5	1.65714e-19
C450	a_92_74##2	Y#8	3.92636e-17
C451	Y#5	B1#2	2.15257e-20
C452	a_92_74##4	A1#9	9.92842e-19
C453	a_77_368##4	VPWR#4	3.28319e-19
C454	B1#8	B1#1	4.49184e-17
C455	C1#3	Y#1	2.36491e-18
C456	B1	A1#2	1.02545e-17
C457	a_92_74##2	A1#11	3.43558e-17
C458	VGND#4	A1#6	4.55661e-20
C459	a_77_368##10	VPWR#8	5.21059e-17
C460	a_901_368##4	C1#9	1.24924e-19
C461	VGND#10	A1#8	1.49876e-19
C462	C1#3	a_901_368##6	5.78758e-19
C463	VPWR#2	B1#5	4.43608e-18
C464	B1	B1#2	1.45375e-17
C465	a_901_368##2	C1#8	2.10313e-17
C466	B1	C1#6	5.36e-18
C467	Y#5	Y#13	4.89296e-19
C468	VPWR#5	VPWR#4	1.22166e-18
C469	a_92_74##4	a_92_74#	1.08054e-19
C470	a_92_74##4	A1#8	9.04832e-19
C471	a_77_368##10	a_77_368##9	1.25897e-18
C472	Y#4	VGND#9	1.46878e-17
C473	B1#1	C1#9	4.71164e-17
C474	a_77_368##7	A2#12	5.73877e-17
C475	a_92_74##2	A1#9	3.43558e-17
C476	Y#3	C1#9	3.01975e-19
C477	A1#2	B1#5	4.06825e-18
C478	Y#4	C1#6	1.23936e-18
C479	A2#12	VPWR#11	3.08474e-17
C480	a_92_74##6	A2#10	1.95034e-19
C481	a_77_368##5	VPWR#4	3.13618e-19
C482	a_77_368##3	a_77_368#	5.49821e-21
C483	a_92_74##6	A2#4	6.34827e-18
C484	a_77_368##12	A2#12	1.73273e-18
C485	VPWR#8	a_77_368##9	5.29637e-17
C486	Y#6	A1#9	3.92063e-17
C487	a_77_368##7	A2#11	2.12167e-18
C488	a_901_368##2	C1#4	2.10045e-17
C489	VPWR#2	B1#9	2.89684e-18
C490	Y#6	a_92_74##2	3.63925e-17
C491	C1#9	C1#8	4.66466e-17
C492	VPWR#10	A2#12	4.90852e-19
C493	Y#5	VGND#9	1.47618e-17
C494	A2#11	VPWR#11	2.52041e-17
C495	VGND#9	B1#4	3.96874e-19
C496	A2	A2#2	1.63066e-17
C497	Y#4	Y#12	1.64539e-18
C498	VPWR#3	A1#5	4.36718e-20
C499	a_77_368##12	A2#11	4.41312e-17
C500	A2	A2#9	2.4728e-17
C501	VPWR#8	a_901_368##5	3.50859e-18
C502	Y#3	C1#8	4.89585e-19
C503	Y#3	VGND#8	1.46895e-17
C504	a_77_368##4	A1#5	4.55735e-18
C505	a_92_74##6	A2#8	1.69139e-17
C506	a_77_368##6	A2#4	4.81513e-18
C507	C1#6	Y#1	4.6703e-19
C508	VPWR#10	A2#11	2.16476e-18
C509	a_77_368##5	VPWR#5	3.13618e-19
C510	Y#6	A1#8	4.70111e-17
C511	VPWR#11	A2#7	6.18985e-19
C512	A2	A1#6	1.00431e-17
C513	C1#8	C1#4	4.61769e-17
C514	VGND#4	a_92_74##4	2.31973e-18
C515	Y#13	A1#9	1.67221e-19
C516	a_77_368##11	A2#11	9.62907e-20
C517	A2#7	a_77_368##12	1.78245e-17
C518	a_77_368##9	a_901_368##5	6.06771e-17
C519	VGND#4	a_92_74##2	3.83596e-17
C520	a_92_74#	A1#8	4.64456e-17
C521	VPWR#10	A2#7	4.62144e-17
C522	VGND#4	Y#6	3.97612e-18
C523	VPWR#1	Y#1	7.69104e-18
C524	Y#4	VGND#8	1.3558e-17
C525	VGND#8	C1#3	4.7621e-19
C526	a_92_74##6	A2#6	1.70261e-17
C527	Y#6	B1#7	4.46104e-19
C528	a_77_368##11	A2#7	2.23229e-19
C529	Y#3	C1#4	1.91753e-17
C530	VGND#4	a_92_74#	3.03356e-17
C531	a_77_368##12	A2#5	2.40966e-19
C532	a_77_368##6	A2#9	8.01961e-19
C533	C1#4	C1#1	4.64187e-17
C534	Y#3	Y#10	2.70667e-19
C535	a_92_74#	Y#6	4.09523e-17
C536	VGND#2	Y#3	2.91756e-19
C537	Y#13	A1#8	1.91197e-18
C538	a_77_368##9	a_77_368##8	1.66905e-18
C539	VPWR#1	Y#9	7.8484e-18
C540	VPWR#10	A2#5	5.19665e-17
C541	a_77_368##6	VPWR#5	3.13618e-19
C542	a_77_368##2	B1#4	3.81944e-18
C543	C1#2	a_901_368##6	5.74176e-19
C544	a_92_74#	B1#7	1.15635e-18
C545	a_901_368#	VPWR#1	7.52202e-17
C546	A1#6	A1#5	4.0818e-18
C547	A2#5	a_77_368##11	2.61267e-17
C548	a_77_368##12	A1#13	1.07786e-19
C549	VGND#9	A1#8	4.99384e-19
C550	A1	A2#2	5.07109e-18
C551	a_77_368##4	a_77_368##3	5.98012e-19
C552	VPWR#9	A2#5	2.13205e-18
C553	a_901_368##4	a_77_368##8	1.01425e-17
C554	VPWR#10	A1#13	2.13205e-18
C555	a_901_368##5	a_77_368##8	4.42079e-17
C556	a_92_74##6	A2#1	9.24914e-20
C557	Y#6	Y#13	2.49981e-18
C558	Y#4	Y#10	2.04331e-18
C559	B1#7	Y#13	2.1829e-17
C560	A1	A1#2	1.65352e-17
C561	VGND#9	B1#2	3.82798e-19
C562	Y#3	C1#1	4.14871e-17
C563	a_77_368##10	A2#5	9.62907e-20
C564	a_77_368##12	VPWR#5	7.18333e-18
C565	A1	A1#5	3.86258e-17
C566	A1#13	a_77_368##11	2.14335e-17
C567	VGND#5	A2#4	3.80851e-20
C568	VGND#2	Y#4	2.91756e-19
C569	A1	A1#6	1.59762e-17
C570	a_92_74##7	A2#9	1.73856e-18
C571	VPWR#9	A1#13	4.55665e-17
C572	VGND#9	B1#7	2.80526e-17
C573	a_901_368##5	a_901_368##8	3.18266e-18
C574	VGND#3	Y#13	1.75937e-17
C575	VGND#1	C1#2	4.05941e-19
C576	a_77_368##10	A1#13	2.23229e-19
C577	a_92_74##7	a_92_74##6	5.2354e-19
C578	a_77_368##11	A1#12	2.23229e-19
C579	a_901_368##4	B1#4	1.53974e-19
C580	a_92_74#	Y#13	7.31248e-18
C581	Y#13	B1#6	8.60616e-19
C582	a_92_74##6	A1#7	3.90164e-20
C583	a_901_368##4	a_901_368##8	9.30374e-20
C584	VPWR#5	A2#4	3.11162e-20
C585	A1#5	VPWR#9	6.13865e-19
C586	VGND#9	VGND#2	7.59287e-19
C587	Y#12	B1#7	8.50681e-19
C588	a_77_368##5	A1#6	9.05954e-19
C589	VPWR#9	A1#12	5.19665e-17
C590	a_77_368##8	a_901_368##8	3.4678e-17
C591	a_901_368##3	a_77_368#	1.2703e-17
C592	VGND#3	Y#4	3.16197e-19
C593	VGND#9	B1#6	3.18571e-17
C594	A1#12	a_77_368##10	2.61267e-17
C595	a_77_368##11	A1#10	9.62907e-20
C596	Y#5	B1#4	1.24272e-17
C597	a_901_368##2	C1#3	7.33242e-20
C598	C1#2	Y#9	4.36321e-19
C599	A2#10	A2#8	3.9603e-17
C600	A1#6	VPWR#9	6.47602e-19
C601	a_901_368##3	C1#3	4.9048e-20
C602	VPWR#8	A1#12	2.52395e-18
C603	VPWR#9	A1#10	2.13205e-18
C604	Y#13	C1#7	1.90388e-19
C605	a_92_74##6	VGND#11	2.2577e-17
C606	a_77_368##5	a_77_368##4	8.32696e-19
C607	a_77_368##8	a_77_368#	2.54942e-18
C608	B1#6	Y#12	1.75578e-17
C609	a_901_368##4	a_77_368#	1.2831e-17
C610	a_77_368##11	VPWR#4	5.20514e-18
C611	a_77_368##9	A1#12	1.28445e-19
C612	A1#10	a_77_368##10	2.14335e-17
C613	a_901_368##4	VPWR#2	1.85268e-17
C614	VGND#2	Y#12	5.19931e-18
C615	Y#3	C1#3	5.61484e-18
C616	VGND#9	C1#7	1.48705e-18
C617	VPWR#8	A1#10	4.57251e-17
C618	a_901_368##3	a_901_368##7	2.37452e-18
C619	VGND#3	B1#4	8.58193e-19
C620	VPWR#1	B1#2	3.0061e-20
C621	Y#4	C1#3	7.72229e-20
C622	C1	B1#2	9.83192e-18
C623	VGND#8	B1#6	1.37067e-18
C624	VGND#11	A2#9	1.20272e-19
C625	A2#8	A2#6	4.09562e-17
C626	Y#13	VGND#9	3.83514e-17
C627	VGND#3	Y#5	7.75168e-18
C628	a_77_368##11	VPWR#5	5.26615e-18
C629	a_77_368#	a_901_368##8	4.54959e-17
C630	C1	C1#2	1.35672e-17
C631	a_77_368##9	A1#10	2.87151e-19
C632	a_77_368##10	A1#1	3.97421e-19
C633	a_92_74##6	a_92_74##8	1.24483e-18
C634	a_901_368##2	Y#1	1.26669e-17
C635	C1	C1#6	1.58368e-17
C636	a_77_368##4	VPWR#3	5.24331e-19
C637	C1#7	Y#12	1.30919e-17
C638	VPWR#1	C1#2	3.42147e-20
C639	VPWR#8	A1#1	5.06423e-17
C640	Y#10	B1#6	2.4169e-19
C641	A1#5	a_77_368##10	6.21314e-19
C642	VPWR#2	B1#4	6.64704e-20
C643	a_901_368##4	a_901_368##7	1.63452e-18
C644	VGND#3	Y#12	5.25973e-18
C645	VPWR#1	C1#6	3.67658e-21
C646	a_77_368##10	B1#5	3.5131e-20
C647	a_901_368##8	a_901_368##7	2.88051e-18
C648	A1#1	a_77_368##9	3.68533e-17
C649	VGND#2	C1#3	5.90557e-20
C650	VGND#8	C1#7	2.83665e-17
C651	Y#13	Y#12	2.28353e-18
C652	A2#6	A2#1	3.96767e-17
C653	Y#3	a_77_368#	3.38251e-21
C654	a_901_368##3	Y#1	1.04692e-17
C655	VPWR#8	B1#5	7.88927e-19
C656	a_901_368##5	A1#1	2.98962e-18
C657	a_92_74##6	VGND#10	2.26406e-17
C658	a_901_368#	C1#2	8.48479e-20
C659	Y#12	C1#5	4.35715e-19
C660	VGND#4	Y#5	7.7238e-19
C661	a_901_368##2	a_901_368##6	4.35239e-20
C662	A1#2	VPWR#8	5.98782e-19
C663	a_77_368##6	a_77_368##5	8.60298e-19
C664	Y#10	C1#7	7.99896e-19
C665	a_77_368##9	B1#5	1.94722e-18
C666	a_77_368##8	A1#1	3.34486e-19
C667	a_77_368#	a_901_368##7	6.85259e-17
C668	Y#4	a_77_368#	2.1594e-18
C669	VGND#8	C1#5	2.72032e-17
C670	VGND#9	Y#12	3.76784e-17
C671	VPWR#8	B1#9	6.99797e-20
C672	a_901_368##5	B1#5	4.34063e-17
C673	A2#1	A1#7	4.08253e-17
C674	a_92_74##6	a_92_74##4	5.06977e-19
C675	a_77_368##9	B1#9	1.31723e-19
C676	B1#5	a_77_368##8	2.68779e-17
C677	a_77_368##2	a_901_368##4	9.4177e-19
C678	a_901_368##2	Y#9	9.53264e-18
C679	C1#5	Y#10	9.88976e-18
C680	VPWR#8	B1#8	3.97099e-20
C681	VGND#10	A2#2	5.06958e-19
C682	a_901_368##5	B1#9	1.4051e-18
C683	a_901_368##8	B1#5	1.67036e-18
C684	A1#5	VPWR#8	6.47602e-19
C685	VGND#9	VGND#8	1.66094e-18
C686	Y#4	a_901_368##7	1.73751e-18
C687	A1#7	A1#11	4.06774e-17
C688	B1#9	a_77_368##8	2.30476e-17
C689	a_77_368#	B1#5	2.18267e-19
C690	a_901_368##7	Y#1	5.79589e-17
C691	VGND#1	Y#3	1.4683e-18
C692	B1#1	C1#6	1.07098e-18
C693	a_901_368##8	B1#9	3.77839e-17
C694	a_901_368##2	VPWR#1	8.65495e-17
C695	VGND#1	Y#4	9.75803e-19
C696	a_901_368##3	VPWR#1	6.69199e-17
C697	a_77_368##8	B1#8	4.52038e-19
C698	a_77_368#	B1#9	4.87956e-19
C699	Y#12	VGND#8	4.16102e-17
C700	a_901_368##4	VPWR#1	4.61581e-17
C701	a_901_368##7	a_901_368##6	4.93988e-18
C702	a_77_368##9	VPWR#2	1.44439e-17
C703	A1#11	A1#9	4.06774e-17
C704	a_901_368##8	B1#8	4.21562e-17
C705	Y#3	VPWR#1	1.26284e-17
C706	Y#3	a_901_368##6	2.19407e-17
C707	a_77_368##8	B1#1	1.94989e-19
C708	a_77_368#	B1#8	3.34712e-17
C709	VGND#1	VGND#2	6.1439e-17
C710	Y#1	a_901_368##6	4.32322e-17
C711	VGND#8	C1#6	4.34917e-19
C712	Y#12	Y#10	1.43992e-18
C713	VGND#5	A2#8	9.71076e-19
C714	a_901_368##8	B1#1	1.41963e-18
C715	VGND#5	A1#6	1.13348e-21
C716	a_901_368##7	B1#8	7.38649e-19
C717	VGND#3	VGND#2	1.14921e-18
C718	A1#9	A1#8	4.06774e-17
C719	a_77_368##6	A2#12	3.66027e-19
C720	a_77_368#	B1#1	5.56257e-17
C721	a_901_368##5	VPWR#2	4.57072e-17
C722	Y#1	Y#9	2.08705e-18
C723	a_901_368##8	C1#9	2.20153e-19
C724	Y#3	Y#9	5.85198e-18
C725	B1#1	a_901_368##7	2.03871e-17
C726	VGND#8	Y#10	2.21918e-17
C727	a_77_368##5	A2#11	6.57987e-20
C728	VGND#5	A2#6	5.33427e-18
C729	a_77_368#	C1#9	1.32438e-18
C730	a_77_368##6	A2#11	1.78806e-17
C731	A1#8	B1#7	9.91079e-19
C732	a_901_368##6	Y#9	3.48691e-17
C733	a_901_368##7	C1#9	5.41128e-17
C734	a_92_74##4	a_77_368##5	4.27599e-18
C735	VPWR#6	VPWR#10	2.83194e-19
C736	VPWR#6	VPWR#5	9.69359e-19
C737	VGND#6	A2#6	9.71076e-19
C738	a_77_368##12	VPWR#6	6.05652e-18
C739	VPWR#6	A2#7	5.01904e-19
C740	VPWR#6	A2#11	5.2259e-18
C741	a_77_368##7	VPWR#6	2.1071e-17
C742	VPWR#6	A2#12	5.4572e-18
C743	VGND	VGND#6	1.14906e-16
C744	VGND#6	A2#8	5.49981e-18
C745	VGND#6	A2#9	4.13281e-20
C746	VGND#6	a_92_74##7	1.7841e-17
C747	VGND#6	A2	2.5223e-18
C748	VGND#6	VNB	5.79969e-17
C749	VGND#6	VGND#5	1.68991e-18
C750	VPWR#6	A2#4	1.77417e-20
C751	VGND#6	A2#10	5.38052e-18
C752	VGND#6	a_92_74##6	2.91756e-19
C753	a_77_368##6	VPWR#6	3.13618e-19
C754	A2	VPWR#6	1.58468e-18
C755	VPWR	VPWR#6	1.00319e-16
C756	VGND#6	A2#4	3.62715e-20
C757	VGND#6	a_92_74##8	5.24871e-18
C758	VPWR#6	VNB	5.40691e-17
*
*
.ENDS sky130_fd_sc_hs__a211oi_4
*
