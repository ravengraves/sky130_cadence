* Extracted by Quantus, converted by sky130cad/quantus.py
*
*
*
*                       LINUX           Wed Nov 18 08:03:25 2026
*
*
*
*  PROGRAM  advgen
*
*  Name           : advgen - Quantus - (64-bit)
*  Version        : 25.1.0-p047
*  Build Date     : Thu Dec 11 23:20:30 PST 2025
*
*  HSPICE LIBRARY
*
*  OPERATING_TEMPERATURE 150
*  QRC_TECH_DIR <path>/tech
*
*
*

*
.SUBCKT sky130_fd_sc_hs__a211o_4 VPB VNB VGND VPWR X A2 C1 A1 B1
*
*
*  caps2d version: 10
*
*
*       TRANSISTOR CARDS
*
*
XM3 VGND#14 a_105_280##12 X#2 VNB sky130_fd_pr__nfet_01v8_lvt l=0.15 w=0.74 ad=0.1961 as=0.2072 pd=2.01 ps=2.04
XM5 X#2 a_105_280##10 VGND#13 VNB sky130_fd_pr__nfet_01v8_lvt l=0.15 w=0.74 ad=0.2072 as=0.2072 pd=2.04 ps=2.04
XM11 X#1 a_105_280##8 VGND#13 VNB sky130_fd_pr__nfet_01v8_lvt l=0.15 w=0.74 ad=0.2072 as=0.2072 pd=2.04 ps=2.04
XM23 VGND#12 a_105_280# X#1 VNB sky130_fd_pr__nfet_01v8_lvt l=0.15 w=0.74 ad=0.2441 as=0.2072 pd=2.16 ps=2.04
XM0 a_105_280##17 B1#1 VGND#12 VNB sky130_fd_pr__nfet_01v8_lvt l=0.15 w=0.64 ad=0.1792 as=0.2441 pd=1.84 ps=2.16
XM13 a_105_280##17 C1#5 VGND#11 VNB sky130_fd_pr__nfet_01v8_lvt l=0.15 w=0.64 ad=0.1792 as=0.22985 pd=1.84 ps=2.1
XM20 VGND#11 C1#1 a_105_280##15 VNB sky130_fd_pr__nfet_01v8_lvt l=0.15 w=0.64 ad=0.22985 as=0.221125 pd=2.1 ps=2.08
XM17 VGND#10 B1#4 a_105_280##15 VNB sky130_fd_pr__nfet_01v8_lvt l=0.15 w=0.64 ad=0.4608 as=0.221125 pd=2.72 ps=2.08
XM2 a_1064_123##2 A2#4 VGND#10 VNB sky130_fd_pr__nfet_01v8_lvt l=0.15 w=0.64 ad=0.1792 as=0.4608 pd=1.84 ps=2.72
XM8 a_1064_123##2 A1#5 a_105_280##14 VNB sky130_fd_pr__nfet_01v8_lvt l=0.15 w=0.64 ad=0.1792 as=0.1792 pd=1.84 ps=1.84
XM9 a_105_280##14 A1#1 a_1064_123# VNB sky130_fd_pr__nfet_01v8_lvt l=0.15 w=0.64 ad=0.1792 as=0.1792 pd=1.84 ps=1.84
XM1 VGND#1 A2#2 a_1064_123# VNB sky130_fd_pr__nfet_01v8_lvt l=0.15 w=0.64 ad=0.1696 as=0.1792 pd=1.81 ps=1.84
XM4 VPWR#7 a_105_280##7 X#5 VPB sky130_fd_pr__pfet_01v8 l=0.15 w=1.12 ad=0.308 as=0.336 pd=2.79 ps=2.84
XM16 X#5 a_105_280##13 VPWR#11 VPB sky130_fd_pr__pfet_01v8 l=0.15 w=1.12 ad=0.336 as=0.336 pd=2.84 ps=2.84
XM18 X#6 a_105_280##11 VPWR#11 VPB sky130_fd_pr__pfet_01v8 l=0.15 w=1.12 ad=0.336 as=0.336 pd=2.84 ps=2.84
XM14 VPWR#10 a_105_280##9 X#6 VPB sky130_fd_pr__pfet_01v8 l=0.15 w=1.12 ad=0.308 as=0.336 pd=2.79 ps=2.84
XM15 a_517_392##5 B1#3 a_602_392##2 VPB sky130_fd_pr__pfet_01v8 l=0.15 w=1 ad=0.275 as=0.35 pd=2.55 ps=2.7
XM7 a_105_280##21 C1#7 a_602_392##2 VPB sky130_fd_pr__pfet_01v8 l=0.15 w=1 ad=0.3 as=0.35 pd=2.6 ps=2.7
XM19 a_602_392# C1#6 a_105_280##21 VPB sky130_fd_pr__pfet_01v8 l=0.15 w=1 ad=0.325 as=0.3 pd=2.65 ps=2.6
XM21 a_602_392# B1#6 a_517_392##3 VPB sky130_fd_pr__pfet_01v8 l=0.15 w=1 ad=0.325 as=0.305 pd=2.65 ps=2.61
XM22 VPWR#9 A2#5 a_517_392##3 VPB sky130_fd_pr__pfet_01v8 l=0.15 w=1 ad=0.655 as=0.305 pd=3.31 ps=2.61
XM12 a_517_392##6 A1#6 VPWR#9 VPB sky130_fd_pr__pfet_01v8 l=0.15 w=1 ad=0.3 as=0.655 pd=2.6 ps=3.31
XM10 VPWR#8 A1#4 a_517_392##6 VPB sky130_fd_pr__pfet_01v8 l=0.15 w=1 ad=0.3 as=0.3 pd=2.6 ps=2.6
XM6 a_517_392# A2#1 VPWR#8 VPB sky130_fd_pr__pfet_01v8 l=0.15 w=1 ad=0.275 as=0.3 pd=2.55 ps=2.6
*
*
*       RESISTOR AND CAP/DIODE CARDS
*
Rg1	a_105_280#	a_105_280##2	403.540253
Rg2	a_105_280##2	a_105_280##3	83.023369
Rg3	a_105_280##3	a_105_280##4	36.027042
Rg4	a_105_280##4	a_105_280##5	159.160965
Rg5	a_105_280##5	a_105_280##6	63.547134
Rg6	a_105_280##6	a_105_280##7	658.358582
Rg7	a_105_280##2	a_105_280##8	296.645660
Rg8	a_105_280##2	a_105_280##9	480.767517
Rg9	a_105_280##3	a_105_280##10	313.411285
Rg10	a_105_280##4	a_105_280##11	467.978302
Rg11	a_105_280##5	a_105_280##12	394.019714
Rg12	a_105_280##6	a_105_280##13	388.771576
Rg13	B1#1	B1#2	435.128693
Rg14	B1#2	B1#3	408.386017
Rg15	C1#1	C1#2	294.260559
Rg16	C1#2	C1#3	35.518757
Rg17	C1#3	C1#4	17.816948
Rg18	C1#4	C1#5	333.619080
Rg19	C1#2	C1#6	494.395050
Rg20	C1#4	C1#7	493.970734
Rg21	B1#4	B1#5	351.918732
Rg22	B1#5	B1#6	408.386017
Rg23	A1#1	A1#2	341.315308
Rg24	A1#2	A1#3	56.190357
Rg25	A1#2	A1#4	423.573059
Rg26	A1#3	A1#5	345.741425
Rg27	A1#3	A1#6	420.399719
Rg28	A2#1	A2#2	810.649841
Rg29	A2#2	A2#3	1088.625854
Rg30	A2#3	A2#4	273.732178
Rg31	A2#4	A2#5	949.292908
Rf1	X#1	X	49.506863
Rf2	X	X#3	7.784983
Rf3	X	X#4	86.053215
Rf4	X#4	X#5	35.443844
Rf5	X#4	X#6	84.249115
Rf6	X#2	X#3	7.500000
Rf7	C1	C1#3	166.531570
Rf8	a_602_392#	a_602_392##2	76.558060
Rf9	B1	B1#2	239.292480
Rf10	B1	B1#5	168.818405
Rf11	A2#3	A2	170.778168
Rf12	a_105_280##14	a_105_280##16	151.212219
Rf13	a_105_280##16	a_105_280##18	69.315071
Rf14	a_105_280##18	a_105_280##19	65.678024
Rf15	a_105_280##19	a_105_280##2	173.347794
Rf16	a_105_280##19	a_105_280##21	140.407516
Rf17	a_105_280##15	a_105_280##16	15.000000
Rf18	a_105_280##17	a_105_280##18	7.500000
Rf19	A1	A1#7	12.007017
Rf20	A1#7	A1	6.889272
Rf21	a_1064_123#	a_1064_123##2	93.820694
Rf22	a_517_392#	a_517_392##2	88.441513
Rf23	a_517_392##2	a_517_392##4	96.120102
Rf24	a_517_392##4	a_517_392##5	141.312866
Rf25	a_517_392##2	a_517_392##6	20.795578
Rf27	a_517_392##3	a_517_392##4	5.000000
Rf28	VGND#1	VGND#2	42.850208
Rf29	VGND#2	VGND#3	175.844543
Rf30	VGND#3	VGND#4	70.444664
Rf31	VGND#4	VGND#5	19.333849
Rf32	VGND#5	VGND#6	47.823540
Rf33	VGND#6	VGND#7	62.774361
Rf34	VGND#7	VGND#8	62.774361
Rf36	VGND#3	VGND#10	41.790440
Rf37	VGND#4	VGND#11	35.885353
Rf38	VGND#6	VGND#12	31.141060
Rf39	VGND#7	VGND#13	32.342297
Rf40	VGND#8	VGND#14	33.306259
Rf41	VPWR#1	VPWR#2	48.554047
Rf42	VPWR#2	VPWR#3	78.715088
Rf43	VPWR#3	VPWR#4	135.719009
Rf44	VPWR#4	VPWR#5	85.567123
Rf45	VPWR#5	VPWR#6	68.798325
Rf46	VPWR#6	VPWR#7	115.139610
Rf47	VPWR#2	VPWR#8	33.109421
Rf48	VPWR#3	VPWR#9	15.407028
Rf49	VPWR#5	VPWR#10	67.810089
Rf50	VPWR#6	VPWR#11	44.620285
Rf56	A1#3	A1#7	160.232803
Re1	VPWR#1	VPWR	11.068454
Re2	VPWR	VPWR#4	0.790604
Re3	VGND#2	VGND	11.068454
Re4	VGND	VGND#5	0.790604
*
*       CAPACITOR CARDS
*
*
C1	VGND#4	a_105_280#	5.44653e-19
C2	VGND#7	a_105_280##8	9.48478e-19
C3	a_105_280##6	a_105_280##4	9.88792e-18
C4	X#4	VPWR#6	2.26359e-19
C5	a_105_280##4	VGND#13	2.45324e-19
C6	VGND#3	a_105_280#	1.38203e-19
C7	a_517_392##6	VPWR#8	5.92888e-17
C8	B1#1	C1#4	3.88496e-18
C9	VGND#1	A2#2	3.74525e-17
C10	VGND#7	a_105_280##10	1.22744e-18
C11	A2#2	a_1064_123#	2.28469e-17
C12	VGND#1	A1#1	3.316e-18
C13	A1#3	A1#2	3.63751e-18
C14	a_105_280##14	A2#2	1.87909e-18
C15	a_1064_123#	A1#1	3.41515e-17
C16	a_517_392##3	a_517_392##6	1.64881e-18
C17	VGND#1	A1#5	3.6695e-19
C18	VGND#14	a_105_280##6	4.96025e-18
C19	a_105_280##14	A1#1	2.77897e-17
C20	a_517_392##3	VPWR#9	1.2119e-18
C21	VGND#10	A2#2	1.05438e-19
C22	a_1064_123#	A1#5	1.22296e-18
C23	VPWR#2	A2#1	1.50015e-18
C24	VGND#1	A2#4	9.8707e-20
C25	a_105_280##14	A1#5	3.33286e-17
C26	A2#3	A1#2	2.53693e-19
C27	VPWR#3	A1#4	2.70081e-18
C28	VGND#10	A1#1	1.54544e-19
C29	a_1064_123#	A2#4	6.43126e-19
C30	X#2	X#6	3.12157e-18
C31	a_1064_123##2	A1#5	2.8919e-17
C32	VPWR#2	A1#4	9.77649e-19
C33	a_517_392##3	a_602_392#	5.88224e-17
C34	a_105_280##15	A1#1	1.60159e-19
C35	a_105_280##14	A2#4	2.44888e-17
C36	VGND#10	A1#5	2.56823e-19
C37	a_1064_123#	B1#4	3.70298e-19
C38	VPWR#3	A1#6	3.26634e-17
C39	a_1064_123##2	A2#4	2.09568e-17
C40	a_517_392##3	a_105_280##21	2.02914e-17
C41	a_105_280##15	A1#5	2.79907e-19
C42	a_105_280##14	B1#4	2.16683e-19
C43	A2#4	VGND#10	1.5242e-17
C44	a_602_392#	a_105_280##21	5.62582e-19
C45	a_517_392##3	a_602_392##2	1.42951e-18
C46	a_1064_123##2	B1#4	1.21726e-18
C47	a_105_280##15	A2#4	1.21997e-17
C48	VPWR#3	A2#5	2.53747e-17
C49	C1#4	B1#5	2.77236e-17
C50	a_105_280##14	C1#1	1.09659e-19
C51	VGND#10	B1#4	3.74232e-17
C52	a_517_392##5	a_517_392##3	8.93166e-19
C53	a_517_392##2	A2#1	8.50916e-19
C54	VPWR#5	B1#6	4.16161e-20
C55	a_105_280##15	B1#4	3.09056e-17
C56	a_105_280##21	a_602_392##2	2.18994e-18
C57	VGND#10	C1#1	3.06795e-18
C58	VPWR#3	B1#6	7.9407e-18
C59	VGND#11	B1#4	7.84724e-19
C60	a_517_392##2	A1#4	1.5716e-17
C61	a_105_280##21	a_517_392##5	6.38284e-17
C62	VPWR#10	a_602_392#	3.26978e-21
C63	a_105_280##15	C1#1	4.55423e-17
C64	VPWR#5	C1#6	5.043e-20
C65	VGND#10	C1#5	6.40521e-19
C66	a_517_392#	A2#2	1.75162e-19
C67	C1#1	VGND#11	1.89072e-17
C68	a_517_392##5	a_602_392##2	5.95261e-17
C69	VPWR#3	C1#6	7.95369e-19
C70	a_105_280##15	C1#5	1.17608e-18
C71	a_517_392##2	A1#6	2.13396e-17
C72	a_105_280##17	C1#1	8.1345e-19
C73	VPWR#8	A2#2	4.99273e-19
C74	VPWR#10	a_602_392##2	8.045e-18
C75	VGND#11	C1#5	2.95988e-17
C76	VPWR#5	C1#7	1.56766e-19
C77	a_105_280##15	B1#1	4.00658e-19
C78	VPWR#3	C1#7	3.77296e-19
C79	a_105_280##17	C1#5	2.7475e-17
C80	VPWR#10	a_517_392##5	2.81874e-17
C81	a_517_392##2	A2#5	6.47421e-19
C82	VGND#11	B1#1	1.56292e-18
C83	VPWR#6	B1#3	1.98622e-20
C84	VGND#12	C1#5	8.24753e-19
C85	VPWR#5	B1#3	9.26099e-19
C86	B1#2	C1#4	4.20511e-17
C87	a_105_280##17	B1#1	4.31527e-17
C88	a_105_280##12	a_105_280##4	3.94998e-18
C89	VPWR#3	B1#3	2.79782e-19
C90	VGND#11	a_105_280#	7.7028e-19
C91	a_517_392##2	B1#6	1.93223e-19
C92	B1#1	VGND#12	1.73527e-17
C93	X#6	VPWR#10	8.59711e-17
C94	VPWR#6	a_105_280##9	5.23024e-19
C95	a_105_280##17	a_105_280#	1.06656e-18
C96	VPWR#5	a_105_280##9	7.90307e-18
C97	a_517_392##3	C1#4	2.31566e-19
C98	VPWR#11	VPWR#10	1.94092e-18
C99	VGND#12	a_105_280#	3.92916e-17
C100	a_517_392##2	C1#6	1.42413e-19
C101	a_105_280##17	a_105_280##8	1.38358e-19
C102	X#6	VPWR#11	8.18952e-17
C103	a_105_280#	X#1	1.66845e-17
C104	VPWR#6	a_105_280##11	5.28755e-18
C105	VGND#3	a_1064_123##2	4.91141e-18
C106	X#2	B1#1	1.45137e-19
C107	a_105_280##2	C1#4	2.09966e-19
C108	VGND#12	a_105_280##8	2.74056e-18
C109	A1#2	A2#1	1.78666e-17
C110	VPWR#5	a_105_280##11	5.30308e-19
C111	a_517_392##3	A2#4	4.47209e-19
C112	VGND#13	a_105_280#	2.20917e-18
C113	X#5	X#6	4.20221e-18
C114	a_105_280##2	a_105_280##6	3.90546e-20
C115	a_105_280##17	a_105_280##10	8.34766e-20
C116	a_1064_123#	a_517_392##2	6.08466e-18
C117	X#1	a_105_280##8	2.63748e-17
C118	X#2	a_105_280#	4.07615e-19
C119	a_105_280##4	a_105_280##2	4.86747e-18
C120	X#5	VPWR#11	6.84928e-17
C121	VPWR#6	a_105_280##13	5.79469e-18
C122	VGND#13	a_105_280##8	2.67689e-17
C123	a_602_392#	C1#4	1.27489e-19
C124	VGND#4	a_105_280##15	3.61601e-18
C125	X#1	a_105_280##10	4.23001e-19
C126	VPWR#5	a_105_280##13	8.1728e-20
C127	X#2	a_105_280##8	7.37111e-18
C128	VPWR#7	VPWR#11	2.2895e-18
C129	VGND#13	a_105_280##10	2.71528e-17
C130	VGND#3	a_105_280##15	4.81332e-18
C131	X#1	a_105_280##12	1.76544e-19
C132	VPWR#7	X#5	7.87223e-17
C133	VPWR#6	a_105_280##7	3.85629e-18
C134	X#2	a_105_280##10	2.04713e-17
C135	VGND#13	a_105_280##12	2.27385e-18
C136	VGND#6	a_105_280##17	1.64641e-18
C137	VGND#14	a_105_280##10	3.00124e-18
C138	VGND#7	VGND#12	8.55012e-20
C139	a_105_280##12	X#2	2.0697e-17
C140	VGND#11	VGND#3	1.98308e-18
C141	a_105_280##21	C1#4	6.38569e-19
C142	VGND#14	a_105_280##12	3.67049e-17
C143	VGND#7	X#1	3.32148e-18
C144	VGND#12	VGND#4	4.55894e-19
C145	A2#2	A1#1	4.91286e-17
C146	VGND#6	X#1	2.96753e-18
C147	VPWR#1	VPWR#2	5.65073e-20
C148	a_602_392##2	C1#4	1.45965e-19
C149	a_517_392#	A2#1	3.52171e-17
C150	a_517_392##5	a_105_280#	3.9754e-19
C151	A1#5	A1#1	3.60524e-17
C152	VPWR#8	A2#1	4.47982e-17
C153	a_517_392#	A1#4	8.62068e-19
C154	VGND#7	X#2	5.6283e-18
C155	VPWR#8	A1#4	4.27975e-17
C156	A2#4	A1#5	3.24892e-17
C157	a_517_392#	A1#6	2.92101e-19
C158	a_517_392#	VPWR#2	3.11111e-18
C159	A1#4	a_517_392##6	1.82386e-17
C160	VPWR#8	A1#6	2.5728e-18
C161	VGND#14	VGND#7	8.55802e-20
C162	VPWR#3	VPWR#8	2.26826e-18
C163	a_517_392##5	C1#4	1.67316e-19
C164	A1#6	a_517_392##6	2.60042e-17
C165	X#4	a_105_280##6	2.73312e-17
C166	a_517_392##3	A1#4	2.268e-19
C167	B1#4	A2#4	1.1506e-17
C168	X#4	a_105_280##13	7.33269e-18
C169	A1#6	VPWR#9	3.04499e-17
C170	a_517_392##6	A2#5	5.01651e-19
C171	VPWR#3	a_517_392##6	6.08047e-17
C172	a_517_392##3	A1#6	8.99613e-19
C173	A2#5	VPWR#9	3.04499e-17
C174	VPWR#6	a_105_280##6	7.98794e-20
C175	C1#1	B1#4	2.80705e-17
C176	X#4	a_105_280##7	9.69369e-18
C177	a_517_392##6	B1#6	1.30372e-19
C178	a_517_392##6	VPWR#2	6.81242e-18
C179	a_517_392##3	A2#5	3.39933e-17
C180	VPWR#6	VPWR#5	7.0017e-19
C181	X#4	a_105_280##4	3.072e-19
C182	VPWR#3	VPWR#9	8.05282e-18
C183	VPWR#3	A1#3	2.71347e-20
C184	a_602_392#	A2#5	6.73299e-19
C185	VPWR#2	A1#3	1.81876e-20
C186	a_517_392##3	B1#6	4.46979e-17
C187	C1#5	C1#1	2.71799e-17
C188	a_602_392#	B1#6	3.22789e-17
C189	a_517_392##3	C1#6	1.80239e-17
C190	a_105_280##21	B1#6	9.72532e-19
C191	a_517_392##3	VPWR#3	6.04359e-17
C192	a_517_392##5	A2#5	8.9626e-20
C193	a_602_392#	C1#6	3.96984e-17
C194	B1#1	C1#5	3.49301e-17
C195	VGND#3	A1#3	7.23695e-20
C196	VPWR#6	a_105_280##4	3.89911e-20
C197	a_517_392##3	C1#7	7.26731e-19
C198	a_1064_123#	A1#2	8.75762e-20
C199	a_105_280##21	C1#6	2.86958e-17
C200	a_517_392##5	B1#6	1.32643e-19
C201	VPWR#2	A1#2	3.9602e-21
C202	a_517_392##2	A1#3	4.13224e-18
C203	a_1064_123#	VGND#1	5.61581e-17
C204	VPWR#10	B1#6	3.76815e-19
C205	a_602_392#	VPWR#3	9.89494e-18
C206	VPWR#3	B1#5	5.46939e-20
C207	VGND#4	A2#3	3.52037e-19
C208	a_105_280#	B1#1	3.27206e-17
C209	a_517_392##3	B1#3	4.72976e-19
C210	a_105_280##21	C1#7	3.34211e-17
C211	a_517_392##5	C1#6	2.20237e-19
C212	VGND#3	A2#3	6.72381e-17
C213	a_602_392##2	C1#7	4.41256e-17
C214	B1	A1#2	7.35696e-20
C215	VGND#2	a_1064_123#	8.75421e-18
C216	VPWR#10	C1#6	3.54309e-19
C217	B1	C1#4	1.64413e-17
C218	a_105_280##21	B1#3	1.49085e-17
C219	a_517_392##5	C1#7	1.37173e-17
C220	a_517_392##2	A2#3	1.58617e-19
C221	a_517_392##2	a_517_392#	2.65331e-18
C222	X#6	a_105_280##6	1.61112e-18
C223	a_105_280##8	a_105_280#	3.95031e-17
C224	VGND#2	a_1064_123##2	3.05826e-18
C225	B1#3	a_602_392##2	2.54489e-17
C226	VPWR#10	C1#7	9.48497e-19
C227	VGND#3	B1#5	6.16638e-20
C228	VPWR#5	a_105_280##4	2.54742e-20
C229	a_517_392##5	B1#3	3.37762e-17
C230	a_105_280##14	A1#2	1.15412e-18
C231	a_1064_123#	a_105_280##14	3.87131e-17
C232	a_602_392##2	a_105_280##9	1.03048e-18
C233	VPWR#10	B1#3	5.00357e-18
C234	a_517_392##2	VPWR#8	2.70649e-17
C235	a_105_280##10	a_105_280##8	3.73726e-17
C236	a_517_392##5	a_105_280##9	2.82725e-18
C237	X#6	B1#3	9.05422e-19
C238	X#6	a_105_280##4	3.35353e-18
C239	VPWR#3	VPWR#2	1.25446e-18
C240	a_105_280##9	VPWR#10	3.66676e-17
C241	VPWR#11	B1#3	6.46577e-20
C242	A1	A1#2	1.85866e-17
C243	a_517_392##5	VPWR#5	6.35932e-18
C244	X#6	a_105_280##9	7.25983e-17
C245	a_105_280##12	a_105_280##10	3.85275e-17
C246	a_517_392##2	a_517_392##6	1.91927e-18
C247	VPWR#11	a_105_280##6	6.54581e-19
C248	a_517_392#	VPWR#1	2.80683e-17
C249	VPWR#10	a_105_280##11	6.54315e-19
C250	VPWR#11	a_105_280##9	6.46452e-19
C251	a_1064_123#	A1#3	3.50032e-20
C252	a_105_280##2	VPWR#5	2.29919e-18
C253	a_105_280##14	a_1064_123##2	4.21699e-17
C254	VGND#10	a_1064_123#	1.31387e-18
C255	a_105_280##14	A1#3	3.01254e-18
C256	X#6	a_105_280##11	7.45263e-17
C257	a_1064_123##2	A1#3	3.78606e-19
C258	VPWR#10	a_105_280##13	1.53981e-19
C259	a_105_280##11	VPWR#11	2.03739e-17
C260	VGND#5	a_105_280##17	8.97492e-18
C261	A2#3	VGND#1	4.44937e-18
C262	VGND#2	a_517_392#	3.16185e-18
C263	VGND#7	a_105_280##2	8.10524e-20
C264	a_517_392##2	VPWR#9	4.40236e-18
C265	a_1064_123#	A2#3	1.34915e-18
C266	X#6	a_105_280##13	2.5049e-18
C267	X#5	a_105_280##11	6.47074e-19
C268	VGND#6	a_105_280##2	5.46889e-19
C269	VPWR#11	a_105_280##4	7.3924e-20
C270	A2#3	a_105_280##14	4.23887e-18
C271	VPWR#11	a_105_280##13	4.77976e-17
C272	X#6	VPWR#6	8.72556e-18
C273	A2#3	a_1064_123##2	1.56511e-17
C274	X#6	a_105_280##7	3.41477e-19
C275	a_105_280##13	X#5	1.80649e-17
C276	VGND#10	A2#3	1.99901e-17
C277	C1	C1#4	2.24986e-17
C278	VPWR#11	a_105_280##7	2.41886e-18
C279	X#6	VPWR#5	8.44968e-18
C280	VPWR#7	a_105_280##13	1.16752e-18
C281	VGND#10	a_1064_123##2	7.66978e-18
C282	a_105_280##15	a_105_280##14	1.46151e-18
C283	VGND#11	A2#3	9.82508e-19
C284	X#5	a_105_280##7	5.15506e-17
C285	VGND#10	B1#5	3.83101e-19
C286	A1#4	A2#1	4.21281e-17
C287	VPWR#7	a_105_280##7	3.23445e-17
C288	a_105_280##15	B1#5	3.66804e-18
C289	a_602_392#	VPWR#4	2.27149e-17
C290	X#4	B1#2	5.31314e-20
C291	a_602_392##2	VPWR#4	3.2805e-17
C292	A1#6	A1#4	4.34151e-17
C293	a_517_392##5	VPWR#4	3.27087e-18
C294	X#5	VPWR#6	1.37017e-17
C295	a_105_280##15	VGND#10	7.00104e-17
C296	X#4	a_105_280##2	2.8303e-18
C297	A2#5	A1#6	1.03064e-17
C298	A1#2	A2#2	1.42932e-17
C299	VGND#11	VGND#10	7.29939e-18
C300	VGND#2	A2#2	2.14647e-17
C301	a_105_280##17	B1#2	3.23953e-17
C302	VPWR#7	VPWR#6	9.47412e-19
C303	VGND#2	A1#1	3.08991e-18
C304	VGND#12	B1#2	7.20104e-19
C305	B1#6	A2#5	4.26913e-17
C306	VGND#14	X#4	2.08354e-17
C307	a_105_280##6	a_105_280##11	2.59382e-18
C308	VGND#2	A1#5	1.83444e-18
C309	B1#5	a_517_392##3	1.82832e-18
C310	a_105_280##15	VGND#11	2.85359e-17
C311	B1#5	a_602_392#	4.9856e-19
C312	a_105_280##15	C1#4	4.65128e-18
C313	C1#6	B1#6	3.82913e-17
C314	VGND#12	a_105_280##2	3.87352e-17
C315	VGND#7	VGND#6	1.35733e-18
C316	a_105_280##2	X#1	4.54268e-17
C317	X	a_105_280##6	1.33495e-17
C318	a_105_280##2	VGND#13	6.62307e-19
C319	a_105_280##17	a_105_280##15	5.95933e-18
C320	X	a_105_280##4	1.63064e-17
C321	X#2	a_105_280##2	4.24512e-18
C322	VGND#7	a_105_280##4	3.16186e-20
C323	C1#7	C1#6	4.65058e-17
C324	A2#3	A2#2	1.97268e-18
C325	a_105_280##17	VGND#11	3.75792e-17
C326	A2#4	A1#3	1.385e-17
C327	B1#2	a_105_280##21	5.59871e-17
C328	A2#3	A1#1	8.92468e-18
C329	B1#3	C1#7	3.48011e-17
C330	VGND#5	C1#5	2.39993e-18
C331	B1#2	a_602_392##2	4.70453e-19
C332	A2#3	A1#5	2.57797e-17
C333	VGND#1	a_517_392#	1.2488e-17
C334	a_517_392##5	B1#2	5.94092e-19
C335	A2#3	A2#4	1.07284e-18
C336	VPWR#10	B1#2	2.06638e-20
C337	C1#4	VGND#11	2.81216e-18
C338	VGND#12	VGND#11	5.09843e-18
C339	B1#4	A2#3	3.19703e-18
C340	X#6	B1#2	1.10327e-18
C341	a_105_280##9	B1#3	6.65394e-18
C342	VGND#6	VGND#4	1.16072e-18
C343	C1#1	A2#3	1.02268e-18
C344	a_105_280##2	a_517_392##5	3.18613e-17
C345	B1#5	A2#4	1.27929e-17
C346	B1	a_517_392##2	1.46821e-18
C347	a_517_392##2	VPWR#3	4.19581e-17
C348	C1#5	A2#3	4.56168e-19
C349	a_105_280##2	VPWR#10	6.55196e-17
C350	X#6	a_105_280##2	6.52592e-18
C351	VGND#12	a_105_280##17	4.69279e-17
C352	a_105_280##11	a_105_280##9	4.79328e-17
C353	A1	a_517_392##2	8.20714e-17
C354	a_105_280##7	a_105_280##6	9.87372e-18
C355	a_105_280##13	a_105_280##11	4.71498e-17
C356	a_517_392##2	VPWR#2	1.6661e-19
C357	a_105_280##17	C1#4	4.30334e-18
C358	VPWR#4	C1#6	5.24068e-18
C359	a_105_280##7	a_105_280##13	4.71255e-17
C360	VGND	C1#4	7.37823e-20
C361	VPWR#4	C1#7	5.25323e-18
C362	A2#5	A1#3	5.23821e-18
C363	VGND#4	VGND#3	1.4711e-18
C364	X#1	VGND#12	3.73094e-17
C365	a_105_280#	B1#2	5.46799e-18
C366	a_105_280##15	B1	4.7377e-17
C367	VGND	a_105_280##6	3.82797e-18
C368	VGND	a_105_280##4	8.5219e-19
C369	VPWR#4	B1#3	5.98965e-18
C370	VPWR#3	A2#4	1.88209e-18
C371	a_1064_123#	A1	3.34616e-18
C372	a_105_280##2	a_105_280#	1.21344e-17
C373	a_105_280##14	A1	9.51817e-17
C374	a_105_280##2	a_105_280##8	2.69364e-18
C375	B1#5	A2#5	2.20585e-17
C376	VGND#13	VGND#12	8.47883e-18
C377	X#2	a_105_280##17	9.71043e-19
C378	a_105_280##15	A1	1.21341e-17
C379	a_105_280##2	a_105_280##10	5.84738e-19
C380	C1#6	B1#5	6.23304e-18
C381	B1	a_517_392##3	4.96545e-17
C382	B1	a_602_392#	6.59576e-18
C383	VGND#13	X#1	1.33659e-17
C384	B1	a_105_280##21	3.5822e-17
C385	a_105_280##15	C1	2.60712e-17
C386	a_105_280##17	C1	2.76577e-17
C387	A1	a_517_392##6	2.67147e-18
C388	A1#2	VNB	2.42724e-17
C389	C1#4	VNB	5.4122e-17
C390	A1	a_517_392##3	1.24989e-17
C391	a_105_280##6	VNB	5.79233e-17
C392	A2	VGND#1	6.53276e-19
C393	a_105_280##2	B1#6	2.72741e-20
C394	B1#2	C1#7	1.17194e-17
C395	a_517_392##2	A2#2	2.73163e-19
C396	a_105_280##4	VNB	2.61544e-17
C397	A2	a_1064_123#	3.09807e-18
C398	A2	a_105_280##14	8.5971e-18
C399	a_105_280##2	C1#6	4.41728e-20
C400	B1#2	B1#3	2.38551e-18
C401	X#2	X#1	2.25262e-18
C402	A2	VGND#10	1.83931e-17
C403	a_105_280##2	C1#7	8.3657e-20
C404	A2	a_105_280##15	2.65065e-18
C405	VPWR	VPWR#6	7.92471e-17
C406	a_105_280##9	B1#2	1.74497e-18
C407	VGND#3	A1#5	1.72724e-18
C408	VPWR	VPWR#5	7.31637e-17
C409	VGND#2	A1#3	1.5492e-19
C410	VPWR	VPWR#3	1.44982e-16
C411	a_105_280##2	B1#3	1.05229e-18
C412	VPWR	VPWR#2	4.99707e-17
C413	X	X#4	1.28571e-17
C414	B1	A2#4	2.17954e-18
C415	a_105_280##2	a_105_280##9	2.0661e-18
C416	A2#3	VGND#2	1.29075e-17
C417	A1	A2#2	3.38063e-18
C418	X#2	VGND#13	5.09788e-17
C419	VPWR	a_517_392##2	5.17658e-18
C420	C1#4	B1#4	5.05378e-18
C421	a_517_392##2	A1#2	3.58748e-19
C422	A1	A2#4	1.62661e-17
C423	a_105_280##2	a_105_280##7	2.74323e-20
C424	A2#3	A1#3	7.19886e-19
C425	VGND#3	A2#4	1.71259e-19
C426	X	X#2	3.52725e-19
C427	VPWR	X#4	1.0946e-18
C428	VGND#14	X	1.57542e-17
C429	C1	A1#5	1.53449e-19
C430	VPWR#4	B1#2	3.11803e-20
C431	VGND#14	VGND#13	2.30966e-18
C432	VGND	VGND#7	5.1684e-17
C433	VGND	VGND#6	5.02601e-17
C434	C1	A2#4	1.02459e-18
C435	VGND	VGND#4	5.97675e-17
C436	B1	A2#1	3.44254e-19
C437	VGND	VGND#3	1.18251e-16
C438	C1	B1#4	6.94697e-19
C439	B1	A1#4	2.28319e-19
C440	C1	C1#1	1.67543e-18
C441	B1	A1#6	6.41725e-19
C442	A2	A2#2	2.41717e-19
C443	a_105_280##15	a_517_392##3	9.61417e-18
C444	C1	B1#1	2.69661e-19
C445	A2	A1#1	4.12862e-19
C446	B1	A2#5	5.54222e-18
C447	C1	a_105_280#	3.19428e-19
C448	A2	A1#5	8.8175e-19
C449	A1	A2#1	3.57581e-18
C450	VGND#2	A1#2	1.13784e-19
C451	B1	B1#6	5.25835e-18
C452	A2	A2#4	6.64883e-18
C453	X	X#6	2.98058e-17
C454	B1	C1#6	1.12021e-17
C455	A2	B1#4	6.00764e-19
C456	VPWR	a_517_392#	5.55723e-18
C457	VGND#14	X#2	5.97193e-17
C458	VGND	X#4	6.65129e-18
C459	VPWR	VPWR#8	2.19908e-17
C460	B1	C1#7	3.03284e-19
C461	VGND#3	B1#4	7.56483e-19
C462	VPWR	a_517_392##6	1.45864e-17
C463	A1	A2#5	6.97716e-18
C464	B1	B1#3	1.20847e-19
C465	VGND	a_1064_123#	1.55209e-17
C466	VPWR#6	VNB	3.25641e-17
C467	VPWR	a_517_392##3	9.39906e-18
C468	VGND	a_105_280##14	6.8836e-18
C469	VPWR#5	VNB	3.40567e-17
C470	VPWR#3	VNB	5.26427e-17
C471	VGND	a_1064_123##2	1.21025e-17
C472	VPWR	a_602_392#	1.92305e-17
C473	B1	a_105_280##9	3.58334e-20
C474	VPWR#2	VNB	2.55322e-17
C475	VPWR	a_105_280##21	4.84873e-18
C476	VGND	a_105_280##15	1.95297e-17
C477	VGND#7	VNB	2.69298e-17
C478	VPWR	a_602_392##2	1.90109e-17
C479	VGND#6	VNB	2.52872e-17
C480	VGND#4	VNB	2.23966e-17
C481	VPWR	a_517_392##5	1.89196e-17
C482	VGND	a_105_280##17	1.71506e-17
C483	VGND#3	VNB	4.98245e-17
C484	VGND	VGND#12	2.19083e-17
C485	VGND	X#1	9.72876e-18
C486	VPWR	X#6	1.90826e-17
C487	a_517_392##2	VNB	2.43944e-18
C488	VGND	VGND#13	1.57619e-17
C489	a_105_280##2	B1#2	7.47727e-17
C490	VGND#4	C1#1	2.10171e-18
C491	a_517_392##2	A2#4	2.06001e-18
C492	VGND	X#2	1.65616e-17
C493	C1#4	C1#1	7.66073e-19
C494	VPWR	X#5	1.48151e-17
C495	VGND	VGND#14	2.21607e-17
C496	VGND	a_517_392#	6.25396e-19
C497	VPWR	VPWR#7	5.97132e-17
C498	X	a_105_280##8	3.50328e-19
C499	X	a_105_280##10	1.84208e-18
C500	VPWR#5	a_105_280#	2.2513e-19
C501	X#4	VNB	2.51005e-17
C502	X	a_105_280##12	7.80005e-18
C503	VGND#1	VNB	4.82614e-17
C504	a_1064_123#	VNB	8.16821e-18
C505	a_105_280##14	VNB	1.35976e-18
C506	VGND	VPWR#10	2.75474e-18
C507	VGND#10	VNB	4.38518e-18
C508	X#4	VPWR#11	1.19326e-17
C509	VGND	X#6	4.57778e-18
C510	a_105_280##15	VNB	6.47064e-18
C511	VGND#11	VNB	3.33346e-18
C512	VPWR	a_105_280#	2.19519e-19
C513	a_105_280##17	VNB	3.52188e-18
C514	VGND#12	VNB	2.75913e-18
C515	B1	A1#3	1.09431e-18
C516	VGND	VPWR#7	9.77861e-18
C517	VGND	A2#2	8.473e-18
C518	X#2	VNB	3.64594e-18
C519	VGND	A1#1	5.24759e-18
C520	VGND#14	VNB	3.42283e-17
C521	VGND	A1#5	5.07596e-18
C522	a_517_392#	VNB	5.27925e-17
C523	VPWR#8	VNB	2.47961e-18
C524	VGND	A2#4	1.70292e-19
C525	VPWR	A2#1	1.76407e-18
C526	B1	B1#5	2.08873e-17
C527	a_517_392##6	VNB	4.88768e-18
C528	A1	A1#3	2.02541e-17
C529	VGND	B1#4	4.21313e-18
C530	VPWR	A1#4	5.25648e-19
C531	VGND	C1#1	8.80556e-18
C532	a_602_392#	VNB	3.27217e-18
C533	VGND	C1#5	5.02595e-18
C534	VPWR	A1#6	8.88737e-19
C535	A1	A2#3	8.23319e-19
C536	VGND	B1#1	9.03827e-18
C537	VPWR	A2#5	6.948e-19
C538	a_602_392##2	VNB	3.62309e-18
C539	VGND	a_105_280#	3.96635e-19
C540	a_517_392##5	VNB	5.66633e-18
C541	A1	B1#5	3.16596e-18
C542	VPWR	B1#6	1.61232e-18
C543	B1#2	B1	2.41486e-18
C544	VPWR#10	VNB	3.09571e-18
C545	VGND	a_105_280##8	4.40496e-19
C546	C1	A1#3	7.72536e-20
C547	X#6	VNB	3.55135e-18
C548	VPWR	C1#6	7.48236e-19
C549	VGND	a_105_280##10	4.60215e-19
C550	VPWR#11	VNB	4.09278e-19
C551	VGND	a_105_280##12	7.35783e-19
C552	VPWR	C1#7	7.98753e-19
C553	a_105_280##2	B1	3.27303e-19
C554	X#5	VNB	2.30788e-18
C555	VPWR#7	VNB	9.33923e-17
C556	VPWR	B1#3	6.50462e-19
C557	A2#2	VNB	8.60147e-17
C558	C1	B1#5	3.79546e-19
C559	A1#1	VNB	2.02146e-17
C560	VPWR	a_105_280##9	3.72108e-18
C561	A1#5	VNB	1.97055e-17
C562	VPWR	a_105_280##11	8.965e-19
C563	A2#4	VNB	4.88881e-17
C564	B1#4	VNB	2.84737e-17
C565	X#4	X#5	6.25736e-20
C566	VPWR	a_105_280##13	8.67582e-19
C567	C1#1	VNB	2.98546e-17
C568	B1#2	C1	1.76139e-17
C569	C1#5	VNB	2.94428e-17
C570	VPWR	a_105_280##7	5.0886e-18
C571	VPWR#4	C1#4	9.00861e-20
C572	B1#1	VNB	3.25147e-17
C573	VGND#3	C1#5	2.94336e-19
C574	a_105_280#	VNB	4.33093e-17
C575	a_105_280##2	C1	2.41965e-18
C576	a_105_280##8	VNB	2.09818e-17
C577	VGND#6	B1#1	4.8168e-18
C578	a_105_280##10	VNB	2.2575e-17
C579	a_105_280##12	VNB	3.55577e-17
C580	VPWR	VPWR#4	7.95808e-17
C581	A2#1	VNB	5.39349e-17
C582	A1#4	VNB	2.60775e-17
C583	A1#6	VNB	2.73697e-17
C584	A2#5	VNB	4.5865e-17
C585	B1#6	VNB	2.92961e-17
C586	C1#6	VNB	3.38359e-17
C587	C1#7	VNB	3.42294e-17
C588	VGND	VGND#2	6.74722e-17
C589	X	a_105_280##2	3.39273e-17
C590	B1#3	VNB	3.53e-17
C591	a_105_280##9	VNB	4.16834e-17
C592	B1	A1	1.58611e-17
C593	VGND	VGND#5	2.11438e-17
C594	a_105_280##11	VNB	3.3811e-17
C595	VPWR	B1#2	3.64545e-18
C596	a_105_280##13	VNB	2.80783e-17
C597	a_105_280##7	VNB	5.6762e-17
C598	VGND	A2#3	3.24754e-17
C599	VPWR	a_105_280##2	1.16364e-17
C600	C1	B1	3.05093e-17
C601	VPWR#1	VNB	9.98133e-17
C602	VGND#2	VNB	1.27649e-16
C603	C1	A1	1.7895e-18
C604	VPWR#4	VNB	4.31016e-17
C605	VGND	B1#2	3.15587e-18
C606	VGND#5	VNB	1.17816e-17
C607	VGND	a_105_280##2	8.7243e-18
C608	A1#3	VNB	3.46057e-17
C609	VPWR#7	X#4	1.23986e-17
C610	a_517_392#	VPWR#8	6.64487e-17
C611	A2#3	VNB	8.28015e-17
C612	B1#5	VNB	3.32459e-17
C613	B1#2	VNB	3.78244e-17
C614	VPWR	B1	6.64428e-18
C615	a_105_280##2	VNB	5.98436e-17
C616	VPWR	A1	5.93496e-18
C617	VGND	B1	5.64033e-18
C618	VPWR	C1	2.43549e-18
C619	VGND	A1	6.1934e-18
C620	VGND	C1	2.68308e-18
C621	B1	VNB	5.6886e-18
C622	VPWR	X	5.54008e-18
C623	VGND#6	a_105_280#	3.77494e-18
C624	A1	VNB	8.85063e-18
C625	C1	VNB	1.88781e-18
C626	VGND	X	1.26667e-18
C627	A2	VNB	1.16357e-18
C628	VPWR	VNB	3.00318e-16
C629	VGND	VNB	2.93109e-16
C630	VGND#8	a_105_280##6	5.34945e-19
C631	a_517_392##4	A2#5	4.2666e-18
C632	VGND#8	VNB	5.91736e-17
C633	VGND#8	a_105_280##12	1.26626e-18
C634	a_517_392##4	VPWR#3	3.622e-17
C635	VGND#8	X	2.06445e-19
C636	VGND#8	a_105_280##4	2.56151e-20
C637	a_602_392#	a_517_392##4	1.63189e-17
C638	VGND#8	X#4	1.28124e-18
C639	VGND#8	X#2	5.25547e-18
C640	a_517_392##4	VNB	4.98943e-18
C641	VGND	VGND#8	9.21504e-17
C642	a_517_392##4	a_517_392##3	5.4064e-18
C643	VGND#8	VGND#7	1.35859e-18
C644	VPWR	a_517_392##4	1.36674e-17
C645	a_517_392##4	B1#6	3.89931e-18
*
*
.ENDS sky130_fd_sc_hs__a211o_4
*
