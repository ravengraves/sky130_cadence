* Extracted by Quantus, converted by sky130cad/quantus.py
*
*
*
*                       LINUX           Wed Nov 18 08:38:13 2026
*
*
*
*  PROGRAM  advgen
*
*  Name           : advgen - Quantus - (64-bit)
*  Version        : 25.1.0-p047
*  Build Date     : Thu Dec 11 23:20:30 PST 2025
*
*  HSPICE LIBRARY
*
*  OPERATING_TEMPERATURE 150
*  QRC_TECH_DIR <path>/tech
*
*
*

*
.SUBCKT sky130_fd_sc_hs__fa_1 VPB VNB VGND CIN VPWR SUM COUT A B
*
*
*  caps2d version: 10
*
*
*       TRANSISTOR CARDS
*
*
XM27 SUM#2 a_69_260##3 VGND#13 VNB sky130_fd_pr__nfet_01v8_lvt l=0.15 w=0.74 ad=0.2109 as=0.38315 pd=2.05 ps=2.79
XM12 VGND#13 A#1 a_237_75# VNB sky130_fd_pr__nfet_01v8_lvt l=0.15 w=0.64 ad=0.38315 as=0.1536 pd=2.79 ps=1.76
XM6 a_237_75# B#11 a_315_75# VNB sky130_fd_pr__nfet_01v8_lvt l=0.15 w=0.64 ad=0.1536 as=0.1536 pd=1.76 ps=1.76
XM4 a_315_75# CIN#3 a_69_260##6 VNB sky130_fd_pr__nfet_01v8_lvt l=0.15 w=0.64 ad=0.1536 as=0.2496 pd=1.76 ps=2.06
XM7 a_69_260##6 a_465_249##3 a_501_75##2 VNB sky130_fd_pr__nfet_01v8_lvt l=0.15 w=0.64 ad=0.2496 as=0.2304 pd=2.06 ps=2
XM20 a_501_75##2 B#9 VGND#12 VNB sky130_fd_pr__nfet_01v8_lvt l=0.15 w=0.64 ad=0.2304 as=0.33815 pd=2 ps=2.55
XM25 VGND#12 A#6 a_501_75# VNB sky130_fd_pr__nfet_01v8_lvt l=0.15 w=0.64 ad=0.33815 as=0.1792 pd=2.55 ps=1.84
XM22 a_501_75# CIN#6 VGND#9 VNB sky130_fd_pr__nfet_01v8_lvt l=0.15 w=0.64 ad=0.1792 as=0.3168 pd=1.84 ps=2.27
XM3 VGND#9 A#7 a_936_75# VNB sky130_fd_pr__nfet_01v8_lvt l=0.15 w=0.64 ad=0.3168 as=0.1536 pd=2.27 ps=1.76
XM21 a_936_75# B#6 a_465_249##12 VNB sky130_fd_pr__nfet_01v8_lvt l=0.15 w=0.64 ad=0.1536 as=0.1792 pd=1.76 ps=1.84
XM10 a_465_249##12 CIN#9 a_1100_75##2 VNB sky130_fd_pr__nfet_01v8_lvt l=0.15 w=0.64 ad=0.1792 as=0.7192 pd=1.84 ps=3.46
XM18 a_1100_75##2 A#10 VGND#8 VNB sky130_fd_pr__nfet_01v8_lvt l=0.15 w=0.64 ad=0.7192 as=0.42455 pd=3.46 ps=2.82
XM8 VGND#8 B#1 a_1100_75# VNB sky130_fd_pr__nfet_01v8_lvt l=0.15 w=0.64 ad=0.42455 as=0.1696 pd=2.82 ps=1.81
XM0 VGND#7 a_465_249##4 COUT#3 VNB sky130_fd_pr__nfet_01v8_lvt l=0.15 w=0.74 ad=0.1961 as=0.1998 pd=2.01 ps=2.02
XM9 SUM#1 a_69_260# VPWR#11 VPB sky130_fd_pr__pfet_01v8 l=0.15 w=1.12 ad=0.3192 as=0.398 pd=2.81 ps=2.97
XM2 VPWR#11 A#3 a_217_368# VPB sky130_fd_pr__pfet_01v8 l=0.15 w=1 ad=0.398 as=0.373375 pd=2.97 ps=2.92
XM1 a_217_368# B#10 a_318_389# VPB sky130_fd_pr__pfet_01v8 l=0.15 w=1 ad=0.373375 as=0.39175 pd=2.92 ps=3.13
XM5 a_318_389# CIN#1 a_69_260##4 VPB sky130_fd_pr__pfet_01v8 l=0.15 w=1 ad=0.39175 as=0.3 pd=3.13 ps=2.6
XM19 a_69_260##4 a_465_249# a_509_347##2 VPB sky130_fd_pr__pfet_01v8 l=0.15 w=1 ad=0.3 as=0.335 pd=2.6 ps=2.67
XM11 a_509_347##2 B#8 VPWR#9 VPB sky130_fd_pr__pfet_01v8 l=0.15 w=1 ad=0.335 as=0.487275 pd=2.67 ps=3.28
XM13 VPWR#9 A#4 a_509_347# VPB sky130_fd_pr__pfet_01v8 l=0.15 w=1 ad=0.487275 as=0.355 pd=3.28 ps=2.71
XM14 a_509_347# CIN#4 VPWR#7 VPB sky130_fd_pr__pfet_01v8 l=0.15 w=1 ad=0.355 as=0.31 pd=2.71 ps=2.62
XM23 VPWR#7 A#9 a_916_347# VPB sky130_fd_pr__pfet_01v8 l=0.15 w=1 ad=0.31 as=0.355 pd=2.62 ps=2.71
XM24 a_916_347# B#5 a_465_249##13 VPB sky130_fd_pr__pfet_01v8 l=0.15 w=1 ad=0.355 as=0.3 pd=2.71 ps=2.6
XM26 a_465_249##13 CIN#7 a_1107_347##2 VPB sky130_fd_pr__pfet_01v8 l=0.15 w=1 ad=0.3 as=0.445 pd=2.6 ps=2.89
XM15 a_1107_347##2 A#12 VPWR#5 VPB sky130_fd_pr__pfet_01v8 l=0.15 w=1 ad=0.445 as=0.698125 pd=2.89 ps=3.52
XM17 VPWR#5 B#3 a_1107_347# VPB sky130_fd_pr__pfet_01v8 l=0.15 w=1 ad=0.698125 as=0.335 pd=3.52 ps=2.67
XM16 VPWR#3 a_465_249##7 COUT#1 VPB sky130_fd_pr__pfet_01v8 l=0.15 w=1.12 ad=0.3304 as=0.3192 pd=2.83 ps=2.81
*
*
*       RESISTOR AND CAP/DIODE CARDS
*
Rg1	a_69_260#	a_69_260##2	456.846832
Rg2	a_69_260##2	a_69_260##3	353.846649
Rg3	A#1	A#2	371.290009
Rg4	A#2	A#3	469.301178
Rg5	CIN#1	CIN#2	415.953644
Rg6	CIN#2	CIN#3	371.792084
Rg7	a_465_249#	a_465_249##2	400.207520
Rg8	a_465_249##2	a_465_249##3	348.108032
Rg9	A#4	A#5	453.277618
Rg10	A#5	A#6	279.244598
Rg11	CIN#4	CIN#5	411.880859
Rg12	CIN#5	CIN#6	431.313812
Rg13	A#7	A#8	316.773132
Rg14	A#8	A#9	464.950958
Rg15	CIN#7	CIN#8	400.207520
Rg16	CIN#8	CIN#9	348.108032
Rg17	A#10	A#11	448.327240
Rg18	A#11	A#12	408.014282
Rg19	B#1	B#2	410.641907
Rg20	B#2	B#3	437.261749
Rg21	B#3	B#4	1451.789429
Rg22	B#4	B#5	450.339508
Rg23	B#5	B#6	809.539124
Rg24	B#4	B#7	1135.399658
Rg25	B#7	B#8	450.339508
Rg26	B#8	B#9	809.539124
Rg27	B#7	B#10	1137.663208
Rg28	B#10	B#11	986.983093
Rg29	a_465_249##4	a_465_249##5	322.953644
Rg30	a_465_249##5	a_465_249##6	35.518757
Rg31	a_465_249##5	a_465_249##7	507.075531
Rf1	SUM	SUM#1	95.961670
Rf2	SUM	SUM#3	8.509030
Rf3	SUM#3	SUM	8.509030
Rf4	SUM#2	SUM#3	7.500000
Rf5	CIN#2	CIN#11	179.366638
Rf6	a_69_260##4	a_69_260##5	149.226059
Rf7	a_69_260##5	a_69_260##6	167.974884
Rf8	a_501_75#	a_501_75##2	97.856285
Rf9	a_509_347#	a_509_347##2	84.026688
Rf10	CIN#5	CIN#13	161.186752
Rf11	CIN#14	CIN	10.731724
Rf12	CIN#13	CIN#14	9.364013
Rf13	CIN#8	CIN#17	186.726074
Rf14	A#11	A#14	282.666168
Rf15	A#14	A#15	78.506798
Rf16	A#15	A#2	348.219055
Rf17	A#14	A#17	7.894152
Rf18	A#17	A	0.196836
Rf19	A#15	A#5	168.126953
Rf20	a_1107_347#	a_1107_347##2	118.669548
Rf21	B#12	B#2	82.622246
Rf22	B	B#14	2.505846
Rf23	B#12	B#14	3.579155
Rf24	a_1100_75#	a_1100_75##2	142.923798
Rf25	a_465_249##6	a_465_249##9	268.947632
Rf26	a_465_249##9	a_465_249##10	130.299728
Rf27	a_465_249##10	a_465_249##2	371.854767
Rf28	a_465_249##9	a_465_249##12	119.815987
Rf29	a_465_249##10	a_465_249##13	16.685177
Rf30	COUT	COUT#2	0.251111
Rf31	COUT#2	COUT	18.331110
Rf32	COUT	COUT#4	7.282945
Rf33	COUT#4	COUT	7.282945
Rf34	COUT#1	COUT#2	5.000000
Rf35	COUT#3	COUT#4	7.500000
Rf37	VPWR#2	VPWR#3	41.783939
Rf38	VPWR#2	VPWR#4	88.263428
Rf39	VPWR#4	VPWR#5	19.713268
Rf40	VPWR#4	VPWR#6	160.924133
Rf41	VPWR#6	VPWR#7	45.530331
Rf42	VPWR#6	VPWR#8	66.451416
Rf43	VPWR#8	VPWR#9	36.233871
Rf44	VPWR#8	VPWR#10	194.874176
Rf45	VPWR#10	VPWR#11	35.333496
Rf48	VGND#2	VGND#3	16.469177
Rf49	VGND#3	VGND#4	52.994427
Rf50	VGND#4	VGND#5	192.638275
Rf51	VGND#5	VGND#6	69.880638
Rf52	VGND#2	VGND#7	41.631927
Rf53	VGND#4	VGND#8	26.283115
Rf54	VGND#5	VGND#9	27.786339
Rf55	VGND#6	VGND#10	188.907089
Rf57	VGND#6	VGND#12	27.966743
Rf58	VGND#10	VGND#13	23.832428
Rf65	A#8	A#17	160.232803
Rf60	a_69_260##2	a_69_260##5	160.232803
Re1	CIN#17	CIN	11.228309
Re3	CIN	CIN#11	13.698293
Re4	VPWR#2	VPWR	3.735117
Re5	VPWR	VPWR#8	1.067176
Re6	VGND#3	VGND	3.735117
Re7	VGND	VGND#6	1.067176
*
*       CAPACITOR CARDS
*
*
C1	VPWR#7	A#9	4.13093e-17
C2	VPWR#8	A#15	1.32461e-18
C3	VPWR#9	B#5	9.77908e-20
C4	B#14	a_465_249##6	4.41376e-19
C5	VGND#3	a_1100_75#	2.50286e-17
C6	VPWR#8	A#14	2.88857e-18
C7	B#9	A#6	1.66649e-17
C8	a_509_347#	A#9	3.73041e-19
C9	VPWR#7	B#4	6.78396e-19
C10	a_1100_75#	a_465_249##9	3.31165e-17
C11	a_465_249##9	B#6	3.37911e-19
C12	a_509_347##2	B#5	7.17901e-20
C13	VGND#3	VGND#8	1.41975e-17
C14	VPWR#7	CIN#4	3.8011e-17
C15	a_465_249##9	B#2	5.71163e-17
C16	VPWR#4	CIN#8	4.77868e-19
C17	VGND#3	a_1100_75##2	3.49664e-19
C18	VGND#6	A#15	1.28498e-17
C19	CIN#4	a_509_347#	2.23481e-17
C20	B#14	B#2	1.15134e-17
C21	a_509_347##2	A#9	6.97451e-20
C22	VPWR#8	CIN#14	1.62362e-18
C23	VGND#6	A#14	1.07626e-17
C24	VPWR#7	A#4	2.26427e-18
C25	a_465_249##3	B#9	2.61757e-17
C26	A#11	a_465_249##10	4.30846e-17
C27	a_465_249##9	VGND#8	7.91988e-19
C28	VPWR#9	CIN#4	1.29486e-18
C29	a_509_347#	B#7	6.46575e-18
C30	A#15	CIN#13	3.22364e-17
C31	a_465_249##9	A#7	2.04772e-19
C32	a_465_249##9	A#11	8.32619e-17
C33	a_509_347#	A#4	5.055e-17
C34	VPWR#6	A#8	5.05556e-19
C35	CIN#17	B#4	5.727e-20
C36	a_509_347##2	CIN#4	1.22905e-19
C37	VPWR#7	B#8	6.1683e-19
C38	CIN#17	a_465_249##12	5.83096e-19
C39	A#4	VPWR#9	2.1974e-17
C40	A#10	B#3	4.25307e-19
C41	a_509_347#	B#8	6.90065e-19
C42	A#14	CIN#13	3.61654e-17
C43	CIN#8	a_465_249##10	3.80379e-17
C44	CIN#3	a_465_249##3	2.29161e-17
C45	a_465_249##9	a_1100_75##2	8.87848e-17
C46	a_509_347##2	A#4	9.03451e-19
C47	a_465_249##9	CIN#8	3.52877e-20
C48	VGND#6	CIN#13	2.56438e-18
C49	B#8	VPWR#9	2.86847e-17
C50	VPWR#6	CIN#5	1.4835e-19
C51	a_69_260##4	A#4	2.04649e-19
C52	a_509_347#	a_465_249#	1.80261e-19
C53	a_509_347##2	B#8	3.0636e-17
C54	VPWR#9	B#7	1.55483e-17
C55	VPWR#9	a_465_249#	1.21142e-18
C56	a_465_249##10	A#8	1.12318e-18
C57	B#11	CIN#3	4.60269e-17
C58	a_69_260##4	B#8	2.2733e-18
C59	a_465_249#	a_509_347##2	2.63453e-17
C60	VPWR#9	B#4	2.64035e-19
C61	VPWR#9	CIN#1	7.93625e-19
C62	A#14	A#11	1.60226e-18
C63	a_69_260##4	a_465_249#	5.60967e-17
C64	A#1	B#11	4.58695e-17
C65	a_465_249##10	CIN#5	2.5695e-21
C66	A#14	CIN#9	5.30971e-18
C67	VPWR#9	B#10	7.42063e-19
C68	VPWR#11	B#8	4.94532e-19
C69	a_69_260##4	CIN#1	7.1772e-17
C70	a_509_347##2	B#7	3.83062e-18
C71	CIN#11	B#7	2.07622e-19
C72	CIN#11	VGND#12	3.67597e-18
C73	A#14	CIN#8	1.06045e-17
C74	a_465_249##6	VGND#7	2.39075e-17
C75	VGND#6	a_1100_75##2	4.31182e-17
C76	a_465_249##10	VPWR#6	8.76596e-18
C77	CIN#11	a_501_75##2	7.83219e-19
C78	VGND#3	VPWR#3	5.16811e-18
C79	a_465_249##6	a_1100_75#	3.58922e-17
C80	VPWR#9	A#3	7.56153e-19
C81	VPWR#11	a_465_249#	4.28602e-19
C82	VGND#6	a_465_249##12	2.0139e-17
C83	a_69_260##3	A#1	1.88876e-17
C84	a_69_260##4	B#10	3.9282e-17
C85	a_465_249##9	VGND#9	3.34341e-21
C86	A#14	B#6	2.17847e-17
C87	CIN#11	a_69_260##6	3.69976e-18
C88	A#15	A#8	5.04575e-19
C89	A#14	A#8	2.47317e-17
C90	VPWR#11	CIN#1	1.97348e-18
C91	a_69_260##4	A#3	1.44056e-18
C92	a_1100_75#	B#2	1.89367e-18
C93	VGND#6	a_501_75#	1.53803e-17
C94	a_465_249##10	VPWR#4	6.20419e-18
C95	VGND#8	B#2	1.0149e-18
C96	A#14	A#7	7.39637e-18
C97	VGND#6	VGND#12	1.1682e-16
C98	VPWR#11	B#10	6.56824e-18
C99	a_69_260##4	B#7	3.95458e-18
C100	VPWR#8	B#7	4.88285e-17
C101	A#15	CIN#5	4.85574e-18
C102	CIN#14	A#8	5.36371e-19
C103	a_69_260##4	a_69_260#	7.5721e-19
C104	VGND#6	a_501_75##2	2.07965e-17
C105	A#14	CIN#5	6.68163e-18
C106	A#15	CIN#6	8.57922e-18
C107	VPWR#8	B#4	1.61494e-17
C108	VGND#6	a_69_260##6	3.45042e-17
C109	a_465_249##4	COUT#3	7.35092e-18
C110	A#3	VPWR#11	2.69094e-17
C111	a_1107_347#	VPWR#3	4.18787e-17
C112	CIN#13	A#8	3.64734e-18
C113	CIN#17	a_465_249##13	1.41329e-18
C114	A#14	CIN#6	1.08309e-17
C115	A#11	a_1100_75##2	4.38686e-18
C116	SUM#1	A#3	7.57499e-19
C117	A#15	A#5	2.83075e-17
C118	CIN#14	CIN#5	5.7518e-18
C119	a_465_249##4	VGND#7	1.92123e-17
C120	VPWR#11	a_69_260#	5.75766e-17
C121	A#14	A#5	4.58123e-19
C122	a_465_249##12	A#11	4.28966e-17
C123	A#15	A#6	7.59027e-18
C124	VPWR#5	VPWR#3	3.76431e-18
C125	CIN#13	CIN#5	1.09992e-17
C126	SUM#1	a_69_260#	2.63146e-17
C127	B#3	a_465_249##7	4.91793e-18
C128	a_1100_75#	a_465_249##4	2.53724e-18
C129	a_1100_75##2	CIN#8	3.77664e-19
C130	VPWR#4	a_465_249##7	5.67685e-19
C131	VPWR#8	a_1107_347#	1.47145e-18
C132	CIN#14	A#5	5.27773e-19
C133	A#15	a_465_249##2	7.44226e-17
C134	VGND#7	B#1	2.64694e-18
C135	a_1107_347#	VPWR#5	6.10317e-17
C136	a_465_249##12	CIN#8	5.89583e-19
C137	B#4	B#3	1.27761e-19
C138	A#15	B#9	2.12147e-17
C139	VGND#8	a_465_249##4	2.08097e-18
C140	CIN#13	A#5	3.6146e-18
C141	VPWR#8	a_1107_347##2	1.53928e-17
C142	a_1100_75#	B#1	4.78266e-17
C143	A#12	B#3	1.3749e-17
C144	VGND#5	A#15	7.30146e-19
C145	a_1107_347##2	a_1107_347#	2.63628e-18
C146	a_465_249##2	CIN#14	9.83762e-18
C147	VPWR#4	B#3	4.2631e-17
C148	VGND#7	A#10	2.79225e-19
C149	A#15	CIN#2	4.28588e-19
C150	a_1100_75##2	a_465_249##4	3.26058e-20
C151	a_465_249##6	VPWR#3	3.93849e-17
C152	A#15	a_465_249##3	2.34802e-17
C153	B#1	VGND#8	2.00916e-17
C154	a_465_249##2	CIN#13	1.31643e-18
C155	A#8	VGND#9	2.94257e-18
C156	B#7	VGND#12	7.7345e-19
C157	a_1107_347##2	VPWR#5	5.31549e-17
C158	a_1100_75#	A#10	9.1162e-19
C159	CIN#7	A#12	2.39874e-17
C160	B#5	B#3	1.12383e-19
C161	CIN#11	a_509_347##2	7.75993e-18
C162	a_509_347#	VPWR#8	1.51319e-17
C163	VGND#3	a_465_249##4	5.55472e-18
C164	a_1100_75##2	B#1	1.69827e-18
C165	A#15	A#2	2.58423e-19
C166	VGND#5	A#14	3.63214e-18
C167	A#12	B#4	1.48126e-17
C168	VPWR#4	A#12	6.04564e-19
C169	CIN#11	a_69_260##4	6.12422e-17
C170	VPWR#4	VPWR#3	8.37735e-19
C171	VPWR#8	VPWR#9	2.01053e-17
C172	B#2	a_1107_347#	6.85315e-18
C173	A#10	VGND#8	2.28925e-17
C174	VGND#3	B#1	9.05601e-18
C175	VGND#9	CIN#5	7.53006e-19
C176	A#14	a_465_249##12	3.4438e-17
C177	a_509_347##2	VPWR#8	2.13847e-17
C178	B#5	CIN#7	4.57011e-17
C179	a_69_260##4	VPWR#8	3.08635e-17
C180	a_1100_75##2	A#10	4.22154e-17
C181	VGND#8	CIN#9	2.83028e-19
C182	VPWR#5	A#11	2.27474e-20
C183	VPWR#4	CIN#7	2.16236e-18
C184	a_1107_347#	VPWR#4	7.59815e-18
C185	A#15	B#11	7.99182e-20
C186	a_465_249##9	a_465_249##7	9.28656e-19
C187	A#15	B#7	1.74431e-19
C188	VPWR#11	B#7	2.19503e-19
C189	CIN#11	SUM#1	3.22119e-19
C190	a_465_249##12	A#10	8.155e-19
C191	a_501_75#	A#5	8.00917e-19
C192	VGND#6	a_69_260##4	1.40031e-18
C193	a_1107_347##2	A#11	7.78167e-21
C194	A#9	B#5	3.94978e-17
C195	VPWR#6	VPWR#5	8.08186e-19
C196	CIN#9	a_1100_75##2	2.66349e-17
C197	A#5	VGND#12	1.55493e-18
C198	VPWR#8	VPWR#11	2.22331e-17
C199	VPWR#7	VPWR#5	2.0739e-18
C200	CIN#7	B#4	1.86615e-17
C201	CIN#17	B#6	5.28681e-18
C202	a_465_249##10	B#3	2.32904e-19
C203	VGND#8	B#6	1.63693e-19
C204	VPWR#8	SUM#1	1.60562e-17
C205	B#14	a_465_249##7	5.08701e-19
C206	a_465_249##12	CIN#9	4.36902e-17
C207	a_465_249##10	a_916_347#	4.37381e-18
C208	a_465_249##9	B#3	6.23471e-18
C209	A#14	VGND#9	3.90974e-17
C210	CIN#4	A#9	4.04081e-17
C211	VGND#12	a_465_249##2	1.24798e-19
C212	A#15	a_501_75#	6.30576e-17
C213	a_1100_75##2	B#6	1.23417e-18
C214	VGND#9	A#10	3.01528e-19
C215	VGND#6	SUM#1	1.00664e-18
C216	a_501_75##2	a_465_249##2	6.95392e-19
C217	B#8	B#5	3.30659e-20
C218	a_465_249##10	A#12	2.00808e-17
C219	VPWR#6	A#9	2.10269e-18
C220	a_465_249##12	B#6	2.93823e-17
C221	a_465_249##9	a_465_249##10	2.23053e-19
C222	A#4	CIN#4	3.22815e-17
C223	B#14	B#3	5.18642e-18
C224	VGND#12	CIN#2	1.15566e-19
C225	a_465_249##9	A#12	2.73275e-18
C226	a_1100_75##2	A#7	6.44231e-19
C227	A#11	B#4	3.38518e-19
C228	VGND#9	CIN#9	4.96786e-19
C229	a_1107_347##2	VPWR#4	7.63268e-18
C230	A#15	VGND#12	1.83089e-18
C231	VGND#6	A#10	5.68265e-18
C232	a_465_249##6	a_465_249##4	4.59624e-18
C233	a_69_260##6	CIN#2	6.5754e-19
C234	a_465_249##6	B#1	1.21046e-17
C235	VGND#6	CIN#9	9.25266e-18
C236	a_465_249##12	A#7	3.60724e-18
C237	a_465_249##10	CIN#7	4.25541e-17
C238	A#14	B#4	2.04103e-19
C239	B#8	A#4	2.72627e-17
C240	VPWR#6	CIN#4	2.48871e-18
C241	a_465_249##6	A#10	3.92907e-19
C242	VGND#6	B#6	1.06211e-17
C243	VGND#9	B#6	3.15357e-18
C244	B#14	A#12	3.23088e-19
C245	a_465_249##9	CIN#7	2.32311e-19
C246	A#15	a_501_75##2	6.64869e-17
C247	VGND#6	A#7	4.44404e-18
C248	A#2	a_69_260##6	9.07426e-17
C249	a_509_347#	CIN#5	1.69819e-19
C250	A#10	B#2	4.19925e-18
C251	VGND#6	CIN#6	4.28111e-18
C252	a_465_249##12	CIN#6	6.71615e-19
C253	a_501_75#	B#6	2.16018e-19
C254	a_465_249#	B#8	3.974e-17
C255	a_465_249##10	B#5	4.17837e-17
C256	VGND#6	A#6	9.688e-18
C257	VGND#9	A#7	3.70738e-17
C258	CIN#8	B#4	3.02958e-19
C259	A#2	VGND#13	1.45331e-18
C260	a_509_347#	VPWR#7	4.00157e-17
C261	CIN#11	B#11	4.95447e-18
C262	a_509_347#	A#5	3.98429e-19
C263	a_465_249##9	VPWR#3	4.96831e-18
C264	A#11	A#10	2.82907e-19
C265	A#9	B#4	1.62388e-17
C266	VGND#6	B#9	9.16023e-18
C267	A#15	a_69_260##6	1.48273e-17
C268	a_465_249##9	B#5	1.62034e-20
C269	VPWR#9	A#5	2.02496e-19
C270	A#11	CIN#9	1.30619e-17
C271	a_465_249##12	A#6	2.44019e-19
C272	a_465_249##10	a_1107_347#	2.34014e-18
C273	a_501_75#	A#7	1.07511e-18
C274	VGND#6	a_465_249##3	1.20265e-17
C275	CIN#1	a_465_249#	4.12153e-17
C276	B#10	B#8	3.69588e-19
C277	A#11	B#6	8.85459e-20
C278	CIN#6	VGND#9	1.96773e-17
C279	VPWR#9	VPWR#7	4.53959e-18
C280	a_69_260##2	VGND#13	4.76398e-18
C281	VGND#6	CIN#3	9.77668e-18
C282	a_465_249##2	a_509_347#	5.61981e-17
C283	a_465_249##10	A#9	3.16989e-17
C284	a_465_249##2	VPWR#9	7.18229e-18
C285	CIN#17	A#12	9.50256e-19
C286	VGND#12	A#7	6.22895e-19
C287	a_1100_75#	VGND#7	2.59451e-17
C288	a_465_249##9	B#14	1.4364e-17
C289	VGND#6	B#11	1.14153e-17
C290	a_465_249##9	a_1107_347#	1.69544e-17
C291	a_465_249##2	a_509_347##2	6.0356e-17
C292	B#6	CIN#8	1.66458e-17
C293	a_501_75#	CIN#6	2.79367e-17
C294	a_465_249##12	B#9	3.01213e-19
C295	B#10	CIN#1	6.27327e-17
C296	CIN#17	CIN#7	2.26982e-18
C297	VGND#6	A#1	8.95409e-18
C298	a_509_347#	VPWR#9	3.19484e-17
C299	CIN#4	B#7	6.67906e-18
C300	a_465_249##2	a_69_260##4	2.99364e-17
C301	a_465_249##10	VPWR#5	3.51845e-19
C302	VGND#9	A#6	1.38892e-18
C303	VGND#6	a_69_260##3	1.09992e-18
C304	CIN#17	B#5	1.63697e-17
C305	A#8	B#4	2.10735e-19
C306	VGND#12	CIN#6	2.63236e-18
C307	A#8	B#6	2.22569e-17
C308	CIN#4	B#4	1.41386e-17
C309	VGND#8	VGND#7	4.60049e-18
C310	a_465_249##10	CIN#4	1.85568e-17
C311	a_509_347#	VPWR#6	2.82144e-18
C312	CIN#17	A#9	3.79145e-18
C313	a_509_347##2	a_509_347#	2.26921e-18
C314	a_501_75#	A#6	3.58986e-17
C315	VPWR#8	B#3	2.14486e-20
C316	A#3	B#10	4.70395e-17
C317	CIN#2	a_69_260##4	1.63154e-17
C318	a_465_249##9	VPWR#5	4.02692e-18
C319	CIN#6	A#8	2.87865e-18
C320	CIN#17	CIN#4	2.96388e-19
C321	VGND#9	B#9	4.35073e-19
C322	VPWR#8	A#12	3.34498e-18
C323	a_69_260#	B#10	1.31111e-18
C324	a_465_249##10	a_1107_347##2	1.11112e-16
C325	B#14	a_1107_347#	4.73739e-17
C326	A#6	VGND#12	2.61581e-17
C327	VPWR#8	CIN#7	5.20867e-18
C328	a_509_347##2	VPWR#9	2.69018e-17
C329	a_1100_75#	VGND#8	3.0055e-17
C330	a_1100_75##2	VGND#7	1.51719e-19
C331	A#2	a_69_260##4	3.73251e-18
C332	a_69_260#	A#3	3.43636e-17
C333	VGND#6	A#12	2.48767e-19
C334	a_501_75#	B#9	9.66365e-19
C335	a_69_260##6	CIN#6	2.08552e-20
C336	a_465_249##10	A#4	4.48165e-19
C337	VPWR#9	VPWR#6	3.30728e-18
C338	VGND#9	a_465_249##3	3.22838e-20
C339	a_501_75##2	A#6	9.96691e-19
C340	VPWR#6	B#7	6.03482e-18
C341	CIN#14	B#7	1.01137e-19
C342	B#2	a_465_249##7	9.22145e-20
C343	A#4	B#7	1.79163e-17
C344	CIN#5	B#7	2.99998e-19
C345	a_465_249##9	a_1107_347##2	2.16565e-17
C346	VPWR#8	A#9	2.8383e-18
C347	a_69_260##2	a_69_260##4	2.20104e-18
C348	B#9	VGND#12	2.62673e-17
C349	A#5	CIN#6	4.14599e-18
C350	a_465_249##10	a_465_249##13	3.79956e-18
C351	a_1100_75##2	a_1100_75#	3.15672e-18
C352	VPWR#8	CIN#4	2.82635e-18
C353	A#14	a_936_75#	2.15966e-18
C354	a_69_260##6	A#6	2.79234e-19
C355	A#12	B#2	1.40601e-18
C356	CIN#11	B#8	1.18633e-19
C357	a_1107_347#	A#10	4.57921e-20
C358	B#9	A#5	1.68931e-17
C359	VPWR#8	A#4	5.91162e-18
C360	a_501_75##2	B#9	3.98689e-17
C361	A#11	B#3	6.89502e-20
C362	a_465_249##10	B#8	9.59404e-20
C363	a_69_260##4	a_509_347##2	6.10245e-17
C364	a_69_260##2	VPWR#11	4.92952e-17
C365	CIN#14	B#4	4.60152e-20
C366	CIN#11	a_465_249#	3.3685e-18
C367	VGND#12	a_465_249##3	9.47784e-18
C368	SUM#1	a_69_260##2	2.95829e-17
C369	A#11	A#12	3.05953e-18
C370	A#14	B#5	1.26563e-18
C371	VPWR#6	B#4	4.93811e-17
C372	CIN#11	CIN#1	4.4143e-18
C373	a_1100_75##2	VGND#8	2.43887e-17
C374	a_465_249##2	B#9	1.94137e-17
C375	a_69_260##6	B#9	9.70402e-19
C376	VPWR#5	A#10	5.71016e-19
C377	VPWR#8	a_465_249#	7.64119e-18
C378	CIN#8	A#12	7.66723e-19
C379	a_501_75##2	a_465_249##3	2.97615e-17
C380	CIN#11	B#10	1.34775e-17
C381	VPWR#8	CIN#1	6.32466e-18
C382	A#5	B#7	3.21663e-19
C383	VGND#12	CIN#3	1.07314e-18
C384	a_1107_347##2	A#10	1.12834e-19
C385	CIN#11	A#3	6.48909e-19
C386	VPWR#8	B#10	1.16813e-17
C387	B#5	CIN#8	1.84973e-17
C388	a_465_249##3	a_69_260##6	1.5574e-17
C389	VPWR#8	A#3	8.65047e-18
C390	A#2	B#9	8.11216e-20
C391	a_501_75##2	CIN#3	7.04852e-19
C392	CIN#14	B#5	7.79415e-19
C393	a_465_249##10	VPWR#7	4.83001e-17
C394	B#11	CIN#2	2.3088e-17
C395	A#8	B#5	1.3223e-17
C396	VPWR#8	a_69_260#	4.76813e-18
C397	VGND#12	B#11	4.20764e-19
C398	A#2	CIN#3	1.63657e-17
C399	VPWR#4	B#4	1.9168e-17
C400	a_69_260##6	CIN#3	4.18531e-17
C401	a_465_249##12	a_1100_75##2	4.37948e-17
C402	A#2	B#11	4.4296e-17
C403	a_69_260##2	a_465_249##3	2.09419e-19
C404	CIN#5	A#9	2.69022e-18
C405	A#2	A#1	6.87458e-18
C406	CIN#13	B#5	6.99144e-20
C407	a_69_260##2	CIN#3	3.09295e-19
C408	CIN#14	A#9	3.91218e-18
C409	a_69_260##3	A#2	4.12499e-18
C410	VPWR#11	a_69_260##4	8.75551e-18
C411	VGND#12	A#1	2.94296e-19
C412	a_69_260##4	a_318_389#	3.47916e-18
C413	a_69_260##2	B#11	4.66968e-19
C414	a_465_249##10	a_509_347#	1.23726e-17
C415	a_465_249#	B#7	1.79128e-17
C416	a_465_249##2	B#7	1.70496e-18
C417	a_69_260##6	B#11	1.98111e-17
C418	A#4	CIN#5	2.17843e-18
C419	a_69_260##2	A#1	2.95982e-18
C420	VPWR#9	a_217_368#	4.34941e-21
C421	a_465_249##2	B#5	3.04725e-19
C422	CIN#17	VPWR#8	1.50426e-17
C423	a_69_260##2	a_69_260##3	1.70459e-17
C424	a_465_249##2	A#9	4.09648e-19
C425	a_69_260##4	a_217_368#	1.42455e-18
C426	A#14	a_465_249##10	9.71979e-18
C427	VGND#6	CIN#17	1.41729e-17
C428	VGND#3	a_465_249##6	1.18971e-17
C429	CIN#14	CIN#4	3.68574e-18
C430	a_465_249##2	CIN#4	1.12764e-18
C431	B#8	A#5	1.10394e-17
C432	CIN#11	VPWR#8	3.11393e-17
C433	a_69_260##6	A#1	2.33424e-17
C434	A#15	B#8	1.96684e-18
C435	a_465_249##2	A#4	2.51183e-17
C436	VGND#3	B#2	6.59181e-18
C437	VPWR#11	a_217_368#	6.11645e-19
C438	VGND#9	a_1100_75##2	5.11876e-18
C439	a_465_249##2	B#8	4.828e-17
C440	VGND#6	CIN#11	2.4785e-17
C441	CIN#17	B#2	6.45876e-19
C442	a_465_249##2	a_465_249#	5.97653e-18
C443	VGND#3	VGND#4	3.4759e-17
C444	CIN#17	A#11	1.7441e-18
C445	CIN#14	A#4	3.78449e-18
C446	a_465_249##2	CIN#1	4.14189e-19
C447	a_69_260##6	a_69_260##3	5.27774e-19
C448	VGND#4	a_1100_75#	3.34492e-18
C449	a_465_249##2	B#10	1.18273e-19
C450	VGND#9	a_465_249##12	1.17197e-17
C451	CIN#17	CIN#8	2.49208e-19
C452	a_69_260##6	a_315_75#	1.52674e-18
C453	VGND#4	B#1	3.20568e-18
C454	B#10	CIN#2	1.16856e-17
C455	CIN#17	A#8	3.97989e-18
C456	CIN#17	VGND#5	3.15936e-18
C457	SUM#1	VPWR#11	7.07276e-17
C458	A#1	VGND#13	9.55175e-18
C459	VPWR#8	A#11	3.31614e-18
C460	CIN#14	B#8	7.87521e-19
C461	CIN#17	CIN#5	3.68391e-19
C462	A#2	B#10	1.43665e-17
C463	B#2	a_465_249##6	8.11977e-17
C464	VGND#6	A#11	6.90622e-18
C465	VGND#5	A#10	2.33111e-19
C466	VPWR#8	CIN#8	2.24178e-18
C467	a_501_75#	a_465_249##12	8.52412e-19
C468	a_69_260##6	a_237_75#	2.46891e-18
C469	a_69_260##2	CIN#1	3.23441e-19
C470	B#5	a_916_347#	2.63075e-17
C471	VGND#6	CIN#8	2.59639e-18
C472	a_69_260##2	B#10	4.07834e-18
C473	B#6	a_936_75#	1.42257e-17
C474	A#9	a_916_347#	2.58082e-17
C475	VGND#5	a_1100_75##2	1.62173e-17
C476	a_69_260##3	VGND#13	1.83253e-17
C477	A#7	a_936_75#	1.44953e-17
C478	a_69_260##2	A#3	3.04351e-17
C479	A#11	B#2	6.65857e-18
C480	VGND#4	A#10	4.43324e-18
C481	CIN#13	B#8	7.9708e-20
C482	a_69_260##2	a_69_260#	4.12623e-18
C483	B#10	B#7	5.52504e-19
C484	A#2	B#7	4.26709e-21
C485	CIN	B#7	1.83569e-19
C486	CIN	B#4	2.72265e-19
C487	a_69_260##3	SUM#2	1.06171e-20
C488	CIN#14	a_465_249##10	2.73224e-17
C489	CIN#11	a_465_249##2	3.04358e-17
C490	CIN#8	A#11	8.69481e-17
C491	VGND#5	CIN#9	5.61494e-18
C492	a_465_249##2	VPWR#8	9.84668e-18
C493	VGND#4	a_1100_75##2	7.036e-17
C494	CIN#11	CIN#2	1.57814e-17
C495	A#11	A#8	1.58337e-19
C496	B#14	COUT	4.74393e-18
C497	VGND#6	a_465_249##2	4.66629e-18
C498	VPWR#8	CIN#2	1.18147e-18
C499	VGND#5	a_465_249##12	1.54824e-17
C500	CIN#17	VPWR#6	4.2614e-18
C501	A#2	CIN#11	4.53949e-17
C502	a_501_75#	VGND#9	2.77899e-17
C503	VGND#6	CIN#2	6.36282e-19
C504	VPWR#8	A#2	2.39741e-18
C505	a_69_260##2	CIN#11	1.16993e-17
C506	VGND#6	A#2	1.01195e-17
C507	CIN#1	a_318_389#	2.40451e-17
C508	B#1	a_465_249##4	5.79305e-18
C509	CIN#5	A#8	3.26829e-17
C510	VPWR#8	a_69_260##2	1.06566e-17
C511	B#10	a_318_389#	2.71583e-17
C512	VGND#5	B#6	8.32911e-18
C513	VGND#6	a_69_260##2	1.34652e-17
C514	B#7	B#4	9.01045e-20
C515	VGND#12	VGND#9	4.72754e-18
C516	COUT	COUT#3	3.68207e-18
C517	CIN#17	a_916_347#	7.87401e-19
C518	VGND#7	COUT	3.67617e-17
C519	A#5	CIN#5	3.41197e-17
C520	B#10	a_217_368#	2.63507e-17
C521	a_1100_75#	COUT	1.98706e-18
C522	CIN#3	a_315_75#	1.10331e-17
C523	A#3	a_217_368#	2.55948e-17
C524	a_465_249##2	CIN#5	8.2937e-19
C525	B#11	a_315_75#	1.10331e-17
C526	a_465_249##2	A#5	3.15046e-18
C527	VGND#3	a_465_249##9	4.33603e-18
C528	VPWR#5	B#4	1.24127e-18
C529	a_501_75#	VGND#12	2.96479e-17
C530	A#10	B#1	1.18042e-17
C531	B#11	a_237_75#	1.10331e-17
C532	VPWR#3	a_465_249##7	7.30109e-17
C533	VGND#5	A#7	6.44726e-18
C534	A#1	a_237_75#	1.08705e-17
C535	CIN#11	a_318_389#	2.35198e-19
C536	CIN#2	a_465_249##2	5.4979e-17
C537	A#2	A#5	2.0751e-19
C538	COUT	COUT#1	1.59725e-17
C539	VPWR#3	COUT	8.55027e-17
C540	CIN	VGND#5	1.1528e-18
C541	A#2	a_465_249##2	4.14223e-19
C542	COUT	VPWR#5	3.76194e-21
C543	a_1107_347#	a_465_249##7	7.5266e-18
C544	CIN#17	a_465_249##10	5.03316e-17
C545	A#2	CIN#2	3.53879e-17
C546	CIN	VPWR#6	1.96396e-18
C547	SUM	a_69_260##6	9.61535e-19
C548	a_501_75##2	a_501_75#	2.3745e-18
C549	VPWR#3	B#3	7.01145e-18
C550	VGND#6	VGND#5	1.34599e-16
C551	CIN#17	a_465_249##9	8.03634e-19
C552	SUM	SUM#2	9.51535e-18
C553	B#7	VNB	1.03987e-16
C554	B#4	VNB	1.12882e-16
C555	CIN	a_465_249##10	1.50475e-17
C556	VPWR#5	a_465_249##7	6.89779e-19
C557	a_69_260##2	A#2	1.2788e-16
C558	CIN#9	A#10	2.7848e-18
C559	VGND#6	VGND#4	5.02615e-17
C560	VGND#5	CIN#6	6.77639e-18
C561	a_1107_347#	B#3	3.86071e-17
C562	COUT	a_465_249##4	2.94567e-17
C563	a_465_249##2	a_916_347#	1.62889e-19
C564	CIN	A#15	2.4816e-17
C565	CIN	A#14	1.29852e-17
C566	COUT	B#1	1.31155e-18
C567	COUT	A#10	3.78641e-19
C568	CIN	CIN#14	2.73125e-17
C569	VPWR#8	VPWR#6	1.11017e-16
C570	VPWR#3	A#12	2.34446e-19
C571	a_501_75##2	VGND#12	3.34302e-17
C572	CIN#17	B#14	1.32893e-18
C573	a_1107_347##2	B#4	6.57339e-18
C574	VGND#5	a_501_75#	4.6977e-18
C575	CIN#14	VPWR#7	2.72533e-20
C576	VPWR#5	B#3	4.82638e-17
C577	VPWR#8	VPWR#4	1.21963e-16
C578	SUM	SUM#1	2.36953e-18
C579	a_1107_347#	A#12	1.54322e-18
C580	CIN	VGND#9	4.92204e-18
C581	CIN	a_501_75#	3.13846e-18
C582	CIN	VGND#12	2.80798e-18
C583	a_1107_347##2	B#3	1.57986e-18
C584	CIN	a_501_75##2	1.36931e-18
C585	B#6	CIN#9	3.78386e-17
C586	VGND#12	a_69_260##6	1.89476e-17
C587	COUT	a_465_249##7	3.45469e-17
C588	VGND#5	A#6	6.5248e-19
C589	COUT	B#3	3.25942e-19
C590	VPWR#5	A#12	4.4529e-17
C591	a_69_260##2	a_217_368#	6.37963e-18
C592	SUM	CIN#3	1.11752e-19
C593	SUM	B#11	1.55232e-19
C594	a_465_249##10	B#7	5.13128e-20
C595	SUM	A#1	1.30237e-18
C596	CIN#14	a_509_347#	2.1555e-19
C597	SUM	a_69_260##3	2.03895e-17
C598	a_1107_347#	CIN#7	4.44384e-19
C599	VGND#5	VNB	6.03838e-17
C600	VGND#4	VNB	5.02198e-17
C601	CIN	VPWR#7	5.68348e-18
C602	CIN	a_509_347#	5.15889e-18
C603	VGND#12	VGND#5	1.373e-18
C604	a_465_249##9	a_465_249##4	4.07836e-19
C605	CIN	VPWR#9	3.06005e-18
C606	A#15	a_69_260##4	2.31133e-18
C607	VPWR#6	VNB	3.8137e-17
C608	CIN	a_509_347##2	1.91589e-18
C609	VPWR#4	VNB	4.79438e-17
C610	a_1107_347##2	A#12	6.04992e-17
C611	a_465_249##10	VNB	4.62743e-19
C612	a_465_249##9	VNB	1.25124e-17
C613	A#15	A#14	3.75044e-18
C614	a_69_260##6	a_501_75##2	2.74172e-17
C615	B#14	VNB	8.95591e-18
C616	VPWR#5	CIN#7	1.14617e-18
C617	A#15	VNB	8.73259e-18
C618	A#14	VNB	6.003e-18
C619	CIN#14	VNB	1.66924e-19
C620	A#7	B#6	4.47129e-17
C621	CIN#13	VNB	3.21819e-20
C622	VGND#3	COUT	1.99851e-17
C623	VGND#5	B#9	1.77028e-19
C624	VGND#7	VNB	3.78681e-18
C625	a_1100_75#	VNB	3.7638e-18
C626	VGND#8	VNB	2.58144e-18
C627	CIN#7	a_1107_347##2	1.97849e-17
C628	a_1100_75##2	VNB	2.06416e-18
C629	a_465_249##10	B#4	8.00717e-18
C630	VPWR#8	a_465_249##10	2.78318e-17
C631	VGND#9	VNB	1.38134e-18
C632	VGND#12	VNB	5.91963e-17
C633	a_69_260##6	VNB	2.93396e-18
C634	a_465_249##6	COUT	7.17143e-17
C635	a_465_249##9	B#1	9.2805e-18
C636	A#14	CIN#17	5.79639e-17
C637	VPWR#5	B#5	5.8953e-19
C638	B#2	COUT	1.64907e-18
C639	CIN#11	SUM	6.83379e-19
C640	VPWR#3	VNB	1.49947e-17
C641	VPWR#8	a_465_249##9	1.70968e-18
C642	a_1107_347#	VNB	1.31516e-17
C643	CIN	A#9	3.01503e-18
C644	VPWR#5	VNB	3.22728e-18
C645	CIN	CIN#4	7.17354e-20
C646	a_1107_347##2	VNB	2.66227e-18
C647	CIN#7	a_465_249##13	2.10271e-17
C648	CIN	A#4	3.0514e-18
C649	VGND#6	SUM	1.58036e-17
C650	VPWR#7	VNB	2.45651e-18
C651	CIN	B#8	5.28007e-19
C652	a_509_347#	VNB	5.40898e-19
C653	VPWR#9	VNB	7.07247e-18
C654	a_509_347##2	VNB	8.42798e-19
C655	a_69_260##4	VNB	4.41993e-19
C656	VPWR#7	A#12	2.51822e-19
C657	VPWR#11	VNB	7.82889e-18
C658	SUM#1	VNB	5.99751e-17
C659	a_465_249##4	VNB	3.09284e-17
C660	B#1	VNB	4.2402e-17
C661	A#10	VNB	3.59996e-17
C662	CIN#9	VNB	2.70106e-17
C663	B#6	VNB	3.58681e-17
C664	A#7	VNB	2.13668e-17
C665	CIN#6	VNB	2.31251e-17
C666	A#6	VNB	2.76591e-17
C667	CIN#6	A#7	1.44367e-17
C668	B#9	VNB	4.11062e-17
C669	VGND#4	A#11	3.84444e-19
C670	a_465_249##3	VNB	3.03414e-17
C671	VPWR#5	A#9	2.27403e-19
C672	CIN#3	VNB	2.71735e-17
C673	B#11	VNB	3.81849e-17
C674	CIN	VPWR#8	2.95272e-17
C675	A#1	VNB	2.72625e-17
C676	VGND#6	CIN	2.78831e-17
C677	a_69_260##3	VNB	3.46395e-17
C678	VGND#6	a_465_249##10	4.10087e-18
C679	a_465_249##7	VNB	4.3525e-17
C680	SUM	a_69_260##2	1.01437e-16
C681	B#3	VNB	9.87607e-17
C682	B#5	a_465_249##13	1.75971e-17
C683	A#12	VNB	3.04487e-17
C684	CIN#7	VNB	2.46527e-17
C685	B#5	VNB	3.6698e-17
C686	A#9	VNB	2.51621e-17
C687	CIN#14	CIN#17	2.15411e-18
C688	a_465_249##9	A#10	3.17733e-17
C689	CIN#4	VNB	2.34337e-17
C690	A#4	VNB	3.15828e-17
C691	B#8	VNB	4.14551e-17
C692	a_465_249#	VNB	2.41476e-17
C693	VPWR#7	CIN#7	2.73394e-19
C694	CIN#1	VNB	2.40199e-17
C695	VGND#6	a_465_249##9	1.0173e-17
C696	B#10	VNB	7.60004e-17
C697	CIN	a_465_249##2	3.61114e-17
C698	A#3	VNB	3.80461e-17
C699	a_69_260#	VNB	3.97794e-17
C700	VPWR#4	B#2	6.22835e-20
C701	VGND#3	VNB	1.33369e-16
C702	CIN#17	VNB	3.67396e-18
C703	VPWR#6	VPWR#4	1.0217e-18
C704	CIN#11	VNB	2.99923e-18
C705	VPWR#8	VNB	3.18067e-16
C706	VGND#6	VNB	2.82247e-16
C707	a_465_249##6	VNB	7.78607e-17
C708	B#2	VNB	7.62746e-17
C709	A#11	VNB	3.40817e-17
C710	CIN#8	VNB	2.82962e-17
C711	A#8	VNB	2.37932e-17
C712	CIN#5	VNB	3.86615e-17
C713	VGND#5	CIN#8	8.63319e-20
C714	A#5	VNB	2.92909e-17
C715	CIN#11	A#15	6.95119e-18
C716	a_465_249##2	VNB	3.62528e-17
C717	CIN#2	VNB	3.07579e-17
C718	A#2	VNB	3.24354e-17
C719	CIN#13	CIN#17	2.19341e-18
C720	a_69_260##2	VNB	4.48576e-17
C721	VPWR#7	B#5	4.01127e-18
C722	A#6	CIN#6	3.38513e-17
C723	a_465_249##9	CIN#9	1.18338e-18
C724	COUT	VNB	1.18722e-16
C725	SUM	VNB	5.89506e-17
C726	CIN	VNB	2.66063e-18
C727	a_465_249##9	a_465_249##6	1.85324e-18
C728	a_509_347#	B#5	2.00888e-19
C729	VPWR#7	B#7	2.8135e-19
C730	VPWR#2	VPWR#4	4.54495e-17
C731	B#14	VPWR#2	9.54272e-18
C732	VGND#10	a_69_260##6	2.65148e-17
C733	VGND#2	COUT	2.05008e-17
C734	VGND#10	a_465_249##3	4.97461e-19
C735	VGND#2	A#10	3.12331e-19
C736	VGND#10	A#2	6.31416e-19
C737	VGND#2	a_465_249##4	7.98845e-18
C738	COUT	VPWR#2	3.60493e-17
C739	VPWR#8	VPWR#10	1.29925e-16
C740	VPWR#2	a_465_249##6	3.62288e-18
C741	VPWR#2	VNB	1.86064e-16
C742	VGND#2	a_465_249##6	8.62438e-20
C743	VPWR#2	a_465_249##7	7.5076e-18
C744	VPWR#10	A#2	2.3367e-19
C745	VPWR#10	VNB	7.01509e-17
C746	VGND#3	VGND#2	7.59438e-17
C747	VPWR#10	B#10	2.01842e-17
C748	VGND#10	VGND#13	9.10822e-18
C749	VGND#10	A#1	1.48295e-17
C750	a_69_260##4	VPWR#10	3.49892e-18
C751	VPWR#10	a_69_260#	3.84954e-18
C752	VGND#10	CIN#3	5.96787e-18
C753	VGND#2	VNB	3.95533e-17
C754	VPWR#2	B#2	3.94062e-19
C755	VPWR#2	VPWR#3	2.13754e-17
C756	VPWR#2	B#3	3.52595e-18
C757	VGND#10	a_69_260##2	3.66539e-17
C758	SUM#1	VPWR#10	1.85715e-17
C759	VGND#10	B#9	3.32545e-19
C760	VGND#2	B#1	1.71258e-18
C761	VGND#10	VNB	7.60557e-17
C762	CIN#11	VPWR#10	4.0223e-18
C763	a_1107_347#	VPWR#2	2.17909e-17
C764	VPWR#10	CIN#2	5.96904e-19
C765	VGND#6	VGND#10	1.40884e-16
C766	VPWR#10	CIN#1	1.51894e-18
C767	VGND#10	a_69_260##3	1.3784e-17
C768	a_69_260##2	VPWR#10	2.77645e-18
C769	VPWR#10	A#3	3.19306e-18
C770	CIN#11	VGND#10	2.19249e-18
C771	VGND#8	VGND#2	1.44844e-18
C772	VGND#10	SUM	2.50191e-17
C773	VGND#10	B#11	9.13356e-18
*
*
.ENDS sky130_fd_sc_hs__fa_1
*
