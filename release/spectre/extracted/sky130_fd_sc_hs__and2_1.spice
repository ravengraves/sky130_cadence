* Extracted by Quantus, converted by sky130cad/quantus.py
*
*
*
*                       LINUX           Wed Nov 18 08:16:05 2026
*
*
*
*  PROGRAM  advgen
*
*  Name           : advgen - Quantus - (64-bit)
*  Version        : 25.1.0-p047
*  Build Date     : Thu Dec 11 23:20:30 PST 2025
*
*  HSPICE LIBRARY
*
*  OPERATING_TEMPERATURE 150
*  QRC_TECH_DIR <path>/tech
*
*
*

*
.SUBCKT sky130_fd_sc_hs__and2_1 VPB VNB VGND VPWR X A B
*
*
*  caps2d version: 10
*
*
*       TRANSISTOR CARDS
*
*
XM4 a_56_136##6 A#2 a_143_136# VNB sky130_fd_pr__nfet_01v8_lvt l=0.15 w=0.64 ad=0.1824 as=0.2752 pd=1.85 ps=2.28
XM2 a_143_136# B#3 VGND#4 VNB sky130_fd_pr__nfet_01v8_lvt l=0.15 w=0.64 ad=0.2752 as=0.3107 pd=2.28 ps=2.34
XM3 VGND#4 a_56_136# X#3 VNB sky130_fd_pr__nfet_01v8_lvt l=0.15 w=0.74 ad=0.3107 as=0.2109 pd=2.34 ps=2.05
XM0 VPWR#7 A#1 a_56_136##7 VPB sky130_fd_pr__pfet_01v8 l=0.15 w=0.84 ad=0.252 as=0.294 pd=2.28 ps=2.38
XM1 a_56_136##7 B#1 VPWR#6 VPB sky130_fd_pr__pfet_01v8 l=0.15 w=0.84 ad=0.294 as=0.3976 pd=2.38 ps=3.01
XM5 VPWR#6 a_56_136##3 X#1 VPB sky130_fd_pr__pfet_01v8 l=0.15 w=1.12 ad=0.3976 as=0.3304 pd=3.01 ps=2.83
*
*
*       RESISTOR AND CAP/DIODE CARDS
*
Rg1	A#1	A#2	834.666809
Rg2	A#2	A#3	304.989380
Rg3	B#1	B#2	485.151062
Rg4	B#2	B#3	291.663208
Rg5	a_56_136#	a_56_136##2	307.937683
Rg6	a_56_136##2	a_56_136##3	434.639221
Rf1	A#4	A	1.371530
Rf2	A#3	A#6	81.487930
Rf3	A#4	A#6	6.324279
Rf4	A#7	A	1.371530
Rf5	A#6	A#7	8.853991
Rf6	B#2	B	168.893600
Rf7	a_56_136##2	a_56_136##5	226.660950
Rf8	a_56_136##5	a_56_136##6	87.526443
Rf9	a_56_136##5	a_56_136##7	28.385349
Rf10	X	X#2	11.936309
Rf11	X#2	X	0.331564
Rf12	X	X#3	81.643158
Rf13	X#1	X#2	5.000000
Rf15	VPWR#2	VPWR#3	25.908394
Rf16	VPWR#3	VPWR#4	49.829536
Rf18	VPWR#2	VPWR#6	33.503098
Rf19	VPWR#4	VPWR#7	34.297962
Rf21	VGND#2	VGND#3	22.255869
Rf22	VGND#2	VGND#4	44.939819
Re1	VPWR#3	VPWR	1.964508
Re2	VGND	VGND#3	1.964582
*
*       CAPACITOR CARDS
*
*
C1	VGND#4	a_56_136##5	1.56084e-18
C2	a_56_136##5	VPWR#6	1.00355e-17
C3	VGND#4	X#3	5.0357e-17
C4	A#6	a_56_136##6	2.161e-17
C5	a_56_136##5	VPWR#7	4.47461e-17
C6	a_56_136##6	X#3	3.49499e-18
C7	a_56_136##6	VGND#4	4.82278e-18
C8	X#3	X#1	3.94532e-18
C9	a_56_136##5	A#2	4.27262e-18
C10	a_56_136##5	a_56_136##3	3.44329e-19
C11	X#3	a_56_136#	3.67236e-17
C12	VPWR#6	X#1	6.17707e-17
C13	A#6	A#2	1.24403e-18
C14	a_56_136#	VGND#4	2.37755e-17
C15	a_56_136##5	B#1	1.01513e-17
C16	X#3	B#3	4.09519e-18
C17	a_56_136##7	X#1	3.06577e-18
C18	B#3	VGND#4	2.69691e-17
C19	X#3	A#2	1.33756e-18
C20	a_56_136##5	A#1	2.1687e-17
C21	a_56_136##7	VPWR#6	6.13608e-17
C22	a_56_136##6	a_56_136#	1.77989e-18
C23	VGND#4	A#2	3.90434e-18
C24	VPWR#7	VPWR#6	2.00214e-18
C25	a_56_136##6	B#3	4.5429e-18
C26	VPWR#7	a_56_136##7	7.2485e-17
C27	a_56_136##6	A#2	3.84113e-17
C28	a_56_136##5	VPWR#3	3.61713e-19
C29	X#1	a_56_136##3	2.93244e-17
C30	B#3	a_56_136#	2.05365e-17
C31	VPWR#7	A#2	6.05739e-19
C32	a_56_136##5	a_56_136##2	1.68642e-18
C33	VPWR#6	a_56_136##3	5.31475e-17
C34	X#1	B#1	6.525e-19
C35	a_56_136##7	a_56_136##3	2.00604e-18
C36	B#1	VPWR#6	1.95512e-17
C37	VGND#3	A#6	1.63949e-17
C38	a_56_136##5	B#2	4.74905e-17
C39	A#2	B#3	1.59004e-17
C40	VPWR#7	a_56_136##3	3.55338e-19
C41	a_56_136##7	B#1	5.3524e-17
C42	VPWR#6	A#1	1.09067e-18
C43	VPWR#7	B#1	1.86685e-18
C44	a_56_136##7	A#1	1.82935e-17
C45	VPWR#7	A#1	3.57834e-17
C46	a_56_136##2	X#3	4.78495e-17
C47	a_56_136##2	VGND#4	1.00988e-17
C48	a_56_136##7	VPWR#3	1.54788e-17
C49	A#6	A#3	1.0358e-17
C50	B#2	VGND#4	1.58143e-18
C51	a_56_136##2	X#1	5.46394e-17
C52	B#1	a_56_136##3	3.15677e-17
C53	a_56_136##2	VPWR#6	2.3749e-17
C54	a_56_136##6	B#2	8.89813e-18
C55	VGND#4	A#3	2.24393e-18
C56	VPWR#6	B#2	4.69745e-19
C57	A#3	a_56_136##6	6.14244e-18
C58	VGND#3	B#3	5.35105e-18
C59	A#1	B#1	3.35901e-17
C60	VGND#3	A#2	2.31828e-20
C61	a_56_136##2	A#2	9.91963e-20
C62	VPWR#3	B#1	5.64312e-18
C63	VPWR#7	A#3	5.32919e-19
C64	A#3	a_56_136#	1.09895e-18
C65	A#2	B#2	3.12386e-17
C66	a_56_136##2	a_56_136##3	6.797e-18
C67	A#3	B#3	8.18323e-18
C68	A	a_56_136##5	2.26196e-18
C69	B#2	a_56_136##3	4.90358e-18
C70	B	X#3	2.85916e-18
C71	B	VGND#4	9.03423e-18
C72	A#1	B#2	3.48562e-18
C73	a_56_136##6	B	1.23529e-17
C74	B#3	a_143_136#	1.6068e-17
C75	A#2	a_143_136#	1.45015e-17
C76	A	VGND#4	1.39813e-17
C77	VPWR#3	B#2	2.55659e-20
C78	A	a_56_136##6	1.70728e-17
C79	VPWR	a_56_136##5	6.7255e-18
C80	B	a_56_136#	2.16071e-18
C81	B	B#3	7.18541e-18
C82	B#2	a_56_136##2	4.69341e-17
C83	VGND#3	A#3	1.2505e-17
C84	B	A#2	4.04691e-18
C85	A	a_56_136#	3.02686e-18
C86	A	B#3	4.1188e-18
C87	VGND	a_56_136##5	6.01056e-18
C88	A	A#2	4.31043e-18
C89	VPWR	X#1	2.10088e-17
C90	VGND	A#6	7.08675e-18
C91	VPWR	VPWR#6	2.21408e-17
C92	VPWR	a_56_136##7	1.68307e-17
C93	VGND	X#3	2.04705e-17
C94	VGND#3	B	1.63686e-18
C95	a_56_136##5	VNB	3.10455e-17
C96	VGND	a_56_136##6	6.21619e-18
C97	VGND	X#1	8.7973e-19
C98	B	a_56_136##2	1.16255e-17
C99	VGND#3	A	4.06489e-17
C100	B	B#2	5.19297e-18
C101	A#6	VNB	1.46259e-18
C102	VPWR	a_56_136##3	4.32067e-18
C103	X#3	VNB	5.61788e-17
C104	VGND	a_56_136#	5.74164e-18
C105	VPWR	B#1	3.31077e-19
C106	VGND#4	VNB	5.0816e-18
C107	VGND	B#3	7.634e-18
C108	VPWR	A#1	5.77495e-19
C109	VGND	A#2	1.47196e-18
C110	a_56_136##6	VNB	3.42809e-17
C111	X#1	VNB	7.00336e-17
C112	A	A#3	3.06715e-17
C113	VPWR#6	VNB	3.67284e-18
C114	VPWR	VPWR#3	9.28792e-18
C115	B	a_143_136#	1.19937e-18
C116	a_56_136##7	VNB	4.72242e-18
C117	VPWR#7	VNB	3.74707e-17
C118	a_56_136#	VNB	3.38446e-17
C119	VPWR	a_56_136##2	3.40928e-18
C120	B#3	VNB	2.88571e-17
C121	A#2	VNB	4.80971e-17
C122	VPWR	B#2	2.43047e-18
C123	a_56_136##3	VNB	3.7625e-17
C124	VGND	VGND#3	3.89869e-17
C125	B#1	VNB	3.68965e-17
C126	VGND	a_56_136##2	4.51798e-18
C127	A#1	VNB	4.83586e-17
C128	VPWR#3	VNB	1.34259e-16
C129	VGND	A#3	6.80625e-18
C130	VGND#3	VNB	1.71871e-16
C131	a_56_136##2	VNB	3.94482e-17
C132	B#2	VNB	3.07806e-17
C133	A#3	VNB	8.66756e-17
C134	VGND	B	6.40663e-18
C135	VGND	A	2.07954e-17
C136	A	VNB	3.09302e-17
C137	VPWR	VNB	6.06543e-17
C138	VGND	VNB	5.97908e-17
C139	VPWR#3	VPWR#4	3.97295e-17
C140	VPWR#4	VPWR#6	4.5171e-20
C141	VPWR#4	VPWR#2	8.8728e-19
C142	VPWR#2	a_56_136##3	3.31575e-18
C143	a_56_136##2	VPWR#2	3.53297e-19
C144	a_56_136##5	VPWR#4	9.0954e-19
C145	VGND#2	a_56_136##2	4.80657e-19
C146	VPWR#4	A#1	4.62147e-18
C147	VPWR#2	VNB	4.25365e-17
C148	X#1	VPWR#2	2.48015e-17
C149	VPWR#4	VNB	4.06486e-17
C150	VPWR#3	VPWR#2	4.62095e-17
C151	VPWR#4	B#1	5.67114e-19
C152	VGND#3	VGND#2	4.75052e-17
C153	A	VGND#2	6.36938e-18
C154	VGND#2	VNB	5.22038e-17
C155	VPWR#4	a_56_136##3	1.87396e-19
C156	VGND#2	X#3	1.86378e-17
C157	VPWR	VPWR#2	2.94052e-17
C158	VGND#2	a_56_136#	6.97039e-18
C159	VGND#2	A#3	3.37223e-18
C160	a_56_136##7	VPWR#4	3.54883e-18
C161	VPWR	VPWR#4	5.09408e-17
C162	VGND	VGND#2	5.32438e-17
*
*
.ENDS sky130_fd_sc_hs__and2_1
*
