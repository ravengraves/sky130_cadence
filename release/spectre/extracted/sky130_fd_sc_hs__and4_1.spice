* Extracted by Quantus, converted by sky130cad/quantus.py
*
*
*
*                       LINUX           Wed Nov 18 08:18:14 2026
*
*
*
*  PROGRAM  advgen
*
*  Name           : advgen - Quantus - (64-bit)
*  Version        : 25.1.0-p047
*  Build Date     : Thu Dec 11 23:20:30 PST 2025
*
*  HSPICE LIBRARY
*
*  OPERATING_TEMPERATURE 150
*  QRC_TECH_DIR <path>/tech
*
*
*

*
.SUBCKT sky130_fd_sc_hs__and4_1 VPB VNB VGND VPWR X B C A D
*
*
*  caps2d version: 10
*
*
*       TRANSISTOR CARDS
*
*
XM8 a_96_74##7 A#1 a_179_74# VNB sky130_fd_pr__nfet_01v8_lvt l=0.15 w=0.64 ad=0.1696 as=0.1536 pd=1.81 ps=1.76
XM7 a_179_74# B#1 a_257_74# VNB sky130_fd_pr__nfet_01v8_lvt l=0.15 w=0.64 ad=0.1536 as=0.1536 pd=1.76 ps=1.76
XM6 a_257_74# C#3 a_335_74# VNB sky130_fd_pr__nfet_01v8_lvt l=0.15 w=0.64 ad=0.1536 as=0.2688 pd=1.76 ps=2.12
XM1 a_335_74# D#3 VGND#4 VNB sky130_fd_pr__nfet_01v8_lvt l=0.15 w=0.64 ad=0.2688 as=0.2554 pd=2.12 ps=2.2
XM9 VGND#4 a_96_74##3 X#2 VNB sky130_fd_pr__nfet_01v8_lvt l=0.15 w=0.74 ad=0.2554 as=0.2109 pd=2.2 ps=2.05
XM3 VPWR#6 A#3 a_96_74##9 VPB sky130_fd_pr__pfet_01v8 l=0.15 w=0.84 ad=0.2898 as=0.294 pd=2.37 ps=2.38
XM4 a_96_74##9 B#3 VPWR#5 VPB sky130_fd_pr__pfet_01v8 l=0.15 w=0.84 ad=0.294 as=0.4704 pd=2.38 ps=2.8
XM5 VPWR#5 C#1 a_96_74##8 VPB sky130_fd_pr__pfet_01v8 l=0.15 w=0.84 ad=0.4704 as=0.294 pd=2.8 ps=2.38
XM0 a_96_74##8 D#1 VPWR#4 VPB sky130_fd_pr__pfet_01v8 l=0.15 w=0.84 ad=0.294 as=0.4396 pd=2.38 ps=3.11
XM2 VPWR#4 a_96_74# X#1 VPB sky130_fd_pr__pfet_01v8 l=0.15 w=1.12 ad=0.4396 as=0.3304 pd=3.11 ps=2.83
*
*
*       RESISTOR AND CAP/DIODE CARDS
*
Rg1	A#1	A#2	336.593323
Rg2	A#2	A#3	470.766693
Rg3	B#1	B#2	480.755798
Rg4	B#2	B#3	420.384705
Rg5	C#1	C#2	478.945160
Rg6	C#2	C#3	337.550110
Rg7	D#1	D#2	488.281677
Rg8	D#2	D#3	479.525604
Rg9	a_96_74#	a_96_74##2	464.927643
Rg10	a_96_74##2	a_96_74##3	392.177277
Rf1	A#4	A	1.292473
Rf2	A#2	A#6	81.408875
Rf3	A#4	A#6	5.370198
Rf4	A#7	A	1.292473
Rf5	A#6	A#7	7.048386
Rf6	B	B#4	0.984182
Rf7	B#4	B	13.581709
Rf8	C	C#4	8.267126
Rf9	C#4	C	6.298763
Rf10	D#4	D#2	161.302414
Rf11	D	D#6	1.069610
Rf12	D#4	D#6	5.583287
Rf13	a_96_74##2	a_96_74##5	235.485718
Rf14	a_96_74##5	a_96_74##6	92.563164
Rf15	a_96_74##6	a_96_74##7	147.523911
Rf16	a_96_74##5	a_96_74##8	23.956533
Rf17	a_96_74##6	a_96_74##9	23.366024
Rf18	X#1	X	81.858566
Rf19	X	X#2	11.362064
Rf21	VPWR#2	VPWR#3	65.355659
Rf22	VPWR#2	VPWR#4	31.337896
Rf23	VPWR#3	VPWR#5	23.421036
Rf24	VPWR#3	VPWR#6	136.226669
Rf26	VGND#2	VGND#3	51.476067
Rf27	VGND#2	VGND#4	31.337896
Rf30	C#2	C#4	80.116402
Rf29	B#2	B#4	160.232803
Re1	VPWR#3	VPWR	1.403190
Re2	VGND	VGND#3	1.403242
*
*       CAPACITOR CARDS
*
*
C1	VGND#4	X#2	6.51709e-17
C2	VGND	VNB	7.77693e-17
C3	VPWR	VNB	5.51939e-17
C4	B	VNB	1.51397e-18
C5	C	VNB	2.10674e-18
C6	A	VNB	4.69929e-18
C7	a_96_74##6	a_96_74##9	1.78967e-18
C8	D	VNB	7.75581e-20
C9	VGND	B	1.51365e-17
C10	VGND	C	1.49203e-17
C11	VGND	A	4.96292e-18
C12	VPWR	B	3.06109e-18
C13	VPWR	C	2.99502e-18
C14	A#2	VNB	8.01146e-17
C15	B#2	VNB	4.66298e-17
C16	C#2	VNB	3.65261e-17
C17	D#2	VNB	3.50822e-17
C18	VPWR	D	2.58432e-18
C19	a_96_74##5	VPWR#5	8.79645e-17
C20	a_96_74##2	VNB	5.02684e-17
C21	VGND#3	VNB	2.26356e-16
C22	VPWR#3	VNB	1.96438e-16
C23	B	C	9.62092e-17
C24	A#3	VNB	4.71783e-17
C25	B#3	VNB	3.1418e-17
C26	A	B	2.2452e-17
C27	VGND	B#2	8.05792e-19
C28	C#1	VNB	3.34698e-17
C29	D#1	VNB	3.88968e-17
C30	a_96_74#	VNB	3.56477e-17
C31	VGND	a_96_74##2	6.24629e-18
C32	A#1	VNB	3.27266e-17
C33	B#1	VNB	3.11205e-17
C34	VGND	VGND#3	5.46213e-17
C35	C#3	VNB	2.78415e-17
C36	C	D	1.47584e-17
C37	D#3	VNB	2.8046e-17
C38	B	a_179_74#	5.52613e-19
C39	a_96_74##3	VNB	3.5218e-17
C40	VPWR#6	VNB	6.31331e-17
C41	a_96_74##9	VNB	6.72955e-18
C42	B	a_257_74#	6.83915e-19
C43	VPWR#5	VNB	2.83843e-18
C44	a_96_74##6	VPWR#5	2.55183e-17
C45	VPWR#4	VNB	4.05827e-18
C46	VPWR	a_96_74##2	3.28512e-18
C47	X#1	VNB	5.86346e-17
C48	a_96_74##7	VNB	6.8373e-17
C49	VPWR	VPWR#3	2.72862e-17
C50	C	a_257_74#	1.63323e-20
C51	VGND	A#1	4.04837e-18
C52	VGND#4	VNB	1.91894e-18
C53	VGND	B#1	7.48447e-19
C54	X#2	VNB	7.22277e-17
C55	B	A#2	9.5192e-18
C56	C	a_335_74#	2.68719e-18
C57	VPWR	A#3	1.40284e-18
C58	VGND	C#3	2.34935e-19
C59	a_96_74##5	a_96_74##8	4.89812e-18
C60	A#6	VNB	3.54579e-18
C61	VPWR	B#3	2.48552e-19
C62	B	B#2	2.00449e-17
C63	VGND	D#3	3.52798e-19
C64	A#7	VNB	3.828e-18
C65	VGND	a_96_74##3	1.72265e-18
C66	VPWR	C#1	5.40785e-19
C67	B	C#2	5.71404e-18
C68	D#4	VNB	3.1403e-18
C69	VPWR	D#1	2.73826e-19
C70	VPWR	a_96_74#	4.01092e-18
C71	B	D#2	2.49472e-19
C72	a_96_74##5	VNB	2.14001e-17
C73	C	B#2	5.3508e-18
C74	a_96_74##6	VNB	4.04212e-17
C75	B	a_96_74##2	1.23692e-18
C76	VGND	X#1	9.0513e-19
C77	C	C#2	2.4442e-17
C78	A	A#2	1.30584e-17
C79	VGND#3	B	1.42154e-17
C80	VGND	a_96_74##7	2.78287e-17
C81	C	D#2	6.42911e-18
C82	A	B#2	6.12918e-19
C83	VGND	VGND#4	1.99853e-17
C84	C	a_96_74##2	3.95829e-18
C85	VGND	X#2	2.52051e-17
C86	VPWR	VPWR#6	4.20201e-17
C87	VGND#3	C	1.39898e-17
C88	VPWR	a_96_74##9	1.60013e-17
C89	VPWR	VPWR#5	4.48934e-17
C90	a_96_74##5	VPWR#4	6.73688e-17
C91	VPWR	VPWR#4	2.2239e-17
C92	D	C#2	2.20683e-18
C93	VGND	D#4	4.94714e-18
C94	VPWR	X#1	1.98009e-17
C95	VGND#3	A	7.36971e-19
C96	D	D#2	8.11942e-18
C97	D	a_96_74##2	1.8419e-17
C98	B	A#1	9.72042e-18
C99	B	B#1	2.20291e-17
C100	B	C#3	6.10133e-18
C101	VPWR	A#7	3.08446e-18
C102	a_96_74##5	X#1	6.75489e-18
C103	C	B#1	5.82496e-18
C104	C	C#3	2.90067e-17
C105	VPWR	a_96_74##5	1.98719e-17
C106	C	D#3	8.1916e-18
C107	VPWR	a_96_74##6	8.88661e-18
C108	C	a_96_74##3	3.51229e-19
C109	A#2	B#2	3.84698e-17
C110	a_96_74##7	B	4.21332e-17
C111	A	B#1	8.45606e-19
C112	D	a_96_74#	2.0598e-19
C113	B#2	C#2	3.99675e-17
C114	A#6	B	1.59746e-17
C115	a_96_74##2	A#2	1.33033e-19
C116	A#7	B	1.97408e-17
C117	VGND#3	A#2	4.2982e-19
C118	a_96_74##7	a_96_74##6	1.83362e-18
C119	a_96_74##2	B#2	6.80478e-20
C120	C#2	D#2	4.31603e-17
C121	C	VGND#4	2.73176e-17
C122	VGND#4	D#4	1.3237e-17
C123	C	X#2	5.44475e-18
C124	VPWR#3	A#2	1.25635e-19
C125	A#1	a_179_74#	1.71328e-18
C126	VGND#3	B#2	3.55947e-19
C127	a_96_74##7	A	5.7096e-17
C128	a_96_74##2	C#2	4.25502e-19
C129	B#1	a_179_74#	1.14876e-17
C130	D#2	a_96_74##2	3.86556e-17
C131	a_96_74##6	B	3.67008e-17
C132	B#1	a_257_74#	1.15098e-17
C133	C	D#4	2.53782e-17
C134	A#3	B#2	4.37692e-18
C135	C#3	a_257_74#	1.28458e-18
C136	VPWR#3	D#2	3.24722e-20
C137	C	a_96_74##5	2.7862e-17
C138	B#2	C#1	2.65031e-18
C139	C#3	a_335_74#	1.7025e-17
C140	D#3	a_335_74#	2.12237e-18
C141	a_96_74##2	A#3	4.57302e-20
C142	A#2	B#1	1.27537e-17
C143	C#1	D#2	1.40816e-18
C144	a_96_74##2	C#1	1.15363e-19
C145	VGND#4	a_96_74##5	3.3653e-18
C146	D#2	a_96_74#	4.52347e-18
C147	D	a_96_74##5	3.00837e-17
C148	VPWR#3	B#3	4.04449e-18
C149	B#1	C#2	4.95758e-18
C150	a_96_74##2	a_96_74#	7.03397e-18
C151	VPWR#3	C#1	9.72039e-19
C152	C#2	D#3	1.61406e-18
C153	A#3	B#3	3.08256e-17
C154	VPWR#5	B#2	9.16517e-19
C155	VGND#3	A#1	7.99977e-18
C156	D#2	a_96_74##3	1.40833e-18
C157	B#3	C#1	1.33459e-17
C158	a_96_74##7	A#2	1.97025e-17
C159	VGND#3	B#1	6.16915e-18
C160	VPWR#5	C#2	8.60382e-19
C161	VGND#3	C#3	6.35221e-18
C162	C#1	D#1	3.39444e-17
C163	a_96_74##6	A#6	3.83984e-18
C164	D#1	a_96_74#	2.60922e-17
C165	X#1	D#2	1.83083e-19
C166	A#6	A#2	6.0216e-18
C167	VPWR#3	VPWR#6	2.96384e-17
C168	a_96_74##2	VPWR#4	2.05592e-17
C169	A#7	A#2	9.84379e-18
C170	a_96_74##9	VPWR#3	1.57121e-17
C171	a_96_74##2	X#1	4.73042e-17
C172	A#6	B#2	1.92069e-18
C173	X#2	C#2	1.34516e-19
C174	A#3	VPWR#6	2.82096e-17
C175	A#7	B#2	3.42439e-18
C176	VGND#4	D#2	3.3141e-18
C177	VGND#3	a_96_74##7	3.98325e-17
C178	a_96_74##9	A#3	4.50095e-17
C179	X#2	D#2	6.50659e-19
C180	a_96_74##6	A#7	5.52148e-17
C181	VPWR#6	B#3	1.17163e-18
C182	VPWR#5	A#3	2.78517e-18
C183	VGND#4	a_96_74##2	1.32166e-19
C184	B#3	a_96_74##9	1.63163e-17
C185	a_96_74##2	X#2	7.2901e-17
C186	a_96_74##6	A#2	1.62947e-17
C187	VPWR#5	B#3	5.08462e-17
C188	A#1	B#1	4.31749e-17
C189	a_96_74##9	C#1	1.37505e-18
C190	D#4	C#2	2.96104e-18
C191	VPWR#5	C#1	5.71533e-17
C192	a_96_74##9	D#1	2.53278e-19
C193	a_96_74##6	B#2	3.19223e-18
C194	C#1	a_96_74##8	5.8063e-19
C195	B#1	C#3	4.72193e-17
C196	D#4	D#2	9.58026e-18
C197	VPWR#5	D#1	2.14723e-18
C198	VPWR#4	C#1	1.13911e-18
C199	a_96_74##5	C#2	2.39438e-18
C200	D#1	a_96_74##8	1.94997e-17
C201	a_96_74##6	C#2	1.72737e-20
C202	VPWR#5	a_96_74#	4.37181e-19
C203	D#1	VPWR#4	3.0117e-17
C204	D#4	a_96_74##2	2.3309e-17
C205	C#3	D#3	2.56089e-17
C206	a_96_74##5	D#2	2.02876e-18
C207	X#1	D#1	1.913e-18
C208	a_96_74#	VPWR#4	3.03679e-17
C209	a_96_74##6	D#2	2.30263e-19
C210	X#1	a_96_74#	4.67144e-17
C211	D#3	a_96_74##3	2.77343e-17
C212	a_96_74##7	A#1	3.44688e-17
C213	a_96_74##5	VPWR#3	1.30214e-17
C214	VPWR#6	a_96_74##9	6.20552e-17
C215	a_96_74##6	VPWR#3	9.16915e-19
C216	a_96_74##7	B#1	6.08939e-18
C217	VPWR#6	VPWR#5	2.60161e-18
C218	a_96_74##7	C#3	5.35488e-19
C219	a_96_74##9	VPWR#5	6.19173e-17
C220	VGND#4	A#1	5.64299e-19
C221	a_96_74##7	D#3	3.63908e-19
C222	a_96_74##5	A#3	3.79756e-19
C223	a_96_74##6	A#3	2.73389e-17
C224	VGND#4	B#1	7.63934e-19
C225	a_96_74##5	B#3	8.34832e-19
C226	VGND#4	C#3	4.42314e-18
C227	a_96_74##6	B#3	1.8498e-17
C228	VPWR#5	VPWR#4	1.56441e-18
C229	X#2	C#3	5.90409e-19
C230	a_96_74##5	C#1	2.87841e-17
C231	VGND#4	D#3	4.32e-17
C232	a_96_74##6	C#1	7.25494e-20
C233	X#2	D#3	3.0059e-18
C234	a_96_74##3	VGND#4	1.94143e-17
C235	a_96_74##5	D#1	5.6245e-17
C236	VPWR#4	X#1	6.71291e-17
C237	X#2	a_96_74##3	3.86478e-17
C238	a_96_74##5	a_96_74#	3.18966e-18
C239	X#2	X#1	3.99674e-18
C240	a_96_74##7	VGND#4	2.07926e-18
C241	a_96_74##7	A#6	1.05008e-17
C242	a_96_74##6	VPWR#6	3.65252e-17
C243	a_96_74##9	a_96_74##5	2.96529e-18
C244	VPWR#2	VNB	4.73241e-17
C245	VGND#2	D#4	7.40299e-19
C246	VPWR#2	D#2	2.64002e-22
C247	VGND#2	X#2	3.14682e-17
C248	VPWR	VPWR#2	3.55601e-17
C249	a_96_74##2	VPWR#2	2.5912e-19
C250	VGND#2	VNB	5.33753e-17
C251	VPWR#3	VPWR#2	5.36124e-17
C252	VGND#2	D#3	3.80187e-18
C253	VGND	VGND#2	4.05164e-17
C254	VPWR#5	VPWR#2	9.2321e-19
C255	VGND#2	a_96_74##3	7.59029e-18
C256	VGND#2	a_96_74##2	1.15867e-18
C257	X#1	VPWR#2	2.25962e-17
C258	VPWR#2	D#1	5.68126e-18
C259	VGND#3	VGND#2	5.88054e-17
C260	VPWR#2	a_96_74#	4.62971e-18
C261	a_96_74##5	VPWR#2	5.16225e-18
*
*
.ENDS sky130_fd_sc_hs__and4_1
*
