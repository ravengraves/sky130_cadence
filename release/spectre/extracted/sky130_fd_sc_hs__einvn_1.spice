* Extracted by Quantus, converted by sky130cad/quantus.py
*
*
*
*                       LINUX           Wed Nov 18 08:36:43 2026
*
*
*
*  PROGRAM  advgen
*
*  Name           : advgen - Quantus - (64-bit)
*  Version        : 25.1.0-p047
*  Build Date     : Thu Dec 11 23:20:30 PST 2025
*
*  HSPICE LIBRARY
*
*  OPERATING_TEMPERATURE 150
*  QRC_TECH_DIR <path>/tech
*
*
*

*
.SUBCKT sky130_fd_sc_hs__einvn_1 VPB VNB VGND VPWR Z A TE_B
*
*
*  caps2d version: 10
*
*
*       TRANSISTOR CARDS
*
*
XM5 a_22_46##4 TE_B#3 VGND#1 VNB sky130_fd_pr__nfet_01v8_lvt l=0.15 w=0.42 ad=0.1218 as=0.2564 pd=1.42 ps=2.36
XM2 VGND#1 a_22_46# a_281_100# VNB sky130_fd_pr__nfet_01v8_lvt l=0.15 w=0.74 ad=0.2564 as=0.1776 pd=2.36 ps=1.96
XM4 a_281_100# A#3 Z#2 VNB sky130_fd_pr__nfet_01v8_lvt l=0.15 w=0.74 ad=0.1776 as=0.2109 pd=1.96 ps=2.05
XM0 a_22_46##3 TE_B#4 VPWR#1 VPB sky130_fd_pr__pfet_01v8 l=0.15 w=0.64 ad=0.1888 as=0.388 pd=1.87 ps=3.01
XM3 VPWR#1 TE_B#1 a_278_368# VPB sky130_fd_pr__pfet_01v8 l=0.15 w=1.12 ad=0.388 as=0.3024 pd=3.01 ps=2.78
XM1 a_278_368# A#1 Z#1 VPB sky130_fd_pr__pfet_01v8 l=0.15 w=1.12 ad=0.3024 as=0.3304 pd=2.78 ps=2.83
*
*
*       RESISTOR AND CAP/DIODE CARDS
*
Rg1	TE_B#1	TE_B#2	638.734802
Rg2	TE_B#2	TE_B#3	203.864471
Rg3	TE_B#2	TE_B#4	284.657074
Rg4	a_22_46#	a_22_46##2	626.156860
Rg5	A#1	A#2	434.639221
Rg6	A#2	A#3	307.937683
Rf1	a_22_46##3	a_22_46##5	98.372208
Rf2	a_22_46##5	a_22_46##2	93.990692
Rf3	a_22_46##4	a_22_46##5	15.000000
Rf4	TE_B#2	TE_B	182.855682
Rf5	A#4	A#2	162.219223
Rf6	A	A#6	1.986418
Rf7	A#4	A#6	4.798750
Rf8	Z#1	Z	7.612675
Rf9	Z	Z#2	116.545715
Rf10	VGND#1	VGND#2	41.921906
Rf12	VPWR#1	VPWR#2	39.225067
Re1	VPWR#2	VPWR	1.964508
Re2	VGND	VGND#2	1.964582
*
*       CAPACITOR CARDS
*
*
C1	A#4	Z#2	4.09447e-17
C2	A#6	Z#1	4.54648e-17
C3	a_22_46##4	A#4	2.14618e-18
C4	A#4	Z#1	3.64356e-18
C5	VGND#1	Z#2	2.81296e-17
C6	Z#2	Z#1	3.44586e-18
C7	a_22_46##4	VGND#1	4.03891e-17
C8	A#4	a_22_46#	3.45621e-18
C9	A#4	TE_B#3	8.69059e-19
C10	Z#2	A#3	3.72635e-17
C11	A#6	A#1	4.10928e-18
C12	Z#2	a_22_46#	8.79454e-18
C13	VPWR#1	Z#1	3.60646e-17
C14	A#6	TE_B#1	4.29507e-18
C15	a_22_46##4	a_22_46##3	3.647e-18
C16	VGND#1	A#3	9.45337e-18
C17	Z#2	TE_B#3	3.91173e-19
C18	a_22_46##3	Z#1	6.89551e-21
C19	a_22_46##4	A#3	1.16442e-19
C20	VGND#1	a_22_46#	4.9712e-17
C21	a_22_46##4	a_22_46#	2.18911e-18
C22	TE_B#3	VGND#1	1.07622e-17
C23	a_22_46##3	VPWR#1	4.72577e-17
C24	a_22_46##4	TE_B#3	2.76976e-17
C25	VGND#1	TE_B#1	3.6513e-19
C26	Z#1	A#1	5.51764e-17
C27	a_22_46#	A#3	5.92927e-17
C28	A#6	A#2	6.04094e-18
C29	Z#1	TE_B#1	1.21684e-17
C30	VPWR#1	A#1	1.18611e-17
C31	A#4	A#2	1.17353e-17
C32	TE_B#3	a_22_46#	1.87368e-17
C33	Z#1	TE_B#4	2.90234e-19
C34	a_22_46##3	A#1	1.27403e-19
C35	VPWR#1	TE_B#1	6.78078e-17
C36	a_22_46##3	TE_B#1	1.50317e-18
C37	A#4	TE_B#2	8.58376e-19
C38	TE_B#4	VPWR#1	1.85574e-17
C39	Z#2	A#2	9.33286e-18
C40	a_22_46##3	TE_B#4	3.33905e-17
C41	a_22_46#	TE_B#1	1.045e-17
C42	a_22_46##4	A#2	4.87236e-19
C43	A#2	Z#1	7.94799e-18
C44	VGND#1	TE_B#2	6.02299e-19
C45	a_22_46##4	TE_B#2	5.98045e-17
C46	TE_B#1	A#1	6.31108e-17
C47	Z#1	TE_B#2	5.76583e-20
C48	VGND#1	a_22_46##2	5.17882e-17
C49	TE_B#4	TE_B#1	2.53097e-17
C50	TE_B#2	VPWR#1	5.75434e-18
C51	TE_B#2	a_22_46##3	5.4989e-17
C52	a_22_46#	A#2	8.55681e-18
C53	TE_B#3	A#2	4.70829e-20
C54	a_22_46##3	a_22_46##2	2.83374e-19
C55	a_22_46#	TE_B#2	1.59354e-19
C56	TE_B	A#6	1.17796e-17
C57	a_22_46##2	a_22_46#	3.11485e-18
C58	TE_B#1	A#2	1.24517e-17
C59	a_22_46##2	TE_B#3	1.19493e-17
C60	TE_B	A#4	1.7588e-17
C61	TE_B#2	TE_B#1	5.7591e-19
C62	A#3	a_281_100#	1.78568e-17
C63	VGND#1	TE_B	3.23093e-17
C64	a_22_46#	a_281_100#	1.71273e-17
C65	A#1	a_278_368#	2.92593e-17
C66	TE_B#1	a_278_368#	2.83201e-17
C67	TE_B	VPWR#1	3.58636e-17
C68	TE_B#2	A#2	1.58007e-18
C69	VPWR	A#6	5.78135e-18
C70	TE_B	a_22_46#	2.02861e-18
C71	a_22_46##2	TE_B#2	2.8385e-18
C72	TE_B	A#1	5.4923e-19
C73	TE_B	TE_B#1	7.22182e-18
C74	VGND	A#4	6.38351e-18
C75	VPWR	Z#1	2.57419e-17
C76	VPWR	VPWR#1	2.23029e-17
C77	VGND	Z#2	2.2454e-17
C78	VPWR	a_22_46##3	1.55187e-17
C79	TE_B	A#2	4.35322e-18
C80	A#6	VNB	2.91292e-18
C81	TE_B	TE_B#2	4.48862e-18
C82	A#4	VNB	7.39002e-18
C83	VPWR	A#1	2.39847e-18
C84	VGND	a_22_46##3	7.63173e-19
C85	TE_B	a_22_46##2	2.22694e-19
C86	VGND	A#3	9.96828e-18
C87	VPWR	TE_B#1	2.84373e-18
C88	Z#2	VNB	5.84543e-17
C89	VGND	a_22_46#	3.67723e-18
C90	VPWR	TE_B#4	6.3556e-18
C91	VGND	TE_B#3	6.13801e-19
C92	a_22_46##4	VNB	4.51724e-17
C93	Z#1	VNB	7.42577e-17
C94	VPWR#1	VNB	1.5936e-17
C95	VGND	TE_B#1	5.24313e-19
C96	a_22_46##3	VNB	5.24976e-17
C97	A#3	VNB	3.02391e-17
C98	a_22_46#	VNB	4.80751e-17
C99	VPWR	TE_B#2	3.07295e-18
C100	TE_B#3	VNB	2.15399e-17
C101	A#1	VNB	2.99505e-17
C102	TE_B#1	VNB	4.172e-17
C103	TE_B#4	VNB	3.98642e-17
C104	VGND	TE_B#2	3.95318e-18
C105	VGND	a_22_46##2	3.34039e-17
C106	A#2	VNB	3.66858e-17
C107	TE_B#2	VNB	5.06804e-17
C108	VPWR	TE_B	1.38531e-18
C109	a_22_46##2	VNB	1.17675e-16
C110	VGND	TE_B	1.70302e-18
C111	TE_B	VNB	3.88576e-18
C112	VPWR	VNB	6.65318e-17
C113	VGND	VNB	6.03368e-17
C114	Z#1	VPWR#2	3.13942e-17
C115	VGND#2	TE_B#1	5.10078e-19
C116	VPWR#2	a_22_46#	9.16714e-19
C117	VPWR#2	TE_B#4	3.8148e-18
C118	VGND#2	a_22_46##2	7.46809e-17
C119	VGND	VGND#2	9.56737e-17
C120	VGND#2	Z#2	2.01204e-17
C121	VPWR#2	TE_B#2	5.53049e-19
C122	VGND#2	a_22_46#	1.10134e-17
C123	a_22_46##3	VPWR#2	8.659e-18
C124	VGND#2	A#2	9.10259e-20
C125	VPWR#2	A#1	7.4309e-18
C126	VGND#2	A#4	1.27851e-18
C127	VGND#2	VNB	2.12468e-16
C128	VGND#2	TE_B#3	1.18457e-18
C129	VGND#2	TE_B#2	5.59209e-19
C130	VPWR#2	TE_B#1	4.90664e-18
C131	VPWR#2	VNB	2.17514e-16
C132	VPWR#2	A#2	4.50366e-20
C133	VGND#2	A#3	6.03486e-18
C134	A#6	VPWR#2	9.24904e-19
C135	VPWR	VPWR#2	7.08874e-17
*
*
.ENDS sky130_fd_sc_hs__einvn_1
*
