* Extracted by Quantus, converted by sky130cad/quantus.py
*
*
*
*                       LINUX           Wed Nov 18 08:31:51 2026
*
*
*
*  PROGRAM  advgen
*
*  Name           : advgen - Quantus - (64-bit)
*  Version        : 25.1.0-p047
*  Build Date     : Thu Dec 11 23:20:30 PST 2025
*
*  HSPICE LIBRARY
*
*  OPERATING_TEMPERATURE 150
*  QRC_TECH_DIR <path>/tech
*
*
*

*
.SUBCKT sky130_fd_sc_hs__dlrtn_2 VPB VNB VGND VPWR Q RESET_B D GATE_N
*
*
*  caps2d version: 10
*
*
*       TRANSISTOR CARDS
*
*
XM4 a_27_136##5 D#3 VGND#12 VNB sky130_fd_pr__nfet_01v8_lvt l=0.15 w=0.55 ad=0.15675 as=0.40125 pd=1.67 ps=2.98
XM0 VGND#12 GATE_N#3 a_232_98##13 VNB sky130_fd_pr__nfet_01v8_lvt l=0.15 w=0.74 ad=0.40125 as=0.2257 pd=2.98 ps=2.09
XM18 a_373_82##9 a_232_98# VGND#8 VNB sky130_fd_pr__nfet_01v8_lvt l=0.15 w=0.74 ad=0.2294 as=0.8418 pd=2.1 ps=3.96
XM3 VGND#8 a_27_136# a_697_74# VNB sky130_fd_pr__nfet_01v8_lvt l=0.15 w=0.64 ad=0.8418 as=0.1536 pd=3.96 ps=1.76
XM1 a_697_74# a_232_98##7 a_670_392##5 VNB sky130_fd_pr__nfet_01v8_lvt l=0.15 w=0.64 ad=0.1536 as=0.1915 pd=1.76 ps=1.93
XM8 a_670_392##5 a_373_82##3 a_870_74# VNB sky130_fd_pr__nfet_01v8_lvt l=0.15 w=0.42 ad=0.1915 as=0.1155 pd=1.93 ps=1.39
XM10 a_870_74# a_913_406# VGND#7 VNB sky130_fd_pr__nfet_01v8_lvt l=0.15 w=0.42 ad=0.1155 as=0.1197 pd=1.39 ps=1.41
XM17 a_913_406##16 a_670_392# a_1153_74# VNB sky130_fd_pr__nfet_01v8_lvt l=0.15 w=0.74 ad=0.2109 as=0.1776 pd=2.05 ps=1.96
XM15 a_1153_74# RESET_B#3 VGND#6 VNB sky130_fd_pr__nfet_01v8_lvt l=0.15 w=0.74 ad=0.1776 as=0.6845 pd=1.96 ps=3.33
XM12 VGND#6 a_913_406##9 Q#3 VNB sky130_fd_pr__nfet_01v8_lvt l=0.15 w=0.74 ad=0.6845 as=0.2072 pd=3.33 ps=2.04
XM21 Q#3 a_913_406##8 VGND#1 VNB sky130_fd_pr__nfet_01v8_lvt l=0.15 w=0.74 ad=0.2072 as=0.2627 pd=2.04 ps=2.19
XM16 a_27_136##7 D#1 VPWR#12 VPB sky130_fd_pr__pfet_01v8 l=0.15 w=0.84 ad=0.2478 as=0.336 pd=2.27 ps=2.48
XM11 VPWR#12 GATE_N#1 a_232_98##10 VPB sky130_fd_pr__pfet_01v8 l=0.15 w=0.84 ad=0.336 as=0.2478 pd=2.48 ps=2.27
XM14 a_373_82##8 a_232_98##4 VPWR#11 VPB sky130_fd_pr__pfet_01v8 l=0.15 w=0.84 ad=0.2478 as=0.5165 pd=2.27 ps=3.36
XM7 VPWR#11 a_27_136##3 a_586_392# VPB sky130_fd_pr__pfet_01v8 l=0.15 w=1 ad=0.5165 as=0.27 pd=3.36 ps=2.54
XM2 a_586_392# a_373_82# a_670_392##7 VPB sky130_fd_pr__pfet_01v8 l=0.15 w=1 ad=0.27 as=0.3371 pd=2.54 ps=2.78
XM9 a_670_392##7 a_232_98##8 a_778_504# VPB sky130_fd_pr__pfet_01v8 l=0.15 w=0.42 ad=0.3371 as=0.2898 pd=2.78 ps=2.22
XM6 a_778_504# a_913_406##3 VPWR#10 VPB sky130_fd_pr__pfet_01v8 l=0.15 w=0.42 ad=0.2898 as=0.5383 pd=2.22 ps=3.92
XM13 VPWR#10 a_670_392##4 a_913_406##13 VPB sky130_fd_pr__pfet_01v8 l=0.15 w=1.12 ad=0.5383 as=0.3472 pd=3.92 ps=2.86
XM19 a_913_406##13 RESET_B#1 VPWR#9 VPB sky130_fd_pr__pfet_01v8 l=0.15 w=1.12 ad=0.3472 as=0.9968 pd=2.86 ps=4.02
XM5 VPWR#9 a_913_406##10 Q#1 VPB sky130_fd_pr__pfet_01v8 l=0.15 w=1.12 ad=0.9968 as=0.336 pd=4.02 ps=2.84
XM20 Q#1 a_913_406##4 VPWR#1 VPB sky130_fd_pr__pfet_01v8 l=0.15 w=1.12 ad=0.336 as=0.3976 pd=2.84 ps=2.95
*
*
*       RESISTOR AND CAP/DIODE CARDS
*
Rg1	D#1	D#2	384.586975
Rg2	D#2	D#3	343.399017
Rg3	GATE_N#1	GATE_N#2	367.623138
Rg4	GATE_N#2	GATE_N#3	371.062500
Rg5	a_232_98#	a_232_98##2	343.439178
Rg6	a_232_98##2	a_232_98##3	340.039551
Rg7	a_232_98##2	a_232_98##4	479.615845
Rg8	a_373_82#	a_373_82##2	560.440308
Rg9	a_27_136#	a_27_136##2	561.815308
Rg10	a_27_136##2	a_27_136##3	492.429810
Rg11	a_232_98##5	a_232_98##6	50.300888
Rg12	a_232_98##6	a_232_98##7	816.474976
Rg13	a_232_98##6	a_232_98##8	248.803528
Rg14	a_373_82##3	a_373_82##4	382.539764
Rg15	a_913_406#	a_913_406##2	819.276672
Rg16	a_913_406##2	a_913_406##3	233.787552
Rg17	a_670_392#	a_670_392##2	397.590515
Rg18	a_670_392##2	a_670_392##3	243.990448
Rg19	a_670_392##2	a_670_392##4	449.490784
Rg20	RESET_B#1	RESET_B#2	492.059540
Rg21	RESET_B#2	RESET_B#3	307.937683
Rg22	a_913_406##4	a_913_406##5	516.454041
Rg23	a_913_406##5	a_913_406##6	175.687637
Rg24	a_913_406##6	a_913_406##7	166.343643
Rg25	a_913_406##5	a_913_406##8	354.916412
Rg26	a_913_406##6	a_913_406##9	404.262573
Rg27	a_913_406##6	a_913_406##10	435.824982
Rf1	D#2	D#5	161.051773
Rf2	D#6	D	0.818971
Rf3	D#5	D#6	4.724072
Rf4	GATE_N#2	GATE_N	162.201172
Rf5	a_27_136##2	a_27_136##6	370.424805
Rf6	a_27_136##6	a_27_136##7	89.301514
Rf7	a_27_136##5	a_27_136##6	15.000000
Rf8	a_232_98##5	a_232_98##11	364.726471
Rf9	a_232_98##11	a_232_98##3	44.657024
Rf10	a_232_98##3	a_232_98##13	43.908150
Rf11	a_232_98##10	a_232_98##11	7.500000
Rf12	a_373_82##4	a_373_82##2	202.514740
Rf13	a_373_82##2	a_373_82##7	86.940361
Rf14	a_373_82##7	a_373_82##8	22.822226
Rf15	a_373_82##7	a_373_82##9	75.380325
Rf16	a_670_392##5	a_670_392##3	129.181885
Rf17	a_670_392##3	a_670_392##7	163.379608
Rf18	RESET_B	RESET_B#4	1.406682
Rf19	RESET_B#5	RESET_B#2	161.639481
Rf20	RESET_B#4	RESET_B#5	4.941762
Rf21	a_913_406##7	a_913_406##12	220.216629
Rf22	a_913_406##12	a_913_406##14	12.943274
Rf23	a_913_406##14	a_913_406##2	203.065918
Rf24	a_913_406##12	a_913_406##16	70.358658
Rf25	a_913_406##13	a_913_406##14	5.000000
Rf26	Q	Q#2	0.096609
Rf27	Q#2	Q	7.052421
Rf28	Q	Q#3	77.256020
Rf29	Q#1	Q#2	5.000000
Rf30	VPWR#1	VPWR#2	65.192429
Rf31	VPWR#2	VPWR#3	69.738693
Rf32	VPWR#3	VPWR#4	99.158669
Rf33	VPWR#4	VPWR#5	129.499161
Rf34	VPWR#5	VPWR#6	59.511623
Rf35	VPWR#6	VPWR#7	116.466469
Rf37	VPWR#3	VPWR#9	36.061966
Rf38	VPWR#4	VPWR#10	14.765843
Rf39	VPWR#6	VPWR#11	23.681496
Rf40	VPWR#7	VPWR#12	41.179714
Rf41	VGND#1	VGND#2	61.061543
Rf42	VGND#2	VGND#3	62.948936
Rf43	VGND#3	VGND#4	122.095306
Rf44	VGND#4	VGND#5	113.568993
Rf45	VGND#3	VGND#6	12.647206
Rf46	VGND#4	VGND#7	31.948624
Rf47	VGND#5	VGND#9	14.140693
Rf48	VGND#9	VGND#10	133.923920
Rf50	VGND#10	VGND#12	24.468842
Rf51	VGND#8	VGND#9	7.500000
Re1	VPWR#2	VPWR	4.549932
Re2	VPWR	VPWR#5	0.974985
Re3	VGND#2	VGND	4.549932
Re4	VGND	VGND#5	0.974985
*
*       CAPACITOR CARDS
*
*
C1	a_232_98##10	a_670_392##7	2.52323e-20
C2	a_670_392##5	a_232_98#	2.24575e-18
C3	a_373_82##7	a_373_82#	5.94379e-19
C4	a_27_136#	VGND#8	1.07139e-17
C5	a_232_98##10	VPWR#11	6.81408e-18
C6	a_373_82##9	a_27_136#	2.14009e-19
C7	Q#3	a_913_406##6	1.01413e-17
C8	a_232_98#	VGND#8	3.09583e-17
C9	a_373_82##7	a_27_136##3	1.95983e-18
C10	a_232_98##10	a_373_82##8	3.34362e-18
C11	VGND#2	VGND#3	5.38388e-17
C12	a_373_82##9	a_232_98#	3.61193e-17
C13	Q#3	a_913_406##5	1.29561e-17
C14	VGND#8	GATE_N#3	6.33611e-19
C15	a_232_98##13	a_232_98#	6.50376e-19
C16	a_373_82##7	a_232_98##4	3.14662e-17
C17	VPWR#2	VPWR#3	1.85784e-17
C18	a_373_82##9	GATE_N#3	5.36079e-19
C19	VPWR#4	VPWR#3	8.17482e-19
C20	VPWR#12	a_232_98##10	7.78468e-17
C21	a_232_98##13	GATE_N#3	4.12683e-17
C22	VPWR#3	VPWR#1	6.95628e-19
C23	a_373_82##7	GATE_N#1	6.83376e-19
C24	a_27_136##5	a_232_98#	4.91208e-19
C25	GATE_N#3	VGND#12	2.05529e-17
C26	VGND#5	VGND#4	2.70877e-19
C27	a_232_98##13	D#3	4.43771e-18
C28	a_27_136##7	VPWR#12	7.8235e-17
C29	VGND#3	a_913_406##12	6.0733e-19
C30	a_27_136##5	GATE_N#3	3.58801e-17
C31	D#3	VGND#12	1.75794e-17
C32	a_373_82#	a_232_98##6	1.805e-17
C33	VPWR#4	VPWR#9	1.49835e-18
C34	a_27_136##5	D#3	5.08032e-17
C35	VGND#3	a_913_406##7	3.93223e-17
C36	a_913_406##6	a_913_406##5	7.77301e-18
C37	a_913_406##12	a_913_406##6	3.17618e-21
C38	a_232_98##10	a_232_98##6	2.00613e-19
C39	a_913_406##9	a_913_406##8	3.88877e-17
C40	VGND#3	RESET_B#2	3.10874e-18
C41	a_232_98##10	a_232_98##2	9.86217e-20
C42	VPWR#1	a_913_406##4	3.02914e-17
C43	VPWR#4	VPWR#10	1.54633e-17
C44	a_913_406##7	VPWR#3	8.86857e-19
C45	a_373_82##9	a_373_82##7	2.77543e-18
C46	a_913_406##4	Q#1	2.44089e-17
C47	VGND#4	a_670_392##3	7.13364e-19
C48	VGND#3	RESET_B#5	2.61947e-17
C49	VPWR#1	a_913_406##10	1.45875e-18
C50	RESET_B#3	a_913_406##9	3.78212e-18
C51	VPWR#9	a_913_406##4	8.41548e-19
C52	VPWR#3	RESET_B#2	2.81589e-19
C53	a_913_406##10	Q#1	2.37354e-17
C54	a_913_406##12	a_670_392##2	2.25163e-17
C55	a_913_406##12	VPWR#4	6.79534e-17
C56	VPWR#1	RESET_B#1	3.75297e-19
C57	a_913_406##12	a_913_406##7	2.45282e-18
C58	a_913_406##10	VPWR#9	4.32519e-17
C59	Q#3	VGND#1	7.52794e-17
C60	VGND#3	RESET_B#4	1.64432e-18
C61	a_913_406##16	a_670_392##2	1.56891e-18
C62	a_670_392#	RESET_B#3	5.20661e-17
C63	a_670_392##3	VPWR#4	3.17775e-18
C64	a_913_406##12	VPWR#9	5.80651e-17
C65	a_913_406##12	a_232_98##6	2.79055e-19
C66	RESET_B#1	VPWR#9	2.29148e-17
C67	a_913_406##12	VPWR#3	6.52382e-18
C68	RESET_B#5	a_913_406##7	2.44289e-17
C69	a_913_406##12	RESET_B#2	4.23835e-18
C70	VGND#4	a_373_82##4	2.90015e-19
C71	RESET_B#1	a_913_406##13	2.42438e-17
C72	a_913_406##2	VPWR#4	3.95369e-17
C73	VPWR#9	a_670_392##4	1.00623e-18
C74	a_913_406#	a_670_392#	5.49584e-18
C75	a_913_406##12	a_913_406##13	9.87154e-19
C76	a_670_392##4	a_913_406##13	2.42438e-17
C77	RESET_B#5	RESET_B#2	1.20583e-17
C78	a_670_392##3	a_913_406##12	6.69128e-17
C79	VPWR#9	a_913_406##3	1.93272e-19
C80	VPWR#6	VPWR#11	9.67268e-18
C81	RESET_B#4	RESET_B#2	6.14294e-18
C82	a_670_392##4	VPWR#10	1.66476e-17
C83	VPWR#2	Q#3	1.43507e-18
C84	a_913_406##12	VPWR#10	2.70565e-18
C85	VPWR#4	a_373_82##4	4.12291e-19
C86	a_373_82##3	a_913_406#	3.31251e-17
C87	VGND#2	VGND#1	2.60154e-17
C88	a_913_406##3	VPWR#10	1.41128e-17
C89	a_913_406##12	a_913_406##2	1.0987e-18
C90	a_670_392##7	a_670_392##4	1.65305e-19
C91	RESET_B#5	a_913_406##6	2.52325e-19
C92	VGND#2	Q#3	3.73732e-17
C93	a_232_98##5	VPWR#6	1.03006e-18
C94	a_913_406##16	Q#3	1.81959e-18
C95	a_232_98##7	a_373_82##3	2.56023e-17
C96	a_232_98##5	VPWR#4	1.27404e-17
C97	a_232_98##10	VPWR#6	5.71533e-17
C98	a_232_98##8	a_670_392##7	1.02124e-17
C99	a_27_136#	a_232_98##7	6.27088e-17
C100	a_670_392##7	a_373_82#	2.99422e-17
C101	a_232_98##5	a_913_406##12	3.029e-18
C102	VPWR#12	VPWR#6	3.63017e-18
C103	VPWR#6	a_27_136##2	3.08555e-19
C104	a_232_98#	a_27_136#	3.39247e-18
C105	a_670_392##7	a_27_136##3	1.99782e-18
C106	a_913_406##7	Q#3	8.42003e-18
C107	VGND#3	a_913_406##8	1.2024e-18
C108	a_913_406##7	VGND#6	5.21648e-18
C109	a_232_98##10	a_232_98##8	5.56762e-19
C110	VGND#5	VGND#7	5.24796e-19
C111	VPWR#2	a_913_406##6	3.36931e-20
C112	a_670_392##7	a_232_98##4	9.94649e-19
C113	a_27_136##3	VPWR#11	2.50441e-17
C114	a_670_392##5	a_232_98##6	4.07813e-20
C115	VPWR#6	a_232_98##3	1.32876e-19
C116	VPWR#2	a_913_406##5	4.06813e-20
C117	Q#3	RESET_B#2	1.30555e-18
C118	GATE_N#3	a_232_98#	4.31231e-18
C119	VGND#7	a_913_406##16	2.77107e-17
C120	a_232_98##10	a_373_82#	5.9557e-19
C121	VGND#5	a_670_392##5	1.72924e-17
C122	RESET_B#2	VGND#6	8.0991e-19
C123	VPWR#2	VPWR#1	2.94948e-17
C124	VGND#3	a_913_406##9	1.82431e-17
C125	RESET_B#4	a_670_392##2	4.43148e-18
C126	a_232_98##4	VPWR#11	2.31461e-17
C127	a_232_98##10	a_27_136##3	2.01265e-17
C128	VGND#5	VGND#8	6.869e-19
C129	a_913_406##16	RESET_B#2	7.91238e-19
C130	a_232_98##4	a_373_82##8	1.88803e-17
C131	D#3	GATE_N#3	2.01083e-17
C132	a_373_82##7	a_373_82##2	3.6484e-18
C133	VGND#2	VPWR#1	4.88009e-18
C134	VPWR#12	a_27_136##3	6.62717e-19
C135	a_232_98##10	a_232_98##4	1.53477e-17
C136	VGND#3	RESET_B#3	3.65398e-17
C137	VGND#2	a_913_406##6	1.53217e-18
C138	a_670_392##5	a_913_406##16	1.69696e-18
C139	VPWR#12	a_232_98##4	1.15283e-18
C140	a_670_392##3	a_913_406##16	4.82427e-17
C141	a_373_82##7	a_670_392##7	4.60166e-18
C142	VGND#2	a_913_406##5	5.22762e-20
C143	a_232_98##10	GATE_N#1	5.63507e-17
C144	a_27_136##2	a_373_82##7	1.84957e-17
C145	VGND#7	a_670_392##3	3.23641e-17
C146	a_27_136##7	a_232_98##4	5.01569e-20
C147	GATE_N#1	VPWR#12	2.52713e-17
C148	RESET_B#5	a_913_406##12	1.90818e-17
C149	a_670_392##5	VGND#7	1.18813e-17
C150	a_670_392##5	a_670_392##3	7.41255e-18
C151	VGND#3	a_670_392#	8.08197e-18
C152	a_27_136##7	GATE_N#1	3.46095e-20
C153	VGND#7	a_913_406##2	2.17777e-19
C154	D#1	VPWR#12	3.28747e-17
C155	a_232_98##3	a_373_82##7	4.71615e-17
C156	a_27_136##5	D#5	2.05777e-17
C157	VGND#4	a_913_406#	4.82628e-18
C158	a_27_136##7	D#1	4.10975e-17
C159	a_913_406##12	RESET_B#4	4.10739e-17
C160	a_913_406#	a_670_392##2	4.20902e-19
C161	a_373_82##7	VPWR#11	4.84489e-18
C162	VGND#3	a_913_406#	2.49089e-19
C163	a_913_406##7	VPWR#9	3.44812e-17
C164	a_913_406##10	a_913_406##4	4.71733e-17
C165	a_373_82##7	GATE_N#2	3.5067e-19
C166	a_670_392##5	a_373_82##4	6.45718e-17
C167	VGND#4	a_373_82##3	5.47191e-18
C168	VPWR#6	a_778_504#	3.80051e-19
C169	VGND#8	a_232_98##2	4.54782e-20
C170	VGND#1	VPWR#1	1.39389e-17
C171	a_373_82##7	a_373_82##8	1.82702e-18
C172	RESET_B#1	a_913_406##10	5.95069e-18
C173	a_670_392##5	a_232_98##5	3.89046e-19
C174	a_373_82##7	a_232_98##6	7.93155e-20
C175	VGND#2	a_913_406##8	9.86663e-18
C176	a_670_392##4	RESET_B#1	4.34556e-17
C177	a_232_98##10	a_373_82##7	9.68358e-17
C178	a_670_392##3	VPWR#10	5.64508e-19
C179	VGND#2	a_913_406##9	3.36411e-18
C180	a_373_82##7	a_232_98##2	5.95726e-18
C181	VGND#8	a_373_82##2	4.6551e-18
C182	VGND#5	a_232_98##6	3.96043e-21
C183	a_373_82##9	a_232_98##2	1.21031e-17
C184	a_913_406##2	VPWR#10	1.42267e-18
C185	a_27_136##2	a_670_392##5	1.4007e-17
C186	a_913_406##3	a_670_392##4	4.69242e-18
C187	a_27_136##2	VGND#8	1.00842e-16
C188	a_670_392##7	a_913_406##2	6.44003e-19
C189	D#5	D#2	1.00981e-17
C190	a_27_136##2	a_373_82##9	7.52716e-17
C191	a_913_406##7	a_913_406##6	1.58781e-17
C192	a_232_98##8	a_913_406##3	8.27868e-18
C193	a_913_406##7	a_913_406##5	8.76627e-19
C194	a_373_82##4	a_670_392##7	3.99301e-17
C195	a_27_136##2	VGND#12	5.85699e-21
C196	VGND#8	a_232_98##3	1.75413e-19
C197	a_913_406##7	a_670_392##2	1.61165e-19
C198	VGND#5	a_913_406#	2.91687e-19
C199	RESET_B#5	a_913_406##9	7.93248e-19
C200	a_232_98##3	a_373_82##9	3.01675e-17
C201	RESET_B#2	a_913_406##9	1.82367e-19
C202	VGND#5	a_373_82##3	5.61288e-19
C203	a_232_98##13	a_232_98##2	5.53528e-20
C204	a_232_98##13	a_232_98##3	3.26995e-18
C205	a_373_82#	a_232_98##8	2.00017e-17
C206	a_232_98##5	a_670_392##7	1.08579e-16
C207	VGND#5	a_232_98##7	1.06164e-17
C208	GATE_N	a_232_98##2	5.49776e-20
C209	a_670_392#	RESET_B#2	5.38613e-18
C210	a_27_136##5	a_232_98##3	4.11105e-18
C211	VGND#5	a_27_136#	1.5074e-17
C212	a_232_98##13	GATE_N#2	2.953e-18
C213	a_373_82##2	a_670_392##7	7.38382e-17
C214	VPWR#2	a_913_406##4	1.01715e-17
C215	a_27_136##3	a_373_82#	5.11499e-17
C216	RESET_B#2	a_913_406##6	1.60087e-18
C217	a_670_392##3	a_670_392#	1.00792e-18
C218	VPWR#2	a_913_406##10	5.12986e-18
C219	VGND#3	VGND#1	3.5823e-18
C220	a_27_136##5	GATE_N#2	8.87344e-19
C221	a_232_98##13	a_373_82##9	2.67604e-17
C222	a_670_392##3	a_913_406#	2.11086e-17
C223	a_670_392##2	RESET_B#2	2.69497e-17
C224	a_232_98##4	a_27_136##3	2.24637e-17
C225	a_373_82##2	a_232_98##10	4.96733e-18
C226	a_670_392##3	a_232_98##7	1.30981e-19
C227	a_27_136##5	D#2	6.87705e-18
C228	VGND#8	a_27_136##5	9.47051e-19
C229	GATE_N#1	a_27_136##3	2.14154e-19
C230	a_373_82##4	a_670_392#	1.17711e-19
C231	a_670_392##3	a_27_136#	2.91417e-19
C232	RESET_B#4	a_670_392#	9.70314e-20
C233	VGND#3	Q#3	6.2839e-17
C234	a_232_98##10	a_27_136##2	1.13404e-18
C235	a_373_82##4	a_913_406#	2.95149e-17
C236	GATE_N#1	a_232_98##4	4.82546e-18
C237	a_913_406##7	a_913_406##4	1.30368e-19
C238	a_373_82##4	a_232_98##7	4.9358e-17
C239	a_232_98##3	a_232_98##10	3.50622e-18
C240	a_913_406##7	a_913_406##10	2.46072e-19
C241	D#1	GATE_N#1	2.42736e-17
C242	VPWR#12	a_232_98##3	1.28424e-18
C243	VPWR#5	a_232_98##8	7.8743e-18
C244	a_670_392##3	a_670_392##2	6.66713e-19
C245	a_27_136##7	a_232_98##3	1.1785e-18
C246	VGND#3	VGND#6	2.2038e-17
C247	a_27_136##5	a_232_98##13	6.79905e-17
C248	a_27_136##5	a_232_98##2	6.6496e-20
C249	a_670_392##3	a_232_98##6	1.09251e-19
C250	VPWR#5	a_373_82#	7.48269e-18
C251	VPWR#12	GATE_N#2	2.77444e-18
C252	a_373_82##2	a_232_98##7	1.89823e-17
C253	a_27_136##7	GATE_N#2	2.01889e-19
C254	a_27_136##2	a_913_406#	9.11338e-20
C255	a_27_136##5	VGND#12	5.46882e-18
C256	a_373_82##2	a_27_136#	3.31959e-17
C257	a_27_136##2	a_373_82##3	8.39173e-19
C258	VGND#3	a_913_406##6	2.06392e-18
C259	a_670_392##3	a_670_392##4	1.35524e-18
C260	a_27_136##2	a_232_98##7	3.93107e-18
C261	a_27_136##7	D#2	1.08483e-17
C262	a_27_136##2	a_27_136#	8.09431e-18
C263	VGND#4	a_670_392##2	3.98307e-20
C264	a_913_406##2	a_670_392##4	7.41455e-18
C265	VGND#4	a_913_406##16	1.56425e-17
C266	a_27_136##2	a_232_98#	4.07463e-17
C267	a_27_136##2	GATE_N#3	5.50654e-19
C268	a_913_406##2	a_670_392##2	8.03601e-19
C269	a_27_136##2	D#3	3.06936e-19
C270	a_232_98##6	a_913_406##2	5.21004e-18
C271	GATE_N#3	a_232_98##2	1.74274e-19
C272	a_232_98##3	GATE_N#3	4.35329e-19
C273	VGND#3	a_913_406##16	3.59636e-17
C274	Q	a_913_406##6	5.82237e-18
C275	a_232_98##5	a_670_392##4	4.27335e-19
C276	Q	a_913_406##5	4.67119e-18
C277	a_232_98##3	D#3	4.7768e-19
C278	D#5	a_27_136##7	4.93584e-17
C279	a_232_98##5	a_913_406##3	6.23946e-18
C280	a_232_98##5	a_232_98##8	1.39275e-17
C281	VPWR#2	a_913_406##7	5.11241e-18
C282	a_232_98##5	a_373_82#	2.35686e-17
C283	VGND#2	a_913_406##7	3.88211e-18
C284	a_232_98##5	a_27_136##3	8.47275e-18
C285	VGND#7	VGND#3	1.06158e-18
C286	a_373_82##2	a_373_82#	7.19692e-18
C287	a_232_98##5	a_232_98##4	3.35944e-19
C288	a_373_82##4	a_670_392##2	5.69567e-20
C289	a_373_82##2	a_27_136##3	2.9832e-17
C290	a_373_82##4	a_232_98##6	5.82513e-20
C291	VGND#1	a_913_406##8	2.35502e-17
C292	a_373_82##2	a_232_98##4	2.29344e-19
C293	RESET_B#3	a_1153_74#	1.73994e-17
C294	VPWR#4	a_913_406##10	3.69542e-19
C295	a_670_392#	a_1153_74#	1.73994e-17
C296	VPWR#9	VPWR#1	8.32938e-19
C297	a_232_98##4	a_27_136##2	1.62357e-18
C298	RESET_B#2	a_913_406##7	3.32614e-17
C299	Q#3	a_913_406##8	4.05033e-17
C300	a_232_98##3	a_232_98##4	3.87747e-19
C301	VGND#1	a_913_406##9	1.46589e-18
C302	VGND#4	a_670_392##5	9.18132e-18
C303	a_232_98##3	GATE_N#1	2.03492e-18
C304	VGND#5	a_373_82##4	5.47411e-19
C305	GATE_N#2	a_232_98##4	1.30768e-18
C306	a_232_98##5	VPWR#5	1.80519e-17
C307	VPWR#4	RESET_B#1	1.2896e-18
C308	a_232_98##3	D#1	3.83526e-20
C309	VGND#5	a_232_98##5	3.83035e-20
C310	Q#3	a_913_406##9	3.94795e-17
C311	a_913_406#	a_870_74#	9.10064e-18
C312	VPWR#5	a_373_82##2	4.85109e-20
C313	a_913_406##3	a_778_504#	9.74171e-18
C314	VGND#4	VGND#3	5.15799e-19
C315	a_670_392##3	a_913_406##2	1.05005e-16
C316	a_373_82##3	a_870_74#	9.10064e-18
C317	VPWR#3	RESET_B#1	5.76714e-18
C318	VGND#1	RESET_B#3	1.54745e-19
C319	VGND#5	a_373_82##2	5.97058e-18
C320	a_232_98##8	a_778_504#	1.34757e-17
C321	VPWR#5	a_27_136##2	6.34694e-20
C322	a_232_98##5	a_232_98##6	5.27686e-19
C323	a_373_82##4	a_670_392##3	3.927e-17
C324	a_913_406##6	a_913_406##4	5.09044e-18
C325	a_913_406##9	VGND#6	4.28889e-18
C326	VGND	a_670_392##2	1.97777e-21
C327	a_373_82##4	a_913_406##2	1.44379e-17
C328	a_670_392##3	a_232_98##5	1.87346e-17
C329	VGND	a_232_98##2	5.2071e-19
C330	Q#3	RESET_B#3	7.19611e-19
C331	VPWR#4	a_670_392##4	1.62445e-17
C332	a_373_82#	a_586_392#	2.06649e-17
C333	a_232_98##5	a_913_406##2	5.91945e-17
C334	a_373_82##2	a_670_392##3	6.49133e-19
C335	a_27_136##3	a_586_392#	2.06649e-17
C336	a_373_82##4	a_232_98##5	1.00436e-17
C337	a_373_82##2	a_913_406##2	9.43164e-20
C338	a_232_98##7	a_697_74#	1.50481e-17
C339	RESET_B#3	VGND#6	2.50755e-17
C340	a_913_406##12	a_913_406##10	1.37606e-18
C341	VGND#3	Q	6.92384e-18
C342	a_27_136#	a_697_74#	1.50481e-17
C343	a_232_98##13	GATE_N	2.27199e-17
C344	VPWR#6	a_913_406##3	1.21974e-18
C345	Q#3	a_670_392#	2.43321e-19
C346	a_27_136##5	GATE_N	5.0425e-18
C347	a_913_406##16	a_913_406##9	3.97457e-19
C348	Q	VPWR#3	8.84651e-18
C349	a_373_82##2	a_232_98##5	1.20958e-17
C350	a_27_136##2	a_373_82##4	1.63439e-19
C351	VPWR#4	a_913_406##3	2.88654e-17
C352	a_913_406##12	Q	2.75714e-18
C353	a_232_98##5	a_27_136##2	2.64585e-19
C354	a_373_82##2	a_232_98##6	2.23356e-17
C355	a_373_82##2	a_27_136##2	8.55108e-17
C356	a_27_136##5	D	6.41356e-18
C357	a_913_406##12	RESET_B#1	5.8504e-17
C358	a_373_82##2	a_232_98##2	2.55238e-19
C359	a_913_406##16	RESET_B#3	9.16593e-18
C360	a_913_406##6	VNB	2.25829e-17
C361	a_913_406##5	VNB	3.43972e-17
C362	a_670_392##2	VNB	2.15561e-17
C363	a_232_98##6	VNB	4.11262e-17
C364	VPWR#6	a_232_98##8	2.22544e-18
C365	a_232_98##2	VNB	2.15358e-17
C366	VPWR	VPWR#6	9.2089e-17
C367	a_27_136##2	a_232_98##3	4.12988e-18
C368	VPWR	VPWR#4	1.6089e-16
C369	GATE_N	VPWR#12	2.7194e-17
C370	VPWR	VPWR#3	4.86785e-17
C371	VPWR#4	a_232_98##8	4.27294e-18
C372	VPWR	a_913_406##12	2.45023e-17
C373	VGND#7	RESET_B#3	5.63367e-19
C374	Q#3	Q	6.32895e-18
C375	GATE_N#2	a_232_98##3	2.90407e-17
C376	VPWR	RESET_B#5	1.57305e-18
C377	VPWR	RESET_B#4	1.35891e-18
C378	a_232_98##5	a_778_504#	7.26053e-18
C379	a_913_406##16	a_670_392#	5.76986e-17
C380	VPWR	a_373_82##7	9.88637e-18
C381	D	VPWR#12	2.21186e-17
C382	a_232_98##3	D#2	3.6961e-19
C383	a_913_406##12	a_670_392##4	5.18255e-17
C384	a_232_98##5	a_586_392#	4.01501e-18
C385	D#2	GATE_N#2	2.55553e-17
C386	VGND	VGND#4	9.07744e-17
C387	VGND	VGND#3	9.85513e-17
C388	VPWR#6	a_373_82#	2.79133e-18
C389	a_373_82##2	a_586_392#	7.29793e-19
C390	VGND#7	a_670_392#	2.70712e-18
C391	VPWR	D#5	1.94931e-18
C392	Q	VPWR#1	1.11927e-16
C393	Q	Q#1	8.9284e-19
C394	Q	VPWR#9	9.07851e-17
C395	VGND	a_913_406##12	4.21326e-18
C396	VPWR#4	a_373_82#	1.61195e-18
C397	a_913_406##16	a_913_406#	3.03378e-18
C398	VGND	RESET_B#5	1.48365e-18
C399	VGND	RESET_B#4	4.55419e-18
C400	RESET_B#1	a_913_406##6	4.21017e-19
C401	VGND	a_373_82##7	3.58015e-18
C402	a_232_98##2	a_27_136##2	2.80883e-17
C403	RESET_B#5	Q#3	4.60168e-18
C404	a_913_406##12	a_913_406##3	1.20162e-18
C405	VGND#7	a_913_406#	2.94924e-17
C406	a_27_136##5	VPWR#12	3.17965e-18
C407	GATE_N	a_232_98##4	1.42535e-19
C408	VPWR	VPWR#9	2.09269e-17
C409	VGND	D#5	1.83178e-18
C410	VGND#4	VNB	4.84143e-17
C411	VGND#3	VNB	5.57463e-17
C412	VPWR#6	a_27_136##3	1.82356e-17
C413	VPWR#6	VNB	4.94333e-17
C414	VPWR#4	VNB	6.57974e-17
C415	VPWR	a_670_392##7	6.28865e-18
C416	a_913_406##16	a_913_406##12	2.1998e-18
C417	a_913_406##16	a_373_82##3	2.09811e-19
C418	VGND	a_913_406##16	2.05917e-17
C419	VPWR#3	VNB	3.54198e-17
C420	a_670_392##5	a_670_392#	2.85945e-19
C421	VGND	VGND#7	1.81832e-17
C422	VPWR#3	a_913_406##6	1.57234e-20
C423	VGND	a_670_392##5	2.44713e-17
C424	a_913_406##12	VNB	8.42948e-18
C425	VPWR	a_232_98##10	3.76609e-17
C426	VGND	VGND#8	1.20622e-16
C427	a_670_392##2	RESET_B#1	2.12245e-18
C428	VGND	a_373_82##9	6.27477e-18
C429	RESET_B#5	VNB	2.20987e-18
C430	VPWR#4	a_27_136##3	1.02202e-18
C431	VGND	a_232_98##13	8.28752e-18
C432	VPWR	a_27_136##7	2.21944e-17
C433	VPWR#4	a_670_392##2	1.08152e-19
C434	a_373_82##7	VNB	1.01262e-17
C435	VGND	a_27_136##5	3.6985e-17
C436	Q	a_913_406##4	3.64459e-17
C437	a_27_136##5	a_27_136##7	3.0947e-18
C438	Q	a_913_406##10	5.46906e-17
C439	VGND#7	a_373_82##3	3.92956e-18
C440	Q	RESET_B#1	2.72812e-18
C441	a_913_406##12	a_232_98##8	2.62575e-19
C442	VGND	a_670_392##7	3.32932e-18
C443	VPWR#6	a_232_98##2	3.6703e-20
C444	D#5	VNB	2.25368e-18
C445	VGND#1	VNB	4.78258e-17
C446	Q#3	VNB	1.05625e-17
C447	a_913_406##16	VNB	8.8064e-18
C448	a_670_392##5	a_913_406#	1.93064e-17
C449	VGND#7	VNB	3.69807e-18
C450	a_670_392##5	VNB	9.13455e-18
C451	VGND#8	VNB	5.01045e-17
C452	VPWR#6	a_232_98##4	1.13476e-17
C453	a_373_82##9	VNB	3.42488e-18
C454	VGND	RESET_B#3	5.86909e-19
C455	a_232_98##13	VNB	5.43047e-18
C456	VPWR	RESET_B#1	4.14348e-19
C457	VGND	a_670_392#	2.15644e-18
C458	VGND	a_913_406#	1.15362e-18
C459	a_27_136##5	VNB	5.34748e-17
C460	VPWR#1	VNB	6.0402e-17
C461	VGND	a_373_82##3	1.56726e-20
C462	VPWR	a_913_406##3	4.06638e-18
C463	VGND	a_232_98##7	1.42886e-18
C464	VPWR#9	VNB	2.71727e-18
C465	VPWR	a_232_98##8	1.0411e-17
C466	Q	VPWR#2	5.873e-17
C467	VGND	a_27_136#	1.75646e-18
C468	GATE_N	a_232_98##3	4.79941e-17
C469	VPWR	a_373_82#	1.94772e-18
C470	VGND	a_232_98#	9.51945e-18
C471	VGND#2	Q	4.66043e-18
C472	a_232_98##3	a_232_98##2	1.2064e-17
C473	VGND	GATE_N#3	9.47289e-18
C474	VPWR	a_27_136##3	4.42547e-19
C475	a_670_392##7	VNB	2.57735e-18
C476	GATE_N	GATE_N#2	1.7611e-17
C477	VGND	D#3	5.82994e-18
C478	VPWR	a_232_98##4	8.33681e-18
C479	VGND#7	a_232_98##7	3.3671e-19
C480	VPWR	GATE_N#1	8.12451e-18
C481	GATE_N	D#2	3.75075e-18
C482	a_232_98##10	VNB	1.57099e-17
C483	a_913_406##7	Q	2.92232e-17
C484	VPWR	D#1	8.12451e-18
C485	VPWR#12	VNB	1.77856e-17
C486	a_27_136##7	VNB	7.0092e-17
C487	a_913_406##8	VNB	3.40324e-17
C488	D	GATE_N#2	3.47481e-18
C489	a_913_406##9	VNB	3.06003e-17
C490	RESET_B#3	VNB	2.18752e-17
C491	a_670_392#	VNB	2.71134e-17
C492	D	D#2	6.2945e-18
C493	a_670_392##5	a_373_82##3	3.9353e-17
C494	a_913_406#	VNB	4.72455e-17
C495	VPWR	VPWR#5	6.90177e-17
C496	a_373_82##3	VNB	2.43903e-17
C497	a_232_98##7	VNB	4.29629e-17
C498	a_27_136#	VNB	3.52749e-17
C499	VPWR	a_913_406##7	1.89777e-18
C500	a_232_98#	VNB	4.03359e-17
C501	GATE_N#3	VNB	3.92133e-17
C502	D#3	VNB	3.19726e-17
C503	VPWR	a_670_392##3	9.24001e-18
C504	a_913_406##4	VNB	4.79934e-17
C505	VPWR	a_913_406##2	6.35258e-18
C506	a_913_406##10	VNB	3.77709e-17
C507	RESET_B#1	VNB	3.78507e-17
C508	VPWR	a_373_82##4	3.49179e-18
C509	a_670_392##4	VNB	3.31929e-17
C510	VPWR	a_232_98##5	3.32153e-17
C511	a_913_406##3	VNB	2.85681e-17
C512	VGND	VGND#5	5.8522e-17
C513	a_232_98##8	VNB	2.50083e-17
C514	VPWR	a_373_82##2	8.3014e-18
C515	VGND	a_913_406##7	2.95516e-18
C516	a_373_82#	VNB	3.30741e-17
C517	a_27_136##3	VNB	3.66958e-17
C518	VGND	RESET_B#2	8.85545e-20
C519	VPWR	a_27_136##2	3.3858e-18
C520	VPWR#6	GATE_N#1	1.5875e-18
C521	a_232_98##4	VNB	4.85737e-17
C522	VGND	a_670_392##3	1.16365e-17
C523	VPWR	a_232_98##3	2.10206e-18
C524	GATE_N#1	VNB	3.78601e-17
C525	VGND#7	a_27_136#	3.55542e-19
C526	D#1	VNB	3.91701e-17
C527	a_670_392##7	a_232_98##6	3.18446e-17
C528	VGND	a_373_82##4	5.83275e-18
C529	VPWR#2	VNB	1.46949e-16
C530	VGND#2	VNB	1.33492e-16
C531	VGND	a_373_82##2	1.43819e-17
C532	VPWR#5	VNB	3.53247e-17
C533	VGND#5	VNB	2.96738e-17
C534	VGND	a_27_136##2	2.96682e-17
C535	a_913_406##7	VNB	2.61033e-17
C536	VGND	a_232_98##3	3.24453e-18
C537	RESET_B#2	VNB	2.98534e-17
C538	a_670_392##5	a_232_98##7	1.81014e-17
C539	a_670_392##3	VNB	6.46434e-17
C540	a_913_406##2	VNB	6.67987e-17
C541	a_373_82##4	VNB	4.69793e-17
C542	a_232_98##5	VNB	3.19335e-17
C543	a_373_82##2	VNB	3.32406e-17
C544	a_27_136##2	VNB	5.4318e-17
C545	D	GATE_N	2.85427e-17
C546	a_232_98##3	VNB	5.74731e-17
C547	GATE_N#2	VNB	2.94581e-17
C548	D#2	VNB	4.36799e-17
C549	VPWR	GATE_N	2.68472e-18
C550	VPWR	D	1.48758e-18
C551	VGND	GATE_N	3.65777e-18
C552	VGND	D	2.95676e-18
C553	GATE_N	VNB	2.32313e-18
C554	D	VNB	2.88192e-18
C555	Q	VNB	1.26951e-17
C556	VPWR	VNB	2.93985e-16
C557	GATE_N#2	a_232_98##2	4.44408e-19
C558	VGND	VNB	3.06563e-16
C559	a_670_392##5	a_27_136#	7.72127e-18
C560	VPWR#6	D#1	7.09674e-19
C561	a_913_406##16	RESET_B#4	1.68503e-17
C562	D#5	VPWR#7	1.41439e-19
C563	VGND#10	VNB	7.95333e-17
C564	VPWR#7	D#2	6.42993e-20
C565	VGND	VGND#10	1.22979e-16
C566	VPWR	VPWR#7	1.35423e-16
C567	a_232_98##10	VPWR#7	1.415e-17
C568	VPWR#7	a_27_136##3	2.92945e-19
C569	VGND#10	a_27_136##5	7.15565e-17
C570	VGND#10	VGND#12	6.01522e-18
C571	VPWR#7	VNB	6.88195e-17
C572	VGND#10	VGND#8	2.26901e-18
C573	VPWR#7	VPWR#6	5.08482e-19
C574	VGND#10	D#3	2.26739e-18
C575	VGND#10	GATE_N#3	1.14523e-17
C576	VGND#10	D#2	7.91732e-19
C577	a_27_136##7	VPWR#7	1.83019e-17
C578	VPWR#7	GATE_N#1	3.56669e-18
C579	GATE_N	VPWR#7	3.20595e-19
C580	VGND#10	a_232_98#	1.95856e-18
C581	VGND#10	GATE_N#2	9.03976e-20
C582	VGND#10	a_232_98##3	1.28793e-19
C583	VPWR#7	a_232_98##3	6.11108e-20
C584	VPWR#7	D#1	3.54468e-18
C585	D	VPWR#7	1.76013e-19
*
*
.ENDS sky130_fd_sc_hs__dlrtn_2
*
