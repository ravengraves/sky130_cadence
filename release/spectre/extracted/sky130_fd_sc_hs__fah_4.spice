* Extracted by Quantus, converted by sky130cad/quantus.py
*
*
*
*                       LINUX           Wed Nov 18 08:39:02 2026
*
*
*
*  PROGRAM  advgen
*
*  Name           : advgen - Quantus - (64-bit)
*  Version        : 25.1.0-p047
*  Build Date     : Thu Dec 11 23:20:30 PST 2025
*
*  HSPICE LIBRARY
*
*  OPERATING_TEMPERATURE 150
*  QRC_TECH_DIR <path>/tech
*
*
*

*
.SUBCKT sky130_fd_sc_hs__fah_4 VPB VNB VGND VPWR COUT SUM B CI A
*
*
*  caps2d version: 10
*
*
*       TRANSISTOR CARDS
*
*
XM38 a_27_74##7 A#5 VGND#20 VNB sky130_fd_pr__nfet_01v8_lvt l=0.15 w=0.64 ad=0.1824 as=0.1792 pd=1.85 ps=1.84
XM8 VGND#20 A#6 a_200_74##4 VNB sky130_fd_pr__nfet_01v8_lvt l=0.15 w=0.64 ad=0.1792 as=0.1824 pd=1.84 ps=1.85
XM21 VGND#19 a_27_74# a_427_362##6 VNB sky130_fd_pr__nfet_01v8_lvt l=0.15 w=0.74 ad=0.418 as=0.233 pd=2.8 ps=2.13
XM3 a_427_362##6 B#9 a_536_114##8 VNB sky130_fd_pr__nfet_01v8_lvt l=0.15 w=0.64 ad=0.233 as=0.1792 pd=2.13 ps=1.84
XM37 a_536_114##8 a_586_257##4 a_200_74##6 VNB sky130_fd_pr__nfet_01v8_lvt l=0.15 w=0.64 ad=0.1792 as=0.2444 pd=1.84 ps=2.16
XM14 a_200_74##6 B#8 a_528_362##10 VNB sky130_fd_pr__nfet_01v8_lvt l=0.15 w=0.64 ad=0.2444 as=0.2048 pd=2.16 ps=1.92
XM42 a_528_362##10 a_586_257##2 a_427_362# VNB sky130_fd_pr__nfet_01v8_lvt l=0.15 w=0.64 ad=0.2048 as=0.1696 pd=1.92 ps=1.81
XM23 VGND#18 B#6 a_586_257##8 VNB sky130_fd_pr__nfet_01v8_lvt l=0.15 w=0.74 ad=0.27675 as=0.2035 pd=2.42 ps=2.05
XM15 a_1183_102##2 a_528_362##6 a_1278_102##15 VNB sky130_fd_pr__nfet_01v8_lvt l=0.15 w=0.64 ad=0.208 as=0.244125 pd=1.93 ps=2.21
XM18 a_1278_102##15 a_536_114##3 a_1378_125##8 VNB sky130_fd_pr__nfet_01v8_lvt l=0.15 w=0.64 ad=0.244125 as=0.1792 pd=2.21 ps=1.84
XM28 a_1378_125##8 a_528_362# a_1265_379##14 VNB sky130_fd_pr__nfet_01v8_lvt l=0.15 w=0.64 ad=0.1792 as=0.23685 pd=1.84 ps=2.18
XM34 a_1265_379##14 a_536_114##2 a_586_257##7 VNB sky130_fd_pr__nfet_01v8_lvt l=0.15 w=0.64 ad=0.23685 as=0.356425 pd=2.18 ps=3.14
XM19 a_1183_102##6 a_1378_125# VGND#17 VNB sky130_fd_pr__nfet_01v8_lvt l=0.15 w=0.64 ad=0.23505 as=0.6622 pd=2.02 ps=3.8
XM10 VGND#17 a_1265_379##10 COUT#1 VNB sky130_fd_pr__nfet_01v8_lvt l=0.15 w=0.74 ad=0.6622 as=0.2072 pd=3.8 ps=2.04
XM9 COUT#1 a_1265_379##8 VGND#11 VNB sky130_fd_pr__nfet_01v8_lvt l=0.15 w=0.74 ad=0.2072 as=0.3735 pd=2.04 ps=2.9
XM24 COUT#6 a_1265_379##6 VGND#11 VNB sky130_fd_pr__nfet_01v8_lvt l=0.15 w=0.74 ad=0.2072 as=0.3735 pd=2.04 ps=2.9
XM11 VGND#10 a_1265_379# COUT#6 VNB sky130_fd_pr__nfet_01v8_lvt l=0.15 w=0.74 ad=0.36 as=0.2072 pd=2.83 ps=2.04
XM12 a_1378_125##5 CI#1 VGND#9 VNB sky130_fd_pr__nfet_01v8_lvt l=0.15 w=0.64 ad=0.1824 as=0.4185 pd=1.85 ps=3
XM35 VGND#9 a_1278_102##12 SUM#5 VNB sky130_fd_pr__nfet_01v8_lvt l=0.15 w=0.74 ad=0.4185 as=0.2072 pd=3 ps=2.04
XM4 SUM#5 a_1278_102##10 VGND#8 VNB sky130_fd_pr__nfet_01v8_lvt l=0.15 w=0.74 ad=0.2072 as=0.2072 pd=2.04 ps=2.04
XM39 VGND#8 a_1278_102##8 SUM#1 VNB sky130_fd_pr__nfet_01v8_lvt l=0.15 w=0.74 ad=0.2072 as=0.2072 pd=2.04 ps=2.04
XM43 SUM#1 a_1278_102##7 VGND#1 VNB sky130_fd_pr__nfet_01v8_lvt l=0.15 w=0.74 ad=0.2072 as=0.2627 pd=2.04 ps=2.19
XM16 a_27_74##8 A#7 VPWR#21 VPB sky130_fd_pr__pfet_01v8 l=0.15 w=1 ad=0.295 as=0.3 pd=2.59 ps=2.6
XM40 VPWR#21 A#1 a_200_74##5 VPB sky130_fd_pr__pfet_01v8 l=0.15 w=1 ad=0.3 as=0.295 pd=2.6 ps=2.59
XM13 VPWR#20 a_27_74##4 a_427_362##4 VPB sky130_fd_pr__pfet_01v8 l=0.15 w=1.12 ad=0.5163 as=0.3724 pd=3.55 ps=2.95
XM17 a_427_362##4 B#5 a_528_362##8 VPB sky130_fd_pr__pfet_01v8 l=0.15 w=0.84 ad=0.3724 as=0.2562 pd=2.95 ps=2.29
XM30 a_528_362##8 a_586_257##5 a_200_74# VPB sky130_fd_pr__pfet_01v8 l=0.15 w=0.84 ad=0.2562 as=0.4789 pd=2.29 ps=3.2
XM25 a_200_74# B#7 a_536_114##6 VPB sky130_fd_pr__pfet_01v8 l=0.15 w=0.84 ad=0.4789 as=0.252 pd=3.2 ps=2.28
XM1 a_536_114##6 a_586_257# a_427_362##2 VPB sky130_fd_pr__pfet_01v8 l=0.15 w=0.84 ad=0.252 as=0.2478 pd=2.28 ps=2.27
XM26 VPWR#19 B#1 a_586_257##11 VPB sky130_fd_pr__pfet_01v8 l=0.15 w=1.12 ad=0.3304 as=0.40435 pd=2.83 ps=3.01
XM5 a_586_257##11 a_528_362##3 a_1265_379##16 VPB sky130_fd_pr__pfet_01v8 l=0.15 w=0.84 ad=0.40435 as=0.3738 pd=3.01 ps=2.57
XM41 a_1265_379##16 a_536_114##5 a_1378_125##10 VPB sky130_fd_pr__pfet_01v8 l=0.15 w=0.84 ad=0.3738 as=0.4501 pd=2.57 ps=3.1
XM31 a_1378_125##10 a_528_362##2 a_1278_102##16 VPB sky130_fd_pr__pfet_01v8 l=0.15 w=0.84 ad=0.4501 as=0.672 pd=3.1 ps=3.28
XM20 a_1278_102##16 a_536_114# a_1183_102##5 VPB sky130_fd_pr__pfet_01v8 l=0.15 w=0.84 ad=0.672 as=0.390725 pd=3.28 ps=3
XM0 a_1183_102##5 a_1378_125##4 VPWR#18 VPB sky130_fd_pr__pfet_01v8 l=0.15 w=1 ad=0.390725 as=0.901 pd=3 ps=4.1
XM6 COUT#5 a_1265_379##11 VPWR#18 VPB sky130_fd_pr__pfet_01v8 l=0.15 w=1.12 ad=0.336 as=0.901 pd=2.84 ps=4.1
XM36 COUT#5 a_1265_379##12 VPWR#17 VPB sky130_fd_pr__pfet_01v8 l=0.15 w=1.12 ad=0.336 as=0.59455 pd=2.84 ps=3.65
XM27 VPWR#17 a_1265_379##9 COUT#3 VPB sky130_fd_pr__pfet_01v8 l=0.15 w=1.12 ad=0.59455 as=0.336 pd=3.65 ps=2.84
XM32 VPWR#16 a_1265_379##7 COUT#3 VPB sky130_fd_pr__pfet_01v8 l=0.15 w=1.12 ad=0.8914 as=0.336 pd=4.04 ps=2.84
XM2 a_1378_125##9 CI#3 VPWR#15 VPB sky130_fd_pr__pfet_01v8 l=0.15 w=1 ad=0.295 as=0.4764 pd=2.59 ps=3.11
XM7 SUM#4 a_1278_102##6 VPWR#15 VPB sky130_fd_pr__pfet_01v8 l=0.15 w=1.12 ad=0.336 as=0.4764 pd=2.84 ps=3.11
XM22 VPWR#14 a_1278_102##11 SUM#4 VPB sky130_fd_pr__pfet_01v8 l=0.15 w=1.12 ad=0.4368 as=0.336 pd=3.02 ps=2.84
XM29 SUM#6 a_1278_102##9 VPWR#14 VPB sky130_fd_pr__pfet_01v8 l=0.15 w=1.12 ad=0.3472 as=0.4368 pd=2.86 ps=3.02
XM33 VPWR#1 a_1278_102# SUM#6 VPB sky130_fd_pr__pfet_01v8 l=0.15 w=1.12 ad=0.3304 as=0.3472 pd=2.83 ps=2.86
*
*
*       RESISTOR AND CAP/DIODE CARDS
*
Rg1	A#1	A#2	416.791565
Rg2	A#2	A#3	20.753330
Rg3	A#3	A#4	32.582375
Rg4	A#4	A#5	549.395447
Rg5	A#2	A#6	493.679504
Rg6	A#4	A#7	469.506683
Rg7	a_27_74#	a_27_74##2	295.491547
Rg8	a_27_74##2	a_27_74##3	218.870483
Rg9	a_27_74##2	a_27_74##4	506.508362
Rg10	a_586_257#	a_586_257##2	663.705505
Rg11	a_586_257##2	a_586_257##3	313.072052
Rg12	a_586_257##3	a_586_257##4	897.500244
Rg13	a_586_257##4	a_586_257##5	711.427246
Rg14	a_586_257##3	a_586_257##6	29.258865
Rg15	B#1	B#2	732.769775
Rg16	B#2	B#3	47.931213
Rg17	B#3	B#4	793.710876
Rg18	B#4	B#5	987.841431
Rg19	B#2	B#6	368.056519
Rg20	B#4	B#7	417.481293
Rg21	B#7	B#8	784.954529
Rg22	B#5	B#9	726.270630
Rg23	a_528_362#	a_528_362##2	870.708557
Rg24	a_528_362##2	a_528_362##3	1373.204468
Rg25	a_528_362##3	a_528_362##4	504.015594
Rg26	a_528_362##4	a_528_362##5	247.424850
Rg27	a_528_362##4	a_528_362##6	246.868378
Rg28	a_536_114#	a_536_114##2	1035.708252
Rg29	a_536_114##2	a_536_114##3	1361.431274
Rg30	a_536_114##3	a_536_114##4	308.879059
Rg31	a_536_114##4	a_536_114##5	362.477081
Rg32	a_1378_125#	a_1378_125##2	469.910187
Rg33	a_1378_125##2	a_1378_125##3	83.793213
Rg34	a_1378_125##2	a_1378_125##4	395.100159
Rg35	a_1265_379#	a_1265_379##2	384.172974
Rg36	a_1265_379##2	a_1265_379##3	79.339371
Rg37	a_1265_379##3	a_1265_379##4	84.313179
Rg38	a_1265_379##4	a_1265_379##5	30.583244
Rg39	a_1265_379##2	a_1265_379##6	327.082642
Rg40	a_1265_379##2	a_1265_379##7	449.101105
Rg41	a_1265_379##3	a_1265_379##8	322.988434
Rg42	a_1265_379##3	a_1265_379##9	449.490784
Rg43	a_1265_379##4	a_1265_379##10	299.493988
Rg44	a_1265_379##5	a_1265_379##11	505.161743
Rg45	a_1265_379##5	a_1265_379##12	429.126801
Rg46	CI#1	CI#2	279.244598
Rg47	CI#2	CI#3	400.207520
Rg48	a_1278_102#	a_1278_102##2	503.938385
Rg49	a_1278_102##2	a_1278_102##3	65.673950
Rg50	a_1278_102##3	a_1278_102##4	93.112160
Rg51	a_1278_102##4	a_1278_102##5	54.058781
Rg52	a_1278_102##5	a_1278_102##6	451.328491
Rg53	a_1278_102##2	a_1278_102##7	377.236847
Rg54	a_1278_102##3	a_1278_102##8	343.399963
Rg55	a_1278_102##3	a_1278_102##9	432.348541
Rg56	a_1278_102##4	a_1278_102##10	306.145477
Rg57	a_1278_102##4	a_1278_102##11	432.847015
Rg58	a_1278_102##5	a_1278_102##12	299.493988
Rf1	A#8	A	0.298263
Rf2	A#3	A#10	80.414665
Rf3	A#8	A#10	1.779862
Rf4	a_27_74##3	a_27_74##6	247.920959
Rf5	a_27_74##6	a_27_74##7	34.048882
Rf6	a_27_74##6	a_27_74##8	82.450142
Rf7	a_528_362##7	a_528_362##8	40.339935
Rf8	a_200_74#	a_200_74##2	112.541504
Rf9	a_200_74##2	a_200_74##3	122.862854
Rf10	a_200_74##3	a_200_74##4	56.922520
Rf11	a_200_74##2	a_200_74##5	62.062107
Rf12	a_200_74##3	a_200_74##6	165.076355
Rf13	a_536_114##6	a_536_114##7	32.920876
Rf14	a_536_114##7	a_536_114##8	112.694733
Rf15	a_528_362##9	a_528_362##10	78.809647
Rf16	a_427_362#	a_427_362##3	91.930084
Rf17	a_427_362##3	a_427_362##5	141.764557
Rf18	a_427_362##5	a_427_362##6	96.192024
Rf19	a_427_362##2	a_427_362##3	7.500000
Rf20	a_427_362##4	a_427_362##5	7.500000
Rf21	B	B#3	55.346161
Rf22	a_528_362##5	a_528_362##12	186.327026
Rf23	a_1183_102#	a_1183_102##2	70.157005
Rf24	a_536_114##4	a_536_114##10	161.711792
Rf25	a_536_114##11	a_536_114##12	1.478985
Rf26	a_536_114##10	a_536_114##11	14.535711
Rf27	a_586_257##7	a_586_257##9	225.451050
Rf28	a_586_257##9	a_586_257##6	240.337524
Rf29	a_586_257##9	a_586_257##11	175.348419
Rf30	a_586_257##8	a_586_257##9	7.500000
Rf31	a_1183_102##3	a_1183_102##4	8.213201
Rf32	a_1183_102##4	a_1183_102##5	59.068268
Rf33	a_1183_102##4	a_1183_102##6	56.144455
Rf34	a_1265_379##5	a_1265_379##15	289.095032
Rf35	a_1265_379##15	a_1265_379##16	156.016205
Rf36	a_1265_379##14	a_1265_379##15	15.000000
Rf37	COUT#1	COUT#2	51.704922
Rf38	COUT#2	COUT	12.255700
Rf39	COUT	COUT#4	10.772657
Rf40	COUT#4	COUT#5	70.318146
Rf41	COUT#2	COUT#6	38.598427
Rf42	COUT#3	COUT#4	15.000000
Rf43	a_1378_125##5	a_1378_125##6	102.505821
Rf44	a_1378_125##6	a_1378_125##7	374.543640
Rf45	a_1378_125##7	a_1378_125##8	268.044983
Rf46	a_1378_125##6	a_1378_125##9	7.947185
Rf47	a_1378_125##7	a_1378_125##11	1.446456
Rf48	a_1378_125##11	a_1378_125##3	209.893616
Rf49	a_1378_125##10	a_1378_125##11	15.000000
Rf50	CI#4	CI#2	161.684418
Rf51	CI	CI#6	1.451613
Rf52	CI#4	CI#6	5.660404
Rf53	a_1278_102##4	a_1278_102##14	209.796448
Rf54	a_1278_102##14	a_1278_102##15	449.363129
Rf55	a_1278_102##14	a_1278_102##16	385.651123
Rf56	SUM#1	SUM#2	19.013641
Rf57	SUM#2	SUM#3	42.205822
Rf58	SUM#3	SUM#4	82.094650
Rf59	SUM#2	SUM#5	78.077034
Rf60	SUM#3	SUM	4.158064
Rf61	SUM	SUM#7	0.388081
Rf62	SUM#7	SUM	13.970907
Rf63	SUM#6	SUM#7	5.000000
Rf64	VGND#1	VGND#2	84.441910
Rf65	VGND#2	VGND#3	18.238092
Rf66	VGND#3	VGND#4	68.977966
Rf67	VGND#4	VGND#5	78.474533
Rf68	VGND#5	VGND#6	73.001427
Rf69	VGND#6	VGND#7	78.395172
Rf70	VGND#3	VGND#8	39.231567
Rf71	VGND#4	VGND#9	24.586226
Rf72	VGND#5	VGND#10	24.862514
Rf73	VGND#6	VGND#11	24.862514
Rf74	VGND#7	VGND#12	389.334595
Rf75	VGND#12	VGND#13	101.515656
Rf76	VGND#13	VGND#14	123.845337
Rf77	VGND#14	VGND#15	72.742805
Rf79	VGND#7	VGND#17	32.435226
Rf80	VGND#12	VGND#18	26.240368
Rf81	VGND#14	VGND#19	33.273071
Rf82	VGND#15	VGND#20	37.201691
Rf83	VPWR#1	VPWR#2	96.250885
Rf84	VPWR#2	VPWR#3	22.986374
Rf85	VPWR#3	VPWR#4	73.001427
Rf86	VPWR#4	VPWR#5	93.107758
Rf87	VPWR#5	VPWR#6	89.089973
Rf88	VPWR#6	VPWR#7	37.231220
Rf89	VPWR#7	VPWR#8	49.632885
Rf90	VPWR#8	VPWR#9	285.561462
Rf91	VPWR#9	VPWR#10	155.573029
Rf92	VPWR#10	VPWR#11	117.946327
Rf93	VPWR#11	VPWR#12	77.070869
Rf95	VPWR#3	VPWR#14	33.503098
Rf96	VPWR#4	VPWR#15	37.301857
Rf97	VPWR#5	VPWR#16	19.444679
Rf98	VPWR#6	VPWR#17	23.090988
Rf99	VPWR#8	VPWR#18	19.899023
Rf100	VPWR#9	VPWR#19	32.912586
Rf101	VPWR#11	VPWR#20	22.290352
Rf102	VPWR#12	VPWR#21	44.422604
Re1	a_528_362##12	a_528_362##9	12.051637
Re2	a_528_362##9	a_528_362##7	11.228309
Re3	a_536_114##12	a_536_114##7	25.122730
Re4	a_1183_102##3	a_1183_102#	25.122730
Re5	VPWR#2	VPWR#23	4.103880
Re6	VPWR#23	VPWR	0.921908
Re7	VPWR	VPWR#10	2.357848
Re8	VGND#2	VGND#22	4.103880
Re9	VGND#22	VGND	0.921908
Re10	VGND	VGND#13	2.357848
Re19	VPWR#7	VPWR#23	0.698413
Re22	VGND#7	VGND#22	0.698413
*
*       CAPACITOR CARDS
*
*
C1	VGND#13	a_1183_102##2	6.3892e-18
C2	a_586_257##8	a_1278_102##15	2.70151e-17
C3	a_536_114##12	a_1265_379##16	1.63946e-17
C4	SUM#5	a_1278_102##12	3.82328e-17
C5	SUM#3	a_1278_102##2	9.22874e-18
C6	VGND#13	a_586_257##8	5.67968e-17
C7	a_427_362##2	a_586_257##3	1.5398e-19
C8	VGND#8	VGND#1	4.67415e-18
C9	B#5	B#4	7.81854e-19
C10	VGND#20	A#5	3.23555e-17
C11	a_536_114##12	a_586_257##11	4.60247e-17
C12	VGND#13	VGND#18	1.87625e-17
C13	CI#3	a_1278_102##6	2.69785e-17
C14	SUM#3	VPWR#1	6.1119e-17
C15	VPWR#10	A#4	2.1545e-19
C16	VGND#8	CI#1	1.95528e-19
C17	a_1378_125##9	VPWR#16	8.40152e-18
C18	VPWR#15	COUT#3	1.73212e-21
C19	a_536_114##6	B#4	1.60622e-19
C20	VGND#13	a_427_362#	4.7653e-18
C21	a_536_114##12	VPWR#19	6.23912e-18
C22	SUM#2	a_1278_102##3	5.10565e-18
C23	a_1278_102##12	VGND#9	7.26928e-18
C24	a_536_114##11	a_1378_125##10	1.75629e-18
C25	A#5	a_27_74##7	1.53175e-17
C26	VGND#13	a_528_362##10	1.02172e-17
C27	a_1265_379##7	a_1278_102##6	8.41249e-20
C28	a_586_257##8	a_1183_102##2	5.69178e-17
C29	a_1278_102##3	SUM#1	3.56891e-19
C30	VPWR#3	a_1278_102##11	2.58544e-18
C31	a_1265_379##5	VGND#11	4.99702e-20
C32	a_1278_102##14	COUT#2	5.38781e-17
C33	a_1378_125##8	a_528_362##4	9.64166e-18
C34	VGND#13	a_200_74##6	8.90955e-17
C35	VGND#13	a_528_362##4	2.63958e-20
C36	SUM#5	CI#1	1.96276e-18
C37	a_1183_102##3	VPWR#8	5.19964e-18
C38	a_1265_379##5	COUT#1	3.39285e-17
C39	a_1278_102##8	a_1278_102##7	3.74617e-17
C40	a_1265_379##7	CI#3	2.80871e-18
C41	a_27_74##2	B#5	4.7156e-18
C42	VGND#13	a_536_114##8	1.45394e-17
C43	a_1378_125##9	COUT#3	2.82564e-18
C44	a_1278_102##4	a_1278_102##5	3.88533e-17
C45	VPWR#5	a_1278_102##6	1.12315e-18
C46	a_1378_125##5	a_1278_102##12	1.46167e-18
C47	a_1265_379##5	VGND#17	1.72451e-17
C48	a_1183_102#	a_1265_379##16	4.22566e-18
C49	VGND#8	a_1265_379#	9.71038e-20
C50	VGND#13	a_427_362##6	7.41509e-18
C51	VGND#2	a_1278_102##7	9.42092e-18
C52	a_1278_102##4	a_1278_102##3	1.1523e-17
C53	a_27_74##6	A#4	2.68768e-17
C54	a_1265_379##5	a_1183_102##6	4.72098e-17
C55	a_1265_379##16	a_536_114##3	6.08591e-20
C56	VPWR#8	VPWR#18	1.01208e-17
C57	VGND#8	a_1278_102##5	3.9202e-19
C58	SUM#3	SUM#6	7.72745e-19
C59	CI#1	VGND#9	1.21389e-17
C60	VGND#13	VGND#19	1.28291e-17
C61	a_1183_102#	a_586_257##11	2.52241e-17
C62	VGND#13	a_586_257##3	1.4212e-17
C63	VPWR#4	a_1278_102##6	4.63814e-18
C64	VGND#2	a_1278_102##8	4.49996e-18
C65	B#7	a_586_257##2	3.25611e-18
C66	a_536_114##11	a_1265_379##16	4.51661e-17
C67	a_1278_102##2	SUM#1	4.25808e-19
C68	a_1278_102##15	a_1378_125##2	9.03271e-19
C69	VGND#3	a_1278_102##7	6.50174e-18
C70	SUM#2	a_1278_102##2	8.20107e-18
C71	a_536_114##6	a_586_257##3	7.15501e-20
C72	VGND#10	a_1278_102##12	7.03715e-19
C73	VGND#13	a_200_74##4	1.86757e-17
C74	a_1265_379##11	VGND#17	8.1147e-19
C75	VGND#13	a_27_74##2	2.3479e-19
C76	a_1265_379##14	a_1265_379##5	3.17178e-18
C77	a_1378_125##9	VPWR#17	3.73794e-18
C78	SUM#5	a_1265_379#	5.27609e-19
C79	VGND#2	a_1278_102##10	4.41929e-18
C80	a_1265_379##9	a_1265_379##7	4.80697e-17
C81	VPWR#6	CI#3	1.60785e-19
C82	VPWR#5	a_1265_379#	5.82642e-19
C83	a_536_114##2	a_1378_125##2	3.21651e-19
C84	a_1378_125##5	CI#1	2.23087e-17
C85	a_200_74#	B#4	1.74247e-17
C86	a_1183_102##6	a_1265_379##11	1.0807e-18
C87	VGND#13	a_27_74##7	1.62034e-17
C88	a_1278_102##15	a_1265_379##5	3.60686e-17
C89	VGND#2	a_1278_102##12	8.67031e-18
C90	a_528_362##12	a_586_257##11	2.77551e-17
C91	a_1278_102##10	a_1278_102##8	3.75645e-17
C92	a_1378_125##3	a_1183_102##6	1.06939e-17
C93	a_586_257##4	B#7	1.77031e-19
C94	VPWR#5	CI#3	2.25944e-18
C95	a_586_257##8	VGND#18	5.52406e-17
C96	VGND#8	a_1278_102##3	5.566e-19
C97	a_200_74##2	a_586_257#	7.38623e-20
C98	a_1278_102##14	a_1378_125##5	9.9241e-17
C99	a_1183_102##4	a_1378_125##2	1.41496e-17
C100	a_1378_125##9	COUT#5	6.3921e-19
C101	a_1378_125##8	B#2	1.15087e-19
C102	VPWR#1	a_1278_102#	2.90106e-17
C103	VGND#10	CI#1	2.07568e-18
C104	a_1265_379##14	a_1378_125##3	1.13947e-16
C105	SUM#3	VPWR#14	6.83579e-17
C106	VGND#12	a_586_257##7	5.56159e-17
C107	a_1265_379##12	a_1265_379##9	2.36322e-17
C108	a_200_74#	B#2	3.15985e-18
C109	VPWR#4	CI#3	1.34773e-17
C110	SUM#3	VPWR#2	2.43999e-18
C111	CI#6	VPWR#4	4.2255e-19
C112	CI#2	a_1278_102##5	2.42849e-17
C113	VGND#2	VGND#4	1.63829e-17
C114	VGND#3	a_1278_102##8	9.67275e-19
C115	SUM#5	VGND#8	4.26564e-17
C116	a_1378_125##5	a_1265_379#	1.68643e-18
C117	a_1278_102##15	a_1378_125##3	2.10704e-18
C118	A#4	a_27_74##4	1.7688e-18
C119	a_200_74##6	a_528_362##8	1.86848e-20
C120	a_1278_102#	SUM#6	2.48805e-17
C121	a_1378_125##9	a_1265_379##3	3.35532e-19
C122	VGND#2	VGND#3	9.40275e-17
C123	SUM#3	a_1278_102#	2.14524e-17
C124	SUM#5	a_1278_102##5	3.36898e-18
C125	VPWR#6	a_1265_379##7	2.15944e-18
C126	a_536_114##12	VPWR#9	2.42603e-18
C127	a_427_362#	a_586_257##8	5.66317e-18
C128	a_586_257##7	a_536_114##4	3.24445e-19
C129	a_528_362##9	a_427_362##2	2.55539e-17
C130	VPWR#1	a_1278_102##9	1.19093e-18
C131	a_1278_102##12	a_1278_102##10	3.76469e-17
C132	a_200_74##2	B#7	8.30036e-20
C133	VGND#4	a_1278_102##10	1.24769e-18
C134	a_1265_379##11	a_1265_379##12	4.79719e-17
C135	VPWR#14	a_1278_102#	1.47503e-18
C136	a_536_114##4	a_1265_379##14	1.94092e-17
C137	a_536_114##7	a_586_257##11	1.29375e-17
C138	a_1278_102##4	VPWR#14	3.77799e-18
C139	a_1265_379#	VGND#10	2.66676e-17
C140	a_528_362##9	a_536_114##6	3.02388e-17
C141	VGND#4	VGND#3	2.48615e-18
C142	VPWR#5	a_1265_379##7	1.56266e-17
C143	a_1278_102##14	VGND#10	4.69565e-17
C144	a_1378_125##8	a_536_114##4	7.59879e-17
C145	a_528_362##8	B#4	2.7496e-20
C146	a_1278_102##4	SUM#4	5.04152e-17
C147	VGND#11	CI#1	1.29658e-19
C148	VPWR#8	VPWR#6	2.75747e-18
C149	SUM#4	SUM#3	2.63787e-18
C150	a_1265_379##2	CI#2	4.77419e-20
C151	a_1278_102##9	SUM#6	2.40332e-17
C152	a_1378_125##9	a_1265_379##2	5.276e-19
C153	a_536_114##4	a_1278_102##15	9.79093e-19
C154	a_200_74##3	a_27_74##3	6.48777e-17
C155	a_1278_102##4	VPWR#15	9.22879e-18
C156	VGND#2	SUM#3	6.01056e-19
C157	a_536_114##7	a_427_362##2	7.21716e-17
C158	VGND#3	a_1278_102##10	9.65356e-19
C159	SUM#2	a_1278_102##7	2.18035e-17
C160	VPWR#8	a_1265_379##9	5.57491e-19
C161	a_528_362##10	a_586_257##8	1.43409e-18
C162	a_27_74##3	a_200_74##2	5.05402e-18
C163	COUT#6	a_1265_379#	3.05664e-17
C164	VPWR#1	a_1278_102##11	2.52866e-19
C165	a_528_362##4	a_1183_102##2	1.02413e-18
C166	a_536_114##7	a_536_114##6	9.87498e-18
C167	a_27_74##6	a_27_74##3	1.6558e-18
C168	VGND#2	SUM#2	1.79594e-17
C169	a_586_257##7	a_536_114#	2.13215e-19
C170	a_1278_102##9	VPWR#14	3.18853e-17
C171	a_1378_125##4	a_1265_379##11	9.2774e-18
C172	SUM#3	a_1278_102##9	3.45175e-17
C173	VPWR#4	a_1278_102##5	2.01357e-20
C174	a_1183_102##3	a_1378_125#	7.30083e-18
C175	a_200_74##2	a_586_257##5	1.4473e-19
C176	a_536_114##7	a_200_74#	7.53882e-18
C177	VGND#10	a_1265_379##6	2.11482e-18
C178	VPWR#6	a_1265_379##9	1.39617e-17
C179	a_536_114##8	a_427_362##4	4.03759e-18
C180	CI#6	a_1278_102##5	1.37355e-18
C181	CI#1	a_1278_102##12	1.97316e-17
C182	a_1378_125##8	a_528_362##5	3.26401e-19
C183	a_1378_125##7	VPWR#9	8.21601e-17
C184	a_1265_379##14	a_536_114#	3.84806e-19
C185	VPWR#10	a_1265_379##16	4.10632e-18
C186	a_528_362##7	a_427_362##2	2.14817e-19
C187	a_536_114#	a_1265_379##11	6.74574e-19
C188	VGND#4	a_1278_102##12	1.06031e-17
C189	VGND#11	a_1265_379#	2.36384e-18
C190	CI#2	VPWR#15	3.177e-18
C191	a_528_362##8	a_536_114##7	1.74759e-17
C192	a_1183_102##3	a_536_114##2	8.27579e-19
C193	SUM#4	a_1278_102##9	5.2276e-19
C194	a_27_74##3	A#10	3.66362e-17
C195	COUT#5	VPWR#17	3.08359e-19
C196	a_1278_102##16	a_1378_125##9	6.06363e-17
C197	a_1278_102##14	COUT#6	6.79523e-17
C198	VPWR#10	a_586_257##11	1.72381e-17
C199	VPWR#5	a_1265_379##9	2.13276e-18
C200	a_1378_125##9	CI#2	1.04502e-17
C201	a_528_362##5	a_1183_102##2	1.85758e-17
C202	a_1278_102##5	VGND#9	7.75434e-19
C203	CI#6	a_1278_102#	8.7331e-20
C204	a_427_362##4	a_536_114##7	4.71671e-18
C205	a_1278_102##11	VPWR#14	3.63609e-17
C206	COUT#6	a_1265_379##6	2.04761e-17
C207	a_536_114#	a_1378_125##4	3.27812e-17
C208	a_586_257##8	a_528_362##5	5.54886e-17
C209	VPWR#10	VPWR#19	1.63435e-17
C210	a_200_74##3	B#5	7.83717e-19
C211	a_528_362##7	a_200_74#	2.55711e-18
C212	a_1265_379#	a_1278_102##12	1.67567e-19
C213	a_586_257##7	a_528_362##2	1.84335e-19
C214	VPWR#15	a_1278_102##9	2.85428e-19
C215	SUM#2	a_1278_102##8	2.45955e-17
C216	a_427_362##2	VPWR#10	2.68681e-17
C217	a_1265_379##5	a_1265_379##3	8.05763e-18
C218	VPWR#8	a_1265_379##12	2.10291e-18
C219	VGND#10	a_1265_379##8	5.94541e-19
C220	a_427_362##4	B#4	6.31497e-19
C221	a_1278_102##15	a_536_114#	2.68657e-19
C222	a_200_74##2	B#5	1.31751e-17
C223	SUM#4	a_1278_102##11	7.63248e-17
C224	SUM#3	a_1278_102##11	1.17671e-18
C225	a_1265_379##14	a_528_362##2	1.73537e-17
C226	VPWR#10	a_536_114##6	1.39783e-18
C227	a_427_362##4	a_528_362##7	3.66707e-17
C228	a_1265_379##6	VGND#11	2.43943e-17
C229	a_1378_125##9	a_1265_379##5	8.51975e-19
C230	CI#6	a_1278_102##3	1.76853e-19
C231	a_1265_379#	CI#1	4.75798e-18
C232	a_1265_379##5	a_1378_125##2	2.18241e-18
C233	a_1183_102##3	a_1278_102##14	4.13857e-19
C234	a_1278_102##14	a_1265_379##3	9.13629e-19
C235	a_1378_125##7	VPWR#8	1.73235e-16
C236	a_528_362##10	a_427_362#	2.65835e-17
C237	VPWR#6	a_1265_379##12	1.01363e-17
C238	a_200_74#	VPWR#10	5.37401e-17
C239	a_536_114##12	a_536_114##2	8.5768e-21
C240	VGND#7	a_1265_379##10	3.71565e-18
C241	a_1183_102#	VPWR#9	1.47619e-18
C242	VPWR#14	a_1278_102##6	7.67963e-19
C243	a_528_362##2	a_536_114#	7.25311e-18
C244	VGND#14	a_200_74##3	4.47366e-17
C245	a_586_257##8	a_528_362##4	5.27907e-19
C246	VGND#4	CI#1	8.19624e-18
C247	a_528_362##4	a_536_114##3	4.89133e-18
C248	a_1378_125##8	a_528_362##2	3.93621e-19
C249	VPWR#15	a_1278_102##11	1.25159e-18
C250	a_586_257##8	B#3	6.12583e-17
C251	VPWR#8	a_1378_125#	4.28308e-19
C252	VPWR#6	a_1265_379##3	1.76684e-19
C253	a_1278_102##14	VGND#11	4.67337e-17
C254	VPWR#10	a_528_362##8	3.15746e-18
C255	VGND#7	a_1378_125#	1.17331e-18
C256	a_1183_102#	VPWR#8	9.03741e-19
C257	VPWR#3	a_1278_102##5	1.98672e-20
C258	B#3	VGND#18	3.76689e-18
C259	a_200_74##3	a_27_74##4	4.3888e-18
C260	VPWR#5	a_1265_379##12	5.79668e-19
C261	VPWR#10	a_427_362##4	1.17301e-17
C262	SUM#4	a_1278_102##6	5.60572e-17
C263	a_1265_379##5	VPWR#17	4.49903e-18
C264	a_1378_125##5	a_1378_125##9	2.74081e-18
C265	a_427_362##2	a_586_257##4	2.02036e-20
C266	a_427_362#	B#3	3.29365e-17
C267	a_1278_102##15	a_528_362##2	4.04072e-19
C268	A#10	A#4	1.70927e-17
C269	VGND#7	a_536_114##2	9.53343e-18
C270	a_536_114##12	a_536_114##3	4.69008e-20
C271	VPWR#6	VPWR#5	2.80646e-18
C272	VPWR#2	a_1278_102##3	1.97888e-20
C273	a_1265_379##14	a_536_114##5	7.9538e-19
C274	a_1265_379##5	COUT#5	6.60435e-17
C275	SUM#2	a_1278_102##10	6.96557e-19
C276	VPWR#9	a_528_362##4	1.72136e-19
C277	a_200_74##2	a_27_74##4	4.66477e-17
C278	a_1265_379##3	COUT#3	2.57736e-19
C279	a_1265_379##8	VGND#11	2.28481e-17
C280	VGND#5	a_1265_379#	5.85413e-18
C281	a_536_114##5	a_528_362##2	3.44955e-17
C282	VPWR#8	a_1265_379##11	1.21599e-17
C283	VPWR#10	a_200_74##5	2.04541e-17
C284	a_1278_102##6	VPWR#15	3.2994e-17
C285	VPWR#2	a_1278_102##2	2.36101e-20
C286	SUM#3	a_1278_102##6	1.45004e-19
C287	VGND#17	a_1265_379##6	5.80483e-19
C288	a_27_74##6	a_27_74##4	1.0868e-20
C289	a_1378_125##8	a_536_114##5	2.15986e-18
C290	a_586_257##6	a_586_257##8	2.58423e-18
C291	a_1265_379##5	a_1183_102##5	4.55036e-19
C292	VPWR#8	a_1378_125##2	1.73921e-19
C293	CI#6	a_1278_102##2	2.21091e-20
C294	a_1265_379##6	a_1265_379#	3.86014e-17
C295	VGND#13	a_427_362##4	1.62717e-18
C296	a_1183_102#	a_536_114##2	3.49017e-19
C297	a_1278_102##16	VPWR#17	2.29543e-18
C298	a_1278_102##14	a_1265_379##2	4.03215e-18
C299	a_586_257##6	VGND#18	3.33022e-17
C300	a_528_362##3	a_528_362##2	4.30889e-19
C301	SUM#4	CI#3	8.42451e-19
C302	a_1265_379##5	a_1278_102##16	8.06739e-18
C303	VPWR#6	a_1265_379##11	2.08053e-18
C304	COUT#1	a_1265_379##8	2.34334e-17
C305	a_1378_125##9	a_1278_102##6	1.56983e-18
C306	VPWR#10	a_27_74##8	1.62293e-17
C307	VGND#4	a_1265_379#	8.04401e-19
C308	a_1183_102#	a_528_362#	2.90814e-18
C309	a_586_257##6	a_427_362#	3.8527e-17
C310	a_586_257##11	VPWR#9	1.17287e-17
C311	a_1278_102##14	COUT#1	3.88424e-17
C312	VGND#6	a_1265_379##6	3.71604e-18
C313	VPWR#8	a_536_114##2	1.26499e-19
C314	a_1265_379##2	COUT#3	2.543e-19
C315	CI#6	a_1278_102##11	2.26122e-19
C316	a_200_74##3	B#8	2.14814e-19
C317	a_528_362##10	a_586_257##6	2.49153e-17
C318	VGND#6	a_1278_102##14	7.6992e-18
C319	a_528_362##3	a_536_114##5	2.14705e-17
C320	a_427_362##4	a_27_74##2	1.57836e-18
C321	a_1378_125##3	a_1378_125##2	7.6726e-18
C322	CI#3	VPWR#15	3.75167e-17
C323	a_200_74##6	a_528_362##10	2.23321e-17
C324	VGND#11	a_1265_379##10	2.30477e-18
C325	a_200_74##6	a_586_257##6	1.09442e-17
C326	a_200_74##2	A#1	2.45809e-18
C327	VPWR#2	a_1278_102#	1.2879e-17
C328	a_1378_125##3	a_1183_102##5	2.36163e-17
C329	a_427_362##4	B#8	2.99798e-20
C330	a_1278_102##16	COUT#5	6.07567e-17
C331	a_586_257##8	B#2	2.00598e-17
C332	SUM#2	a_1278_102##12	2.54629e-19
C333	VGND#17	a_1265_379##8	1.29348e-18
C334	a_1378_125##8	a_528_362##3	1.08186e-17
C335	a_1278_102##14	a_1378_125##9	1.88511e-16
C336	a_1183_102##3	a_1378_125##7	5.64114e-18
C337	a_1378_125##3	a_1278_102##16	1.32985e-17
C338	VPWR#9	B#4	5.80513e-18
C339	A#10	a_27_74##4	1.3249e-18
C340	SUM#4	a_1265_379##7	8.07913e-20
C341	VPWR#2	a_1278_102##9	4.16619e-18
C342	a_1378_125##9	CI#3	6.29515e-17
C343	SUM#3	CI#3	1.83262e-19
C344	VPWR#8	a_1378_125##4	9.58417e-18
C345	a_1265_379##8	a_1265_379##6	2.29945e-17
C346	COUT#1	a_1265_379##10	2.3583e-17
C347	CI#6	VPWR#15	2.34207e-17
C348	B#1	a_528_362##3	4.25706e-17
C349	VPWR#2	a_1278_102##11	1.03359e-19
C350	a_1183_102#	VGND#12	1.56403e-18
C351	VPWR#15	a_1265_379##7	6.62769e-19
C352	a_1278_102##14	a_1278_102##12	2.22807e-19
C353	a_427_362##4	a_586_257##4	1.34863e-19
C354	a_536_114##8	a_528_362##10	2.95549e-17
C355	a_1278_102##16	VPWR#18	1.0631e-17
C356	a_200_74##3	a_586_257##4	2.50578e-19
C357	VPWR#6	a_1378_125##4	3.35912e-19
C358	a_1278_102##14	VGND#17	6.62954e-17
C359	VGND#11	a_1378_125#	2.31769e-19
C360	VPWR#2	a_1278_102##6	4.2709e-19
C361	a_528_362##9	VPWR#9	3.77029e-19
C362	CI#6	a_1278_102##6	1.38122e-18
C363	VGND#6	a_1265_379##8	3.69688e-18
C364	a_586_257##8	a_586_257##3	5.7869e-19
C365	a_200_74##2	A#7	2.46274e-19
C366	VGND#5	a_1278_102##14	9.94206e-18
C367	a_1378_125##8	B#1	5.64665e-19
C368	a_1265_379##10	VGND#17	8.92798e-18
C369	a_1278_102##4	a_1278_102##7	7.75468e-20
C370	a_1378_125##9	a_1265_379##7	2.95602e-17
C371	a_1265_379##3	a_1265_379##2	3.43274e-18
C372	a_1278_102##14	CI#3	8.68843e-19
C373	a_27_74##3	VGND#19	3.00255e-18
C374	a_1278_102##4	a_1278_102##8	5.87859e-20
C375	a_1265_379##16	a_536_114##4	1.12852e-18
C376	SUM#2	CI#1	6.84994e-20
C377	a_1378_125##7	VPWR#7	5.79689e-18
C378	VGND#12	a_586_257##8	1.13875e-16
C379	a_1278_102##14	VPWR#16	1.11284e-17
C380	VPWR#5	VPWR#4	7.76845e-19
C381	COUT#1	a_1378_125#	1.75245e-18
C382	a_200_74##4	a_27_74##3	6.06955e-17
C383	VPWR#15	a_1265_379##9	1.48035e-19
C384	VPWR#5	a_1265_379##2	4.54602e-19
C385	a_1278_102##4	a_1278_102##10	2.542e-19
C386	a_1278_102##16	a_1183_102##5	4.03652e-17
C387	a_1265_379##7	VPWR#16	2.10333e-17
C388	VPWR#9	B#2	1.20147e-17
C389	a_536_114##8	a_200_74##6	9.25676e-17
C390	a_1183_102##6	a_1265_379##10	6.45705e-20
C391	a_1265_379##10	a_1265_379##8	3.93397e-17
C392	a_528_362##9	a_586_257##2	8.2363e-19
C393	a_1278_102##4	a_1278_102##12	1.01767e-17
C394	a_1378_125##9	CI#6	3.41395e-17
C395	VPWR#8	a_536_114#	7.40933e-18
C396	VGND#7	a_1278_102##14	4.49306e-17
C397	a_528_362##4	a_536_114##4	1.89907e-17
C398	a_200_74##3	B#9	5.32746e-18
C399	a_528_362##12	VGND#12	1.60492e-18
C400	a_1378_125##9	a_1265_379##9	2.20913e-17
C401	a_1278_102##14	CI#1	1.8136e-17
C402	a_1278_102##4	CI#1	1.6995e-17
C403	a_528_362##9	B#8	6.34935e-19
C404	a_1183_102##3	a_1183_102##4	9.78601e-18
C405	a_1265_379##7	COUT#3	2.27516e-17
C406	a_1378_125#	VGND#17	2.14805e-17
C407	B#7	a_586_257#	5.18382e-17
C408	CI#6	CI#3	4.32232e-18
C409	a_1278_102##4	a_1265_379#	2.93589e-19
C410	a_586_257##8	B#1	3.31725e-19
C411	VPWR#6	a_536_114#	2.1101e-19
C412	VGND#3	SUM#2	9.07929e-18
C413	VGND#4	a_1278_102##14	3.92767e-18
C414	a_528_362##5	a_586_257##11	5.30154e-18
C415	a_536_114##7	a_586_257##2	2.03811e-19
C416	a_536_114##7	VPWR#9	4.05449e-18
C417	a_427_362##2	VPWR#9	2.12219e-18
C418	a_1278_102##14	a_1265_379##7	2.2618e-17
C419	a_536_114##7	B#8	9.38189e-19
C420	VPWR#11	a_27_74##2	1.18294e-19
C421	a_536_114##12	a_1378_125##7	3.79087e-18
C422	a_1378_125#	a_1183_102##6	1.3309e-17
C423	a_1378_125##2	a_1265_379##11	2.26288e-18
C424	a_1183_102##3	a_1265_379##9	4.33466e-19
C425	a_1378_125##9	a_1265_379##12	2.17432e-17
C426	a_427_362#	B#4	1.25364e-20
C427	VGND#18	a_586_257##3	9.4762e-18
C428	a_536_114##7	a_586_257##4	5.86601e-19
C429	VPWR#9	a_528_362##2	1.35024e-17
C430	a_1265_379##9	COUT#3	2.27516e-17
C431	a_1265_379#	CI#2	6.39502e-18
C432	a_586_257##5	B#7	2.70542e-17
C433	a_1378_125#	a_1265_379##10	4.48639e-18
C434	CI#6	a_1265_379##2	9.93361e-21
C435	B#3	a_586_257##11	2.18894e-17
C436	a_200_74##3	a_27_74#	4.62683e-17
C437	a_536_114##7	B#9	1.02548e-19
C438	a_1183_102##3	a_1265_379##12	6.50936e-19
C439	B#5	B#7	3.25836e-19
C440	VPWR#8	a_528_362##2	6.50224e-18
C441	VGND#13	a_536_114##3	1.19193e-18
C442	a_1278_102##14	a_1265_379#	4.68431e-17
C443	VGND#12	a_528_362##9	5.49385e-19
C444	a_1265_379##9	VPWR#17	2.86822e-17
C445	a_528_362##7	a_586_257##4	5.25513e-20
C446	a_1183_102##3	a_1265_379##11	9.07786e-18
C447	a_427_362##2	B#3	8.58227e-17
C448	a_1183_102##3	a_1265_379##3	7.94554e-20
C449	CI#6	a_1265_379##7	5.49896e-20
C450	a_427_362##6	a_536_114##8	6.69735e-17
C451	A	A#4	1.28389e-17
C452	VPWR#7	a_1265_379##12	3.79025e-18
C453	a_586_257##3	B#6	7.47483e-18
C454	B#5	a_586_257##5	4.91265e-17
C455	a_1183_102##6	a_536_114##2	4.75014e-19
C456	a_1265_379##5	a_1265_379##6	1.05037e-19
C457	a_427_362#	B#2	3.67419e-18
C458	VGND#13	B#6	6.70313e-19
C459	a_528_362##5	a_528_362##4	1.27922e-19
C460	a_200_74#	B#3	5.45047e-18
C461	VPWR#7	a_1265_379##11	3.17388e-18
C462	a_1278_102##14	a_1265_379##9	7.31195e-18
C463	a_1265_379##14	a_1378_125#	1.77685e-18
C464	a_1265_379##5	a_1265_379##8	1.53401e-19
C465	a_427_362#	a_586_257#	7.02984e-19
C466	a_1183_102##3	a_536_114#	5.53651e-18
C467	a_1183_102##3	a_1378_125##2	2.09048e-18
C468	a_1265_379##12	VPWR#17	2.87525e-17
C469	a_536_114##2	a_1378_125#	1.52951e-18
C470	a_27_74##6	a_27_74#	1.07368e-19
C471	a_1278_102##15	a_1265_379##10	2.42918e-19
C472	a_1265_379##5	a_1265_379##10	4.39614e-18
C473	B#2	a_528_362##5	1.22773e-18
C474	VGND#11	VGND#10	7.76373e-18
C475	a_200_74##3	A#6	8.88381e-19
C476	VGND#13	B#8	8.08607e-18
C477	VPWR#4	VPWR#3	9.53351e-19
C478	VPWR#9	a_536_114##5	1.64264e-18
C479	a_586_257##7	a_536_114##2	3.87333e-17
C480	a_27_74##4	B#5	4.92615e-17
C481	a_1265_379##5	a_1378_125#	4.19119e-17
C482	VGND#12	a_536_114##2	2.81285e-18
C483	VGND#13	a_586_257##4	1.04585e-17
C484	a_200_74#	VPWR#11	1.85702e-19
C485	CI#6	a_1265_379#	4.16889e-19
C486	COUT#5	a_1265_379##12	4.15687e-17
C487	a_1265_379##5	a_536_114##2	2.76557e-19
C488	a_1278_102##14	a_1265_379##6	1.9348e-17
C489	a_1265_379##16	a_1378_125##10	4.27174e-18
C490	a_427_362#	a_586_257##3	1.70318e-18
C491	VGND#13	B#9	1.07085e-18
C492	A#1	B#5	2.74589e-19
C493	VGND#7	a_1265_379##11	4.69638e-20
C494	a_1265_379##14	a_536_114##2	5.9463e-17
C495	a_586_257##2	B#2	6.08213e-18
C496	VGND#13	a_27_74#	1.48033e-18
C497	VPWR#10	VPWR#11	9.2573e-17
C498	A#1	a_27_74##4	5.2825e-18
C499	a_1278_102##15	a_1378_125#	4.60983e-18
C500	a_1183_102#	a_1378_125##7	2.70902e-18
C501	a_1278_102##16	a_1265_379##9	6.813e-18
C502	a_1278_102##14	a_1265_379##12	2.17887e-19
C503	a_1378_125##3	a_536_114##2	4.30872e-17
C504	VGND#13	A#6	2.01378e-18
C505	a_536_114##12	a_528_362##2	1.72797e-18
C506	VPWR#10	VPWR#9	1.41139e-16
C507	a_27_74##6	A#6	4.93292e-18
C508	a_586_257##7	a_528_362#	6.22484e-18
C509	VGND#7	a_536_114#	5.91482e-20
C510	a_536_114##12	a_536_114##11	2.41004e-17
C511	a_528_362#	a_536_114##2	3.96327e-17
C512	a_200_74##3	A#5	9.33963e-20
C513	COUT#5	a_1265_379##11	3.17306e-17
C514	a_1378_125##3	a_528_362#	8.37379e-19
C515	VGND#13	A#5	1.69236e-18
C516	a_586_257##3	a_586_257##2	5.51401e-19
C517	a_1378_125##8	a_536_114##2	8.92313e-19
C518	a_536_114##12	a_536_114##5	8.24297e-20
C519	a_528_362##10	B#2	2.83513e-19
C520	a_200_74##3	a_200_74##6	1.95523e-18
C521	VPWR#9	a_528_362##3	1.39556e-17
C522	a_27_74##3	VPWR#20	1.10652e-18
C523	A#7	A#1	4.21119e-17
C524	a_536_114##4	a_536_114##2	5.36768e-19
C525	a_536_114##12	a_528_362##3	9.41784e-19
C526	VGND#12	a_528_362#	1.41217e-18
C527	a_1265_379##11	VPWR#18	2.71133e-17
C528	a_200_74##3	a_200_74##2	2.04354e-18
C529	B#3	B#4	8.07271e-19
C530	a_528_362#	a_1265_379##14	1.74257e-17
C531	a_1278_102##14	a_1265_379##8	1.98493e-17
C532	a_1278_102##16	a_1265_379##12	1.41909e-17
C533	a_536_114##3	a_536_114##2	1.06169e-18
C534	a_27_74##3	a_200_74##5	1.67156e-17
C535	VPWR#21	A#4	5.49698e-18
C536	a_536_114##4	a_528_362#	2.26932e-17
C537	a_1183_102#	a_528_362##2	2.85961e-18
C538	B#3	B#2	5.28726e-17
C539	a_1278_102##15	a_536_114##2	2.17834e-17
C540	COUT#5	a_1378_125##4	1.90057e-18
C541	SUM#2	SUM#3	2.24252e-18
C542	a_536_114##3	a_536_114##4	1.03082e-18
C543	a_586_257##7	a_536_114##3	2.54926e-17
C544	VGND#2	VGND#1	5.58951e-17
C545	a_27_74##6	A#5	8.34049e-18
C546	a_1378_125##8	a_528_362#	3.12077e-17
C547	a_1278_102##14	a_1265_379##11	1.14858e-18
C548	a_536_114##3	a_528_362#	4.60214e-17
C549	a_528_362##10	a_586_257##3	3.5002e-18
C550	a_200_74##6	B#4	5.10446e-19
C551	a_1183_102#	a_528_362##3	2.62529e-18
C552	a_1378_125##4	VPWR#18	2.97666e-17
C553	a_200_74##3	a_427_362##4	2.06881e-17
C554	a_1183_102##2	a_536_114##2	4.78939e-19
C555	a_1278_102##16	a_1265_379##11	2.14996e-17
C556	a_1265_379##14	a_536_114##3	1.06236e-18
C557	a_1183_102#	B#1	7.60158e-18
C558	a_27_74##6	a_200_74##3	4.94529e-19
C559	a_528_362##5	a_528_362##6	5.71316e-18
C560	a_528_362##12	a_528_362##3	2.58235e-19
C561	a_1278_102##15	a_528_362#	2.60342e-17
C562	B	B#2	2.03933e-17
C563	a_1183_102##5	a_1378_125##4	3.13494e-17
C564	a_200_74##4	VGND#19	2.79795e-17
C565	VPWR#9	B#1	1.84764e-18
C566	VGND#12	a_536_114##3	1.43081e-17
C567	B#6	a_528_362##5	1.37552e-17
C568	a_1278_102##14	a_1265_379##10	2.714e-17
C569	VGND#2	SUM#5	1.38926e-17
C570	a_528_362##12	B#1	1.56706e-17
C571	a_586_257##3	B#8	1.57503e-17
C572	a_200_74##2	a_427_362##4	9.53964e-17
C573	a_1278_102##15	a_1278_102##14	1.40131e-18
C574	a_1378_125##8	a_536_114##3	3.02902e-17
C575	a_1278_102##16	a_1378_125##4	1.70277e-17
C576	a_1183_102##2	a_528_362#	6.44429e-19
C577	a_528_362##6	a_536_114##3	2.67145e-17
C578	a_586_257##11	VPWR#19	8.21854e-17
C579	B#3	B#6	6.16522e-18
C580	a_200_74##3	VPWR#20	3.17325e-20
C581	a_27_74##8	A#4	5.08046e-19
C582	a_1265_379##14	a_528_362##6	3.3988e-19
C583	a_536_114#	a_1183_102##5	2.26411e-17
C584	a_536_114##8	B#5	5.46333e-19
C585	a_200_74##3	a_427_362##6	8.2112e-17
C586	B#3	a_586_257##2	3.87293e-19
C587	a_528_362##9	a_586_257#	7.31874e-18
C588	COUT#6	a_1265_379##2	4.00972e-18
C589	a_1183_102##5	a_1378_125##2	3.1318e-19
C590	a_1278_102##15	a_536_114##3	2.70081e-17
C591	VGND#20	VGND#19	2.39001e-18
C592	a_27_74##6	a_200_74##2	4.38666e-19
C593	a_586_257##6	a_586_257##3	2.14069e-17
C594	a_536_114##12	a_528_362##4	9.60411e-20
C595	a_528_362##9	B#7	7.41046e-18
C596	a_586_257##8	a_528_362#	1.91571e-19
C597	a_1278_102##16	a_536_114#	6.26512e-17
C598	B#6	a_536_114##3	4.27207e-19
C599	VGND#17	VGND#11	6.76951e-18
C600	a_586_257##6	B#6	5.20311e-18
C601	a_1278_102##16	a_1265_379##3	2.74145e-19
C602	a_1378_125##7	a_1265_379##12	2.81257e-19
C603	a_536_114##7	a_586_257#	2.74848e-18
C604	a_1378_125##8	a_528_362##6	6.86355e-18
C605	a_200_74##6	a_586_257##3	1.19585e-17
C606	COUT#2	VGND#11	1.07948e-19
C607	a_536_114##8	B#4	1.4783e-19
C608	a_200_74##2	VPWR#20	1.12013e-17
C609	a_586_257##6	a_586_257##2	1.07926e-17
C610	a_1278_102##14	a_1378_125#	1.36075e-17
C611	VGND#12	a_528_362##6	2.98341e-18
C612	a_1378_125##7	a_536_114##11	1.37981e-19
C613	VGND#13	VGND#14	7.78768e-17
C614	a_1183_102##2	a_536_114##3	1.17433e-18
C615	a_536_114##7	B#7	1.98761e-17
C616	a_586_257##6	B#8	1.49415e-18
C617	VGND#13	VGND#12	1.44281e-16
C618	B#6	a_528_362##6	2.22873e-18
C619	a_586_257##6	a_586_257##4	9.42155e-19
C620	a_1265_379##3	VGND#11	1.13994e-18
C621	a_536_114##7	a_586_257##5	7.30741e-18
C622	VPWR#10	B#1	5.11985e-19
C623	VPWR#11	VPWR#20	5.74604e-18
C624	VGND#20	a_200_74##4	5.45023e-17
C625	a_1278_102##15	a_528_362##6	2.34896e-17
C626	a_528_362##7	B#7	2.302e-18
C627	a_1278_102##4	VPWR#4	2.68531e-19
C628	a_528_362##2	a_1278_102##16	9.46209e-18
C629	a_200_74##3	VGND#19	6.5364e-17
C630	VPWR#10	a_586_257#	7.05468e-18
C631	a_536_114##7	B#5	5.70773e-19
C632	a_1265_379##16	a_536_114#	1.36677e-19
C633	a_1265_379##5	a_1265_379##11	1.52549e-17
C634	a_586_257##4	a_586_257##3	1.2464e-18
C635	a_586_257##8	a_536_114##3	8.51679e-20
C636	a_528_362##7	a_586_257##5	1.56294e-17
C637	VGND#13	B#1	5.256e-20
C638	VPWR#10	B#7	2.90843e-19
C639	a_528_362##2	a_1378_125##10	2.08125e-17
C640	a_528_362##7	B#5	6.20073e-18
C641	a_528_362##6	a_1183_102##2	1.3082e-17
C642	a_1378_125##7	a_1265_379##11	2.38415e-17
C643	a_200_74##5	a_200_74##2	2.21746e-17
C644	a_1378_125##3	a_1265_379##11	7.22702e-21
C645	VPWR#10	a_586_257##5	2.95413e-18
C646	a_1378_125##7	VPWR#17	2.64507e-21
C647	a_1183_102##3	VGND#7	4.7835e-19
C648	a_27_74##3	a_27_74#	2.89358e-19
C649	VGND#13	B#7	3.87741e-19
C650	a_528_362##7	a_27_74##4	2.60212e-19
C651	VGND#7	a_1378_125##2	1.01666e-19
C652	VGND#18	a_536_114##3	2.91413e-19
C653	a_1378_125##3	a_1378_125##4	4.42304e-19
C654	a_1278_102##14	a_536_114##2	2.21175e-19
C655	VPWR#10	B#5	1.48091e-17
C656	a_1265_379##2	VGND#11	1.23801e-18
C657	a_1278_102##16	a_1378_125##2	3.58328e-19
C658	a_1265_379##16	a_528_362##2	1.95859e-17
C659	VGND#12	B#6	2.33973e-18
C660	a_27_74##3	A#6	8.51956e-18
C661	a_1278_102##15	B#6	3.40378e-19
C662	a_586_257##2	B#6	5.61723e-18
C663	a_1378_125##3	a_536_114#	2.74264e-17
C664	VPWR#10	a_27_74##4	9.34283e-18
C665	a_27_74##3	a_27_74##2	4.93631e-18
C666	a_586_257##8	a_528_362##6	1.79625e-17
C667	CI#6	SUM#3	1.83712e-18
C668	a_200_74##4	a_200_74##3	2.6813e-18
C669	a_1378_125##3	a_528_362##2	3.59985e-18
C670	a_536_114##5	a_1378_125##10	1.3481e-17
C671	a_536_114##8	a_586_257##3	1.39192e-18
C672	a_27_74##3	A#4	3.59595e-17
C673	a_200_74##5	VPWR#11	1.79473e-17
C674	VPWR#10	A#1	2.69606e-18
C675	A#10	a_200_74##3	3.98295e-18
C676	B	VPWR#9	7.98715e-18
C677	a_1183_102##2	B#6	2.64704e-18
C678	COUT	a_1265_379##3	1.15805e-17
C679	a_1183_102#	a_536_114##12	1.41204e-16
C680	COUT	a_1265_379##2	1.46757e-17
C681	VPWR#10	A#7	2.08927e-18
C682	COUT	a_1378_125##2	1.11501e-20
C683	a_536_114##4	a_528_362##2	1.53633e-17
C684	a_1265_379##16	a_536_114##5	4.83545e-17
C685	a_27_74##7	VGND#20	5.06443e-17
C686	a_427_362##2	a_536_114##6	3.52356e-17
C687	VGND#12	B#1	9.6255e-21
C688	COUT#1	a_1265_379##3	9.93835e-19
C689	a_27_74##6	A	6.14917e-17
C690	a_1378_125##7	a_1378_125##4	1.71827e-17
C691	VGND#4	a_1278_102##4	4.11896e-17
C692	a_528_362##12	a_536_114##12	5.13087e-17
C693	COUT#2	a_1265_379##6	9.80321e-18
C694	a_1378_125##7	COUT#5	2.4519e-18
C695	a_528_362##3	a_536_114##4	8.823e-18
C696	a_586_257##8	B#6	8.21925e-17
C697	B#8	a_586_257##2	3.14958e-17
C698	a_1183_102##3	a_586_257##7	5.68219e-19
C699	a_536_114##8	a_27_74##2	6.58799e-19
C700	VPWR#10	a_1378_125##7	2.37392e-17
C701	VPWR#6	a_1265_379##5	4.5499e-19
C702	a_528_362##3	a_1265_379##16	2.84732e-17
C703	a_528_362##12	a_1183_102#	4.40661e-17
C704	a_427_362##2	a_200_74#	1.8139e-17
C705	a_1183_102##3	a_1265_379##14	1.22842e-17
C706	VGND#14	a_200_74##4	9.20782e-18
C707	a_27_74##2	B#9	1.26692e-17
C708	a_1265_379##14	a_1378_125##7	1.26428e-17
C709	B#6	VGND#18	2.31598e-17
C710	a_528_362##5	B#1	2.17174e-17
C711	VPWR#2	a_1278_102##4	5.77332e-18
C712	VPWR#21	VPWR#11	2.16804e-18
C713	a_1278_102##4	SUM#3	4.73139e-17
C714	a_528_362##3	a_586_257##11	1.73823e-17
C715	a_27_74##8	a_200_74##2	3.45478e-19
C716	VGND#4	a_1278_102##5	6.28532e-19
C717	B#3	a_528_362##3	4.78727e-20
C718	a_1183_102#	a_528_362##4	1.29715e-17
C719	VGND#2	a_1278_102##4	5.60542e-18
C720	VGND#5	CI#2	5.16345e-20
C721	a_586_257##8	a_586_257##2	8.74549e-19
C722	SUM#2	a_1278_102##4	3.67307e-17
C723	B#3	B#1	1.67536e-19
C724	a_1378_125##7	a_536_114#	2.77148e-17
C725	a_536_114##12	VPWR#10	3.14621e-17
C726	a_1183_102##3	a_1278_102##15	3.04591e-18
C727	COUT#2	a_1265_379##8	8.14415e-18
C728	a_1378_125##7	VPWR#18	6.03558e-18
C729	a_586_257##4	B#8	2.98357e-17
C730	a_427_362#	B#6	6.17944e-18
C731	a_1183_102##4	a_1265_379##11	4.61075e-18
C732	VGND#4	CI#2	5.96665e-20
C733	VPWR#19	a_528_362##3	2.33748e-18
C734	B#3	a_586_257#	2.85245e-18
C735	a_528_362##12	a_536_114##7	4.01578e-17
C736	a_1278_102##14	a_1278_102##4	1.52983e-18
C737	A#10	a_200_74##5	1.62464e-17
C738	B#3	B#7	5.88087e-19
C739	a_1183_102#	B#2	2.10271e-19
C740	a_27_74##6	a_27_74##8	1.79002e-18
C741	a_536_114##7	a_528_362##9	1.52834e-16
C742	VPWR#11	B#5	1.09099e-17
C743	a_27_74##6	A#10	8.92618e-18
C744	VPWR#10	a_1183_102#	2.55032e-18
C745	a_586_257##11	B#1	4.58797e-17
C746	B#3	a_586_257##5	2.00353e-19
C747	VPWR#8	a_1378_125##3	3.21051e-20
C748	a_1378_125##9	a_1265_379#	1.86346e-18
C749	CI#6	a_1278_102##4	7.75118e-18
C750	a_1378_125##7	a_1378_125#	4.51325e-19
C751	a_528_362##10	B#6	3.88492e-19
C752	B#3	B#5	3.36634e-19
C753	a_1265_379##5	a_1183_102##3	2.56529e-17
C754	VGND#13	a_1183_102#	1.83375e-17
C755	VGND#7	VGND#11	6.05881e-19
C756	VPWR#19	B#1	5.45448e-17
C757	a_586_257##8	B#8	1.16673e-19
C758	VPWR#3	VPWR#1	8.82913e-19
C759	a_427_362##6	a_27_74##2	4.18947e-18
C760	a_528_362##7	a_536_114##7	5.89049e-17
C761	VPWR#7	a_1265_379##5	5.41804e-20
C762	VPWR#10	a_528_362##9	8.97316e-19
C763	a_27_74##6	VGND#20	3.60795e-17
C764	VGND#13	a_528_362##12	1.62017e-17
C765	VGND#3	VGND#1	2.50407e-18
C766	SUM#3	CI#2	4.35246e-20
C767	VGND#6	a_1265_379##5	6.79211e-21
C768	a_427_362#	a_586_257##2	3.08379e-17
C769	a_1183_102##3	a_1378_125##3	6.78312e-17
C770	B#9	a_586_257##4	5.25024e-17
C771	a_536_114##7	VPWR#10	5.03006e-17
C772	a_1378_125##7	a_528_362##2	4.92789e-17
C773	VGND#13	a_528_362##9	2.4846e-17
C774	COUT#2	a_1265_379##10	2.936e-19
C775	a_536_114##7	a_200_74##2	1.34237e-18
C776	B#2	a_528_362##3	4.53667e-19
C777	a_536_114##12	a_1265_379##14	3.83183e-18
C778	a_1183_102##4	a_1378_125##4	6.64719e-18
C779	a_1378_125##7	a_1183_102##5	9.30334e-18
C780	VGND#6	a_1265_379##3	3.10497e-20
C781	VGND#14	a_586_257##4	4.25985e-19
C782	A#10	VPWR#21	1.64343e-17
C783	VGND#7	a_1265_379##5	5.87752e-20
C784	a_528_362##7	VPWR#10	1.0083e-17
C785	a_1278_102##14	CI#2	3.47765e-18
C786	a_536_114##12	a_1378_125##3	8.48791e-19
C787	VGND#13	a_536_114##7	9.06057e-19
C788	VPWR#10	a_536_114##11	1.16519e-18
C789	a_200_74#	a_528_362##8	8.59655e-19
C790	a_27_74##3	a_27_74##4	3.89701e-18
C791	a_586_257##2	a_528_362##10	1.5507e-17
C792	a_536_114##12	a_1378_125##8	2.65046e-17
C793	a_1378_125##7	a_1378_125##2	2.24649e-19
C794	VGND#3	a_1278_102##5	5.50301e-20
C795	VGND#7	a_1378_125##3	2.15591e-19
C796	a_528_362##12	a_528_362##4	1.71988e-19
C797	VGND#13	a_528_362##7	1.64555e-17
C798	VPWR#9	a_536_114##4	1.58038e-19
C799	a_27_74#	a_586_257##4	1.27645e-18
C800	a_536_114##12	a_536_114##4	4.70227e-19
C801	a_427_362##6	A#4	1.31513e-20
C802	A#4	a_27_74#	9.99466e-20
C803	VPWR#11	a_27_74##4	1.35205e-17
C804	a_1378_125##7	a_536_114##2	1.27132e-17
C805	CI#6	CI#2	5.97048e-18
C806	a_427_362#	B#8	9.29e-19
C807	VGND#7	a_586_257##7	5.71619e-17
C808	a_427_362##2	a_586_257#	4.21431e-17
C809	COUT	a_1278_102##14	6.75589e-17
C810	a_536_114##12	a_528_362##5	4.68634e-18
C811	a_27_74##6	a_27_74##7	4.63127e-19
C812	a_528_362##7	a_200_74##3	1.31757e-18
C813	a_1265_379##14	a_1183_102##6	2.68181e-17
C814	a_200_74##6	a_586_257##2	1.7244e-18
C815	a_1183_102#	a_536_114##4	4.32386e-17
C816	a_536_114##12	a_1183_102##2	4.53508e-19
C817	a_427_362##4	a_200_74#	6.63249e-17
C818	a_586_257##8	B	2.83764e-19
C819	a_528_362##12	B#2	2.42717e-18
C820	B#2	a_528_362##4	6.09926e-19
C821	a_27_74#	B#9	3.14374e-17
C822	A#6	a_586_257##4	1.65993e-19
C823	B#1	a_528_362##4	1.27345e-18
C824	VPWR#2	VPWR#1	5.10402e-17
C825	a_536_114##6	a_586_257#	2.44191e-17
C826	a_1183_102#	a_528_362##5	2.51208e-17
C827	a_1378_125##7	a_536_114##5	1.17582e-17
C828	COUT#2	a_1378_125#	1.15218e-19
C829	COUT#2	COUT	9.03425e-19
C830	a_536_114##12	a_586_257##8	1.84368e-18
C831	B#8	a_528_362##10	1.90182e-17
C832	a_1378_125##7	a_1278_102##16	2.48522e-16
C833	VGND#4	VGND#8	4.67123e-18
C834	a_1378_125##8	a_1265_379##16	3.02257e-18
C835	VPWR	VPWR#9	3.64278e-17
C836	VGND#6	a_1265_379##2	4.36828e-20
C837	VPWR	VPWR#8	1.51063e-16
C838	a_536_114##8	a_586_257##2	8.93049e-19
C839	VGND#14	B#9	3.29323e-19
C840	VPWR	VPWR#6	5.81369e-17
C841	a_427_362##2	B#7	2.22472e-17
C842	a_27_74##2	VGND#19	8.01181e-19
C843	a_1278_102##14	a_1265_379##5	9.26219e-17
C844	VPWR	VPWR#5	1.02039e-16
C845	a_200_74#	a_586_257#	9.64847e-19
C846	VPWR	VPWR#4	5.45725e-17
C847	VGND#7	a_1278_102##15	8.22521e-17
C848	a_1278_102##4	CI#2	2.43565e-17
C849	VPWR#14	VPWR#1	1.4765e-18
C850	a_528_362##12	B#3	1.58899e-17
C851	a_427_362##4	a_528_362##8	5.59956e-17
C852	A	VPWR#21	2.61112e-17
C853	a_1183_102#	a_586_257##7	1.00049e-18
C854	VPWR#2	VPWR#14	2.08937e-17
C855	VGND#3	a_1278_102##3	3.38429e-20
C856	B#8	a_200_74##6	2.02664e-17
C857	a_528_362##9	B#3	8.14912e-18
C858	B#2	B#1	1.87445e-17
C859	B#7	a_536_114##6	1.81586e-17
C860	a_1265_379##14	a_586_257##7	2.72319e-18
C861	VPWR#9	a_528_362##5	3.58387e-20
C862	VGND#2	VPWR#1	4.467e-18
C863	a_1183_102#	a_1265_379##14	2.65817e-17
C864	a_536_114##7	B#3	2.59423e-17
C865	VPWR#11	A#1	2.21014e-18
C866	VPWR#2	SUM#4	1.80313e-17
C867	A#6	a_27_74#	3.7214e-18
C868	VPWR	a_1278_102##14	1.38588e-17
C869	a_586_257##6	a_528_362##9	4.90309e-18
C870	VGND#13	a_536_114##4	9.30564e-19
C871	a_1278_102##3	SUM#6	2.31756e-19
C872	a_1278_102##15	a_1265_379##16	2.90763e-19
C873	VPWR	CI#6	4.02995e-18
C874	a_528_362##10	a_586_257##4	9.36555e-19
C875	VPWR#10	a_200_74##2	1.89001e-17
C876	a_427_362##2	a_586_257##5	6.76261e-19
C877	B#7	a_200_74#	2.27615e-17
C878	VGND#12	a_528_362##4	1.13236e-19
C879	VGND#12	a_536_114##4	2.27607e-20
C880	a_1183_102#	a_1378_125##8	7.31545e-17
C881	a_427_362##4	a_586_257#	1.71678e-19
C882	a_536_114##7	a_586_257##6	4.42591e-19
C883	VPWR	a_1378_125##7	9.43358e-17
C884	a_586_257##11	a_1378_125##8	1.80138e-17
C885	VGND#13	a_528_362##5	7.94119e-18
C886	a_1183_102##4	COUT#5	8.91698e-18
C887	a_536_114##8	B#8	1.71361e-17
C888	VPWR#10	B#3	1.09113e-17
C889	a_1278_102##3	a_1278_102#	1.7758e-19
C890	COUT#2	CI#2	2.11371e-19
C891	a_1378_125##7	a_528_362##3	3.17699e-17
C892	SUM	VPWR#1	2.50753e-17
C893	COUT#1	COUT	2.52169e-18
C894	a_586_257##11	B	1.34174e-17
C895	VPWR	a_1183_102##4	5.84519e-19
C896	SUM	SUM#6	2.62213e-19
C897	a_1378_125##7	a_1378_125##10	5.0661e-18
C898	a_1183_102#	a_1278_102##15	4.10168e-18
C899	a_528_362##9	B#4	4.21161e-19
C900	B	VPWR#19	5.88259e-17
C901	VGND#13	B#3	3.22818e-18
C902	VPWR#14	SUM	2.88081e-17
C903	a_528_362##8	B#7	1.6032e-18
C904	VPWR	a_536_114##11	1.14507e-18
C905	VGND#4	SUM#5	8.98536e-18
C906	a_528_362##7	a_27_74##3	1.28079e-18
C907	a_200_74##6	a_586_257##4	4.06575e-17
C908	a_1278_102##5	VNB	4.28353e-17
C909	a_1278_102##3	VNB	2.00982e-17
C910	a_1278_102##2	VNB	3.72103e-17
C911	VGND#13	a_586_257##6	2.03008e-17
C912	VGND#14	a_27_74#	3.37345e-18
C913	a_528_362##9	B#2	8.45461e-19
C914	a_1183_102#	a_1183_102##2	1.61702e-18
C915	B#4	B#2	1.36593e-18
C916	a_1265_379##3	VNB	2.01547e-17
C917	a_1265_379##2	VNB	2.62674e-17
C918	VPWR#10	a_27_74##3	5.14943e-18
C919	a_586_257##11	a_528_362##4	3.94452e-19
C920	a_427_362##6	B#8	6.54105e-20
C921	a_1378_125##2	VNB	2.6211e-17
C922	a_528_362##4	VNB	2.34221e-17
C923	a_427_362##2	B#5	2.84611e-19
C924	a_200_74#	a_586_257##5	2.7935e-17
C925	B#4	VNB	1.06412e-16
C926	SUM#4	VPWR#4	8.49345e-18
C927	B#2	VNB	1.79163e-16
C928	a_1278_102##2	SUM#6	2.76509e-19
C929	a_427_362##4	B#7	5.22433e-19
C930	a_586_257##3	VNB	6.95464e-17
C931	a_1378_125##7	a_1265_379##5	3.54501e-19
C932	a_27_74##2	VNB	2.1225e-17
C933	A#4	VNB	7.18759e-17
C934	VGND#13	a_27_74##3	7.86848e-18
C935	VGND#3	a_1278_102##2	4.03781e-20
C936	VGND#13	a_200_74##3	3.59274e-17
C937	VGND	VGND#12	4.00258e-17
C938	A#5	A#6	4.16248e-17
C939	a_528_362##9	a_586_257##3	2.96275e-19
C940	VGND	VGND#6	5.43463e-17
C941	a_1183_102#	a_586_257##8	1.47004e-18
C942	VGND	VGND#5	5.90358e-17
C943	a_1183_102##6	a_1378_125##2	9.50061e-18
C944	a_1278_102##5	a_1278_102##3	8.09879e-19
C945	VGND	VGND#4	6.07055e-17
C946	VPWR#14	a_1278_102##5	9.43225e-19
C947	VPWR#10	A#10	2.36874e-18
C948	a_536_114##8	a_586_257##4	4.90843e-17
C949	VGND#5	a_1265_379##2	1.16488e-20
C950	a_586_257#	B#4	1.2381e-17
C951	B#3	VPWR#9	1.0966e-17
C952	a_528_362##8	a_586_257##5	2.75319e-17
C953	VGND	a_1278_102##14	6.60191e-17
C954	VPWR#11	A#7	6.74567e-19
C955	a_1378_125#	a_1265_379##11	2.02849e-17
C956	VPWR#5	VPWR#15	3.21678e-18
C957	a_1183_102##4	VPWR#18	1.63632e-18
C958	VGND#13	a_27_74##6	1.83423e-18
C959	COUT#2	a_1265_379##3	5.0068e-18
C960	VGND#1	a_1278_102##7	2.36588e-17
C961	VGND#12	a_528_362##5	4.99415e-19
C962	a_200_74##6	B#9	6.08075e-18
C963	a_1265_379##5	COUT#2	8.9189e-18
C964	VGND	COUT#2	6.50404e-18
C965	a_200_74#	B#5	1.67944e-17
C966	a_1378_125##7	B#1	2.37556e-18
C967	a_427_362##2	a_27_74##4	7.26616e-20
C968	a_586_257#	B#2	2.91399e-17
C969	a_427_362##4	a_586_257##5	1.78771e-17
C970	a_536_114##11	a_528_362##2	5.58437e-18
C971	COUT	VPWR#17	1.10813e-18
C972	VGND#3	SUM#5	4.95749e-18
C973	a_1378_125##7	a_1265_379##16	1.53938e-16
C974	SUM#4	VPWR#3	8.5883e-18
C975	a_427_362##6	a_586_257##4	1.37193e-19
C976	a_1378_125##8	a_1265_379##14	2.99264e-17
C977	a_1278_102##15	a_586_257##7	1.48766e-16
C978	a_1183_102##2	a_586_257##11	5.85566e-19
C979	COUT	a_1278_102##16	2.6836e-17
C980	VGND#4	VGND#9	6.97071e-18
C981	SUM#2	VGND#1	7.52934e-17
C982	VPWR#14	a_1278_102##3	2.54131e-19
C983	B#5	a_528_362##8	1.7158e-17
C984	a_528_362##12	a_586_257##8	4.75343e-17
C985	a_1378_125##9	VPWR#6	5.21199e-17
C986	a_536_114##8	B#9	3.64904e-17
C987	SUM#4	VPWR#14	7.67352e-17
C988	a_1183_102##4	a_536_114##2	1.6176e-19
C989	a_200_74##4	A#4	6.0094e-19
C990	VPWR#11	VNB	4.47565e-17
C991	a_1378_125##3	a_1378_125##7	1.51416e-18
C992	VPWR#9	VNB	8.57988e-17
C993	VPWR#8	VNB	7.6246e-17
C994	a_1278_102##7	SUM#1	1.54011e-17
C995	VGND#13	A#10	2.20596e-18
C996	VPWR#6	VNB	2.61647e-17
C997	a_1183_102##4	a_1265_379##5	3.56309e-18
C998	VPWR#5	VNB	4.58969e-17
C999	VPWR#4	VNB	3.26358e-17
C1000	a_528_362##12	VGND#18	3.19872e-19
C1001	VGND#19	a_586_257##4	3.89189e-19
C1002	VPWR#3	VNB	2.19013e-17
C1003	VPWR	VPWR#15	2.0124e-17
C1004	a_200_74#	a_27_74##4	9.60346e-19
C1005	a_200_74##3	a_586_257##3	4.3762e-20
C1006	VGND	a_1378_125##5	6.41205e-18
C1007	a_427_362##4	B#5	6.05043e-17
C1008	VPWR	a_1378_125##9	5.01461e-17
C1009	a_586_257##11	B#2	1.1118e-17
C1010	VGND#14	VNB	4.40613e-17
C1011	VGND	VGND#10	2.14363e-17
C1012	a_536_114##7	B#4	1.26825e-18
C1013	VGND#12	VNB	1.01124e-16
C1014	VGND	COUT#6	3.55573e-18
C1015	VGND#6	VNB	2.96098e-17
C1016	VGND	VGND#11	2.12376e-17
C1017	VGND#5	VNB	3.25918e-17
C1018	a_536_114##2	a_1378_125##4	1.29687e-18
C1019	VGND#4	VNB	4.0107e-17
C1020	VGND	COUT#1	2.54739e-18
C1021	VGND#3	VNB	4.11218e-17
C1022	VGND	VGND#17	1.43677e-17
C1023	VPWR	COUT#5	3.59778e-18
C1024	a_200_74##6	a_27_74#	2.48398e-19
C1025	VGND	a_1183_102##6	2.1138e-18
C1026	a_586_257##8	a_586_257##11	1.6284e-18
C1027	SUM#3	VNB	7.86056e-18
C1028	VGND	a_586_257##7	4.58151e-17
C1029	SUM#2	VNB	9.29999e-18
C1030	VPWR	a_1183_102##5	2.42475e-18
C1031	VGND	a_1265_379##14	9.69784e-18
C1032	a_1278_102##14	VNB	3.00868e-17
C1033	VGND	a_1378_125##8	3.25435e-18
C1034	VPWR	a_1278_102##16	2.03933e-17
C1035	VGND#1	a_1278_102##8	1.37306e-18
C1036	a_536_114##7	B#2	2.87711e-18
C1037	CI#6	VNB	2.64147e-18
C1038	VGND	a_1278_102##15	4.56429e-17
C1039	B#9	a_427_362##6	1.75399e-17
C1040	VPWR	a_1265_379##16	5.42331e-18
C1041	a_1278_102##15	a_1265_379##14	1.48875e-16
C1042	COUT#2	a_1265_379##2	8.00225e-18
C1043	a_1378_125##7	VNB	2.16587e-17
C1044	a_1183_102##2	a_586_257##7	3.71527e-20
C1045	COUT#2	VNB	1.23559e-18
C1046	a_536_114##11	a_536_114##5	1.1054e-17
C1047	a_1378_125##9	VPWR#5	8.34221e-17
C1048	a_1183_102##4	VNB	1.46275e-18
C1049	VGND#8	a_1278_102##7	2.52698e-18
C1050	a_536_114##7	a_586_257##3	1.92932e-19
C1051	VGND#12	B#2	3.58242e-20
C1052	a_536_114##11	VNB	5.6059e-19
C1053	a_528_362##9	a_586_257##8	4.52877e-19
C1054	VPWR#15	VPWR#14	1.69573e-18
C1055	a_586_257##11	a_1378_125##7	6.91491e-17
C1056	SUM	a_1278_102#	1.20479e-17
C1057	a_536_114##8	a_27_74#	1.08257e-18
C1058	SUM	a_1278_102##9	1.11548e-17
C1059	SUM#4	a_1278_102##5	3.06643e-18
C1060	a_27_74##4	a_427_362##4	2.14221e-17
C1061	a_200_74##5	B#5	3.85823e-19
C1062	a_200_74##3	VNB	1.18428e-17
C1063	B#7	B#4	2.35203e-19
C1064	a_1378_125##9	VPWR#7	3.71892e-18
C1065	a_200_74##2	VNB	6.46017e-19
C1066	a_27_74##6	VNB	4.54939e-17
C1067	a_536_114##7	a_27_74##2	3.54666e-19
C1068	A#10	VNB	3.96094e-19
C1069	a_528_362##9	VGND#18	7.4113e-19
C1070	VGND#1	VNB	7.51145e-17
C1071	SUM#2	SUM#1	2.50422e-18
C1072	a_1278_102##8	SUM#1	3.43101e-18
C1073	VGND#8	VNB	1.26063e-18
C1074	B	B#1	1.26119e-18
C1075	SUM#5	VNB	2.60419e-18
C1076	VGND	a_1183_102##5	4.73305e-19
C1077	a_1378_125##5	VNB	6.87951e-18
C1078	VGND#10	VNB	8.87187e-18
C1079	a_27_74##4	VPWR#20	3.04654e-17
C1080	COUT#6	VNB	3.97365e-19
C1081	a_1378_125##7	a_536_114##4	1.40319e-19
C1082	a_1378_125##3	a_1183_102##4	2.44874e-17
C1083	VPWR#21	B#5	6.05263e-20
C1084	VGND#11	VNB	9.63293e-18
C1085	VPWR#19	B#4	1.82168e-19
C1086	a_200_74##3	a_27_74##2	2.08169e-17
C1087	VGND#17	VNB	3.11923e-18
C1088	B#7	B#2	6.19783e-19
C1089	a_528_362##9	a_427_362#	2.67081e-17
C1090	a_1183_102##6	VNB	6.7595e-19
C1091	a_586_257##7	VNB	1.13053e-17
C1092	a_1265_379##14	VNB	1.85427e-17
C1093	SUM#5	a_1278_102##7	1.89459e-19
C1094	a_27_74#	a_427_362##6	1.87977e-17
C1095	a_1378_125##8	VNB	9.04216e-20
C1096	a_1278_102##15	VNB	2.59897e-17
C1097	a_1183_102##2	VNB	4.36516e-18
C1098	a_586_257##8	VNB	2.76494e-17
C1099	a_536_114##2	a_528_362##2	2.19062e-17
C1100	VGND#18	VNB	3.35485e-18
C1101	COUT	CI#3	3.61022e-19
C1102	a_427_362#	VNB	3.0463e-18
C1103	a_1378_125##8	a_1278_102##15	5.81069e-17
C1104	a_1378_125##9	VPWR#4	6.35785e-18
C1105	a_528_362##10	VNB	5.43052e-18
C1106	COUT	a_1265_379##7	1.33149e-17
C1107	a_1183_102##2	a_1265_379##14	2.55991e-18
C1108	a_200_74##6	VNB	8.73765e-18
C1109	a_536_114##8	VNB	4.39188e-18
C1110	COUT	a_1265_379##9	1.8291e-17
C1111	a_200_74##5	a_27_74##4	4.84172e-18
C1112	a_427_362##6	VNB	4.6988e-18
C1113	VGND#19	VNB	5.66001e-18
C1114	COUT	a_1265_379##12	4.4435e-19
C1115	VPWR#15	SUM#4	9.17284e-17
C1116	VGND#14	a_27_74##2	8.92421e-20
C1117	VPWR#21	a_200_74##5	7.63881e-17
C1118	a_200_74##4	VNB	1.03375e-17
C1119	VGND#20	VNB	2.90806e-18
C1120	COUT	a_1265_379##11	2.11909e-19
C1121	a_27_74##7	VNB	3.04546e-17
C1122	a_586_257##3	B#7	1.92455e-19
C1123	VPWR#1	VNB	7.89926e-17
C1124	COUT	a_1378_125##4	1.65509e-20
C1125	a_1183_102##4	a_1278_102##16	2.39433e-17
C1126	a_536_114##7	a_586_257##8	2.6474e-19
C1127	VGND	CI#1	8.01899e-18
C1128	VPWR#14	VNB	3.72548e-18
C1129	VGND#8	a_1278_102##8	3.4099e-17
C1130	VGND	a_1265_379#	9.08932e-18
C1131	VPWR#11	a_27_74##3	6.11837e-19
C1132	SUM#4	VNB	2.16127e-18
C1133	VPWR#15	VNB	5.34281e-18
C1134	VGND	a_1265_379##6	8.67969e-18
C1135	VGND#20	A#4	1.22172e-18
C1136	a_536_114##11	a_528_362##3	2.29424e-18
C1137	a_1378_125##9	VNB	2.06946e-17
C1138	VGND	a_1265_379##8	9.42092e-18
C1139	VPWR#10	A	2.66764e-18
C1140	VGND	a_1265_379##10	8.6703e-18
C1141	VGND	a_1378_125#	1.21837e-20
C1142	a_1278_102##9	a_1278_102#	4.47733e-17
C1143	a_27_74#	VGND#19	2.11211e-17
C1144	VPWR	a_1278_102##6	2.74651e-18
C1145	VGND#13	A	1.79834e-18
C1146	SUM#3	a_1278_102##5	2.82707e-18
C1147	VPWR#21	a_27_74##4	6.51255e-19
C1148	VPWR	CI#3	8.52713e-18
C1149	a_1278_102##16	VNB	2.09852e-19
C1150	a_1183_102##3	a_1183_102##5	1.18901e-17
C1151	VPWR	a_1265_379##7	5.31075e-19
C1152	a_1278_102##11	a_1278_102##3	1.55261e-19
C1153	SUM	VPWR#2	3.50198e-17
C1154	VGND#1	VPWR#1	1.60578e-17
C1155	a_1265_379##16	VNB	1.60807e-20
C1156	VPWR#19	B#2	9.86463e-18
C1157	VPWR	a_1265_379##9	6.68761e-19
C1158	VPWR#19	a_1378_125##7	3.8249e-18
C1159	a_586_257##11	VNB	6.05883e-18
C1160	a_1278_102##4	VGND#8	2.65329e-18
C1161	a_528_362##7	B#4	1.2087e-19
C1162	VPWR#19	VNB	7.12069e-18
C1163	VPWR	a_1265_379##12	6.71616e-19
C1164	a_427_362##2	VNB	9.98788e-19
C1165	a_528_362##12	B	4.98801e-19
C1166	VPWR	a_1265_379##11	9.22696e-19
C1167	VPWR#5	VPWR#16	1.36743e-17
C1168	VGND#12	a_586_257##3	1.07587e-17
C1169	VGND#12	a_586_257##6	3.10715e-17
C1170	a_536_114##8	a_528_362##9	1.31263e-18
C1171	a_200_74#	VNB	5.65316e-18
C1172	VPWR	a_1378_125##4	7.56713e-18
C1173	a_528_362##8	VNB	2.778e-20
C1174	a_427_362##4	VNB	3.94527e-18
C1175	VPWR	a_536_114#	4.50011e-18
C1176	a_536_114##7	B	3.67259e-18
C1177	a_200_74##5	VNB	1.74317e-17
C1178	VPWR#21	VNB	2.63324e-18
C1179	a_27_74##8	VNB	4.98534e-17
C1180	a_1278_102##4	SUM#5	1.00063e-16
C1181	a_200_74##5	A#1	6.59273e-17
C1182	a_427_362##6	A#6	1.31477e-19
C1183	a_1278_102##7	VNB	3.25517e-17
C1184	a_1183_102##3	a_1278_102##16	2.94494e-17
C1185	a_27_74##8	a_27_74##4	5.16228e-20
C1186	a_1278_102##8	VNB	2.51777e-17
C1187	a_1278_102##10	VNB	2.48852e-17
C1188	VPWR#10	B	1.0087e-17
C1189	a_1278_102##12	VNB	3.13261e-17
C1190	CI#1	VNB	3.50609e-17
C1191	a_200_74##2	VPWR#11	5.14094e-17
C1192	SUM#2	VGND#8	5.12333e-17
C1193	a_1265_379#	VNB	4.86437e-17
C1194	a_200_74##3	A#4	1.53887e-18
C1195	a_1265_379##6	VNB	2.96291e-17
C1196	a_1183_102##3	COUT	2.67618e-18
C1197	SUM#5	a_1278_102##8	4.33532e-19
C1198	a_200_74##4	a_27_74#	9.72271e-19
C1199	a_1265_379##8	VNB	3.03671e-17
C1200	a_1265_379##10	VNB	3.06782e-17
C1201	a_1378_125##9	SUM#4	2.38893e-18
C1202	VGND#10	VGND#4	7.1722e-18
C1203	a_1183_102##2	a_1378_125##8	1.71559e-17
C1204	a_1378_125#	VNB	4.89622e-17
C1205	a_1278_102##4	VGND#9	1.48744e-17
C1206	a_536_114##2	VNB	9.57131e-17
C1207	a_528_362#	VNB	3.61146e-17
C1208	a_536_114##3	VNB	7.32721e-17
C1209	a_528_362##7	a_586_257##3	1.7264e-19
C1210	a_528_362##6	VNB	2.95598e-17
C1211	B#6	VNB	4.66091e-17
C1212	a_1278_102##16	a_1378_125#	2.08151e-18
C1213	a_586_257##2	VNB	2.83887e-17
C1214	A#1	VPWR#21	1.88016e-17
C1215	B#8	VNB	3.08962e-17
C1216	a_1265_379##14	a_1378_125##2	2.72242e-18
C1217	a_586_257##4	VNB	6.62767e-17
C1218	B#9	VNB	3.77811e-17
C1219	a_27_74#	VNB	3.54814e-17
C1220	A#6	VNB	3.89384e-17
C1221	a_1183_102##3	VPWR	3.27287e-17
C1222	a_1378_125##5	a_1278_102##4	1.17867e-17
C1223	a_1278_102##3	a_1278_102##2	8.879e-19
C1224	A#5	VNB	3.47376e-17
C1225	VPWR	VPWR#7	2.84677e-17
C1226	a_536_114##11	a_1265_379##14	1.2433e-17
C1227	a_586_257##5	B#4	1.02852e-17
C1228	VGND#19	A#6	2.70631e-18
C1229	a_1278_102#	VNB	4.15799e-17
C1230	a_536_114##12	VPWR	1.05152e-17
C1231	a_528_362##7	a_27_74##2	2.66334e-19
C1232	VGND#8	a_1278_102##10	3.05246e-17
C1233	a_1278_102##9	VNB	3.15971e-17
C1234	a_1278_102##11	VNB	3.16768e-17
C1235	a_1278_102##6	VNB	3.60561e-17
C1236	a_1278_102##11	a_1278_102##9	3.23055e-17
C1237	a_1183_102#	VPWR	9.28542e-18
C1238	CI#3	VNB	3.81921e-17
C1239	a_1265_379##7	VNB	3.97292e-17
C1240	a_1265_379##9	VNB	3.55811e-17
C1241	a_1265_379##12	VNB	3.60488e-17
C1242	COUT	CI#2	3.46572e-19
C1243	VGND#20	a_27_74#	2.80473e-19
C1244	a_200_74##5	A#7	2.53788e-18
C1245	a_27_74##8	A#1	6.4401e-19
C1246	a_1265_379##11	VNB	4.86952e-17
C1247	a_1378_125##4	VNB	3.9307e-17
C1248	a_1265_379##5	COUT	3.19171e-17
C1249	a_27_74##8	VPWR#21	7.38781e-17
C1250	a_536_114#	VNB	6.02978e-17
C1251	a_528_362##2	VNB	1.04736e-16
C1252	VGND	a_1183_102##3	3.15333e-17
C1253	a_536_114##11	a_536_114##4	3.32742e-19
C1254	a_536_114##5	VNB	2.65912e-17
C1255	a_528_362##3	VNB	7.52516e-17
C1256	B#1	VNB	4.87498e-17
C1257	a_586_257#	VNB	3.34645e-17
C1258	VGND	VGND#7	1.68788e-16
C1259	a_427_362##2	B#4	1.23377e-17
C1260	VPWR	a_1278_102##4	1.9807e-18
C1261	B#7	VNB	4.25144e-17
C1262	VGND	a_1183_102#	1.41224e-17
C1263	a_586_257##5	VNB	3.17208e-17
C1264	B#5	VNB	8.52886e-17
C1265	VPWR	a_1265_379##5	6.68402e-18
C1266	a_27_74##4	VNB	4.51342e-17
C1267	SUM#3	a_1278_102##3	7.52931e-18
C1268	A#1	VNB	3.72071e-17
C1269	VPWR	a_1378_125##3	2.99085e-18
C1270	A#7	VNB	3.73728e-17
C1271	a_427_362##6	a_536_114##7	3.50852e-19
C1272	a_1378_125##9	VPWR#15	6.97765e-17
C1273	VGND#14	a_27_74##3	1.55579e-19
C1274	VPWR#21	A#7	4.70819e-17
C1275	VPWR#2	VNB	1.37007e-16
C1276	a_200_74##4	A#6	4.74744e-17
C1277	VGND#2	VNB	1.17496e-16
C1278	a_1183_102##3	VNB	4.49306e-18
C1279	VGND#13	a_586_257##7	4.63432e-18
C1280	VGND	a_1278_102##4	6.35178e-18
C1281	VPWR#7	VNB	1.47022e-17
C1282	a_536_114##2	a_1278_102##16	6.90359e-19
C1283	a_536_114##12	VNB	5.41814e-19
C1284	VGND	CI#2	3.96038e-18
C1285	VGND#7	VNB	1.00015e-16
C1286	VGND	a_1265_379##5	1.77043e-17
C1287	a_1183_102##2	a_1278_102##15	2.28522e-17
C1288	a_1183_102#	VNB	3.188e-18
C1289	a_586_257##8	a_1378_125##8	2.40008e-18
C1290	VGND	a_1378_125##3	6.01552e-18
C1291	a_528_362##12	VNB	1.71565e-18
C1292	SUM#5	a_1278_102##10	2.96133e-17
C1293	a_528_362##9	VNB	5.45507e-18
C1294	VGND	a_536_114##4	9.50568e-19
C1295	a_536_114##7	VNB	1.33689e-18
C1296	a_528_362##7	VNB	3.08242e-18
C1297	a_536_114##12	a_1183_102##5	2.28883e-18
C1298	VPWR#10	VNB	3.40207e-16
C1299	VGND#13	VNB	3.31954e-16
C1300	a_1278_102##4	VNB	2.15184e-18
C1301	CI#2	VNB	2.88574e-17
C1302	a_1265_379##14	a_528_362##4	7.34228e-19
C1303	a_1265_379##5	VNB	3.159e-17
C1304	a_27_74##8	A#7	2.78693e-17
C1305	VPWR#10	a_528_362##4	2.29092e-19
C1306	a_1378_125##3	VNB	6.5334e-17
C1307	a_528_362##7	a_200_74##6	5.37595e-18
C1308	VGND#19	A#5	6.16147e-19
C1309	a_536_114##4	VNB	3.0238e-17
C1310	SUM#5	SUM#2	2.34428e-18
C1311	a_528_362##5	VNB	4.76427e-17
C1312	a_427_362#	a_427_362##2	2.30048e-18
C1313	B#3	VNB	1.42278e-18
C1314	VPWR#2	VPWR#4	1.17138e-17
C1315	a_586_257##6	VNB	6.22217e-18
C1316	CI#2	a_1378_125##5	4.19993e-17
C1317	a_27_74##3	VNB	4.87682e-17
C1318	A#6	VGND#20	1.33942e-17
C1319	VGND#13	a_1378_125##8	4.16869e-18
C1320	a_536_114##12	a_1278_102##16	1.65771e-18
C1321	a_1278_102##6	a_1278_102##11	4.53255e-17
C1322	SUM#2	a_1278_102##5	6.41408e-19
C1323	VGND#8	a_1278_102##12	1.75276e-18
C1324	a_427_362##2	B#2	1.85436e-17
C1325	VPWR#10	B#4	3.77418e-17
C1326	a_536_114##8	a_528_362##7	5.53956e-17
C1327	a_1378_125##8	a_536_114##11	2.65781e-17
C1328	A	VNB	1.11351e-18
C1329	VPWR	COUT	7.33802e-18
C1330	VPWR#2	VPWR#3	4.30721e-17
C1331	VGND#13	a_1278_102##15	2.82784e-18
C1332	VPWR#6	VPWR#17	1.04092e-17
C1333	B	VNB	9.62912e-18
C1334	VGND	COUT	1.10772e-18
C1335	SUM	VNB	2.29178e-18
C1336	a_536_114##12	a_1378_125##10	3.3107e-18
C1337	VPWR#10	B#2	7.7532e-18
C1338	COUT	VNB	8.01897e-19
C1339	VPWR	VNB	2.31538e-16
C1340	a_200_74##4	A#5	1.33528e-18
C1341	VGND	VNB	2.33015e-16
C1342	a_200_74##2	A#4	1.80117e-19
C1343	VPWR#12	VNB	4.54309e-17
C1344	VPWR#12	VPWR#11	7.56243e-19
C1345	VGND#15	VNB	4.60521e-17
C1346	VGND#15	a_200_74##4	9.6891e-18
C1347	a_200_74##5	VPWR#12	9.22988e-18
C1348	VGND#13	VGND#15	9.41216e-17
C1349	VGND#15	A#5	3.78479e-18
C1350	VGND#15	A#4	3.44571e-20
C1351	VGND#15	a_27_74##7	1.90483e-17
C1352	VPWR#12	A#1	7.55677e-18
C1353	VGND#15	VGND#19	2.32365e-19
C1354	VGND#15	a_27_74##6	2.28617e-19
C1355	VGND#15	A#6	7.14226e-18
C1356	A#10	VPWR#12	4.13405e-19
C1357	VGND#15	a_27_74##3	6.44284e-19
C1358	VPWR#12	A#7	6.96274e-18
C1359	a_27_74##8	VPWR#12	1.90504e-17
C1360	VPWR#10	VPWR#12	9.50486e-17
C1361	VGND#15	VGND#14	8.99422e-19
C1362	VPWR#12	B#5	1.25629e-19
C1363	A	VPWR#12	5.61307e-19
*
*
.ENDS sky130_fd_sc_hs__fah_4
*
