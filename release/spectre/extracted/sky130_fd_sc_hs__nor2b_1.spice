* Extracted by Quantus, converted by sky130cad/quantus.py
*
*
*
*                       LINUX           Wed Nov 18 08:49:24 2026
*
*
*
*  PROGRAM  advgen
*
*  Name           : advgen - Quantus - (64-bit)
*  Version        : 25.1.0-p047
*  Build Date     : Thu Dec 11 23:20:30 PST 2025
*
*  HSPICE LIBRARY
*
*  OPERATING_TEMPERATURE 150
*  QRC_TECH_DIR <path>/tech
*
*
*

*
.SUBCKT sky130_fd_sc_hs__nor2b_1 VPB VNB VGND VPWR Y B_N A
*
*
*  caps2d version: 10
*
*
*       TRANSISTOR CARDS
*
*
XM2 a_27_112##7 B_N#1 VGND#4 VNB sky130_fd_pr__nfet_01v8_lvt l=0.15 w=0.55 ad=0.2805 as=0.30715 pd=2.12 ps=2.4
XM5 VGND#4 A#1 Y#3 VNB sky130_fd_pr__nfet_01v8_lvt l=0.15 w=0.74 ad=0.30715 as=0.2627 pd=2.4 ps=2.19
XM4 Y#3 a_27_112# VGND#1 VNB sky130_fd_pr__nfet_01v8_lvt l=0.15 w=0.74 ad=0.2627 as=0.2627 pd=2.19 ps=2.19
XM1 a_27_112##6 B_N#4 VPWR#1 VPB sky130_fd_pr__pfet_01v8 l=0.15 w=0.84 ad=0.2478 as=0.469 pd=2.27 ps=3.16
XM3 VPWR#1 A#3 a_278_368# VPB sky130_fd_pr__pfet_01v8 l=0.15 w=1.12 ad=0.469 as=0.3024 pd=3.16 ps=2.78
XM0 a_278_368# a_27_112##3 Y#1 VPB sky130_fd_pr__pfet_01v8 l=0.15 w=1.12 ad=0.3024 as=0.42 pd=2.78 ps=2.99
*
*
*       RESISTOR AND CAP/DIODE CARDS
*
Rg1	B_N#1	B_N#2	273.800995
Rg2	B_N#2	B_N#3	80.295654
Rg3	B_N#2	B_N#4	444.450897
Rg4	A#1	A#2	303.799591
Rg5	A#2	A#3	487.921478
Rg6	a_27_112#	a_27_112##2	365.323883
Rg7	a_27_112##2	a_27_112##3	447.963806
Rf1	B_N	B_N#5	0.617720
Rf2	B_N#6	B_N#3	160.850525
Rf3	B_N#5	B_N#6	3.543054
Rf4	A	A#2	163.775864
Rf5	a_27_112##2	a_27_112##5	244.661407
Rf6	a_27_112##5	a_27_112##6	26.574633
Rf7	a_27_112##5	a_27_112##7	83.272591
Rf8	Y	Y#2	0.149458
Rf9	Y#2	Y	10.910419
Rf10	Y	Y#3	122.140266
Rf11	Y#1	Y#2	5.000000
Rf12	VGND#1	VGND#2	104.349495
Rf14	VGND#2	VGND#4	36.016815
Rf15	VPWR#1	VPWR#2	38.437725
Re1	VPWR#2	VPWR	1.964508
Re2	VGND	VGND#2	1.964582
*
*       CAPACITOR CARDS
*
*
C1	VGND	VNB	6.09161e-17
C2	VPWR	VNB	5.77264e-17
C3	A	VNB	2.39439e-18
C4	VGND	A	3.24901e-18
C5	B_N#3	VNB	4.96721e-17
C6	A#2	VNB	3.43029e-17
C7	a_27_112##2	VNB	5.56558e-17
C8	VPWR	A	1.94129e-18
C9	VGND	B_N#3	2.02539e-18
C10	B_N#4	VNB	4.73504e-17
C11	A#3	VNB	3.30224e-17
C12	a_27_112##3	VNB	2.75106e-17
C13	VGND	a_27_112##2	5.5883e-18
C14	B_N#1	VNB	4.01401e-17
C15	A#1	VNB	3.06123e-17
C16	VPWR	B_N#3	2.67249e-18
C17	a_27_112#	VNB	3.46389e-17
C18	a_27_112##6	VNB	3.75232e-17
C19	VPWR#1	VNB	1.16868e-17
C20	VPWR	a_27_112##2	9.35284e-18
C21	Y#1	VNB	8.36699e-17
C22	a_27_112##7	VNB	1.83761e-17
C23	VGND#4	VNB	8.62199e-18
C24	Y#3	VNB	2.3504e-17
C25	VGND#1	VNB	4.90051e-17
C26	VGND	B_N#1	8.39453e-18
C27	B_N#5	VNB	1.18006e-17
C28	VGND	A#1	3.88157e-20
C29	B_N#6	VNB	1.73808e-17
C30	VPWR	B_N#4	8.11898e-18
C31	VGND	a_27_112#	1.58655e-19
C32	VPWR	A#3	1.00613e-18
C33	a_27_112##5	VNB	1.80827e-17
C34	VPWR	a_27_112##3	4.49825e-18
C35	VGND	Y#1	9.07451e-19
C36	A	A#2	2.12289e-17
C37	VGND	a_27_112##7	1.63328e-17
C38	VGND	VGND#4	2.09797e-17
C39	VGND	Y#3	1.78239e-17
C40	A	a_27_112##2	4.82364e-17
C41	VGND	VGND#1	3.57465e-17
C42	VGND	B_N#5	6.1164e-18
C43	VPWR	a_27_112##6	1.41301e-17
C44	VPWR	VPWR#1	2.28085e-17
C45	VPWR	Y#1	2.111e-17
C46	VGND	a_27_112##5	3.38873e-18
C47	a_27_112##2	a_278_368#	4.55565e-18
C48	VPWR	B_N#6	5.00625e-18
C49	VPWR	a_27_112##5	5.51461e-18
C50	A#2	a_27_112##2	3.3369e-17
C51	A	a_27_112#	1.40417e-18
C52	A#3	a_278_368#	2.80368e-17
C53	a_27_112##3	a_278_368#	2.89706e-17
C54	A	Y#1	1.14937e-18
C55	a_27_112##7	A	1.20293e-17
C56	VGND#4	A	2.68937e-17
C57	A	Y#3	3.61958e-18
C58	a_27_112##2	A#3	2.2832e-17
C59	a_27_112##2	a_27_112##3	6.15787e-18
C60	a_27_112##5	A	2.68536e-17
C61	B_N#2	VNB	2.38574e-17
C62	A#2	a_27_112#	1.51928e-18
C63	VPWR#1	A#2	1.16379e-18
C64	B_N#4	A#3	2.1279e-17
C65	B_N#3	a_27_112##7	8.49282e-18
C66	a_27_112##2	VPWR#1	6.35e-18
C67	a_27_112##7	A#2	1.55821e-18
C68	A#3	a_27_112##3	6.11352e-17
C69	A#2	VGND#4	6.14296e-18
C70	a_27_112##2	Y#1	6.70866e-17
C71	B_N#5	B_N#3	1.00606e-17
C72	Y#3	A#2	4.69696e-19
C73	B_N#6	B_N#3	1.31375e-17
C74	a_27_112##2	Y#3	4.59452e-17
C75	VGND	B_N#2	1.20603e-18
C76	a_27_112##2	VGND#1	4.90567e-19
C77	a_27_112##5	B_N#3	9.20062e-18
C78	a_27_112##6	B_N#4	3.61742e-17
C79	B_N#4	VPWR#1	2.33039e-17
C80	a_27_112##6	A#3	3.15201e-18
C81	a_27_112##5	A#2	4.72983e-18
C82	VPWR#1	A#3	6.87433e-17
C83	a_27_112##6	a_27_112##3	9.08483e-19
C84	Y#1	B_N#4	9.34985e-19
C85	B_N#1	A#1	1.5761e-17
C86	VPWR#1	a_27_112##3	1.22894e-17
C87	a_27_112##5	a_27_112##2	2.79389e-18
C88	Y#1	A#3	9.98309e-18
C89	A#1	a_27_112#	2.58373e-17
C90	Y#1	a_27_112##3	3.62858e-17
C91	a_27_112##7	B_N#1	3.12159e-17
C92	a_27_112##6	VPWR#1	3.78614e-17
C93	B_N#1	VGND#4	1.6895e-17
C94	a_27_112##7	A#1	2.17296e-18
C95	a_27_112##5	B_N#4	2.25633e-17
C96	Y#3	B_N#1	1.77093e-18
C97	VGND#4	A#1	4.71568e-17
C98	a_27_112##7	a_27_112#	5.77258e-19
C99	a_27_112##6	Y#1	2.28166e-18
C100	Y#3	A#1	1.53229e-17
C101	VGND#4	a_27_112#	5.46001e-18
C102	VPWR#1	Y#1	2.69968e-17
C103	VGND#1	A#1	1.20558e-18
C104	Y#3	a_27_112#	5.40923e-17
C105	a_27_112#	VGND#1	2.12114e-17
C106	Y#3	Y#1	3.33125e-18
C107	a_27_112##7	VGND#4	3.26747e-17
C108	a_27_112##7	Y#3	5.41936e-18
C109	VGND#4	Y#3	4.15722e-17
C110	a_27_112##5	a_27_112##6	2.62804e-19
C111	a_27_112##7	B_N#5	4.13917e-17
C112	VGND#4	VGND#1	1.47785e-18
C113	B_N#6	a_27_112##7	1.95759e-18
C114	A	B_N#2	4.84587e-18
C115	a_27_112##5	VPWR#1	2.59727e-17
C116	Y#3	VGND#1	8.05506e-17
C117	a_27_112##7	a_27_112##5	2.80248e-18
C118	VGND#4	a_27_112##5	3.19685e-18
C119	a_27_112##5	B_N#2	1.55327e-17
C120	B_N#6	a_27_112##5	3.78151e-17
C121	B_N#2	A#2	3.17454e-17
C122	a_27_112##2	B_N#2	8.26212e-19
C123	a_27_112##7	B_N#2	8.56903e-18
C124	VGND#2	a_27_112##7	1.05084e-17
C125	VGND#2	Y#3	1.38646e-17
C126	VPWR#2	a_27_112##3	6.82909e-18
C127	VGND#2	B_N#5	1.89402e-18
C128	VGND	VGND#2	5.04172e-17
C129	VGND#2	A	5.26101e-19
C130	VGND#2	B_N#3	1.42112e-18
C131	VGND#2	a_27_112##2	1.76986e-19
C132	VGND#2	B_N#1	3.48933e-18
C133	VPWR#2	B_N#2	1.85931e-20
C134	VGND#2	a_27_112#	2.49264e-18
C135	Y#1	VPWR#2	2.70753e-17
C136	VPWR#2	A#3	4.1546e-18
C137	VGND#2	VGND#1	2.56548e-17
C138	VGND#2	VNB	1.92297e-16
C139	VPWR#2	B_N#3	1.44906e-18
C140	VGND#2	a_27_112##5	1.40734e-19
C141	VPWR#2	VNB	2.19094e-16
C142	a_27_112##2	VPWR#2	2.00931e-18
C143	B_N#6	VPWR#2	8.53769e-19
C144	VPWR	VPWR#2	7.05871e-17
C145	VGND#2	B_N#2	1.34704e-19
C146	a_27_112##6	VPWR#2	8.70289e-18
C147	VGND#2	A#1	3.9335e-18
C148	VPWR#2	B_N#4	4.5897e-18
C149	a_27_112##5	VPWR#2	1.27573e-18
*
*
.ENDS sky130_fd_sc_hs__nor2b_1
*
