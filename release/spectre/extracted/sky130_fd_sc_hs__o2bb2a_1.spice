* Extracted by Quantus, converted by sky130cad/quantus.py
*
*
*
*                       LINUX           Wed Nov 18 08:59:36 2026
*
*
*
*  PROGRAM  advgen
*
*  Name           : advgen - Quantus - (64-bit)
*  Version        : 25.1.0-p047
*  Build Date     : Thu Dec 11 23:20:30 PST 2025
*
*  HSPICE LIBRARY
*
*  OPERATING_TEMPERATURE 150
*  QRC_TECH_DIR <path>/tech
*
*
*

*
.SUBCKT sky130_fd_sc_hs__o2bb2a_1 VNB VPB VGND VPWR X B2 B1 A1_N A2_N
*
*
*  caps2d version: 10
*
*
*       TRANSISTOR CARDS
*
*
XM9 X#3 a_83_260##3 VGND#7 VNB sky130_fd_pr__nfet_01v8_lvt l=0.15 w=0.74 ad=0.2109 as=0.3779 pd=2.05 ps=2.55
XM10 VGND#7 A1_N#1 a_253_94# VNB sky130_fd_pr__nfet_01v8_lvt l=0.15 w=0.64 ad=0.3779 as=0.1536 pd=2.55 ps=1.76
XM8 a_253_94# A2_N#3 a_233_384##5 VNB sky130_fd_pr__nfet_01v8_lvt l=0.15 w=0.64 ad=0.1536 as=0.1824 pd=1.76 ps=1.85
XM2 a_83_260##5 a_233_384##4 a_588_74##2 VNB sky130_fd_pr__nfet_01v8_lvt l=0.15 w=0.64 ad=0.1824 as=0.1792 pd=1.85 ps=1.84
XM7 a_588_74##2 B2#3 VGND#6 VNB sky130_fd_pr__nfet_01v8_lvt l=0.15 w=0.64 ad=0.1792 as=0.2432 pd=1.84 ps=2.04
XM11 VGND#6 B1#4 a_588_74# VNB sky130_fd_pr__nfet_01v8_lvt l=0.15 w=0.64 ad=0.2432 as=0.1824 pd=2.04 ps=1.85
XM0 X#1 a_83_260# VPWR#6 VPB sky130_fd_pr__pfet_01v8 l=0.15 w=1.12 ad=0.3304 as=0.4556 pd=2.83 ps=3.11
XM3 VPWR#6 A1_N#3 a_233_384##7 VPB sky130_fd_pr__pfet_01v8 l=0.15 w=0.84 ad=0.4556 as=0.2982 pd=3.11 ps=2.39
XM5 a_233_384##7 A2_N#1 VPWR#5 VPB sky130_fd_pr__pfet_01v8 l=0.15 w=0.84 ad=0.2982 as=0.9534 pd=2.39 ps=3.95
XM6 VPWR#5 a_233_384# a_83_260##4 VPB sky130_fd_pr__pfet_01v8 l=0.15 w=0.84 ad=0.9534 as=0.3448 pd=3.95 ps=2.72
XM1 a_83_260##4 B2#1 a_693_384# VPB sky130_fd_pr__pfet_01v8 l=0.15 w=1 ad=0.3448 as=0.27 pd=2.72 ps=2.54
XM4 a_693_384# B1#3 VPWR#1 VPB sky130_fd_pr__pfet_01v8 l=0.15 w=1 ad=0.27 as=0.295 pd=2.54 ps=2.59
*
*
*       RESISTOR AND CAP/DIODE CARDS
*
Rg1	a_83_260#	a_83_260##2	455.703033
Rg2	a_83_260##2	a_83_260##3	352.702850
Rg3	A1_N#1	A1_N#2	391.960175
Rg4	A1_N#2	A1_N#3	388.179535
Rg5	A2_N#1	A2_N#2	354.298584
Rg6	A2_N#2	A2_N#3	399.755615
Rg7	a_233_384#	a_233_384##2	650.000244
Rg8	a_233_384##2	a_233_384##3	392.774323
Rg9	a_233_384##2	a_233_384##4	254.451508
Rg10	B2#1	B2#2	521.934631
Rg11	B2#2	B2#3	376.011292
Rg12	B1#1	B1#2	29.629290
Rg13	B1#2	B1#3	569.818970
Rg14	B1#2	B1#4	334.951599
Rf1	X	X#2	0.181173
Rf2	X#2	X	13.225628
Rf3	X	X#3	86.591301
Rf4	X#1	X#2	5.000000
Rf5	A1_N#2	A1_N	164.699432
Rf6	A2_N	A2_N#2	162.988510
Rf7	a_233_384##5	a_233_384##3	62.380337
Rf8	a_233_384##3	a_233_384##7	72.241501
Rf9	a_83_260##4	a_83_260##6	131.499298
Rf10	a_83_260##6	a_83_260##2	369.425171
Rf11	a_83_260##5	a_83_260##6	7.500000
Rf12	B2	B2#4	10.038653
Rf13	B2#4	B2	8.857635
Rf14	a_588_74#	a_588_74##2	99.722191
Rf15	B1	B1#1	162.201172
Rf16	VPWR#1	VPWR#2	175.633270
Rf17	VPWR#2	VPWR#3	104.474205
Rf19	VPWR#2	VPWR#5	13.682128
Rf20	VPWR#3	VPWR#6	37.105022
Rf22	VGND#2	VGND#3	103.707169
Rf23	VGND#3	VGND#4	93.989029
Rf25	VGND#2	VGND#6	33.326477
Rf26	VGND#4	VGND#7	18.452824
Rf31	B2#2	B2#4	160.232803
Re1	VPWR#2	VPWR	1.091357
Re2	VGND	VGND#3	1.091398
*
*       CAPACITOR CARDS
*
*
C1	VGND	VNB	7.31018e-17
C2	VPWR	VNB	6.28409e-17
C3	X	VNB	4.91887e-17
C4	B2	VNB	8.68346e-18
C5	B1	VNB	1.70015e-17
C6	A2_N	VNB	2.86752e-18
C7	VGND	X	1.46282e-18
C8	a_83_260##2	VNB	4.31547e-17
C9	A1_N#2	VNB	3.4583e-17
C10	A2_N#2	VNB	3.07256e-17
C11	VGND	B2	4.71127e-18
C12	a_233_384##3	VNB	6.55086e-17
C13	B2#2	VNB	3.86662e-17
C14	VPWR	X	1.76916e-17
C15	VGND	B1	3.91787e-18
C16	VGND#3	VNB	2.25783e-16
C17	VPWR#2	VNB	1.8426e-16
C18	VPWR	B2	8.24425e-18
C19	a_83_260#	VNB	4.37032e-17
C20	A1_N#3	VNB	3.36518e-17
C21	A2_N#1	VNB	2.64951e-17
C22	VGND	A2_N	3.16434e-18
C23	a_233_384#	VNB	4.20201e-17
C24	VPWR	B1	2.24829e-18
C25	B2#1	VNB	4.08214e-17
C26	B1#3	VNB	3.56426e-17
C27	a_83_260##3	VNB	3.45907e-17
C28	A1_N#1	VNB	2.78308e-17
C29	A2_N#3	VNB	3.5931e-17
C30	a_233_384##4	VNB	2.9365e-17
C31	B2#3	VNB	2.56724e-17
C32	VPWR	A2_N	1.91338e-18
C33	B1#4	VNB	2.81224e-17
C34	X#1	VNB	1.98603e-17
C35	VPWR#6	VNB	6.18416e-18
C36	VPWR#5	VNB	8.50315e-17
C37	a_83_260##4	VNB	7.51726e-18
C38	B2	B1	2.92028e-17
C39	VPWR#1	VNB	8.7458e-17
C40	X#3	VNB	5.27302e-17
C41	a_233_384##5	VNB	1.32268e-18
C42	VGND	a_83_260##2	6.74891e-18
C43	a_83_260##5	VNB	2.99393e-17
C44	a_588_74##2	VNB	2.09806e-18
C45	VGND#6	VNB	3.23971e-18
C46	VGND	A1_N#2	2.75264e-18
C47	a_588_74#	VNB	3.58563e-17
C48	VGND	a_233_384##3	1.06816e-17
C49	VGND	B2#2	1.24487e-18
C50	a_588_74##2	a_83_260##4	2.69912e-19
C51	VPWR	a_83_260##2	3.34221e-18
C52	VGND	VGND#3	2.02149e-17
C53	VPWR	A1_N#2	4.38682e-18
C54	VPWR	a_233_384##3	5.20056e-18
C55	X	a_83_260##2	3.12421e-17
C56	VPWR	B2#2	1.5574e-18
C57	X	A1_N#2	4.47728e-18
C58	X	A2_N#2	4.75904e-19
C59	X	a_233_384##3	1.46653e-18
C60	VGND	a_83_260##3	1.96077e-18
C61	VGND	A1_N#1	2.89141e-18
C62	VPWR	a_83_260#	3.83668e-18
C63	VPWR	A1_N#3	6.74299e-18
C64	VGND	a_233_384##4	2.92347e-18
C65	VGND	B2#3	3.66094e-19
C66	VPWR	A2_N#1	3.68486e-18
C67	VGND	B1#4	1.53182e-18
C68	VPWR	a_233_384#	3.82084e-18
C69	VPWR	B2#1	1.00132e-17
C70	B2	B2#2	1.55623e-17
C71	VPWR	B1#3	4.21192e-18
C72	X	a_83_260#	2.62929e-17
C73	VGND	a_83_260##4	4.58325e-18
C74	X	A1_N#3	2.48647e-18
C75	VGND	VPWR#1	3.6772e-18
C76	VGND	X#3	1.9682e-17
C77	X	A2_N#1	3.58061e-19
C78	B1	B2#2	7.05511e-19
C79	VGND	a_233_384##5	6.39731e-18
C80	VGND	a_83_260##5	5.2873e-17
C81	VGND	a_588_74##2	1.49549e-17
C82	a_233_384##2	VNB	2.2953e-17
C83	VGND	VGND#6	1.62017e-17
C84	A1_N#2	A2_N	3.12152e-17
C85	B1#2	VNB	6.3876e-17
C86	VPWR	VPWR#6	2.04985e-17
C87	VGND	a_588_74#	1.55643e-17
C88	VPWR#5	a_233_384##2	2.6471e-19
C89	VPWR	a_233_384##7	9.1784e-18
C90	A2_N	A2_N#2	2.16473e-17
C91	VPWR	VPWR#5	1.25617e-16
C92	VPWR	a_83_260##4	1.68898e-17
C93	A2_N	a_233_384##3	3.09365e-17
C94	a_83_260##2	a_253_94#	1.68504e-17
C95	VPWR	VPWR#1	4.85835e-17
C96	X	X#1	3.16086e-18
C97	X	VPWR#6	4.83223e-17
C98	X#3	X	3.95306e-18
C99	a_588_74#	VPWR#1	2.02782e-18
C100	a_83_260##4	B2	1.48013e-17
C101	a_83_260##2	A1_N#2	1.02097e-16
C102	a_83_260##2	A2_N#2	1.7267e-19
C103	a_83_260##5	B2	2.69302e-17
C104	a_588_74##2	B2	3.76488e-17
C105	a_83_260##2	a_233_384##3	1.7698e-18
C106	A1_N#2	A2_N#2	4.1669e-17
C107	B2	VGND#6	1.24089e-18
C108	B1	VPWR#1	1.84817e-17
C109	a_83_260##4	a_233_384##2	1.77967e-18
C110	a_588_74#	B2	1.76574e-17
C111	a_83_260##5	a_233_384##5	3.71925e-17
C112	A1_N#2	a_233_384##3	1.17056e-18
C113	A2_N#2	a_233_384##3	3.41225e-17
C114	a_83_260##4	B1#2	6.66796e-19
C115	A2_N	a_233_384##7	3.80534e-17
C116	A1_N#1	a_253_94#	6.12117e-18
C117	B1	a_588_74#	3.85451e-17
C118	A2_N#3	a_253_94#	2.92362e-18
C119	VGND#3	A2_N#2	3.56135e-20
C120	B2#1	a_693_384#	2.52858e-17
C121	a_83_260##5	a_588_74##2	6.37673e-17
C122	VGND#3	a_233_384##3	5.14466e-19
C123	B1#3	a_693_384#	2.61244e-17
C124	a_83_260#	A1_N#2	3.95882e-18
C125	a_233_384##5	A2_N	2.20323e-17
C126	a_83_260##5	A2_N	2.46359e-18
C127	VGND	a_233_384##2	9.24955e-19
C128	a_83_260##5	VGND#6	2.84455e-18
C129	VGND	B1#2	1.56606e-18
C130	A1_N#3	A2_N#2	1.18351e-18
C131	a_233_384##3	a_83_260#	3.53091e-20
C132	a_233_384##3	A1_N#3	2.54682e-19
C133	A2_N#2	a_233_384#	8.57563e-20
C134	a_588_74##2	VGND#6	4.97427e-17
C135	a_83_260##2	a_83_260##3	3.51236e-18
C136	a_233_384##3	A2_N#1	1.48038e-18
C137	a_83_260##2	A1_N#1	1.73008e-17
C138	a_233_384##3	a_233_384#	1.18311e-17
C139	a_83_260##5	a_253_94#	5.76333e-20
C140	a_83_260##2	A2_N#3	1.26546e-17
C141	a_233_384##3	B2#1	4.8173e-19
C142	a_233_384#	B2#2	5.74828e-18
C143	a_83_260##2	a_233_384##4	2.65822e-19
C144	a_588_74##2	a_588_74#	2.3134e-18
C145	A1_N#2	A2_N#3	1.87949e-18
C146	a_588_74#	VGND#6	4.24515e-17
C147	VPWR	B1#2	6.32841e-19
C148	a_83_260##2	VPWR#6	2.48964e-17
C149	a_83_260##2	a_233_384##7	5.98986e-18
C150	A2_N#3	a_233_384##3	7.16029e-18
C151	a_83_260#	A1_N#3	2.65018e-17
C152	VPWR#1	B1#2	7.1772e-18
C153	A1_N#2	a_233_384##7	3.18554e-17
C154	A1_N#3	A2_N#1	2.92139e-17
C155	X#3	a_83_260##2	4.3753e-17
C156	a_233_384##7	A2_N#2	2.61236e-18
C157	VGND#3	A1_N#1	6.98714e-21
C158	a_83_260##2	VGND#7	3.02772e-19
C159	A2_N#2	VPWR#5	1.29254e-18
C160	VGND#3	A2_N#3	1.48743e-18
C161	A2_N#1	a_233_384#	2.10049e-18
C162	a_83_260##4	A2_N#2	3.60146e-20
C163	a_233_384##3	a_233_384##7	1.48019e-18
C164	X#3	A1_N#2	1.04846e-20
C165	a_83_260##2	a_233_384##5	5.6685e-17
C166	VGND#3	a_233_384##4	1.47809e-18
C167	a_233_384##3	VPWR#5	5.98438e-17
C168	a_83_260##2	a_83_260##5	2.05339e-18
C169	a_233_384##3	a_83_260##4	4.55873e-17
C170	a_233_384#	B2#1	3.9062e-17
C171	a_233_384##5	A1_N#2	4.55085e-20
C172	VPWR#5	B2#2	8.18206e-20
C173	B2#2	a_83_260##4	9.14787e-18
C174	a_233_384##5	A2_N#2	3.62492e-18
C175	a_233_384##3	a_233_384##2	9.2267e-18
C176	B2#1	B1#3	6.73257e-17
C177	a_83_260##5	A2_N#2	3.75326e-19
C178	a_233_384##3	a_233_384##5	7.34699e-19
C179	B2	a_233_384##2	7.97969e-18
C180	B2	B1#2	1.02096e-17
C181	a_83_260##5	a_233_384##3	5.1724e-17
C182	VPWR#2	VPWR#5	9.0018e-17
C183	X#1	a_83_260#	2.59636e-17
C184	a_83_260#	VPWR#6	4.23142e-17
C185	a_83_260##5	B2#2	1.84516e-18
C186	X#1	A1_N#3	1.09753e-18
C187	a_588_74##2	B2#2	1.448e-17
C188	a_233_384##7	a_83_260#	5.99251e-19
C189	VPWR#2	VPWR#1	3.66199e-17
C190	A1_N#3	VPWR#6	2.84961e-17
C191	B2#2	VGND#6	7.13848e-19
C192	a_233_384##2	B2#2	2.80122e-17
C193	VPWR#5	a_83_260#	3.56536e-18
C194	a_233_384##7	A1_N#3	4.10105e-17
C195	B2#2	B1#2	3.55204e-17
C196	VPWR#6	A2_N#1	5.01085e-18
C197	a_83_260##3	A1_N#1	1.41693e-17
C198	VPWR#5	A1_N#3	2.65545e-18
C199	B1	B1#2	2.09289e-17
C200	VGND#3	a_83_260##5	9.06733e-17
C201	a_233_384##7	A2_N#1	5.19869e-17
C202	a_83_260##4	A1_N#3	3.56225e-19
C203	VPWR#6	a_233_384#	5.35374e-19
C204	VPWR#5	A2_N#1	5.22475e-17
C205	A1_N#1	A2_N#3	4.49545e-17
C206	a_83_260##4	A2_N#1	1.35186e-18
C207	VPWR#5	a_233_384#	5.01297e-17
C208	a_83_260##4	a_233_384#	4.13059e-17
C209	VPWR#5	B2#1	1.35849e-17
C210	A2_N#3	a_233_384##4	2.48049e-18
C211	a_83_260##4	B2#1	5.97409e-17
C212	VPWR#5	B1#3	1.23599e-18
C213	VPWR#1	a_233_384#	7.96948e-19
C214	a_233_384##4	B2#3	3.28379e-17
C215	a_83_260##4	B1#3	9.71696e-18
C216	VPWR#1	B2#1	1.12248e-17
C217	VPWR#1	B1#3	5.74342e-17
C218	VGND#3	a_233_384##2	1.26195e-19
C219	B2#3	B1#4	2.26354e-17
C220	a_83_260##5	a_233_384##2	2.06157e-17
C221	a_83_260##5	B1#2	1.44804e-19
C222	a_233_384##2	B2#3	2.39311e-18
C223	X#3	a_83_260##3	3.62097e-17
C224	a_83_260##3	VGND#7	6.19685e-18
C225	X#1	VPWR#6	4.29911e-17
C226	X#3	A1_N#1	9.43719e-19
C227	A1_N#1	VGND#7	1.78775e-17
C228	X#3	A2_N#3	2.97457e-19
C229	VPWR#6	a_233_384##7	3.22896e-17
C230	a_83_260##5	a_83_260##3	8.80013e-19
C231	a_233_384##5	A1_N#1	1.27341e-18
C232	VPWR#6	VPWR#5	1.66956e-17
C233	a_83_260##5	A1_N#1	3.048e-18
C234	a_233_384##5	A2_N#3	3.65428e-17
C235	a_233_384##7	VPWR#5	3.42523e-17
C236	a_83_260##5	A2_N#3	1.73237e-17
C237	a_83_260##4	a_233_384##7	5.83853e-20
C238	a_233_384##5	a_233_384##4	1.57065e-18
C239	a_83_260##5	a_233_384##4	5.10471e-17
C240	a_83_260##4	VPWR#5	5.53041e-17
C241	a_588_74##2	a_233_384##4	1.2221e-17
C242	a_83_260##5	B2#3	2.61228e-18
C243	VGND#6	a_233_384##4	1.27127e-18
C244	a_588_74##2	B2#3	4.797e-17
C245	VPWR#5	VPWR#1	5.71714e-18
C246	a_83_260##5	B1#4	9.04153e-19
C247	B2#3	VGND#6	2.25356e-17
C248	a_83_260##4	VPWR#1	2.78369e-17
C249	a_588_74##2	B1#4	1.39004e-18
C250	a_588_74#	B2#3	1.23445e-18
C251	B1#4	VGND#6	2.41266e-17
C252	a_588_74#	B1#2	6.13831e-18
C253	a_233_384##5	a_233_384##7	1.61146e-18
C254	a_588_74#	B1#4	3.7898e-17
C255	a_83_260##5	VPWR#5	3.05311e-18
C256	VGND#4	B2#3	3.74823e-20
C257	VGND#2	B2#3	2.68494e-18
C258	VGND#3	VGND#2	6.37492e-17
C259	VGND#4	VGND#7	8.84384e-18
C260	VGND	VGND#2	4.09391e-17
C261	VGND#4	a_233_384##4	3.33901e-19
C262	X	VPWR#3	2.23373e-17
C263	VGND#2	a_233_384##4	5.96318e-18
C264	VGND	VGND#4	7.32156e-17
C265	VPWR#3	a_83_260#	4.63542e-18
C266	VGND#2	B1	5.84901e-19
C267	VGND#4	X#3	8.08055e-17
C268	VGND#4	A2_N#3	3.35748e-18
C269	VPWR#3	VNB	5.01594e-17
C270	VGND#2	B1#2	5.00439e-19
C271	VPWR#3	VPWR#5	9.40451e-19
C272	VPWR	VPWR#3	3.68444e-17
C273	VGND#2	a_588_74#	1.88465e-17
C274	VGND#4	a_83_260##5	4.70902e-17
C275	VGND#4	A1_N#1	2.96365e-17
C276	VGND#2	VNB	5.74154e-17
C277	VGND#4	A1_N#2	1.05772e-18
C278	VGND#4	VNB	6.38632e-17
C279	VGND#3	VGND#4	6.8128e-17
C280	A1_N#2	VPWR#3	1.07688e-18
C281	VGND#4	a_83_260##3	2.45493e-17
C282	VGND#4	a_83_260##2	8.2532e-17
C283	VGND#2	B1#4	2.08313e-18
C284	a_233_384##7	VPWR#3	1.56636e-18
C285	VPWR#2	VPWR#3	5.57791e-17
C286	a_83_260##2	VPWR#3	2.51872e-19
C287	VPWR#3	A1_N#3	4.50416e-18
C288	VGND#2	a_588_74##2	1.4526e-17
*
*
.ENDS sky130_fd_sc_hs__o2bb2a_1
*
