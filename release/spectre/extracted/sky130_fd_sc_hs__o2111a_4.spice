* Extracted by Quantus, converted by sky130cad/quantus.py
*
*
*
*                       LINUX           Wed Nov 18 08:52:58 2026
*
*
*
*  PROGRAM  advgen
*
*  Name           : advgen - Quantus - (64-bit)
*  Version        : 25.1.0-p047
*  Build Date     : Thu Dec 11 23:20:30 PST 2025
*
*  HSPICE LIBRARY
*
*  OPERATING_TEMPERATURE 150
*  QRC_TECH_DIR <path>/tech
*
*
*

*
.SUBCKT sky130_fd_sc_hs__o2111a_4 VNB VPB VGND VPWR X D1 C1 B1 A2 A1
*
*
*  caps2d version: 10
*
*
*       TRANSISTOR CARDS
*
*
XM24 a_27_74##3 D1#5 a_27_392##24 VNB sky130_fd_pr__nfet_01v8_lvt l=0.15 w=0.74 ad=0.2146 as=0.2072 pd=2.06 ps=2.04
XM5 a_27_392##24 D1#4 a_27_74##4 VNB sky130_fd_pr__nfet_01v8_lvt l=0.15 w=0.74 ad=0.2072 as=0.2072 pd=2.04 ps=2.04
XM1 a_27_74##4 C1#4 a_287_74##2 VNB sky130_fd_pr__nfet_01v8_lvt l=0.15 w=0.74 ad=0.2072 as=0.2072 pd=2.04 ps=2.04
XM9 a_287_74##2 C1#6 a_27_74# VNB sky130_fd_pr__nfet_01v8_lvt l=0.15 w=0.74 ad=0.2072 as=0.24285 pd=2.04 ps=2.49
XM11 a_477_198##4 B1#6 a_287_74# VNB sky130_fd_pr__nfet_01v8_lvt l=0.15 w=0.74 ad=0.21835 as=0.2072 pd=2.21 ps=2.04
XM10 a_287_74# B1#1 a_477_198##6 VNB sky130_fd_pr__nfet_01v8_lvt l=0.15 w=0.74 ad=0.2072 as=0.2072 pd=2.04 ps=2.04
XM18 a_477_198##6 A2#7 VGND#11 VNB sky130_fd_pr__nfet_01v8_lvt l=0.15 w=0.74 ad=0.2072 as=0.2516 pd=2.04 ps=2.16
XM21 VGND#11 A2#1 a_477_198##5 VNB sky130_fd_pr__nfet_01v8_lvt l=0.15 w=0.74 ad=0.2516 as=0.2183 pd=2.16 ps=2.07
XM19 VGND#10 A1#5 a_477_198# VNB sky130_fd_pr__nfet_01v8_lvt l=0.15 w=0.74 ad=0.2109 as=0.2072 pd=2.05 ps=2.04
XM23 a_477_198# A1#6 VGND#9 VNB sky130_fd_pr__nfet_01v8_lvt l=0.15 w=0.74 ad=0.2072 as=0.259 pd=2.04 ps=2.18
XM6 VGND#9 a_27_392##6 X#4 VNB sky130_fd_pr__nfet_01v8_lvt l=0.15 w=0.74 ad=0.259 as=0.2072 pd=2.18 ps=2.04
XM20 VGND#8 a_27_392##10 X#4 VNB sky130_fd_pr__nfet_01v8_lvt l=0.15 w=0.74 ad=0.3108 as=0.2072 pd=2.32 ps=2.04
XM22 X#6 a_27_392##8 VGND#8 VNB sky130_fd_pr__nfet_01v8_lvt l=0.15 w=0.74 ad=0.2072 as=0.3108 pd=2.04 ps=2.32
XM7 X#6 a_27_392##7 VGND#1 VNB sky130_fd_pr__nfet_01v8_lvt l=0.15 w=0.74 ad=0.2072 as=0.2627 pd=2.04 ps=2.19
XM12 VPWR#16 D1#6 a_27_392##18 VPB sky130_fd_pr__pfet_01v8 l=0.15 w=0.84 ad=0.336 as=0.2478 pd=2.48 ps=2.27
XM13 a_27_392##23 D1#1 VPWR#16 VPB sky130_fd_pr__pfet_01v8 l=0.15 w=0.84 ad=0.252 as=0.336 pd=2.28 ps=2.48
XM3 VPWR#15 C1#5 a_27_392##23 VPB sky130_fd_pr__pfet_01v8 l=0.15 w=0.84 ad=0.294 as=0.252 pd=2.38 ps=2.28
XM25 a_27_392##22 C1#1 VPWR#15 VPB sky130_fd_pr__pfet_01v8 l=0.15 w=0.84 ad=0.3948 as=0.294 pd=2.62 ps=2.38
XM15 VPWR#14 B1#4 a_27_392##22 VPB sky130_fd_pr__pfet_01v8 l=0.15 w=0.84 ad=0.252 as=0.3948 pd=2.28 ps=2.62
XM27 a_27_392##19 B1#5 VPWR#14 VPB sky130_fd_pr__pfet_01v8 l=0.15 w=0.84 ad=0.4206 as=0.252 pd=2.87 ps=2.28
XM8 a_747_392##2 A2#5 a_27_392##19 VPB sky130_fd_pr__pfet_01v8 l=0.15 w=1 ad=0.35 as=0.4206 pd=2.7 ps=2.87
XM0 a_27_392##21 A2#6 a_747_392##2 VPB sky130_fd_pr__pfet_01v8 l=0.15 w=1 ad=0.295 as=0.35 pd=2.59 ps=2.7
XM2 a_747_392# A1#7 VPWR#13 VPB sky130_fd_pr__pfet_01v8 l=0.15 w=1 ad=0.3 as=0.345 pd=2.6 ps=2.69
XM17 VPWR#12 A1#1 a_747_392# VPB sky130_fd_pr__pfet_01v8 l=0.15 w=1 ad=0.4168 as=0.3 pd=3.01 ps=2.6
XM14 X#5 a_27_392##12 VPWR#12 VPB sky130_fd_pr__pfet_01v8 l=0.15 w=1.12 ad=0.392 as=0.4168 pd=2.94 ps=3.01
XM26 VPWR#11 a_27_392##11 X#5 VPB sky130_fd_pr__pfet_01v8 l=0.15 w=1.12 ad=0.336 as=0.392 pd=2.84 ps=2.94
XM4 VPWR#11 a_27_392##9 X#1 VPB sky130_fd_pr__pfet_01v8 l=0.15 w=1.12 ad=0.336 as=0.336 pd=2.84 ps=2.84
XM16 X#1 a_27_392# VPWR#1 VPB sky130_fd_pr__pfet_01v8 l=0.15 w=1.12 ad=0.336 as=0.3864 pd=2.84 ps=2.93
*
*
*       RESISTOR AND CAP/DIODE CARDS
*
Rg1	D1#1	D1#2	381.424896
Rg2	D1#2	D1#3	194.899673
Rg3	D1#2	D1#4	530.972107
Rg4	D1#3	D1#5	431.789032
Rg5	D1#3	D1#6	324.385376
Rg6	C1#1	C1#2	420.748138
Rg7	C1#2	C1#3	46.535358
Rg8	C1#3	C1#4	314.496185
Rg9	C1#2	C1#5	350.476776
Rg10	C1#3	C1#6	266.380035
Rg11	B1#1	B1#2	335.684296
Rg12	B1#2	B1#3	57.848751
Rg13	B1#3	B1#4	420.256989
Rg14	B1#2	B1#5	356.496521
Rg15	B1#3	B1#6	327.315399
Rg16	A2#1	A2#2	357.385376
Rg17	A2#2	A2#3	32.565670
Rg18	A2#3	A2#4	30.613653
Rg19	A2#4	A2#5	425.091339
Rg20	A2#2	A2#6	424.106537
Rg21	A2#4	A2#7	359.104828
Rg22	A1#1	A1#2	440.222260
Rg23	A1#2	A1#3	17.800245
Rg24	A1#3	A1#4	35.535461
Rg25	A1#4	A1#5	454.941925
Rg26	A1#2	A1#6	466.406647
Rg27	A1#4	A1#7	424.106537
Rg28	a_27_392#	a_27_392##2	504.521545
Rg29	a_27_392##2	a_27_392##3	204.295883
Rg30	a_27_392##3	a_27_392##4	97.598366
Rg31	a_27_392##4	a_27_392##5	75.477074
Rg32	a_27_392##5	a_27_392##6	409.214935
Rg33	a_27_392##2	a_27_392##7	377.170135
Rg34	a_27_392##3	a_27_392##8	394.377136
Rg35	a_27_392##3	a_27_392##9	447.198364
Rg36	a_27_392##4	a_27_392##10	379.238098
Rg37	a_27_392##4	a_27_392##11	431.337585
Rg38	a_27_392##5	a_27_392##12	452.207367
Rf1	D1#7	D1	0.772649
Rf2	D1#3	D1#9	161.005447
Rf3	D1#7	D1#9	5.708254
Rf4	C1	C1#7	3.936727
Rf5	C1#7	C1	14.959562
Rf6	a_27_74#	a_27_74##2	81.833931
Rf7	a_27_74##2	a_27_74##3	51.128143
Rf8	a_27_74##2	a_27_74##4	21.168327
Rf9	a_287_74#	a_287_74##2	122.974304
Rf10	B1#2	B1	162.201172
Rf11	A2	A2#8	6.889272
Rf12	A2#8	A2	12.007017
Rf13	a_477_198#	a_477_198##2	110.461380
Rf14	a_477_198##2	a_477_198##3	70.006004
Rf15	a_477_198##3	a_477_198##4	62.264690
Rf16	a_477_198##2	a_477_198##5	15.787825
Rf17	a_477_198##3	a_477_198##6	15.489866
Rf18	a_747_392#	a_747_392##2	132.537704
Rf19	A1#3	A1	162.201172
Rf20	a_27_392##4	a_27_392##14	297.082886
Rf21	a_27_392##14	a_27_392##15	77.958336
Rf22	a_27_392##15	a_27_392##16	75.401566
Rf23	a_27_392##16	a_27_392##17	34.772495
Rf24	a_27_392##17	a_27_392##18	53.186649
Rf25	a_27_392##14	a_27_392##20	13.602406
Rf26	a_27_392##20	a_27_392##21	102.477867
Rf27	a_27_392##15	a_27_392##22	17.756187
Rf28	a_27_392##16	a_27_392##23	17.953024
Rf29	a_27_392##17	a_27_392##24	85.954567
Rf30	a_27_392##19	a_27_392##20	5.000000
Rf31	X#1	X#2	24.506115
Rf32	X#2	X	63.524029
Rf33	X	X#3	47.312088
Rf34	X#3	X#4	87.959900
Rf35	X#2	X#5	51.438068
Rf36	X#3	X#6	18.149860
Rf37	VPWR#1	VPWR#2	66.771828
Rf38	VPWR#2	VPWR#3	37.231220
Rf39	VPWR#3	VPWR#4	69.348907
Rf40	VPWR#4	VPWR#5	75.558197
Rf41	VPWR#5	VPWR#6	115.760506
Rf42	VPWR#6	VPWR#7	37.231220
Rf43	VPWR#7	VPWR#8	78.114967
Rf44	VPWR#8	VPWR#9	73.001427
Rf46	VPWR#3	VPWR#11	31.928404
Rf47	VPWR#4	VPWR#12	31.534731
Rf48	VPWR#5	VPWR#13	32.342297
Rf49	VPWR#7	VPWR#14	45.136658
Rf50	VPWR#8	VPWR#15	45.136658
Rf51	VPWR#9	VPWR#16	45.136658
Rf52	VGND#1	VGND#2	63.557476
Rf53	VGND#2	VGND#3	43.075260
Rf54	VGND#3	VGND#4	73.001427
Rf55	VGND#4	VGND#5	62.774361
Rf56	VGND#5	VGND#6	79.575981
Rf57	VGND#6	VGND#7	39.422733
Rf58	VGND#3	VGND#8	37.263206
Rf59	VGND#4	VGND#9	33.306259
Rf60	VGND#5	VGND#10	31.141060
Rf61	VGND#6	VGND#11	40.412586
Rf65	A2#3	A2#8	80.116402
Rf63	C1#2	C1#7	160.232803
Re1	VPWR#2	VPWR	4.549932
Re2	VPWR	VPWR#6	0.974985
Re3	VGND#2	VGND	4.549932
Re4	VGND	VGND#7	0.974985
*
*       CAPACITOR CARDS
*
*
C1	VPWR#7	A2#6	1.80989e-19
C2	A2#7	a_477_198##6	1.18791e-17
C3	a_477_198##4	a_27_392##15	1.52609e-17
C4	a_477_198##2	a_477_198##5	3.88858e-18
C5	VPWR#5	A2#6	2.90472e-18
C6	VPWR#14	a_27_392##19	4.67204e-17
C7	a_477_198##3	VGND#11	1.43238e-17
C8	VGND#11	B1#1	2.69508e-18
C9	VPWR#4	VPWR#3	1.07669e-18
C10	VPWR#8	A2#5	2.36711e-19
C11	a_477_198##6	B1#1	2.91181e-17
C12	a_27_392##22	a_27_392##19	2.37916e-18
C13	VPWR#14	B1#3	6.75593e-19
C14	a_477_198##4	a_27_392##14	3.07374e-18
C15	VPWR#7	A2#5	1.67158e-18
C16	a_477_198##2	VGND#11	5.46899e-17
C17	VGND#11	B1#6	4.29502e-19
C18	VPWR#3	VPWR#1	1.58099e-18
C19	a_477_198##3	a_477_198##6	2.49997e-18
C20	B1#1	a_287_74#	1.56248e-17
C21	X#6	VGND#1	4.31078e-17
C22	a_287_74##2	a_27_392##16	3.09915e-20
C23	a_27_392##22	VPWR#14	3.9473e-17
C24	a_27_74#	A2#7	2.50879e-19
C25	a_477_198##6	B1#6	1.40566e-18
C26	D1#2	C1#3	2.19936e-17
C27	a_27_392##14	A1#1	7.66782e-20
C28	a_27_392##17	B1#3	1.95707e-19
C29	VGND#11	C1#6	4.95212e-19
C30	VPWR#15	VPWR#14	2.54456e-18
C31	VPWR#7	B1#5	1.28947e-18
C32	a_287_74#	B1#6	4.22676e-17
C33	a_477_198##6	a_477_198##2	1.89247e-18
C34	a_287_74##2	a_27_392##15	8.78774e-18
C35	a_27_74#	B1#1	4.83024e-19
C36	a_477_198##3	a_287_74#	9.54523e-18
C37	VGND#8	VGND#1	1.62783e-18
C38	a_477_198##6	C1#6	1.4009e-19
C39	a_27_74##4	a_27_392##16	1.04099e-18
C40	a_477_198##4	B1#6	5.02013e-17
C41	VPWR#15	a_27_392##22	3.94077e-17
C42	a_27_392##24	a_27_392##17	2.03228e-18
C43	a_27_392##14	A1#7	1.22796e-19
C44	a_287_74##2	B1#1	8.47851e-20
C45	a_27_392##17	C1#3	7.87153e-19
C46	a_287_74#	C1#6	7.06739e-19
C47	a_27_74#	B1#6	3.62533e-18
C48	VGND#8	X#6	4.85536e-17
C49	VPWR#7	B1#4	2.95121e-18
C50	a_27_392##23	a_27_392##22	3.51314e-18
C51	a_477_198##4	C1#6	1.89194e-18
C52	X#2	VPWR#1	3.99342e-17
C53	a_287_74##2	B1#6	1.30862e-18
C54	VGND#11	A2#4	1.65086e-18
C55	a_287_74#	C1#4	6.2498e-20
C56	a_27_392##14	A2#6	1.61979e-17
C57	X#5	VPWR#4	7.97908e-18
C58	a_27_74#	C1#6	4.25746e-17
C59	a_27_392##23	VPWR#15	4.65055e-17
C60	a_27_392##17	D1#2	1.38148e-17
C61	a_27_392##16	VPWR#8	1.72137e-19
C62	C1#2	C1#3	8.84798e-18
C63	VPWR#8	C1#1	2.9551e-18
C64	X#4	X#6	3.70665e-18
C65	a_477_198##4	C1#4	4.1098e-20
C66	VPWR#5	VPWR#12	5.60527e-20
C67	a_287_74##2	C1#6	4.74874e-17
C68	X#2	X#1	7.02256e-19
C69	X#5	VPWR#3	7.8869e-18
C70	a_287_74#	D1#4	4.33594e-20
C71	a_27_392##24	B1#6	3.8197e-19
C72	VPWR#16	VPWR#15	3.24633e-18
C73	a_27_74#	C1#4	1.10859e-18
C74	VGND#6	a_477_198##3	3.35584e-19
C75	a_27_392##16	C1#3	2.59704e-18
C76	X#2	VPWR#3	3.34021e-19
C77	a_27_392##14	A2#5	1.66619e-17
C78	X#4	VGND#8	5.36381e-17
C79	a_477_198##4	D1#4	5.45892e-19
C80	a_27_392##15	VPWR#8	3.39212e-19
C81	a_287_74##2	C1#4	3.08959e-17
C82	VPWR#16	a_27_392##23	4.65233e-17
C83	VPWR#8	C1#5	2.00621e-18
C84	a_27_392##24	C1#6	8.24563e-20
C85	a_747_392#	VPWR#5	1.01343e-17
C86	VPWR#15	C1#3	1.08845e-18
C87	a_27_74#	D1#4	2.59055e-19
C88	a_27_74##2	a_287_74#	5.99324e-19
C89	X#2	VPWR#11	2.09512e-17
C90	C1#4	a_27_74##4	1.09831e-17
C91	a_27_392##14	A2#4	3.47505e-18
C92	a_27_392##15	B1#3	1.62033e-19
C93	a_27_392##18	a_27_392##23	3.75304e-18
C94	VGND#9	VGND#8	1.62783e-18
C95	a_27_392##14	B1#5	1.57373e-17
C96	a_27_392##17	B1#4	2.98419e-19
C97	a_287_74##2	D1#4	1.18932e-18
C98	VGND#6	a_477_198##2	4.98983e-18
C99	a_27_392##24	C1#4	9.08477e-19
C100	a_747_392#	VPWR#4	7.5608e-18
C101	a_27_392##15	VPWR#7	3.39212e-19
C102	D1#3	D1#2	1.26954e-17
C103	a_27_392##18	VPWR#16	4.65055e-17
C104	D1#4	a_27_74##4	1.78959e-17
C105	a_27_74##3	C1#4	2.73106e-19
C106	a_27_392##15	B1#4	1.26019e-17
C107	VGND#9	X#4	7.11283e-17
C108	a_27_392##15	C1#3	1.70935e-18
C109	a_27_392##24	D1#4	3.37711e-17
C110	a_27_392##14	B1#4	3.19373e-19
C111	VGND#5	a_477_198##2	5.07638e-18
C112	a_27_392##17	C1#1	5.05571e-19
C113	X#3	X#2	2.47416e-17
C114	a_27_74##4	D1#5	1.13853e-18
C115	a_27_74##3	D1#4	1.24113e-18
C116	a_27_392##14	VPWR#7	3.13897e-19
C117	a_27_74##2	a_27_74#	1.91351e-18
C118	a_27_392##24	D1#5	2.99066e-17
C119	a_477_198#	X#4	2.89282e-18
C120	a_27_392##15	C1#1	1.28586e-17
C121	a_27_392##21	VPWR#5	3.31107e-17
C122	a_27_392##14	B1#3	7.82741e-18
C123	a_27_392##14	C1#1	7.54111e-20
C124	a_27_74##3	D1#5	4.18685e-17
C125	a_27_392##17	C1#5	6.81228e-19
C126	a_27_392##16	C1#5	1.73358e-17
C127	a_27_74##2	a_287_74##2	2.15536e-17
C128	a_477_198#	VGND#9	6.4898e-17
C129	a_27_392##8	a_27_392##7	3.90141e-17
C130	a_747_392##2	VPWR#5	1.4994e-18
C131	a_27_392##17	D1#1	1.22393e-17
C132	a_287_74#	B1#3	1.40967e-18
C133	VPWR#7	a_27_392##19	1.31245e-17
C134	VGND#10	VGND#9	2.30962e-18
C135	a_27_74##2	a_27_74##4	1.24473e-18
C136	a_27_392##16	D1#1	8.04659e-18
C137	a_27_392##10	a_27_392##8	2.15639e-17
C138	D1#2	VPWR#16	1.33743e-18
C139	VPWR#1	a_27_392#	3.01457e-17
C140	a_27_392##17	D1#6	1.05885e-17
C141	VGND#10	a_477_198#	6.65384e-17
C142	a_27_74##2	a_27_392##24	1.83341e-17
C143	X#1	a_27_392#	4.41877e-17
C144	VGND#2	VGND#3	5.53594e-17
C145	VPWR#1	a_27_392##9	1.26222e-18
C146	VPWR#11	a_27_392#	2.74582e-18
C147	VPWR#2	VPWR#3	3.70997e-17
C148	a_27_392##6	a_27_392##10	3.82303e-17
C149	a_27_392##22	VPWR#8	5.46992e-18
C150	a_27_392##9	X#1	1.88267e-17
C151	a_477_198##4	B1#3	5.15108e-18
C152	X#5	a_27_392#	2.94658e-19
C153	VPWR#11	a_27_392##9	5.00819e-17
C154	a_477_198##3	A2#4	1.07629e-18
C155	a_27_392##22	VPWR#7	5.4001e-18
C156	VGND#4	a_27_392##5	3.56411e-20
C157	X#2	VPWR#2	2.85169e-18
C158	X#1	a_27_392##11	4.06439e-19
C159	a_477_198##4	C1#3	4.37073e-18
C160	X#5	a_27_392##9	4.51722e-19
C161	A1#6	a_27_392##6	2.91189e-17
C162	VPWR#11	a_27_392##11	4.40816e-17
C163	a_27_392##14	a_747_392#	1.94055e-17
C164	VGND#2	X#3	2.50733e-18
C165	X#1	a_27_392##12	1.81421e-19
C166	X#5	a_27_392##11	6.85693e-17
C167	VGND#11	VGND#10	4.93363e-18
C168	VGND#2	X#2	4.15239e-18
C169	VPWR#11	a_27_392##12	1.78268e-18
C170	VPWR#12	a_27_392##11	1.84496e-18
C171	A1#5	A1#6	4.37196e-17
C172	a_27_392##23	VPWR#8	4.74521e-18
C173	a_27_392##14	VPWR#13	1.10778e-18
C174	a_27_392##12	X#5	1.9539e-17
C175	a_477_198##2	A2#4	2.65536e-18
C176	a_477_198##3	B1#3	1.86655e-18
C177	VGND#3	a_27_392##5	1.84888e-20
C178	VGND#4	a_27_392##4	4.12968e-19
C179	VPWR#12	a_27_392##12	5.91949e-17
C180	a_27_74#	C1#3	8.54857e-19
C181	VGND#3	a_27_392##4	1.65489e-20
C182	X#5	A1#1	8.96024e-19
C183	a_747_392#	a_27_392##12	1.14349e-18
C184	A2#1	A1#5	4.4225e-18
C185	a_27_392##14	a_27_392##21	6.01042e-19
C186	A1#1	VPWR#12	2.38801e-17
C187	VPWR#13	a_27_392##12	2.87603e-19
C188	VGND#5	A1#3	2.75157e-20
C189	X#5	A1#7	5.08821e-19
C190	a_747_392#	A1#1	4.8589e-17
C191	VGND#4	A1#3	8.96853e-19
C192	a_27_392##4	VPWR#4	9.74819e-19
C193	VPWR#12	A1#7	1.17386e-18
C194	a_27_392##14	VPWR#6	2.02514e-20
C195	A2#7	A2#1	2.92739e-17
C196	VPWR#13	A1#1	7.74125e-19
C197	a_477_198##6	VGND#11	3.67617e-17
C198	a_27_392##14	a_747_392##2	7.70155e-17
C199	VPWR#3	a_27_392##4	2.61362e-20
C200	X#5	A2#6	3.56658e-19
C201	a_747_392#	A1#7	5.73777e-17
C202	VGND#3	a_27_392##7	8.88416e-19
C203	a_27_392##3	a_27_392##2	8.33715e-18
C204	a_287_74##2	C1#3	8.0929e-18
C205	X#3	a_27_392##4	3.05899e-17
C206	VPWR#12	A2#6	8.25056e-20
C207	A1#7	VPWR#13	3.4749e-17
C208	VPWR#5	A1#3	4.29597e-20
C209	a_27_392##4	X#2	4.64888e-17
C210	B1#1	A2#7	3.90804e-17
C211	a_747_392#	A2#6	3.88717e-19
C212	VPWR#4	A1#3	2.8789e-20
C213	a_27_392##21	A1#7	8.30312e-19
C214	a_27_392##19	A1#1	2.11526e-19
C215	a_27_392##14	a_27_392##19	3.74866e-18
C216	VPWR#13	A2#6	1.82824e-18
C217	a_747_392##2	A1#7	3.5242e-19
C218	A1#6	a_27_392##5	2.14291e-18
C219	VGND#3	a_27_392##8	3.63614e-18
C220	a_27_392##15	VPWR#14	1.35582e-17
C221	a_287_74#	a_477_198##6	3.16104e-17
C222	a_747_392#	A2#5	1.15225e-19
C223	VGND#7	a_477_198##3	4.87903e-19
C224	a_27_392##21	A2#6	5.77709e-17
C225	a_27_392##19	A1#7	3.38746e-19
C226	B1#6	B1#1	3.98903e-17
C227	VPWR#13	A2#5	2.05041e-19
C228	VGND#2	VGND#1	2.23979e-17
C229	a_747_392##2	A2#6	3.66788e-17
C230	a_27_392##14	VPWR#14	1.34715e-17
C231	VGND#2	X#6	3.01592e-17
C232	a_27_392##21	A2#5	7.61424e-19
C233	a_27_392##19	A2#6	1.15011e-18
C234	a_27_74#	VGND#11	2.17699e-18
C235	a_27_392##15	a_27_392##22	1.20037e-18
C236	VGND#3	a_27_392##10	5.40681e-18
C237	VGND#7	a_27_74##2	6.31486e-17
C238	a_747_392##2	A2#5	3.67658e-17
C239	B1#4	B1#3	9.4311e-19
C240	VGND#2	X#4	6.842e-19
C241	C1#6	B1#6	2.9274e-18
C242	a_27_392##16	VPWR#15	1.65465e-17
C243	a_27_392##21	B1#5	1.9961e-19
C244	VGND#3	VGND#1	5.56729e-19
C245	a_27_392##19	A2#5	3.79748e-17
C246	a_27_392##22	a_27_392##14	9.40337e-19
C247	a_287_74#	a_477_198##4	6.00846e-17
C248	a_27_74##4	D1#2	1.74717e-18
C249	VGND#4	a_27_392##6	4.70848e-18
C250	VPWR#14	A2#5	9.28466e-19
C251	a_27_392##15	VPWR#15	1.19956e-17
C252	a_27_392##24	B1#3	6.11201e-20
C253	B1#5	a_27_392##19	2.63975e-17
C254	a_27_392##22	A2#5	2.7354e-19
C255	VGND#3	a_27_392##6	4.64234e-19
C256	C1#4	C1#6	3.54336e-17
C257	VPWR#14	B1#5	4.15578e-17
C258	a_27_392##16	a_27_392##23	1.66908e-19
C259	a_27_74#	a_287_74#	3.50477e-18
C260	a_287_74##2	a_477_198##6	6.68928e-19
C261	VPWR#15	A2#5	2.23014e-20
C262	a_27_392##19	B1#4	7.31989e-19
C263	a_27_392##22	B1#5	6.00171e-19
C264	a_27_392##24	C1#3	4.26461e-18
C265	VGND#4	A1#6	4.92989e-18
C266	a_27_392##17	VPWR#16	2.91586e-17
C267	VGND#6	A1#5	8.19577e-19
C268	VPWR#14	B1#4	3.73298e-17
C269	C1#1	B1#3	1.96351e-19
C270	D1#4	C1#4	3.68489e-17
C271	a_287_74##2	a_287_74#	1.87567e-18
C272	X#3	a_27_392##7	2.18637e-17
C273	VGND#3	A1#6	1.51773e-19
C274	a_27_392##19	C1#1	1.90799e-19
C275	B1#4	a_27_392##22	2.20151e-17
C276	C1#3	C1#1	1.11682e-18
C277	VGND#5	A1#5	1.24646e-18
C278	a_27_392##24	D1#2	2.40257e-18
C279	VGND#8	a_27_392##4	1.1821e-18
C280	VPWR#14	C1#1	1.71904e-18
C281	VPWR#15	B1#4	1.71904e-18
C282	X#4	a_27_392##4	5.46439e-17
C283	a_287_74##2	a_477_198##4	4.19789e-18
C284	C1#1	a_27_392##22	2.68667e-17
C285	VGND#4	X#4	8.48245e-18
C286	a_27_392##23	B1#4	2.79387e-19
C287	D1#5	D1#4	4.18804e-17
C288	VGND#9	a_27_392##4	1.85738e-17
C289	C1#2	a_27_392##16	1.26716e-17
C290	VPWR#2	VPWR#1	2.90795e-17
C291	VGND#6	A2#1	1.97828e-18
C292	A2	A1#4	1.95937e-17
C293	a_477_198#	a_27_392##4	4.03004e-18
C294	VPWR#15	C1#1	4.55986e-17
C295	A2	A2#4	3.71886e-17
C296	X#3	a_27_392##8	2.33322e-17
C297	VGND#7	a_477_198##6	9.06601e-18
C298	X#1	VPWR#2	2.92726e-17
C299	A2	B1#3	6.65187e-18
C300	a_27_392##22	C1#5	9.29866e-19
C301	VGND#7	a_287_74#	1.81649e-17
C302	a_27_392##23	C1#1	1.50341e-18
C303	VPWR#2	VPWR#11	2.17661e-17
C304	a_27_74#	a_287_74##2	5.33898e-17
C305	a_477_198##3	a_27_392##14	6.04552e-18
C306	VGND#2	VPWR#1	2.21711e-18
C307	VGND#3	X#4	8.6585e-18
C308	C1#5	VPWR#15	2.17309e-17
C309	D1#3	a_27_392##17	2.81732e-17
C310	VPWR#2	X#5	1.08006e-18
C311	VPWR#16	C1#1	3.7388e-19
C312	VGND#7	a_27_74#	5.27638e-17
C313	a_477_198#	A1#3	3.44323e-17
C314	a_27_392##23	C1#5	4.27897e-17
C315	VGND#6	A2#7	2.65187e-18
C316	A2#1	A1#4	1.21417e-18
C317	VGND#7	a_287_74##2	9.58716e-19
C318	a_27_74##2	C1#3	2.55546e-19
C319	VGND#5	a_477_198#	5.50166e-18
C320	VPWR#11	a_27_392##3	3.25101e-19
C321	VPWR#15	D1#1	1.36794e-18
C322	VPWR#16	C1#5	1.47847e-18
C323	a_27_392##24	a_477_198##4	3.62198e-18
C324	a_27_392##23	D1#1	3.69178e-17
C325	VGND#6	VGND#10	1.13739e-18
C326	VGND#9	VGND#3	3.82144e-19
C327	a_27_74##2	a_27_392##17	4.17678e-19
C328	VGND#7	a_27_74##3	4.94193e-17
C329	D1#1	VPWR#16	2.60753e-17
C330	VPWR#15	D1#6	7.70534e-19
C331	B1	A2#4	4.08384e-18
C332	a_27_74##4	a_287_74##2	4.06502e-17
C333	a_27_74##2	D1#2	1.46524e-19
C334	VGND#4	a_477_198#	5.20222e-18
C335	VGND#6	VGND#5	8.01971e-19
C336	a_27_392##23	D1#6	1.22123e-18
C337	a_27_392##18	D1#1	1.18413e-18
C338	B1	B1#3	2.15583e-17
C339	B1	C1#3	1.69357e-18
C340	a_27_392##9	a_27_392#	4.63717e-17
C341	D1#6	VPWR#16	3.17915e-17
C342	a_27_74##2	D1#3	1.85474e-20
C343	VPWR#4	a_27_392##5	1.02356e-20
C344	X#5	a_27_392##5	7.23054e-19
C345	a_27_392##18	D1#6	3.8779e-17
C346	a_27_392##21	VPWR#6	2.59182e-17
C347	a_27_392##11	a_27_392##9	4.60293e-17
C348	a_27_392##4	VPWR#11	2.68887e-18
C349	a_27_392##4	X#5	9.54607e-17
C350	a_27_392##24	a_27_74##4	3.31642e-17
C351	a_27_392##19	VPWR#6	3.95755e-17
C352	a_27_392##4	VPWR#12	4.03371e-17
C353	a_27_392##4	a_747_392#	6.19404e-17
C354	a_27_392##12	a_27_392##11	3.70995e-17
C355	C1	B1#3	3.29592e-18
C356	a_27_392##4	VPWR#13	2.06356e-19
C357	C1	C1#3	2.38336e-17
C358	C1	D1#2	1.36728e-17
C359	a_27_74##3	a_27_74##4	3.24229e-18
C360	A2#4	A1#4	4.27982e-18
C361	X#3	VGND#1	3.88324e-18
C362	VGND#5	VGND#4	1.35733e-18
C363	a_477_198##3	a_477_198##2	7.69196e-19
C364	A1#3	a_747_392#	4.80556e-18
C365	VGND#6	C1#6	4.25582e-19
C366	VGND#2	a_27_392##7	2.81375e-18
C367	A1#1	a_27_392##12	3.13031e-17
C368	a_287_74##2	C1#2	7.88865e-18
C369	VGND#2	a_27_392##8	1.85861e-18
C370	a_27_74##3	a_27_392##24	4.6047e-17
C371	X#3	X#6	9.59055e-20
C372	A1#7	A1#1	4.14618e-17
C373	VPWR#8	C1#3	6.48221e-20
C374	D1#3	a_27_392##24	1.66727e-17
C375	a_27_74##3	D1#3	1.23938e-17
C376	A2#6	A1#7	3.89996e-18
C377	X#3	VGND#8	1.8904e-17
C378	VGND#4	VGND#3	9.53351e-19
C379	VPWR#2	a_27_392##3	3.83779e-20
C380	A2#5	A2#6	3.17649e-17
C381	VPWR#2	a_27_392##2	3.45369e-20
C382	X	a_27_392##5	7.76147e-20
C383	X	a_27_392##3	2.55153e-19
C384	B1#5	A2#5	2.27989e-17
C385	X	a_27_392##2	1.70415e-17
C386	VGND#7	B1#1	4.08223e-18
C387	a_27_392##4	A2#1	3.0039e-19
C388	X#1	VPWR#1	6.29176e-17
C389	VGND#7	B1#6	3.8424e-18
C390	VPWR#2	a_27_392#	7.58716e-18
C391	VGND#7	C1#6	4.48044e-18
C392	B1#4	B1#5	3.65808e-17
C393	VGND#8	a_27_392##3	3.57495e-19
C394	VPWR#2	a_27_392##9	1.05762e-18
C395	VGND#7	C1#4	4.43464e-18
C396	a_477_198##2	A1#6	1.8382e-19
C397	VPWR#11	VPWR#1	1.77567e-18
C398	a_27_74#	VGND#6	2.93583e-18
C399	VGND#7	D1#4	4.43427e-18
C400	VPWR#2	a_27_392##11	5.71279e-19
C401	VGND#2	a_27_392##3	5.71176e-19
C402	VPWR#16	D1#3	3.10708e-19
C403	VGND#7	D1#5	4.43427e-18
C404	C1#1	B1#4	1.82715e-17
C405	VGND#2	a_27_392##2	2.1121e-20
C406	D1#3	a_27_392##18	2.35434e-17
C407	a_27_392##7	VGND#1	2.0246e-17
C408	A2	a_27_392##14	1.21265e-16
C409	C1#3	B1#6	1.32711e-18
C410	VPWR#11	X#1	4.86254e-17
C411	X#4	a_27_392##5	2.26497e-18
C412	X#3	a_27_392##3	2.82678e-18
C413	a_477_198##2	A1#5	1.82379e-18
C414	C1#5	C1#1	2.91582e-17
C415	a_477_198##3	A2	4.26543e-17
C416	a_477_198##2	A2	9.29612e-17
C417	X#6	a_27_392##7	3.51137e-17
C418	a_27_392##4	a_27_392#	4.40112e-19
C419	VPWR	B1#3	1.20655e-20
C420	VPWR	C1#3	1.20655e-20
C421	a_477_198##3	A2#1	2.33332e-19
C422	a_27_392##4	a_27_392##9	1.40673e-19
C423	VGND#1	a_27_392##8	1.36469e-18
C424	X#5	X#1	2.29988e-18
C425	D1#1	C1#5	3.55108e-17
C426	a_27_392##4	a_27_392##11	8.47586e-19
C427	B1	a_27_392##14	4.27123e-17
C428	VGND#8	a_27_392##7	5.67849e-19
C429	X#2	a_27_392##5	2.10766e-20
C430	VPWR#6	A2#6	1.51518e-18
C431	a_477_198##2	A2#1	3.93778e-17
C432	a_27_392##4	a_27_392##12	1.00818e-17
C433	a_477_198##3	B1	3.01691e-17
C434	X#3	a_27_392##2	1.02254e-18
C435	X#6	a_27_392##8	3.26421e-17
C436	VPWR#6	A2#5	4.43469e-18
C437	a_27_392##4	A1#1	2.31781e-17
C438	X#5	VPWR#11	6.61579e-17
C439	D1#6	D1#1	2.41089e-17
C440	A1#3	a_27_392##12	7.42446e-18
C441	a_477_198##3	A2#7	1.8398e-17
C442	VGND#1	a_27_392##10	2.8808e-19
C443	a_27_392##4	A1#7	1.8158e-17
C444	a_477_198#	A2	2.11429e-17
C445	VPWR#6	B1#5	1.64304e-18
C446	a_27_392##17	C1	2.14625e-17
C447	C1	a_27_392##16	4.88305e-17
C448	a_27_392##8	VGND#8	2.05259e-17
C449	a_27_392##4	A2#6	3.42365e-20
C450	A2	VGND#11	3.95187e-18
C451	D1#3	D1#4	3.94855e-18
C452	a_477_198##2	A2#7	1.52851e-18
C453	VPWR#12	VPWR#11	1.81065e-18
C454	X#2	a_27_392##3	7.7842e-18
C455	X#6	a_27_392##10	1.18139e-18
C456	VPWR#6	A2#4	4.31875e-20
C457	X#4	a_27_392##8	7.63238e-19
C458	VGND	D1#2	3.36675e-20
C459	a_27_74##2	C1	1.57157e-18
C460	a_477_198##3	B1#1	2.31108e-17
C461	B1#3	A2#4	2.91744e-17
C462	a_27_392##10	VGND#8	2.34124e-17
C463	VPWR#12	X#5	6.68914e-17
C464	VPWR#6	B1#3	8.04047e-20
C465	B1	a_287_74#	2.87527e-18
C466	VGND#9	a_27_392##8	2.8808e-19
C467	a_477_198##4	B1	1.17492e-17
C468	a_477_198##2	B1#1	2.16346e-19
C469	X#2	a_27_392##2	9.22427e-18
C470	X#4	a_27_392##10	6.01604e-17
C471	VGND#8	a_27_392##6	2.93363e-19
C472	A2	a_747_392##2	4.02046e-18
C473	X#3	X	2.03341e-18
C474	VGND#9	a_27_392##10	7.57597e-19
C475	VPWR#2	a_27_392##4	2.77466e-18
C476	a_287_74##2	C1	1.42564e-17
C477	a_27_74##4	C1	1.30245e-17
C478	a_477_198#	a_27_392##5	9.15937e-19
C479	a_27_392##24	C1	6.78663e-18
C480	X#4	a_27_392##6	4.12806e-17
C481	VGND#2	a_27_392##4	2.63728e-18
C482	a_747_392#	VPWR#12	5.26121e-17
C483	X#5	VPWR#13	1.50709e-19
C484	VPWR#8	VPWR#7	3.45487e-18
C485	B1	a_27_392##19	1.54315e-18
C486	a_27_392##21	A2#4	4.50902e-19
C487	VPWR	VPWR#8	8.42633e-17
C488	VPWR	VPWR#7	7.37794e-17
C489	VGND#8	A1#6	1.33133e-19
C490	VPWR	VPWR#5	7.96108e-17
C491	VPWR	VPWR#4	6.19067e-17
C492	VPWR	VPWR#3	1.09455e-17
C493	VGND#9	a_27_392##6	1.72172e-17
C494	X	VGND#1	2.80125e-17
C495	D1#3	D1#1	4.32685e-19
C496	VGND#7	B1#3	1.899e-19
C497	VPWR	a_27_392##17	2.63396e-18
C498	VPWR#13	VPWR#12	1.48844e-18
C499	VPWR	a_27_392##16	2.06963e-18
C500	a_477_198#	a_27_392##3	3.45219e-19
C501	a_27_74##3	D1	9.65388e-18
C502	VPWR	a_27_392##15	4.30901e-18
C503	X#4	A1#6	1.76569e-18
C504	VPWR	a_27_392##14	8.20406e-18
C505	VGND#7	C1#3	1.50379e-19
C506	A1#3	a_27_392##4	7.20428e-17
C507	a_27_392##4	a_27_392##5	2.10926e-17
C508	a_477_198#	a_27_392##6	2.94533e-19
C509	C1	VPWR#15	2.21305e-18
C510	VGND#7	D1#2	3.30812e-20
C511	a_27_392##4	a_27_392##3	1.50353e-17
C512	VGND	VGND#6	7.54393e-17
C513	VGND	VGND#5	5.84727e-17
C514	VGND	VGND#4	5.82802e-17
C515	VGND	VGND#3	1.65093e-17
C516	a_27_74##2	B1#6	2.42414e-19
C517	VGND#9	A1#6	4.6314e-17
C518	a_747_392#	VPWR#13	7.62801e-17
C519	a_27_392##4	a_27_392##2	2.17765e-19
C520	D1#4	C1#3	1.0182e-17
C521	X	VPWR#1	3.50036e-17
C522	a_477_198#	a_27_392##2	3.49949e-19
C523	VGND#7	D1#3	5.69736e-20
C524	a_27_392##4	A1#4	1.03624e-18
C525	X#4	A1#5	2.67828e-19
C526	VGND	a_27_392##15	4.97911e-18
C527	VPWR#3	a_27_392##9	1.77722e-18
C528	D1	a_27_392##18	1.82008e-17
C529	A1#6	a_477_198#	1.83363e-17
C530	a_27_392##5	VNB	2.73271e-17
C531	a_27_392##3	VNB	2.58112e-17
C532	a_27_392##2	VNB	2.62169e-17
C533	VGND	a_477_198##3	3.78923e-18
C534	X#2	a_27_392#	1.47732e-17
C535	A1#4	VNB	2.99396e-17
C536	VGND	a_477_198##2	1.86641e-17
C537	A2#4	VNB	6.06751e-17
C538	B1#3	VNB	5.83558e-17
C539	a_27_392##4	A2#4	5.11831e-19
C540	C1#3	VNB	8.16942e-17
C541	D1#2	VNB	2.59268e-17
C542	VGND	a_27_74##2	2.92281e-17
C543	a_747_392##2	A2#4	1.03833e-18
C544	VGND#9	A1#5	2.78327e-18
C545	a_27_74##2	C1#6	8.17277e-19
C546	VGND#10	A1#6	2.40058e-18
C547	VPWR	X#5	1.62131e-17
C548	VGND	X#4	1.71513e-17
C549	VPWR	VPWR#12	2.14679e-17
C550	VGND	VGND#9	1.8648e-17
C551	VGND	a_477_198#	1.35039e-17
C552	VPWR	a_747_392#	2.00079e-17
C553	VGND	VGND#10	2.19859e-17
C554	VPWR	VPWR#13	1.78795e-17
C555	VPWR	a_27_392##21	2.50462e-17
C556	VPWR	a_747_392##2	1.16695e-17
C557	VGND	a_477_198##6	1.27268e-17
C558	a_27_392##21	VPWR#13	3.30286e-17
C559	a_477_198#	A1#5	3.66676e-17
C560	a_747_392##2	a_747_392#	1.32117e-18
C561	VGND	a_287_74#	1.98479e-17
C562	VPWR	a_27_392##19	2.18995e-17
C563	X	A1#6	8.01982e-20
C564	VGND	a_477_198##4	6.31375e-18
C565	VGND	a_27_74#	2.30286e-17
C566	VPWR	a_27_392##22	1.56547e-17
C567	VGND	a_287_74##2	1.43967e-17
C568	A1#3	a_27_392##5	2.0571e-17
C569	VPWR#3	a_27_392##11	1.13142e-18
C570	VGND	a_27_392##24	6.87682e-18
C571	VPWR	a_27_392##23	1.47496e-17
C572	VGND	a_27_74##3	2.42557e-17
C573	VPWR	a_27_392##18	1.53356e-17
C574	X#2	a_27_392##9	2.35668e-17
C575	a_27_74##2	C1#4	1.92034e-17
C576	VGND#10	A1#5	4.63523e-17
C577	VGND#6	VNB	3.07995e-17
C578	VGND#5	VNB	3.1714e-17
C579	a_477_198#	A2#1	2.65114e-19
C580	A1#4	A1#3	7.56182e-18
C581	VGND#4	VNB	2.87574e-17
C582	VGND#3	VNB	2.77095e-17
C583	VGND#3	X#3	2.25448e-19
C584	A2	a_27_392##4	2.89664e-17
C585	VPWR#4	a_27_392##12	4.21634e-18
C586	VPWR#8	VNB	3.80396e-17
C587	VPWR#7	VNB	3.09052e-17
C588	VPWR#5	VNB	4.29654e-17
C589	VPWR#4	VNB	2.9939e-17
C590	VPWR#3	VNB	2.37652e-17
C591	VGND	a_27_392##10	1.8548e-19
C592	A2	A1#3	2.85647e-17
C593	X#3	VNB	8.1742e-19
C594	VGND	a_27_392##6	1.31428e-18
C595	X#2	VNB	3.55374e-18
C596	VGND	A1#6	1.20054e-18
C597	a_27_392##17	VNB	2.55167e-18
C598	a_27_392##16	VNB	2.68946e-18
C599	VGND	A1#5	6.85283e-19
C600	a_27_392##15	VNB	7.06942e-18
C601	a_27_392##14	VNB	1.15691e-17
C602	VGND	A2#1	8.80556e-18
C603	VGND	A2#7	4.07579e-18
C604	VPWR	a_27_392##11	5.42876e-20
C605	a_477_198##2	VNB	1.66096e-17
C606	VGND	B1#1	1.06605e-17
C607	VPWR	a_27_392##12	2.86375e-18
C608	a_27_74##3	a_27_392##18	2.9265e-19
C609	VGND	B1#6	1.06605e-17
C610	a_27_392##21	a_747_392##2	8.07517e-17
C611	a_27_74##2	VNB	4.55414e-18
C612	VPWR	A1#1	1.45142e-18
C613	VGND	C1#6	2.74479e-18
C614	VGND#10	A2#1	2.5614e-18
C615	VGND	C1#4	1.65293e-18
C616	X#2	a_27_392##11	6.13967e-19
C617	VGND#1	VNB	2.7068e-17
C618	VGND	D1#4	1.37803e-18
C619	VPWR	A2#6	1.8826e-18
C620	X#6	VNB	5.34939e-18
C621	VGND#8	VNB	2.39197e-18
C622	VGND	D1#5	2.16842e-18
C623	a_27_74##2	D1#4	2.14614e-17
C624	VPWR	A2#5	2.02113e-18
C625	X#4	VNB	2.32804e-18
C626	VGND#9	VNB	4.6412e-18
C627	a_477_198#	VNB	5.10596e-18
C628	VPWR	B1#5	2.94319e-18
C629	VGND#10	VNB	9.4514e-18
C630	VPWR	B1#4	4.32298e-18
C631	C1#3	B1#3	1.70197e-17
C632	VGND#11	A1#5	1.1529e-18
C633	VGND#11	VNB	3.44129e-18
C634	a_477_198##6	VNB	2.77696e-18
C635	VPWR#2	X	2.40409e-18
C636	a_287_74#	VNB	7.83818e-18
C637	VPWR	C1#1	4.33044e-18
C638	a_27_392##3	a_27_392#	4.09658e-18
C639	a_477_198##4	VNB	2.44594e-18
C640	a_27_74#	VNB	1.14709e-17
C641	VGND#2	X	3.07015e-18
C642	VPWR	C1#5	8.07299e-18
C643	a_287_74##2	VNB	4.29639e-18
C644	a_27_74##4	VNB	3.85551e-18
C645	a_27_392##24	VNB	5.7722e-18
C646	VPWR	D1#1	8.07117e-18
C647	a_27_74##3	VNB	4.6558e-17
C648	VPWR#1	VNB	6.24e-17
C649	VPWR	D1#6	9.0119e-18
C650	X#1	VNB	2.40111e-18
C651	VPWR#11	VNB	2.34902e-19
C652	X#5	VNB	5.56713e-18
C653	VPWR#12	VNB	1.17305e-18
C654	a_27_392##4	X	2.42186e-18
C655	a_747_392#	VNB	4.25632e-18
C656	VPWR#5	VPWR#4	8.89837e-19
C657	VPWR#13	VNB	5.89476e-18
C658	A2#1	a_477_198##5	2.38073e-17
C659	a_27_392##21	VNB	1.00946e-17
C660	a_477_198##2	a_477_198#	2.28261e-18
C661	a_747_392##2	VNB	3.34808e-18
C662	a_27_392##19	VNB	6.22356e-18
C663	VPWR#14	VNB	3.99272e-20
C664	D1	D1#3	1.01546e-17
C665	VPWR	VPWR#6	4.96382e-17
C666	a_27_392##19	a_27_392##21	2.59148e-18
C667	a_27_392##22	VNB	6.47977e-18
C668	VPWR#15	VNB	1.07723e-18
C669	a_27_392##23	VNB	2.71179e-18
C670	VPWR#4	A1#1	7.64575e-18
C671	VPWR#16	VNB	4.62877e-18
C672	a_27_392##18	VNB	4.54266e-17
C673	VPWR	a_27_392##4	1.20172e-17
C674	a_27_392##7	VNB	3.53561e-17
C675	a_27_392##8	VNB	2.88598e-17
C676	a_27_392##10	VNB	2.92311e-17
C677	VPWR	A1#3	2.52207e-18
C678	a_27_392##6	VNB	3.01471e-17
C679	A1#6	VNB	3.12827e-17
C680	A1#5	VNB	3.49831e-17
C681	A2#1	VNB	3.49192e-17
C682	VGND#10	A2#7	3.3876e-19
C683	A2#7	VNB	2.64687e-17
C684	B1#1	VNB	2.94599e-17
C685	B1#6	VNB	3.46309e-17
C686	VGND	VGND#7	2.04117e-16
C687	VPWR	C1#2	4.60154e-19
C688	C1#6	VNB	2.64137e-17
C689	C1#4	VNB	2.60814e-17
C690	VGND	a_27_392##4	5.73858e-18
C691	D1#4	VNB	3.50407e-17
C692	VPWR	D1#3	1.46668e-18
C693	B1	A2	3.09223e-17
C694	D1#5	VNB	4.1262e-17
C695	VGND	A1#3	4.31629e-18
C696	a_27_392#	VNB	4.48145e-17
C697	A2#1	VGND#11	2.06459e-17
C698	a_27_392##9	VNB	2.97998e-17
C699	a_27_392##11	VNB	2.81035e-17
C700	a_27_392##12	VNB	3.35785e-17
C701	A1#1	VNB	3.32641e-17
C702	VGND	C1#2	7.13985e-19
C703	A1#7	VNB	2.96779e-17
C704	X#2	a_27_392##12	1.53284e-19
C705	A2#6	VNB	3.42085e-17
C706	VGND	D1#3	1.96085e-18
C707	C1	B1	4.89086e-18
C708	A2#5	VNB	3.66196e-17
C709	B1#5	VNB	2.8705e-17
C710	B1#4	VNB	2.62119e-17
C711	C1#1	VNB	2.73264e-17
C712	C1#5	VNB	2.97779e-17
C713	a_27_392##19	a_747_392##2	4.56903e-17
C714	D1#1	VNB	3.29989e-17
C715	D1#6	VNB	3.75807e-17
C716	VPWR#2	VNB	1.28832e-16
C717	VGND#2	VNB	1.35705e-16
C718	VPWR#6	VNB	2.93941e-17
C719	VPWR	A2	6.80724e-18
C720	VGND#7	VNB	1.24385e-16
C721	a_27_392##4	VNB	4.86555e-17
C722	VPWR	B1	1.6832e-18
C723	VPWR#5	A1#7	2.55437e-18
C724	A1#3	VNB	4.93552e-17
C725	a_287_74#	a_27_392##15	1.10947e-18
C726	VGND	A2	7.27757e-18
C727	VPWR	C1	3.26221e-18
C728	D1#3	VNB	6.9846e-17
C729	VGND	B1	1.82546e-18
C730	VPWR	D1	1.07083e-18
C731	a_477_198##2	VGND#10	4.72668e-17
C732	VGND	C1	3.45314e-18
C733	a_477_198##6	A2#1	5.74071e-19
C734	VGND	D1	1.63919e-18
C735	A2	VNB	1.34084e-17
C736	B1	VNB	2.67242e-19
C737	C1	VNB	1.86544e-18
C738	D1	VNB	1.78835e-17
C739	X	VNB	3.682e-17
C740	VPWR	VNB	3.0135e-16
C741	VGND	VNB	3.11559e-16
C742	VGND#11	A2#7	3.62533e-17
C743	a_27_392##16	VPWR#9	2.20234e-19
C744	a_27_392##18	VPWR#9	1.21746e-17
C745	VPWR	VPWR#9	1.06451e-16
C746	VPWR#9	D1#3	7.83095e-20
C747	VPWR#9	D1#1	2.20374e-18
C748	VPWR#9	VPWR#8	4.48882e-18
C749	VPWR#9	D1#6	2.00768e-18
C750	VPWR#9	VNB	5.91848e-17
C751	a_27_392##23	VPWR#9	4.77453e-18
C752	a_27_392##17	VPWR#9	6.83486e-20
*
*
.ENDS sky130_fd_sc_hs__o2111a_4
*
