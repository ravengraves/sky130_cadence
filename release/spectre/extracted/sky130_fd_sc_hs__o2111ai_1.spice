* Extracted by Quantus, converted by sky130cad/quantus.py
*
*
*
*                       LINUX           Wed Nov 18 08:53:06 2026
*
*
*
*  PROGRAM  advgen
*
*  Name           : advgen - Quantus - (64-bit)
*  Version        : 25.1.0-p047
*  Build Date     : Thu Dec 11 23:20:30 PST 2025
*
*  HSPICE LIBRARY
*
*  OPERATING_TEMPERATURE 150
*  QRC_TECH_DIR <path>/tech
*
*
*

*
.SUBCKT sky130_fd_sc_hs__o2111ai_1 VNB VPB VGND VPWR Y C1 D1 B1 A2 A1
*
*
*  caps2d version: 10
*
*
*       TRANSISTOR CARDS
*
*
XM9 Y#3 D1#1 a_182_74# VNB sky130_fd_pr__nfet_01v8_lvt l=0.15 w=0.74 ad=0.4625 as=0.1776 pd=2.73 ps=1.96
XM8 a_182_74# C1#3 a_260_74# VNB sky130_fd_pr__nfet_01v8_lvt l=0.15 w=0.74 ad=0.1776 as=0.2886 pd=1.96 ps=2.26
XM5 a_260_74# B1#3 a_368_74##2 VNB sky130_fd_pr__nfet_01v8_lvt l=0.15 w=0.74 ad=0.2886 as=0.2664 pd=2.26 ps=2.2
XM3 a_368_74##2 A2#3 VGND#4 VNB sky130_fd_pr__nfet_01v8_lvt l=0.15 w=0.74 ad=0.2664 as=0.3256 pd=2.2 ps=2.36
XM2 VGND#4 A1#4 a_368_74# VNB sky130_fd_pr__nfet_01v8_lvt l=0.15 w=0.74 ad=0.3256 as=0.2109 pd=2.36 ps=2.05
XM0 VPWR#6 D1#3 Y#4 VPB sky130_fd_pr__pfet_01v8 l=0.15 w=1.12 ad=0.3864 as=0.336 pd=2.93 ps=2.84
XM6 Y#4 C1#1 VPWR#5 VPB sky130_fd_pr__pfet_01v8 l=0.15 w=1.12 ad=0.336 as=0.5376 pd=2.84 ps=3.2
XM4 VPWR#5 B1#1 Y#1 VPB sky130_fd_pr__pfet_01v8 l=0.15 w=1.12 ad=0.5376 as=0.364 pd=3.2 ps=2.89
XM7 Y#1 A2#1 a_490_368# VPB sky130_fd_pr__pfet_01v8 l=0.15 w=1.12 ad=0.364 as=0.3416 pd=2.89 ps=2.85
XM1 a_490_368# A1#3 VPWR#1 VPB sky130_fd_pr__pfet_01v8 l=0.15 w=1.12 ad=0.3416 as=0.3304 pd=2.85 ps=2.83
*
*
*       RESISTOR AND CAP/DIODE CARDS
*
Rg1	D1#1	D1#2	307.937683
Rg2	D1#2	D1#3	492.059540
Rg3	C1#1	C1#2	492.059540
Rg4	C1#2	C1#3	307.937683
Rg5	B1#1	B1#2	492.059540
Rg6	B1#2	B1#3	307.937683
Rg7	A2#1	A2#2	492.059540
Rg8	A2#2	A2#3	307.937683
Rg9	A1#1	A1#2	33.566734
Rg10	A1#2	A1#3	509.088165
Rg11	A1#2	A1#4	327.557861
Rf1	D1	D1#2	163.775864
Rf2	C1#2	C1	163.676605
Rf3	B1	B1#4	1.492039
Rf4	B1#5	B1#2	161.724838
Rf5	B1#4	B1#5	5.118254
Rf6	Y#1	Y#2	98.263916
Rf7	Y#2	Y#3	128.327515
Rf8	Y#2	Y	4.397923
Rf9	Y	Y#5	11.031110
Rf10	Y#5	Y	0.151111
Rf11	Y#4	Y#5	5.000000
Rf12	A2#4	A2#2	161.307495
Rf13	A2	A2#6	1.074685
Rf14	A2#4	A2#6	9.707032
Rf15	a_368_74#	a_368_74##2	97.242226
Rf16	A1	A1#1	163.775864
Rf17	VPWR#1	VPWR#2	136.060226
Rf18	VPWR#2	VPWR#3	84.312263
Rf20	VPWR#2	VPWR#5	38.437725
Rf21	VPWR#3	VPWR#6	34.939823
Rf23	VGND#2	VGND#3	62.397453
Rf24	VGND#2	VGND#4	28.457888
Re1	VPWR#2	VPWR	1.403190
Re2	VGND	VGND#3	1.403242
*
*       CAPACITOR CARDS
*
*
C1	A2#2	A1#2	3.09472e-17
C2	A1#2	a_368_74#	6.87746e-18
C3	B1#5	A2#4	2.75591e-17
C4	a_368_74#	A2#6	2.63911e-17
C5	a_368_74##2	A2#6	2.7346e-18
C6	a_368_74##2	A2#4	3.09947e-17
C7	A2#6	VPWR#1	7.35054e-19
C8	a_368_74##2	B1#5	2.47837e-17
C9	A2#4	VPWR#1	4.85765e-20
C10	a_368_74#	VGND#4	4.32738e-17
C11	A2#4	Y#1	2.57392e-17
C12	a_368_74##2	a_368_74#	3.84514e-18
C13	a_368_74##2	VGND#4	3.9693e-17
C14	B1#5	Y#1	2.65503e-17
C15	VPWR#1	A1#2	8.84015e-18
C16	B1#4	Y#1	7.93157e-18
C17	a_368_74#	VPWR#1	2.77468e-18
C18	Y#3	a_368_74##2	1.59846e-18
C19	a_368_74##2	Y#1	7.30755e-18
C20	a_368_74#	A1#4	4.7246e-17
C21	A1	A1#2	2.21934e-17
C22	A1#4	VGND#4	2.56528e-17
C23	Y#1	VPWR#1	3.83202e-17
C24	a_368_74#	A2#3	1.48757e-18
C25	a_368_74##2	A1#4	1.38624e-18
C26	VGND#4	A2#3	3.45677e-17
C27	VPWR#5	VPWR#1	7.80877e-19
C28	a_368_74#	B1#3	3.07737e-19
C29	a_368_74##2	A2#3	2.84612e-17
C30	VGND#4	B1#3	1.9245e-18
C31	a_368_74##2	B1#3	4.03003e-17
C32	Y#1	VPWR#5	9.69063e-17
C33	VGND#4	C1#3	7.02458e-19
C34	a_368_74##2	C1#3	3.82311e-18
C35	VGND#4	D1#1	4.3914e-19
C36	a_368_74##2	D1#1	3.33491e-19
C37	Y#3	B1#3	5.73179e-19
C38	VPWR#6	VPWR#5	1.27222e-18
C39	Y#3	C1#3	6.8079e-18
C40	Y#3	D1#1	4.36387e-17
C41	A2#4	VPWR#2	3.98842e-19
C42	A2#3	A1#4	1.97918e-17
C43	VPWR#1	A1#3	6.25771e-17
C44	VPWR#1	A2#1	1.149e-17
C45	A2#6	A2#2	4.98146e-18
C46	Y#1	A1#3	1.35216e-17
C47	VGND#3	B1#5	3.68786e-19
C48	B1#3	A2#3	2.7175e-17
C49	VPWR#1	B1#1	3.02065e-19
C50	VPWR#5	A1#3	7.39631e-19
C51	A2#4	A2#2	1.6243e-17
C52	VGND#3	B1#4	1.42558e-18
C53	Y#1	A2#1	7.51617e-17
C54	VPWR#1	C1#1	1.56304e-19
C55	VPWR#5	A2#1	2.61023e-18
C56	C1#3	B1#3	2.46076e-17
C57	Y#1	B1#1	6.54611e-17
C58	A2#4	B1#2	4.59578e-18
C59	B1#1	VPWR#5	3.47787e-17
C60	B1#5	A2#2	2.90233e-18
C61	Y#1	C1#1	5.20212e-19
C62	D1#1	C1#3	4.77567e-17
C63	VGND#3	a_368_74##2	1.39258e-17
C64	C1#1	VPWR#5	3.6446e-17
C65	VPWR#6	B1#1	2.76125e-19
C66	B1#5	B1#2	1.2576e-17
C67	C1#1	Y#4	2.37392e-17
C68	B1#4	B1#2	5.07975e-18
C69	VPWR#5	D1#3	1.17855e-18
C70	VPWR#2	VPWR#1	3.91612e-17
C71	VPWR#6	C1#1	1.39656e-18
C72	D1#3	Y#4	2.44129e-17
C73	VGND#3	Y#3	3.99803e-17
C74	A2#2	VGND#4	1.88053e-18
C75	C1#2	B1#4	1.88532e-17
C76	a_368_74##2	A2#2	2.40023e-18
C77	D1#3	VPWR#6	2.94165e-17
C78	Y#1	VPWR#2	1.76704e-17
C79	B1#2	a_368_74##2	3.33249e-18
C80	VPWR#1	A2#2	3.71619e-19
C81	A2#1	A1#3	5.61591e-17
C82	Y#3	B1#2	1.54829e-19
C83	Y#1	A2#2	1.89522e-18
C84	Y#3	C1#2	2.59808e-19
C85	B1#1	A2#1	4.35124e-17
C86	Y#1	B1#2	2.2178e-18
C87	VPWR	A1#2	7.96482e-19
C88	VGND#3	B1#3	7.54315e-18
C89	VPWR#5	B1#2	8.12062e-19
C90	D1#2	Y#3	1.39955e-17
C91	VGND#3	C1#3	6.10598e-18
C92	C1#1	B1#1	2.33657e-17
C93	VGND#3	D1#1	7.55507e-18
C94	D1#3	C1#1	4.77947e-17
C95	VPWR#2	A2#1	7.91063e-18
C96	A2#6	A1	3.20284e-17
C97	VPWR#2	B1#1	9.94729e-19
C98	VPWR#6	D1#2	8.82593e-19
C99	VPWR#2	C1#1	3.4833e-18
C100	VGND	A1#2	7.30575e-19
C101	a_368_74#	A1	2.81452e-17
C102	VPWR#2	A2#2	5.14916e-20
C103	A1	VPWR#1	2.17534e-17
C104	A1#3	a_490_368#	3.13092e-17
C105	B1#3	a_260_74#	2.03405e-18
C106	A2#1	a_490_368#	3.05213e-17
C107	VGND#3	B1#2	1.30731e-19
C108	C1#3	a_260_74#	1.81161e-17
C109	VGND#3	C1#2	5.3307e-19
C110	C1#3	a_182_74#	1.28198e-17
C111	B1#2	A2#2	3.58059e-17
C112	VGND#3	D1#2	1.58794e-19
C113	D1#1	a_182_74#	1.68915e-18
C114	C1	B1#4	2.52104e-17
C115	C1#2	B1#2	2.55712e-17
C116	Y#3	D1	4.3645e-17
C117	C1	a_368_74#	2.21583e-20
C118	C1	a_368_74##2	2.648e-17
C119	D1#2	C1#2	3.86978e-17
C120	B1#4	Y	1.21538e-17
C121	A1#2	VNB	6.21753e-17
C122	Y#3	C1	3.61921e-17
C123	VPWR	A2#6	4.24334e-18
C124	VPWR	A2#4	2.82781e-18
C125	VPWR	B1#5	1.1998e-18
C126	Y#3	Y	6.66514e-18
C127	VPWR	B1#4	9.85737e-19
C128	C1	A1#4	6.51606e-19
C129	C1	A2#3	1.05548e-18
C130	A2#6	A1#2	1.27891e-17
C131	Y	Y#1	2.68218e-18
C132	C1#2	a_260_74#	3.2174e-19
C133	C1	B1#3	9.43355e-18
C134	VGND	A2#6	2.42129e-18
C135	Y	VPWR#5	1.02041e-16
C136	C1	C1#3	2.50412e-17
C137	Y	Y#4	8.94437e-19
C138	VGND	A2#4	2.26203e-18
C139	C1	D1#1	9.8299e-18
C140	Y	VPWR#6	1.22504e-16
C141	VPWR	VPWR#1	4.78676e-17
C142	VGND	B1#5	2.38914e-18
C143	VGND	B1#4	3.76128e-18
C144	VPWR	Y#1	1.76507e-17
C145	VPWR	VPWR#5	2.11042e-17
C146	VGND	a_368_74#	1.78379e-17
C147	VGND	VGND#4	2.21947e-17
C148	VGND	a_368_74##2	1.79142e-17
C149	VPWR	VPWR#6	2.21363e-17
C150	VGND#3	D1	1.08315e-18
C151	VGND	Y#3	2.77103e-17
C152	Y	A2#1	2.11256e-19
C153	VGND	VPWR#1	3.5578e-18
C154	Y	B1#1	2.53535e-18
C155	VGND	Y#1	4.09967e-18
C156	Y	C1#1	5.56029e-17
C157	VGND#3	C1	1.22234e-17
C158	Y	D1#3	5.33849e-17
C159	VPWR	A1#3	4.23984e-18
C160	D1	C1#2	1.69649e-17
C161	VGND	A1#4	6.33466e-19
C162	VPWR	A2#1	2.08875e-18
C163	Y	VPWR#2	1.04654e-17
C164	VGND	A2#3	6.38494e-19
C165	D1	D1#2	1.86691e-17
C166	VPWR	B1#1	5.51789e-19
C167	C1	B1#2	1.57613e-18
C168	VGND	B1#3	1.62085e-18
C169	VGND#3	Y	1.43001e-18
C170	VPWR	C1#1	6.16039e-20
C171	VGND	C1#3	1.0218e-18
C172	C1	C1#2	7.23849e-18
C173	VPWR	D1#3	2.51003e-19
C174	VGND	D1#1	2.62859e-18
C175	C1	D1#2	1.71131e-18
C176	VPWR	VPWR#2	3.30707e-17
C177	A2#6	VNB	2.60805e-18
C178	A2#4	VNB	8.12785e-19
C179	C1#2	Y	5.15432e-17
C180	B1#5	VNB	7.60845e-19
C181	Y	D1#2	2.51801e-18
C182	B1#4	VNB	2.23924e-18
C183	VPWR	A2#2	8.50171e-19
C184	a_368_74#	VNB	3.46887e-17
C185	VGND#4	VNB	3.26872e-18
C186	C1	a_260_74#	4.22998e-20
C187	a_368_74##2	VNB	2.68805e-18
C188	VPWR	C1#2	2.57084e-18
C189	VGND	VGND#3	5.69932e-17
C190	Y#3	VNB	6.45976e-17
C191	VPWR#1	VNB	9.24822e-17
C192	VGND	A2#2	1.88178e-19
C193	Y#1	VNB	7.43161e-18
C194	VPWR#5	VNB	3.95347e-18
C195	VGND	B1#2	3.29866e-19
C196	VPWR#6	VNB	4.42447e-17
C197	VGND	C1#2	1.15925e-18
C198	A1#4	VNB	3.14061e-17
C199	A2#3	VNB	2.27703e-17
C200	VGND	D1#2	3.32079e-19
C201	B1#3	VNB	2.82779e-17
C202	C1#3	VNB	2.59275e-17
C203	D1#1	VNB	3.4041e-17
C204	A1#3	VNB	3.07303e-17
C205	A2#1	VNB	3.13623e-17
C206	D1	C1	2.40618e-17
C207	VPWR	A1	2.05074e-18
C208	B1#1	VNB	3.31664e-17
C209	C1#1	VNB	3.75866e-17
C210	D1#3	VNB	4.35955e-17
C211	D1	Y	3.62602e-17
C212	VPWR#2	VNB	1.95071e-16
C213	VGND#3	VNB	2.31816e-16
C214	VGND	A1	4.06985e-18
C215	A2#2	VNB	2.99971e-17
C216	VPWR	D1	1.92839e-18
C217	B1#2	VNB	3.1488e-17
C218	C1#2	VNB	3.11183e-17
C219	D1#2	VNB	3.87667e-17
C220	VGND	D1	4.45414e-18
C221	VPWR	Y	2.81323e-17
C222	VGND	C1	1.53735e-17
C223	VGND	Y	9.2129e-18
C224	A1	VNB	2.07849e-17
C225	D1	VNB	8.24171e-18
C226	C1	VNB	1.4171e-18
C227	Y	VNB	3.68535e-17
C228	VPWR	VNB	6.80887e-17
C229	VGND	VNB	7.13355e-17
C230	VGND#3	VGND#2	5.72296e-17
C231	VPWR#3	VNB	4.58192e-17
C232	VGND#2	a_368_74##2	6.71852e-18
C233	VGND#2	VNB	5.05709e-17
C234	VPWR	VPWR#3	3.1611e-17
C235	Y	VPWR#3	1.29243e-17
C236	VGND#2	A1#2	4.95372e-19
C237	VGND#2	a_368_74#	2.06561e-17
C238	VGND#2	A1	7.82199e-19
C239	VGND	VGND#2	3.2411e-17
C240	VPWR#2	VPWR#3	4.83727e-17
C241	VGND#2	A2#3	9.45063e-19
C242	VPWR#3	D1#3	2.59958e-18
C243	VGND#2	A1#4	2.73034e-18
*
*
.ENDS sky130_fd_sc_hs__o2111ai_1
*
