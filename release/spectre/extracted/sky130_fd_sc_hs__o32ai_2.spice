* Extracted by Quantus, converted by sky130cad/quantus.py
*
*
*
*                       LINUX           Wed Nov 18 09:03:23 2026
*
*
*
*  PROGRAM  advgen
*
*  Name           : advgen - Quantus - (64-bit)
*  Version        : 25.1.0-p047
*  Build Date     : Thu Dec 11 23:20:30 PST 2025
*
*  HSPICE LIBRARY
*
*  OPERATING_TEMPERATURE 150
*  QRC_TECH_DIR <path>/tech
*
*
*

*
.SUBCKT sky130_fd_sc_hs__o32ai_2 VNB VPB VGND VPWR Y B2 B1 A3 A2 A1
*
*
*  caps2d version: 10
*
*
*       TRANSISTOR CARDS
*
*
XM6 Y#3 B2#4 a_27_74##9 VNB sky130_fd_pr__nfet_01v8_lvt l=0.15 w=0.74 ad=0.2072 as=0.2109 pd=2.04 ps=2.05
XM19 a_27_74##10 B2#5 Y#3 VNB sky130_fd_pr__nfet_01v8_lvt l=0.15 w=0.74 ad=0.259 as=0.2072 pd=2.18 ps=2.04
XM1 a_27_74##10 B1#7 Y#1 VNB sky130_fd_pr__nfet_01v8_lvt l=0.15 w=0.74 ad=0.259 as=0.259 pd=2.18 ps=2.18
XM16 Y#1 B1#1 a_27_74##5 VNB sky130_fd_pr__nfet_01v8_lvt l=0.15 w=0.74 ad=0.259 as=0.259 pd=2.18 ps=2.18
XM3 VGND#9 A3#7 a_27_74##5 VNB sky130_fd_pr__nfet_01v8_lvt l=0.15 w=0.74 ad=0.5986 as=0.259 pd=3.2 ps=2.18
XM11 a_27_74##3 A3#5 VGND#9 VNB sky130_fd_pr__nfet_01v8_lvt l=0.15 w=0.74 ad=0.2553 as=0.5986 pd=2.17 ps=3.2
XM8 VGND#7 A2#5 a_27_74##3 VNB sky130_fd_pr__nfet_01v8_lvt l=0.15 w=0.74 ad=0.2442 as=0.2553 pd=2.14 ps=2.17
XM2 a_27_74##7 A2#1 VGND#7 VNB sky130_fd_pr__nfet_01v8_lvt l=0.15 w=0.74 ad=0.2257 as=0.2442 pd=2.09 ps=2.14
XM13 VGND#5 A1#5 a_27_74##7 VNB sky130_fd_pr__nfet_01v8_lvt l=0.15 w=0.74 ad=0.6734 as=0.2257 pd=3.3 ps=2.09
XM18 a_27_74# A1#1 VGND#5 VNB sky130_fd_pr__nfet_01v8_lvt l=0.15 w=0.74 ad=0.2109 as=0.6734 pd=2.05 ps=3.3
XM0 a_27_368##4 B2#6 Y#4 VPB sky130_fd_pr__pfet_01v8 l=0.15 w=1.12 ad=0.3304 as=0.336 pd=2.83 ps=2.84
XM12 Y#4 B2#1 a_27_368##2 VPB sky130_fd_pr__pfet_01v8 l=0.15 w=1.12 ad=0.336 as=0.336 pd=2.84 ps=2.84
XM14 VPWR#7 B1#5 a_27_368##2 VPB sky130_fd_pr__pfet_01v8 l=0.15 w=1.12 ad=0.336 as=0.336 pd=2.84 ps=2.84
XM4 a_27_368# B1#6 VPWR#7 VPB sky130_fd_pr__pfet_01v8 l=0.15 w=1.12 ad=0.3304 as=0.336 pd=2.83 ps=2.84
XM7 Y#5 A3#6 a_499_368##3 VPB sky130_fd_pr__pfet_01v8 l=0.15 w=1.12 ad=0.336 as=0.3304 pd=2.84 ps=2.83
XM15 a_499_368##4 A3#1 Y#5 VPB sky130_fd_pr__pfet_01v8 l=0.15 w=1.12 ad=0.336 as=0.336 pd=2.84 ps=2.84
XM17 a_499_368##4 A2#6 a_768_368##2 VPB sky130_fd_pr__pfet_01v8 l=0.15 w=1.12 ad=0.336 as=0.336 pd=2.84 ps=2.84
XM9 a_768_368##2 A2#4 a_499_368# VPB sky130_fd_pr__pfet_01v8 l=0.15 w=1.12 ad=0.336 as=0.3304 pd=2.84 ps=2.83
XM10 a_768_368# A1#6 VPWR#6 VPB sky130_fd_pr__pfet_01v8 l=0.15 w=1.12 ad=0.3416 as=0.3864 pd=2.85 ps=2.93
XM5 VPWR#1 A1#4 a_768_368# VPB sky130_fd_pr__pfet_01v8 l=0.15 w=1.12 ad=0.3304 as=0.3416 pd=2.83 ps=2.85
*
*
*       RESISTOR AND CAP/DIODE CARDS
*
Rg1	B2#1	B2#2	451.075073
Rg2	B2#2	B2#3	33.943779
Rg3	B2#3	B2#4	367.856995
Rg4	B2#2	B2#5	400.506866
Rg5	B2#3	B2#6	419.956482
Rg6	B1#1	B1#2	409.214935
Rg7	B1#2	B1#3	38.477005
Rg8	B1#3	B1#4	30.613651
Rg9	B1#4	B1#5	450.212830
Rg10	B1#2	B1#6	452.207367
Rg11	B1#4	B1#7	398.323700
Rg12	A3#1	A3#2	515.572815
Rg13	A3#2	A3#3	67.132561
Rg14	A3#3	A3#4	65.082108
Rg15	A3#2	A3#5	475.782410
Rg16	A3#3	A3#6	419.554810
Rg17	A3#4	A3#7	409.393127
Rg18	A2#1	A2#2	397.555725
Rg19	A2#2	A2#3	56.190357
Rg20	A2#2	A2#4	449.655212
Rg21	A2#3	A2#5	402.789612
Rg22	A2#3	A2#6	451.603058
Rg23	A1#1	A1#2	397.555725
Rg24	A1#2	A1#3	95.087555
Rg25	A1#2	A1#4	449.655212
Rg26	A1#3	A1#5	464.249420
Rg27	A1#3	A1#6	429.126801
Rf1	B2	B2#7	1.680815
Rf2	B2#7	B2	12.988117
Rf3	B1#3	B1	166.137894
Rf4	a_27_368#	a_27_368##3	90.728546
Rf5	a_27_368##3	a_27_368##4	116.349121
Rf6	a_27_368##2	a_27_368##3	7.500000
Rf7	A3#8	A3	1.409262
Rf8	A3#4	A3#10	161.642059
Rf9	A3#8	A3#10	10.848897
Rf10	A3#11	A3	1.409262
Rf11	A3#10	A3#11	3.820034
Rf12	Y#1	Y#2	24.270992
Rf13	Y#2	Y#3	94.082047
Rf14	Y#2	Y	152.912231
Rf15	Y	Y#4	181.481888
Rf16	Y	Y#6	9.718944
Rf17	Y#6	Y	5.019327
Rf18	Y#5	Y#6	7.500000
Rf19	A2#7	A2	1.409262
Rf20	A2#3	A2#9	161.642059
Rf21	A2#7	A2#9	7.334466
Rf22	A2#10	A2	1.409262
Rf23	A2#9	A2#10	7.334466
Rf24	a_499_368#	a_499_368##2	80.336922
Rf25	a_499_368##2	a_499_368##3	89.080147
Rf26	a_499_368##2	a_499_368##4	38.224628
Rf27	a_768_368#	a_768_368##2	144.354691
Rf28	A1	A1#7	12.376911
Rf29	A1#7	A1	2.292021
Rf30	a_27_74#	a_27_74##2	123.314133
Rf31	a_27_74##2	a_27_74##4	80.662697
Rf32	a_27_74##4	a_27_74##6	85.795570
Rf33	a_27_74##2	a_27_74##7	18.149860
Rf34	a_27_74##6	a_27_74##8	76.082664
Rf35	a_27_74##8	a_27_74##9	93.451416
Rf36	a_27_74##8	a_27_74##10	24.272007
Rf37	a_27_74##3	a_27_74##4	7.500000
Rf38	a_27_74##5	a_27_74##6	15.000000
Rf39	VPWR#1	VPWR#2	116.276939
Rf40	VPWR#2	VPWR#3	137.310394
Rf41	VPWR#3	VPWR#4	111.800072
Rf43	VPWR#2	VPWR#6	31.534731
Rf44	VPWR#4	VPWR#7	37.538910
Rf46	VGND#2	VGND#3	91.109810
Rf47	VGND#3	VGND#4	62.068390
Rf48	VGND#2	VGND#6	9.066329
Rf49	VGND#6	VGND#5	15.000000
Rf50	VGND#3	VGND#7	36.672695
Rf52	VGND#4	VGND#9	22.854990
Rf53	VGND#5	VGND#6	15.000000
Rf54	B2#3	B2#7	80.116402
Rf58	A1#3	A1#7	53.410934
Re1	VPWR#3	VPWR	0.755546
Re2	VGND	VGND#4	0.755573
*
*       CAPACITOR CARDS
*
*
C1	a_27_74##5	a_27_74##3	1.88158e-18
C2	VGND#3	A2#1	3.45582e-18
C3	a_27_74##5	VGND#9	1.03485e-16
C4	Y#2	Y#5	3.25113e-18
C5	VPWR#3	A3#3	1.13558e-20
C6	a_27_74#	VPWR#1	1.63553e-19
C7	VGND#3	A2#5	4.58405e-18
C8	Y#4	B1#4	2.4064e-18
C9	VPWR#3	A3#2	1.09861e-20
C10	VGND#3	a_27_74##2	2.25448e-19
C11	a_27_74#	A1#2	1.56383e-18
C12	a_27_74##5	Y#1	2.20794e-19
C13	VGND#3	A3#5	7.85959e-19
C14	VGND#3	A3#7	7.13312e-20
C15	a_27_74##2	A1#5	2.30538e-17
C16	A1#3	A1#2	8.60438e-19
C17	A2#2	A1#3	1.71979e-17
C18	Y#3	a_27_74##10	2.97055e-19
C19	a_27_74##2	A2#1	2.34908e-17
C20	A1#5	A1#2	1.48055e-18
C21	Y#2	Y#4	4.24007e-18
C22	A2#2	A1#5	5.46804e-18
C23	VPWR#2	A1#2	2.08806e-20
C24	a_27_74##9	Y#3	5.89551e-17
C25	a_27_74##8	A3#7	2.31325e-19
C26	A2#3	A2#2	3.61196e-18
C27	A3#2	A2#3	2.39083e-17
C28	VPWR#2	A2#2	2.04405e-21
C29	a_27_74##3	a_499_368##4	1.65719e-18
C30	a_27_74##8	B1#1	1.01101e-18
C31	a_27_74##3	Y#5	5.23654e-17
C32	VGND#7	A2#2	2.23027e-19
C33	a_27_74##8	B1#7	3.11197e-17
C34	Y#5	VGND#9	1.31428e-18
C35	a_768_368#	VPWR#1	7.74859e-17
C36	A3#4	A3#2	6.81106e-19
C37	a_27_74##5	Y#5	4.66457e-18
C38	B1#4	A3#4	1.89566e-17
C39	a_27_74##8	B2#5	2.19114e-17
C40	VPWR#6	VPWR#1	1.45506e-18
C41	a_768_368#	VPWR#6	1.0017e-16
C42	a_27_74##8	B2#4	1.08622e-18
C43	Y#2	A3#5	5.96879e-20
C44	a_27_74##3	A3#3	7.84447e-19
C45	a_27_74#	A1#1	5.46279e-17
C46	Y#2	A3#7	1.73587e-17
C47	a_499_368#	VPWR#6	5.68246e-17
C48	a_768_368##2	a_768_368#	1.24932e-18
C49	VPWR#2	A1#4	2.18981e-18
C50	A1#1	VGND#5	1.46881e-17
C51	a_27_74##3	A3#2	1.34656e-20
C52	a_27_74#	A1#5	1.0603e-18
C53	a_27_74##7	A1#1	1.09228e-18
C54	Y#2	B1#1	3.25253e-17
C55	A1#5	VGND#5	1.85416e-17
C56	VPWR#2	A1#6	2.57874e-18
C57	VGND#7	A1#1	9.56699e-20
C58	a_499_368#	a_768_368##2	8.85568e-17
C59	a_27_74##7	A1#5	4.00764e-17
C60	VGND#9	A3#3	1.36582e-18
C61	Y#2	B1#7	2.74144e-17
C62	B2#3	B1#4	2.19729e-17
C63	a_499_368##4	a_499_368#	4.14108e-18
C64	VGND#7	A1#5	1.25381e-18
C65	A2#1	a_27_74##7	3.09343e-17
C66	VPWR#2	A2#4	4.4526e-18
C67	VGND#9	A3#2	1.34563e-19
C68	a_499_368##4	a_768_368##2	5.79632e-17
C69	a_27_74##3	A1#5	3.97376e-19
C70	Y#2	B2#5	8.48046e-19
C71	a_27_74##8	B1#4	3.49578e-19
C72	A2#1	VGND#7	1.71005e-17
C73	a_27_74##7	A2#5	2.02239e-18
C74	VGND#9	B1#4	4.6389e-20
C75	a_27_74##3	A2#1	1.03763e-18
C76	VGND#7	A2#5	3.15677e-17
C77	a_27_74##5	A3#3	3.90604e-19
C78	Y#5	a_499_368##4	6.11636e-17
C79	a_27_74##7	A3#5	4.07553e-19
C80	a_27_74##3	A2#5	2.84197e-17
C81	a_27_74##9	a_27_368##4	3.05711e-19
C82	VGND#7	A3#5	1.29334e-18
C83	a_499_368##3	a_499_368##4	3.51463e-18
C84	VGND#9	A2#5	9.91506e-19
C85	a_27_74##8	Y#2	5.55352e-17
C86	a_27_74##3	A3#5	6.96436e-17
C87	Y#5	a_499_368##3	8.07468e-17
C88	VGND#7	A3#7	1.06623e-19
C89	a_27_74##5	B1#4	1.20858e-19
C90	A3#5	VGND#9	2.97902e-17
C91	a_27_74##3	A3#7	1.01722e-18
C92	Y#5	a_27_368#	3.90383e-17
C93	a_27_74##5	A3#5	9.46971e-19
C94	a_27_74##2	A2#2	6.7474e-19
C95	a_499_368##2	A2#6	1.83577e-17
C96	A3#7	VGND#9	3.2214e-17
C97	a_27_368#	a_499_368##3	5.13255e-17
C98	a_27_74##3	B1#1	5.25216e-20
C99	a_27_74##5	A3#7	5.09191e-17
C100	VPWR#7	a_499_368##3	2.59788e-18
C101	VGND#9	B1#1	4.91147e-18
C102	a_499_368##2	A3#1	1.7125e-17
C103	a_27_74##5	B1#1	2.9668e-17
C104	a_27_368#	VPWR#7	4.69275e-17
C105	VGND#9	B1#7	4.6031e-18
C106	B1#1	Y#1	1.65618e-17
C107	a_27_368##2	a_27_368#	2.52173e-18
C108	a_27_74##5	B1#7	4.87141e-19
C109	VGND#9	B2#5	6.96023e-20
C110	B1#7	Y#1	7.87229e-18
C111	a_27_368##2	VPWR#7	4.14838e-17
C112	Y#4	a_27_368#	2.65005e-17
C113	Y#3	B1#1	2.31325e-19
C114	B1#7	a_27_74##10	1.65618e-17
C115	Y#4	VPWR#7	1.26714e-18
C116	Y#5	A1#5	4.84956e-19
C117	Y#3	B1#7	1.01101e-18
C118	VGND#3	a_27_74##7	9.22e-18
C119	B2#5	a_27_74##10	7.87229e-18
C120	a_27_368##2	Y#4	8.30477e-17
C121	a_27_74##9	B1#7	2.17015e-19
C122	Y#5	A2#1	1.60745e-19
C123	Y#3	B2#5	4.50573e-17
C124	a_27_368##4	a_27_368##2	2.14025e-18
C125	Y#5	A2#5	3.08251e-19
C126	a_27_74##9	B2#5	9.79648e-19
C127	a_27_368##4	Y#4	8.3632e-17
C128	Y#3	B2#4	3.53828e-17
C129	a_499_368##2	A3#3	1.71689e-21
C130	Y#5	A3#5	4.64371e-18
C131	a_27_74##9	B2#4	3.55095e-17
C132	VGND#3	a_27_74##3	6.38805e-18
C133	VPWR#3	VPWR#2	6.69667e-17
C134	a_499_368##2	A3#2	7.70775e-20
C135	VGND#9	VGND#3	9.70379e-19
C136	A1#5	A1#1	3.47017e-18
C137	A1#4	VPWR#1	3.32891e-17
C138	a_768_368#	A1#4	5.57571e-17
C139	A1	A1#2	2.21068e-17
C140	A1	A2#2	8.47061e-18
C141	VPWR#1	A1#6	1.24697e-18
C142	a_499_368##2	VPWR#3	6.02758e-17
C143	VPWR#6	A1#4	1.44551e-18
C144	A2#1	A1#5	3.53071e-17
C145	VPWR#2	A1#3	3.16074e-19
C146	a_768_368#	A1#6	6.99127e-17
C147	VPWR#1	A2#4	1.19801e-19
C148	A1#6	VPWR#6	3.40883e-17
C149	A1#2	a_768_368#	1.49863e-18
C150	a_768_368#	A2#4	3.91107e-19
C151	a_499_368#	A1#6	1.30927e-18
C152	A2#5	A2#1	2.77462e-17
C153	VPWR#2	A2#3	4.46662e-21
C154	VPWR#6	A2#4	2.35096e-18
C155	a_27_74##2	A1#3	6.37704e-18
C156	a_768_368##2	A1#6	3.20281e-19
C157	a_768_368#	A2#6	1.15484e-19
C158	a_499_368#	A2#4	7.36037e-17
C159	A2	A2#2	8.55249e-18
C160	A2	A3#3	7.66243e-20
C161	VPWR#6	A2#6	1.87397e-19
C162	A2	A3#2	1.15084e-17
C163	a_768_368##2	A2#4	4.06026e-17
C164	A3#5	A2#5	2.81526e-17
C165	Y#5	A1#6	3.49367e-19
C166	a_499_368#	A2#6	1.74812e-18
C167	a_27_74##2	A2#3	8.56153e-18
C168	a_499_368##4	A2#4	1.04783e-18
C169	a_27_74##2	VGND#5	1.8692e-18
C170	VPWR#6	A3#1	6.80595e-20
C171	a_768_368##2	A2#6	4.48013e-17
C172	Y#5	A2#4	8.30705e-19
C173	A2#3	a_499_368##2	1.12602e-18
C174	a_499_368#	A3#1	3.46651e-19
C175	A2#6	a_499_368##4	2.32322e-17
C176	A3#7	A3#5	7.9847e-18
C177	VPWR#6	A3#6	4.15238e-20
C178	a_768_368##2	A3#1	1.49186e-18
C179	Y#5	A2#6	2.78847e-18
C180	a_27_74##2	a_27_74##7	6.36745e-19
C181	A3#1	a_499_368##4	2.86205e-17
C182	a_499_368##3	A2#6	3.00902e-19
C183	A3	A3#3	5.64358e-18
C184	Y#5	A3#1	5.89544e-17
C185	B1#1	A3#7	2.56573e-17
C186	A3	B1#4	1.11939e-17
C187	a_499_368##4	A3#6	1.10947e-18
C188	VGND#9	a_27_74##8	3.12479e-17
C189	a_499_368##3	A3#1	6.72697e-19
C190	a_27_74##2	VGND#7	2.09822e-17
C191	Y#5	A3#6	6.19132e-17
C192	a_27_74##8	B2#3	1.81069e-19
C193	a_499_368##4	B1#6	9.63945e-20
C194	B1#7	B1#1	2.51191e-17
C195	a_499_368##3	A3#6	4.46648e-17
C196	Y#2	A3#4	2.05758e-17
C197	Y#5	B1#6	1.20472e-17
C198	a_27_368#	A3#6	1.27019e-18
C199	a_27_74#	A1#3	3.2281e-18
C200	a_27_74##8	a_27_74##5	2.97845e-18
C201	a_499_368##3	B1#6	2.94222e-18
C202	a_499_368#	A2#2	1.5452e-20
C203	VPWR#7	A3#6	2.50207e-19
C204	A3#3	A3#2	8.87588e-19
C205	B2#5	B1#7	2.51072e-17
C206	Y#5	B1#5	4.14871e-19
C207	a_27_368#	B1#6	7.20191e-17
C208	a_499_368##3	B1#5	3.3688e-19
C209	B1	B1#4	1.92797e-17
C210	B1#6	VPWR#7	2.43186e-17
C211	Y#4	A3#6	2.72797e-19
C212	a_27_74##8	Y#1	1.02365e-18
C213	Y#5	B2#1	2.80335e-19
C214	a_27_368#	B1#5	1.24917e-18
C215	a_27_368##2	B1#6	3.70342e-19
C216	VPWR#3	VPWR#1	2.56862e-17
C217	B2#4	B2#5	3.83069e-17
C218	VPWR#7	B1#5	3.39644e-17
C219	VGND#7	A2#3	1.00828e-18
C220	Y#4	B1#6	8.71605e-18
C221	a_27_74##3	A2#3	1.38051e-17
C222	a_27_368#	B2#1	2.11095e-19
C223	a_27_368##2	B1#5	5.01307e-17
C224	VPWR#7	B2#1	8.08227e-19
C225	a_27_74##8	a_27_74##10	4.05128e-18
C226	Y#4	B1#5	2.18761e-17
C227	a_499_368#	VPWR#3	5.02918e-18
C228	A2#2	a_768_368##2	2.54717e-19
C229	a_27_368##2	B2#1	3.47221e-17
C230	a_27_368##4	B1#5	1.83236e-19
C231	B1#4	A3#3	1.20241e-19
C232	Y#4	B2#1	5.46984e-17
C233	VGND#9	A3#4	5.79094e-19
C234	B2	B1#4	9.75434e-18
C235	a_27_368##2	B2#6	7.58329e-19
C236	a_27_74##5	A3#4	5.1506e-19
C237	A1#3	a_768_368#	6.96921e-18
C238	Y#5	VPWR#3	7.61696e-19
C239	a_27_368##4	B2#1	7.95869e-19
C240	a_27_74##8	Y#3	4.9447e-17
C241	A1#3	VPWR#6	2.76064e-18
C242	Y#4	B2#6	4.55145e-17
C243	a_499_368##3	VPWR#3	4.55208e-17
C244	a_27_368##4	B2#6	4.33374e-17
C245	a_768_368##2	A1#3	4.79992e-18
C246	A1#6	A1#4	4.46157e-17
C247	VPWR#2	VPWR#1	8.72215e-19
C248	Y#2	A3#3	1.3781e-18
C249	a_499_368#	A2#3	1.13887e-19
C250	a_27_74##9	a_27_74##8	2.81165e-18
C251	Y#5	A1#3	2.90667e-20
C252	A2#3	a_768_368##2	2.20838e-17
C253	A2#4	A1#6	4.75e-18
C254	Y#5	A2#3	1.87532e-18
C255	a_768_368#	VPWR#2	1.74378e-17
C256	Y#3	B2#3	3.56275e-18
C257	a_27_74##9	B2#3	2.11416e-18
C258	A2#6	A2#4	4.41297e-17
C259	A1	VPWR#2	6.10584e-20
C260	A3#4	Y#5	2.97225e-17
C261	A3#4	a_499_368##3	2.3403e-18
C262	Y#2	B1#4	4.1743e-18
C263	a_27_74##2	A1	7.83425e-17
C264	A3#1	A2#6	4.77783e-17
C265	Y#2	a_27_74##3	3.57119e-19
C266	Y#5	A2#2	1.93551e-19
C267	Y#5	B2#3	6.04113e-20
C268	A3#6	A3#1	4.56908e-17
C269	a_499_368#	VPWR#2	4.34477e-17
C270	Y#5	A3#3	1.70208e-17
C271	a_27_74##2	A2	2.62053e-17
C272	A2	a_499_368##2	2.81933e-19
C273	Y#2	VGND#9	1.02353e-18
C274	a_27_368##2	B2#3	3.31932e-20
C275	B1#6	A3#6	5.53894e-18
C276	B2#3	Y#4	3.66038e-18
C277	Y#5	A3#2	6.02783e-18
C278	B2#3	a_27_368##4	2.10276e-18
C279	a_768_368##2	VPWR#2	8.92492e-19
C280	a_27_74#	A1	7.3232e-17
C281	B1#5	B1#6	4.68935e-17
C282	Y#2	a_27_74##5	9.9209e-17
C283	Y#5	B1#4	5.45635e-19
C284	VPWR#3	A2#6	4.46413e-18
C285	B2#1	B1#5	4.70296e-17
C286	Y#2	A3	4.75311e-17
C287	VPWR#3	A3#1	4.464e-18
C288	A3#3	a_499_368##3	9.08705e-20
C289	Y#2	Y#1	2.15172e-18
C290	VPWR#3	A3#6	4.4526e-18
C291	a_27_74##3	A2	2.2891e-17
C292	B2#6	B2#1	4.59547e-17
C293	A1	VPWR#1	3.39425e-17
C294	A1	a_768_368#	8.86515e-17
C295	A2#3	A2#6	4.26001e-18
C296	Y#2	B1	4.35747e-17
C297	A1	a_768_368##2	3.13897e-17
C298	a_27_74#	VGND#5	1.22665e-18
C299	A2	a_768_368##2	2.70252e-17
C300	Y#2	B2	1.94773e-17
C301	A2	a_499_368##4	2.17498e-17
C302	a_27_74##7	a_27_74#	2.18168e-18
C303	Y#3	Y#2	2.97845e-18
C304	Y#5	A2	1.99757e-17
C305	a_27_74##2	a_768_368##2	5.91166e-18
C306	A3	Y#5	8.86968e-17
C307	VPWR#3	A2#3	1.57467e-20
C308	VPWR	VPWR#2	3.79986e-17
C309	VPWR#3	A3#4	1.68914e-19
C310	Y#3	B2	6.13375e-17
C311	VPWR	a_499_368##2	2.53161e-17
C312	a_27_74##9	B2	2.13927e-17
C313	a_27_368#	B1#4	4.95196e-19
C314	a_499_368##2	a_768_368##2	1.14267e-17
C315	VGND	VGND#3	4.18933e-17
C316	B1	Y#4	4.13472e-17
C317	A1	A1#4	5.53105e-18
C318	A1	A1#6	2.0906e-18
C319	A1#2	VNB	4.17229e-17
C320	VGND	a_27_74##8	2.7875e-17
C321	A1	A2#4	1.18467e-18
C322	A2#2	VNB	2.19491e-17
C323	A3#3	VNB	2.10088e-17
C324	A3#2	VNB	2.33975e-17
C325	B1#4	VNB	5.37406e-17
C326	VGND	a_27_74##2	5.01019e-18
C327	A2	A1#6	1.01399e-19
C328	B2	Y#4	8.00784e-17
C329	VGND#7	a_27_74##7	4.18392e-17
C330	B2	a_27_368##4	3.29479e-17
C331	A2	A2#4	1.83665e-18
C332	A2	A2#6	1.09702e-18
C333	VGND	Y#2	1.36226e-17
C334	A2	A3#1	1.47581e-18
C335	a_499_368##2	a_499_368##4	5.47123e-20
C336	VPWR	VPWR#1	3.73212e-17
C337	A2	A3#6	3.18596e-19
C338	VPWR	a_768_368#	1.85831e-17
C339	VPWR	VPWR#6	2.17216e-17
C340	VGND	a_27_74#	1.83398e-17
C341	VPWR	a_499_368#	2.2608e-17
C342	VPWR	a_768_368##2	1.04358e-17
C343	VGND	a_27_74##7	1.63694e-17
C344	A3	A3#6	1.72546e-18
C345	VGND	a_27_74##3	2.0926e-17
C346	VPWR	Y#5	1.55726e-17
C347	VGND	VGND#9	6.71741e-17
C348	a_27_74##3	a_27_74##7	4.14826e-18
C349	VPWR	a_499_368##3	2.10444e-17
C350	VGND	a_27_74##5	2.57503e-17
C351	A3	B1#6	1.59194e-18
C352	VPWR	a_27_368#	1.75291e-17
C353	VGND	Y#3	8.30997e-18
C354	VPWR	a_27_368##2	1.73186e-17
C355	VGND	a_27_74##9	2.05565e-17
C356	VPWR	Y#4	1.17024e-17
C357	A1	A1#3	3.75551e-17
C358	VPWR	a_27_368##4	2.37253e-17
C359	B1#4	VPWR#7	1.37611e-18
C360	B1	B1#6	1.60479e-18
C361	a_499_368##2	Y#5	1.52075e-17
C362	B1	B1#5	9.63367e-20
C363	A2	A1#3	4.20057e-18
C364	VGND	Y#5	4.03386e-18
C365	B1	B2#1	1.22859e-19
C366	A2	A2#3	8.93244e-18
C367	a_27_74##3	VGND#7	4.77008e-17
C368	VGND#3	VNB	2.94625e-17
C369	B2	B1#5	1.20549e-18
C370	B2	B2#1	2.02437e-18
C371	VPWR#2	VNB	5.25925e-17
C372	VGND	A1#1	8.27671e-19
C373	a_27_74##8	VNB	5.44288e-18
C374	VGND#3	A1#1	5.76251e-20
C375	B2	B2#6	6.691e-18
C376	VGND	A2#1	2.7079e-19
C377	A3	A3#4	5.17646e-18
C378	a_27_74##2	VNB	5.41511e-18
C379	VPWR	A1#4	2.52258e-18
C380	VGND	A2#5	4.77349e-19
C381	a_499_368##2	VNB	4.29988e-18
C382	VPWR	A1#6	1.42725e-19
C383	VGND	A3#5	1.28299e-19
C384	VGND	A3#7	4.63604e-19
C385	VPWR	A2#4	1.95051e-18
C386	VGND	B1#1	2.09393e-18
C387	VPWR	A2#6	1.60084e-18
C388	Y#2	VNB	3.93611e-18
C389	VGND	B1#7	1.51957e-18
C390	B1	A3#4	1.134e-18
C391	VPWR	A3#1	1.67331e-18
C392	VGND	B2#5	1.68843e-18
C393	VPWR	A3#6	1.49769e-18
C394	VGND	B2#4	2.46984e-18
C395	VPWR	B1#6	4.10996e-19
C396	a_27_74#	VNB	4.4268e-17
C397	B1	B2#3	1.15461e-18
C398	VPWR	B1#5	1.07453e-18
C399	a_27_74##7	VNB	2.98369e-18
C400	VGND#7	VNB	4.74672e-19
C401	a_27_74##3	VNB	4.07931e-18
C402	VPWR	B2#1	1.4918e-18
C403	VGND#9	VNB	7.17653e-17
C404	a_27_74##5	VNB	3.13629e-18
C405	VPWR	B2#6	2.34467e-18
C406	VGND#9	VGND#7	1.9321e-18
C407	Y#3	VNB	4.80205e-18
C408	B2	B2#3	4.66398e-17
C409	a_27_74##9	VNB	4.62799e-17
C410	VPWR#1	VNB	7.4447e-17
C411	VPWR	VPWR#3	3.13637e-17
C412	a_768_368#	VNB	3.82022e-18
C413	VPWR#6	VNB	9.75495e-18
C414	a_499_368#	VNB	1.28796e-17
C415	A2	A1	3.06614e-17
C416	a_768_368##2	VNB	2.03959e-18
C417	Y#5	VNB	8.97494e-18
C418	a_499_368##3	VNB	1.03136e-17
C419	a_27_368#	VNB	9.76074e-18
C420	VPWR	A2#3	1.67677e-18
C421	VPWR#7	VNB	3.91088e-19
C422	a_27_368##2	VNB	2.46244e-18
C423	VPWR	A3#4	1.31525e-18
C424	a_27_368##4	VNB	5.35914e-17
C425	A1#1	VNB	3.32138e-17
C426	A1#5	VNB	3.77602e-17
C427	A2#1	VNB	2.46351e-17
C428	A2#5	VNB	2.49851e-17
C429	A3#5	VNB	2.97555e-17
C430	VGND#3	A1#5	7.45814e-19
C431	A3#7	VNB	2.84538e-17
C432	VGND	A2#3	1.30684e-18
C433	B1#1	VNB	2.99445e-17
C434	B1#7	VNB	2.99079e-17
C435	VGND	A3#4	1.1521e-18
C436	B2#5	VNB	2.92694e-17
C437	B2#4	VNB	3.76844e-17
C438	B1	A3	2.93177e-17
C439	A1#4	VNB	4.04263e-17
C440	A1#6	VNB	3.15136e-17
C441	A2#4	VNB	3.68214e-17
C442	A2#6	VNB	3.18419e-17
C443	a_27_74##3	VGND#9	5.82134e-17
C444	A3#1	VNB	3.47016e-17
C445	A3#6	VNB	3.49015e-17
C446	a_27_368##2	B1#4	1.73408e-19
C447	B1#6	VNB	3.26624e-17
C448	B2	B1	3.89297e-17
C449	VPWR	A1	1.03885e-17
C450	B1#5	VNB	2.87826e-17
C451	B2#1	VNB	3.21783e-17
C452	B2#6	VNB	4.19643e-17
C453	VPWR	A2	3.01941e-18
C454	VPWR#3	VNB	3.00758e-16
C455	VPWR	A3	3.50907e-18
C456	VGND	A1	1.01423e-17
C457	A1#3	VNB	7.26588e-17
C458	A2#3	VNB	3.40029e-17
C459	VGND	A2	3.46879e-18
C460	VPWR	B1	2.55966e-18
C461	A3#4	VNB	3.61606e-17
C462	VGND	A3	3.62703e-18
C463	VPWR	B2	7.32077e-18
C464	B2#3	VNB	7.04606e-17
C465	VGND	B1	2.65026e-18
C466	VGND	B2	7.52616e-18
C467	A1	VNB	4.5176e-17
C468	A2	VNB	3.59687e-18
C469	A3	VNB	9.07974e-18
C470	B1	VNB	5.8612e-18
C471	B2	VNB	3.33545e-17
C472	VPWR	VNB	8.27934e-17
C473	VGND	VNB	7.28097e-17
C474	VGND#4	B2#5	4.43427e-18
C475	a_27_368##2	VPWR#4	3.56491e-17
C476	VGND#4	VGND#9	9.14893e-17
C477	VGND#2	VNB	7.14592e-17
C478	VGND#4	a_27_74##9	4.85813e-17
C479	VGND#4	B2#3	6.09812e-20
C480	VGND#2	A1#2	5.87811e-19
C481	a_27_368##4	VPWR#4	5.71e-17
C482	VGND	VGND#2	9.62406e-17
C483	VGND#4	VNB	2.99e-16
C484	VGND#2	a_27_74##7	5.27015e-17
C485	VPWR#4	A2#6	4.71085e-20
C486	VGND#2	A2#1	1.13712e-18
C487	VPWR	VPWR#4	7.04152e-17
C488	VGND#2	a_27_74#	9.36235e-17
C489	VGND#2	A1#1	2.02356e-17
C490	VPWR#4	A3#6	3.64867e-19
C491	VGND#4	a_27_74##8	4.0986e-17
C492	VGND#3	VGND#2	1.41862e-18
C493	VGND#2	A1#3	3.68287e-18
C494	VGND	VGND#4	2.79538e-17
C495	VPWR#4	B1#5	4.68185e-18
C496	VGND#4	B2#4	4.43427e-18
C497	VPWR#4	a_499_368##3	8.23901e-19
C498	VGND#4	VGND#3	3.78758e-17
C499	VPWR#4	B2#6	4.77598e-18
C500	VPWR#3	VPWR#4	9.89122e-17
C501	VGND#7	VGND#2	2.00544e-18
C502	VGND#2	A2#5	3.31873e-19
C503	VPWR#4	A3#4	1.27717e-19
C504	VGND#2	VGND#5	2.21206e-17
C505	VGND#2	A1#5	1.75287e-17
C506	VPWR#4	A3#1	4.82868e-20
C507	VPWR#4	B2#3	4.43634e-20
C508	VPWR#4	B1#6	5.39959e-18
C509	Y#5	VPWR#4	1.00021e-18
C510	VGND#4	VGND#2	7.63053e-17
C511	VPWR#4	VNB	8.3679e-17
C512	VPWR#4	B2#1	5.06515e-18
C513	VGND#2	a_27_74##2	3.63552e-17
C514	a_27_368#	VPWR#4	1.80306e-17
*
*
.ENDS sky130_fd_sc_hs__o32ai_2
*
