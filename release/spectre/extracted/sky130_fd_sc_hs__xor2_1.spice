* Extracted by Quantus, converted by sky130cad/quantus.py
*
*
*
*                       LINUX           Wed Nov 18 09:14:50 2026
*
*
*
*  PROGRAM  advgen
*
*  Name           : advgen - Quantus - (64-bit)
*  Version        : 25.1.0-p047
*  Build Date     : Thu Dec 11 23:20:30 PST 2025
*
*  HSPICE LIBRARY
*
*  OPERATING_TEMPERATURE 150
*  QRC_TECH_DIR <path>/tech
*
*
*

*
.SUBCKT sky130_fd_sc_hs__xor2_1 VNB VPB VGND VPWR X A B
*
*
*  caps2d version: 10
*
*
*       TRANSISTOR CARDS
*
*
XM3 VGND#4 A#3 a_194_125##6 VNB sky130_fd_pr__nfet_01v8_lvt l=0.15 w=0.55 ad=0.33275 as=0.35475 pd=2.31 ps=2.39
XM4 a_194_125##6 B#1 VGND#6 VNB sky130_fd_pr__nfet_01v8_lvt l=0.15 w=0.55 ad=0.35475 as=0.25215 pd=2.39 ps=2.2
XM8 VGND#6 A#2 a_455_87# VNB sky130_fd_pr__nfet_01v8_lvt l=0.15 w=0.74 ad=0.25215 as=0.1776 pd=2.2 ps=1.96
XM6 a_455_87# B#6 X#2 VNB sky130_fd_pr__nfet_01v8_lvt l=0.15 w=0.74 ad=0.1776 as=0.3108 pd=1.96 ps=2.32
XM1 X#2 a_194_125##3 VGND#5 VNB sky130_fd_pr__nfet_01v8_lvt l=0.15 w=0.74 ad=0.3108 as=0.2997 pd=2.32 ps=2.29
XM2 VPWR#7 A#6 a_158_392# VPB sky130_fd_pr__pfet_01v8 l=0.15 w=1 ad=0.295 as=0.27 pd=2.59 ps=2.54
XM9 a_158_392# B#3 a_194_125##7 VPB sky130_fd_pr__pfet_01v8 l=0.15 w=1 ad=0.27 as=0.295 pd=2.54 ps=2.59
XM5 a_355_368##2 A#1 VPWR#6 VPB sky130_fd_pr__pfet_01v8 l=0.15 w=1.12 ad=0.3752 as=0.4704 pd=2.91 ps=3.08
XM7 VPWR#6 B#4 a_355_368# VPB sky130_fd_pr__pfet_01v8 l=0.15 w=1.12 ad=0.4704 as=0.392 pd=3.08 ps=2.94
XM0 a_355_368# a_194_125# X#1 VPB sky130_fd_pr__pfet_01v8 l=0.15 w=1.12 ad=0.392 as=0.3864 pd=2.94 ps=2.93
*
*
*       RESISTOR AND CAP/DIODE CARDS
*
Rg1	B#1	B#2	332.949463
Rg2	B#2	B#3	525.593994
Rg3	A#1	A#2	848.737549
Rg4	A#2	A#3	1413.078857
Rg5	A#3	A#4	317.992523
Rg6	A#4	A#5	50.564472
Rg7	A#4	A#6	478.116486
Rg8	B#4	B#5	434.639221
Rg9	B#5	B#6	345.238708
Rg10	a_194_125#	a_194_125##2	451.082245
Rg11	a_194_125##2	a_194_125##3	424.409119
Rf1	A	A#7	1.541025
Rf2	A#8	A#5	81.657425
Rf3	A#7	A#8	6.044444
Rf4	B#2	B	206.255219
Rf5	B	B#5	161.455215
Rf6	a_355_368#	a_355_368##2	103.033638
Rf7	a_194_125##2	a_194_125##5	310.297791
Rf8	a_194_125##5	a_194_125##6	92.327835
Rf9	a_194_125##5	a_194_125##7	15.400315
Rf10	X#1	X	141.621994
Rf11	X	X#3	4.213448
Rf12	X#3	X	6.726733
Rf13	X#2	X#3	7.500000
Rf15	VGND#2	VGND#3	107.944099
Rf16	VGND#3	VGND#4	121.078667
Rf17	VGND#2	VGND#5	34.507496
Rf18	VGND#3	VGND#6	39.363033
Rf20	VPWR#2	VPWR#3	40.479092
Rf21	VPWR#3	VPWR#4	104.437675
Rf23	VPWR#2	VPWR#6	27.868893
Rf24	VPWR#4	VPWR#7	35.924004
Re1	VPWR#3	VPWR	1.227783
Re2	VGND	VGND#3	1.227829
*
*       CAPACITOR CARDS
*
*
C1	A#8	a_194_125##5	1.6439e-17
C2	a_194_125##6	a_194_125##5	2.36636e-18
C3	A#8	a_194_125##6	3.31354e-17
C4	a_194_125##5	VPWR#6	1.13235e-18
C5	VGND#6	VGND#5	2.69253e-18
C6	VGND#4	A#8	3.9826e-17
C7	a_194_125##5	a_355_368##2	1.12933e-16
C8	VGND#4	A#7	2.17948e-17
C9	a_194_125##5	a_194_125##7	3.92297e-18
C10	a_194_125##6	VGND#6	3.4032e-17
C11	VPWR#7	a_194_125##5	6.17332e-17
C12	VGND#4	VGND#6	7.85215e-18
C13	VGND#4	a_194_125##6	3.58038e-17
C14	a_194_125##5	A#2	3.9359e-19
C15	A#8	VPWR#7	1.91451e-17
C16	A#7	VPWR#7	6.53069e-18
C17	a_355_368#	X#1	6.81099e-17
C18	a_194_125##5	A#3	1.38892e-19
C19	VGND#5	a_194_125##3	2.95851e-17
C20	a_194_125##3	X#2	5.03251e-18
C21	a_355_368#	VPWR#6	5.11841e-17
C22	X#1	a_355_368##2	1.12867e-19
C23	VGND#5	B#6	2.21158e-18
C24	a_355_368##2	a_355_368#	2.59266e-18
C25	B#6	X#2	1.87045e-17
C26	VGND#5	A#2	8.18503e-19
C27	a_194_125##5	a_194_125#	5.29242e-19
C28	VGND#6	a_194_125##3	1.05519e-18
C29	a_355_368##2	VPWR#6	5.21774e-17
C30	A#8	A#3	4.01249e-18
C31	a_194_125##6	a_194_125##3	1.17137e-19
C32	VGND#6	B#6	5.81356e-18
C33	a_194_125##5	B#4	7.70595e-19
C34	a_194_125##6	B#6	1.24013e-19
C35	VGND#6	A#2	6.4765e-17
C36	a_194_125##5	A#1	2.73e-17
C37	a_194_125##6	A#2	4.1858e-18
C38	VPWR#7	VPWR#6	3.55076e-19
C39	VGND#6	B#1	1.41181e-17
C40	VGND#4	A#2	1.41923e-18
C41	a_194_125##5	B#3	4.94319e-17
C42	a_194_125##6	B#1	3.86095e-17
C43	VGND#6	A#3	4.71165e-18
C44	VGND#4	B#1	2.40408e-18
C45	a_194_125##6	A#3	4.6872e-17
C46	a_194_125##5	A#6	1.92924e-17
C47	A#3	VGND#4	3.85353e-17
C48	a_355_368##2	A#2	3.08316e-19
C49	a_194_125##5	VPWR#3	1.9248e-17
C50	X#1	a_194_125#	2.67296e-17
C51	B#6	a_194_125##3	2.1412e-17
C52	a_355_368#	a_194_125#	4.91145e-17
C53	X#1	B#4	8.07476e-19
C54	VPWR#6	a_194_125#	2.35461e-18
C55	a_355_368#	B#4	3.40551e-17
C56	a_355_368##2	a_194_125#	2.10809e-19
C57	X#1	A#1	6.00346e-19
C58	A#2	B#6	5.60279e-17
C59	VPWR#6	B#4	4.58655e-17
C60	a_355_368#	A#1	5.78771e-19
C61	a_355_368##2	B#4	5.9153e-19
C62	VPWR#6	A#1	4.2291e-17
C63	a_355_368#	B#3	8.27648e-20
C64	A#2	B#1	3.83577e-17
C65	a_355_368##2	A#1	3.7772e-17
C66	VPWR#6	B#3	1.11846e-18
C67	A#3	A#2	6.74021e-19
C68	a_355_368##2	B#3	1.27669e-18
C69	a_194_125##5	B#2	9.42975e-17
C70	VPWR#6	A#6	4.29459e-19
C71	A#3	B#1	8.45366e-18
C72	a_194_125##2	VGND#5	2.79099e-18
C73	B#3	a_194_125##7	3.393e-17
C74	VPWR#7	A#1	4.96685e-19
C75	VGND#3	a_194_125##6	8.89906e-18
C76	a_194_125##5	A#5	3.49547e-18
C77	VPWR#7	B#3	7.85431e-18
C78	VGND#3	VGND#4	4.45094e-17
C79	A#8	B#2	5.20781e-19
C80	a_194_125##6	a_194_125##2	1.57299e-19
C81	VPWR#7	A#6	4.38798e-17
C82	a_355_368##2	VPWR#3	2.15337e-17
C83	a_194_125##2	X#1	7.96343e-17
C84	A#8	A#5	2.29659e-17
C85	a_194_125##6	B#5	1.58921e-19
C86	A#7	A#5	1.43498e-17
C87	a_194_125##2	a_355_368#	6.27601e-17
C88	VGND#6	B#2	2.64196e-17
C89	a_194_125##2	VPWR#6	1.53849e-18
C90	a_194_125##6	B#2	4.07138e-17
C91	B#4	a_194_125#	3.70621e-17
C92	a_194_125##2	a_355_368##2	4.17784e-18
C93	a_355_368#	B#5	1.35246e-18
C94	B#5	VPWR#6	1.23479e-18
C95	a_194_125##6	A#5	8.54308e-18
C96	VGND#3	a_194_125##3	3.56657e-20
C97	A#1	B#4	2.74745e-17
C98	A#5	VGND#4	1.38377e-17
C99	VGND#3	B#6	8.34991e-18
C100	a_355_368##2	B#2	9.20996e-19
C101	VGND#3	A#2	2.66617e-17
C102	B#6	a_194_125##2	5.03776e-19
C103	B#3	A#1	6.21533e-18
C104	VGND#3	B#1	2.69429e-18
C105	a_194_125##2	A#2	6.0064e-19
C106	VGND#3	A#3	1.44539e-17
C107	A#2	B#5	1.40819e-17
C108	A#6	B#3	4.97618e-17
C109	VPWR#7	A#5	5.87511e-18
C110	A#2	B#2	1.01048e-17
C111	a_194_125##2	a_194_125#	7.95517e-18
C112	B	a_194_125##5	2.19413e-17
C113	a_194_125##2	B#4	1.7126e-17
C114	A#3	B#2	1.97219e-18
C115	B#5	a_194_125#	5.26487e-19
C116	A#5	B#1	3.82015e-19
C117	a_194_125##2	A#1	3.75425e-19
C118	a_194_125##2	B#3	2.35631e-20
C119	A#1	B#5	1.39858e-17
C120	B#2	A#1	1.33301e-17
C121	B	X#2	1.91305e-18
C122	VGND#6	B	1.51309e-17
C123	A#6	B#2	4.5842e-18
C124	B#6	a_455_87#	1.73994e-17
C125	A#2	a_455_87#	1.73994e-17
C126	VPWR#3	B#2	3.17287e-19
C127	B#5	a_194_125##2	3.79703e-17
C128	VGND#3	B#2	1.32281e-18
C129	X	VGND#5	5.53173e-17
C130	X	X#2	1.25811e-17
C131	VPWR	a_194_125##5	3.02032e-17
C132	a_194_125##2	B#2	6.54536e-19
C133	VGND#6	X	3.5398e-17
C134	B#3	a_158_392#	1.98094e-17
C135	B	A#2	1.46334e-17
C136	VPWR	A#8	3.56295e-18
C137	X	X#1	3.21958e-18
C138	VPWR	A#7	3.70937e-18
C139	A#5	B#2	2.39931e-17
C140	B	a_194_125#	7.27872e-19
C141	B	B#4	2.04224e-18
C142	VPWR	X#1	1.94285e-17
C143	X	a_194_125##3	3.11304e-17
C144	VPWR	a_355_368#	1.75575e-17
C145	VGND	A#8	3.93622e-18
C146	B	A#1	1.55306e-17
C147	VGND	A#7	3.13229e-18
C148	VPWR	VPWR#6	2.68628e-17
C149	X	B#6	3.59939e-17
C150	VPWR	a_355_368##2	1.80486e-17
C151	X	A#2	9.18673e-18
C152	X	B#1	7.88201e-20
C153	VGND	a_194_125##6	1.95964e-17
C154	VPWR	VPWR#7	2.0684e-17
C155	VGND	VGND#4	6.75984e-17
C156	VGND	X#1	9.06801e-19
C157	VGND#3	B	1.38913e-18
C158	B	a_194_125##2	8.08241e-17
C159	VGND	VPWR#7	3.20596e-18
C160	B	B#5	2.12321e-17
C161	VPWR	a_194_125#	4.67202e-18
C162	VGND	a_194_125##3	4.18083e-18
C163	VGND	B#6	9.62187e-18
C164	VPWR	B#4	6.11762e-19
C165	B	B#2	7.20043e-21
C166	VGND	A#2	7.75247e-18
C167	VPWR	A#1	9.41715e-19
C168	VGND	B#1	3.42339e-18
C169	VPWR	B#3	9.72446e-20
C170	VGND	A#3	1.18062e-17
C171	VGND#3	X	5.26637e-18
C172	VPWR	A#6	3.81898e-18
C173	a_194_125##5	VNB	2.28316e-17
C174	X	a_194_125##2	5.45788e-17
C175	X	B#5	3.81748e-18
C176	VPWR	VPWR#3	1.91562e-17
C177	A#8	VNB	7.85773e-18
C178	A#7	VNB	2.81634e-17
C179	X	B#2	8.35258e-20
C180	VGND#5	VNB	1.96658e-17
C181	VPWR	a_194_125##2	6.63927e-18
C182	VGND#6	VNB	4.96895e-18
C183	a_194_125##6	VNB	7.11357e-18
C184	VGND#4	VNB	8.25137e-17
C185	X#1	VNB	7.68427e-17
C186	VPWR	B#2	5.51486e-18
C187	a_355_368#	VNB	2.76102e-18
C188	VPWR#6	VNB	1.69781e-18
C189	VGND	VGND#3	7.02325e-17
C190	a_355_368##2	VNB	9.97288e-18
C191	VPWR	A#5	3.38431e-18
C192	VGND	a_194_125##2	3.70691e-18
C193	VPWR#7	VNB	4.70833e-17
C194	a_194_125##3	VNB	3.57067e-17
C195	B#6	VNB	2.80158e-17
C196	VGND	B#2	5.61932e-18
C197	A#2	VNB	7.2513e-17
C198	B#1	VNB	2.25399e-17
C199	VGND	A#5	6.69828e-20
C200	A#3	VNB	7.40906e-17
C201	a_194_125#	VNB	3.68538e-17
C202	B#4	VNB	2.8137e-17
C203	X	B	2.67544e-17
C204	A#1	VNB	4.60709e-17
C205	B#3	VNB	3.53415e-17
C206	A#6	VNB	4.59684e-17
C207	VPWR	B	4.45403e-18
C208	VPWR#3	VNB	1.98442e-16
C209	VGND#3	VNB	2.14658e-16
C210	a_194_125##2	VNB	4.75005e-17
C211	B#5	VNB	2.21289e-17
C212	VGND	B	7.01085e-18
C213	B#2	VNB	7.80277e-17
C214	A#5	VNB	8.48979e-17
C215	VGND	X	2.67396e-17
C216	B	VNB	4.1433e-18
C217	X	VNB	2.80352e-17
C218	VPWR	VNB	6.80701e-17
C219	VGND	VNB	5.63153e-17
C220	a_355_368#	VPWR#2	2.04602e-17
C221	VPWR#2	VNB	6.09478e-17
C222	A#8	VPWR#4	3.31458e-19
C223	VPWR#4	VNB	4.92833e-17
C224	a_194_125##2	VPWR#2	3.30129e-19
C225	VGND#2	a_194_125##3	3.2858e-18
C226	VGND#3	VGND#2	5.08945e-17
C227	VPWR#3	VPWR#2	7.27996e-17
C228	VGND#2	A#2	6.89475e-19
C229	VGND#2	B#5	8.55105e-20
C230	VPWR#4	VPWR#2	1.20605e-19
C231	VPWR#2	A#1	1.57746e-18
C232	VPWR#4	VPWR#6	8.87786e-20
C233	VPWR#4	B#3	5.31275e-18
C234	VPWR#2	a_194_125#	5.80508e-18
C235	X#1	VPWR#2	2.77558e-17
C236	A#7	VPWR#4	7.50455e-19
C237	VPWR	VPWR#2	4.12228e-17
C238	VGND#2	X	1.57575e-17
C239	VPWR#3	VPWR#4	5.35723e-17
C240	VGND	VGND#2	5.40698e-17
C241	VPWR	VPWR#4	3.6936e-17
C242	VGND#2	VNB	4.77677e-17
C243	VPWR#4	A#6	1.54313e-18
C244	a_355_368##2	VPWR#2	4.68179e-19
C245	VPWR#4	A#5	1.99145e-18
C246	a_194_125##5	VPWR#4	1.39044e-17
C247	VPWR#2	B#4	9.54282e-19
*
*
.ENDS sky130_fd_sc_hs__xor2_1
*
