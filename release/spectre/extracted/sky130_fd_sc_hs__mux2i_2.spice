* Extracted by Quantus, converted by sky130cad/quantus.py
*
*
*
*                       LINUX           Wed Nov 18 08:43:34 2026
*
*
*
*  PROGRAM  advgen
*
*  Name           : advgen - Quantus - (64-bit)
*  Version        : 25.1.0-p047
*  Build Date     : Thu Dec 11 23:20:30 PST 2025
*
*  HSPICE LIBRARY
*
*  OPERATING_TEMPERATURE 150
*  QRC_TECH_DIR <path>/tech
*
*
*

*
.SUBCKT sky130_fd_sc_hs__mux2i_2 VPB VNB VGND VPWR Y A0 S A1
*
*
*  caps2d version: 10
*
*
*       TRANSISTOR CARDS
*
*
XM1 a_115_74##2 A0#5 Y#4 VNB sky130_fd_pr__nfet_01v8_lvt l=0.15 w=0.74 ad=0.2738 as=0.2109 pd=2.22 ps=2.05
XM15 Y#2 A0#1 a_115_74##2 VNB sky130_fd_pr__nfet_01v8_lvt l=0.15 w=0.74 ad=0.37635 as=0.2738 pd=2.71 ps=2.22
XM7 a_337_74##2 A1#5 Y#2 VNB sky130_fd_pr__nfet_01v8_lvt l=0.15 w=0.74 ad=0.54135 as=0.37635 pd=3.01 ps=2.71
XM10 Y#1 A1#1 a_337_74##2 VNB sky130_fd_pr__nfet_01v8_lvt l=0.15 w=0.74 ad=0.2553 as=0.54135 pd=2.17 ps=3.01
XM8 VGND#7 S#5 a_337_74# VNB sky130_fd_pr__nfet_01v8_lvt l=0.15 w=0.74 ad=0.36 as=0.2442 pd=2.83 ps=2.14
XM13 a_337_74# S#1 VGND#6 VNB sky130_fd_pr__nfet_01v8_lvt l=0.15 w=0.74 ad=0.2442 as=0.43125 pd=2.14 ps=3.01
XM9 VGND#6 a_922_72##4 a_115_74# VNB sky130_fd_pr__nfet_01v8_lvt l=0.15 w=0.74 ad=0.43125 as=0.2442 pd=3.01 ps=2.14
XM16 a_115_74# a_922_72# VGND#5 VNB sky130_fd_pr__nfet_01v8_lvt l=0.15 w=0.74 ad=0.2442 as=0.3107 pd=2.14 ps=2.34
XM12 VGND#5 S#8 a_922_72##10 VNB sky130_fd_pr__nfet_01v8_lvt l=0.15 w=0.64 ad=0.3107 as=0.1824 pd=2.34 ps=1.85
XM5 a_118_368# A0#7 Y#6 VPB sky130_fd_pr__pfet_01v8 l=0.15 w=1.12 ad=0.3808 as=0.3416 pd=2.92 ps=2.85
XM11 Y#8 A0#6 a_118_368# VPB sky130_fd_pr__pfet_01v8 l=0.15 w=1.12 ad=0.5264 as=0.3808 pd=3.18 ps=2.92
XM2 Y#8 A1#7 a_340_368# VPB sky130_fd_pr__pfet_01v8 l=0.15 w=1.12 ad=0.5264 as=0.7616 pd=3.18 ps=3.6
XM4 a_340_368# A1#6 Y#10 VPB sky130_fd_pr__pfet_01v8 l=0.15 w=1.12 ad=0.7616 as=0.3304 pd=3.6 ps=2.83
XM14 VPWR#7 S#7 a_118_368##2 VPB sky130_fd_pr__pfet_01v8 l=0.15 w=1.12 ad=0.581825 as=0.336 pd=3.6 ps=2.84
XM17 a_118_368##2 S#6 VPWR#6 VPB sky130_fd_pr__pfet_01v8 l=0.15 w=1.12 ad=0.336 as=0.6042 pd=2.84 ps=3.61
XM0 VPWR#6 a_922_72##6 a_340_368##2 VPB sky130_fd_pr__pfet_01v8 l=0.15 w=1.12 ad=0.6042 as=0.336 pd=3.61 ps=2.84
XM3 a_340_368##2 a_922_72##5 VPWR#5 VPB sky130_fd_pr__pfet_01v8 l=0.15 w=1.12 ad=0.336 as=0.4764 pd=2.84 ps=3.11
XM6 VPWR#5 S#10 a_922_72##7 VPB sky130_fd_pr__pfet_01v8 l=0.15 w=1 ad=0.4764 as=0.295 pd=3.11 ps=2.59
*
*
*       RESISTOR AND CAP/DIODE CARDS
*
Rg1	A0#1	A0#2	322.953644
Rg2	A0#2	A0#3	30.596949
Rg3	A0#3	A0#4	30.613653
Rg4	A0#4	A0#5	322.953644
Rg5	A0#2	A0#6	507.075531
Rg6	A0#4	A0#7	507.075531
Rg7	A1#1	A1#2	397.555725
Rg8	A1#2	A1#3	64.065247
Rg9	A1#3	A1#4	64.081947
Rg10	A1#4	A1#5	397.555725
Rg11	A1#2	A1#6	449.655212
Rg12	A1#4	A1#7	449.655212
Rg13	S#1	S#2	325.369507
Rg14	S#2	S#3	22.722054
Rg15	S#3	S#4	30.613651
Rg16	S#4	S#5	328.692261
Rg17	S#2	S#6	449.668243
Rg18	S#4	S#7	449.655212
Rg19	a_922_72#	a_922_72##2	328.187561
Rg20	a_922_72##2	a_922_72##3	56.207058
Rg21	a_922_72##3	a_922_72##4	322.953644
Rg22	a_922_72##2	a_922_72##5	456.044586
Rg23	a_922_72##3	a_922_72##6	454.096741
Rg24	S#8	S#9	283.297180
Rg25	S#9	S#10	398.521515
Rf1	A0	A0#8	15.531252
Rf2	A0#8	A0	1.411932
Rf3	Y#1	Y#3	116.785248
Rf4	Y#3	Y#5	82.935364
Rf5	Y#5	Y	82.255943
Rf6	Y	Y#7	13.362514
Rf7	Y#7	Y	0.181173
Rf8	Y	Y#9	71.332794
Rf9	Y#9	Y#10	114.713928
Rf10	Y#2	Y#3	15.000000
Rf11	Y#4	Y#5	7.500000
Rf12	Y#6	Y#7	5.000000
Rf13	Y#8	Y#9	15.000000
Rf14	A1	A1#8	4.528324
Rf15	A1#8	A1	13.584970
Rf16	a_118_368#	a_118_368##2	203.372177
Rf17	a_337_74#	a_337_74##2	165.614807
Rf18	a_340_368#	a_340_368##2	211.610504
Rf19	a_115_74#	a_115_74##2	315.763580
Rf20	S#9	S	256.416168
Rf21	S	S#12	7.038167
Rf22	S#12	S	8.317834
Rf23	a_922_72##7	a_922_72##8	102.050369
Rf24	a_922_72##8	a_922_72##2	225.969818
Rf25	a_922_72##8	a_922_72##10	15.090259
Rf27	VGND#2	VGND#3	77.923950
Rf28	VGND#3	VGND#4	94.750099
Rf29	VGND#2	VGND#5	37.460041
Rf30	VGND#3	VGND#6	24.076445
Rf31	VGND#4	VGND#7	27.966743
Rf33	VPWR#2	VPWR#3	76.097687
Rf34	VPWR#3	VPWR#4	94.750099
Rf35	VPWR#2	VPWR#5	35.274624
Rf36	VPWR#3	VPWR#6	24.453804
Rf37	VPWR#4	VPWR#7	24.405090
Rf39	A1#3	A1#8	53.410934
Rf41	S#3	S#12	80.116402
Rf38	A0#3	A0#8	80.116402
Re1	VPWR#4	VPWR	0.755546
Re2	VGND	VGND#4	0.755573
*
*       CAPACITOR CARDS
*
*
C1	a_118_368##2	A1#2	5.8052e-20
C2	a_340_368##2	VPWR#3	6.65352e-17
C3	VPWR#3	VPWR#6	1.24286e-17
C4	a_115_74#	VGND#5	3.08219e-17
C5	a_922_72##8	a_922_72##7	2.4234e-18
C6	A1#2	S#4	2.95028e-18
C7	a_115_74#	VGND#6	4.25121e-18
C8	Y#10	A1#2	2.2199e-19
C9	VPWR#4	S#4	2.52541e-20
C10	a_115_74#	a_337_74#	1.02433e-16
C11	VPWR#4	A1#4	5.43495e-21
C12	VPWR#4	A1#2	5.16321e-21
C13	a_115_74#	VGND#7	3.40884e-18
C14	A1#4	a_340_368#	1.19773e-19
C15	a_115_74#	Y#1	1.17918e-17
C16	A1#2	a_340_368#	1.13784e-19
C17	VGND#4	S#4	6.52244e-20
C18	a_337_74#	VGND#7	1.3074e-18
C19	a_115_74#	a_337_74##2	5.54203e-19
C20	VGND#4	A1#4	1.02095e-20
C21	VGND#4	A1#2	9.74087e-21
C22	a_337_74#	Y#1	7.96907e-20
C23	A1#4	A1#2	5.90093e-19
C24	Y#8	A1#4	2.33674e-19
C25	S#9	a_922_72##3	7.27627e-20
C26	a_337_74##2	a_337_74#	1.09793e-18
C27	a_115_74##2	a_115_74#	4.18901e-18
C28	Y#1	a_337_74##2	2.51492e-18
C29	a_118_368#	A1#4	6.45359e-20
C30	a_922_72##3	a_922_72##2	1.34296e-18
C31	VGND#3	S#8	7.14495e-19
C32	a_922_72##2	S#4	1.95826e-18
C33	Y#2	a_337_74##2	1.51279e-18
C34	a_115_74##2	Y#1	7.52551e-17
C35	VGND#3	a_922_72#	1.98454e-18
C36	a_115_74##2	a_337_74##2	1.03607e-16
C37	VGND#3	a_922_72##4	9.55864e-18
C38	Y#2	a_115_74##2	1.08894e-16
C39	Y#4	a_337_74##2	1.40794e-18
C40	a_922_72##8	S#8	3.38191e-17
C41	S#3	S#4	2.93586e-17
C42	VGND#3	S#1	1.10296e-17
C43	a_922_72##8	a_922_72#	1.68977e-18
C44	Y#4	a_115_74##2	4.87493e-17
C45	a_337_74#	a_118_368##2	5.82385e-18
C46	VGND#3	S#5	2.10884e-18
C47	a_922_72##8	a_922_72##4	6.61913e-19
C48	VGND#3	A1#1	3.70679e-19
C49	a_922_72##8	S#1	3.9811e-19
C50	VPWR#5	a_922_72##7	5.07567e-17
C51	A0#3	A1#4	1.17199e-17
C52	S#8	a_922_72##10	6.13931e-18
C53	A0#4	A0#3	4.1042e-18
C54	a_340_368##2	VPWR#5	7.14178e-17
C55	a_922_72##7	VPWR#6	7.61067e-20
C56	S#8	VGND#5	2.26711e-17
C57	a_115_74#	S#8	8.8473e-19
C58	a_922_72#	VGND#5	2.60011e-17
C59	S#1	a_922_72##3	1.01164e-19
C60	a_340_368##2	VPWR#6	3.84748e-18
C61	a_115_74#	a_922_72#	3.10086e-17
C62	VGND#5	a_922_72##4	1.57237e-18
C63	a_340_368##2	a_118_368##2	4.91264e-17
C64	VPWR#3	a_922_72##5	1.16007e-18
C65	a_115_74#	a_922_72##4	4.38156e-17
C66	a_115_74##2	Y#8	2.84339e-18
C67	a_337_74#	a_922_72#	7.29588e-19
C68	VGND#5	S#1	4.33212e-19
C69	a_922_72##4	VGND#6	1.9903e-17
C70	a_115_74#	S#1	2.92211e-17
C71	a_115_74#	a_922_72##3	8.50472e-19
C72	VPWR#3	a_922_72##6	1.33745e-17
C73	a_337_74#	a_922_72##4	2.42582e-18
C74	VGND#5	S#5	3.67423e-20
C75	S#1	VGND#6	1.9903e-17
C76	a_115_74#	S#5	2.91873e-17
C77	a_118_368##2	VPWR#7	1.0327e-17
C78	a_340_368#	a_340_368##2	2.24777e-18
C79	a_115_74#	S#4	9.41544e-19
C80	a_337_74#	S#1	3.11541e-17
C81	a_922_72##8	S#10	2.94025e-20
C82	VPWR#3	S#6	1.69064e-17
C83	Y#1	a_922_72##4	4.12768e-19
C84	a_118_368##2	Y#10	8.78517e-17
C85	a_115_74#	A1#1	1.21116e-18
C86	a_337_74#	S#5	3.70728e-17
C87	Y#1	S#1	6.59726e-19
C88	a_118_368##2	a_340_368#	1.3777e-16
C89	A1#2	S#5	1.33995e-19
C90	S#5	VGND#7	1.94153e-17
C91	VPWR#3	S#7	3.08181e-18
C92	a_337_74##2	S#1	3.01678e-19
C93	a_337_74#	A1#1	6.6617e-19
C94	a_340_368#	VPWR#7	5.40949e-18
C95	Y#8	a_118_368##2	1.41232e-18
C96	Y#1	S#5	3.00883e-18
C97	a_337_74##2	S#5	8.20611e-19
C98	Y#10	a_340_368#	8.41253e-18
C99	VPWR#3	A1#6	8.72818e-19
C100	a_337_74#	A1#5	2.37778e-19
C101	Y#1	A1#1	4.11985e-17
C102	a_337_74##2	A1#1	3.36033e-17
C103	a_115_74##2	S#5	5.53678e-20
C104	Y#1	A1#5	1.53627e-18
C105	Y#8	a_340_368#	1.63432e-18
C106	A1#5	a_337_74##2	2.30674e-17
C107	a_115_74##2	A1#1	2.58513e-17
C108	Y#1	A0#1	5.29331e-19
C109	a_118_368#	a_340_368#	3.70713e-17
C110	Y#2	A1#5	3.70916e-17
C111	a_337_74#	S#4	5.49213e-18
C112	Y#4	A1#1	3.65406e-19
C113	a_337_74##2	A0#1	1.73851e-18
C114	a_115_74##2	A1#5	2.40904e-17
C115	Y#8	a_118_368#	9.80185e-17
C116	Y#1	A0#5	4.76525e-19
C117	Y#2	A0#1	3.53874e-17
C118	Y#4	A1#5	8.87233e-19
C119	a_337_74##2	A0#5	2.19491e-19
C120	a_115_74##2	A0#1	4.44089e-17
C121	Y#4	A0#1	2.62536e-18
C122	A0#5	a_115_74##2	1.88575e-17
C123	Y#4	A0#5	4.45478e-17
C124	VPWR#4	VPWR#3	4.57441e-17
C125	a_922_72#	S#8	2.03424e-17
C126	a_922_72##7	S#10	3.92324e-17
C127	S#10	VPWR#5	3.28682e-17
C128	a_922_72##7	a_922_72##5	1.74811e-18
C129	a_922_72##4	a_922_72#	3.04538e-17
C130	a_340_368##2	S#10	8.13742e-19
C131	VGND#4	VGND#3	4.90355e-17
C132	a_922_72##5	VPWR#5	3.87005e-17
C133	a_922_72##7	a_922_72##6	2.79659e-19
C134	a_340_368##2	a_922_72##5	5.45441e-17
C135	a_118_368##2	S#10	7.27962e-19
C136	VPWR#5	a_922_72##6	1.37472e-18
C137	S#1	a_922_72##4	2.15455e-17
C138	a_922_72##7	S#6	1.90474e-19
C139	A1	S#4	7.30184e-18
C140	a_340_368##2	a_922_72##6	6.07196e-17
C141	VPWR#3	a_922_72##2	1.13572e-20
C142	a_118_368##2	a_922_72##5	7.52962e-19
C143	A1	A1#4	1.72497e-17
C144	VPWR#5	S#6	2.70474e-19
C145	A1	A1#2	1.64024e-17
C146	a_922_72##6	VPWR#6	2.8079e-17
C147	A1	A0#4	1.89248e-19
C148	Y#1	A1#2	9.45966e-20
C149	S#5	S#1	3.04801e-17
C150	a_340_368##2	S#6	2.90022e-17
C151	a_118_368##2	a_922_72##6	3.5356e-18
C152	VGND#3	a_922_72##2	2.7745e-20
C153	a_922_72##8	S#9	7.69215e-17
C154	S#6	VPWR#6	2.63581e-17
C155	a_340_368##2	S#7	1.23249e-17
C156	a_118_368##2	S#6	3.68591e-17
C157	Y#10	a_922_72##6	2.21285e-19
C158	A1#1	S#5	2.99087e-18
C159	a_922_72##2	a_922_72##8	2.60711e-18
C160	VPWR#3	a_922_72##3	3.92095e-21
C161	a_340_368#	a_922_72##6	2.84942e-19
C162	a_337_74##2	A1#4	3.27156e-18
C163	a_118_368##2	S#7	5.06487e-17
C164	S	a_922_72##3	1.63164e-17
C165	Y#10	S#6	5.33741e-19
C166	S	S#4	7.16484e-18
C167	S#7	VPWR#7	3.03865e-17
C168	S	A1#2	1.06097e-18
C169	a_340_368#	S#6	1.48635e-18
C170	A1#5	A1#1	7.61811e-18
C171	a_118_368##2	A1#6	2.19549e-17
C172	a_337_74##2	A1#2	5.19474e-18
C173	Y#10	S#7	2.07927e-18
C174	VPWR#3	S#4	2.49173e-20
C175	VGND#4	a_115_74#	4.60843e-17
C176	a_340_368#	S#7	1.06617e-17
C177	a_118_368##2	A1#7	1.15551e-19
C178	Y#10	A1#6	4.76358e-17
C179	S#9	VGND#5	4.02745e-18
C180	A0#1	A1#5	2.08446e-17
C181	a_340_368#	A1#6	6.98103e-17
C182	VGND#4	VGND#7	8.0289e-18
C183	a_118_368##2	A0#6	7.49699e-20
C184	VGND#4	Y#1	8.68847e-17
C185	Y#2	A1#4	1.03507e-19
C186	a_922_72##2	VGND#5	2.43318e-17
C187	a_340_368#	A1#7	5.29468e-17
C188	A0#5	A0#1	2.60314e-17
C189	a_118_368#	A1#6	5.73233e-19
C190	a_922_72##2	a_115_74#	2.85853e-17
C191	A0	A1#4	7.90906e-18
C192	VGND#4	Y#2	8.69454e-17
C193	Y#8	A1#7	4.83906e-17
C194	A0	A1#2	2.73397e-19
C195	A0	A0#4	1.06118e-17
C196	a_340_368#	A0#6	3.97708e-18
C197	a_118_368#	A1#7	2.5856e-17
C198	a_337_74#	a_922_72##2	8.78573e-18
C199	VGND#4	Y#4	5.5425e-17
C200	Y#8	A0#6	5.28882e-17
C201	a_340_368##2	VPWR#4	4.20967e-18
C202	a_115_74#	S#3	4.93982e-18
C203	a_118_368#	A0#6	6.51423e-17
C204	a_337_74#	S#3	4.30459e-17
C205	S#9	a_922_72##7	3.48116e-17
C206	VPWR#4	VPWR#7	7.42617e-18
C207	A0#7	a_118_368#	2.74533e-17
C208	a_115_74##2	A1#4	1.5493e-19
C209	S#9	VPWR#5	5.04975e-17
C210	A0#7	Y#6	1.23614e-17
C211	a_340_368#	VPWR#4	9.38208e-17
C212	Y	A1#4	7.42093e-19
C213	S#4	a_922_72##6	8.89851e-20
C214	Y	A0#4	7.35509e-18
C215	a_922_72##5	S#10	2.64193e-17
C216	a_115_74##2	A1#2	2.38578e-19
C217	Y#1	A1#3	5.25815e-19
C218	a_337_74##2	A1#3	9.83907e-18
C219	a_922_72##2	a_340_368##2	2.0487e-18
C220	a_118_368#	VPWR#4	2.93715e-17
C221	Y#2	A1#3	4.84412e-19
C222	a_115_74##2	A1#3	1.74324e-18
C223	a_922_72##6	a_922_72##5	4.50505e-17
C224	S#3	a_340_368##2	4.71932e-18
C225	a_337_74##2	A0#3	1.58688e-18
C226	S#3	VPWR#6	8.022e-19
C227	Y#2	A0#3	4.05951e-19
C228	S#3	a_118_368##2	4.33532e-17
C229	A0#3	a_115_74##2	7.17024e-18
C230	VGND#3	a_922_72##3	2.26542e-20
C231	S#6	a_922_72##6	2.31017e-17
C232	Y#4	A0#3	5.61072e-19
C233	VGND#4	a_922_72##4	5.417e-19
C234	a_118_368##2	A1#3	9.28831e-19
C235	VGND#4	S#1	1.18518e-18
C236	S#7	S#6	4.91761e-17
C237	Y#10	A1#3	3.34738e-18
C238	a_922_72##2	S#8	6.26751e-19
C239	VGND#4	S#5	1.17675e-17
C240	VGND#3	S#4	6.47412e-20
C241	A1#3	a_340_368#	2.92238e-18
C242	a_922_72##2	a_922_72#	1.2467e-17
C243	VGND#4	A1#1	6.8339e-18
C244	Y#4	A0#4	5.15953e-18
C245	Y#8	A1#3	2.34258e-18
C246	a_922_72##2	a_922_72##4	5.95405e-18
C247	VGND#4	A1#5	4.53367e-18
C248	A1#6	S#7	4.28367e-18
C249	VGND#3	VGND#5	5.69557e-18
C250	a_118_368#	A1#3	5.90504e-19
C251	a_922_72##2	S#1	1.55591e-18
C252	VGND#4	A0#1	4.56783e-18
C253	a_922_72##2	S#5	1.112e-19
C254	Y#8	A0#3	1.74418e-19
C255	VGND#4	A0#5	4.43427e-18
C256	a_118_368#	A0#3	9.01917e-19
C257	A1#7	A1#6	1.19734e-17
C258	VGND#3	a_115_74#	5.30435e-17
C259	VGND	A0#4	2.10317e-20
C260	VPWR#4	a_922_72##6	4.58462e-19
C261	A0#6	A1#7	2.64375e-17
C262	S#9	S#10	1.01275e-17
C263	VPWR#4	S#6	1.98659e-18
C264	S#9	a_922_72##5	1.35299e-17
C265	VPWR#4	S#7	1.27592e-17
C266	S#9	a_922_72##6	2.57701e-19
C267	A0#7	A0#6	4.25809e-17
C268	VGND#3	VGND#6	8.82734e-18
C269	VPWR#4	A1#6	9.37296e-18
C270	A0#3	A1#5	1.177e-18
C271	a_922_72##8	a_922_72##10	5.25775e-18
C272	VPWR#4	A1#7	8.38507e-18
C273	VPWR#4	A0#6	6.25616e-18
C274	a_337_74#	A1	3.8736e-17
C275	VPWR#4	A0#7	5.81305e-18
C276	a_340_368##2	a_922_72##3	6.74894e-20
C277	S#3	S#6	5.55868e-18
C278	a_922_72##3	VNB	1.91675e-17
C279	a_337_74##2	A1	9.54117e-17
C280	S#4	VNB	6.08401e-17
C281	A1#4	VNB	2.44929e-17
C282	S#3	S#7	1.82744e-18
C283	A1#2	VNB	3.07439e-17
C284	a_922_72##8	VGND#5	4.09831e-17
C285	A0#4	VNB	2.7945e-17
C286	a_115_74#	S	1.58444e-17
C287	a_115_74##2	A1	4.6866e-18
C288	a_337_74#	S	1.60423e-17
C289	a_340_368##2	S#4	4.08145e-19
C290	A1	a_118_368##2	2.25373e-17
C291	A1	Y#10	7.74469e-17
C292	S	a_340_368##2	4.95062e-17
C293	A1	Y#8	4.40093e-17
C294	VPWR	VPWR#3	3.80357e-17
C295	S	VPWR#6	3.35548e-18
C296	A0	a_337_74##2	6.29484e-18
C297	S	a_118_368##2	1.73997e-17
C298	a_115_74##2	A0	5.10077e-17
C299	S	VPWR#7	7.06958e-19
C300	a_922_72##2	S#9	7.39935e-17
C301	Y#4	A0	3.12529e-17
C302	S#4	a_922_72##3	1.64772e-17
C303	Y#10	S	4.84201e-18
C304	VPWR#4	A1#3	1.32885e-19
C305	VGND#4	A1#3	9.96449e-20
C306	VPWR#4	A0#3	1.37439e-19
C307	VGND#4	A0#3	1.8522e-19
C308	Y#4	Y	3.12962e-18
C309	A0	Y#8	2.03705e-17
C310	VGND	VGND#3	3.95453e-17
C311	VGND	a_922_72##8	1.62997e-17
C312	VPWR	a_922_72##7	1.58605e-17
C313	Y	a_118_368#	8.62582e-17
C314	VPWR	VPWR#5	2.1768e-17
C315	A0	A1#1	1.90727e-19
C316	Y	Y#6	5.85654e-18
C317	S	S#10	2.96356e-19
C318	VPWR	a_340_368##2	3.25639e-17
C319	A0	A1#5	2.07031e-18
C320	A1	S#7	8.11913e-19
C321	VGND	a_115_74#	3.63757e-17
C322	S	a_922_72##5	8.62856e-18
C323	VPWR	a_118_368##2	1.51353e-17
C324	A1	A1#6	2.107e-18
C325	VPWR#3	VNB	3.42189e-17
C326	VGND	a_337_74#	7.40309e-18
C327	S	a_922_72##6	1.76202e-17
C328	VPWR	Y#10	4.18328e-18
C329	A1	A1#7	2.05858e-18
C330	VGND	Y#1	2.58935e-17
C331	S	S#6	3.21196e-18
C332	VGND#3	VNB	4.14616e-17
C333	VPWR	a_340_368#	4.02068e-17
C334	VGND	a_337_74##2	7.64556e-18
C335	VPWR	Y#8	5.57014e-18
C336	A1	A0#6	1.86016e-18
C337	VGND	Y#2	3.58509e-17
C338	S	S#7	2.03493e-18
C339	VGND	a_115_74##2	2.76474e-17
C340	VPWR	a_118_368#	2.68007e-17
C341	a_922_72##8	VNB	5.82172e-17
C342	VGND	Y#4	2.64742e-17
C343	S	A1#6	1.54471e-18
C344	A1	A0#7	3.26678e-19
C345	S	A1#7	2.57551e-19
C346	VGND#5	VNB	1.17332e-17
C347	a_115_74#	VNB	5.25183e-18
C348	a_337_74#	VNB	8.8013e-18
C349	VGND	Y#8	3.71868e-18
C350	Y#1	VNB	1.16218e-17
C351	a_337_74##2	VNB	3.35417e-18
C352	Y#2	VNB	4.16339e-18
C353	VGND	S#8	7.07136e-18
C354	VGND	a_922_72#	7.61667e-18
C355	Y#4	VNB	5.58503e-17
C356	Y	A1#6	2.79476e-19
C357	VGND	a_922_72##4	8.06641e-18
C358	VPWR	S#10	7.25174e-18
C359	S	S#9	3.189e-18
C360	a_922_72##7	VNB	4.91296e-17
C361	VPWR#5	VNB	7.32863e-18
C362	VGND	S#1	7.61667e-18
C363	Y	A1#7	7.11103e-19
C364	VPWR	a_922_72##5	1.60159e-18
C365	a_340_368##2	VNB	2.13294e-18
C366	A1	A1#3	1.7655e-17
C367	VGND	S#5	8.06641e-18
C368	S	a_922_72##2	4.37765e-17
C369	Y	A0#6	3.28289e-18
C370	VGND	A1#1	2.18229e-18
C371	a_118_368##2	VNB	5.88982e-18
C372	VPWR	S#6	5.63958e-19
C373	VGND	A1#5	1.69019e-18
C374	Y	A0#7	5.43845e-17
C375	A1	A0#3	3.03344e-18
C376	Y#10	VNB	2.24107e-18
C377	VGND	A0#1	1.68998e-18
C378	VPWR	S#7	6.86588e-19
C379	a_340_368#	VNB	4.98879e-18
C380	VGND	A0#5	2.3749e-18
C381	VPWR	A1#6	7.50518e-19
C382	a_118_368#	VNB	2.77133e-18
C383	Y	VPWR#4	2.52487e-17
C384	S#4	a_118_368##2	2.24247e-18
C385	VPWR	A1#7	1.51495e-18
C386	S#8	VNB	3.60744e-17
C387	VPWR	A0#6	5.033e-19
C388	a_922_72#	VNB	2.98649e-17
C389	a_922_72##4	VNB	2.91454e-17
C390	VPWR	A0#7	1.60573e-18
C391	S#1	VNB	2.88904e-17
C392	S#5	VNB	3.1531e-17
C393	A0	A0#3	2.90731e-17
C394	A1#1	VNB	3.38781e-17
C395	VPWR	VPWR#4	1.09536e-16
C396	A1#5	VNB	3.25972e-17
C397	A0#1	VNB	2.60396e-17
C398	A0#5	VNB	3.2926e-17
C399	A0#6	A1#4	1.73987e-18
C400	VPWR	S#9	4.9446e-18
C401	S#10	VNB	4.26811e-17
C402	Y	A0#3	3.02097e-18
C403	VPWR	a_922_72##2	2.31419e-18
C404	a_922_72##5	VNB	3.51935e-17
C405	a_922_72##6	VNB	3.27773e-17
C406	VPWR	S#3	3.3051e-18
C407	S#6	VNB	3.43244e-17
C408	S#7	VNB	3.38026e-17
C409	VGND	VGND#4	9.23498e-17
C410	A1#6	VNB	3.74317e-17
C411	VGND	S#9	4.24626e-18
C412	A1#7	VNB	3.26391e-17
C413	VGND	a_922_72##2	5.07658e-18
C414	A0#6	VNB	3.50247e-17
C415	A0#7	VNB	4.53534e-17
C416	VGND	S#3	3.58935e-18
C417	A1	S	3.06369e-17
C418	VPWR#4	VNB	3.85507e-16
C419	VGND	A0#3	6.75636e-19
C420	VGND#4	VNB	3.85756e-16
C421	A0	A1	1.30735e-17
C422	VPWR#3	VPWR#5	1.54157e-18
C423	S#9	VNB	3.88123e-17
C424	a_922_72##2	VNB	2.24286e-17
C425	S#3	VNB	1.12837e-18
C426	Y	A1	4.95495e-18
C427	A1#3	VNB	3.37264e-17
C428	A0#3	VNB	3.19321e-17
C429	VPWR	A1	7.61601e-18
C430	Y	A0	3.36934e-17
C431	VPWR	S	7.30429e-18
C432	VGND	A1	9.81958e-18
C433	VPWR	A0	5.53588e-18
C434	VGND	S	6.73922e-18
C435	VPWR	Y	2.01197e-17
C436	VGND	A0	6.47497e-18
C437	A1	VNB	1.78824e-17
C438	S	VNB	1.27642e-17
C439	VGND	Y	2.77466e-18
C440	A0	VNB	1.8294e-17
C441	Y	VNB	7.30613e-17
C442	VPWR	VNB	6.87098e-17
C443	VGND	VNB	8.01767e-17
C444	VGND#4	VGND#2	5.68884e-17
C445	VGND#2	S#8	2.13446e-18
C446	VPWR#2	VNB	5.0512e-17
C447	VPWR#2	S#10	6.23039e-18
C448	VGND#2	a_922_72##8	1.11507e-17
C449	a_922_72##7	VPWR#2	1.46431e-17
C450	VPWR#2	a_922_72##5	4.5268e-18
C451	VGND#2	a_922_72#	6.11444e-18
C452	VGND	VGND#2	6.02373e-17
C453	VGND#2	a_115_74#	5.60415e-18
C454	S#9	VPWR#2	7.25082e-19
C455	VPWR	VPWR#2	3.94575e-17
C456	VPWR#2	a_922_72##2	2.47426e-20
C457	S	VPWR#2	2.82515e-19
C458	VGND#2	a_922_72##2	9.33115e-19
C459	VGND#3	VGND#2	1.2323e-18
C460	VGND#2	VNB	5.50833e-17
C461	VPWR#4	VPWR#2	5.7043e-17
C462	VPWR#3	VPWR#2	8.92252e-19
C463	a_340_368##2	VPWR#2	9.2938e-18
*
*
.ENDS sky130_fd_sc_hs__mux2i_2
*
