* Extracted by Quantus, converted by sky130cad/quantus.py
*
*
*
*                       LINUX           Wed Nov 18 09:15:28 2026
*
*
*
*  PROGRAM  advgen
*
*  Name           : advgen - Quantus - (64-bit)
*  Version        : 25.1.0-p047
*  Build Date     : Thu Dec 11 23:20:30 PST 2025
*
*  HSPICE LIBRARY
*
*  OPERATING_TEMPERATURE 150
*  QRC_TECH_DIR <path>/tech
*
*
*

*
.SUBCKT sky130_fd_sc_hs__xor3_2 VNB VPB VGND VPWR X A B C
*
*
*  caps2d version: 10
*
*
*       TRANSISTOR CARDS
*
*
XM15 a_27_134##3 a_83_289##3 VGND#9 VNB sky130_fd_pr__nfet_01v8_lvt l=0.15 w=0.64 ad=0.1824 as=0.6949 pd=1.85 ps=3.62
XM11 VGND#9 A#1 a_83_289##11 VNB sky130_fd_pr__nfet_01v8_lvt l=0.15 w=0.64 ad=0.6949 as=0.339725 pd=3.62 ps=2.55
XM1 a_83_289##11 B#9 a_416_113##4 VNB sky130_fd_pr__nfet_01v8_lvt l=0.15 w=0.64 ad=0.339725 as=0.2075 pd=2.55 ps=1.98
XM6 a_416_113##4 a_440_315##7 a_27_134# VNB sky130_fd_pr__nfet_01v8_lvt l=0.15 w=0.42 ad=0.2075 as=0.3163 pd=1.98 ps=2.32
XM21 a_27_134# B#11 a_372_419##4 VNB sky130_fd_pr__nfet_01v8_lvt l=0.15 w=0.64 ad=0.3163 as=0.299 pd=2.32 ps=2.28
XM14 a_372_419##4 a_440_315# a_83_289##4 VNB sky130_fd_pr__nfet_01v8_lvt l=0.15 w=0.64 ad=0.299 as=0.2848 pd=2.28 ps=2.17
XM3 a_440_315##9 B#1 VGND#8 VNB sky130_fd_pr__nfet_01v8_lvt l=0.15 w=0.74 ad=0.2035 as=0.46725 pd=2.03 ps=2.88
XM23 a_372_419##2 a_1162_379# a_1195_424##10 VNB sky130_fd_pr__nfet_01v8_lvt l=0.15 w=0.64 ad=0.176 as=0.33955 pd=1.83 ps=2.48
XM16 a_1195_424##10 C#6 a_416_113##5 VNB sky130_fd_pr__nfet_01v8_lvt l=0.15 w=0.64 ad=0.33955 as=0.2144 pd=2.48 ps=1.95
XM2 a_1162_379##7 C#1 VGND#7 VNB sky130_fd_pr__nfet_01v8_lvt l=0.15 w=0.42 ad=0.1197 as=0.2942 pd=1.41 ps=2.34
XM4 VGND#7 a_1195_424##6 X#3 VNB sky130_fd_pr__nfet_01v8_lvt l=0.15 w=0.74 ad=0.2942 as=0.2072 pd=2.34 ps=2.04
XM12 X#3 a_1195_424##5 VGND#1 VNB sky130_fd_pr__nfet_01v8_lvt l=0.15 w=0.74 ad=0.2072 as=0.2109 pd=2.04 ps=2.05
XM17 a_27_134##6 a_83_289# VPWR#10 VPB sky130_fd_pr__pfet_01v8 l=0.15 w=1 ad=0.295 as=0.445 pd=2.59 ps=2.89
XM10 VPWR#10 A#3 a_83_289##7 VPB sky130_fd_pr__pfet_01v8 l=0.15 w=1 ad=0.445 as=0.3706 pd=2.89 ps=2.77
XM7 a_83_289##7 B#5 a_372_419##6 VPB sky130_fd_pr__pfet_01v8 l=0.15 w=0.84 ad=0.3706 as=0.2802 pd=2.77 ps=2.39
XM8 a_372_419##6 a_440_315##5 a_27_134##5 VPB sky130_fd_pr__pfet_01v8 l=0.15 w=0.64 ad=0.2802 as=0.192 pd=2.39 ps=1.88
XM20 a_27_134##5 B#10 a_416_113# VPB sky130_fd_pr__pfet_01v8 l=0.15 w=0.64 ad=0.192 as=0.3054 pd=1.88 ps=2.45
XM0 a_416_113# a_440_315##6 a_83_289##5 VPB sky130_fd_pr__pfet_01v8 l=0.15 w=0.84 ad=0.3054 as=0.5544 pd=2.45 ps=3
XM5 a_440_315##8 B#6 VPWR#7 VPB sky130_fd_pr__pfet_01v8 l=0.15 w=1.12 ad=0.3304 as=0.3304 pd=2.83 ps=2.83
XM18 a_416_113##7 a_1162_379##3 a_1195_424##9 VPB sky130_fd_pr__pfet_01v8 l=0.15 w=0.84 ad=0.2478 as=0.5124 pd=2.27 ps=2.9
XM9 a_1195_424##9 C#4 a_372_419# VPB sky130_fd_pr__pfet_01v8 l=0.15 w=0.84 ad=0.5124 as=0.2478 pd=2.9 ps=2.27
XM19 a_1162_379##5 C#5 VPWR#3 VPB sky130_fd_pr__pfet_01v8 l=0.15 w=0.64 ad=0.24 as=0.7912 pd=2.03 ps=3.73
XM22 VPWR#3 a_1195_424##7 X#1 VPB sky130_fd_pr__pfet_01v8 l=0.15 w=1.12 ad=0.7912 as=0.336 pd=3.73 ps=2.84
XM13 X#1 a_1195_424# VPWR#1 VPB sky130_fd_pr__pfet_01v8 l=0.15 w=1.12 ad=0.336 as=0.3304 pd=2.84 ps=2.83
*
*
*       RESISTOR AND CAP/DIODE CARDS
*
Rg1	a_83_289#	a_83_289##2	400.207520
Rg2	a_83_289##2	a_83_289##3	293.591156
Rg3	A#1	A#2	269.641388
Rg4	A#2	A#3	401.708130
Rg5	a_440_315#	a_440_315##2	291.416443
Rg6	a_440_315##2	a_440_315##3	262.723297
Rg7	a_440_315##3	a_440_315##4	401.797424
Rg8	a_440_315##4	a_440_315##5	440.744385
Rg9	a_440_315##3	a_440_315##6	329.700531
Rg10	a_440_315##4	a_440_315##7	340.173401
Rg11	B#1	B#2	322.988434
Rg12	B#2	B#3	214.427322
Rg13	B#3	B#4	1951.515625
Rg14	B#4	B#5	817.872681
Rg15	B#2	B#6	506.911102
Rg16	B#2	B#7	36.508282
Rg17	B#3	B#8	1272.828613
Rg18	B#8	B#9	1004.030579
Rg19	B#4	B#10	347.044342
Rg20	B#8	B#11	368.866516
Rg21	a_1162_379#	a_1162_379##2	314.401978
Rg22	a_1162_379##2	a_1162_379##3	555.683167
Rg23	C#1	C#2	545.630127
Rg24	C#2	C#3	332.713196
Rg25	C#3	C#4	513.690674
Rg26	C#2	C#5	369.617615
Rg27	C#3	C#6	270.183289
Rg28	a_1195_424#	a_1195_424##2	516.454041
Rg29	a_1195_424##2	a_1195_424##3	175.687637
Rg30	a_1195_424##3	a_1195_424##4	49.974792
Rg31	a_1195_424##2	a_1195_424##5	343.439178
Rg32	a_1195_424##3	a_1195_424##6	392.785339
Rg33	a_1195_424##3	a_1195_424##7	435.824982
Rf1	A#4	A	0.930865
Rf2	A#2	A#6	161.163666
Rf3	A#4	A#6	11.416508
Rf4	a_27_134#	a_27_134##2	44.067841
Rf5	a_27_134##2	a_27_134##4	201.373596
Rf6	a_27_134##2	a_27_134##5	46.899567
Rf7	a_27_134##4	a_27_134##6	108.984207
Rf8	a_27_134##3	a_27_134##4	7.500000
Rf9	a_416_113##2	a_416_113##3	3.936727
Rf10	a_416_113##3	a_416_113##4	200.740997
Rf11	a_416_113#	a_416_113##2	15.000000
Rf12	a_83_289##4	a_83_289##6	91.075768
Rf13	a_83_289##6	a_83_289##8	229.285309
Rf14	a_83_289##8	a_83_289##9	23.191593
Rf15	a_83_289##9	a_83_289##2	224.861206
Rf16	a_83_289##9	a_83_289##11	76.613625
Rf17	a_83_289##5	a_83_289##6	7.500000
Rf18	a_83_289##7	a_83_289##8	7.500000
Rf19	a_440_315##8	a_440_315##10	119.168579
Rf20	a_440_315##10	a_440_315##2	280.852814
Rf21	a_440_315##9	a_440_315##10	15.000000
Rf22	B	B#12	0.794212
Rf23	B#13	B#7	161.027008
Rf24	B#12	B#13	3.543054
Rf25	a_1195_424##8	a_1195_424##9	35.465080
Rf26	a_1195_424##8	a_1195_424##10	68.110870
Rf27	C	C#3	171.744415
Rf28	a_416_113##5	a_416_113##6	199.367935
Rf29	a_416_113##6	a_416_113##7	22.762220
Rf30	a_372_419#	a_372_419##3	302.048615
Rf31	a_372_419##3	a_372_419##5	240.034607
Rf32	a_372_419##5	a_372_419##6	238.674210
Rf33	a_372_419##2	a_372_419##3	15.000000
Rf34	a_372_419##4	a_372_419##5	7.500000
Rf35	a_1162_379##2	a_1162_379##6	396.770386
Rf36	a_1162_379##6	a_1162_379##7	125.265762
Rf37	a_1162_379##5	a_1162_379##6	15.000000
Rf38	a_1195_424##11	a_1195_424##4	189.897003
Rf39	X	X#2	0.196836
Rf40	X#2	X	14.369054
Rf41	X	X#4	6.495599
Rf42	X#4	X	8.070291
Rf43	X#1	X#2	5.000000
Rf44	X#3	X#4	7.500000
Rf45	VPWR#1	VPWR#2	137.305267
Rf46	VPWR#2	VPWR#4	16.182457
Rf47	VPWR#4	VPWR#5	6.089883
Rf48	VPWR#2	VPWR#6	226.745026
Rf49	VPWR#6	VPWR#7	48.259808
Rf50	VPWR#6	VPWR#8	125.314415
Rf51	VPWR#8	VPWR#9	177.488174
Rf52	VPWR#9	VPWR#10	32.617332
Rf54	VPWR#3	VPWR#4	7.500000
Rf55	VPWR#3	VPWR#5	5.000000
Rf56	VGND#1	VGND#2	129.683136
Rf57	VGND#2	VGND#3	198.730164
Rf58	VGND#3	VGND#4	151.977844
Rf59	VGND#4	VGND#5	178.932251
Rf61	VGND#2	VGND#7	37.591507
Rf62	VGND#3	VGND#8	28.073811
Rf63	VGND#5	VGND#9	20.597172
Re1	a_416_113##6	a_416_113##3	23.476074
Re2	a_1195_424##11	a_1195_424##8	22.652748
Re3	VPWR#2	VPWR	2.920302
Re4	VPWR	VPWR#8	1.251558
Re5	VGND#2	VGND	2.920302
Re6	VGND	VGND#4	1.251558
*
*       CAPACITOR CARDS
*
*
C1	a_416_113#	a_440_315##4	1.15495e-18
C2	a_27_134##5	B#4	1.45906e-19
C3	B#11	a_372_419##4	2.13655e-17
C4	B#7	B#3	2.93015e-19
C5	a_416_113##4	a_440_315#	7.19776e-19
C6	B#7	B#2	1.11e-17
C7	VPWR#3	C#1	6.45162e-18
C8	a_27_134##5	a_416_113#	3.71086e-17
C9	a_372_419##6	a_83_289##5	1.08793e-16
C10	B#11	a_27_134#	2.19076e-17
C11	a_416_113#	a_440_315##3	2.61417e-17
C12	a_372_419##4	a_440_315##7	4.32571e-20
C13	a_372_419##2	B#3	1.38009e-18
C14	a_416_113##4	B#11	1.56878e-17
C15	a_372_419##6	a_416_113#	3.73114e-17
C16	a_27_134#	a_440_315##7	2.9475e-17
C17	B#8	a_440_315##2	2.59494e-18
C18	a_372_419##4	B#9	6.26593e-19
C19	a_372_419#	C#1	5.21256e-18
C20	a_372_419##2	B#2	3.62473e-18
C21	a_372_419##6	a_27_134##5	6.81365e-17
C22	a_440_315##2	B#4	3.23248e-18
C23	a_440_315##7	a_416_113##4	1.78981e-17
C24	a_27_134##5	a_440_315##4	8.85618e-19
C25	a_372_419##6	B#4	3.9204e-18
C26	a_440_315##4	a_440_315##3	1.79303e-19
C27	a_440_315##2	B#3	3.04693e-17
C28	a_27_134#	B#9	1.40193e-18
C29	a_416_113##7	VPWR#6	2.25488e-17
C30	a_83_289##11	a_440_315##7	4.27725e-20
C31	a_372_419#	C#6	3.75066e-18
C32	a_440_315##4	a_440_315##2	5.72306e-19
C33	a_372_419##6	B#3	2.96707e-19
C34	B#9	a_416_113##4	2.96208e-17
C35	VGND#7	VGND#1	2.89649e-18
C36	VGND#8	B#3	9.77709e-19
C37	a_83_289##7	a_372_419##6	1.06801e-16
C38	a_372_419#	a_1162_379#	6.38773e-19
C39	a_440_315##9	B#8	1.89448e-18
C40	B#9	a_83_289##11	1.97328e-17
C41	a_416_113##4	A#1	1.61053e-18
C42	B#2	VGND#8	1.29782e-18
C43	a_372_419##6	a_440_315##4	4.69253e-19
C44	B#4	B#6	6.95914e-18
C45	a_83_289##7	B#4	5.33555e-18
C46	A#1	a_83_289##11	1.29476e-17
C47	a_27_134##3	B#9	5.67319e-19
C48	a_27_134##2	a_440_315##6	7.26983e-19
C49	a_416_113##4	a_83_289##3	6.64653e-19
C50	a_83_289##9	a_440_315##5	9.4809e-19
C51	B#3	B#6	4.04729e-17
C52	VPWR#10	a_83_289##7	5.79712e-17
C53	A#2	a_440_315##4	3.50569e-18
C54	A#1	VGND#9	1.90729e-17
C55	a_372_419##6	a_440_315##3	1.96632e-19
C56	a_440_315##8	VPWR#6	1.05539e-17
C57	a_83_289##11	a_83_289##3	1.91378e-18
C58	a_440_315##9	B#3	3.32547e-17
C59	VGND#2	VGND#3	7.79043e-18
C60	a_27_134##3	A#1	3.3818e-17
C61	a_83_289##4	B#8	1.61954e-18
C62	a_83_289##3	VGND#9	1.67139e-17
C63	a_83_289##9	B#5	5.59532e-18
C64	a_1162_379##7	VGND#7	6.52551e-17
C65	a_27_134##6	VPWR#10	6.21082e-17
C66	a_440_315##9	B#2	7.6485e-18
C67	a_27_134##3	a_83_289##3	4.76956e-17
C68	a_83_289##7	a_440_315##4	2.99409e-19
C69	a_440_315##6	B#4	1.55939e-17
C70	a_83_289##5	VPWR#6	6.0596e-18
C71	a_83_289##4	B#4	2.88539e-19
C72	B#12	B#2	8.52685e-18
C73	a_440_315##6	B#3	6.62304e-18
C74	a_83_289##9	A#3	2.23567e-17
C75	a_83_289##2	a_440_315##4	3.26684e-20
C76	a_372_419##2	a_1162_379##3	2.43292e-19
C77	a_83_289##4	B#3	2.55281e-17
C78	a_1195_424##8	VPWR#6	1.34105e-18
C79	a_440_315##4	a_440_315##6	6.61965e-19
C80	a_27_134##2	B#5	8.95346e-18
C81	a_372_419##4	B#8	2.36537e-17
C82	a_83_289##9	a_83_289#	5.82354e-19
C83	a_83_289##4	B#2	4.00652e-19
C84	VPWR#1	a_1195_424#	3.26313e-17
C85	a_416_113#	a_440_315#	5.69923e-19
C86	a_27_134##2	a_27_134#	2.356e-18
C87	a_27_134##3	a_83_289##9	1.66875e-18
C88	a_1195_424##6	a_1195_424##5	3.82725e-17
C89	a_372_419##2	VGND#7	4.11104e-18
C90	a_1195_424#	X#1	2.44129e-17
C91	a_416_113##6	VPWR#6	6.58499e-18
C92	B#10	B#3	1.07776e-19
C93	a_416_113#	B#11	1.38933e-17
C94	VPWR#1	a_1195_424##7	1.30219e-18
C95	a_83_289##4	B#6	2.2299e-20
C96	VPWR#3	a_1195_424#	1.50862e-18
C97	a_27_134##2	a_416_113##4	7.09261e-17
C98	a_372_419##4	B#3	2.20297e-17
C99	a_1195_424##7	X#1	2.37392e-17
C100	a_416_113##5	a_1195_424##10	6.14248e-17
C101	a_372_419##2	a_1162_379##7	2.42714e-17
C102	a_416_113#	a_440_315##7	1.0647e-18
C103	a_440_315##4	B#10	1.16671e-17
C104	C#1	a_1195_424##6	1.92996e-17
C105	a_27_134#	B#8	1.60062e-18
C106	a_1195_424##7	VPWR#3	3.09947e-17
C107	a_372_419##6	B#11	8.95619e-19
C108	a_416_113##3	VPWR#6	5.67697e-19
C109	a_27_134##2	a_83_289##11	6.01704e-17
C110	a_416_113##5	a_372_419##2	1.31986e-16
C111	a_1162_379##5	a_1195_424##7	7.97671e-19
C112	a_372_419##4	a_440_315##6	1.12015e-17
C113	a_440_315##5	B#4	1.19982e-17
C114	C#5	VPWR#3	2.4573e-17
C115	a_372_419#	a_1195_424##7	8.29546e-20
C116	C#6	C#1	3.85932e-18
C117	a_372_419##4	a_440_315##4	9.9331e-20
C118	a_1162_379##5	C#5	4.4791e-17
C119	VPWR#8	VPWR#6	1.46393e-16
C120	a_372_419##4	B#10	3.63986e-19
C121	a_372_419##6	B#9	4.38464e-18
C122	a_1195_424##9	a_1195_424##7	5.56875e-20
C123	C#2	a_1195_424##6	1.41158e-18
C124	VPWR#3	C#4	8.75255e-19
C125	a_1162_379#	C#1	1.42026e-19
C126	a_372_419#	C#5	4.2841e-18
C127	a_27_134#	B#10	6.67425e-19
C128	VGND#4	VGND#3	1.19643e-16
C129	a_416_113##4	B#8	9.71517e-18
C130	a_83_289##7	B#9	8.23732e-19
C131	A#6	a_83_289##11	1.18405e-17
C132	a_372_419##4	a_440_315##3	1.06959e-17
C133	a_1162_379##5	C#4	2.68879e-17
C134	a_1162_379#	C#6	1.4483e-17
C135	a_372_419##4	a_440_315##5	1.43689e-19
C136	a_440_315##9	a_416_113##5	2.4904e-18
C137	VPWR#3	a_1162_379##3	6.04757e-20
C138	a_27_134##3	a_27_134##2	1.17766e-18
C139	C#4	a_372_419#	2.49081e-17
C140	B#5	B#4	9.0746e-19
C141	a_416_113##4	B#4	1.21354e-20
C142	a_1162_379##5	a_1162_379##3	2.74043e-19
C143	A#4	a_83_289##11	2.30438e-17
C144	a_1195_424##9	C#4	3.7412e-17
C145	B#12	a_416_113##6	1.04834e-17
C146	a_372_419##4	B#5	8.48247e-20
C147	a_372_419##2	VGND#8	8.72811e-17
C148	a_27_134#	a_440_315##4	4.25702e-18
C149	B#1	a_1162_379#	2.62908e-18
C150	a_416_113##7	C#4	6.50472e-19
C151	a_416_113##4	B#3	2.21376e-19
C152	a_1162_379##3	a_1195_424##9	1.85285e-18
C153	A#4	VGND#9	4.33575e-19
C154	a_1195_424##11	VGND#7	6.12293e-18
C155	VPWR#7	C#4	1.98854e-19
C156	a_416_113##4	B#5	9.80166e-20
C157	a_27_134##3	A#6	9.46929e-20
C158	a_372_419##2	a_440_315##9	4.71715e-17
C159	a_416_113##7	a_1162_379##3	5.72661e-17
C160	VGND#3	B#3	4.86939e-18
C161	VGND#3	C#3	4.04127e-20
C162	VPWR#7	a_1162_379##3	2.05546e-18
C163	a_27_134##3	A#4	2.31811e-17
C164	a_416_113##7	B#6	1.58115e-18
C165	VGND#2	VGND#1	5.60019e-17
C166	VPWR#7	B#6	6.31804e-17
C167	a_416_113##4	a_440_315##4	1.33385e-18
C168	a_416_113##3	a_83_289##9	2.99866e-18
C169	VGND#3	B#2	2.15952e-19
C170	B#11	a_440_315#	1.89468e-17
C171	VGND#3	a_1162_379##2	4.53538e-20
C172	VGND#2	VGND#7	1.82804e-17
C173	B#6	a_440_315##8	2.54592e-17
C174	C#6	C#2	2.18384e-18
C175	VPWR#2	a_1195_424##10	8.27038e-19
C176	A#3	a_440_315##4	6.47943e-19
C177	a_372_419##4	a_372_419##2	9.75104e-19
C178	a_83_289##9	a_440_315##4	3.19092e-18
C179	VGND#2	a_1162_379##7	3.16018e-17
C180	a_416_113##4	a_440_315##3	4.89925e-19
C181	a_83_289##5	B#6	3.2948e-18
C182	a_440_315##7	a_440_315#	6.17299e-20
C183	VGND#2	a_416_113##5	1.05782e-17
C184	VGND#4	B#12	3.13757e-18
C185	a_1162_379##2	VPWR#6	2.42935e-17
C186	VPWR#8	a_83_289##9	1.84922e-18
C187	a_440_315##8	a_440_315##6	1.82251e-19
C188	VGND#1	VPWR#1	9.74914e-18
C189	VGND#2	a_1195_424##10	1.43391e-18
C190	a_440_315##7	B#11	1.28599e-17
C191	a_440_315##9	a_83_289##4	6.9475e-17
C192	a_440_315##6	a_83_289##5	1.54781e-17
C193	VGND#2	a_372_419##2	8.90137e-17
C194	a_440_315##8	B#10	2.35343e-20
C195	VGND#3	C#6	5.15789e-19
C196	B#9	B#11	8.28217e-19
C197	a_416_113#	a_440_315##6	3.77668e-17
C198	a_1195_424##8	a_416_113##5	1.00962e-17
C199	a_83_289##11	a_440_315##4	9.82184e-20
C200	VGND#4	a_83_289##9	9.42243e-19
C201	a_83_289##5	B#10	7.09571e-18
C202	a_1195_424##8	a_1195_424##10	3.2921e-18
C203	a_372_419##4	a_440_315##9	5.52448e-17
C204	a_27_134##5	a_440_315##6	8.1798e-19
C205	B#9	a_440_315##7	2.54544e-17
C206	VPWR#8	a_27_134##2	4.40052e-18
C207	a_1195_424##8	a_372_419##2	3.77811e-18
C208	B#10	a_416_113#	1.72846e-17
C209	a_372_419##6	a_440_315##6	1.77719e-17
C210	a_83_289##5	a_440_315##5	1.16726e-19
C211	A#1	a_440_315##7	1.39205e-19
C212	a_27_134##5	B#10	3.05731e-17
C213	VPWR#8	A#6	2.96109e-18
C214	VGND#3	a_1162_379#	2.77843e-18
C215	a_416_113##6	a_1195_424##10	6.50068e-19
C216	a_83_289##7	a_440_315##6	1.25491e-19
C217	a_1195_424##11	VPWR#1	2.76729e-18
C218	a_416_113#	a_440_315##5	1.37343e-19
C219	a_372_419##6	B#10	2.09008e-17
C220	a_416_113##6	a_372_419##2	5.30531e-17
C221	A#1	B#9	1.61841e-17
C222	VGND#4	a_27_134##2	1.59173e-17
C223	a_83_289##5	B#5	1.94822e-19
C224	a_27_134##5	a_440_315##5	2.61279e-17
C225	a_416_113##6	VGND#8	1.96902e-18
C226	VPWR#6	B#4	1.26616e-17
C227	a_83_289##7	B#10	4.80502e-19
C228	a_1195_424##11	VPWR#3	8.89342e-17
C229	a_440_315##9	a_416_113##6	6.86387e-18
C230	VPWR#2	VPWR#1	5.71959e-17
C231	a_372_419##6	a_440_315##5	2.83989e-17
C232	VGND#4	A#4	5.15611e-18
C233	a_1195_424##11	a_1162_379##5	3.21404e-17
C234	a_27_134##5	B#5	1.07724e-18
C235	B#12	a_1162_379##2	3.16087e-20
C236	VGND#3	B#1	4.44935e-18
C237	a_83_289##7	a_440_315##5	6.49132e-18
C238	a_83_289##3	A#1	6.20114e-18
C239	a_416_113##6	a_372_419##4	7.58819e-19
C240	a_1195_424##11	a_372_419#	9.07911e-18
C241	VGND#7	VPWR#3	4.82149e-19
C242	VPWR#2	VPWR#3	2.0558e-17
C243	a_372_419##6	B#5	4.06847e-17
C244	B#2	a_1162_379#	8.36343e-19
C245	VGND#2	VPWR#1	3.65607e-18
C246	a_416_113##3	a_440_315##9	2.16482e-18
C247	a_1195_424##11	C#2	1.28135e-18
C248	a_27_134##5	A#3	6.72001e-19
C249	VPWR#6	B#3	2.15092e-19
C250	a_1162_379##5	VPWR#2	1.04175e-16
C251	a_83_289##7	B#5	3.33289e-17
C252	a_416_113##3	a_83_289##4	2.17171e-18
C253	VPWR#2	a_372_419#	8.66177e-18
C254	a_372_419##6	A#3	1.10145e-18
C255	a_416_113##3	a_372_419##4	3.51403e-17
C256	VGND#2	VPWR#3	4.30662e-18
C257	VPWR#10	B#5	6.74165e-19
C258	VGND#4	a_416_113##5	8.8342e-18
C259	a_416_113##4	a_372_419##4	3.96993e-17
C260	a_83_289##9	a_27_134##5	4.37104e-18
C261	a_1195_424##4	X#3	1.65515e-19
C262	a_83_289##7	A#3	4.60544e-17
C263	VGND#4	a_1195_424##10	3.525e-18
C264	a_1195_424##4	VGND#7	4.71995e-17
C265	a_416_113##3	a_416_113##4	5.82303e-19
C266	VGND#4	a_372_419##2	5.22579e-17
C267	VGND#2	a_372_419#	6.39914e-18
C268	A#3	VPWR#10	2.87695e-17
C269	a_1162_379##7	a_1195_424##4	2.30441e-17
C270	VPWR#6	B#2	2.35028e-20
C271	B#3	B#1	3.28455e-17
C272	VGND#4	VGND#8	1.50537e-17
C273	a_83_289##7	a_83_289#	1.81588e-18
C274	a_27_134##6	A#3	3.46344e-19
C275	a_416_113##4	a_27_134#	8.47149e-17
C276	a_1195_424##8	a_1162_379##5	1.38492e-17
C277	VGND#4	a_440_315##9	1.51455e-17
C278	a_83_289#	VPWR#10	3.84877e-17
C279	VPWR#2	a_1195_424##2	4.06813e-20
C280	a_83_289##9	a_372_419##6	1.03204e-17
C281	a_1195_424##8	a_372_419#	8.26164e-17
C282	a_27_134##2	B#8	2.18438e-20
C283	VGND#4	a_83_289##4	6.8891e-18
C284	VPWR#2	C#2	7.92941e-20
C285	a_27_134##6	a_83_289#	4.2017e-17
C286	VGND#4	a_372_419##4	1.11823e-16
C287	B#8	a_440_315#	1.02068e-17
C288	a_372_419#	a_1162_379##7	7.05113e-17
C289	a_1195_424##7	a_1195_424#	4.61659e-17
C290	C#3	a_416_113##5	8.32954e-18
C291	VGND#4	a_27_134#	7.85577e-18
C292	a_1195_424##10	C#3	1.26034e-17
C293	VGND#4	a_416_113##4	6.706e-17
C294	a_83_289##9	a_83_289##7	2.5367e-18
C295	a_1195_424##10	a_1162_379##5	4.09626e-19
C296	a_372_419##2	C#3	1.59117e-18
C297	VGND#4	a_83_289##11	4.68374e-18
C298	a_416_113##5	a_372_419#	3.86464e-17
C299	a_27_134##2	a_416_113#	2.31603e-17
C300	a_416_113##6	a_416_113##7	2.38769e-19
C301	a_416_113##5	a_1162_379##2	1.80847e-17
C302	C#5	a_1195_424##7	6.32675e-18
C303	a_440_315#	B#3	1.60782e-17
C304	VGND#3	a_372_419##2	1.20197e-16
C305	a_83_289##9	A#2	8.54366e-18
C306	a_27_134##2	a_440_315##2	2.54709e-19
C307	a_416_113##6	VPWR#7	6.50557e-17
C308	VGND#4	a_27_134##3	3.11463e-17
C309	a_1162_379##2	a_1195_424##10	2.12606e-17
C310	a_1195_424##10	a_372_419#	7.23346e-18
C311	a_1162_379##2	a_372_419##2	3.62944e-18
C312	a_416_113##6	a_440_315##8	4.20217e-17
C313	C#4	a_1195_424##7	3.81183e-19
C314	VPWR#8	a_1162_379##5	1.05944e-17
C315	VGND#2	a_1195_424##2	5.08292e-20
C316	a_83_289##9	VPWR#10	1.26646e-17
C317	a_416_113##5	a_1195_424##9	3.98754e-19
C318	a_416_113##6	a_83_289##5	1.34537e-17
C319	VGND#2	C#2	1.26387e-18
C320	C#4	C#5	4.42863e-18
C321	VPWR#8	a_1195_424##9	7.53023e-18
C322	a_1195_424##11	C#1	3.85782e-18
C323	a_27_134##2	A#2	1.6597e-18
C324	a_83_289##2	a_83_289##9	2.84867e-18
C325	a_372_419##2	a_372_419#	4.74582e-18
C326	C	C#2	2.56332e-19
C327	VPWR#8	a_416_113##7	2.16227e-17
C328	B#9	B#5	3.5868e-19
C329	a_416_113##3	a_83_289##5	4.85106e-17
C330	A#6	A#2	1.59936e-17
C331	a_27_134##6	a_83_289##9	9.39095e-19
C332	VGND#2	a_1195_424##5	1.24003e-17
C333	VPWR#2	C#1	2.41238e-19
C334	a_27_134##2	a_372_419##6	1.60644e-17
C335	A#4	A#2	5.85966e-18
C336	a_1195_424##4	VPWR#3	5.60723e-18
C337	a_416_113##3	a_416_113#	3.63362e-17
C338	a_440_315##9	B#7	4.21976e-18
C339	a_1162_379##3	C#4	1.65005e-17
C340	VPWR#8	a_440_315##8	1.33662e-17
C341	VGND#2	a_1195_424##6	1.45585e-17
C342	a_1162_379##5	a_1195_424##4	1.93132e-17
C343	a_416_113##3	a_27_134##5	6.06008e-18
C344	B#11	B#3	2.99484e-19
C345	a_83_289##5	VPWR#8	1.48185e-16
C346	a_1162_379##5	C#2	1.32805e-17
C347	VGND#2	C#1	1.83619e-17
C348	a_27_134##3	a_83_289##11	2.31373e-17
C349	VGND#4	VPWR#7	3.20241e-18
C350	a_416_113##3	a_372_419##6	6.90847e-18
C351	VPWR#8	a_416_113#	5.47368e-18
C352	a_83_289##2	A#6	2.80266e-17
C353	a_27_134##2	a_440_315##4	3.76718e-17
C354	VGND#2	C#6	6.26588e-19
C355	a_440_315##9	a_440_315##2	8.85928e-18
C356	B#6	a_1162_379##3	6.45374e-18
C357	VPWR#8	a_27_134##5	6.55452e-18
C358	a_27_134##2	a_83_289##7	1.69167e-18
C359	a_1162_379##5	C#3	1.95093e-18
C360	VGND#4	a_83_289##5	3.26778e-18
C361	a_440_315##2	a_83_289##4	6.34479e-17
C362	VPWR#8	a_372_419##6	2.43866e-17
C363	a_372_419#	C#3	2.72312e-17
C364	B#8	a_440_315##7	6.13204e-18
C365	a_27_134##3	VGND#9	5.09387e-18
C366	a_372_419##4	a_440_315##2	1.25201e-16
C367	VGND#4	a_416_113#	2.04324e-18
C368	a_83_289##7	VPWR#8	7.34368e-17
C369	a_1162_379##2	a_1162_379##5	2.03609e-18
C370	VPWR#8	VPWR#10	2.11724e-17
C371	a_27_134##2	a_440_315##3	1.98704e-19
C372	B#11	a_440_315##3	1.02946e-17
C373	a_416_113##6	C#6	7.44719e-20
C374	VPWR#8	a_27_134##6	2.37295e-17
C375	a_1162_379##2	a_1195_424##9	6.29976e-17
C376	a_416_113##6	a_1162_379#	1.48757e-19
C377	a_416_113##7	a_1162_379##2	6.12578e-17
C378	a_372_419#	C#2	1.55328e-17
C379	a_416_113##6	B#1	2.90207e-18
C380	B#10	a_440_315##6	2.65081e-17
C381	VPWR#7	a_1162_379##2	2.49691e-18
C382	B#12	a_1162_379#	4.63594e-20
C383	a_83_289##11	A#2	2.79297e-18
C384	a_440_315##8	a_1162_379##2	5.53122e-19
C385	A#2	VGND#9	1.53705e-18
C386	a_440_315##5	a_440_315##6	5.38641e-19
C387	a_27_134##3	A#2	2.4812e-18
C388	A#6	VPWR#10	2.29209e-18
C389	a_1195_424##11	a_1195_424##7	8.44561e-18
C390	B#7	VPWR#7	1.97022e-17
C391	a_440_315##5	B#10	3.79847e-17
C392	B#9	B#8	1.22319e-18
C393	VGND#3	a_372_419##4	1.52021e-17
C394	VPWR#2	a_1195_424#	7.43236e-18
C395	a_440_315##8	B#7	1.9867e-17
C396	a_416_113##3	B#11	1.41762e-18
C397	a_1195_424##11	C#5	2.71192e-18
C398	a_83_289##2	VGND#9	1.83334e-18
C399	B#5	B#10	7.45898e-19
C400	VPWR#2	a_1195_424##7	9.98427e-18
C401	a_27_134##3	a_83_289##2	4.47637e-17
C402	a_416_113##6	B#3	4.09456e-18
C403	VPWR#2	C#5	8.72475e-18
C404	B#5	a_440_315##5	3.23791e-17
C405	VGND#4	B#1	2.03556e-18
C406	a_416_113##6	B#2	7.52663e-18
C407	VPWR#2	C#4	3.89786e-18
C408	a_440_315##2	a_83_289##5	4.87209e-17
C409	VGND#4	a_440_315#	1.614e-18
C410	A#3	a_440_315##5	5.01692e-19
C411	a_416_113#	a_440_315##2	2.61489e-19
C412	A#6	a_440_315##4	6.21086e-19
C413	A#3	B#5	3.3186e-17
C414	VGND#4	a_440_315##7	2.68892e-18
C415	a_83_289##4	a_440_315##8	2.32491e-17
C416	a_1195_424##8	C#5	3.74894e-19
C417	a_440_315##9	a_83_289##5	1.87014e-19
C418	VPWR#3	VPWR#1	1.41887e-18
C419	a_1195_424##2	X#3	1.97476e-19
C420	VGND#4	B#9	1.20083e-17
C421	a_1195_424##8	C#4	1.92619e-17
C422	a_1162_379##2	C#6	6.302e-19
C423	B#9	a_440_315##4	6.41151e-19
C424	VGND#4	A#1	7.69683e-18
C425	a_27_134##5	A#2	1.41408e-20
C426	a_416_113##3	B#8	2.22555e-19
C427	a_83_289#	A#3	2.36533e-17
C428	a_1195_424##8	a_1162_379##3	5.3258e-18
C429	X	a_1195_424##2	1.62859e-17
C430	X	C#2	7.64971e-19
C431	a_416_113##6	C#4	2.19323e-19
C432	VGND#4	a_83_289##3	7.7446e-18
C433	a_83_289##4	a_83_289##5	3.87458e-18
C434	a_416_113##6	a_1162_379##3	1.14233e-17
C435	VPWR#10	A#2	1.52962e-18
C436	B#8	B#3	3.31194e-19
C437	VGND#1	a_1195_424##5	2.66113e-17
C438	a_416_113##6	B#6	7.08692e-18
C439	a_83_289##9	a_27_134##2	5.90191e-18
C440	a_372_419##4	a_83_289##5	6.28091e-17
C441	a_83_289##2	VPWR#10	1.68915e-17
C442	a_1195_424##4	a_1195_424#	1.57972e-18
C443	a_1195_424##5	X#3	1.5442e-17
C444	a_83_289##2	a_27_134##6	6.89343e-17
C445	a_440_315##2	B#1	1.81302e-19
C446	a_416_113##3	a_440_315##6	5.77648e-18
C447	a_440_315##2	a_440_315#	1.74959e-17
C448	VPWR#8	B#6	2.08078e-18
C449	C#5	a_1195_424##4	2.16036e-18
C450	VGND#1	a_1195_424##6	1.47525e-18
C451	a_416_113#	a_372_419##4	1.19997e-16
C452	a_440_315##2	B#11	1.11993e-18
C453	VPWR#8	a_440_315##6	1.17747e-18
C454	a_1162_379##5	VPWR#3	8.4086e-17
C455	VGND#7	a_1195_424##5	1.63574e-18
C456	a_440_315##7	a_440_315##2	1.8519e-19
C457	a_1195_424##11	VPWR#2	3.07564e-17
C458	C#3	C#5	2.6302e-18
C459	a_1195_424##6	X#3	1.4935e-17
C460	a_416_113##3	B#5	2.94416e-19
C461	VPWR#8	B#4	5.42367e-17
C462	VPWR#8	a_440_315##5	1.0709e-18
C463	a_416_113#	a_27_134#	3.92749e-17
C464	A#2	a_440_315##7	1.20004e-19
C465	VPWR#8	B#3	4.82738e-19
C466	a_1162_379##3	C#3	5.16126e-19
C467	VGND#1	C#1	5.443e-19
C468	VGND#7	C#2	3.45266e-19
C469	B#4	B#3	1.44607e-19
C470	VPWR#8	B#5	1.03806e-17
C471	a_1162_379##2	C#4	2.95062e-18
C472	VPWR#8	B#2	3.55324e-19
C473	a_1195_424##6	VGND#7	2.18017e-17
C474	VPWR#8	A#3	3.24904e-18
C475	A#6	a_83_289##9	4.33027e-17
C476	a_1162_379##2	a_1162_379##3	4.79209e-17
C477	a_1195_424##8	VPWR#2	2.03186e-17
C478	VPWR#8	a_440_315##4	4.68836e-19
C479	a_416_113##4	a_416_113#	2.61984e-18
C480	a_83_289##3	A#2	1.29778e-19
C481	VPWR#8	a_83_289#	8.94746e-18
C482	B#6	a_1162_379##2	1.55993e-18
C483	a_1162_379##5	a_372_419#	1.3106e-16
C484	VPWR#8	a_440_315##3	2.56571e-19
C485	a_372_419##6	a_372_419##4	1.10731e-18
C486	a_1162_379##7	a_1195_424##6	8.18487e-19
C487	C#1	VGND#7	2.39202e-17
C488	VGND#3	a_1162_379##3	3.36489e-20
C489	VPWR#6	C#4	1.25318e-18
C490	a_416_113##6	a_1195_424##8	9.66734e-18
C491	VPWR#8	VPWR#2	4.40193e-18
C492	VGND#4	B#8	6.45882e-17
C493	a_1162_379##5	a_1195_424##9	1.98501e-17
C494	a_27_134#	a_372_419##6	2.40603e-18
C495	a_27_134##2	a_440_315#	1.17649e-20
C496	C	a_416_113##5	1.73248e-17
C497	a_1162_379##7	C#1	5.49443e-17
C498	a_1195_424##11	a_1195_424##4	4.47726e-18
C499	VPWR#7	B#4	8.32946e-19
C500	a_1195_424##10	C	3.72109e-17
C501	a_1195_424##8	VPWR#8	1.06599e-17
C502	VGND#4	B#3	8.53405e-18
C503	VPWR#2	a_1195_424##4	6.35249e-19
C504	a_1162_379##7	C#2	1.20965e-17
C505	B#8	a_440_315##4	7.19944e-19
C506	a_1195_424##9	a_372_419#	3.34394e-17
C507	a_416_113##6	VPWR#8	2.99648e-17
C508	VGND#4	B#2	1.24889e-18
C509	VGND#2	a_1195_424##4	4.03536e-18
C510	a_416_113##5	C#1	8.838e-19
C511	VPWR#2	C#3	1.4952e-19
C512	a_416_113##3	VPWR#8	3.63965e-17
C513	VPWR#7	B#3	1.48902e-18
C514	VGND#4	a_440_315##4	4.64325e-19
C515	VGND#4	a_416_113##6	8.83834e-18
C516	VPWR#6	a_1162_379##3	5.75398e-18
C517	a_27_134##2	B#11	5.73353e-19
C518	VGND#2	C#3	2.94289e-18
C519	a_372_419##2	a_1195_424##6	4.46518e-19
C520	a_1162_379##7	C#6	6.53633e-19
C521	VGND#4	a_440_315##3	8.63463e-19
C522	a_1195_424##8	C#3	8.81467e-18
C523	a_1195_424##10	C#1	7.33947e-19
C524	a_1195_424##4	a_1195_424##2	7.36781e-18
C525	a_1162_379##2	a_1195_424##8	6.54888e-17
C526	VPWR#7	B#2	4.60767e-18
C527	a_416_113##5	C#6	4.4726e-17
C528	C	a_372_419#	7.09171e-17
C529	a_83_289##2	A#3	4.76019e-19
C530	C#2	a_1195_424##4	1.60148e-17
C531	a_416_113##6	a_1162_379##2	9.25502e-17
C532	a_83_289##2	a_83_289#	1.17188e-17
C533	a_372_419##2	C#1	4.27744e-18
C534	a_27_134##2	a_440_315##7	2.6803e-18
C535	a_1162_379##7	a_1162_379#	6.86248e-20
C536	a_83_289##7	a_83_289##11	1.50783e-19
C537	B#7	a_416_113##6	2.06384e-17
C538	VPWR#6	B#6	8.79319e-18
C539	C#6	a_1195_424##10	1.2569e-17
C540	a_440_315##8	B#4	9.35488e-20
C541	VPWR#8	a_1162_379##2	1.47993e-17
C542	B#3	B#2	1.18435e-17
C543	VGND#4	a_1162_379##2	3.29092e-18
C544	a_440_315##4	B#4	4.1777e-19
C545	B#8	a_440_315##3	1.34031e-18
C546	a_416_113##5	a_1162_379#	3.76561e-17
C547	X	VGND#1	7.0374e-17
C548	a_416_113##3	a_440_315##2	1.43669e-17
C549	VGND#7	X	7.53271e-17
C550	a_1162_379##7	X	4.35173e-18
C551	a_372_419##2	C#6	1.20708e-17
C552	VPWR#8	a_440_315##2	7.04552e-19
C553	a_440_315##8	B#3	2.03686e-17
C554	a_27_134##2	B#9	3.79019e-17
C555	a_1162_379##2	C#3	1.91834e-17
C556	VGND#4	a_440_315##2	5.2144e-18
C557	C	C#6	3.063e-18
C558	a_1162_379#	a_1195_424##10	2.011e-17
C559	C	a_1162_379#	2.92978e-19
C560	VPWR#8	a_83_289##2	5.95475e-18
C561	B#7	a_1162_379##2	6.84461e-19
C562	a_416_113##5	B#1	6.09838e-19
C563	VPWR#7	a_416_113##7	5.59225e-17
C564	a_372_419##2	B#12	1.57468e-17
C565	VGND#4	a_83_289##2	5.37493e-18
C566	X	VPWR#1	8.69472e-17
C567	a_83_289##5	B#8	2.67046e-19
C568	a_440_315##8	B#2	4.38893e-18
C569	X	X#1	8.86216e-19
C570	a_372_419##2	a_1162_379#	3.87023e-17
C571	VPWR#3	X	6.81388e-17
C572	C#3	C#2	2.57943e-18
C573	a_27_134##2	A#1	1.81897e-18
C574	a_1195_424##2	VNB	3.35597e-17
C575	C#2	VNB	3.53965e-17
C576	B#8	VNB	1.36674e-16
C577	B#4	VNB	1.5159e-16
C578	B#3	VNB	1.61883e-16
C579	B#2	VNB	4.31904e-17
C580	a_440_315##4	VNB	4.96273e-17
C581	VGND#8	a_1162_379#	3.99104e-19
C582	a_440_315##3	VNB	3.31711e-17
C583	a_83_289##5	B#4	3.66623e-17
C584	a_440_315##3	B#4	8.53269e-19
C585	a_372_419##2	B#1	3.77246e-17
C586	a_1195_424##10	C#2	2.33495e-19
C587	X	a_1195_424##5	2.46854e-17
C588	X	a_1195_424##6	2.27842e-17
C589	a_83_289##2	A#2	3.6753e-17
C590	a_440_315##9	a_1162_379#	1.12432e-18
C591	a_27_134##3	a_27_134##6	2.28159e-18
C592	a_440_315##8	VPWR#7	7.79891e-17
C593	a_27_134##2	a_83_289##3	3.72667e-19
C594	a_83_289##5	B#3	3.44197e-17
C595	B#1	VGND#8	2.62706e-17
C596	a_416_113##5	B#3	2.49279e-19
C597	X	a_1195_424#	3.67385e-17
C598	VGND#2	C	2.802e-18
C599	A#4	A#1	8.16811e-18
C600	a_372_419##2	a_440_315#	3.42588e-19
C601	X	a_1195_424##7	3.06627e-17
C602	a_1195_424##8	C	1.47483e-17
C603	X	C#5	1.05625e-18
C604	a_83_289##5	VPWR#7	2.14281e-18
C605	X	C#4	1.65669e-19
C606	a_440_315##9	B#12	1.48499e-17
C607	a_416_113#	B#8	6.51696e-19
C608	B#1	a_440_315##9	1.84385e-17
C609	VGND#3	VNB	7.54714e-17
C610	VPWR#6	VNB	7.65935e-17
C611	C	C#3	1.52142e-17
C612	B#12	VNB	2.58675e-18
C613	a_83_289##9	VNB	3.2764e-18
C614	C	a_1162_379##2	8.82125e-20
C615	a_83_289##4	B#1	5.57382e-19
C616	a_1195_424##11	X	3.28898e-17
C617	a_83_289##5	a_440_315##8	8.40232e-17
C618	a_27_134##2	VNB	1.03346e-17
C619	X	VPWR#2	3.73531e-17
C620	a_372_419##2	B#11	9.94877e-20
C621	A#6	VNB	4.30556e-19
C622	a_416_113#	B#4	7.42169e-19
C623	A#4	VNB	7.6428e-19
C624	VGND#1	VNB	6.93977e-17
C625	VGND#2	X	3.56017e-17
C626	A#4	a_83_289##3	3.07532e-18
C627	VGND#7	VNB	7.43839e-18
C628	a_1162_379##7	VNB	3.49271e-18
C629	a_416_113##5	VNB	5.90726e-18
C630	a_1195_424##10	VNB	6.3105e-18
C631	a_372_419##2	VNB	4.01636e-17
C632	VGND#8	VNB	2.53452e-18
C633	a_440_315##9	a_440_315#	5.12519e-19
C634	a_440_315##9	VNB	3.68479e-18
C635	a_440_315##3	B#3	4.69985e-19
C636	a_372_419##4	VNB	1.91084e-17
C637	a_27_134#	VNB	1.10967e-18
C638	a_416_113##4	VNB	1.36272e-17
C639	a_83_289##11	VNB	3.3669e-18
C640	a_27_134##3	VNB	5.41232e-17
C641	VPWR#1	VNB	8.05899e-17
C642	B#2	a_1162_379##2	7.26274e-18
C643	VPWR#3	VNB	8.40691e-18
C644	X	a_1195_424##4	5.6222e-17
C645	a_1162_379##5	VNB	2.99176e-17
C646	a_372_419##4	B#1	1.22387e-19
C647	a_372_419#	VNB	2.37738e-17
C648	a_416_113##7	VNB	1.38417e-17
C649	VPWR#7	VNB	1.42409e-18
C650	a_440_315##8	VNB	1.30223e-17
C651	a_83_289##5	VNB	2.45488e-17
C652	a_416_113#	VNB	4.24176e-18
C653	a_27_134##5	VNB	1.19073e-18
C654	a_372_419##6	VNB	1.82751e-18
C655	a_83_289##7	VNB	1.40003e-17
C656	VPWR#10	VNB	4.72961e-18
C657	a_27_134##6	VNB	6.52988e-17
C658	a_83_289##5	a_440_315##3	5.45124e-19
C659	a_1195_424##5	VNB	3.55058e-17
C660	a_1195_424##6	VNB	3.28037e-17
C661	a_440_315#	a_83_289##4	1.52983e-17
C662	C#1	VNB	6.16637e-17
C663	C#6	VNB	3.43976e-17
C664	a_1162_379##5	VPWR#6	1.88292e-17
C665	a_1162_379#	VNB	3.22547e-17
C666	B#1	VNB	2.85892e-17
C667	a_440_315#	VNB	2.61277e-17
C668	B#11	VNB	2.89137e-17
C669	a_440_315##7	VNB	2.47774e-17
C670	B#9	VNB	8.94441e-17
C671	A#1	VNB	2.61986e-17
C672	a_83_289##3	VNB	3.08969e-17
C673	a_1195_424#	VNB	4.78342e-17
C674	a_1195_424##7	VNB	3.32408e-17
C675	C#5	VNB	4.25787e-17
C676	C#4	VNB	4.61368e-17
C677	a_1162_379##3	VNB	4.56599e-17
C678	B#6	VNB	4.48458e-17
C679	a_440_315##6	VNB	2.78841e-17
C680	B#10	VNB	2.74834e-17
C681	a_440_315##5	VNB	3.11494e-17
C682	B#5	VNB	6.68292e-17
C683	A#3	VNB	3.29647e-17
C684	a_83_289#	VNB	4.24517e-17
C685	a_1195_424##11	VNB	4.89374e-18
C686	VPWR#2	VNB	2.2659e-16
C687	a_440_315#	a_372_419##4	2.03367e-17
C688	VGND#2	VNB	2.34115e-16
C689	a_1195_424##8	VNB	2.61519e-18
C690	a_416_113##6	VNB	2.17889e-17
C691	a_416_113##3	VNB	5.71438e-18
C692	VPWR#8	VNB	3.45871e-16
C693	VGND#4	VNB	3.53474e-16
C694	a_1195_424##4	VNB	5.10241e-17
C695	C#3	VNB	6.43709e-17
C696	a_1162_379##2	VNB	5.65716e-17
C697	B#7	VNB	4.22436e-18
C698	a_440_315##2	VNB	3.47832e-17
C699	A#2	VNB	4.33079e-17
C700	a_83_289##2	VNB	3.8832e-17
C701	C	VNB	5.07056e-18
C702	X	VNB	2.18247e-17
C703	a_1195_424##10	B#2	1.45157e-19
C704	a_27_134##6	VPWR#9	2.71643e-17
C705	VGND#5	VGND#9	1.26208e-17
C706	VGND#5	a_83_289##3	1.76594e-18
C707	VGND#5	a_83_289##2	5.43099e-19
C708	VGND#5	a_440_315##4	8.48569e-20
C709	VPWR#9	VNB	7.40905e-17
C710	VGND#5	B#5	2.18242e-19
C711	a_83_289##7	VPWR#9	6.30052e-17
C712	VGND#5	a_27_134##2	7.38137e-18
C713	a_83_289##2	VPWR#9	6.90305e-19
C714	VGND#5	A#1	2.62339e-18
C715	VGND#5	A#2	9.78685e-19
C716	VGND#4	VGND#5	1.66355e-16
C717	VGND#5	VNB	1.016e-16
C718	VPWR#9	a_83_289#	1.29892e-17
C719	VPWR#9	B#9	9.07987e-19
C720	VPWR#9	A#3	8.9658e-18
C721	VGND#5	a_416_113##4	1.15159e-17
C722	VGND#5	B#9	1.69139e-17
C723	VPWR#9	B#5	1.42915e-17
C724	VGND#5	B#11	2.28651e-19
C725	VPWR#8	VPWR#9	1.37462e-16
C726	VGND#5	B#8	4.51727e-19
C727	a_83_289##9	VPWR#9	3.15981e-19
C728	VGND#5	a_27_134##3	8.3013e-17
*
*
.ENDS sky130_fd_sc_hs__xor3_2
*
