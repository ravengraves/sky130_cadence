* Extracted by Quantus, converted by sky130cad/quantus.py
*
*
*
*                       LINUX           Wed Nov 18 09:00:57 2026
*
*
*
*  PROGRAM  advgen
*
*  Name           : advgen - Quantus - (64-bit)
*  Version        : 25.1.0-p047
*  Build Date     : Thu Dec 11 23:20:30 PST 2025
*
*  HSPICE LIBRARY
*
*  OPERATING_TEMPERATURE 150
*  QRC_TECH_DIR <path>/tech
*
*
*

*
.SUBCKT sky130_fd_sc_hs__o311a_4 VNB VPB VGND VPWR X B1 A2 A3 C1 A1
*
*
*  caps2d version: 10
*
*
*       TRANSISTOR CARDS
*
*
XM3 VGND#9 a_83_244##11 X#3 VNB sky130_fd_pr__nfet_01v8_lvt l=0.15 w=0.74 ad=0.2627 as=0.2072 pd=2.19 ps=2.04
XM11 VGND#14 a_83_244##8 X#3 VNB sky130_fd_pr__nfet_01v8_lvt l=0.15 w=0.74 ad=0.4033 as=0.2072 pd=2.57 ps=2.04
XM25 X#1 a_83_244##5 VGND#14 VNB sky130_fd_pr__nfet_01v8_lvt l=0.15 w=0.74 ad=0.259 as=0.4033 pd=2.18 ps=2.57
XM20 X#1 a_83_244# VGND#13 VNB sky130_fd_pr__nfet_01v8_lvt l=0.15 w=0.74 ad=0.259 as=0.2109 pd=2.18 ps=2.05
XM1 a_651_78##2 B1#1 a_564_78##7 VNB sky130_fd_pr__nfet_01v8_lvt l=0.15 w=0.64 ad=0.5088 as=0.178025 pd=2.87 ps=1.85
XM15 a_651_78##2 C1#6 a_83_244##14 VNB sky130_fd_pr__nfet_01v8_lvt l=0.15 w=0.64 ad=0.5088 as=0.34395 pd=2.87 ps=2.59
XM8 a_83_244##14 C1#1 a_651_78# VNB sky130_fd_pr__nfet_01v8_lvt l=0.15 w=0.64 ad=0.34395 as=0.1792 pd=2.59 ps=1.84
XM27 a_564_78##5 B1#4 a_651_78# VNB sky130_fd_pr__nfet_01v8_lvt l=0.15 w=0.64 ad=0.2432 as=0.1792 pd=2.04 ps=1.84
XM5 VGND#12 A3#4 a_564_78##5 VNB sky130_fd_pr__nfet_01v8_lvt l=0.15 w=0.64 ad=0.2464 as=0.2432 pd=2.05 ps=2.04
XM7 a_564_78##3 A3#1 VGND#12 VNB sky130_fd_pr__nfet_01v8_lvt l=0.15 w=0.64 ad=0.1824 as=0.2464 pd=1.85 ps=2.05
XM6 a_564_78##3 A2#1 VGND#11 VNB sky130_fd_pr__nfet_01v8_lvt l=0.15 w=0.64 ad=0.1824 as=0.24 pd=1.85 ps=2.03
XM9 VGND#11 A1#5 a_564_78##8 VNB sky130_fd_pr__nfet_01v8_lvt l=0.15 w=0.64 ad=0.24 as=0.2432 pd=2.03 ps=2.04
XM21 a_564_78##8 A1#1 VGND#10 VNB sky130_fd_pr__nfet_01v8_lvt l=0.15 w=0.64 ad=0.2432 as=0.1888 pd=2.04 ps=1.87
XM18 VGND#10 A2#7 a_564_78# VNB sky130_fd_pr__nfet_01v8_lvt l=0.15 w=0.64 ad=0.1888 as=0.1824 pd=1.87 ps=1.85
XM0 VPWR#6 a_83_244##13 X#5 VPB sky130_fd_pr__pfet_01v8 l=0.15 w=1.12 ad=0.3304 as=0.336 pd=2.83 ps=2.84
XM2 X#5 a_83_244##12 VPWR#12 VPB sky130_fd_pr__pfet_01v8 l=0.15 w=1.12 ad=0.336 as=0.392 pd=2.84 ps=2.94
XM16 X#6 a_83_244##9 VPWR#12 VPB sky130_fd_pr__pfet_01v8 l=0.15 w=1.12 ad=0.5432 as=0.392 pd=3.21 ps=2.94
XM23 VPWR#11 a_83_244##4 X#6 VPB sky130_fd_pr__pfet_01v8 l=0.15 w=1.12 ad=0.3868 as=0.5432 pd=2.95 ps=3.21
XM19 a_83_244##21 B1#3 VPWR#11 VPB sky130_fd_pr__pfet_01v8 l=0.15 w=1 ad=0.42 as=0.3868 pd=2.84 ps=2.95
XM12 VPWR#10 C1#5 a_83_244##21 VPB sky130_fd_pr__pfet_01v8 l=0.15 w=1 ad=0.715 as=0.42 pd=3.43 ps=2.84
XM13 a_83_244##20 C1#7 VPWR#10 VPB sky130_fd_pr__pfet_01v8 l=0.15 w=1 ad=0.35 as=0.715 pd=2.7 ps=3.43
XM10 VPWR#7 B1#6 a_83_244##20 VPB sky130_fd_pr__pfet_01v8 l=0.15 w=1 ad=0.295 as=0.35 pd=2.59 ps=2.7
XM22 a_1034_392##4 A3#6 a_83_244##19 VPB sky130_fd_pr__pfet_01v8 l=0.15 w=1 ad=0.445 as=0.32 pd=2.89 ps=2.64
XM14 a_83_244##19 A3#5 a_1034_392##2 VPB sky130_fd_pr__pfet_01v8 l=0.15 w=1 ad=0.32 as=0.305 pd=2.64 ps=2.61
XM24 a_1034_392##2 A2#3 a_1338_392##2 VPB sky130_fd_pr__pfet_01v8 l=0.15 w=1 ad=0.305 as=0.42 pd=2.61 ps=2.84
XM4 VPWR#9 A1#7 a_1338_392##2 VPB sky130_fd_pr__pfet_01v8 l=0.15 w=1 ad=0.3 as=0.42 pd=2.6 ps=2.84
XM17 a_1338_392# A1#6 VPWR#9 VPB sky130_fd_pr__pfet_01v8 l=0.15 w=1 ad=0.32 as=0.3 pd=2.64 ps=2.6
XM26 a_1338_392# A2#6 a_1034_392# VPB sky130_fd_pr__pfet_01v8 l=0.15 w=1 ad=0.32 as=0.325 pd=2.64 ps=2.65
*
*
*       RESISTOR AND CAP/DIODE CARDS
*
Rg1	a_83_244#	a_83_244##2	351.188324
Rg2	a_83_244##2	a_83_244##3	61.144661
Rg3	a_83_244##2	a_83_244##4	476.975128
Rg4	a_83_244##3	a_83_244##5	302.425262
Rg5	a_83_244##3	a_83_244##6	51.378597
Rg6	a_83_244##6	a_83_244##7	90.026917
Rg7	a_83_244##7	a_83_244##8	321.855652
Rg8	a_83_244##6	a_83_244##9	476.975128
Rg9	a_83_244##7	a_83_244##10	66.386436
Rg10	a_83_244##10	a_83_244##11	339.802612
Rg11	a_83_244##7	a_83_244##12	506.463013
Rg12	a_83_244##10	a_83_244##13	511.615417
Rg13	B1#1	B1#2	506.835419
Rg14	B1#2	B1#3	504.318359
Rg15	C1#1	C1#2	677.029236
Rg16	C1#2	C1#3	16.454807
Rg17	C1#3	C1#4	49.240993
Rg18	C1#4	C1#5	610.551208
Rg19	C1#2	C1#6	408.449280
Rg20	C1#3	C1#7	405.568939
Rg21	B1#4	B1#5	463.106628
Rg22	B1#5	B1#6	629.673767
Rg23	A3#1	A3#2	456.749146
Rg24	A3#2	A3#3	50.300888
Rg25	A3#3	A3#4	454.941925
Rg26	A3#2	A3#5	416.902710
Rg27	A3#3	A3#6	437.431122
Rg28	A2#1	A2#2	325.153564
Rg29	A2#2	A2#3	509.830780
Rg30	A1#1	A1#2	479.497955
Rg31	A1#2	A1#3	20.753328
Rg32	A1#3	A1#4	32.582375
Rg33	A1#4	A1#5	483.635010
Rg34	A1#2	A1#6	415.618561
Rg35	A1#4	A1#7	415.223511
Rg36	A2#4	A2#5	194.783905
Rg37	A2#5	A2#6	572.402466
Rg38	A2#5	A2#7	307.647919
Rf1	X#1	X#2	85.150932
Rf2	X#2	X	43.524918
Rf3	X#2	X#3	16.341667
Rf4	X	X#4	48.316002
Rf5	X#4	X#5	28.407557
Rf6	X#4	X#6	86.951324
Rf7	C1#8	C1#4	161.364883
Rf8	C1	C1#10	1.132081
Rf9	C1#8	C1#10	2.487195
Rf10	a_651_78#	a_651_78##2	96.945671
Rf11	B1#5	B1	166.334732
Rf12	B1	B1#2	346.181030
Rf13	a_83_244##14	a_83_244##15	148.932907
Rf14	a_83_244##15	a_83_244##16	98.786667
Rf15	a_83_244##16	a_83_244##17	96.312874
Rf16	a_83_244##17	a_83_244##3	138.130249
Rf17	a_83_244##15	a_83_244##19	33.853783
Rf18	a_83_244##16	a_83_244##20	17.618225
Rf19	a_83_244##17	a_83_244##21	21.715120
Rf20	A3#7	A3#2	160.866913
Rf21	A3	A3#9	0.634105
Rf22	A3#7	A3#9	3.149382
Rf23	a_1338_392#	a_1338_392##2	103.670883
Rf24	A1	A1#3	80.116402
Rf25	a_564_78#	a_564_78##2	81.904221
Rf26	a_564_78##2	a_564_78##4	64.206451
Rf27	a_564_78##4	a_564_78##6	64.381973
Rf28	a_564_78##6	a_564_78##7	208.906326
Rf29	a_564_78##2	a_564_78##8	11.260589
Rf30	a_564_78##3	a_564_78##4	7.500000
Rf31	a_564_78##5	a_564_78##6	7.500000
Rf32	a_1034_392#	a_1034_392##3	156.414047
Rf33	a_1034_392##3	a_1034_392##4	63.365501
Rf34	a_1034_392##2	a_1034_392##3	15.000000
Rf35	A2	A2#4	14.448026
Rf36	A2#4	A2	0.413953
Rf37	A2#4	A2#2	275.113098
Rf39	VGND#2	VGND#3	18.238092
Rf40	VGND#3	VGND#4	54.763340
Rf41	VGND#4	VGND#5	73.001427
Rf42	VGND#5	VGND#6	187.715240
Rf43	VGND#6	VGND#7	69.738693
Rf44	VGND#7	VGND#8	77.526459
Rf45	VGND#8	VGND#9	99.899841
Rf46	VGND#2	VGND#10	32.735970
Rf47	VGND#4	VGND#11	32.735970
Rf48	VGND#5	VGND#12	32.735970
Rf49	VGND#7	VGND#13	31.731567
Rf50	VGND#8	VGND#14	27.459908
Rf51	VPWR#1	VPWR#2	213.648163
Rf52	VPWR#2	VPWR#3	105.971733
Rf53	VPWR#3	VPWR#4	77.299416
Rf54	VPWR#4	VPWR#5	79.210724
Rf55	VPWR#5	VPWR#6	120.594025
Rf56	VPWR#2	VPWR#8	23.641058
Rf57	VPWR#8	VPWR#9	151.350143
Rf58	VPWR#3	VPWR#10	17.124172
Rf59	VPWR#4	VPWR#11	34.939823
Rf60	VPWR#5	VPWR#12	34.939823
Rf61	VPWR#7	VPWR#8	7.500000
Re1	VPWR#1	VPWR	3.735117
Re2	VPWR	VPWR#3	1.067176
Re3	VGND#3	VGND	3.735117
Re4	VGND	VGND#6	1.067176
*
*       CAPACITOR CARDS
*
*
C1	a_564_78#	VGND#10	3.97116e-17
C2	VPWR#4	a_83_244##4	2.60471e-18
C3	VGND#13	C1#6	6.71784e-19
C4	a_83_244##14	a_83_244#	6.80142e-19
C5	a_83_244##15	A2#3	4.6932e-19
C6	a_83_244##14	C1#3	8.37751e-18
C7	a_564_78##7	B1#1	4.976e-17
C8	X#6	VPWR#11	5.76646e-17
C9	a_83_244##16	A3#5	4.06205e-20
C10	VGND#13	B1#1	4.03462e-18
C11	VPWR#7	VPWR#2	2.24733e-18
C12	VPWR#5	a_83_244##9	9.94764e-19
C13	VGND#13	a_83_244##17	6.51134e-18
C14	a_564_78##7	a_83_244#	1.45681e-18
C15	VPWR#12	VPWR#11	1.23316e-18
C16	X#6	a_83_244##6	9.65167e-18
C17	a_83_244##15	A3#5	2.87535e-19
C18	a_83_244##17	VPWR#4	1.37938e-19
C19	VGND#13	a_83_244#	5.17771e-17
C20	X#6	VPWR#12	9.70625e-17
C21	a_83_244##16	A3#6	1.28378e-19
C22	a_83_244##20	VPWR#2	9.14782e-18
C23	VPWR#5	a_83_244##12	4.58911e-18
C24	a_83_244#	X#1	1.51848e-17
C25	a_83_244##15	A3#6	1.70592e-17
C26	a_651_78##2	C1#3	1.21085e-18
C27	X#5	X#6	4.30643e-18
C28	VGND#13	a_83_244##5	1.94213e-18
C29	a_83_244##17	B1#6	6.50809e-19
C30	VPWR#12	a_83_244##7	5.67701e-19
C31	VGND#14	a_83_244#	1.1533e-18
C32	VGND#11	VGND#10	2.5418e-18
C33	a_83_244##16	B1#6	1.69205e-17
C34	X#1	a_83_244##5	5.38625e-17
C35	X#5	VPWR#12	8.17562e-17
C36	VPWR#12	a_83_244##6	5.3175e-19
C37	a_83_244##15	B1#6	3.89117e-20
C38	VGND#13	a_83_244##8	2.50011e-19
C39	VPWR#10	VPWR#2	4.12906e-19
C40	VPWR#5	a_83_244##13	1.60482e-18
C41	a_83_244##5	VGND#14	2.65376e-17
C42	B1#2	C1#3	3.74774e-18
C43	a_83_244##17	C1#7	1.09059e-18
C44	VPWR#6	VPWR#12	1.51987e-18
C45	X#1	a_83_244##8	7.38234e-19
C46	a_83_244##16	VPWR#2	1.71544e-19
C47	a_83_244##21	VPWR#4	1.01086e-17
C48	a_83_244##16	C1#7	2.32572e-17
C49	a_83_244##6	B1#2	3.62757e-17
C50	a_83_244##8	VGND#14	2.88671e-17
C51	a_83_244##15	C1#7	3.36876e-19
C52	VPWR#6	X#5	8.04282e-17
C53	a_564_78##7	C1#3	2.40716e-19
C54	C1#10	B1#6	6.25256e-19
C55	VGND#9	a_83_244##5	2.50011e-19
C56	a_83_244##17	C1#5	2.85642e-17
C57	a_83_244##8	X#3	1.4935e-17
C58	a_83_244##16	C1#5	6.30694e-19
C59	VGND#14	a_83_244##11	1.50375e-18
C60	VGND#9	a_83_244##8	1.37281e-18
C61	A3#9	VPWR#9	3.96979e-18
C62	a_564_78##3	VGND#11	4.17328e-17
C63	a_83_244##11	X#3	1.5442e-17
C64	a_83_244##17	B1#3	2.02099e-17
C65	X#6	VPWR#5	1.14476e-17
C66	a_83_244##17	C1#3	3.1519e-19
C67	a_83_244##16	B1#3	1.52281e-19
C68	a_83_244##11	VGND#9	2.33039e-17
C69	a_83_244##3	a_83_244##7	5.54095e-20
C70	a_83_244##3	a_83_244##6	4.57532e-17
C71	VGND#12	VGND#11	3.01654e-18
C72	X#6	VPWR#4	7.06878e-18
C73	A1#1	A2#5	8.61988e-18
C74	a_83_244##17	a_83_244##4	1.19154e-18
C75	A1#1	A2#7	3.11259e-17
C76	a_83_244##15	A1#4	3.24008e-19
C77	C1#3	B1#6	2.11173e-17
C78	a_564_78##3	VGND#12	4.24043e-17
C79	C1#10	B1#3	3.27356e-19
C80	a_83_244##17	a_83_244##9	3.01872e-19
C81	A1#4	A2#5	2.53486e-17
C82	A1#5	A1#1	2.62035e-17
C83	a_83_244##16	C1#3	6.03454e-18
C84	a_1034_392#	A2#6	4.59123e-17
C85	a_564_78##5	a_564_78##3	2.58531e-18
C86	X#5	VPWR#5	1.66988e-17
C87	A2#6	a_1338_392#	2.57298e-17
C88	A3#9	a_83_244##19	2.8604e-17
C89	VPWR#4	VPWR#3	7.89541e-19
C90	a_1034_392#	A1#6	1.7626e-17
C91	VGND#3	VGND#4	4.35402e-17
C92	VPWR#3	VPWR#2	4.34593e-19
C93	VPWR#9	A2#6	1.41693e-18
C94	a_564_78##5	VGND#12	5.2363e-17
C95	a_83_244##15	A3#3	1.65761e-17
C96	A2#1	A1#5	2.42764e-17
C97	a_1338_392#	A1#6	4.11915e-17
C98	X#2	X#1	2.88963e-18
C99	VPWR#6	VPWR#5	8.13392e-19
C100	a_83_244##14	B1#6	6.08437e-19
C101	a_1034_392#	A1#7	2.20735e-19
C102	VPWR#9	A1#6	3.82716e-17
C103	a_83_244##15	VPWR#9	8.36319e-18
C104	a_1034_392##2	A2#6	1.379e-19
C105	a_83_244##14	a_564_78##3	7.07695e-19
C106	a_1338_392#	A1#7	2.91077e-19
C107	a_83_244##15	C1#3	1.16497e-19
C108	VPWR#5	a_83_244##10	4.01973e-20
C109	a_83_244##19	A2#6	3.4068e-19
C110	A3#1	A2#1	3.23029e-17
C111	X#2	VGND#14	5.26404e-17
C112	a_1034_392#	A2#3	1.41165e-19
C113	VPWR#9	A1#7	4.6905e-17
C114	X#4	VPWR#5	6.61394e-19
C115	a_1034_392##2	A1#6	1.8956e-19
C116	a_564_78##5	a_651_78#	1.02536e-16
C117	a_1338_392#	A2#3	1.59069e-19
C118	a_1338_392##2	A1#7	4.05033e-17
C119	a_83_244##19	A1#6	3.59917e-19
C120	VGND#3	a_564_78##2	3.4266e-17
C121	VPWR#9	A2#3	3.15447e-17
C122	C1#5	C1#3	8.09889e-19
C123	X#2	X#3	4.68449e-19
C124	a_1034_392##2	A1#7	1.6337e-17
C125	VPWR#5	a_83_244##7	4.24656e-20
C126	X#4	a_83_244##12	2.08185e-17
C127	A3#4	A3#1	2.55715e-17
C128	a_564_78##5	a_83_244##14	2.15484e-17
C129	A2#3	a_1338_392##2	2.86323e-17
C130	X#1	a_83_244##6	6.97703e-18
C131	VPWR#2	C1#3	7.98651e-20
C132	a_83_244##19	A1#7	6.47772e-19
C133	VPWR#9	A3#5	2.07802e-17
C134	a_564_78##7	C1#5	1.53412e-19
C135	a_1034_392##2	A2#3	4.43009e-17
C136	VGND#9	X#2	5.72937e-17
C137	X#4	a_83_244##13	4.57631e-18
C138	a_1338_392##2	A3#5	1.90395e-18
C139	a_651_78#	a_83_244##14	6.70984e-17
C140	a_564_78##5	a_651_78##2	8.09327e-18
C141	a_83_244##19	A2#3	2.63049e-18
C142	B1#4	A3#4	2.6053e-17
C143	VPWR#5	a_83_244##6	1.3324e-19
C144	VPWR#9	A3#6	7.13662e-18
C145	a_1034_392##2	A3#5	3.59571e-17
C146	VGND#14	a_83_244##7	4.03447e-19
C147	a_1338_392##2	A3#6	1.47874e-18
C148	a_83_244##19	A3#5	3.23896e-17
C149	a_651_78##2	a_651_78#	2.55299e-18
C150	VPWR#7	A2#3	3.05171e-19
C151	a_1034_392#	A2#5	2.38344e-18
C152	VPWR#9	B1#6	3.54031e-19
C153	a_1034_392##2	A3#6	1.13901e-18
C154	VGND#14	a_83_244##6	1.79289e-18
C155	C1#1	B1#4	4.0642e-17
C156	a_83_244##15	a_1034_392##4	4.57043e-18
C157	A3#6	a_83_244##19	2.10059e-17
C158	a_83_244##17	VPWR#3	3.28319e-19
C159	VPWR#7	A3#5	4.93768e-19
C160	a_83_244##10	X#3	1.47679e-19
C161	a_1034_392#	A1#4	1.92602e-19
C162	a_83_244##16	VPWR#7	3.53325e-17
C163	a_83_244##16	VPWR#3	1.6661e-19
C164	a_1034_392##2	B1#6	3.17542e-19
C165	a_1034_392##4	A3#6	5.10353e-17
C166	a_83_244##20	A3#5	2.27721e-19
C167	VPWR#4	a_83_244##6	2.78759e-19
C168	VGND#8	X#2	1.70709e-17
C169	VPWR#7	A3#6	1.59757e-17
C170	C1#6	C1#1	1.91596e-17
C171	a_83_244##7	X#3	6.35019e-19
C172	a_83_244##15	VPWR#7	4.5572e-17
C173	a_1034_392##4	B1#6	5.65756e-19
C174	VPWR#2	A3#2	1.62317e-20
C175	a_83_244##20	A3#6	6.04355e-19
C176	a_83_244##16	a_83_244##20	9.06133e-19
C177	VPWR#7	B1#6	5.65791e-17
C178	a_83_244##17	VPWR#10	2.63939e-17
C179	B1#1	C1#6	3.47451e-18
C180	VGND#3	a_564_78#	2.2081e-17
C181	B1#6	a_83_244##20	1.92866e-17
C182	a_564_78##7	a_651_78##2	1.13929e-16
C183	VGND#13	a_83_244##14	7.34222e-21
C184	a_83_244##10	VGND#9	2.01084e-18
C185	A3#9	A1#3	3.42298e-18
C186	VGND#3	VGND#10	1.57528e-17
C187	VPWR#7	C1#7	1.53121e-18
C188	VGND#8	a_83_244##10	2.42175e-20
C189	VPWR#10	B1#6	8.65548e-19
C190	VGND#4	A1#4	2.23046e-20
C191	a_1338_392#	A1#4	8.12846e-20
C192	a_83_244##16	VPWR#10	3.48971e-17
C193	VPWR#2	B1#5	2.73486e-19
C194	a_83_244##20	C1#7	4.57379e-17
C195	A3#7	A1#3	1.66442e-18
C196	a_83_244##17	a_83_244##21	1.59007e-18
C197	VGND#3	VGND#11	1.56041e-17
C198	a_564_78##2	A2#2	5.22438e-17
C199	VGND#4	A1#5	9.07238e-19
C200	a_83_244#	B1#1	4.62071e-18
C201	VPWR#7	C1#5	5.18258e-20
C202	C1#7	VPWR#10	2.91736e-17
C203	VGND#5	B1#5	8.82972e-20
C204	VGND#3	a_564_78##3	1.81791e-18
C205	A3#9	A2#2	9.09451e-19
C206	a_83_244##20	C1#5	6.05633e-19
C207	a_83_244##21	C1#7	3.04725e-19
C208	a_83_244##21	a_83_244##16	1.33449e-19
C209	VGND#8	a_83_244##7	1.04102e-19
C210	VGND#13	a_564_78##7	5.11144e-17
C211	a_83_244##15	A1#3	1.34295e-18
C212	VPWR#10	C1#5	5.8921e-17
C213	A3#7	A2#2	1.02218e-17
C214	a_83_244##17	VPWR#11	3.18819e-17
C215	a_83_244##5	a_83_244#	2.74819e-17
C216	a_83_244##20	B1#3	1.4623e-19
C217	VGND#4	A2#1	2.66596e-18
C218	C1#5	a_83_244##21	1.81436e-17
C219	A3#9	A3#2	1.38498e-17
C220	VPWR#10	B1#3	2.01138e-18
C221	VPWR#11	C1#5	1.15382e-18
C222	VPWR#9	A1#4	2.59503e-18
C223	B1#4	A3#3	6.68406e-19
C224	VGND#5	A3#1	2.56679e-18
C225	VPWR#4	B1#2	9.46869e-20
C226	VGND#8	a_83_244##6	6.45801e-20
C227	a_83_244##15	A2#2	7.4367e-18
C228	a_83_244##21	B1#3	4.91902e-17
C229	A3#7	A3#2	1.50232e-17
C230	X#6	a_83_244##17	2.77223e-18
C231	a_83_244##8	a_83_244##5	1.35923e-17
C232	a_564_78##3	VPWR#9	6.56025e-18
C233	VPWR#10	a_83_244##4	2.66594e-19
C234	B1#3	VPWR#11	2.26017e-17
C235	VPWR#5	VPWR#4	7.42807e-19
C236	VGND#7	B1#2	1.91809e-18
C237	X#1	VGND#13	6.25082e-17
C238	a_564_78##2	A2#7	9.56569e-19
C239	A1	A2#5	6.96718e-18
C240	VGND#6	a_564_78##5	2.83529e-17
C241	a_83_244##21	a_83_244##4	1.11586e-18
C242	X#6	B1#3	4.03928e-19
C243	a_83_244##15	A3#9	1.43492e-17
C244	a_83_244##15	A3#2	1.53721e-18
C245	VPWR#11	a_83_244##4	5.46675e-17
C246	a_1034_392#	VPWR#1	1.27941e-16
C247	VGND#5	A3#4	9.07238e-19
C248	a_83_244##11	a_83_244##8	3.66424e-17
C249	a_83_244##3	VPWR#4	3.78128e-19
C250	VPWR#1	a_1338_392#	1.02613e-17
C251	a_83_244##4	X#6	2.9435e-17
C252	VGND#14	VGND#13	1.63438e-18
C253	C1#10	a_83_244##6	2.86923e-20
C254	VPWR#1	VPWR#9	7.95724e-18
C255	VPWR#11	a_83_244##9	2.52183e-18
C256	VPWR#12	a_83_244##4	9.16463e-19
C257	a_564_78##2	A1#1	2.03689e-17
C258	VGND#7	a_83_244##3	5.41804e-19
C259	VGND#6	a_564_78##7	9.48529e-17
C260	a_1338_392##2	A1#4	3.22429e-19
C261	a_83_244##16	B1#5	2.52639e-18
C262	VPWR#1	a_1338_392##2	9.31092e-18
C263	VGND#7	a_83_244##6	1.19459e-19
C264	a_83_244##15	B1#5	1.53466e-17
C265	X#6	a_83_244##9	5.08869e-17
C266	X#5	a_83_244##4	3.20448e-19
C267	X#1	VGND#14	5.15252e-17
C268	a_1034_392##2	VPWR#1	1.138e-16
C269	VGND#5	B1#4	4.2089e-18
C270	C1#3	C1#1	1.95921e-18
C271	VPWR#12	a_83_244##9	6.45157e-17
C272	A2#2	VGND#11	1.0094e-18
C273	a_83_244##17	C1#4	5.90008e-18
C274	X#6	a_83_244##12	1.15507e-18
C275	X#5	a_83_244##9	2.15695e-18
C276	a_564_78##3	A2#2	4.07316e-17
C277	a_564_78##2	A1#5	2.00144e-17
C278	a_83_244##16	C1#4	5.31708e-18
C279	a_83_244##15	A3#7	1.84807e-17
C280	a_83_244##12	VPWR#12	2.4987e-17
C281	VPWR#6	a_83_244##9	2.56585e-19
C282	C1#1	B1#6	1.12155e-17
C283	X#5	a_83_244##12	6.33673e-17
C284	VGND#5	C1#1	4.16505e-18
C285	VPWR#12	a_83_244##13	1.48739e-18
C286	C1#10	C1#4	1.01457e-17
C287	VPWR#6	a_83_244##12	1.23062e-18
C288	a_83_244##17	B1#2	6.08342e-17
C289	a_564_78##3	A3#2	1.46627e-18
C290	a_1034_392##2	A1#4	6.53628e-20
C291	a_83_244##17	a_83_244##16	9.8604e-19
C292	B1#2	a_83_244##16	3.666e-18
C293	A2#5	a_564_78#	7.12882e-18
C294	VGND#5	a_564_78##3	8.21274e-18
C295	a_564_78##2	A2#1	4.68127e-19
C296	VGND#12	A3#2	8.74504e-19
C297	A1#6	A2#6	3.79845e-17
C298	X#5	a_83_244##13	5.36799e-17
C299	C1#8	C1#4	1.12505e-17
C300	a_564_78##5	A3#2	1.13091e-18
C301	VPWR#6	a_83_244##13	3.52467e-17
C302	a_564_78##5	a_83_244##19	1.60573e-18
C303	VGND#9	VGND#14	1.70762e-18
C304	C1#10	B1#2	1.60042e-19
C305	a_83_244##20	VPWR#3	8.48947e-18
C306	VGND#4	a_564_78##3	8.12073e-18
C307	A1#7	A1#6	4.14454e-17
C308	B1#1	C1#5	1.13666e-17
C309	B1#2	C1#8	3.85518e-17
C310	a_564_78##5	B1#5	8.80445e-19
C311	A1#3	a_1338_392#	1.55329e-17
C312	a_651_78#	B1#5	5.37154e-19
C313	a_83_244##21	VPWR#3	7.54336e-18
C314	A1#3	VPWR#9	5.75646e-17
C315	C1#8	a_83_244##6	3.4896e-20
C316	a_83_244##14	B1#5	1.13832e-17
C317	X#4	a_83_244##10	1.98532e-17
C318	VPWR#1	A2#5	3.27743e-19
C319	a_83_244##3	C1#10	2.11794e-19
C320	VPWR#11	VPWR#3	1.30888e-20
C321	A2#3	A1#7	2.07964e-17
C322	a_83_244##16	a_83_244##15	1.50383e-18
C323	VPWR#1	A1#4	2.50977e-20
C324	X#2	X#6	5.67938e-19
C325	a_83_244##3	C1#8	1.18054e-18
C326	A2#2	VPWR#9	2.29446e-17
C327	X#4	a_83_244##3	6.18212e-18
C328	X#4	VPWR#12	1.58943e-17
C329	VGND#5	a_564_78##5	7.52008e-17
C330	X#2	a_83_244##3	1.72358e-17
C331	a_1338_392##2	A2#2	3.14585e-19
C332	B1#1	C1#3	5.83606e-19
C333	VGND#3	A2#7	4.30977e-18
C334	X#4	a_83_244##7	1.12722e-17
C335	a_651_78##2	C1#4	3.04509e-18
C336	A3#5	A2#3	4.22034e-17
C337	VGND#7	a_83_244#	3.79359e-18
C338	a_1034_392##2	A2#2	1.73549e-19
C339	VGND#3	A1#1	4.4873e-18
C340	a_564_78##7	C1#4	1.1591e-18
C341	A2	A2#5	3.75175e-17
C342	VPWR#9	A3#2	5.12388e-19
C343	A2	A1#4	7.86523e-18
C344	VGND#3	A1#5	5.16856e-18
C345	X#4	X#5	3.95309e-20
C346	VGND#3	A2#1	2.02509e-18
C347	VGND#8	a_83_244##5	2.73301e-18
C348	a_1034_392##2	A3#2	3.48365e-19
C349	A3#6	A3#5	3.98602e-17
C350	a_651_78##2	B1#2	6.69511e-17
C351	X#4	a_83_244##6	1.19964e-18
C352	a_83_244##15	A1#5	1.56393e-19
C353	X#2	a_83_244##10	4.63407e-18
C354	A3#2	a_83_244##19	3.23434e-18
C355	a_564_78##2	a_564_78#	2.44845e-18
C356	B1#2	a_564_78##7	4.24483e-17
C357	VGND#3	A2#5	1.658e-19
C358	B1#2	VGND#13	2.69199e-17
C359	a_1034_392##4	A3#2	1.50994e-20
C360	VGND#8	VGND#7	9.709e-19
C361	VGND#3	A1#4	6.95202e-20
C362	a_83_244##17	C1#10	9.97272e-18
C363	B1#6	A3#6	3.24877e-18
C364	X#4	VPWR#6	7.46798e-18
C365	X#2	a_83_244##7	1.05051e-17
C366	a_1034_392#	a_1338_392#	1.16406e-16
C367	a_1034_392##4	B1#5	1.00791e-18
C368	VGND#8	a_83_244##8	2.73301e-18
C369	VGND#13	a_83_244##3	1.81419e-17
C370	a_564_78##2	VGND#10	4.37442e-17
C371	VPWR#7	B1#5	2.9021e-18
C372	a_83_244##3	X#1	6.50528e-17
C373	C1#7	B1#6	3.40277e-17
C374	a_83_244##3	VGND#14	4.80352e-18
C375	C1#10	a_83_244##16	3.29272e-17
C376	B1	A3#3	4.81099e-18
C377	B1	C1#3	3.07966e-17
C378	a_1034_392#	VPWR#9	1.04993e-18
C379	X#2	a_83_244##6	2.66657e-18
C380	VGND#6	C1#1	2.7793e-21
C381	VPWR#3	B1#1	1.39481e-20
C382	a_83_244##15	A3#1	6.72447e-19
C383	C1#5	C1#7	6.93999e-18
C384	VGND#8	a_83_244##11	1.77853e-18
C385	VGND#6	C1#6	4.2086e-18
C386	a_564_78##2	a_564_78##8	1.40614e-17
C387	C1#4	VPWR#10	3.82678e-18
C388	A2#2	A1#5	1.58322e-17
C389	a_1338_392#	VPWR#9	4.86696e-17
C390	a_1338_392##2	a_1034_392#	6.86359e-18
C391	VGND#6	B1#1	4.15004e-18
C392	VGND#7	a_564_78##7	1.09786e-17
C393	VPWR#1	A2#6	6.74279e-18
C394	a_564_78#	A2#7	2.72533e-17
C395	A3#1	A2#2	7.90071e-18
C396	B1#3	C1#5	2.81793e-17
C397	a_83_244##15	A3#4	5.60344e-18
C398	VPWR#1	A1#6	6.0749e-18
C399	A2#2	A3#4	4.82625e-19
C400	VGND#8	VGND#13	2.06412e-19
C401	a_1034_392##2	a_1034_392#	1.20163e-18
C402	VPWR#3	C1#3	4.14425e-20
C403	VPWR#1	A1#7	6.09604e-18
C404	a_564_78##2	VGND#11	4.42967e-17
C405	VGND#10	A2#7	2.72739e-17
C406	a_83_244##4	B1#3	4.08429e-17
C407	VPWR#1	A2#3	4.72929e-18
C408	a_564_78#	A1#1	8.22205e-19
C409	X	a_83_244##10	9.04023e-18
C410	VPWR#1	A3#5	3.93921e-18
C411	VPWR#9	a_1338_392##2	7.10554e-17
C412	a_83_244##3	VPWR#11	1.55144e-17
C413	a_83_244##3	X#6	7.38918e-17
C414	VGND#8	X#1	8.75633e-18
C415	a_83_244##9	a_83_244##4	2.37858e-17
C416	VGND#10	A1#1	2.59639e-17
C417	a_564_78##3	a_564_78##2	2.59023e-18
C418	a_83_244##16	C1#1	1.19406e-18
C419	C1#1	B1#5	1.01771e-17
C420	a_564_78#	A1#5	1.87e-19
C421	VPWR#9	a_1034_392##2	6.62152e-17
C422	A1#1	a_564_78##8	8.26373e-18
C423	a_83_244##12	a_83_244##9	3.82418e-17
C424	a_83_244##15	C1#1	2.25896e-19
C425	VGND#7	X#1	9.14462e-18
C426	VGND#5	VGND#4	1.10752e-18
C427	a_564_78##3	A2#7	3.85534e-19
C428	VGND#10	A1#5	1.30704e-18
C429	VPWR#3	B1#6	4.32832e-19
C430	VGND#6	C1#3	9.27385e-20
C431	a_1034_392##2	a_1338_392##2	6.85347e-17
C432	VPWR#9	a_83_244##19	4.60042e-17
C433	VGND#11	A1#1	8.03551e-19
C434	B1#1	C1#4	1.11372e-17
C435	VPWR#3	C1#7	4.67484e-18
C436	a_83_244##13	a_83_244##12	4.84109e-17
C437	VPWR	C1#3	2.15988e-19
C438	A1#3	A2#3	1.09711e-18
C439	A1#5	a_564_78##8	1.07177e-17
C440	VPWR#3	C1#5	6.80266e-18
C441	VPWR	a_83_244##6	3.34538e-19
C442	a_83_244##17	B1#1	1.70009e-18
C443	B1#2	B1#1	1.22472e-17
C444	a_564_78##3	A1#1	6.89037e-19
C445	VPWR#3	B1#3	3.3285e-19
C446	VGND#10	A2#1	3.20692e-19
C447	a_83_244##10	a_83_244##7	3.89437e-18
C448	VPWR#9	a_1034_392##4	1.38274e-17
C449	VGND#6	C1#5	5.35554e-21
C450	B1#2	a_83_244#	2.54879e-18
C451	VPWR#3	a_83_244##4	5.41324e-20
C452	A1#5	VGND#11	2.62384e-17
C453	B1#2	a_83_244##5	7.14777e-19
C454	a_564_78##2	A1#4	1.27888e-18
C455	A3#2	A2#3	5.21813e-18
C456	B1#2	a_83_244##8	3.60405e-19
C457	B1#2	a_83_244##11	2.77089e-20
C458	a_1034_392##2	a_83_244##19	1.80111e-18
C459	a_1338_392##2	a_1034_392##4	5.43291e-19
C460	a_564_78##3	A1#5	1.89055e-18
C461	a_564_78##2	A2	2.8635e-17
C462	A2#1	VGND#11	2.20471e-17
C463	A1	a_1034_392#	1.00813e-18
C464	B1#5	A3#6	4.39504e-18
C465	A1	a_1338_392#	1.74143e-17
C466	VGND#12	A1#5	3.83573e-19
C467	VPWR#2	A2#3	4.8709e-20
C468	VGND	a_83_244##7	6.2396e-19
C469	a_564_78##3	A2#1	5.29452e-17
C470	VGND	a_83_244##6	9.51961e-19
C471	VGND#9	VGND#8	1.1926e-18
C472	a_564_78##3	A3#7	1.06173e-17
C473	VGND#11	A3#1	8.29552e-19
C474	a_564_78#	A2	4.94909e-17
C475	VGND#12	A2#1	8.43275e-19
C476	VPWR#10	C1#3	5.76074e-20
C477	A1#3	A1#4	3.86951e-17
C478	B1	a_83_244##16	5.52908e-17
C479	VPWR#1	A1#3	3.09596e-18
C480	B1	a_83_244##15	6.60649e-17
C481	a_564_78##3	A3#1	5.43561e-17
C482	B1#2	C1#5	9.76404e-18
C483	C1#10	B1	3.48275e-18
C484	VGND#3	A1#3	3.2578e-18
C485	VPWR#1	A2#2	2.68153e-18
C486	VPWR#2	A3#5	2.00144e-19
C487	C1#8	B1	1.86706e-17
C488	VGND#11	A3#4	3.81719e-19
C489	a_83_244##3	C1#5	6.87902e-19
C490	a_83_244##4	B1#2	2.16138e-18
C491	VGND#3	A2#2	5.41078e-18
C492	VPWR#1	A3#2	3.23184e-20
C493	VGND#12	A3#3	1.11477e-19
C494	A3#1	VGND#12	2.08902e-17
C495	a_83_244##3	a_83_244##4	3.3249e-18
C496	VPWR	VPWR#5	7.34361e-17
C497	A1#4	A2#6	9.72184e-18
C498	VPWR	VPWR#4	6.24813e-17
C499	A2	a_1034_392#	2.96797e-17
C500	a_564_78##3	A3#4	1.59426e-18
C501	VPWR	VPWR#2	1.20201e-16
C502	a_83_244##3	a_83_244##9	3.51468e-19
C503	VPWR#7	a_1034_392##4	7.21893e-17
C504	a_651_78#	B1	5.67207e-19
C505	B1	a_83_244##14	1.0878e-16
C506	a_564_78##5	A3#1	8.30461e-19
C507	a_651_78##2	B1	1.13964e-17
C508	X	X#4	9.14365e-18
C509	a_564_78##5	A3#7	2.96671e-18
C510	A2#2	A1#3	5.43006e-17
C511	a_83_244##7	a_83_244##6	4.03777e-18
C512	a_83_244##14	A2#1	3.10198e-20
C513	A3#4	VGND#12	2.15112e-17
C514	VPWR#2	A3#6	6.72403e-18
C515	A1#3	A3#2	1.46207e-18
C516	VPWR	A3#9	2.95661e-18
C517	A2#2	A2#5	1.79705e-19
C518	VGND#6	C1#4	1.27823e-19
C519	VPWR#3	B1#2	4.3779e-20
C520	a_564_78##3	B1#4	4.2241e-19
C521	A3#2	A2#2	3.62896e-17
C522	VPWR	a_83_244##17	4.71794e-18
C523	A3#9	A1#4	9.1708e-19
C524	A2#2	A1#4	4.33803e-17
C525	VPWR	a_83_244##16	4.20564e-18
C526	VPWR	a_83_244##15	5.23571e-18
C527	VGND#6	B1#2	8.25316e-20
C528	a_564_78##5	A3#4	3.39784e-17
C529	A1	A2#6	9.65915e-18
C530	VPWR	C1#10	2.05736e-18
C531	VGND	VGND#8	8.06588e-17
C532	VGND	VGND#7	6.06146e-17
C533	a_83_244##14	A3#1	5.85743e-20
C534	VPWR	X#4	4.35211e-18
C535	VGND	VGND#5	1.01252e-16
C536	A2	A1#1	7.92231e-18
C537	VGND#9	VPWR#6	3.32361e-19
C538	VGND	VGND#4	1.24421e-17
C539	VGND#12	B1#4	3.18826e-19
C540	a_83_244##20	VPWR#7	6.21569e-17
C541	VGND#9	X	3.38093e-17
C542	A2#2	A3#3	4.09502e-19
C543	a_651_78#	A3#4	6.63673e-19
C544	a_564_78##5	A3#3	5.37097e-19
C545	a_564_78##3	C1#1	1.27824e-19
C546	VPWR#2	B1#6	5.59549e-18
C547	VGND	A3#7	4.1113e-18
C548	X#2	a_83_244#	2.63242e-19
C549	a_564_78##5	B1#4	2.9635e-17
C550	VGND	a_83_244##17	4.20232e-18
C551	A2#5	VNB	6.26372e-17
C552	A1#4	VNB	6.51489e-17
C553	VGND	a_83_244##16	3.0877e-18
C554	A3#3	VNB	2.49777e-17
C555	VGND	a_83_244##15	2.17873e-18
C556	C1#3	VNB	5.5676e-17
C557	a_83_244##10	VNB	2.96788e-17
C558	VPWR#10	VPWR#7	1.31161e-18
C559	a_83_244##7	VNB	2.68579e-17
C560	a_83_244##6	VNB	6.94396e-17
C561	a_83_244##14	A3#4	1.09018e-19
C562	B1#2	C1#4	1.82433e-17
C563	VGND	C1#8	2.0863e-18
C564	VGND	X#4	3.43355e-18
C565	VGND	X#2	2.02689e-17
C566	VPWR	VPWR#9	1.03728e-17
C567	B1	C1#1	6.97498e-18
C568	X	VPWR#6	2.68404e-17
C569	X#2	X#4	3.88077e-17
C570	B1	C1#6	5.11486e-18
C571	VPWR	a_1034_392##2	2.33514e-17
C572	a_651_78#	B1#4	2.49652e-17
C573	A2	A2#6	3.7529e-18
C574	VPWR	a_83_244##19	2.15778e-18
C575	B1	B1#1	3.26638e-19
C576	a_564_78##5	C1#3	4.95478e-19
C577	VGND	a_564_78##3	1.89107e-17
C578	VPWR	a_1034_392##4	2.04615e-17
C579	VGND	VGND#12	1.57528e-17
C580	a_83_244##3	B1#2	2.91311e-17
C581	VGND	a_564_78##5	4.44708e-17
C582	VPWR	VPWR#7	7.07865e-18
C583	a_564_78##3	C1#6	2.07653e-19
C584	VGND	a_651_78#	1.06869e-17
C585	VPWR	a_83_244##20	1.74667e-17
C586	VGND	a_83_244##14	6.61822e-18
C587	VPWR	VPWR#10	4.16078e-17
C588	VGND	a_651_78##2	1.44645e-17
C589	VPWR	a_83_244##21	1.77719e-17
C590	VGND	a_564_78##7	4.28816e-17
C591	VPWR#10	a_83_244##20	6.47688e-17
C592	a_564_78##5	C1#1	1.03174e-17
C593	VGND	VGND#13	1.90546e-17
C594	VPWR	VPWR#11	2.24459e-17
C595	VPWR#1	A1	1.64623e-18
C596	X#2	a_83_244##5	1.28536e-18
C597	VGND	X#1	1.88295e-17
C598	VPWR	X#6	1.92814e-17
C599	VGND	VGND#14	2.28857e-17
C600	VPWR	VPWR#12	2.17041e-17
C601	VGND#3	A1	1.17931e-18
C602	VPWR	X#5	1.73706e-17
C603	VGND	VGND#9	6.43695e-17
C604	VPWR#2	C1#7	1.04208e-18
C605	VPWR	VPWR#6	5.71494e-17
C606	a_83_244##14	B1#4	1.20167e-17
C607	X	a_83_244##11	8.69433e-18
C608	a_651_78#	C1#1	3.17346e-17
C609	B1	B1#6	4.46765e-18
C610	VPWR	C1#1	2.74148e-19
C611	A3#3	A3#2	6.78033e-18
C612	a_83_244##21	a_83_244##20	1.07501e-18
C613	VGND	X#6	4.24012e-18
C614	a_1034_392##2	VPWR#2	4.67916e-18
C615	VPWR#5	VNB	3.75243e-17
C616	VPWR#4	VNB	3.30846e-17
C617	VGND	VPWR#6	1.21667e-18
C618	VPWR#2	VNB	5.36499e-17
C619	VGND#8	VNB	4.25823e-17
C620	a_564_78##5	C1#6	5.40443e-19
C621	VGND#7	VNB	3.25805e-17
C622	VGND#5	VNB	5.74142e-17
C623	A2	VPWR#1	5.82896e-18
C624	VGND#4	VNB	2.89371e-17
C625	X#2	a_83_244##8	4.1429e-17
C626	VGND	A2#1	6.44878e-18
C627	VGND#3	A2	8.48028e-18
C628	VGND	A3#1	9.70632e-18
C629	a_564_78##5	a_83_244##15	3.33308e-17
C630	a_83_244##14	C1#1	2.73568e-17
C631	VGND	A3#4	5.16856e-18
C632	a_564_78##2	VNB	5.8584e-18
C633	A3#9	VNB	1.7314e-19
C634	A3#7	VNB	2.72615e-18
C635	A3#9	A2#3	8.06771e-19
C636	VPWR	A2#3	1.35778e-18
C637	a_83_244##17	VNB	5.64315e-18
C638	a_83_244##16	VNB	2.59636e-18
C639	VGND	B1#1	7.01395e-20
C640	VPWR	A3#5	3.97791e-19
C641	a_83_244##15	VNB	5.46736e-18
C642	VGND	a_83_244#	2.594e-19
C643	VPWR	A3#6	1.3079e-18
C644	a_564_78##7	B1#4	1.75409e-19
C645	C1#10	VNB	2.04075e-18
C646	VGND	a_83_244##5	3.23819e-20
C647	A2	A1#3	2.07468e-17
C648	a_83_244##21	VPWR#10	4.84252e-17
C649	VPWR	B1#6	1.58788e-18
C650	C1#8	VNB	1.86485e-18
C651	VGND	a_83_244##8	2.89749e-19
C652	X#4	VNB	3.21008e-18
C653	VPWR#2	C1#5	7.61452e-20
C654	a_651_78#	C1#6	7.26129e-19
C655	X#2	VNB	5.50903e-18
C656	VGND	a_83_244##11	4.34081e-19
C657	A2#2	A2	1.4958e-18
C658	a_564_78#	VNB	3.39052e-17
C659	VGND#10	VNB	1.49336e-18
C660	VPWR	C1#5	5.75323e-19
C661	VGND#11	VNB	3.83049e-18
C662	VPWR	B1#3	3.12686e-19
C663	a_564_78##3	VNB	5.48577e-18
C664	VGND#12	VNB	4.26624e-18
C665	a_564_78##5	VNB	1.1321e-17
C666	VPWR	a_83_244##4	2.97671e-18
C667	a_83_244##14	VNB	4.48309e-18
C668	VPWR	a_83_244##9	6.3471e-19
C669	a_651_78##2	C1#1	1.03722e-18
C670	a_564_78##7	VNB	1.61314e-17
C671	VGND#13	VNB	9.93298e-18
C672	VPWR	a_83_244##12	1.68059e-18
C673	X#1	VNB	2.60821e-18
C674	a_83_244##15	A1#6	4.25072e-21
C675	VGND#14	VNB	4.23974e-18
C676	VPWR	a_83_244##13	2.66141e-18
C677	VGND#9	VNB	5.95111e-17
C678	a_651_78#	C1#3	8.67443e-19
C679	a_564_78##5	B1#1	3.29456e-19
C680	a_1034_392#	VNB	5.66696e-17
C681	B1	B1#5	2.82893e-17
C682	VPWR#9	VNB	1.01611e-18
C683	VPWR	VPWR#1	4.10679e-17
C684	a_1338_392##2	VNB	1.34907e-18
C685	VGND	C1#5	1.34601e-18
C686	a_1034_392##2	VNB	5.83004e-18
C687	a_83_244##19	VNB	8.6673e-19
C688	a_1034_392##4	VNB	3.34824e-18
C689	VPWR#7	VNB	9.42113e-18
C690	VPWR	VPWR#3	8.95706e-17
C691	a_83_244##20	VNB	2.73306e-18
C692	C1#6	a_83_244##14	2.05496e-17
C693	B1#2	B1	1.49932e-18
C694	X#2	a_83_244##11	2.37383e-17
C695	VPWR#10	VNB	2.2055e-18
C696	a_83_244##21	VNB	2.81266e-18
C697	VPWR#11	VNB	1.2667e-18
C698	X#6	VNB	7.49327e-18
C699	VPWR#11	VPWR#10	1.41277e-18
C700	VPWR#12	VNB	1.00182e-18
C701	X#5	VNB	2.2083e-18
C702	VPWR#6	VNB	7.99263e-17
C703	A2#7	VNB	3.2392e-17
C704	A1#1	VNB	2.88838e-17
C705	VPWR	A2#2	1.18896e-18
C706	A1#5	VNB	3.17218e-17
C707	a_564_78##7	C1#1	2.65434e-19
C708	A2#1	VNB	2.98224e-17
C709	A3#1	VNB	3.32757e-17
C710	A3#4	VNB	3.12063e-17
C711	X	a_83_244##3	6.64815e-19
C712	B1#4	VNB	2.99294e-17
C713	VPWR	B1#5	3.4757e-20
C714	A3#7	A1#4	5.77992e-20
C715	C1#1	VNB	4.37985e-17
C716	VGND	VGND#6	8.53307e-17
C717	C1#6	VNB	2.72767e-17
C718	VPWR#4	B1#3	2.74055e-18
C719	a_651_78#	B1#1	3.57515e-20
C720	B1#1	VNB	4.48223e-17
C721	a_83_244#	VNB	2.91074e-17
C722	a_83_244##5	VNB	2.61394e-17
C723	VPWR	B1#2	2.83117e-18
C724	a_83_244##8	VNB	2.64672e-17
C725	a_83_244##11	VNB	3.18758e-17
C726	VGND	A2#2	8.43505e-19
C727	VPWR	a_83_244##3	6.35014e-18
C728	A2#6	VNB	4.646e-17
C729	A2	A1	4.84642e-17
C730	A1#6	VNB	3.0288e-17
C731	A1#7	VNB	3.02474e-17
C732	a_651_78##2	C1#6	4.8935e-17
C733	A2#3	VNB	3.63773e-17
C734	A3#5	VNB	2.90191e-17
C735	A3#6	VNB	3.67369e-17
C736	B1#6	VNB	3.96018e-17
C737	VGND	B1#2	1.36148e-17
C738	C1#7	VNB	2.94651e-17
C739	C1#5	VNB	4.63002e-17
C740	VGND	a_83_244##3	8.21851e-18
C741	B1#3	VNB	3.55364e-17
C742	a_83_244##4	VNB	3.60156e-17
C743	a_83_244##9	VNB	3.20442e-17
C744	a_83_244##12	VNB	3.47623e-17
C745	a_83_244##13	VNB	4.68203e-17
C746	VGND#13	C1#1	5.22087e-19
C747	VPWR#11	a_83_244##21	6.57339e-17
C748	B1#5	A3#3	3.04689e-17
C749	a_83_244##15	A1#7	6.24035e-21
C750	VPWR#1	VNB	2.21177e-16
C751	VGND#3	VNB	1.49083e-16
C752	VPWR#11	a_83_244##6	7.1893e-19
C753	VPWR#3	VNB	4.46341e-17
C754	VGND#6	VNB	5.35953e-17
C755	a_83_244##14	B1#1	1.46803e-18
C756	A1#3	VNB	4.26846e-18
C757	A2#2	VNB	3.93934e-17
C758	A3#2	VNB	3.38565e-17
C759	B1#5	VNB	4.86023e-17
C760	C1#4	VNB	5.37265e-17
C761	B1#2	VNB	6.56028e-17
C762	C1#3	B1#5	1.22272e-18
C763	a_83_244##3	VNB	5.46601e-18
C764	VPWR	B1	6.16839e-18
C765	a_564_78##7	C1#6	1.23421e-17
C766	VPWR	X	2.06904e-18
C767	VGND	B1	5.33961e-18
C768	VGND	X	3.16666e-18
C769	A1	VNB	4.73348e-18
C770	a_83_244##14	a_83_244##15	5.29131e-19
C771	A2	VNB	3.86336e-17
C772	B1	VNB	8.76393e-18
C773	a_1034_392##4	VPWR#2	2.95627e-17
C774	X	VNB	3.14511e-17
C775	VPWR	VNB	2.9418e-16
C776	VGND	VNB	3.13705e-16
C777	VGND#4	a_564_78##2	5.3001e-18
C778	A2#3	A1#4	4.1714e-18
C779	B1#1	a_651_78##2	1.96565e-17
C780	VGND#2	a_564_78#	1.18549e-17
C781	VGND#2	A2	8.51729e-19
C782	VGND#2	VNB	1.78438e-17
C783	VGND#3	VGND#2	2.22731e-17
C784	VGND#2	A2#5	5.46579e-19
*
*
.ENDS sky130_fd_sc_hs__o311a_4
*
