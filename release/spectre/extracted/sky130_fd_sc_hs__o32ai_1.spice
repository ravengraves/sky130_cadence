* Extracted by Quantus, converted by sky130cad/quantus.py
*
*
*
*                       LINUX           Wed Nov 18 09:03:15 2026
*
*
*
*  PROGRAM  advgen
*
*  Name           : advgen - Quantus - (64-bit)
*  Version        : 25.1.0-p047
*  Build Date     : Thu Dec 11 23:20:30 PST 2025
*
*  HSPICE LIBRARY
*
*  OPERATING_TEMPERATURE 150
*  QRC_TECH_DIR <path>/tech
*
*
*

*
.SUBCKT sky130_fd_sc_hs__o32ai_1 VNB VPB VGND VPWR Y B1 A1 B2 A3 A2
*
*
*  caps2d version: 10
*
*
*       TRANSISTOR CARDS
*
*
XM9 a_27_74##4 B1#4 Y#3 VNB sky130_fd_pr__nfet_01v8_lvt l=0.15 w=0.74 ad=0.2109 as=0.4329 pd=2.05 ps=2.65
XM6 Y#3 B2#1 a_27_74##2 VNB sky130_fd_pr__nfet_01v8_lvt l=0.15 w=0.74 ad=0.4329 as=0.259 pd=2.65 ps=2.18
XM4 a_27_74##2 A3#1 VGND#4 VNB sky130_fd_pr__nfet_01v8_lvt l=0.15 w=0.74 ad=0.259 as=0.333 pd=2.18 ps=2.38
XM3 VGND#4 A2#1 a_27_74# VNB sky130_fd_pr__nfet_01v8_lvt l=0.15 w=0.74 ad=0.333 as=0.2072 pd=2.38 ps=2.04
XM1 a_27_74# A1#3 VGND#1 VNB sky130_fd_pr__nfet_01v8_lvt l=0.15 w=0.74 ad=0.2072 as=0.2109 pd=2.04 ps=2.05
XM2 VPWR#3 B1#1 a_128_368# VPB sky130_fd_pr__pfet_01v8 l=0.15 w=1.12 ad=0.3752 as=0.3024 pd=2.91 ps=2.78
XM0 a_128_368# B2#3 Y#1 VPB sky130_fd_pr__pfet_01v8 l=0.15 w=1.12 ad=0.3024 as=0.56 pd=2.78 ps=3.24
XM7 Y#1 A3#3 a_342_368# VPB sky130_fd_pr__pfet_01v8 l=0.15 w=1.12 ad=0.56 as=0.4704 pd=3.24 ps=3.08
XM8 a_342_368# A2#3 a_456_368# VPB sky130_fd_pr__pfet_01v8 l=0.15 w=1.12 ad=0.4704 as=0.4704 pd=3.08 ps=3.08
XM5 a_456_368# A1#4 VPWR#1 VPB sky130_fd_pr__pfet_01v8 l=0.15 w=1.12 ad=0.4704 as=0.3304 pd=3.08 ps=2.83
*
*
*       RESISTOR AND CAP/DIODE CARDS
*
Rg1	B1#1	B1#2	576.058960
Rg2	B1#2	B1#3	38.471840
Rg3	B1#2	B1#4	410.888580
Rg4	B2#1	B2#2	409.393127
Rg5	B2#2	B2#3	451.603058
Rg6	A3#1	A3#2	382.539734
Rg7	A3#2	A3#3	434.639221
Rg8	A2#1	A2#2	382.539734
Rg9	A2#2	A2#3	434.639221
Rg10	A1#1	A1#2	35.535461
Rg11	A1#2	A1#3	322.953644
Rg12	A1#2	A1#4	507.075531
Rf1	B1	B1#5	0.705966
Rf2	B1#6	B1#3	160.938766
Rf3	B1#5	B1#6	3.543054
Rf4	B2#2	B2#5	161.149612
Rf5	B2#6	B2	0.916808
Rf6	B2#5	B2#6	5.739682
Rf7	Y#2	Y	0.130472
Rf8	Y	Y#3	106.433815
Rf9	Y#1	Y#2	5.000000
Rf10	A3	A3#2	166.137894
Rf11	A2#2	A2	165.146637
Rf12	a_27_74#	a_27_74##3	97.169380
Rf13	a_27_74##3	a_27_74##4	106.928566
Rf14	a_27_74##2	a_27_74##3	7.500000
Rf15	A1#5	A1	1.323686
Rf16	A1#1	A1#7	161.556488
Rf17	A1#5	A1#7	3.304946
Rf18	VPWR#1	VPWR#2	131.056259
Rf19	VPWR#2	VPWR#3	137.187042
Rf20	VGND#1	VGND#2	107.660652
Rf21	VGND#2	VGND#3	24.447384
Rf22	VGND#2	VGND#4	37.066368
Re1	VPWR#2	VPWR	1.403190
Re2	VGND	VGND#3	1.403242
*
*       CAPACITOR CARDS
*
*
C1	VGND	VNB	6.83208e-17
C2	VPWR	VNB	6.9627e-17
C3	Y	VNB	8.25106e-18
C4	A1	VNB	1.11731e-17
C5	A3	VNB	2.2907e-18
C6	A2	VNB	5.70533e-18
C7	B1#3	VNB	6.45113e-17
C8	B2#2	VNB	3.76699e-17
C9	A3#2	VNB	2.44258e-17
C10	A2#2	VNB	3.3209e-17
C11	VPWR	Y	3.02105e-17
C12	VGND#3	VNB	2.19819e-16
C13	VGND	A1	4.05124e-18
C14	VPWR#2	VNB	2.01206e-16
C15	B1#1	VNB	4.36439e-17
C16	B2#3	VNB	3.49101e-17
C17	A3#3	VNB	3.47018e-17
C18	A2#3	VNB	3.26403e-17
C19	VGND	A3	3.8027e-18
C20	A1#4	VNB	4.33382e-17
C21	B1#6	Y#3	1.7012e-17
C22	B1#4	VNB	3.75778e-17
C23	VGND	A2	4.88941e-18
C24	B2#1	VNB	3.10755e-17
C25	A3#1	VNB	3.19253e-17
C26	A2#1	VNB	3.12975e-17
C27	A1#3	VNB	3.16437e-17
C28	VPWR#3	VNB	9.46164e-17
C29	VPWR	A3	1.08693e-17
C30	VGND#4	VGND#1	1.58046e-18
C31	VPWR#1	VNB	9.22843e-17
C32	VPWR	A2	1.82487e-17
C33	a_27_74##4	VNB	3.74763e-17
C34	Y#3	VNB	8.45627e-18
C35	a_27_74##2	VNB	1.90284e-17
C36	VGND#4	VNB	2.68344e-18
C37	a_27_74#	VNB	1.86817e-17
C38	Y	A3	5.91045e-17
C39	VGND#1	VNB	6.46801e-17
C40	B1#5	VNB	7.07094e-18
C41	B1#6	VNB	1.17802e-17
C42	VGND	B1#3	7.30575e-19
C43	B2#5	VNB	2.20089e-18
C44	Y	A2	1.34551e-17
C45	B2#6	VNB	1.79258e-18
C46	VGND#2	A1#3	2.26786e-18
C47	A1#7	VNB	1.45296e-17
C48	Y	a_128_368#	1.28301e-18
C49	VGND#2	VNB	2.90343e-17
C50	VGND	VGND#3	4.52599e-17
C51	VPWR	B1#3	6.87871e-19
C52	VPWR	A2#2	5.33303e-23
C53	Y	B1#3	5.24018e-19
C54	VGND#1	a_27_74#	6.57636e-17
C55	Y	B2#2	5.92378e-18
C56	VPWR	VPWR#2	4.20621e-17
C57	VGND	B1#4	2.71043e-18
C58	A3	A2	1.07596e-16
C59	VGND	B2#1	1.00545e-18
C60	VPWR	B1#1	5.56447e-18
C61	VGND	A3#1	1.8804e-19
C62	VGND	A2#1	4.51442e-21
C63	VPWR	B2#3	3.21635e-19
C64	VGND	A1#3	5.15445e-18
C65	VPWR	A3#3	7.25338e-19
C66	VGND	VPWR#3	2.72043e-18
C67	VPWR	A2#3	2.60803e-19
C68	Y	VPWR#2	2.55809e-17
C69	VPWR	A1#4	4.43867e-18
C70	Y#3	B2#5	3.62022e-17
C71	A3	a_342_368#	6.50928e-18
C72	A1	B2#2	1.99811e-19
C73	Y	B1#1	3.10284e-17
C74	VGND	VPWR#1	2.54825e-18
C75	VGND	a_27_74##4	2.47595e-17
C76	Y	B2#3	5.50019e-17
C77	VGND	Y#3	1.0341e-17
C78	A1	A3#2	2.80852e-19
C79	VGND	a_27_74##2	2.66016e-17
C80	A2	a_342_368#	2.92053e-18
C81	Y	A3#3	1.76496e-17
C82	A1	A2#2	4.75987e-19
C83	VGND	a_27_74#	1.7786e-17
C84	Y	A2#3	2.27313e-18
C85	VGND	VGND#1	3.88028e-17
C86	VPWR	VPWR#3	4.87406e-17
C87	A2	a_456_368#	1.17281e-18
C88	Y	A1#4	3.89698e-19
C89	VGND	B1#5	3.0254e-18
C90	A1#2	VNB	6.6074e-17
C91	VGND	B2#5	3.72053e-18
C92	A3	B2#2	4.17895e-18
C93	VPWR	VPWR#1	4.94508e-17
C94	A3	A3#2	1.74648e-17
C95	a_27_74##2	B2#5	2.86637e-18
C96	A3	A2#2	2.29018e-18
C97	VPWR#3	Y	1.23808e-16
C98	VGND	VGND#2	4.22647e-17
C99	A2	A3#2	4.76485e-18
C100	Y	Y#1	8.76734e-18
C101	A2	A2#2	1.96365e-17
C102	VPWR	B1#6	2.13169e-18
C103	Y#3	B2#6	6.88929e-18
C104	A3	VPWR#2	3.78661e-18
C105	Y	VPWR#1	2.12756e-18
C106	VPWR	B2#6	2.53789e-18
C107	Y#3	Y	2.58145e-18
C108	a_27_74##2	Y	4.20631e-18
C109	A3	B1#1	1.12119e-19
C110	A1	B2#1	4.46244e-19
C111	A2	VPWR#2	1.54155e-17
C112	A1	A3#1	6.27237e-19
C113	A3	B2#3	1.62853e-18
C114	A1	A2#1	1.06304e-18
C115	VPWR	A1#7	3.2415e-18
C116	A3	A3#3	2.60438e-17
C117	A3#2	a_342_368#	4.74264e-19
C118	A3	A2#3	4.87435e-18
C119	A2	B2#3	1.19775e-18
C120	Y#3	A1#2	2.55158e-19
C121	Y	B2#6	4.63769e-17
C122	A2	A3#3	9.69996e-18
C123	A2#2	a_456_368#	4.65275e-19
C124	A2	A2#3	4.33307e-17
C125	B1#3	B2#2	2.12663e-17
C126	A2	A1#4	1.86255e-17
C127	B1#1	a_128_368#	2.2776e-17
C128	B2#3	a_128_368#	1.98156e-17
C129	B2#2	A3#2	2.97823e-17
C130	VGND#1	A1	3.3784e-17
C131	A3	Y#1	3.50291e-18
C132	A1#7	VPWR#1	2.8851e-17
C133	VGND#3	B1#3	2.97766e-19
C134	A3#3	a_342_368#	1.93016e-17
C135	A3#2	A2#2	2.50788e-17
C136	A2#3	a_342_368#	2.84101e-17
C137	VGND#3	B2#2	1.19566e-19
C138	VPWR#2	B2#2	9.9093e-20
C139	A2#3	a_456_368#	2.83564e-17
C140	VGND#3	A3#2	5.43791e-20
C141	a_27_74##2	A3	4.49392e-17
C142	A1#4	a_456_368#	2.22744e-18
C143	VPWR#2	A3#2	5.83592e-20
C144	A2	VPWR#1	5.15733e-17
C145	B1#1	B2#2	3.40021e-18
C146	VPWR#2	A2#2	2.49423e-20
C147	VGND	A1#2	2.49969e-19
C148	B2#5	A3	1.59334e-17
C149	a_27_74#	A2	3.68819e-17
C150	B2#6	A3	1.36235e-17
C151	B1#3	B2#1	9.62529e-19
C152	A2#2	A1#4	1.80637e-18
C153	VPWR#2	B2#3	5.33885e-18
C154	VPWR#3	B1#3	8.96125e-18
C155	VPWR#2	A3#3	8.38488e-18
C156	A2	A1#7	8.57557e-18
C157	VPWR	A1#2	8.68889e-19
C158	VPWR#2	A2#3	6.14085e-18
C159	B1#1	B2#3	5.30933e-17
C160	B2#2	Y#1	8.22328e-19
C161	a_27_74#	a_456_368#	2.6272e-19
C162	VGND#3	B1#4	5.31202e-18
C163	A1#7	A1#2	1.33896e-17
C164	B2#3	A3#3	2.10298e-17
C165	VGND#3	B2#1	5.35671e-18
C166	B1#3	a_27_74##4	5.59411e-18
C167	Y#3	B1#3	1.1284e-17
C168	VGND#3	A3#1	5.5386e-18
C169	a_27_74##4	B2#2	2.08498e-19
C170	a_27_74#	A1#2	1.06957e-17
C171	A3#3	A2#3	2.97629e-17
C172	VGND#2	a_27_74#	1.55578e-17
C173	Y#3	B2#2	1.11052e-17
C174	a_27_74##2	B2#2	4.07289e-19
C175	B1#5	B1#3	9.82662e-18
C176	A2#3	A1#4	2.91581e-17
C177	Y#3	A3#2	2.89646e-19
C178	VPWR#1	A2#2	2.78388e-20
C179	B1#6	B1#3	1.38539e-17
C180	VPWR#2	VPWR#3	3.96693e-17
C181	VGND#2	VGND#1	1.25012e-18
C182	a_27_74##2	A3#2	3.58473e-18
C183	VGND#4	A3#2	4.70192e-19
C184	Y#3	A2#2	1.31539e-19
C185	B1#5	B2#2	1.33281e-19
C186	B2#5	B1#3	1.91433e-18
C187	A2#2	A1#2	3.04844e-17
C188	B2#6	B1#3	6.18323e-19
C189	VGND#4	A2#2	1.06132e-18
C190	VPWR#3	B1#1	3.48221e-17
C191	A1#2	VGND#1	9.80549e-18
C192	B2#5	B2#2	1.39666e-17
C193	a_27_74#	A2#2	2.26843e-18
C194	VGND#3	a_27_74##4	4.02648e-17
C195	VPWR#3	B2#3	1.33472e-18
C196	VPWR#2	VPWR#1	4.08329e-17
C197	B2#6	B2#2	6.71467e-18
C198	B2#5	A3#2	2.08312e-18
C199	VGND#3	a_27_74##2	3.54776e-17
C200	VPWR#3	A3#3	6.68291e-19
C201	A2#1	A1#2	2.3492e-18
C202	B2#3	Y#1	2.82327e-17
C203	B1#4	B2#1	1.18154e-17
C204	B2#6	A3#2	9.84757e-19
C205	VPWR#3	A2#3	2.73789e-19
C206	A3#3	Y#1	1.92231e-17
C207	VGND#3	VGND#1	3.05952e-17
C208	B2#1	A3#1	2.82926e-17
C209	VPWR#1	B2#3	3.65766e-19
C210	A1	A1#2	1.01166e-17
C211	VPWR#1	A3#3	7.52958e-19
C212	A3#1	A2#1	1.97567e-17
C213	VPWR#1	A2#3	7.63162e-18
C214	A1#7	A2#2	2.68166e-18
C215	VPWR#1	A1#4	5.29951e-17
C216	A2#1	A1#3	3.66575e-17
C217	a_27_74##4	B1#4	5.00815e-17
C218	B2#6	B1#1	8.58449e-19
C219	VGND#3	VGND#2	3.56763e-17
C220	B1#4	Y#3	3.14752e-17
C221	a_27_74##4	B2#1	1.14079e-18
C222	a_27_74##2	B1#4	1.35918e-18
C223	B2#6	B2#3	1.16576e-18
C224	B2#1	Y#3	2.68363e-17
C225	a_27_74##4	A3#1	2.90325e-19
C226	VGND#4	B1#4	2.97478e-19
C227	a_27_74##2	B2#1	4.19357e-17
C228	Y#3	A3#1	1.14208e-18
C229	B2#6	A3#3	8.93755e-19
C230	VGND#4	B2#1	5.38887e-19
C231	a_27_74##2	A3#1	5.90851e-17
C232	Y#3	A2#1	1.07424e-19
C233	A3#1	VGND#4	2.43605e-17
C234	a_27_74##2	A2#1	7.2524e-19
C235	a_27_74#	A3#1	1.4032e-18
C236	A2#1	VGND#4	2.10927e-17
C237	B1#5	B2#1	2.97662e-19
C238	VGND#1	A3#1	2.76414e-19
C239	A2	A1#2	6.93596e-18
C240	a_27_74#	A2#1	5.57936e-17
C241	VGND#4	A1#3	5.73123e-19
C242	VGND#1	A2#1	1.39629e-18
C243	a_27_74#	A1#3	4.02018e-17
C244	A1#3	VGND#1	2.46994e-17
C245	B1#6	VPWR#3	2.28595e-17
C246	a_27_74##4	Y#3	6.08165e-17
C247	a_27_74##4	a_27_74##2	2.44235e-18
C248	VGND#2	B1#4	2.31322e-19
C249	a_27_74##2	Y#3	5.36904e-17
C250	VGND#2	B2#1	6.83414e-19
C251	a_27_74##2	VGND#4	6.0456e-17
C252	VGND#2	A3#1	2.76548e-18
C253	a_27_74##4	B1#5	3.00623e-17
C254	a_27_74##2	a_27_74#	3.29019e-18
C255	VPWR#1	A1#2	7.87137e-18
C256	B1#5	Y#3	1.82254e-17
C257	a_27_74#	VGND#4	4.98891e-17
C258	VGND#2	A2#1	8.2202e-18
*
*
.ENDS sky130_fd_sc_hs__o32ai_1
*
