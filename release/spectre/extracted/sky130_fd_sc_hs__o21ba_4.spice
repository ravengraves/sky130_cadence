* Extracted by Quantus, converted by sky130cad/quantus.py
*
*
*
*                       LINUX           Wed Nov 18 08:56:25 2026
*
*
*
*  PROGRAM  advgen
*
*  Name           : advgen - Quantus - (64-bit)
*  Version        : 25.1.0-p047
*  Build Date     : Thu Dec 11 23:20:30 PST 2025
*
*  HSPICE LIBRARY
*
*  OPERATING_TEMPERATURE 150
*  QRC_TECH_DIR <path>/tech
*
*
*

*
.SUBCKT sky130_fd_sc_hs__o21ba_4 VNB VPB VGND VPWR X B1_N A1 A2
*
*
*  caps2d version: 10
*
*
*       TRANSISTOR CARDS
*
*
XM9 a_27_368##11 B1_N#1 VGND#13 VNB sky130_fd_pr__nfet_01v8_lvt l=0.15 w=0.74 ad=0.2109 as=0.2701 pd=2.05 ps=2.21
XM19 X#5 a_193_48##6 VGND#13 VNB sky130_fd_pr__nfet_01v8_lvt l=0.15 w=0.74 ad=0.2146 as=0.2701 pd=2.06 ps=2.21
XM15 VGND#12 a_193_48##10 X#5 VNB sky130_fd_pr__nfet_01v8_lvt l=0.15 w=0.74 ad=0.2072 as=0.2146 pd=2.04 ps=2.06
XM4 X#6 a_193_48##8 VGND#12 VNB sky130_fd_pr__nfet_01v8_lvt l=0.15 w=0.74 ad=0.2072 as=0.2072 pd=2.04 ps=2.04
XM18 VGND#11 a_193_48##7 X#6 VNB sky130_fd_pr__nfet_01v8_lvt l=0.15 w=0.74 ad=0.2109 as=0.2072 pd=2.05 ps=2.04
XM1 a_193_48##13 a_27_368##6 a_618_94##4 VNB sky130_fd_pr__nfet_01v8_lvt l=0.15 w=0.64 ad=0.1792 as=0.1824 pd=1.84 ps=1.85
XM14 a_618_94##6 a_27_368# a_193_48##13 VNB sky130_fd_pr__nfet_01v8_lvt l=0.15 w=0.64 ad=0.24725 as=0.1792 pd=2.29 ps=1.84
XM17 VGND#10 A1#3 a_618_94##6 VNB sky130_fd_pr__nfet_01v8_lvt l=0.15 w=0.64 ad=0.224 as=0.24725 pd=1.98 ps=2.29
XM20 VGND#10 A2#7 a_618_94##5 VNB sky130_fd_pr__nfet_01v8_lvt l=0.15 w=0.64 ad=0.224 as=0.1792 pd=1.98 ps=1.84
XM11 a_618_94##5 A2#1 VGND#9 VNB sky130_fd_pr__nfet_01v8_lvt l=0.15 w=0.64 ad=0.1792 as=0.1792 pd=1.84 ps=1.84
XM13 a_618_94# A1#2 VGND#9 VNB sky130_fd_pr__nfet_01v8_lvt l=0.15 w=0.64 ad=0.1856 as=0.1792 pd=1.86 ps=1.84
XM0 a_27_368##9 B1_N#3 VPWR#10 VPB sky130_fd_pr__pfet_01v8 l=0.15 w=1.12 ad=0.3304 as=0.448 pd=2.83 ps=3.04
XM10 X#2 a_193_48##12 VPWR#10 VPB sky130_fd_pr__pfet_01v8 l=0.15 w=1.12 ad=0.336 as=0.448 pd=2.84 ps=3.04
XM2 VPWR#9 a_193_48##11 X#2 VPB sky130_fd_pr__pfet_01v8 l=0.15 w=1.12 ad=0.336 as=0.336 pd=2.84 ps=2.84
XM8 X#1 a_193_48##9 VPWR#9 VPB sky130_fd_pr__pfet_01v8 l=0.15 w=1.12 ad=0.336 as=0.336 pd=2.84 ps=2.84
XM21 VPWR#8 a_193_48# X#1 VPB sky130_fd_pr__pfet_01v8 l=0.15 w=1.12 ad=0.742 as=0.336 pd=3.83 ps=2.84
XM6 VPWR#8 a_27_368##7 a_193_48##19 VPB sky130_fd_pr__pfet_01v8 l=0.15 w=0.84 ad=0.742 as=0.252 pd=3.83 ps=2.28
XM16 a_193_48##19 a_27_368##5 VPWR#7 VPB sky130_fd_pr__pfet_01v8 l=0.15 w=0.84 ad=0.252 as=0.4078 pd=2.28 ps=2.87
XM12 a_892_392##2 A1#5 VPWR#7 VPB sky130_fd_pr__pfet_01v8 l=0.15 w=1 ad=0.3 as=0.4078 pd=2.6 ps=2.87
XM3 a_892_392##2 A2#5 a_193_48##16 VPB sky130_fd_pr__pfet_01v8 l=0.15 w=1 ad=0.3 as=0.3 pd=2.6 ps=2.6
XM5 a_193_48##16 A2#6 a_892_392# VPB sky130_fd_pr__pfet_01v8 l=0.15 w=1 ad=0.3 as=0.3 pd=2.6 ps=2.6
XM7 VPWR#1 A1#1 a_892_392# VPB sky130_fd_pr__pfet_01v8 l=0.15 w=1 ad=0.295 as=0.3 pd=2.59 ps=2.6
*
*
*       RESISTOR AND CAP/DIODE CARDS
*
Rg1	B1_N#1	B1_N#2	319.398315
Rg2	B1_N#2	B1_N#3	507.822205
Rg3	a_193_48#	a_193_48##2	481.518219
Rg4	a_193_48##2	a_193_48##3	58.552822
Rg5	a_193_48##3	a_193_48##4	86.720970
Rg6	a_193_48##4	a_193_48##5	84.094505
Rg7	a_193_48##5	a_193_48##6	353.222290
Rg8	a_193_48##2	a_193_48##7	383.707489
Rg9	a_193_48##3	a_193_48##8	348.967102
Rg10	a_193_48##3	a_193_48##9	459.496155
Rg11	a_193_48##4	a_193_48##10	360.082428
Rg12	a_193_48##4	a_193_48##11	474.259644
Rg13	a_193_48##5	a_193_48##12	497.173828
Rg14	a_27_368#	a_27_368##2	549.734131
Rg15	a_27_368##2	a_27_368##3	58.979431
Rg16	a_27_368##3	a_27_368##4	25.519691
Rg17	a_27_368##2	a_27_368##5	373.081268
Rg18	a_27_368##3	a_27_368##6	533.426819
Rg19	a_27_368##4	a_27_368##7	353.602478
Rg20	A2#1	A2#2	334.258667
Rg21	A2#2	A2#3	52.258068
Rg22	A2#3	A2#4	16.832588
Rg23	A2#4	A2#5	427.036713
Rg24	A2#2	A2#6	422.061859
Rg25	A2#4	A2#7	345.759003
Rg26	A1#1	A1#2	797.020508
Rg27	A1#2	A1#3	1550.805664
Rg28	A1#3	A1#4	334.702850
Rg29	A1#4	A1#5	417.269073
Rf1	B1_N#4	B1_N#2	161.672424
Rf2	B1_N	B1_N#6	1.439625
Rf3	B1_N#4	B1_N#6	4.588779
Rf4	X#1	X#3	44.482971
Rf5	X#3	X	2.732089
Rf6	X#3	X	20.450989
Rf7	X	X#4	44.602913
Rf8	X#4	X#5	27.122309
Rf9	X#4	X#6	73.429756
Rf10	X#2	X#3	15.000000
Rf11	a_27_368##4	a_27_368##10	405.157837
Rf12	a_27_368##10	a_27_368##11	102.442505
Rf13	a_27_368##9	a_27_368##10	5.000000
Rf14	A1#4	A1#7	160.893372
Rf15	A1#8	A1	0.660563
Rf16	A1#7	A1#8	8.660800
Rf17	a_193_48##13	a_193_48##14	143.009689
Rf18	a_193_48##14	a_193_48##15	117.209000
Rf19	a_193_48##15	a_193_48##17	45.956142
Rf20	a_193_48##14	a_193_48##3	89.640900
Rf21	a_193_48##15	a_193_48##19	38.695343
Rf22	a_193_48##16	a_193_48##17	7.500000
Rf23	a_892_392#	a_892_392##2	106.865250
Rf24	A2	A2#3	161.413818
Rf25	a_618_94#	a_618_94##2	76.184158
Rf26	a_618_94##2	a_618_94##3	65.100159
Rf27	a_618_94##3	a_618_94##4	91.374878
Rf28	a_618_94##2	a_618_94##5	16.097075
Rf29	a_618_94##3	a_618_94##6	18.366917
Rf30	VPWR#1	VPWR#2	181.657135
Rf31	VPWR#2	VPWR#3	72.916389
Rf32	VPWR#3	VPWR#4	106.300468
Rf33	VPWR#4	VPWR#5	67.498253
Rf35	VPWR#2	VPWR#7	39.034733
Rf36	VPWR#3	VPWR#8	16.828671
Rf37	VPWR#4	VPWR#9	31.948624
Rf38	VPWR#5	VPWR#10	29.813919
Rf40	VGND#2	VGND#3	62.889057
Rf41	VGND#3	VGND#4	109.973808
Rf42	VGND#4	VGND#5	44.228367
Rf43	VGND#5	VGND#6	62.889057
Rf44	VGND#6	VGND#7	61.735950
Rf46	VGND#2	VGND#9	50.073776
Rf47	VGND#3	VGND#10	50.073776
Rf48	VGND#5	VGND#11	40.783081
Rf49	VGND#6	VGND#12	39.585419
Rf50	VGND#7	VGND#13	32.125244
Re1	VPWR#3	VPWR	0.755546
Re2	VGND	VGND#4	0.755573
*
*       CAPACITOR CARDS
*
*
C1	VGND#11	a_193_48##13	2.91539e-17
C2	VGND#3	A2#7	1.74038e-18
C3	VGND#3	a_618_94##2	2.62504e-19
C4	VGND#5	A1#3	3.33956e-19
C5	VGND#3	A1#3	2.76127e-17
C6	a_618_94#	VPWR#1	4.07569e-19
C7	X#6	VGND#11	6.29465e-17
C8	VGND#3	a_27_368#	2.31211e-18
C9	a_618_94##2	A1#2	2.86931e-19
C10	A1#2	A2#4	1.69893e-17
C11	a_27_368##9	a_193_48##5	7.0402e-19
C12	VGND#12	VGND#11	1.77208e-18
C13	a_27_368##9	a_193_48##4	3.69778e-19
C14	a_618_94##2	A2#1	1.42889e-17
C15	VGND#6	a_193_48##7	6.79288e-19
C16	X#6	VGND#12	4.42089e-17
C17	VGND#5	a_193_48##7	8.11845e-18
C18	a_618_94##3	A2#7	1.15365e-18
C19	X#5	X#6	2.66306e-18
C20	VGND#3	a_193_48##7	1.59792e-19
C21	a_618_94##2	A2#7	2.12038e-17
C22	a_193_48##15	A1#2	5.94104e-19
C23	VGND#6	a_193_48##8	5.22019e-18
C24	VGND#5	a_193_48##14	2.41839e-19
C25	X#5	VGND#12	3.47726e-17
C26	a_618_94##3	A1#3	4.21527e-17
C27	VGND#5	a_193_48##8	7.17888e-19
C28	a_618_94##2	A1#3	3.76957e-19
C29	a_193_48##15	A2#1	4.26601e-19
C30	VGND#13	VGND#12	1.99441e-18
C31	VGND#6	a_193_48##10	5.15611e-18
C32	a_618_94##3	a_27_368#	2.33252e-17
C33	VGND#5	a_193_48##10	1.12262e-19
C34	VGND#13	X#5	4.59741e-17
C35	a_193_48##15	A2#7	8.20496e-19
C36	VGND#6	a_193_48##6	5.45187e-19
C37	a_618_94##3	a_27_368##6	2.04981e-18
C38	VGND#4	a_193_48##5	5.79001e-21
C39	VPWR#2	A2#4	2.90312e-20
C40	a_193_48##15	A1#3	1.39195e-18
C41	VGND#4	a_193_48##4	1.87486e-21
C42	a_27_368##11	VGND#13	5.8303e-17
C43	a_193_48##14	A1#3	1.12031e-19
C44	a_618_94##3	a_193_48##7	8.88284e-20
C45	a_193_48##15	a_27_368#	5.66671e-18
C46	B1_N#6	a_27_368##9	5.12012e-18
C47	A1#3	A2#4	1.76753e-19
C48	a_193_48##14	a_27_368#	4.51948e-19
C49	a_27_368##9	B1_N#4	2.59465e-17
C50	a_193_48##14	a_27_368##6	1.1332e-17
C51	a_193_48##15	VPWR#2	8.1417e-19
C52	a_892_392#	VPWR#1	1.15731e-16
C53	A1#4	A2#4	2.54676e-17
C54	VPWR#4	a_193_48##4	4.35366e-20
C55	VGND#6	X#4	3.94429e-19
C56	a_193_48##14	a_193_48##7	1.07512e-18
C57	a_618_94#	A1#2	4.42756e-17
C58	A1#2	VGND#9	1.94998e-17
C59	a_618_94#	A2#1	1.93282e-18
C60	a_892_392#	a_193_48##16	7.51391e-17
C61	a_193_48##14	a_193_48##8	5.3366e-20
C62	a_618_94##5	A1#2	4.77482e-18
C63	VGND#9	A2#1	2.80009e-17
C64	a_618_94##3	a_193_48##15	2.95654e-17
C65	a_892_392##2	a_892_392#	3.01982e-18
C66	VGND#10	A1#2	7.8979e-19
C67	a_618_94#	A2#7	2.75266e-19
C68	X#4	a_27_368##6	3.86202e-20
C69	a_193_48##14	a_193_48##10	1.35046e-20
C70	A2#1	a_618_94##5	1.12713e-17
C71	a_193_48##16	a_892_392##2	6.68851e-17
C72	VGND#9	A2#7	2.34732e-18
C73	a_193_48##14	a_618_94##3	3.67377e-18
C74	VGND#10	A2#1	7.53534e-19
C75	a_27_368##4	a_193_48##5	2.96139e-20
C76	VPWR#2	A1#1	8.43692e-20
C77	X#4	a_193_48##7	2.0643e-20
C78	a_193_48##13	A1#2	1.96225e-19
C79	a_618_94##2	A2#4	3.68627e-18
C80	a_27_368##4	a_193_48##4	1.09579e-19
C81	a_618_94##5	A2#7	2.73346e-17
C82	a_193_48##14	a_193_48##6	9.89103e-21
C83	a_193_48##2	a_27_368##4	5.50504e-18
C84	VGND#9	A1#3	1.08608e-18
C85	A2#7	VGND#10	1.94292e-17
C86	VPWR#7	a_892_392##2	4.76538e-17
C87	a_193_48##19	a_193_48##16	9.909e-19
C88	a_618_94##5	A1#3	3.11763e-18
C89	X#4	a_193_48##8	4.01131e-20
C90	VPWR#2	A2#6	1.75817e-18
C91	A1#3	VGND#10	2.29291e-17
C92	a_193_48##13	A2#7	3.78916e-19
C93	X#4	a_193_48##10	1.44102e-17
C94	A1#3	a_618_94##6	1.30039e-17
C95	a_193_48##3	a_193_48##5	1.98165e-19
C96	VPWR#2	A2#5	5.04569e-18
C97	a_193_48##19	VPWR#7	3.90875e-17
C98	a_193_48##3	a_193_48##4	1.80197e-17
C99	VGND#10	a_27_368#	8.86434e-19
C100	a_193_48##2	a_27_368##6	1.00521e-18
C101	a_193_48##3	a_193_48##2	1.76904e-17
C102	a_193_48##13	A1#3	4.04975e-18
C103	VGND#13	a_27_368##9	2.28898e-18
C104	a_193_48##15	A1#1	2.18736e-19
C105	a_27_368#	a_618_94##6	5.55736e-18
C106	VPWR#8	VPWR#7	1.05709e-18
C107	B1_N#6	a_193_48##10	3.13734e-19
C108	X#4	a_193_48##6	4.1333e-18
C109	a_618_94##4	A1#3	1.7013e-19
C110	a_618_94##3	A1#7	2.5421e-17
C111	VPWR#2	A1#5	7.2903e-18
C112	a_27_368##11	a_27_368##9	3.05376e-18
C113	a_193_48##13	a_27_368#	2.97269e-17
C114	VPWR#8	a_193_48##19	2.18467e-17
C115	VGND#11	A1#3	4.6447e-20
C116	B1_N#6	a_193_48##6	1.60749e-18
C117	X#4	B1_N#1	6.61746e-19
C118	a_193_48##15	A2#6	4.07932e-20
C119	a_618_94##4	a_27_368#	4.01042e-19
C120	a_193_48##13	a_27_368##6	4.30316e-17
C121	B1_N#2	a_193_48##5	3.43244e-17
C122	VPWR#2	a_27_368##5	8.81569e-18
C123	a_618_94##3	a_193_48##2	5.7647e-20
C124	VGND#11	a_193_48##2	1.89755e-18
C125	a_618_94##4	a_27_368##6	4.04418e-17
C126	a_193_48##19	VPWR#9	5.11146e-21
C127	a_193_48##14	a_193_48##15	7.82788e-18
C128	a_193_48##15	A2#5	7.46822e-20
C129	a_193_48##13	a_193_48##7	7.84738e-19
C130	VGND#11	a_27_368##6	8.84226e-19
C131	a_892_392#	A1#2	5.97424e-19
C132	VPWR#9	VPWR#8	9.37435e-18
C133	a_618_94##4	a_193_48##7	5.96191e-19
C134	VPWR#2	a_27_368##7	8.91415e-19
C135	X#6	a_193_48##4	2.2891e-19
C136	a_193_48##15	A1#5	1.75909e-17
C137	VGND#11	a_193_48##7	4.59517e-17
C138	X#1	VPWR#9	7.66349e-19
C139	X#6	a_193_48##7	1.35301e-17
C140	VPWR#2	a_193_48#	1.57186e-19
C141	VGND#11	a_193_48##8	1.82481e-18
C142	VGND#12	a_193_48##7	4.67668e-19
C143	a_193_48##15	a_27_368##5	1.88266e-17
C144	VGND#3	a_618_94##5	2.54889e-18
C145	X#6	a_193_48##8	4.79573e-17
C146	VPWR#4	a_193_48##9	3.93824e-18
C147	VGND#11	a_193_48##10	1.90842e-19
C148	a_193_48##8	VGND#12	1.48923e-17
C149	a_193_48##16	A1#3	2.86549e-19
C150	VPWR#10	VPWR#9	8.61427e-18
C151	X#1	a_27_368##9	2.52116e-17
C152	a_193_48##15	A1#7	3.88235e-17
C153	a_193_48##15	a_27_368##7	5.29857e-18
C154	X#6	a_193_48##10	1.37182e-18
C155	VGND#12	a_193_48##4	5.76864e-19
C156	X#5	a_193_48##8	3.94352e-19
C157	VGND#12	a_193_48##10	2.79369e-17
C158	a_27_368##9	VPWR#9	4.39569e-17
C159	VPWR#4	a_193_48##11	3.96617e-18
C160	X#6	a_193_48##6	2.12608e-19
C161	a_193_48##10	X#5	1.23614e-17
C162	a_193_48##15	A2#4	4.28559e-19
C163	a_27_368##9	X#2	3.65087e-18
C164	VGND#12	a_193_48##6	1.16114e-18
C165	VGND#13	a_193_48##10	2.4503e-18
C166	a_193_48##5	X#5	2.76162e-19
C167	a_27_368##9	VPWR#10	7.2142e-17
C168	a_193_48##6	X#5	1.61663e-17
C169	a_27_368##11	a_193_48##10	1.28974e-19
C170	VGND#5	a_193_48##13	5.81939e-18
C171	VGND#13	a_193_48##6	5.48864e-17
C172	a_193_48##4	X#5	8.94238e-20
C173	a_27_368##11	a_193_48##6	1.75489e-18
C174	a_193_48##13	VGND#3	4.36237e-18
C175	B1_N#1	VGND#13	2.09483e-17
C176	a_27_368##11	B1_N#1	3.66742e-17
C177	VGND#6	VGND#11	6.30072e-19
C178	A1#2	A2#1	5.34865e-17
C179	X#4	a_193_48##14	3.11155e-19
C180	VGND#4	VGND#6	3.35575e-17
C181	VGND#4	VGND#5	3.03289e-17
C182	VGND#6	X#6	6.82598e-18
C183	VGND#4	VGND#3	4.84899e-17
C184	A2#7	A2#1	3.48225e-17
C185	VPWR#3	VPWR#4	3.60713e-17
C186	A1#3	A1#2	5.446e-19
C187	VPWR#1	A1#1	3.34493e-17
C188	VPWR#3	VPWR#2	6.7067e-17
C189	VGND#5	X#6	7.17288e-18
C190	a_892_392#	A1#1	5.44057e-17
C191	a_618_94##2	VGND#9	1.34967e-17
C192	VPWR#1	A2#6	3.34689e-18
C193	a_618_94##3	a_618_94##5	4.0637e-18
C194	A1#3	A2#7	4.28227e-17
C195	a_892_392#	A2#6	6.66674e-17
C196	VPWR#1	A2#5	8.61062e-20
C197	A2#6	a_193_48##16	1.97281e-17
C198	a_618_94##2	a_618_94##5	3.17433e-19
C199	A2#4	A1#1	1.28535e-17
C200	VGND#4	a_618_94##3	1.68094e-19
C201	a_892_392#	A2#5	1.92887e-18
C202	a_618_94##3	VGND#10	4.59716e-17
C203	a_892_392##2	A2#6	1.08647e-18
C204	a_193_48##15	a_193_48##2	5.09624e-19
C205	a_27_368#	A1#3	3.55388e-17
C206	VGND#6	X#5	5.32102e-18
C207	a_193_48##14	a_193_48##5	1.73093e-20
C208	a_892_392#	A2#4	2.003e-19
C209	VGND#3	A1#4	7.03787e-20
C210	VPWR#1	A1#5	2.45233e-20
C211	a_193_48##16	A2#5	4.28386e-17
C212	a_892_392##2	A2#5	5.02462e-17
C213	a_193_48##19	A2#6	9.02726e-20
C214	a_618_94##2	VGND#10	1.33781e-17
C215	VPWR#1	a_27_368##5	1.48855e-20
C216	a_193_48##16	A1#5	1.04559e-17
C217	a_618_94##3	a_618_94##6	4.94627e-18
C218	a_27_368##6	a_27_368#	4.2179e-17
C219	a_193_48##7	A1#3	1.91519e-19
C220	a_193_48##14	a_193_48##4	2.36331e-20
C221	VGND#13	VGND#6	6.95636e-20
C222	a_892_392##2	A1#5	3.92859e-17
C223	a_193_48##19	A2#5	1.51108e-19
C224	a_193_48##16	a_27_368##5	1.86714e-19
C225	A2	A2#4	3.45945e-17
C226	A1#5	VPWR#7	2.44967e-17
C227	a_618_94##3	A1#4	2.87452e-18
C228	a_892_392##2	a_27_368##5	2.83559e-19
C229	a_193_48##19	A1#5	1.16782e-18
C230	a_193_48##7	a_27_368##6	3.91259e-18
C231	a_618_94##3	a_193_48##13	3.40654e-17
C232	a_193_48##14	a_193_48##2	9.86295e-18
C233	VGND#6	a_193_48##3	2.46685e-20
C234	a_193_48##16	A2#4	3.26805e-18
C235	a_27_368##5	VPWR#7	2.59397e-17
C236	VGND#5	a_193_48##3	6.66058e-19
C237	a_27_368##4	VPWR#4	1.98569e-18
C238	VPWR#8	A1#5	3.36245e-19
C239	VPWR#2	a_27_368##4	3.13066e-20
C240	a_193_48##19	a_27_368##5	3.99775e-17
C241	VPWR#7	a_27_368##7	1.74111e-19
C242	a_193_48##8	a_193_48##7	3.91467e-17
C243	a_618_94##3	a_27_368##4	3.02661e-19
C244	VPWR#8	a_27_368##5	2.10418e-18
C245	a_193_48##15	A1#4	5.52083e-18
C246	a_618_94##4	a_618_94##3	2.37845e-18
C247	a_27_368##7	a_193_48##19	9.85212e-18
C248	VPWR#4	a_193_48##3	5.51377e-20
C249	VPWR#7	a_193_48#	6.45418e-20
C250	a_27_368##7	VPWR#8	3.96685e-17
C251	A1	A2#4	7.26418e-18
C252	a_193_48##10	a_193_48##8	3.59947e-17
C253	A1#7	A1#4	1.21913e-17
C254	a_193_48##19	a_193_48#	9.79869e-19
C255	X#1	a_27_368##7	1.19693e-18
C256	a_193_48##15	a_27_368##4	9.33888e-17
C257	a_193_48##14	a_27_368##4	6.71267e-17
C258	VPWR#8	a_193_48#	4.01952e-17
C259	B1_N#6	X#4	1.16175e-17
C260	a_892_392##2	A2#4	5.14604e-20
C261	a_193_48##19	a_193_48##9	2.52155e-19
C262	X#1	a_193_48#	3.50416e-17
C263	a_193_48##6	a_193_48##10	3.81623e-17
C264	A1#7	a_27_368##4	4.48255e-18
C265	VPWR#8	a_193_48##9	3.01234e-18
C266	VPWR#9	a_193_48#	3.8336e-18
C267	VGND#4	a_193_48##13	7.54252e-17
C268	a_193_48##19	a_193_48##11	1.70694e-19
C269	X#1	a_193_48##9	4.64256e-17
C270	a_193_48##14	a_193_48##3	9.33905e-20
C271	VPWR#9	a_193_48##9	3.70917e-17
C272	B1_N#1	a_193_48##6	2.64293e-17
C273	a_27_368##9	a_193_48#	5.38757e-19
C274	VPWR#9	a_193_48##11	3.59287e-17
C275	X#4	a_193_48##3	3.20307e-17
C276	a_193_48##11	X#2	2.38309e-17
C277	VPWR#3	VPWR#1	4.3441e-17
C278	a_27_368##9	a_193_48##9	8.55666e-18
C279	VPWR#9	a_193_48##12	2.59362e-18
C280	VPWR#10	a_193_48##11	2.64763e-18
C281	a_193_48##13	a_193_48##14	2.46567e-18
C282	a_193_48##12	X#2	2.38309e-17
C283	a_27_368##9	a_193_48##11	1.66422e-17
C284	a_618_94##4	a_193_48##15	7.67814e-18
C285	VPWR#10	a_193_48##12	4.76031e-17
C286	X#4	B1_N#2	1.78138e-18
C287	VGND#6	VGND#5	1.1306e-18
C288	a_193_48##13	a_27_368##4	7.2955e-19
C289	a_27_368##9	a_193_48##12	2.79994e-17
C290	B1_N#6	B1_N#2	6.49588e-18
C291	a_618_94##4	a_27_368##4	1.2474e-18
C292	a_193_48##14	a_618_94##4	8.03414e-17
C293	B1_N#3	VPWR#10	3.73772e-17
C294	VPWR#3	VPWR#8	5.68894e-17
C295	B1_N#4	B1_N#2	1.30624e-17
C296	a_193_48##5	a_193_48##4	6.0903e-18
C297	a_27_368##9	B1_N#3	6.95622e-17
C298	A2#6	A1#1	4.22139e-17
C299	A1#7	a_618_94##6	1.11816e-18
C300	X	a_193_48##5	8.78217e-18
C301	X	a_193_48##4	5.70582e-18
C302	X	a_193_48##2	2.31518e-19
C303	a_193_48##3	VGND#11	1.65403e-17
C304	a_193_48##14	VGND#11	6.4456e-17
C305	a_193_48##3	X#6	5.83466e-17
C306	A2#5	A2#6	4.28026e-17
C307	a_193_48##3	VGND#12	2.72177e-18
C308	VPWR#2	VPWR#1	1.66512e-19
C309	VPWR#7	A1#4	5.66385e-19
C310	A1#5	A2#5	4.21239e-17
C311	VPWR#7	a_27_368##4	4.76776e-19
C312	a_892_392#	VPWR#2	1.68222e-17
C313	B1_N#2	VGND#13	4.04078e-18
C314	a_27_368##4	a_193_48##19	1.88309e-17
C315	a_27_368##11	B1_N#2	3.20989e-18
C316	a_27_368##5	A1#5	2.32774e-17
C317	a_27_368##4	VPWR#8	9.20424e-17
C318	a_27_368##4	X#1	4.66815e-17
C319	VGND#4	a_27_368#	1.66179e-18
C320	VPWR#8	a_193_48##3	3.96991e-20
C321	a_27_368##7	a_27_368##5	3.65304e-17
C322	a_193_48##3	X#1	5.31146e-17
C323	VGND#4	a_27_368##6	3.41666e-18
C324	a_193_48##16	VPWR#2	2.75203e-19
C325	VPWR#9	a_193_48##3	1.71175e-19
C326	a_618_94##2	A2	6.20885e-17
C327	a_193_48#	a_27_368##7	6.3733e-18
C328	a_27_368#	A1#4	5.02927e-19
C329	a_27_368##9	a_193_48##3	1.88024e-19
C330	a_618_94#	VGND#9	4.25136e-17
C331	VPWR#2	a_892_392##2	4.77734e-17
C332	VPWR#10	B1_N#2	6.89885e-19
C333	a_193_48##9	a_193_48#	5.00894e-17
C334	a_618_94##3	A1	1.50256e-17
C335	a_27_368##9	B1_N#2	9.02013e-18
C336	VGND	a_193_48##4	1.10111e-18
C337	a_618_94##2	A1	1.14592e-17
C338	VGND	a_193_48##2	5.79538e-20
C339	X#4	a_193_48##5	4.99113e-18
C340	a_618_94##5	a_618_94#	3.48722e-18
C341	a_193_48##11	a_193_48##9	4.81426e-17
C342	a_618_94##2	a_193_48##16	4.17973e-18
C343	a_618_94#	A2	5.35355e-17
C344	X#4	a_193_48##4	3.83998e-18
C345	a_193_48##12	a_193_48##11	4.95038e-17
C346	a_618_94##5	VGND#9	2.9508e-17
C347	B1_N#3	a_193_48##12	3.28286e-17
C348	B1_N#2	a_193_48##6	7.09071e-19
C349	a_193_48##19	VPWR#2	8.43165e-18
C350	X#4	a_193_48##2	3.61252e-20
C351	VGND#10	VGND#9	6.00591e-18
C352	VPWR#8	a_193_48##2	1.28987e-20
C353	A2	VPWR#1	3.30746e-17
C354	a_27_368##4	A1#5	5.81506e-18
C355	A2	a_892_392#	3.94004e-17
C356	A2	a_193_48##16	4.40617e-17
C357	a_27_368##4	a_27_368##5	1.38555e-18
C358	VPWR#4	VPWR#8	1.27405e-18
C359	X#4	VGND#12	1.63998e-17
C360	a_27_368##4	a_27_368##7	1.66037e-17
C361	a_27_368##4	a_193_48#	3.29408e-17
C362	VGND#10	a_618_94##5	2.9508e-17
C363	VPWR	VPWR#4	2.47982e-17
C364	X#4	X	3.24145e-18
C365	VPWR	VPWR#2	5.45169e-17
C366	a_27_368##4	a_193_48##9	7.97458e-18
C367	VPWR#8	VPWR#2	1.04913e-18
C368	A1	a_193_48##16	2.78918e-17
C369	B1_N#6	X	8.61492e-18
C370	a_27_368##4	a_193_48##11	2.32784e-19
C371	VGND#3	A2#4	6.4424e-20
C372	a_193_48##15	a_193_48##16	1.86522e-19
C373	VPWR	a_193_48##15	4.24925e-18
C374	a_27_368##4	a_193_48##12	3.16478e-19
C375	VPWR	a_193_48##14	5.83863e-18
C376	A2	A1#2	1.55204e-17
C377	X#1	a_193_48##4	4.97745e-19
C378	X#4	X#5	2.17939e-18
C379	VPWR	A1#7	1.23848e-18
C380	VGND	VGND#6	3.46321e-17
C381	VGND#6	a_193_48##5	1.6076e-20
C382	VGND	VGND#5	3.47566e-17
C383	VGND	VGND#3	4.63656e-17
C384	A2	A1#3	2.79506e-20
C385	VPWR	B1_N#6	2.16593e-18
C386	VPWR	B1_N#4	1.42519e-18
C387	A2#4	VNB	5.20319e-17
C388	X#1	a_193_48##2	3.01533e-19
C389	VGND	a_618_94##3	1.63145e-17
C390	a_193_48##5	VNB	1.93896e-17
C391	a_193_48##4	VNB	2.9013e-17
C392	VGND	a_618_94##2	2.37443e-18
C393	a_193_48##2	VNB	3.14534e-17
C394	VGND#4	a_27_368##4	5.8123e-20
C395	A1	A1#3	3.141e-19
C396	B1_N#6	a_193_48##5	5.82252e-18
C397	VGND	a_193_48##15	1.78432e-18
C398	VGND#13	X#4	1.83612e-17
C399	VGND	a_193_48##14	4.45059e-18
C400	VGND	A1#7	1.32879e-18
C401	a_27_368##4	A1#4	2.71357e-17
C402	VGND	X#4	1.73976e-18
C403	A2	A1#1	1.80698e-17
C404	VGND	B1_N#6	1.78228e-18
C405	X	X#2	1.43912e-19
C406	VGND#6	a_193_48##4	3.57918e-20
C407	VPWR	VPWR#1	4.23328e-17
C408	VGND	B1_N#4	2.34242e-18
C409	VGND	a_618_94#	1.40168e-17
C410	VPWR	a_892_392#	2.34804e-17
C411	a_27_368##9	X	6.98444e-17
C412	VPWR	a_193_48##16	8.85727e-18
C413	VGND	a_618_94##5	1.0613e-17
C414	a_193_48##3	a_27_368##4	3.25101e-18
C415	VPWR	a_892_392##2	1.96941e-17
C416	VGND	a_193_48##13	3.69657e-17
C417	VPWR	a_193_48##19	1.36835e-17
C418	B1_N#6	a_193_48##4	8.66502e-20
C419	VGND	a_618_94##4	6.40675e-18
C420	a_193_48##13	VGND#10	5.58024e-18
C421	VPWR	VPWR#8	6.54079e-17
C422	a_27_368##11	X#4	1.86449e-18
C423	VPWR	X#1	4.18743e-18
C424	VGND	X#6	1.40067e-17
C425	a_193_48##15	VPWR#7	4.43269e-17
C426	VPWR	VPWR#9	1.56308e-17
C427	VGND	X#5	1.25187e-17
C428	VGND	VGND#13	2.07606e-17
C429	VPWR	VPWR#10	1.93821e-17
C430	VGND	a_27_368##11	2.02162e-17
C431	VPWR	a_27_368##9	3.47826e-17
C432	VPWR#9	a_193_48##4	1.8467e-19
C433	VGND#13	B1_N#6	1.9874e-17
C434	VGND	X#1	3.17574e-18
C435	VGND#6	VNB	2.60624e-17
C436	VGND#5	VNB	2.46468e-17
C437	A1#7	a_193_48##16	4.04475e-18
C438	VGND#3	VNB	3.52629e-17
C439	VGND	a_27_368##9	1.453e-18
C440	VPWR#4	VNB	2.9317e-17
C441	VGND	A1#2	6.85553e-18
C442	VPWR#2	VNB	5.15267e-17
C443	VGND	A2#1	2.22888e-18
C444	VGND#3	A1#2	5.59616e-19
C445	a_618_94##3	VNB	5.8486e-18
C446	a_618_94##2	VNB	1.70658e-18
C447	VGND	A2#7	3.49503e-18
C448	VGND	A1#3	5.72116e-18
C449	VPWR	A1#1	3.04303e-18
C450	a_193_48##15	a_193_48##19	6.84269e-19
C451	a_193_48##15	VNB	4.41969e-18
C452	VGND	a_27_368#	3.90274e-18
C453	a_193_48##14	VNB	2.65495e-17
C454	X	a_193_48#	9.44971e-20
C455	A2	A1#4	1.14454e-18
C456	VPWR	A2#6	1.35585e-18
C457	A1#7	VNB	4.22597e-19
C458	VGND	a_193_48##7	2.12206e-19
C459	X	a_193_48##9	1.53336e-19
C460	VPWR	A2#5	1.38158e-18
C461	VGND	a_193_48##8	3.54736e-19
C462	X#4	VNB	2.76998e-18
C463	VPWR	A1#5	1.67425e-18
C464	X	a_193_48##11	2.30789e-17
C465	VGND	a_193_48##10	9.20264e-19
C466	B1_N#6	VNB	3.25505e-18
C467	VPWR	a_27_368##5	1.83622e-19
C468	VGND	a_193_48##6	3.64843e-18
C469	X	a_193_48##12	1.55841e-17
C470	A1	A1#4	5.20252e-18
C471	B1_N#4	VNB	2.22977e-18
C472	a_618_94#	VNB	4.0185e-17
C473	VGND	B1_N#1	2.06634e-18
C474	VGND#9	VNB	4.02039e-18
C475	X	B1_N#3	4.52e-18
C476	a_618_94##5	VNB	6.14616e-19
C477	VPWR	a_193_48#	2.73847e-19
C478	VGND#10	VNB	6.15829e-18
C479	VPWR#10	VPWR#4	2.23035e-19
C480	a_193_48##13	VNB	1.91599e-17
C481	VPWR	a_193_48##9	3.10837e-19
C482	a_618_94##4	VNB	1.94236e-18
C483	VGND#11	VNB	2.31491e-18
C484	VPWR	a_193_48##11	3.28673e-19
C485	X#6	VNB	2.49489e-18
C486	VGND#12	VNB	2.96238e-19
C487	X#5	VNB	4.77937e-18
C488	VPWR	a_193_48##12	3.61055e-19
C489	VGND#13	VNB	2.4221e-18
C490	a_27_368##11	VNB	4.7656e-17
C491	VPWR	B1_N#3	5.92758e-19
C492	VPWR#1	VNB	8.85162e-17
C493	a_892_392#	VNB	5.79831e-18
C494	a_193_48##16	VNB	2.15174e-18
C495	a_892_392##2	VNB	2.63473e-18
C496	VPWR#7	VNB	1.77205e-18
C497	a_193_48##19	VNB	2.29954e-18
C498	VPWR#8	VNB	4.62336e-17
C499	X	a_27_368##4	8.63156e-19
C500	X#1	VNB	5.8702e-19
C501	VPWR#9	VNB	2.18855e-19
C502	X	a_193_48##3	3.96352e-17
C503	VPWR#10	VNB	2.8646e-18
C504	a_27_368##9	VNB	7.74642e-17
C505	A1#2	VNB	1.05291e-16
C506	X	B1_N#2	1.33664e-18
C507	VGND#13	B1_N#4	9.42837e-18
C508	A2#1	VNB	1.99733e-17
C509	A2#7	VNB	2.38844e-17
C510	VPWR	a_27_368##4	1.91759e-17
C511	A1#3	VNB	7.17348e-17
C512	a_27_368#	VNB	3.21432e-17
C513	a_27_368##6	VNB	3.9039e-17
C514	VGND	VGND#4	1.67962e-17
C515	VPWR	a_193_48##3	5.13856e-18
C516	a_193_48##7	VNB	3.25202e-17
C517	a_193_48##8	VNB	2.62521e-17
C518	a_193_48##10	VNB	2.41209e-17
C519	a_193_48##6	VNB	2.56172e-17
C520	A1	A2	3.06961e-17
C521	B1_N#1	VNB	3.33927e-17
C522	VGND	a_27_368##4	2.18866e-18
C523	VGND#3	a_618_94##3	8.50126e-18
C524	A1#1	VNB	5.70788e-17
C525	A2#6	VNB	3.11206e-17
C526	VGND	a_193_48##3	6.49568e-18
C527	A2#5	VNB	3.09241e-17
C528	a_618_94##4	a_193_48##13	4.51863e-17
C529	A1#5	VNB	3.24032e-17
C530	VGND	B1_N#2	1.25491e-19
C531	a_27_368##5	VNB	3.24844e-17
C532	a_27_368##7	VNB	3.29751e-17
C533	a_193_48#	VNB	3.51521e-17
C534	a_193_48##9	VNB	3.03055e-17
C535	a_193_48##11	VNB	3.0371e-17
C536	a_193_48##12	VNB	3.06957e-17
C537	B1_N#3	VNB	3.77051e-17
C538	VPWR	A2	7.03033e-18
C539	VPWR#3	VNB	2.49029e-16
C540	a_27_368##9	VPWR#4	2.9732e-18
C541	VGND#4	VNB	2.81772e-16
C542	VPWR	A1	1.20413e-18
C543	A1#4	VNB	3.57619e-17
C544	VGND	A2	5.87489e-18
C545	A1#7	VPWR#7	9.4845e-19
C546	a_27_368##4	VNB	8.14561e-17
C547	a_193_48##3	VNB	4.27765e-17
C548	VGND	A1	1.29085e-18
C549	B1_N#2	VNB	3.90399e-17
C550	VPWR	X	4.92393e-18
C551	a_193_48##12	a_193_48##4	1.58575e-18
C552	VGND	X	1.74483e-18
C553	a_27_368##11	B1_N#4	2.77958e-17
C554	A2	VNB	2.26808e-17
C555	X	VNB	2.89643e-18
C556	VPWR	VNB	6.03366e-17
C557	VGND	VNB	7.41772e-17
C558	VPWR#5	a_193_48##12	3.96891e-18
C559	VGND#7	B1_N#4	5.26101e-19
C560	VGND#2	VNB	4.49348e-17
C561	a_27_368##9	VPWR#5	2.51814e-17
C562	VGND	VGND#2	4.91257e-17
C563	VGND#7	a_193_48##5	4.70147e-20
C564	VGND#7	VNB	4.84893e-17
C565	VPWR	VPWR#5	3.44455e-17
C566	VGND#2	A1#2	2.42333e-17
C567	VGND#3	VGND#2	4.11686e-18
C568	VGND#7	a_193_48##6	1.36116e-18
C569	VPWR#5	VPWR#4	9.89112e-19
C570	VPWR#5	a_193_48##5	5.10194e-20
C571	VGND#2	a_618_94##2	2.62504e-19
C572	VPWR#5	B1_N#3	2.55393e-18
C573	VGND	VGND#7	3.34075e-17
C574	VGND#7	a_27_368##11	2.37915e-17
C575	VPWR#3	VPWR#5	5.54679e-17
C576	VGND#2	A2#4	1.98104e-19
C577	VGND#7	B1_N#1	4.70195e-18
C578	VGND#2	A1#3	6.55157e-19
C579	VGND#2	a_618_94##5	2.52816e-18
C580	VGND#2	A2#1	5.48025e-19
C581	VGND#4	VGND#2	5.14401e-17
C582	VGND#2	a_618_94#	9.49934e-18
C583	VPWR#5	VNB	4.95563e-17
C584	VGND#7	VGND#6	1.05424e-18
C585	VGND#7	X#5	6.392e-18
C586	VGND#4	VGND#7	5.42046e-17
*
*
.ENDS sky130_fd_sc_hs__o21ba_4
*
