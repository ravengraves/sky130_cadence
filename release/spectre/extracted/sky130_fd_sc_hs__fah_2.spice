* Extracted by Quantus, converted by sky130cad/quantus.py
*
*
*
*                       LINUX           Wed Nov 18 08:39:02 2026
*
*
*
*  PROGRAM  advgen
*
*  Name           : advgen - Quantus - (64-bit)
*  Version        : 25.1.0-p047
*  Build Date     : Thu Dec 11 23:20:30 PST 2025
*
*  HSPICE LIBRARY
*
*  OPERATING_TEMPERATURE 150
*  QRC_TECH_DIR <path>/tech
*
*
*

*
.SUBCKT sky130_fd_sc_hs__fah_2 VPB VNB VGND VPWR COUT SUM B A CI
*
*
*  caps2d version: 10
*
*
*       TRANSISTOR CARDS
*
*
XM28 VGND#10 a_81_260##4 a_114_368# VNB sky130_fd_pr__nfet_01v8_lvt l=0.15 w=0.74 ad=0.222 as=0.1961 pd=2.08 ps=2.01
XM17 a_81_260##5 A#4 VGND#15 VNB sky130_fd_pr__nfet_01v8_lvt l=0.15 w=0.64 ad=0.2272 as=0.1792 pd=1.99 ps=1.84
XM14 VGND#15 A#1 a_413_392##4 VNB sky130_fd_pr__nfet_01v8_lvt l=0.15 w=0.64 ad=0.1792 as=0.1792 pd=1.84 ps=1.84
XM23 a_413_392##4 B#1 a_514_424##17 VNB sky130_fd_pr__nfet_01v8_lvt l=0.15 w=0.64 ad=0.1792 as=0.3904 pd=1.84 ps=2.5
XM35 a_514_424##17 a_481_379##7 a_114_368##7 VNB sky130_fd_pr__nfet_01v8_lvt l=0.15 w=0.64 ad=0.3904 as=0.544 pd=2.5 ps=2.98
XM9 a_114_368##7 B#5 a_849_424##12 VNB sky130_fd_pr__nfet_01v8_lvt l=0.15 w=0.64 ad=0.544 as=0.4448 pd=2.98 ps=2.67
XM1 a_849_424##12 a_481_379# a_413_392##6 VNB sky130_fd_pr__nfet_01v8_lvt l=0.15 w=0.64 ad=0.4448 as=0.2455 pd=2.67 ps=2.38
XM15 VGND#14 B#7 a_481_379##8 VNB sky130_fd_pr__nfet_01v8_lvt l=0.15 w=0.74 ad=0.31405 as=0.233 pd=2.87 ps=2.13
XM20 a_481_379##8 a_849_424##5 a_1451_424##10 VNB sky130_fd_pr__nfet_01v8_lvt l=0.15 w=0.64 ad=0.233 as=0.56 pd=2.13 ps=3.03
XM32 a_1451_424##10 a_514_424##3 a_1689_424##8 VNB sky130_fd_pr__nfet_01v8_lvt l=0.15 w=0.64 ad=0.56 as=0.4352 pd=3.03 ps=2.64
XM0 a_1689_424##8 a_849_424##6 a_1895_424##10 VNB sky130_fd_pr__nfet_01v8_lvt l=0.15 w=0.64 ad=0.4352 as=0.4729 pd=2.64 ps=2.9
XM19 a_1895_424##10 a_514_424##8 a_2052_424# VNB sky130_fd_pr__nfet_01v8_lvt l=0.15 w=0.64 ad=0.4729 as=0.2688 pd=2.9 ps=2.12
XM33 a_2052_424# a_1689_424##3 VGND#13 VNB sky130_fd_pr__nfet_01v8_lvt l=0.15 w=0.64 ad=0.2688 as=0.3652 pd=2.12 ps=2.64
XM7 VGND#13 CI#3 a_1689_424##10 VNB sky130_fd_pr__nfet_01v8_lvt l=0.15 w=0.64 ad=0.3652 as=0.176 pd=2.64 ps=1.83
XM26 COUT#1 a_1451_424##6 VGND#12 VNB sky130_fd_pr__nfet_01v8_lvt l=0.15 w=0.74 ad=0.2072 as=0.2739 pd=2.04 ps=2.27
XM31 VGND#11 a_1451_424##5 COUT#1 VNB sky130_fd_pr__nfet_01v8_lvt l=0.15 w=0.74 ad=0.259 as=0.2072 pd=2.18 ps=2.04
XM16 SUM#2 a_1895_424##6 VGND#11 VNB sky130_fd_pr__nfet_01v8_lvt l=0.15 w=0.74 ad=0.2146 as=0.259 pd=2.06 ps=2.18
XM18 VGND#1 a_1895_424# SUM#2 VNB sky130_fd_pr__nfet_01v8_lvt l=0.15 w=0.74 ad=0.2109 as=0.2146 pd=2.05 ps=2.06
XM13 VPWR#10 a_81_260##3 a_114_368##4 VPB sky130_fd_pr__pfet_01v8 l=0.15 w=1.12 ad=0.3192 as=0.3136 pd=2.81 ps=2.8
XM34 a_81_260##8 A#3 VPWR#15 VPB sky130_fd_pr__pfet_01v8 l=0.15 w=1 ad=0.285 as=0.36 pd=2.57 ps=2.72
XM22 VPWR#15 A#5 a_413_392##2 VPB sky130_fd_pr__pfet_01v8 l=0.15 w=1 ad=0.36 as=0.3406 pd=2.72 ps=2.71
XM4 a_413_392##2 a_481_379##5 a_514_424##13 VPB sky130_fd_pr__pfet_01v8 l=0.15 w=0.84 ad=0.3406 as=0.7686 pd=2.71 ps=3.51
XM27 a_514_424##13 B#3 a_114_368##5 VPB sky130_fd_pr__pfet_01v8 l=0.15 w=0.84 ad=0.7686 as=0.3864 pd=3.51 ps=2.6
XM10 a_114_368##5 a_481_379##6 a_849_424##11 VPB sky130_fd_pr__pfet_01v8 l=0.15 w=0.84 ad=0.3864 as=1.1298 pd=2.6 ps=4.37
XM29 a_849_424##11 B#10 a_413_392# VPB sky130_fd_pr__pfet_01v8 l=0.15 w=0.84 ad=1.1298 as=0.2394 pd=4.37 ps=2.25
XM30 VPWR#14 B#11 a_481_379##9 VPB sky130_fd_pr__pfet_01v8 l=0.15 w=1.12 ad=0.3192 as=0.3948 pd=2.81 ps=2.99
XM11 a_481_379##9 a_514_424# a_1451_424##8 VPB sky130_fd_pr__pfet_01v8 l=0.15 w=0.84 ad=0.3948 as=0.8736 pd=2.99 ps=3.76
XM8 a_1451_424##8 a_849_424##7 a_1689_424##11 VPB sky130_fd_pr__pfet_01v8 l=0.15 w=0.84 ad=0.8736 as=0.7392 pd=3.76 ps=3.44
XM2 a_1689_424##11 a_514_424##5 a_1895_424##8 VPB sky130_fd_pr__pfet_01v8 l=0.15 w=0.84 ad=0.7392 as=0.5334 pd=3.44 ps=2.95
XM5 a_1895_424##8 a_849_424# a_2052_424##2 VPB sky130_fd_pr__pfet_01v8 l=0.15 w=0.84 ad=0.5334 as=0.4918 pd=2.95 ps=3.07
XM21 a_2052_424##2 a_1689_424##4 VPWR#13 VPB sky130_fd_pr__pfet_01v8 l=0.15 w=1 ad=0.4918 as=0.5914 pd=3.07 ps=3.46
XM24 VPWR#13 CI#1 a_1689_424##5 VPB sky130_fd_pr__pfet_01v8 l=0.15 w=1 ad=0.5914 as=0.285 pd=3.46 ps=2.57
XM3 VPWR#12 a_1451_424##7 COUT#2 VPB sky130_fd_pr__pfet_01v8 l=0.15 w=1.12 ad=0.303 as=0.336 pd=2.81 ps=2.84
XM25 COUT#2 a_1451_424# VPWR#11 VPB sky130_fd_pr__pfet_01v8 l=0.15 w=1.12 ad=0.336 as=0.336 pd=2.84 ps=2.84
XM6 VPWR#11 a_1895_424##4 SUM#1 VPB sky130_fd_pr__pfet_01v8 l=0.15 w=1.12 ad=0.336 as=0.3472 pd=2.84 ps=2.86
XM12 SUM#1 a_1895_424##5 VPWR#1 VPB sky130_fd_pr__pfet_01v8 l=0.15 w=1.12 ad=0.3472 as=0.336 pd=2.86 ps=2.84
*
*
*       RESISTOR AND CAP/DIODE CARDS
*
Rg1	a_81_260#	a_81_260##2	69.933121
Rg2	a_81_260##2	a_81_260##3	469.335449
Rg3	a_81_260##2	a_81_260##4	387.022156
Rg4	A#1	A#2	335.647034
Rg5	A#2	A#3	548.326599
Rg6	A#2	A#4	282.340088
Rg7	A#2	A#5	473.866638
Rg8	B#1	B#2	485.386353
Rg9	B#3	B#4	354.298584
Rg10	B#5	B#6	279.244598
Rg11	a_481_379#	a_481_379##2	355.013092
Rg12	a_481_379##2	a_481_379##3	479.952271
Rg13	a_481_379##3	a_481_379##4	600.852966
Rg14	a_481_379##4	a_481_379##5	1067.414551
Rg15	a_481_379##3	a_481_379##6	335.548798
Rg16	a_481_379##4	a_481_379##7	234.008942
Rg17	B#7	B#8	547.215454
Rg18	B#8	B#9	74.436798
Rg19	B#9	B#10	574.998535
Rg20	B#8	B#11	388.908356
Rg21	B#9	B#12	40.009975
Rg22	a_514_424#	a_514_424##2	346.607391
Rg23	a_514_424##3	a_514_424##4	325.153564
Rg24	a_514_424##5	a_514_424##6	514.531372
Rg25	a_849_424#	a_849_424##2	942.284058
Rg26	a_849_424##2	a_849_424##3	793.401855
Rg27	a_849_424##3	a_849_424##4	234.602875
Rg28	a_849_424##4	a_849_424##5	413.530487
Rg29	a_849_424##2	a_849_424##6	308.610992
Rg30	a_849_424##3	a_849_424##7	331.921295
Rg31	a_514_424##7	a_514_424##8	399.755615
Rg32	a_1689_424#	a_1689_424##2	182.971558
Rg33	a_1689_424##2	a_1689_424##3	480.765717
Rg34	a_1689_424##2	a_1689_424##4	415.223511
Rg35	CI#1	CI#2	409.090576
Rg36	CI#2	CI#3	436.266174
Rg37	a_1451_424#	a_1451_424##2	507.075531
Rg38	a_1451_424##2	a_1451_424##3	61.878078
Rg39	a_1451_424##3	a_1451_424##4	46.693027
Rg40	a_1451_424##2	a_1451_424##5	322.953644
Rg41	a_1451_424##3	a_1451_424##6	362.264893
Rg42	a_1451_424##3	a_1451_424##7	451.213501
Rg43	a_1895_424#	a_1895_424##2	368.862610
Rg44	a_1895_424##2	a_1895_424##3	67.465767
Rg45	a_1895_424##3	a_1895_424##4	467.208984
Rg46	a_1895_424##2	a_1895_424##5	471.862823
Rg47	a_1895_424##3	a_1895_424##6	374.015472
Rf1	a_114_368#	a_114_368##2	48.788265
Rf2	a_114_368##2	a_114_368##3	4.980746
Rf3	a_114_368##2	a_114_368##4	47.831318
Rf4	a_81_260##5	a_81_260##6	43.197365
Rf5	a_81_260##6	a_81_260#	164.387070
Rf6	a_81_260##6	a_81_260##8	56.436161
Rf7	A#6	A	2.886009
Rf8	A#2	A#8	163.118805
Rf9	A#6	A#8	6.331763
Rf10	a_114_368##5	a_114_368##6	78.736511
Rf11	a_114_368##6	a_114_368##7	26.311781
Rf12	a_413_392#	a_413_392##3	301.656250
Rf13	a_413_392##3	a_413_392##5	100.984955
Rf14	a_413_392##5	a_413_392##6	285.439209
Rf15	a_413_392##2	a_413_392##3	7.500000
Rf16	a_413_392##4	a_413_392##5	7.500000
Rf17	B#12	B#14	284.519440
Rf18	B#14	B#15	62.273506
Rf19	B#15	B#2	115.402748
Rf20	B#14	B#6	205.360733
Rf21	B#15	B#4	230.999496
Rf22	B#2	B	5.548359
Rf23	a_481_379##8	a_481_379##10	82.383186
Rf24	a_481_379##10	a_481_379##2	272.617432
Rf25	a_481_379##9	a_481_379##10	15.000000
Rf26	a_849_424##4	a_849_424##9	417.569733
Rf27	a_849_424##9	a_849_424##10	58.609070
Rf28	a_849_424##10	a_849_424##11	35.722931
Rf29	a_849_424##9	a_849_424##12	28.396952
Rf30	a_849_424##10	a_849_424##11	25.234573
Rf31	a_1451_424##8	a_1451_424##9	92.496910
Rf32	a_1451_424##9	a_1451_424##10	19.790314
Rf33	a_514_424##7	a_514_424##6	353.297974
Rf34	a_514_424##6	a_514_424##11	144.355423
Rf35	a_514_424##11	a_514_424##12	139.455338
Rf36	a_514_424##12	a_514_424##14	316.837952
Rf37	a_514_424##11	a_514_424##4	236.346252
Rf38	a_514_424##12	a_514_424##2	196.408493
Rf39	a_514_424##14	a_514_424##17	112.836113
Rf40	a_514_424##13	a_514_424##14	7.500000
Rf41	a_2052_424#	a_2052_424##2	146.331818
Rf42	CI#2	CI#5	161.005447
Rf43	CI#6	CI	0.772649
Rf44	CI#5	CI#6	5.708254
Rf45	a_1689_424##5	a_1689_424#	65.053429
Rf46	a_1689_424#	a_1689_424##7	30.545364
Rf47	a_1689_424##7	a_1689_424##9	189.759979
Rf48	a_1689_424##7	a_1689_424##10	26.208628
Rf49	a_1689_424##9	a_1689_424##11	117.684364
Rf50	a_1689_424##8	a_1689_424##9	7.500000
Rf51	a_1451_424##4	a_1451_424##12	178.341751
Rf52	COUT#1	COUT	54.233952
Rf53	COUT	COUT#3	13.388785
Rf54	COUT#3	COUT	0.970202
Rf55	COUT#2	COUT#3	15.000000
Rf56	a_1895_424##3	a_1895_424##9	472.800476
Rf57	a_1895_424##9	a_1895_424##10	108.397652
Rf58	a_1895_424##8	a_1895_424##9	7.500000
Rf59	SUM#1	SUM	64.414948
Rf60	SUM	SUM#3	3.208534
Rf61	SUM#2	SUM#3	7.500000
Rf62	VPWR#1	VPWR#2	65.204430
Rf63	VPWR#2	VPWR#3	52.206570
Rf64	VPWR#3	VPWR#4	65.696381
Rf65	VPWR#4	VPWR#5	80.282089
Rf66	VPWR#5	VPWR#6	82.132881
Rf67	VPWR#6	VPWR#7	266.609772
Rf68	VPWR#7	VPWR#8	224.240479
Rf69	VPWR#8	VPWR#9	120.874039
Rf70	VPWR#9	VPWR#10	148.777069
Rf71	VPWR#3	VPWR#11	32.342297
Rf72	VPWR#4	VPWR#12	32.342297
Rf73	VPWR#5	VPWR#13	22.587994
Rf74	VPWR#7	VPWR#14	34.704330
Rf75	VPWR#9	VPWR#15	35.727165
Rf76	VGND#1	VGND#2	36.005051
Rf77	VGND#2	VGND#3	54.032833
Rf78	VGND#3	VGND#4	68.618401
Rf79	VGND#4	VGND#5	73.789284
Rf80	VGND#5	VGND#6	84.040886
Rf81	VGND#6	VGND#7	261.496246
Rf82	VGND#7	VGND#8	229.354019
Rf83	VGND#8	VGND#9	99.381493
Rf84	VGND#9	VGND#10	153.431488
Rf85	VGND#3	VGND#11	33.306259
Rf86	VGND#4	VGND#12	30.373932
Rf87	VGND#5	VGND#13	28.073811
Rf88	VGND#7	VGND#14	31.948624
Rf89	VGND#9	VGND#15	45.213318
Re1	a_114_368##6	a_114_368##3	25.946058
Re2	a_1451_424##12	a_1451_424##9	25.946058
Re3	VPWR#2	VPWR#17	6.363944
Re4	VPWR#17	VPWR	1.106290
Re5	VPWR	VPWR#8	2.173466
Re6	VGND#2	VGND#17	6.363944
Re7	VGND#17	VGND	1.106290
Re8	VGND	VGND#8	2.173466
Re14	VPWR#6	VPWR#17	0.698413
Re17	VGND#6	VGND#17	0.698413
*
*       CAPACITOR CARDS
*
*
C1	a_413_392##2	a_514_424##13	1.72183e-16
C2	VGND#11	VGND#1	1.97003e-18
C3	a_1895_424##10	a_1689_424##2	4.71994e-19
C4	a_413_392##4	B#5	2.95222e-19
C5	VGND#7	B#9	5.34803e-19
C6	VGND#9	A#2	2.98887e-19
C7	B#3	a_481_379##3	9.81696e-20
C8	VGND#3	a_1451_424##2	6.5791e-20
C9	a_849_424##10	B#10	1.015e-18
C10	B#14	a_849_424##9	4.76647e-17
C11	a_514_424##17	a_481_379##7	2.86538e-17
C12	a_1451_424##7	a_1451_424#	4.9071e-17
C13	a_514_424##7	a_2052_424#	8.77556e-17
C14	a_1689_424##7	a_1689_424##5	8.79271e-19
C15	a_81_260##5	VGND#15	3.25655e-17
C16	a_2052_424#	a_2052_424##2	1.78676e-18
C17	a_849_424##10	a_481_379##2	7.35377e-17
C18	a_514_424##7	a_1895_424##10	1.07488e-16
C19	a_849_424##9	a_481_379##2	9.80043e-17
C20	a_413_392##4	a_481_379##7	7.43488e-18
C21	a_1689_424##8	a_514_424##7	3.37074e-17
C22	a_1689_424#	a_1689_424##2	2.46404e-17
C23	VGND#11	SUM#2	6.66706e-17
C24	a_514_424##12	B#3	2.46531e-19
C25	VGND#9	A#4	2.79078e-18
C26	a_413_392##6	B#15	1.02194e-17
C27	VPWR#9	A#2	2.26099e-19
C28	B#1	a_514_424##17	2.13496e-17
C29	a_1895_424##3	SUM#1	6.64691e-17
C30	VPWR#15	a_413_392##2	9.31505e-17
C31	VGND#2	a_1895_424#	1.28669e-18
C32	CI#1	a_1451_424##7	6.94899e-18
C33	VGND#7	a_413_392##6	7.86929e-17
C34	a_1895_424##10	a_2052_424##2	2.12481e-18
C35	a_114_368#	VGND#15	2.17895e-18
C36	B#14	B#12	2.55988e-18
C37	a_1895_424##3	VPWR#11	3.82308e-17
C38	VGND#7	B#8	1.61751e-19
C39	VGND#9	a_81_260#	1.33507e-18
C40	a_514_424##6	a_1895_424##10	6.44449e-17
C41	VGND#2	a_1895_424##6	1.33009e-18
C42	A#8	a_413_392##2	1.82122e-17
C43	a_114_368##6	a_413_392#	6.42272e-19
C44	a_413_392##4	B#1	1.70326e-17
C45	a_849_424##10	B#6	9.10624e-19
C46	a_1895_424##3	COUT#2	6.19497e-17
C47	a_1895_424##10	a_849_424##2	2.8323e-17
C48	a_514_424##6	a_1689_424##8	1.12751e-16
C49	VPWR#8	a_481_379##9	3.753e-18
C50	a_413_392##6	B#14	9.48982e-17
C51	B#6	a_849_424##9	5.69171e-17
C52	VGND#2	VGND#3	1.3718e-17
C53	a_1895_424##3	VPWR#12	3.51706e-17
C54	VPWR#5	VPWR#4	8.95385e-19
C55	a_114_368#	a_81_260##5	3.00334e-17
C56	VGND#10	VGND#15	1.63465e-19
C57	B#15	a_481_379##4	3.20799e-18
C58	a_1689_424##4	CI#1	1.91701e-17
C59	a_1895_424##10	a_1895_424##8	1.66085e-18
C60	a_114_368##6	a_114_368##5	3.49507e-18
C61	VGND#9	a_81_260##4	9.11091e-19
C62	a_81_260#	VPWR#9	7.13965e-19
C63	a_413_392#	VPWR#8	1.12061e-16
C64	B#14	a_481_379##2	6.11806e-19
C65	VPWR#2	VPWR#3	1.15632e-17
C66	COUT#2	a_1451_424##4	1.77414e-18
C67	a_413_392##4	A#1	3.80387e-17
C68	a_81_260##8	VPWR#15	7.23184e-17
C69	a_114_368##6	a_514_424##13	1.10395e-17
C70	a_1451_424##12	VGND#5	2.65321e-18
C71	A#8	VPWR#15	8.90735e-18
C72	a_1689_424##8	a_849_424##3	3.81827e-18
C73	a_514_424##7	a_1689_424##2	3.01534e-17
C74	a_514_424##4	a_1689_424##8	3.94476e-17
C75	VPWR#8	a_849_424##11	4.57422e-18
C76	VPWR#12	a_1451_424##4	7.96494e-19
C77	COUT#1	VGND#11	7.04433e-17
C78	a_114_368##6	a_413_392##2	5.12629e-18
C79	a_1451_424##12	a_1451_424##6	5.9601e-18
C80	a_514_424##4	a_1451_424##10	4.93371e-17
C81	B#14	a_849_424##12	9.16048e-18
C82	a_1451_424##12	VGND#4	2.13253e-18
C83	a_413_392#	VPWR#7	8.05912e-17
C84	VPWR#8	a_114_368##5	6.50627e-18
C85	A#1	VGND#15	1.60836e-17
C86	B#15	a_114_368##7	4.95338e-17
C87	a_849_424#	a_1689_424##4	2.1684e-17
C88	a_849_424##2	a_514_424##7	3.43978e-17
C89	VGND#8	a_481_379##9	1.43573e-18
C90	B#15	a_481_379##3	2.98947e-19
C91	a_1451_424##12	CI#3	5.28845e-19
C92	COUT#2	CI#2	3.08505e-19
C93	VPWR#8	a_514_424##13	4.08464e-17
C94	A#5	a_481_379##4	4.1255e-19
C95	a_413_392##4	A#4	4.15277e-18
C96	CI#5	a_1689_424##5	2.16299e-17
C97	B#14	B#6	1.55988e-18
C98	a_81_260##2	a_114_368##4	7.64865e-21
C99	a_1689_424##8	a_849_424##2	1.72893e-17
C100	a_1451_424##9	VGND#7	6.80649e-19
C101	a_81_260##5	A#1	1.37641e-18
C102	a_849_424##4	a_1689_424##8	3.58068e-18
C103	a_413_392##2	VPWR#8	1.52621e-16
C104	a_1451_424##12	a_1689_424##3	5.65149e-18
C105	a_1451_424##2	a_1895_424##6	1.68602e-18
C106	VGND#12	VGND#11	1.83428e-18
C107	VGND#10	a_114_368#	5.86941e-17
C108	a_81_260##2	A#4	1.08952e-19
C109	a_849_424##4	a_1451_424##10	1.02729e-16
C110	a_1689_424##5	CI#2	2.52096e-18
C111	a_1451_424##4	a_1895_424##8	3.7155e-18
C112	a_1689_424##8	a_1689_424##11	4.68446e-19
C113	VPWR#8	VPWR#15	2.18287e-17
C114	VGND#15	A#4	3.22073e-17
C115	a_114_368##4	a_81_260##8	7.44155e-17
C116	a_1451_424##12	a_514_424##8	9.62046e-20
C117	VPWR#10	VPWR#15	5.88658e-19
C118	B#14	a_114_368##7	2.94285e-17
C119	a_849_424##4	a_481_379##8	1.07175e-16
C120	a_514_424##5	a_849_424#	1.08718e-17
C121	a_1689_424#	COUT#2	1.19138e-18
C122	B#15	a_514_424##17	5.55695e-17
C123	VPWR#8	a_81_260##8	1.64356e-17
C124	a_413_392##4	a_81_260##4	7.05184e-19
C125	a_849_424##4	VGND#14	4.45306e-17
C126	a_114_368##3	a_413_392##2	3.59608e-18
C127	B#15	B#4	1.64904e-18
C128	a_2052_424##2	CI#2	9.78175e-21
C129	A#4	a_81_260##5	2.05782e-17
C130	a_1451_424##10	a_849_424##3	6.85979e-19
C131	a_413_392##6	a_849_424##4	5.11719e-19
C132	VPWR#8	a_114_368##4	1.94677e-17
C133	a_1451_424##9	a_514_424##8	4.11593e-19
C134	a_114_368##3	VPWR#15	1.10165e-17
C135	a_1895_424##8	CI#2	1.51975e-19
C136	VPWR#4	VPWR#3	1.31785e-18
C137	a_849_424##3	a_514_424##6	2.52395e-17
C138	VGND#12	COUT#1	2.64287e-17
C139	VGND#15	a_81_260##4	7.53041e-19
C140	a_1689_424##7	a_1689_424##10	2.84314e-18
C141	a_1689_424##2	VPWR#13	9.39582e-19
C142	VPWR#8	VPWR#10	6.78117e-17
C143	a_1689_424#	VPWR#13	3.37176e-18
C144	a_114_368##3	a_81_260##8	7.45161e-19
C145	a_1451_424##9	a_849_424##6	8.7312e-19
C146	a_481_379##8	a_514_424##2	2.33538e-17
C147	a_849_424##7	a_514_424##5	4.05285e-18
C148	a_114_368#	A#4	1.60222e-18
C149	a_514_424##6	a_849_424##2	5.0306e-17
C150	B#14	a_481_379##3	1.46406e-18
C151	a_2052_424##2	a_1689_424#	5.31987e-17
C152	a_114_368##3	a_114_368##4	4.42554e-20
C153	a_1451_424##9	a_514_424##3	1.9719e-18
C154	VPWR#10	a_81_260##2	5.45917e-20
C155	a_413_392##4	B#15	8.28883e-17
C156	a_114_368##4	VPWR#10	9.00257e-17
C157	a_81_260##5	a_81_260##4	2.8922e-18
C158	a_1451_424##10	a_849_424##2	8.61915e-20
C159	a_1689_424#	a_1895_424##8	1.95023e-17
C160	a_514_424##12	a_849_424##5	7.24314e-19
C161	a_114_368##3	VPWR#10	1.58582e-17
C162	VGND#10	A#4	5.03354e-19
C163	a_1451_424##8	a_1451_424##10	1.99296e-18
C164	a_1689_424##10	COUT#1	4.65906e-18
C165	VGND#6	a_514_424##8	4.14724e-18
C166	VGND#9	a_413_392##4	4.24774e-17
C167	a_81_260##4	a_114_368#	3.1193e-17
C168	a_514_424#	a_849_424##7	3.5654e-18
C169	a_481_379##8	B#12	6.31637e-19
C170	a_81_260##2	A#3	2.77747e-19
C171	a_514_424##7	a_2052_424##2	2.62779e-17
C172	a_1689_424##7	VGND#13	5.78569e-17
C173	VGND#6	a_849_424##6	4.13139e-18
C174	a_1451_424##8	a_849_424##5	2.53969e-18
C175	a_514_424##7	a_1895_424##8	8.21111e-18
C176	B#12	a_413_392##6	8.21028e-17
C177	VGND#5	a_1689_424##7	2.51267e-17
C178	VGND#10	a_81_260##4	3.2647e-17
C179	VGND#6	a_514_424##3	7.47918e-18
C180	VPWR#7	a_849_424##3	1.15419e-20
C181	a_514_424##4	a_849_424##3	4.02046e-17
C182	A#8	B#2	1.62538e-19
C183	a_2052_424##2	a_1689_424##2	8.11645e-18
C184	a_1689_424##10	VGND#12	2.93048e-17
C185	a_514_424##12	B#7	5.02592e-19
C186	B#11	a_514_424#	2.85874e-17
C187	a_514_424##4	a_849_424##2	3.04904e-17
C188	B#15	a_481_379##5	2.77855e-19
C189	a_514_424##6	a_1895_424##8	8.91065e-17
C190	VPWR#5	a_1689_424##2	7.40964e-19
C191	a_1895_424##10	a_849_424#	4.04699e-18
C192	SUM#1	VPWR#1	9.82319e-17
C193	a_1689_424##11	a_514_424##6	9.87761e-17
C194	a_413_392##6	a_481_379##2	2.66623e-19
C195	a_1689_424##7	a_2052_424#	8.55936e-17
C196	a_114_368##6	VGND#9	1.63225e-18
C197	VPWR#2	a_1895_424##5	8.31633e-18
C198	a_1451_424##12	a_1689_424##7	4.58323e-17
C199	a_481_379##9	B#7	5.98683e-18
C200	a_413_392##2	VPWR#9	3.51119e-17
C201	VPWR#4	a_1451_424##2	4.60955e-21
C202	VGND#9	A#8	3.80985e-20
C203	VPWR#2	a_1895_424##2	4.81494e-20
C204	A#8	A#2	2.09798e-17
C205	B#10	B#11	6.91749e-18
C206	a_114_368##7	a_481_379##2	6.43775e-19
C207	VGND#13	VGND#12	3.27199e-18
C208	B#15	B#14	2.49692e-18
C209	VPWR#2	a_1895_424##4	3.47239e-18
C210	a_1895_424##6	a_1895_424#	3.73818e-17
C211	a_514_424##4	a_1689_424##11	5.2125e-17
C212	VPWR#11	VPWR#1	1.45992e-18
C213	a_413_392##6	B#6	3.645e-19
C214	a_1451_424##8	a_514_424##4	4.9885e-17
C215	B#6	a_849_424##12	6.40814e-19
C216	a_849_424##4	a_849_424##3	2.47268e-19
C217	a_481_379##6	B#10	1.76717e-18
C218	a_1895_424##8	a_1689_424##2	1.47621e-18
C219	a_114_368##7	B#6	4.63987e-17
C220	VGND#9	a_81_260##5	1.54773e-17
C221	VPWR#1	a_1895_424##5	2.83369e-17
C222	a_1689_424##10	VGND#13	1.08762e-17
C223	a_1451_424##4	a_1451_424##6	6.27654e-19
C224	a_849_424##4	a_849_424##2	9.32404e-19
C225	a_1689_424##10	CI#5	1.1129e-17
C226	a_1451_424##9	a_1689_424##7	2.11636e-18
C227	a_1689_424##11	a_849_424##4	1.47753e-19
C228	VPWR#11	SUM#1	2.28632e-17
C229	a_1451_424##12	CI#5	4.57897e-18
C230	CI#3	a_1451_424##4	3.03643e-18
C231	a_114_368##6	B#1	3.02772e-19
C232	a_1451_424##8	a_849_424##4	8.42827e-17
C233	a_481_379##8	B#8	8.09907e-18
C234	SUM#1	a_1895_424##5	5.72452e-17
C235	B#8	a_849_424##4	1.95132e-18
C236	VPWR#7	B#9	1.57746e-19
C237	a_481_379##9	a_849_424##4	8.60432e-18
C238	a_1451_424##4	a_1689_424##3	2.28935e-19
C239	a_1451_424##5	a_1895_424##6	2.68252e-17
C240	a_114_368##6	A#1	9.67747e-19
C241	B#3	a_481_379##6	1.88653e-17
C242	VPWR#1	a_1895_424##4	1.1108e-18
C243	VPWR#3	a_1451_424##2	5.24779e-20
C244	B#4	a_114_368##7	4.15541e-17
C245	a_514_424##11	a_849_424##3	1.50244e-18
C246	VGND#2	a_1895_424##2	6.23302e-19
C247	VPWR#11	a_1895_424##5	2.39451e-18
C248	a_849_424##9	B#7	8.40903e-18
C249	a_514_424##17	B#4	3.04588e-17
C250	a_514_424##2	a_1451_424##8	5.94972e-18
C251	a_1689_424##8	a_1689_424##7	8.89369e-19
C252	a_1689_424##3	CI#2	1.88228e-19
C253	SUM#1	a_1895_424##4	1.72424e-17
C254	a_481_379##9	a_514_424##2	4.95717e-17
C255	VGND#14	B#9	9.91182e-20
C256	a_514_424##12	B#9	6.20318e-18
C257	VGND#8	B#5	3.59861e-18
C258	VGND#1	a_1895_424#	2.43048e-17
C259	a_114_368##3	VGND#9	5.12997e-18
C260	a_481_379##5	B#3	3.72532e-18
C261	a_81_260##8	VPWR#9	1.76933e-17
C262	a_514_424##2	a_849_424##3	7.62018e-20
C263	VPWR#8	VPWR#9	1.03615e-16
C264	VGND#8	a_481_379##7	2.85027e-18
C265	VPWR#11	a_1895_424##4	3.85409e-17
C266	VPWR#7	B#8	1.00856e-19
C267	B#2	a_514_424##17	3.62999e-18
C268	A#8	a_413_392##4	2.8546e-17
C269	a_1451_424##6	a_1451_424##5	3.77351e-17
C270	VPWR#8	VPWR#7	1.27525e-16
C271	VGND#8	B#1	1.27948e-18
C272	a_514_424##11	a_849_424##2	3.40882e-19
C273	a_114_368##3	A#4	3.33643e-18
C274	a_413_392##4	B#2	6.09647e-18
C275	SUM#1	a_1451_424#	4.36829e-19
C276	SUM#2	a_1895_424#	3.14835e-17
C277	a_849_424##9	a_481_379#	1.90928e-17
C278	B#8	VGND#14	2.69256e-18
C279	COUT#2	a_1895_424##4	2.20003e-18
C280	VGND#8	A#1	2.43305e-18
C281	B#8	a_514_424##2	8.60357e-18
C282	VPWR#3	a_1895_424##4	3.33004e-18
C283	a_514_424##11	a_1895_424##8	2.55899e-17
C284	a_114_368##3	a_81_260##4	1.25188e-17
C285	A#5	a_481_379##5	3.8544e-17
C286	a_514_424##7	a_1689_424##3	1.42747e-18
C287	a_1451_424##9	a_849_424#	1.78175e-18
C288	VGND#1	a_1895_424##6	2.14029e-18
C289	a_1689_424##11	a_849_424##3	1.73162e-17
C290	a_514_424##12	B#8	1.9841e-18
C291	VGND#8	A#4	3.60226e-18
C292	VGND#6	a_1689_424##7	4.58457e-17
C293	VPWR#11	a_1451_424#	2.58558e-17
C294	VPWR#12	VPWR#11	9.0811e-18
C295	VGND#10	VGND#9	4.84074e-19
C296	a_514_424##7	a_514_424##8	1.89195e-17
C297	a_514_424##17	A#2	7.04539e-20
C298	VGND#11	a_1895_424#	1.35671e-18
C299	a_481_379##2	a_481_379##9	2.2824e-18
C300	VGND#8	VGND#9	1.0935e-16
C301	VGND#8	a_81_260##4	3.36647e-19
C302	a_114_368##4	VPWR#9	9.35379e-18
C303	VPWR#6	a_849_424#	4.61081e-18
C304	SUM#1	a_1451_424##7	2.23999e-19
C305	A#8	VGND#15	6.16076e-18
C306	a_413_392##4	A#2	1.298e-17
C307	a_514_424##7	a_849_424##6	9.73821e-19
C308	COUT#2	a_1451_424#	3.75792e-17
C309	SUM#2	a_1895_424##6	3.63193e-17
C310	VGND#15	A#2	2.4151e-18
C311	VGND#8	VGND#7	1.01494e-16
C312	a_413_392##6	B#9	4.94852e-19
C313	A#3	A#5	3.61523e-17
C314	CI#3	a_1451_424##6	5.0614e-18
C315	a_413_392#	a_481_379##2	3.87872e-18
C316	VPWR#6	a_514_424##5	4.40683e-18
C317	a_1689_424##11	a_849_424##2	5.48506e-18
C318	a_849_424##9	B#5	3.1019e-18
C319	a_81_260##5	A#2	2.83753e-18
C320	a_514_424##6	a_514_424##8	3.78444e-19
C321	VGND#6	a_849_424#	4.38899e-20
C322	VPWR#11	a_1451_424##7	2.6959e-18
C323	COUT#1	a_1895_424#	1.03146e-20
C324	a_481_379##2	a_849_424##11	8.00208e-19
C325	VGND#1	a_1451_424##5	3.24609e-19
C326	a_514_424##11	a_1689_424##11	1.02501e-16
C327	a_481_379##9	B#6	2.21776e-19
C328	a_514_424##6	a_849_424##6	2.2136e-17
C329	VPWR#6	a_849_424##7	3.28606e-18
C330	VPWR#12	a_1451_424#	3.91822e-18
C331	VPWR#3	a_1451_424#	3.97452e-18
C332	a_114_368##5	a_481_379##2	6.57727e-20
C333	SUM#1	CI#1	1.4839e-19
C334	VGND#11	a_1895_424##6	1.71434e-17
C335	a_1451_424##12	a_1689_424##2	1.5806e-19
C336	a_81_260#	a_413_392##4	4.45108e-19
C337	a_514_424##6	a_514_424##3	6.27412e-19
C338	a_514_424##12	a_514_424##11	1.58613e-18
C339	a_481_379##2	a_514_424##13	6.29356e-18
C340	B#12	B#9	7.12689e-19
C341	COUT#2	a_1451_424##7	3.26967e-17
C342	a_81_260##3	A#3	7.90245e-18
C343	VPWR#5	a_1451_424##7	1.46622e-18
C344	a_514_424##12	a_1451_424##8	8.53164e-17
C345	a_1895_424##3	a_1895_424##5	2.24742e-18
C346	a_1895_424##8	a_1895_424##5	1.15489e-19
C347	SUM#2	a_1451_424##5	1.21665e-18
C348	A#8	VPWR#9	5.86517e-19
C349	B#6	a_849_424##11	9.74124e-18
C350	a_514_424##4	a_849_424##6	8.3576e-20
C351	a_1689_424##5	COUT#2	1.02464e-17
C352	VPWR#10	VPWR#9	3.93929e-19
C353	a_1895_424##3	a_1895_424##4	1.97145e-17
C354	a_81_260#	a_114_368#	1.65979e-18
C355	a_1689_424##2	CI#1	1.623e-19
C356	a_1451_424##8	a_849_424##3	1.48461e-17
C357	a_514_424##11	VPWR#6	9.78586e-17
C358	VPWR#12	a_1451_424##7	4.20069e-17
C359	VPWR#4	a_1451_424##7	3.93302e-18
C360	COUT#1	a_1895_424##6	2.83951e-20
C361	a_1689_424##3	CI#3	1.82884e-17
C362	VGND#10	a_81_260#	2.56423e-19
C363	a_1451_424##9	a_849_424##9	2.00997e-18
C364	a_1895_424##3	a_1451_424#	2.78559e-17
C365	a_849_424##5	a_514_424##4	5.58408e-18
C366	a_514_424##11	a_1451_424##8	1.08713e-16
C367	COUT#2	CI#1	1.196e-18
C368	VGND#11	a_1451_424##5	4.57275e-17
C369	a_849_424##4	a_849_424##6	2.86048e-19
C370	a_1895_424##8	a_1895_424##4	1.5641e-19
C371	a_1895_424##3	a_1451_424##7	3.12569e-17
C372	a_1689_424##5	a_1451_424##7	4.20868e-18
C373	a_413_392##6	a_481_379##4	5.59343e-20
C374	a_849_424##4	a_514_424##3	2.2949e-18
C375	a_1451_424##4	a_1451_424#	3.2008e-18
C376	a_2052_424##2	a_1451_424#	2.55078e-19
C377	a_1451_424##8	a_849_424##2	1.07461e-19
C378	B#4	a_114_368##5	3.85253e-17
C379	a_1895_424##8	SUM#1	1.54383e-18
C380	a_514_424##12	a_481_379##9	8.38057e-17
C381	a_1895_424##3	CI#1	2.78838e-19
C382	VPWR#12	CI#1	3.92304e-18
C383	VPWR#5	CI#1	1.50882e-17
C384	a_849_424##4	a_849_424##5	2.77518e-17
C385	a_514_424##13	B#4	2.35858e-17
C386	VGND#3	a_1895_424##3	4.41816e-19
C387	COUT#1	a_1451_424##5	1.15294e-17
C388	a_413_392##2	B#4	2.23155e-19
C389	a_849_424##4	B#7	2.53943e-17
C390	COUT#2	a_1689_424##4	2.93467e-21
C391	VPWR#8	B#11	5.82988e-19
C392	a_1895_424##8	a_1451_424#	2.17987e-19
C393	a_1689_424##5	CI#1	4.10118e-17
C394	a_1689_424##8	a_1895_424##10	3.23171e-18
C395	a_514_424##8	a_1689_424##3	2.15031e-17
C396	a_849_424##4	a_481_379#	1.9803e-19
C397	a_481_379##2	B#9	4.2736e-17
C398	VGND#11	a_1451_424##6	2.94461e-18
C399	CI#2	a_1451_424##7	9.24959e-19
C400	a_413_392##6	a_481_379##3	6.34559e-19
C401	a_2052_424##2	a_1451_424##7	6.02609e-19
C402	VPWR#8	B#10	1.90757e-18
C403	a_1451_424##9	a_849_424##3	6.93753e-18
C404	VPWR#12	a_1689_424##4	7.36174e-19
C405	VGND#12	a_1451_424##5	7.08367e-19
C406	a_114_368##7	a_514_424##13	1.4001e-18
C407	B#7	a_514_424##2	9.56324e-18
C408	a_849_424##2	a_514_424##8	6.47142e-19
C409	CI#1	VPWR#13	2.18263e-17
C410	a_413_392##2	B#2	1.4188e-18
C411	VPWR#8	a_481_379##6	6.10983e-18
C412	VGND#3	a_1895_424##6	4.7536e-18
C413	a_514_424##12	VPWR#14	4.8127e-17
C414	a_1451_424##9	a_849_424##2	4.7079e-18
C415	a_1689_424#	a_1451_424##7	1.90078e-19
C416	a_481_379##3	a_481_379##2	1.44919e-18
C417	a_1895_424##8	a_1451_424##7	1.55353e-18
C418	COUT#1	a_1451_424##6	3.55977e-17
C419	a_114_368##6	a_481_379##5	2.67123e-18
C420	VGND#4	a_1451_424##4	1.7603e-19
C421	VPWR#8	B#3	6.06262e-18
C422	a_1895_424##3	VPWR#4	2.39194e-18
C423	VPWR#5	a_1689_424##4	1.47313e-17
C424	a_1689_424#	CI#1	1.96394e-19
C425	a_1689_424##5	VPWR#13	1.44735e-18
C426	VPWR#12	a_2052_424##2	8.5478e-20
C427	a_2052_424##2	CI#1	1.99624e-18
C428	B#12	B#7	3.64781e-18
C429	VGND#3	a_1451_424##4	2.94647e-20
C430	a_514_424##13	A#2	3.43678e-22
C431	VGND#11	CI#3	1.12004e-19
C432	B#14	a_481_379#	1.31959e-17
C433	a_514_424##17	a_514_424##13	9.21089e-19
C434	VPWR#12	a_849_424#	2.66852e-19
C435	a_1895_424##3	VPWR#3	2.85384e-18
C436	VPWR#8	a_481_379##5	7.75389e-18
C437	a_1689_424#	a_1689_424##4	6.31332e-18
C438	B#12	a_481_379#	2.93729e-17
C439	a_413_392##2	A#2	1.5428e-18
C440	a_849_424##6	a_514_424##8	7.66975e-18
C441	a_1689_424##4	VPWR#13	2.52491e-17
C442	a_1451_424##6	VGND#12	1.1166e-17
C443	VPWR#15	A#2	3.76911e-18
C444	B#12	B#5	7.585e-19
C445	VPWR#8	A#5	2.56152e-18
C446	a_1895_424##8	CI#1	3.62644e-17
C447	a_1895_424##2	SUM#2	1.48457e-19
C448	B#15	B#5	1.00732e-18
C449	COUT#1	CI#3	5.55668e-19
C450	a_2052_424##2	a_1689_424##4	4.50393e-17
C451	a_849_424##10	a_514_424##12	2.63538e-17
C452	VPWR#8	A#3	4.93002e-18
C453	a_1895_424##8	VPWR#12	9.76237e-18
C454	VGND#5	CI#2	2.18383e-20
C455	a_514_424##12	a_413_392#	9.28525e-17
C456	a_1451_424##10	a_1689_424##8	5.16777e-17
C457	VPWR#8	a_514_424##12	1.18208e-17
C458	a_81_260#	a_413_392##2	2.94081e-18
C459	a_849_424#	a_514_424##7	2.59626e-17
C460	VGND#3	a_1451_424##5	1.37137e-18
C461	VGND#8	a_481_379##5	4.38899e-20
C462	a_1689_424##10	a_1451_424##6	2.25621e-18
C463	a_481_379##9	B#9	7.21217e-18
C464	a_81_260#	VPWR#15	9.88382e-18
C465	VGND#4	CI#2	5.51912e-20
C466	VPWR#6	a_849_424##3	1.06524e-19
C467	a_114_368##3	A#3	4.71591e-19
C468	VPWR#4	a_1451_424##4	1.35923e-19
C469	B#14	B#5	1.70995e-17
C470	VPWR#5	a_849_424#	2.04881e-18
C471	a_1895_424##8	a_1689_424##4	3.51498e-17
C472	a_81_260#	a_81_260##8	4.79586e-19
C473	a_114_368##6	a_849_424##9	4.97953e-18
C474	VGND#12	CI#3	2.64308e-18
C475	B#6	a_481_379#	6.28856e-18
C476	a_849_424#	a_1689_424##2	1.61383e-18
C477	a_514_424##6	a_849_424#	3.11178e-17
C478	a_81_260#	a_114_368##4	1.24387e-17
C479	a_114_368##3	a_81_260##3	4.35511e-18
C480	a_481_379##3	B#6	5.311e-17
C481	a_514_424##3	a_849_424##6	7.52403e-18
C482	VPWR#6	a_849_424##2	4.59929e-19
C483	a_849_424#	a_2052_424##2	2.96668e-17
C484	a_1895_424##8	a_1689_424##5	3.82221e-17
C485	B#6	B#5	2.94347e-18
C486	VPWR#10	a_81_260#	2.37699e-20
C487	a_1451_424##12	VGND#6	1.3041e-18
C488	VGND#4	a_1451_424##6	8.33764e-18
C489	VGND#13	a_1451_424##6	6.31112e-19
C490	a_514_424##6	a_514_424##5	1.39472e-17
C491	B#15	a_481_379##7	2.78681e-17
C492	a_481_379##9	B#8	1.95307e-17
C493	B	a_481_379##4	4.65726e-18
C494	a_849_424##7	a_514_424##6	1.29274e-19
C495	a_114_368##7	a_481_379##4	9.01211e-18
C496	a_1451_424##9	VGND#6	9.07425e-18
C497	a_1689_424##10	CI#3	6.29591e-17
C498	a_1895_424##8	a_849_424#	5.85565e-17
C499	a_514_424##12	a_849_424##11	7.06575e-18
C500	VGND#2	VGND#1	1.56656e-17
C501	a_514_424##4	a_514_424##5	2.04134e-19
C502	B#4	B#5	1.36715e-20
C503	VPWR#8	a_849_424##10	7.07084e-18
C504	VPWR#5	CI#2	2.38428e-20
C505	a_849_424##9	a_481_379##9	4.62997e-17
C506	B#14	a_481_379##7	4.4252e-19
C507	a_849_424##2	a_849_424#	4.99033e-19
C508	VGND#12	a_1689_424##3	3.48696e-19
C509	a_2052_424##2	a_514_424##5	5.50541e-19
C510	a_1895_424##8	VPWR#13	2.75527e-18
C511	B#4	a_481_379##7	1.00453e-19
C512	a_514_424##4	a_849_424##7	3.43624e-18
C513	VGND#5	CI#3	4.92531e-18
C514	VGND#15	a_413_392##2	1.26052e-18
C515	VGND#2	SUM#2	3.21134e-17
C516	VPWR#4	CI#2	2.66117e-20
C517	VPWR#8	a_849_424##9	7.51353e-18
C518	a_1689_424##11	a_849_424#	2.71089e-19
C519	B#4	B#1	5.29497e-21
C520	VPWR#5	a_514_424##5	4.11398e-19
C521	CI#3	VGND#13	1.79229e-17
C522	a_849_424##5	a_514_424##3	4.3885e-18
C523	VGND#11	VGND#2	1.30681e-19
C524	a_514_424##5	a_1895_424##8	3.64034e-17
C525	B#15	B#1	4.0891e-19
C526	a_114_368##7	a_481_379##3	1.97908e-17
C527	VPWR#2	a_1895_424##3	2.39824e-18
C528	B#9	VPWR#14	1.66361e-18
C529	VGND#4	CI	5.26639e-19
C530	a_413_392##4	a_481_379##5	1.94158e-18
C531	a_1689_424##10	a_1689_424##3	5.29092e-19
C532	VGND#6	a_849_424##3	8.97475e-20
C533	a_1895_424##8	a_2052_424##2	9.21535e-17
C534	VGND#2	a_1895_424##3	3.79391e-18
C535	B#4	a_481_379##4	6.31934e-17
C536	a_114_368##5	a_514_424##12	1.68922e-18
C537	a_2052_424#	CI#3	2.51339e-19
C538	a_514_424##5	a_1689_424##11	2.35474e-17
C539	a_514_424##2	a_849_424##7	4.04108e-19
C540	SUM	a_1895_424##2	3.43064e-17
C541	A#1	B#2	7.3557e-19
C542	B#4	a_481_379##3	3.18231e-17
C543	VGND#6	a_849_424##2	5.0816e-19
C544	SUM	a_1451_424##2	1.01082e-18
C545	a_1451_424##12	a_1895_424##3	2.25203e-18
C546	VPWR#7	a_849_424##7	1.19058e-19
C547	a_1689_424##7	a_1451_424##4	4.20297e-18
C548	a_1451_424##12	SUM#2	2.21132e-18
C549	a_514_424##2	a_514_424#	5.16078e-19
C550	a_1895_424##8	a_849_424##7	7.79357e-22
C551	a_1689_424##3	VGND#13	1.55943e-17
C552	a_114_368##6	B#15	1.07185e-17
C553	B#8	VPWR#14	1.36372e-18
C554	B#11	a_514_424##2	7.95411e-18
C555	VGND#5	a_1689_424##3	4.11832e-18
C556	a_514_424##17	a_481_379##4	2.20692e-17
C557	a_1451_424##12	a_1451_424##4	9.15978e-21
C558	a_1451_424##12	VGND#11	2.77667e-18
C559	A#2	A#1	2.36914e-18
C560	a_849_424##9	B#9	3.42875e-17
C561	B#7	a_849_424##5	3.94695e-17
C562	a_114_368##6	B#14	2.37288e-18
C563	a_81_260##5	VPWR#15	9.00446e-19
C564	a_849_424##7	a_1689_424##11	1.69162e-17
C565	VGND#9	A	4.49866e-19
C566	a_1451_424##12	COUT#1	3.3963e-17
C567	a_2052_424#	a_1689_424##3	2.95959e-17
C568	VPWR#8	a_114_368##3	1.97512e-18
C569	VGND#8	a_114_368##6	5.16641e-17
C570	COUT#1	a_1895_424##2	5.84491e-20
C571	a_481_379##8	a_514_424##12	1.07297e-18
C572	a_81_260#	A#1	9.79128e-20
C573	a_1451_424##12	a_1689_424#	4.92988e-19
C574	a_1451_424##8	a_849_424##7	4.97163e-17
C575	a_1451_424##12	VGND#12	3.48886e-17
C576	VGND#3	SUM#2	3.95431e-18
C577	a_81_260#	A#4	2.77013e-19
C578	a_514_424##17	a_481_379##3	1.36858e-19
C579	VGND#1	VPWR#1	2.16595e-19
C580	a_1689_424##11	a_1895_424##8	9.09972e-19
C581	a_413_392#	B#9	1.22511e-18
C582	a_1689_424##7	CI#2	1.86879e-18
C583	VPWR#7	a_514_424#	5.55589e-18
C584	VGND#8	a_849_424##9	1.55274e-17
C585	a_481_379##2	B#10	2.29324e-17
C586	a_1451_424##12	a_514_424##7	4.43614e-18
C587	VGND#8	a_114_368##3	5.4349e-17
C588	a_1451_424##12	a_1689_424##10	4.65874e-17
C589	B#2	a_481_379##4	2.86597e-17
C590	a_849_424##10	a_849_424##11	8.23701e-18
C591	a_849_424##9	B#8	1.92003e-17
C592	a_1451_424##9	a_514_424##7	3.38942e-17
C593	a_481_379#	B#7	7.90548e-19
C594	a_514_424##8	a_2052_424#	1.19206e-17
C595	a_1451_424##12	VGND#13	5.31271e-18
C596	a_514_424#	a_1451_424##8	3.44652e-17
C597	COUT	a_1451_424##2	1.31756e-17
C598	VPWR#6	a_514_424##7	1.00127e-19
C599	VPWR#14	a_849_424##7	1.17508e-20
C600	VGND#5	VGND#4	2.14057e-19
C601	a_1451_424##9	a_514_424##6	3.37991e-17
C602	a_1689_424##7	a_849_424#	1.15602e-19
C603	a_1689_424##8	a_1689_424##3	1.08267e-19
C604	a_114_368##6	B#9	6.65022e-20
C605	a_849_424##10	a_481_379##3	1.56595e-19
C606	a_1451_424##12	a_2052_424#	2.72131e-17
C607	a_413_392##4	a_481_379##4	1.47903e-18
C608	VGND#6	a_514_424##7	3.86839e-20
C609	VPWR#6	a_514_424##6	4.47564e-19
C610	a_514_424#	a_481_379##9	2.47772e-17
C611	a_1451_424##9	a_514_424##4	2.08308e-17
C612	a_514_424##8	a_1895_424##10	2.12554e-17
C613	CI#5	CI#2	1.34441e-17
C614	a_1689_424##7	a_1689_424#	9.43713e-19
C615	a_1451_424##4	a_1895_424##3	1.00583e-17
C616	VPWR#7	B#11	6.74841e-18
C617	a_1451_424##9	a_849_424##4	4.57212e-18
C618	a_114_368##5	a_849_424##10	6.04173e-18
C619	VPWR#14	a_514_424#	4.23035e-18
C620	a_114_368##6	a_481_379##4	2.91887e-18
C621	SUM#1	VPWR#3	2.66014e-18
C622	B#5	a_481_379#	6.99267e-18
C623	VGND#4	COUT#1	5.39887e-18
C624	VGND#6	a_514_424##4	1.4985e-18
C625	a_481_379##5	B#4	1.38842e-17
C626	COUT#1	a_1451_424##2	6.16805e-18
C627	a_1689_424##8	a_514_424##8	2.72693e-19
C628	a_481_379##9	B#11	4.27401e-17
C629	a_413_392##6	VGND#14	2.30596e-17
C630	a_114_368##6	a_481_379##3	5.61296e-21
C631	VPWR#8	A#8	3.46739e-18
C632	a_849_424##9	a_849_424##10	2.59065e-18
C633	CI#2	a_1451_424##4	1.975e-17
C634	a_413_392#	a_514_424#	4.4935e-19
C635	B#2	a_481_379##5	2.29657e-17
C636	a_514_424##12	VPWR#7	3.98173e-17
C637	a_1689_424##10	CI	7.79e-18
C638	a_849_424##6	a_1895_424##10	1.59948e-17
C639	A#2	a_481_379##4	5.79799e-19
C640	a_1451_424##9	B#12	4.12054e-19
C641	a_1451_424##9	a_1895_424##10	2.74247e-17
C642	a_1689_424#	a_1451_424##4	3.52514e-18
C643	VGND#8	B#15	1.21342e-17
C644	VPWR#14	B#11	4.4055e-17
C645	a_413_392#	a_481_379##3	5.45751e-19
C646	a_1689_424#	CI#5	2.66172e-17
C647	a_81_260##2	A#2	8.07067e-20
C648	a_1689_424#	CI#2	5.4701e-18
C649	VGND#8	B#14	1.68517e-17
C650	a_1689_424##7	a_514_424##7	2.67365e-17
C651	a_1451_424##9	a_1689_424##8	5.06728e-17
C652	a_481_379##9	B#10	9.92452e-19
C653	VPWR	a_849_424##3	9.14761e-18
C654	VGND#3	COUT#1	7.21106e-18
C655	VPWR	a_849_424##2	8.20627e-19
C656	a_849_424##10	a_514_424##13	4.48549e-17
C657	a_413_392##4	a_81_260##2	4.52652e-20
C658	a_849_424##9	a_481_379##3	1.18486e-18
C659	a_413_392#	B#11	3.43274e-18
C660	a_514_424##11	CI#1	2.71064e-19
C661	a_1689_424##8	a_849_424##6	5.03692e-17
C662	a_481_379##7	B#5	3.80831e-18
C663	VPWR#7	B#10	5.59745e-18
C664	VGND#7	a_849_424##4	8.18577e-17
C665	A#3	A#2	2.83155e-18
C666	a_114_368##6	B#12	1.19652e-18
C667	a_81_260#	a_481_379##5	4.14283e-19
C668	a_1451_424##9	a_1451_424##10	3.94127e-17
C669	VGND#7	a_849_424##9	7.36088e-19
C670	a_114_368##3	A#8	1.6178e-17
C671	VPWR#14	B#10	1.86546e-18
C672	a_81_260#	A#5	1.18083e-18
C673	B	B#15	2.42053e-18
C674	a_81_260#	A#3	5.63557e-18
C675	a_1451_424##9	a_481_379##8	2.34172e-18
C676	a_1451_424##10	a_849_424##6	2.66274e-19
C677	VPWR#8	a_481_379##4	1.66943e-19
C678	VGND#5	a_1689_424##10	9.173e-18
C679	VPWR#8	a_481_379##2	6.95508e-18
C680	a_81_260#	a_81_260##3	5.71073e-19
C681	a_514_424##11	VPWR#7	4.43879e-17
C682	a_413_392#	B#10	6.00127e-17
C683	a_114_368##6	B#6	5.67844e-18
C684	VGND#8	B#12	1.12121e-17
C685	VGND#4	VGND#3	7.56132e-19
C686	a_514_424##6	a_514_424##7	8.0161e-19
C687	VPWR#8	a_481_379##3	6.45841e-18
C688	a_1689_424##8	a_514_424##3	1.73197e-17
C689	CI	COUT#2	8.19491e-19
C690	VPWR#8	B#6	4.11672e-18
C691	VGND#3	COUT	3.12092e-19
C692	VPWR#14	a_481_379##6	6.88297e-20
C693	a_1689_424##7	a_1689_424##2	1.13391e-19
C694	VGND#8	a_481_379##2	3.51951e-18
C695	a_114_368##6	B#4	3.5897e-17
C696	CI	a_1689_424##5	1.9175e-17
C697	B#10	a_849_424##11	1.90055e-17
C698	a_514_424##11	a_1689_424##4	4.02454e-19
C699	B#1	a_481_379##7	9.0975e-18
C700	VPWR#5	VPWR#12	3.09149e-18
C701	a_81_260#	a_481_379##4	1.20935e-19
C702	VGND#12	VGND#3	3.30265e-19
C703	VGND#7	a_849_424##5	4.59831e-18
C704	VPWR#7	a_849_424##4	8.88069e-20
C705	VPWR#8	B#4	3.206e-18
C706	VGND#8	A#8	2.03155e-18
C707	a_514_424##4	a_514_424##6	1.37875e-19
C708	A	a_81_260##5	1.48173e-17
C709	VGND#8	B#6	2.49751e-18
C710	a_849_424##11	a_481_379##3	5.52186e-18
C711	VPWR#7	a_481_379##6	1.06668e-19
C712	a_413_392#	a_481_379##6	2.01131e-17
C713	VGND#7	a_514_424##2	5.78671e-20
C714	a_1451_424##10	a_514_424##3	5.02894e-17
C715	a_81_260#	a_81_260##2	5.38062e-19
C716	a_114_368##5	B#10	3.27536e-19
C717	VPWR#8	B#2	4.76831e-19
C718	VGND#4	a_1689_424##10	7.69388e-18
C719	VGND#9	a_481_379##5	6.14458e-20
C720	VGND	a_1451_424##2	2.87134e-19
C721	a_849_424##9	a_481_379##8	7.59071e-17
C722	VGND#8	B#4	9.08887e-19
C723	VGND	a_1689_424##2	1.05127e-19
C724	VGND	a_849_424##3	5.91825e-20
C725	VGND#6	a_1689_424##8	9.96367e-17
C726	a_849_424##4	a_514_424##4	1.06445e-17
C727	VPWR#2	VPWR#1	1.46924e-17
C728	a_413_392##6	a_114_368##7	1.02958e-19
C729	a_514_424##11	VPWR#5	3.00279e-18
C730	a_481_379##6	a_849_424##11	3.37451e-17
C731	a_1689_424##8	a_849_424##5	8.08382e-19
C732	a_481_379##9	VPWR#14	7.60486e-19
C733	a_481_379#	B#9	2.8171e-18
C734	VGND#8	B#2	2.31397e-20
C735	B	a_514_424##17	7.26231e-17
C736	VGND#6	a_1451_424##10	9.97123e-18
C737	a_114_368##3	A#2	7.79986e-18
C738	a_413_392##4	B	1.07359e-16
C739	VGND#11	SUM	1.68636e-18
C740	SUM#1	VPWR#2	3.11937e-17
C741	a_413_392#	B#3	2.64122e-19
C742	COUT#1	SUM	2.04273e-18
C743	VPWR#8	a_81_260#	4.91579e-18
C744	VGND#8	A#2	5.48543e-21
C745	A#1	B#1	3.55544e-17
C746	a_514_424##2	a_849_424##4	7.51117e-17
C747	a_114_368##5	a_481_379##6	3.08613e-17
C748	a_514_424##11	a_849_424#	2.08228e-18
C749	a_114_368##3	a_81_260#	1.24794e-16
C750	VPWR	VPWR#7	8.17112e-17
C751	a_114_368##5	a_481_379##4	2.02539e-18
C752	a_849_424##5	a_1451_424##10	3.21347e-17
C753	a_1895_424##2	SUM#1	5.35405e-20
C754	VPWR	VPWR#5	8.70798e-17
C755	VPWR	VPWR#4	6.2332e-17
C756	VGND#8	a_81_260#	4.31365e-18
C757	VPWR#11	VPWR#2	2.19497e-19
C758	VPWR	VPWR#3	4.18532e-17
C759	VPWR#7	a_514_424##2	4.77871e-20
C760	VGND#7	B#7	4.45218e-18
C761	a_1689_424##7	a_1451_424##6	3.75124e-19
C762	VGND#2	VPWR#1	2.83914e-18
C763	a_514_424##13	a_481_379##6	2.47996e-17
C764	B#9	B#11	4.87913e-19
C765	a_849_424##9	VGND#14	3.41938e-17
C766	a_1689_424##8	B#7	6.93205e-19
C767	A	VPWR#15	2.03535e-17
C768	VGND#7	B#12	5.17521e-18
C769	VGND#13	VGND#4	3.54532e-19
C770	VPWR	CI#5	1.00799e-18
C771	VGND#2	SUM#1	1.22338e-18
C772	a_114_368##5	B#3	3.22861e-17
C773	a_114_368##3	a_81_260##2	3.06724e-17
C774	a_514_424##12	a_514_424##5	1.42057e-19
C775	a_849_424##5	a_481_379##8	1.94695e-17
C776	a_413_392##2	a_481_379##6	2.98907e-19
C777	VPWR	a_514_424##12	2.56403e-17
C778	a_114_368##5	a_481_379##3	1.05013e-17
C779	VPWR	a_514_424##11	5.94675e-17
C780	SUM	VPWR#1	1.73477e-17
C781	SUM	SUM#1	2.63205e-18
C782	a_514_424##6	a_514_424##11	3.22559e-18
C783	a_413_392#	VPWR#14	3.97439e-17
C784	A#4	A#1	3.63332e-17
C785	B	a_514_424##13	5.42707e-17
C786	a_514_424##13	B#3	4.12269e-17
C787	a_1895_424##2	VNB	3.53512e-17
C788	a_413_392##2	B	4.92519e-17
C789	a_1451_424##2	VNB	2.09423e-17
C790	a_1689_424##2	VNB	4.38442e-17
C791	a_514_424##11	a_514_424##5	1.41334e-17
C792	a_849_424##3	VNB	3.61257e-17
C793	a_81_260##5	a_81_260##2	3.4712e-20
C794	a_849_424##2	VNB	5.65659e-17
C795	B#9	VNB	7.11314e-17
C796	B#6	a_481_379##2	1.12383e-17
C797	VGND	VGND#7	8.21937e-17
C798	B#8	VNB	3.85016e-17
C799	a_481_379##4	VNB	4.44968e-17
C800	VGND	VGND#5	5.85726e-17
C801	VGND#8	B#9	1.72278e-18
C802	VPWR#9	a_481_379##5	4.59695e-18
C803	a_481_379##3	VNB	5.15112e-17
C804	VGND	VGND#4	5.71403e-17
C805	a_81_260##2	VNB	3.71428e-17
C806	VGND	VGND#3	4.12338e-17
C807	a_114_368##5	a_481_379##5	7.88308e-19
C808	a_1895_424##3	a_1895_424##2	3.61603e-18
C809	VPWR#5	VPWR#13	1.06942e-17
C810	a_413_392##2	B#3	2.03563e-17
C811	a_1689_424##7	CI#3	4.48856e-18
C812	a_114_368##6	a_413_392##6	1.14068e-18
C813	a_413_392##6	a_849_424##9	2.46205e-18
C814	VGND#7	a_481_379#	2.97659e-18
C815	a_481_379##8	B#7	4.62342e-17
C816	VGND	a_1689_424##7	3.79149e-17
C817	a_514_424##13	a_481_379##5	6.43726e-17
C818	B#14	a_849_424##11	1.86302e-18
C819	VGND#7	a_481_379##2	2.5643e-20
C820	VPWR#7	a_849_424##5	5.07877e-20
C821	VGND#8	a_481_379##4	3.94128e-19
C822	a_514_424##12	a_849_424##7	9.42556e-19
C823	VPWR#15	B#3	1.68782e-19
C824	a_514_424##13	a_481_379##4	3.33262e-18
C825	a_1451_424##2	a_1895_424##3	3.78414e-17
C826	a_1895_424##3	VGND#11	2.84348e-17
C827	SUM	a_1895_424#	3.55479e-18
C828	a_81_260##4	A#4	3.34493e-18
C829	SUM	a_1895_424##6	3.13442e-18
C830	B	B#5	5.59387e-20
C831	B#15	a_114_368##5	5.7664e-19
C832	a_514_424##11	a_514_424##4	2.44323e-19
C833	SUM	a_1451_424##5	1.82132e-19
C834	a_413_392##2	a_481_379##5	4.07279e-17
C835	VGND#8	a_481_379##3	3.71102e-19
C836	B#7	VGND#14	5.95364e-18
C837	B	a_481_379##7	1.3349e-18
C838	a_114_368##6	a_114_368##7	3.23243e-17
C839	B	B#1	1.57662e-17
C840	COUT#1	a_1895_424##3	3.75787e-18
C841	a_514_424##11	a_849_424##7	3.5713e-17
C842	B	A#1	1.13999e-18
C843	A#2	B#2	2.84208e-17
C844	a_413_392#	a_849_424##11	1.40557e-17
C845	a_514_424##13	A#5	1.22831e-18
C846	a_481_379##4	B#5	9.40372e-20
C847	a_1451_424##12	VPWR#12	1.3905e-18
C848	a_481_379##8	a_481_379#	1.4657e-19
C849	a_114_368##6	a_514_424##17	3.2673e-17
C850	VPWR#15	a_481_379##5	6.61057e-19
C851	VGND#9	VNB	5.7254e-17
C852	a_514_424##13	a_481_379##3	1.64741e-18
C853	a_1895_424##3	VGND#12	1.0975e-19
C854	VGND#7	VNB	1.07476e-16
C855	VPWR	VPWR#11	1.58244e-17
C856	VPWR#9	A#5	4.76724e-18
C857	VGND#5	VNB	3.19777e-17
C858	VPWR	COUT#2	3.85184e-18
C859	VGND#4	VNB	3.33267e-17
C860	VGND#3	VNB	2.69755e-17
C861	VPWR	VPWR#12	1.54593e-17
C862	VPWR#9	VNB	5.49538e-17
C863	VPWR#7	VNB	1.11743e-16
C864	VPWR	a_1689_424##5	4.40595e-18
C865	a_849_424##9	a_849_424##12	4.63189e-18
C866	VGND	VGND#11	1.9395e-17
C867	VPWR#5	VNB	3.94199e-17
C868	a_81_260#	A#2	3.80057e-17
C869	VPWR#4	VNB	3.29135e-17
C870	VGND	COUT#1	1.60266e-17
C871	a_1689_424##7	a_1689_424##3	2.83386e-17
C872	a_413_392##6	B#7	1.31303e-18
C873	VPWR#3	VNB	2.69425e-17
C874	VGND	VGND#12	1.17468e-17
C875	VPWR	a_2052_424##2	7.637e-18
C876	VGND	a_1689_424##10	1.60576e-17
C877	VPWR	a_1895_424##8	5.77338e-17
C878	a_114_368##6	a_413_392##4	4.43008e-17
C879	VGND	VGND#13	1.437e-17
C880	VPWR#7	a_481_379##2	3.06285e-19
C881	a_1451_424##12	a_1689_424##5	5.71105e-18
C882	a_413_392##2	A#5	5.79376e-17
C883	VPWR	a_1689_424##11	9.20217e-18
C884	VGND	a_2052_424#	4.39346e-18
C885	VPWR	a_1451_424##8	1.75468e-17
C886	a_1689_424##7	VNB	1.40001e-17
C887	VGND	a_1689_424##8	4.51215e-17
C888	VPWR	a_481_379##9	3.47759e-18
C889	VGND	a_1451_424##10	2.09013e-17
C890	a_114_368##7	a_849_424##10	6.20965e-20
C891	VGND	a_481_379##8	1.17774e-17
C892	a_413_392##4	a_114_368##7	4.20137e-19
C893	CI#5	VNB	5.44568e-19
C894	a_514_424##12	a_514_424#	3.44942e-17
C895	SUM	a_1895_424##5	1.68951e-18
C896	VPWR#8	a_114_368##7	1.0868e-18
C897	VGND#14	a_481_379#	5.45907e-19
C898	VGND#13	a_1689_424##2	9.16717e-19
C899	a_514_424##12	VNB	1.10151e-17
C900	SUM	a_1895_424##4	1.26065e-18
C901	a_514_424##11	VNB	1.38622e-17
C902	VPWR#7	B#7	8.10049e-20
C903	A	A#3	2.30964e-18
C904	a_1451_424##12	CI	5.35469e-18
C905	a_1451_424##12	VPWR#13	7.19472e-19
C906	B#15	a_514_424##13	3.66573e-19
C907	a_849_424##9	VNB	1.27956e-17
C908	VPWR#15	A#5	1.85206e-17
C909	COUT#1	a_1451_424##4	2.44999e-17
C910	a_514_424##11	a_849_424##4	9.11185e-19
C911	B	B#3	1.59772e-19
C912	B#15	VNB	3.47969e-19
C913	B#14	VNB	1.19518e-19
C914	B	a_481_379##5	2.76827e-17
C915	a_514_424##11	a_514_424#	2.69263e-19
C916	B	A#5	6.56628e-19
C917	A#8	VNB	5.08949e-20
C918	a_1451_424##4	VGND#12	2.45941e-18
C919	a_1451_424##12	a_2052_424##2	1.91547e-18
C920	a_413_392##2	A#3	2.22032e-18
C921	COUT	a_1895_424##4	4.84632e-19
C922	VGND#1	VNB	1.78425e-17
C923	a_413_392##6	a_481_379#	3.26208e-17
C924	a_413_392##2	a_481_379##4	9.09524e-19
C925	VGND#8	a_481_379##8	1.46484e-18
C926	SUM#2	VNB	1.78307e-17
C927	COUT	a_1451_424#	2.24022e-18
C928	VGND#11	VNB	3.63636e-18
C929	COUT#1	VNB	3.00517e-18
C930	VGND#12	VNB	6.09567e-18
C931	a_1689_424##10	VNB	7.62348e-18
C932	a_1451_424##4	a_1451_424##2	3.94301e-18
C933	VGND#13	VNB	2.36114e-18
C934	a_2052_424#	VNB	1.35772e-18
C935	a_1895_424##10	VNB	5.79069e-18
C936	a_114_368##7	a_849_424##9	3.94934e-18
C937	a_1689_424##8	VNB	1.4201e-17
C938	VPWR#8	A	2.13918e-18
C939	CI	a_1451_424##4	2.49612e-17
C940	a_114_368##5	a_849_424##11	3.00284e-17
C941	a_1451_424##10	VNB	1.06648e-17
C942	a_514_424##13	a_413_392#	1.00196e-16
C943	a_1451_424##12	a_1895_424##8	8.45339e-18
C944	a_481_379##8	VNB	3.68369e-18
C945	VPWR#9	A#3	2.93108e-19
C946	VGND#14	VNB	9.68762e-18
C947	a_114_368##3	A	1.66724e-17
C948	a_1689_424##10	a_1689_424##5	7.97304e-19
C949	VPWR#15	A#3	5.79829e-17
C950	CI	CI#2	6.37002e-18
C951	a_413_392##6	VNB	4.18023e-17
C952	VGND#8	VGND#14	1.85812e-17
C953	a_1689_424##7	a_514_424##8	1.71486e-17
C954	a_114_368##7	VNB	2.23633e-18
C955	VGND#8	A	1.10935e-18
C956	a_514_424##17	VNB	4.40077e-18
C957	a_413_392##4	VNB	2.82349e-17
C958	a_1895_424##8	VPWR#5	6.06382e-17
C959	a_1451_424##4	a_1689_424##2	2.67355e-19
C960	VGND#15	VNB	1.25838e-18
C961	VGND	a_1451_424##5	3.40562e-18
C962	a_81_260##5	VNB	1.64452e-17
C963	VGND#7	a_1451_424##10	1.45586e-17
C964	VPWR#2	SUM	2.77451e-18
C965	VGND	a_1451_424##6	4.24993e-18
C966	a_114_368##6	B	3.73678e-17
C967	a_114_368#	VNB	9.90465e-18
C968	VPWR	a_1895_424##4	4.62288e-21
C969	VGND#10	VNB	6.66088e-17
C970	VGND	CI#3	8.02586e-18
C971	VPWR#1	VNB	5.3598e-17
C972	VPWR	a_1451_424#	3.27299e-19
C973	VPWR#8	B	5.35792e-18
C974	SUM#1	VNB	2.97375e-18
C975	VPWR#11	VNB	1.7907e-19
C976	VPWR	a_1451_424##7	5.21661e-19
C977	a_514_424##12	B#11	2.92959e-17
C978	a_481_379#	a_849_424##12	8.34331e-18
C979	COUT#2	VNB	3.8017e-19
C980	a_413_392##2	a_81_260##3	8.76785e-20
C981	VPWR	CI#1	6.86273e-19
C982	VGND#7	a_849_424##3	9.4408e-20
C983	VPWR#12	VNB	3.05433e-18
C984	a_514_424##2	a_514_424##12	4.06432e-18
C985	VGND#8	a_413_392##6	1.26639e-16
C986	VGND	a_514_424##3	3.67457e-18
C987	a_1689_424##5	VNB	3.54107e-18
C988	VPWR	a_1689_424##4	8.06989e-19
C989	a_481_379##4	a_481_379##3	1.74615e-18
C990	VGND	a_849_424##5	5.05771e-18
C991	VGND#8	B	2.56384e-18
C992	a_1451_424##9	a_2052_424##2	8.52205e-19
C993	a_81_260##8	A#3	1.77349e-17
C994	VGND	B#7	2.95938e-18
C995	VPWR	a_849_424#	1.76308e-18
C996	a_1895_424##8	VNB	1.1709e-17
C997	VPWR	a_514_424##5	1.21113e-18
C998	a_413_392##2	a_481_379##3	2.43064e-19
C999	a_1689_424##11	VNB	2.49974e-18
C1000	a_1451_424##8	VNB	1.07555e-18
C1001	VPWR	a_849_424##7	2.92075e-18
C1002	a_481_379##9	VNB	5.48312e-18
C1003	VPWR#14	VNB	4.43519e-18
C1004	VPWR	a_514_424#	1.7307e-19
C1005	a_413_392#	VNB	2.0357e-17
C1006	a_849_424##11	VNB	7.85793e-19
C1007	a_114_368##5	VNB	3.94472e-19
C1008	a_514_424##13	VNB	2.13276e-18
C1009	a_413_392##6	B#5	6.5816e-18
C1010	a_413_392##2	VNB	1.7027e-17
C1011	a_514_424##13	a_849_424##11	4.59608e-17
C1012	a_81_260##8	VNB	1.31621e-17
C1013	VPWR#15	a_81_260##3	1.15083e-18
C1014	a_114_368##4	VNB	2.37742e-17
C1015	SUM	a_1895_424##3	5.4552e-17
C1016	VPWR#10	VNB	7.47669e-17
C1017	a_1451_424##9	a_1895_424##8	5.99438e-18
C1018	a_1895_424#	VNB	2.94496e-17
C1019	a_1895_424##6	VNB	2.80379e-17
C1020	a_114_368##4	A#3	2.21904e-18
C1021	a_1451_424##5	VNB	2.27993e-17
C1022	VGND#5	a_1689_424##2	2.26174e-20
C1023	a_81_260##2	VGND#10	1.32485e-18
C1024	a_1451_424##6	VNB	3.58968e-17
C1025	CI#3	VNB	4.59346e-17
C1026	a_1689_424##10	CI#2	2.87082e-18
C1027	a_1689_424##3	VNB	3.34772e-17
C1028	a_514_424##8	VNB	2.94279e-17
C1029	a_1895_424##8	VPWR#4	6.56763e-18
C1030	a_849_424##6	VNB	2.81768e-17
C1031	VGND#8	a_114_368##7	3.14315e-18
C1032	a_514_424##3	VNB	2.81395e-17
C1033	a_114_368##3	VGND#15	1.21691e-17
C1034	a_849_424##5	VNB	4.68055e-17
C1035	B#7	VNB	4.64773e-17
C1036	a_481_379#	VNB	4.09058e-17
C1037	COUT	a_1895_424##3	2.23829e-17
C1038	a_2052_424#	a_1689_424##2	7.65695e-18
C1039	B#5	VNB	2.80103e-17
C1040	a_481_379##7	VNB	2.66137e-17
C1041	COUT	a_1451_424##4	2.80354e-17
C1042	VPWR	VPWR#6	1.25938e-16
C1043	B#1	VNB	2.6931e-17
C1044	a_1451_424##9	a_1689_424##11	4.12638e-18
C1045	a_81_260##8	a_81_260##3	1.55641e-18
C1046	A#1	VNB	2.53285e-17
C1047	COUT	CI#2	8.85657e-19
C1048	A#4	VNB	2.82869e-17
C1049	A	A#2	1.38686e-17
C1050	a_81_260##4	VNB	4.37585e-17
C1051	VPWR#10	A#3	9.44e-19
C1052	VGND#9	B#1	1.57347e-18
C1053	a_1895_424##5	VNB	4.20203e-17
C1054	a_81_260#	A	4.3749e-17
C1055	B#5	a_849_424##12	2.05643e-17
C1056	a_1895_424##4	VNB	3.2402e-17
C1057	VGND#8	a_514_424##17	3.4279e-18
C1058	a_1451_424#	VNB	3.23772e-17
C1059	B	B#2	1.85391e-17
C1060	a_114_368##3	a_81_260##5	2.26207e-17
C1061	a_1895_424##4	a_1895_424##5	4.54194e-17
C1062	a_1451_424##7	VNB	3.86066e-17
C1063	CI#1	VNB	4.3941e-17
C1064	VPWR	a_1895_424##3	1.67767e-17
C1065	B	A#2	3.61387e-18
C1066	a_1689_424##4	VNB	3.87378e-17
C1067	a_1689_424##7	a_849_424##6	3.43978e-19
C1068	a_849_424#	VNB	6.26254e-17
C1069	VGND	a_1451_424##12	8.60487e-17
C1070	VPWR	a_1451_424##4	4.56372e-18
C1071	a_514_424##5	VNB	3.1728e-17
C1072	VGND	a_1451_424##9	8.16712e-17
C1073	a_514_424##13	a_114_368##5	6.64664e-17
C1074	a_849_424##7	VNB	3.26257e-17
C1075	a_514_424#	VNB	2.65218e-17
C1076	a_2052_424#	CI#2	2.08073e-19
C1077	VPWR	a_1689_424#	6.07303e-18
C1078	B#11	VNB	3.34798e-17
C1079	VGND	VGND#6	1.20467e-16
C1080	B#10	VNB	4.54246e-17
C1081	VPWR	a_514_424##7	5.80962e-18
C1082	a_114_368##4	a_81_260##3	7.47887e-17
C1083	a_514_424##12	B#10	2.79174e-17
C1084	a_481_379##6	VNB	3.05366e-17
C1085	VPWR	a_514_424##6	3.86936e-18
C1086	B#3	VNB	3.21894e-17
C1087	a_1895_424##8	VPWR#6	3.10592e-17
C1088	VGND#8	a_413_392##4	1.49855e-16
C1089	a_481_379##5	VNB	5.82569e-17
C1090	VPWR	a_514_424##4	6.92291e-19
C1091	a_413_392##6	a_481_379##7	3.15218e-19
C1092	A#5	VNB	3.87219e-17
C1093	a_114_368##3	a_114_368#	8.57061e-19
C1094	A#3	VNB	3.80123e-17
C1095	VPWR	a_849_424##4	5.03917e-18
C1096	VGND	a_1895_424##3	2.06252e-18
C1097	a_81_260##3	VNB	4.69675e-17
C1098	VPWR	a_514_424##2	1.62021e-18
C1099	VGND	a_1451_424##4	2.77355e-19
C1100	VPWR#2	VNB	1.1801e-16
C1101	VGND#2	VNB	1.14546e-16
C1102	a_1451_424##12	VNB	4.16752e-18
C1103	VGND#15	a_413_392##4	4.74916e-17
C1104	VGND	a_514_424##7	8.87475e-18
C1105	VPWR#6	VNB	7.17777e-17
C1106	VGND	a_514_424##6	4.79826e-18
C1107	VGND#6	VNB	7.20617e-17
C1108	VGND#9	B#2	1.5735e-20
C1109	B#5	a_114_368##7	1.76895e-17
C1110	VGND	a_514_424##4	2.55106e-18
C1111	a_114_368##6	VNB	1.01039e-18
C1112	VPWR#8	VNB	3.94037e-16
C1113	VGND	a_849_424##4	4.29455e-17
C1114	a_114_368##3	VNB	6.92049e-17
C1115	SUM#2	VGND#1	5.99071e-17
C1116	VGND	a_514_424##2	3.47887e-18
C1117	a_81_260##3	VPWR#10	3.27618e-17
C1118	VGND#8	VNB	3.65899e-16
C1119	a_114_368##3	VGND#10	3.92201e-17
C1120	a_1895_424##3	VNB	3.15292e-17
C1121	a_1451_424##4	VNB	5.71915e-17
C1122	CI#2	VNB	5.17138e-17
C1123	a_1689_424#	VNB	3.69483e-18
C1124	a_514_424##7	VNB	3.51299e-17
C1125	a_1689_424##2	CI#2	3.56667e-17
C1126	a_514_424##6	VNB	3.36502e-17
C1127	a_514_424##4	VNB	3.88418e-17
C1128	a_849_424##4	VNB	5.84247e-17
C1129	a_849_424##10	B#11	1.31498e-19
C1130	a_514_424##2	VNB	3.926e-17
C1131	B#12	VNB	2.71552e-17
C1132	a_413_392##2	a_114_368##5	2.70696e-18
C1133	a_481_379##2	VNB	5.6983e-17
C1134	VGND#8	a_81_260##5	1.87711e-17
C1135	CI#5	a_1689_424##2	4.40819e-18
C1136	B#6	VNB	2.77784e-17
C1137	B#14	a_849_424##10	5.83912e-19
C1138	B#1	a_481_379##4	3.5688e-18
C1139	B#4	VNB	1.85853e-17
C1140	B#2	VNB	2.92269e-17
C1141	A#2	VNB	5.6392e-17
C1142	a_81_260#	VNB	6.21098e-17
C1143	a_1451_424#	a_1895_424##4	4.78617e-17
C1144	CI	COUT	5.72911e-18
C1145	COUT#2	a_1689_424##2	2.07328e-19
C1146	a_514_424##17	B#5	1.45321e-20
C1147	VPWR	CI	1.06703e-18
C1148	a_2052_424#	a_1689_424#	2.33032e-17
C1149	VGND#8	a_114_368#	1.57015e-17
C1150	VGND	CI	8.37468e-19
C1151	CI	VNB	2.21924e-18
C1152	A	VNB	5.74309e-19
C1153	B	VNB	5.20808e-18
C1154	VGND	COUT	1.55799e-18
C1155	VGND#9	A#1	1.404e-18
C1156	a_1689_424##7	a_514_424##3	9.23393e-20
C1157	a_81_260##5	a_413_392##4	1.05532e-17
C1158	SUM	VNB	2.53194e-17
C1159	COUT	VNB	7.14681e-19
C1160	a_849_424##9	B#12	1.24551e-16
C1161	VPWR	VNB	2.53334e-16
C1162	VGND	VNB	2.42602e-16
C1163	a_514_424##12	a_481_379##6	1.0097e-18
C1164	a_481_379##7	a_114_368##7	1.5911e-17
C1165	a_481_379##2	a_514_424##12	5.98616e-17
C1166	VGND#8	VGND#10	7.70985e-17
*
*
.ENDS sky130_fd_sc_hs__fah_2
*
