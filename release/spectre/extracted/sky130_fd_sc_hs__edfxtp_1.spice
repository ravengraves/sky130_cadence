* Extracted by Quantus, converted by sky130cad/quantus.py
*
*
*
*                       LINUX           Wed Nov 18 08:36:33 2026
*
*
*
*  PROGRAM  advgen
*
*  Name           : advgen - Quantus - (64-bit)
*  Version        : 25.1.0-p047
*  Build Date     : Thu Dec 11 23:20:30 PST 2025
*
*  HSPICE LIBRARY
*
*  OPERATING_TEMPERATURE 150
*  QRC_TECH_DIR <path>/tech
*
*
*

*
.SUBCKT sky130_fd_sc_hs__edfxtp_1 VPB VNB VGND VPWR Q D DE CLK
*
*
*  caps2d version: 10
*
*
*       TRANSISTOR CARDS
*
*
XM29 a_27_508##10 D#1 a_131_74# VNB sky130_fd_pr__nfet_01v8_lvt l=0.15 w=0.42 ad=0.1197 as=0.1008 pd=1.41 ps=1.32
XM4 a_131_74# DE#5 VGND#18 VNB sky130_fd_pr__nfet_01v8_lvt l=0.15 w=0.42 ad=0.1008 as=0.1176 pd=1.32 ps=1.4
XM11 a_159_446##9 DE#7 VGND#17 VNB sky130_fd_pr__nfet_01v8_lvt l=0.15 w=0.42 ad=0.1176 as=0.1176 pd=1.4 ps=1.4
XM21 VGND#17 a_159_446##3 a_491_87# VNB sky130_fd_pr__nfet_01v8_lvt l=0.15 w=0.42 ad=0.1176 as=0.0882 pd=1.4 ps=1.26
XM30 a_491_87# a_533_61##3 a_27_508##9 VNB sky130_fd_pr__nfet_01v8_lvt l=0.15 w=0.42 ad=0.0882 as=0.1197 pd=1.26 ps=1.41
XM13 VGND#16 CLK#3 a_763_74##15 VNB sky130_fd_pr__nfet_01v8_lvt l=0.15 w=0.74 ad=0.2109 as=0.2035 pd=2.05 ps=2.03
XM8 VGND#12 a_763_74##5 a_958_74##13 VNB sky130_fd_pr__nfet_01v8_lvt l=0.15 w=0.74 ad=0.2072 as=0.2109 pd=2.04 ps=2.05
XM20 a_27_508##8 a_763_74# a_1156_90##6 VNB sky130_fd_pr__nfet_01v8_lvt l=0.15 w=0.42 ad=0.1197 as=0.3423 pd=1.41 ps=2.47
XM23 a_1156_90##6 a_958_74##3 a_1349_90# VNB sky130_fd_pr__nfet_01v8_lvt l=0.15 w=0.42 ad=0.3423 as=0.126 pd=2.47 ps=1.44
XM12 a_1349_90# a_1409_64##3 VGND#11 VNB sky130_fd_pr__nfet_01v8_lvt l=0.15 w=0.42 ad=0.126 as=0.2776 pd=1.44 ps=2.34
XM28 VGND#11 a_1156_90##3 a_1409_64##13 VNB sky130_fd_pr__nfet_01v8_lvt l=0.15 w=0.64 ad=0.2776 as=0.1824 pd=2.34 ps=1.85
XM3 VGND#10 a_1409_64##4 a_1797_74# VNB sky130_fd_pr__nfet_01v8_lvt l=0.15 w=0.74 ad=0.2109 as=0.2516 pd=2.05 ps=2.16
XM5 a_1797_74# a_958_74##5 a_1895_74##10 VNB sky130_fd_pr__nfet_01v8_lvt l=0.15 w=0.74 ad=0.2516 as=0.2424 pd=2.16 ps=2.2
XM25 a_1895_74##10 a_763_74##9 a_1997_74# VNB sky130_fd_pr__nfet_01v8_lvt l=0.15 w=0.42 ad=0.2424 as=0.1008 pd=2.2 ps=1.32
XM1 a_1997_74# a_533_61##4 VGND#8 VNB sky130_fd_pr__nfet_01v8_lvt l=0.15 w=0.42 ad=0.1008 as=0.4011 pd=1.32 ps=2.75
XM24 VGND#8 a_1895_74##5 a_533_61##11 VNB sky130_fd_pr__nfet_01v8_lvt l=0.15 w=0.42 ad=0.4011 as=0.1197 pd=2.75 ps=1.41
XM15 Q#3 a_1895_74##6 VGND#1 VNB sky130_fd_pr__nfet_01v8_lvt l=0.15 w=0.74 ad=0.2109 as=0.2627 pd=2.05 ps=2.19
XM16 a_27_508##7 D#3 a_114_508# VPB sky130_fd_pr__pfet_01v8 l=0.15 w=0.42 ad=0.1197 as=0.1008 pd=1.41 ps=1.32
XM27 a_114_508# a_159_446##2 VPWR#18 VPB sky130_fd_pr__pfet_01v8 l=0.15 w=0.42 ad=0.1008 as=0.1239 pd=1.32 ps=1.43
XM31 a_159_446##8 DE#6 VPWR#17 VPB sky130_fd_pr__pfet_01v8 l=0.15 w=0.64 ad=0.1888 as=0.2809 pd=1.87 ps=2.34
XM0 VPWR#17 DE#1 a_554_436# VPB sky130_fd_pr__pfet_01v8 l=0.15 w=0.42 ad=0.2809 as=0.1008 pd=2.34 ps=1.32
XM10 a_554_436# a_533_61# a_27_508##3 VPB sky130_fd_pr__pfet_01v8 l=0.15 w=0.42 ad=0.1008 as=0.1155 pd=1.32 ps=1.39
XM18 VPWR#16 CLK#1 a_763_74##13 VPB sky130_fd_pr__pfet_01v8 l=0.15 w=1.12 ad=0.3136 as=0.308 pd=2.8 ps=2.79
XM9 VPWR#15 a_763_74##8 a_958_74##16 VPB sky130_fd_pr__pfet_01v8 l=0.15 w=1.12 ad=0.308 as=0.308 pd=2.79 ps=2.79
XM22 a_27_508# a_958_74# a_1156_90##4 VPB sky130_fd_pr__pfet_01v8 l=0.15 w=0.42 ad=0.1176 as=0.126 pd=1.4 ps=1.44
XM6 a_1156_90##4 a_763_74##7 a_1382_508# VPB sky130_fd_pr__pfet_01v8 l=0.15 w=0.42 ad=0.126 as=0.1491 pd=1.44 ps=1.55
XM7 a_1382_508# a_1409_64# VPWR#14 VPB sky130_fd_pr__pfet_01v8 l=0.15 w=0.42 ad=0.1491 as=0.293825 pd=1.55 ps=2.66
XM2 VPWR#14 a_1156_90# a_1409_64##8 VPB sky130_fd_pr__pfet_01v8 l=0.15 w=0.84 ad=0.293825 as=0.2478 pd=2.66 ps=2.27
XM26 VPWR#13 a_1409_64##7 a_1794_392# VPB sky130_fd_pr__pfet_01v8 l=0.15 w=1 ad=0.295 as=0.785 pd=2.59 ps=3.57
XM32 a_1794_392# a_763_74##11 a_1895_74##11 VPB sky130_fd_pr__pfet_01v8 l=0.15 w=1 ad=0.785 as=0.3328 pd=3.57 ps=2.77
XM14 a_1895_74##11 a_958_74##7 a_2088_502# VPB sky130_fd_pr__pfet_01v8 l=0.15 w=0.42 ad=0.3328 as=0.1134 pd=2.77 ps=1.38
XM33 a_2088_502# a_533_61##6 VPWR#12 VPB sky130_fd_pr__pfet_01v8 l=0.15 w=0.42 ad=0.1134 as=0.2935 pd=1.38 ps=2.4
XM17 VPWR#12 a_1895_74##7 a_533_61##15 VPB sky130_fd_pr__pfet_01v8 l=0.15 w=0.64 ad=0.2935 as=0.176 pd=2.4 ps=1.83
XM19 Q#1 a_1895_74# VPWR#1 VPB sky130_fd_pr__pfet_01v8 l=0.15 w=1.12 ad=0.308 as=0.3192 pd=2.79 ps=2.81
*
*
*       RESISTOR AND CAP/DIODE CARDS
*
Rg1	D#1	D#2	328.965332
Rg2	D#2	D#3	471.250824
Rg3	a_159_446#	a_159_446##2	561.204590
Rg4	a_159_446##3	a_159_446##4	475.011719
Rg5	DE#1	DE#2	524.855835
Rg6	DE#2	DE#3	469.332458
Rg7	DE#3	DE#4	34.551098
Rg8	DE#4	DE#5	568.054871
Rg9	DE#2	DE#6	234.008942
Rg10	DE#4	DE#7	278.254547
Rg11	a_533_61#	a_533_61##2	396.981689
Rg12	a_533_61##2	a_533_61##3	350.017548
Rg13	CLK#1	CLK#2	578.255859
Rg14	CLK#2	CLK#3	299.838959
Rg15	a_958_74#	a_958_74##2	327.395081
Rg16	a_958_74##3	a_958_74##4	228.538391
Rg17	a_763_74#	a_763_74##2	535.286499
Rg18	a_763_74##2	a_763_74##3	129.212997
Rg19	a_763_74##3	a_763_74##4	286.620209
Rg20	a_763_74##4	a_763_74##5	481.494080
Rg21	a_763_74##2	a_763_74##6	761.213989
Rg22	a_763_74##6	a_763_74##7	253.279114
Rg23	a_763_74##3	a_763_74##8	383.392029
Rg24	a_1409_64#	a_1409_64##2	621.172913
Rg25	a_1409_64##2	a_1409_64##3	373.876648
Rg26	a_1156_90#	a_1156_90##2	364.833252
Rg27	a_1156_90##2	a_1156_90##3	569.115662
Rg28	a_1409_64##4	a_1409_64##5	354.516052
Rg29	a_1409_64##5	a_1409_64##6	39.456203
Rg30	a_1409_64##5	a_1409_64##7	500.920410
Rg31	a_958_74##5	a_958_74##6	468.170471
Rg32	a_763_74##9	a_763_74##10	555.639709
Rg33	a_763_74##10	a_763_74##11	408.386017
Rg34	a_958_74##7	a_958_74##8	567.448364
Rg35	a_533_61##4	a_533_61##5	1196.137817
Rg36	a_533_61##5	a_533_61##6	245.891434
Rg37	a_1895_74#	a_1895_74##2	577.774719
Rg38	a_1895_74##2	a_1895_74##3	502.561401
Rg39	a_1895_74##3	a_1895_74##4	27.481752
Rg40	a_1895_74##4	a_1895_74##5	337.027618
Rg41	a_1895_74##2	a_1895_74##6	298.988861
Rg42	a_1895_74##3	a_1895_74##7	625.192017
Rf1	D#4	D	1.330131
Rf2	D#2	D#6	54.741066
Rf3	D#4	D#6	6.537743
Rf4	D#7	D	1.330131
Rf5	D#6	D#7	6.193651
Rf6	DE	DE#3	161.020142
Rf7	a_159_446##4	a_159_446##6	185.160034
Rf8	a_159_446##6	a_159_446#	45.372871
Rf9	a_159_446##6	a_159_446##8	68.313522
Rf10	a_159_446#	a_159_446##9	86.238281
Rf11	a_533_61##7	a_533_61##2	81.842125
Rf12	a_533_61##9	a_533_61##10	1.725721
Rf13	a_533_61##7	a_533_61##10	9.931700
Rf14	CLK#2	CLK	163.775864
Rf15	a_763_74##4	a_763_74##14	89.064293
Rf16	a_763_74##14	a_763_74##15	70.013580
Rf17	a_763_74##13	a_763_74##14	15.000000
Rf18	a_27_508#	a_27_508##2	82.616211
Rf19	a_27_508##2	a_27_508##4	135.156357
Rf20	a_27_508##4	a_27_508##5	19.684275
Rf21	a_27_508##5	a_27_508##6	302.928070
Rf22	a_27_508##6	a_27_508##7	33.660446
Rf23	a_27_508##2	a_27_508##8	113.341599
Rf24	a_27_508##5	a_27_508##9	114.106903
Rf25	a_27_508##6	a_27_508##10	132.149200
Rf26	a_27_508##3	a_27_508##4	15.000000
Rf27	a_1156_90##4	a_1156_90##5	80.482903
Rf28	a_1156_90##5	a_1156_90##6	100.455109
Rf29	a_1156_90##5	a_1156_90##2	257.706848
Rf30	a_1409_64##8	a_1409_64##9	71.593948
Rf31	a_1409_64##9	a_1409_64##10	25.560278
Rf32	a_1409_64##10	a_1409_64##2	212.129410
Rf33	a_1409_64##9	a_1409_64##6	90.560806
Rf34	a_1409_64##10	a_1409_64##13	47.128876
Rf35	a_763_74##10	a_763_74##6	595.930298
Rf36	a_958_74##8	a_958_74##6	229.406021
Rf37	a_958_74##6	a_958_74##11	269.945465
Rf38	a_958_74##11	a_958_74##12	113.035896
Rf39	a_958_74##12	a_958_74##13	88.392990
Rf40	a_958_74##11	a_958_74##4	167.990509
Rf41	a_958_74##12	a_958_74##15	107.646652
Rf42	a_958_74##15	a_958_74##16	27.057779
Rf43	a_958_74##15	a_958_74##2	167.967621
Rf44	a_1895_74##4	a_1895_74##9	175.802551
Rf45	a_1895_74##9	a_1895_74##10	113.451233
Rf46	a_1895_74##9	a_1895_74##11	126.117546
Rf47	a_533_61##11	a_533_61##12	87.357658
Rf48	a_533_61##12	a_533_61##13	27.637007
Rf49	a_533_61##13	a_533_61##5	203.588318
Rf50	a_533_61##13	a_533_61##15	23.697521
Rf51	Q	Q#2	0.196836
Rf52	Q#2	Q	14.369054
Rf53	Q	Q#3	47.820194
Rf54	Q#1	Q#2	5.000000
Rf55	VPWR#1	VPWR#2	164.865204
Rf56	VPWR#2	VPWR#3	93.086227
Rf57	VPWR#3	VPWR#4	85.444542
Rf58	VPWR#4	VPWR#5	79.941223
Rf59	VPWR#5	VPWR#6	177.520996
Rf60	VPWR#6	VPWR#7	95.704430
Rf61	VPWR#7	VPWR#8	34.674454
Rf62	VPWR#8	VPWR#9	62.125736
Rf63	VPWR#9	VPWR#10	105.258347
Rf65	VPWR#2	VPWR#12	28.624041
Rf66	VPWR#4	VPWR#13	31.161278
Rf67	VPWR#5	VPWR#14	31.161278
Rf68	VPWR#6	VPWR#15	37.027283
Rf69	VPWR#7	VPWR#16	35.098007
Rf70	VPWR#9	VPWR#17	55.445858
Rf71	VPWR#10	VPWR#18	40.352859
Rf72	VGND#1	VGND#2	165.189728
Rf73	VGND#2	VGND#3	72.716476
Rf74	VGND#3	VGND#4	80.753609
Rf75	VGND#4	VGND#5	105.258347
Rf76	VGND#5	VGND#6	207.163788
Rf77	VGND#6	VGND#7	82.214622
Rf78	VGND#2	VGND#9	5.809657
Rf79	VGND#9	VGND#8	15.000000
Rf80	VGND#4	VGND#10	39.073792
Rf81	VGND#5	VGND#11	41.120300
Rf82	VGND#6	VGND#12	41.038895
Rf83	VGND#7	VGND#13	87.270805
Rf84	VGND#13	VGND#14	71.540421
Rf86	VGND#7	VGND#16	57.430012
Rf87	VGND#13	VGND#17	37.066368
Rf88	VGND#14	VGND#18	31.948624
Rf89	VGND#8	VGND#9	15.000000
Re1	a_533_61##12	a_533_61##9	35.002666
Re2	VPWR#3	VPWR	2.042809
Re3	VPWR	VPWR#8	1.896894
Re4	VGND#3	VGND	2.042809
Re5	VGND	VGND#7	1.896894
*
*       CAPACITOR CARDS
*
*
C1	a_1409_64#	a_1409_64##7	2.47175e-19
C2	CLK#2	VGND#16	5.31687e-18
C3	a_27_508##8	a_958_74##16	5.91954e-17
C4	a_533_61##12	a_1409_64##9	6.13623e-17
C5	D#7	D#2	1.7444e-17
C6	a_1409_64##8	a_1409_64##2	1.20144e-19
C7	VGND#3	a_1409_64##3	2.92641e-18
C8	a_1895_74##4	a_1895_74##6	2.19031e-18
C9	a_27_508##9	CLK#2	4.82394e-18
C10	a_27_508##10	D#1	2.76203e-17
C11	a_533_61##9	a_958_74##12	2.79185e-18
C12	a_1409_64#	a_1156_90#	2.97463e-17
C13	a_1409_64##9	a_1409_64##8	2.83664e-19
C14	a_958_74##13	a_958_74##12	2.38988e-18
C15	DE#5	a_159_446##2	4.34378e-19
C16	VPWR#12	VPWR#1	7.34904e-19
C17	D#6	D#2	6.44528e-18
C18	a_27_508##7	VPWR#18	1.53711e-17
C19	VPWR#2	a_1895_74##4	6.37257e-19
C20	a_763_74##15	a_533_61##2	3.77796e-19
C21	VGND#13	DE#4	2.47921e-19
C22	a_763_74##6	VPWR#13	2.44288e-17
C23	Q#3	a_1895_74##2	2.50333e-17
C24	VGND#2	VGND#8	1.2921e-17
C25	D#4	D#2	1.68159e-17
C26	VGND#16	a_533_61##2	3.2323e-20
C27	VPWR#3	a_1409_64##10	6.41819e-19
C28	a_533_61##4	a_1895_74##4	2.09009e-17
C29	a_763_74##6	a_1409_64##8	6.10704e-17
C30	VPWR#2	a_1895_74##7	5.5021e-18
C31	a_27_508##9	a_533_61##2	1.9128e-17
C32	a_763_74##6	VPWR#14	4.04996e-17
C33	D#4	DE#4	2.57859e-19
C34	VPWR#3	a_1409_64##9	3.94835e-18
C35	a_763_74##7	a_1409_64#	1.92719e-17
C36	VGND#3	a_1895_74##2	1.35608e-18
C37	VGND#2	a_1895_74##6	1.08019e-18
C38	VGND#6	a_763_74##3	6.75558e-20
C39	VPWR#9	VPWR#7	7.14391e-19
C40	a_533_61##4	a_533_61##5	1.1125e-18
C41	a_958_74##16	a_1409_64##2	2.30224e-19
C42	a_27_508##6	DE#4	2.39942e-18
C43	a_1409_64##9	VGND#10	3.23842e-18
C44	a_533_61##13	a_1895_74#	1.01302e-18
C45	a_1156_90##5	a_1409_64##9	3.40924e-19
C46	a_1156_90##4	a_763_74##6	3.21549e-17
C47	a_763_74##13	a_27_508##8	1.98187e-17
C48	a_159_446##9	a_533_61##2	9.93558e-20
C49	a_1156_90##5	a_1409_64##8	9.47311e-19
C50	a_533_61##5	VPWR#2	1.45169e-18
C51	a_1895_74##4	a_533_61##13	3.57144e-18
C52	VPWR#3	a_1156_90##5	1.55949e-18
C53	VGND#13	DE#2	3.34386e-19
C54	VGND#3	a_1409_64##10	6.19976e-19
C55	VPWR#12	a_533_61##15	4.06916e-17
C56	a_533_61##4	a_958_74##8	2.7254e-17
C57	a_958_74#	a_763_74##7	2.1691e-17
C58	a_1895_74##9	a_1895_74#	2.38626e-19
C59	VPWR#2	a_533_61##6	7.98586e-18
C60	VGND#1	a_1895_74##6	2.85342e-17
C61	a_1895_74##9	a_1895_74##4	3.0619e-18
C62	a_958_74##16	a_763_74##6	1.09113e-18
C63	VGND#3	a_1409_64##9	3.74917e-18
C64	VGND#17	a_159_446##4	1.77225e-17
C65	a_1409_64##8	a_958_74##2	1.09725e-19
C66	VPWR#1	a_1895_74#	3.52446e-17
C67	a_958_74##13	a_763_74##13	1.20521e-17
C68	a_27_508##9	DE#4	3.51754e-19
C69	DE#2	a_533_61##2	6.55486e-19
C70	a_958_74##16	a_763_74#	1.61306e-18
C71	VGND#2	a_1895_74##5	1.66933e-17
C72	a_27_508##6	DE#2	7.8771e-19
C73	VGND#6	a_763_74##2	5.82157e-21
C74	a_763_74##10	a_533_61##4	7.14987e-19
C75	Q#3	a_1895_74##6	2.80725e-17
C76	VGND#4	a_958_74##6	3.56478e-17
C77	a_1895_74#	Q#1	3.14298e-17
C78	a_533_61##13	a_1895_74##7	3.40751e-17
C79	VGND#7	a_763_74##5	1.81795e-19
C80	a_958_74##16	a_958_74##4	3.98387e-19
C81	a_763_74##8	a_958_74#	5.11731e-18
C82	VGND#3	a_1156_90##5	1.19449e-18
C83	VPWR#2	a_958_74##8	4.03632e-19
C84	a_533_61##13	a_533_61##5	4.69524e-19
C85	a_533_61##12	a_1895_74#	4.88199e-18
C86	VGND#12	a_763_74##13	2.03412e-17
C87	a_1156_90##4	a_958_74##2	1.79107e-17
C88	VGND#1	a_1895_74##5	1.05651e-18
C89	VPWR#1	a_1895_74##7	9.8242e-19
C90	VGND#7	CLK#3	7.26254e-18
C91	VGND#4	a_533_61##4	1.20865e-19
C92	a_958_74##6	a_533_61##4	1.34209e-19
C93	a_958_74##5	a_763_74##10	1.44187e-18
C94	VGND#2	a_1895_74##10	1.29426e-17
C95	a_1895_74##9	a_1895_74##7	1.65124e-18
C96	D#7	a_159_446##2	2.90827e-18
C97	a_533_61##15	a_1895_74#	2.1929e-18
C98	a_958_74##2	a_27_508#	2.45077e-17
C99	a_159_446##9	DE#3	2.79843e-17
C100	a_1895_74##9	a_533_61##5	5.40423e-17
C101	D#4	a_159_446##9	1.64558e-17
C102	VPWR#2	a_958_74##7	2.0034e-18
C103	a_533_61##11	a_1895_74##6	3.82582e-18
C104	a_533_61##12	a_1895_74##7	2.8122e-18
C105	a_1895_74##11	a_533_61##15	1.62444e-18
C106	VGND#7	a_533_61##3	1.45292e-18
C107	a_958_74##6	a_763_74##9	2.93219e-19
C108	VPWR#3	a_1895_74#	5.83024e-18
C109	a_958_74##16	a_958_74##2	9.17295e-18
C110	a_763_74##13	a_763_74#	4.73873e-20
C111	a_1895_74##5	a_1895_74##6	4.24804e-18
C112	Q#3	a_1895_74##5	8.64736e-19
C113	CLK#1	a_763_74##8	2.97492e-18
C114	VGND#2	a_1895_74##2	2.30553e-19
C115	VPWR#12	a_1895_74#	6.49287e-19
C116	a_958_74##6	a_958_74##5	3.54183e-18
C117	VPWR#7	VPWR#6	7.33071e-19
C118	VGND#2	a_533_61##4	3.38837e-17
C119	VPWR#3	a_1895_74##7	6.2683e-18
C120	DE#4	a_159_446##4	2.72147e-17
C121	VPWR#1	a_533_61##6	2.82016e-19
C122	a_533_61##9	a_763_74##2	1.69579e-18
C123	a_763_74##10	VPWR#4	5.11721e-18
C124	a_533_61##9	a_1156_90##5	5.65617e-17
C125	a_533_61##15	a_1895_74##7	4.04452e-17
C126	a_958_74##6	a_1409_64##4	2.59089e-17
C127	VGND#4	a_1409_64##6	2.08893e-19
C128	DE#2	a_159_446##4	2.76268e-17
C129	a_159_446##9	a_159_446#	3.13244e-18
C130	a_533_61##13	a_958_74##8	4.57607e-20
C131	VPWR#3	a_533_61##6	3.92254e-18
C132	a_763_74##13	a_763_74##5	1.72955e-18
C133	a_1895_74##11	VPWR#12	1.37828e-17
C134	VGND#5	a_763_74##2	6.79953e-20
C135	a_1895_74##5	a_533_61##11	2.50527e-17
C136	a_27_508##2	a_763_74##3	7.11731e-18
C137	a_958_74##6	a_1156_90##3	2.52569e-18
C138	VPWR#15	a_763_74##4	6.67929e-19
C139	VGND#4	a_763_74##9	1.41642e-19
C140	a_1895_74##9	a_958_74##8	7.19337e-17
C141	a_533_61#	CLK#1	5.04967e-18
C142	a_1895_74##7	VPWR#12	1.47154e-17
C143	VPWR#2	a_763_74##11	1.24565e-18
C144	VPWR#3	a_958_74##7	1.74657e-17
C145	a_27_508#	a_763_74##2	6.23719e-19
C146	a_763_74##13	a_763_74##4	4.01386e-17
C147	a_1895_74##11	a_1895_74#	2.46087e-19
C148	a_533_61##4	a_1895_74##5	6.80415e-18
C149	a_533_61##15	a_533_61##6	1.14645e-18
C150	a_1895_74##5	VGND#8	3.643e-18
C151	VPWR#3	a_763_74##11	8.71541e-18
C152	a_159_446##9	D#2	2.28331e-18
C153	a_1156_90##3	a_1409_64##6	3.27698e-18
C154	a_1156_90##5	a_1156_90##4	6.80696e-19
C155	VGND#2	a_763_74##9	3.32054e-18
C156	VGND#5	a_1156_90##2	1.28605e-20
C157	VPWR#4	a_958_74##6	1.13656e-19
C158	a_533_61##11	a_533_61##4	1.6871e-18
C159	VPWR#2	VPWR#1	6.76517e-19
C160	VPWR#12	a_533_61##6	2.97879e-17
C161	VPWR#4	a_1409_64##7	3.90195e-18
C162	DE#1	a_533_61#	4.2103e-17
C163	DE#6	CLK#1	3.1206e-19
C164	VGND#4	a_1156_90##2	1.43073e-20
C165	a_533_61##9	a_27_508##2	3.26281e-17
C166	a_763_74##13	CLK#2	4.04302e-17
C167	a_27_508##2	a_763_74##2	1.41685e-18
C168	a_763_74##15	a_27_508##3	7.89363e-19
C169	a_27_508##10	D#6	8.62513e-18
C170	a_1895_74##11	a_1895_74##7	4.047e-19
C171	a_27_508##6	VPWR#9	6.66912e-18
C172	DE#3	DE#4	2.06465e-17
C173	a_27_508##10	D#2	1.84038e-17
C174	a_533_61##15	a_958_74##7	2.08833e-19
C175	a_958_74##16	a_763_74##3	9.015e-20
C176	CLK#2	VPWR#16	2.43726e-18
C177	VPWR#3	a_1156_90#	8.17825e-18
C178	a_763_74##10	a_1895_74##9	1.61569e-18
C179	VGND#4	a_958_74##5	8.55876e-19
C180	VGND#10	VGND#2	8.79267e-19
C181	a_533_61##4	VGND#8	1.76902e-17
C182	a_27_508##3	CLK#2	2.34874e-17
C183	a_1895_74##4	a_1895_74#	2.0111e-18
C184	a_763_74##9	a_533_61##4	4.57867e-17
C185	VPWR#12	a_958_74##7	3.694e-18
C186	VGND#16	a_27_508##3	8.47278e-19
C187	a_763_74##13	a_533_61##2	2.0659e-18
C188	a_1895_74##10	a_1895_74##5	5.70402e-19
C189	a_1409_64##2	a_1156_90##3	1.06226e-17
C190	VPWR#5	a_1156_90#	6.83465e-18
C191	a_533_61##11	a_763_74##9	4.99538e-19
C192	DE#6	DE#1	1.03482e-17
C193	D#4	a_27_508##10	4.95571e-17
C194	a_1895_74##11	a_533_61##6	4.16077e-18
C195	a_958_74##16	a_763_74##2	2.95252e-17
C196	a_533_61##15	a_763_74##11	9.20599e-20
C197	VGND#2	a_958_74##5	1.22176e-18
C198	VPWR#4	a_1409_64##6	2.06478e-19
C199	a_1156_90##5	VPWR#6	3.60772e-19
C200	VGND#5	a_1409_64##4	1.86604e-19
C201	a_27_508##3	a_533_61##2	1.56218e-17
C202	DE#4	DE#2	1.41408e-18
C203	a_27_508##9	a_27_508##3	5.63852e-19
C204	a_533_61##5	a_1895_74##7	1.8619e-17
C205	a_533_61##9	a_533_61##10	2.82524e-17
C206	VPWR#12	a_763_74##11	1.70372e-18
C207	a_958_74##6	a_1895_74##9	8.4887e-19
C208	a_159_446##2	DE#6	5.11644e-18
C209	VPWR#6	a_1409_64#	4.81621e-20
C210	a_958_74##4	a_1409_64##4	6.04809e-19
C211	a_1895_74##11	a_958_74##7	3.48764e-17
C212	a_1895_74##10	a_533_61##4	1.3842e-17
C213	a_533_61##11	a_958_74##5	5.47423e-19
C214	VGND#4	a_1409_64##4	7.49195e-18
C215	a_958_74##16	a_1156_90##5	5.12395e-17
C216	a_27_508##6	DE#5	1.38195e-18
C217	a_159_446#	DE#4	3.61237e-17
C218	VPWR#13	a_533_61##6	2.73383e-19
C219	a_958_74##5	a_763_74##9	2.58593e-17
C220	a_159_446##4	a_27_508##3	4.84324e-17
C221	VPWR#13	a_1895_74##11	5.81202e-18
C222	a_958_74##4	a_1156_90##3	3.42978e-17
C223	a_763_74##3	VPWR#15	1.13227e-18
C224	VPWR#5	a_1409_64#	4.15489e-18
C225	a_958_74##7	a_533_61##5	3.0203e-17
C226	a_159_446##9	DE#4	1.82178e-17
C227	a_159_446#	DE#2	1.70333e-17
C228	a_958_74##4	a_1409_64##3	2.83427e-17
C229	a_1156_90##5	VPWR#5	2.00746e-20
C230	VPWR#12	a_1409_64##7	1.39472e-19
C231	a_1156_90##6	a_1156_90##5	1.342e-18
C232	VGND#2	a_1409_64##4	3.2808e-19
C233	a_533_61##5	a_763_74##11	9.13965e-19
C234	D#3	a_159_446##2	4.598e-17
C235	VGND#5	a_763_74##6	9.98671e-20
C236	a_533_61##15	VPWR#2	1.57345e-17
C237	a_763_74##11	a_1895_74##11	2.65053e-17
C238	a_958_74##4	a_958_74##3	8.79248e-18
C239	VGND#5	a_1156_90##3	3.58389e-18
C240	a_958_74##13	a_27_508##8	6.09439e-17
C241	a_27_508##2	a_1156_90##4	5.55356e-18
C242	a_958_74##12	a_763_74##3	1.40176e-19
C243	a_1895_74##10	a_763_74##9	2.94806e-17
C244	VPWR#13	a_958_74##7	8.42271e-19
C245	VGND#1	VPWR#1	1.07994e-17
C246	a_1895_74##4	a_1895_74##2	1.39776e-18
C247	a_763_74#	a_958_74##4	4.0628e-18
C248	a_533_61##12	Q#3	1.63812e-17
C249	a_763_74##11	a_958_74##8	5.74747e-18
C250	VPWR#6	a_763_74##7	7.26694e-20
C251	VGND#10	a_533_61##4	8.32976e-20
C252	a_763_74##10	a_958_74##7	1.07728e-18
C253	a_1409_64##4	a_958_74##5	2.9517e-17
C254	a_533_61##12	a_533_61##11	1.32271e-18
C255	a_1895_74##11	a_1409_64##7	2.81785e-18
C256	VPWR#5	a_1409_64##2	1.36798e-19
C257	a_763_74##10	a_763_74##11	2.35737e-17
C258	VPWR#5	a_763_74##7	4.55484e-18
C259	VPWR#13	a_763_74##11	3.00331e-18
C260	VPWR#5	VPWR#4	6.66881e-19
C261	VGND#13	a_533_61##7	2.37037e-18
C262	a_1895_74##10	a_958_74##5	3.90492e-17
C263	D#2	DE#4	1.3908e-18
C264	a_763_74##10	a_1409_64##7	3.98732e-17
C265	VPWR#8	a_533_61#	2.87121e-18
C266	a_958_74##12	a_763_74##2	1.01622e-18
C267	VGND#5	a_958_74##4	6.93681e-17
C268	DE#4	VGND#18	1.68026e-18
C269	VGND#2	a_1895_74##9	6.14442e-17
C270	VGND#5	a_1409_64##3	3.18954e-18
C271	VGND#10	a_763_74##9	1.52618e-19
C272	a_1409_64##8	a_763_74##11	1.34419e-18
C273	a_159_446##8	a_159_446#	6.62458e-20
C274	a_763_74##10	a_1156_90#	6.80149e-19
C275	a_1895_74##9	a_1895_74##6	5.54987e-19
C276	a_1895_74##11	a_1156_90#	5.61482e-19
C277	VGND#4	a_958_74##4	5.02918e-18
C278	VPWR#18	a_159_446#	5.04093e-19
C279	VPWR#13	a_1409_64##7	4.23571e-17
C280	VPWR#6	a_958_74#	3.46261e-18
C281	a_533_61##12	a_1895_74##10	7.10407e-18
C282	VGND#12	a_958_74##13	7.09289e-17
C283	a_763_74##15	a_27_508##8	9.05879e-19
C284	a_1156_90##3	a_1409_64##4	4.16349e-18
C285	VGND#3	VGND#1	7.92131e-17
C286	a_763_74##13	a_763_74##2	3.70507e-19
C287	a_533_61##7	a_159_446##3	3.17608e-18
C288	a_1895_74##10	a_1409_64##4	5.20736e-18
C289	a_159_446##8	D#2	2.89046e-20
C290	a_763_74##6	VPWR#5	1.09483e-17
C291	a_1409_64##8	a_1409_64##7	5.55284e-18
C292	VPWR#5	a_958_74#	2.33746e-18
C293	a_27_508##2	a_958_74##16	5.42958e-17
C294	a_1409_64##9	a_763_74##10	6.81938e-18
C295	CLK#2	a_763_74##5	1.3731e-18
C296	a_533_61##12	VPWR#3	8.2515e-17
C297	VGND#3	Q#3	2.00536e-17
C298	VGND#10	a_958_74##5	2.79988e-18
C299	a_763_74##6	VPWR#4	4.81041e-18
C300	VPWR#13	a_1156_90#	4.65412e-18
C301	VPWR#14	VPWR#13	7.42393e-18
C302	a_533_61##12	VGND#10	1.73284e-18
C303	VPWR#7	a_763_74##8	1.59458e-19
C304	VGND#3	a_533_61##11	1.90594e-17
C305	a_1156_90##2	a_1409_64##7	1.76284e-18
C306	VGND#3	a_533_61##12	8.06823e-17
C307	VPWR#14	a_1409_64##7	1.98218e-18
C308	a_27_508##2	VPWR#7	2.66446e-18
C309	VGND#5	a_958_74##3	3.5828e-18
C310	a_1895_74##9	a_1895_74##5	3.01351e-19
C311	VGND#13	DE#1	7.234e-19
C312	a_1409_64##8	a_1156_90#	3.84495e-17
C313	a_533_61##11	a_533_61##13	2.87871e-19
C314	a_1895_74##10	a_1156_90##3	2.86902e-19
C315	a_1409_64##3	a_1156_90##3	1.12184e-17
C316	VPWR#6	a_763_74##8	6.64944e-18
C317	a_533_61##2	CLK#3	4.2159e-18
C318	a_958_74##6	a_1409_64##10	1.9869e-18
C319	a_533_61##13	a_533_61##15	2.88215e-19
C320	VPWR#13	a_1409_64#	1.64917e-18
C321	VPWR#1	a_1895_74##2	4.10151e-20
C322	VGND#10	a_1409_64##4	4.72852e-17
C323	VGND#6	a_958_74##13	5.45998e-17
C324	a_533_61##12	VGND#11	1.32023e-18
C325	a_27_508##2	VPWR#15	4.77504e-17
C326	a_533_61##9	VPWR#3	8.70594e-18
C327	a_1409_64##2	a_1156_90#	4.38658e-18
C328	a_958_74##6	a_1409_64##9	9.88533e-17
C329	a_1156_90#	VPWR#14	2.31684e-17
C330	VPWR#9	CLK#1	8.23977e-19
C331	VGND#6	a_763_74#	3.6033e-18
C332	a_159_446##3	a_533_61##2	1.14953e-17
C333	a_763_74##6	a_1409_64##7	3.41817e-19
C334	a_1156_90##4	a_1409_64##7	5.60008e-19
C335	a_763_74##15	VGND#12	6.02459e-17
C336	a_1409_64##8	a_1409_64#	3.09274e-18
C337	VGND#3	a_1895_74##10	4.55736e-17
C338	VGND#3	a_533_61##9	8.9346e-18
C339	VGND#6	a_763_74##4	4.44887e-20
C340	a_1895_74##11	VPWR#2	1.54512e-18
C341	a_27_508##2	VPWR#6	1.09527e-17
C342	VGND#13	a_159_446##6	3.86593e-19
C343	a_763_74##6	a_1156_90#	3.22107e-17
C344	a_1409_64##13	a_1409_64##4	4.87415e-19
C345	VPWR#7	CLK#1	3.41972e-18
C346	a_1895_74##9	a_533_61##11	3.44109e-18
C347	a_1895_74##9	a_533_61##4	3.80623e-17
C348	a_763_74##6	a_1409_64#	5.49342e-17
C349	a_533_61##12	a_1895_74##4	7.06728e-17
C350	VPWR#14	a_1409_64#	2.34536e-17
C351	a_958_74##3	a_1409_64##3	2.27864e-17
C352	VGND#10	a_1156_90##3	5.69557e-19
C353	a_1409_64##10	a_1409_64##6	1.1111e-19
C354	a_1156_90##4	a_1156_90#	9.16302e-19
C355	a_763_74##6	a_763_74##7	2.5717e-18
C356	a_533_61##13	VPWR#12	1.3783e-17
C357	a_533_61##9	VPWR#8	2.68966e-18
C358	a_27_508##2	a_763_74##13	8.60369e-17
C359	VGND#6	a_958_74##12	3.05597e-17
C360	VPWR#3	a_1895_74##4	5.42783e-19
C361	VPWR#6	a_958_74##2	7.18332e-19
C362	VGND#16	VGND#12	2.11656e-18
C363	VGND#11	a_1409_64##4	1.51769e-20
C364	a_533_61##12	a_533_61##5	1.19344e-17
C365	a_1409_64##9	a_1409_64##6	4.12165e-17
C366	a_27_508##6	a_27_508##3	3.10847e-18
C367	a_27_508##8	a_27_508##2	1.57498e-18
C368	a_958_74#	a_763_74##6	1.88161e-18
C369	a_533_61##9	VGND#7	3.56684e-18
C370	VGND#3	a_1409_64##13	6.18283e-18
C371	VGND#3	a_1895_74##4	5.91237e-18
C372	a_1409_64##13	a_1156_90##3	8.73093e-18
C373	VPWR#3	a_533_61##5	5.43414e-18
C374	VGND#6	a_763_74##5	7.13708e-18
C375	a_533_61##12	a_958_74##8	2.51616e-17
C376	VPWR#14	a_763_74##7	3.67304e-18
C377	a_763_74##8	a_763_74##6	6.4391e-19
C378	a_1156_90##4	a_1409_64#	3.28851e-18
C379	VGND#6	CLK#2	5.66856e-20
C380	VGND#13	CLK#3	2.79692e-19
C381	a_1156_90##5	a_1409_64##6	1.84239e-19
C382	a_159_446#	a_159_446##3	2.26125e-20
C383	VGND#3	a_533_61##5	1.72307e-19
C384	a_763_74##5	a_763_74##2	7.38178e-19
C385	VPWR#3	a_958_74##8	2.35155e-18
C386	a_1895_74##9	a_763_74##9	4.4225e-19
C387	a_533_61##12	a_763_74##10	5.90503e-17
C388	VGND#16	a_763_74##15	5.32337e-17
C389	a_1409_64##10	a_1156_90##2	4.25563e-17
C390	a_763_74#	a_958_74##3	3.68972e-18
C391	a_1156_90##3	VGND#11	2.12602e-17
C392	a_958_74##12	a_763_74##6	1.54001e-19
C393	a_1156_90##4	VPWR#14	7.41088e-18
C394	VGND#3	a_958_74##8	3.19057e-18
C395	a_763_74##10	VPWR#3	3.13749e-17
C396	a_159_446#	DE#5	1.81135e-17
C397	VGND#13	VGND#16	5.4974e-19
C398	VPWR#14	a_958_74#	7.00583e-19
C399	a_533_61##12	a_958_74##6	4.10956e-17
C400	VGND#5	a_958_74##12	5.6499e-17
C401	a_1156_90##2	a_1409_64##9	2.04627e-17
C402	a_958_74##13	a_27_508##2	1.51875e-18
C403	VPWR#6	a_763_74##4	1.65032e-18
C404	a_1156_90##4	a_763_74##7	2.75498e-17
C405	a_763_74##8	a_958_74##2	1.06213e-17
C406	VGND#3	a_763_74##10	2.23793e-18
C407	VPWR#3	a_958_74##6	4.60797e-18
C408	VGND#6	a_763_74##15	8.32773e-18
C409	a_533_61##12	a_1409_64##6	2.04433e-18
C410	a_533_61##9	VGND#11	4.0827e-19
C411	VPWR#9	DE#1	2.0119e-18
C412	D#2	DE#5	2.15857e-17
C413	a_27_508##3	DE#4	1.31343e-19
C414	Q#3	a_1895_74##4	7.16524e-19
C415	VGND#6	CLK#3	9.10523e-19
C416	a_27_508##9	a_763_74##15	2.4337e-18
C417	a_1156_90##5	a_1156_90##2	7.14653e-19
C418	a_763_74##4	a_763_74##8	1.08102e-17
C419	VGND#3	a_958_74##6	3.17397e-17
C420	VGND#11	a_1409_64##3	2.52512e-17
C421	VPWR#14	a_763_74##8	4.3068e-19
C422	a_533_61##12	a_1156_90##2	3.41724e-17
C423	VPWR#15	a_1409_64#	2.32567e-19
C424	a_533_61##5	a_1895_74##4	2.65812e-17
C425	VGND#13	a_533_61##3	5.25985e-18
C426	a_1895_74##9	a_958_74##5	1.38102e-19
C427	a_533_61##11	a_1895_74##4	2.68755e-17
C428	CLK#1	a_763_74##4	1.62744e-17
C429	a_1409_64##10	a_1409_64##2	8.82498e-19
C430	a_763_74##5	a_763_74#	5.24197e-18
C431	a_1156_90##4	a_958_74#	2.587e-17
C432	a_27_508##3	a_27_508##2	1.11419e-18
C433	a_533_61##10	DE#2	4.51991e-20
C434	a_958_74##12	a_958_74##4	3.35224e-18
C435	VPWR#3	a_1156_90##2	3.66723e-18
C436	a_533_61##12	a_1409_64##2	1.1088e-17
C437	a_533_61##9	a_1156_90##6	1.26549e-18
C438	a_1409_64##9	a_1409_64##2	1.77608e-18
C439	VPWR#7	CLK#2	3.85181e-20
C440	a_27_508##3	DE#2	1.25322e-17
C441	a_1895_74##11	a_533_61##13	2.26582e-18
C442	a_1409_64##9	a_1409_64##7	1.37746e-18
C443	a_958_74#	a_27_508#	1.14339e-17
C444	VGND#3	a_1156_90##2	1.10289e-18
C445	VGND#13	a_27_508##9	1.09162e-18
C446	a_27_508##9	VGND#16	5.93769e-17
C447	a_958_74##8	a_533_61##5	4.60355e-17
C448	a_533_61##9	a_27_508##8	2.75345e-17
C449	VPWR#15	a_763_74##7	2.62481e-19
C450	a_533_61##12	a_763_74##6	1.17942e-17
C451	VPWR#6	a_763_74##3	1.66457e-21
C452	VGND#1	Q#3	9.04208e-17
C453	VGND#11	a_958_74##3	1.00644e-18
C454	a_1156_90##4	a_763_74##8	1.38198e-18
C455	a_533_61##9	a_1156_90##2	2.35624e-18
C456	VGND#3	a_1409_64##2	1.56111e-18
C457	a_533_61##2	CLK#1	3.28828e-18
C458	a_1156_90##5	a_1409_64##2	1.45773e-17
C459	VGND#16	VGND#6	9.15269e-20
C460	VPWR#9	DE#6	4.3848e-18
C461	VPWR#3	a_763_74##6	2.80806e-17
C462	a_763_74##10	a_533_61##5	4.75724e-19
C463	a_533_61##9	a_958_74##13	1.35158e-17
C464	a_1156_90##6	a_1409_64##3	6.29182e-19
C465	a_533_61##12	a_958_74##4	4.91847e-18
C466	a_533_61##9	a_1409_64##2	5.34532e-18
C467	CLK#3	a_763_74##5	5.12558e-18
C468	VPWR#9	DE#2	1.85842e-19
C469	a_27_508#	a_1156_90##4	4.71693e-17
C470	a_27_508#	a_763_74##8	3.52744e-18
C471	a_1895_74##9	a_1895_74##11	4.34868e-19
C472	a_1895_74##9	a_1409_64##4	9.58481e-20
C473	a_533_61##4	a_1997_74#	8.35249e-18
C474	a_958_74##8	a_763_74##10	8.02538e-17
C475	a_533_61##2	DE#1	1.16916e-17
C476	a_533_61##9	VGND#12	7.55747e-18
C477	VPWR#15	a_958_74#	1.508e-18
C478	VGND#13	a_159_446##3	4.28757e-18
C479	a_958_74##12	a_958_74##2	4.59405e-19
C480	VPWR#9	a_533_61##2	1.95562e-19
C481	a_27_508##6	a_159_446##8	7.0931e-17
C482	a_763_74##9	a_1997_74#	8.35249e-18
C483	a_1409_64##9	a_763_74##6	2.52038e-18
C484	a_533_61##9	a_763_74##6	1.08622e-17
C485	VGND#3	a_958_74##4	3.70333e-17
C486	a_958_74##6	a_958_74##8	2.66008e-18
C487	a_958_74##16	a_763_74##8	3.42069e-17
C488	a_533_61##6	a_2088_502#	1.06762e-17
C489	a_533_61##9	a_763_74##15	3.07749e-18
C490	a_533_61##11	VGND#1	9.75906e-19
C491	a_159_446##4	DE#1	7.49094e-18
C492	a_533_61##9	a_958_74##4	1.80179e-17
C493	a_958_74##7	a_2088_502#	1.06762e-17
C494	a_958_74##6	a_763_74##10	7.33475e-17
C495	D#4	DE#5	4.47732e-18
C496	a_1156_90##6	a_958_74##3	1.51073e-17
C497	a_27_508#	CLK#1	2.49522e-19
C498	a_1156_90##5	a_763_74##6	7.45412e-17
C499	VPWR#6	a_763_74##2	2.8994e-19
C500	a_533_61##9	VGND#16	5.85249e-18
C501	a_763_74##8	VPWR#15	2.80005e-17
C502	a_533_61##9	a_958_74##2	6.22679e-18
C503	a_1409_64##6	a_763_74##10	3.97e-18
C504	VGND#13	DE#3	7.23638e-19
C505	VPWR#9	a_159_446##2	2.62941e-19
C506	a_533_61##3	CLK#3	3.94123e-18
C507	a_958_74##4	a_1409_64##10	1.08981e-17
C508	VGND#17	VGND#16	1.65728e-18
C509	VGND#6	a_763_74##13	8.41167e-19
C510	a_958_74##16	CLK#1	1.73226e-19
C511	a_533_61##9	a_27_508##9	1.2998e-18
C512	a_1156_90##5	a_1156_90#	1.21004e-19
C513	a_1409_64##6	a_958_74##6	4.53066e-17
C514	a_763_74##13	a_763_74##8	2.71637e-18
C515	a_763_74##10	a_1156_90##2	3.63529e-19
C516	a_533_61##7	DE#4	2.38987e-18
C517	a_27_508##6	VPWR#18	7.14122e-17
C518	a_763_74##11	a_1794_392#	3.36309e-17
C519	a_533_61##9	a_763_74##4	6.43936e-19
C520	a_27_508#	a_958_74##16	1.6548e-17
C521	a_533_61##11	Q#3	6.95737e-17
C522	a_1409_64##7	a_1794_392#	1.86137e-17
C523	VGND#13	DE#7	4.36811e-18
C524	VPWR#15	CLK#1	4.16685e-18
C525	a_958_74##5	a_1797_74#	1.6166e-17
C526	a_763_74#	a_1156_90##6	8.4805e-18
C527	a_533_61##10	a_27_508##3	5.81647e-17
C528	a_533_61##9	CLK#2	2.1978e-17
C529	a_1895_74##10	a_958_74##8	2.99089e-17
C530	VPWR#16	a_763_74##8	2.04004e-18
C531	a_1409_64##4	a_1797_74#	2.00901e-17
C532	a_958_74##13	a_958_74##3	7.08674e-20
C533	a_1156_90##2	a_1409_64##6	1.83371e-17
C534	a_1156_90##5	a_958_74##4	3.36854e-17
C535	VPWR#8	CLK#2	9.43494e-20
C536	VGND#17	a_27_508##9	1.77534e-17
C537	a_763_74##13	CLK#1	5.33379e-17
C538	VGND#5	VGND#4	5.52543e-19
C539	a_533_61##9	a_533_61##2	5.79957e-19
C540	VPWR#3	VPWR#1	6.69442e-17
C541	VPWR#2	a_1895_74##2	2.48413e-19
C542	VPWR#15	a_27_508#	5.75011e-18
C543	a_27_508##3	a_763_74##8	1.01829e-18
C544	a_159_446##3	a_533_61##3	4.16095e-17
C545	a_27_508##8	a_763_74#	3.36767e-17
C546	VGND#7	CLK#2	3.83517e-20
C547	D#2	a_159_446##2	9.13028e-18
C548	VGND#7	a_763_74##15	9.38874e-18
C549	a_1156_90##4	VPWR#5	2.07866e-17
C550	a_533_61##13	VPWR#2	2.27507e-19
C551	a_1409_64#	a_1382_508#	1.02164e-17
C552	a_533_61##12	VPWR#12	6.31191e-18
C553	a_533_61##9	a_159_446##4	1.12657e-17
C554	VPWR#16	CLK#1	4.01801e-17
C555	a_1156_90##2	a_1409_64##2	9.66408e-17
C556	a_763_74##6	a_1409_64##6	1.8778e-18
C557	a_958_74##4	a_958_74##6	3.09956e-18
C558	VPWR#5	a_763_74##2	1.9101e-20
C559	VGND#7	a_533_61##2	5.89637e-19
C560	a_763_74##7	a_1382_508#	1.10473e-17
C561	DE#2	VPWR#17	2.91681e-18
C562	a_1895_74##10	a_763_74##10	1.07158e-18
C563	a_763_74##13	a_533_61#	7.64004e-19
C564	a_159_446##6	a_27_508##6	2.23048e-18
C565	a_1156_90##2	a_763_74##6	1.45952e-17
C566	a_958_74##13	a_763_74#	2.07805e-18
C567	a_958_74##4	a_1409_64##6	2.42546e-20
C568	VPWR#3	a_533_61##15	1.70877e-17
C569	a_27_508##3	CLK#1	3.75941e-17
C570	a_27_508#	VPWR#6	2.14411e-17
C571	VGND#3	VPWR#1	3.82176e-18
C572	VGND#13	DE#5	6.38762e-19
C573	VGND#7	a_27_508##9	1.86678e-17
C574	a_763_74##6	a_1409_64##2	2.32947e-17
C575	a_1156_90##5	a_958_74##2	4.26465e-17
C576	a_958_74##4	a_1156_90##2	2.52524e-19
C577	a_533_61##7	a_27_508##3	8.73668e-18
C578	a_533_61##12	VGND#5	9.97697e-19
C579	a_27_508##8	a_763_74##5	3.53026e-18
C580	a_533_61##9	a_159_446#	3.36548e-19
C581	VPWR#16	a_533_61#	3.00027e-18
C582	a_533_61##12	a_1895_74##11	2.40298e-17
C583	a_1409_64##3	a_1349_90#	2.3778e-18
C584	DE#4	a_159_446##3	9.94336e-18
C585	Q	a_1895_74##2	6.06322e-18
C586	DE#7	a_159_446##3	2.38195e-17
C587	a_958_74##4	a_1409_64##2	9.66849e-17
C588	a_958_74##3	a_1349_90#	4.64203e-18
C589	VGND#13	a_159_446##9	6.47543e-18
C590	a_533_61##12	VGND#4	3.12737e-18
C591	a_27_508##3	a_533_61#	5.33394e-17
C592	a_27_508##7	a_27_508##6	6.79886e-19
C593	a_958_74##4	a_763_74##6	2.48485e-17
C594	a_1895_74##9	VPWR#2	9.9339e-20
C595	a_958_74##6	a_1895_74##10	4.94342e-17
C596	a_958_74##13	a_763_74##5	5.35278e-17
C597	a_533_61#	a_554_436#	9.87534e-18
C598	VPWR#17	CLK#1	9.81758e-19
C599	VPWR#16	DE#1	4.64536e-19
C600	a_533_61##12	VGND#2	1.25147e-17
C601	DE#1	a_554_436#	9.87534e-18
C602	a_763_74##6	a_958_74##2	2.81173e-17
C603	a_763_74##15	a_763_74#	1.36771e-19
C604	a_533_61##12	VPWR#13	3.1837e-18
C605	a_1895_74##11	VPWR#3	4.08485e-17
C606	a_27_508##8	CLK#3	6.19797e-20
C607	a_27_508##2	a_958_74##2	1.38959e-18
C608	a_958_74##6	VGND#10	6.96561e-17
C609	a_763_74##5	VGND#12	1.76446e-17
C610	a_27_508##3	DE#1	2.53189e-17
C611	a_159_446##8	DE#2	7.72988e-18
C612	a_533_61##12	a_1409_64##8	5.87248e-18
C613	DE#5	DE#7	3.79024e-18
C614	VPWR#17	a_533_61#	3.12999e-18
C615	a_159_446##6	a_27_508##3	1.40769e-17
C616	a_958_74##6	a_1409_64##13	4.90183e-17
C617	VPWR#16	DE#6	1.1843e-18
C618	a_159_446##9	VGND#17	4.06241e-17
C619	a_958_74##13	CLK#3	2.07953e-19
C620	a_159_446##2	a_114_508#	9.7209e-18
C621	a_533_61##12	VPWR#14	2.30119e-18
C622	VPWR#3	VPWR#13	2.80794e-17
C623	VGND#3	a_1895_74##11	8.20377e-19
C624	VGND#4	VGND#2	1.34908e-20
C625	a_159_446##6	DE#4	9.33347e-18
C626	D#3	a_114_508#	1.01349e-17
C627	a_763_74##15	a_763_74##5	2.05246e-18
C628	VGND#18	VGND#13	3.62359e-19
C629	a_27_508##3	DE#6	2.58467e-17
C630	VPWR#16	VPWR#15	6.84126e-18
C631	VPWR#3	a_1409_64##8	3.12037e-18
C632	VPWR#17	DE#1	3.42903e-17
C633	VGND#12	CLK#3	2.30761e-18
C634	VPWR	DE#4	6.01622e-21
C635	CLK#2	a_763_74##4	7.36281e-18
C636	VGND#10	a_1409_64##6	1.32077e-18
C637	a_27_508##2	a_763_74##4	1.4245e-17
C638	a_1156_90##6	a_763_74##2	2.14458e-20
C639	VGND#16	a_763_74##5	3.71338e-19
C640	a_533_61##11	a_1895_74##10	1.94278e-21
C641	VGND#18	VGND#17	3.21164e-18
C642	D#1	DE#5	3.76769e-17
C643	VPWR#3	VPWR#14	9.66761e-18
C644	a_958_74##12	a_1409_64##3	1.47775e-19
C645	a_27_508##3	a_159_446##2	1.05108e-19
C646	a_763_74##2	a_1409_64##2	1.61071e-18
C647	a_533_61##2	CLK#2	2.42609e-17
C648	a_763_74##15	CLK#3	5.19782e-17
C649	a_763_74##10	a_1794_392#	1.21919e-17
C650	a_763_74##13	VPWR#16	3.71439e-18
C651	DE#6	VPWR#17	2.43857e-17
C652	VGND#3	VGND#5	8.7116e-17
C653	a_1156_90##5	a_763_74##8	2.79698e-19
C654	a_159_446##6	DE#2	2.14506e-17
C655	CLK	a_763_74##15	8.00365e-18
C656	a_27_508##9	a_763_74##5	6.03843e-20
C657	VGND#16	CLK	2.43431e-17
C658	VGND#12	a_533_61##3	8.20394e-20
C659	a_27_508##9	CLK	1.74363e-17
C660	a_27_508##8	a_763_74##3	1.46691e-17
C661	a_27_508##6	D#7	6.64514e-17
C662	a_533_61##9	VGND#13	3.41714e-18
C663	a_533_61##12	VPWR#5	2.21706e-18
C664	Q	VPWR#2	5.65013e-18
C665	a_159_446##4	a_533_61##2	4.15097e-17
C666	DE#6	a_159_446##8	8.90254e-18
C667	VGND#3	VGND#4	8.74724e-17
C668	VPWR#3	a_1156_90##4	6.93265e-18
C669	a_159_446##9	VGND#18	4.80796e-17
C670	CLK#3	VGND#16	1.35061e-17
C671	a_533_61##13	Q	3.78054e-17
C672	a_27_508##3	a_763_74##13	4.91655e-17
C673	a_27_508##2	a_958_74#	1.03229e-18
C674	a_27_508##10	a_27_508##6	1.4713e-18
C675	a_533_61##12	VPWR#4	3.98079e-18
C676	a_1895_74##11	a_533_61##4	3.46919e-19
C677	VGND#3	VGND#2	1.60547e-16
C678	VPWR#18	DE#6	5.8867e-19
C679	DE#3	a_159_446##4	1.09162e-17
C680	a_533_61##3	a_491_87#	8.8457e-18
C681	a_958_74##12	a_958_74##3	4.9816e-18
C682	VPWR#9	VPWR#16	3.42125e-18
C683	a_159_446##3	a_491_87#	8.8457e-18
C684	a_1409_64##10	a_958_74##5	1.28291e-19
C685	a_533_61##9	VGND#6	5.48393e-18
C686	a_27_508##9	CLK#3	2.55587e-18
C687	a_159_446##8	a_159_446##2	6.71114e-19
C688	a_159_446#	a_159_446##4	2.74458e-18
C689	VGND	a_763_74##2	1.45166e-19
C690	a_533_61##12	VPWR#2	5.01933e-18
C691	VGND	DE#4	1.15026e-20
C692	a_763_74##6	a_1382_508#	3.74573e-18
C693	VGND	DE#2	7.66761e-21
C694	a_27_508##8	a_763_74##2	1.2968e-17
C695	a_159_446#	DE#3	2.7425e-17
C696	VGND#16	a_533_61##3	2.13999e-18
C697	a_27_508##3	VPWR#16	4.45121e-17
C698	a_533_61##9	VGND#5	2.37485e-18
C699	VPWR#12	a_1895_74##4	6.41194e-19
C700	VPWR#18	a_159_446##2	3.20472e-17
C701	VPWR	VPWR#9	8.15135e-17
C702	VPWR	VPWR#7	7.97764e-17
C703	DE#3	D#2	3.88867e-19
C704	VPWR	VPWR#6	1.15561e-16
C705	VPWR	VPWR#5	1.77832e-17
C706	VPWR#3	VPWR#5	9.01323e-17
C707	CLK	a_763_74##13	1.5636e-17
C708	D#2	a_159_446#	4.54957e-17
C709	a_27_508##2	a_763_74##8	4.37688e-17
C710	a_533_61##7	a_27_508##9	5.42745e-17
C711	VGND#11	a_1409_64##2	1.83039e-18
C712	a_533_61##15	a_533_61##5	1.1364e-19
C713	a_533_61##9	a_1156_90##4	1.09464e-18
C714	a_27_508##9	a_533_61##3	3.42902e-17
C715	a_958_74##6	a_1797_74#	6.30786e-18
C716	VPWR#3	VPWR#4	7.38625e-17
C717	a_958_74##13	a_763_74##3	9.62762e-19
C718	a_958_74##12	a_763_74#	2.66644e-17
C719	a_1409_64##10	a_1409_64##4	6.55163e-19
C720	VPWR#18	D#3	4.57704e-18
C721	VGND#17	CLK#3	4.02632e-19
C722	a_27_508##10	a_159_446##9	1.02797e-17
C723	a_533_61##5	VPWR#12	3.50676e-17
C724	DE#5	a_131_74#	9.7209e-18
C725	VGND#16	a_159_446##3	2.32298e-19
C726	a_533_61##9	a_27_508#	3.6101e-18
C727	a_27_508##3	VPWR#9	4.57681e-17
C728	a_27_508##7	a_159_446##2	5.05973e-18
C729	D#1	a_131_74#	1.01349e-17
C730	VPWR#3	VPWR#2	1.29913e-16
C731	VPWR	a_1156_90##5	1.74969e-18
C732	VPWR	a_27_508##6	2.92737e-17
C733	a_27_508##6	D#6	6.55178e-18
C734	VGND	VGND#13	9.32369e-17
C735	VPWR	a_27_508##2	2.12718e-17
C736	a_533_61##10	a_533_61##2	1.09051e-17
C737	a_533_61##9	a_958_74##16	4.34735e-17
C738	VGND	VGND#6	1.20017e-16
C739	a_533_61##12	a_533_61##13	7.61252e-18
C740	VGND	VGND#5	3.9933e-17
C741	a_159_446##2	DE#2	2.06116e-19
C742	VPWR	a_533_61##10	2.99825e-18
C743	a_1895_74##7	a_1895_74#	7.47124e-18
C744	VPWR#17	VPWR#16	5.10546e-18
C745	a_27_508##9	a_159_446##3	3.76192e-18
C746	a_1895_74##2	VNB	4.78485e-17
C747	a_763_74##3	VNB	1.88772e-17
C748	a_763_74##2	VNB	5.45488e-17
C749	a_1895_74##11	a_533_61##5	1.31755e-17
C750	VPWR	a_159_446##6	1.33773e-18
C751	DE#4	VNB	7.09447e-17
C752	DE#2	VNB	3.44939e-17
C753	a_27_508##2	CLK#1	1.68988e-18
C754	a_27_508##7	D#3	2.56785e-17
C755	a_27_508##3	VPWR#7	2.92055e-18
C756	a_533_61##9	VPWR#15	3.32011e-18
C757	CLK	a_763_74##5	2.19675e-19
C758	VPWR	D#7	4.71652e-18
C759	a_27_508##10	VGND#18	1.04929e-17
C760	a_533_61##12	a_1895_74##9	4.26553e-17
C761	VGND#17	a_533_61##3	4.90853e-18
C762	a_533_61##7	a_533_61##2	2.17534e-17
C763	VGND#13	VGND#7	6.25348e-19
C764	Q	VPWR#1	9.90165e-17
C765	a_533_61##9	VPWR#9	2.07815e-18
C766	Q	Q#1	4.22769e-18
C767	a_958_74##4	a_1349_90#	1.16133e-17
C768	VGND	a_958_74##12	4.32336e-17
C769	a_533_61##15	Q	4.69392e-17
C770	a_1409_64##10	a_1156_90##3	6.88005e-18
C771	VPWR#12	Q	1.4075e-18
C772	a_533_61##9	a_763_74##13	9.95877e-17
C773	a_958_74##12	a_763_74##5	3.94171e-19
C774	a_1156_90##6	a_763_74##6	8.73887e-19
C775	a_763_74##2	a_958_74##4	1.88293e-18
C776	a_27_508##3	VPWR#17	1.00693e-16
C777	a_958_74##4	a_1409_64##13	6.00993e-17
C778	a_533_61##9	VPWR#7	3.02589e-18
C779	VGND	a_1156_90##5	1.91768e-18
C780	VPWR	a_27_508##8	7.86475e-19
C781	a_159_446##6	a_533_61##2	1.3993e-19
C782	a_1895_74##11	a_958_74##8	5.51888e-17
C783	a_159_446##4	a_533_61##10	2.14868e-17
C784	a_533_61##9	VPWR#16	3.36804e-18
C785	a_958_74##4	VGND#11	1.0561e-16
C786	a_533_61##6	a_1895_74##7	9.6514e-18
C787	VGND#7	VGND#6	1.1554e-18
C788	VGND	a_533_61##7	5.20762e-18
C789	VGND#17	a_159_446##3	3.65929e-17
C790	VPWR#3	a_533_61##13	1.55457e-18
C791	a_533_61##9	VPWR#6	6.86295e-18
C792	VGND	a_159_446##6	3.14168e-18
C793	VGND#13	VNB	3.81433e-17
C794	VGND#6	VNB	6.18945e-17
C795	a_27_508##2	a_533_61#	8.86001e-20
C796	VGND#5	VNB	6.91538e-17
C797	a_533_61##9	a_27_508##3	6.48422e-17
C798	VGND#4	VNB	4.39672e-17
C799	VGND#2	VNB	6.59948e-17
C800	VGND	D#4	9.62953e-18
C801	VPWR#9	VNB	4.4732e-17
C802	a_159_446##8	a_27_508##3	5.26587e-17
C803	a_159_446##4	a_533_61##7	2.61003e-17
C804	VPWR#7	VNB	3.39647e-17
C805	VPWR#6	VNB	6.12407e-17
C806	VPWR#5	VNB	5.60007e-17
C807	VPWR#4	VNB	3.96381e-17
C808	VPWR#2	VNB	5.9242e-17
C809	a_958_74##4	a_1156_90##6	6.51659e-17
C810	a_533_61##9	VPWR#5	3.24324e-18
C811	VPWR#3	a_1895_74##9	1.14789e-18
C812	a_27_508##6	a_159_446#	4.32057e-17
C813	a_533_61##13	VNB	6.70556e-18
C814	a_1895_74##9	VNB	5.35152e-18
C815	VPWR	a_1156_90##4	1.30485e-17
C816	VGND#10	a_1895_74##10	1.28713e-17
C817	a_159_446##9	a_159_446##3	2.33368e-19
C818	a_763_74##10	a_1895_74##11	7.98005e-17
C819	VGND	a_1156_90##6	6.71986e-18
C820	VPWR	a_27_508#	1.98009e-17
C821	a_958_74##12	VNB	1.69618e-17
C822	VGND	a_27_508##8	8.3895e-18
C823	VPWR	a_958_74##16	4.42564e-18
C824	VGND	a_958_74##13	3.21021e-17
C825	VPWR	a_763_74##13	7.89554e-18
C826	VGND	a_763_74##15	2.19701e-17
C827	a_533_61##12	a_1895_74##6	6.6336e-21
C828	VGND	a_27_508##9	1.89342e-17
C829	VPWR	a_27_508##3	3.94578e-17
C830	a_1409_64##10	VNB	4.87973e-18
C831	a_1409_64##9	VNB	1.21087e-17
C832	a_1156_90##5	VNB	8.26604e-18
C833	VGND	a_159_446##9	2.00099e-17
C834	a_27_508##6	VNB	7.45593e-17
C835	a_27_508##3	VPWR#8	8.89149e-18
C836	VGND#17	DE#7	2.79336e-17
C837	VGND	VGND#18	1.59928e-17
C838	VPWR	a_159_446##8	6.57669e-18
C839	a_533_61##9	VPWR#17	3.79258e-18
C840	a_958_74##7	a_533_61##6	2.8306e-17
C841	a_27_508##2	VNB	1.2603e-17
C842	VGND	a_27_508##10	2.28779e-17
C843	VPWR	a_27_508##7	1.8134e-17
C844	a_533_61##10	VNB	3.28694e-19
C845	a_533_61##7	VNB	1.4263e-18
C846	VGND#2	VGND#1	1.02816e-18
C847	a_159_446##6	VNB	1.23398e-18
C848	a_27_508##6	DE#6	2.13898e-18
C849	a_159_446##9	a_533_61##7	1.54728e-18
C850	VGND#7	CLK	9.64518e-19
C851	D#7	VNB	4.83654e-19
C852	Q	a_1895_74#	4.19873e-17
C853	a_763_74##10	VPWR#13	1.94415e-17
C854	D#6	VNB	5.59167e-19
C855	Q	a_1895_74##7	3.13008e-18
C856	D#4	VNB	6.19129e-18
C857	VGND#1	VNB	8.11104e-17
C858	Q	a_533_61##6	1.95978e-19
C859	a_763_74##2	a_958_74##2	2.49881e-17
C860	Q#3	VNB	1.51138e-17
C861	a_533_61##11	VNB	1.44584e-17
C862	VGND	a_958_74##16	7.03336e-19
C863	DE#3	a_533_61##7	8.94072e-18
C864	a_1895_74##10	VNB	5.10675e-18
C865	a_1895_74##9	a_1895_74##2	1.67596e-19
C866	VGND	a_763_74##13	3.90525e-18
C867	VGND#10	VNB	8.76234e-19
C868	DE#7	a_159_446##9	1.09055e-17
C869	a_1409_64##13	VNB	1.81563e-19
C870	VGND#11	VNB	2.4313e-19
C871	a_1156_90##6	VNB	5.16449e-18
C872	a_1409_64##8	a_763_74##10	6.56672e-18
C873	a_533_61##12	a_533_61##4	8.2526e-19
C874	a_27_508##8	VNB	1.14183e-17
C875	a_958_74##13	VNB	1.55721e-17
C876	a_27_508##6	D#2	2.56329e-17
C877	VGND#12	VNB	9.85233e-18
C878	a_763_74##15	VNB	1.20262e-17
C879	VGND#16	VNB	2.67363e-18
C880	a_27_508##9	VNB	1.4461e-17
C881	VGND#3	a_1895_74##9	8.51585e-18
C882	VGND#17	VNB	6.1513e-19
C883	a_159_446##9	VNB	1.09065e-17
C884	VGND#18	VNB	4.06738e-18
C885	VGND#17	DE#5	1.07622e-18
C886	a_27_508##10	VNB	5.82161e-17
C887	VPWR#1	VNB	8.81702e-17
C888	DE#3	a_159_446##6	2.78764e-17
C889	a_533_61##15	VNB	8.3038e-18
C890	VPWR#12	VNB	1.34265e-18
C891	a_763_74##11	a_958_74##7	2.9324e-17
C892	a_1895_74##11	VNB	1.47395e-17
C893	VGND	a_958_74##3	1.40165e-20
C894	VPWR#13	VNB	3.51499e-18
C895	VGND#18	DE#7	2.46423e-18
C896	a_1409_64##8	VNB	2.91918e-18
C897	VGND	a_763_74##5	5.22699e-19
C898	a_533_61##12	Q	5.28735e-17
C899	VPWR#14	VNB	2.42828e-18
C900	VPWR#3	Q	2.0363e-17
C901	CLK	CLK#2	1.1444e-17
C902	VGND	a_533_61##3	6.33653e-18
C903	a_1156_90##4	VNB	2.72387e-18
C904	VGND#3	a_1895_74##6	2.34615e-18
C905	a_27_508#	VNB	9.15507e-18
C906	VGND	a_159_446##3	4.79966e-18
C907	a_958_74##16	VNB	7.63863e-18
C908	CLK	a_533_61##2	1.09558e-18
C909	VGND	DE#7	4.32798e-18
C910	VPWR	CLK#1	4.67523e-18
C911	VPWR#15	VNB	7.71959e-18
C912	VGND	DE#5	2.1769e-18
C913	a_763_74##13	VNB	1.13578e-17
C914	VPWR	a_533_61#	7.2579e-18
C915	VPWR#16	VNB	9.93207e-18
C916	VGND	D#1	1.68584e-18
C917	a_533_61##12	a_1895_74##2	2.60434e-18
C918	VPWR#3	a_533_61##4	1.95777e-21
C919	a_27_508##3	VNB	3.52268e-17
C920	VPWR	DE#1	3.18258e-18
C921	VPWR	DE#6	2.51152e-20
C922	VPWR#17	VNB	5.0697e-18
C923	a_159_446##8	VNB	6.59586e-19
C924	Q	a_1895_74##4	5.55958e-19
C925	VPWR	a_159_446##2	7.6483e-19
C926	VPWR#18	VNB	1.81282e-18
C927	a_27_508##6	a_159_446##2	2.11443e-17
C928	a_159_446##9	DE#5	1.61576e-17
C929	VPWR	D#3	1.70875e-18
C930	a_27_508##7	VNB	2.5575e-17
C931	VGND#2	a_1895_74##4	1.98315e-17
C932	a_1895_74##6	VNB	2.97794e-17
C933	a_1895_74##5	VNB	2.62854e-17
C934	a_533_61##4	VNB	5.70245e-17
C935	a_763_74##9	VNB	3.14414e-17
C936	a_958_74##12	a_1156_90##6	9.41124e-17
C937	a_958_74##5	VNB	2.67602e-17
C938	a_159_446#	a_533_61##7	2.76054e-19
C939	a_1409_64##4	VNB	3.36528e-17
C940	a_1156_90##3	VNB	3.80222e-17
C941	VGND#2	Q#3	2.53627e-18
C942	a_533_61##9	VPWR	7.05305e-17
C943	a_1409_64##3	VNB	2.43623e-17
C944	a_27_508##8	a_763_74##4	2.58583e-18
C945	a_958_74##3	VNB	2.08634e-17
C946	VPWR	VPWR#8	3.45025e-17
C947	a_763_74#	VNB	4.27226e-17
C948	a_763_74##5	VNB	4.59745e-17
C949	CLK#3	VNB	3.67233e-17
C950	a_533_61##3	VNB	2.49538e-17
C951	VGND	DE#1	4.85948e-19
C952	a_159_446##3	VNB	2.59681e-17
C953	DE#7	VNB	2.35477e-17
C954	VGND	a_159_446##2	6.95149e-19
C955	DE#5	VNB	4.17014e-17
C956	D#1	VNB	2.52909e-17
C957	a_1895_74#	VNB	6.05317e-17
C958	a_1895_74##7	VNB	5.24033e-17
C959	a_958_74##13	a_763_74##4	6.84473e-18
C960	VPWR#13	a_1409_64##6	8.70012e-19
C961	a_533_61##6	VNB	2.05365e-17
C962	a_958_74##7	VNB	4.64192e-17
C963	a_763_74##11	VNB	3.34835e-17
C964	VGND#18	DE#5	2.81779e-17
C965	VGND	a_533_61##9	6.98311e-17
C966	a_1409_64##7	VNB	3.73582e-17
C967	a_1156_90#	VNB	4.10659e-17
C968	a_159_446##9	a_159_446##6	2.13576e-19
C969	a_159_446#	a_159_446##6	9.35163e-18
C970	a_1409_64##7	a_763_74##11	8.50587e-18
C971	a_1409_64#	VNB	4.1212e-17
C972	VGND	VGND#7	7.9833e-17
C973	a_763_74##7	VNB	1.85928e-17
C974	a_958_74#	VNB	2.42051e-17
C975	a_533_61##10	DE#1	5.43844e-18
C976	a_763_74##8	VNB	3.97626e-17
C977	VPWR	a_958_74##2	1.67179e-18
C978	CLK#1	VNB	6.35126e-17
C979	a_533_61#	VNB	3.70378e-17
C980	DE#1	VNB	3.51257e-17
C981	VGND#12	a_763_74##4	1.5486e-18
C982	VPWR	CLK#2	2.57187e-18
C983	DE#6	VNB	3.12818e-17
C984	a_763_74##4	a_763_74##2	1.61989e-18
C985	a_159_446##2	VNB	5.74718e-17
C986	a_27_508##10	DE#7	3.38812e-19
C987	D#3	VNB	3.75124e-17
C988	VPWR	a_159_446##4	2.76299e-18
C989	a_533_61##12	VNB	2.93665e-17
C990	a_1156_90##5	a_763_74##2	2.18819e-17
C991	a_159_446##9	D#1	1.64357e-18
C992	VPWR#3	VNB	2.91421e-16
C993	VGND#3	a_763_74##9	4.38615e-18
C994	VGND#3	VNB	2.81376e-16
C995	VPWR	a_159_446#	5.35579e-18
C996	VGND	a_958_74##4	1.62404e-18
C997	a_533_61##9	VNB	1.26548e-17
C998	VPWR#8	VNB	1.96668e-17
C999	VGND#7	VNB	3.85088e-17
C1000	a_1895_74##4	VNB	8.06642e-17
C1001	VGND	CLK#2	7.01842e-19
C1002	a_533_61##5	VNB	6.74739e-17
C1003	a_958_74##8	VNB	4.49271e-17
C1004	a_763_74##10	VNB	5.36725e-17
C1005	VGND	a_159_446##4	2.75615e-18
C1006	a_958_74##6	VNB	5.77855e-17
C1007	VGND	DE#3	3.42849e-18
C1008	a_1409_64##6	VNB	6.31044e-17
C1009	a_1156_90##2	VNB	4.44406e-17
C1010	VGND	a_159_446#	7.10022e-19
C1011	VGND#1	a_1895_74##2	5.57967e-19
C1012	a_27_508##6	D#3	1.524e-17
C1013	a_1409_64##2	VNB	7.1791e-17
C1014	a_27_508##8	CLK#2	6.27686e-19
C1015	a_763_74##6	VNB	7.60796e-17
C1016	a_958_74##4	VNB	4.52697e-17
C1017	a_958_74##2	VNB	5.4657e-17
C1018	a_763_74##4	VNB	7.44971e-17
C1019	CLK#2	VNB	4.6024e-17
C1020	D#7	a_159_446#	4.26668e-17
C1021	VGND#3	a_958_74##5	5.78237e-18
C1022	a_533_61##2	VNB	8.19089e-17
C1023	a_159_446##4	VNB	5.54276e-17
C1024	DE#3	VNB	1.83065e-18
C1025	a_159_446#	VNB	5.23037e-17
C1026	a_958_74##12	a_27_508##8	6.22368e-17
C1027	D#2	VNB	1.13893e-16
C1028	VGND#18	D#1	4.83357e-18
C1029	a_958_74##16	a_1156_90##6	9.88862e-18
C1030	VGND#2	a_533_61##11	5.2591e-17
C1031	a_1156_90##2	a_1409_64##8	1.10459e-17
C1032	a_1156_90#	a_1409_64##7	3.88168e-18
C1033	a_27_508##10	DE#5	5.84736e-18
C1034	a_159_446##6	D#2	1.42823e-19
C1035	VPWR#3	a_1895_74##2	5.89825e-19
C1036	D#6	a_159_446#	1.79868e-17
C1037	a_958_74##12	a_958_74##16	3.39912e-19
C1038	VGND	CLK	3.19871e-18
C1039	a_1409_64##10	a_1409_64##8	2.748e-18
C1040	CLK	VNB	1.19561e-18
C1041	VPWR#2	a_1895_74#	9.4341e-19
C1042	VPWR#14	a_1156_90##2	2.89408e-19
C1043	Q	VNB	3.03767e-17
C1044	a_533_61##12	a_1409_64##10	1.30718e-17
C1045	VPWR	VNB	2.83955e-16
C1046	a_763_74##15	CLK#2	6.5437e-19
C1047	VGND	VNB	2.84127e-16
C1048	D#4	a_159_446#	2.68809e-17
C1049	VPWR#10	D#2	1.87394e-19
C1050	VGND#14	D#2	2.82512e-19
C1051	VGND#14	a_159_446##9	6.18686e-18
C1052	VPWR#10	a_159_446##2	7.69271e-18
C1053	VGND	VGND#14	1.07669e-16
C1054	VPWR#10	a_159_446#	6.30822e-20
C1055	VGND#14	DE#5	4.95399e-18
C1056	VGND#14	VGND#13	1.00364e-18
C1057	VGND#14	DE#4	6.9819e-19
C1058	VGND#14	a_27_508##10	2.73236e-17
C1059	VPWR	VPWR#10	1.27417e-16
C1060	VPWR#10	DE#2	1.07054e-19
C1061	a_27_508##6	VPWR#10	3.98799e-17
C1062	a_27_508##7	VPWR#10	2.16426e-17
C1063	VGND#14	D#4	3.00652e-18
C1064	VGND#14	VNB	6.28951e-17
C1065	VPWR#10	DE#4	5.43505e-20
C1066	VGND#14	D#1	7.32816e-18
C1067	VPWR#10	VNB	6.68069e-17
C1068	VPWR#10	D#3	7.59714e-18
C1069	VPWR#10	VPWR#9	5.52543e-19
*
*
.ENDS sky130_fd_sc_hs__edfxtp_1
*
