* Extracted by Quantus, converted by sky130cad/quantus.py
*
*
*
*                       LINUX           Wed Nov 18 08:38:08 2026
*
*
*
*  PROGRAM  advgen
*
*  Name           : advgen - Quantus - (64-bit)
*  Version        : 25.1.0-p047
*  Build Date     : Thu Dec 11 23:20:30 PST 2025
*
*  HSPICE LIBRARY
*
*  OPERATING_TEMPERATURE 150
*  QRC_TECH_DIR <path>/tech
*
*
*

*
.SUBCKT sky130_fd_sc_hs__einvp_8 VPB VNB VGND VPWR Z A TE
*
*
*  caps2d version: 10
*
*
*       TRANSISTOR CARDS
*
*
XM8 Z#9 A#13 a_27_74##10 VNB sky130_fd_pr__nfet_01v8_lvt l=0.15 w=0.74 ad=0.2072 as=0.2109 pd=2.04 ps=2.05
XM3 a_27_74##16 A#25 Z#9 VNB sky130_fd_pr__nfet_01v8_lvt l=0.15 w=0.74 ad=0.259 as=0.2072 pd=2.18 ps=2.04
XM10 Z#7 A#23 a_27_74##16 VNB sky130_fd_pr__nfet_01v8_lvt l=0.15 w=0.74 ad=0.259 as=0.259 pd=2.18 ps=2.18
XM29 Z#7 A#21 a_27_74##15 VNB sky130_fd_pr__nfet_01v8_lvt l=0.15 w=0.74 ad=0.259 as=0.259 pd=2.18 ps=2.18
XM19 a_27_74##15 A#19 Z#5 VNB sky130_fd_pr__nfet_01v8_lvt l=0.15 w=0.74 ad=0.259 as=0.259 pd=2.18 ps=2.18
XM31 a_27_74##14 A#17 Z#5 VNB sky130_fd_pr__nfet_01v8_lvt l=0.15 w=0.74 ad=0.259 as=0.259 pd=2.18 ps=2.18
XM24 Z#3 A#15 a_27_74##14 VNB sky130_fd_pr__nfet_01v8_lvt l=0.15 w=0.74 ad=0.259 as=0.259 pd=2.18 ps=2.18
XM0 a_27_74##5 A#1 Z#3 VNB sky130_fd_pr__nfet_01v8_lvt l=0.15 w=0.74 ad=0.2072 as=0.259 pd=2.04 ps=2.18
XM17 VGND#11 TE#10 a_27_74##5 VNB sky130_fd_pr__nfet_01v8_lvt l=0.15 w=0.74 ad=0.259 as=0.2072 pd=2.18 ps=2.04
XM11 a_27_74##13 TE#18 VGND#11 VNB sky130_fd_pr__nfet_01v8_lvt l=0.15 w=0.74 ad=0.2072 as=0.259 pd=2.04 ps=2.18
XM20 VGND#10 TE#17 a_27_74##13 VNB sky130_fd_pr__nfet_01v8_lvt l=0.15 w=0.74 ad=0.2072 as=0.2072 pd=2.04 ps=2.04
XM32 VGND#10 TE#16 a_27_74##12 VNB sky130_fd_pr__nfet_01v8_lvt l=0.15 w=0.74 ad=0.2072 as=0.2072 pd=2.04 ps=2.04
XM4 a_27_74##12 TE#15 VGND#9 VNB sky130_fd_pr__nfet_01v8_lvt l=0.15 w=0.74 ad=0.2072 as=0.2072 pd=2.04 ps=2.04
XM2 VGND#9 TE#14 a_27_74##11 VNB sky130_fd_pr__nfet_01v8_lvt l=0.15 w=0.74 ad=0.2072 as=0.2072 pd=2.04 ps=2.04
XM25 a_27_74##11 TE#13 VGND#8 VNB sky130_fd_pr__nfet_01v8_lvt l=0.15 w=0.74 ad=0.2072 as=0.259 pd=2.04 ps=2.18
XM5 a_27_74# TE#12 VGND#8 VNB sky130_fd_pr__nfet_01v8_lvt l=0.15 w=0.74 ad=0.2109 as=0.259 pd=2.05 ps=2.18
XM18 a_802_323##17 TE#11 VGND#1 VNB sky130_fd_pr__nfet_01v8_lvt l=0.15 w=0.74 ad=0.2146 as=0.2109 pd=2.06 ps=2.05
XM30 Z#12 A#27 a_27_368##10 VPB sky130_fd_pr__pfet_01v8 l=0.15 w=1.12 ad=0.336 as=0.3248 pd=2.84 ps=2.82
XM16 a_27_368##16 A#26 Z#12 VPB sky130_fd_pr__pfet_01v8 l=0.15 w=1.12 ad=0.336 as=0.336 pd=2.84 ps=2.84
XM6 a_27_368##16 A#24 Z#14 VPB sky130_fd_pr__pfet_01v8 l=0.15 w=1.12 ad=0.336 as=0.336 pd=2.84 ps=2.84
XM26 Z#14 A#22 a_27_368##15 VPB sky130_fd_pr__pfet_01v8 l=0.15 w=1.12 ad=0.336 as=0.336 pd=2.84 ps=2.84
XM1 Z#13 A#20 a_27_368##15 VPB sky130_fd_pr__pfet_01v8 l=0.15 w=1.12 ad=0.336 as=0.336 pd=2.84 ps=2.84
XM13 a_27_368##14 A#18 Z#13 VPB sky130_fd_pr__pfet_01v8 l=0.15 w=1.12 ad=0.336 as=0.336 pd=2.84 ps=2.84
XM33 Z#1 A#16 a_27_368##14 VPB sky130_fd_pr__pfet_01v8 l=0.15 w=1.12 ad=0.336 as=0.336 pd=2.84 ps=2.84
XM15 a_27_368##5 A#14 Z#1 VPB sky130_fd_pr__pfet_01v8 l=0.15 w=1.12 ad=0.336 as=0.336 pd=2.84 ps=2.84
XM28 a_27_368##5 a_802_323##9 VPWR#11 VPB sky130_fd_pr__pfet_01v8 l=0.15 w=1.12 ad=0.336 as=0.336 pd=2.84 ps=2.84
XM22 VPWR#11 a_802_323##16 a_27_368##13 VPB sky130_fd_pr__pfet_01v8 l=0.15 w=1.12 ad=0.336 as=0.336 pd=2.84 ps=2.84
XM27 a_27_368##13 a_802_323##15 VPWR#10 VPB sky130_fd_pr__pfet_01v8 l=0.15 w=1.12 ad=0.336 as=0.336 pd=2.84 ps=2.84
XM12 VPWR#10 a_802_323##14 a_27_368##12 VPB sky130_fd_pr__pfet_01v8 l=0.15 w=1.12 ad=0.336 as=0.336 pd=2.84 ps=2.84
XM9 VPWR#9 a_802_323##13 a_27_368##12 VPB sky130_fd_pr__pfet_01v8 l=0.15 w=1.12 ad=0.336 as=0.336 pd=2.84 ps=2.84
XM21 a_27_368##11 a_802_323##12 VPWR#9 VPB sky130_fd_pr__pfet_01v8 l=0.15 w=1.12 ad=0.336 as=0.336 pd=2.84 ps=2.84
XM7 a_27_368##11 a_802_323##11 VPWR#8 VPB sky130_fd_pr__pfet_01v8 l=0.15 w=1.12 ad=0.336 as=0.336 pd=2.84 ps=2.84
XM14 VPWR#8 a_802_323##10 a_27_368# VPB sky130_fd_pr__pfet_01v8 l=0.15 w=1.12 ad=0.336 as=0.3248 pd=2.84 ps=2.82
XM23 a_802_323##20 TE#1 VPWR#1 VPB sky130_fd_pr__pfet_01v8 l=0.15 w=1.12 ad=0.3192 as=0.3192 pd=2.81 ps=2.81
*
*
*       RESISTOR AND CAP/DIODE CARDS
*
Rg1	A#1	A#2	412.523956
Rg2	A#2	A#3	40.324123
Rg3	A#3	A#4	37.362804
Rg4	A#4	A#5	47.206425
Rg5	A#5	A#6	27.519188
Rg6	A#6	A#7	54.029289
Rg7	A#7	A#8	29.394114
Rg8	A#8	A#9	56.569717
Rg9	A#9	A#10	89.522995
Rg10	A#10	A#11	75.142822
Rg11	A#11	A#12	61.015285
Rg12	A#12	A#13	322.953644
Rg13	A#2	A#14	473.627625
Rg14	A#3	A#15	296.149994
Rg15	A#4	A#16	476.975128
Rg16	A#5	A#17	296.149994
Rg17	A#6	A#18	476.975128
Rg18	A#7	A#19	307.346313
Rg19	A#8	A#20	397.698334
Rg20	A#9	A#21	301.631989
Rg21	A#9	A#22	485.753845
Rg22	A#10	A#23	370.195038
Rg23	A#10	A#24	459.143646
Rg24	A#11	A#25	370.195038
Rg25	A#11	A#26	459.143646
Rg26	A#12	A#27	507.075531
Rg27	a_802_323#	a_802_323##2	430.806519
Rg28	a_802_323##2	a_802_323##3	221.972031
Rg29	a_802_323##3	a_802_323##4	221.972031
Rg30	a_802_323##4	a_802_323##5	221.972031
Rg31	a_802_323##5	a_802_323##6	221.972031
Rg32	a_802_323##6	a_802_323##7	221.972031
Rg33	a_802_323##7	a_802_323##8	221.972031
Rg34	a_802_323##8	a_802_323##9	592.600037
Rg35	a_802_323##2	a_802_323##10	371.735809
Rg36	a_802_323##3	a_802_323##11	371.735809
Rg37	a_802_323##4	a_802_323##12	371.735809
Rg38	a_802_323##5	a_802_323##13	371.735809
Rg39	a_802_323##6	a_802_323##14	371.735809
Rg40	a_802_323##7	a_802_323##15	371.735809
Rg41	a_802_323##8	a_802_323##16	371.735809
Rg42	TE#1	TE#2	486.547119
Rg43	TE#2	TE#3	542.530212
Rg44	TE#3	TE#4	250.665115
Rg45	TE#4	TE#5	210.494781
Rg46	TE#5	TE#6	210.494781
Rg47	TE#6	TE#7	210.494781
Rg48	TE#7	TE#8	210.494781
Rg49	TE#8	TE#9	210.494781
Rg50	TE#9	TE#10	533.463684
Rg51	TE#2	TE#11	302.425262
Rg52	TE#3	TE#12	282.787201
Rg53	TE#4	TE#13	282.787201
Rg54	TE#5	TE#14	282.787201
Rg55	TE#6	TE#15	282.787201
Rg56	TE#7	TE#16	282.787201
Rg57	TE#8	TE#17	282.787201
Rg58	TE#9	TE#18	282.787201
Rf1	A	A#9	18.204504
Rf2	Z#1	Z#2	21.553938
Rf3	Z#2	Z	32.312939
Rf4	Z	Z#4	54.877174
Rf5	Z#4	Z#6	59.845901
Rf6	Z#6	Z#8	59.885448
Rf7	Z#8	Z#9	77.493279
Rf8	Z#2	Z#10	65.696381
Rf9	Z#10	Z#11	65.696381
Rf10	Z#11	Z#12	84.059937
Rf11	Z#10	Z#13	21.554951
Rf12	Z#11	Z#14	21.554951
Rf13	Z#3	Z#4	15.000000
Rf14	Z#5	Z#6	15.000000
Rf15	Z#7	Z#8	15.000000
Rf16	a_27_368#	a_27_368##2	104.278221
Rf17	a_27_368##2	a_27_368##3	65.811081
Rf18	a_27_368##3	a_27_368##4	80.681114
Rf19	a_27_368##4	a_27_368##6	84.997406
Rf20	a_27_368##6	a_27_368##7	95.390015
Rf21	a_27_368##7	a_27_368##8	65.512337
Rf22	a_27_368##8	a_27_368##9	66.421333
Rf23	a_27_368##9	a_27_368##10	96.049217
Rf24	a_27_368##2	a_27_368##11	39.817963
Rf25	a_27_368##3	a_27_368##12	39.817963
Rf26	a_27_368##4	a_27_368##13	18.048523
Rf27	a_27_368##7	a_27_368##14	32.084732
Rf28	a_27_368##8	a_27_368##15	29.722061
Rf29	a_27_368##9	a_27_368##16	31.424841
Rf30	a_27_368##5	a_27_368##6	7.500000
Rf31	a_27_74#	a_27_74##2	98.225571
Rf32	a_27_74##2	a_27_74##3	65.876305
Rf33	a_27_74##3	a_27_74##4	65.876305
Rf34	a_27_74##4	a_27_74##6	100.827217
Rf35	a_27_74##6	a_27_74##7	92.369057
Rf36	a_27_74##7	a_27_74##8	73.001427
Rf37	a_27_74##8	a_27_74##9	73.001427
Rf38	a_27_74##9	a_27_74##10	84.519470
Rf39	a_27_74##2	a_27_74##11	31.573793
Rf40	a_27_74##3	a_27_74##12	42.916145
Rf41	a_27_74##4	a_27_74##13	31.573793
Rf42	a_27_74##7	a_27_74##14	19.941607
Rf43	a_27_74##8	a_27_74##15	19.941607
Rf44	a_27_74##9	a_27_74##16	19.941607
Rf45	a_27_74##5	a_27_74##6	7.500000
Rf46	a_802_323##17	a_802_323##18	75.331223
Rf47	a_802_323##18	a_802_323#	42.096596
Rf48	a_802_323##18	a_802_323##20	8.268150
Rf49	TE	TE#2	172.417145
Rf50	VPWR#1	VPWR#2	117.800789
Rf51	VPWR#2	VPWR#3	68.335030
Rf52	VPWR#3	VPWR#4	65.811081
Rf53	VPWR#4	VPWR#5	62.954285
Rf54	VPWR#5	VPWR#6	65.818954
Rf55	VPWR#6	VPWR#7	70.469200
Rf56	VPWR#3	VPWR#8	46.469112
Rf57	VPWR#4	VPWR#9	46.469112
Rf58	VPWR#5	VPWR#10	65.253311
Rf59	VPWR#6	VPWR#11	30.747387
Rf60	VGND#1	VGND#2	99.649635
Rf61	VGND#2	VGND#3	45.997280
Rf62	VGND#3	VGND#4	67.887894
Rf63	VGND#4	VGND#5	62.774361
Rf64	VGND#5	VGND#6	67.887894
Rf65	VGND#6	VGND#7	88.366570
Rf66	VGND#3	VGND#8	32.617332
Rf67	VGND#4	VGND#9	32.617332
Rf68	VGND#5	VGND#10	32.617332
Rf69	VGND#6	VGND#11	32.617332
Re1	VPWR#2	VPWR	3.246228
Re2	VPWR	VPWR#7	1.159367
Re3	VGND#2	VGND	3.246228
Re4	VGND	VGND#7	1.159367
*
*       CAPACITOR CARDS
*
*
C1	VGND#8	a_27_74#	6.61121e-17
C2	a_27_74##13	TE#18	3.58824e-17
C3	a_27_368##7	A#3	1.53257e-19
C4	a_27_368##12	VPWR#5	6.5241e-18
C5	VPWR#4	a_802_323##12	5.29041e-18
C6	a_27_368##3	VPWR#5	2.23325e-19
C7	VGND#10	TE#10	3.18276e-19
C8	TE#18	VGND#11	1.76708e-17
C9	Z#1	a_27_368##5	5.32292e-17
C10	VPWR#4	a_802_323##4	1.26443e-20
C11	a_27_368##14	A#5	1.14869e-18
C12	VPWR#3	a_802_323##12	7.03614e-19
C13	VPWR#2	TE#3	5.68903e-19
C14	a_27_74##11	a_27_74#	2.1367e-18
C15	a_27_74##13	TE#10	1.43557e-18
C16	a_27_368##12	VPWR#4	7.19941e-18
C17	a_27_74##5	TE#18	3.72774e-19
C18	a_27_368##14	a_27_368##5	3.56103e-18
C19	VPWR#5	a_802_323##13	2.78329e-19
C20	VGND#11	TE#10	4.13285e-17
C21	a_27_368##3	VPWR#4	1.7866e-19
C22	TE#8	a_802_323##6	1.46102e-17
C23	VPWR#4	a_802_323##13	5.84e-18
C24	a_27_74##11	VGND#8	6.1225e-17
C25	a_27_74##13	A#1	1.70524e-19
C26	a_27_368##14	Z#1	5.34215e-17
C27	a_27_74##5	TE#10	2.51378e-17
C28	VPWR#3	a_802_323##13	1.05533e-19
C29	a_27_74##5	A#3	6.94792e-18
C30	a_27_368##13	VPWR#6	7.24898e-18
C31	VPWR#2	a_802_323##2	1.79569e-18
C32	VGND#11	A#1	2.06297e-18
C33	Z#3	A#5	1.35472e-18
C34	Z#3	TE#10	2.00816e-18
C35	Z#13	Z#1	1.22865e-18
C36	VPWR#5	a_802_323##14	5.14399e-18
C37	VGND#2	TE#5	8.88998e-21
C38	a_27_368##13	VPWR#5	6.47453e-18
C39	VGND#9	VGND#8	1.89091e-18
C40	a_27_368##2	VPWR#4	1.7866e-19
C41	a_27_74##5	A#1	3.30203e-17
C42	VGND#2	TE#4	8.77886e-21
C43	VPWR#3	a_802_323##4	9.86258e-21
C44	VPWR#4	a_802_323##14	4.12904e-19
C45	Z#11	A#11	1.07629e-18
C46	VGND#2	TE#3	1.58464e-18
C47	Z#13	a_27_368##14	5.50152e-17
C48	VGND#11	A#15	2.74381e-19
C49	Z#3	A#1	3.77561e-17
C50	a_27_74##5	A#15	3.76464e-19
C51	VGND#9	a_27_74##11	5.81653e-17
C52	TE#7	a_802_323##6	9.28706e-18
C53	VPWR#5	a_802_323##15	5.1143e-18
C54	a_27_368##15	a_27_368##14	3.79902e-18
C55	a_27_368##2	VPWR#3	1.7866e-19
C56	A#11	A#10	7.45227e-18
C57	Z#11	A#10	1.26144e-17
C58	A#8	Z#5	7.98914e-18
C59	VPWR#11	VPWR#5	7.78961e-20
C60	VGND#11	A#17	7.05125e-20
C61	VPWR#3	a_802_323##3	2.29372e-20
C62	Z#3	A#3	1.14901e-17
C63	Z#3	Z#2	5.30484e-18
C64	Z#3	A#15	2.95047e-17
C65	a_27_368##4	A#3	1.49106e-18
C66	VPWR#4	a_802_323##15	1.05533e-19
C67	Z#5	A#1	2.01668e-19
C68	a_27_74##2	a_27_368#	2.58608e-17
C69	a_27_368##15	Z#13	5.96254e-17
C70	A#5	a_27_74##14	1.14215e-18
C71	a_27_368##5	VPWR#6	1.39689e-17
C72	A#15	a_27_74##14	1.65963e-17
C73	a_27_74##12	a_27_74##11	2.00505e-18
C74	a_27_368##2	a_802_323##10	2.54908e-20
C75	VPWR#6	a_802_323##16	1.83324e-18
C76	VGND#6	a_802_323##9	4.19759e-20
C77	VGND#11	A#19	3.82212e-20
C78	Z#3	A#17	9.17705e-19
C79	VPWR#5	a_802_323##16	2.78329e-19
C80	Z#5	A#15	7.20353e-19
C81	Z#14	Z#13	1.25826e-18
C82	VPWR#3	a_802_323##2	2.21276e-20
C83	A#17	a_27_74##14	1.14611e-17
C84	a_27_74##12	VGND#9	5.72385e-17
C85	Z#14	a_27_368##15	5.66199e-17
C86	a_27_368##2	a_802_323##11	1.32058e-19
C87	Z#3	A#19	2.37658e-19
C88	Z#5	A#17	3.88686e-17
C89	a_27_368##16	A#11	3.5326e-19
C90	TE#7	a_802_323##5	1.35438e-17
C91	VPWR#6	a_802_323##9	1.83689e-18
C92	A#8	a_27_74##15	4.89205e-19
C93	a_27_368##16	a_27_368##15	3.74942e-18
C94	VGND#10	VGND#9	2.30962e-18
C95	a_27_368##3	a_802_323##12	2.54908e-20
C96	Z#5	A#5	1.87195e-18
C97	a_27_368##16	A#10	3.4855e-19
C98	VPWR#7	A#12	2.86526e-20
C99	Z#3	A#21	1.57522e-19
C100	Z#5	A#19	2.88424e-17
C101	VPWR#7	A#11	4.97466e-20
C102	a_27_368##2	a_802_323##12	1.69558e-19
C103	Z#7	A#17	2.01668e-19
C104	a_27_368##16	Z#14	5.5111e-17
C105	VPWR#7	A#10	4.97466e-20
C106	Z#10	A#8	1.34715e-17
C107	VPWR#7	A#8	7.50418e-20
C108	A#19	a_27_74##15	1.65963e-17
C109	VGND#10	a_27_74##12	5.72009e-17
C110	A#10	Z#7	3.65612e-18
C111	a_27_74##4	TE#9	1.73007e-17
C112	Z#12	A#12	1.58345e-18
C113	a_27_368##3	a_802_323##13	1.32058e-19
C114	Z#12	Z#14	1.25826e-18
C115	Z#5	A#21	4.24687e-19
C116	Z#7	A#19	7.20353e-19
C117	VPWR#7	A#5	6.45458e-20
C118	a_27_368##2	a_802_323##13	3.36084e-20
C119	A#21	a_27_74##15	1.14611e-17
C120	Z#12	A#11	1.15062e-17
C121	VPWR#7	A#3	5.83057e-20
C122	TE#6	a_802_323##5	1.03547e-17
C123	Z#12	a_27_368##16	5.63478e-17
C124	Z#7	A#8	1.39816e-18
C125	a_27_74##13	a_27_74##12	2.00505e-18
C126	a_27_368##4	a_802_323##14	1.02932e-18
C127	Z#7	A#21	3.88686e-17
C128	a_27_74##4	TE#8	1.18111e-17
C129	a_27_368##3	a_802_323##14	1.66024e-19
C130	A#11	a_27_74##16	6.42342e-19
C131	VGND#7	A#12	6.36013e-20
C132	a_27_368##10	a_27_368##16	3.81608e-18
C133	VGND#7	A#11	1.05795e-19
C134	a_27_368##2	a_802_323##14	1.32141e-20
C135	VGND#7	A#10	1.38647e-19
C136	a_27_74##13	VGND#10	5.82226e-17
C137	VGND#6	VGND#5	1.13428e-18
C138	VGND#7	A#8	2.87094e-19
C139	Z#7	A#23	2.88424e-17
C140	a_27_368##4	a_802_323##15	1.41292e-17
C141	Z#9	A#21	1.91366e-19
C142	a_27_368##10	Z#12	9.04749e-17
C143	A#10	a_27_74##16	4.41051e-19
C144	a_27_368##2	a_27_368#	4.83815e-19
C145	a_27_368##10	A#12	7.62562e-20
C146	a_27_368##3	a_802_323##15	3.22207e-20
C147	A#23	a_27_74##16	1.65963e-17
C148	VGND#7	A#5	1.57924e-19
C149	VGND#3	VGND#1	3.7162e-19
C150	a_27_74##4	a_27_368##4	4.66402e-17
C151	A#12	Z#9	2.13128e-18
C152	VGND#11	VGND#10	1.89091e-18
C153	VGND#7	A#3	1.71841e-19
C154	Z#7	A#25	4.24687e-19
C155	Z#9	A#23	6.95062e-19
C156	Z#10	A#5	1.82287e-18
C157	VPWR#6	A#3	1.04538e-19
C158	TE#6	a_802_323##4	1.24773e-17
C159	a_27_368##4	a_802_323##16	2.08446e-17
C160	A#25	a_27_74##16	1.14611e-17
C161	a_27_74##10	A#23	2.60206e-19
C162	a_27_368##2	VPWR#8	2.11404e-17
C163	A#11	Z#9	2.67726e-18
C164	VGND#11	a_27_74##13	6.12637e-17
C165	Z#9	A#25	3.7065e-17
C166	a_27_74##4	a_27_368##3	3.91207e-17
C167	a_27_74##10	A#25	2.03964e-18
C168	a_27_368##4	a_802_323##9	1.64183e-18
C169	Z#9	A#10	1.05896e-18
C170	TE#12	TE#11	3.77078e-18
C171	a_27_368#	TE#4	1.77432e-18
C172	A#13	Z#9	1.71906e-17
C173	a_27_74##5	a_27_74##13	1.21821e-18
C174	VGND#5	VGND#4	1.35733e-18
C175	TE#3	a_802_323#	1.88161e-17
C176	Z#2	a_802_323##15	7.49935e-20
C177	a_27_368##7	A#14	4.83243e-18
C178	a_27_74##3	TE#7	1.16997e-17
C179	a_27_368##3	VPWR#9	1.31268e-17
C180	a_27_74##10	A#12	2.74747e-19
C181	a_27_74##10	A#13	4.36405e-17
C182	a_27_74##3	a_27_368##3	5.45322e-17
C183	a_27_368##4	a_27_368##12	2.24669e-18
C184	VGND#3	a_27_74#	1.76448e-18
C185	a_27_368#	TE#3	4.83327e-18
C186	TE#5	a_802_323##4	1.1422e-17
C187	a_27_368##4	A#14	1.10436e-19
C188	a_27_74##5	VGND#11	7.22588e-17
C189	a_27_368##2	VPWR#9	1.29882e-17
C190	TE#13	TE#12	2.77008e-17
C191	a_27_74##10	A#11	3.08253e-20
C192	Z#2	a_802_323##16	1.28036e-19
C193	a_27_368##7	A#16	1.59205e-17
C194	a_27_74##3	TE#6	1.17921e-17
C195	a_27_74##3	a_27_368##2	2.35607e-17
C196	a_27_74#	TE#3	2.29708e-17
C197	a_27_368##4	VPWR#10	2.92399e-17
C198	TE#14	TE#13	3.76049e-17
C199	Z#2	a_802_323##9	3.03435e-19
C200	VGND#4	a_27_74##11	6.98551e-18
C201	VPWR#1	TE#1	3.40349e-17
C202	a_27_368##3	VPWR#10	1.90433e-17
C203	a_27_368##7	A#18	1.58248e-17
C204	a_27_74##2	a_27_368##2	6.64719e-17
C205	VGND#4	VGND#3	1.13178e-18
C206	a_27_74##5	Z#3	7.70894e-17
C207	a_802_323##20	TE#1	6.00324e-17
C208	a_27_368##4	a_27_368##13	1.4445e-18
C209	TE#4	VGND#8	2.44488e-18
C210	TE#5	a_802_323##3	1.14109e-17
C211	Z#10	A#16	2.99145e-19
C212	VPWR#1	a_802_323##10	5.98647e-19
C213	Z#2	A#14	1.18108e-17
C214	VGND#3	a_27_74##11	6.71052e-18
C215	TE#15	TE#14	3.78218e-17
C216	a_27_368##8	A#20	1.56203e-17
C217	VPWR#8	TE#1	4.23994e-19
C218	a_802_323##17	a_802_323##20	5.79458e-18
C219	A#10	A#9	4.80129e-18
C220	a_27_74##4	a_802_323##8	3.39408e-18
C221	A#9	A#8	4.32116e-18
C222	a_27_368##4	VPWR#11	2.40335e-17
C223	TE#3	VGND#8	2.42362e-18
C224	a_27_368#	a_802_323##10	5.18144e-17
C225	VPWR#1	a_802_323##11	9.31779e-20
C226	VGND#5	a_27_74##12	5.25459e-18
C227	Z#10	A#18	2.12137e-17
C228	Z#2	A#16	2.07164e-17
C229	TE#5	a_27_74##11	4.02419e-19
C230	a_802_323##10	VPWR#8	1.94789e-17
C231	TE#16	TE#15	3.8557e-17
C232	a_27_368##8	A#22	1.57358e-17
C233	Z#3	a_27_74##14	8.44797e-20
C234	a_27_74##9	A#11	5.53079e-19
C235	VGND#6	TE#9	3.12372e-20
C236	a_27_368#	a_802_323##11	2.26047e-18
C237	a_27_368##11	a_802_323##10	3.13733e-19
C238	a_27_368##7	Z#1	3.0809e-17
C239	A#8	A#5	4.80129e-18
C240	a_27_74##2	TE#5	1.16807e-17
C241	VGND#4	a_27_74##12	5.20514e-18
C242	Z#11	a_27_368##9	3.03885e-18
C243	Z#11	A#20	2.99145e-19
C244	a_27_74##4	a_802_323##7	5.94396e-18
C245	VGND#3	TE#12	1.25649e-18
C246	VPWR#8	a_802_323##11	4.98259e-17
C247	Z#10	A#20	1.09171e-17
C248	TE#4	a_27_74##11	3.97388e-19
C249	TE#4	a_802_323##3	1.24895e-17
C250	Z#2	A#18	4.35989e-19
C251	Z#5	Z#3	2.5966e-18
C252	a_27_368##9	A#24	1.59149e-17
C253	a_27_74#	a_27_368#	1.81238e-17
C254	a_27_368##11	a_802_323##11	1.77272e-17
C255	TE#17	TE#16	3.78218e-17
C256	a_27_368#	a_802_323##12	1.72393e-19
C257	TE#6	VGND#9	1.70079e-18
C258	VGND#6	a_27_74##13	6.75998e-18
C259	a_27_74##9	A#10	7.33306e-19
C260	VPWR#9	a_802_323##11	3.62753e-19
C261	VPWR#8	a_802_323##12	2.64711e-18
C262	a_27_368##7	a_27_368##14	3.07104e-18
C263	a_27_74##5	a_802_323##9	6.04402e-18
C264	Z#11	a_27_368##8	1.33913e-18
C265	a_27_74##2	TE#4	1.5815e-17
C266	Z#11	A#22	2.1361e-17
C267	a_27_368#	a_802_323##2	2.30395e-17
C268	a_27_74##4	a_802_323##6	4.24445e-18
C269	Z#5	a_27_74##14	1.15522e-18
C270	a_27_368##11	a_802_323##12	5.3157e-17
C271	Z#3	a_27_74##15	2.38766e-20
C272	Z#10	A#22	2.99145e-19
C273	VGND#3	TE#13	2.75399e-18
C274	a_27_368##8	Z#13	1.57552e-17
C275	a_27_368##9	A#26	1.57365e-17
C276	TE#18	TE#17	3.76071e-17
C277	TE#5	VGND#9	1.61414e-18
C278	a_802_323##12	VPWR#9	1.92684e-17
C279	VPWR#8	a_802_323##13	1.88047e-19
C280	VGND#5	a_27_74##13	6.93606e-18
C281	Z#2	A#5	1.04567e-18
C282	VGND#5	TE#9	2.36014e-20
C283	a_27_368##12	a_802_323##12	3.13733e-19
C284	a_27_368##11	a_802_323##13	2.22686e-18
C285	TE#7	a_27_74##12	4.02419e-19
C286	a_27_368##4	a_27_368##3	5.61673e-19
C287	a_27_368##7	Z#13	1.55484e-17
C288	Z#11	A#24	1.09171e-17
C289	VGND#4	TE#14	1.26221e-18
C290	Z#10	a_27_368##8	1.18669e-18
C291	a_27_74##2	TE#3	2.62736e-18
C292	VPWR#9	a_802_323##13	4.98259e-17
C293	a_27_368##8	a_27_368##15	3.05171e-18
C294	VPWR#8	a_802_323##3	1.68299e-18
C295	TE#4	a_802_323##2	1.22133e-17
C296	TE#10	TE#18	2.7661e-17
C297	a_27_368##12	a_802_323##13	1.77272e-17
C298	VPWR#2	VPWR#3	6.217e-17
C299	a_27_368##11	a_802_323##14	1.59179e-19
C300	VPWR#6	VPWR#5	8.93032e-19
C301	TE#6	a_27_74##12	3.97388e-19
C302	Z#5	a_27_74##15	8.44797e-20
C303	a_27_368##9	Z#14	1.48442e-17
C304	VGND#2	VGND#4	8.3941e-18
C305	VPWR#10	a_802_323##13	3.35849e-19
C306	VPWR#9	a_802_323##14	2.28881e-18
C307	Z#11	A#26	2.99145e-19
C308	Z#10	a_27_368##7	1.41535e-18
C309	VGND#2	VGND#3	4.93188e-17
C310	VGND#5	TE#8	5.48386e-20
C311	VPWR#8	a_802_323##2	3.05454e-18
C312	TE#8	VGND#10	1.70079e-18
C313	VGND#6	a_27_74##5	2.34465e-17
C314	a_27_74##3	a_802_323##6	1.39213e-18
C315	a_27_368##12	a_802_323##14	5.31135e-17
C316	VGND#4	TE#15	1.25935e-18
C317	a_27_74#	a_802_323##2	4.35809e-18
C318	A#1	TE#10	3.9884e-17
C319	a_27_368##8	Z#14	1.65321e-17
C320	a_802_323##14	VPWR#10	2.36097e-17
C321	Z#7	Z#5	2.5966e-18
C322	VPWR#9	a_802_323##15	1.88047e-19
C323	Z#2	A#3	4.08048e-18
C324	a_802_323##4	a_27_368##11	5.35763e-19
C325	a_27_368##13	a_802_323##14	1.22404e-18
C326	a_27_368##12	a_802_323##15	2.20978e-18
C327	a_27_368##9	a_27_368##16	4.34145e-18
C328	a_27_74##8	A#8	1.03166e-18
C329	a_27_368##3	a_27_368##2	4.95027e-19
C330	VGND#5	TE#16	1.25935e-18
C331	TE#7	VGND#10	1.61414e-18
C332	VPWR#11	a_802_323##14	3.06214e-19
C333	a_802_323##15	VPWR#10	2.95826e-17
C334	A#15	A#1	2.52872e-17
C335	a_27_74##3	a_802_323##5	5.5773e-18
C336	VGND#5	TE#7	5.55328e-20
C337	Z#7	a_27_74##15	1.15522e-18
C338	TE#3	a_802_323##2	2.50983e-17
C339	a_802_323##3	a_27_368##11	4.99981e-19
C340	TE#9	a_27_74##13	4.02419e-19
C341	a_27_368##13	a_802_323##15	4.92321e-17
C342	Z#10	a_27_368##14	8.52943e-18
C343	VPWR#11	a_802_323##15	2.26949e-18
C344	VPWR#10	a_802_323##16	3.35849e-19
C345	a_27_368##9	Z#12	1.59281e-17
C346	VPWR#9	a_802_323##5	1.63576e-18
C347	a_27_368##5	a_802_323##15	2.04618e-19
C348	VPWR#5	VPWR#4	9.40188e-19
C349	Z#2	a_27_368##5	1.84946e-19
C350	a_802_323##16	a_27_368##13	1.526e-17
C351	A#17	A#15	2.48518e-17
C352	VGND#5	TE#17	1.25649e-18
C353	TE#8	a_27_74##13	3.97388e-19
C354	a_27_74##3	a_802_323##4	3.62483e-18
C355	VPWR#11	a_802_323##16	4.7714e-17
C356	VGND#2	a_27_74##2	1.61828e-18
C357	Z#10	Z#13	1.40954e-19
C358	a_27_368##5	a_802_323##16	4.74361e-19
C359	VPWR#2	a_27_368##2	1.34468e-18
C360	VPWR#9	a_802_323##4	3.20849e-18
C361	a_27_368##13	a_802_323##9	5.12053e-19
C362	Z#7	a_27_74##16	8.44797e-20
C363	a_27_74##7	A#8	3.23957e-19
C364	VGND#6	TE#18	2.73971e-18
C365	Z#11	a_27_368##15	1.04446e-17
C366	A#19	A#17	2.4938e-17
C367	Z#2	Z#1	1.41752e-19
C368	VPWR#11	a_802_323##9	4.14816e-17
C369	a_27_368##4	TE#9	4.58605e-18
C370	a_27_368##5	a_802_323##9	5.61102e-17
C371	a_27_368##13	A#14	2.29045e-19
C372	a_802_323##6	a_27_368##12	5.35763e-19
C373	a_27_74##2	TE#11	9.99848e-21
C374	Z#10	a_27_368##15	1.20502e-17
C375	TE#9	VGND#11	3.45303e-18
C376	Z#9	Z#7	2.52447e-18
C377	Z#1	a_802_323##9	1.2266e-18
C378	VGND#7	a_27_74##9	6.77313e-17
C379	VPWR#11	A#14	1.84112e-18
C380	a_27_368##9	VPWR#7	6.22563e-17
C381	VGND#2	a_27_368##2	1.88517e-18
C382	VGND#7	a_27_74##8	7.02824e-17
C383	A#21	A#19	2.48518e-17
C384	a_27_368##8	VPWR#7	6.29851e-17
C385	Z#11	Z#14	1.40954e-19
C386	a_27_368##14	a_802_323##9	2.89295e-19
C387	VGND#7	a_27_74##7	7.0829e-17
C388	a_27_368##5	A#14	2.86851e-17
C389	Z#2	a_27_368##14	1.08769e-17
C390	a_27_368##7	VPWR#7	7.25251e-17
C391	a_802_323##5	a_27_368##12	4.99981e-19
C392	Z#2	a_27_368##7	1.41535e-18
C393	VGND#6	TE#10	1.25649e-18
C394	Z#1	A#14	4.45151e-17
C395	VPWR#11	A#16	2.65252e-19
C396	a_27_74##2	a_802_323##4	1.6805e-18
C397	Z#9	a_27_74##16	1.15522e-18
C398	VPWR#4	VPWR#3	9.47047e-19
C399	a_27_368##14	A#14	6.81937e-19
C400	a_27_74##2	TE#12	8.78444e-20
C401	a_27_368##5	A#16	6.29557e-19
C402	VGND#4	TE#6	5.48386e-20
C403	A#23	A#21	2.4938e-17
C404	VPWR#10	a_802_323##7	3.05463e-18
C405	Z#11	Z#10	1.73196e-18
C406	Z#11	a_27_368##16	2.07041e-17
C407	Z#1	A#16	4.1228e-17
C408	VPWR#11	A#18	7.33399e-20
C409	a_27_74##3	TE#13	1.8945e-20
C410	VGND#2	VGND#1	6.27089e-17
C411	A#16	a_27_368##14	2.38515e-17
C412	TE#10	a_802_323##8	1.3779e-17
C413	a_27_368##5	A#18	2.71197e-19
C414	VGND#2	a_802_323##17	4.89633e-17
C415	VGND#6	A#1	2.19528e-18
C416	Z#13	A#16	1.37436e-18
C417	a_27_74##2	a_802_323##3	5.40854e-18
C418	A#25	A#23	2.4847e-17
C419	a_27_368##3	TE#9	1.2751e-19
C420	VPWR#10	a_802_323##6	3.0653e-18
C421	VGND#2	a_27_74#	3.25292e-17
C422	Z#1	A#18	1.47144e-18
C423	a_27_74##2	TE#13	6.17654e-19
C424	VPWR#11	A#20	4.23817e-20
C425	VGND#2	VGND#8	2.19959e-17
C426	a_27_368##15	A#16	3.01924e-19
C427	A#18	a_27_368##14	2.85292e-17
C428	VGND#4	TE#5	5.55328e-20
C429	VGND#2	a_27_74##11	1.46518e-17
C430	Z#12	Z#11	1.73196e-18
C431	a_27_74##10	Z#9	4.77626e-17
C432	Z#2	a_27_368##4	8.54175e-19
C433	Z#13	A#18	4.76545e-17
C434	a_27_74##7	A#5	9.69927e-19
C435	a_27_74##3	TE#14	4.32939e-20
C436	a_802_323##8	a_27_368##13	5.05934e-19
C437	a_27_368##15	A#18	7.28844e-19
C438	A#13	A#25	3.84003e-17
C439	A#3	a_802_323##9	7.20083e-18
C440	a_27_368##14	A#20	6.79749e-19
C441	a_27_368##3	TE#8	4.82832e-18
C442	a_27_74##2	a_802_323##2	4.35707e-18
C443	Z#13	A#20	4.09608e-17
C444	A#5	A#3	4.80129e-18
C445	VGND#8	a_27_74##2	2.58324e-17
C446	a_27_74##2	TE#14	2.26304e-19
C447	a_27_74##4	TE#15	2.11897e-20
C448	A#20	a_27_368##15	2.43782e-17
C449	a_802_323##7	a_27_368##13	5.29811e-19
C450	a_27_368##14	A#22	2.87586e-19
C451	a_27_74##9	A#9	2.40151e-19
C452	VGND#4	TE#4	2.36014e-20
C453	Z#14	A#20	1.35799e-18
C454	a_27_74##8	A#9	5.95184e-19
C455	Z#13	A#22	1.31502e-18
C456	a_27_74##3	TE#15	2.06573e-19
C457	VGND#6	a_27_74##4	1.6661e-19
C458	a_27_368##16	A#20	2.90192e-19
C459	A#22	a_27_368##15	2.89114e-17
C460	a_27_368##3	TE#7	5.48899e-18
C461	A	A#12	2.38372e-17
C462	Z#14	A#22	4.77816e-17
C463	A	A#11	1.86318e-17
C464	a_27_74##2	TE#15	4.67535e-20
C465	A	A#10	1.86344e-17
C466	VPWR#2	VPWR#1	5.67301e-17
C467	a_27_74##4	TE#16	4.67535e-20
C468	A	A#8	2.95141e-17
C469	TE#2	VGND#1	2.67692e-17
C470	VGND#9	a_27_74##3	1.60629e-17
C471	a_27_368##16	A#22	6.837e-19
C472	a_27_368##9	A#9	4.20724e-21
C473	a_802_323##20	VPWR#2	3.74991e-17
C474	a_802_323##17	TE#2	4.20378e-17
C475	a_27_368##15	A#24	7.05194e-19
C476	A	A#5	2.02181e-17
C477	a_27_368##8	A#9	8.04635e-20
C478	a_27_368#	VPWR#2	2.45553e-17
C479	A	A#3	1.24085e-17
C480	TE#10	a_802_323##9	4.41797e-18
C481	Z#14	A#24	4.11613e-17
C482	VPWR#11	a_802_323##8	4.65312e-19
C483	a_27_74##3	TE#16	2.06573e-19
C484	a_27_74##7	A#3	3.73408e-19
C485	VGND#5	a_27_74##4	2.15613e-19
C486	A#24	a_27_368##16	2.39312e-17
C487	a_27_368##3	TE#6	2.35445e-18
C488	VGND#2	VPWR#1	4.09574e-18
C489	a_802_323##10	TE#1	3.37707e-21
C490	VGND#7	a_27_74##5	1.42343e-17
C491	a_27_368##15	A#26	2.9835e-19
C492	VGND#2	a_802_323##20	3.15861e-18
C493	Z#12	A#24	1.65714e-18
C494	VGND#9	a_27_74##2	1.61061e-17
C495	a_802_323##20	VPWR#1	9.08159e-17
C496	a_27_74##2	TE#16	2.11897e-20
C497	Z#11	A#9	2.67353e-18
C498	Z#14	A#26	1.37948e-18
C499	VGND#2	a_27_368#	4.15372e-18
C500	a_27_74##4	TE#17	2.26304e-19
C501	a_27_368##10	A#24	3.14635e-19
C502	Z#10	A#9	1.24132e-18
C503	A#26	a_27_368##16	2.86622e-17
C504	a_27_74#	a_802_323#	2.16784e-17
C505	VGND#3	TE#4	3.0543e-20
C506	VGND#10	a_27_74##4	1.60629e-17
C507	a_802_323##11	a_802_323##10	4.75642e-17
C508	Z#12	A#26	5.91018e-17
C509	a_27_74##3	TE#17	4.32939e-20
C510	a_27_368##10	A#26	1.38896e-18
C511	a_27_368##9	A#12	9.46629e-21
C512	VGND#5	a_27_74##3	2.15613e-19
C513	a_27_368##16	A#27	1.41417e-18
C514	a_27_74##5	a_27_368##5	7.88742e-19
C515	Z#10	Z#2	1.73196e-18
C516	Z	A#8	3.65807e-19
C517	VGND#7	a_27_74##10	5.17551e-17
C518	Z#12	A#27	5.50983e-17
C519	a_802_323##12	a_802_323##11	4.71752e-17
C520	Z	A#5	4.23832e-19
C521	a_27_74##4	TE#18	5.82663e-19
C522	a_27_368##10	A#27	4.54944e-17
C523	VGND#10	a_27_74##3	1.61061e-17
C524	Z	A#3	1.27356e-17
C525	a_27_74##7	TE#10	2.02452e-19
C526	VPWR#8	VPWR#1	7.58986e-19
C527	VGND#3	TE#3	3.4708e-21
C528	a_27_368##4	a_802_323##8	1.24233e-17
C529	a_27_74##3	TE#18	1.8945e-20
C530	a_802_323##13	a_802_323##12	4.75642e-17
C531	a_27_368##2	TE#6	2.68516e-18
C532	a_27_368##9	A#11	6.99454e-20
C533	TE#2	VPWR#1	4.77968e-19
C534	VGND#4	a_27_74##3	2.15613e-19
C535	A#8	A#18	2.59382e-18
C536	a_27_74##7	a_27_74##5	2.41878e-18
C537	TE#2	a_802_323##20	1.94976e-17
C538	a_27_368##5	VPWR#7	1.48021e-17
C539	a_27_74##4	TE#10	1.46189e-18
C540	a_802_323##14	a_802_323##13	4.71632e-17
C541	a_27_74##7	A#1	7.49433e-19
C542	VPWR	a_802_323##7	2.0786e-20
C543	VGND#11	a_27_74##4	2.59415e-17
C544	VPWR	a_802_323##6	2.11273e-20
C545	VPWR	a_802_323##5	3.68833e-20
C546	a_27_74##5	a_802_323##8	3.2264e-18
C547	a_27_368##4	a_802_323##7	7.56041e-18
C548	VPWR	a_802_323##4	2.28338e-20
C549	A#9	a_27_74##15	5.72522e-19
C550	VPWR	a_802_323##3	3.58481e-20
C551	a_27_368##2	TE#5	5.73309e-18
C552	TE#11	VGND#1	2.67196e-17
C553	A#9	Z#7	4.74997e-18
C554	a_27_368#	VPWR#8	8.55649e-17
C555	a_27_368##9	A#10	7.09972e-20
C556	a_27_368#	a_802_323#	1.14383e-16
C557	a_802_323##15	a_802_323##14	4.813e-17
C558	VGND#2	TE#11	3.22895e-18
C559	VGND#4	a_27_74##2	2.15613e-19
C560	a_27_74##8	A#15	2.41211e-19
C561	a_27_74##7	Z#3	4.27179e-17
C562	VGND#2	TE#12	8.0617e-19
C563	A#3	TE#10	6.78682e-18
C564	a_27_74##4	A#1	2.14316e-20
C565	a_802_323##17	TE#11	6.06947e-17
C566	VGND#2	TE#13	1.38626e-19
C567	a_27_368##10	VPWR#7	5.05006e-17
C568	a_27_74##7	A#15	2.53359e-17
C569	a_27_368##11	a_27_368#	1.98011e-18
C570	a_802_323##16	a_802_323##15	4.71494e-17
C571	VGND#1	TE#12	8.74947e-19
C572	a_27_368##2	TE#4	4.20791e-18
C573	a_27_74#	TE#11	1.36632e-18
C574	VGND#3	a_27_74##2	1.6661e-19
C575	a_27_74##7	a_27_74##14	2.72184e-18
C576	a_27_74##8	A#17	8.25226e-19
C577	a_27_368##11	VPWR#8	8.05902e-17
C578	a_802_323##9	a_802_323##16	4.71833e-17
C579	a_802_323##17	TE#12	1.81104e-18
C580	VGND	TE#9	8.88998e-21
C581	VGND	TE#8	8.77886e-21
C582	VGND	TE#7	8.88998e-21
C583	VGND	TE#6	8.77886e-21
C584	VGND#8	TE#11	1.05787e-18
C585	a_27_74##8	Z#5	3.96131e-17
C586	VGND	a_802_323##8	7.60574e-21
C587	a_27_74##7	A#17	2.01078e-17
C588	a_27_368##3	a_802_323##7	2.79964e-18
C589	VPWR#6	a_802_323##8	2.14954e-20
C590	a_27_74#	TE#12	1.52848e-17
C591	VGND	A#12	3.15475e-19
C592	A#14	a_802_323##9	4.974e-17
C593	VGND	A#11	5.78925e-19
C594	VGND	A#10	5.78925e-19
C595	a_27_74##9	A#19	2.41211e-19
C596	VPWR#9	VPWR#8	2.2895e-18
C597	VGND	A#8	7.11757e-19
C598	a_27_74##11	TE#11	7.66062e-20
C599	VGND	A#5	6.50876e-19
C600	VGND	A#3	1.1956e-18
C601	a_27_368##15	A#9	7.76691e-19
C602	A#3	A#1	1.7594e-18
C603	a_27_74##7	Z#5	3.82788e-17
C604	VGND#8	TE#12	4.81838e-17
C605	a_27_74##8	A#19	2.53316e-17
C606	A#16	A#14	4.79847e-17
C607	VGND#1	TE	1.89961e-17
C608	a_27_368##4	TE#10	2.16685e-18
C609	VGND#7	A#1	2.21001e-18
C610	VPWR#9	a_27_368##11	8.05902e-17
C611	a_27_74##8	a_27_74##15	2.69348e-18
C612	A#10	A#22	2.59382e-18
C613	a_27_74#	TE#13	4.0054e-19
C614	a_27_368##3	a_802_323##6	1.03688e-17
C615	VGND#7	A#15	4.44935e-18
C616	a_27_74##7	A#19	5.07959e-19
C617	a_27_74##11	TE#12	1.69363e-18
C618	a_27_368##8	A#8	2.80273e-19
C619	VGND#7	A#17	4.44935e-18
C620	VPWR#2	TE#1	4.17515e-18
C621	A#18	A#16	4.90905e-17
C622	A#22	A#8	2.45093e-18
C623	A	Z#11	8.6687e-17
C624	VPWR#6	a_802_323##7	9.86258e-21
C625	a_27_74##9	Z#7	3.96131e-17
C626	A	Z#10	7.71086e-17
C627	a_27_74##9	A#21	8.25226e-19
C628	VGND#7	A#19	4.39559e-18
C629	VPWR#2	a_802_323##10	1.08251e-18
C630	VGND#7	A#21	4.44935e-18
C631	TE#13	VGND#8	1.78236e-17
C632	A	Z#2	4.31346e-17
C633	VPWR#2	a_802_323##11	9.94353e-19
C634	a_27_368##12	a_27_368##11	1.98011e-18
C635	VGND#7	A#23	4.44935e-18
C636	VGND#9	TE#12	3.18276e-19
C637	TE#9	VNB	1.56261e-17
C638	A#20	A#18	4.62424e-17
C639	TE#8	VNB	1.31077e-17
C640	a_27_74##8	A#21	2.01078e-17
C641	TE#7	VNB	1.31135e-17
C642	TE#6	VNB	1.31193e-17
C643	VGND#7	A#25	4.43427e-18
C644	TE#5	VNB	1.31251e-17
C645	TE#4	VNB	1.41434e-17
C646	TE#3	VNB	2.52102e-17
C647	a_802_323##8	VNB	1.53574e-17
C648	a_802_323##7	VNB	1.3453e-17
C649	a_802_323##6	VNB	1.33748e-17
C650	VGND#7	A#13	4.43427e-18
C651	a_802_323##5	VNB	1.33584e-17
C652	a_27_368##3	a_802_323##5	9.21204e-18
C653	a_802_323##4	VNB	1.33671e-17
C654	Z	a_27_368##4	1.32487e-17
C655	a_27_74##11	TE#13	4.25355e-17
C656	a_27_74##8	Z#7	3.83193e-17
C657	a_802_323##3	VNB	1.33633e-17
C658	a_802_323##2	VNB	2.49199e-17
C659	A#12	VNB	4.04057e-17
C660	A#11	VNB	3.05698e-17
C661	VPWR	VPWR#6	5.95816e-17
C662	A#10	VNB	3.04257e-17
C663	A#8	VNB	4.46867e-17
C664	VPWR	VPWR#5	5.84801e-17
C665	A#22	A#20	4.73562e-17
C666	VPWR	VPWR#4	6.73223e-17
C667	a_27_368##12	VPWR#9	8.05902e-17
C668	TE	VPWR#1	9.08591e-18
C669	A#5	VNB	2.90206e-17
C670	VPWR	VPWR#3	7.23737e-18
C671	A#3	VNB	4.16978e-17
C672	a_27_74##9	a_27_74##8	3.10574e-18
C673	VGND#8	TE#14	1.24834e-18
C674	a_27_74##9	a_27_74##16	2.70126e-18
C675	a_27_74##9	A#23	2.53316e-17
C676	Z#3	A	3.38748e-17
C677	VGND#9	TE#13	2.22015e-18
C678	Z#5	A	8.23581e-17
C679	A#24	A#22	4.62643e-17
C680	Z#7	A	8.23581e-17
C681	VPWR	a_27_368##9	2.5034e-17
C682	VPWR#3	VPWR#1	1.50884e-19
C683	a_27_74##8	A#23	5.07959e-19
C684	Z#9	A	5.73061e-17
C685	VPWR	a_27_368##8	2.5859e-17
C686	a_27_74##11	TE#14	1.21582e-17
C687	VPWR	a_27_368##7	2.80951e-17
C688	a_27_74##10	A	1.83028e-17
C689	VPWR#10	VPWR#9	2.22058e-18
C690	a_802_323#	TE#1	3.28617e-17
C691	VPWR	a_27_368##4	3.20382e-18
C692	a_27_74##12	TE#13	1.50665e-19
C693	VPWR	a_27_368##3	2.38514e-18
C694	A#26	A#24	4.73865e-17
C695	VPWR	a_27_368##2	9.77465e-19
C696	a_27_368##7	A#8	6.99454e-20
C697	a_802_323##10	a_802_323#	3.15849e-17
C698	VGND	VGND#6	6.46394e-17
C699	VPWR	Z#11	3.34867e-18
C700	a_27_74##5	Z	1.73907e-17
C701	VGND	VGND#5	5.30681e-17
C702	VPWR	Z#10	2.70508e-18
C703	VGND	VGND#4	4.46319e-17
C704	VPWR#5	a_802_323##7	1.23914e-20
C705	TE#9	a_802_323##8	1.17815e-17
C706	VGND#9	TE#14	4.343e-17
C707	VPWR#7	A#14	4.44831e-18
C708	VPWR	Z#2	1.55332e-18
C709	a_27_74##9	Z#9	3.52667e-17
C710	A#27	A#26	4.62339e-17
C711	a_27_74##9	A#25	1.94016e-17
C712	VPWR#7	A#16	4.46319e-18
C713	VPWR#10	a_27_368##12	7.91468e-17
C714	VGND	a_27_74##9	2.61483e-17
C715	VGND	a_27_74##8	2.70342e-17
C716	VGND	a_27_74##7	2.72241e-17
C717	VPWR#7	A#18	4.46319e-18
C718	VGND	a_27_74##4	3.35001e-18
C719	a_27_74##11	TE#15	3.82529e-19
C720	VGND	a_27_74##3	2.89042e-18
C721	VGND	a_27_74##2	1.29992e-18
C722	VPWR#7	A#20	4.43427e-18
C723	a_27_74##12	TE#14	3.54223e-19
C724	VGND	a_27_368##4	3.49791e-18
C725	a_27_368##2	a_802_323##5	5.98971e-19
C726	VGND	a_27_368##3	6.07385e-18
C727	VPWR#7	A#22	4.46319e-18
C728	VGND	a_27_368##2	3.83892e-18
C729	VGND	Z#11	4.60366e-18
C730	A	Z#12	4.97858e-17
C731	VGND	Z#10	4.09762e-18
C732	A	a_27_368##10	1.38948e-18
C733	VPWR#7	A#24	4.43427e-18
C734	VGND#9	TE#15	3.69935e-17
C735	Z	a_27_368##5	3.80574e-17
C736	VGND	Z#2	3.94792e-18
C737	VGND#6	VNB	3.44199e-17
C738	VPWR#7	A#26	4.42933e-18
C739	VGND#5	VNB	2.7609e-17
C740	VGND#4	VNB	2.76079e-17
C741	VGND#3	VNB	2.51654e-17
C742	VPWR#5	a_802_323##6	1.26443e-20
C743	VPWR#6	VNB	3.03979e-17
C744	VPWR#5	VNB	2.45485e-17
C745	a_27_74##8	a_27_74##7	3.10574e-18
C746	VGND#1	a_802_323##17	5.88346e-17
C747	VPWR#4	VNB	2.6035e-17
C748	VPWR#7	A#27	4.46477e-18
C749	VPWR#3	VNB	2.72305e-17
C750	VGND	VGND#9	2.17326e-17
C751	a_27_74##10	a_27_74##9	3.4302e-18
C752	a_27_74##5	a_27_368##4	6.12417e-18
C753	a_27_74##11	TE#16	1.68548e-19
C754	VPWR	a_27_368##11	1.53438e-17
C755	VGND	a_27_74##12	1.21533e-17
C756	a_27_74##9	A#13	1.02433e-18
C757	VGND	VGND#10	2.17326e-17
C758	a_27_74##9	VNB	4.86437e-18
C759	VGND	a_27_74##13	1.48435e-17
C760	VPWR	a_27_368##12	1.53438e-17
C761	a_27_74##8	VNB	5.08835e-18
C762	TE#15	a_27_74##12	1.4966e-17
C763	a_27_74##7	VNB	5.16336e-18
C764	VGND	VGND#11	2.1903e-17
C765	VGND	a_27_74##5	2.02105e-17
C766	a_27_74##4	VNB	3.95221e-18
C767	VPWR	a_27_368##13	1.55127e-17
C768	VGND	Z#3	1.14581e-17
C769	a_27_74##3	VNB	3.52534e-18
C770	VPWR	VPWR#11	2.21599e-17
C771	a_27_74##2	VNB	4.51743e-18
C772	a_27_368##13	VPWR#10	5.0876e-17
C773	A	A#1	7.35687e-19
C774	a_27_368##9	VNB	4.45195e-18
C775	VGND	Z#5	1.00342e-17
C776	VPWR	a_27_368##5	1.7382e-17
C777	a_27_368##8	VNB	4.55195e-18
C778	a_27_368##7	VNB	5.29329e-18
C779	VPWR	Z#1	9.38746e-18
C780	VGND	Z#7	1.00342e-17
C781	a_27_368##2	a_802_323##4	1.03896e-17
C782	a_27_368##4	VNB	1.13024e-18
C783	a_27_368##3	VNB	1.35068e-18
C784	VPWR	Z#13	9.01965e-18
C785	VGND	Z#9	7.35037e-18
C786	a_27_368##2	VNB	1.37234e-18
C787	VGND#9	TE#16	2.18507e-18
C788	Z#11	VNB	2.29509e-18
C789	VGND	a_27_74##10	2.48412e-17
C790	a_27_368#	VPWR#3	8.56147e-18
C791	Z#10	VNB	1.78488e-18
C792	VPWR	Z#14	9.01557e-18
C793	VGND#10	TE#15	2.18507e-18
C794	Z#2	VNB	1.39314e-18
C795	VPWR	Z#12	9.71836e-18
C796	VPWR#2	TE#2	4.03815e-18
C797	Z	TE#10	6.93411e-19
C798	VPWR	a_27_368##10	2.49445e-17
C799	VGND#1	VNB	6.2312e-17
C800	a_802_323##17	VNB	1.68592e-17
C801	a_27_74#	VNB	1.37419e-17
C802	VGND#8	VNB	1.04648e-18
C803	VGND#2	TE#2	7.33763e-18
C804	a_27_74##11	VNB	2.22472e-18
C805	VPWR#3	TE#1	1.49453e-19
C806	a_802_323#	VPWR#2	5.57585e-17
C807	TE#9	a_802_323##7	1.56719e-17
C808	a_27_74##12	VNB	5.10612e-18
C809	VPWR#11	VPWR#10	2.28687e-18
C810	a_27_74##13	VNB	2.22472e-18
C811	VGND#11	VNB	9.12329e-19
C812	VGND#2	a_802_323#	5.18547e-18
C813	TE#16	a_27_74##12	1.89031e-17
C814	a_27_74##5	VNB	6.30091e-18
C815	Z#3	VNB	1.21006e-18
C816	a_27_74##13	TE#15	1.68548e-19
C817	VGND	Z#12	3.09666e-18
C818	a_27_74##10	VNB	4.0405e-17
C819	VGND	a_27_368##10	6.14053e-18
C820	VPWR#1	VNB	8.22327e-17
C821	VPWR#7	A#9	8.54306e-20
C822	a_802_323##20	VNB	5.05583e-18
C823	a_27_368#	VNB	2.83586e-18
C824	VPWR#8	VNB	4.09278e-19
C825	a_27_368##11	VNB	2.43142e-18
C826	a_802_323#	TE#2	4.23365e-17
C827	a_27_368##2	a_802_323##3	9.84434e-18
C828	VGND	TE#14	7.09234e-19
C829	VGND#7	A#9	1.68872e-19
C830	VPWR#9	VNB	4.09278e-19
C831	a_27_368##12	VNB	2.43142e-18
C832	VGND	TE#15	7.62328e-19
C833	VPWR#10	VNB	2.92383e-18
C834	VGND#10	TE#16	4.34033e-17
C835	VGND	TE#16	7.62328e-19
C836	a_27_368##13	VNB	2.32228e-18
C837	VGND	TE#17	7.83056e-19
C838	VPWR#11	VNB	3.75695e-19
C839	a_27_368##5	VNB	2.69861e-18
C840	VGND	TE#18	1.38626e-19
C841	VPWR#11	a_27_368##13	4.50101e-17
C842	a_27_368##7	A#5	4.42692e-19
C843	VGND	TE#10	9.69444e-19
C844	Z	a_802_323##15	4.89398e-19
C845	VGND	A#1	1.45584e-18
C846	a_27_368##5	A#3	1.69739e-18
C847	VGND	A#15	2.07092e-18
C848	Z	a_802_323##16	1.55575e-18
C849	VGND	A#17	1.64891e-18
C850	Z	a_802_323##9	2.23685e-17
C851	a_27_74#	a_802_323##17	8.39487e-17
C852	VGND	A#19	1.58381e-18
C853	VGND#8	VGND#1	4.62357e-19
C854	Z#12	VNB	5.58027e-18
C855	VPWR	a_802_323##12	8.30754e-19
C856	a_27_368##10	VNB	6.57868e-17
C857	VGND	A#21	1.64891e-18
C858	Z	A#14	7.1241e-18
C859	a_27_368##4	VPWR#6	3.69186e-19
C860	TE#11	VNB	3.6048e-17
C861	VPWR	a_802_323##13	9.98939e-19
C862	VGND	A#23	1.58906e-18
C863	a_27_74##12	TE#17	3.54223e-19
C864	TE#12	VNB	2.47695e-17
C865	VGND	A#25	1.65999e-18
C866	VPWR	a_802_323##14	9.67432e-19
C867	TE#13	VNB	2.47376e-17
C868	VPWR#4	a_802_323##6	9.86258e-21
C869	TE#14	VNB	2.23995e-17
C870	VGND	A#13	2.33633e-18
C871	VPWR	a_802_323##15	9.03395e-19
C872	TE#15	VNB	2.31084e-17
C873	VPWR#2	TE	1.62282e-18
C874	a_27_74##13	TE#16	3.82529e-19
C875	TE#16	VNB	2.33353e-17
C876	VPWR	a_802_323##16	1.14365e-18
C877	VPWR#3	a_802_323##10	5.44017e-18
C878	TE#17	VNB	2.26236e-17
C879	VPWR	a_802_323##9	1.26618e-18
C880	TE#18	VNB	2.4646e-17
C881	VGND#2	TE	5.66783e-19
C882	A#27	A#11	2.57505e-18
C883	TE#10	VNB	3.47335e-17
C884	VPWR	A#14	1.44368e-18
C885	A#1	VNB	3.02527e-17
C886	A#15	VNB	2.76275e-17
C887	VPWR	A#16	1.53639e-18
C888	A#17	VNB	2.69958e-17
C889	a_27_368##11	VPWR#4	6.5241e-18
C890	VPWR	A#18	1.64233e-18
C891	A#19	VNB	2.71631e-17
C892	A#21	VNB	2.72258e-17
C893	VPWR	A#20	1.65796e-18
C894	a_27_368##5	a_27_368##13	2.67532e-18
C895	A#23	VNB	2.7296e-17
C896	A#25	VNB	2.67878e-17
C897	VPWR	A#22	1.64233e-18
C898	A#13	VNB	3.48213e-17
C899	VPWR	A#24	1.65796e-18
C900	VGND#10	TE#17	3.70491e-17
C901	TE#1	VNB	4.81833e-17
C902	VPWR	A#26	1.65215e-18
C903	a_27_368##2	a_802_323##2	7.58198e-19
C904	a_802_323##10	VNB	3.31897e-17
C905	a_802_323##11	VNB	2.88051e-17
C906	VPWR	A#27	2.43096e-18
C907	a_802_323##12	VNB	3.01904e-17
C908	a_27_74##10	a_27_368##10	8.70801e-18
C909	a_802_323##13	VNB	2.88259e-17
C910	a_802_323##14	VNB	3.19421e-17
C911	a_802_323##15	VNB	3.20871e-17
C912	A	A#9	2.24044e-17
C913	a_802_323##16	VNB	2.86857e-17
C914	a_802_323##9	VNB	4.20165e-17
C915	VPWR	VPWR#7	2.08071e-16
C916	A#14	VNB	3.52043e-17
C917	A#16	VNB	3.52542e-17
C918	A#18	VNB	3.54039e-17
C919	Z	A#9	9.93422e-20
C920	a_27_74##12	TE#18	1.50665e-19
C921	A#20	VNB	3.19109e-17
C922	A#22	VNB	3.57978e-17
C923	A#24	VNB	3.19193e-17
C924	A#26	VNB	3.15827e-17
C925	VPWR#4	a_802_323##11	2.93116e-19
C926	a_27_74##13	TE#17	1.21582e-17
C927	VGND	VGND#7	2.13916e-16
C928	A#27	VNB	4.67247e-17
C929	a_27_368##4	VPWR#5	1.31203e-19
C930	a_27_368##11	VPWR#3	7.19941e-18
C931	a_27_368##5	VPWR#11	5.97267e-17
C932	VPWR#2	VNB	1.72243e-16
C933	TE#8	a_802_323##7	8.21958e-18
C934	VGND#2	VNB	1.66582e-16
C935	VGND	A#9	8.05846e-19
C936	VPWR#7	VNB	1.26954e-16
C937	VGND#7	VNB	1.32083e-16
C938	TE#2	VNB	7.24721e-17
C939	a_802_323#	VNB	9.9288e-17
C940	A	Z	1.6238e-17
C941	A#9	VNB	3.3752e-17
C942	VPWR#4	a_802_323##5	2.21669e-20
C943	VPWR	A	1.69467e-17
C944	VPWR#3	a_802_323##11	5.84e-18
C945	VPWR	Z	3.19634e-18
C946	VGND#10	TE#18	2.22015e-18
C947	VGND	A	1.972e-17
C948	TE	VNB	1.6903e-17
C949	VGND	Z	1.304e-18
C950	A	VNB	4.1491e-17
C951	Z	VNB	5.26878e-18
C952	VGND#11	TE#17	7.30871e-19
C953	A#12	A#11	4.74226e-18
C954	VPWR	VNB	3.06453e-16
C955	VGND	VNB	3.047e-16
*
*
.ENDS sky130_fd_sc_hs__einvp_8
*
