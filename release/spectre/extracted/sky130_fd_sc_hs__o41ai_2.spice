* Extracted by Quantus, converted by sky130cad/quantus.py
*
*
*
*                       LINUX           Wed Nov 18 09:04:52 2026
*
*
*
*  PROGRAM  advgen
*
*  Name           : advgen - Quantus - (64-bit)
*  Version        : 25.1.0-p047
*  Build Date     : Thu Dec 11 23:20:30 PST 2025
*
*  HSPICE LIBRARY
*
*  OPERATING_TEMPERATURE 150
*  QRC_TECH_DIR <path>/tech
*
*
*

*
.SUBCKT sky130_fd_sc_hs__o41ai_2 VNB VPB VGND VPWR Y B1 A4 A3 A2 A1
*
*
*  caps2d version: 10
*
*
*       TRANSISTOR CARDS
*
*
XM2 a_132_74##7 B1#6 Y#3 VNB sky130_fd_pr__nfet_01v8_lvt l=0.15 w=0.74 ad=0.2109 as=0.2072 pd=2.05 ps=2.04
XM8 Y#3 B1#1 a_132_74##5 VNB sky130_fd_pr__nfet_01v8_lvt l=0.15 w=0.74 ad=0.2072 as=0.259 pd=2.04 ps=2.18
XM16 VGND#10 A4#6 a_132_74##5 VNB sky130_fd_pr__nfet_01v8_lvt l=0.15 w=0.74 ad=0.259 as=0.259 pd=2.18 ps=2.18
XM3 a_132_74##10 A4#1 VGND#10 VNB sky130_fd_pr__nfet_01v8_lvt l=0.15 w=0.74 ad=0.2553 as=0.259 pd=2.17 ps=2.18
XM15 a_132_74##10 A3#4 VGND#9 VNB sky130_fd_pr__nfet_01v8_lvt l=0.15 w=0.74 ad=0.2553 as=0.2109 pd=2.17 ps=2.05
XM17 VGND#9 A3#5 a_132_74##9 VNB sky130_fd_pr__nfet_01v8_lvt l=0.15 w=0.74 ad=0.2109 as=0.2294 pd=2.05 ps=2.1
XM9 a_132_74##9 A2#4 VGND#8 VNB sky130_fd_pr__nfet_01v8_lvt l=0.15 w=0.74 ad=0.2294 as=0.3108 pd=2.1 ps=2.32
XM11 VGND#8 A2#5 a_132_74##8 VNB sky130_fd_pr__nfet_01v8_lvt l=0.15 w=0.74 ad=0.3108 as=0.2072 pd=2.32 ps=2.04
XM1 VGND#7 A1#4 a_132_74##8 VNB sky130_fd_pr__nfet_01v8_lvt l=0.15 w=0.74 ad=0.259 as=0.2072 pd=2.18 ps=2.04
XM18 a_132_74# A1#5 VGND#7 VNB sky130_fd_pr__nfet_01v8_lvt l=0.15 w=0.74 ad=0.2627 as=0.259 pd=2.19 ps=2.18
XM0 Y#2 B1#8 VPWR#5 VPB sky130_fd_pr__pfet_01v8 l=0.15 w=1.12 ad=0.336 as=0.3192 pd=2.84 ps=2.81
XM7 VPWR#7 B1#7 Y#2 VPB sky130_fd_pr__pfet_01v8 l=0.15 w=1.12 ad=0.3136 as=0.336 pd=2.8 ps=2.84
XM4 a_314_368##4 A4#4 Y#1 VPB sky130_fd_pr__pfet_01v8 l=0.15 w=1.12 ad=0.3136 as=0.336 pd=2.8 ps=2.84
XM12 Y#1 A4#5 a_314_368##2 VPB sky130_fd_pr__pfet_01v8 l=0.15 w=1.12 ad=0.336 as=0.4872 pd=2.84 ps=3.11
XM13 a_607_368##2 A3#6 a_314_368##2 VPB sky130_fd_pr__pfet_01v8 l=0.15 w=1.12 ad=0.336 as=0.4872 pd=2.84 ps=3.11
XM5 a_314_368# A3#1 a_607_368##2 VPB sky130_fd_pr__pfet_01v8 l=0.15 w=1.12 ad=0.3136 as=0.336 pd=2.8 ps=2.84
XM6 a_607_368# A2#6 a_807_368##3 VPB sky130_fd_pr__pfet_01v8 l=0.15 w=1.12 ad=0.336 as=0.3192 pd=2.84 ps=2.81
XM14 a_807_368##4 A2#1 a_607_368# VPB sky130_fd_pr__pfet_01v8 l=0.15 w=1.12 ad=0.336 as=0.336 pd=2.84 ps=2.84
XM19 VPWR#6 A1#6 a_807_368##4 VPB sky130_fd_pr__pfet_01v8 l=0.15 w=1.12 ad=0.336 as=0.336 pd=2.84 ps=2.84
XM10 a_807_368# A1#1 VPWR#6 VPB sky130_fd_pr__pfet_01v8 l=0.15 w=1.12 ad=0.3192 as=0.336 pd=2.81 ps=2.84
*
*
*       RESISTOR AND CAP/DIODE CARDS
*
Rg1	B1#1	B1#2	543.492310
Rg2	B1#2	B1#3	39.461365
Rg3	B1#3	B1#4	41.475883
Rg4	B1#4	B1#5	53.472427
Rg5	B1#2	B1#6	338.411591
Rg6	B1#2	B1#7	510.140869
Rg7	B1#4	B1#8	458.070160
Rg8	A4#1	A4#2	388.639923
Rg9	A4#2	A4#3	96.836349
Rg10	A4#3	A4#4	467.115509
Rg11	A4#2	A4#5	430.350372
Rg12	A4#3	A4#6	391.322327
Rg13	A3#1	A3#2	449.514771
Rg14	A3#2	A3#3	39.329731
Rg15	A3#3	A3#4	397.555725
Rg16	A3#2	A3#5	388.136108
Rg17	A3#3	A3#6	449.655212
Rg18	A2#1	A2#2	613.414185
Rg19	A2#2	A2#3	49.018646
Rg20	A2#3	A2#4	428.396027
Rg21	A2#2	A2#5	400.759766
Rg22	A2#2	A2#6	432.872406
Rg23	A1#1	A1#2	435.677338
Rg24	A1#2	A1#3	44.579723
Rg25	A1#3	A1#4	507.521912
Rg26	A1#3	A1#5	319.069031
Rg27	A1#3	A1#6	468.059753
Rf1	B1#3	B1	160.762283
Rf2	B1	B1#5	53.676292
Rf3	Y#1	Y	53.926453
Rf4	Y	Y#2	77.575386
Rf5	Y	Y#3	48.752224
Rf6	A4#2	A4#8	162.448425
Rf7	A4#9	A4	2.215620
Rf8	A4#8	A4#9	5.583287
Rf9	A3#7	A3	2.193861
Rf10	A3#2	A3#9	162.426666
Rf11	A3#7	A3#9	5.195247
Rf12	a_314_368#	a_314_368##3	98.617226
Rf13	a_314_368##3	a_314_368##4	98.892487
Rf14	a_314_368##2	a_314_368##3	5.000000
Rf15	a_607_368#	a_607_368##2	156.733475
Rf16	A2#3	A2	116.493881
Rf17	a_132_74#	a_132_74##2	87.519394
Rf18	a_132_74##2	a_132_74##3	71.208916
Rf19	a_132_74##3	a_132_74##4	69.074753
Rf20	a_132_74##4	a_132_74##6	78.325729
Rf21	a_132_74##6	a_132_74##7	98.915329
Rf22	a_132_74##2	a_132_74##8	18.149860
Rf23	a_132_74##3	a_132_74##9	19.942978
Rf24	a_132_74##4	a_132_74##10	21.341251
Rf25	a_132_74##5	a_132_74##6	7.500000
Rf26	A1#7	A1	1.310145
Rf27	A1#2	A1#9	81.426544
Rf28	A1#7	A1#9	5.042445
Rf29	A1#10	A1	1.310145
Rf30	A1#9	A1#10	9.626486
Rf31	a_807_368#	a_807_368##2	80.666893
Rf32	a_807_368##2	a_807_368##3	76.816536
Rf33	a_807_368##2	a_807_368##4	18.602406
Rf35	VPWR#2	VPWR#3	175.419235
Rf36	VPWR#3	VPWR#4	142.423935
Rf37	VPWR#4	VPWR#5	101.810982
Rf38	VPWR#2	VPWR#6	53.143215
Rf39	VPWR#4	VPWR#7	36.061966
Rf41	VGND#2	VGND#3	73.001427
Rf42	VGND#3	VGND#4	74.925278
Rf43	VGND#4	VGND#5	65.501762
Rf45	VGND#2	VGND#7	36.475861
Rf46	VGND#3	VGND#8	36.475861
Rf47	VGND#4	VGND#9	39.973763
Rf48	VGND#5	VGND#10	36.475861
Re1	VPWR#3	VPWR	0.755546
Re2	VGND	VGND#4	0.755573
*
*       CAPACITOR CARDS
*
*
C1	VGND#10	VGND#9	2.13369e-18
C2	VGND#3	A3#5	3.89344e-19
C3	VGND#10	a_132_74##10	3.87107e-17
C4	a_807_368##2	A1#4	4.08041e-19
C5	VPWR#5	B1#4	1.06895e-17
C6	a_132_74##5	a_132_74##10	2.9944e-18
C7	VGND#7	A1#3	2.22113e-18
C8	a_132_74##5	VGND#10	5.73477e-17
C9	A4#9	a_314_368##2	3.05039e-17
C10	A1#2	A1#3	1.2297e-17
C11	Y#1	A4#9	2.51128e-17
C12	a_132_74##5	Y#3	6.58832e-17
C13	VGND#3	a_132_74##3	2.25448e-19
C14	Y#1	A4#8	5.3014e-18
C15	a_132_74##7	a_132_74##5	3.65274e-18
C16	A2#3	A1#3	1.53148e-18
C17	VGND#3	a_132_74##2	2.25448e-19
C18	a_132_74##7	Y#3	4.35821e-17
C19	A3#3	A2#3	3.01682e-17
C20	a_132_74##2	A1#4	1.92184e-17
C21	VPWR#4	A4#3	2.72937e-20
C22	a_132_74##3	A2#5	1.67888e-19
C23	a_132_74##4	A2#4	4.2209e-20
C24	a_132_74##2	A2#5	1.96737e-17
C25	VPWR#4	B1#4	8.6079e-20
C26	a_132_74##3	A2#4	1.96881e-17
C27	VPWR#4	B1#1	4.29693e-19
C28	a_132_74##4	A3#5	9.97475e-20
C29	a_132_74##3	A3#5	1.69859e-17
C30	a_807_368#	VPWR#6	5.25446e-17
C31	a_132_74##4	A3#4	2.16131e-17
C32	A3#3	A2#4	1.15522e-18
C33	a_807_368##2	A1#3	2.78476e-18
C34	a_807_368##4	a_807_368#	2.36849e-18
C35	a_132_74##3	A3#4	6.93506e-20
C36	a_132_74##4	A4#1	1.95415e-17
C37	A4#2	A3#3	3.39091e-17
C38	a_807_368##4	VPWR#6	5.20507e-17
C39	A4#3	A4#2	4.97571e-18
C40	a_132_74##3	A4#1	3.05004e-20
C41	a_607_368#	VPWR#6	2.50627e-18
C42	a_132_74##4	A4#6	9.3195e-20
C43	a_132_74#	A1#5	2.60402e-17
C44	a_607_368#	a_807_368##4	5.31008e-17
C45	VGND#7	A1#5	3.35732e-17
C46	a_132_74##5	Y#1	1.42505e-17
C47	a_132_74#	A1#4	1.17784e-18
C48	a_807_368##3	a_807_368##4	2.36849e-18
C49	a_132_74##8	A1#5	2.27955e-18
C50	a_807_368##2	A1#1	1.94029e-19
C51	VGND#9	A3#3	1.03712e-18
C52	a_132_74##2	a_807_368##2	5.75813e-19
C53	A1#4	VGND#7	1.79404e-17
C54	VGND#8	A1#5	2.27865e-19
C55	a_607_368#	a_807_368##3	8.07321e-17
C56	a_132_74##8	A1#4	3.83729e-17
C57	VGND#7	A2#5	6.09306e-19
C58	a_807_368##2	A1#6	2.24371e-17
C59	VGND#8	A1#4	3.38496e-19
C60	a_132_74##8	A2#5	3.35415e-17
C61	a_314_368#	a_807_368##3	6.66214e-17
C62	a_607_368##2	a_607_368#	1.13059e-18
C63	VGND#7	A2#4	1.55893e-19
C64	A2#5	VGND#8	2.08093e-17
C65	a_807_368##2	A2#1	2.34782e-17
C66	B1#5	B1#4	4.89075e-17
C67	a_132_74##8	A2#4	8.65003e-19
C68	a_132_74##9	A2#5	6.92872e-19
C69	A2#4	VGND#8	2.35333e-17
C70	a_132_74##7	Y#2	3.59978e-19
C71	a_314_368#	a_607_368##2	9.29761e-17
C72	VGND#9	A2#5	1.65123e-19
C73	a_807_368##2	A2#6	1.59203e-19
C74	a_132_74##9	A2#4	3.83897e-17
C75	VGND#8	A3#5	3.16862e-19
C76	a_314_368##2	a_314_368#	2.4852e-18
C77	VGND#9	A2#4	1.20429e-18
C78	A4#8	B1#1	7.9752e-19
C79	A3#5	a_132_74##9	1.25833e-17
C80	a_314_368##2	a_607_368##2	5.18889e-17
C81	a_132_74##10	A2#4	2.29805e-19
C82	VGND#9	A3#5	3.24796e-17
C83	a_132_74##4	a_132_74##3	3.77449e-19
C84	a_132_74##9	A3#4	5.5914e-19
C85	VGND#10	A4#3	3.46109e-19
C86	a_132_74##10	A3#5	5.43069e-19
C87	a_132_74##2	A2#1	9.49326e-19
C88	VGND#9	A3#4	2.80203e-17
C89	a_314_368##2	Y#1	6.01775e-17
C90	a_132_74##9	A4#1	2.45909e-19
C91	A3#4	a_132_74##10	1.66792e-17
C92	VGND#9	A4#1	1.07258e-18
C93	a_314_368##4	a_314_368##2	3.01982e-18
C94	VGND#10	A3#4	1.11369e-18
C95	VPWR#4	A4#4	4.44973e-18
C96	Y#3	A3#5	8.78255e-20
C97	A4#1	a_132_74##10	2.03034e-17
C98	a_314_368##4	Y#1	8.37485e-17
C99	a_132_74##5	A3#4	2.88515e-19
C100	a_132_74##5	A4#3	1.37874e-18
C101	VGND#10	A4#1	3.6627e-17
C102	Y#3	A3#4	1.22655e-19
C103	a_132_74##10	A4#6	4.85804e-19
C104	VPWR#4	B1#7	1.84324e-18
C105	a_132_74##5	A4#1	1.63002e-18
C106	B1#1	A4#3	1.33432e-17
C107	a_132_74##5	B1#4	5.08552e-19
C108	A4#6	VGND#10	1.65363e-17
C109	VPWR#7	a_314_368##4	8.2219e-17
C110	Y#2	Y#1	1.13865e-18
C111	Y#3	A4#1	2.32746e-19
C112	VGND#3	a_132_74##8	8.48245e-18
C113	a_132_74##5	A4#6	6.20366e-17
C114	Y#3	A3#3	1.3418e-19
C115	A3#9	A3#1	1.89119e-18
C116	Y#3	A4#6	1.24977e-18
C117	a_132_74##5	B1#1	3.01002e-17
C118	Y#3	A4#3	2.6837e-19
C119	Y#2	VPWR#7	6.84668e-17
C120	a_132_74##7	A4#6	2.81934e-19
C121	Y#3	B1#1	3.31846e-17
C122	VPWR#5	VPWR#7	2.06271e-18
C123	a_132_74##5	B1#6	6.89861e-19
C124	Y#3	B1#4	5.8621e-18
C125	a_132_74##7	B1#1	6.45358e-19
C126	B1#4	B1#6	3.08093e-17
C127	Y#3	B1#6	2.81878e-17
C128	VPWR#5	Y#2	8.6354e-17
C129	A4#9	A3#6	1.27494e-18
C130	VGND#3	a_132_74##9	7.45739e-18
C131	a_132_74##7	B1#6	4.54012e-17
C132	a_132_74##3	A3#9	2.71564e-17
C133	VGND#4	VGND#3	4.06122e-17
C134	VPWR#3	VPWR#4	6.40577e-17
C135	A1#3	a_807_368#	4.05886e-18
C136	A4#9	A4#5	1.31538e-18
C137	a_132_74##4	A3#3	1.61283e-18
C138	a_132_74#	a_807_368##2	3.52593e-18
C139	B1#4	a_132_74##7	2.37283e-17
C140	A4#9	A4#4	1.95933e-19
C141	A1#4	A1#5	2.37466e-17
C142	a_807_368#	A1#1	5.55283e-17
C143	A1#1	VPWR#6	2.70995e-17
C144	VGND#3	A2#3	2.22417e-20
C145	A1#3	VPWR#6	1.89184e-18
C146	a_807_368#	A1#6	2.12167e-18
C147	a_807_368##4	A1#1	1.99344e-18
C148	A2#5	A1#4	4.01388e-17
C149	A1#6	VPWR#6	2.89893e-17
C150	a_132_74##3	A3#3	1.05214e-18
C151	a_132_74##4	A4#8	4.55642e-17
C152	a_607_368#	A1#1	3.46259e-19
C153	a_132_74##2	A1#3	3.50346e-18
C154	A1#2	a_807_368##2	5.65189e-19
C155	a_807_368##4	A1#6	5.23881e-17
C156	A1	A1#3	3.30504e-17
C157	a_807_368##3	A1#1	5.23879e-19
C158	VPWR#6	A2#1	6.54315e-19
C159	VGND#4	a_132_74##4	2.25448e-19
C160	a_607_368#	A1#6	6.21657e-19
C161	A2#4	A2#5	2.15208e-17
C162	VGND#4	a_132_74##3	2.91756e-19
C163	a_807_368##4	A2#1	4.59447e-17
C164	a_807_368##3	A1#6	6.1977e-19
C165	A2#3	a_807_368##2	4.20784e-18
C166	VPWR#7	B1#1	7.70318e-19
C167	VPWR#6	A2#6	2.50453e-19
C168	A2#1	a_607_368#	2.63019e-17
C169	a_807_368##4	A2#6	1.86078e-18
C170	a_807_368##3	A2#1	2.44775e-18
C171	A3#5	A2#4	3.44205e-17
C172	a_607_368#	A2#6	4.45444e-17
C173	A2	A1#3	1.47499e-17
C174	a_807_368##3	A2#6	7.96387e-17
C175	a_607_368##2	A2#1	1.06116e-19
C176	VPWR#4	A4#2	1.23731e-20
C177	a_607_368#	A3#1	3.22462e-19
C178	a_314_368#	A2#6	1.42027e-18
C179	a_132_74##3	A2#3	3.95197e-17
C180	A3#4	A3#5	3.88381e-17
C181	A2#1	A1#3	9.6042e-18
C182	a_807_368##3	A3#1	3.88422e-18
C183	a_132_74##2	A2#3	4.93159e-17
C184	a_607_368##2	A2#6	3.49356e-19
C185	a_607_368#	A3#6	9.14396e-20
C186	a_314_368#	A3#1	6.88793e-17
C187	a_807_368##3	A3#6	7.9581e-19
C188	a_607_368##2	A3#1	3.88086e-17
C189	A4#1	A3#4	2.96965e-17
C190	Y#1	A2#6	6.10293e-19
C191	a_314_368#	A3#6	1.40843e-18
C192	A3#9	A2#3	2.46616e-17
C193	a_314_368##2	A3#1	3.68196e-19
C194	a_807_368##3	A4#5	4.70255e-19
C195	a_607_368##2	A3#6	4.62281e-17
C196	Y#1	A3#1	5.61083e-19
C197	a_132_74##4	A4#2	7.65492e-18
C198	A3	A3#3	1.20679e-17
C199	a_314_368#	A4#5	2.18874e-19
C200	a_314_368##2	A3#6	4.41886e-17
C201	A4#6	A4#1	2.50036e-17
C202	a_132_74#	A1#2	2.4448e-17
C203	a_807_368##3	A4#4	5.23814e-19
C204	a_607_368##2	A4#5	1.27501e-18
C205	Y#1	A3#6	9.99033e-19
C206	VPWR#7	A3#1	4.57084e-20
C207	VGND#4	a_132_74##9	7.71869e-18
C208	a_314_368##2	A4#5	7.81276e-17
C209	a_132_74##2	VGND#7	1.81423e-17
C210	A1#4	A2#1	1.11025e-17
C211	B1#1	A4#6	2.88745e-17
C212	A4#5	Y#1	2.51242e-17
C213	a_132_74##3	a_132_74##8	8.0587e-19
C214	VGND#4	a_132_74##10	7.42229e-18
C215	VPWR#7	A3#6	6.57727e-20
C216	a_314_368##2	A4#4	1.92843e-18
C217	a_314_368##4	A4#5	1.61928e-18
C218	Y#1	A4#4	3.28806e-17
C219	A4#9	A4#2	5.48622e-18
C220	VPWR#7	A4#5	1.99309e-19
C221	a_132_74##2	a_132_74##8	9.59055e-20
C222	VGND#8	A2#3	2.14236e-18
C223	B1#6	B1#1	3.71386e-17
C224	a_314_368##4	A4#4	8.40713e-17
C225	a_132_74##3	VGND#8	1.40872e-17
C226	Y#2	A4#5	9.16612e-20
C227	A4#8	A4#2	1.39646e-17
C228	a_132_74##4	a_132_74##9	1.53339e-19
C229	Y#1	B1#7	3.55843e-19
C230	VPWR#7	A4#4	2.68894e-18
C231	a_314_368##4	B1#7	1.77291e-18
C232	a_607_368#	VPWR#3	3.03573e-17
C233	Y#2	A4#4	3.23266e-19
C234	a_132_74##2	VGND#8	1.33415e-17
C235	Y#1	B1#8	2.30443e-19
C236	VPWR#7	B1#7	6.81985e-17
C237	a_132_74##3	a_132_74##9	5.92182e-19
C238	A1#2	a_807_368#	1.62035e-17
C239	a_132_74##4	VGND#9	1.26789e-17
C240	Y#2	B1#7	5.68395e-17
C241	VPWR#7	B1#8	3.1126e-18
C242	a_607_368##2	VPWR#3	6.85428e-17
C243	VPWR#5	B1#7	3.81132e-18
C244	a_314_368##2	VPWR#3	4.12275e-17
C245	Y#2	B1#8	2.36945e-17
C246	a_132_74##3	VGND#9	1.19888e-17
C247	VPWR#5	B1#8	5.46624e-17
C248	a_132_74##4	a_132_74##10	1.54619e-18
C249	B1	A4#3	8.77692e-19
C250	B1	B1#4	4.80876e-17
C251	a_314_368##4	VPWR#3	7.45826e-18
C252	a_314_368#	A3#3	2.29388e-18
C253	VGND#10	A4#2	8.47337e-19
C254	A1#6	A1#1	4.73439e-17
C255	a_132_74##5	A4#2	7.59224e-19
C256	A2#3	a_607_368#	3.16944e-18
C257	Y#3	A4#2	1.49623e-19
C258	A2#3	a_807_368##3	6.49605e-17
C259	a_807_368##2	a_807_368#	6.21728e-19
C260	A2#3	a_314_368#	9.66729e-18
C261	a_132_74##4	VGND#10	1.58589e-17
C262	VPWR#3	VPWR#5	2.7231e-17
C263	A2#1	A1#6	4.58574e-17
C264	A2#3	a_607_368##2	3.72422e-18
C265	A3#9	A3#3	1.32485e-17
C266	a_807_368##2	VPWR#6	1.63705e-17
C267	B1#4	A4#3	1.94267e-18
C268	A2#6	A2#1	4.91162e-17
C269	a_132_74##5	a_132_74##4	5.74436e-19
C270	Y	A3#3	1.12882e-19
C271	Y	A4#3	1.07462e-17
C272	B1#5	Y#3	3.90186e-18
C273	Y	B1#4	1.07225e-17
C274	A3#3	a_607_368##2	1.74606e-18
C275	B1#5	a_132_74##7	5.9269e-17
C276	VGND#4	A2#5	1.46223e-19
C277	A3#1	A2#6	5.29205e-18
C278	VGND#4	A2#4	5.215e-19
C279	A4#2	a_314_368##2	3.98449e-18
C280	A1	a_807_368##2	2.74609e-17
C281	a_807_368##2	a_807_368##4	1.70491e-18
C282	Y#1	A4#2	5.48808e-18
C283	VGND#4	A3#5	4.86956e-18
C284	a_314_368##4	A4#2	7.49974e-20
C285	A4#5	A3#3	7.05952e-19
C286	A2#3	A1#4	7.65037e-18
C287	VGND#4	A3#4	4.47765e-18
C288	A3#6	A3#1	4.43699e-17
C289	VGND#4	A4#1	4.75455e-19
C290	A2#4	A2#3	8.63037e-19
C291	A2	a_807_368##2	4.27224e-17
C292	a_807_368##2	a_607_368#	9.74737e-18
C293	A4#5	A3#6	2.629e-17
C294	A4#4	A4#5	4.8069e-17
C295	a_132_74##2	A2	3.89546e-17
C296	a_807_368##3	a_807_368##2	6.21728e-19
C297	A3#9	A2	3.46701e-19
C298	a_132_74#	A1	2.86163e-17
C299	A1#2	A1#1	3.2639e-18
C300	B1#7	A4#4	5.23515e-18
C301	A4#9	A3#3	1.79903e-18
C302	a_132_74##4	A3	2.05955e-17
C303	VPWR#3	A3#1	4.464e-18
C304	a_132_74##3	A3	2.84916e-18
C305	a_132_74#	VGND#7	4.95804e-17
C306	VPWR#3	A3#6	7.38377e-18
C307	VGND	A1#3	5.17379e-18
C308	B1#8	B1#7	5.01572e-17
C309	VPWR#3	A4#5	4.44973e-18
C310	A2#3	A2#1	1.47802e-20
C311	VGND	B1#4	9.1963e-18
C312	A4#9	A4#3	9.38656e-20
C313	A4#9	A3	1.16952e-17
C314	a_132_74##8	a_132_74#	4.13674e-18
C315	A4#8	A3	1.49286e-17
C316	A1	a_807_368#	2.62183e-17
C317	B1	VPWR#4	1.36897e-19
C318	B1#5	B1#6	2.19669e-18
C319	Y#1	A4#3	1.02772e-17
C320	a_132_74##8	VGND#7	4.1409e-17
C321	B1#7	A4#3	2.48625e-19
C322	Y	VPWR#4	8.10146e-19
C323	VGND#8	VGND#7	1.87827e-18
C324	VPWR#3	A2#3	1.47125e-19
C325	a_314_368##4	VPWR#4	4.71479e-17
C326	A3	a_314_368#	1.28254e-17
C327	A3	a_314_368##2	1.0021e-17
C328	VPWR	VPWR#4	3.51046e-17
C329	VGND#8	a_132_74##8	4.14352e-17
C330	VPWR#3	A4#2	4.53696e-20
C331	a_314_368##4	A4#3	7.60108e-20
C332	A2	A1#4	6.36817e-18
C333	VPWR	a_807_368##2	3.60989e-18
C334	Y	A4#8	3.57517e-18
C335	B1	Y#3	9.17367e-18
C336	a_132_74##7	B1	2.55825e-17
C337	A4#8	A3#3	5.2907e-18
C338	a_132_74##9	a_132_74##8	3.32581e-18
C339	VPWR	A3#9	1.51848e-18
C340	VGND	VGND#3	4.33512e-17
C341	VPWR	A4#9	2.19934e-18
C342	A1	A1#6	1.4573e-18
C343	a_132_74##5	Y	1.53777e-17
C344	A1	A2#1	1.14573e-18
C345	a_132_74##7	Y	6.21661e-19
C346	A1#3	VNB	1.13976e-16
C347	A3#3	VNB	5.02962e-17
C348	A4#3	VNB	2.59342e-17
C349	B1#4	VNB	1.93811e-16
C350	A2	A1#6	1.28833e-18
C351	B1	Y#2	2.89603e-17
C352	VGND	a_132_74##4	3.33222e-18
C353	A2	A2#1	1.07437e-17
C354	B1	VPWR#5	3.23603e-17
C355	a_132_74##3	a_314_368#	9.09397e-18
C356	VGND	a_132_74##3	2.70349e-18
C357	VGND	a_132_74##2	2.98372e-18
C358	a_132_74##9	VGND#8	4.09953e-17
C359	VGND#3	A1#5	2.01144e-19
C360	Y#2	VPWR#4	1.07332e-17
C361	VGND	A3#9	1.5769e-18
C362	Y	a_314_368##4	3.73562e-17
C363	VPWR	a_807_368#	1.76196e-17
C364	Y	VPWR#7	4.54724e-17
C365	VGND	A4#8	2.76573e-18
C366	VPWR	a_807_368##4	1.58676e-17
C367	VGND	a_132_74#	1.72052e-17
C368	VPWR	a_607_368#	2.58005e-17
C369	VPWR	a_807_368##3	8.99664e-18
C370	VGND	a_132_74##8	1.57545e-17
C371	VPWR	a_314_368#	9.67196e-18
C372	A3	A3#6	1.57074e-18
C373	VPWR	a_607_368##2	2.80832e-17
C374	VGND	a_132_74##9	1.49343e-17
C375	A3	A4#5	1.75176e-19
C376	VPWR	a_314_368##2	2.16189e-17
C377	A4#8	B1#4	2.20399e-19
C378	VGND	a_132_74##10	1.39474e-17
C379	VGND#9	VGND#8	2.01781e-18
C380	VPWR	Y#1	6.65614e-18
C381	VPWR	a_314_368##4	2.58296e-17
C382	VGND	a_132_74##5	2.45437e-17
C383	VPWR	VPWR#7	2.21656e-17
C384	VGND	Y#3	8.37452e-18
C385	VGND	a_132_74##7	2.02979e-17
C386	VPWR	Y#2	1.20566e-17
C387	VPWR	VPWR#5	3.92358e-17
C388	VPWR#7	B1#4	7.57305e-19
C389	Y	B1#1	1.10469e-17
C390	VPWR#5	VPWR#4	1.22166e-18
C391	VGND#3	A1#4	4.19101e-19
C392	a_132_74##4	a_314_368##2	5.16253e-18
C393	VGND	Y#1	2.77045e-18
C394	VGND#3	VNB	3.16417e-17
C395	VGND	Y#2	1.31293e-18
C396	VGND#9	a_132_74##9	3.89514e-17
C397	VGND	VPWR#5	4.59035e-18
C398	VPWR#4	VNB	5.00729e-17
C399	VGND	A1#5	1.44875e-18
C400	VGND	A1#4	2.35585e-19
C401	VGND	A2#5	1.6027e-19
C402	VPWR	A1#1	1.05294e-18
C403	VGND	A2#4	2.20911e-19
C404	A3	A4#2	2.78916e-18
C405	VPWR	A1#6	1.00085e-18
C406	VGND	A3#5	7.23232e-19
C407	Y	A4#4	3.58777e-18
C408	a_132_74##4	VNB	4.4006e-18
C409	VPWR	A2#1	4.84274e-19
C410	a_132_74##3	VNB	5.6498e-18
C411	VGND	A3#4	4.56639e-19
C412	a_132_74##2	VNB	2.49666e-18
C413	Y	B1#7	7.81361e-18
C414	VGND	A4#1	7.35061e-19
C415	VPWR	A2#6	2.45751e-18
C416	VGND	A4#6	2.30126e-19
C417	VPWR	A3#1	1.67854e-18
C418	A3#9	VNB	1.40542e-18
C419	VGND	B1#1	1.51634e-18
C420	A4#9	VNB	1.35633e-18
C421	VPWR	A3#6	2.08282e-18
C422	VGND	B1#6	3.40465e-18
C423	A4#8	VNB	3.58399e-19
C424	VPWR	A4#5	1.52745e-18
C425	a_132_74#	VNB	4.36389e-17
C426	VPWR	A4#4	1.9818e-18
C427	VGND#7	VNB	2.31205e-18
C428	a_132_74##8	VNB	1.96561e-18
C429	VPWR	B1#7	1.30425e-18
C430	VGND#8	VNB	2.67337e-18
C431	a_132_74##4	Y#1	3.91164e-18
C432	a_132_74##9	VNB	2.30936e-18
C433	VGND#9	VNB	4.21172e-20
C434	VPWR	B1#8	3.37116e-18
C435	a_132_74##10	VNB	4.95925e-18
C436	VGND#10	VNB	4.44753e-19
C437	VGND#3	A2#5	5.20407e-18
C438	a_132_74##10	a_132_74##9	2.88985e-18
C439	a_132_74##5	VNB	6.76105e-18
C440	Y#3	VNB	5.9345e-19
C441	a_132_74##7	VNB	6.57023e-18
C442	VPWR	VPWR#3	4.00823e-17
C443	a_807_368#	VNB	5.40844e-17
C444	VPWR#6	VNB	2.82484e-18
C445	a_807_368##4	VNB	2.15003e-18
C446	Y	A4#2	1.25873e-19
C447	a_607_368#	VNB	6.34059e-18
C448	a_807_368##3	VNB	8.41395e-18
C449	VPWR	A1#2	1.07602e-18
C450	A2	A1	3.58383e-17
C451	a_314_368#	VNB	8.01251e-18
C452	a_607_368##2	VNB	6.29228e-18
C453	VPWR	A2#3	5.78691e-18
C454	a_314_368##2	VNB	2.7924e-18
C455	Y#1	VNB	2.20862e-18
C456	a_314_368##4	VNB	1.63741e-17
C457	VPWR#7	VNB	1.15787e-17
C458	Y#2	VNB	7.12407e-18
C459	VPWR#5	VNB	8.15888e-17
C460	A1#5	VNB	2.5505e-17
C461	VGND	VGND#4	4.13945e-17
C462	A1#4	VNB	3.88893e-17
C463	A2#5	VNB	2.82827e-17
C464	VGND	A1#2	1.48408e-18
C465	A2#4	VNB	3.07732e-17
C466	A3#5	VNB	2.55146e-17
C467	VGND	A2#3	5.03571e-18
C468	A3#4	VNB	2.5229e-17
C469	A4#1	VNB	2.61284e-17
C470	A4#6	VNB	2.66069e-17
C471	VPWR#3	A3#3	2.95251e-20
C472	B1#1	VNB	4.47035e-17
C473	B1#6	VNB	2.88502e-17
C474	A1#1	VNB	4.12148e-17
C475	A1#6	VNB	3.32053e-17
C476	VGND	B1#5	1.68991e-17
C477	A2#1	VNB	4.23067e-17
C478	A2#6	VNB	3.39553e-17
C479	A3#1	VNB	3.70699e-17
C480	a_132_74##10	VGND#9	4.07674e-17
C481	A3#6	VNB	3.36689e-17
C482	A3#9	a_314_368#	1.97696e-17
C483	A4#5	VNB	3.50351e-17
C484	Y#2	B1#4	2.15257e-18
C485	A4#4	VNB	3.71208e-17
C486	VPWR	A1	3.64949e-18
C487	B1#7	VNB	3.35156e-17
C488	B1#8	VNB	4.68864e-17
C489	VPWR	A2	3.23301e-18
C490	VPWR#3	VNB	3.15483e-16
C491	VGND#4	VNB	2.79026e-16
C492	VPWR	A3	1.38209e-18
C493	A1#2	VNB	7.36545e-19
C494	VGND	A1	6.65047e-18
C495	A2#3	VNB	8.39863e-17
C496	B1	Y	3.02976e-17
C497	VGND	A2	2.49307e-18
C498	A4#2	VNB	3.82634e-17
C499	VGND	A3	1.45566e-18
C500	VPWR	B1	5.18329e-18
C501	B1#5	VNB	2.96634e-17
C502	VPWR	Y	5.7316e-18
C503	VGND#3	A2#4	5.16002e-18
C504	VGND	B1	3.43503e-18
C505	VGND	Y	2.80978e-18
C506	a_132_74#	A1#3	1.84604e-17
C507	A1	VNB	2.82758e-17
C508	A2	VNB	9.7429e-19
C509	A3	VNB	4.02792e-18
C510	B1	VNB	2.01974e-17
C511	Y	VNB	9.85733e-18
C512	VPWR	VNB	8.23685e-17
C513	VGND	VNB	7.57592e-17
C514	VGND#5	B1#6	4.59567e-18
C515	VPWR#3	VPWR#2	8.06157e-17
C516	VGND#4	VGND#2	6.87939e-17
C517	VPWR#2	A1#1	7.91242e-18
C518	VGND#2	A1#5	4.40572e-18
C519	a_807_368#	VPWR#2	2.12143e-17
C520	VGND#2	VNB	6.25097e-17
C521	VPWR#2	A2#1	6.14447e-18
C522	a_807_368##4	VPWR#2	1.66935e-17
C523	VGND#5	VNB	9.16773e-17
C524	VGND#2	A1	1.70835e-18
C525	VPWR#2	A3#1	8.73926e-20
C526	VGND#5	A4#6	4.6109e-18
C527	VGND	VGND#2	6.42003e-17
C528	VPWR	VPWR#2	6.26533e-17
C529	VGND#5	a_132_74##7	4.81366e-17
C530	VGND#4	VGND#5	1.1345e-16
C531	VGND#5	B1	3.96443e-19
C532	VGND#2	A2#4	1.32187e-19
C533	VGND	VGND#5	7.72952e-17
C534	VGND#3	VGND#2	1.35535e-18
C535	VGND#2	A1#2	2.52676e-19
C536	VGND#5	A3#4	7.52729e-19
C537	VGND#2	A1#4	5.18214e-18
C538	VGND#5	a_132_74##5	5.34916e-17
C539	VGND#5	B1#5	2.58756e-17
C540	VGND#2	a_132_74##8	8.43305e-18
C541	VGND#5	a_132_74##4	2.91756e-19
C542	VPWR#2	A1#6	5.0677e-18
C543	VGND#5	B1#1	4.94902e-18
C544	VPWR#2	A2#3	1.93446e-20
C545	VPWR#2	A1#4	2.36886e-20
C546	VPWR#2	A2#6	3.52582e-18
C547	a_607_368#	VPWR#2	2.92046e-17
C548	VGND#2	a_132_74#	2.17266e-17
C549	VGND#2	A2#1	2.40488e-20
C550	VGND#5	a_132_74##10	6.9777e-18
C551	VGND#5	A4#2	6.80091e-20
C552	VPWR#2	A1#3	8.78754e-20
C553	VGND#5	A4#1	4.90092e-18
C554	VGND#2	A1#3	1.61868e-18
C555	a_807_368##2	VPWR#2	7.70776e-19
C556	VPWR#2	VNB	6.93837e-17
C557	VGND#2	A2#3	1.43181e-20
C558	VGND#5	B1#4	9.58191e-18
C559	VGND#2	A2#5	7.55381e-19
C560	VGND#2	a_132_74##2	2.25448e-19
*
*
.ENDS sky130_fd_sc_hs__o41ai_2
*
