* Extracted by Quantus, converted by sky130cad/quantus.py
*
*
*
*                       LINUX           Wed Nov 18 09:02:41 2026
*
*
*
*  PROGRAM  advgen
*
*  Name           : advgen - Quantus - (64-bit)
*  Version        : 25.1.0-p047
*  Build Date     : Thu Dec 11 23:20:30 PST 2025
*
*  HSPICE LIBRARY
*
*  OPERATING_TEMPERATURE 150
*  QRC_TECH_DIR <path>/tech
*
*
*

*
.SUBCKT sky130_fd_sc_hs__o32a_1 VNB VPB VGND VPWR X B1 A1 A2 A3 B2
*
*
*  caps2d version: 10
*
*
*       TRANSISTOR CARDS
*
*
XM1 X#1 a_83_264# VGND#6 VNB sky130_fd_pr__nfet_01v8_lvt l=0.15 w=0.74 ad=0.2109 as=0.2938 pd=2.05 ps=2.32
XM8 VGND#6 A1#1 a_251_74##4 VNB sky130_fd_pr__nfet_01v8_lvt l=0.15 w=0.64 ad=0.2938 as=0.1792 pd=2.32 ps=1.84
XM7 a_251_74##4 A2#1 VGND#5 VNB sky130_fd_pr__nfet_01v8_lvt l=0.15 w=0.64 ad=0.1792 as=0.2688 pd=1.84 ps=2.12
XM4 VGND#5 A3#1 a_251_74##2 VNB sky130_fd_pr__nfet_01v8_lvt l=0.15 w=0.64 ad=0.2688 as=0.224 pd=2.12 ps=1.98
XM10 a_251_74##2 B2#1 a_83_264##7 VNB sky130_fd_pr__nfet_01v8_lvt l=0.15 w=0.64 ad=0.224 as=0.2848 pd=1.98 ps=2.17
XM11 a_83_264##7 B1#4 a_251_74# VNB sky130_fd_pr__nfet_01v8_lvt l=0.15 w=0.64 ad=0.2848 as=0.2144 pd=2.17 ps=1.95
XM0 X#2 a_83_264##3 VPWR#5 VPB sky130_fd_pr__pfet_01v8 l=0.15 w=1.12 ad=0.3304 as=0.5514 pd=2.83 ps=3.26
XM6 VPWR#5 A1#3 a_248_368# VPB sky130_fd_pr__pfet_01v8 l=0.15 w=1 ad=0.5514 as=0.27 pd=3.26 ps=2.54
XM3 a_248_368# A2#3 a_332_368# VPB sky130_fd_pr__pfet_01v8 l=0.15 w=1 ad=0.27 as=0.39 pd=2.54 ps=2.78
XM5 a_332_368# A3#3 a_83_264##4 VPB sky130_fd_pr__pfet_01v8 l=0.15 w=1 ad=0.39 as=0.39 pd=2.78 ps=2.78
XM2 a_83_264##4 B2#3 a_548_368# VPB sky130_fd_pr__pfet_01v8 l=0.15 w=1 ad=0.39 as=0.445 pd=2.78 ps=2.89
XM9 a_548_368# B1#3 VPWR#1 VPB sky130_fd_pr__pfet_01v8 l=0.15 w=1 ad=0.445 as=0.295 pd=2.89 ps=2.59
*
*
*       RESISTOR AND CAP/DIODE CARDS
*
Rg1	a_83_264#	a_83_264##2	365.323883
Rg2	a_83_264##2	a_83_264##3	447.963806
Rg3	A1#1	A1#2	423.651459
Rg4	A1#2	A1#3	408.386017
Rg5	A2#1	A2#2	411.232849
Rg6	A2#2	A2#3	400.207520
Rg7	A3#1	A3#2	411.232849
Rg8	A3#2	A3#3	400.207520
Rg9	B2#1	B2#2	411.232849
Rg10	B2#2	B2#3	400.207520
Rg11	B1#1	B1#2	203.643158
Rg12	B1#2	B1#3	490.044800
Rg13	B1#2	B1#4	328.692291
Rf1	X#1	X	10.162277
Rf2	X	X#2	96.363968
Rf3	A1#2	A1#5	161.455215
Rf4	A1#6	A1	1.222411
Rf5	A1#5	A1#6	5.435189
Rf6	A2	A2#2	166.137894
Rf7	A3#4	A3#2	160.844009
Rf8	A3	A3#6	0.611206
Rf9	A3#4	A3#6	5.905091
Rf10	B2#4	B2#2	161.760818
Rf11	B2	B2#6	1.528014
Rf12	B2#4	B2#6	5.435189
Rf13	a_83_264##4	a_83_264##5	13.575536
Rf14	a_83_264##5	a_83_264##2	313.705688
Rf15	a_83_264##5	a_83_264##7	140.211060
Rf16	a_251_74#	a_251_74##3	97.164131
Rf17	a_251_74##3	a_251_74##4	98.914589
Rf18	a_251_74##2	a_251_74##3	7.500000
Rf19	B1	B1#1	12.781700
Rf20	B1#1	B1	1.997141
Rf21	VPWR#1	VPWR#2	164.338791
Rf22	VPWR#2	VPWR#3	83.253036
Rf24	VPWR#3	VPWR#5	31.534731
Rf26	VGND#2	VGND#3	76.240181
Rf28	VGND#2	VGND#5	40.957939
Rf29	VGND#3	VGND#6	31.337896
Re1	VPWR#2	VPWR	1.227783
Re2	VGND	VGND#2	1.227829
*
*       CAPACITOR CARDS
*
*
C1	VGND	VNB	7.09232e-17
C2	VPWR	VNB	6.06619e-17
C3	X	VNB	6.85129e-17
C4	B1	VNB	2.97122e-17
C5	A2	VNB	1.87475e-18
C6	A3	VNB	2.22032e-18
C7	B2	VNB	2.11584e-18
C8	VGND	X	2.29415e-17
C9	a_83_264##2	VNB	4.27254e-17
C10	A1#2	VNB	2.98722e-17
C11	VGND	B1	5.46515e-18
C12	A2#2	VNB	3.12882e-17
C13	A3#2	VNB	3.09521e-17
C14	B2#2	VNB	3.4114e-17
C15	VPWR#2	VNB	2.32593e-16
C16	VPWR	B1	4.03727e-18
C17	a_83_264##3	VNB	4.10153e-17
C18	A1#3	VNB	3.38452e-17
C19	A2#3	VNB	2.84686e-17
C20	A3#3	VNB	3.10014e-17
C21	B2#3	VNB	2.81086e-17
C22	B1#3	VNB	3.60591e-17
C23	VPWR	A2	2.51368e-18
C24	a_83_264#	VNB	3.48015e-17
C25	A1#1	VNB	3.16639e-17
C26	A2#1	VNB	2.88026e-17
C27	A3#1	VNB	2.86445e-17
C28	VPWR	A3	2.51368e-18
C29	B2#1	VNB	3.18764e-17
C30	B1#4	VNB	3.20344e-17
C31	X#2	VNB	5.81226e-17
C32	VPWR#5	VNB	7.92442e-18
C33	VPWR	B2	2.67829e-18
C34	VPWR#1	VNB	8.00409e-17
C35	VGND#6	VNB	5.42696e-18
C36	a_251_74##4	VNB	8.62715e-18
C37	VGND#5	VNB	2.54757e-18
C38	a_251_74##2	VNB	9.19861e-18
C39	a_83_264##7	VNB	9.78053e-18
C40	VGND	a_83_264##2	4.19719e-18
C41	a_251_74#	VNB	3.16674e-17
C42	A1#5	VNB	1.68502e-18
C43	A1#6	VNB	1.83573e-18
C44	A3#4	VNB	9.77003e-19
C45	VGND	A2#2	2.59275e-18
C46	B2#4	VNB	1.53269e-18
C47	a_83_264##5	VNB	8.46405e-18
C48	VPWR	a_83_264##2	8.74038e-18
C49	A2	A3	1.30199e-17
C50	X	a_83_264##2	5.60611e-17
C51	A3	B2	1.64649e-17
C52	X	A1#2	6.49313e-20
C53	X	A2#2	9.64642e-20
C54	VPWR	VPWR#2	4.72468e-17
C55	VGND	a_83_264#	2.40129e-18
C56	X	A3#2	7.32857e-20
C57	VGND	A1#1	1.18773e-18
C58	VPWR	a_83_264##3	3.83665e-18
C59	VGND	A2#1	1.61522e-19
C60	VGND	A3#1	3.78087e-19
C61	VPWR	A1#3	9.00216e-18
C62	VGND	B2#1	1.04648e-18
C63	VPWR	A2#3	9.00216e-18
C64	VGND	B1#4	1.7723e-18
C65	VPWR	A3#3	7.25174e-18
C66	VGND	X#2	8.9408e-19
C67	VPWR	B2#3	7.25174e-18
C68	VPWR	B1#3	4.30258e-18
C69	VGND	VGND#6	1.97702e-17
C70	VGND	a_251_74##4	1.78676e-17
C71	A2	A1#2	1.68343e-18
C72	VGND	a_251_74##2	2.59814e-17
C73	A2	A2#2	6.87297e-18
C74	B1#2	VNB	6.35392e-17
C75	VGND	a_83_264##7	9.2181e-18
C76	VPWR	X#2	1.96328e-17
C77	VGND	a_251_74#	2.05036e-17
C78	VGND	A1#5	3.4804e-18
C79	VPWR	VPWR#5	2.24862e-17
C80	A2	A3#2	1.30299e-18
C81	X	a_83_264#	3.13182e-17
C82	X	A1#1	1.52204e-18
C83	VGND	A3#4	2.89831e-18
C84	A3	A2#2	1.4957e-18
C85	A3	A3#2	5.67105e-18
C86	VPWR	VPWR#1	4.22413e-17
C87	VGND	B2#4	2.86097e-18
C88	B1	B1#3	3.85671e-18
C89	A3	B2#2	7.88097e-19
C90	X	X#2	3.95354e-18
C91	B2	A3#2	1.69074e-18
C92	B2	B2#2	5.08932e-18
C93	A2	A1#3	4.83925e-19
C94	VGND#6	a_251_74##4	6.16769e-17
C95	VPWR	A1#6	2.67829e-18
C96	a_83_264##2	a_248_368#	1.74549e-18
C97	A2	A2#3	2.03921e-18
C98	X	X#1	3.2808e-18
C99	A2	A3#3	8.02098e-19
C100	X	VGND#6	6.24119e-17
C101	X	a_251_74##4	3.81422e-18
C102	VPWR	a_83_264##5	3.84515e-17
C103	A3	A2#3	3.88406e-19
C104	A3	A3#3	2.05847e-18
C105	VGND#6	VGND#5	1.56522e-18
C106	A2#2	a_332_368#	5.29945e-19
C107	B1	VPWR#1	3.02638e-17
C108	A3	B2#3	5.64345e-19
C109	B2	A3#3	3.8431e-19
C110	B2	B2#3	2.04462e-18
C111	a_251_74#	VPWR#1	9.95455e-21
C112	a_83_264##2	A1#2	3.64834e-17
C113	a_83_264##7	B1	4.93956e-17
C114	B2	B1#3	9.95607e-19
C115	B1	a_251_74#	3.47446e-17
C116	a_251_74##4	VGND#5	6.70891e-17
C117	B2#2	a_548_368#	2.92383e-19
C118	A1#2	A2#2	3.49329e-17
C119	A1#3	a_248_368#	2.38236e-17
C120	a_251_74##4	a_251_74##2	3.17342e-18
C121	A2#3	a_248_368#	2.38236e-17
C122	A2#2	A3#2	3.27926e-17
C123	A2#3	a_332_368#	2.85037e-17
C124	A3#3	a_332_368#	2.85037e-17
C125	VGND#5	a_251_74##2	5.54048e-17
C126	A3#2	B2#2	3.17658e-17
C127	A1#5	A2	3.35794e-18
C128	A1#6	A2	1.49696e-17
C129	a_83_264##2	a_83_264##3	6.99678e-18
C130	B2#3	a_548_368#	2.79519e-17
C131	VGND#6	A1#5	8.30902e-18
C132	A2	A3#4	2.93277e-18
C133	VPWR#2	A2#2	1.64442e-19
C134	a_83_264##2	A1#3	2.70047e-17
C135	VGND	B1#2	2.57232e-18
C136	B1#3	a_548_368#	3.11738e-17
C137	a_83_264##3	A1#2	2.97744e-19
C138	a_83_264##2	A2#3	2.99666e-19
C139	VPWR#2	A3#2	5.45936e-20
C140	VPWR#5	a_83_264##5	9.76536e-18
C141	a_83_264##2	A3#3	1.43245e-19
C142	A2	a_83_264##5	4.21135e-17
C143	VPWR#2	B2#2	1.64442e-19
C144	a_251_74##4	A1#5	2.13164e-17
C145	B2	a_83_264##7	1.55239e-17
C146	a_83_264##2	B2#3	1.05442e-19
C147	a_251_74##2	a_83_264##7	6.94224e-17
C148	a_251_74##2	a_251_74#	2.12548e-18
C149	A3	a_83_264##5	4.41097e-17
C150	a_83_264#	A1#2	1.22346e-18
C151	a_251_74#	a_83_264##7	4.78065e-17
C152	B2	a_83_264##5	3.97551e-17
C153	B2#2	B1#3	4.37515e-18
C154	a_83_264##2	X#2	4.62026e-17
C155	a_83_264##5	a_83_264##4	1.23479e-17
C156	VPWR#2	A2#3	6.84131e-18
C157	a_83_264##2	VPWR#5	4.7235e-17
C158	VPWR#2	A3#3	3.69431e-18
C159	a_83_264##3	A1#3	2.10759e-17
C160	X#2	A1#2	1.61829e-20
C161	A1#2	VPWR#5	4.20301e-19
C162	VPWR#2	B2#3	4.66883e-18
C163	a_83_264##2	a_83_264##4	4.76933e-20
C164	VPWR#2	B1#3	2.41133e-18
C165	A1#3	A2#3	5.42522e-17
C166	VPWR#1	B1#2	3.11731e-18
C167	a_83_264##2	X#1	7.99479e-19
C168	a_83_264##5	VPWR#1	4.97827e-17
C169	VGND#6	a_83_264##2	1.29329e-17
C170	a_251_74##2	A3#4	4.24635e-17
C171	A2#3	A3#3	3.35954e-17
C172	a_251_74##4	a_83_264##2	8.28618e-19
C173	a_83_264##5	a_248_368#	4.30293e-18
C174	VGND#6	A1#2	2.96695e-18
C175	A3#2	a_83_264##4	5.29945e-19
C176	a_251_74##4	A1#2	4.25851e-18
C177	A3#3	B2#3	2.88208e-17
C178	a_83_264##5	a_332_368#	9.22029e-18
C179	a_83_264##2	A1#5	2.38083e-17
C180	a_251_74##4	A2#2	5.10904e-17
C181	B1	B1#2	2.67041e-17
C182	a_83_264##7	A1#2	6.27031e-20
C183	B2#3	B1#3	2.57268e-17
C184	VGND#5	A2#2	8.68212e-19
C185	a_83_264##2	A1#6	5.0179e-17
C186	a_83_264##5	a_548_368#	8.47991e-18
C187	A1#5	A1#2	1.00756e-17
C188	a_251_74##2	B2#4	2.09489e-17
C189	a_83_264##7	A2#2	9.49707e-20
C190	VGND#5	A3#2	4.06423e-19
C191	a_251_74##4	a_83_264##5	7.62571e-18
C192	A1#6	A1#2	5.533e-18
C193	a_251_74##2	A3#2	6.99363e-18
C194	A1#5	A2#2	1.84708e-17
C195	X#2	a_83_264##3	4.85554e-17
C196	a_83_264##7	A3#2	2.11292e-19
C197	a_83_264##7	B2#4	4.55557e-17
C198	B2#4	B1#2	2.87689e-18
C199	a_83_264##3	VPWR#5	4.28066e-17
C200	A1#6	A2#2	1.01014e-18
C201	a_251_74##2	B2#2	4.30464e-19
C202	X#2	A1#3	3.03269e-18
C203	a_83_264##7	B2#2	1.29163e-17
C204	VPWR#2	VPWR#1	2.86754e-17
C205	A1#3	VPWR#5	2.97383e-17
C206	A2#2	A3#4	1.62084e-17
C207	X#2	A2#3	3.93777e-19
C208	a_251_74##2	a_83_264##5	6.86547e-18
C209	VPWR#5	A2#3	3.41871e-18
C210	a_83_264#	A1#1	2.18844e-17
C211	X#2	A3#3	2.57533e-19
C212	A3#4	A3#2	9.13754e-18
C213	VPWR#5	A3#3	2.07256e-18
C214	B2#2	B1#2	2.43795e-17
C215	a_83_264##7	a_83_264##5	2.61815e-18
C216	A1#1	A2#1	3.77363e-17
C217	a_83_264##5	A2#2	2.07911e-18
C218	A3#4	B2#2	1.76377e-18
C219	VPWR#5	B2#3	1.1729e-18
C220	B2#4	A3#2	2.34068e-18
C221	VPWR#1	A1#3	3.83484e-19
C222	A3#3	a_83_264##4	2.4612e-17
C223	B2#4	B2#2	1.08491e-17
C224	A2#1	A3#1	2.144e-17
C225	VPWR#1	A2#3	3.75537e-19
C226	a_83_264##5	A3#2	2.49024e-18
C227	B2#3	a_83_264##4	2.44356e-17
C228	VPWR#1	A3#3	6.72782e-19
C229	a_83_264##5	B2#2	3.26989e-18
C230	A3#1	B2#1	2.73697e-17
C231	VPWR#1	B2#3	7.41573e-18
C232	A3#4	B2#4	2.06508e-17
C233	VPWR#1	B1#3	4.58664e-17
C234	B2#1	B1#4	1.6906e-17
C235	A1#6	a_83_264##3	2.1826e-19
C236	A1#6	A1#3	2.05465e-18
C237	a_83_264##5	VPWR#2	2.50358e-17
C238	a_83_264#	X#1	7.56416e-18
C239	B2	B1#2	6.33062e-19
C240	a_83_264##7	B2#3	3.43358e-19
C241	A1#6	A2#3	7.18412e-19
C242	a_83_264#	VGND#6	2.91946e-17
C243	X#2	VPWR#5	6.79199e-17
C244	a_83_264##7	B1#3	1.97216e-18
C245	B2#1	B1#2	1.90285e-18
C246	a_251_74##4	a_83_264#	7.41813e-19
C247	A1#1	VGND#6	2.0725e-17
C248	VGND#5	a_83_264#	2.71363e-19
C249	a_251_74##4	A1#1	3.53334e-17
C250	a_83_264##5	a_83_264##3	1.81322e-18
C251	VGND#6	A2#1	1.36469e-18
C252	VGND#5	A1#1	5.07755e-19
C253	a_251_74##4	A2#1	4.95759e-17
C254	a_83_264##7	B1#2	1.49112e-17
C255	VGND#6	A3#1	2.8808e-19
C256	a_83_264##5	A1#3	1.97677e-18
C257	A2#1	VGND#5	2.09297e-17
C258	a_251_74##4	A3#1	6.53438e-19
C259	a_251_74##2	A2#1	6.53438e-19
C260	a_83_264##5	A2#3	2.78493e-17
C261	A3#1	VGND#5	1.79308e-17
C262	a_251_74##2	A3#1	4.79639e-17
C263	VGND#5	B2#1	3.91903e-19
C264	a_83_264##5	A3#3	3.8648e-17
C265	a_83_264##7	A3#1	9.635e-19
C266	a_251_74#	B1#2	6.13831e-18
C267	a_251_74##2	B2#1	3.31683e-17
C268	VGND#5	B1#4	2.89589e-19
C269	a_251_74#	A3#1	1.7257e-19
C270	a_83_264##7	B2#1	2.99735e-17
C271	a_83_264##5	B2#3	5.00567e-17
C272	a_251_74##2	B1#4	9.28331e-19
C273	a_251_74#	B2#1	9.05066e-19
C274	a_83_264##7	B1#4	3.01898e-17
C275	a_83_264##5	B1#3	2.67373e-17
C276	a_251_74#	B1#4	3.1536e-17
C277	VGND#2	A3#1	5.57202e-18
C278	VGND#3	a_83_264##2	5.0034e-19
C279	VGND#2	a_83_264#	3.58741e-19
C280	VGND#3	A1#5	4.12191e-19
C281	VGND#2	a_251_74##2	3.77568e-17
C282	VGND#3	A1#1	4.76848e-18
C283	VGND#6	VGND#2	3.82144e-19
C284	VGND#3	a_83_264#	4.74518e-18
C285	VPWR#3	A1#3	6.84131e-18
C286	VGND#2	B2#2	7.4814e-20
C287	VGND#2	B1#4	5.66073e-18
C288	VGND#2	VNB	2.58803e-16
C289	VPWR	VPWR#3	4.12123e-17
C290	VPWR#3	a_83_264##3	4.62988e-18
C291	VGND#3	a_251_74##4	8.48245e-18
C292	VGND#2	A2#1	5.61681e-18
C293	a_83_264##5	VPWR#3	3.38532e-19
C294	VGND#2	a_251_74#	3.43866e-17
C295	VPWR#3	A1#2	1.99324e-21
C296	VGND#2	B1	1.01968e-18
C297	a_83_264##2	VPWR#3	1.67021e-18
C298	X#2	VPWR#3	2.23488e-17
C299	VGND	VGND#2	8.24944e-17
C300	VPWR#2	VPWR#3	5.93902e-17
C301	VGND#2	A3#2	5.66773e-20
C302	VGND#2	B2#1	5.96636e-18
C303	VGND#3	X	2.80112e-17
C304	VGND#2	VGND#3	6.09089e-17
C305	VGND#2	A1#1	8.56932e-19
C306	VPWR#3	VNB	5.37877e-17
C307	VGND#2	a_251_74##4	8.6585e-18
C308	VGND	VGND#3	4.01438e-17
C309	VGND#2	B1#2	7.30885e-19
C310	VGND#3	VNB	5.31646e-17
*
*
.ENDS sky130_fd_sc_hs__o32a_1
*
