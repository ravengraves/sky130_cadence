* Extracted by Quantus, converted by sky130cad/quantus.py
*
*
*
*                       LINUX           Wed Nov 18 08:26:55 2026
*
*
*
*  PROGRAM  advgen
*
*  Name           : advgen - Quantus - (64-bit)
*  Version        : 25.1.0-p047
*  Build Date     : Thu Dec 11 23:20:30 PST 2025
*
*  HSPICE LIBRARY
*
*  OPERATING_TEMPERATURE 150
*  QRC_TECH_DIR <path>/tech
*
*
*

*
.SUBCKT sky130_fd_sc_hs__dfrtp_1 VPB VNB VGND RESET_B VPWR Q D CLK
*
*
*  caps2d version: 10
*
*
*       TRANSISTOR CARDS
*
*
XM25 a_30_78##5 D#1 a_117_78# VNB sky130_fd_pr__nfet_01v8_lvt l=0.15 w=0.42 ad=0.1197 as=0.1008 pd=1.41 ps=1.32
XM24 a_117_78# RESET_B#3 VGND#14 VNB sky130_fd_pr__nfet_01v8_lvt l=0.15 w=0.42 ad=0.1008 as=0.1197 pd=1.32 ps=1.41
XM12 a_306_74##13 CLK#3 VGND#13 VNB sky130_fd_pr__nfet_01v8_lvt l=0.15 w=0.74 ad=0.2109 as=0.259 pd=2.05 ps=2.18
XM2 VGND#13 a_306_74##10 a_490_366##14 VNB sky130_fd_pr__nfet_01v8_lvt l=0.15 w=0.74 ad=0.259 as=0.2627 pd=2.18 ps=2.19
XM3 a_30_78# a_306_74##9 a_695_457##9 VNB sky130_fd_pr__nfet_01v8_lvt l=0.15 w=0.42 ad=0.1197 as=0.147 pd=1.41 ps=1.54
XM14 a_695_457##9 a_490_366# a_816_138# VNB sky130_fd_pr__nfet_01v8_lvt l=0.15 w=0.42 ad=0.147 as=0.1008 pd=1.54 ps=1.32
XM28 a_816_138# a_830_359# a_894_138# VNB sky130_fd_pr__nfet_01v8_lvt l=0.15 w=0.42 ad=0.1008 as=0.1008 pd=1.32 ps=1.32
XM20 a_894_138# RESET_B#7 VGND#12 VNB sky130_fd_pr__nfet_01v8_lvt l=0.15 w=0.42 ad=0.1008 as=0.422475 pd=1.32 ps=2.9
XM5 VGND#12 a_695_457##3 a_830_359##5 VNB sky130_fd_pr__nfet_01v8_lvt l=0.15 w=0.74 ad=0.422475 as=0.4921 pd=2.9 ps=2.81
XM4 a_830_359##5 a_490_366##5 a_1266_74##10 VNB sky130_fd_pr__nfet_01v8_lvt l=0.15 w=0.74 ad=0.4921 as=0.458 pd=2.81 ps=3.28
XM31 a_1266_74##10 a_306_74# a_1476_81# VNB sky130_fd_pr__nfet_01v8_lvt l=0.15 w=0.42 ad=0.458 as=0.1008 pd=3.28 ps=1.32
XM27 a_1476_81# a_1518_203##3 VGND#11 VNB sky130_fd_pr__nfet_01v8_lvt l=0.15 w=0.42 ad=0.1008 as=0.1512 pd=1.32 ps=1.56
XM16 VGND#11 RESET_B#9 a_1656_81# VNB sky130_fd_pr__nfet_01v8_lvt l=0.15 w=0.42 ad=0.1512 as=0.0882 pd=1.56 ps=1.26
XM19 a_1656_81# a_1266_74##4 a_1518_203##4 VNB sky130_fd_pr__nfet_01v8_lvt l=0.15 w=0.42 ad=0.0882 as=0.1197 pd=1.26 ps=1.41
XM1 VGND#10 a_1266_74# a_1864_409##5 VNB sky130_fd_pr__nfet_01v8_lvt l=0.15 w=0.55 ad=0.15675 as=0.15675 pd=1.67 ps=1.67
XM15 Q#3 a_1864_409# VGND#1 VNB sky130_fd_pr__nfet_01v8_lvt l=0.15 w=0.74 ad=0.2109 as=0.2109 pd=2.05 ps=2.05
XM11 VPWR#15 D#3 a_30_78##6 VPB sky130_fd_pr__pfet_01v8 l=0.15 w=0.42 ad=0.1197 as=0.126 pd=1.41 ps=1.44
XM29 a_30_78##6 RESET_B#4 VPWR#14 VPB sky130_fd_pr__pfet_01v8 l=0.15 w=0.42 ad=0.126 as=0.1176 pd=1.44 ps=1.4
XM7 a_306_74##14 CLK#1 VPWR#12 VPB sky130_fd_pr__pfet_01v8 l=0.15 w=1.12 ad=0.3136 as=0.336 pd=2.8 ps=2.84
XM23 VPWR#12 a_306_74##7 a_490_366##12 VPB sky130_fd_pr__pfet_01v8 l=0.15 w=1.12 ad=0.336 as=0.3136 pd=2.84 ps=2.8
XM22 a_30_78##2 a_490_366##3 a_695_457##7 VPB sky130_fd_pr__pfet_01v8 l=0.15 w=0.42 ad=0.1239 as=0.126 pd=1.43 ps=1.44
XM8 a_695_457##7 a_306_74##8 a_785_457# VPB sky130_fd_pr__pfet_01v8 l=0.15 w=0.42 ad=0.126 as=0.1008 pd=1.44 ps=1.32
XM17 a_785_457# a_830_359##3 VPWR#9 VPB sky130_fd_pr__pfet_01v8 l=0.15 w=0.42 ad=0.1008 as=0.27425 pd=1.32 ps=2.31
XM9 VPWR#9 RESET_B#8 a_695_457##8 VPB sky130_fd_pr__pfet_01v8 l=0.15 w=0.42 ad=0.27425 as=0.1239 pd=2.31 ps=1.43
XM21 VPWR#7 a_695_457# a_830_359##4 VPB sky130_fd_pr__pfet_01v8 l=0.15 w=1 ad=0.305 as=0.38125 pd=2.61 ps=3.01
XM26 a_830_359##4 a_306_74##2 a_1266_74##8 VPB sky130_fd_pr__pfet_01v8 l=0.15 w=1 ad=0.38125 as=0.4603 pd=3.01 ps=3.46
XM13 a_1266_74##8 a_490_366##6 a_1468_493# VPB sky130_fd_pr__pfet_01v8 l=0.15 w=0.42 ad=0.4603 as=0.1134 pd=3.46 ps=1.38
XM0 a_1468_493# a_1518_203##2 VPWR#5 VPB sky130_fd_pr__pfet_01v8 l=0.15 w=0.42 ad=0.1134 as=0.1785 pd=1.38 ps=1.69
XM30 VPWR#5 RESET_B#11 a_1518_203##7 VPB sky130_fd_pr__pfet_01v8 l=0.15 w=0.42 ad=0.1785 as=0.126 pd=1.69 ps=1.44
XM18 a_1518_203##7 a_1266_74##6 VPWR#3 VPB sky130_fd_pr__pfet_01v8 l=0.15 w=0.42 ad=0.126 as=0.2856 pd=1.44 ps=2.45
XM6 VPWR#3 a_1266_74##5 a_1864_409##7 VPB sky130_fd_pr__pfet_01v8 l=0.15 w=0.84 ad=0.2856 as=0.2478 pd=2.45 ps=2.27
XM10 Q#1 a_1864_409##4 VPWR#1 VPB sky130_fd_pr__pfet_01v8 l=0.15 w=1.12 ad=0.3808 as=0.336 pd=2.92 ps=2.84
*
*
*       RESISTOR AND CAP/DIODE CARDS
*
Rg1	D#1	D#2	317.704102
Rg2	D#2	D#3	451.289124
Rg3	RESET_B#1	RESET_B#2	6.813559
Rg4	RESET_B#2	RESET_B#3	443.254333
Rg5	RESET_B#2	RESET_B#4	447.888123
Rg6	CLK#1	CLK#2	456.142303
Rg7	CLK#2	CLK#3	372.003876
Rg8	a_490_366#	a_490_366##2	586.419800
Rg9	a_490_366##2	a_490_366##3	331.373016
Rg10	a_830_359#	a_830_359##2	541.952332
Rg11	a_830_359##2	a_830_359##3	229.649475
Rg12	RESET_B#5	RESET_B#6	33.566738
Rg13	RESET_B#6	RESET_B#7	535.091370
Rg14	RESET_B#6	RESET_B#8	248.803528
Rg15	a_695_457#	a_695_457##2	507.287354
Rg16	a_695_457##2	a_695_457##3	316.771820
Rg17	a_490_366##4	a_490_366##5	532.433044
Rg18	a_490_366##6	a_490_366##7	227.952118
Rg19	a_306_74#	a_306_74##2	1415.939575
Rg20	a_306_74##2	a_306_74##3	1794.448853
Rg21	a_306_74##3	a_306_74##4	1417.253418
Rg22	a_306_74##4	a_306_74##5	56.634361
Rg23	a_306_74##5	a_306_74##6	19.357107
Rg24	a_306_74##6	a_306_74##7	505.566559
Rg25	a_306_74##3	a_306_74##8	296.970245
Rg26	a_306_74##4	a_306_74##9	517.586731
Rg27	a_306_74##6	a_306_74##10	314.317688
Rg28	a_1518_203#	a_1518_203##2	711.099243
Rg29	a_1518_203#	a_1518_203##3	262.028748
Rg30	RESET_B#9	RESET_B#10	796.175964
Rg31	RESET_B#10	RESET_B#11	272.051971
Rg32	a_1266_74#	a_1266_74##2	533.791626
Rg33	a_1266_74##2	a_1266_74##3	88.769745
Rg34	a_1266_74##3	a_1266_74##4	458.898102
Rg35	a_1266_74##2	a_1266_74##5	457.186584
Rg36	a_1266_74##3	a_1266_74##6	503.673767
Rg37	a_1864_409#	a_1864_409##2	417.640869
Rg38	a_1864_409##2	a_1864_409##3	292.219025
Rg39	a_1864_409##2	a_1864_409##4	434.109863
Rf1	D	D#4	5.370198
Rf2	D#4	D	7.048386
Rf3	RESET_B	RESET_B#1	82.914993
Rf4	CLK	CLK#2	174.977905
Rf5	a_306_74##5	a_306_74##12	228.640137
Rf6	a_306_74##12	a_306_74##13	18.820055
Rf7	a_306_74##12	a_306_74##14	76.665009
Rf8	a_30_78#	a_30_78##3	158.933929
Rf9	a_30_78##3	a_30_78##4	165.407318
Rf10	a_30_78##4	a_30_78##5	157.597595
Rf11	a_30_78##4	a_30_78##6	34.145622
Rf12	a_30_78##2	a_30_78##3	15.000000
Rf13	RESET_B#14	RESET_B#15	11.254055
Rf14	RESET_B#5	RESET_B#17	161.709076
Rf15	RESET_B#14	RESET_B#17	2.937730
Rf16	a_695_457##2	a_695_457##5	252.946808
Rf17	a_695_457##5	a_695_457##6	50.392170
Rf18	a_695_457##6	a_695_457##7	40.545528
Rf19	a_695_457##5	a_695_457##8	35.205444
Rf20	a_695_457##6	a_695_457##9	128.689529
Rf21	a_830_359##4	a_830_359##6	93.349190
Rf22	a_830_359##6	a_830_359##2	335.229065
Rf23	a_830_359##5	a_830_359##6	15.000000
Rf24	a_490_366##4	a_490_366##9	165.549789
Rf25	a_490_366##9	a_490_366##10	394.338531
Rf26	a_490_366##10	a_490_366##11	63.382107
Rf27	a_490_366##11	a_490_366##12	42.387703
Rf28	a_490_366##9	a_490_366##7	199.051361
Rf29	a_490_366##10	a_490_366##14	23.311863
Rf30	a_490_366##11	a_490_366##2	175.794952
Rf31	RESET_B#18	RESET_B#19	0.674438
Rf32	RESET_B#20	RESET_B#10	160.907242
Rf33	RESET_B#19	RESET_B#20	10.090100
Rf34	a_1266_74##3	a_1266_74##9	330.107239
Rf35	a_1266_74##9	a_1266_74##10	158.691132
Rf36	a_1266_74##8	a_1266_74##9	7.500000
Rf37	a_1518_203##4	a_1518_203##5	30.766592
Rf38	a_1518_203##5	a_1518_203#	229.527298
Rf39	a_1518_203##5	a_1518_203##7	171.359665
Rf40	a_1864_409##5	a_1864_409##3	50.962002
Rf41	a_1864_409##3	a_1864_409##7	79.504059
Rf42	Q	Q#2	5.177638
Rf43	Q#2	Q#3	88.852310
Rf44	Q#1	Q#2	5.000000
Rf45	VPWR#1	VPWR#2	174.192581
Rf46	VPWR#2	VPWR#3	38.378853
Rf47	VPWR#2	VPWR#4	66.451416
Rf48	VPWR#4	VPWR#5	37.460041
Rf49	VPWR#4	VPWR#6	169.793335
Rf50	VPWR#6	VPWR#7	44.191132
Rf51	VPWR#6	VPWR#8	79.941223
Rf52	VPWR#8	VPWR#9	31.554951
Rf53	VPWR#8	VPWR#10	86.905563
Rf54	VPWR#10	VPWR#11	88.366570
Rf55	VPWR#11	VPWR#12	33.129639
Rf56	VPWR#11	VPWR#13	68.675751
Rf57	VPWR#13	VPWR#14	37.027283
Rf58	VPWR#13	VPWR#15	111.916550
Rf59	VGND#1	VGND#2	149.329437
Rf60	VGND#2	VGND#3	30.714024
Rf61	VGND#3	VGND#4	70.834450
Rf62	VGND#4	VGND#5	204.280045
Rf63	VGND#5	VGND#6	127.966812
Rf64	VGND#6	VGND#7	86.540306
Rf65	VGND#7	VGND#8	74.519791
Rf67	VGND#2	VGND#10	41.120300
Rf68	VGND#4	VGND#11	35.885353
Rf69	VGND#5	VGND#12	22.477486
Rf70	VGND#7	VGND#13	34.310661
Rf71	VGND#8	VGND#14	41.376114
Rf72	D#2	D#4	53.410934
Re1	RESET_B#18	RESET_B#15	14.521620
Re2	RESET_B#15	RESET_B	6.390494
Re4	VPWR#2	VPWR	2.377092
Re5	VPWR	VPWR#10	1.528131
Re6	VGND#3	VGND	2.377092
Re7	VGND	VGND#6	1.528131
*
*       CAPACITOR CARDS
*
*
C1	a_306_74##5	a_490_366##11	2.99214e-17
C2	VGND#6	a_30_78##5	2.78898e-17
C3	a_695_457##8	a_306_74##3	2.5412e-18
C4	a_695_457##3	VGND#12	1.37353e-17
C5	a_490_366##11	a_30_78##2	1.12249e-17
C6	RESET_B#4	VPWR#14	1.93925e-17
C7	a_695_457##6	a_490_366##2	5.93051e-19
C8	VPWR#15	CLK#1	1.74873e-19
C9	VGND#2	RESET_B#9	3.28182e-19
C10	RESET_B#15	a_1266_74##8	1.05157e-17
C11	a_830_359##5	RESET_B#7	1.37836e-17
C12	a_30_78#	a_306_74##6	7.4201e-18
C13	a_30_78##6	RESET_B#4	2.69874e-17
C14	a_490_366##4	a_1518_203##4	6.60992e-19
C15	RESET_B#15	a_830_359##4	4.11628e-17
C16	a_695_457##7	VPWR#7	1.63857e-18
C17	VPWR#13	VPWR#11	1.21953e-18
C18	a_695_457##8	RESET_B#6	5.05201e-18
C19	VPWR#14	D#3	7.14071e-19
C20	VGND#7	a_306_74##6	2.38463e-19
C21	VPWR#15	RESET_B#4	1.26838e-18
C22	a_695_457##9	a_490_366##5	2.52665e-19
C23	RESET_B#7	VGND#12	1.10967e-17
C24	VGND#4	a_1518_203##3	3.48706e-18
C25	RESET_B#15	VPWR#7	3.95607e-17
C26	a_830_359##3	a_306_74##3	1.49531e-17
C27	CLK#2	a_490_366##11	3.11803e-18
C28	a_490_366##4	VGND#11	2.93708e-17
C29	VPWR#1	a_1864_409##3	4.62206e-20
C30	a_30_78##6	D#3	2.35212e-17
C31	a_830_359##5	a_830_359#	2.78652e-19
C32	RESET_B#15	a_695_457##8	1.14236e-17
C33	a_1266_74##5	a_1864_409##4	3.24447e-18
C34	RESET_B#7	a_306_74##3	1.28933e-19
C35	a_1864_409##3	Q#1	9.77202e-20
C36	a_490_366##14	a_830_359##5	5.85452e-17
C37	VPWR#15	D#3	1.75249e-17
C38	VGND#2	a_1518_203##3	1.23306e-19
C39	a_1266_74##10	a_490_366##4	2.02872e-16
C40	RESET_B#15	VPWR#9	3.85105e-18
C41	a_695_457##5	VPWR#9	3.47074e-17
C42	a_695_457##9	a_695_457##3	4.12147e-19
C43	a_30_78##4	VPWR#13	4.26423e-18
C44	VPWR#11	a_306_74##7	3.9031e-18
C45	VPWR#10	a_1266_74##8	5.69619e-18
C46	VPWR#9	a_306_74##3	2.11709e-17
C47	a_490_366##4	a_830_359##5	5.30942e-17
C48	a_306_74##3	a_894_138#	9.5051e-19
C49	VPWR#10	a_830_359##4	1.2508e-17
C50	a_830_359##5	a_490_366#	1.66895e-19
C51	VGND#4	a_306_74#	4.05586e-18
C52	a_306_74##6	a_490_366##14	6.17291e-18
C53	a_490_366##14	VGND#12	3.55965e-18
C54	RESET_B#15	a_695_457##7	7.20337e-18
C55	a_1266_74##6	a_1266_74##5	2.62027e-17
C56	a_1266_74##10	a_695_457##2	8.51686e-19
C57	VPWR#13	CLK#1	8.64467e-19
C58	a_695_457##9	RESET_B#7	7.13927e-19
C59	RESET_B#15	a_30_78##2	4.07732e-17
C60	VPWR#10	a_695_457##8	6.45756e-18
C61	a_695_457##2	a_830_359##5	1.13532e-16
C62	a_30_78##4	VPWR#11	3.06233e-18
C63	a_306_74##3	a_306_74##8	1.00422e-18
C64	a_306_74##12	RESET_B#2	6.82235e-18
C65	VPWR#3	a_1266_74##3	6.45928e-19
C66	a_1518_203##5	a_1864_409#	5.28558e-20
C67	VGND#6	a_830_359##4	1.73703e-18
C68	VGND#5	a_490_366##5	5.04207e-18
C69	a_490_366##14	a_695_457##3	1.64714e-17
C70	VPWR#11	CLK#1	4.74307e-18
C71	VPWR#10	VPWR#9	1.15458e-17
C72	a_1518_203##7	a_1266_74##3	6.2251e-17
C73	a_306_74##12	a_306_74##5	1.94859e-18
C74	VGND#6	VPWR#7	4.2113e-18
C75	RESET_B#11	a_1266_74##6	2.12533e-17
C76	VGND#4	a_490_366##5	3.29005e-19
C77	VPWR#9	a_490_366##12	2.59045e-20
C78	a_695_457##9	a_830_359#	5.3059e-18
C79	a_490_366##14	a_490_366##4	2.42419e-18
C80	RESET_B#14	a_695_457##8	1.132e-17
C81	VGND#2	a_1864_409##2	1.42254e-20
C82	CLK#2	a_30_78##4	1.08884e-18
C83	a_695_457##7	VPWR#10	1.93866e-17
C84	a_306_74##6	a_490_366##3	1.98931e-17
C85	a_490_366##14	RESET_B#7	1.61708e-17
C86	VPWR#13	RESET_B#4	5.66255e-18
C87	a_306_74##6	a_490_366#	1.71404e-18
C88	a_1518_203##7	RESET_B#10	7.80958e-18
C89	VGND#10	a_1864_409##7	1.13569e-18
C90	a_695_457##7	a_306_74##6	6.4392e-19
C91	a_30_78#	a_695_457##9	9.35291e-17
C92	a_1518_203##5	a_1266_74#	4.3597e-19
C93	a_30_78##2	VPWR#10	3.30095e-17
C94	a_30_78##2	a_695_457##7	5.614e-17
C95	a_306_74##12	CLK#2	6.0229e-17
C96	VPWR#2	a_1266_74#	6.49362e-19
C97	VGND#5	a_695_457##3	1.17601e-17
C98	VPWR#5	RESET_B#10	3.92077e-18
C99	a_30_78##2	a_695_457##6	3.96148e-17
C100	a_1518_203##2	RESET_B#11	1.36095e-17
C101	a_695_457##5	a_306_74##2	6.75013e-20
C102	a_695_457##9	a_490_366#	4.78165e-17
C103	VPWR#10	a_490_366##12	2.37281e-18
C104	VGND#3	a_1864_409#	4.8781e-18
C105	a_830_359##2	a_830_359##5	4.36537e-19
C106	a_306_74##3	a_490_366##3	1.68415e-17
C107	a_490_366##14	a_830_359#	1.2986e-17
C108	a_1518_203##7	a_1518_203#	5.10498e-19
C109	VPWR#10	VPWR#12	1.18087e-18
C110	a_1266_74##8	RESET_B#10	1.11087e-18
C111	VGND#3	a_1266_74#	1.22306e-18
C112	a_490_366##14	RESET_B#6	5.94047e-19
C113	a_490_366##14	a_695_457##9	6.71629e-17
C114	a_30_78#	a_490_366#	6.73302e-18
C115	VGND#2	a_1266_74##2	3.48382e-20
C116	VPWR#5	a_1518_203#	9.14198e-19
C117	a_490_366#	a_306_74##3	2.4367e-19
C118	RESET_B#18	a_306_74#	1.56447e-18
C119	VPWR#10	a_306_74##14	3.56703e-18
C120	VGND#6	a_490_366##12	2.41444e-18
C121	VPWR#13	D#3	3.38183e-18
C122	VGND#3	a_1266_74##4	1.75541e-17
C123	a_1518_203##5	a_1266_74##4	1.02622e-17
C124	a_490_366##6	a_1518_203##2	2.57337e-17
C125	a_695_457##9	a_306_74##9	1.09914e-17
C126	a_695_457##5	a_695_457#	1.18946e-19
C127	a_695_457##7	a_306_74##3	3.73785e-18
C128	VGND#5	RESET_B#7	2.68145e-18
C129	a_490_366##14	a_490_366#	1.2956e-17
C130	VGND#3	RESET_B#9	9.91461e-18
C131	a_1266_74##8	a_1518_203#	1.28812e-18
C132	a_30_78##2	a_490_366##12	4.13722e-17
C133	a_695_457##9	a_830_359##2	8.19843e-17
C134	a_306_74##7	a_306_74##6	3.41959e-17
C135	VPWR#8	VPWR#6	4.13496e-19
C136	a_306_74##2	a_1518_203##2	3.15417e-19
C137	VPWR#10	a_30_78##6	1.61031e-17
C138	VGND#6	a_306_74##14	1.3668e-18
C139	a_490_366##14	a_30_78#	7.92813e-17
C140	D#2	a_30_78##4	1.85084e-17
C141	a_30_78##2	a_306_74##6	3.25454e-17
C142	a_30_78#	a_306_74##9	4.33154e-17
C143	a_830_359##4	a_1518_203#	2.47749e-20
C144	VGND#4	a_1518_203##5	1.21156e-18
C145	VGND#3	a_1518_203##3	3.82658e-18
C146	VGND#1	a_1864_409##2	9.05821e-20
C147	a_695_457##6	RESET_B#8	6.30688e-19
C148	VPWR#10	VPWR#15	5.32951e-17
C149	a_490_366##14	a_830_359##2	3.86415e-17
C150	a_490_366##11	a_306_74##6	4.02956e-17
C151	a_306_74##2	a_490_366##6	8.75535e-18
C152	a_30_78##2	VPWR#12	3.68713e-17
C153	a_695_457##2	RESET_B#6	2.57939e-17
C154	a_490_366##7	a_1266_74##8	1.13814e-16
C155	a_490_366##14	a_306_74##9	9.46879e-18
C156	a_306_74##7	a_306_74##3	1.94077e-17
C157	VPWR#4	a_306_74#	3.42659e-20
C158	a_1518_203##5	RESET_B#9	7.17918e-18
C159	VGND#5	RESET_B#6	5.54507e-19
C160	a_695_457##5	RESET_B#8	1.1114e-17
C161	a_695_457##9	a_490_366##2	4.58086e-18
C162	a_30_78#	a_306_74##10	5.34785e-19
C163	a_30_78#	a_490_366##2	5.99794e-17
C164	VGND#5	a_830_359#	1.33113e-18
C165	VGND#13	a_306_74##9	2.51807e-19
C166	a_490_366##14	a_490_366##2	2.51201e-18
C167	VPWR#6	a_490_366##5	3.84936e-19
C168	a_490_366##4	a_1266_74##8	4.9606e-18
C169	VGND#2	a_1518_203##5	3.61357e-19
C170	a_695_457#	a_306_74##2	5.77504e-17
C171	a_695_457##6	a_830_359##3	2.14359e-17
C172	RESET_B#15	a_490_366##5	3.40127e-18
C173	a_30_78##2	a_306_74##3	6.87267e-18
C174	a_306_74##10	a_490_366##14	2.29054e-17
C175	a_490_366##4	a_830_359##4	1.9037e-18
C176	VGND#13	a_490_366##14	4.39907e-17
C177	a_695_457##5	a_830_359##3	1.70668e-18
C178	a_1518_203##5	a_1518_203##3	5.72596e-20
C179	a_490_366##12	a_306_74##6	1.46186e-17
C180	a_306_74##14	a_490_366##12	5.25645e-18
C181	VPWR#14	a_30_78##2	9.92845e-19
C182	a_1864_409##3	a_1864_409#	2.60144e-19
C183	Q#3	a_1864_409##2	1.12213e-17
C184	VGND#13	a_306_74##10	3.77973e-17
C185	a_695_457##6	a_785_457#	1.65218e-18
C186	a_306_74##5	a_490_366##14	4.92218e-17
C187	RESET_B#5	a_306_74##3	1.17901e-19
C188	a_1864_409##3	a_1266_74#	1.89159e-17
C189	RESET_B#8	a_695_457#	3.46546e-18
C190	a_306_74##5	VGND#13	1.82294e-17
C191	a_490_366##14	CLK#3	7.12357e-20
C192	a_695_457##2	a_830_359##4	7.68745e-19
C193	RESET_B#5	RESET_B#6	1.24383e-17
C194	a_695_457##6	a_306_74##8	1.38097e-17
C195	a_695_457##2	VPWR#7	2.64111e-17
C196	a_490_366##11	a_306_74##3	4.47482e-20
C197	a_1266_74##2	a_1864_409##2	1.67432e-19
C198	RESET_B#15	a_490_366#	2.24489e-19
C199	a_30_78##2	RESET_B#2	1.58111e-19
C200	a_695_457##2	a_695_457##8	5.43721e-19
C201	a_695_457##5	a_306_74##8	1.36515e-19
C202	CLK#3	VGND#13	1.82333e-17
C203	VGND#2	VGND#1	4.92622e-19
C204	Q#3	a_1266_74##2	8.62652e-20
C205	RESET_B#18	VPWR#6	1.70084e-18
C206	a_1518_203##5	a_306_74#	6.54647e-20
C207	VGND#14	a_306_74##10	1.62812e-19
C208	a_830_359##3	RESET_B#8	1.15495e-17
C209	CLK#2	VGND#13	1.40523e-18
C210	a_306_74##8	a_695_457#	1.16023e-19
C211	VGND#6	a_490_366##5	5.41653e-18
C212	VPWR#14	VPWR#12	1.05196e-17
C213	RESET_B#2	CLK#1	1.00186e-17
C214	a_1266_74##8	a_306_74#	9.03873e-19
C215	RESET_B#5	VPWR#7	3.13213e-17
C216	VGND#3	VGND#4	1.21543e-16
C217	RESET_B#18	VPWR#4	4.3847e-18
C218	CLK#3	a_306_74##13	1.03765e-17
C219	a_490_366##11	a_30_78#	1.79734e-17
C220	RESET_B#9	a_1266_74##3	1.91692e-17
C221	a_695_457##6	a_490_366##3	4.57553e-19
C222	VGND#6	a_695_457##3	9.39585e-19
C223	RESET_B#5	a_695_457##8	1.27883e-17
C224	CLK#3	a_306_74##6	4.71704e-18
C225	VPWR#12	a_306_74##6	5.96176e-19
C226	VGND#3	VGND#2	8.22537e-17
C227	VGND#13	RESET_B#3	8.19749e-19
C228	a_30_78##4	a_490_366##12	8.57961e-19
C229	a_830_359##4	a_830_359##2	1.18501e-19
C230	VGND#6	RESET_B#7	3.6749e-18
C231	a_830_359##2	a_306_74##3	1.4327e-18
C232	a_695_457##5	a_490_366##3	2.68755e-20
C233	VGND#14	CLK#3	1.31382e-18
C234	a_306_74##8	a_830_359##3	3.74967e-17
C235	RESET_B#18	a_1266_74##5	4.48345e-19
C236	a_1266_74##3	a_306_74#	6.24276e-18
C237	a_830_359##2	RESET_B#6	3.44924e-17
C238	VGND#2	Q#3	7.10998e-18
C239	VGND#6	a_830_359#	1.5969e-18
C240	VPWR#2	a_1864_409##4	5.77699e-18
C241	VPWR#2	VPWR#6	8.66764e-18
C242	RESET_B#4	a_306_74##3	8.72513e-20
C243	VGND#14	VGND#13	1.20922e-18
C244	RESET_B#15	VGND#5	2.46978e-18
C245	VGND#7	a_306_74##10	6.28783e-18
C246	VGND#6	a_490_366#	2.13705e-18
C247	VPWR#9	a_830_359##2	8.46217e-19
C248	VPWR#2	a_1266_74##5	1.04576e-17
C249	VPWR#2	VPWR#4	1.1424e-16
C250	a_830_359##4	a_490_366##5	1.25448e-18
C251	a_1518_203#	RESET_B#9	4.94178e-17
C252	RESET_B#3	VGND#14	1.8535e-17
C253	VGND#6	a_306_74##9	2.10724e-18
C254	a_490_366##3	a_306_74##8	3.10877e-17
C255	VPWR#2	a_1266_74##6	1.29417e-17
C256	a_30_78##5	CLK#3	1.2816e-18
C257	VPWR#12	a_306_74##3	4.22882e-18
C258	VGND#6	a_306_74##10	1.41111e-18
C259	RESET_B#18	a_1518_203##2	8.12832e-18
C260	a_306_74##6	a_490_366##2	4.03666e-17
C261	a_30_78##6	VPWR#14	2.69337e-17
C262	a_306_74#	a_1518_203#	6.22793e-17
C263	VPWR#2	RESET_B#11	8.22443e-18
C264	VPWR#4	VPWR#3	9.71325e-19
C265	VGND#14	RESET_B#2	6.25553e-18
C266	a_30_78##2	a_830_359##2	8.27519e-19
C267	a_490_366##4	a_1266_74#	2.54659e-19
C268	VGND#2	a_1864_409##5	2.07487e-17
C269	VGND#6	CLK#3	2.34746e-19
C270	a_306_74##14	a_306_74##6	7.41816e-19
C271	a_490_366##12	a_830_359##2	2.11282e-20
C272	VGND#14	D#1	2.42642e-18
C273	VGND#7	CLK#3	4.63355e-18
C274	VPWR#2	a_1518_203##2	5.54762e-18
C275	VPWR#8	a_490_366#	4.13497e-19
C276	D#2	a_30_78##5	9.09209e-17
C277	a_490_366##4	a_1266_74##4	1.18513e-19
C278	a_490_366##2	a_306_74##3	1.14438e-18
C279	RESET_B#2	CLK#3	3.61811e-18
C280	a_695_457##7	a_490_366##2	5.08093e-19
C281	VGND#6	RESET_B#3	9.99256e-18
C282	a_30_78##4	a_306_74##14	4.63152e-17
C283	VPWR#1	a_1864_409##2	2.35569e-18
C284	a_30_78##5	RESET_B#3	1.51221e-17
C285	a_490_366##7	a_306_74#	1.69913e-17
C286	VPWR#15	VPWR#14	2.00319e-18
C287	RESET_B#18	a_306_74##2	2.803e-18
C288	VPWR#11	a_306_74##6	1.60718e-19
C289	a_490_366##4	RESET_B#9	5.08973e-19
C290	a_30_78##2	a_490_366##2	4.67631e-17
C291	VPWR#2	a_490_366##6	7.99172e-18
C292	VPWR#2	a_1518_203##5	1.37349e-18
C293	VGND#6	D#1	1.243e-17
C294	a_490_366##4	a_1518_203##3	7.14152e-18
C295	a_490_366##12	a_490_366##2	2.22611e-19
C296	RESET_B#18	RESET_B#20	1.85301e-17
C297	RESET_B#15	VPWR#8	4.78974e-18
C298	a_490_366##4	a_306_74#	7.41647e-17
C299	CLK#1	a_306_74##7	4.9866e-17
C300	a_1518_203##7	VPWR#4	5.66207e-18
C301	VPWR#15	a_30_78##6	3.39417e-17
C302	VGND#10	a_1266_74##2	7.16398e-18
C303	VPWR#13	a_306_74##3	5.93639e-20
C304	VPWR#1	a_1266_74##2	1.32172e-19
C305	a_30_78##5	D#1	3.47649e-17
C306	RESET_B#15	VPWR#6	6.17307e-18
C307	a_306_74##5	a_30_78##2	1.32376e-18
C308	a_490_366##4	a_490_366##5	2.32127e-17
C309	a_30_78##4	VPWR#14	3.21441e-17
C310	VGND#3	a_306_74##2	4.63212e-20
C311	D#3	RESET_B#2	2.98395e-18
C312	a_306_74##5	a_490_366##12	1.9992e-17
C313	a_306_74##5	a_306_74##6	2.1233e-17
C314	a_490_366##4	a_695_457##3	1.69241e-17
C315	a_30_78##4	a_306_74##7	2.21741e-19
C316	a_695_457##2	a_306_74#	1.02625e-18
C317	a_306_74##12	a_306_74##14	3.12501e-18
C318	VGND#1	Q#3	7.74266e-17
C319	VGND#3	a_1518_203##5	6.83913e-18
C320	a_1864_409##3	a_1864_409##4	6.51604e-19
C321	a_1518_203##5	a_1864_409##7	1.70678e-17
C322	RESET_B#15	a_306_74##2	2.61937e-18
C323	RESET_B#4	CLK#1	5.84332e-18
C324	VPWR#14	a_306_74##6	1.29441e-19
C325	a_695_457##2	a_490_366##5	6.91472e-18
C326	CLK#2	a_30_78##2	2.70535e-19
C327	VPWR#2	RESET_B#20	2.64072e-18
C328	a_695_457##9	a_695_457##6	8.46968e-20
C329	a_1864_409##3	a_1266_74##5	3.2604e-19
C330	a_30_78##5	VGND#14	2.50473e-17
C331	a_490_366##12	CLK#2	2.16905e-19
C332	RESET_B#15	a_695_457#	4.24214e-18
C333	a_1864_409##2	Q#1	8.31707e-19
C334	a_1266_74##10	a_306_74##2	8.90995e-18
C335	VGND#6	VGND#7	9.00874e-17
C336	VPWR#9	RESET_B#7	2.92234e-19
C337	a_695_457##2	RESET_B#7	2.64099e-17
C338	a_306_74##5	RESET_B#2	1.11847e-19
C339	a_1266_74##3	a_1266_74##5	7.63518e-18
C340	a_306_74##14	CLK#2	3.24921e-17
C341	D#3	RESET_B#4	2.67031e-17
C342	a_30_78##4	CLK#1	1.90553e-17
C343	a_695_457##2	a_830_359#	2.06814e-18
C344	a_830_359##5	a_306_74##2	2.34606e-18
C345	VGND#6	VGND#5	1.45144e-16
C346	VPWR#10	VPWR#13	6.78738e-17
C347	VPWR#10	a_306_74##2	1.14564e-17
C348	a_306_74##14	RESET_B#2	8.36528e-18
C349	VPWR#11	a_306_74##3	1.42286e-18
C350	a_1518_203##5	VPWR#3	1.96365e-17
C351	VGND#6	VGND#4	6.95303e-18
C352	VPWR#10	VPWR#11	7.46418e-17
C353	VPWR#10	a_695_457#	2.07238e-18
C354	a_1266_74##10	a_695_457#	5.02891e-20
C355	a_30_78#	a_695_457##6	2.8376e-18
C356	VGND#3	RESET_B#20	7.24001e-20
C357	VGND#6	a_306_74##2	5.78272e-19
C358	RESET_B#15	a_306_74##8	2.47081e-18
C359	VPWR#1	a_1864_409##4	4.94415e-17
C360	CLK#2	a_306_74##6	4.19082e-17
C361	RESET_B#10	a_1266_74##6	1.33963e-17
C362	VPWR#10	VPWR#8	7.81081e-17
C363	a_1266_74##8	a_1468_493#	2.2183e-18
C364	VPWR#10	RESET_B#8	2.52433e-18
C365	a_30_78##5	RESET_B#2	8.50753e-18
C366	VPWR#15	a_30_78##4	8.32703e-19
C367	a_830_359##2	RESET_B#7	4.93836e-18
C368	a_1864_409##5	Q#3	5.33682e-17
C369	a_30_78##4	RESET_B#4	1.59002e-17
C370	a_1266_74#	a_1864_409#	5.02258e-18
C371	VGND#10	VGND#1	6.11257e-19
C372	a_30_78##6	a_306_74##6	1.82606e-19
C373	VPWR#10	VPWR#6	1.15306e-16
C374	VPWR#10	a_830_359##3	3.16574e-18
C375	VPWR#7	a_1468_493#	8.61119e-21
C376	a_1864_409##4	Q#1	9.24603e-18
C377	a_830_359##2	a_830_359#	1.32804e-17
C378	a_830_359##5	VPWR#7	4.92392e-18
C379	a_1518_203##2	RESET_B#10	2.77876e-17
C380	a_1266_74##8	VPWR#6	1.18594e-17
C381	a_490_366#	a_830_359##2	1.54469e-17
C382	a_1266_74##3	a_306_74##2	9.76473e-20
C383	VPWR#1	a_1266_74##5	5.32865e-19
C384	a_1518_203##5	a_1518_203##7	3.06392e-18
C385	RESET_B#2	CLK#2	1.51521e-17
C386	a_1864_409##7	a_1864_409##4	7.23474e-19
C387	VPWR#10	a_490_366##3	6.32359e-18
C388	VGND#6	a_306_74##8	6.37169e-19
C389	VPWR#14	RESET_B#2	1.78149e-18
C390	VPWR#2	a_1864_409##2	3.4411e-20
C391	VPWR#15	D#2	3.2287e-18
C392	VGND#2	a_1864_409##3	8.55065e-19
C393	a_30_78##4	D#3	1.15937e-17
C394	VPWR#10	a_306_74##7	4.7799e-18
C395	a_1266_74##8	VPWR#4	2.05123e-17
C396	VPWR#8	a_306_74##3	3.41235e-17
C397	VPWR#3	a_1864_409##4	6.86828e-19
C398	a_306_74##9	a_490_366##2	2.54836e-17
C399	RESET_B#18	VPWR#2	3.62699e-17
C400	a_1266_74##2	a_1864_409##4	3.04056e-19
C401	a_490_366##7	a_1518_203##2	2.56108e-17
C402	a_1266_74##4	a_1266_74#	4.17402e-18
C403	a_306_74##2	a_1518_203#	8.02825e-19
C404	VPWR#10	CLK#1	4.6571e-18
C405	VGND#11	VGND#2	4.57779e-19
C406	CLK	a_306_74##6	4.48693e-20
C407	a_1266_74##5	a_1864_409##7	3.26028e-17
C408	a_830_359##4	VPWR#6	7.07247e-18
C409	VGND#3	RESET_B#18	1.70658e-18
C410	a_1518_203##7	a_1864_409##4	5.14632e-20
C411	VPWR#10	RESET_B#4	5.13749e-19
C412	CLK	RESET_B#2	2.20151e-19
C413	a_306_74##5	a_306_74##9	2.48763e-19
C414	a_490_366##7	a_306_74##2	2.74189e-17
C415	VGND#10	a_1864_409##5	4.2723e-17
C416	VGND#4	a_1266_74##3	1.16287e-18
C417	VPWR#3	a_1266_74##5	4.81523e-17
C418	a_306_74##5	a_306_74##10	1.10125e-17
C419	VPWR#10	D#3	2.87699e-18
C420	a_695_457##6	a_306_74##6	7.45632e-20
C421	a_306_74##5	CLK#3	9.45933e-21
C422	a_1864_409##7	a_1266_74##6	3.81217e-19
C423	a_490_366##4	a_306_74##2	4.56915e-17
C424	VPWR#8	RESET_B#6	4.66151e-19
C425	a_1518_203##7	a_1266_74##5	1.71293e-18
C426	RESET_B#9	a_1266_74##4	5.29883e-17
C427	a_30_78##2	a_306_74##9	2.20598e-19
C428	a_306_74##6	a_306_74##3	1.92762e-19
C429	RESET_B#18	VPWR#10	3.98731e-18
C430	a_695_457##2	a_306_74##2	1.94548e-18
C431	VPWR#3	a_1266_74##6	1.66589e-17
C432	VGND#3	a_1864_409##2	2.17469e-22
C433	a_1518_203##4	a_1864_409##5	1.40504e-18
C434	VPWR#6	a_306_74##3	3.5174e-18
C435	VPWR#5	a_1266_74##5	5.73148e-19
C436	VPWR#3	a_1266_74##2	6.0348e-19
C437	a_695_457##2	a_695_457#	4.44026e-19
C438	a_1266_74##2	a_1864_409#	1.46283e-19
C439	VGND#3	a_1266_74##2	3.16891e-18
C440	RESET_B#5	a_306_74##2	1.02942e-18
C441	VGND#4	RESET_B#10	1.4385e-19
C442	a_490_366##14	a_894_138#	2.24781e-19
C443	a_1518_203##7	a_1266_74##6	3.66036e-17
C444	a_695_457##8	VPWR#8	2.30089e-18
C445	RESET_B#5	a_695_457#	5.47341e-19
C446	D	RESET_B#2	5.1789e-18
C447	VPWR#3	RESET_B#11	1.28175e-18
C448	RESET_B#20	a_1518_203##7	4.27693e-17
C449	RESET_B#15	VPWR#10	8.15252e-17
C450	VPWR#5	a_1266_74##6	1.44192e-18
C451	a_1864_409##3	VPWR#2	7.31148e-18
C452	a_1518_203##3	RESET_B#9	1.84784e-17
C453	a_1266_74##3	RESET_B#18	2.14753e-17
C454	a_1518_203##4	VGND#10	3.50429e-17
C455	a_1518_203##7	RESET_B#11	2.48813e-17
C456	a_695_457##8	VPWR#6	1.95576e-18
C457	D#2	RESET_B#3	3.48839e-18
C458	VGND#3	a_1864_409##3	4.13453e-18
C459	a_1266_74##3	VPWR#4	8.64933e-20
C460	a_1518_203##5	a_1864_409##3	4.87809e-17
C461	VPWR#2	a_1266_74##3	3.91421e-18
C462	RESET_B#15	a_695_457##6	3.27865e-17
C463	VPWR#6	RESET_B#6	1.57492e-18
C464	RESET_B#18	RESET_B#10	6.31301e-18
C465	VPWR#3	VPWR#1	1.15194e-18
C466	D#2	RESET_B#2	7.67953e-17
C467	a_830_359##5	a_816_138#	2.90842e-20
C468	a_695_457##6	a_695_457##5	6.07388e-18
C469	RESET_B#20	VPWR#4	7.17485e-19
C470	VPWR#3	a_1518_203##2	3.60088e-19
C471	VPWR#10	a_490_366##11	7.88797e-19
C472	a_695_457##6	a_306_74##3	3.24459e-18
C473	a_695_457##9	a_306_74##8	2.69766e-19
C474	VGND#3	a_1266_74##3	1.08559e-17
C475	a_490_366##11	a_490_366#	1.62086e-19
C476	RESET_B#15	a_695_457##5	2.91721e-17
C477	VGND#4	a_1518_203#	2.09734e-18
C478	RESET_B#11	VPWR#5	1.47627e-17
C479	RESET_B#18	a_1518_203#	6.89662e-18
C480	a_306_74##8	a_830_359##2	3.94133e-18
C481	a_1266_74##4	a_1656_81#	8.8457e-18
C482	VGND#5	VGND#12	7.14839e-18
C483	a_1266_74##8	a_1266_74##6	1.90246e-19
C484	a_695_457##9	a_816_138#	1.80047e-18
C485	a_1518_203##7	a_1518_203##2	8.66239e-19
C486	RESET_B#20	VPWR#5	1.46159e-17
C487	VPWR#2	a_1518_203#	7.61949e-20
C488	RESET_B#9	a_1656_81#	8.8457e-18
C489	a_1266_74#	a_1266_74##2	6.45731e-18
C490	a_490_366##3	a_830_359##2	8.11201e-19
C491	RESET_B#18	a_490_366##7	4.68959e-17
C492	a_490_366##14	a_816_138#	5.42539e-19
C493	Q	a_1864_409##2	1.24358e-17
C494	a_306_74#	a_1518_203##3	3.29895e-17
C495	Q	a_1266_74##2	4.94684e-19
C496	a_490_366##2	a_306_74##8	5.76459e-18
C497	VGND#3	a_1518_203#	5.9362e-18
C498	VPWR#2	a_490_366##7	2.4263e-18
C499	a_1518_203##2	VPWR#5	1.81324e-17
C500	RESET_B#18	a_490_366##4	1.4143e-17
C501	a_1518_203##5	a_1266_74##3	9.49719e-17
C502	VPWR#9	VPWR#6	1.18067e-18
C503	RESET_B#15	a_306_74##6	3.2289e-19
C504	VGND#1	a_1864_409#	2.83577e-17
C505	a_695_457##6	RESET_B#6	8.60336e-20
C506	a_1266_74##8	RESET_B#11	8.22344e-20
C507	VGND#3	a_490_366##7	4.37216e-19
C508	VGND#11	VGND#10	1.31518e-18
C509	VPWR#3	a_1864_409##7	5.34719e-17
C510	VGND#3	a_490_366##4	3.17351e-17
C511	RESET_B#15	RESET_B#14	8.98834e-18
C512	a_1518_203##5	a_1864_409##5	5.46277e-18
C513	Q#3	a_1864_409#	4.89273e-17
C514	RESET_B#15	a_306_74##3	7.85413e-19
C515	VPWR#5	a_490_366##6	2.54903e-18
C516	RESET_B#15	a_490_366##4	3.81648e-18
C517	a_695_457##5	a_306_74##3	2.0748e-18
C518	a_490_366##5	a_306_74#	3.25982e-18
C519	a_1266_74##8	a_1518_203##2	2.5457e-17
C520	VGND#1	a_1266_74#	9.96504e-19
C521	a_695_457##6	VPWR#10	1.07263e-17
C522	RESET_B#15	RESET_B#6	1.03795e-18
C523	CLK#2	a_306_74##7	2.092e-18
C524	a_306_74#	a_1476_81#	7.54101e-18
C525	RESET_B#15	a_695_457##2	1.78961e-17
C526	a_1518_203##2	a_1468_493#	8.26061e-18
C527	a_1518_203##5	RESET_B#10	3.99891e-19
C528	a_1266_74##3	RESET_B#20	1.85547e-17
C529	a_1266_74##3	RESET_B#10	6.62434e-17
C530	a_1518_203##7	a_1864_409##7	2.20771e-18
C531	a_1864_409##5	a_1864_409#	1.29713e-18
C532	VPWR#10	a_695_457##5	4.50997e-18
C533	a_695_457##9	a_695_457##7	3.34689e-19
C534	a_490_366##6	a_1468_493#	8.06292e-18
C535	VGND#11	a_1518_203##4	1.5565e-17
C536	a_1266_74##4	a_1266_74##2	3.10525e-18
C537	RESET_B#15	RESET_B#5	1.4517e-17
C538	VGND#5	a_490_366##4	9.29829e-17
C539	VPWR#5	a_306_74##2	1.21383e-18
C540	a_1266_74##3	a_1518_203#	7.32207e-17
C541	Q#3	a_1266_74#	1.60897e-18
C542	VGND#6	a_490_366##4	3.71575e-17
C543	a_1266_74##8	a_490_366##6	2.85176e-17
C544	VPWR#10	a_695_457##2	2.23458e-18
C545	VGND#4	a_490_366##4	6.96106e-17
C546	VGND#10	a_1518_203##5	5.01751e-18
C547	RESET_B#15	a_830_359##2	3.15682e-17
C548	a_1518_203#	RESET_B#10	1.73542e-17
C549	a_490_366##7	a_1266_74##3	1.68856e-17
C550	VPWR#7	a_1518_203##2	4.24187e-19
C551	a_1518_203##5	a_1864_409##2	6.04976e-20
C552	a_695_457##5	RESET_B#6	7.18899e-18
C553	VGND#10	a_1864_409#	3.73683e-19
C554	VGND#6	a_695_457##2	1.08309e-17
C555	VGND#1	a_1266_74##4	3.27949e-19
C556	VPWR#10	RESET_B#5	1.92107e-18
C557	a_1518_203##7	VPWR#3	7.60144e-17
C558	a_695_457##3	a_490_366##5	8.787e-18
C559	a_306_74##12	a_490_366##14	5.49749e-19
C560	a_490_366##4	a_1266_74##3	2.37289e-17
C561	RESET_B#15	a_490_366##2	1.54287e-17
C562	a_1864_409##5	a_1266_74#	4.12384e-17
C563	VGND#6	RESET_B#5	1.23755e-18
C564	VPWR#5	a_695_457#	3.12642e-19
C565	a_30_78##2	VPWR#11	4.77208e-18
C566	VPWR#10	a_830_359##2	1.66411e-18
C567	VGND#3	VGND#1	6.91636e-17
C568	RESET_B#20	RESET_B#10	1.36306e-17
C569	a_1518_203#	a_1518_203##5	3.00977e-18
C570	a_490_366##7	a_1518_203#	8.6406e-19
C571	a_1266_74##8	a_306_74##2	4.39173e-17
C572	a_490_366##4	RESET_B#10	1.99385e-19
C573	VPWR#4	a_490_366##7	4.21958e-19
C574	a_830_359##3	a_785_457#	5.99579e-18
C575	VGND#6	a_830_359##2	5.8741e-18
C576	RESET_B#18	VGND#11	3.17779e-18
C577	VPWR#7	a_490_366##6	5.51176e-19
C578	VPWR#10	RESET_B#14	9.88267e-19
C579	VPWR#10	a_490_366##2	4.92185e-19
C580	VGND#3	Q#3	2.00149e-17
C581	RESET_B#7	a_894_138#	7.06907e-18
C582	a_490_366##4	a_1518_203#	4.47937e-17
C583	a_306_74##8	a_785_457#	6.4829e-18
C584	VGND#5	a_695_457##2	1.41024e-19
C585	RESET_B#6	a_306_74##3	1.10855e-18
C586	VPWR#5	VPWR#3	3.41023e-18
C587	a_830_359#	a_894_138#	7.06907e-18
C588	a_1266_74#	VGND#10	1.49565e-17
C589	a_306_74##2	a_830_359##4	3.64685e-17
C590	VGND#6	a_490_366##2	2.65904e-18
C591	a_30_78#	a_30_78##2	1.1186e-18
C592	VPWR#10	a_30_78##4	1.08757e-17
C593	VPWR#10	a_306_74##5	1.00062e-18
C594	a_1518_203##5	a_1864_409##4	1.34636e-19
C595	VGND#3	a_1864_409##5	1.86217e-17
C596	a_1518_203##5	a_1266_74##2	3.69108e-17
C597	a_306_74##12	VGND#13	6.11643e-17
C598	a_1266_74##8	a_695_457#	9.15002e-19
C599	a_1864_409##5	a_1266_74##4	3.09043e-19
C600	VGND#6	a_306_74##5	5.56472e-18
C601	RESET_B#7	a_695_457##3	1.15917e-17
C602	VPWR#10	CLK#2	4.49541e-19
C603	RESET_B#18	a_1266_74##10	3.87184e-18
C604	VPWR#7	a_306_74##2	5.90569e-18
C605	a_1518_203##4	a_1266_74#	1.44893e-18
C606	a_30_78##5	a_117_78#	1.95017e-18
C607	a_490_366##4	a_695_457##2	1.01858e-18
C608	VGND#6	CLK#2	4.98926e-18
C609	a_30_78##4	VGND#14	2.87001e-19
C610	VPWR#5	a_1518_203##7	3.81342e-17
C611	VPWR#10	a_306_74##6	1.81358e-19
C612	a_695_457#	a_830_359##4	3.13067e-17
C613	VGND#6	RESET_B#14	1.11539e-18
C614	VGND#3	a_1518_203##4	3.28556e-17
C615	a_695_457##8	a_306_74##2	1.5074e-18
C616	VGND#10	a_1266_74##4	1.86574e-18
C617	a_830_359#	a_816_138#	4.48282e-18
C618	a_695_457##2	RESET_B#5	1.55516e-17
C619	VPWR#7	a_695_457#	6.20632e-17
C620	a_490_366#	a_816_138#	7.55747e-18
C621	VPWR#13	VPWR#12	3.68402e-19
C622	VGND#6	D#2	7.58568e-18
C623	a_1518_203##5	a_1266_74##5	8.38224e-18
C624	a_306_74##12	a_306_74##13	7.10364e-18
C625	D	a_30_78##4	5.77918e-17
C626	VPWR#9	a_306_74##2	3.52225e-19
C627	VPWR#10	a_306_74##3	3.69408e-17
C628	a_695_457##5	RESET_B#14	2.88693e-17
C629	a_830_359##2	a_695_457##2	5.37598e-17
C630	a_830_359#	RESET_B#7	4.55527e-17
C631	a_1518_203##4	a_1266_74##4	3.41357e-17
C632	a_490_366##14	a_490_366##12	2.21192e-18
C633	a_695_457##8	a_695_457#	6.48374e-19
C634	VPWR#4	RESET_B#11	4.52888e-18
C635	VGND#6	a_306_74##12	2.18369e-17
C636	a_490_366##4	a_1518_203##5	6.36502e-19
C637	VGND#11	a_1266_74#	2.42066e-19
C638	VGND#10	RESET_B#9	1.37066e-19
C639	VPWR#7	RESET_B#8	4.43894e-18
C640	a_1266_74##10	RESET_B#6	5.54693e-22
C641	VPWR#9	a_695_457#	1.61428e-18
C642	VGND#7	a_490_366##14	1.67428e-17
C643	a_490_366##2	a_830_359##2	1.25379e-17
C644	VGND#4	a_306_74##2	1.84058e-20
C645	a_1266_74##8	a_1518_203##7	3.16971e-18
C646	VGND#3	a_1266_74##10	7.79308e-18
C647	VGND#14	a_306_74##12	4.53418e-17
C648	a_695_457##8	RESET_B#8	1.89371e-17
C649	VGND#5	a_830_359##2	4.30965e-20
C650	VPWR#6	a_1518_203##2	1.89712e-19
C651	a_1518_203##4	RESET_B#9	3.32586e-18
C652	VGND#6	a_306_74##6	3.23947e-18
C653	RESET_B#18	a_1476_81#	1.91633e-18
C654	a_490_366#	a_830_359#	4.62805e-17
C655	VPWR#7	a_830_359##3	5.42902e-19
C656	a_30_78##5	a_30_78##4	7.9194e-19
C657	RESET_B#8	VPWR#9	1.56606e-17
C658	VGND#11	a_1266_74##4	3.1104e-18
C659	VGND#10	a_1518_203##3	1.11806e-19
C660	VGND#4	VGND#2	6.46189e-19
C661	VGND#5	a_490_366##14	6.64067e-17
C662	VPWR#4	a_1518_203##2	2.74611e-18
C663	RESET_B#5	VPWR#6	7.19996e-19
C664	a_695_457##7	a_695_457#	2.3481e-19
C665	a_1266_74##8	VPWR#5	4.12715e-17
C666	a_306_74##5	CLK#2	3.30849e-17
C667	RESET_B#15	a_1266_74##10	1.69358e-22
C668	CLK	a_30_78##2	5.74371e-18
C669	VPWR#7	a_306_74##8	1.91016e-19
C670	CLK	a_490_366##12	6.7123e-18
C671	a_1518_203##4	a_1518_203##3	1.41342e-18
C672	a_830_359##3	VPWR#9	1.65571e-17
C673	RESET_B#15	a_830_359##5	9.89572e-18
C674	a_306_74##14	CLK	5.41101e-18
C675	a_695_457##7	RESET_B#8	4.55719e-19
C676	VPWR#6	a_490_366##6	3.25957e-19
C677	VGND#11	RESET_B#9	1.52753e-17
C678	a_1864_409##3	a_1864_409##2	1.80823e-19
C679	a_306_74##9	a_490_366#	2.52786e-17
C680	VPWR#5	a_830_359##4	2.17305e-20
C681	RESET_B#3	a_117_78#	7.85499e-18
C682	VGND#6	RESET_B#2	1.10179e-18
C683	a_830_359##5	RESET_B#6	9.96755e-19
C684	RESET_B#15	VGND#12	2.38227e-21
C685	D#1	a_117_78#	8.21089e-18
C686	Q	VPWR#1	1.3227e-16
C687	Q	Q#1	1.57676e-17
C688	a_1266_74##2	a_1864_409##3	3.14717e-17
C689	a_1864_409##7	Q	8.89582e-17
C690	a_1864_409##2	VNB	4.87525e-17
C691	VPWR#3	Q	3.31293e-18
C692	a_1266_74##2	VNB	4.50071e-17
C693	a_306_74##6	VNB	1.20486e-16
C694	VPWR#4	a_490_366##6	6.59398e-18
C695	a_306_74##3	VNB	1.54747e-16
C696	RESET_B#6	VNB	6.27842e-17
C697	VPWR#9	a_306_74##8	2.50809e-18
C698	RESET_B#2	VNB	1.18994e-16
C699	a_30_78##5	a_306_74##12	9.08659e-18
C700	a_695_457##7	a_830_359##3	4.48521e-19
C701	a_1518_203##4	a_306_74#	6.95141e-20
C702	D	VPWR#15	1.92937e-17
C703	RESET_B#20	a_1266_74##6	1.47968e-18
C704	Q#3	a_1864_409##3	3.45774e-17
C705	VGND#11	a_1518_203##3	2.78531e-17
C706	VGND#7	a_306_74##5	4.04769e-19
C707	a_30_78##2	a_830_359##3	2.47495e-19
C708	a_306_74##10	a_306_74##9	2.88774e-18
C709	a_30_78##4	a_306_74##6	2.0275e-19
C710	RESET_B#15	a_695_457##9	2.79163e-18
C711	a_830_359##5	a_1266_74##10	8.1695e-17
C712	VPWR#9	a_490_366##3	6.32217e-19
C713	VPWR#6	a_306_74##2	5.18474e-17
C714	a_30_78##6	VPWR#13	1.65854e-17
C715	a_306_74##12	a_306_74##9	6.15771e-20
C716	a_695_457##7	a_306_74##8	2.31329e-17
C717	RESET_B#14	a_306_74##3	4.98927e-20
C718	RESET_B#15	a_30_78#	5.05137e-18
C719	a_830_359##4	a_1266_74##8	9.62787e-17
C720	VGND#10	a_1864_409##3	3.3558e-18
C721	a_830_359##2	a_894_138#	2.07635e-19
C722	VPWR#4	a_306_74##2	9.06597e-19
C723	a_30_78##2	a_306_74##8	2.52827e-18
C724	VGND#11	a_306_74#	4.32699e-18
C725	RESET_B#15	a_490_366##14	8.4524e-18
C726	VPWR#9	a_306_74##7	9.69672e-19
C727	VPWR#12	a_830_359##3	2.0926e-19
C728	VGND#7	VNB	3.7293e-17
C729	VGND#5	VNB	7.88933e-17
C730	VGND#4	VNB	6.31314e-17
C731	VGND#2	VNB	4.00659e-17
C732	a_695_457##7	a_490_366##3	2.11158e-17
C733	VPWR#13	VNB	3.62647e-17
C734	RESET_B#6	a_306_74##2	1.04798e-18
C735	VPWR#11	VNB	3.80841e-17
C736	a_1266_74##3	a_1266_74##2	7.66418e-18
C737	VPWR#8	VNB	2.86379e-17
C738	a_830_359##2	a_816_138#	8.38899e-19
C739	VPWR#6	VNB	4.75773e-17
C740	VGND#6	a_1266_74##10	8.69178e-18
C741	VPWR#4	VNB	5.5695e-17
C742	CLK	a_306_74##7	1.7561e-18
C743	CLK#3	a_306_74##10	2.40838e-17
C744	RESET_B#18	a_1864_409##7	1.16042e-18
C745	CLK	CLK#1	1.76056e-18
C746	VPWR#7	a_1266_74##8	3.94436e-18
C747	a_1518_203##5	VNB	8.3099e-18
C748	VPWR#2	VPWR#1	8.73883e-17
C749	Q	a_1864_409##4	2.92898e-17
C750	a_306_74##12	a_306_74##10	1.08565e-18
C751	VGND#7	CLK#2	4.77932e-20
C752	RESET_B#20	VNB	9.36642e-19
C753	Q	a_1266_74##5	5.04139e-18
C754	a_695_457##6	VPWR#8	4.94207e-18
C755	RESET_B#14	RESET_B#6	7.62018e-18
C756	VPWR#6	a_695_457#	1.58338e-18
C757	a_30_78##2	a_490_366##3	2.17063e-17
C758	VGND#2	a_1864_409#	6.72285e-19
C759	VGND#6	a_830_359##5	1.71155e-17
C760	VPWR#15	VPWR#13	7.06672e-19
C761	VPWR#12	a_306_74##8	5.89768e-19
C762	a_695_457##6	VNB	6.02526e-18
C763	a_695_457##5	VNB	2.04241e-18
C764	RESET_B#14	VNB	1.7268e-18
C765	a_30_78##4	VNB	1.1773e-17
C766	VGND#11	a_490_366##5	1.23916e-20
C767	a_306_74##12	VNB	1.37274e-17
C768	a_490_366##12	a_490_366##3	2.17442e-19
C769	VPWR#10	CLK	1.2712e-18
C770	VGND#1	VNB	7.90359e-17
C771	Q#3	VNB	2.20357e-17
C772	RESET_B#18	a_1518_203##7	5.06635e-18
C773	a_1864_409##5	VNB	1.10985e-17
C774	a_830_359##5	VGND#12	3.933e-18
C775	VPWR#7	a_830_359##4	8.45297e-17
C776	VGND#10	VNB	6.58537e-18
C777	a_1864_409##7	VPWR#2	2.04466e-17
C778	a_1518_203##4	VNB	8.19616e-18
C779	a_306_74#	a_1266_74##10	1.31248e-17
C780	VGND#11	VNB	1.12697e-18
C781	VGND#3	VPWR#1	5.55873e-18
C782	VGND#4	a_1266_74#	2.14841e-19
C783	a_1266_74##10	VNB	1.93121e-18
C784	a_830_359##5	VNB	8.04648e-18
C785	a_30_78##2	a_306_74##7	2.95911e-17
C786	a_830_359##4	RESET_B#6	2.11307e-19
C787	VPWR#10	D	7.82018e-18
C788	a_695_457##9	VNB	5.08261e-18
C789	VPWR#8	RESET_B#8	3.20364e-18
C790	a_30_78#	VNB	4.16735e-18
C791	a_695_457##2	a_695_457##5	3.38258e-19
C792	RESET_B#3	CLK#3	4.55057e-18
C793	a_490_366##14	VNB	3.92575e-17
C794	VPWR#12	a_490_366##3	1.17639e-18
C795	VGND#13	VNB	2.67347e-18
C796	RESET_B#18	VPWR#5	2.84331e-17
C797	Q	VPWR#2	5.00549e-17
C798	VGND#14	VNB	7.92287e-18
C799	a_306_74##12	CLK#3	3.79948e-17
C800	VGND#3	Q	2.35927e-18
C801	a_30_78##5	VNB	2.81408e-17
C802	VPWR#1	VNB	9.55644e-17
C803	a_1864_409##7	VNB	5.30683e-18
C804	VPWR#3	VNB	2.82591e-18
C805	a_1518_203##7	VNB	4.1029e-18
C806	VPWR#5	VNB	6.82558e-18
C807	a_306_74##7	a_490_366##12	2.49648e-17
C808	a_1266_74##8	VNB	1.72751e-18
C809	a_830_359##4	VNB	2.06576e-18
C810	a_830_359##5	a_306_74#	8.83441e-20
C811	VPWR#7	VNB	5.48973e-18
C812	a_695_457##5	VPWR#8	1.18759e-18
C813	a_695_457##8	VNB	2.15931e-18
C814	Q	a_1864_409##3	6.59629e-17
C815	VPWR#9	VNB	9.37109e-18
C816	VPWR#11	CLK#2	7.77886e-20
C817	a_1518_203##7	VPWR#2	2.63215e-17
C818	a_695_457##7	VNB	6.67552e-19
C819	VGND#2	a_1266_74#	6.90323e-18
C820	a_30_78##2	VNB	1.41845e-17
C821	VGND#6	a_695_457##9	1.12761e-17
C822	a_490_366##12	VNB	7.41355e-19
C823	a_306_74##14	VNB	2.43871e-18
C824	CLK	CLK#2	8.42821e-19
C825	a_30_78##2	CLK#1	1.07618e-17
C826	VPWR#14	VNB	3.69344e-18
C827	RESET_B#6	a_695_457#	1.14592e-17
C828	a_30_78##6	VNB	2.15803e-18
C829	VPWR#15	VNB	5.67496e-17
C830	a_1864_409#	VNB	3.65152e-17
C831	a_1266_74##10	a_490_366##5	4.6785e-17
C832	a_1266_74#	VNB	4.47608e-17
C833	VPWR#12	a_306_74##7	3.97186e-17
C834	a_1266_74##4	VNB	3.66676e-17
C835	RESET_B#9	VNB	3.88726e-17
C836	a_1518_203##3	VNB	2.3272e-17
C837	a_306_74#	VNB	5.85732e-17
C838	RESET_B#18	a_1266_74##8	9.09306e-17
C839	a_490_366##5	VNB	4.45766e-17
C840	VGND#6	a_30_78#	1.05495e-17
C841	a_695_457##3	VNB	3.41093e-17
C842	VPWR#14	a_490_366##3	1.00522e-19
C843	RESET_B#7	VNB	3.64558e-17
C844	a_830_359#	VNB	3.01751e-17
C845	a_490_366#	VNB	4.7681e-17
C846	D	D#2	3.42349e-17
C847	a_306_74##9	VNB	3.63476e-17
C848	VPWR#7	a_306_74##3	9.7767e-20
C849	a_306_74##10	VNB	2.92396e-17
C850	CLK#3	VNB	3.08305e-17
C851	a_490_366##12	CLK#1	2.3673e-18
C852	RESET_B#3	VNB	3.04829e-17
C853	D#1	VNB	3.239e-17
C854	VGND#11	RESET_B#10	3.87994e-19
C855	a_695_457##2	RESET_B#14	1.00973e-17
C856	D#1	RESET_B#3	3.49467e-17
C857	a_1864_409##4	VNB	3.42124e-17
C858	a_1266_74##5	VNB	4.04412e-17
C859	a_306_74##14	a_306_74##7	2.43578e-18
C860	a_306_74##12	RESET_B#3	2.57658e-18
C861	a_1266_74##6	VNB	3.9087e-17
C862	VGND#6	a_490_366##14	1.47607e-16
C863	RESET_B#11	VNB	2.6515e-17
C864	a_1518_203##2	VNB	4.21709e-17
C865	a_490_366##6	VNB	2.68694e-17
C866	a_695_457##8	VPWR#7	2.21563e-17
C867	VPWR#8	a_830_359##3	3.21436e-18
C868	a_306_74##2	VNB	1.43272e-16
C869	VGND#3	a_1518_203##7	6.76102e-19
C870	a_695_457#	VNB	3.94437e-17
C871	RESET_B#8	VNB	2.67098e-17
C872	a_695_457##5	a_830_359##4	7.3536e-19
C873	a_490_366##5	a_830_359##5	1.78499e-17
C874	a_30_78##2	RESET_B#4	4.17526e-19
C875	a_830_359##3	VNB	1.95753e-17
C876	a_306_74##8	VNB	2.66038e-17
C877	a_490_366##3	VNB	2.32582e-17
C878	a_306_74##7	VNB	3.58928e-17
C879	VPWR#12	CLK#1	3.61457e-17
C880	CLK#1	VNB	4.62097e-17
C881	RESET_B#4	VNB	3.22515e-17
C882	D#3	VNB	4.58634e-17
C883	RESET_B#18	VNB	6.50977e-18
C884	a_306_74##12	a_306_74##6	2.95414e-19
C885	VPWR#2	VNB	2.59774e-16
C886	VPWR#14	a_306_74##7	2.28955e-19
C887	VGND#3	VNB	2.43847e-16
C888	VPWR#2	a_1266_74##8	2.73195e-17
C889	RESET_B#15	VNB	9.85164e-18
C890	a_1266_74##10	a_695_457##3	1.24582e-18
C891	VPWR#10	VNB	2.98696e-16
C892	VGND#6	VNB	3.64752e-16
C893	a_490_366##5	a_306_74##2	1.36531e-17
C894	a_1864_409##3	VNB	6.33855e-17
C895	a_1266_74##3	VNB	7.4619e-17
C896	VPWR#7	RESET_B#6	7.24414e-18
C897	RESET_B#10	VNB	5.94947e-17
C898	a_1518_203#	VNB	5.91414e-17
C899	a_490_366##7	VNB	3.19241e-17
C900	VGND#2	a_1266_74##4	1.19887e-18
C901	a_490_366##4	VNB	6.32818e-17
C902	a_306_74##14	CLK#1	3.67278e-17
C903	a_695_457##2	VNB	4.81999e-17
C904	RESET_B#5	VNB	5.29755e-18
C905	a_830_359##2	VNB	4.92192e-17
C906	a_490_366##2	VNB	5.30056e-17
C907	a_306_74##5	VNB	3.96234e-18
C908	a_695_457##6	a_830_359##2	4.19022e-17
C909	CLK#2	VNB	4.25278e-17
C910	a_30_78##6	a_306_74##7	3.12631e-19
C911	VPWR#9	VPWR#7	7.19297e-18
C912	VGND#7	a_306_74##12	1.01534e-17
C913	D#2	VNB	1.45042e-16
C914	RESET_B#8	a_306_74##3	1.89482e-17
C915	a_1518_203#	VGND#11	4.08959e-17
C916	a_30_78##4	RESET_B#2	2.89163e-17
C917	VPWR#12	RESET_B#4	3.33325e-18
C918	a_830_359##2	a_695_457##5	4.79779e-17
C919	a_830_359##5	a_695_457##3	4.39877e-17
C920	VPWR#14	CLK#1	5.51097e-18
C921	a_695_457##5	VPWR#7	4.20634e-18
C922	CLK	VNB	3.30996e-18
C923	VGND#1	VPWR#1	1.3848e-17
C924	D	VNB	2.44751e-17
C925	VGND#4	RESET_B#9	5.57289e-18
C926	Q	VNB	3.80406e-17
C927	a_695_457##9	a_830_359##5	5.89769e-20
C928	a_1518_203#	a_1266_74##2	7.38853e-20
C929	a_30_78##6	CLK#1	1.23569e-18
C930	RESET_B	a_306_74##5	9.74995e-18
C931	RESET_B	a_30_78##2	2.79404e-17
C932	RESET_B	VPWR#13	1.41307e-18
C933	VPWR#10	RESET_B	5.55566e-17
C934	VGND#8	D#2	1.42193e-18
C935	RESET_B	a_306_74##6	6.5123e-18
C936	RESET_B	a_490_366##2	5.34938e-19
C937	VGND#8	a_306_74##10	2.70911e-19
C938	a_30_78##4	RESET_B	1.11547e-16
C939	RESET_B	VGND#13	4.51785e-18
C940	RESET_B	VPWR#14	3.73943e-18
C941	RESET_B	a_490_366##11	8.51067e-18
C942	VGND#8	a_30_78##5	2.4455e-17
C943	VGND#8	D#1	6.31227e-18
C944	RESET_B	D	4.25e-18
C945	VGND#8	RESET_B#2	8.168e-19
C946	RESET_B	a_490_366##14	2.66505e-18
C947	RESET_B	RESET_B#2	4.04382e-17
C948	RESET_B	a_306_74##14	8.91382e-17
C949	RESET_B	VNB	2.00388e-17
C950	RESET_B	CLK	1.42272e-17
C951	VGND#8	VGND#7	1.18259e-18
C952	RESET_B	CLK#3	9.02547e-20
C953	a_30_78##5	RESET_B	3.3302e-17
C954	VGND#8	CLK#3	1.47028e-18
C955	RESET_B	CLK#1	2.17804e-18
C956	RESET_B	VPWR#12	8.57979e-18
C957	RESET_B	a_306_74##7	2.41717e-18
C958	VGND#8	VGND#13	1.2455e-18
C959	VGND#8	a_306_74##12	1.04821e-17
C960	RESET_B	a_490_366##12	3.07666e-17
C961	RESET_B	CLK#2	5.83474e-18
C962	VGND#6	VGND#8	1.23645e-16
C963	VGND#8	VNB	6.6673e-17
C964	RESET_B	VPWR#11	4.83924e-18
C965	RESET_B	a_306_74##12	3.97801e-17
C966	VGND#6	RESET_B	3.20544e-18
C967	RESET_B	VGND#14	1.84768e-17
C968	VGND#8	RESET_B#3	1.08127e-17
*
*
.ENDS sky130_fd_sc_hs__dfrtp_1
*
