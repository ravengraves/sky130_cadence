* Extracted by Quantus, converted by sky130cad/quantus.py
*
*
*
*                       LINUX           Wed Nov 18 08:50:45 2026
*
*
*
*  PROGRAM  advgen
*
*  Name           : advgen - Quantus - (64-bit)
*  Version        : 25.1.0-p047
*  Build Date     : Thu Dec 11 23:20:30 PST 2025
*
*  HSPICE LIBRARY
*
*  OPERATING_TEMPERATURE 150
*  QRC_TECH_DIR <path>/tech
*
*
*

*
.SUBCKT sky130_fd_sc_hs__nor3b_2 VPB VNB VGND VPWR Y B A C_N
*
*
*  caps2d version: 10
*
*
*       TRANSISTOR CARDS
*
*
XM12 a_27_392##10 C_N#3 VGND#8 VNB sky130_fd_pr__nfet_01v8_lvt l=0.15 w=0.64 ad=0.1824 as=0.2938 pd=1.85 ps=2.32
XM0 Y#4 a_27_392##4 VGND#8 VNB sky130_fd_pr__nfet_01v8_lvt l=0.15 w=0.74 ad=0.2183 as=0.2938 pd=2.07 ps=2.32
XM2 VGND#7 a_27_392##5 Y#4 VNB sky130_fd_pr__nfet_01v8_lvt l=0.15 w=0.74 ad=0.5328 as=0.2183 pd=2.92 ps=2.07
XM1 Y#2 B#4 VGND#7 VNB sky130_fd_pr__nfet_01v8_lvt l=0.15 w=0.74 ad=0.2072 as=0.5328 pd=2.04 ps=2.92
XM4 VGND#4 B#5 Y#2 VNB sky130_fd_pr__nfet_01v8_lvt l=0.15 w=0.74 ad=0.6216 as=0.2072 pd=3.16 ps=2.04
XM13 VGND#4 A#5 Y#1 VNB sky130_fd_pr__nfet_01v8_lvt l=0.15 w=0.74 ad=0.6216 as=0.2442 pd=3.16 ps=2.14
XM5 Y#1 A#6 VGND#1 VNB sky130_fd_pr__nfet_01v8_lvt l=0.15 w=0.74 ad=0.2442 as=0.2257 pd=2.14 ps=2.09
XM8 a_27_392##9 C_N#1 VPWR#7 VPB sky130_fd_pr__pfet_01v8 l=0.15 w=1 ad=0.29 as=0.29 pd=2.58 ps=2.58
XM3 Y#5 a_27_392##6 a_227_368##3 VPB sky130_fd_pr__pfet_01v8 l=0.15 w=1.12 ad=0.336 as=0.3248 pd=2.84 ps=2.82
XM9 a_227_368##4 a_27_392# Y#5 VPB sky130_fd_pr__pfet_01v8 l=0.15 w=1.12 ad=0.336 as=0.336 pd=2.84 ps=2.84
XM11 a_227_368##4 B#6 a_495_368##2 VPB sky130_fd_pr__pfet_01v8 l=0.15 w=1.12 ad=0.336 as=0.336 pd=2.84 ps=2.84
XM7 a_495_368##2 B#1 a_227_368# VPB sky130_fd_pr__pfet_01v8 l=0.15 w=1.12 ad=0.336 as=0.3248 pd=2.84 ps=2.82
XM6 a_495_368# A#7 VPWR#6 VPB sky130_fd_pr__pfet_01v8 l=0.15 w=1.12 ad=0.336 as=0.3248 pd=2.84 ps=2.82
XM10 VPWR#1 A#1 a_495_368# VPB sky130_fd_pr__pfet_01v8 l=0.15 w=1.12 ad=0.3248 as=0.336 pd=2.82 ps=2.84
*
*
*       RESISTOR AND CAP/DIODE CARDS
*
Rg1	C_N#1	C_N#2	407.404541
Rg2	C_N#2	C_N#3	466.933014
Rg3	a_27_392#	a_27_392##2	572.199768
Rg4	a_27_392##2	a_27_392##3	55.134548
Rg5	a_27_392##3	a_27_392##4	301.631989
Rg6	a_27_392##2	a_27_392##5	319.959229
Rg7	a_27_392##2	a_27_392##6	504.081116
Rg8	B#1	B#2	419.438019
Rg9	B#2	B#3	82.677444
Rg10	B#3	B#4	397.555725
Rg11	B#2	B#5	369.283997
Rg12	B#3	B#6	449.655212
Rg13	A#1	A#2	449.655212
Rg14	A#2	A#3	36.503117
Rg15	A#3	A#4	16.832588
Rg16	A#4	A#5	391.985748
Rg17	A#2	A#6	397.555725
Rg18	A#4	A#7	451.084564
Rf1	C_N#2	C_N#5	161.032593
Rf2	C_N#6	C_N	0.799792
Rf3	C_N#5	C_N#6	5.117745
Rf4	a_27_392##3	a_27_392##8	216.973953
Rf5	a_27_392##8	a_27_392##9	87.013222
Rf6	a_27_392##8	a_27_392##10	26.169874
Rf7	a_227_368#	a_227_368##2	88.702446
Rf8	a_227_368##2	a_227_368##3	85.613640
Rf9	a_227_368##2	a_227_368##4	28.251745
Rf10	B#2	B#8	81.607719
Rf11	B#9	B	1.491315
Rf12	B#8	B#9	5.500849
Rf13	Y#1	Y#3	123.176834
Rf14	Y#3	Y	16.105774
Rf15	Y	Y#4	37.199383
Rf16	Y	Y#5	99.104309
Rf17	Y#2	Y#3	7.500000
Rf18	a_495_368#	a_495_368##3	129.364502
Rf19	a_495_368##3	a_495_368##2	39.383251
Rf20	a_495_368##2	a_495_368##3	15.000000
Rf21	A	A#8	1.680815
Rf22	A#8	A	12.988117
Rf23	VPWR#1	VPWR#2	109.131935
Rf24	VPWR#2	VPWR#3	89.462326
Rf25	VPWR#3	VPWR#4	122.335045
Rf27	VPWR#2	VPWR#6	32.715752
Rf28	VPWR#4	VPWR#7	35.727165
Rf29	VGND#1	VGND#2	118.326241
Rf30	VGND#2	VGND#3	66.761253
Rf31	VGND#2	VGND#4	15.339460
Rf32	VGND#3	VGND#5	124.051735
Rf34	VGND#3	VGND#7	16.471745
Rf35	VGND#5	VGND#8	31.141060
Rf39	A#3	A#8	80.116402
Re1	VPWR#3	VPWR	0.982218
Re2	VGND	VGND#3	0.982254
*
*       CAPACITOR CARDS
*
*
C1	Y#1	a_495_368##2	2.48566e-18
C2	VGND	VNB	5.5305e-17
C3	VPWR	VNB	7.18588e-17
C4	Y	VNB	3.9767e-18
C5	B	VNB	7.16845e-18
C6	A	VNB	3.57251e-17
C7	VGND	Y	9.52869e-18
C8	C_N	VNB	1.19306e-18
C9	VGND	B	1.81403e-18
C10	VGND	A	8.17524e-18
C11	VGND	C_N	1.09487e-18
C12	VPWR	B	1.80882e-18
C13	C_N#2	VNB	5.77457e-17
C14	a_27_392##3	VNB	9.20219e-17
C15	VPWR	A	7.63514e-18
C16	B#2	VNB	5.37116e-17
C17	a_27_392##10	VGND#8	5.21682e-17
C18	VPWR	C_N	1.03564e-18
C19	VGND#3	VNB	2.00127e-16
C20	VPWR#3	VNB	2.44001e-16
C21	C_N#1	VNB	3.70324e-17
C22	a_27_392##6	VNB	4.42357e-17
C23	B	A	3.4781e-17
C24	VGND	a_27_392##3	6.93031e-18
C25	B#3	a_495_368##2	2.05988e-18
C26	a_27_392#	VNB	4.64317e-17
C27	VGND	B#2	2.80443e-18
C28	B#6	VNB	3.38353e-17
C29	B#1	VNB	3.48649e-17
C30	A#7	VNB	2.97007e-17
C31	A#1	VNB	3.98174e-17
C32	VPWR	C_N#2	4.63624e-21
C33	C_N#3	VNB	4.23418e-17
C34	VPWR	a_27_392##3	6.72986e-18
C35	a_27_392##4	VNB	2.79059e-17
C36	a_27_392##5	VNB	2.32402e-17
C37	VPWR	B#2	2.56855e-18
C38	B#4	VNB	2.52729e-17
C39	B#5	VNB	3.04314e-17
C40	A#5	VNB	2.82865e-17
C41	A#6	VNB	3.23384e-17
C42	a_27_392##9	VNB	5.39521e-17
C43	Y	a_27_392##3	5.44362e-17
C44	a_27_392##8	a_227_368##3	1.89832e-18
C45	VPWR#7	VNB	1.63596e-17
C46	VPWR	VPWR#3	2.56012e-17
C47	a_227_368##3	VNB	1.64258e-17
C48	Y	B#2	4.2028e-18
C49	Y#5	VNB	6.48433e-18
C50	a_227_368##4	VNB	1.80677e-18
C51	VPWR	C_N#1	2.08385e-18
C52	a_495_368##2	VNB	7.6822e-18
C53	a_227_368#	VNB	1.18484e-17
C54	VGND	C_N#3	1.17338e-18
C55	VPWR	a_27_392##6	2.00486e-18
C56	VPWR#6	VNB	9.02381e-18
C57	a_495_368#	VNB	2.3049e-18
C58	VGND	a_27_392##4	1.65204e-18
C59	VPWR	a_27_392#	1.60245e-18
C60	VPWR#1	VNB	7.2544e-17
C61	a_27_392##10	VNB	3.01907e-17
C62	VGND	a_27_392##5	7.03421e-19
C63	B	B#2	1.16711e-17
C64	VGND#8	VNB	3.88865e-18
C65	VPWR	B#6	1.59909e-18
C66	VGND	B#4	4.4539e-19
C67	Y#4	VNB	2.24109e-18
C68	VGND#7	VNB	4.69744e-17
C69	VGND	B#5	2.77813e-19
C70	VPWR	B#1	2.09293e-18
C71	Y#2	VNB	7.38679e-18
C72	VGND	A#5	4.59023e-19
C73	VPWR	A#7	1.09279e-18
C74	VGND#2	B#4	2.33667e-18
C75	VPWR#2	A#4	4.09423e-20
C76	Y#1	VNB	8.52507e-18
C77	VGND	A#6	5.37002e-19
C78	C_N	C_N#2	5.76212e-18
C79	VPWR	A#1	2.14265e-18
C80	VGND#1	VNB	6.82806e-17
C81	A	B#2	6.83287e-18
C82	C_N#5	VNB	2.05182e-18
C83	VGND	a_227_368##3	3.37872e-18
C84	a_27_392##3	C_N	3.25886e-17
C85	a_27_392##8	VNB	4.16114e-17
C86	a_227_368##2	VNB	4.55533e-18
C87	VGND	a_227_368##4	3.73171e-18
C88	a_27_392##3	B#3	2.0195e-17
C89	VGND#8	Y#4	5.28449e-17
C90	a_27_392##8	Y#5	3.85016e-19
C91	VPWR#2	VNB	4.11172e-17
C92	VGND	a_27_392##10	1.78137e-17
C93	VGND	VGND#8	2.20563e-17
C94	VGND#2	VNB	4.89007e-17
C95	VPWR	a_27_392##9	1.45598e-17
C96	Y	C_N#3	2.20162e-19
C97	VGND	Y#4	1.4657e-17
C98	VPWR	VPWR#7	2.20596e-17
C99	VGND	VGND#7	6.74648e-17
C100	Y	a_27_392##4	8.84477e-19
C101	VGND	Y#2	1.66138e-17
C102	VPWR	a_227_368##3	2.31214e-17
C103	Y	a_27_392##5	1.63407e-17
C104	B	A#7	1.72349e-19
C105	VPWR	Y#5	6.61998e-18
C106	VGND	Y#1	1.66995e-17
C107	Y	B#4	1.65459e-17
C108	VGND	VGND#1	4.07103e-17
C109	VGND	C_N#5	1.27714e-18
C110	VPWR	a_495_368##2	1.22041e-17
C111	Y	B#5	1.28671e-19
C112	VPWR	a_227_368#	2.10032e-17
C113	Y	A#5	6.87431e-20
C114	a_227_368##2	Y#5	1.05476e-17
C115	VPWR	VPWR#6	2.21326e-17
C116	C_N	a_27_392##6	1.37339e-18
C117	A	B#1	1.12921e-19
C118	VGND#2	B#5	2.49166e-17
C119	VGND#8	VGND#7	2.0858e-18
C120	VGND	a_27_392##8	9.41582e-19
C121	VPWR	a_495_368#	1.55233e-17
C122	A	A#7	2.09002e-18
C123	VPWR	VPWR#1	3.58917e-17
C124	C_N	a_27_392#	5.88185e-19
C125	A	A#1	5.01154e-18
C126	C_N#2	a_27_392##3	2.36919e-17
C127	Y	a_227_368##4	1.15368e-17
C128	VGND	VGND#2	8.67125e-17
C129	B#2	a_27_392##3	2.31746e-18
C130	VPWR	C_N#5	1.97789e-18
C131	VGND#7	Y#4	3.39814e-17
C132	a_227_368##2	a_227_368##4	3.36709e-18
C133	a_27_392##10	Y	1.77777e-19
C134	VPWR	a_227_368##2	2.42714e-17
C135	VGND#2	A#5	2.67961e-17
C136	Y	VGND#7	7.08151e-17
C137	B	a_495_368##2	2.83378e-17
C138	VGND#1	VPWR#1	3.45202e-19
C139	VPWR#3	a_27_392##3	5.12409e-20
C140	VPWR	VPWR#2	3.09895e-17
C141	Y#4	Y#2	1.34544e-18
C142	VPWR#3	B#2	1.1053e-20
C143	B#2	B#3	1.17025e-17
C144	C_N#2	a_27_392##6	1.99567e-18
C145	A	a_495_368##2	8.69522e-18
C146	a_227_368##2	a_495_368##2	1.68599e-17
C147	a_27_392##8	Y	1.62222e-18
C148	C_N	VPWR#7	2.10105e-17
C149	Y#2	B	2.20931e-17
C150	A	a_495_368#	6.92142e-17
C151	B#2	A#4	9.92504e-18
C152	C_N	Y#5	5.48667e-18
C153	VGND#2	A#6	2.37652e-18
C154	B#3	VNB	2.58822e-17
C155	a_27_392##3	a_27_392#	6.66949e-18
C156	A	VPWR#1	3.43677e-17
C157	A#4	VNB	6.86148e-17
C158	VGND#7	Y#2	3.90414e-17
C159	B#2	a_27_392##6	3.67201e-19
C160	B#2	a_27_392#	1.26814e-18
C161	B#2	B#6	1.69271e-18
C162	Y#1	A	6.04215e-17
C163	B#2	B#1	2.02322e-18
C164	VGND#1	A	3.22855e-17
C165	C_N#3	a_27_392##3	1.60992e-18
C166	VPWR#3	a_27_392#	4.48043e-18
C167	a_27_392##3	a_27_392##4	5.30486e-18
C168	Y#2	VGND#4	1.05624e-18
C169	VPWR#3	B#6	4.46413e-18
C170	C_N#1	a_27_392##6	5.72999e-18
C171	a_27_392##3	a_27_392##5	1.40016e-18
C172	VPWR#3	B#1	4.464e-18
C173	a_27_392##3	B#4	4.89839e-18
C174	A#4	VPWR#6	6.14695e-19
C175	a_27_392##9	C_N#2	1.14879e-18
C176	a_27_392##8	C_N	5.91158e-18
C177	Y#2	Y#1	2.70804e-18
C178	a_27_392##6	a_27_392#	4.95801e-17
C179	A	VPWR#2	9.92199e-20
C180	VPWR#7	C_N#2	5.02762e-18
C181	a_227_368##3	C_N#2	3.83349e-19
C182	VGND#2	A	1.23691e-20
C183	Y#5	C_N#2	1.12938e-18
C184	a_27_392##3	VPWR#7	2.56624e-18
C185	a_27_392#	B#6	4.62692e-17
C186	Y#1	VGND#4	2.23267e-19
C187	a_27_392##3	a_227_368##3	2.78913e-17
C188	a_27_392##8	a_27_392##10	2.06008e-19
C189	Y#5	a_27_392##3	1.00428e-17
C190	B#6	B#1	4.5928e-17
C191	VGND#2	A#4	9.52127e-20
C192	Y#5	B#2	6.26781e-18
C193	VGND#8	a_27_392##8	1.21963e-17
C194	A#4	a_495_368#	3.92642e-18
C195	VGND#8	C_N#2	1.52024e-18
C196	B#2	a_495_368##2	4.33988e-17
C197	B#1	A#7	5.30011e-18
C198	a_495_368##2	VPWR#2	1.16947e-18
C199	Y#1	VGND#1	6.949e-17
C200	B#2	a_227_368#	2.26814e-18
C201	VGND#8	a_27_392##3	2.95978e-17
C202	A#7	A#1	4.66922e-17
C203	a_27_392##3	Y#4	3.43939e-17
C204	a_227_368##3	VPWR#3	8.85572e-18
C205	a_227_368#	VPWR#2	2.19942e-17
C206	a_27_392##3	VGND#7	3.0142e-18
C207	C_N#5	C_N#2	1.12527e-17
C208	a_27_392##9	C_N#1	2.77278e-17
C209	VPWR#7	C_N#1	6.65241e-17
C210	VGND#7	B#2	2.44833e-20
C211	VPWR#3	B#3	1.13558e-20
C212	Y#2	B#2	3.60365e-17
C213	a_27_392##9	a_27_392##6	1.5959e-19
C214	a_227_368#	VPWR#3	2.30838e-17
C215	a_227_368##3	C_N#1	2.3877e-18
C216	a_27_392##8	C_N#2	2.15224e-17
C217	VPWR#7	a_27_392##6	2.81019e-18
C218	Y	B#3	1.87387e-18
C219	a_227_368##2	B#3	8.58444e-20
C220	a_227_368##3	a_27_392##6	9.11335e-17
C221	Y	A#4	1.26745e-19
C222	VPWR#3	VPWR#1	2.47834e-17
C223	VPWR#7	a_27_392#	1.86789e-19
C224	a_27_392##6	Y#5	3.09124e-17
C225	a_27_392##8	a_27_392##3	2.61411e-18
C226	a_495_368#	VPWR#2	1.40113e-17
C227	C_N#3	a_27_392##4	2.15922e-17
C228	a_227_368##2	a_27_392##3	7.53735e-20
C229	a_227_368##3	a_27_392#	2.33594e-18
C230	VGND#3	VGND#7	5.91916e-17
C231	a_227_368##4	a_27_392##6	2.73446e-18
C232	VPWR#7	B#6	6.57738e-20
C233	a_27_392#	Y#5	2.78128e-17
C234	a_227_368##4	a_27_392#	4.91228e-17
C235	VPWR#7	B#1	4.57606e-20
C236	VPWR#2	VPWR#1	1.02439e-18
C237	a_27_392##4	a_27_392##5	3.51715e-17
C238	a_227_368##2	B#2	7.43985e-21
C239	Y#5	B#6	3.06027e-19
C240	a_495_368##2	a_27_392#	1.37582e-18
C241	VPWR#6	a_27_392##6	4.19266e-20
C242	VGND#3	VGND#1	2.83756e-17
C243	B#6	a_227_368##4	1.89796e-17
C244	a_227_368#	a_27_392#	3.1786e-19
C245	Y#5	B#1	1.36848e-19
C246	a_495_368##2	B#6	4.71569e-17
C247	VPWR#6	a_27_392#	6.85395e-20
C248	a_27_392##5	B#4	6.21787e-18
C249	a_227_368##4	B#1	2.36139e-18
C250	B	A#4	4.20507e-18
C251	a_227_368#	B#6	7.36593e-19
C252	a_495_368##2	B#1	6.15987e-17
C253	VPWR#6	B#6	1.91368e-19
C254	a_227_368##4	A#7	5.26618e-19
C255	a_27_392##8	C_N#5	5.73857e-17
C256	a_227_368#	B#1	4.58196e-17
C257	VPWR#2	B#2	1.75174e-19
C258	B#4	B#5	4.14787e-17
C259	a_495_368##2	A#7	4.16411e-19
C260	VPWR#6	B#1	2.2729e-18
C261	a_227_368##4	A#1	2.77259e-19
C262	a_227_368#	A#7	1.38813e-18
C263	a_495_368#	B#1	3.40392e-19
C264	VGND#2	B#2	1.9705e-18
C265	a_495_368##2	A#1	2.06379e-19
C266	a_227_368##2	VPWR#3	6.27988e-17
C267	VPWR#6	A#7	6.91831e-17
C268	B#5	A#5	3.36153e-18
C269	a_495_368#	A#7	3.50196e-17
C270	A	A#4	4.38221e-17
C271	VPWR#6	A#1	2.87304e-18
C272	VPWR#1	A#7	1.26362e-18
C273	a_495_368#	A#1	5.37149e-17
C274	A#5	A#6	3.29555e-17
C275	A#1	VPWR#1	3.29898e-17
C276	VGND#3	VGND#2	6.12986e-17
C277	VPWR#3	VPWR#2	5.21209e-17
C278	a_27_392##10	C_N#3	2.89103e-17
C279	a_27_392##9	VPWR#7	7.65386e-17
C280	VGND#7	VGND#2	4.16802e-18
C281	VGND#7	B#3	4.76064e-20
C282	a_227_368##2	a_27_392#	2.71461e-17
C283	C_N#3	VGND#8	2.73833e-17
C284	a_27_392##9	a_227_368##3	1.05192e-18
C285	a_27_392##10	a_27_392##4	7.61926e-20
C286	VPWR#7	a_227_368##3	8.65979e-17
C287	a_227_368##2	B#6	1.92713e-17
C288	a_27_392##4	VGND#8	2.21891e-17
C289	VGND#2	Y#2	8.00747e-17
C290	VGND#7	C_N#3	4.81498e-19
C291	a_27_392#	B#3	1.23823e-17
C292	a_27_392##10	a_27_392##5	2.81245e-20
C293	Y#4	a_27_392##4	3.43259e-17
C294	VGND#8	a_27_392##5	1.26817e-18
C295	VGND#7	a_27_392##4	1.55704e-18
C296	a_227_368##3	Y#5	8.20993e-17
C297	Y#4	a_27_392##5	2.42983e-17
C298	VGND#2	VGND#4	9.14009e-18
C299	Y#2	a_27_392##4	1.04534e-19
C300	Y#2	B#3	3.24975e-18
C301	VGND#7	a_27_392##5	3.94499e-17
C302	a_227_368##3	a_227_368##4	4.93988e-18
C303	Y#4	B#4	4.29321e-19
C304	Y#2	a_27_392##5	3.99872e-19
C305	VGND#2	Y#1	8.80644e-17
C306	Y#5	a_227_368##4	6.73742e-17
C307	VGND#7	B#4	4.21856e-17
C308	Y#4	B#5	1.2128e-19
C309	Y#2	B#4	3.67623e-17
C310	VGND#7	B#5	1.90752e-18
C311	VGND#2	VGND#1	2.91001e-18
C312	a_227_368##4	a_495_368##2	7.11485e-17
C313	Y#2	B#5	3.59434e-17
C314	Y#1	B#4	1.80679e-19
C315	a_27_392##8	C_N#3	1.79771e-17
C316	a_227_368##4	a_227_368#	4.02424e-18
C317	B#5	VGND#4	2.39221e-17
C318	Y#2	A#5	6.14415e-19
C319	Y#1	B#5	6.06892e-19
C320	a_227_368#	a_495_368##2	8.56056e-17
C321	A#5	VGND#4	2.39221e-17
C322	VPWR#2	A#7	1.84214e-18
C323	a_27_392##8	a_27_392##4	6.80745e-19
C324	Y#2	A#6	3.67967e-19
C325	a_227_368##4	a_495_368#	2.89268e-21
C326	a_495_368##2	VPWR#6	1.20795e-17
C327	Y#1	A#5	4.22727e-17
C328	a_27_392##8	a_27_392##5	2.56636e-19
C329	VGND#1	A#5	3.12159e-18
C330	VPWR#2	A#1	2.56237e-18
C331	a_495_368##2	a_495_368#	1.32159e-18
C332	a_227_368#	VPWR#6	5.78759e-17
C333	A#6	Y#1	2.09336e-17
C334	Y#4	a_227_368##3	4.32131e-18
C335	VGND#1	A#6	4.24257e-17
C336	Y#5	B#3	1.40221e-18
C337	a_495_368#	VPWR#6	8.02668e-17
C338	Y#1	A#4	3.56648e-18
C339	VPWR#6	VPWR#1	1.64534e-18
C340	a_495_368#	VPWR#1	8.19749e-17
C341	C_N#5	VPWR#7	1.70344e-17
C342	Y#2	a_495_368##2	6.24324e-18
C343	a_27_392##8	a_27_392##9	4.89457e-18
C344	VGND#5	C_N#3	2.73385e-18
C345	VGND#5	a_27_392##8	1.93187e-19
C346	VPWR#4	VNB	5.90048e-17
C347	VGND#3	VGND#5	5.44064e-17
C348	a_227_368##3	VPWR#4	3.68474e-17
C349	a_27_392##3	VPWR#4	1.1994e-18
C350	VPWR#4	C_N#1	4.16693e-18
C351	VGND#5	VNB	4.84386e-17
C352	a_27_392##9	VPWR#4	1.88053e-17
C353	VGND#5	a_27_392##4	5.05876e-18
C354	VGND#5	Y#4	5.93829e-18
C355	VPWR#3	VPWR#4	6.79165e-17
C356	VPWR#4	a_27_392##6	4.46319e-18
C357	C_N#5	VPWR#4	4.63486e-19
C358	VGND#5	a_27_392##10	2.25361e-17
C359	VGND#5	a_27_392##3	7.01675e-19
C360	VPWR	VPWR#4	4.17515e-17
C361	VGND	VGND#5	3.52833e-17
C362	VGND#5	VGND#7	1.1403e-18
*
*
.ENDS sky130_fd_sc_hs__nor3b_2
*
