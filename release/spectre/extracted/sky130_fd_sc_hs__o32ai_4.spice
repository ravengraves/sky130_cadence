* Extracted by Quantus, converted by sky130cad/quantus.py
*
*
*
*                       LINUX           Wed Nov 18 09:03:33 2026
*
*
*
*  PROGRAM  advgen
*
*  Name           : advgen - Quantus - (64-bit)
*  Version        : 25.1.0-p047
*  Build Date     : Thu Dec 11 23:20:30 PST 2025
*
*  HSPICE LIBRARY
*
*  OPERATING_TEMPERATURE 150
*  QRC_TECH_DIR <path>/tech
*
*
*

*
.SUBCKT sky130_fd_sc_hs__o32ai_4 VNB VPB VGND VPWR Y A2 A1 B2 B1 A3
*
*
*  caps2d version: 10
*
*
*       TRANSISTOR CARDS
*
*
XM39 a_27_74##13 B2#10 Y#7 VNB sky130_fd_pr__nfet_01v8_lvt l=0.15 w=0.74 ad=0.2109 as=0.2072 pd=2.05 ps=2.04
XM17 Y#7 B2#8 a_27_74##20 VNB sky130_fd_pr__nfet_01v8_lvt l=0.15 w=0.74 ad=0.2072 as=0.259 pd=2.04 ps=2.18
XM26 Y#13 B2#6 a_27_74##20 VNB sky130_fd_pr__nfet_01v8_lvt l=0.15 w=0.74 ad=0.2183 as=0.259 pd=2.07 ps=2.18
XM2 a_27_74##19 B2#1 Y#13 VNB sky130_fd_pr__nfet_01v8_lvt l=0.15 w=0.74 ad=0.2479 as=0.2183 pd=2.15 ps=2.07
XM3 Y#12 B1#12 a_27_74##19 VNB sky130_fd_pr__nfet_01v8_lvt l=0.15 w=0.74 ad=0.259 as=0.2479 pd=2.18 ps=2.15
XM14 a_27_74##18 B1#8 Y#12 VNB sky130_fd_pr__nfet_01v8_lvt l=0.15 w=0.74 ad=0.259 as=0.259 pd=2.18 ps=2.18
XM24 Y#11 B1#6 a_27_74##18 VNB sky130_fd_pr__nfet_01v8_lvt l=0.15 w=0.74 ad=0.259 as=0.259 pd=2.18 ps=2.18
XM30 a_27_74##8 B1#1 Y#11 VNB sky130_fd_pr__nfet_01v8_lvt l=0.15 w=0.74 ad=0.259 as=0.259 pd=2.18 ps=2.18
XM35 a_27_74##8 A3#7 VGND#14 VNB sky130_fd_pr__nfet_01v8_lvt l=0.15 w=0.74 ad=0.259 as=0.3546 pd=2.18 ps=2.56
XM18 VGND#14 A3#11 a_27_74##17 VNB sky130_fd_pr__nfet_01v8_lvt l=0.15 w=0.74 ad=0.3546 as=0.2553 pd=2.56 ps=2.17
XM38 VGND#13 A3#10 a_27_74##17 VNB sky130_fd_pr__nfet_01v8_lvt l=0.15 w=0.74 ad=0.2109 as=0.2553 pd=2.05 ps=2.17
XM13 a_27_74##5 A3#8 VGND#13 VNB sky130_fd_pr__nfet_01v8_lvt l=0.15 w=0.74 ad=0.5252 as=0.2109 pd=2.91 ps=2.05
XM4 a_27_74##5 A2#11 VGND#12 VNB sky130_fd_pr__nfet_01v8_lvt l=0.15 w=0.74 ad=0.5252 as=0.3108 pd=2.91 ps=2.32
XM29 VGND#12 A2#8 a_27_74##16 VNB sky130_fd_pr__nfet_01v8_lvt l=0.15 w=0.74 ad=0.3108 as=0.2072 pd=2.32 ps=2.04
XM25 a_27_74##16 A2#6 VGND#11 VNB sky130_fd_pr__nfet_01v8_lvt l=0.15 w=0.74 ad=0.2072 as=0.3108 pd=2.04 ps=2.32
XM8 VGND#11 A2#1 a_27_74##15 VNB sky130_fd_pr__nfet_01v8_lvt l=0.15 w=0.74 ad=0.3108 as=0.259 pd=2.32 ps=2.18
XM21 VGND#10 A1#12 a_27_74##15 VNB sky130_fd_pr__nfet_01v8_lvt l=0.15 w=0.74 ad=0.259 as=0.259 pd=2.18 ps=2.18
XM15 VGND#10 A1#10 a_27_74##14 VNB sky130_fd_pr__nfet_01v8_lvt l=0.15 w=0.74 ad=0.259 as=0.2072 pd=2.18 ps=2.04
XM22 a_27_74##14 A1#8 VGND#4 VNB sky130_fd_pr__nfet_01v8_lvt l=0.15 w=0.74 ad=0.2072 as=0.259 pd=2.04 ps=2.18
XM9 a_27_74# A1#6 VGND#4 VNB sky130_fd_pr__nfet_01v8_lvt l=0.15 w=0.74 ad=0.2627 as=0.259 pd=2.19 ps=2.18
XM31 Y#9 B2#12 a_27_368##6 VPB sky130_fd_pr__pfet_01v8 l=0.15 w=1.12 ad=0.336 as=0.3304 pd=2.84 ps=2.83
XM0 a_27_368##8 B2#11 Y#9 VPB sky130_fd_pr__pfet_01v8 l=0.15 w=1.12 ad=0.336 as=0.336 pd=2.84 ps=2.84
XM10 a_27_368##8 B2#7 Y#14 VPB sky130_fd_pr__pfet_01v8 l=0.15 w=1.12 ad=0.336 as=0.336 pd=2.84 ps=2.84
XM28 Y#14 B2#5 a_27_368##3 VPB sky130_fd_pr__pfet_01v8 l=0.15 w=1.12 ad=0.336 as=0.336 pd=2.84 ps=2.84
XM16 a_27_368##3 B1#14 VPWR#9 VPB sky130_fd_pr__pfet_01v8 l=0.15 w=1.12 ad=0.336 as=0.336 pd=2.84 ps=2.84
XM19 a_27_368##7 B1#13 VPWR#9 VPB sky130_fd_pr__pfet_01v8 l=0.15 w=1.12 ad=0.336 as=0.336 pd=2.84 ps=2.84
XM23 VPWR#7 B1#9 a_27_368##7 VPB sky130_fd_pr__pfet_01v8 l=0.15 w=1.12 ad=0.3472 as=0.336 pd=2.86 ps=2.84
XM33 VPWR#7 B1#5 a_27_368# VPB sky130_fd_pr__pfet_01v8 l=0.15 w=1.12 ad=0.3472 as=0.3304 pd=2.86 ps=2.83
XM11 Y#1 A3#13 a_861_368##5 VPB sky130_fd_pr__pfet_01v8 l=0.15 w=1.12 ad=0.336 as=0.3304 pd=2.84 ps=2.83
XM6 a_861_368##8 A3#12 Y#1 VPB sky130_fd_pr__pfet_01v8 l=0.15 w=1.12 ad=0.336 as=0.336 pd=2.84 ps=2.84
XM32 a_861_368##8 A3#9 Y#10 VPB sky130_fd_pr__pfet_01v8 l=0.15 w=1.12 ad=0.336 as=0.336 pd=2.84 ps=2.84
XM34 Y#10 A3#1 a_861_368##7 VPB sky130_fd_pr__pfet_01v8 l=0.15 w=1.12 ad=0.336 as=0.448 pd=2.84 ps=3.04
XM20 a_861_368##7 A2#13 a_1330_368##4 VPB sky130_fd_pr__pfet_01v8 l=0.15 w=1.12 ad=0.448 as=0.336 pd=3.04 ps=2.84
XM7 a_861_368##6 A2#12 a_1330_368##4 VPB sky130_fd_pr__pfet_01v8 l=0.15 w=1.12 ad=0.392 as=0.336 pd=2.94 ps=2.84
XM12 a_1330_368##6 A2#7 a_861_368##6 VPB sky130_fd_pr__pfet_01v8 l=0.15 w=1.12 ad=0.392 as=0.392 pd=2.94 ps=2.94
XM27 a_1330_368##6 A2#5 a_861_368# VPB sky130_fd_pr__pfet_01v8 l=0.15 w=1.12 ad=0.392 as=0.3864 pd=2.94 ps=2.93
XM5 a_1330_368##5 A1#13 VPWR#5 VPB sky130_fd_pr__pfet_01v8 l=0.15 w=1.12 ad=0.336 as=0.3304 pd=2.84 ps=2.83
XM1 VPWR#4 A1#9 a_1330_368##5 VPB sky130_fd_pr__pfet_01v8 l=0.15 w=1.12 ad=0.448 as=0.336 pd=3.04 ps=2.84
XM36 VPWR#4 A1#7 a_1330_368# VPB sky130_fd_pr__pfet_01v8 l=0.15 w=1.12 ad=0.448 as=0.336 pd=3.04 ps=2.84
XM37 a_1330_368# A1#1 VPWR#1 VPB sky130_fd_pr__pfet_01v8 l=0.15 w=1.12 ad=0.336 as=0.3304 pd=2.84 ps=2.83
*
*
*       RESISTOR AND CAP/DIODE CARDS
*
Rg1	B2#1	B2#2	397.555725
Rg2	B2#2	B2#3	66.369736
Rg3	B2#3	B2#4	57.428749
Rg4	B2#2	B2#5	449.655212
Rg5	B2#3	B2#6	394.377136
Rg6	B2#3	B2#7	447.198364
Rg7	B2#4	B2#8	385.636414
Rg8	B2#4	B2#9	90.033310
Rg9	B2#9	B2#10	397.555725
Rg10	B2#4	B2#11	429.126801
Rg11	B2#9	B2#12	449.655212
Rg12	B1#1	B1#2	402.492584
Rg13	B1#2	B1#3	52.969254
Rg14	B1#3	B1#4	48.941441
Rg15	B1#2	B1#5	419.554810
Rg16	B1#3	B1#6	372.847198
Rg17	B1#4	B1#7	32.314770
Rg18	B1#7	B1#8	401.438538
Rg19	B1#4	B1#9	429.126801
Rg20	B1#7	B1#10	20.616657
Rg21	B1#10	B1#11	67.149261
Rg22	B1#11	B1#12	408.557617
Rg23	B1#10	B1#13	419.554810
Rg24	B1#11	B1#14	453.216797
Rg25	A3#1	A3#2	446.302460
Rg26	A3#2	A3#3	47.905842
Rg27	A3#3	A3#4	25.491310
Rg28	A3#4	A3#5	59.357647
Rg29	A3#5	A3#6	73.490227
Rg30	A3#6	A3#7	512.949829
Rg31	A3#2	A3#8	372.847198
Rg32	A3#3	A3#9	390.783234
Rg33	A3#4	A3#10	377.411346
Rg34	A3#5	A3#11	375.854645
Rg35	A3#5	A3#12	427.954132
Rg36	A3#6	A3#13	416.207306
Rg37	A2#1	A2#2	417.258026
Rg38	A2#2	A2#3	53.112595
Rg39	A2#3	A2#4	59.244587
Rg40	A2#2	A2#5	419.554810
Rg41	A2#3	A2#6	370.752045
Rg42	A2#4	A2#7	429.126801
Rg43	A2#4	A2#8	377.027313
Rg44	A2#4	A2#9	57.284767
Rg45	A2#9	A2#10	51.607704
Rg46	A2#10	A2#11	374.096069
Rg47	A2#9	A2#12	419.554810
Rg48	A2#10	A2#13	462.695465
Rg49	A1#1	A1#2	556.728394
Rg50	A1#2	A1#3	27.502531
Rg51	A1#3	A1#4	61.830250
Rg52	A1#4	A1#5	45.833405
Rg53	A1#2	A1#6	374.383392
Rg54	A1#3	A1#7	390.783234
Rg55	A1#4	A1#8	370.752045
Rg56	A1#5	A1#9	429.126801
Rg57	A1#5	A1#10	377.027313
Rg58	A1#5	A1#11	58.549522
Rg59	A1#11	A1#12	433.848450
Rg60	A1#11	A1#13	419.554810
Rf1	B2	B2#13	4.094411
Rf2	B2#13	B2	13.772109
Rf3	a_27_368#	a_27_368##2	77.204956
Rf4	a_27_368##2	a_27_368##4	70.753075
Rf5	a_27_368##4	a_27_368##5	84.145554
Rf6	a_27_368##5	a_27_368##6	81.982613
Rf7	a_27_368##2	a_27_368##7	14.409969
Rf8	a_27_368##5	a_27_368##8	21.341251
Rf9	a_27_368##3	a_27_368##4	7.500000
Rf10	B1	B1#15	15.633204
Rf11	B1#15	B1	2.233315
Rf12	A3	A3#14	16.005423
Rf13	A3#14	A3	1.861096
Rf14	Y#1	Y#2	16.278900
Rf15	Y#2	Y#3	57.006226
Rf16	Y#3	Y#4	220.090927
Rf17	Y#4	Y#5	73.001427
Rf18	Y#5	Y#6	70.136757
Rf19	Y#6	Y#7	91.751038
Rf20	Y#2	Y#8	238.826050
Rf21	Y#8	Y#9	90.920380
Rf22	Y#3	Y#10	20.177185
Rf23	Y#4	Y#11	24.075169
Rf24	Y#5	Y#12	24.075169
Rf25	Y#6	Y#13	26.794743
Rf26	Y#8	Y#15	8.779915
Rf27	Y#15	Y	2.460454
Rf28	Y#14	Y#15	7.500000
Rf29	a_861_368#	a_861_368##2	87.519394
Rf30	a_861_368##2	a_861_368##3	72.642242
Rf31	a_861_368##3	a_861_368##4	69.842804
Rf32	a_861_368##4	a_861_368##5	89.080147
Rf33	a_861_368##2	a_861_368##6	18.149860
Rf34	a_861_368##3	a_861_368##7	22.856937
Rf35	a_861_368##4	a_861_368##8	28.306047
Rf36	A2	A2#14	12.224110
Rf37	A2#14	A2	2.444822
Rf38	a_1330_368#	a_1330_368##2	87.971939
Rf39	a_1330_368##2	a_1330_368##3	110.257187
Rf40	a_1330_368##3	a_1330_368##4	86.089958
Rf41	a_1330_368##2	a_1330_368##5	18.602406
Rf42	a_1330_368##3	a_1330_368##6	16.279915
Rf43	a_27_74#	a_27_74##2	87.519394
Rf44	a_27_74##2	a_27_74##3	73.001427
Rf45	a_27_74##3	a_27_74##4	73.001427
Rf46	a_27_74##4	a_27_74##6	88.505867
Rf47	a_27_74##6	a_27_74##7	68.750130
Rf48	a_27_74##7	a_27_74##9	75.818977
Rf49	a_27_74##9	a_27_74##10	77.657356
Rf50	a_27_74##10	a_27_74##11	73.001427
Rf51	a_27_74##11	a_27_74##12	67.887894
Rf52	a_27_74##12	a_27_74##13	93.451416
Rf53	a_27_74##2	a_27_74##14	18.149860
Rf54	a_27_74##3	a_27_74##15	18.149860
Rf55	a_27_74##4	a_27_74##16	18.149860
Rf56	a_27_74##7	a_27_74##17	10.866916
Rf57	a_27_74##10	a_27_74##18	23.287825
Rf58	a_27_74##11	a_27_74##19	23.287825
Rf59	a_27_74##12	a_27_74##20	23.287825
Rf60	a_27_74##5	a_27_74##6	5.000000
Rf61	a_27_74##8	a_27_74##9	15.000000
Rf62	A1	A1#14	2.444822
Rf63	A1#14	A1	12.224110
Rf64	VPWR#1	VPWR#2	115.911690
Rf65	VPWR#2	VPWR#3	67.912430
Rf66	VPWR#2	VPWR#4	31.534731
Rf67	VPWR#3	VPWR#5	43.353802
Rf68	VPWR#3	VPWR#6	405.722443
Rf69	VPWR#6	VPWR#7	53.972439
Rf70	VPWR#6	VPWR#8	60.729954
Rf71	VPWR#8	VPWR#9	48.224632
Rf74	VGND#2	VGND#3	84.275742
Rf75	VGND#2	VGND#4	35.098007
Rf76	VGND#3	VGND#5	63.894653
Rf77	VGND#5	VGND#6	73.001427
Rf78	VGND#6	VGND#7	98.203850
Rf79	VGND#7	VGND#8	73.731934
Rf80	VGND#8	VGND#9	94.210602
Rf81	VGND#3	VGND#10	38.595905
Rf82	VGND#5	VGND#11	35.098007
Rf83	VGND#6	VGND#12	35.098007
Rf84	VGND#7	VGND#13	31.161278
Rf85	VGND#8	VGND#14	28.011898
Rf87	B1#4	B1#15	32.046562
Rf88	A3#5	A3#14	53.410934
Rf90	A1#5	A1#14	40.058201
Rf89	A2#4	A2#14	32.046562
Rf86	B2#4	B2#13	40.058201
Re1	VPWR#3	VPWR	2.377092
Re2	VPWR	VPWR#6	1.528131
Re3	VGND#3	VGND	2.377092
Re4	VGND	VGND#9	1.528131
*
*       CAPACITOR CARDS
*
*
C1	a_1330_368#	A1#1	5.53366e-17
C2	a_27_368##5	Y#14	7.19279e-19
C3	Y#8	B1#9	8.61052e-18
C4	Y#3	a_27_74##5	3.0853e-17
C5	B1#10	VPWR#7	1.28784e-18
C6	VPWR#1	A1#7	1.23062e-18
C7	VPWR#4	A1#1	1.46384e-18
C8	Y#3	B1#5	2.06439e-19
C9	a_27_368##3	a_27_368##2	2.94218e-18
C10	A2#1	A1#12	3.053e-17
C11	a_27_74##4	A2#8	2.18263e-17
C12	Y#2	B1#5	1.57101e-17
C13	a_27_74#	VGND#4	5.54871e-17
C14	B1#10	A3#7	1.67662e-18
C15	a_861_368##3	A2#10	7.81191e-20
C16	a_1330_368#	A1#7	6.41821e-17
C17	a_27_74##7	A2#11	1.43045e-19
C18	A1#3	a_1330_368#	2.97352e-18
C19	VPWR#1	A1#9	2.57768e-19
C20	A1#7	VPWR#4	3.20013e-17
C21	a_1330_368##3	a_861_368##2	1.89277e-17
C22	a_27_368##5	a_27_368##8	5.24145e-20
C23	Y#3	VGND#13	1.76047e-19
C24	Y#8	B1#13	1.29646e-17
C25	a_1330_368#	A1#9	5.19482e-19
C26	a_1330_368##5	A1#7	6.53314e-19
C27	a_1330_368#	VPWR#1	7.81108e-17
C28	A2#6	A2#1	2.18273e-17
C29	a_27_74##7	Y#4	3.86553e-17
C30	a_27_74##14	a_27_74#	2.99118e-18
C31	Y#2	B1#9	4.43443e-18
C32	A3#12	A3#4	2.31942e-19
C33	a_27_368##5	B2#2	8.46999e-20
C34	A1#9	VPWR#4	3.62253e-17
C35	VPWR#5	A1#7	1.72643e-19
C36	a_27_74##7	A3#8	7.79323e-19
C37	a_27_368##2	B1#5	1.45401e-18
C38	a_27_368##5	Y#9	1.03322e-17
C39	B1#10	a_27_368##7	5.48219e-19
C40	a_1330_368##5	A1#9	5.30654e-17
C41	VPWR#2	A1#3	3.77382e-20
C42	VPWR#4	VPWR#1	1.47906e-18
C43	Y#3	a_27_74##17	3.26122e-19
C44	Y#8	B1#14	1.42181e-17
C45	Y#4	VGND#14	1.80233e-19
C46	B1#10	B1#1	3.42806e-19
C47	a_27_74##14	VGND#4	4.52314e-17
C48	VPWR#4	A1#13	1.28756e-18
C49	VPWR#5	A1#9	3.70183e-19
C50	A2#8	A2#6	3.91192e-17
C51	a_861_368##2	A2#10	7.70775e-20
C52	Y#2	B1#13	1.99392e-19
C53	a_27_74##7	Y#3	4.58361e-17
C54	A1#3	VPWR#4	2.61307e-19
C55	a_1330_368##5	A1#13	4.61625e-17
C56	a_1330_368#	VPWR#4	7.06161e-17
C57	a_27_74##7	A3#10	1.97032e-17
C58	a_27_368##2	B1#9	3.51789e-17
C59	VGND#8	a_27_74##7	9.35908e-18
C60	A1#13	VPWR#5	3.63566e-17
C61	VPWR#4	A2#5	8.30684e-20
C62	B1#11	VPWR#9	4.8866e-19
C63	Y#8	B2#5	3.58997e-17
C64	Y#4	a_27_74##8	1.03275e-16
C65	VGND#10	VGND#4	2.31653e-18
C66	A2#11	A2#8	2.18628e-17
C67	a_861_368#	A1#13	1.41052e-18
C68	a_1330_368##5	A2#5	3.03216e-19
C69	a_1330_368##5	a_1330_368#	2.07064e-18
C70	B2#9	B2#4	2.83377e-18
C71	B1#10	VPWR#9	4.87566e-19
C72	a_27_368##2	B1#13	3.14787e-17
C73	VPWR#5	A2#5	1.16395e-18
C74	B2#4	B2#2	2.68295e-18
C75	a_861_368##4	A3#4	6.77032e-20
C76	a_27_74##7	A3#11	3.13287e-17
C77	VGND#7	a_27_74##7	1.04373e-17
C78	VGND#10	a_27_74##14	4.526e-17
C79	a_27_74##10	A3#7	2.01668e-19
C80	a_861_368#	A2#5	5.74426e-17
C81	a_861_368##6	A1#13	1.09084e-19
C82	Y#8	B2#7	2.93862e-17
C83	Y#4	Y#11	2.19486e-18
C84	a_1330_368##5	VPWR#4	6.22197e-17
C85	VPWR#3	VPWR#2	6.98138e-17
C86	A3#8	A2#11	7.98166e-18
C87	Y#5	a_27_74##18	2.34589e-19
C88	a_861_368##2	A2#3	1.71862e-19
C89	VGND#3	VGND#6	7.24932e-17
C90	A2#5	a_1330_368##6	2.54251e-17
C91	B1#10	A3#6	1.39395e-17
C92	VGND#3	VGND#5	8.09845e-17
C93	a_27_368##2	B1#14	1.22713e-18
C94	a_861_368##6	A2#5	2.01137e-18
C95	a_861_368#	A2#7	7.23601e-19
C96	a_27_368##3	B1#11	9.13712e-20
C97	A1#11	VPWR#5	1.87006e-18
C98	VPWR#5	VPWR#4	2.15425e-18
C99	a_27_74##15	a_27_74##14	2.99118e-18
C100	a_27_74##7	A3#7	5.56888e-19
C101	Y#8	B2#11	1.82409e-18
C102	A2#7	a_1330_368##6	1.16921e-17
C103	a_1330_368##4	A2#5	1.98955e-19
C104	a_27_74##10	B1#1	1.07811e-18
C105	A3#10	A3#8	3.90999e-17
C106	Y#5	Y#12	2.03633e-18
C107	a_861_368##6	A2#7	4.87232e-17
C108	Y#6	a_27_74##19	7.71197e-20
C109	VPWR#5	a_1330_368##5	5.30395e-17
C110	a_861_368##3	A3#4	8.74933e-20
C111	a_1330_368##4	A2#7	1.19957e-18
C112	a_27_74##15	VGND#10	4.526e-17
C113	VGND#11	A2#3	1.41971e-18
C114	a_27_74##11	B1#6	2.01668e-19
C115	a_27_74#	A1#6	3.36999e-17
C116	a_27_368##5	B2#7	1.58461e-17
C117	VGND#5	a_27_74##15	7.37096e-18
C118	Y#8	B2#12	4.83341e-19
C119	a_861_368##7	A2#7	3.2757e-19
C120	A2#12	a_861_368##6	2.37687e-17
C121	A3#11	A3#10	2.92847e-17
C122	a_27_74##10	B1#6	3.43044e-17
C123	Y#7	B2#9	7.63933e-18
C124	a_1330_368##2	a_1330_368#	5.43544e-19
C125	a_1330_368##4	A2#12	5.81433e-17
C126	Y#3	A2#6	1.22207e-19
C127	VGND#4	A1#6	3.48647e-17
C128	Y#6	Y#13	4.3434e-19
C129	a_1330_368##3	VPWR#3	1.4712e-17
C130	VGND#11	VGND#10	2.35476e-18
C131	a_861_368##7	A2#12	7.65346e-19
C132	a_861_368##6	A2#13	7.69238e-19
C133	a_27_74#	A1#8	8.5167e-19
C134	a_1330_368##2	VPWR#3	5.81344e-18
C135	a_27_368##5	B2#11	1.64369e-17
C136	a_27_74##11	B1#8	1.07811e-18
C137	a_861_368#	VPWR#5	5.51737e-17
C138	a_27_74##14	A1#6	1.90333e-18
C139	a_1330_368##4	A2#13	4.41183e-17
C140	VGND#3	a_27_74##4	3.55569e-18
C141	A3#7	A3#11	2.0681e-17
C142	Y#13	Y#5	2.40945e-18
C143	VGND#3	a_27_74##3	3.02863e-18
C144	a_27_74##10	B1#8	2.37752e-17
C145	A1#8	VGND#4	1.73767e-17
C146	Y#3	A2#8	1.96261e-19
C147	A2#13	a_861_368##7	2.84554e-17
C148	VGND#6	a_27_74##4	2.25448e-19
C149	a_861_368##6	A3#1	3.34595e-19
C150	a_1330_368##2	VPWR#4	2.493e-17
C151	a_861_368##3	VPWR#3	5.28486e-17
C152	VGND#3	a_27_74##2	3.32101e-18
C153	VGND#11	a_27_74##15	4.526e-17
C154	VGND#6	a_27_74##16	8.48245e-18
C155	VGND#10	A1#6	2.81034e-19
C156	a_27_74##12	B1#12	2.11099e-19
C157	a_861_368##2	VPWR#3	9.68737e-17
C158	VGND#12	A2#10	1.4203e-18
C159	a_1330_368##3	a_1330_368##5	1.11835e-18
C160	a_27_74##14	A1#8	3.83781e-17
C161	a_861_368##8	A2#13	2.70909e-19
C162	B1#1	A3#7	2.74092e-17
C163	A3#1	a_861_368##7	3.32139e-17
C164	a_27_74##13	B2#9	1.50085e-19
C165	a_27_74##11	B1#12	3.42314e-17
C166	VGND#9	a_27_74##12	6.84955e-17
C167	VGND#4	A1#10	7.51478e-19
C168	Y#3	A2#11	1.44133e-18
C169	a_861_368#	a_1330_368##6	2.69038e-19
C170	A3#1	Y#10	2.32494e-17
C171	a_27_74##16	a_27_74##15	3.05636e-18
C172	VGND#9	a_27_74##11	6.79489e-17
C173	VGND#5	a_27_74##16	8.43305e-18
C174	VGND#10	A1#8	4.17478e-19
C175	Y#7	Y#6	8.55542e-20
C176	a_1330_368##2	a_1330_368##5	1.36226e-18
C177	a_27_74##10	B1#12	4.24687e-19
C178	VGND#5	a_27_74##4	2.25448e-19
C179	VGND#9	a_27_74##10	7.21008e-17
C180	a_861_368##8	A3#1	6.21778e-19
C181	a_861_368##7	A3#9	7.37969e-19
C182	a_27_74##12	B2#1	1.19557e-18
C183	a_27_74##14	A1#10	3.32919e-17
C184	A1#5	VPWR#2	8.28148e-20
C185	Y#4	A3#8	7.68916e-20
C186	B1#6	B1#1	2.63925e-17
C187	A3#9	Y#10	2.09011e-17
C188	a_861_368##6	a_861_368#	4.30643e-18
C189	VGND#7	a_27_74##5	1.93638e-17
C190	VGND#4	A1#12	1.89458e-19
C191	VGND#6	A2#4	3.49862e-20
C192	a_27_74##11	B2#1	2.29888e-17
C193	a_27_74##16	VGND#11	4.52314e-17
C194	A3#9	a_861_368##8	2.39014e-17
C195	Y#3	A3#8	7.66067e-18
C196	a_861_368##4	VPWR#6	6.23145e-17
C197	A1#10	VGND#10	1.70721e-17
C198	VGND#5	A2#4	5.42195e-20
C199	a_861_368##7	A3#12	3.22082e-19
C200	a_861_368##3	VPWR#6	2.1267e-17
C201	a_1330_368##2	VPWR#5	3.08132e-17
C202	a_27_74##5	A2#10	3.69556e-18
C203	a_27_74##14	A1#12	1.38142e-18
C204	VGND#5	a_27_74##3	2.25448e-19
C205	B1#8	B1#6	2.63821e-17
C206	Y#4	A3#10	9.26534e-20
C207	a_27_74##15	A1#10	4.89223e-19
C208	a_1330_368##3	a_861_368#	9.42627e-17
C209	a_27_74##12	B2#6	3.36651e-17
C210	a_861_368##5	A3#9	3.00902e-19
C211	A3#12	a_861_368##8	2.73382e-17
C212	VGND#6	a_27_74##5	1.84032e-17
C213	VGND#8	A3#5	4.24824e-20
C214	VGND#12	VGND#11	2.31653e-18
C215	Y#3	a_861_368##4	1.48265e-17
C216	VGND#10	A1#12	3.33368e-17
C217	VGND#7	A3#5	4.86586e-20
C218	A3#12	Y#1	2.32435e-17
C219	Y#3	A3#10	8.12078e-18
C220	a_27_74##11	B2#6	4.56061e-19
C221	A2#3	A1#11	1.37281e-17
C222	a_27_74##12	a_27_74##11	2.8637e-18
C223	a_27_74##3	A1#5	2.65793e-17
C224	a_861_368##5	A3#12	6.72697e-19
C225	a_27_74##14	A2#1	2.32314e-19
C226	a_861_368##8	A3#13	1.10947e-18
C227	B1#12	B1#8	2.63925e-17
C228	B2#2	Y#14	2.70455e-19
C229	a_27_74##2	A1#5	9.37531e-17
C230	A1#12	a_27_74##15	1.37036e-17
C231	Y#4	A3#11	8.93386e-18
C232	A3#13	Y#1	2.32435e-17
C233	A2#3	a_861_368#	2.49581e-18
C234	a_1330_368##3	a_1330_368##6	4.42787e-18
C235	VGND#12	a_27_74##16	4.526e-17
C236	Y#2	VPWR#6	1.7696e-18
C237	a_27_74##12	B2#8	2.31917e-17
C238	A1#5	a_1330_368##2	1.09488e-16
C239	Y#6	Y#8	5.02562e-18
C240	a_1330_368##4	a_861_368##6	5.47865e-17
C241	VGND#10	A2#1	1.24757e-18
C242	VGND#13	VGND#6	2.68377e-20
C243	Y#3	a_861_368##3	1.55349e-17
C244	a_861_368##5	A3#13	4.47025e-17
C245	Y#2	a_861_368##4	1.58252e-17
C246	a_861_368##8	B1#5	9.63945e-20
C247	VGND#11	A1#12	3.85133e-19
C248	VGND#3	a_27_74#	1.84797e-17
C249	a_27_368#	A3#13	1.27098e-18
C250	a_27_74##4	A2#4	9.94856e-17
C251	B1#11	B1#10	2.16813e-18
C252	B2#1	B1#12	2.84995e-17
C253	a_27_74##15	A2#1	3.65836e-17
C254	a_27_74##3	A2#4	5.16612e-17
C255	VPWR#7	A3#13	2.26775e-19
C256	a_861_368##7	a_861_368##6	4.22446e-18
C257	Y#4	A3#7	1.77649e-17
C258	a_861_368##5	B1#5	2.92943e-18
C259	a_27_74##5	a_27_74##16	3.79686e-18
C260	VGND#3	a_27_74##14	2.52485e-17
C261	A2#4	a_1330_368##3	1.05526e-16
C262	a_27_368##2	VPWR#6	1.06873e-17
C263	VGND#10	A2#6	1.92268e-19
C264	a_1330_368##3	a_861_368##6	5.9359e-17
C265	a_27_368#	B1#5	7.22789e-17
C266	A2#1	VGND#11	2.11029e-17
C267	a_27_74##12	B2#10	9.4696e-19
C268	VGND#3	a_27_74##15	2.79418e-17
C269	a_27_74##7	A3#5	1.3409e-18
C270	Y#5	B1#1	2.01668e-19
C271	B1#5	VPWR#7	2.59084e-17
C272	B2#6	B2#1	3.52461e-17
C273	a_861_368##7	a_1330_368##4	7.05397e-17
C274	a_861_368##5	B1#9	4.09854e-19
C275	a_27_74##15	A2#6	6.29336e-19
C276	A2#4	a_861_368##3	1.00765e-18
C277	VGND#3	a_27_74##16	1.6766e-17
C278	a_27_74##16	A2#1	6.29336e-19
C279	a_27_74##5	VGND#12	5.45591e-17
C280	a_27_74##11	a_27_74##10	2.5966e-18
C281	a_27_368#	B1#9	1.22668e-18
C282	A2#3	a_1330_368##6	8.91769e-19
C283	VGND#14	VGND#7	5.73929e-19
C284	Y#4	B1#1	2.36033e-17
C285	VPWR#9	B1#5	1.45537e-19
C286	B1#9	VPWR#7	2.76175e-17
C287	A2#6	VGND#11	2.41516e-17
C288	VGND#3	a_27_74##5	3.52154e-18
C289	B2#9	Y#9	1.4151e-18
C290	Y#6	Y#5	8.64932e-20
C291	a_1330_368##4	a_1330_368##3	2.59148e-18
C292	VGND#8	a_27_74##8	2.70619e-17
C293	VGND#12	A2#1	1.92268e-19
C294	A3	A3#6	1.35453e-17
C295	B2#8	B2#6	2.64226e-17
C296	A3	A3#4	1.83194e-17
C297	B1#9	a_27_368##7	2.32435e-17
C298	Y#5	B1#6	1.07811e-18
C299	VPWR#2	A1#1	2.26874e-18
C300	Y#3	A2#10	5.00704e-18
C301	a_861_368##4	A3#5	7.18016e-20
C302	a_27_74##16	A2#6	3.83781e-17
C303	VGND#13	VGND#12	1.17747e-18
C304	VPWR#9	B1#9	3.25542e-19
C305	VPWR#7	B1#13	5.79414e-19
C306	A3	B1#10	1.92422e-18
C307	Y#4	B1#6	1.64917e-17
C308	Y#3	A2#4	2.01037e-19
C309	a_27_74##5	A3#4	3.47623e-18
C310	B1#13	a_27_368##7	2.32435e-17
C311	Y#6	B1#8	6.56647e-21
C312	VGND#11	A2#8	4.17478e-19
C313	a_27_74##12	B2#4	2.26626e-18
C314	B2#10	B2#8	3.96762e-17
C315	VGND#12	A2#6	6.92522e-19
C316	Y#8	B1#11	8.32603e-19
C317	A1#3	A1#1	3.66256e-18
C318	B1#13	VPWR#9	2.5102e-17
C319	a_27_74#	A1#5	5.81842e-17
C320	VPWR#7	B1#14	1.45657e-19
C321	Y#5	B1#8	2.68973e-17
C322	VGND#4	A1#5	2.45996e-19
C323	a_27_74##5	VGND#13	3.3723e-17
C324	a_27_74##16	A2#8	3.32919e-17
C325	a_27_368##3	B1#13	1.39411e-18
C326	a_861_368##2	a_1330_368##6	7.06526e-19
C327	a_861_368##8	a_861_368##7	3.71591e-18
C328	VPWR#2	A1#7	2.56349e-18
C329	Y#4	A3#5	7.94641e-18
C330	B1#14	VPWR#9	2.65635e-17
C331	Y#4	B1#8	7.39322e-19
C332	VGND#11	A2#11	1.92268e-19
C333	Y#3	A3#5	2.46175e-18
C334	a_27_368##6	B2#9	8.58444e-20
C335	VPWR#3	VPWR#1	5.77088e-17
C336	Y#6	B1#12	1.70081e-20
C337	A2#8	VGND#12	2.1173e-17
C338	Y#2	A3#5	2.39049e-18
C339	a_27_368##3	B1#14	5.9353e-17
C340	B1	A3#6	8.86983e-18
C341	VPWR#3	a_1330_368#	1.80139e-17
C342	Y#5	Y#4	2.5966e-18
C343	Y#8	B1#10	2.91645e-18
C344	A2#10	a_1330_368##4	2.74797e-18
C345	a_27_74##16	A2#11	8.74051e-19
C346	VPWR#3	VPWR#4	2.11306e-17
C347	Y#5	B1#12	1.62889e-17
C348	B1	B1#11	1.46491e-17
C349	a_27_74##5	A2#8	7.44092e-19
C350	Y#3	A2#3	1.19587e-19
C351	B1	B1#10	5.57012e-17
C352	VGND#9	a_27_74##8	2.03417e-17
C353	a_861_368##2	a_861_368##6	1.26724e-18
C354	a_1330_368##5	VPWR#3	2.67203e-17
C355	a_27_368##8	B1#14	3.00902e-19
C356	Y#4	A3#6	5.50944e-18
C357	a_27_368##3	B2#5	3.72741e-17
C358	VPWR#2	A1#9	2.57874e-18
C359	VGND#13	A3#4	6.61669e-19
C360	A2#11	VGND#12	2.46372e-17
C361	a_861_368##3	a_1330_368##4	1.50733e-17
C362	B2#5	Y#14	2.32435e-17
C363	a_861_368#	VPWR#3	7.65121e-17
C364	Y#6	B2#1	9.38054e-18
C365	VGND#13	A2#8	1.39459e-19
C366	B1	B2#2	9.9424e-18
C367	a_27_74##2	VGND#4	2.08459e-17
C368	A2#3	A1#12	6.55992e-19
C369	a_27_74##5	VGND#14	1.41817e-20
C370	a_27_368##8	B2#5	6.72697e-19
C371	Y#8	B2#4	2.87471e-18
C372	a_27_74##13	a_27_368##6	3.05711e-19
C373	a_27_368##3	B2#7	6.72697e-19
C374	a_27_74##5	A2#11	7.31568e-17
C375	Y#6	B2#4	1.02042e-17
C376	Y#5	B2#1	4.1756e-19
C377	A1#7	A1#1	4.6599e-17
C378	a_27_74##5	A2#4	2.88471e-17
C379	B2#7	Y#14	2.32435e-17
C380	a_861_368##2	a_1330_368##4	1.73564e-17
C381	VPWR#3	a_1330_368##4	8.2398e-18
C382	VGND#12	A3#8	3.17151e-19
C383	B2#7	a_27_368##8	2.14314e-17
C384	VGND#13	A2#11	7.30987e-19
C385	a_27_368##3	B2#11	3.00902e-19
C386	a_861_368##3	a_861_368##7	4.44567e-18
C387	VGND#9	a_27_74##13	4.85813e-17
C388	VGND#14	VGND#13	1.08832e-18
C389	Y#6	B2#6	8.24372e-18
C390	Y#9	B2#7	3.70342e-19
C391	a_861_368##5	a_861_368##8	3.51463e-18
C392	a_27_74##2	a_27_74##14	9.59055e-20
C393	A1#9	A1#7	3.14541e-17
C394	a_27_74##5	A3#8	3.19543e-17
C395	B2	B1#11	5.10578e-18
C396	a_861_368##4	Y#10	2.76997e-19
C397	a_27_368##8	B2#11	3.96761e-17
C398	a_27_74##3	VGND#10	1.46339e-17
C399	a_27_368##5	B2#4	1.70544e-19
C400	Y#9	B2#11	5.3121e-17
C401	B2	B2#9	2.16155e-17
C402	a_1330_368##2	VPWR#2	1.6661e-19
C403	VGND#13	A3#8	2.88726e-17
C404	B2	B2#2	8.92357e-18
C405	a_861_368##5	Y#1	3.09359e-19
C406	Y#5	B1#11	8.26446e-18
C407	a_27_368##6	B2#11	2.84262e-18
C408	A1#13	A1#9	4.5867e-17
C409	A1#5	VPWR#1	3.34257e-17
C410	a_27_368##8	B2#12	2.31174e-18
C411	a_861_368##3	Y#10	3.58981e-19
C412	Y#6	B2#8	1.38801e-20
C413	A2#3	A2#1	1.7628e-18
C414	A1#9	A1#3	1.5188e-19
C415	a_27_74##5	A3#10	7.43557e-19
C416	A1#5	a_1330_368#	5.67761e-17
C417	Y#4	Y#2	5.43224e-18
C418	B2#12	Y#9	2.25476e-17
C419	a_27_74##2	VGND#10	1.45567e-17
C420	Y#8	a_27_368##5	2.36193e-17
C421	A1#5	VPWR#4	1.78423e-18
C422	a_27_368##6	B2#12	6.00758e-17
C423	a_861_368##4	a_861_368##8	5.47123e-20
C424	a_27_74##3	a_27_74##15	5.33767e-19
C425	A1#5	a_1330_368##5	6.90755e-19
C426	Y#3	A3#4	3.52849e-17
C427	VGND#13	A3#10	2.58524e-17
C428	A2#5	A1#13	4.97248e-18
C429	VGND#14	A3#6	1.45847e-18
C430	a_27_74##4	VGND#11	1.57989e-17
C431	a_27_74##3	A1#11	1.14261e-18
C432	Y#5	B1#10	1.35424e-17
C433	a_27_74##5	A3#11	3.7151e-19
C434	VPWR#6	a_861_368##5	4.63769e-17
C435	A3#10	a_27_74##17	7.72085e-18
C436	a_27_368#	a_861_368##5	5.17134e-17
C437	a_27_368#	VPWR#6	1.74295e-17
C438	Y#2	Y#3	3.01982e-18
C439	A2#7	A2#5	3.36495e-17
C440	Y#2	A3#6	6.18615e-18
C441	VGND#13	A3#11	1.64855e-18
C442	a_861_368##4	Y#1	3.26619e-19
C443	a_1330_368##2	A1#7	1.71495e-19
C444	a_27_74##8	VGND#14	5.00024e-17
C445	VGND#14	A3#10	5.96848e-19
C446	a_27_74##3	VGND#11	1.56609e-17
C447	VPWR#7	a_861_368##5	2.69921e-18
C448	a_27_74##5	A3#7	8.17658e-20
C449	a_27_74##4	a_27_74##16	9.59055e-20
C450	A2#4	a_861_368##6	1.54706e-18
C451	A3#11	a_27_74##17	1.64878e-17
C452	A2#4	a_1330_368##4	6.40851e-17
C453	A2#12	A2#7	3.39924e-17
C454	VGND#13	A3#7	2.46619e-19
C455	a_27_74##7	a_27_74##5	2.77043e-18
C456	VGND#3	A1#6	1.57396e-18
C457	Y#2	A3#4	6.4762e-19
C458	Y#8	a_27_368##2	6.14945e-17
C459	A3#11	VGND#14	2.35816e-17
C460	a_27_368#	VPWR#7	3.61769e-17
C461	A2	A2#10	6.87198e-18
C462	VGND#3	A1#8	5.1191e-19
C463	a_27_74##8	A3#6	6.37609e-19
C464	a_1330_368##2	A1#9	1.83818e-17
C465	VPWR#3	A2#10	2.21207e-20
C466	a_27_74##2	A1#11	2.77853e-18
C467	Y#4	B1#10	1.82708e-17
C468	Y#7	B2#4	1.00161e-17
C469	VGND#3	A1#10	4.81366e-18
C470	A2#13	A2#12	4.59518e-17
C471	VGND#8	VGND#7	1.98668e-19
C472	A2	A3#4	8.15116e-18
C473	a_27_74##8	A3#11	1.03919e-18
C474	VGND#3	A1#12	4.65532e-18
C475	a_27_74##4	VGND#12	2.65136e-17
C476	a_27_74##11	B1#11	5.06887e-19
C477	VPWR#3	A2#3	1.44447e-19
C478	VGND#3	A2#1	5.64642e-19
C479	a_27_74##8	Y#11	1.45633e-19
C480	A3#7	VGND#14	2.45703e-17
C481	A3#5	a_861_368##8	1.18314e-19
C482	a_27_74##4	A2#10	4.2672e-18
C483	a_1330_368##3	A1#13	3.82811e-19
C484	VGND#3	A2#6	1.93887e-19
C485	Y#8	B2#2	1.12577e-18
C486	A3#5	Y#1	5.71975e-19
C487	A3#1	A2#13	3.34329e-17
C488	a_27_74##7	VGND#13	4.7647e-17
C489	VGND#3	A2#8	1.71792e-19
C490	a_861_368##5	A3#5	7.4148e-20
C491	a_1330_368##2	A1#13	2.44066e-17
C492	a_27_74##8	A3#7	5.20487e-17
C493	Y#3	a_861_368##7	7.27217e-17
C494	VGND#3	A2#11	4.34718e-19
C495	a_27_74##7	A3#6	6.98424e-19
C496	A3#9	A3#1	4.6396e-17
C497	VGND#14	B1#1	4.4773e-19
C498	a_27_74##11	B1#10	2.10429e-19
C499	VPWR#9	VPWR#7	1.77709e-18
C500	A3#4	Y#10	2.2624e-19
C501	a_1330_368##3	A2#5	4.08902e-17
C502	Y#3	B1#10	6.67616e-19
C503	a_27_74##8	B1#1	2.95734e-17
C504	A1#12	A1#5	2.7989e-18
C505	B2#2	B1#11	2.80613e-17
C506	a_27_74##7	a_27_74##17	3.74828e-18
C507	A3#12	A3#9	4.79978e-17
C508	Y#3	Y#10	6.05323e-19
C509	Y#4	A3	6.47183e-17
C510	a_1330_368##2	A2#5	7.95943e-20
C511	A3	Y#3	9.67944e-17
C512	a_27_74##2	A1#3	4.95883e-18
C513	VGND#14	B1#6	1.75234e-19
C514	A3	Y#2	8.25828e-17
C515	B1#1	Y#11	1.66163e-17
C516	a_27_74##7	A3#4	8.26272e-19
C517	Y#6	B2#2	1.40101e-17
C518	a_27_74##10	a_27_74##8	2.5966e-18
C519	VGND#7	VGND#6	4.35574e-19
C520	A3#13	A3#12	4.60899e-17
C521	a_27_74##8	B1#6	4.24687e-19
C522	a_27_74##4	A2#3	2.11457e-18
C523	a_1330_368##3	A2#7	2.51876e-17
C524	B1	Y#8	1.07314e-16
C525	Y#6	B1	1.5618e-17
C526	Y#5	B1	8.34157e-17
C527	VGND#9	B1#1	4.47052e-18
C528	B2#4	Y#14	2.74109e-19
C529	A3#4	A2#10	1.34081e-17
C530	a_27_74##7	VGND#14	4.14527e-17
C531	Y#3	a_861_368##8	4.36544e-17
C532	VGND#14	B1#8	6.32707e-20
C533	Y#4	B1	9.55137e-17
C534	B1#6	Y#11	5.66852e-18
C535	B2#4	a_27_368##8	1.22002e-18
C536	B1#5	A3#13	5.54031e-18
C537	VGND#9	B1#6	4.47052e-18
C538	B1	Y#2	8.40147e-17
C539	B2#4	Y#9	1.39623e-18
C540	a_27_74##10	B1#10	1.73394e-18
C541	VGND#9	B1#8	4.47052e-18
C542	a_27_368##3	VPWR#9	3.94747e-17
C543	VPWR#3	A1#1	2.51756e-18
C544	VGND#5	A1#12	3.08106e-19
C545	VGND#9	B1#12	4.47052e-18
C546	A3#4	a_861_368##8	9.98412e-19
C547	B1#6	a_27_74##18	1.66163e-17
C548	Y#2	B1#10	6.46069e-18
C549	a_27_74##10	Y#11	9.16812e-19
C550	VPWR#3	A1#7	1.90138e-19
C551	Y#2	a_861_368##8	4.3542e-17
C552	VGND#9	B2#1	4.48038e-18
C553	B1#9	B1#5	4.51717e-17
C554	B2	Y#8	6.14125e-17
C555	a_1330_368##2	A1#11	4.9114e-18
C556	a_1330_368##3	A2#12	7.53191e-19
C557	VGND#9	B2#6	4.47052e-18
C558	VPWR#3	A1#9	6.14168e-19
C559	Y#6	B2	5.15067e-17
C560	a_27_74##8	B1#10	1.56689e-19
C561	VGND#9	B2#8	4.43427e-18
C562	VPWR#3	A1#13	6.46896e-18
C563	a_27_74##8	a_27_74##7	2.5798e-18
C564	A3#7	A3#5	1.31918e-18
C565	VGND#6	A2#1	9.58118e-20
C566	VGND#9	B2#10	4.43427e-18
C567	B1#13	B1#9	4.57724e-17
C568	a_27_74##12	B2#9	5.48587e-20
C569	VPWR#3	A2#5	7.42913e-18
C570	B1#8	a_27_74##18	5.66852e-18
C571	Y#2	a_27_368##2	1.37514e-17
C572	VPWR#6	A3#6	3.18629e-19
C573	a_861_368##2	A2#7	2.11859e-17
C574	VPWR#3	A2#7	6.19854e-18
C575	a_27_74##3	A2#3	2.20564e-18
C576	VPWR#6	A3#4	4.16193e-20
C577	Y#2	Y#1	6.11841e-19
C578	VPWR#3	A2#12	6.15834e-18
C579	VGND#5	A2#1	4.79166e-18
C580	a_27_74##10	a_27_74##18	4.04784e-18
C581	B1#14	B1#13	4.72943e-17
C582	B1#8	Y#12	1.66163e-17
C583	VPWR#3	A2#13	4.4526e-18
C584	VGND#6	VGND#5	1.35051e-18
C585	A1#5	A1#1	9.65207e-18
C586	a_27_74##11	Y#12	7.74494e-19
C587	a_27_368##8	a_27_368##3	3.6274e-18
C588	B2#5	B1#14	4.46747e-17
C589	A1#5	A1#9	2.07201e-18
C590	VGND#6	A2#6	5.67511e-19
C591	VPWR#6	B1#10	1.06599e-19
C592	Y#8	a_27_368##7	5.24889e-19
C593	A1#5	A1#13	2.06839e-18
C594	a_861_368##2	A2#12	1.55939e-17
C595	Y#3	A2#5	3.18916e-19
C596	B1#12	Y#12	5.66852e-18
C597	VGND	A3#6	1.30096e-19
C598	Y#2	a_861_368##5	8.30271e-17
C599	Y#13	B1#8	1.82923e-19
C600	A2	a_861_368##3	8.63357e-19
C601	A1#5	A2#5	1.09332e-19
C602	VPWR#6	A3#1	4.45244e-18
C603	B2#7	B2#5	4.60584e-17
C604	A2#4	A1#13	2.98645e-19
C605	a_27_74##10	Y#12	2.4597e-19
C606	VGND#5	A2#6	4.79166e-18
C607	VPWR#6	A3#9	4.49303e-18
C608	B1#12	a_27_74##19	1.62303e-17
C609	A2#4	A2#5	2.09372e-18
C610	Y#3	A2	2.37861e-17
C611	Y#7	B2	6.16883e-17
C612	VPWR#6	A3#12	4.50003e-18
C613	a_27_74#	A1#3	2.81928e-18
C614	A2#4	A2#7	2.11916e-18
C615	a_27_74##13	B2	1.77115e-17
C616	a_861_368##3	A2#13	1.8407e-17
C617	a_27_74##11	a_27_74##19	4.45383e-18
C618	B2#11	B2#7	4.42701e-17
C619	VPWR#6	A3#13	4.77833e-18
C620	A2#4	A2#12	2.07252e-18
C621	Y#13	B1#12	9.81773e-19
C622	VPWR#6	B1#5	7.4879e-18
C623	Y#8	VPWR#9	1.15912e-18
C624	A2#4	A2#13	3.96888e-18
C625	Y#3	A2#7	2.78983e-19
C626	a_27_74##12	B2#2	8.49439e-20
C627	a_861_368##5	A3#6	1.46257e-18
C628	Y#2	a_27_368#	5.67916e-17
C629	a_27_74##12	Y#13	4.19947e-17
C630	VGND#6	A2#8	4.84536e-18
C631	a_27_74##3	a_1330_368##3	1.09168e-18
C632	VPWR#6	B1#9	5.33276e-18
C633	B2#12	B2#11	4.65957e-17
C634	A1#5	A1#11	2.04026e-17
C635	B2#1	a_27_74##19	5.54508e-18
C636	VPWR#6	B1#13	5.65677e-19
C637	Y#9	a_27_368##8	3.89854e-17
C638	a_27_74##5	A2	1.62008e-17
C639	VGND#9	B1#11	2.33168e-20
C640	VPWR#6	B1#14	9.00513e-20
C641	A1#5	A1#3	3.87421e-17
C642	VGND#5	A2#8	3.40119e-19
C643	VGND#9	B1#10	1.3404e-19
C644	Y#13	B2#1	3.09756e-17
C645	a_861_368##3	A3#1	1.88922e-17
C646	a_27_74##11	Y#13	4.3543e-17
C647	Y#3	A2#12	4.65244e-19
C648	a_27_368##6	a_27_368##8	4.83152e-18
C649	Y#8	a_27_368##3	8.83973e-17
C650	Y#2	VPWR#7	1.20735e-18
C651	VPWR	a_861_368##4	2.71103e-17
C652	a_27_74##3	a_1330_368##2	4.70881e-18
C653	a_27_74##12	a_27_74##20	3.65714e-18
C654	VPWR	a_861_368##3	2.39333e-17
C655	A1#5	A2#3	8.032e-18
C656	VGND#6	A2#11	4.87741e-18
C657	B2	Y#9	4.32351e-17
C658	VPWR	Y#8	1.60636e-17
C659	B2	a_27_368##6	3.69249e-17
C660	VGND#9	B2#9	2.02148e-20
C661	B2#6	Y#13	1.27564e-17
C662	a_861_368##4	A3#9	1.58461e-17
C663	VGND	VGND#8	6.35202e-17
C664	VGND#4	A1#3	1.34256e-18
C665	VPWR	Y#3	9.59173e-18
C666	Y#7	B2#1	2.00241e-19
C667	a_27_368##6	Y#9	7.03041e-17
C668	VGND	VGND#7	6.7636e-17
C669	VPWR	Y#2	1.93285e-17
C670	VGND	VGND#6	1.85806e-17
C671	VGND#6	A2#10	7.87384e-20
C672	VPWR	a_27_368##5	3.10115e-17
C673	A2	a_861_368##7	2.06122e-17
C674	VPWR	a_27_368##2	1.98629e-17
C675	VGND#9	B2#2	2.04757e-20
C676	a_27_74##11	B2#2	1.13902e-19
C677	VGND#5	A2#11	9.58118e-20
C678	a_27_74##12	Y#6	1.64657e-17
C679	a_1330_368##3	A2#3	1.02916e-17
C680	VGND	a_27_74##12	3.05598e-17
C681	VGND	a_27_74##11	2.92545e-17
C682	B2#6	a_27_74##20	1.66163e-17
C683	VGND	a_27_74##10	3.20396e-17
C684	Y#3	A2#13	1.78786e-18
C685	VGND	a_27_74##7	2.22015e-17
C686	Y#8	Y#14	6.11841e-19
C687	VGND#7	A3#8	9.38294e-19
C688	VPWR#3	A1#5	1.51492e-17
C689	A2#4	A1#11	1.12458e-17
C690	Y#13	B2#8	3.8666e-19
C691	VGND#3	A1#5	1.75796e-17
C692	Y#7	B2#6	1.07542e-18
C693	VPWR#3	A2#4	1.20356e-17
C694	a_27_74##12	Y#7	5.88524e-17
C695	VGND	Y#6	3.02604e-18
C696	VGND	Y#5	1.09698e-17
C697	VPWR#2	VPWR#1	8.82913e-19
C698	VGND	Y#4	1.70745e-17
C699	VGND#3	A2#4	1.008e-17
C700	VGND	Y#3	6.40448e-18
C701	VGND#6	A3#8	2.90737e-19
C702	a_861_368##4	A3#12	1.57323e-17
C703	A1#11	VNB	3.50176e-17
C704	A1#3	VNB	5.22506e-17
C705	B2#8	a_27_74##20	5.66852e-18
C706	A2#10	VNB	5.4869e-17
C707	a_27_74##13	B2#6	1.89192e-19
C708	A2#3	VNB	4.98023e-17
C709	Y#7	Y#13	2.3833e-18
C710	a_27_74##2	A1#8	2.07097e-17
C711	A3#6	VNB	3.81972e-17
C712	A3#4	VNB	5.23111e-17
C713	A2#4	A2#10	2.75307e-17
C714	a_27_74##11	Y#6	1.68235e-17
C715	B1#11	VNB	2.73513e-17
C716	VPWR#6	A3#5	2.48982e-20
C717	B1#10	VNB	9.67629e-17
C718	B2#9	VNB	4.21458e-17
C719	B2#2	VNB	2.48606e-17
C720	Y#3	A3#1	2.97457e-17
C721	A2#4	A1#5	3.40451e-17
C722	A3	A3#1	3.65922e-19
C723	VGND	a_27_74##5	2.886e-17
C724	Y#8	a_27_368##8	5.53954e-17
C725	VPWR	a_1330_368##4	1.84013e-18
C726	Y#7	B2#8	3.91548e-17
C727	VGND	VGND#13	1.59566e-17
C728	A2#4	A2#3	3.82398e-17
C729	VGND	VGND#14	1.93773e-17
C730	VGND	a_27_74##8	2.6308e-17
C731	A3	A3#12	2.03545e-18
C732	a_27_368##2	a_27_368#	2.97567e-18
C733	VGND#7	A3#10	9.28585e-19
C734	VPWR	a_861_368##5	2.30893e-17
C735	A3	A3#13	2.05228e-18
C736	VPWR	a_27_368#	1.83769e-17
C737	VGND	Y#13	7.4766e-18
C738	A3	B1#5	1.03249e-19
C739	VGND#9	B2#4	8.1472e-20
C740	a_1330_368##3	a_1330_368##2	2.93568e-19
C741	VGND	Y#7	9.334e-18
C742	VGND	a_27_74##13	2.25299e-17
C743	VPWR	a_27_368##3	2.12614e-17
C744	a_27_74##13	B2#8	8.54052e-19
C745	Y#7	a_27_74##20	1.79177e-19
C746	VGND#10	A1#11	1.50523e-18
C747	a_27_74##13	a_27_74##12	2.45118e-18
C748	B1	A3#13	3.94111e-19
C749	VPWR	Y#9	6.93575e-18
C750	a_1330_368#	VPWR#2	1.68601e-17
C751	VPWR	a_27_368##6	2.49848e-17
C752	B1	B1#5	2.12441e-18
C753	B1	B1#9	2.08893e-18
C754	A1#8	A1#6	2.45416e-17
C755	B1	B1#13	2.09836e-18
C756	a_27_74##2	A1#10	2.08529e-17
C757	Y#7	B2#10	3.15595e-17
C758	B1	B1#14	2.08189e-18
C759	Y#3	A3#9	3.12422e-17
C760	a_27_74##11	Y#5	6.18898e-17
C761	B1	B2#5	1.06554e-18
C762	VGND#8	VNB	3.5785e-17
C763	VGND#7	VNB	3.73897e-17
C764	VGND#8	A3#11	2.9375e-18
C765	VGND#6	VNB	3.80751e-17
C766	VGND#5	VNB	3.13727e-17
C767	Y#9	Y#8	2.52173e-18
C768	VPWR#2	VNB	3.57569e-17
C769	B2	B1#14	4.0129e-19
C770	a_27_74##12	VNB	5.04076e-18
C771	a_27_368##2	VPWR#7	3.92847e-17
C772	a_27_74##11	VNB	4.8937e-18
C773	a_27_74##10	VNB	5.3157e-18
C774	A2	A2#13	1.5096e-18
C775	a_27_74##7	VNB	2.60042e-18
C776	B2	B2#5	3.99142e-19
C777	a_27_74##13	B2#10	3.55351e-17
C778	Y#2	A3#9	1.73137e-18
C779	a_27_74##4	VNB	1.97866e-18
C780	A2	A3#1	8.86966e-19
C781	a_27_74##3	VNB	4.58385e-18
C782	a_27_74##2	VNB	1.71387e-18
C783	B2	B2#7	2.04856e-18
C784	a_1330_368##3	VNB	2.94961e-18
C785	a_1330_368##2	VNB	4.33759e-18
C786	a_861_368##4	VNB	4.38626e-18
C787	a_861_368##3	VNB	6.50754e-18
C788	B2	B2#11	2.09839e-18
C789	a_861_368##2	VNB	5.18182e-18
C790	a_27_74##3	A1#12	1.96915e-17
C791	Y#6	VNB	2.24331e-18
C792	B2	B2#12	4.24777e-18
C793	Y#5	VNB	1.01584e-18
C794	Y#4	VNB	2.48052e-18
C795	Y#3	VNB	4.31406e-18
C796	A3#4	A3#1	1.86961e-19
C797	Y#2	VNB	7.50149e-18
C798	VGND	A3#8	4.59938e-19
C799	VGND	A3#10	4.90193e-19
C800	a_27_368##5	VNB	5.3841e-18
C801	VGND	A3#11	1.72298e-19
C802	a_27_368##2	VNB	2.08637e-18
C803	VGND	A3#7	1.88329e-18
C804	a_27_74#	VNB	4.57019e-17
C805	VGND#4	VNB	2.81583e-18
C806	VGND	B1#1	1.4938e-18
C807	a_27_74##14	VNB	1.96561e-18
C808	VGND#10	VNB	5.26681e-19
C809	VGND	B1#6	1.48583e-18
C810	a_27_74##15	VNB	2.63465e-18
C811	VGND#11	VNB	3.16584e-18
C812	VGND	B1#8	1.65032e-18
C813	a_27_74##16	VNB	1.96561e-18
C814	A3	A3#5	1.72431e-17
C815	VGND#12	VNB	3.16584e-18
C816	VGND	B1#12	1.55192e-18
C817	a_27_74##5	VNB	9.50398e-18
C818	VGND#13	VNB	3.28602e-19
C819	VGND	B2#1	1.64638e-18
C820	VGND#14	VNB	4.46111e-18
C821	VGND	B2#6	1.54872e-18
C822	a_27_74##8	VNB	3.08671e-18
C823	VGND	B2#8	1.65999e-18
C824	VPWR	A2#13	1.6482e-18
C825	VGND	B2#10	2.4414e-18
C826	A1#10	A1#8	3.91176e-17
C827	VPWR	A3#1	1.64819e-18
C828	VPWR	A3#9	1.64156e-18
C829	Y#3	A3#12	1.84633e-18
C830	Y#7	VNB	6.78066e-18
C831	a_27_74##13	VNB	4.68557e-17
C832	a_27_74##10	Y#5	6.10717e-17
C833	VPWR#1	VNB	7.65163e-17
C834	VPWR	A3#12	1.64161e-18
C835	a_1330_368#	VNB	2.19739e-18
C836	VPWR#4	VNB	3.73621e-18
C837	VPWR	A3#13	1.48173e-18
C838	a_1330_368##5	VNB	2.1429e-18
C839	a_27_74##13	Y#7	6.01671e-17
C840	VPWR#5	VNB	8.30377e-18
C841	B1#10	a_27_368#	1.84439e-18
C842	a_861_368#	VNB	1.28599e-17
C843	VPWR	B1#5	1.76171e-19
C844	VPWR	B1#9	5.4936e-19
C845	a_27_368##2	a_27_368##7	1.04781e-18
C846	VPWR	B1#13	5.4936e-19
C847	VPWR	B1#14	9.92396e-19
C848	a_861_368##5	VNB	1.03932e-17
C849	B2	B2#4	3.29062e-17
C850	a_27_368##2	B1#11	1.34011e-19
C851	a_27_368#	VNB	9.72846e-18
C852	VPWR#7	VNB	2.80556e-18
C853	VPWR	B2#5	1.49488e-18
C854	Y#2	A3#12	3.36291e-17
C855	VPWR#9	VNB	2.79388e-18
C856	VGND#8	A3#7	2.68921e-18
C857	VPWR	B2#7	1.56804e-18
C858	a_27_74##5	a_861_368##7	8.09453e-18
C859	a_27_368##3	VNB	2.24696e-18
C860	VPWR	B2#11	1.57716e-18
C861	A3#6	A3#5	8.81379e-19
C862	a_27_368##6	VNB	5.42786e-17
C863	VPWR	B2#12	2.35157e-18
C864	A1#6	VNB	3.03665e-17
C865	A1#8	VNB	2.73249e-17
C866	A1#10	VNB	2.71451e-17
C867	A1#12	VNB	2.93415e-17
C868	A2#1	VNB	3.20786e-17
C869	VPWR	VPWR#3	2.93492e-17
C870	A2#6	VNB	2.91049e-17
C871	A2#8	VNB	2.88402e-17
C872	A2#11	VNB	3.11902e-17
C873	A3#5	A3#4	2.20859e-18
C874	A3#8	VNB	2.66165e-17
C875	a_27_74##3	A2#1	2.00424e-17
C876	A3#10	VNB	2.43444e-17
C877	VPWR	VPWR#6	1.84432e-16
C878	A3#11	VNB	2.86302e-17
C879	A3#7	VNB	3.26667e-17
C880	B1#1	VNB	2.99166e-17
C881	B1	A3	2.81775e-17
C882	B1#6	VNB	2.93632e-17
C883	B1#8	VNB	2.92619e-17
C884	B1#12	VNB	2.93921e-17
C885	B2#1	VNB	2.9045e-17
C886	B2#6	VNB	2.91346e-17
C887	VPWR	A2#4	1.27882e-18
C888	B2#8	VNB	2.89367e-17
C889	B2#10	VNB	3.74314e-17
C890	A1#1	VNB	4.57373e-17
C891	A1#7	VNB	3.11851e-17
C892	B2	B1	2.67606e-17
C893	A1#9	VNB	3.22642e-17
C894	VGND	VGND#9	2.16396e-16
C895	A1#13	VNB	3.21616e-17
C896	A2#5	VNB	3.56606e-17
C897	Y#8	B1#5	2.40481e-19
C898	A2#7	VNB	3.24828e-17
C899	A2#12	VNB	3.2133e-17
C900	VGND	A2#4	9.3427e-19
C901	A2#13	VNB	3.23679e-17
C902	A3#1	VNB	3.43197e-17
C903	A3#9	VNB	3.21803e-17
C904	A3#12	VNB	3.24166e-17
C905	A3#13	VNB	3.38031e-17
C906	B1#5	VNB	3.53572e-17
C907	B1#9	VNB	3.24034e-17
C908	Y#3	A3#13	2.64338e-19
C909	B1#13	VNB	3.18053e-17
C910	VGND#7	A3#4	5.48409e-20
C911	B1#14	VNB	3.15065e-17
C912	A1#12	A1#10	2.4605e-17
C913	B2#5	VNB	3.32252e-17
C914	B2#7	VNB	3.23754e-17
C915	a_1330_368##5	VPWR#2	7.42574e-18
C916	B2#11	VNB	3.17805e-17
C917	VPWR	A3	4.962e-18
C918	B2#12	VNB	4.09919e-17
C919	a_27_368##2	VPWR#9	4.2844e-17
C920	VPWR#3	VNB	3.15318e-16
C921	VPWR	B1	8.76479e-18
C922	VGND#3	VNB	2.39804e-16
C923	a_27_74##4	A2#6	2.16496e-17
C924	VPWR#6	VNB	9.89921e-17
C925	VPWR	B2	9.17054e-18
C926	VGND#9	VNB	1.33189e-16
C927	VGND	A3	6.39115e-18
C928	a_27_74##10	Y#4	6.38489e-17
C929	A1#5	VNB	9.76134e-17
C930	A1#1	VPWR#1	3.32234e-17
C931	A2#4	VNB	5.09633e-17
C932	VGND	B1	1.09967e-17
C933	a_27_368##2	B1#10	1.14296e-18
C934	A3#5	VNB	3.07523e-17
C935	VGND	B2	9.97384e-18
C936	VPWR	A2	2.18406e-18
C937	B2#4	VNB	5.65099e-17
C938	Y#2	A3#13	3.49057e-17
C939	VGND	A2	1.74202e-18
C940	A3	VNB	7.24876e-18
C941	B1	VNB	1.40586e-17
C942	B2	VNB	3.10077e-17
C943	A2	VNB	2.17269e-18
C944	VPWR	VNB	3.14169e-16
C945	VGND	VNB	3.08202e-16
C946	VPWR#8	B2#7	4.63908e-18
C947	VGND#2	VNB	5.91465e-17
C948	VGND#2	A1#3	9.59764e-20
C949	VGND#2	A1#12	9.54473e-20
C950	VGND#2	A1#10	6.1321e-19
C951	VGND#2	A1#8	4.79827e-18
C952	VGND#2	A1#6	3.83516e-18
C953	VGND#2	a_27_74##2	2.25448e-19
C954	VGND#2	A1#5	2.24219e-18
C955	VGND#3	VGND#2	1.19956e-16
C956	VGND#2	a_27_74##14	8.43305e-18
C957	VGND#2	a_27_74#	2.17266e-17
C958	a_27_368##3	VPWR#8	4.0863e-17
C959	a_27_368##5	VPWR#8	6.96671e-17
C960	VPWR#8	B2#11	4.52818e-18
C961	VPWR#8	B2#12	4.50834e-18
C962	a_27_368##2	VPWR#8	7.2814e-18
C963	VPWR#8	B2#9	1.13558e-20
C964	a_27_368##6	VPWR#8	5.06246e-17
C965	VPWR#8	B2#2	1.12044e-20
C966	VPWR#8	VPWR#6	6.93111e-19
C967	VPWR	VPWR#8	1.75966e-16
C968	VPWR#8	B1#5	1.50513e-19
C969	VPWR#8	B1#9	5.65677e-19
C970	VPWR#8	B1#13	5.31781e-18
C971	VPWR#8	B2#4	4.51204e-20
C972	VPWR#8	VNB	9.90077e-17
C973	VPWR#8	B1#14	4.8945e-18
C974	VPWR#8	B2#5	4.8878e-18
C975	VPWR#8	B1#10	1.42058e-20
*
*
.ENDS sky130_fd_sc_hs__o32ai_4
*
