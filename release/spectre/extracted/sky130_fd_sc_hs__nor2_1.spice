* Extracted by Quantus, converted by sky130cad/quantus.py
*
*
*
*                       LINUX           Wed Nov 18 08:48:41 2026
*
*
*
*  PROGRAM  advgen
*
*  Name           : advgen - Quantus - (64-bit)
*  Version        : 25.1.0-p047
*  Build Date     : Thu Dec 11 23:20:30 PST 2025
*
*  HSPICE LIBRARY
*
*  OPERATING_TEMPERATURE 150
*  QRC_TECH_DIR <path>/tech
*
*
*

*
.SUBCKT sky130_fd_sc_hs__nor2_1 VPB VNB VGND VPWR Y A B
*
*
*  caps2d version: 10
*
*
*       TRANSISTOR CARDS
*
*
XM1 VGND#3 A#1 Y#3 VNB sky130_fd_pr__nfet_01v8_lvt l=0.15 w=0.74 ad=0.2109 as=0.2072 pd=2.05 ps=2.04
XM2 Y#3 B#4 VGND#1 VNB sky130_fd_pr__nfet_01v8_lvt l=0.15 w=0.74 ad=0.2072 as=0.2109 pd=2.04 ps=2.05
XM0 VPWR#2 A#4 a_116_368# VPB sky130_fd_pr__pfet_01v8 l=0.15 w=1.12 ad=0.3304 as=0.3024 pd=2.83 ps=2.78
XM3 a_116_368# B#3 Y#1 VPB sky130_fd_pr__pfet_01v8 l=0.15 w=1.12 ad=0.3024 as=0.3304 pd=2.78 ps=2.83
*
*
*       RESISTOR AND CAP/DIODE CARDS
*
Rg1	A#1	A#2	368.862610
Rg2	A#2	A#3	24.690777
Rg3	A#2	A#4	471.862823
Rg4	B#1	B#2	26.676205
Rg5	B#2	B#3	472.420441
Rg6	B#2	B#4	369.630585
Rf1	A#5	A#3	160.919952
Rf2	A	A#7	0.687145
Rf3	A#5	A#7	7.873454
Rf4	Y	Y#2	0.652361
Rf5	Y#2	Y#3	105.261581
Rf6	Y#1	Y#2	5.000000
Rf7	B#1	B#6	160.919952
Rf8	B#7	B	0.687145
Rf9	B#6	B#7	7.873454
Rf10	VGND#1	VGND#2	61.792049
Rf11	VGND#2	VGND#3	74.875984
Rf12	VPWR#1	VPWR#2	65.769608
Re1	VPWR#1	VPWR	3.274347
Re2	VGND	VGND#2	3.274471
*
*       CAPACITOR CARDS
*
*
C1	VGND	VNB	4.70772e-17
C2	VPWR	VNB	5.03252e-17
C3	Y	VNB	5.7014e-17
C4	B	VNB	1.00591e-17
C5	A#3	VNB	6.29087e-17
C6	VPWR	Y	2.69894e-17
C7	VGND#2	VNB	1.47252e-16
C8	VPWR#1	VNB	1.47909e-16
C9	VPWR	B	2.66614e-18
C10	A#4	VNB	4.2581e-17
C11	VGND	A#3	7.64562e-19
C12	B#3	VNB	4.16115e-17
C13	Y	B	4.57279e-17
C14	A#1	VNB	3.29891e-17
C15	VGND	VGND#2	2.94421e-17
C16	B#4	VNB	2.82605e-17
C17	VPWR#2	VNB	5.32507e-17
C18	Y	a_116_368#	1.45897e-17
C19	VGND#3	VNB	4.23238e-17
C20	Y#3	VNB	1.1284e-17
C21	VGND#1	VNB	4.48304e-17
C22	Y	A#3	1.50278e-18
C23	VPWR	VPWR#1	3.32103e-17
C24	A#5	VNB	1.00419e-17
C25	VGND	A#1	4.05906e-18
C26	A#7	VNB	1.02786e-17
C27	VGND	B#4	4.73348e-18
C28	VPWR	A#4	5.29349e-18
C29	B#6	VNB	9.73152e-18
C30	VPWR	B#3	5.93227e-19
C31	Y	VPWR#1	3.05065e-17
C32	VGND	VGND#3	2.40043e-17
C33	B	A#3	4.66872e-19
C34	VGND	Y#3	1.71349e-17
C35	VGND	VGND#1	2.97568e-17
C36	Y	A#4	2.41688e-17
C37	VGND	A#5	2.74201e-18
C38	VPWR	VPWR#2	3.08427e-17
C39	Y	B#3	4.55468e-17
C40	VGND	B#6	2.35039e-18
C41	VPWR#2	Y	7.66562e-17
C42	B	A#4	2.71334e-19
C43	Y	Y#1	6.39094e-18
C44	B	B#3	2.76043e-18
C45	VPWR	A#7	2.26259e-18
C46	A#4	a_116_368#	1.2729e-17
C47	B#3	a_116_368#	6.83715e-18
C48	A#7	Y	1.77047e-17
C49	B#6	B#2	1.58031e-17
C50	Y#3	B	4.85169e-18
C51	VPWR#1	A#4	3.96645e-18
C52	A#3	VPWR#2	5.21112e-18
C53	VPWR#1	B#3	4.51148e-18
C54	VGND#2	A#1	5.44884e-18
C55	VGND#2	B#4	3.3219e-18
C56	VGND#3	A#3	8.15458e-18
C57	A#4	B#3	5.69648e-17
C58	Y#3	A#3	6.99157e-18
C59	B#2	VNB	6.18045e-17
C60	A#5	A#3	1.78611e-17
C61	A#7	A#3	8.87516e-18
C62	VGND#2	Y#3	1.37656e-17
C63	VPWR#2	A#4	4.62658e-17
C64	VGND#2	VGND#1	1.36896e-19
C65	B#6	A#3	8.33373e-19
C66	VPWR#2	B#3	4.88316e-18
C67	A#1	B#4	3.95613e-17
C68	B#3	Y#1	1.19009e-17
C69	VGND#3	A#1	2.34488e-17
C70	A#7	A#4	3.58179e-18
C71	Y#3	A#1	4.06006e-17
C72	VGND#3	B#4	1.33135e-18
C73	A#7	B#3	3.16386e-19
C74	VGND#1	A#1	3.91173e-18
C75	Y#3	B#4	1.49731e-17
C76	VGND#1	B#4	3.45423e-17
C77	VGND#3	Y#3	6.26312e-17
C78	A#7	VPWR#2	2.95803e-17
C79	VGND#3	VGND#1	3.20261e-18
C80	A#5	VGND#3	3.54547e-17
C81	Y#3	VGND#1	6.53762e-17
C82	A#5	Y#3	2.60363e-17
C83	Y	B#2	5.83338e-18
C84	A#7	Y#3	4.38898e-18
C85	Y#3	B#6	2.87812e-17
C86	B#6	VGND#1	3.42904e-17
C87	B	B#2	9.03672e-18
C88	B#2	Y#1	4.7669e-19
C89	Y#3	B#2	7.32628e-18
C90	A#3	B#2	2.54156e-17
C91	VGND#1	B#2	8.67539e-18
C92	A#5	B#2	9.52263e-19
C93	VPWR#1	B#2	2.2551e-19
C94	A#7	B#2	5.3976e-19
*
*
.ENDS sky130_fd_sc_hs__nor2_1
*
