* Extracted by Quantus, converted by sky130cad/quantus.py
*
*
*
*                       LINUX           Wed Nov 18 09:05:06 2026
*
*
*
*  PROGRAM  advgen
*
*  Name           : advgen - Quantus - (64-bit)
*  Version        : 25.1.0-p047
*  Build Date     : Thu Dec 11 23:20:30 PST 2025
*
*  HSPICE LIBRARY
*
*  OPERATING_TEMPERATURE 150
*  QRC_TECH_DIR <path>/tech
*
*
*

*
.SUBCKT sky130_fd_sc_hs__or2_2 VNB VPB VGND VPWR X B A
*
*
*  caps2d version: 10
*
*
*       TRANSISTOR CARDS
*
*
XM3 VGND#3 B#4 a_27_368##11 VNB sky130_fd_pr__nfet_01v8_lvt l=0.15 w=0.64 ad=0.1792 as=0.1792 pd=1.84 ps=1.84
XM2 a_27_368##11 A#1 VGND#4 VNB sky130_fd_pr__nfet_01v8_lvt l=0.15 w=0.64 ad=0.1792 as=0.2552 pd=1.84 ps=2.19
XM0 VGND#4 a_27_368##4 X#1 VNB sky130_fd_pr__nfet_01v8_lvt l=0.15 w=0.74 ad=0.2552 as=0.2072 pd=2.19 ps=2.04
XM6 X#1 a_27_368##5 VGND#1 VNB sky130_fd_pr__nfet_01v8_lvt l=0.15 w=0.74 ad=0.2072 as=0.2479 pd=2.04 ps=2.15
XM1 a_27_368##10 B#1 a_114_368# VPB sky130_fd_pr__pfet_01v8 l=0.15 w=1 ad=0.285 as=0.24 pd=2.57 ps=2.48
XM4 a_114_368# A#3 VPWR#4 VPB sky130_fd_pr__pfet_01v8 l=0.15 w=1 ad=0.24 as=0.4254 pd=2.48 ps=3.02
XM7 VPWR#4 a_27_368##7 X#3 VPB sky130_fd_pr__pfet_01v8 l=0.15 w=1.12 ad=0.4254 as=0.3584 pd=3.02 ps=2.88
XM5 X#3 a_27_368##6 VPWR#1 VPB sky130_fd_pr__pfet_01v8 l=0.15 w=1.12 ad=0.3584 as=0.3304 pd=2.88 ps=2.83
*
*
*       RESISTOR AND CAP/DIODE CARDS
*
Rg1	B#1	B#2	472.643829
Rg2	B#2	B#3	26.659500
Rg3	B#2	B#4	294.260559
Rg4	A#1	A#2	353.846649
Rg5	A#2	A#3	400.207520
Rg6	a_27_368#	a_27_368##2	41.678959
Rg7	a_27_368##2	a_27_368##3	70.323891
Rg8	a_27_368##3	a_27_368##4	368.862610
Rg9	a_27_368##2	a_27_368##5	367.764618
Rg10	a_27_368##2	a_27_368##6	471.250305
Rg11	a_27_368##3	a_27_368##7	471.862823
Rf1	B	B#3	163.775864
Rf2	A#4	A#2	162.239227
Rf3	A	A#6	2.006430
Rf4	A#4	A#6	4.483734
Rf5	A	A#7	2.006430
Rf6	A#6	A#7	11.059877
Rf7	X	X#2	9.833392
Rf8	X#2	X	9.833392
Rf9	X	X#4	16.112940
Rf10	X#4	X	2.299738
Rf11	X#1	X#2	7.500000
Rf12	X#3	X#4	15.000000
Rf13	a_27_368#	a_27_368##9	285.152954
Rf14	a_27_368##9	a_27_368##10	70.419144
Rf15	a_27_368##9	a_27_368##11	144.105240
Rf16	VGND#1	VGND#2	99.230423
Rf17	VGND#2	VGND#3	111.102318
Rf18	VGND#2	VGND#4	40.761108
Rf19	VPWR#1	VPWR#2	98.081841
Rf21	VPWR#2	VPWR#4	36.824379
Re1	VPWR#2	VPWR	1.964508
Re2	VGND	VGND#2	1.964582
*
*       CAPACITOR CARDS
*
*
C1	A#1	a_27_368##3	7.49707e-19
C2	a_27_368##3	a_27_368##2	3.36673e-18
C3	a_27_368##9	a_27_368##3	5.1765e-18
C4	a_27_368##9	a_27_368##2	7.98727e-19
C5	VGND#2	a_27_368##3	6.36986e-20
C6	VGND#2	a_27_368##2	3.75822e-20
C7	a_27_368#	a_27_368##3	1.24229e-19
C8	a_27_368#	a_27_368##2	2.78362e-17
C9	A#7	a_27_368##9	4.6468e-17
C10	A#2	a_27_368##3	3.14085e-17
C11	A#4	a_27_368##9	6.59637e-18
C12	a_27_368##9	VGND#1	2.72486e-19
C13	a_27_368##9	X#1	1.71428e-19
C14	a_27_368##11	a_27_368##9	1.38844e-18
C15	a_27_368##9	VPWR#1	1.97731e-17
C16	a_27_368##9	X#3	4.27391e-18
C17	a_27_368##9	VPWR#4	3.48527e-17
C18	a_27_368##11	A#4	5.56457e-17
C19	VGND#4	VGND#1	1.84057e-18
C20	a_27_368##10	a_27_368##9	2.14593e-18
C21	A#7	VPWR#4	1.40658e-18
C22	A#4	a_27_368##3	2.48433e-18
C23	a_27_368##11	VGND#4	6.38099e-17
C24	A	a_27_368##3	6.99198e-19
C25	a_27_368##10	A#7	4.72202e-17
C26	VGND#3	VGND#4	4.46261e-18
C27	VGND#3	a_27_368##11	5.21105e-17
C28	a_27_368##9	a_27_368##6	1.55498e-17
C29	VGND#1	a_27_368##5	3.00797e-17
C30	a_27_368##5	X#1	1.53889e-17
C31	a_27_368##9	a_27_368##7	2.70895e-17
C32	VGND#1	a_27_368##4	1.25363e-18
C33	VPWR#4	VPWR#1	9.91244e-18
C34	a_27_368##10	a_27_368##11	6.94536e-20
C35	VGND#4	a_27_368##5	1.5422e-18
C36	VGND#1	a_27_368##2	1.07743e-17
C37	a_27_368##11	a_27_368##5	1.03172e-18
C38	a_27_368##9	A#3	1.89391e-17
C39	VGND#4	a_27_368##4	3.51718e-17
C40	X	a_27_368##3	1.11297e-17
C41	X	a_27_368##2	1.55921e-17
C42	a_27_368##11	a_27_368##4	7.44383e-18
C43	A#7	a_27_368##7	1.89177e-18
C44	A#1	VGND#4	1.75459e-17
C45	a_27_368##9	B#1	5.79824e-19
C46	VGND#3	a_27_368##4	1.37114e-18
C47	a_27_368##11	A#1	4.66001e-17
C48	a_27_368##10	VPWR#4	6.83186e-18
C49	VGND#4	B#4	1.42908e-18
C50	A#7	A#3	1.08131e-17
C51	VGND#3	A#1	2.7193e-18
C52	a_27_368##3	X#1	2.28296e-19
C53	a_27_368##11	B#4	1.36529e-17
C54	A#7	B#1	6.17808e-18
C55	VGND#3	B#4	3.49131e-17
C56	a_27_368##2	X#1	1.34695e-19
C57	VPWR#1	a_27_368##6	2.97275e-17
C58	a_27_368##4	a_27_368##5	3.93448e-17
C59	a_27_368#	a_27_368##9	5.93624e-18
C60	a_27_368##6	X#3	2.77647e-17
C61	VPWR#1	a_27_368##7	4.78966e-18
C62	VPWR#4	a_27_368##6	5.24241e-18
C63	a_27_368##7	X#3	2.08574e-17
C64	A#1	a_27_368##4	2.75122e-17
C65	a_27_368##9	A#2	5.36306e-18
C66	VPWR#4	a_27_368##7	4.5034e-17
C67	VGND#2	A#4	6.74466e-19
C68	a_27_368##10	a_27_368##6	4.49314e-19
C69	B#4	A#1	3.34985e-17
C70	A#3	VPWR#4	2.59094e-17
C71	VGND#2	VGND#1	2.89123e-17
C72	a_27_368##10	a_27_368##7	1.48331e-18
C73	VPWR#4	B#1	4.18447e-18
C74	a_27_368##10	A#3	1.17043e-17
C75	a_27_368#	VGND#1	3.57802e-17
C76	VGND#2	a_27_368##11	9.88915e-18
C77	A#4	A#2	1.21414e-17
C78	a_27_368##11	a_27_368##3	5.90662e-18
C79	a_27_368##10	B#1	6.07604e-17
C80	VGND#2	VGND#3	2.34808e-17
C81	A#4	B#3	6.45297e-18
C82	a_27_368##11	a_27_368##2	7.43098e-20
C83	VGND#4	A#2	8.17738e-19
C84	a_27_368#	VPWR#1	2.47602e-17
C85	a_27_368##11	A#2	7.08992e-18
C86	a_27_368##7	a_27_368##6	4.43376e-17
C87	a_27_368##11	B#3	1.46128e-19
C88	VGND#2	a_27_368##5	2.60426e-18
C89	B#3	VGND#3	8.7302e-18
C90	A#3	a_27_368##7	3.10459e-17
C91	A#2	VPWR#4	8.20339e-19
C92	VGND#2	a_27_368##4	7.9844e-18
C93	A	a_27_368##9	2.22073e-17
C94	VGND#2	A#1	2.51274e-18
C95	VGND#2	B#4	5.25664e-18
C96	B#1	A#3	5.95161e-17
C97	a_27_368##10	B#3	3.92128e-18
C98	a_27_368#	a_27_368##6	8.33557e-18
C99	B#3	A#1	5.17955e-18
C100	a_27_368#	a_27_368##7	7.01844e-19
C101	a_27_368##3	VNB	2.02497e-17
C102	a_27_368##2	VNB	6.12382e-17
C103	a_27_368##9	X	8.04212e-17
C104	a_27_368##10	a_114_368#	3.1815e-18
C105	B	A#4	2.45252e-17
C106	A#2	a_27_368##7	7.68696e-19
C107	B#1	A#2	3.98786e-18
C108	A	VPWR#4	8.98223e-20
C109	B	a_27_368##11	2.57405e-18
C110	VPWR	a_27_368##9	1.49372e-17
C111	VGND#3	B	2.78873e-17
C112	X	VGND#1	6.51162e-17
C113	a_27_368##10	A	9.89615e-18
C114	X	X#1	2.64712e-18
C115	VPWR	A#7	4.90465e-18
C116	VGND#4	X	4.10077e-17
C117	a_27_368##11	X	5.13118e-17
C118	A#3	a_114_368#	1.79259e-17
C119	B	a_27_368##10	2.07087e-17
C120	X	X#3	1.71228e-18
C121	B#1	a_114_368#	1.36331e-17
C122	a_27_368##2	VPWR#1	1.22689e-18
C123	A	a_27_368##7	1.06885e-18
C124	X	a_27_368##5	2.24732e-17
C125	B#3	A#2	3.06685e-17
C126	VPWR	VPWR#1	3.67054e-17
C127	VGND	A#4	5.79188e-18
C128	A	A#3	1.70905e-18
C129	X	a_27_368##4	1.2254e-17
C130	VPWR	VPWR#4	1.63069e-17
C131	VGND	VGND#1	4.03869e-17
C132	X	A#1	4.64788e-19
C133	A	B#1	3.90319e-18
C134	VPWR	a_27_368##10	1.9426e-17
C135	VGND	a_27_368##11	1.53714e-17
C136	VGND	VGND#3	3.96512e-17
C137	X	a_27_368##6	1.13676e-17
C138	X	a_27_368##7	7.37154e-18
C139	VGND	a_27_368##10	2.84256e-18
C140	VPWR	a_27_368##6	3.04381e-19
C141	VGND	a_27_368##5	3.91099e-18
C142	A	A#2	5.67269e-18
C143	VGND	a_27_368##4	4.63835e-18
C144	VPWR	a_27_368##7	1.04469e-18
C145	VGND	A#1	7.56462e-18
C146	A	B#3	2.544e-18
C147	VPWR	A#3	7.25174e-18
C148	VGND	B#4	4.1784e-18
C149	B	A#2	2.04236e-18
C150	a_27_368##9	VNB	1.16471e-18
C151	VPWR	B#1	9.1888e-18
C152	VGND#2	X	1.33352e-17
C153	X	a_27_368#	6.07336e-17
C154	B	B#3	2.35717e-17
C155	A#4	VNB	9.33128e-19
C156	VGND#1	VNB	7.16976e-17
C157	a_27_368##3	X#3	1.37938e-19
C158	VPWR	a_27_368#	2.95992e-18
C159	VGND#4	VNB	1.49578e-18
C160	a_27_368##11	VNB	7.71714e-18
C161	VGND#3	VNB	5.80247e-17
C162	VPWR#1	VNB	4.72434e-17
C163	VGND	VGND#2	5.19892e-17
C164	VPWR#4	VNB	6.31322e-18
C165	VGND	a_27_368#	2.17475e-18
C166	a_27_368##10	VNB	5.08115e-17
C167	a_27_368##5	VNB	3.55577e-17
C168	a_27_368##4	VNB	2.99672e-17
C169	A#1	VNB	2.7863e-17
C170	VGND	B#3	1.10693e-20
C171	B#4	VNB	3.31411e-17
C172	a_27_368##6	VNB	3.34187e-17
C173	a_27_368##2	X#3	1.36316e-19
C174	a_27_368##7	VNB	3.7084e-17
C175	A#3	VNB	3.09003e-17
C176	B#1	VNB	4.88079e-17
C177	VPWR	B	2.63526e-18
C178	VGND#2	VNB	1.65029e-16
C179	VPWR	X	3.8675e-18
C180	a_27_368#	VNB	4.99308e-17
C181	VGND	B	2.26728e-18
C182	A#2	VNB	2.99223e-17
C183	B#3	VNB	5.90296e-17
C184	VGND	X	1.58374e-17
C185	A	VNB	4.77625e-18
C186	B	VNB	1.80668e-17
C187	X	VNB	1.00685e-17
C188	VPWR	VNB	5.22778e-17
C189	VGND	VNB	5.06219e-17
C190	VPWR#2	a_27_368##3	6.70514e-20
C191	VPWR	VPWR#2	5.49834e-17
C192	VPWR#2	VPWR#1	2.87717e-17
C193	VPWR#2	B#1	4.50298e-18
C194	a_27_368##10	VPWR#2	1.6616e-17
C195	VPWR#2	A#3	6.58076e-18
C196	a_27_368##9	VPWR#2	5.70209e-18
C197	VPWR#2	VNB	1.90816e-16
C198	VPWR#2	a_27_368##7	5.32506e-18
C199	VPWR#2	B#3	2.17112e-19
C200	VPWR#2	a_27_368##2	6.27979e-20
*
*
.ENDS sky130_fd_sc_hs__or2_2
*
