* Extracted by Quantus, converted by sky130cad/quantus.py
*
*
*
*                       LINUX           Wed Nov 18 08:02:43 2026
*
*
*
*  PROGRAM  advgen
*
*  Name           : advgen - Quantus - (64-bit)
*  Version        : 25.1.0-p047
*  Build Date     : Thu Dec 11 23:20:30 PST 2025
*
*  HSPICE LIBRARY
*
*  OPERATING_TEMPERATURE 150
*  QRC_TECH_DIR <path>/tech
*
*
*

*
.SUBCKT sky130_fd_sc_hs__a2111oi_2 VPB VNB VGND VPWR Y B1 D1 C1 A1 A2
*
*
*  caps2d version: 10
*
*
*       TRANSISTOR CARDS
*
*
XM16 VGND#9 D1#4 Y#5 VNB sky130_fd_pr__nfet_01v8_lvt l=0.15 w=0.74 ad=0.2109 as=0.2886 pd=2.05 ps=2.26
XM5 Y#5 C1#3 VGND#8 VNB sky130_fd_pr__nfet_01v8_lvt l=0.15 w=0.74 ad=0.2886 as=0.2886 pd=2.26 ps=2.26
XM1 VGND#8 B1#4 Y#2 VNB sky130_fd_pr__nfet_01v8_lvt l=0.15 w=0.74 ad=0.2886 as=0.1961 pd=2.26 ps=2.01
XM3 a_722_74##4 A1#7 Y#1 VNB sky130_fd_pr__nfet_01v8_lvt l=0.15 w=0.74 ad=0.1961 as=0.2072 pd=2.01 ps=2.04
XM8 Y#1 A1#1 a_722_74##2 VNB sky130_fd_pr__nfet_01v8_lvt l=0.15 w=0.74 ad=0.2072 as=0.2072 pd=2.04 ps=2.04
XM7 a_722_74##2 A2#5 VGND#7 VNB sky130_fd_pr__nfet_01v8_lvt l=0.15 w=0.74 ad=0.2072 as=0.2146 pd=2.04 ps=2.06
XM11 VGND#7 A2#6 a_722_74# VNB sky130_fd_pr__nfet_01v8_lvt l=0.15 w=0.74 ad=0.2146 as=0.1961 pd=2.06 ps=2.01
XM2 Y#6 D1#3 a_69_368##3 VPB sky130_fd_pr__pfet_01v8 l=0.15 w=1.12 ad=0.336 as=0.308 pd=2.84 ps=2.79
XM9 a_69_368##4 D1#1 Y#6 VPB sky130_fd_pr__pfet_01v8 l=0.15 w=1.12 ad=0.336 as=0.336 pd=2.84 ps=2.84
XM12 a_334_368##2 C1#4 a_69_368##4 VPB sky130_fd_pr__pfet_01v8 l=0.15 w=1.12 ad=0.336 as=0.336 pd=2.84 ps=2.84
XM10 a_69_368# C1#1 a_334_368##2 VPB sky130_fd_pr__pfet_01v8 l=0.15 w=1.12 ad=0.308 as=0.336 pd=2.79 ps=2.84
XM4 a_334_368# B1#5 a_533_368##5 VPB sky130_fd_pr__pfet_01v8 l=0.15 w=1.12 ad=0.336 as=0.308 pd=2.84 ps=2.79
XM13 a_533_368##3 B1#1 a_334_368# VPB sky130_fd_pr__pfet_01v8 l=0.15 w=1.12 ad=0.336 as=0.336 pd=2.84 ps=2.84
XM6 VPWR#6 A1#5 a_533_368##3 VPB sky130_fd_pr__pfet_01v8 l=0.15 w=1.12 ad=0.336 as=0.336 pd=2.84 ps=2.84
XM14 a_533_368##6 A1#6 VPWR#6 VPB sky130_fd_pr__pfet_01v8 l=0.15 w=1.12 ad=0.336 as=0.336 pd=2.84 ps=2.84
XM15 a_533_368##6 A2#7 VPWR#5 VPB sky130_fd_pr__pfet_01v8 l=0.15 w=1.12 ad=0.336 as=0.336 pd=2.84 ps=2.84
XM0 VPWR#5 A2#1 a_533_368# VPB sky130_fd_pr__pfet_01v8 l=0.15 w=1.12 ad=0.336 as=0.308 pd=2.84 ps=2.79
*
*
*       RESISTOR AND CAP/DIODE CARDS
*
Rg1	D1#1	D1#2	429.126801
Rg2	D1#2	D1#3	503.586761
Rg3	D1#2	D1#4	377.027313
Rg4	C1#1	C1#2	507.018372
Rg5	C1#2	C1#3	377.027313
Rg6	C1#2	C1#4	416.495819
Rg7	B1#1	B1#2	502.279022
Rg8	B1#2	B1#3	61.691868
Rg9	B1#3	B1#4	750.791809
Rg10	B1#3	B1#5	475.000031
Rg11	A1#1	A1#2	397.555725
Rg12	A1#2	A1#3	28.628225
Rg13	A1#3	A1#4	24.707481
Rg14	A1#4	A1#5	451.667847
Rg15	A1#2	A1#6	449.655212
Rg16	A1#4	A1#7	402.159912
Rg17	A2#1	A2#2	503.938385
Rg18	A2#2	A2#3	31.581308
Rg19	A2#3	A2#4	21.754395
Rg20	A2#4	A2#5	397.555725
Rg21	A2#2	A2#6	451.838898
Rg22	A2#4	A2#7	449.655212
Rf1	D1#5	D1	1.409262
Rf2	D1#2	D1#7	161.642059
Rf3	D1#5	D1#7	12.529713
Rf4	D1#8	D1	1.409262
Rf5	D1#7	D1#8	2.139219
Rf6	a_69_368#	a_69_368##2	88.788750
Rf7	a_69_368##2	a_69_368##3	89.080147
Rf8	a_69_368##2	a_69_368##4	38.224628
Rf9	C1	C1#2	160.538406
Rf10	a_334_368#	a_334_368##2	128.072418
Rf11	B1	B1#6	7.412643
Rf12	B1#6	B1	9.530541
Rf13	Y#1	Y#3	116.885353
Rf14	Y#3	Y#4	81.226479
Rf15	Y#4	Y	85.170479
Rf16	Y#4	Y#5	18.149860
Rf17	Y	Y#6	77.838089
Rf18	Y#2	Y#3	7.500000
Rf19	A1#8	A1	1.409262
Rf20	A1#3	A1#10	161.642059
Rf21	A1#8	A1#10	1.528014
Rf22	A1#11	A1	1.409262
Rf23	A1#10	A1#11	13.140918
Rf24	A2	A2#3	166.137894
Rf25	a_722_74#	a_722_74##3	107.668564
Rf26	a_722_74##3	a_722_74##4	73.010193
Rf27	a_722_74##2	a_722_74##3	7.500000
Rf28	a_533_368#	a_533_368##2	89.588470
Rf29	a_533_368##2	a_533_368##4	71.668030
Rf30	a_533_368##4	a_533_368##5	100.914352
Rf31	a_533_368##2	a_533_368##6	20.631947
Rf32	a_533_368##3	a_533_368##4	5.000000
Rf34	VPWR#2	VPWR#3	65.818954
Rf35	VPWR#3	VPWR#4	92.141670
Rf36	VPWR#2	VPWR#5	32.518913
Rf37	VPWR#3	VPWR#6	53.143215
Rf39	VGND#2	VGND#3	157.028351
Rf40	VGND#3	VGND#4	76.672798
Rf41	VGND#4	VGND#5	73.360992
Rf43	VGND#2	VGND#7	37.596169
Rf44	VGND#4	VGND#8	37.596169
Rf45	VGND#5	VGND#9	38.247387
Rf48	B1#2	B1#6	160.232803
Re1	VPWR#4	VPWR	0.818510
Re2	VGND	VGND#3	0.818540
*
*       CAPACITOR CARDS
*
*
C1	VGND	VNB	9.13437e-17
C2	VPWR	VNB	8.90565e-17
C3	Y	VNB	7.89559e-17
C4	B1	VNB	5.6359e-18
C5	D1	VNB	1.6226e-17
C6	VGND	Y	8.97713e-18
C7	VGND#8	A1#7	2.17892e-19
C8	C1	VNB	1.57804e-17
C9	A1	VNB	1.08188e-18
C10	VGND	B1	5.24305e-18
C11	A2	VNB	9.8331e-18
C12	VPWR	Y	6.49687e-18
C13	VGND	D1	3.76292e-18
C14	VGND	C1	7.03715e-18
C15	VPWR	B1	3.28509e-18
C16	VGND	A1	2.99731e-18
C17	VPWR	D1	3.09369e-18
C18	D1#2	VNB	3.90254e-17
C19	VPWR	C1	8.66534e-18
C20	a_722_74##4	B1#4	1.11562e-18
C21	C1#2	VNB	3.45492e-17
C22	Y	D1	3.81014e-17
C23	B1#2	VNB	4.44024e-17
C24	VPWR	A1	3.18813e-18
C25	VPWR#3	VPWR#5	2.83085e-19
C26	A2#3	VNB	9.53825e-18
C27	VPWR	A2	2.54651e-18
C28	VGND#3	VNB	2.84941e-16
C29	VPWR#4	VNB	3.54796e-16
C30	a_334_368##2	a_334_368#	1.51502e-18
C31	D1#3	VNB	7.77698e-17
C32	C1	B1	1.69446e-17
C33	a_69_368#	a_533_368##5	6.64225e-17
C34	D1#1	VNB	3.2874e-17
C35	C1#4	VNB	3.28761e-17
C36	Y#2	A1#7	1.65669e-18
C37	C1#1	VNB	4.68907e-17
C38	B1	A1	1.62754e-17
C39	VGND	B1#2	1.70383e-18
C40	B1#5	VNB	3.91869e-17
C41	D1	C1	3.6421e-17
C42	a_533_368##2	VPWR#3	3.13618e-19
C43	B1#1	VNB	3.54387e-17
C44	A1#5	VNB	3.16568e-17
C45	VGND	A2#3	2.69273e-18
C46	A1#6	VNB	3.1672e-17
C47	D1#7	a_69_368##2	8.35356e-19
C48	VGND	VGND#3	3.83091e-17
C49	A2#7	VNB	2.90427e-17
C50	A2#1	VNB	3.70807e-17
C51	D1#4	VNB	3.6137e-17
C52	Y#1	B1#4	2.77009e-19
C53	C1#3	VNB	2.71641e-17
C54	C1	A1	3.90545e-18
C55	VPWR	B1#2	1.2651e-18
C56	B1#4	VNB	5.92197e-17
C57	A1#7	VNB	3.60434e-17
C58	A1#1	VNB	3.04991e-17
C59	A2#5	VNB	2.49842e-17
C60	Y	D1#2	8.10414e-19
C61	VGND	C1#1	4.03412e-21
C62	Y#1	A1#10	1.56684e-17
C63	A2#6	VNB	3.01386e-17
C64	a_69_368##3	VNB	4.17256e-17
C65	Y	C1#2	1.53218e-19
C66	Y#6	VNB	2.35054e-18
C67	A1#4	A2#4	2.62462e-17
C68	VPWR	VPWR#4	7.36801e-17
C69	a_334_368##2	VNB	3.00024e-18
C70	A1	A2	1.98553e-17
C71	a_722_74##4	A1#7	3.82601e-17
C72	a_69_368#	VNB	1.2676e-17
C73	a_533_368##5	VNB	1.44549e-17
C74	VPWR	D1#3	2.58973e-18
C75	a_334_368#	VNB	3.13901e-18
C76	B1	D1#2	4.29922e-19
C77	a_533_368##3	VNB	1.90015e-18
C78	VPWR	D1#1	1.67344e-18
C79	VPWR#6	VNB	2.92383e-18
C80	VPWR#3	C1#1	6.18609e-20
C81	a_533_368##6	VNB	2.24265e-18
C82	B1	C1#2	1.07923e-18
C83	VPWR	C1#4	1.67955e-18
C84	VPWR#5	VNB	2.38853e-18
C85	VGND	D1#4	4.68381e-19
C86	a_533_368#	VNB	5.95951e-17
C87	VGND#9	VNB	2.39827e-17
C88	VGND	C1#3	1.85055e-19
C89	VPWR	C1#1	1.68578e-18
C90	B1	B1#2	1.19016e-17
C91	Y#5	VNB	5.68804e-18
C92	Y	VPWR#4	2.15571e-18
C93	Y#2	A1#1	3.7591e-19
C94	VGND	B1#4	3.78332e-19
C95	D1	D1#2	1.00569e-17
C96	VGND#8	VNB	2.06531e-18
C97	VPWR	B1#5	1.62774e-18
C98	Y#2	VNB	2.72012e-17
C99	VGND	A1#7	8.74289e-19
C100	VPWR	B1#1	1.44862e-18
C101	a_722_74##4	VNB	1.20992e-17
C102	VGND	A1#1	8.43202e-19
C103	Y#1	VNB	7.89075e-18
C104	D1	C1#2	5.69122e-18
C105	VPWR	A1#5	1.19992e-18
C106	a_722_74##2	VNB	9.06137e-18
C107	VGND	A2#5	8.39541e-19
C108	Y	D1#3	1.52906e-17
C109	VGND#7	VNB	1.37929e-18
C110	VGND	A2#6	1.47147e-18
C111	VPWR	A1#6	7.76551e-19
C112	a_722_74#	VNB	4.57856e-17
C113	Y	D1#1	3.29945e-19
C114	D1#7	VNB	7.58676e-19
C115	VPWR	A2#7	1.00981e-18
C116	C1	D1#2	5.8981e-18
C117	Y#1	A1#7	4.84477e-17
C118	Y	C1#4	3.04077e-19
C119	VPWR	A2#1	1.91479e-18
C120	a_69_368##2	VNB	4.54117e-18
C121	Y	C1#1	2.80487e-19
C122	C1	C1#2	2.95005e-17
C123	Y#4	VNB	3.387e-18
C124	a_334_368#	a_533_368##5	1.003e-16
C125	VGND	a_334_368#	2.42969e-18
C126	C1	B1#2	2.45462e-19
C127	A1#10	VNB	4.09684e-18
C128	A1#10	A1#6	7.88683e-19
C129	a_722_74##2	A1#10	2.63107e-19
C130	VGND	a_533_368#	4.86396e-18
C131	A1	B1#2	3.10034e-18
C132	VPWR#3	VNB	3.16283e-17
C133	VGND	Y#5	1.66001e-17
C134	a_722_74##2	A1#7	1.66657e-18
C135	D1	D1#3	9.86163e-18
C136	VPWR	a_69_368##3	2.10444e-17
C137	VGND	Y#2	2.99428e-17
C138	VGND#4	VNB	3.58005e-17
C139	VPWR	Y#6	8.82791e-18
C140	VGND	a_722_74##4	1.87456e-17
C141	D1	D1#1	2.00787e-18
C142	C1#1	B1#3	1.38986e-18
C143	VGND	Y#1	1.35246e-17
C144	A1	A2#3	1.70922e-17
C145	VPWR	a_334_368##2	1.07935e-17
C146	VGND	a_722_74##2	1.82971e-17
C147	VPWR#3	B1#5	1.948e-19
C148	VPWR	a_69_368#	2.10176e-17
C149	Y	B1#4	1.34229e-18
C150	VGND	a_722_74#	1.53989e-17
C151	VPWR	a_533_368##5	2.48908e-17
C152	Y#1	A1#1	2.9696e-17
C153	a_533_368##5	a_533_368##3	2.73314e-18
C154	VGND	D1#7	1.23194e-18
C155	VPWR	a_334_368#	9.77987e-18
C156	a_533_368##2	A1#4	1.70963e-18
C157	VPWR	a_533_368##3	1.9867e-17
C158	C1	D1#1	5.94173e-19
C159	VPWR	a_533_368##6	1.3444e-17
C160	VGND#7	A1#7	4.1437e-19
C161	VPWR	VPWR#5	2.17678e-17
C162	Y	a_69_368##3	2.31379e-17
C163	VPWR	a_533_368#	1.52305e-17
C164	VGND	Y#4	3.53853e-18
C165	Y	Y#6	4.32335e-18
C166	C1	C1#1	1.35624e-17
C167	VGND	A1#10	1.32337e-18
C168	C1	B1#5	3.40314e-18
C169	a_722_74##2	A1#1	3.94427e-17
C170	a_533_368##2	A1#5	2.03238e-19
C171	B1	A1#7	8.85963e-19
C172	C1	B1#1	4.20793e-19
C173	A2#4	VPWR#5	1.2952e-18
C174	B1	A1#1	1.03633e-18
C175	a_533_368##3	a_334_368#	6.30747e-17
C176	C1	A1#5	1.53092e-19
C177	B1	A2#5	6.3944e-19
C178	A1	C1#1	8.71441e-19
C179	B1	A2#6	5.85999e-19
C180	Y#1	A2#5	8.78766e-19
C181	A1	B1#5	4.30672e-19
C182	VPWR	D1#7	1.58716e-18
C183	VGND	VGND#4	4.78476e-17
C184	A1	B1#1	8.97628e-19
C185	VPWR#3	B1#1	1.98238e-18
C186	VGND#7	A1#1	1.44604e-18
C187	VPWR	a_69_368##2	2.5289e-17
C188	Y	VGND#9	1.0449e-17
C189	A1	A1#5	1.59722e-18
C190	D1#2	C1#2	3.53524e-17
C191	A1	A1#6	1.24837e-18
C192	a_722_74##2	A2#5	2.61237e-17
C193	B1	a_334_368#	1.87061e-17
C194	A1	A2#7	1.39897e-18
C195	VPWR	A1#10	1.22714e-18
C196	B1	a_533_368##3	1.08164e-17
C197	C1	B1#4	1.35607e-17
C198	D1	Y#6	2.83108e-17
C199	a_533_368##2	A1#6	1.78719e-17
C200	a_722_74#	A1#1	1.87275e-19
C201	D1	a_69_368##4	1.93332e-17
C202	A2	A1#6	2.06677e-19
C203	VPWR	a_533_368##2	3.57277e-18
C204	Y#4	D1#7	1.95328e-17
C205	A2	A2#7	2.05005e-18
C206	B1#3	VNB	5.38919e-17
C207	VGND#7	A2#5	2.90604e-17
C208	VPWR	VPWR#3	3.50771e-17
C209	A1#4	VNB	5.32331e-17
C210	A2	A2#1	1.24605e-19
C211	A2#4	VNB	6.8562e-17
C212	a_533_368##3	VPWR#6	5.99283e-17
C213	Y#2	B1	2.56811e-17
C214	VPWR#3	A1#5	4.87193e-18
C215	a_722_74##2	A2#6	7.99205e-19
C216	a_533_368##2	A2#4	1.73372e-18
C217	VPWR#4	D1#2	2.96509e-20
C218	Y#1	B1	3.05449e-17
C219	C1	a_334_368##2	8.29015e-17
C220	a_722_74#	A2#5	8.37828e-19
C221	Y#4	D1#4	1.95552e-17
C222	VPWR#4	C1#2	3.01484e-20
C223	VGND#3	B1#2	1.51496e-18
C224	a_533_368##2	A2#7	1.9111e-17
C225	a_334_368#	VPWR#5	1.47381e-20
C226	D1#3	D1#2	9.27231e-19
C227	C1	a_334_368#	2.60915e-17
C228	a_533_368##3	a_533_368##6	1.73069e-18
C229	VGND#7	A2#6	3.01821e-17
C230	VPWR#4	B1#2	4.69892e-20
C231	D1#1	C1#2	1.87464e-19
C232	a_722_74#	A2#6	3.77878e-17
C233	VPWR#3	A1#6	5.2259e-18
C234	VPWR#6	a_533_368##6	5.11921e-17
C235	A1	a_533_368##3	1.47064e-17
C236	Y#4	C1#3	1.84049e-17
C237	a_722_74##2	a_533_368##2	3.66221e-18
C238	Y#2	C1	7.30821e-17
C239	a_533_368##2	A2#1	3.32333e-19
C240	D1	a_69_368##2	5.32539e-19
C241	a_533_368#	a_533_368##3	4.75919e-21
C242	VPWR#6	VPWR#5	2.28687e-18
C243	VGND	B1#3	2.43896e-18
C244	Y#4	D1	4.00909e-17
C245	VGND#4	Y#5	9.15128e-18
C246	VPWR#3	A2#7	5.01904e-19
C247	Y#4	B1#4	1.45351e-19
C248	VPWR#4	D1#3	4.43628e-18
C249	A2	a_533_368#	1.14873e-17
C250	Y#1	A1	7.32762e-18
C251	C1	a_69_368##2	1.56695e-18
C252	a_533_368##6	VPWR#5	5.30395e-17
C253	a_722_74##2	A1	2.63253e-17
C254	VPWR#4	D1#1	4.47364e-18
C255	B1#1	A1#4	3.57866e-18
C256	Y#4	C1	2.76702e-17
C257	VPWR#4	C1#4	4.42929e-18
C258	a_533_368##6	a_533_368#	1.29937e-18
C259	VPWR#4	C1#1	4.49043e-18
C260	D1#3	D1#1	4.58361e-17
C261	VPWR#4	B1#5	4.46319e-18
C262	Y#2	a_334_368#	4.12705e-18
C263	C1#2	B1#4	5.86816e-18
C264	VPWR#4	B1#1	2.90097e-18
C265	D1#7	Y#6	2.19072e-17
C266	a_533_368#	VPWR#5	5.95271e-17
C267	D1#1	C1#4	4.97484e-17
C268	C1#2	B1#3	1.0213e-18
C269	a_69_368##3	D1#2	1.39068e-19
C270	VGND#4	Y#2	1.17954e-17
C271	B1#2	A1#7	4.54644e-18
C272	D1#2	Y#6	3.72275e-18
C273	C1#4	C1#1	4.80145e-17
C274	A1	a_533_368##2	3.27633e-17
C275	C1#1	B1#5	6.30428e-18
C276	C1#2	a_334_368##2	4.14442e-18
C277	a_69_368##2	Y#6	1.52101e-17
C278	VGND#3	B1#4	8.69851e-20
C279	Y#1	a_533_368##3	4.19705e-18
C280	A2	a_533_368##2	3.14194e-17
C281	a_69_368#	C1#2	1.68721e-19
C282	VGND#3	A1#7	1.98867e-18
C283	B1#5	B1#1	5.002e-17
C284	VPWR#4	B1#4	2.62772e-19
C285	B1#3	B1#2	4.78619e-18
C286	a_69_368##2	a_69_368##4	8.04838e-19
C287	Y#2	B1#3	1.32716e-17
C288	B1#2	a_533_368##5	1.10055e-18
C289	B1#2	A1#4	2.59763e-17
C290	VGND#9	Y#5	4.52314e-17
C291	B1#2	a_334_368#	9.16553e-18
C292	VGND#9	D1#2	5.24386e-19
C293	B1#1	A1#5	4.66155e-17
C294	B1#2	a_533_368##3	7.20745e-19
C295	VGND#4	D1#4	9.02801e-19
C296	a_69_368##2	a_334_368##2	1.53013e-17
C297	VGND#9	VGND#8	1.33567e-18
C298	a_69_368##3	VPWR#4	5.03936e-17
C299	A1#5	A1#6	4.7523e-17
C300	VGND#8	C1#2	1.25849e-18
C301	Y#5	VGND#8	4.53275e-17
C302	Y#2	C1#2	2.71434e-19
C303	B1	B1#3	1.59873e-17
C304	VGND#4	C1#3	4.14118e-18
C305	a_334_368##2	VPWR#4	7.88625e-19
C306	B1	A1#4	9.24188e-18
C307	A1#6	A2#7	4.68064e-17
C308	a_334_368##2	B1#3	4.2031e-20
C309	B1#4	C1#1	9.92875e-18
C310	B1	A2#4	5.37648e-19
C311	a_69_368##3	D1#3	3.75855e-17
C312	Y#4	a_69_368##4	5.0022e-18
C313	a_69_368#	VPWR#4	5.03207e-17
C314	Y#5	Y#2	3.74183e-18
C315	D1#7	D1#2	1.05545e-17
C316	Y#2	B1#2	1.0971e-18
C317	Y#6	D1#3	6.08562e-17
C318	a_533_368##5	VPWR#4	6.02471e-17
C319	a_69_368##3	D1#1	1.30694e-18
C320	A2#7	A2#1	4.63307e-17
C321	a_334_368#	VPWR#4	6.65522e-19
C322	a_69_368##4	D1#3	1.29161e-18
C323	Y#1	B1#2	1.78154e-17
C324	VGND#4	B1#4	6.47752e-18
C325	a_69_368##2	D1#2	8.05003e-20
C326	Y#6	D1#1	5.05809e-17
C327	a_533_368##3	VPWR#4	8.86929e-18
C328	Y#2	VGND#8	6.25661e-17
C329	a_69_368##3	C1#4	3.00902e-19
C330	D1#1	a_69_368##4	2.86205e-17
C331	Y#6	C1#4	1.53933e-18
C332	a_722_74##4	A1#4	3.15639e-19
C333	a_334_368##2	D1#1	1.54417e-18
C334	Y#4	D1#2	5.07074e-18
C335	a_69_368##2	C1#2	1.01364e-19
C336	C1#4	a_69_368##4	2.3284e-17
C337	a_69_368#	D1#1	3.00902e-19
C338	VGND#4	A1#7	2.79051e-19
C339	a_334_368##2	C1#4	4.45435e-17
C340	a_722_74#	a_533_368#	1.33883e-17
C341	A2#3	A1#4	7.23605e-19
C342	a_69_368##4	C1#1	1.10947e-18
C343	Y#2	a_722_74##4	6.52606e-18
C344	a_69_368#	C1#4	6.72697e-19
C345	VGND#3	Y#2	1.93445e-17
C346	a_722_74##2	A2#3	2.17817e-17
C347	a_334_368#	D1#1	2.46082e-19
C348	Y#4	C1#2	2.79949e-18
C349	a_334_368##2	C1#1	6.17723e-17
C350	VGND#3	a_722_74##4	1.9432e-17
C351	A2#3	A2#4	1.49024e-17
C352	a_69_368##4	B1#5	9.80742e-20
C353	VGND#3	Y#1	4.73893e-18
C354	a_722_74#	A2#3	1.87137e-17
C355	a_69_368#	C1#1	5.67867e-17
C356	a_334_368#	C1#4	3.6094e-19
C357	Y#2	Y#1	3.5746e-18
C358	D1#4	C1#3	2.47634e-17
C359	a_334_368##2	B1#5	4.28189e-19
C360	a_533_368##5	C1#1	1.40379e-18
C361	Y#1	A1#4	2.87023e-18
C362	a_69_368#	B1#5	1.36496e-18
C363	VGND#9	D1#3	1.13941e-18
C364	a_334_368#	C1#1	8.67455e-19
C365	C1	B1#3	1.81677e-17
C366	Y#1	a_722_74##4	6.23878e-17
C367	VGND#3	B1#3	2.02e-18
C368	a_533_368##5	B1#5	4.85809e-17
C369	C1	A1#4	7.89877e-19
C370	a_533_368##5	B1#3	1.07184e-18
C371	a_533_368##3	C1#1	6.90759e-20
C372	C1#3	B1#4	2.58885e-17
C373	a_334_368#	B1#5	6.21232e-17
C374	a_533_368##5	B1#1	4.47134e-19
C375	a_533_368##3	B1#5	1.94055e-18
C376	B1#1	a_334_368#	1.81938e-17
C377	B1#4	A1#7	8.32945e-19
C378	a_533_368##3	B1#1	7.02875e-17
C379	a_722_74##2	Y#1	4.80642e-17
C380	a_334_368#	A1#5	4.13843e-19
C381	a_722_74##2	A1#4	2.39298e-19
C382	A1	B1#3	2.51225e-19
C383	A1#10	a_533_368##2	1.93353e-17
C384	a_533_368##3	A1#5	7.7003e-17
C385	VPWR#4	B1#3	2.49852e-19
C386	a_69_368##2	VPWR#4	6.32445e-17
C387	A1#10	A1#4	9.96858e-18
C388	A1#7	A1#1	4.06232e-17
C389	A1	A1#4	2.46874e-17
C390	a_334_368#	B1#3	2.44915e-18
C391	a_334_368#	A1#6	2.33468e-19
C392	A1#5	VPWR#6	2.796e-17
C393	A1	A2#4	8.46394e-18
C394	VGND#8	C1#1	5.17962e-19
C395	a_533_368##3	A1#6	1.92695e-18
C396	a_533_368##6	A1#5	1.49451e-18
C397	a_334_368#	A2#7	1.42355e-19
C398	a_533_368#	B1#1	9.69326e-20
C399	Y#2	C1#1	7.8047e-19
C400	a_722_74##2	VGND#7	5.85381e-17
C401	A1#6	VPWR#6	2.45939e-17
C402	A1#1	A2#5	4.09007e-17
C403	VPWR#5	A1#5	3.06214e-19
C404	a_722_74##2	A2#4	1.68003e-18
C405	a_533_368##6	A1#6	4.41312e-17
C406	a_334_368#	A2#1	1.74948e-19
C407	a_533_368#	A1#5	1.42355e-19
C408	D1#7	D1#1	3.30673e-18
C409	VPWR#6	A2#7	3.35849e-19
C410	a_722_74##2	a_722_74#	2.23691e-18
C411	VPWR#5	A1#6	2.79067e-18
C412	A2#7	a_533_368##6	1.78245e-17
C413	A2#5	A2#6	3.76714e-17
C414	a_533_368#	A1#6	4.14908e-19
C415	A2	A1#4	6.42675e-19
C416	VPWR#5	A2#7	4.65316e-17
C417	a_334_368##2	B1#4	1.41588e-18
C418	a_722_74#	VGND#7	5.74102e-17
C419	A2	A2#4	1.18245e-17
C420	a_69_368##2	D1#1	1.82392e-17
C421	a_533_368##6	A2#1	4.8634e-19
C422	a_533_368#	A2#7	1.20191e-18
C423	a_69_368#	B1#4	1.43669e-18
C424	Y#4	D1#3	1.25666e-18
C425	a_533_368##3	a_533_368##2	1.18264e-18
C426	VPWR#5	A2#1	4.75546e-17
C427	Y#4	VGND#9	2.44855e-17
C428	VGND#7	A2#4	1.05147e-18
C429	a_69_368##2	C1#4	1.8492e-17
C430	a_533_368##3	A1#4	7.91507e-19
C431	a_533_368#	A2#1	4.21183e-17
C432	a_533_368##2	VPWR#6	1.58753e-17
C433	Y#4	Y#5	1.01695e-18
C434	VPWR#4	VPWR#3	4.16887e-17
C435	Y#6	a_69_368##3	6.57772e-17
C436	VGND#3	VGND#4	4.32434e-17
C437	a_69_368##3	a_69_368##4	3.51463e-18
C438	Y#4	VGND#8	1.73603e-17
C439	a_533_368##2	a_533_368##6	2.72346e-18
C440	VGND#4	Y#4	2.25448e-19
C441	VGND#9	D1#4	2.64446e-17
C442	Y#6	a_69_368##4	5.80536e-17
C443	a_722_74#	A2#4	1.12898e-18
C444	a_533_368##3	VPWR#3	2.82848e-17
C445	A1#4	VPWR#6	1.88982e-18
C446	D1#4	Y#5	2.42905e-17
C447	Y#4	Y#2	5.25449e-19
C448	a_533_368##2	VPWR#5	2.4671e-17
C449	VGND#9	C1#3	4.31161e-19
C450	VGND#8	D1#4	4.41122e-19
C451	C1#3	Y#5	1.89657e-17
C452	a_69_368##4	a_334_368##2	5.86693e-17
C453	Y#2	D1#4	2.64361e-19
C454	VGND#9	B1#4	2.18833e-19
C455	C1#3	VGND#8	2.35557e-17
C456	a_533_368##2	a_533_368#	8.87901e-19
C457	a_69_368##4	a_69_368#	3.51463e-18
C458	Y#5	B1#4	1.03507e-18
C459	Y#2	C1#3	6.36689e-19
C460	a_533_368##6	VPWR#3	6.05652e-18
C461	a_69_368#	a_334_368##2	8.3051e-17
C462	B1#4	VGND#8	2.1537e-17
C463	Y#2	B1#4	7.78804e-17
C464	VGND#5	C1#3	9.26159e-19
C465	a_533_368##2	VPWR#2	3.13618e-19
C466	VPWR	VPWR#2	3.33053e-17
C467	VGND#3	VGND#2	7.81771e-17
C468	VGND#2	a_722_74##4	1.21239e-17
C469	VPWR#2	A2#7	1.83971e-18
C470	VGND#5	VNB	5.62192e-17
C471	VGND#5	Y#5	9.22e-18
C472	a_533_368##6	VPWR#2	7.18333e-18
C473	VGND#5	Y#4	2.25448e-19
C474	VGND#5	Y	5.77764e-18
C475	VGND#2	A2#5	5.18987e-18
C476	VGND	VGND#2	6.93726e-17
C477	VGND#3	VGND#5	5.71305e-17
C478	VPWR#2	A2#1	1.84209e-18
C479	VGND#5	B1#4	3.68666e-19
C480	VGND#5	D1#2	8.53388e-20
C481	VGND#2	a_722_74#	1.7841e-17
C482	VGND	VGND#5	6.02623e-17
C483	VGND#2	A2#6	5.30949e-18
C484	VGND#5	D1#4	6.54796e-18
C485	VGND#2	A1#7	3.92628e-18
C486	VPWR#2	VNB	4.64543e-17
C487	a_533_368#	VPWR#2	1.78953e-17
C488	VGND#2	a_722_74##2	2.30246e-17
C489	VGND#2	A1#4	8.56915e-20
C490	VGND#5	VGND#4	1.03916e-18
C491	VPWR#3	VPWR#2	9.68748e-19
C492	VPWR#4	VPWR#2	5.21278e-17
C493	VGND#2	A1#1	6.35322e-18
C494	VGND#2	VNB	6.81494e-17
*
*
.ENDS sky130_fd_sc_hs__a2111oi_2
*
