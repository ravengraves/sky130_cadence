* Extracted by Quantus, converted by sky130cad/quantus.py
*
*
*
*                       LINUX           Wed Nov 18 08:35:32 2026
*
*
*
*  PROGRAM  advgen
*
*  Name           : advgen - Quantus - (64-bit)
*  Version        : 25.1.0-p047
*  Build Date     : Thu Dec 11 23:20:30 PST 2025
*
*  HSPICE LIBRARY
*
*  OPERATING_TEMPERATURE 150
*  QRC_TECH_DIR <path>/tech
*
*
*

*
.SUBCKT sky130_fd_sc_hs__ebufn_1 VPB VNB VGND VPWR Z TE_B A
*
*
*  caps2d version: 10
*
*
*       TRANSISTOR CARDS
*
*
XM4 a_27_404##6 TE_B#1 VGND#7 VNB sky130_fd_pr__nfet_01v8_lvt l=0.15 w=0.55 ad=0.15675 as=0.165 pd=1.67 ps=1.7
XM0 VGND#7 A#3 a_229_74##6 VNB sky130_fd_pr__nfet_01v8_lvt l=0.15 w=0.55 ad=0.165 as=0.14575 pd=1.7 ps=1.63
XM7 VGND#6 a_27_404# a_569_74# VNB sky130_fd_pr__nfet_01v8_lvt l=0.15 w=0.74 ad=0.2109 as=0.1776 pd=2.05 ps=1.96
XM6 a_569_74# a_229_74##3 Z#2 VNB sky130_fd_pr__nfet_01v8_lvt l=0.15 w=0.74 ad=0.1776 as=0.2109 pd=1.96 ps=2.05
XM2 a_27_404##5 TE_B#3 VPWR#7 VPB sky130_fd_pr__pfet_01v8 l=0.15 w=0.84 ad=0.2478 as=0.4557 pd=2.27 ps=3.04
XM1 VPWR#7 A#4 a_229_74##7 VPB sky130_fd_pr__pfet_01v8 l=0.15 w=0.84 ad=0.4557 as=0.2562 pd=3.04 ps=2.29
XM5 VPWR#6 TE_B#4 a_566_368# VPB sky130_fd_pr__pfet_01v8 l=0.15 w=1.12 ad=0.3304 as=0.3024 pd=2.83 ps=2.78
XM3 a_566_368# a_229_74# Z#1 VPB sky130_fd_pr__pfet_01v8 l=0.15 w=1.12 ad=0.3024 as=0.3304 pd=2.78 ps=2.83
*
*
*       RESISTOR AND CAP/DIODE CARDS
*
Rg1	TE_B#1	TE_B#2	540.458618
Rg2	TE_B#2	TE_B#3	384.586975
Rg3	A#1	A#2	104.823883
Rg4	A#2	A#3	534.829102
Rg5	A#2	A#4	382.652161
Rg6	TE_B#4	TE_B#5	1127.988647
Rg7	a_27_404#	a_27_404##2	480.885895
Rg8	a_229_74#	a_229_74##2	447.963806
Rg9	a_229_74##2	a_229_74##3	365.323883
Rf1	A	A#1	13.384872
Rf2	A#1	A	5.511418
Rf3	TE_B#5	TE_B	226.013702
Rf4	TE_B	TE_B#2	160.232803
Rf5	a_27_404##2	a_27_404##4	273.537720
Rf6	a_27_404##4	a_27_404##5	84.697815
Rf7	a_27_404##4	a_27_404##6	33.052650
Rf8	a_229_74##2	a_229_74##5	181.679581
Rf9	a_229_74##5	a_229_74##6	138.127533
Rf10	a_229_74##5	a_229_74##7	110.943161
Rf11	Z#1	Z	73.577621
Rf12	Z	Z#2	11.362064
Rf14	VGND#2	VGND#3	46.362534
Rf15	VGND#3	VGND#4	78.717400
Rf17	VGND#2	VGND#6	32.735970
Rf18	VGND#4	VGND#7	40.354588
Rf20	VPWR#2	VPWR#3	44.536270
Rf21	VPWR#3	VPWR#4	80.696266
Rf23	VPWR#2	VPWR#6	35.333496
Rf24	VPWR#4	VPWR#7	27.618225
Re1	VPWR#3	VPWR	1.227783
Re2	VGND	VGND#3	1.227829
*
*       CAPACITOR CARDS
*
*
C1	VGND	VNB	7.15159e-17
C2	VPWR	VNB	6.42706e-17
C3	A	VNB	1.36844e-17
C4	a_229_74##5	Z#2	1.32629e-17
C5	VGND	A	4.43371e-18
C6	TE_B#2	VNB	5.54673e-17
C7	VPWR	A	4.44773e-18
C8	TE_B#5	VNB	8.96423e-17
C9	a_27_404##2	VNB	6.33889e-17
C10	a_229_74##2	VNB	6.35402e-17
C11	VGND#3	VNB	1.97018e-16
C12	VPWR#3	VNB	1.94624e-16
C13	VGND	TE_B#2	3.56504e-18
C14	TE_B#3	VNB	3.95364e-17
C15	A#4	VNB	4.15695e-17
C16	VGND	TE_B#5	2.26051e-19
C17	TE_B#4	VNB	6.06141e-17
C18	a_229_74#	VNB	2.54834e-17
C19	VGND	a_27_404##2	6.38796e-18
C20	VGND	a_229_74##2	7.29814e-18
C21	TE_B#1	VNB	3.76722e-17
C22	VPWR	TE_B#2	7.39787e-18
C23	A#3	VNB	4.32266e-17
C24	VGND	VGND#3	2.04662e-17
C25	a_27_404#	VNB	3.98637e-17
C26	a_229_74##3	VNB	2.59112e-17
C27	a_27_404##5	VNB	5.07118e-17
C28	VPWR	TE_B#5	3.43411e-17
C29	VPWR#7	VNB	1.06527e-17
C30	a_229_74##7	VNB	5.53564e-18
C31	VPWR#6	VNB	1.16446e-19
C32	VPWR	a_229_74##2	7.26698e-18
C33	VGND	TE_B#4	1.20952e-18
C34	Z#1	VNB	7.79689e-17
C35	a_27_404##6	VNB	2.81835e-17
C36	VGND#7	VNB	2.67859e-18
C37	a_229_74##6	VNB	2.5537e-17
C38	VPWR	VPWR#3	1.83529e-17
C39	VGND	TE_B#1	1.3187e-18
C40	VGND#6	VNB	8.56725e-18
C41	VGND	A#3	1.33527e-18
C42	Z#2	VNB	6.22684e-17
C43	VGND	a_27_404#	6.84113e-19
C44	VPWR	TE_B#3	7.03118e-18
C45	VGND	a_229_74##3	2.02658e-18
C46	VPWR	A#4	7.43361e-18
C47	TE_B#2	A	3.7157e-17
C48	a_27_404##4	VNB	4.81314e-17
C49	VPWR	TE_B#4	9.43134e-19
C50	a_229_74##5	VNB	9.76401e-18
C51	VPWR	a_229_74#	4.13616e-18
C52	A	TE_B#5	3.05026e-18
C53	VGND	Z#1	9.1618e-19
C54	VGND	a_27_404##6	1.85056e-17
C55	a_27_404##2	A	4.56921e-17
C56	VGND	a_229_74##6	2.22622e-17
C57	VGND	VGND#6	1.62814e-17
C58	A	a_229_74##2	9.89737e-19
C59	VPWR	a_27_404##5	1.63305e-17
C60	VGND	Z#2	2.53173e-17
C61	VPWR	VPWR#7	2.13555e-17
C62	VPWR	a_229_74##7	4.97598e-18
C63	VPWR	VPWR#6	2.23557e-17
C64	VGND	a_27_404##4	3.87864e-18
C65	VPWR	Z#1	2.49755e-17
C66	VGND	a_229_74##5	1.19369e-17
C67	A	TE_B#4	3.70094e-18
C68	A#2	TE_B#5	2.10526e-18
C69	a_229_74##2	a_566_368#	4.68598e-18
C70	VPWR	a_229_74##5	6.18856e-18
C71	TE_B#2	TE_B#5	2.02388e-18
C72	A	a_229_74##7	5.81324e-17
C73	a_27_404##2	TE_B#5	2.3497e-18
C74	TE_B#4	a_566_368#	2.80952e-17
C75	a_229_74#	a_566_368#	2.82143e-17
C76	TE_B#2	TE_B#3	1.1274e-17
C77	a_27_404#	a_569_74#	1.71273e-17
C78	A#2	VNB	9.12354e-17
C79	TE_B#5	VPWR#3	3.09616e-17
C80	TE_B#2	A#4	1.32948e-17
C81	VGND#3	a_27_404##2	1.93569e-18
C82	a_229_74##3	a_569_74#	1.78568e-17
C83	TE_B#2	TE_B#4	8.34055e-20
C84	TE_B#5	TE_B#3	1.20237e-18
C85	a_27_404##4	A	2.47259e-17
C86	A#2	a_27_404##2	1.03795e-17
C87	TE_B#5	A#4	3.83368e-17
C88	A	a_229_74##5	2.22792e-17
C89	TE_B#5	TE_B#4	2.47653e-17
C90	a_27_404##5	A#2	1.13813e-19
C91	a_27_404##2	TE_B#4	3.56484e-17
C92	a_27_404##5	TE_B#2	5.41155e-17
C93	TE_B#4	a_229_74##2	1.12475e-17
C94	TE_B#2	VPWR#7	5.45328e-17
C95	a_229_74##2	a_229_74#	2.34073e-18
C96	TE_B#2	a_229_74##7	1.38499e-17
C97	TE_B#2	VPWR#6	8.45964e-19
C98	A#3	a_27_404##2	2.58421e-18
C99	a_27_404##2	a_27_404#	2.53703e-18
C100	a_27_404##5	TE_B#5	1.39852e-18
C101	TE_B#3	A#4	1.99547e-17
C102	VPWR#7	TE_B#5	1.16099e-17
C103	A#2	a_229_74##2	5.52439e-19
C104	a_27_404#	a_229_74##2	1.60212e-17
C105	TE_B#5	a_229_74##7	6.84121e-17
C106	TE_B#5	VPWR#6	7.91802e-17
C107	a_27_404##2	a_229_74##7	5.02813e-18
C108	Z#1	TE_B#5	4.15652e-19
C109	a_229_74##5	a_566_368#	6.37584e-19
C110	TE_B#4	a_229_74#	6.19543e-17
C111	a_229_74##6	TE_B#5	1.07178e-19
C112	a_229_74##2	Z#1	6.21552e-17
C113	a_27_404##4	TE_B#2	9.58567e-17
C114	VGND#3	A#2	2.54448e-19
C115	a_229_74##6	a_27_404##2	7.62049e-17
C116	a_27_404##2	VGND#6	8.6166e-19
C117	TE_B#2	a_229_74##5	2.04932e-18
C118	a_27_404##5	TE_B#3	3.79596e-17
C119	a_27_404#	TE_B#4	2.28401e-17
C120	a_229_74##7	A#2	7.24203e-18
C121	TE_B#3	VPWR#7	2.52016e-17
C122	Z#2	a_27_404##2	4.75574e-19
C123	a_27_404##5	A#4	2.79067e-18
C124	a_229_74##7	TE_B#3	1.69352e-18
C125	A#4	VPWR#7	1.96329e-17
C126	VGND#3	a_229_74##6	1.23304e-17
C127	a_27_404##4	A#2	1.45149e-17
C128	VPWR#6	TE_B#3	2.11163e-19
C129	a_229_74##2	Z#2	4.61522e-17
C130	TE_B#1	A#3	3.80257e-17
C131	a_229_74##7	A#4	2.09873e-17
C132	VPWR#7	TE_B#4	4.29378e-19
C133	a_229_74##5	TE_B#5	3.8902e-17
C134	VPWR#6	A#4	1.13555e-19
C135	a_27_404##4	a_27_404##2	1.41689e-18
C136	a_229_74##7	TE_B#4	2.79325e-19
C137	VPWR#3	A#2	1.58076e-19
C138	A#3	a_27_404#	1.48324e-18
C139	VPWR#6	TE_B#4	6.8143e-17
C140	a_229_74##5	a_27_404##2	5.83043e-17
C141	VPWR#6	a_229_74#	1.10881e-17
C142	Z#1	TE_B#4	1.08082e-17
C143	a_27_404#	a_229_74##3	5.72376e-17
C144	a_229_74##5	a_229_74##2	3.1909e-19
C145	Z#1	a_229_74#	5.26284e-17
C146	VGND#3	a_229_74##5	1.22663e-18
C147	a_27_404##5	VPWR#7	1.63599e-17
C148	TE_B#1	a_27_404##6	1.54739e-17
C149	TE_B#1	VGND#7	2.05996e-17
C150	a_229_74##5	A#2	5.45708e-18
C151	a_27_404##6	A#3	2.04424e-18
C152	a_229_74##6	TE_B#1	2.70662e-18
C153	A	A#2	3.07034e-17
C154	A#3	VGND#7	1.70512e-17
C155	a_229_74##5	TE_B#3	1.88774e-20
C156	VGND#6	TE_B#1	6.28219e-19
C157	VPWR#7	VPWR#6	1.26699e-19
C158	a_229_74##6	A#3	1.53223e-17
C159	VGND#7	a_27_404#	7.85862e-19
C160	VGND#6	A#3	1.93353e-18
C161	a_229_74##7	VPWR#6	9.28672e-19
C162	a_229_74##5	A#4	5.22753e-20
C163	a_229_74##6	a_27_404#	1.42072e-18
C164	VGND#6	a_27_404#	5.20073e-17
C165	a_229_74##6	a_229_74##3	2.76854e-19
C166	a_229_74##5	TE_B#4	4.203e-17
C167	Z#2	A#3	8.75613e-19
C168	VGND#6	a_229_74##3	5.48716e-18
C169	Z#2	a_27_404#	9.75849e-18
C170	a_229_74##5	a_229_74#	3.19043e-19
C171	VPWR#6	Z#1	3.14158e-17
C172	Z#2	a_229_74##3	3.98596e-17
C173	a_27_404##4	TE_B#1	1.08202e-17
C174	a_27_404##4	A#3	1.85736e-17
C175	a_229_74##5	TE_B#1	8.37529e-20
C176	a_229_74##5	A#3	1.80779e-19
C177	A#2	TE_B#4	9.67727e-18
C178	a_27_404##6	VGND#7	3.7341e-17
C179	a_229_74##5	a_27_404#	2.80301e-17
C180	a_27_404##6	a_229_74##6	3.57838e-18
C181	a_27_404##4	a_27_404##5	3.89239e-18
C182	a_229_74##5	a_229_74##3	3.41575e-18
C183	VGND#7	a_229_74##6	3.70581e-17
C184	Z#2	Z#1	4.03994e-18
C185	VGND#7	VGND#6	2.10112e-18
C186	a_229_74##6	VGND#6	7.60961e-18
C187	a_229_74##6	A#2	2.22025e-18
C188	a_229_74##5	VPWR#6	4.32765e-17
C189	VGND#6	Z#2	1.40197e-17
C190	a_229_74##5	Z#1	1.7176e-18
C191	VGND#7	a_27_404##4	2.05582e-17
C192	a_27_404##4	a_229_74##6	1.00755e-17
C193	TE_B#2	A#2	3.96053e-17
C194	a_229_74##5	VGND#6	3.74421e-17
C195	VGND#4	a_27_404##6	1.91952e-17
C196	VGND#4	A#2	7.75754e-20
C197	VGND#4	a_27_404#	2.92323e-19
C198	VGND#4	A#3	8.21873e-18
C199	VGND#4	TE_B#1	4.87243e-18
C200	VGND#3	VGND#4	6.05609e-17
C201	VGND#4	VGND#2	3.25878e-19
C202	VGND#4	TE_B#2	5.34381e-20
C203	VGND#4	a_27_404##4	6.74334e-19
C204	VGND	VGND#4	5.99338e-17
C205	VGND#4	VNB	5.71769e-17
C206	VGND#4	VGND#6	7.01963e-20
C207	VGND#4	a_229_74##6	9.45494e-18
C208	VPWR#2	a_229_74##2	1.93692e-18
C209	Z#1	VPWR#2	2.98556e-17
C210	TE_B#2	VPWR#4	5.14303e-19
C211	VGND#2	a_229_74##5	1.94291e-18
C212	VPWR#3	VPWR#2	6.99829e-17
C213	VPWR#2	VNB	6.31767e-17
C214	TE_B#5	VPWR#4	4.46428e-18
C215	VGND#2	Z#2	3.14682e-17
C216	VPWR#4	VPWR#2	3.91616e-20
C217	VPWR#4	VNB	5.19806e-17
C218	VPWR	VPWR#2	4.71321e-17
C219	a_27_404##5	VPWR#4	1.58729e-17
C220	VPWR#2	TE_B#4	4.22826e-18
C221	VPWR	VPWR#4	3.54541e-17
C222	VPWR#2	a_229_74#	4.63768e-18
C223	VGND#2	a_229_74##3	7.51925e-18
C224	VGND#2	a_27_404#	3.80102e-18
C225	VPWR#3	VPWR#4	6.00924e-17
C226	VGND#3	VGND#2	6.99038e-17
C227	VPWR#4	TE_B#3	6.5259e-18
C228	VGND#2	a_229_74##2	1.96039e-18
C229	VGND#2	a_27_404##2	5.67713e-19
C230	VPWR#4	A#4	6.67481e-18
C231	a_229_74##5	VPWR#2	8.1702e-19
C232	VPWR#4	A#2	5.21669e-20
C233	VPWR#7	VPWR#2	2.48791e-19
C234	TE_B#5	VPWR#2	2.61097e-18
C235	VGND	VGND#2	4.86198e-17
C236	VGND#2	VNB	6.41344e-17
*
*
.ENDS sky130_fd_sc_hs__ebufn_1
*
