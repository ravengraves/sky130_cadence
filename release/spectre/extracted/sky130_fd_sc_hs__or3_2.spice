* Extracted by Quantus, converted by sky130cad/quantus.py
*
*
*
*                       LINUX           Wed Nov 18 09:06:13 2026
*
*
*
*  PROGRAM  advgen
*
*  Name           : advgen - Quantus - (64-bit)
*  Version        : 25.1.0-p047
*  Build Date     : Thu Dec 11 23:20:30 PST 2025
*
*  HSPICE LIBRARY
*
*  OPERATING_TEMPERATURE 150
*  QRC_TECH_DIR <path>/tech
*
*
*

*
.SUBCKT sky130_fd_sc_hs__or3_2 VNB VPB VGND VPWR X C B A
*
*
*  caps2d version: 10
*
*
*       TRANSISTOR CARDS
*
*
XM8 a_27_74##10 C#3 VGND#6 VNB sky130_fd_pr__nfet_01v8_lvt l=0.15 w=0.64 ad=0.1824 as=0.3232 pd=1.85 ps=2.29
XM0 VGND#6 B#1 a_27_74##11 VNB sky130_fd_pr__nfet_01v8_lvt l=0.15 w=0.64 ad=0.3232 as=0.224 pd=2.29 ps=1.98
XM6 a_27_74##11 A#3 VGND#5 VNB sky130_fd_pr__nfet_01v8_lvt l=0.15 w=0.64 ad=0.224 as=0.3866 pd=1.98 ps=2.61
XM2 VGND#5 a_27_74##6 X#1 VNB sky130_fd_pr__nfet_01v8_lvt l=0.15 w=0.74 ad=0.3866 as=0.2072 pd=2.61 ps=2.04
XM3 X#1 a_27_74# VGND#1 VNB sky130_fd_pr__nfet_01v8_lvt l=0.15 w=0.74 ad=0.2072 as=0.2627 pd=2.04 ps=2.19
XM4 a_27_74##12 C#1 a_150_392# VPB sky130_fd_pr__pfet_01v8 l=0.15 w=1 ad=0.295 as=0.27 pd=2.59 ps=2.54
XM5 a_150_392# B#3 a_234_392# VPB sky130_fd_pr__pfet_01v8 l=0.15 w=1 ad=0.27 as=0.42 pd=2.54 ps=2.84
XM9 a_234_392# A#1 VPWR#3 VPB sky130_fd_pr__pfet_01v8 l=0.15 w=1 ad=0.42 as=0.4918 pd=2.84 ps=3.16
XM1 VPWR#3 a_27_74##4 X#2 VPB sky130_fd_pr__pfet_01v8 l=0.15 w=1.12 ad=0.4918 as=0.336 pd=3.16 ps=2.84
XM7 X#2 a_27_74##5 VPWR#1 VPB sky130_fd_pr__pfet_01v8 l=0.15 w=1.12 ad=0.336 as=0.3864 pd=2.84 ps=2.93
*
*
*       RESISTOR AND CAP/DIODE CARDS
*
Rg1	C#1	C#2	472.559082
Rg2	C#2	C#3	367.233398
Rg3	B#1	B#2	330.870117
Rg4	B#2	B#3	450.032837
Rg5	A#1	A#2	509.830780
Rg6	A#2	A#3	336.630798
Rg7	a_27_74#	a_27_74##2	380.521820
Rg8	a_27_74##2	a_27_74##3	43.317886
Rg9	a_27_74##3	a_27_74##4	477.953888
Rg10	a_27_74##2	a_27_74##5	474.414978
Rg11	a_27_74##3	a_27_74##6	389.271973
Rf1	C#4	C	1.193052
Rf2	C#2	C#6	81.309456
Rf3	C#4	C#6	5.241417
Rf4	C#7	C	1.193052
Rf5	C#6	C#7	6.879360
Rf6	B	B#2	102.555748
Rf7	A	A#4	1.058949
Rf8	A#5	A#2	161.291748
Rf9	A#4	A#5	3.443809
Rf10	a_27_74##3	a_27_74##8	181.962189
Rf11	a_27_74##8	a_27_74##9	70.520821
Rf12	a_27_74##9	a_27_74##10	23.610529
Rf13	a_27_74##8	a_27_74##11	19.941607
Rf14	a_27_74##9	a_27_74##12	117.189705
Rf15	X#1	X	60.672832
Rf16	X	X#2	70.827942
Rf17	VGND#1	VGND#2	136.855438
Rf18	VGND#2	VGND#3	62.581165
Rf20	VGND#2	VGND#5	27.582468
Rf21	VGND#3	VGND#6	28.613659
Rf22	VPWR#1	VPWR#2	131.571594
Rf23	VPWR#2	VPWR#3	39.421906
Re1	VPWR#2	VPWR	1.403190
Re2	VGND	VGND#2	1.403242
*
*       CAPACITOR CARDS
*
*
C1	VGND	VNB	5.61029e-17
C2	a_27_74##8	VGND#6	5.16956e-17
C3	VPWR	VNB	7.50101e-17
C4	X	VNB	5.54207e-17
C5	C	VNB	1.63745e-18
C6	B	VNB	1.77676e-19
C7	A	VNB	1.14722e-18
C8	C#2	VNB	6.15558e-17
C9	B#2	VNB	2.63588e-17
C10	A#2	VNB	3.96403e-17
C11	VGND	X	4.82606e-18
C12	a_27_74##3	VNB	7.11961e-17
C13	VGND#2	VNB	1.99904e-16
C14	VPWR#2	VNB	2.44291e-16
C15	VGND	C	3.77423e-18
C16	C#1	VNB	4.04797e-17
C17	VPWR	X	3.77293e-18
C18	B#3	VNB	3.44432e-17
C19	A#1	VNB	3.68067e-17
C20	a_27_74##4	VNB	3.88126e-17
C21	a_27_74##5	VNB	3.8992e-17
C22	VGND	A	3.83828e-18
C23	C#3	VNB	3.04033e-17
C24	B#1	VNB	2.85309e-17
C25	A#3	VNB	2.30658e-17
C26	VPWR	B	1.59825e-17
C27	a_27_74##6	VNB	2.82898e-17
C28	a_27_74#	VNB	3.35904e-17
C29	a_27_74##12	VNB	6.79685e-17
C30	VPWR#3	VNB	2.43188e-18
C31	X#2	VNB	5.06516e-18
C32	VPWR#1	VNB	7.46276e-17
C33	VGND#6	VNB	3.41409e-18
C34	X#1	VNB	5.00454e-18
C35	a_27_74##9	VGND#6	4.41724e-17
C36	VGND#1	VNB	5.74291e-17
C37	VGND	B#2	4.37741e-18
C38	C#6	VNB	5.49808e-19
C39	C#7	VNB	4.71437e-19
C40	VGND	a_27_74##3	7.67138e-18
C41	VGND	VGND#2	5.9228e-17
C42	a_27_74##8	VNB	2.59221e-18
C43	a_27_74##9	VNB	5.86656e-17
C44	a_27_74##8	a_27_74##11	1.19589e-17
C45	VPWR	A#2	3.8216e-18
C46	VPWR	a_27_74##3	7.3408e-18
C47	B	a_150_392#	3.07614e-19
C48	B#2	X	1.02593e-18
C49	VPWR	VPWR#2	7.35952e-17
C50	X	A#2	2.64094e-19
C51	B	a_234_392#	1.2509e-18
C52	VGND	C#3	1.00019e-18
C53	C	C#2	1.02137e-17
C54	VPWR	C#1	3.55672e-18
C55	a_27_74##3	X	4.62733e-17
C56	VGND	B#1	7.81048e-20
C57	VPWR	B#3	2.15628e-19
C58	VGND	A#3	4.36339e-19
C59	C	B#2	2.34208e-17
C60	VGND	a_27_74##6	1.27465e-18
C61	VPWR	A#1	3.09392e-18
C62	VGND	a_27_74#	7.44109e-19
C63	VPWR	a_27_74##4	2.06338e-18
C64	VPWR	a_27_74##5	2.98419e-19
C65	C	a_27_74##3	1.2239e-18
C66	VGND	VPWR#3	4.03569e-18
C67	VGND	X#2	2.30585e-18
C68	a_27_74##8	VGND#5	3.1256e-18
C69	B#2	A	1.41596e-17
C70	A	A#2	8.67955e-18
C71	X	a_27_74##5	1.0796e-17
C72	VGND	X#1	1.59442e-17
C73	VPWR	a_27_74##12	1.92372e-17
C74	VGND	VGND#1	3.91074e-17
C75	B	VPWR#2	1.17357e-17
C76	A	a_27_74##3	1.62975e-17
C77	VPWR	VPWR#3	1.965e-17
C78	VPWR	X#2	1.65155e-17
C79	B	C#1	1.13881e-17
C80	VPWR	VPWR#1	4.3469e-17
C81	X	a_27_74##6	3.95149e-20
C82	B	B#3	3.3194e-17
C83	X	a_27_74#	1.68133e-19
C84	B	A#1	1.13919e-17
C85	VGND	a_27_74##8	2.22175e-17
C86	VGND	a_27_74##9	1.99796e-17
C87	a_27_74##8	X#1	3.41537e-18
C88	C	B#1	1.04244e-18
C89	C	a_27_74##6	1.52051e-19
C90	X	VPWR#1	4.51379e-17
C91	C#2	B#2	4.37894e-17
C92	VPWR	C#7	6.25055e-18
C93	C#1	a_150_392#	1.88096e-18
C94	X#1	X	2.46626e-18
C95	X	VGND#1	3.3109e-17
C96	B#3	a_150_392#	2.00079e-17
C97	B#2	A#2	6.25956e-17
C98	a_27_74##12	B	4.03624e-17
C99	B#2	a_27_74##3	7.29535e-18
C100	C	VGND#6	2.95744e-18
C101	B#3	a_234_392#	2.56912e-17
C102	A	a_27_74##6	2.07621e-19
C103	VPWR#2	C#2	5.46298e-20
C104	B	VPWR#3	4.09543e-17
C105	A#2	a_27_74##3	6.05003e-17
C106	A#1	a_234_392#	2.15226e-18
C107	B	X#2	4.24397e-19
C108	VGND#2	A#2	8.77295e-19
C109	A#2	VPWR#2	3.36403e-19
C110	VGND#2	a_27_74##3	2.03591e-17
C111	C#2	B#3	4.41466e-18
C112	B#2	C#1	1.35182e-18
C113	a_27_74##3	VPWR#2	1.04039e-18
C114	B#2	B#3	5.76697e-18
C115	B#2	A#1	3.8835e-18
C116	a_27_74##8	C	8.44465e-18
C117	a_27_74##9	C	5.72312e-17
C118	B#2	a_27_74##4	2.67654e-19
C119	A#2	a_27_74##4	7.31573e-19
C120	C#2	B#1	5.4971e-18
C121	a_27_74##9	C#6	1.46329e-17
C122	VPWR#2	C#1	7.74127e-18
C123	B#2	B#1	2.18981e-18
C124	VPWR#2	B#3	6.22008e-18
C125	VPWR#2	A#1	4.24772e-18
C126	a_27_74##12	C#2	1.12772e-17
C127	B#1	A#2	5.51008e-18
C128	B#2	a_27_74##6	4.17229e-19
C129	VPWR#2	a_27_74##4	7.84669e-18
C130	a_27_74##8	A	2.26835e-17
C131	a_27_74##3	C#3	1.18989e-19
C132	C#1	B#3	5.09553e-17
C133	a_27_74##3	B#1	6.60198e-19
C134	a_27_74##12	B#2	2.9437e-18
C135	A#2	a_27_74##6	1.43722e-18
C136	VGND#2	C#3	3.79437e-19
C137	a_27_74##3	A#3	1.31609e-18
C138	VGND#2	B#1	1.58762e-18
C139	B#3	A#1	3.16842e-17
C140	a_27_74##3	a_27_74##6	6.42086e-18
C141	VGND#2	A#3	1.74998e-17
C142	a_27_74##3	a_27_74#	4.80868e-20
C143	B#2	X#2	3.88945e-18
C144	VGND#2	a_27_74##6	1.54972e-17
C145	VGND#6	C#2	1.82485e-18
C146	A#1	a_27_74##4	2.89986e-17
C147	A#2	VPWR#3	1.59671e-17
C148	VGND#2	a_27_74#	3.21611e-18
C149	B#2	VGND#6	1.78336e-19
C150	a_27_74##3	VPWR#3	1.04011e-18
C151	B#2	a_27_74##11	8.15892e-19
C152	a_27_74##4	a_27_74##5	4.69733e-17
C153	a_27_74##12	VPWR#2	2.49753e-17
C154	a_27_74##3	X#2	5.12902e-17
C155	C#6	C#2	6.29109e-18
C156	C#7	C#2	1.08117e-17
C157	A#2	VGND#5	3.09737e-19
C158	X#1	A#2	1.38494e-19
C159	C#6	B#2	1.78522e-17
C160	a_27_74##12	C#1	4.66985e-17
C161	X#2	VPWR#2	1.22857e-17
C162	a_27_74##3	VGND#5	4.1452e-18
C163	C#7	B#2	3.04651e-17
C164	VGND#6	VGND#2	2.53209e-18
C165	VPWR#2	VPWR#1	3.57851e-17
C166	a_27_74##12	B#3	9.18932e-18
C167	a_27_74##3	X#1	8.47458e-17
C168	VGND#2	VGND#5	6.30941e-18
C169	VPWR#3	C#1	9.30804e-19
C170	a_27_74##12	A#1	4.41337e-19
C171	a_27_74##9	C#2	1.23926e-17
C172	VGND#2	X#1	4.67082e-17
C173	C#3	B#1	1.37543e-17
C174	VGND#2	VGND#1	3.16653e-17
C175	VPWR#3	B#3	5.77912e-18
C176	a_27_74##8	B#2	3.51719e-17
C177	X#2	B#3	2.68693e-19
C178	VPWR#3	A#1	6.29186e-17
C179	B#1	A#3	2.61879e-17
C180	X#2	A#1	2.41342e-18
C181	a_27_74##8	A#2	2.6204e-18
C182	a_27_74##4	VPWR#3	2.00496e-17
C183	a_27_74##9	a_27_74##8	2.59965e-18
C184	VPWR#1	A#1	2.8241e-19
C185	X#2	a_27_74##4	5.97238e-17
C186	A#3	a_27_74##6	1.0987e-17
C187	VPWR#3	a_27_74##5	1.19697e-18
C188	C#7	VPWR#2	1.0136e-18
C189	VPWR#1	a_27_74##4	1.39811e-18
C190	X#2	a_27_74##5	5.93781e-17
C191	a_27_74##5	VPWR#1	3.13726e-17
C192	a_27_74##6	a_27_74#	3.71994e-17
C193	VGND#2	a_27_74##8	6.2245e-17
C194	C#3	a_27_74##10	6.03986e-18
C195	C#3	VGND#6	2.49312e-17
C196	B#1	VGND#6	2.22485e-17
C197	B#1	a_27_74##11	1.48668e-17
C198	a_27_74##12	VPWR#3	2.62734e-18
C199	VGND#6	A#3	6.56646e-19
C200	A#3	a_27_74##11	5.10174e-18
C201	X#1	B#1	2.83578e-19
C202	A#3	VGND#5	1.74484e-17
C203	X#1	A#3	1.58752e-18
C204	a_27_74##6	VGND#5	7.56914e-18
C205	VGND#1	A#3	2.39115e-19
C206	X#1	a_27_74##6	4.05583e-17
C207	VPWR#3	X#2	6.40307e-17
C208	VGND#1	a_27_74##6	1.37281e-18
C209	VPWR#3	VPWR#1	1.21686e-18
C210	X#1	a_27_74#	5.63152e-17
C211	a_27_74#	VGND#1	2.11219e-17
C212	X#2	VPWR#1	7.97155e-17
C213	a_27_74##8	C#3	1.06376e-18
C214	a_27_74##12	C#6	6.25338e-19
C215	a_27_74##9	C#3	3.96094e-17
C216	a_27_74##8	B#1	4.1786e-17
C217	C#7	a_27_74##12	4.32423e-17
C218	a_27_74##9	B#1	1.21874e-18
C219	a_27_74##8	A#3	2.77221e-17
C220	a_27_74##9	A#3	2.01966e-19
C221	a_27_74##8	a_27_74##6	1.04613e-18
C222	a_27_74##9	a_27_74##6	2.5702e-19
C223	a_27_74##9	a_27_74##12	2.3922e-18
C224	X#1	VGND#1	4.45174e-17
C225	a_27_74##8	VPWR#3	2.26431e-18
C226	a_27_74##9	a_27_74##10	5.04738e-18
C227	VGND	VGND#3	5.37383e-17
C228	VGND#3	C#3	5.45241e-18
C229	VGND#3	a_27_74##8	5.81259e-18
C230	VGND#2	VGND#3	5.81372e-17
C231	VGND#3	B#1	4.97855e-18
C232	VGND#3	a_27_74##9	2.2108e-17
C233	VGND#3	VNB	5.14871e-17
C234	VGND#3	A#3	5.06208e-19
*
*
.ENDS sky130_fd_sc_hs__or3_2
*
