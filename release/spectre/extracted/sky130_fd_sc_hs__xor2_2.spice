* Extracted by Quantus, converted by sky130cad/quantus.py
*
*
*
*                       LINUX           Wed Nov 18 09:15:18 2026
*
*
*
*  PROGRAM  advgen
*
*  Name           : advgen - Quantus - (64-bit)
*  Version        : 25.1.0-p047
*  Build Date     : Thu Dec 11 23:20:30 PST 2025
*
*  HSPICE LIBRARY
*
*  OPERATING_TEMPERATURE 150
*  QRC_TECH_DIR <path>/tech
*
*
*

*
.SUBCKT sky130_fd_sc_hs__xor2_2 VNB VPB VGND VPWR X B A
*
*
*  caps2d version: 10
*
*
*       TRANSISTOR CARDS
*
*
XM10 VGND#4 A#1 a_183_74##8 VNB sky130_fd_pr__nfet_01v8_lvt l=0.15 w=0.64 ad=0.5031 as=0.1792 pd=2.9 ps=1.84
XM7 a_183_74##8 B#1 VGND#6 VNB sky130_fd_pr__nfet_01v8_lvt l=0.15 w=0.64 ad=0.1792 as=0.345 pd=1.84 ps=2.48
XM5 VGND#6 A#8 a_399_74##2 VNB sky130_fd_pr__nfet_01v8_lvt l=0.15 w=0.74 ad=0.345 as=0.2072 pd=2.48 ps=2.04
XM12 a_399_74##2 A#9 VGND#5 VNB sky130_fd_pr__nfet_01v8_lvt l=0.15 w=0.74 ad=0.2072 as=0.6312 pd=2.04 ps=3.4
XM13 VGND#5 a_183_74##5 X#4 VNB sky130_fd_pr__nfet_01v8_lvt l=0.15 w=0.74 ad=0.6312 as=0.2072 pd=3.4 ps=2.04
XM8 X#4 B#8 a_399_74# VNB sky130_fd_pr__nfet_01v8_lvt l=0.15 w=0.74 ad=0.2072 as=0.3588 pd=2.04 ps=2.57
XM9 a_399_74# B#4 X#1 VNB sky130_fd_pr__nfet_01v8_lvt l=0.15 w=0.74 ad=0.3588 as=0.2109 pd=2.57 ps=2.05
XM3 VPWR#6 A#3 a_116_392# VPB sky130_fd_pr__pfet_01v8 l=0.15 w=1 ad=0.295 as=0.27 pd=2.59 ps=2.54
XM1 a_116_392# B#3 a_183_74##9 VPB sky130_fd_pr__pfet_01v8 l=0.15 w=1 ad=0.27 as=0.295 pd=2.54 ps=2.59
XM0 VPWR#5 A#10 a_313_368##6 VPB sky130_fd_pr__pfet_01v8 l=0.15 w=1.12 ad=0.392 as=0.3304 pd=2.94 ps=2.83
XM11 a_313_368##4 A#4 VPWR#5 VPB sky130_fd_pr__pfet_01v8 l=0.15 w=1.12 ad=0.336 as=0.392 pd=2.84 ps=2.94
XM2 X#3 a_183_74##4 a_313_368##4 VPB sky130_fd_pr__pfet_01v8 l=0.15 w=1.12 ad=0.336 as=0.336 pd=2.84 ps=2.84
XM4 a_313_368##2 a_183_74# X#3 VPB sky130_fd_pr__pfet_01v8 l=0.15 w=1.12 ad=0.336 as=0.336 pd=2.84 ps=2.84
XM6 a_313_368##2 B#10 VPWR#4 VPB sky130_fd_pr__pfet_01v8 l=0.15 w=1.12 ad=0.336 as=0.392 pd=2.84 ps=2.94
XM14 VPWR#4 B#9 a_313_368# VPB sky130_fd_pr__pfet_01v8 l=0.15 w=1.12 ad=0.392 as=0.3416 pd=2.94 ps=2.85
*
*
*       RESISTOR AND CAP/DIODE CARDS
*
Rg1	A#1	A#2	331.921783
Rg2	A#2	A#3	570.811340
Rg3	B#1	B#2	279.244598
Rg4	B#2	B#3	678.337830
Rg5	A#4	A#5	441.337158
Rg6	A#5	A#6	24.265053
Rg7	A#6	A#7	30.613651
Rg8	A#7	A#8	397.555725
Rg9	A#5	A#9	426.181030
Rg10	A#7	A#10	449.655212
Rg11	a_183_74#	a_183_74##2	453.701172
Rg12	a_183_74##2	a_183_74##3	50.677929
Rg13	a_183_74##3	a_183_74##4	429.126801
Rg14	a_183_74##2	a_183_74##5	411.287628
Rg15	B#4	B#5	319.775085
Rg16	B#5	B#6	58.164238
Rg17	B#6	B#7	20.770033
Rg18	B#7	B#8	318.032684
Rg19	B#5	B#9	504.618683
Rg20	B#7	B#10	507.914795
Rf1	A#6	A	177.137939
Rf2	A	A#2	173.512100
Rf3	a_183_74##3	a_183_74##7	310.136414
Rf4	a_183_74##7	a_183_74##8	207.918228
Rf5	a_183_74##7	a_183_74##9	22.422642
Rf6	B	B#6	169.564575
Rf7	B	B#2	332.893494
Rf8	a_399_74#	a_399_74##2	177.474731
Rf9	X	X#2	7.617567
Rf10	X#2	X	7.485746
Rf11	X	X#3	135.500397
Rf12	X#2	X#4	84.018074
Rf13	X#1	X#2	7.500000
Rf14	a_313_368#	a_313_368##3	88.922882
Rf15	a_313_368##3	a_313_368##5	85.520218
Rf16	a_313_368##5	a_313_368##6	90.575058
Rf17	a_313_368##2	a_313_368##3	7.500000
Rf18	a_313_368##4	a_313_368##5	7.500000
Rf20	VPWR#2	VPWR#3	117.586761
Rf21	VPWR#2	VPWR#4	38.641060
Rf22	VPWR#3	VPWR#5	35.643360
Rf23	VPWR#3	VPWR#6	187.063705
Rf25	VGND#2	VGND#3	61.703136
Rf26	VGND#3	VGND#4	94.597786
Rf27	VGND#2	VGND#5	27.981247
Rf28	VGND#3	VGND#6	35.098007
Re1	VPWR#3	VPWR	0.982218
Re2	VGND	VGND#2	0.982254
*
*       CAPACITOR CARDS
*
*
C1	a_399_74##2	A#7	1.15065e-18
C2	B#3	A#7	8.59512e-19
C3	VGND#3	a_399_74##2	2.64799e-18
C4	a_313_368#	B#7	4.76939e-19
C5	VGND#3	a_183_74##8	1.13278e-17
C6	VGND#4	VGND#3	1.36256e-18
C7	VPWR#4	B#7	6.03787e-19
C8	a_313_368##2	B#7	1.49535e-19
C9	X#1	a_399_74#	3.62119e-17
C10	X#4	X#1	7.09292e-19
C11	a_183_74##8	a_183_74##7	1.23426e-18
C12	B#6	B#7	2.39721e-17
C13	a_399_74#	X#4	4.86658e-17
C14	a_399_74#	VGND#5	2.13421e-18
C15	a_399_74##2	X#1	1.03551e-18
C16	a_399_74##2	a_399_74#	2.84887e-19
C17	a_183_74##3	B#7	2.69869e-18
C18	a_399_74##2	X#4	2.44798e-17
C19	a_183_74##3	a_183_74##2	1.1394e-18
C20	A#7	a_183_74##3	2.65e-17
C21	a_313_368##4	A#7	5.59029e-19
C22	a_399_74##2	VGND#5	1.04212e-17
C23	a_183_74##7	X#3	1.26451e-21
C24	VGND#6	a_399_74##2	3.20583e-17
C25	a_183_74##7	a_313_368##4	2.88327e-18
C26	A#6	A#7	3.33106e-17
C27	a_183_74##8	a_399_74##2	8.85076e-21
C28	A#7	VPWR#5	1.31108e-18
C29	a_183_74##7	VPWR#5	4.03833e-19
C30	a_183_74##8	VGND#6	4.42388e-17
C31	a_183_74##7	a_313_368##6	4.96486e-17
C32	VGND#4	VGND#6	2.44048e-18
C33	VGND#3	a_183_74##5	4.32972e-20
C34	B#2	a_183_74##2	1.13931e-19
C35	a_183_74##7	a_183_74##9	2.29021e-18
C36	B#2	A#7	2.20718e-17
C37	a_183_74##8	VGND#4	8.17564e-17
C38	a_313_368##6	A#7	6.38615e-20
C39	VGND#3	A#9	4.65658e-19
C40	VGND#3	A#8	9.30036e-18
C41	a_183_74##7	VPWR#6	3.51864e-17
C42	A#2	A#7	2.12723e-19
C43	VGND#3	B#1	6.8326e-18
C44	a_313_368#	VPWR#4	6.2986e-17
C45	a_313_368##2	a_313_368#	2.55588e-18
C46	VGND#3	A#1	6.62075e-19
C47	a_313_368##2	VPWR#4	5.7934e-17
C48	X#1	B#4	4.19336e-17
C49	B#4	a_399_74#	2.43342e-17
C50	X#1	B#8	1.11676e-18
C51	a_313_368##2	X#3	7.91435e-17
C52	X#4	B#4	7.83116e-19
C53	a_399_74#	B#8	3.55128e-17
C54	a_313_368##4	a_313_368##2	2.97267e-18
C55	X#1	a_183_74##5	3.29181e-19
C56	X#4	B#8	2.87133e-17
C57	a_313_368##4	X#3	5.13493e-17
C58	a_399_74#	a_183_74##5	1.51885e-17
C59	a_399_74##2	B#4	2.66055e-19
C60	X#1	A#9	1.1217e-19
C61	X#4	a_183_74##5	2.26861e-17
C62	a_399_74#	A#9	5.39139e-19
C63	a_399_74##2	B#8	3.13725e-19
C64	a_183_74##5	VGND#5	1.1706e-17
C65	a_313_368##4	VPWR#5	6.35729e-17
C66	X#4	A#9	1.28595e-19
C67	a_399_74##2	a_183_74##5	7.13248e-18
C68	A#9	VGND#5	1.92805e-17
C69	a_313_368##6	a_313_368##4	2.41843e-18
C70	a_183_74##9	X#3	9.18661e-22
C71	VGND#6	a_183_74##5	1.42409e-19
C72	a_399_74##2	A#9	4.67781e-17
C73	a_313_368##6	VPWR#5	3.82898e-17
C74	VGND#6	A#9	6.01239e-19
C75	a_399_74##2	A#8	3.21361e-17
C76	a_183_74##8	A#9	2.27477e-19
C77	A#8	VGND#6	2.02885e-17
C78	a_183_74##9	a_313_368##6	5.00308e-17
C79	a_399_74##2	B#1	8.46818e-19
C80	a_183_74##8	A#8	2.68357e-19
C81	B#1	VGND#6	2.34557e-17
C82	VPWR#6	VPWR#5	3.33576e-19
C83	a_183_74##7	a_183_74#	9.08264e-20
C84	VGND#4	A#8	3.10654e-19
C85	a_183_74##8	B#1	3.1789e-17
C86	VGND#3	B#3	5.5668e-20
C87	VGND#6	A#1	8.36299e-19
C88	VGND#4	B#1	1.41349e-18
C89	a_183_74##7	a_183_74##4	1.42023e-19
C90	VPWR#6	a_183_74##9	2.13755e-17
C91	a_183_74##8	A#1	5.17589e-17
C92	a_183_74##5	B#7	2.84054e-18
C93	A#1	VGND#4	2.02414e-17
C94	a_183_74##7	A#4	3.56136e-19
C95	a_183_74##7	A#10	1.8718e-17
C96	a_313_368#	B#9	4.98915e-17
C97	a_183_74##7	B#3	3.6033e-17
C98	B#9	VPWR#4	2.69587e-17
C99	B#8	B#4	1.90453e-17
C100	a_313_368#	B#10	1.60183e-18
C101	a_313_368##2	B#9	7.61058e-19
C102	a_183_74##7	A#3	2.68626e-17
C103	VPWR#4	B#10	3.95092e-17
C104	X#3	B#9	5.7401e-19
C105	a_313_368#	a_183_74#	2.00738e-19
C106	a_313_368##2	B#10	3.39993e-17
C107	a_183_74##5	B#8	3.68796e-17
C108	VPWR#4	a_183_74#	8.43487e-19
C109	X#3	B#10	7.67307e-18
C110	a_313_368##2	a_183_74#	5.69589e-17
C111	A#9	a_183_74##5	4.92415e-18
C112	X#3	a_183_74#	5.68746e-17
C113	a_183_74##7	VPWR#3	1.26277e-18
C114	VPWR#5	B#10	2.64005e-20
C115	a_313_368##2	a_183_74##4	1.53105e-18
C116	a_313_368##4	a_183_74#	1.36278e-18
C117	a_183_74##4	X#3	1.78938e-17
C118	VPWR#5	a_183_74#	9.42846e-20
C119	a_183_74##8	B#3	1.03316e-18
C120	A#8	A#9	3.91022e-17
C121	B	B#7	7.94556e-18
C122	a_313_368##4	a_183_74##4	6.16176e-17
C123	B	a_183_74##2	9.1129e-18
C124	VGND#4	B#3	4.29911e-20
C125	X#3	A#4	7.12766e-19
C126	B	A#7	4.06626e-19
C127	VPWR#5	a_183_74##4	6.45173e-19
C128	a_183_74##9	a_183_74#	6.5985e-20
C129	a_313_368##4	A#4	5.29196e-17
C130	a_183_74##7	A#7	6.21887e-19
C131	X#3	A#10	4.804e-19
C132	B#1	A#8	1.46806e-17
C133	A#4	VPWR#5	2.83406e-17
C134	a_183_74##9	a_183_74##4	1.03179e-19
C135	a_313_368##4	A#10	1.19227e-18
C136	a_313_368##6	A#4	3.97021e-19
C137	VGND#3	B#2	1.6662e-18
C138	X#3	B#3	2.83921e-19
C139	VPWR#5	A#10	4.11037e-17
C140	a_183_74##9	A#4	1.86959e-19
C141	A#1	B#1	3.28591e-17
C142	X#1	B#6	1.53121e-17
C143	a_313_368##4	B#3	6.88714e-20
C144	a_313_368##6	A#10	3.79564e-17
C145	B#6	a_399_74#	9.63803e-19
C146	VPWR#5	B#3	6.31887e-19
C147	X	B#7	2.23602e-17
C148	a_183_74##9	A#10	1.71238e-18
C149	X#4	B#6	1.90208e-17
C150	X	a_183_74##2	2.56916e-19
C151	A#6	a_183_74##7	6.23913e-17
C152	a_313_368##6	B#3	1.21458e-18
C153	VPWR#5	A#3	3.69674e-19
C154	B#3	a_183_74##9	3.91867e-17
C155	VPWR#6	A#10	1.00366e-18
C156	a_313_368##2	VPWR#3	5.10206e-19
C157	a_183_74##7	B#2	7.0655e-19
C158	a_183_74##9	A#3	6.32783e-18
C159	VPWR#6	B#3	1.59759e-17
C160	a_399_74##2	a_183_74##3	1.90666e-18
C161	a_313_368##4	VPWR#3	5.03902e-17
C162	VPWR#6	A#3	4.86347e-17
C163	a_183_74##7	A#2	1.15805e-17
C164	a_313_368##6	VPWR#3	1.81283e-17
C165	B#10	B#9	3.95756e-17
C166	a_183_74##9	VPWR#3	1.54044e-17
C167	B#6	X#3	1.2164e-18
C168	B#2	a_399_74##2	5.08608e-17
C169	a_313_368##2	a_183_74##3	1.71689e-21
C170	VPWR#3	VPWR#6	4.75298e-17
C171	a_183_74#	B#10	4.59507e-17
C172	B#2	VGND#6	5.32846e-17
C173	a_183_74##3	X#3	5.45759e-17
C174	a_183_74##8	B#2	2.09405e-17
C175	a_183_74##3	a_313_368##4	6.07732e-17
C176	a_183_74##3	VPWR#5	1.26138e-18
C177	a_183_74##4	a_183_74#	4.59488e-17
C178	a_183_74##2	B#7	3.03051e-17
C179	a_183_74##8	A#2	6.40883e-17
C180	A#2	VGND#4	3.53674e-18
C181	B#6	B#4	3.99417e-18
C182	A#4	a_183_74##4	4.61211e-17
C183	a_183_74##7	a_116_392#	5.03613e-18
C184	B#6	B#8	3.18958e-18
C185	VGND	B#7	1.66855e-18
C186	X#1	B#7	1.84703e-18
C187	A#10	A#4	3.74034e-17
C188	B#3	A#10	1.14176e-17
C189	VPWR#6	A#2	3.41036e-19
C190	VPWR#3	a_183_74##4	4.4526e-18
C191	B#2	A#9	1.85108e-17
C192	A#3	B#3	6.30718e-17
C193	VPWR#3	A#4	2.29845e-18
C194	B#2	A#8	2.77247e-17
C195	a_183_74##3	B#9	2.25285e-19
C196	B#2	B#1	4.73434e-18
C197	VPWR#3	A#10	1.79789e-18
C198	a_183_74##3	B#10	1.83888e-19
C199	a_183_74##7	A	9.16065e-17
C200	A#1	B#2	3.20541e-18
C201	VPWR#3	B#3	1.2898e-19
C202	a_183_74##3	a_183_74#	1.0998e-18
C203	B#7	a_399_74#	2.8485e-18
C204	a_183_74##3	a_183_74##4	7.22665e-18
C205	a_183_74##3	A#4	1.63652e-17
C206	A#6	a_183_74##4	6.43998e-19
C207	a_183_74##3	A#10	4.54546e-19
C208	A#6	A#4	2.15599e-18
C209	a_183_74##8	A	3.98953e-18
C210	a_183_74##3	B#3	5.02131e-19
C211	A#6	A#10	3.64524e-18
C212	a_399_74#	B	2.2956e-18
C213	a_183_74##3	A#3	2.9676e-19
C214	B	X#4	4.03565e-17
C215	B	VGND#5	4.67636e-18
C216	a_399_74##2	B	5.76704e-17
C217	VPWR#3	a_183_74##3	2.25602e-20
C218	a_399_74#	a_183_74##2	1.45558e-19
C219	X	X#1	3.14098e-18
C220	a_183_74##2	B#10	3.71394e-18
C221	A#2	B#3	6.5196e-18
C222	B#7	VNB	5.9682e-17
C223	a_183_74##2	VNB	2.10828e-17
C224	A#7	VNB	5.89802e-17
C225	B	X#3	2.17059e-17
C226	VPWR#3	B#2	3.56491e-19
C227	VPWR	a_183_74##7	1.40219e-17
C228	X#4	B#7	6.38832e-19
C229	X	a_313_368#	6.25773e-17
C230	X	VPWR#4	9.53098e-19
C231	VGND	VGND#3	4.97962e-17
C232	A#6	a_183_74##3	7.58592e-17
C233	X	a_313_368##2	1.6239e-17
C234	B#2	a_183_74##3	5.53294e-19
C235	B#3	a_116_392#	2.43225e-17
C236	B	B#8	4.58499e-18
C237	B	a_183_74##5	2.44612e-17
C238	A#3	a_116_392#	2.51429e-17
C239	B#2	A#6	8.89816e-17
C240	VPWR	a_313_368#	1.78055e-17
C241	VPWR	a_313_368##2	1.96987e-17
C242	A#2	A#6	2.66883e-18
C243	X	B#4	7.08625e-18
C244	VGND	X#1	2.20514e-17
C245	VPWR	X#3	7.76576e-18
C246	VGND	a_399_74#	3.71683e-17
C247	X	B#8	1.50703e-18
C248	VPWR	a_313_368##4	2.54984e-17
C249	VGND	X#4	8.17871e-18
C250	A#7	a_183_74##2	8.93809e-19
C251	VPWR	VPWR#5	1.76442e-17
C252	X	a_183_74##5	6.81573e-19
C253	A#2	B#2	5.86395e-17
C254	VPWR	a_313_368##6	1.4806e-17
C255	VGND	a_399_74##2	1.96795e-17
C256	X	A#9	2.88704e-19
C257	VPWR	a_183_74##9	1.36987e-17
C258	VGND	a_183_74##8	2.37005e-17
C259	VGND	VGND#4	4.91233e-17
C260	VPWR	VPWR#6	5.40245e-17
C261	A	B#3	1.90397e-17
C262	VGND	X#3	2.70769e-18
C263	A	A#3	2.06069e-18
C264	X#4	a_183_74##2	2.75556e-19
C265	X	B#9	1.96204e-17
C266	X	B#10	9.03922e-18
C267	X	a_183_74#	1.76946e-19
C268	X	a_183_74##4	1.10254e-19
C269	VGND	B#4	8.21845e-19
C270	VPWR	B#9	5.68779e-19
C271	VGND	B#8	1.57623e-18
C272	VGND	a_183_74##5	1.80638e-18
C273	VPWR	B#10	6.30391e-19
C274	VGND#3	VNB	3.29955e-17
C275	VGND	A#9	3.06517e-19
C276	VPWR	a_183_74#	1.33277e-18
C277	VGND	A#8	1.16265e-18
C278	VPWR	a_183_74##4	1.35392e-18
C279	VGND	B#1	1.29777e-18
C280	VPWR	A#4	4.61758e-19
C281	VGND	A#1	1.20518e-20
C282	VPWR	A#10	1.05267e-18
C283	A	B#2	2.87852e-17
C284	B	a_183_74##3	6.62602e-17
C285	a_183_74##7	VNB	3.78548e-17
C286	VPWR	B#3	1.90267e-18
C287	A	A#2	5.11042e-18
C288	X#1	VNB	2.7053e-17
C289	VPWR	A#3	7.95707e-19
C290	a_399_74#	VNB	9.65917e-18
C291	B#6	X	6.435e-17
C292	B	B#2	3.39204e-19
C293	a_399_74##2	VNB	1.93806e-18
C294	a_183_74##3	X	3.22828e-18
C295	VGND#6	VNB	3.29308e-18
C296	VPWR	VPWR#3	4.61507e-17
C297	a_183_74##8	VNB	3.94627e-17
C298	VGND#4	VNB	5.65631e-17
C299	a_313_368#	VNB	4.00912e-17
C300	VPWR#4	VNB	8.2066e-19
C301	a_313_368##2	VNB	2.67755e-18
C302	VPWR	B#6	2.63422e-18
C303	X#3	VNB	4.74357e-19
C304	a_313_368##4	VNB	3.90925e-18
C305	VPWR	a_183_74##3	5.53422e-18
C306	VPWR#5	VNB	9.3883e-19
C307	a_313_368##6	VNB	1.03389e-17
C308	a_183_74##9	VNB	9.79858e-18
C309	VPWR	A#6	5.23154e-18
C310	VPWR#6	VNB	8.0528e-17
C311	B#4	VNB	2.98017e-17
C312	B#8	VNB	2.55221e-17
C313	VGND	B#6	3.90461e-18
C314	a_183_74##5	VNB	3.0964e-17
C315	A#9	VNB	3.08344e-17
C316	VGND	a_183_74##3	4.19928e-18
C317	A#8	VNB	3.33855e-17
C318	B#1	VNB	2.68174e-17
C319	VGND	A#6	5.62754e-18
C320	A#1	VNB	3.29e-17
C321	VGND	B#2	9.67411e-18
C322	B#9	VNB	4.50028e-17
C323	B#10	VNB	3.07882e-17
C324	VGND	A#2	4.1338e-18
C325	a_183_74#	VNB	3.19999e-17
C326	a_183_74##4	VNB	3.21275e-17
C327	A#4	VNB	2.97897e-17
C328	A#10	VNB	3.32701e-17
C329	B#3	VNB	4.81321e-17
C330	A#3	VNB	4.37239e-17
C331	VPWR#3	VNB	2.67793e-16
C332	VPWR	A	3.96404e-18
C333	B#6	VNB	3.84032e-18
C334	VPWR	B	1.96741e-18
C335	a_183_74##3	VNB	4.06125e-17
C336	A#6	VNB	1.30063e-17
C337	VGND	A	1.69107e-18
C338	B#2	VNB	4.90034e-17
C339	VPWR	X	6.30686e-18
C340	A#2	VNB	4.76519e-17
C341	VGND	B	7.31593e-18
C342	VGND	X	2.29304e-18
C343	A	VNB	3.94489e-18
C344	B	VNB	4.379e-18
C345	X	VNB	4.84027e-17
C346	VPWR	VNB	7.00892e-17
C347	VGND	VNB	6.64759e-17
C348	VPWR#2	B#9	6.13571e-18
C349	VGND#2	X#1	2.21554e-17
C350	VGND#2	VGND#5	9.19348e-18
C351	VGND#2	a_183_74##3	7.00729e-19
C352	VPWR#2	a_183_74##4	1.0652e-19
C353	VGND#2	B#4	5.23491e-18
C354	VGND#2	A#9	1.16638e-17
C355	VGND#2	VNB	3.00439e-16
C356	VPWR	VPWR#2	6.12495e-17
C357	VGND#2	a_399_74#	1.17133e-16
C358	VGND#2	a_399_74##2	6.5533e-17
C359	a_313_368##2	VPWR#2	4.24068e-17
C360	VGND#2	VGND#4	4.44251e-17
C361	VPWR#2	a_183_74#	5.28637e-18
C362	VPWR#3	VPWR#2	6.84055e-17
C363	VGND#2	a_183_74##2	1.6096e-20
C364	VPWR#2	VNB	5.99773e-17
C365	VGND#2	VGND#3	4.24448e-17
C366	VGND#2	B#8	4.73088e-18
C367	VPWR#5	VPWR#2	6.19035e-20
C368	VGND	VGND#2	7.57609e-17
C369	VGND#2	A#8	1.02021e-18
C370	VPWR#2	A#10	3.93099e-20
C371	VPWR#2	B#10	5.19933e-18
C372	VGND#6	VGND#2	2.05204e-18
C373	VGND#2	B#7	2.51452e-19
C374	VGND#2	A#7	4.87025e-19
C375	VPWR#2	A#4	2.79336e-20
C376	VGND#2	a_183_74##5	6.54303e-18
C377	VGND#2	B#1	2.67872e-19
C378	a_313_368#	VPWR#2	2.15104e-17
*
*
.ENDS sky130_fd_sc_hs__xor2_2
*
