* Extracted by Quantus, converted by sky130cad/quantus.py
*
*
*
*                       LINUX           Wed Nov 18 08:19:24 2026
*
*
*
*  PROGRAM  advgen
*
*  Name           : advgen - Quantus - (64-bit)
*  Version        : 25.1.0-p047
*  Build Date     : Thu Dec 11 23:20:30 PST 2025
*
*  HSPICE LIBRARY
*
*  OPERATING_TEMPERATURE 150
*  QRC_TECH_DIR <path>/tech
*
*
*

*
.SUBCKT sky130_fd_sc_hs__and4bb_2 VPB VNB VGND VPWR X B_N C D A_N
*
*
*  caps2d version: 10
*
*
*       TRANSISTOR CARDS
*
*
XM14 a_27_74##6 A_N#3 VGND#9 VNB sky130_fd_pr__nfet_01v8_lvt l=0.15 w=0.55 ad=0.15675 as=0.15675 pd=1.67 ps=1.67
XM13 a_225_82##10 a_27_74# a_312_82# VNB sky130_fd_pr__nfet_01v8_lvt l=0.15 w=0.74 ad=0.2109 as=0.1776 pd=2.05 ps=1.96
XM12 a_312_82# a_354_252##3 a_390_82# VNB sky130_fd_pr__nfet_01v8_lvt l=0.15 w=0.74 ad=0.1776 as=0.2886 pd=1.96 ps=2.26
XM8 a_390_82# C#3 a_498_82# VNB sky130_fd_pr__nfet_01v8_lvt l=0.15 w=0.74 ad=0.2886 as=0.2664 pd=2.26 ps=2.2
XM3 a_498_82# D#3 VGND#8 VNB sky130_fd_pr__nfet_01v8_lvt l=0.15 w=0.74 ad=0.2664 as=0.5106 pd=2.2 ps=2.86
XM11 VGND#8 a_225_82##5 X#3 VNB sky130_fd_pr__nfet_01v8_lvt l=0.15 w=0.74 ad=0.5106 as=0.2072 pd=2.86 ps=2.04
XM15 X#3 a_225_82##4 VGND#7 VNB sky130_fd_pr__nfet_01v8_lvt l=0.15 w=0.74 ad=0.2072 as=0.37805 pd=2.04 ps=2.82
XM4 VGND#7 B_N#4 a_354_252##4 VNB sky130_fd_pr__nfet_01v8_lvt l=0.15 w=0.55 ad=0.37805 as=0.15675 pd=2.82 ps=1.67
XM5 a_27_74##7 A_N#1 VPWR#11 VPB sky130_fd_pr__pfet_01v8 l=0.15 w=0.84 ad=0.2478 as=0.4 pd=2.27 ps=2.84
XM9 VPWR#11 a_27_74##3 a_225_82##12 VPB sky130_fd_pr__pfet_01v8 l=0.15 w=1 ad=0.4 as=0.57 pd=2.84 ps=3.14
XM2 a_225_82##12 a_354_252# VPWR#10 VPB sky130_fd_pr__pfet_01v8 l=0.15 w=1 ad=0.57 as=0.51 pd=3.14 ps=3.02
XM1 VPWR#10 C#1 a_225_82##11 VPB sky130_fd_pr__pfet_01v8 l=0.15 w=1 ad=0.51 as=0.3 pd=3.02 ps=2.6
XM10 a_225_82##11 D#1 VPWR#9 VPB sky130_fd_pr__pfet_01v8 l=0.15 w=1 ad=0.3 as=0.6568 pd=2.6 ps=3.49
XM0 VPWR#9 a_225_82##6 X#1 VPB sky130_fd_pr__pfet_01v8 l=0.15 w=1.12 ad=0.6568 as=0.336 pd=3.49 ps=2.84
XM7 X#1 a_225_82# VPWR#8 VPB sky130_fd_pr__pfet_01v8 l=0.15 w=1.12 ad=0.336 as=0.406 pd=2.84 ps=3.01
XM6 VPWR#8 B_N#3 a_354_252##7 VPB sky130_fd_pr__pfet_01v8 l=0.15 w=0.84 ad=0.406 as=0.2604 pd=3.01 ps=2.3
*
*
*       RESISTOR AND CAP/DIODE CARDS
*
Rg1	A_N#1	A_N#2	391.992889
Rg2	A_N#2	A_N#3	510.564087
Rg3	a_27_74#	a_27_74##2	466.665070
Rg4	a_27_74##2	a_27_74##3	452.115417
Rg5	a_354_252#	a_354_252##2	492.429810
Rg6	a_354_252##2	a_354_252##3	307.937683
Rg7	C#1	C#2	422.415131
Rg8	C#2	C#3	399.755615
Rg9	D#1	D#2	415.434357
Rg10	D#2	D#3	392.774811
Rg11	a_225_82#	a_225_82##2	455.516602
Rg12	a_225_82##2	a_225_82##3	81.843414
Rg13	a_225_82##2	a_225_82##4	371.813751
Rg14	a_225_82##3	a_225_82##5	347.540955
Rg15	a_225_82##3	a_225_82##6	432.775055
Rg16	B_N#1	B_N#2	27.660566
Rg17	B_N#2	B_N#3	410.273041
Rg18	B_N#2	B_N#4	270.156219
Rf1	A_N#4	A_N	0.772649
Rf2	A_N#2	A_N#6	161.005447
Rf3	A_N#4	A_N#6	5.708254
Rf4	a_27_74##2	a_27_74##5	166.551254
Rf5	a_27_74##5	a_27_74##6	100.209724
Rf6	a_27_74##5	a_27_74##7	83.364746
Rf7	C#2	C#5	161.415527
Rf8	C#6	C	1.182722
Rf9	C#5	C#6	5.978708
Rf10	D#2	D	163.382187
Rf11	a_225_82##3	a_225_82##8	246.892487
Rf12	a_225_82##8	a_225_82##9	78.193794
Rf13	a_225_82##9	a_225_82##10	83.162270
Rf14	a_225_82##8	a_225_82##11	18.602406
Rf15	a_225_82##9	a_225_82##12	21.715120
Rf16	X#2	X	0.181173
Rf17	X	X#3	82.687531
Rf18	X#2	X	13.225628
Rf19	X#1	X#2	5.000000
Rf20	B_N#5	B_N	0.799792
Rf21	B_N#1	B_N#7	161.032593
Rf22	B_N#5	B_N#7	5.117745
Rf23	a_354_252##4	a_354_252##5	48.264927
Rf24	a_354_252##5	a_354_252##2	372.050354
Rf25	a_354_252##5	a_354_252##7	132.293640
Rf27	VGND#2	VGND#3	98.569107
Rf28	VGND#3	VGND#4	36.500717
Rf29	VGND#4	VGND#5	140.962921
Rf31	VGND#2	VGND#7	24.468842
Rf32	VGND#3	VGND#8	37.853714
Rf33	VGND#5	VGND#9	37.066368
Rf35	VPWR#2	VPWR#3	82.190086
Rf36	VPWR#3	VPWR#4	52.937077
Rf37	VPWR#4	VPWR#5	29.926170
Rf38	VPWR#5	VPWR#6	93.820816
Rf40	VPWR#2	VPWR#8	43.597031
Rf41	VPWR#3	VPWR#9	32.125244
Rf42	VPWR#5	VPWR#10	32.420494
Rf43	VPWR#6	VPWR#11	33.109421
Re1	VPWR#4	VPWR	0.892922
Re2	VGND	VGND#4	0.892955
*
*       CAPACITOR CARDS
*
*
C1	VPWR#5	VPWR#3	6.20217e-19
C2	B_N#1	B_N#2	8.42003e-18
C3	B_N#1	a_225_82##2	7.0165e-19
C4	a_27_74##5	a_225_82##10	5.76273e-17
C5	a_225_82##8	X#1	4.06846e-19
C6	a_225_82##3	a_225_82##2	2.68927e-18
C7	VGND#9	a_27_74##5	3.36795e-17
C8	a_225_82##8	VPWR#9	1.62244e-17
C9	VGND#3	a_225_82##4	3.80772e-19
C10	a_225_82##8	a_225_82##11	1.98852e-19
C11	a_225_82##9	VPWR#10	1.3978e-17
C12	VGND#3	a_225_82##5	5.75259e-18
C13	a_225_82##8	VPWR#10	1.91203e-17
C14	a_225_82##9	a_225_82##12	3.61979e-18
C15	a_354_252##5	B_N#4	7.0508e-18
C16	a_27_74##6	A_N#6	7.96406e-18
C17	VGND#3	D#3	5.16633e-18
C18	a_354_252##5	a_225_82##4	2.96664e-17
C19	VGND#3	C#3	7.97259e-19
C20	a_27_74##7	a_225_82##9	3.55331e-19
C21	a_354_252##5	a_225_82##5	2.71758e-17
C22	a_225_82##10	VGND#8	7.57452e-18
C23	a_354_252##4	a_354_252##7	2.20326e-18
C24	VGND#3	a_354_252##3	4.46412e-19
C25	a_354_252##2	a_225_82##2	6.68162e-20
C26	a_354_252##5	D#3	1.98268e-18
C27	X#3	a_354_252##7	8.54733e-18
C28	VGND#3	a_27_74#	2.44066e-19
C29	a_354_252##5	C#3	4.87036e-19
C30	a_27_74##5	VPWR#11	2.0169e-17
C31	a_354_252##5	a_354_252##3	2.51075e-19
C32	X#3	X#1	2.92751e-18
C33	VGND#9	a_225_82##10	4.31826e-17
C34	a_27_74##5	a_27_74##7	4.01656e-18
C35	a_354_252##5	a_27_74#	1.62263e-19
C36	a_27_74##6	a_225_82##10	2.54411e-18
C37	a_225_82##4	B_N#2	9.37308e-19
C38	VPWR#3	a_225_82##6	4.62556e-18
C39	a_27_74##6	VGND#9	5.02741e-17
C40	A_N#6	a_27_74##7	2.50561e-17
C41	VPWR#3	D#1	5.36429e-18
C42	a_354_252##4	B_N#4	3.59019e-17
C43	a_354_252##7	VPWR#8	7.40953e-17
C44	VPWR#5	a_354_252#	6.09957e-18
C45	B_N#4	VGND#7	6.7472e-18
C46	a_225_82##9	VPWR#5	6.71339e-19
C47	a_354_252##4	a_225_82##4	1.26825e-18
C48	X#1	a_354_252##7	3.77637e-17
C49	VGND#3	a_354_252##5	7.76545e-18
C50	X#3	B_N#4	7.85056e-19
C51	a_225_82##4	VGND#7	1.26853e-17
C52	X#1	VPWR#8	5.40585e-17
C53	VGND#8	B_N#4	6.87208e-19
C54	a_225_82##8	VPWR#5	9.23268e-20
C55	a_225_82##10	a_225_82##12	2.00658e-18
C56	X#3	a_225_82##4	2.39671e-17
C57	VPWR#9	VPWR#8	1.80703e-18
C58	a_27_74##5	a_27_74#	7.30589e-19
C59	VGND#8	a_225_82##4	1.71395e-18
C60	X#3	a_225_82##5	2.39052e-17
C61	a_225_82##8	VPWR#3	6.1367e-19
C62	VPWR#9	X#1	2.03155e-17
C63	a_225_82##5	VGND#8	1.26678e-17
C64	a_27_74##5	A_N#3	9.26548e-18
C65	X#3	D#3	4.10666e-19
C66	a_225_82##11	X#1	1.54989e-18
C67	a_225_82##9	a_225_82##6	1.07166e-19
C68	a_225_82##2	B_N#2	1.76799e-17
C69	VGND#8	D#3	4.50932e-17
C70	a_225_82##11	VPWR#9	4.29665e-17
C71	a_225_82##8	a_225_82##6	1.29233e-19
C72	X#3	C#3	9.74717e-20
C73	a_225_82##9	D#1	4.62105e-20
C74	VGND#8	C#3	3.60103e-18
C75	VPWR#10	VPWR#9	1.12531e-18
C76	a_225_82##8	D#1	2.40455e-17
C77	VPWR#4	VPWR#5	3.55698e-17
C78	a_225_82##10	a_225_82##5	2.72315e-19
C79	VPWR#10	a_225_82##11	5.06878e-17
C80	VPWR#4	VPWR#3	3.94819e-17
C81	VGND#8	a_354_252##3	1.64592e-18
C82	a_225_82##9	C#1	2.12573e-19
C83	a_225_82##12	a_225_82##11	1.58824e-18
C84	a_225_82##10	D#3	1.413e-18
C85	a_225_82##8	C#1	2.14543e-17
C86	VGND#8	a_27_74#	8.73396e-19
C87	a_225_82##12	VPWR#10	3.77447e-17
C88	VGND#9	D#3	2.86958e-19
C89	a_225_82##9	a_354_252#	2.28362e-17
C90	a_225_82##10	C#3	2.7034e-18
C91	a_225_82##8	a_354_252#	1.45807e-19
C92	VPWR#11	VPWR#10	8.45274e-19
C93	VGND#9	C#3	3.10065e-19
C94	B_N#2	a_354_252##4	5.86369e-18
C95	a_225_82##10	a_354_252##3	1.21794e-17
C96	a_225_82##9	a_27_74##3	6.55015e-18
C97	VPWR#11	a_225_82##12	3.65073e-17
C98	a_225_82##8	a_27_74##3	2.5587e-20
C99	VGND#9	a_354_252##3	4.9133e-19
C100	a_354_252##5	B_N#7	6.84687e-18
C101	a_225_82##10	a_27_74#	5.71881e-17
C102	VGND#4	VGND#3	3.8905e-17
C103	a_27_74##7	a_225_82##12	1.58459e-18
C104	a_225_82##9	A_N#1	1.26282e-18
C105	VGND#9	a_27_74#	2.50408e-18
C106	a_225_82##10	A_N#3	4.14827e-18
C107	a_225_82##3	VPWR#3	1.46876e-18
C108	C#5	a_354_252#	1.34089e-18
C109	a_27_74##7	VPWR#11	3.6759e-17
C110	a_27_74##6	a_27_74#	5.44828e-19
C111	a_27_74##5	a_354_252#	2.05656e-18
C112	VGND#9	A_N#3	3.8118e-17
C113	a_27_74##6	A_N#3	1.83275e-17
C114	a_27_74##5	a_27_74##3	7.73362e-18
C115	VGND#3	a_225_82##3	1.20487e-19
C116	a_225_82##8	VPWR#4	3.23419e-19
C117	a_354_252##5	B_N#1	1.03651e-17
C118	a_27_74##5	A_N#1	2.77143e-19
C119	a_225_82##4	B_N#4	1.71653e-17
C120	X#3	B_N#2	7.8335e-19
C121	a_354_252##7	B_N#3	5.63518e-17
C122	a_354_252##5	a_225_82##3	2.59826e-17
C123	a_354_252##5	a_225_82##8	2.40688e-18
C124	B_N#3	VPWR#8	2.6533e-17
C125	X#3	a_225_82##2	1.46219e-17
C126	a_225_82##5	a_225_82##4	4.11792e-17
C127	a_354_252##7	a_225_82#	6.19888e-18
C128	X#1	B_N#3	2.53505e-18
C129	a_225_82#	VPWR#8	3.15702e-17
C130	a_354_252##5	D#2	1.18973e-18
C131	X#1	a_225_82#	4.83678e-17
C132	D#3	a_225_82##5	8.09274e-18
C133	VPWR#8	a_225_82##6	7.35918e-19
C134	VGND#3	a_354_252##2	3.80625e-19
C135	VPWR#9	a_225_82#	9.45103e-19
C136	X#1	a_225_82##6	4.42625e-17
C137	VPWR#8	D#1	1.32715e-19
C138	a_225_82##9	D#2	1.29967e-19
C139	a_225_82##6	VPWR#9	2.90845e-17
C140	a_225_82##2	B_N#3	1.30778e-18
C141	C#3	D#3	3.29449e-17
C142	X#1	D#1	1.28422e-18
C143	a_225_82##8	D#2	2.73399e-18
C144	a_225_82##11	a_225_82##6	1.39124e-18
C145	D#1	VPWR#9	3.87522e-17
C146	VPWR#10	a_225_82##6	1.8278e-19
C147	a_225_82##9	C#2	1.03236e-18
C148	a_225_82##11	D#1	4.90588e-17
C149	a_354_252##3	C#3	2.73948e-17
C150	a_225_82##8	C#2	2.31856e-18
C151	VPWR#9	C#1	1.0317e-18
C152	VPWR#10	D#1	1.19842e-18
C153	a_225_82##11	C#1	4.36897e-17
C154	a_354_252##4	B_N#1	2.82073e-17
C155	a_225_82##9	a_354_252##2	2.5504e-17
C156	VPWR#9	a_354_252#	2.04972e-19
C157	C#1	VPWR#10	3.13867e-17
C158	a_27_74#	a_354_252##3	4.68089e-17
C159	a_354_252##2	a_225_82##8	6.61695e-18
C160	a_225_82##11	a_354_252#	1.55826e-18
C161	a_225_82##12	C#1	1.45031e-18
C162	a_225_82##9	a_225_82##8	3.6728e-19
C163	C#5	C#2	1.44489e-17
C164	a_354_252#	VPWR#10	3.79873e-17
C165	VPWR#11	C#1	2.52331e-19
C166	a_225_82##9	a_27_74##2	2.08673e-18
C167	a_225_82##11	a_27_74##3	1.10646e-19
C168	a_354_252#	a_225_82##12	2.49829e-17
C169	A_N#3	a_27_74#	5.12014e-18
C170	X#3	a_225_82##3	3.72877e-17
C171	VPWR#10	a_27_74##3	1.68812e-18
C172	a_354_252##2	C#5	3.52967e-17
C173	a_225_82##3	VGND#8	2.5292e-18
C174	VPWR#11	a_354_252#	2.39885e-18
C175	a_27_74##3	a_225_82##12	2.95669e-17
C176	a_27_74##5	a_354_252##2	5.19888e-19
C177	a_225_82##9	A_N#2	8.15691e-19
C178	a_27_74##7	a_354_252#	1.49863e-19
C179	VPWR#11	a_27_74##3	5.63354e-17
C180	VGND#8	D#2	1.2553e-18
C181	a_225_82##12	A_N#1	6.254e-19
C182	C#5	a_27_74##2	5.93911e-19
C183	a_27_74##7	a_27_74##3	2.1082e-18
C184	a_27_74##5	a_27_74##2	2.14828e-17
C185	A_N#1	VPWR#11	2.39082e-17
C186	X#3	C#2	1.11989e-19
C187	a_225_82##11	VPWR#4	1.66935e-17
C188	a_27_74##7	A_N#1	5.14435e-17
C189	A_N#6	a_27_74##2	2.65648e-18
C190	a_27_74##5	A_N#2	2.16211e-17
C191	X#3	a_354_252##2	3.22817e-19
C192	a_354_252##2	VGND#8	2.80787e-17
C193	a_225_82#	B_N#3	2.80195e-17
C194	a_225_82##3	X#1	5.04495e-17
C195	A_N#6	A_N#2	1.26297e-17
C196	a_225_82##3	VPWR#9	2.24928e-17
C197	X#1	D#2	2.36673e-19
C198	a_225_82##6	a_225_82#	4.68048e-17
C199	a_225_82##10	a_354_252##2	6.14279e-17
C200	D#2	VPWR#9	1.40152e-18
C201	a_225_82##9	C#5	5.12016e-18
C202	a_225_82##10	a_27_74##2	1.922e-17
C203	B_N#1	B_N#4	1.13976e-18
C204	D#1	a_225_82##6	1.42386e-17
C205	a_354_252##5	a_312_82#	2.71563e-21
C206	B_N#1	a_225_82##4	7.15479e-19
C207	VGND#4	D#3	3.61871e-20
C208	a_225_82##10	A_N#2	2.39806e-19
C209	C#2	VPWR#10	1.34279e-18
C210	C#5	a_225_82##8	2.21728e-17
C211	a_27_74##5	a_225_82##9	3.05056e-17
C212	VGND#4	C#3	7.84204e-18
C213	C#1	D#1	4.25085e-17
C214	VGND#9	A_N#2	5.43268e-19
C215	VGND#4	a_354_252##3	7.84204e-18
C216	a_27_74##6	A_N#2	4.08259e-18
C217	VPWR#10	a_354_252##2	9.17459e-19
C218	D#3	a_225_82##3	8.36369e-19
C219	a_354_252##5	a_354_252##4	1.07427e-17
C220	a_354_252#	C#1	1.94994e-17
C221	a_354_252##5	B_N#2	4.54834e-18
C222	VPWR#11	a_27_74##2	5.85979e-19
C223	a_27_74##3	a_354_252#	1.69656e-17
C224	a_354_252##5	VGND#7	1.58493e-17
C225	a_354_252##2	a_225_82##4	1.37563e-20
C226	a_354_252##2	a_225_82##5	1.919e-20
C227	VPWR#4	D#1	1.60499e-18
C228	a_354_252##5	a_225_82##2	4.13497e-18
C229	a_354_252##2	D#3	3.09959e-17
C230	A_N#1	a_27_74##3	2.63136e-17
C231	a_27_74##7	A_N#2	5.7956e-18
C232	VPWR#4	C#1	3.48793e-18
C233	a_354_252##2	C#3	3.50045e-17
C234	a_225_82##3	a_225_82#	2.83692e-19
C235	a_354_252##5	X#3	1.08885e-16
C236	a_354_252##2	a_354_252##3	1.0267e-17
C237	a_27_74#	a_354_252##2	1.08353e-17
C238	a_225_82##3	a_225_82##6	6.22848e-18
C239	a_225_82##3	D#1	2.35611e-19
C240	a_225_82##10	a_312_82#	1.02467e-18
C241	D#2	a_225_82##6	1.68785e-18
C242	a_354_252##5	D	2.85048e-18
C243	a_225_82##3	C#1	6.55564e-20
C244	a_354_252##5	VGND#8	4.66534e-17
C245	a_225_82##3	a_354_252#	2.0177e-19
C246	A_N#2	a_27_74#	8.33354e-19
C247	D	a_225_82##8	3.63406e-17
C248	VGND	B_N#2	4.01342e-19
C249	D#3	a_498_82#	2.07804e-17
C250	C#3	a_498_82#	2.07804e-17
C251	a_354_252#	C#2	2.01338e-18
C252	C#3	a_390_82#	2.14361e-17
C253	C	a_225_82##8	2.52087e-17
C254	a_354_252##3	a_390_82#	2.14361e-17
C255	B_N#7	B_N#2	1.35516e-17
C256	a_27_74##2	a_354_252#	6.67274e-19
C257	a_354_252##7	B_N#2	1.09248e-17
C258	X	VPWR#3	5.89591e-18
C259	a_27_74##6	A_N	1.66651e-17
C260	VGND#4	C#2	1.68495e-19
C261	A_N#2	a_27_74##3	1.49676e-18
C262	a_354_252##3	a_312_82#	2.69557e-18
C263	D#2	a_225_82##3	2.92065e-17
C264	VGND#4	a_354_252##2	9.44639e-18
C265	B_N#2	VNB	6.48866e-17
C266	B_N#7	a_225_82##2	2.02209e-18
C267	a_354_252##7	a_225_82##2	4.33091e-18
C268	a_27_74#	a_312_82#	1.32865e-17
C269	a_225_82##2	VNB	2.71067e-17
C270	a_225_82##3	C#2	4.1245e-19
C271	C#2	D#2	3.6932e-17
C272	a_354_252##2	a_225_82##3	2.58917e-18
C273	VPWR	VPWR#5	2.29294e-17
C274	VPWR#5	VPWR#9	1.04336e-19
C275	VPWR	VPWR#3	2.56436e-17
C276	A_N	a_27_74##7	1.80427e-17
C277	a_354_252##2	D#2	2.42238e-18
C278	a_354_252##2	C#2	3.78732e-17
C279	VPWR	B_N#7	2.40182e-18
C280	a_27_74##2	a_354_252##2	2.30544e-17
C281	VPWR	a_225_82##9	2.60722e-18
C282	VPWR	a_225_82##8	4.84906e-18
C283	VPWR	C#5	1.2586e-18
C284	A_N#2	a_27_74##2	2.47306e-17
C285	VGND	VGND#3	4.70872e-17
C286	VPWR	a_27_74##5	4.02731e-18
C287	VPWR	A_N#6	1.11978e-18
C288	a_27_74##5	A_N#6	3.96132e-17
C289	VGND	a_354_252##5	2.51244e-17
C290	a_354_252##2	a_498_82#	4.61059e-18
C291	X	VPWR#8	2.86452e-17
C292	X	X#1	2.39581e-19
C293	VGND	a_225_82##9	2.76938e-18
C294	VPWR#9	X	1.77647e-17
C295	a_354_252##2	a_390_82#	5.77864e-18
C296	D	a_225_82##6	4.12114e-19
C297	VGND	C#5	1.77782e-18
C298	VPWR#5	VNB	2.74307e-17
C299	VGND	a_27_74##5	6.27221e-18
C300	VPWR#3	VNB	3.01802e-17
C301	VPWR	a_354_252##7	1.69748e-17
C302	VGND	A_N#6	1.10896e-18
C303	a_354_252##2	a_312_82#	2.72968e-18
C304	VGND#3	VNB	3.21893e-17
C305	VGND	a_354_252##4	1.34648e-17
C306	VPWR	VPWR#9	2.15606e-17
C307	VPWR	a_225_82##11	1.58676e-17
C308	VGND	X#3	5.14915e-18
C309	a_354_252##5	VNB	8.95305e-18
C310	VPWR	VPWR#10	2.1587e-17
C311	VPWR	a_225_82##12	1.83223e-17
C312	B_N#7	VNB	1.17971e-17
C313	VPWR	VPWR#11	1.98802e-17
C314	a_225_82##9	VNB	1.19984e-17
C315	VPWR	a_27_74##7	1.54979e-17
C316	VGND	a_225_82##10	2.27575e-17
C317	a_225_82##8	VNB	6.89604e-18
C318	X#1	B_N#2	2.25475e-19
C319	VGND	a_27_74##6	1.37166e-17
C320	VGND	a_354_252##7	4.24862e-18
C321	X	B_N#3	5.06374e-19
C322	C#5	VNB	1.34723e-19
C323	D	a_225_82##3	2.90023e-17
C324	a_27_74##5	VNB	1.15083e-17
C325	VGND	X#1	6.69331e-19
C326	X	a_225_82#	1.2538e-17
C327	X	a_225_82##6	1.18066e-17
C328	D	D#2	2.00732e-17
C329	A_N#6	VNB	1.16154e-18
C330	X	D#1	5.15296e-19
C331	a_354_252##4	VNB	2.74659e-17
C332	D	C#2	1.8146e-18
C333	X#3	VNB	9.42418e-19
C334	VGND#8	VNB	1.05501e-18
C335	a_354_252##2	D	2.26485e-17
C336	A_N	A_N#2	9.82369e-18
C337	a_225_82##12	VPWR#5	9.51871e-18
C338	VGND	B_N#4	6.71928e-18
C339	C	D#2	7.05918e-18
C340	VPWR	B_N#3	6.50795e-18
C341	VGND	a_225_82##4	8.35765e-18
C342	VPWR	a_225_82#	4.05776e-18
C343	a_225_82##10	VNB	1.05181e-17
C344	VGND	a_225_82##5	1.0375e-17
C345	C	C#2	5.81126e-18
C346	X#1	a_225_82##2	6.05525e-18
C347	VGND#9	VNB	9.25633e-18
C348	VPWR	a_225_82##6	3.2762e-18
C349	VGND	D#3	4.22686e-18
C350	a_27_74##6	VNB	5.31829e-17
C351	VGND	C#3	1.0375e-17
C352	VPWR	D#1	1.11569e-18
C353	a_354_252##2	C	1.71617e-17
C354	a_354_252##7	VNB	5.25166e-17
C355	VPWR#8	VNB	1.27358e-17
C356	VGND	a_354_252##3	1.0375e-17
C357	VPWR	C#1	1.62556e-18
C358	X#1	VNB	4.93105e-19
C359	VGND	a_27_74#	9.51615e-18
C360	VPWR#9	VNB	4.36382e-18
C361	VPWR	a_354_252#	1.63434e-18
C362	VGND	A_N#3	1.27791e-18
C363	a_225_82##11	VNB	2.15003e-18
C364	VPWR	a_27_74##3	3.1601e-18
C365	VPWR#10	VNB	4.18727e-18
C366	a_225_82##12	VNB	5.79922e-18
C367	a_354_252##5	a_354_252##7	6.77858e-19
C368	VPWR	A_N#1	9.23468e-18
C369	VPWR#11	VNB	6.89332e-18
C370	a_27_74##7	VNB	4.42966e-17
C371	B_N#4	VNB	3.7906e-17
C372	VPWR	VPWR#4	1.05408e-17
C373	a_225_82##4	VNB	3.52439e-17
C374	a_225_82##5	VNB	3.32018e-17
C375	D#3	VNB	3.08741e-17
C376	C#3	VNB	2.82975e-17
C377	a_354_252##3	VNB	2.82139e-17
C378	VPWR	a_225_82##3	4.48035e-18
C379	a_27_74#	VNB	3.56708e-17
C380	A_N#3	VNB	4.51057e-17
C381	B_N#3	VNB	4.15773e-17
C382	a_225_82#	VNB	3.61729e-17
C383	VGND	VGND#4	3.18507e-17
C384	VPWR	a_354_252##2	3.20433e-18
C385	a_225_82##6	VNB	3.63682e-17
C386	D#1	VNB	3.73336e-17
C387	VGND	B_N#1	2.41662e-18
C388	VPWR	a_27_74##2	9.17861e-19
C389	C#1	VNB	3.42296e-17
C390	VGND	a_225_82##3	3.73304e-18
C391	a_354_252#	VNB	4.05833e-17
C392	a_27_74##3	VNB	4.48257e-17
C393	A_N#1	VNB	4.51064e-17
C394	VGND	a_354_252##2	1.62037e-17
C395	VPWR#4	VNB	2.3181e-16
C396	VGND	a_27_74##2	3.20436e-18
C397	VGND#4	VNB	2.57623e-16
C398	B_N#1	VNB	8.48512e-18
C399	C	D	3.11109e-17
C400	a_225_82##3	VNB	4.02106e-17
C401	D#2	VNB	3.47312e-17
C402	C#2	VNB	3.53583e-17
C403	a_354_252##2	VNB	3.93884e-17
C404	a_27_74##2	VNB	5.23544e-17
C405	A_N#2	VNB	7.83403e-17
C406	VPWR	A_N	2.80236e-18
C407	VPWR	D	1.78529e-18
C408	VGND	A_N	1.24828e-18
C409	VPWR	C	1.06663e-18
C410	VGND	D	2.74797e-18
C411	a_354_252##7	B_N#7	3.6161e-17
C412	VGND	C	1.71224e-18
C413	A_N	VNB	2.10112e-17
C414	VPWR	X	1.80993e-17
C415	D	VNB	3.88886e-18
C416	C	VNB	7.35068e-19
C417	X	VNB	2.33143e-18
C418	VPWR	VNB	7.73954e-17
C419	VGND	VNB	7.34208e-17
C420	a_354_252##7	VPWR#2	9.23924e-18
C421	VPWR#2	VNB	5.2696e-17
C422	a_27_74##5	VPWR#6	5.02594e-19
C423	VGND#5	A_N#3	8.58234e-18
C424	X	VPWR#2	1.23432e-17
C425	VPWR#2	B_N#2	2.66994e-19
C426	VGND#8	VGND#2	3.34661e-18
C427	VPWR#2	a_225_82#	7.9705e-18
C428	a_27_74##7	VPWR#6	1.25632e-17
C429	VPWR#4	VPWR#6	6.73147e-17
C430	VPWR#3	VPWR#2	5.80211e-19
C431	VGND#2	a_225_82##4	1.37215e-17
C432	VPWR#6	VNB	6.11721e-17
C433	VGND#5	A_N#2	6.92748e-20
C434	VPWR#6	A_N#2	1.13743e-19
C435	VGND#2	VGND#7	6.75106e-18
C436	VGND#5	a_354_252##3	3.14934e-19
C437	VGND	VGND#2	5.41632e-17
C438	VGND#5	a_27_74##5	8.34337e-19
C439	VPWR#6	a_27_74##3	4.1978e-18
C440	A_N	VPWR#6	8.78277e-19
C441	VPWR	VPWR#2	5.43185e-17
C442	VPWR#2	a_225_82##2	2.00104e-20
C443	VPWR#2	a_225_82##6	5.69388e-19
C444	VGND#2	a_225_82##3	5.12712e-20
C445	VGND	VGND#5	6.70825e-17
C446	VGND#2	B_N#2	3.11465e-19
C447	VGND#5	D#3	2.17694e-19
C448	VGND#4	VGND#5	7.28701e-17
C449	VGND#2	a_225_82##5	4.62372e-18
C450	a_225_82##12	VPWR#6	8.87877e-18
C451	VPWR#6	A_N#1	4.28172e-18
C452	VGND#5	a_27_74##6	1.7559e-17
C453	VPWR#2	a_225_82##3	1.39261e-20
C454	VGND#4	VGND#2	6.27402e-17
C455	VPWR#4	VPWR#2	5.7043e-17
C456	VGND#5	a_27_74#	6.16608e-18
C457	VPWR	VPWR#6	4.51621e-17
C458	VGND#3	VGND#2	9.33113e-19
C459	VPWR#2	D#1	4.20287e-20
C460	VGND#2	B_N#4	3.98725e-18
C461	VGND#2	VNB	6.74217e-17
C462	VPWR#2	B_N#3	3.45925e-18
C463	VGND#2	a_354_252##5	4.57528e-17
C464	VGND#5	a_27_74##2	2.64382e-19
C465	VGND#2	a_354_252##4	1.16639e-17
C466	VGND#5	VNB	6.52684e-17
C467	VGND#5	a_225_82##10	2.39794e-17
C468	VGND#5	C#3	1.92882e-19
C469	VGND#2	a_225_82##2	3.025e-20
C470	VPWR#6	VPWR#5	5.71998e-19
C471	VPWR#9	VPWR#2	2.44464e-19
C472	VPWR#6	a_27_74##2	5.20611e-19
C473	VGND#2	D#3	7.37739e-19
*
*
.ENDS sky130_fd_sc_hs__and4bb_2
*
