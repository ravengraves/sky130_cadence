* Extracted by Quantus, converted by sky130cad/quantus.py
*
*
*
*                       LINUX           Wed Nov 18 09:03:55 2026
*
*
*
*  PROGRAM  advgen
*
*  Name           : advgen - Quantus - (64-bit)
*  Version        : 25.1.0-p047
*  Build Date     : Thu Dec 11 23:20:30 PST 2025
*
*  HSPICE LIBRARY
*
*  OPERATING_TEMPERATURE 150
*  QRC_TECH_DIR <path>/tech
*
*
*

*
.SUBCKT sky130_fd_sc_hs__o41a_1 VNB VPB VGND VPWR X A4 A3 A2 A1 B1
*
*
*  caps2d version: 10
*
*
*       TRANSISTOR CARDS
*
*
XM11 X#3 a_83_270##3 VGND#8 VNB sky130_fd_pr__nfet_01v8_lvt l=0.15 w=0.74 ad=0.2109 as=0.2627 pd=2.05 ps=2.19
XM4 a_83_270##6 B1#4 a_326_74##3 VNB sky130_fd_pr__nfet_01v8_lvt l=0.15 w=0.64 ad=0.1824 as=0.224 pd=1.85 ps=1.98
XM3 a_326_74##3 A4#3 VGND#7 VNB sky130_fd_pr__nfet_01v8_lvt l=0.15 w=0.64 ad=0.224 as=0.2688 pd=1.98 ps=2.12
XM1 VGND#7 A3#1 a_326_74##4 VNB sky130_fd_pr__nfet_01v8_lvt l=0.15 w=0.64 ad=0.2688 as=0.2176 pd=2.12 ps=1.96
XM8 a_326_74##4 A2#3 VGND#4 VNB sky130_fd_pr__nfet_01v8_lvt l=0.15 w=0.64 ad=0.2176 as=0.3584 pd=1.96 ps=2.4
XM10 VGND#4 A1#1 a_326_74# VNB sky130_fd_pr__nfet_01v8_lvt l=0.15 w=0.64 ad=0.3584 as=0.1824 pd=2.4 ps=1.85
XM0 X#1 a_83_270# VPWR#5 VPB sky130_fd_pr__pfet_01v8 l=0.15 w=1.12 ad=0.3304 as=0.9424 pd=2.83 ps=4.14
XM2 VPWR#5 B1#1 a_83_270##4 VPB sky130_fd_pr__pfet_01v8 l=0.15 w=0.84 ad=0.9424 as=0.40165 pd=4.14 ps=3.01
XM9 a_83_270##4 A4#1 a_443_368# VPB sky130_fd_pr__pfet_01v8 l=0.15 w=1.12 ad=0.40165 as=0.3024 pd=3.01 ps=2.78
XM5 a_443_368# A3#3 a_527_368# VPB sky130_fd_pr__pfet_01v8 l=0.15 w=1.12 ad=0.3024 as=0.4704 pd=2.78 ps=3.08
XM6 a_527_368# A2#1 a_641_368# VPB sky130_fd_pr__pfet_01v8 l=0.15 w=1.12 ad=0.4704 as=0.4704 pd=3.08 ps=3.08
XM7 a_641_368# A1#3 VPWR#1 VPB sky130_fd_pr__pfet_01v8 l=0.15 w=1.12 ad=0.4704 as=0.4592 pd=3.08 ps=3.06
*
*
*       RESISTOR AND CAP/DIODE CARDS
*
Rg1	a_83_270#	a_83_270##2	430.501160
Rg2	a_83_270##2	a_83_270##3	378.401642
Rg3	B1#1	B1#2	380.476135
Rg4	B1#2	B1#3	22.399879
Rg5	B1#2	B1#4	532.549561
Rg6	A4#1	A4#2	510.574768
Rg7	A4#2	A4#3	326.188721
Rg8	A3#1	A3#2	336.630798
Rg9	A3#2	A3#3	492.059540
Rg10	A2#1	A2#2	456.846832
Rg11	A2#2	A2#3	382.539764
Rg12	A1#1	A1#2	411.232849
Rg13	A1#2	A1#3	434.639221
Rf1	X	X#2	5.511418
Rf2	X#2	X	9.054472
Rf3	X	X#3	120.333145
Rf4	X#1	X#2	7.500000
Rf5	B1#5	B1	0.667014
Rf6	B1#3	B1#7	160.899811
Rf7	B1#5	B1#7	8.463963
Rf8	a_83_270##4	a_83_270##5	123.613869
Rf9	a_83_270##5	a_83_270##6	80.646202
Rf10	A4#2	A4#5	161.639359
Rf11	A4#6	A4	1.406553
Rf12	A4#5	A4#6	10.034923
Rf13	A3	A3#2	171.255646
Rf14	A2#2	A2	167.384872
Rf15	A1#2	A1#5	162.782639
Rf16	A1#6	A1	2.549838
Rf17	A1#5	A1#6	3.403765
Rf18	A1#7	A1	2.549838
Rf19	A1#6	A1#7	8.395953
Rf20	a_326_74#	a_326_74##2	97.663857
Rf21	a_326_74##2	a_326_74##3	83.826332
Rf22	a_326_74##2	a_326_74##4	14.016296
Rf23	VPWR#1	VPWR#2	152.573837
Rf24	VPWR#2	VPWR#3	79.416603
Rf26	VPWR#3	VPWR#5	9.993042
Rf28	VGND#2	VGND#3	95.968674
Rf29	VGND#2	VGND#4	25.751442
Rf30	VGND#3	VGND#5	103.310745
Rf32	VGND#3	VGND#7	35.446526
Rf33	VGND#5	VGND#8	26.517212
Rf35	a_83_270##2	a_83_270##5	160.232803
Re1	VPWR#2	VPWR	1.091357
Re2	VGND	VGND#3	1.091398
*
*       CAPACITOR CARDS
*
*
C1	a_326_74##2	a_326_74#	1.97028e-18
C2	a_326_74##2	a_326_74##4	3.01337e-18
C3	a_326_74##2	VGND#7	4.83437e-17
C4	a_326_74#	A1#5	3.50613e-17
C5	a_326_74##3	a_326_74##2	2.65318e-18
C6	A1#6	VPWR#1	6.0339e-20
C7	A4#5	VGND#7	1.5931e-19
C8	A4#5	a_326_74##3	4.60032e-17
C9	a_83_270##6	A4#5	6.48384e-18
C10	a_326_74#	VGND#4	5.06156e-19
C11	a_326_74##2	A1#1	8.75621e-19
C12	a_326_74##2	A2#3	2.5638e-17
C13	A4#6	a_83_270##4	3.03538e-17
C14	a_326_74##2	A3#1	3.75139e-17
C15	a_326_74##3	VGND#7	4.81772e-17
C16	a_326_74##2	A4#3	7.78741e-19
C17	a_326_74#	VPWR#1	1.88667e-19
C18	a_83_270##6	a_326_74##3	6.67944e-17
C19	VGND#8	VGND#7	6.01456e-19
C20	VGND#8	a_83_270##6	4.56154e-17
C21	X#3	a_83_270##6	2.29229e-18
C22	X#3	VGND#8	5.34762e-17
C23	A1#6	A1#3	3.31924e-18
C24	a_326_74#	A1#1	5.06548e-17
C25	A4#5	B1#4	1.22058e-18
C26	a_326_74##3	a_83_270##4	6.4522e-18
C27	A1#6	A2#1	9.75174e-19
C28	A1#1	VGND#4	9.97312e-18
C29	a_326_74#	A2#3	8.78179e-19
C30	A2#3	VGND#4	1.82358e-17
C31	a_326_74#	A3#1	1.61743e-19
C32	A2#3	a_326_74##4	3.65725e-18
C33	VGND#7	A2#3	1.14187e-18
C34	A3#1	a_326_74##4	1.46426e-17
C35	A3#1	VGND#7	2.13071e-17
C36	a_83_270##6	A2#3	3.78789e-19
C37	A4#6	A3#3	1.23066e-18
C38	a_326_74##3	A3#1	5.46317e-19
C39	A4#3	VGND#7	2.31976e-17
C40	a_83_270##6	A3#1	4.42636e-19
C41	a_326_74##3	A4#3	5.21838e-17
C42	A4#6	A4#1	1.03214e-17
C43	VGND#7	B1#4	1.24002e-18
C44	VGND#8	A3#1	1.6208e-19
C45	a_83_270##6	A4#3	2.49382e-18
C46	a_326_74##3	B1#4	1.37091e-17
C47	VGND#7	a_83_270##3	3.94766e-19
C48	VGND#8	A4#3	4.86195e-19
C49	a_83_270##4	VPWR#5	2.38926e-19
C50	a_83_270##6	B1#4	5.43973e-17
C51	VGND#8	B1#4	3.30842e-18
C52	a_83_270##6	a_83_270##3	2.23782e-18
C53	VGND#3	a_326_74##2	8.76448e-18
C54	X#3	B1#4	6.07564e-19
C55	VGND#8	a_83_270##3	4.62107e-17
C56	X#3	a_83_270##3	2.18075e-17
C57	A4#6	VPWR#2	8.54158e-19
C58	A1#6	A1#2	1.04203e-17
C59	a_326_74##2	A2#2	2.36225e-18
C60	A1#5	A1#2	1.61569e-17
C61	A2#3	A1#1	1.25978e-17
C62	A1#6	A2#2	1.75278e-18
C63	VPWR#1	A1#3	4.67469e-17
C64	a_326_74##2	A3#2	3.45544e-18
C65	A1#5	A2#2	3.79834e-18
C66	VPWR#1	A2#1	7.88071e-18
C67	A3#1	A2#3	2.56463e-17
C68	A4#5	A1#2	4.5873e-19
C69	VPWR#1	A3#3	1.02506e-18
C70	VPWR#1	A4#1	4.80152e-19
C71	A4#3	A3#1	1.981e-17
C72	A4#6	A3#2	1.59336e-18
C73	VPWR#1	B1#1	3.56102e-19
C74	A4#5	A3#2	3.14748e-18
C75	a_83_270##4	A3#3	5.13558e-18
C76	B1#4	A4#3	2.96994e-17
C77	a_326_74#	A1#2	1.96021e-18
C78	A4#6	A4#2	4.68679e-18
C79	a_83_270##4	A4#1	6.09338e-17
C80	A4#5	A4#2	1.45327e-17
C81	VGND#3	a_326_74##3	2.09511e-17
C82	a_83_270##3	B1#4	4.28736e-18
C83	B1#3	A4#6	1.80466e-17
C84	a_83_270##4	B1#1	3.06218e-17
C85	X#1	A4#1	6.66807e-20
C86	VPWR#2	VPWR#1	5.02857e-17
C87	B1#1	VPWR#5	2.79279e-17
C88	B1#3	A4#5	1.06611e-17
C89	a_83_270##4	a_83_270#	1.98219e-19
C90	X#1	B1#1	5.34317e-19
C91	a_83_270#	VPWR#5	3.55978e-17
C92	a_83_270##2	A4#5	2.35804e-18
C93	X#1	a_83_270#	2.42989e-17
C94	a_83_270##6	A2#2	1.50023e-20
C95	A1#6	a_641_368#	9.46047e-20
C96	VGND#7	A3#2	4.19027e-19
C97	A1#2	VPWR#1	1.22914e-18
C98	a_83_270##4	VPWR#2	8.50672e-18
C99	a_83_270##6	A3#2	4.0537e-19
C100	VGND#7	A4#2	4.07563e-19
C101	VPWR#1	A2#2	1.21662e-19
C102	a_326_74##3	A4#2	3.49525e-18
C103	A2#1	A1#3	2.94326e-17
C104	a_83_270##6	A4#2	1.7999e-18
C105	a_326_74##3	B1#3	1.10777e-18
C106	a_83_270##6	B1#3	2.98516e-17
C107	A3#3	A2#1	3.01048e-17
C108	X#3	B1#3	3.58581e-20
C109	VGND#3	A3#1	2.73101e-18
C110	a_83_270##6	a_83_270##2	2.73453e-18
C111	A4#1	A3#3	5.95393e-17
C112	VGND#8	a_83_270##2	3.84782e-17
C113	VGND#3	A4#3	2.71641e-18
C114	A2#2	A1#1	6.04452e-19
C115	X#3	a_83_270##2	4.89534e-17
C116	a_83_270##4	A4#2	1.11476e-18
C117	VGND#3	B1#4	6.05203e-18
C118	B1#1	A4#1	2.88151e-17
C119	B1#3	a_83_270##4	3.63682e-17
C120	A3#2	A2#3	1.79878e-18
C121	a_83_270#	A4#1	2.74779e-19
C122	VPWR#2	A2#1	4.0013e-18
C123	A4#3	A3#2	2.46058e-18
C124	a_83_270#	B1#1	3.76579e-18
C125	VPWR#2	A3#3	6.1515e-18
C126	a_83_270##2	VPWR#5	4.0345e-18
C127	VPWR#2	A4#1	8.16512e-18
C128	A2#1	A1#2	6.62157e-19
C129	B1#4	A4#2	6.40059e-18
C130	A3#3	A2#2	1.14784e-18
C131	a_326_74##2	A2	2.50795e-17
C132	a_83_270##2	a_83_270##3	3.26672e-18
C133	A4#1	A3#2	5.15207e-18
C134	A2	A1#6	1.70943e-17
C135	A2	A1#5	1.74505e-17
C136	a_326_74##2	A3	3.46908e-17
C137	B1#3	A4#1	1.52336e-17
C138	a_83_270##2	A3#3	5.30968e-20
C139	a_83_270##6	B1	2.1499e-17
C140	VPWR#2	A3#2	1.07013e-19
C141	a_83_270##2	A4#1	9.18343e-20
C142	a_83_270#	B1#3	2.77283e-18
C143	A1#3	a_641_368#	1.00989e-17
C144	A2#2	A1#2	2.71123e-17
C145	VGND#3	A3#2	9.28339e-20
C146	VPWR#2	A4#2	1.2253e-19
C147	A4#6	A3	2.73606e-17
C148	A2#1	a_641_368#	2.83944e-17
C149	a_83_270##2	a_83_270#	1.50088e-17
C150	A4#5	A3	2.23169e-17
C151	VGND#3	A4#2	1.11114e-19
C152	A2#1	a_527_368#	2.84609e-17
C153	B1	a_83_270##4	9.20792e-18
C154	A3#2	A2#2	2.92984e-17
C155	A1	VPWR#1	4.46169e-17
C156	VGND#3	B1#3	5.83217e-19
C157	A3#3	a_527_368#	2.83188e-17
C158	A3#3	a_443_368#	2.23115e-17
C159	A4#2	A3#2	2.46881e-17
C160	A3	a_326_74##4	6.323e-19
C161	A2	VPWR#1	3.38887e-17
C162	A3	VGND#7	3.22958e-19
C163	A4#1	a_443_368#	1.74212e-18
C164	B1#3	A4#2	2.2684e-17
C165	a_83_270##2	A4#2	2.08276e-19
C166	A2#2	a_641_368#	2.22589e-19
C167	a_83_270##2	B1#3	1.37236e-17
C168	a_83_270##4	A3	4.07605e-17
C169	A1	A1#3	1.26785e-17
C170	VPWR	A4#6	5.95501e-18
C171	A1	A2#1	2.82936e-18
C172	B1	a_83_270#	6.83526e-19
C173	A2	A1#3	1.65887e-17
C174	X#3	X	2.2382e-18
C175	A2	A2#1	4.03391e-17
C176	VGND	a_326_74##2	2.06705e-17
C177	A2	A3#3	5.88e-18
C178	VGND	A1#5	6.10845e-18
C179	X	a_83_270##4	3.29473e-19
C180	A3	A2#1	8.13812e-18
C181	VGND	A4#5	3.65983e-18
C182	X	X#1	8.14896e-18
C183	A3	A3#3	3.39936e-17
C184	A3	A4#1	1.24037e-17
C185	VPWR	VPWR#1	6.28511e-17
C186	A2	VPWR#2	8.07448e-18
C187	A3	B1#1	3.8481e-19
C188	VGND	a_326_74#	1.80935e-17
C189	A3	a_83_270#	6.76485e-20
C190	VPWR	a_83_270##4	1.71273e-17
C191	B1	B1#3	6.21153e-18
C192	A2	A1#2	4.60564e-18
C193	VGND	VGND#7	1.81902e-17
C194	VGND	a_326_74##3	1.76618e-17
C195	VPWR	X#1	1.59224e-17
C196	A3	VPWR#2	1.64475e-17
C197	A2	A2#2	2.04745e-17
C198	a_83_270##2	B1	3.75924e-17
C199	VGND	a_83_270##6	1.8046e-17
C200	VGND	VGND#8	2.45376e-17
C201	A2	A3#2	4.23418e-18
C202	VGND	X#3	1.63708e-17
C203	A3	A1#2	7.97354e-19
C204	A3	A2#2	4.89781e-18
C205	X	A4#1	7.01272e-20
C206	X	B1#1	1.55072e-19
C207	A3	A3#2	2.09609e-17
C208	X	a_83_270#	1.61547e-17
C209	VPWR	A1#3	6.46492e-19
C210	A3	A4#2	3.30216e-18
C211	A1	a_641_368#	5.11131e-18
C212	VGND	A1#1	5.53015e-19
C213	VPWR	A2#1	2.52127e-19
C214	VGND	A2#3	4.39911e-19
C215	A3	B1#3	2.22908e-19
C216	VPWR	A3#3	5.67664e-19
C217	VGND	A3#1	7.75414e-20
C218	VPWR	A4#1	2.79522e-18
C219	VGND	A4#3	3.20368e-19
C220	a_83_270##2	A3	9.78952e-19
C221	A2	a_641_368#	8.01784e-18
C222	VGND	B1#4	2.79822e-18
C223	VPWR	B1#1	4.41526e-18
C224	a_326_74##2	VNB	1.82625e-17
C225	VGND	a_83_270##3	2.3383e-18
C226	VPWR	a_83_270#	2.39528e-18
C227	A2	a_527_368#	7.64812e-18
C228	A1#6	VNB	1.26889e-17
C229	A1#5	VNB	1.35866e-17
C230	VPWR	VPWR#2	3.9276e-17
C231	A4#6	VNB	2.78597e-18
C232	A4#5	VNB	6.00921e-19
C233	A3	a_527_368#	8.36394e-18
C234	A3	a_443_368#	3.01564e-19
C235	a_326_74#	VNB	4.44317e-17
C236	X	a_83_270##2	5.25706e-17
C237	VGND#7	VNB	4.23292e-18
C238	a_326_74##3	VNB	8.58352e-18
C239	a_83_270##6	VNB	1.56972e-17
C240	VGND#8	VNB	9.3682e-18
C241	VGND	VGND#3	3.05353e-17
C242	VPWR	B1#3	1.43315e-18
C243	X#3	VNB	6.02355e-17
C244	VPWR#1	VNB	7.9497e-17
C245	VPWR	a_83_270##2	6.39164e-18
C246	A2	A1	2.78799e-17
C247	a_83_270##4	VNB	4.05553e-18
C248	X#1	VNB	2.53861e-17
C249	A1#1	VNB	3.80876e-17
C250	A2#3	VNB	2.67494e-17
C251	VGND	B1#3	2.60197e-18
C252	A3#1	VNB	2.72058e-17
C253	A4#3	VNB	3.04407e-17
C254	VGND	a_83_270##2	4.7532e-18
C255	A3	A2	1.26147e-16
C256	B1#4	VNB	3.87059e-17
C257	a_83_270##3	VNB	4.04354e-17
C258	A1#3	VNB	3.82234e-17
C259	A2#1	VNB	3.41391e-17
C260	A3#3	VNB	3.49435e-17
C261	A4#1	VNB	4.46463e-17
C262	B1#1	VNB	3.11273e-17
C263	VPWR	B1	1.20856e-18
C264	a_83_270#	VNB	4.42095e-17
C265	VPWR#2	VNB	2.26653e-16
C266	VPWR	A1	7.56316e-18
C267	VGND#3	VNB	2.26735e-16
C268	A1#2	VNB	4.72449e-17
C269	VPWR	A2	1.71011e-17
C270	A2#2	VNB	3.733e-17
C271	VGND	B1	1.29148e-18
C272	A3#2	VNB	2.94286e-17
C273	A4#2	VNB	3.3466e-17
C274	VPWR	A3	1.59824e-17
C275	B1#3	VNB	6.71153e-17
C276	a_83_270##2	VNB	4.96591e-17
C277	VGND	A2	5.19575e-18
C278	VGND	A3	5.02628e-18
C279	B1	VNB	3.11194e-18
C280	A1	VNB	1.4508e-17
C281	A2	VNB	1.03608e-17
C282	A3	VNB	3.79511e-18
C283	X	VNB	3.20934e-17
C284	VPWR	VNB	7.12449e-17
C285	VGND	VNB	7.13939e-17
C286	VGND#2	VNB	5.83708e-17
C287	VGND	VGND#2	6.46502e-17
C288	VGND#2	a_326_74##2	6.47123e-17
C289	VGND#2	A2#2	8.87317e-19
C290	VGND#2	A1#2	6.56009e-19
C291	VGND#3	VGND#2	6.5059e-17
C292	VGND#2	A4#3	3.29049e-19
C293	VGND#2	A3#1	2.14937e-18
C294	VGND#2	A2#3	1.90295e-17
C295	VGND#2	A1#1	1.69522e-17
C296	VGND#7	VGND#2	1.68112e-18
C297	VGND#2	VGND#4	6.89776e-18
C298	VGND#2	a_326_74#	7.76196e-17
C299	VGND#5	VNB	6.0419e-17
C300	VGND	VGND#5	4.35266e-17
C301	VGND#5	X#3	1.81076e-17
C302	VGND#5	a_83_270##6	2.13031e-17
C303	VPWR#3	A3	2.72168e-18
C304	VGND#5	VGND#7	1.12155e-19
C305	VPWR#3	A1#3	6.1804e-19
C306	VPWR#3	B1#3	2.26713e-18
C307	VGND#5	a_83_270##2	4.3417e-19
C308	VPWR#3	A2#1	5.86873e-19
C309	X	VPWR#3	1.45408e-17
C310	VGND#5	B1#3	9.74394e-20
C311	a_83_270##2	VPWR#3	5.50747e-17
C312	VPWR#3	A3#3	1.12678e-18
C313	VPWR	VPWR#3	1.08857e-16
C314	a_83_270##4	VPWR#3	7.63192e-17
C315	VGND#3	VGND#5	6.49715e-17
C316	VPWR#3	A4#1	5.05837e-18
C317	VPWR#3	VPWR#5	2.45306e-17
C318	VPWR#3	a_641_368#	5.46175e-22
C319	VPWR#3	B1#1	3.84619e-17
C320	X#1	VPWR#3	6.97787e-17
C321	VPWR#3	a_83_270#	2.64001e-17
C322	VPWR#3	VNB	7.39682e-17
C323	VGND#5	a_83_270##3	4.19859e-18
C324	VGND#5	B1#4	1.91567e-18
C325	VPWR#2	VPWR#3	7.74958e-17
*
*
.ENDS sky130_fd_sc_hs__o41a_1
*
