* Extracted by Quantus, converted by sky130cad/quantus.py
*
*
*
*                       LINUX           Wed Nov 18 09:07:38 2026
*
*
*
*  PROGRAM  advgen
*
*  Name           : advgen - Quantus - (64-bit)
*  Version        : 25.1.0-p047
*  Build Date     : Thu Dec 11 23:20:30 PST 2025
*
*  HSPICE LIBRARY
*
*  OPERATING_TEMPERATURE 150
*  QRC_TECH_DIR <path>/tech
*
*
*

*
.SUBCKT sky130_fd_sc_hs__or4b_2 VNB VPB VGND VPWR X D_N A B C
*
*
*  caps2d version: 10
*
*
*       TRANSISTOR CARDS
*
*
XM10 a_27_368##7 D_N#1 VGND#9 VNB sky130_fd_pr__nfet_01v8_lvt l=0.15 w=0.55 ad=0.15675 as=0.25585 pd=1.67 ps=2.21
XM6 X#3 a_190_48##4 VGND#9 VNB sky130_fd_pr__nfet_01v8_lvt l=0.15 w=0.74 ad=0.2072 as=0.25585 pd=2.04 ps=2.21
XM8 VGND#8 a_190_48##5 X#3 VNB sky130_fd_pr__nfet_01v8_lvt l=0.15 w=0.74 ad=0.3066 as=0.2072 pd=2.36 ps=2.04
XM11 VGND#8 A#3 a_190_48##12 VNB sky130_fd_pr__nfet_01v8_lvt l=0.15 w=0.64 ad=0.3066 as=0.2816 pd=2.36 ps=2.16
XM3 a_190_48##12 B#1 VGND#7 VNB sky130_fd_pr__nfet_01v8_lvt l=0.15 w=0.64 ad=0.2816 as=0.3168 pd=2.16 ps=2.27
XM4 VGND#7 C#1 a_190_48##11 VNB sky130_fd_pr__nfet_01v8_lvt l=0.15 w=0.64 ad=0.3168 as=0.208 pd=2.27 ps=1.93
XM7 a_190_48##11 a_27_368# VGND#1 VNB sky130_fd_pr__nfet_01v8_lvt l=0.15 w=0.64 ad=0.208 as=0.2272 pd=1.93 ps=1.99
XM0 a_27_368##6 D_N#3 VPWR#4 VPB sky130_fd_pr__pfet_01v8 l=0.15 w=0.84 ad=0.2478 as=0.406 pd=2.27 ps=3.01
XM1 X#1 a_190_48##6 VPWR#4 VPB sky130_fd_pr__pfet_01v8 l=0.15 w=1.12 ad=0.336 as=0.406 pd=2.84 ps=3.01
XM9 VPWR#1 a_190_48# X#1 VPB sky130_fd_pr__pfet_01v8 l=0.15 w=1.12 ad=0.5768 as=0.336 pd=3.33 ps=2.84
XM13 VPWR#1 A#1 a_452_392# VPB sky130_fd_pr__pfet_01v8 l=0.15 w=1 ad=0.5768 as=0.27 pd=3.33 ps=2.54
XM2 a_452_392# B#3 a_536_392# VPB sky130_fd_pr__pfet_01v8 l=0.15 w=1 ad=0.27 as=0.36 pd=2.54 ps=2.72
XM12 a_536_392# C#3 a_638_392# VPB sky130_fd_pr__pfet_01v8 l=0.15 w=1 ad=0.36 as=0.39 pd=2.72 ps=2.78
XM5 a_638_392# a_27_368##3 a_190_48##7 VPB sky130_fd_pr__pfet_01v8 l=0.15 w=1 ad=0.39 as=0.445 pd=2.78 ps=2.89
*
*
*       RESISTOR AND CAP/DIODE CARDS
*
Rg1	D_N#1	D_N#2	324.343445
Rg2	D_N#2	D_N#3	353.541870
Rg3	a_190_48#	a_190_48##2	449.793182
Rg4	a_190_48##2	a_190_48##3	183.302246
Rg5	a_190_48##3	a_190_48##4	343.439178
Rg6	a_190_48##2	a_190_48##5	346.792999
Rg7	a_190_48##3	a_190_48##6	525.154541
Rg8	A#1	A#2	453.277618
Rg9	A#2	A#3	353.846649
Rg10	B#1	B#2	422.710083
Rg11	B#2	B#3	400.207520
Rg12	C#1	C#2	422.710083
Rg13	C#2	C#3	400.207520
Rg14	a_27_368#	a_27_368##2	405.494232
Rg15	a_27_368##2	a_27_368##3	413.532104
Rf1	D_N#4	D_N#2	162.448425
Rf2	D_N	D_N#6	2.215620
Rf3	D_N#4	D_N#6	4.635897
Rf4	X	X#2	1.764915
Rf5	X#2	X#3	84.890915
Rf6	X#1	X#2	15.000000
Rf7	A	A#2	166.137894
Rf8	B	B#2	161.413818
Rf9	C	C#2	161.349457
Rf10	a_27_368##2	a_27_368##5	460.031250
Rf11	a_27_368##5	a_27_368##6	19.843185
Rf12	a_27_368##5	a_27_368##7	118.751755
Rf13	a_190_48##7	a_190_48##8	121.884636
Rf14	a_190_48##8	a_190_48##9	87.555710
Rf15	a_190_48##9	a_190_48##2	229.973358
Rf16	a_190_48##8	a_190_48##11	14.213133
Rf17	a_190_48##9	a_190_48##12	14.213133
Rf18	VGND#1	VGND#2	115.112930
Rf19	VGND#2	VGND#3	57.285812
Rf20	VGND#3	VGND#4	27.333216
Rf21	VGND#4	VGND#5	74.483604
Rf23	VGND#2	VGND#7	28.495510
Rf24	VGND#4	VGND#8	31.583847
Rf25	VGND#5	VGND#9	41.120300
Rf26	VPWR#1	VPWR#2	26.941650
Rf27	VPWR#2	VPWR#3	102.684464
Rf28	VPWR#3	VPWR#4	33.326477
Re1	VPWR#2	VPWR	1.091357
Re2	VGND	VGND#3	1.091398
*
*       CAPACITOR CARDS
*
*
C1	VGND#2	VGND#1	1.01617e-18
C2	X#3	a_190_48##3	5.9259e-18
C3	VGND#4	VGND#7	3.57001e-19
C4	a_190_48##8	VGND#1	7.90412e-17
C5	a_190_48##8	a_190_48##11	3.12121e-18
C6	VGND#4	X#3	8.80135e-18
C7	a_190_48##9	VGND#7	5.25198e-17
C8	a_27_368##7	a_190_48##3	3.62098e-18
C9	a_190_48##8	VGND#7	5.65947e-17
C10	a_190_48##9	a_190_48##12	1.50793e-17
C11	a_190_48##9	VGND#8	4.04077e-17
C12	X#3	a_190_48##9	2.48412e-18
C13	a_190_48##8	a_190_48##7	3.29127e-18
C14	VGND#7	VGND#1	5.04041e-18
C15	VGND#4	a_190_48##3	1.20425e-20
C16	a_190_48##3	a_190_48##2	1.2866e-17
C17	VGND#8	VGND#7	4.43466e-18
C18	VGND#2	a_27_368#	1.60288e-18
C19	a_27_368##7	D_N#4	4.72301e-17
C20	a_190_48##9	a_27_368##6	4.24854e-18
C21	VGND#2	C#1	7.94874e-19
C22	a_190_48##9	a_27_368#	3.55335e-19
C23	D_N#2	a_190_48##3	1.3211e-17
C24	VGND#2	B#1	1.02866e-18
C25	X#3	VGND#8	4.61614e-17
C26	a_190_48##8	a_27_368#	3.86267e-17
C27	a_190_48##9	C#1	6.83714e-19
C28	VGND#9	VGND#8	1.28227e-18
C29	a_190_48##8	C#1	2.81233e-17
C30	VGND#4	a_190_48##5	6.85359e-18
C31	VGND#9	X#3	5.00184e-17
C32	a_190_48##9	B#1	3.1572e-17
C33	a_190_48##8	B#1	2.07642e-18
C34	a_27_368##7	X#3	3.99119e-17
C35	VGND#4	a_190_48##4	4.94607e-19
C36	a_190_48##9	A#3	2.90051e-17
C37	a_27_368##7	VGND#9	5.45868e-17
C38	a_190_48##8	A#3	2.42788e-19
C39	a_190_48##9	a_190_48##5	7.25515e-19
C40	a_190_48##8	a_190_48##5	1.17496e-20
C41	a_27_368##6	a_190_48##3	3.06802e-18
C42	D_N#4	a_27_368##6	1.3283e-17
C43	a_27_368#	VGND#1	2.04943e-17
C44	a_27_368#	a_190_48##11	1.45841e-17
C45	VGND#1	C#1	1.3335e-18
C46	VGND#7	a_27_368#	2.38831e-18
C47	C#1	a_190_48##11	3.34305e-18
C48	VGND#1	B#1	3.36217e-19
C49	a_190_48##7	VPWR#1	2.67554e-17
C50	C#1	VGND#7	2.632e-17
C51	VGND#7	B#1	3.37142e-17
C52	B#1	a_190_48##12	7.18743e-18
C53	a_27_368##7	a_27_368##6	1.36868e-18
C54	VGND#7	A#3	1.08532e-18
C55	VGND#8	B#1	1.0457e-18
C56	A#3	a_190_48##12	1.04792e-17
C57	VGND#7	a_190_48##5	7.02835e-19
C58	X#3	B#1	1.97079e-19
C59	VGND#8	A#3	3.94237e-17
C60	X#3	A#3	9.59465e-19
C61	a_190_48##5	VGND#8	1.72563e-17
C62	VGND#9	A#3	1.62849e-19
C63	VPWR#4	VPWR#1	9.73704e-18
C64	X#3	a_190_48##5	4.23844e-17
C65	VGND#8	a_190_48##4	8.25741e-19
C66	a_27_368##6	VPWR#1	7.3999e-17
C67	VGND#9	a_190_48##5	4.12717e-19
C68	X#3	a_190_48##4	3.81227e-17
C69	a_27_368##6	X#1	4.1099e-18
C70	a_190_48##4	VGND#9	1.77473e-17
C71	X#3	D_N#1	2.36641e-18
C72	a_27_368##6	VPWR#4	5.65761e-17
C73	a_27_368##7	a_190_48##4	5.64873e-18
C74	D_N#1	VGND#9	2.13908e-17
C75	a_27_368##7	D_N#1	4.15816e-17
C76	VGND#3	VGND#4	3.29779e-17
C77	VGND#3	VGND#2	5.30043e-17
C78	C#1	a_27_368#	3.04755e-17
C79	VGND#3	a_190_48##9	1.15465e-17
C80	VGND#2	a_27_368##2	5.07583e-20
C81	a_190_48##7	a_27_368##3	2.05135e-17
C82	a_190_48##7	C#3	1.53146e-18
C83	B#1	C#1	1.71232e-17
C84	a_190_48##9	a_27_368##2	1.27084e-18
C85	a_190_48##8	a_27_368##2	7.28709e-17
C86	a_190_48##7	B#3	6.96929e-19
C87	VPWR#1	a_27_368##3	5.01876e-18
C88	A#3	B#1	1.88026e-17
C89	VGND#2	B#2	3.45776e-20
C90	a_190_48##7	A#1	4.33197e-19
C91	a_190_48##8	C#2	2.98199e-18
C92	VPWR#1	C#3	7.97405e-18
C93	a_190_48##9	B#2	2.81141e-18
C94	a_190_48##5	A#3	2.01764e-17
C95	a_190_48##8	B#2	2.85809e-19
C96	VPWR#1	B#3	9.63873e-18
C97	a_27_368##6	a_27_368##3	3.58936e-19
C98	VGND#3	VGND#1	2.62568e-17
C99	VGND#4	a_190_48##2	4.77664e-19
C100	VPWR#1	A#1	4.38461e-17
C101	a_190_48##9	A#2	3.12232e-18
C102	a_27_368##6	C#3	2.29472e-18
C103	VPWR#4	B#3	1.63349e-19
C104	a_190_48##4	a_190_48##5	3.85334e-17
C105	a_190_48##8	A#2	7.26619e-19
C106	D_N#1	a_190_48##3	7.19994e-19
C107	VGND#1	a_27_368##2	4.22651e-19
C108	VPWR#1	a_190_48#	4.22071e-17
C109	a_27_368##6	B#3	1.85125e-17
C110	VPWR#4	A#1	3.56848e-19
C111	a_190_48#	X#1	2.59374e-17
C112	D_N#1	a_190_48##4	2.42475e-17
C113	a_27_368##6	A#1	2.10526e-17
C114	a_190_48##2	a_190_48##8	1.63144e-18
C115	VPWR#1	a_190_48##6	4.33428e-18
C116	VPWR#4	a_190_48#	4.49849e-18
C117	a_190_48##6	X#1	2.59374e-17
C118	a_27_368##6	a_190_48#	2.78455e-17
C119	VGND#7	C#2	7.28831e-19
C120	VPWR#4	a_190_48##6	3.61274e-17
C121	a_27_368##6	a_190_48##6	3.11719e-17
C122	D_N	a_190_48##3	1.00869e-19
C123	D_N#3	VPWR#4	2.63864e-17
C124	VGND#7	B#2	5.36624e-19
C125	a_27_368##6	D_N#3	5.5479e-17
C126	a_27_368##2	a_190_48##7	1.13389e-16
C127	VPWR#2	VPWR#1	1.2694e-16
C128	C#3	a_27_368##3	3.00815e-17
C129	D_N#4	D_N#2	1.43041e-17
C130	X#3	A#2	1.11627e-21
C131	a_27_368##2	VPWR#1	2.9668e-17
C132	X	a_190_48##3	8.62253e-18
C133	a_190_48##2	VGND#8	2.71671e-17
C134	B#3	C#3	3.08293e-17
C135	VPWR#1	C#2	7.32638e-20
C136	X#3	a_190_48##2	3.96639e-17
C137	a_27_368##6	a_27_368##2	1.39892e-18
C138	VPWR#1	B#2	5.0071e-20
C139	VGND#3	B#1	3.49357e-20
C140	VGND#4	VGND#2	9.81753e-19
C141	A#1	B#3	5.07555e-17
C142	X#3	D_N#2	2.70785e-19
C143	C#1	a_27_368##2	6.47441e-19
C144	VGND#3	A#3	1.67928e-18
C145	VPWR#1	A#2	4.62841e-19
C146	a_27_368##7	D_N#2	8.29223e-18
C147	a_190_48#	A#1	1.89067e-17
C148	a_190_48##2	VPWR#1	1.97586e-18
C149	a_27_368##6	A#2	4.3648e-19
C150	a_190_48##6	a_190_48#	5.02104e-17
C151	D_N#4	a_190_48##3	8.09408e-19
C152	a_190_48##2	a_27_368##6	1.04404e-17
C153	A#2	B#1	2.00117e-18
C154	a_190_48##2	a_27_368#	5.37441e-20
C155	a_27_368##2	a_27_368##3	2.44956e-17
C156	a_190_48##2	C#1	8.6244e-20
C157	D_N#3	a_190_48##6	2.59839e-17
C158	D_N#2	a_27_368##6	8.20759e-18
C159	a_190_48##2	B#1	2.13474e-19
C160	a_27_368##2	C#3	2.51936e-17
C161	C#2	a_27_368##3	4.48397e-19
C162	a_190_48##2	A#3	1.09578e-18
C163	a_190_48##8	C	2.07144e-17
C164	a_27_368##2	B#3	9.74741e-18
C165	a_190_48##2	a_190_48##5	3.6518e-18
C166	a_27_368##2	A#1	1.05168e-19
C167	a_190_48##2	a_190_48##4	3.3227e-20
C168	VGND	a_190_48##3	2.80043e-19
C169	a_190_48##9	B	2.0817e-17
C170	VGND#2	a_190_48##9	2.45745e-18
C171	A#1	B#2	3.14743e-18
C172	a_190_48##9	A	3.06614e-17
C173	a_27_368##6	a_452_392#	1.21425e-17
C174	a_190_48#	A#2	1.91981e-18
C175	VGND#2	a_190_48##8	1.26197e-17
C176	a_190_48##6	a_190_48##2	4.21342e-18
C177	a_27_368##3	a_638_392#	2.48534e-17
C178	C#3	a_638_392#	2.04861e-17
C179	C#2	a_27_368##2	4.46056e-17
C180	D_N#2	a_190_48##6	3.60033e-18
C181	a_27_368##2	B#2	1.00648e-18
C182	VGND#3	A#2	7.68486e-20
C183	C#3	a_536_392#	2.30772e-17
C184	C	X#1	7.94172e-21
C185	B#3	a_536_392#	1.48293e-17
C186	B#2	C#2	3.08125e-17
C187	a_27_368##6	C	1.18743e-17
C188	a_190_48##2	a_27_368##2	1.20294e-19
C189	B#3	a_452_392#	1.1082e-17
C190	A#2	B#2	3.73139e-17
C191	a_190_48##2	C#2	1.44435e-19
C192	A#1	a_452_392#	1.62039e-17
C193	B	a_27_368##6	3.76987e-18
C194	a_190_48##2	A#2	3.16203e-17
C195	a_27_368##2	a_638_392#	7.79036e-18
C196	A	a_27_368##6	3.52358e-17
C197	a_190_48##9	a_190_48##8	2.11408e-18
C198	C	a_27_368##3	8.05854e-18
C199	C#2	a_638_392#	4.79166e-19
C200	a_190_48##3	VNB	2.16567e-17
C201	C	C#3	1.93596e-17
C202	a_27_368##2	a_536_392#	7.36122e-18
C203	X#3	X	2.87056e-18
C204	C	B#3	5.66447e-18
C205	a_27_368##7	X	5.28857e-18
C206	C	A#1	1.27851e-18
C207	D_N	a_27_368##6	5.84351e-17
C208	VGND	VGND#4	4.7114e-17
C209	VGND	VGND#2	2.92569e-17
C210	C	a_190_48#	3.14925e-19
C211	B#2	a_536_392#	3.93943e-19
C212	B	C#3	2.53752e-18
C213	B	B#3	1.02543e-17
C214	C	a_190_48##6	2.11871e-19
C215	VGND	a_190_48##9	1.86306e-17
C216	VGND	a_190_48##8	1.99138e-17
C217	B	A#1	3.11171e-18
C218	X	X#1	2.54201e-19
C219	a_27_368##6	X	1.00619e-16
C220	VPWR	a_190_48##7	1.86224e-17
C221	A	B#3	2.31422e-18
C222	A	A#1	1.24247e-17
C223	VGND	D_N#4	4.47333e-18
C224	VGND	VGND#1	4.08808e-17
C225	A	a_190_48#	4.02584e-18
C226	VPWR	VPWR#1	1.08296e-16
C227	C	a_27_368##2	1.25061e-16
C228	VGND	VGND#7	3.14402e-17
C229	A	a_190_48##6	2.63811e-19
C230	VPWR	VPWR#4	1.63035e-17
C231	C	C#2	1.77864e-17
C232	VPWR	a_27_368##6	4.26454e-17
C233	VGND	X#3	1.70235e-17
C234	C	B#2	3.78945e-18
C235	B	a_27_368##2	5.01579e-18
C236	VGND	a_27_368##7	1.71161e-17
C237	VGND	a_190_48##7	8.03337e-19
C238	D_N	a_190_48##6	3.69217e-19
C239	B	C#2	2.76747e-18
C240	D_N	D_N#3	3.12587e-18
C241	B	B#2	1.73255e-17
C242	A	a_27_368##2	1.94446e-18
C243	X	A#1	2.10571e-18
C244	B	A#2	3.44087e-18
C245	X	a_190_48#	1.01457e-17
C246	A	C#2	8.72767e-19
C247	X	a_190_48##6	1.21382e-17
C248	VGND	a_27_368#	7.70783e-18
C249	VPWR	a_27_368##3	1.23866e-18
C250	A	B#2	6.36529e-18
C251	VGND	C#1	5.86767e-18
C252	X	D_N#3	1.14305e-18
C253	VPWR	C#3	1.03197e-18
C254	VGND	B#1	3.91178e-18
C255	A	A#2	1.94452e-17
C256	VPWR	B#3	9.33913e-19
C257	C	a_638_392#	3.43165e-18
C258	VGND	A#3	4.11639e-18
C259	VPWR	A#1	5.92344e-19
C260	VGND	a_190_48##5	1.55273e-18
C261	a_190_48##2	A	2.78907e-17
C262	VGND#4	VNB	2.6723e-17
C263	VGND#2	VNB	4.11627e-17
C264	VGND	a_190_48##4	4.26908e-18
C265	VPWR	a_190_48#	3.13312e-19
C266	C	a_536_392#	2.01491e-18
C267	VGND	D_N#1	7.23632e-18
C268	VPWR	a_190_48##6	3.5804e-19
C269	a_190_48##9	VNB	1.49063e-17
C270	a_190_48##8	VNB	4.23871e-17
C271	VPWR	D_N#3	6.43517e-18
C272	B	a_536_392#	1.3568e-18
C273	D_N	D_N#2	8.63712e-18
C274	B	a_452_392#	8.08769e-19
C275	D_N#4	VNB	1.54507e-17
C276	X	A#2	5.06709e-20
C277	VGND#1	VNB	6.07405e-17
C278	VPWR	a_27_368##2	2.94221e-17
C279	VGND#7	VNB	5.96591e-18
C280	X	a_190_48##2	3.29469e-17
C281	VGND#8	VNB	2.86939e-18
C282	A	a_452_392#	5.76735e-20
C283	X#3	VNB	2.44672e-18
C284	X	D_N#2	7.50434e-19
C285	VGND#9	VNB	7.17203e-18
C286	a_27_368##7	VNB	3.97681e-17
C287	a_190_48##7	VNB	6.5194e-17
C288	VGND	VGND#3	9.55004e-18
C289	VPWR	a_190_48##2	3.54991e-18
C290	B	C	5.67675e-17
C291	VPWR#1	VNB	1.06486e-16
C292	VGND	a_27_368##2	3.07388e-18
C293	VPWR#4	VNB	1.08301e-17
C294	a_27_368##6	VNB	5.32102e-17
C295	a_27_368#	VNB	3.97017e-17
C296	C#1	VNB	3.11076e-17
C297	B#1	VNB	3.06049e-17
C298	A#3	VNB	3.03696e-17
C299	a_190_48##5	VNB	2.8253e-17
C300	VGND	a_190_48##2	6.029e-18
C301	A	B	5.07424e-17
C302	a_190_48##4	VNB	3.09485e-17
C303	D_N#1	VNB	3.89023e-17
C304	a_27_368##3	VNB	3.40665e-17
C305	C#3	VNB	3.0182e-17
C306	B#3	VNB	2.95368e-17
C307	A#1	VNB	2.9206e-17
C308	a_190_48#	VNB	3.02738e-17
C309	a_190_48##6	VNB	4.06482e-17
C310	D_N#3	VNB	4.46269e-17
C311	VPWR	C	5.92547e-18
C312	VPWR#2	VNB	1.8592e-16
C313	X	A	1.46215e-17
C314	VGND#3	VNB	1.98604e-16
C315	VPWR	B	4.6996e-18
C316	a_27_368##2	VNB	5.7737e-17
C317	C#2	VNB	3.08081e-17
C318	B#2	VNB	3.32374e-17
C319	VGND	C	4.03291e-18
C320	VPWR	A	3.93267e-18
C321	A#2	VNB	2.99706e-17
C322	a_190_48##2	VNB	3.18302e-17
C323	VGND	B	3.80037e-18
C324	VPWR	D_N	2.95296e-18
C325	D_N#2	VNB	5.74175e-17
C326	VGND	A	3.63667e-18
C327	VPWR	X	3.84408e-18
C328	VGND	X	1.03451e-18
C329	C	VNB	4.62674e-18
C330	B	VNB	2.86821e-18
C331	A	VNB	4.35911e-18
C332	D_N	VNB	1.09593e-17
C333	X	VNB	3.1369e-20
C334	VPWR	VNB	6.51525e-17
C335	VGND	VNB	6.68868e-17
C336	VPWR#3	VNB	5.16084e-17
C337	VGND#3	VGND#5	5.33974e-17
C338	VGND#5	VGND#8	1.25784e-18
C339	VGND#5	D_N#2	1.51451e-19
C340	VPWR#2	VPWR#3	5.43747e-17
C341	VGND#5	VGND#4	1.29348e-18
C342	VPWR#3	VPWR#1	1.60305e-18
C343	VPWR#3	D_N#3	3.26744e-18
C344	VPWR#3	D_N#2	8.74503e-20
C345	VGND#5	a_190_48##5	8.96798e-19
C346	VGND#5	D_N#1	2.22259e-18
C347	VGND#5	D_N#4	5.97387e-19
C348	a_27_368##6	VPWR#3	1.14139e-17
C349	VPWR#3	a_190_48##3	4.11379e-20
C350	VGND#5	X#3	8.77902e-18
C351	VGND#5	a_27_368##7	1.12792e-17
C352	VPWR	VPWR#3	3.91713e-17
C353	VGND#5	a_190_48##3	4.06086e-20
C354	VPWR#3	a_190_48##6	3.98959e-18
C355	VGND#5	a_190_48##4	9.03247e-18
C356	VGND	VGND#5	5.22359e-17
C357	VPWR#3	a_190_48##2	5.69602e-21
C358	VGND#5	VNB	5.25885e-17
*
*
.ENDS sky130_fd_sc_hs__or4b_2
*
