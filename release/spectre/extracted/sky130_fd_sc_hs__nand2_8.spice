* Extracted by Quantus, converted by sky130cad/quantus.py
*
*
*
*                       LINUX           Wed Nov 18 08:45:05 2026
*
*
*
*  PROGRAM  advgen
*
*  Name           : advgen - Quantus - (64-bit)
*  Version        : 25.1.0-p047
*  Build Date     : Thu Dec 11 23:20:30 PST 2025
*
*  HSPICE LIBRARY
*
*  OPERATING_TEMPERATURE 150
*  QRC_TECH_DIR <path>/tech
*
*
*

*
.SUBCKT sky130_fd_sc_hs__nand2_8 VPB VNB VGND VPWR Y A B
*
*
*  caps2d version: 10
*
*
*       TRANSISTOR CARDS
*
*
XM16 VGND#11 B#22 a_27_74##13 VNB sky130_fd_pr__nfet_01v8_lvt l=0.15 w=0.74 ad=0.2072 as=0.2035 pd=2.04 ps=2.03
XM0 VGND#11 B#21 a_27_74##16 VNB sky130_fd_pr__nfet_01v8_lvt l=0.15 w=0.74 ad=0.2072 as=0.2072 pd=2.04 ps=2.04
XM10 a_27_74##16 B#19 VGND#10 VNB sky130_fd_pr__nfet_01v8_lvt l=0.15 w=0.74 ad=0.2072 as=0.2072 pd=2.04 ps=2.04
XM6 a_27_74##15 B#17 VGND#10 VNB sky130_fd_pr__nfet_01v8_lvt l=0.15 w=0.74 ad=0.2072 as=0.2072 pd=2.04 ps=2.04
XM5 VGND#9 B#13 a_27_74##15 VNB sky130_fd_pr__nfet_01v8_lvt l=0.15 w=0.74 ad=0.444 as=0.2072 pd=2.68 ps=2.04
XM3 a_27_74##14 B#9 VGND#9 VNB sky130_fd_pr__nfet_01v8_lvt l=0.15 w=0.74 ad=0.2368 as=0.444 pd=2.12 ps=2.68
XM17 VGND#8 B#8 a_27_74##14 VNB sky130_fd_pr__nfet_01v8_lvt l=0.15 w=0.74 ad=0.2072 as=0.2368 pd=2.04 ps=2.12
XM14 a_27_74##8 B#7 VGND#8 VNB sky130_fd_pr__nfet_01v8_lvt l=0.15 w=0.74 ad=0.2072 as=0.2072 pd=2.04 ps=2.04
XM20 a_27_74##8 A#20 Y#9 VNB sky130_fd_pr__nfet_01v8_lvt l=0.15 w=0.74 ad=0.2072 as=0.2072 pd=2.04 ps=2.04
XM4 Y#9 A#19 a_27_74##6 VNB sky130_fd_pr__nfet_01v8_lvt l=0.15 w=0.74 ad=0.2072 as=0.2072 pd=2.04 ps=2.04
XM22 Y#7 A#17 a_27_74##6 VNB sky130_fd_pr__nfet_01v8_lvt l=0.15 w=0.74 ad=0.2072 as=0.2072 pd=2.04 ps=2.04
XM9 Y#7 A#14 a_27_74##4 VNB sky130_fd_pr__nfet_01v8_lvt l=0.15 w=0.74 ad=0.2072 as=0.2072 pd=2.04 ps=2.04
XM1 Y#5 A#10 a_27_74##4 VNB sky130_fd_pr__nfet_01v8_lvt l=0.15 w=0.74 ad=0.2072 as=0.2072 pd=2.04 ps=2.04
XM11 a_27_74##2 A#8 Y#5 VNB sky130_fd_pr__nfet_01v8_lvt l=0.15 w=0.74 ad=0.4736 as=0.2072 pd=2.76 ps=2.04
XM7 a_27_74##2 A#6 Y#3 VNB sky130_fd_pr__nfet_01v8_lvt l=0.15 w=0.74 ad=0.4736 as=0.2072 pd=2.76 ps=2.04
XM18 a_27_74# A#5 Y#3 VNB sky130_fd_pr__nfet_01v8_lvt l=0.15 w=0.74 ad=0.19805 as=0.2072 pd=2.07 ps=2.04
XM2 Y#12 B#15 VPWR#13 VPB sky130_fd_pr__pfet_01v8 l=0.15 w=1.12 ad=0.392 as=1.4952 pd=2.94 ps=4.91
XM12 VPWR#12 B#14 Y#12 VPB sky130_fd_pr__pfet_01v8 l=0.15 w=1.12 ad=1.7808 as=0.392 pd=5.42 ps=2.94
XM13 VPWR#12 B#6 Y#14 VPB sky130_fd_pr__pfet_01v8 l=0.15 w=1.12 ad=1.7808 as=0.336 pd=5.42 ps=2.84
XM19 Y#14 B#1 VPWR#11 VPB sky130_fd_pr__pfet_01v8 l=0.15 w=1.12 ad=0.336 as=0.3864 pd=2.84 ps=2.93
XM15 VPWR#10 A#15 Y#13 VPB sky130_fd_pr__pfet_01v8 l=0.15 w=1.12 ad=0.3864 as=0.392 pd=2.93 ps=2.94
XM21 Y#13 A#11 VPWR#9 VPB sky130_fd_pr__pfet_01v8 l=0.15 w=1.12 ad=0.392 as=0.7616 pd=2.94 ps=3.6
XM23 Y#1 A#7 VPWR#9 VPB sky130_fd_pr__pfet_01v8 l=0.15 w=1.12 ad=0.336 as=0.7616 pd=2.84 ps=3.6
XM8 VPWR#1 A#1 Y#1 VPB sky130_fd_pr__pfet_01v8 l=0.15 w=1.12 ad=0.3248 as=0.336 pd=2.82 ps=2.84
*
*
*       RESISTOR AND CAP/DIODE CARDS
*
Rg1	B#1	B#2	599.066956
Rg2	B#2	B#3	244.338791
Rg3	B#3	B#4	70.426933
Rg4	B#4	B#5	71.600128
Rg5	B#2	B#6	385.612793
Rg6	B#3	B#7	369.205597
Rg7	B#4	B#8	372.817749
Rg8	B#5	B#9	373.790741
Rg9	B#5	B#10	63.259087
Rg10	B#10	B#11	47.879971
Rg11	B#11	B#12	55.577526
Rg12	B#12	B#13	271.021759
Rg13	B#10	B#14	401.671265
Rg14	B#11	B#15	430.490051
Rg15	B#12	B#16	120.941597
Rg16	B#16	B#17	262.702026
Rg17	B#16	B#18	210.494781
Rg18	B#18	B#19	262.702026
Rg19	B#18	B#20	210.494781
Rg20	B#20	B#21	262.702026
Rg21	B#20	B#22	473.208221
Rg22	A#1	A#2	507.075531
Rg23	A#2	A#3	61.439701
Rg24	A#3	A#4	154.455246
Rg25	A#2	A#5	322.953644
Rg26	A#3	A#6	365.484741
Rg27	A#3	A#7	454.433350
Rg28	A#4	A#8	329.607635
Rg29	A#4	A#9	66.003975
Rg30	A#9	A#10	288.256805
Rg31	A#4	A#11	486.547119
Rg32	A#9	A#12	26.861809
Rg33	A#12	A#13	42.440342
Rg34	A#13	A#14	277.694305
Rg35	A#12	A#15	398.671387
Rg36	A#13	A#16	113.518646
Rg37	A#16	A#17	272.954163
Rg38	A#16	A#18	204.871109
Rg39	A#18	A#19	262.702026
Rg40	A#18	A#20	473.208221
Rf1	B	B#5	32.992138
Rf2	A#4	A	25.494644
Rf3	Y#1	Y#2	21.895811
Rf4	Y#2	Y#4	116.133545
Rf5	Y#4	Y#6	56.113605
Rf6	Y#6	Y#8	39.555489
Rf7	Y#8	Y#10	40.141922
Rf8	Y#10	Y	12.971770
Rf9	Y	Y#11	29.115810
Rf10	Y#11	Y#12	171.038330
Rf11	Y#2	Y#13	111.018311
Rf12	Y#11	Y#14	19.353085
Rf13	Y#3	Y#4	15.000000
Rf14	Y#5	Y#6	15.000000
Rf15	Y#7	Y#8	15.000000
Rf16	Y#9	Y#10	15.000000
Rf17	a_27_74#	a_27_74##3	68.465027
Rf18	a_27_74##3	a_27_74##5	53.209217
Rf19	a_27_74##5	a_27_74##7	43.999928
Rf20	a_27_74##7	a_27_74##9	57.718800
Rf21	a_27_74##9	a_27_74##10	85.503166
Rf22	a_27_74##10	a_27_74##11	85.177933
Rf23	a_27_74##11	a_27_74##12	43.377888
Rf24	a_27_74##12	a_27_74##13	88.676796
Rf25	a_27_74##10	a_27_74##14	22.462166
Rf26	a_27_74##11	a_27_74##15	20.841503
Rf27	a_27_74##12	a_27_74##16	28.378750
Rf28	a_27_74##2	a_27_74##3	7.500000
Rf29	a_27_74##4	a_27_74##5	15.000000
Rf30	a_27_74##6	a_27_74##7	15.000000
Rf31	a_27_74##8	a_27_74##9	7.500000
Rf32	VPWR#1	VPWR#2	61.960464
Rf33	VPWR#2	VPWR#3	47.177364
Rf34	VPWR#3	VPWR#4	86.965347
Rf35	VPWR#4	VPWR#5	40.859211
Rf36	VPWR#5	VPWR#6	129.274841
Rf37	VPWR#6	VPWR#7	155.744339
Rf39	VPWR#3	VPWR#9	15.973221
Rf40	VPWR#4	VPWR#10	38.286041
Rf41	VPWR#5	VPWR#11	38.286041
Rf42	VPWR#6	VPWR#12	7.865284
Rf43	VPWR#7	VPWR#13	9.284714
Rf44	VGND#1	VGND#2	277.567352
Rf45	VGND#2	VGND#3	20.429605
Rf46	VGND#3	VGND#4	54.385895
Rf47	VGND#4	VGND#5	77.007011
Rf48	VGND#5	VGND#6	62.774361
Rf50	VGND#2	VGND#8	36.672695
Rf51	VGND#4	VGND#9	16.893320
Rf52	VGND#5	VGND#10	38.247387
Rf53	VGND#6	VGND#11	32.223660
Re1	VPWR#2	VPWR	4.549932
Re2	VPWR	VPWR#6	0.974985
Re3	VGND#1	VGND	4.549932
Re4	VGND	VGND#3	0.974985
*
*       CAPACITOR CARDS
*
*
C1	Y#11	A#11	5.68354e-20
C2	Y#11	Y#14	2.63961e-19
C3	Y#7	a_27_74##6	3.17138e-17
C4	Y#13	A#12	7.48015e-19
C5	VPWR#9	A#3	1.05994e-18
C6	VPWR#11	A#18	2.75034e-18
C7	VPWR#10	A#13	6.92062e-18
C8	a_27_74##8	a_27_74##4	2.61718e-20
C9	Y#2	A#11	4.38455e-19
C10	VPWR#5	B#1	2.73146e-18
C11	VPWR#11	A#16	7.51723e-18
C12	VGND#2	A#18	1.5603e-19
C13	VPWR#10	A#12	2.57521e-20
C14	a_27_74##6	Y#9	4.12298e-17
C15	Y#11	A#15	1.18174e-19
C16	VGND#4	VGND#2	1.00579e-18
C17	Y#11	VPWR#12	8.55079e-17
C18	VGND#2	a_27_74##6	3.7315e-17
C19	Y#2	A#15	2.8269e-19
C20	a_27_74##8	Y#9	4.9722e-17
C21	VGND#2	A#16	1.21579e-19
C22	Y#11	B#1	1.58074e-17
C23	VPWR#5	A#18	6.39507e-20
C24	a_27_74##8	VGND#8	5.19865e-17
C25	a_27_74##14	a_27_74##8	2.07579e-18
C26	a_27_74#	VPWR#1	1.85245e-18
C27	Y#11	B#6	3.05794e-17
C28	a_27_74##14	VGND#8	4.43528e-17
C29	Y#3	Y#2	1.56788e-18
C30	VPWR#5	A#16	2.03365e-19
C31	VGND#2	a_27_74##8	2.30718e-17
C32	VPWR#4	A#16	7.13941e-20
C33	VPWR#12	B#12	2.1788e-20
C34	Y#11	B#14	4.04685e-19
C35	a_27_74##15	a_27_74##14	1.40253e-18
C36	VGND#4	VGND#8	2.27761e-18
C37	B#12	Y#12	3.39873e-18
C38	Y#2	VPWR#3	1.6906e-19
C39	B#10	VPWR#12	4.89867e-19
C40	A#12	A#8	8.95034e-19
C41	B#4	VPWR#12	4.1768e-18
C42	VPWR#4	A#13	1.31589e-19
C43	B#2	Y#14	6.1851e-19
C44	B#10	Y#12	1.56606e-18
C45	B#3	VPWR#12	4.47812e-18
C46	VGND#10	a_27_74##15	4.45987e-17
C47	Y#12	B#4	1.15498e-18
C48	VGND#2	A#14	9.05268e-20
C49	B#2	VPWR#12	9.46691e-19
C50	a_27_74##16	a_27_74##15	1.91315e-18
C51	VGND#4	a_27_74##14	4.74128e-17
C52	a_27_74##16	VGND#10	4.39857e-17
C53	VPWR#4	A#12	3.89911e-20
C54	VGND#11	VGND#10	1.66094e-18
C55	Y#7	VPWR#11	6.10791e-18
C56	VPWR#2	VPWR#3	3.90826e-17
C57	VGND#11	a_27_74##16	4.90231e-17
C58	VGND#2	A#17	5.44433e-18
C59	VPWR#3	A#12	2.6514e-20
C60	VGND#4	VGND#9	1.01707e-17
C61	Y#9	VPWR#11	3.0269e-18
C62	a_27_74##10	a_27_74##8	1.90748e-19
C63	a_27_74#	A#5	3.29893e-17
C64	a_27_74##13	VGND#11	6.36049e-17
C65	Y#3	A#5	3.83893e-17
C66	VGND#5	a_27_74##15	7.48738e-18
C67	Y#3	A#6	3.89035e-17
C68	VGND#2	A#19	5.70052e-18
C69	Y#2	VPWR#2	5.75776e-18
C70	a_27_74##2	A#6	4.47424e-17
C71	VGND#4	a_27_74##15	5.25973e-17
C72	a_27_74##10	VGND#8	2.31191e-17
C73	VGND#5	a_27_74##12	2.27211e-19
C74	Y#3	A#8	1.58256e-19
C75	a_27_74##2	A#8	4.47111e-17
C76	Y#3	A#10	4.85825e-20
C77	Y#1	VPWR#1	6.09974e-17
C78	Y#5	A#8	3.81214e-17
C79	VPWR#9	VPWR#1	2.31427e-18
C80	a_27_74##11	a_27_74##14	1.53003e-19
C81	a_27_74##8	Y#11	1.42412e-18
C82	VGND#2	A#20	6.17784e-18
C83	Y#3	A#14	6.12907e-20
C84	Y#5	A#10	3.49317e-17
C85	VGND#5	B#18	6.77027e-20
C86	VGND#10	VGND#4	1.56218e-18
C87	VPWR#9	Y#1	6.3552e-17
C88	a_27_74##10	a_27_74##14	1.01501e-18
C89	a_27_74##4	A#10	3.38862e-17
C90	VGND#5	a_27_74##11	3.80912e-19
C91	Y#13	Y#1	1.08219e-18
C92	B#3	A#20	8.30539e-18
C93	Y#9	A#8	1.0267e-19
C94	a_27_74##4	A#14	3.38862e-17
C95	A#20	B#2	1.54079e-17
C96	Y#13	VPWR#9	9.33955e-17
C97	VPWR#10	Y#1	1.9058e-20
C98	Y#7	A#14	3.45502e-17
C99	Y#9	A#10	8.78367e-20
C100	VGND#5	a_27_74##16	5.69889e-18
C101	a_27_74##11	VGND#9	7.36337e-19
C102	B#12	B#9	1.87779e-18
C103	VPWR#10	VPWR#9	2.01295e-18
C104	VGND#2	B#7	4.6899e-18
C105	a_27_74##8	A#10	1.40027e-19
C106	VGND#5	B#16	8.56996e-21
C107	Y#7	A#17	3.43126e-17
C108	VGND#3	a_27_74##10	5.76882e-19
C109	VPWR#5	VPWR#4	3.636e-18
C110	Y#9	A#14	1.62811e-19
C111	VPWR#10	Y#13	9.28396e-17
C112	VGND#4	a_27_74##11	2.59637e-17
C113	a_27_74##6	A#17	3.38862e-17
C114	a_27_74##8	A#14	2.38327e-19
C115	Y#9	A#17	2.93385e-19
C116	VGND#8	A#14	1.5115e-19
C117	a_27_74##10	A#20	1.55539e-20
C118	a_27_74##6	A#19	3.34557e-17
C119	a_27_74##8	A#17	4.01692e-19
C120	A#4	VPWR#5	1.3836e-19
C121	VPWR#11	VPWR#10	8.76822e-17
C122	A#4	VPWR#4	3.57055e-19
C123	VGND#4	B#8	1.94468e-18
C124	a_27_74##11	a_27_74##15	6.79153e-19
C125	VPWR#3	A#4	4.13179e-20
C126	Y#9	A#19	3.30469e-17
C127	VGND#11	VGND#5	6.17081e-19
C128	A#3	A#2	3.94406e-18
C129	VGND#8	A#17	2.14912e-19
C130	Y#11	A#12	8.36294e-19
C131	VGND#2	B#8	3.59472e-18
C132	a_27_74##8	A#19	7.30224e-19
C133	VGND#5	B#12	1.10778e-19
C134	Y#9	A#20	2.40496e-17
C135	Y#14	VPWR#11	6.99706e-17
C136	VGND#8	A#19	4.01183e-19
C137	VGND#4	a_27_74##10	2.49223e-17
C138	a_27_74##8	A#20	4.83615e-17
C139	Y#11	A#4	4.03167e-18
C140	VPWR#12	VPWR#11	2.28499e-18
C141	VGND#4	B#5	2.32862e-19
C142	Y#9	B#7	1.09482e-18
C143	a_27_74##12	VGND#10	1.5185e-17
C144	VGND#4	B#12	2.85022e-19
C145	VGND#8	A#20	1.62208e-18
C146	Y#11	A#20	1.47048e-18
C147	a_27_74##10	B#7	6.31352e-20
C148	VGND#5	B#9	1.67755e-19
C149	a_27_74##8	B#7	2.68769e-17
C150	VPWR#12	Y#14	7.91198e-17
C151	a_27_74##14	A#20	1.69263e-19
C152	Y#2	A#4	3.97772e-19
C153	a_27_74##12	B#20	1.62601e-17
C154	a_27_74##11	VGND#10	1.50071e-17
C155	VGND#4	B#9	2.96666e-17
C156	VGND#8	B#7	2.75754e-17
C157	VGND#2	B#9	8.07247e-19
C158	a_27_74##11	B#5	5.09932e-19
C159	a_27_74##8	B#8	3.9711e-19
C160	a_27_74##14	B#7	6.87059e-19
C161	a_27_74##10	B#5	3.47784e-18
C162	A#3	A#1	3.20165e-18
C163	VPWR#4	VPWR#3	9.9519e-19
C164	VGND#8	B#8	2.85868e-17
C165	Y#12	VPWR#12	1.45738e-16
C166	a_27_74##8	B#9	1.67464e-19
C167	B#8	a_27_74##14	1.5902e-17
C168	a_27_74##11	B#8	2.56769e-20
C169	a_27_74##12	a_27_74##16	1.79677e-18
C170	VGND#8	B#9	1.4263e-18
C171	a_27_74##10	B#8	1.80501e-17
C172	B#9	a_27_74##14	1.99295e-17
C173	A#12	A#11	2.59918e-18
C174	VGND#5	B#13	1.00597e-18
C175	a_27_74##15	B#8	1.21048e-19
C176	a_27_74##12	B#18	1.35104e-17
C177	B#3	A#16	9.87881e-19
C178	B#9	VGND#9	2.16039e-17
C179	VGND#4	B#13	1.80261e-17
C180	A#18	B#2	7.43276e-18
C181	A#11	A#3	8.05567e-19
C182	a_27_74##14	B#13	4.14067e-19
C183	a_27_74##15	B#9	4.4832e-19
C184	B#13	VGND#9	8.2255e-18
C185	VGND#10	B#9	1.0509e-19
C186	A#18	B#1	1.74063e-17
C187	a_27_74##15	B#13	3.67693e-17
C188	a_27_74##11	B#9	9.50981e-20
C189	VGND#11	a_27_74##12	2.98123e-17
C190	VGND#10	B#13	1.34538e-18
C191	a_27_74##10	B#9	1.8386e-17
C192	B#1	A#12	4.03014e-18
C193	A#6	A#5	3.76402e-17
C194	VGND#4	B#10	2.05342e-18
C195	B#17	a_27_74##15	1.16718e-17
C196	a_27_74##16	B#13	1.42252e-19
C197	VGND#5	B#17	7.97902e-18
C198	VGND#10	B#17	3.28664e-17
C199	VGND#4	B#17	7.96743e-19
C200	a_27_74##15	B#19	6.16632e-19
C201	a_27_74##16	B#17	3.40125e-19
C202	A#8	A#6	9.46963e-18
C203	VGND#10	B#19	2.80663e-17
C204	a_27_74##11	B#16	1.26402e-17
C205	a_27_74##12	B#13	3.18989e-20
C206	a_27_74##15	B#21	1.5654e-19
C207	B#19	a_27_74##16	1.26382e-17
C208	a_27_74##11	B#13	1.49386e-17
C209	VGND#10	B#21	1.17872e-18
C210	VGND#11	B#19	2.54393e-18
C211	A#10	A#8	3.70159e-17
C212	a_27_74##13	a_27_74##12	2.75727e-18
C213	a_27_74##10	B#13	3.84653e-20
C214	B#21	a_27_74##16	1.6075e-17
C215	a_27_74##13	B#19	1.89095e-19
C216	VGND#11	B#21	4.24489e-17
C217	VGND#5	B#19	5.04052e-18
C218	a_27_74##13	B#21	8.54052e-19
C219	A#14	A#10	3.70159e-17
C220	Y#3	A#12	5.68169e-20
C221	VPWR#3	VPWR#1	1.91485e-18
C222	a_27_74##11	B	5.44303e-17
C223	Y#2	A#3	2.1496e-18
C224	VGND#11	B#22	3.80055e-17
C225	a_27_74##10	B	9.43227e-17
C226	a_27_74##13	B#22	3.03651e-17
C227	a_27_74##11	B#12	1.37526e-17
C228	a_27_74##12	B#17	7.62704e-20
C229	B	Y#11	8.98633e-17
C230	A#17	A#14	3.70159e-17
C231	a_27_74##11	B#17	8.63816e-18
C232	a_27_74#	A#2	2.62914e-19
C233	Y#3	A#3	5.45081e-18
C234	A#19	A#17	3.70159e-17
C235	Y#5	A#12	2.89765e-18
C236	VGND#5	B#21	6.3656e-19
C237	Y#9	B#1	2.7295e-19
C238	VPWR#1	A#1	3.83273e-17
C239	a_27_74##4	A#13	3.26757e-19
C240	Y#2	A#2	4.91615e-18
C241	VPWR#2	A#3	3.87355e-20
C242	Y#7	A#16	2.42053e-18
C243	A#1	Y#1	2.504e-17
C244	Y#3	A#2	1.02005e-17
C245	VGND#2	B#3	2.50219e-20
C246	VPWR#2	A#2	4.67696e-20
C247	a_27_74##2	A#3	1.2147e-18
C248	VGND#1	A#16	1.34692e-21
C249	A#20	A#19	3.69528e-17
C250	a_27_74##6	A#18	4.62225e-19
C251	VPWR#9	A#1	3.06682e-18
C252	VPWR#1	A#7	2.95156e-18
C253	VGND#1	A#13	1.01468e-19
C254	a_27_74##12	B#19	6.50163e-18
C255	a_27_74##4	A#12	1.49193e-18
C256	VGND#1	A#12	1.64446e-19
C257	Y#13	A#1	2.11068e-19
C258	A#7	Y#1	2.84011e-17
C259	Y#7	A#13	2.09886e-18
C260	a_27_74##11	B#19	1.38275e-19
C261	A	Y#2	9.80969e-17
C262	VGND#1	A#3	3.0393e-19
C263	VPWR#9	A#7	7.00295e-17
C264	VPWR#10	A#1	3.76353e-19
C265	a_27_74##2	A#2	4.8115e-20
C266	a_27_74##6	A#16	4.33887e-19
C267	B#7	A#20	4.12788e-17
C268	VGND#1	A#2	2.81684e-19
C269	Y#5	A#3	2.90506e-19
C270	Y#13	A#7	4.64483e-19
C271	Y#1	A#11	5.76538e-19
C272	Y#9	A#18	2.51814e-18
C273	VPWR#10	A#7	4.51974e-19
C274	VPWR#9	A#11	6.27819e-17
C275	Y#7	A#12	2.05342e-18
C276	a_27_74##6	A#13	5.58703e-20
C277	Y#13	A#11	3.55718e-17
C278	Y#1	A#15	1.8355e-19
C279	B#8	B#7	3.97263e-17
C280	Y#9	A#16	9.81237e-19
C281	VPWR#10	A#11	1.87429e-18
C282	VPWR#9	A#15	2.81759e-18
C283	a_27_74##8	A#18	2.09684e-20
C284	Y#13	A#15	5.77579e-17
C285	VGND#2	B#2	3.58647e-20
C286	a_27_74##11	B#10	3.2876e-18
C287	A#15	VPWR#10	3.68629e-17
C288	B#9	B#8	3.35766e-17
C289	a_27_74##12	B#21	2.71784e-18
C290	VPWR#9	B#1	1.07152e-19
C291	VGND#1	a_27_74#	5.12883e-17
C292	VPWR#11	A#15	1.98405e-18
C293	a_27_74##11	B#21	3.51029e-20
C294	VGND#1	Y#3	1.28352e-17
C295	B#4	B#3	3.20043e-18
C296	A#4	A#16	1.0227e-17
C297	VPWR#10	B#1	1.98405e-18
C298	VGND#1	a_27_74##2	7.37091e-17
C299	A#4	A#13	1.41953e-17
C300	B#13	B#9	1.01856e-17
C301	VGND#1	Y#5	1.56487e-18
C302	VPWR#12	A#15	8.2074e-20
C303	a_27_74##10	B#10	2.28266e-18
C304	B#1	VPWR#11	4.67612e-17
C305	A#4	A#12	2.67772e-17
C306	VGND#1	a_27_74##4	3.6961e-17
C307	Y#14	B#1	5.43153e-17
C308	Y#13	VPWR#4	8.48902e-18
C309	A#4	A#3	9.66681e-19
C310	VGND#1	a_27_74##6	8.96798e-19
C311	VPWR#12	B#1	1.06079e-18
C312	VPWR	VPWR#5	4.61976e-17
C313	VPWR#11	B#6	1.41487e-18
C314	VGND#3	B#4	2.34912e-20
C315	VPWR	VPWR#4	4.86484e-17
C316	VPWR	VPWR#3	3.33479e-17
C317	B#17	B#13	3.68545e-17
C318	Y#14	B#6	4.68591e-17
C319	Y#13	VPWR#3	9.32814e-18
C320	B#6	VPWR#12	3.56219e-17
C321	VPWR	Y#11	4.58644e-18
C322	a_27_74##12	a_27_74##11	4.29009e-19
C323	Y#12	B#6	4.62224e-19
C324	a_27_74##11	B#4	1.09194e-19
C325	Y#14	B#14	4.80651e-19
C326	B#19	B#17	3.65073e-17
C327	a_27_74##12	B#22	1.29914e-18
C328	VPWR#5	B#2	1.37961e-20
C329	VPWR#12	B#14	7.33342e-17
C330	A#4	B#3	1.49034e-18
C331	Y#12	B#14	3.84326e-17
C332	VPWR#2	VPWR#1	2.7858e-17
C333	B#12	B#5	3.35585e-18
C334	Y#1	VPWR#2	2.78166e-17
C335	B#21	B#19	3.77449e-17
C336	VPWR#12	B#15	2.27284e-18
C337	a_27_74##10	B#4	2.15531e-18
C338	a_27_74##2	A#4	1.03766e-18
C339	VPWR#2	VPWR#9	3.08623e-17
C340	B#5	B#4	2.81281e-18
C341	A#4	Y#5	6.67026e-17
C342	Y#12	B#15	5.35804e-17
C343	VPWR#2	Y#13	2.71014e-19
C344	a_27_74##4	A#4	2.05059e-19
C345	B#15	VPWR#13	3.98902e-18
C346	VGND	VGND#5	7.50721e-17
C347	VGND	VGND#4	1.02507e-16
C348	Y#7	A#4	5.26883e-17
C349	VGND#3	a_27_74##14	1.16213e-17
C350	VGND	VGND#2	1.32716e-16
C351	B#22	B#21	3.72155e-17
C352	Y#2	VPWR#1	2.94169e-17
C353	Y#9	A#4	1.10514e-20
C354	VGND	a_27_74##12	3.92006e-18
C355	VGND	a_27_74##11	4.64923e-18
C356	VGND	a_27_74##10	4.67265e-18
C357	a_27_74##11	B#3	7.55867e-20
C358	B	A#16	2.48198e-18
C359	VGND#1	A#5	6.84116e-18
C360	a_27_74##10	B#3	1.13415e-18
C361	VGND#1	A#6	6.18898e-18
C362	B	B#12	2.77126e-17
C363	VPWR#9	A#4	1.34285e-18
C364	VGND#1	A#8	5.3356e-18
C365	A#7	A#1	4.8474e-17
C366	a_27_74#	Y#3	4.65083e-17
C367	A#4	Y#13	4.63462e-17
C368	VGND#1	A#10	5.3356e-18
C369	B	B#10	1.64576e-17
C370	VGND#5	VNB	2.72814e-17
C371	VGND#4	VNB	3.51585e-17
C372	B	B#4	1.83621e-17
C373	A#4	VPWR#10	3.24464e-17
C374	Y#2	Y#1	3.24157e-18
C375	VGND#2	VNB	5.83026e-17
C376	VGND#1	A#14	5.3356e-18
C377	B	B#3	2.083e-17
C378	VPWR#5	VNB	2.43496e-17
C379	A#4	VPWR#11	8.53424e-18
C380	VPWR#4	VNB	2.40277e-17
C381	A	A#3	3.44149e-17
C382	B	B#2	5.92297e-18
C383	VPWR#3	VNB	3.63806e-17
C384	A	A#2	1.08166e-17
C385	a_27_74##12	VNB	1.11678e-17
C386	A#11	A#7	1.07097e-17
C387	a_27_74##11	VNB	4.41584e-18
C388	a_27_74##10	VNB	1.39608e-18
C389	Y#11	VNB	2.02347e-18
C390	Y#2	VNB	2.28849e-17
C391	a_27_74##11	a_27_74##10	1.44503e-19
C392	Y	A#18	1.52336e-17
C393	A#15	A#11	3.78142e-17
C394	Y	A#16	5.74891e-18
C395	B#5	VPWR#12	4.89692e-18
C396	Y	A#12	1.54156e-20
C397	a_27_74##8	B	3.24345e-17
C398	Y#12	B#5	9.48166e-18
C399	A	Y#3	9.63515e-17
C400	A	a_27_74##2	8.67832e-18
C401	Y#5	A	3.15234e-17
C402	B#1	A#15	4.57119e-18
C403	Y#3	a_27_74##2	5.17696e-17
C404	Y	B#12	6.63078e-19
C405	Y#14	VPWR#5	8.47314e-18
C406	Y#11	B#4	3.61973e-18
C407	Y	B#4	1.97963e-19
C408	VGND#3	B#8	2.47673e-18
C409	Y	B#3	2.37347e-18
C410	VPWR	A#18	1.09527e-19
C411	VPWR	A#16	1.40941e-18
C412	Y	B#2	4.14474e-18
C413	B#6	B#1	4.70726e-17
C414	VPWR	A#13	8.15656e-19
C415	Y#2	VPWR#9	4.33024e-17
C416	VPWR#2	A#1	1.49651e-18
C417	VPWR#2	A#7	5.32202e-19
C418	B#14	B#6	1.30413e-18
C419	a_27_74##8	Y	2.29577e-18
C420	VPWR#3	A#7	9.84143e-19
C421	B	Y#12	1.06565e-16
C422	VPWR	B#2	7.38002e-23
C423	A	Y#13	2.24243e-17
C424	B#15	B#14	3.84888e-17
C425	VGND	A#18	8.53372e-19
C426	VGND	A#16	2.00888e-18
C427	VGND	A#13	8.50123e-19
C428	VGND	A#12	1.36153e-19
C429	a_27_74##2	Y#5	5.16743e-17
C430	VGND	B#20	1.12519e-20
C431	VGND	B#18	1.11113e-20
C432	VGND	B#16	5.57026e-19
C433	VGND	B#12	6.4058e-19
C434	VGND	B#2	4.94393e-19
C435	A#4	A#11	3.99427e-18
C436	Y#11	B#3	4.61821e-18
C437	VGND	a_27_74##2	1.1707e-17
C438	VGND	Y#5	7.97754e-18
C439	VPWR#12	VPWR#5	1.03962e-18
C440	VGND	a_27_74##4	2.27469e-17
C441	VGND	Y#7	8.27518e-18
C442	A#18	VNB	1.47063e-17
C443	A#16	VNB	2.41686e-17
C444	VGND	a_27_74##6	2.34613e-17
C445	A#4	B#1	1.83566e-18
C446	VPWR	VPWR#9	1.44733e-17
C447	A#13	VNB	2.71945e-17
C448	VGND	Y#9	9.96466e-18
C449	A#12	VNB	2.93441e-17
C450	VPWR	Y#13	1.90015e-17
C451	VGND	a_27_74##8	1.91359e-17
C452	A#3	VNB	3.5421e-17
C453	VPWR	VPWR#10	2.02822e-17
C454	A#2	VNB	3.53463e-17
C455	VGND	a_27_74##14	1.39487e-17
C456	VPWR	VPWR#11	2.02822e-17
C457	B#20	VNB	1.48202e-17
C458	a_27_74##8	B#3	5.18376e-19
C459	B#18	VNB	1.35584e-17
C460	VPWR	Y#14	1.8812e-17
C461	Y#13	Y#2	3.94855e-19
C462	B#16	VNB	1.08914e-17
C463	VGND	a_27_74##15	1.52329e-17
C464	B#12	VNB	5.00886e-17
C465	VPWR	VPWR#12	2.38677e-16
C466	VGND#8	B#4	4.23386e-19
C467	VGND	a_27_74##16	1.3202e-17
C468	VPWR	Y#12	2.11765e-17
C469	B#10	VNB	2.96316e-17
C470	B#4	VNB	2.43848e-17
C471	VGND	VGND#11	2.19511e-17
C472	B#3	VNB	2.66946e-17
C473	B#18	VGND#10	1.03888e-18
C474	VGND	a_27_74##13	1.70718e-17
C475	B#2	VNB	1.50568e-17
C476	Y	A#20	6.67692e-18
C477	a_27_74#	VNB	2.2887e-17
C478	Y#3	VNB	2.79071e-17
C479	Y	B#7	1.80952e-20
C480	a_27_74##2	VNB	6.64084e-18
C481	Y#2	A#1	2.27951e-17
C482	a_27_74##4	VNB	3.96732e-18
C483	VGND	VPWR#10	4.05148e-18
C484	B#20	a_27_74##16	4.96868e-19
C485	Y#5	a_27_74##4	3.56051e-17
C486	a_27_74##6	VNB	4.17493e-18
C487	VGND	VPWR#11	4.4434e-18
C488	Y#9	VNB	3.41684e-19
C489	a_27_74##8	VNB	3.84226e-18
C490	VGND#8	VNB	3.84357e-20
C491	VGND#1	A#4	3.09366e-19
C492	VPWR#3	A#11	9.79091e-19
C493	a_27_74##14	VNB	4.84657e-18
C494	A	A#1	2.55245e-18
C495	a_27_74##15	VNB	2.1858e-18
C496	a_27_74##8	B#2	1.63241e-18
C497	VGND#10	VNB	3.01253e-20
C498	a_27_74##16	VNB	4.67081e-18
C499	VGND#5	VGND#4	1.66799e-18
C500	VGND#11	VNB	2.29053e-18
C501	A	A#11	1.41776e-18
C502	VGND#8	B#3	4.18094e-19
C503	VGND	A#8	8.02485e-19
C504	a_27_74##13	VNB	7.34311e-17
C505	B#16	VGND#10	9.93819e-19
C506	VPWR#1	VNB	4.16023e-17
C507	VGND	A#10	7.7726e-19
C508	Y#1	VNB	4.76246e-18
C509	VGND	A#14	7.7726e-19
C510	VPWR#9	VNB	1.21277e-18
C511	VGND	A#17	2.12089e-18
C512	Y#13	VNB	2.77013e-18
C513	VPWR#10	VNB	1.71726e-17
C514	VGND	A#19	6.42017e-19
C515	VGND#3	B#5	6.59562e-20
C516	VPWR#11	VNB	1.84561e-17
C517	VGND	A#20	5.74228e-19
C518	Y#14	VNB	2.3242e-18
C519	VGND	B#7	8.6619e-19
C520	B#18	a_27_74##16	4.90657e-19
C521	VPWR#12	VNB	7.71378e-17
C522	VPWR	B#22	2.68816e-18
C523	Y#12	VNB	3.08441e-18
C524	VGND	B#8	1.49664e-18
C525	VGND	B#9	4.80824e-19
C526	A#5	VNB	3.3404e-17
C527	Y	B#1	4.07051e-18
C528	A#6	VNB	2.98012e-17
C529	Y#11	VPWR#11	3.42566e-17
C530	A#8	VNB	2.98223e-17
C531	VGND	B#17	3.58533e-19
C532	A#10	VNB	2.75235e-17
C533	VGND	B#19	4.72176e-19
C534	VPWR	A#11	5.23313e-19
C535	A#14	VNB	2.72396e-17
C536	B#20	VGND#11	2.7349e-18
C537	VGND	B#21	5.9004e-19
C538	VPWR#2	A	6.56314e-18
C539	A#17	VNB	2.70732e-17
C540	VPWR	A#15	2.56164e-18
C541	A#19	VNB	2.6815e-17
C542	VGND	B#22	1.73331e-18
C543	A#20	VNB	3.70258e-17
C544	VPWR	B#1	5.52652e-18
C545	VGND#1	A	7.30303e-18
C546	B#7	VNB	2.52058e-17
C547	B#8	VNB	2.70523e-17
C548	B#9	VNB	2.63842e-17
C549	VPWR	B#14	2.01916e-19
C550	B#13	VNB	2.39856e-17
C551	Y#11	B#2	6.67636e-18
C552	B#17	VNB	2.4563e-17
C553	VPWR	B#15	2.95477e-18
C554	B	B#5	2.07751e-17
C555	B#19	VNB	2.12106e-17
C556	B#21	VNB	2.14175e-17
C557	VGND	B#1	8.62544e-19
C558	A	A#4	1.61177e-17
C559	B#22	VNB	6.02382e-17
C560	A#1	VNB	4.05297e-17
C561	A#7	VNB	2.81319e-17
C562	Y	A#4	1.6804e-17
C563	A#11	VNB	3.26263e-17
C564	A#15	VNB	3.3952e-17
C565	Y	B#5	1.33427e-19
C566	B#1	VNB	5.1381e-17
C567	a_27_74##4	Y#7	3.5483e-17
C568	B#6	VNB	3.34621e-17
C569	VGND	VGND#1	7.63856e-17
C570	VPWR	A#4	9.35584e-18
C571	B#14	VNB	3.02378e-17
C572	B#15	VNB	3.67173e-17
C573	VGND	VGND#3	2.0902e-17
C574	VPWR#2	VNB	1.29225e-16
C575	VGND	A#4	9.43375e-18
C576	B	Y	2.64756e-17
C577	VGND#1	VNB	2.08952e-16
C578	VPWR	B	1.61292e-17
C579	VGND#3	VNB	1.11185e-17
C580	A#4	VNB	4.60831e-17
C581	VPWR	A	1.39504e-18
C582	B#5	VNB	2.89269e-17
C583	VGND	B	1.14336e-17
C584	Y#2	A#7	1.50778e-17
C585	VGND	A	1.46266e-18
C586	B	VNB	5.33917e-17
C587	A	VNB	9.79996e-18
C588	VPWR	VNB	2.92563e-16
C589	VPWR#4	A#15	4.61794e-18
C590	VGND	VNB	2.99697e-16
C591	VGND#6	VNB	4.44671e-17
C592	VGND#6	VGND#5	1.35859e-18
C593	B	VPWR#7	5.49526e-19
C594	a_27_74##12	VPWR#7	3.66685e-17
C595	VPWR#7	VPWR#13	7.74835e-17
C596	VPWR#7	VPWR#12	3.78939e-18
C597	VGND#6	B#21	9.67013e-19
C598	VPWR#7	B#16	4.52859e-18
C599	VPWR#7	B#15	3.43445e-17
C600	VPWR#7	B#20	6.42282e-18
C601	VPWR#7	VNB	1.48724e-16
C602	VGND#6	a_27_74##13	1.78354e-17
C603	VPWR	VPWR#7	2.30166e-16
C604	VGND#6	B#22	1.26052e-18
C605	a_27_74##11	VPWR#7	1.82725e-17
C606	VPWR#7	Y#12	1.06697e-16
C607	VGND	VGND#6	7.3676e-17
C608	VPWR#7	B#12	1.62975e-19
C609	VGND#6	B#20	6.85597e-20
C610	VPWR#7	B#18	5.94797e-18
C611	VPWR#7	B#14	1.07013e-18
C612	VGND#6	a_27_74##12	1.78113e-19
C613	VGND#6	a_27_74##16	5.74834e-18
C614	VPWR#7	B#22	3.32743e-18
*
*
.ENDS sky130_fd_sc_hs__nand2_8
*
