* Extracted by Quantus, converted by sky130cad/quantus.py
*
*
*
*                       LINUX           Wed Nov 18 08:34:22 2026
*
*
*
*  PROGRAM  advgen
*
*  Name           : advgen - Quantus - (64-bit)
*  Version        : 25.1.0-p047
*  Build Date     : Thu Dec 11 23:20:30 PST 2025
*
*  HSPICE LIBRARY
*
*  OPERATING_TEMPERATURE 150
*  QRC_TECH_DIR <path>/tech
*
*
*

*
.SUBCKT sky130_fd_sc_hs__dlygate4sd1_1 VPB VNB VGND VPWR X A
*
*
*  caps2d version: 10
*
*
*       TRANSISTOR CARDS
*
*
XM2 a_28_74##7 A#1 VGND#7 VNB sky130_fd_pr__nfet_01v8_lvt l=0.15 w=0.42 ad=0.1113 as=0.3087 pd=1.37 ps=2.31
XM6 VGND#7 a_28_74# a_288_74##7 VNB sky130_fd_pr__nfet_01v8_lvt l=0.15 w=0.42 ad=0.3087 as=0.1113 pd=2.31 ps=1.37
XM3 a_405_138##6 a_288_74# VGND#6 VNB sky130_fd_pr__nfet_01v8_lvt l=0.15 w=0.42 ad=0.2562 as=0.2297 pd=2.06 ps=2.17
XM1 VGND#6 a_405_138##3 X#3 VNB sky130_fd_pr__nfet_01v8_lvt l=0.15 w=0.74 ad=0.2297 as=0.1961 pd=2.17 ps=2.01
XM5 a_28_74##5 A#3 VPWR#7 VPB sky130_fd_pr__pfet_01v8 l=0.15 w=0.42 ad=0.1176 as=0.6225 pd=1.4 ps=3.39
XM4 VPWR#7 a_28_74##4 a_288_74##9 VPB sky130_fd_pr__pfet_01v8 l=0.18 w=1 ad=0.6225 as=0.26 pd=3.39 ps=2.52
XM0 a_405_138##4 a_288_74##4 VPWR#6 VPB sky130_fd_pr__pfet_01v8 l=0.18 w=1 ad=0.58 as=0.388 pd=3.16 ps=2.95
XM7 VPWR#6 a_405_138# X#1 VPB sky130_fd_pr__pfet_01v8 l=0.15 w=1.12 ad=0.388 as=0.3136 pd=2.95 ps=2.8
*
*
*       RESISTOR AND CAP/DIODE CARDS
*
Rg1	A#1	A#2	382.539764
Rg2	A#2	A#3	519.595703
Rg3	a_28_74#	a_28_74##2	423.374023
Rg4	a_28_74##2	a_28_74##3	93.334923
Rg5	a_28_74##2	a_28_74##4	397.213379
Rg6	a_288_74#	a_288_74##2	282.776031
Rg7	a_288_74##2	a_288_74##3	45.362373
Rg8	a_288_74##2	a_288_74##4	365.503296
Rg9	a_405_138#	a_405_138##2	467.246124
Rg10	a_405_138##2	a_405_138##3	363.395935
Rf1	A	A#4	3.280892
Rf2	A#5	A#2	163.513702
Rf3	A#4	A#5	1.266811
Rf4	A	A#7	3.280892
Rf5	A#5	A#7	6.545189
Rf6	a_28_74##5	a_28_74##3	110.133453
Rf7	a_28_74##3	a_28_74##7	94.284950
Rf8	a_288_74##3	a_288_74##6	119.414703
Rf9	a_288_74##6	a_288_74##8	47.645889
Rf10	a_288_74##6	a_288_74##9	68.863724
Rf11	a_288_74##7	a_288_74##8	15.000000
Rf12	a_405_138##4	a_405_138##5	91.106712
Rf13	a_405_138##5	a_405_138##6	89.469757
Rf14	X	X#2	0.237160
Rf15	X#2	X	11.462756
Rf16	X	X#4	5.929011
Rf17	X#4	X	5.770905
Rf18	X#1	X#2	5.000000
Rf19	X#3	X#4	7.500000
Rf21	VPWR#2	VPWR#3	78.139503
Rf22	VPWR#3	VPWR#4	86.175049
Rf24	VPWR#2	VPWR#6	35.274620
Rf25	VPWR#4	VPWR#7	42.577789
Rf27	VGND#2	VGND#3	78.139503
Rf28	VGND#3	VGND#4	85.444542
Rf30	VGND#2	VGND#6	36.082184
Rf31	VGND#4	VGND#7	33.916985
Rf35	a_405_138##2	a_405_138##5	160.232803
Re1	VPWR#3	VPWR	1.227783
Re2	VGND	VGND#3	1.227829
*
*       CAPACITOR CARDS
*
*
C1	VGND	VNB	6.2889e-17
C2	VPWR	VNB	5.88936e-17
C3	X	VNB	1.42606e-16
C4	A	VNB	1.88551e-17
C5	VGND	X	2.53887e-17
C6	VPWR	X	2.61865e-17
C7	A#2	VNB	8.42104e-17
C8	a_28_74##3	VNB	9.02483e-17
C9	VPWR	A	4.81075e-18
C10	a_288_74##3	VNB	8.78244e-17
C11	a_405_138##2	VNB	4.14198e-17
C12	VGND#3	VNB	2.05727e-16
C13	VPWR#3	VNB	2.07353e-16
C14	VGND	A#2	5.38596e-18
C15	A#3	VNB	5.65771e-17
C16	VGND	a_28_74##3	1.14317e-17
C17	a_28_74##4	VNB	4.94955e-17
C18	VGND	a_288_74##3	4.92273e-18
C19	a_288_74##4	VNB	5.77772e-17
C20	a_405_138#	VNB	3.84909e-17
C21	VGND	a_405_138##2	7.44276e-18
C22	VGND	VGND#3	2.37315e-17
C23	A#1	VNB	3.80854e-17
C24	a_28_74#	VNB	3.82694e-17
C25	VPWR	a_28_74##3	9.75309e-18
C26	a_288_74#	VNB	3.16325e-17
C27	a_405_138##3	VNB	3.23832e-17
C28	VPWR	a_288_74##3	4.99455e-18
C29	a_28_74##5	VNB	3.77369e-17
C30	VPWR#7	VNB	6.69643e-18
C31	VPWR	a_405_138##2	4.82199e-18
C32	a_288_74##9	VNB	5.95031e-18
C33	a_405_138##4	VNB	9.45639e-18
C34	X	a_28_74##3	3.28035e-20
C35	VPWR#6	VNB	6.0291e-18
C36	VPWR	VPWR#3	2.64769e-17
C37	a_28_74##7	VNB	3.79922e-17
C38	A	A#2	1.70562e-17
C39	VGND#7	VNB	3.34425e-18
C40	VGND	A#1	1.12236e-18
C41	a_288_74##7	VNB	1.44833e-17
C42	a_405_138##2	X	1.12121e-16
C43	VGND	a_28_74#	5.76472e-18
C44	a_405_138##6	VNB	9.02367e-18
C45	A	a_28_74##3	3.42502e-17
C46	VPWR	A#3	5.50216e-18
C47	VGND#6	VNB	8.59591e-18
C48	VGND	a_288_74#	7.27516e-18
C49	VPWR	a_28_74##4	6.05196e-18
C50	VGND	a_405_138##3	1.10367e-18
C51	A#5	VNB	7.31546e-18
C52	VPWR	a_288_74##4	8.02909e-18
C53	VPWR	a_405_138#	3.88902e-18
C54	a_288_74##6	VNB	1.65432e-17
C55	VGND	a_405_138##4	3.37334e-18
C56	X	a_28_74##4	2.82649e-19
C57	VGND	a_28_74##7	1.72241e-17
C58	X	a_288_74##4	9.43043e-19
C59	VGND	VGND#7	1.50219e-17
C60	VGND	a_288_74##7	1.66393e-17
C61	X	a_405_138#	2.88756e-17
C62	VPWR	a_28_74##5	1.3535e-17
C63	VGND	a_405_138##6	1.50209e-17
C64	VPWR	a_288_74##9	1.24908e-17
C65	VPWR	a_405_138##4	1.25722e-17
C66	X	a_28_74#	2.43293e-19
C67	VPWR	VPWR#6	2.21244e-17
C68	X	a_288_74#	9.16077e-19
C69	X	a_405_138##3	2.14579e-17
C70	A#2	a_28_74##3	7.47323e-17
C71	VGND	a_288_74##6	2.52608e-18
C72	a_405_138##4	X	1.76905e-18
C73	VPWR#6	X	7.86307e-17
C74	a_28_74##3	a_288_74##3	7.38308e-18
C75	X	X#1	1.5152e-17
C76	A	a_28_74##5	5.32157e-17
C77	a_405_138##2	a_28_74##3	2.51593e-19
C78	a_405_138##6	X	1.79643e-18
C79	VPWR	a_288_74##6	2.10455e-18
C80	a_405_138##2	a_288_74##3	8.12536e-17
C81	VGND#6	X	5.33144e-17
C82	X	X#3	9.0914e-18
C83	VGND#3	a_288_74##3	9.43003e-19
C84	a_288_74##3	VPWR#3	9.05476e-19
C85	A#2	a_28_74##4	4.8675e-19
C86	a_28_74##3	A#3	6.84728e-19
C87	a_28_74##3	a_28_74##4	1.65943e-17
C88	a_28_74##3	a_288_74##4	7.85106e-19
C89	A#1	a_28_74##3	2.47695e-19
C90	a_405_138##2	a_288_74##4	1.22336e-17
C91	a_28_74##3	a_28_74#	7.37677e-18
C92	a_405_138##2	a_405_138#	6.83508e-18
C93	a_28_74##5	A#2	1.78985e-19
C94	a_28_74##3	a_288_74#	9.5293e-19
C95	VPWR#3	a_28_74##4	3.92066e-18
C96	VPWR#7	A#2	6.55715e-19
C97	a_28_74##3	VPWR#7	3.33749e-17
C98	A#3	a_28_74##4	1.07031e-17
C99	a_28_74##3	a_288_74##9	2.55395e-17
C100	a_405_138##2	a_288_74#	9.36289e-18
C101	VGND#3	a_28_74#	2.89601e-18
C102	a_405_138##4	a_28_74##3	2.24751e-19
C103	a_28_74##7	A#2	6.21837e-17
C104	a_405_138##2	a_405_138##3	4.35983e-18
C105	VGND#7	A#2	8.77831e-19
C106	a_28_74##4	a_288_74##4	4.95356e-18
C107	a_288_74##3	a_405_138##4	6.20237e-17
C108	a_28_74##4	a_405_138#	1.89566e-19
C109	VGND#7	a_28_74##3	2.26944e-17
C110	a_288_74##4	a_405_138#	3.90504e-17
C111	a_28_74##3	a_288_74##7	2.36232e-17
C112	a_405_138##6	a_28_74##3	9.68283e-19
C113	a_405_138##2	VPWR#6	3.2791e-17
C114	A#5	A#2	1.02069e-17
C115	a_288_74##9	VPWR#3	9.62592e-18
C116	a_405_138##6	a_288_74##3	7.32035e-17
C117	A#5	a_28_74##3	1.43758e-17
C118	a_405_138##4	VPWR#3	4.60299e-18
C119	a_28_74##5	A#3	3.37907e-17
C120	A#3	VPWR#7	2.67193e-17
C121	a_28_74##5	a_28_74##4	1.29104e-18
C122	a_405_138##2	VGND#6	3.27467e-17
C123	a_288_74##9	A#3	3.52668e-18
C124	VGND#3	a_288_74##7	2.36944e-17
C125	a_28_74##4	VPWR#7	2.42102e-17
C126	a_28_74##3	a_288_74##6	9.83663e-17
C127	VGND#3	a_405_138##6	8.13597e-18
C128	a_288_74##9	a_28_74##4	5.2158e-17
C129	A#1	a_28_74#	6.30312e-18
C130	VPWR#7	a_288_74##4	1.36014e-18
C131	a_405_138##4	a_28_74##4	7.04359e-19
C132	a_288_74##9	a_288_74##4	4.27772e-18
C133	a_288_74##6	a_288_74##3	3.48147e-18
C134	VPWR#6	a_28_74##4	3.92717e-18
C135	a_405_138##4	a_288_74##4	3.47838e-17
C136	a_28_74#	a_288_74#	1.72299e-18
C137	a_288_74##9	a_405_138#	1.72941e-18
C138	a_288_74##4	VPWR#6	3.30362e-17
C139	a_28_74#	a_405_138##3	4.20578e-19
C140	a_288_74##6	a_405_138##2	2.54288e-18
C141	a_405_138##4	a_405_138#	1.14952e-18
C142	a_288_74#	a_405_138##3	2.23499e-17
C143	VPWR#6	a_405_138#	5.16915e-17
C144	a_405_138#	X#1	2.106e-20
C145	VGND#3	a_288_74##6	9.2056e-19
C146	a_288_74##6	VPWR#3	6.12968e-19
C147	a_28_74##5	VPWR#7	4.3393e-17
C148	a_28_74##7	A#1	4.01892e-17
C149	A#1	VGND#7	2.19488e-17
C150	a_28_74##5	a_288_74##9	1.51355e-18
C151	a_28_74##7	a_28_74#	1.7008e-18
C152	a_288_74##7	A#1	3.94263e-18
C153	VPWR#7	a_288_74##9	1.38072e-17
C154	a_28_74#	VGND#7	1.40817e-17
C155	a_288_74##7	a_28_74#	2.98105e-17
C156	a_288_74##6	a_28_74##4	2.37562e-18
C157	a_405_138##6	a_28_74#	5.7533e-19
C158	VPWR#6	VPWR#7	6.66403e-20
C159	a_288_74##9	a_405_138##4	1.76991e-17
C160	a_288_74##7	a_288_74#	1.68121e-18
C161	VGND#6	a_28_74#	1.5791e-18
C162	a_28_74##7	a_28_74##5	1.1762e-19
C163	a_288_74##9	VPWR#6	1.02441e-17
C164	a_405_138##6	a_288_74#	1.70168e-17
C165	a_288_74##6	a_288_74##4	3.09515e-19
C166	a_288_74##7	a_405_138##3	2.02115e-18
C167	a_288_74#	VGND#6	1.70646e-17
C168	a_405_138##4	VPWR#6	4.62449e-18
C169	a_405_138##6	a_405_138##3	1.74065e-18
C170	a_288_74##6	a_405_138#	5.54818e-20
C171	VGND#6	a_405_138##3	3.75621e-17
C172	a_28_74##7	VGND#7	4.43527e-17
C173	a_288_74##6	a_288_74#	8.94567e-20
C174	a_28_74##7	a_288_74##7	1.50063e-18
C175	VGND#7	a_288_74##7	1.19695e-17
C176	a_288_74##7	a_405_138##6	2.33799e-17
C177	a_288_74##7	VGND#6	7.20579e-18
C178	a_288_74##6	a_288_74##9	5.10969e-19
C179	a_405_138##6	VGND#6	9.4512e-18
C180	a_288_74##6	a_405_138##4	1.3952e-17
C181	a_288_74##6	a_405_138##6	1.28932e-17
C182	a_405_138##4	VPWR#2	1.41081e-18
C183	VPWR#2	a_405_138#	4.46779e-18
C184	VPWR#2	a_288_74##4	5.21822e-18
C185	VPWR#3	VPWR#2	6.07544e-17
C186	a_405_138##2	VPWR#2	4.72003e-19
C187	VPWR#2	a_288_74##3	2.91366e-19
C188	X	VPWR#2	3.67722e-17
C189	VPWR	VPWR#2	3.88899e-17
C190	VPWR#2	VNB	5.45173e-17
C191	VGND#2	a_405_138##3	7.18811e-18
C192	VGND#2	a_288_74##3	3.57698e-19
C193	VPWR#4	VNB	6.23098e-17
C194	VPWR	VPWR#4	6.32543e-17
C195	VGND#2	a_405_138##2	1.20147e-18
C196	VGND#4	a_28_74##7	2.46863e-17
C197	VGND#3	VGND#2	6.11259e-17
C198	VGND#4	a_28_74##3	5.59032e-18
C199	VGND#2	VNB	5.67507e-17
C200	a_28_74##3	VPWR#4	3.01572e-18
C201	VGND#4	A#1	4.90384e-18
C202	VGND#4	VNB	5.49463e-17
C203	VGND	VGND#2	6.06099e-17
C204	VPWR#3	VPWR#4	5.85877e-17
C205	VGND#4	a_28_74#	6.07166e-18
C206	VPWR#4	A#3	7.28778e-19
C207	VPWR#4	a_28_74##4	1.0449e-17
C208	VGND	VGND#4	4.01903e-17
C209	VGND#2	X	2.53754e-17
C210	VGND#3	VGND#4	5.91484e-17
C211	a_28_74##5	VPWR#4	9.49445e-18
C212	VGND#2	a_405_138##6	1.9439e-18
C213	VGND#2	a_28_74#	3.68218e-19
C214	VGND#2	a_288_74#	2.75157e-18
*
*
.ENDS sky130_fd_sc_hs__dlygate4sd1_1
*
