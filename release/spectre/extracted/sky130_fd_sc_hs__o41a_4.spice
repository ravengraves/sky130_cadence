* Extracted by Quantus, converted by sky130cad/quantus.py
*
*
*
*                       LINUX           Wed Nov 18 09:04:05 2026
*
*
*
*  PROGRAM  advgen
*
*  Name           : advgen - Quantus - (64-bit)
*  Version        : 25.1.0-p047
*  Build Date     : Thu Dec 11 23:20:30 PST 2025
*
*  HSPICE LIBRARY
*
*  OPERATING_TEMPERATURE 150
*  QRC_TECH_DIR <path>/tech
*
*
*

*
.SUBCKT sky130_fd_sc_hs__o41a_4 VNB VPB VGND VPWR X A3 A2 A1 A4 B1
*
*
*  caps2d version: 10
*
*
*       TRANSISTOR CARDS
*
*
XM7 VGND#9 a_110_48##12 X#6 VNB sky130_fd_pr__nfet_01v8_lvt l=0.15 w=0.74 ad=0.2627 as=0.2072 pd=2.19 ps=2.04
XM15 X#6 a_110_48##9 VGND#15 VNB sky130_fd_pr__nfet_01v8_lvt l=0.15 w=0.74 ad=0.2072 as=0.259 pd=2.04 ps=2.18
XM14 X#7 a_110_48##7 VGND#15 VNB sky130_fd_pr__nfet_01v8_lvt l=0.15 w=0.74 ad=0.2072 as=0.259 pd=2.04 ps=2.18
XM27 VGND#14 a_110_48##5 X#7 VNB sky130_fd_pr__nfet_01v8_lvt l=0.15 w=0.74 ad=0.2109 as=0.2072 pd=2.05 ps=2.04
XM21 a_523_124##7 B1#7 a_110_48##19 VNB sky130_fd_pr__nfet_01v8_lvt l=0.15 w=0.64 ad=0.1824 as=0.1792 pd=1.85 ps=1.84
XM22 a_110_48##19 B1#1 a_523_124##5 VNB sky130_fd_pr__nfet_01v8_lvt l=0.15 w=0.64 ad=0.1792 as=0.2368 pd=1.84 ps=2.02
XM8 a_523_124##5 A3#4 VGND#13 VNB sky130_fd_pr__nfet_01v8_lvt l=0.15 w=0.64 ad=0.2368 as=0.3827 pd=2.02 ps=2.52
XM23 VGND#13 A4#7 a_523_124##10 VNB sky130_fd_pr__nfet_01v8_lvt l=0.15 w=0.64 ad=0.3827 as=0.1792 pd=2.52 ps=1.84
XM9 a_523_124##10 A4#1 VGND#12 VNB sky130_fd_pr__nfet_01v8_lvt l=0.15 w=0.64 ad=0.1792 as=0.1792 pd=1.84 ps=1.84
XM5 VGND#12 A3#2 a_523_124##9 VNB sky130_fd_pr__nfet_01v8_lvt l=0.15 w=0.64 ad=0.1792 as=0.1856 pd=1.84 ps=1.86
XM10 VGND#11 A2#4 a_523_124##9 VNB sky130_fd_pr__nfet_01v8_lvt l=0.15 w=0.64 ad=0.1792 as=0.1856 pd=1.84 ps=1.86
XM11 VGND#11 A1#4 a_523_124##8 VNB sky130_fd_pr__nfet_01v8_lvt l=0.15 w=0.64 ad=0.1792 as=0.1792 pd=1.84 ps=1.84
XM24 a_523_124##8 A1#5 VGND#10 VNB sky130_fd_pr__nfet_01v8_lvt l=0.15 w=0.64 ad=0.1792 as=0.22625 pd=1.84 ps=2.01
XM13 a_523_124# A2#2 VGND#10 VNB sky130_fd_pr__nfet_01v8_lvt l=0.15 w=0.64 ad=0.1824 as=0.22625 pd=1.85 ps=2.01
XM1 VPWR#11 a_110_48##13 X#4 VPB sky130_fd_pr__pfet_01v8 l=0.15 w=1.12 ad=0.3304 as=0.336 pd=2.83 ps=2.84
XM4 VPWR#9 a_110_48##10 X#4 VPB sky130_fd_pr__pfet_01v8 l=0.15 w=1.12 ad=0.336 as=0.336 pd=2.84 ps=2.84
XM16 X#1 a_110_48##6 VPWR#9 VPB sky130_fd_pr__pfet_01v8 l=0.15 w=1.12 ad=0.336 as=0.336 pd=2.84 ps=2.84
XM18 X#1 a_110_48# VPWR#7 VPB sky130_fd_pr__pfet_01v8 l=0.15 w=1.12 ad=0.336 as=0.4003 pd=2.84 ps=3.01
XM17 a_110_48##18 B1#5 VPWR#7 VPB sky130_fd_pr__pfet_01v8 l=0.15 w=0.84 ad=0.252 as=0.4003 pd=2.28 ps=3.01
XM2 VPWR#5 B1#6 a_110_48##18 VPB sky130_fd_pr__pfet_01v8 l=0.15 w=0.84 ad=0.2478 as=0.252 pd=2.27 ps=2.28
XM0 a_851_368##2 A3#5 a_762_368##4 VPB sky130_fd_pr__pfet_01v8 l=0.15 w=1.12 ad=0.336 as=0.3304 pd=2.84 ps=2.83
XM6 a_851_368##2 A4#5 a_110_48##14 VPB sky130_fd_pr__pfet_01v8 l=0.15 w=1.12 ad=0.336 as=0.3472 pd=2.84 ps=2.86
XM26 a_110_48##14 A4#6 a_851_368# VPB sky130_fd_pr__pfet_01v8 l=0.15 w=1.12 ad=0.3472 as=0.336 pd=2.86 ps=2.84
XM20 a_762_368##2 A3#1 a_851_368# VPB sky130_fd_pr__pfet_01v8 l=0.15 w=1.12 ad=0.336 as=0.336 pd=2.84 ps=2.84
XM12 a_762_368##2 A2#6 a_1213_368##2 VPB sky130_fd_pr__pfet_01v8 l=0.15 w=1.12 ad=0.336 as=0.336 pd=2.84 ps=2.84
XM3 a_1213_368##2 A1#6 VPWR#4 VPB sky130_fd_pr__pfet_01v8 l=0.15 w=1.12 ad=0.336 as=0.3808 pd=2.84 ps=2.92
XM19 VPWR#4 A1#1 a_1213_368# VPB sky130_fd_pr__pfet_01v8 l=0.15 w=1.12 ad=0.3808 as=0.392 pd=2.92 ps=2.94
XM25 a_1213_368# A2#1 a_762_368# VPB sky130_fd_pr__pfet_01v8 l=0.15 w=1.12 ad=0.392 as=0.3864 pd=2.94 ps=2.93
*
*
*       RESISTOR AND CAP/DIODE CARDS
*
Rg1	a_110_48#	a_110_48##2	489.852875
Rg2	a_110_48##2	a_110_48##3	42.284615
Rg3	a_110_48##3	a_110_48##4	49.541122
Rg4	a_110_48##2	a_110_48##5	324.843109
Rg5	a_110_48##3	a_110_48##6	455.087006
Rg6	a_110_48##4	a_110_48##7	331.118347
Rg7	a_110_48##4	a_110_48##8	62.865845
Rg8	a_110_48##8	a_110_48##9	324.843109
Rg9	a_110_48##4	a_110_48##10	464.658997
Rg10	a_110_48##8	a_110_48##11	36.378445
Rg11	a_110_48##11	a_110_48##12	371.205322
Rg12	a_110_48##11	a_110_48##13	455.087006
Rg13	B1#1	B1#2	318.718842
Rg14	B1#2	B1#3	49.436001
Rg15	B1#3	B1#4	83.816399
Rg16	B1#4	B1#5	508.034332
Rg17	B1#3	B1#6	335.866638
Rg18	B1#4	B1#7	294.264465
Rg19	A4#1	A4#2	294.260559
Rg20	A4#2	A4#3	30.596949
Rg21	A4#3	A4#4	24.707481
Rg22	A4#4	A4#5	451.859222
Rg23	A4#2	A4#6	449.655212
Rg24	A4#4	A4#7	299.789185
Rg25	A3#1	A3#2	790.124878
Rg26	A3#2	A3#3	1184.283447
Rg27	A3#3	A3#4	295.975708
Rg28	A3#4	A3#5	828.920715
Rg29	A1#1	A1#2	444.707855
Rg30	A1#2	A1#3	46.740482
Rg31	A1#3	A1#4	273.732178
Rg32	A1#2	A1#5	281.077362
Rg33	A1#3	A1#6	429.126801
Rg34	A2#1	A2#2	841.329590
Rg35	A2#2	A2#3	300.968994
Rg36	A2#3	A2#4	1149.309692
Rg37	A2#3	A2#5	32.951523
Rg38	A2#4	A2#6	791.767883
Rf1	X#1	X#2	85.194122
Rf2	X#2	X#3	53.521442
Rf3	X#3	X	10.399658
Rf4	X#2	X#4	23.129641
Rf5	X#3	X#5	98.667809
Rf6	X#5	X#6	18.015675
Rf7	X#5	X#7	84.958839
Rf8	B1	B1#2	166.163803
Rf9	A3	A3#3	168.499924
Rf10	a_110_48##14	a_110_48##15	146.910446
Rf11	a_110_48##15	a_110_48##16	24.591537
Rf12	a_110_48##16	a_110_48##4	85.518509
Rf13	a_110_48##15	a_110_48##18	19.884722
Rf14	a_110_48##16	a_110_48##19	38.132713
Rf15	A4#8	A4	1.362411
Rf16	A4#3	A4#10	81.478813
Rf17	A4#8	A4#10	10.465661
Rf18	A4#11	A4	1.362411
Rf19	A4#10	A4#11	7.160716
Rf20	a_851_368#	a_851_368##2	63.871944
Rf21	A1#3	A1#8	161.577332
Rf22	A1#8	A1	1.344532
Rf23	A1#9	A1	1.344532
Rf24	A1#8	A1#9	17.392607
Rf25	a_1213_368#	a_1213_368##2	94.267578
Rf26	a_523_124#	a_523_124##2	86.910385
Rf27	a_523_124##2	a_523_124##3	60.348263
Rf28	a_523_124##3	a_523_124##4	66.192307
Rf29	a_523_124##4	a_523_124##6	99.482063
Rf30	a_523_124##6	a_523_124##7	109.440697
Rf31	a_523_124##2	a_523_124##8	15.969168
Rf32	a_523_124##3	a_523_124##9	19.635996
Rf33	a_523_124##4	a_523_124##10	16.097075
Rf34	a_523_124##5	a_523_124##6	7.500000
Rf35	a_762_368#	a_762_368##3	176.027374
Rf36	a_762_368##3	a_762_368##4	151.218536
Rf37	a_762_368##2	a_762_368##3	5.000000
Rf38	A2	A2#5	192.838959
Rf39	VGND#1	VGND#2	31.444530
Rf40	VGND#2	VGND#3	62.889057
Rf41	VGND#3	VGND#4	60.640194
Rf42	VGND#4	VGND#5	62.896935
Rf43	VGND#5	VGND#6	80.453583
Rf44	VGND#6	VGND#7	84.714043
Rf45	VGND#7	VGND#8	67.887894
Rf46	VGND#8	VGND#9	99.903160
Rf47	VGND#2	VGND#10	48.794708
Rf48	VGND#3	VGND#11	48.794708
Rf49	VGND#4	VGND#12	41.003098
Rf50	VGND#5	VGND#13	64.660995
Rf51	VGND#7	VGND#14	32.715752
Rf52	VGND#8	VGND#15	33.523315
Rf53	VPWR#1	VPWR#2	52.232937
Rf54	VPWR#2	VPWR#3	247.277756
Rf55	VPWR#2	VPWR#4	34.157074
Rf56	VPWR#3	VPWR#5	55.714256
Rf57	VPWR#3	VPWR#6	66.508766
Rf58	VPWR#6	VPWR#7	53.317944
Rf59	VPWR#6	VPWR#8	68.798325
Rf60	VPWR#8	VPWR#9	59.717762
Rf61	VPWR#8	VPWR#10	65.941528
Rf62	VPWR#10	VPWR#11	59.717762
Re1	VPWR#1	VPWR	4.549932
Re2	VPWR	VPWR#3	0.974985
Re3	VGND#1	VGND	4.549932
Re4	VGND	VGND#6	0.974985
*
*       CAPACITOR CARDS
*
*
C1	VPWR#2	A1#1	2.55585e-18
C2	VGND	VNB	2.89368e-16
C3	VPWR	VNB	3.13033e-16
C4	X	VNB	9.67264e-17
C5	A3	VNB	8.86478e-19
C6	A2	VNB	3.83936e-17
C7	A1	VNB	1.1015e-17
C8	VPWR#8	VPWR#6	6.99578e-19
C9	A4	VNB	1.55225e-18
C10	B1	VNB	6.87722e-18
C11	B1#1	A3#4	2.2318e-17
C12	a_762_368##2	a_1213_368##2	1.09123e-16
C13	VGND	X	1.92613e-18
C14	a_110_48##4	VNB	4.11928e-17
C15	B1#4	B1#3	4.30193e-18
C16	A3#3	VNB	7.6028e-17
C17	A4#3	VNB	1.54003e-18
C18	VPWR	X	1.53215e-17
C19	VGND#10	A1#4	1.64155e-18
C20	A1#3	VNB	2.77871e-17
C21	A2#5	VNB	9.41515e-17
C22	VGND#6	VNB	3.44865e-17
C23	VGND#5	VGND#12	1.28029e-18
C24	VPWR#3	VNB	7.29757e-17
C25	VGND	A1	1.86511e-18
C26	VGND#1	VNB	1.36403e-16
C27	VPWR#1	VNB	1.58411e-16
C28	VPWR#3	A4#4	5.64127e-20
C29	VGND	A4	3.34937e-18
C30	a_110_48##13	VNB	3.81319e-17
C31	a_110_48##10	VNB	3.4824e-17
C32	a_762_368##4	A3#1	1.19438e-19
C33	a_110_48##6	VNB	3.67785e-17
C34	VGND	B1	5.45489e-18
C35	a_110_48#	VNB	4.10863e-17
C36	B1#5	VNB	3.9957e-17
C37	VPWR	A1	2.30852e-18
C38	B1#6	VNB	3.41432e-17
C39	A3#5	VNB	4.58563e-17
C40	A4#5	VNB	3.31818e-17
C41	A4#6	VNB	3.26938e-17
C42	VPWR	A4	2.99317e-18
C43	A3#1	VNB	4.31628e-17
C44	a_110_48##14	A4#6	3.16114e-17
C45	A2#6	VNB	4.2333e-17
C46	VGND#12	VGND#11	6.29818e-18
C47	A1#6	VNB	3.06388e-17
C48	A1#1	VNB	2.97701e-17
C49	VPWR	B1	5.20286e-18
C50	A2#1	VNB	5.27137e-17
C51	a_762_368##2	A4#5	5.21372e-19
C52	a_110_48##12	VNB	3.66531e-17
C53	a_110_48##9	VNB	2.37621e-17
C54	a_110_48##7	VNB	2.53319e-17
C55	a_110_48##5	VNB	3.07254e-17
C56	B1#7	VNB	3.05296e-17
C57	B1#1	VNB	2.7138e-17
C58	A3#4	VNB	3.68574e-17
C59	A4#7	VNB	2.19384e-17
C60	A4#1	VNB	1.80649e-17
C61	VGND	a_110_48##4	1.35986e-17
C62	A3#2	VNB	6.49756e-17
C63	A1#5	a_523_124##8	1.14181e-17
C64	VGND#4	a_523_124##9	2.67642e-18
C65	A2#4	VNB	6.08302e-17
C66	A1#4	VNB	1.83474e-17
C67	A1#5	VNB	1.92847e-17
C68	a_523_124##2	a_762_368##2	4.70179e-18
C69	A2#2	VNB	4.82643e-17
C70	VPWR#11	VNB	7.52461e-18
C71	VGND	A3#3	2.7055e-17
C72	X#4	VNB	2.28192e-18
C73	VPWR#9	VNB	2.92383e-18
C74	X#1	VNB	2.92334e-18
C75	VGND	A4#3	1.13904e-18
C76	VPWR#7	VNB	1.81522e-18
C77	VPWR#5	VNB	8.03697e-18
C78	X#1	VPWR#6	1.00924e-17
C79	a_762_368##4	VNB	1.14937e-17
C80	a_851_368##2	VNB	3.19417e-18
C81	VGND#4	a_523_124##3	2.52428e-19
C82	VGND	A2#5	2.41149e-18
C83	a_851_368#	VNB	3.18645e-18
C84	a_762_368##2	VNB	6.29169e-18
C85	VPWR	a_110_48##4	1.21227e-17
C86	VGND	VGND#6	5.63549e-17
C87	a_1213_368##2	VNB	2.09331e-18
C88	VPWR#4	VNB	7.29159e-19
C89	a_1213_368#	VNB	2.76102e-18
C90	a_762_368#	VNB	6.07795e-17
C91	A4	A1	6.53085e-18
C92	VGND#9	VNB	5.56182e-17
C93	a_851_368#	A4#6	4.9728e-17
C94	X#6	VNB	4.66541e-18
C95	a_523_124#	A1#4	6.80239e-19
C96	VGND#15	VNB	3.83662e-19
C97	X#7	VNB	2.10786e-18
C98	VGND#14	VNB	8.30768e-18
C99	a_523_124##7	VNB	1.82035e-17
C100	a_110_48##19	VNB	1.31125e-18
C101	a_523_124##5	VNB	9.85233e-18
C102	VPWR	A4#3	1.46056e-18
C103	VGND#13	VNB	4.34687e-18
C104	VGND#2	A2#5	3.24847e-17
C105	a_523_124##10	VNB	7.22785e-19
C106	a_762_368##2	VPWR#4	5.92982e-19
C107	VGND#12	VNB	2.31054e-18
C108	a_523_124##9	VNB	5.55538e-18
C109	VGND#11	VNB	1.8851e-18
C110	X	a_110_48##4	2.72073e-17
C111	a_523_124##8	VNB	6.21334e-19
C112	VGND#10	VNB	1.87474e-18
C113	a_523_124#	VNB	2.68471e-17
C114	X#2	VNB	2.92817e-18
C115	B1	A4	2.32236e-17
C116	X#5	VNB	1.86197e-17
C117	a_762_368##4	A2#6	8.19876e-20
C118	a_110_48##15	VNB	8.90007e-18
C119	a_110_48##16	VNB	5.36746e-18
C120	VPWR	VPWR#3	1.44568e-16
C121	B1#3	A3#4	1.27206e-17
C122	a_110_48##14	A3#1	1.54857e-18
C123	VGND#3	A2#5	2.98274e-18
C124	a_523_124##2	VNB	3.02509e-18
C125	VGND#2	a_523_124##8	2.69524e-18
C126	a_523_124##3	VNB	6.46537e-18
C127	a_523_124##4	VNB	6.64452e-18
C128	VGND#10	A1#5	2.96972e-17
C129	a_762_368##2	A4#6	1.71306e-17
C130	VGND#2	VNB	1.73446e-17
C131	VGND#3	VNB	2.20197e-17
C132	A3#4	A4#7	9.19124e-18
C133	VPWR#4	A4#5	1.77238e-19
C134	VPWR	a_110_48##13	9.11346e-19
C135	VGND#4	VNB	2.33616e-17
C136	VGND#5	VNB	2.48788e-17
C137	VGND#7	VNB	3.58703e-17
C138	A3	A3#3	6.36546e-18
C139	VGND#8	VNB	3.41136e-17
C140	VPWR	a_110_48##10	9.14936e-19
C141	VPWR#2	VNB	5.50323e-17
C142	VPWR#6	VNB	3.2567e-17
C143	VPWR#8	VNB	2.63319e-17
C144	VPWR#2	A2#1	5.69231e-19
C145	VPWR	a_110_48##6	5.00477e-19
C146	X#1	VPWR#8	8.7511e-18
C147	a_523_124##3	a_762_368##2	1.76435e-17
C148	a_523_124##9	VGND#11	2.86793e-17
C149	VPWR	a_110_48#	2.59545e-18
C150	VPWR	B1#5	8.16158e-18
C151	VGND	a_110_48##12	1.22904e-18
C152	VGND	a_110_48##9	6.20565e-19
C153	VPWR	B1#6	7.92278e-18
C154	VGND	a_110_48##7	9.82498e-20
C155	VPWR	A3#5	2.33348e-18
C156	VGND	a_110_48##5	2.528e-19
C157	a_523_124##8	A2#2	9.69303e-19
C158	VPWR	A4#5	6.00421e-19
C159	X	a_110_48##13	5.0633e-18
C160	a_851_368#	A3#1	4.24344e-17
C161	VPWR	A4#6	6.78853e-19
C162	VPWR	A3#1	1.88014e-18
C163	VGND	A4#7	3.8055e-18
C164	a_762_368#	A1#2	7.23834e-19
C165	VPWR	A2#6	2.24561e-18
C166	a_1213_368##2	VPWR#4	4.10736e-17
C167	VGND	A4#1	2.77003e-18
C168	X#2	a_110_48##13	1.83304e-17
C169	VGND	A3#2	2.91965e-18
C170	VPWR	A1#6	3.42655e-19
C171	VGND	A2#4	3.44538e-18
C172	VGND	A1#4	4.59132e-18
C173	a_523_124#	A1#5	3.53764e-18
C174	A1	A1#3	1.82231e-17
C175	a_110_48##14	A2#6	6.86939e-19
C176	A4	A3#3	3.44814e-19
C177	VGND#1	A2	3.50645e-17
C178	A1	A2#5	3.09636e-19
C179	a_762_368##2	A3#1	4.93483e-17
C180	VGND#4	a_523_124##4	2.71088e-19
C181	VGND	X#1	3.47156e-18
C182	VPWR#4	A4#6	2.59324e-19
C183	VGND	VPWR#7	3.53923e-18
C184	A4	A1#3	1.49832e-18
C185	a_110_48##3	VNB	4.46626e-17
C186	VGND#3	a_523_124##8	2.74024e-18
C187	a_523_124##4	a_762_368##2	2.20214e-18
C188	a_110_48##11	VNB	5.43742e-17
C189	B1#3	VNB	4.39094e-17
C190	B1#4	VNB	2.04877e-17
C191	A2#2	VGND#10	1.51194e-17
C192	A4#4	VNB	4.63486e-17
C193	A1#2	VNB	2.33783e-17
C194	VGND#1	A1	2.37857e-18
C195	VGND	a_762_368##2	2.48937e-18
C196	a_851_368#	A2#6	8.45839e-19
C197	a_523_124##9	a_523_124##8	3.32568e-18
C198	VPWR#1	A1	1.85084e-18
C199	A4#7	A4#1	3.28455e-17
C200	a_1213_368##2	A3#1	1.39378e-18
C201	a_762_368##2	a_762_368#	1.30305e-18
C202	VGND	VGND#9	6.91865e-17
C203	a_1213_368##2	a_1213_368#	3.14168e-18
C204	VGND	X#6	1.41737e-17
C205	VGND	VGND#15	1.82251e-17
C206	VGND	X#7	1.52844e-17
C207	VGND	VGND#14	2.21442e-17
C208	VPWR	X#4	1.76694e-17
C209	VGND	a_523_124##7	2.69216e-17
C210	A4#4	A3#1	1.05581e-17
C211	VGND	a_110_48##19	9.12011e-18
C212	VPWR	X#1	1.8342e-17
C213	VGND	a_523_124##5	2.08434e-17
C214	X#2	a_110_48##10	1.69302e-17
C215	a_762_368##2	A2#6	3.77471e-17
C216	VGND	a_523_124##10	1.18257e-17
C217	A3#4	A4#4	1.34444e-17
C218	a_523_124#	A2#2	4.04787e-17
C219	VPWR#4	A3#1	4.22536e-19
C220	VGND	a_523_124##9	1.05506e-17
C221	VPWR	a_762_368##4	2.01697e-17
C222	VGND	a_523_124##8	8.05287e-18
C223	VPWR	a_851_368##2	1.96863e-17
C224	VGND#1	a_523_124##2	1.467e-18
C225	VPWR	a_110_48##14	5.03767e-18
C226	VGND	X#2	5.22874e-18
C227	VGND#8	a_110_48##12	1.78124e-18
C228	VPWR	a_851_368#	1.96309e-17
C229	VPWR	a_762_368##2	2.56837e-17
C230	VGND	X#5	6.62517e-18
C231	VPWR	a_1213_368##2	1.80227e-17
C232	A3	a_110_48##5	2.47393e-20
C233	a_1213_368##2	A2#6	4.4024e-17
C234	VGND#5	a_523_124##4	9.62788e-19
C235	X	VPWR#11	8.08806e-17
C236	VGND	a_110_48##16	4.7527e-18
C237	A3	B1#1	5.86665e-19
C238	A1	A4#6	1.82735e-19
C239	X	X#4	6.98391e-19
C240	a_762_368#	a_1213_368##2	3.51757e-18
C241	a_1213_368#	VPWR#4	4.56297e-17
C242	VGND#11	a_523_124##8	2.91172e-17
C243	A3	A3#4	8.40293e-18
C244	A1	A3#1	1.07553e-18
C245	A3	A4#7	6.23242e-19
C246	A1	A2#6	3.7682e-18
C247	A4	A3#5	2.31469e-18
C248	A1	A1#6	2.0525e-18
C249	VGND	a_523_124##2	1.45165e-18
C250	A3	A3#2	3.68119e-20
C251	a_762_368##2	A1#6	1.41437e-17
C252	A3#2	A4#1	4.53632e-17
C253	A4	A4#5	1.97221e-18
C254	VGND	a_523_124##3	3.40655e-18
C255	a_523_124##7	a_110_48##15	5.03074e-20
C256	VGND	a_523_124##4	5.45397e-18
C257	A1	A1#1	2.04054e-18
C258	VPWR#4	A2#6	7.4548e-19
C259	A4	A4#6	3.90009e-18
C260	VGND#2	a_523_124#	2.86799e-19
C261	a_762_368#	A3#1	1.352e-19
C262	A1	A2#1	4.3269e-18
C263	VGND	VGND#2	5.4636e-18
C264	X#2	a_110_48##6	4.01416e-19
C265	VGND	VGND#3	6.6723e-17
C266	A4	A3#1	4.24269e-18
C267	VGND	VGND#4	7.68404e-17
C268	VGND	VGND#5	7.00346e-17
C269	B1	A3#5	1.22902e-17
C270	VGND	VGND#7	6.48856e-17
C271	A4	A2#6	1.04487e-18
C272	VGND	VGND#8	6.52373e-17
C273	B1	A4#5	5.45645e-19
C274	A4	A1#6	1.79365e-19
C275	a_1213_368##2	A1#6	5.89253e-17
C276	VPWR	X#2	2.43067e-18
C277	a_762_368#	VPWR#4	1.22499e-18
C278	VPWR	a_110_48##15	2.12477e-17
C279	VGND#11	VGND#10	5.67066e-18
C280	VPWR	a_110_48##16	1.17998e-18
C281	A4#3	A3#3	1.59883e-19
C282	a_762_368##2	A1#1	2.84222e-19
C283	VGND#8	a_110_48##9	1.24119e-18
C284	A2	A1#5	7.8141e-19
C285	A1#6	VPWR#4	2.63556e-17
C286	A1	A3#4	2.81006e-19
C287	A2	A2#2	3.64617e-18
C288	a_523_124##7	a_110_48##16	1.93757e-17
C289	X#2	VPWR#11	7.40308e-18
C290	a_762_368#	A2#6	1.93476e-19
C291	X#7	a_110_48##3	3.92709e-18
C292	VGND#1	VGND#2	5.30684e-17
C293	A1	A3#2	1.07349e-18
C294	A3#2	A2#4	6.5904e-17
C295	a_1213_368##2	A1#1	1.21737e-18
C296	A1	A2#4	3.00571e-18
C297	a_1213_368#	A1#6	5.14259e-19
C298	a_762_368#	a_1213_368#	1.18913e-16
C299	VGND#6	A3#3	1.25148e-17
C300	A4	A3#4	4.19632e-18
C301	X	X#2	2.43661e-18
C302	A1	A2#2	7.42843e-18
C303	a_762_368##2	A2#1	4.79492e-19
C304	X#5	X	6.12968e-18
C305	VPWR#4	A1#1	4.07658e-17
C306	A2#5	A1#3	9.46538e-19
C307	B1#3	VPWR#5	2.40315e-18
C308	a_523_124##8	VGND#10	2.91172e-17
C309	VPWR	VPWR#2	9.86704e-17
C310	A4	A3#2	2.84744e-18
C311	a_762_368#	A1#6	3.28556e-19
C312	VPWR	VPWR#6	7.30522e-17
C313	VPWR	VPWR#8	6.08747e-17
C314	A4	A2#4	6.95414e-19
C315	a_523_124##5	A3	3.5841e-17
C316	X#2	X#4	1.96856e-19
C317	A3	VGND#13	2.52155e-17
C318	a_110_48##16	a_110_48##19	2.40299e-19
C319	B1	A3#4	1.37646e-17
C320	a_1213_368##2	A2#1	2.40585e-19
C321	VPWR#6	VPWR#3	2.6685e-18
C322	VGND#8	a_110_48##7	2.74034e-18
C323	a_1213_368#	A1#1	3.76744e-17
C324	A2	a_762_368#	4.78012e-18
C325	VGND#3	VGND#2	3.58806e-18
C326	a_523_124##4	A3#4	2.97151e-18
C327	A2#4	A1#4	4.74613e-17
C328	VPWR#4	A2#1	1.67448e-18
C329	a_762_368#	A1#1	1.47075e-17
C330	A1	a_762_368##2	3.35128e-17
C331	VGND#1	A2#5	6.38288e-17
C332	a_523_124##8	a_523_124#	3.08634e-18
C333	VGND#7	a_110_48##5	3.81272e-18
C334	VGND	a_110_48##3	2.34602e-19
C335	a_1213_368#	A2#1	4.91126e-17
C336	a_523_124##3	A4#7	5.89722e-20
C337	X#2	VPWR#9	1.71437e-17
C338	a_110_48##15	a_110_48#	1.50106e-18
C339	A1	a_762_368#	3.94145e-17
C340	VGND	a_110_48##11	3.68427e-19
C341	VGND	B1#3	3.56243e-21
C342	a_110_48##16	a_523_124##5	1.13636e-17
C343	A4	a_110_48##14	3.56915e-17
C344	VGND#14	a_110_48##3	5.01385e-18
C345	VGND#10	A2	4.57029e-18
C346	VGND#7	a_110_48##3	7.49923e-20
C347	A4	a_762_368##2	5.39138e-18
C348	a_762_368#	A2#1	4.09505e-17
C349	a_523_124##4	A4#7	2.02685e-17
C350	A1#4	A1#5	3.28955e-17
C351	A3	a_523_124##4	1.73962e-18
C352	a_523_124#	VGND#10	2.78745e-17
C353	B1	a_110_48##14	2.76151e-17
C354	X#2	X#1	2.32408e-18
C355	a_110_48##15	B1#5	2.71039e-17
C356	a_523_124##3	A4#1	1.39129e-19
C357	A4#3	A4#5	8.71621e-20
C358	a_110_48##16	B1#5	9.43935e-19
C359	VPWR#1	VPWR#2	2.58987e-17
C360	a_523_124#	A1	9.02613e-18
C361	X#2	a_110_48##11	5.35833e-18
C362	VGND#9	X#6	3.78455e-17
C363	a_523_124##4	A4#1	1.5531e-17
C364	a_523_124##2	A3#2	6.04984e-21
C365	VGND#4	VGND#3	2.87893e-18
C366	A1#5	A2#2	2.14138e-17
C367	VPWR#3	a_110_48#	1.2261e-18
C368	a_110_48##15	B1#6	4.47688e-17
C369	VGND#10	A1#2	2.59086e-19
C370	VPWR	B1#4	2.23452e-22
C371	a_523_124##7	B1	2.94269e-18
C372	a_523_124##3	A3#2	1.67139e-17
C373	VPWR#3	B1#6	2.47954e-18
C374	a_762_368##4	A3#4	6.44395e-19
C375	VGND#9	VGND#15	1.8833e-18
C376	A2#6	A1#3	1.23607e-17
C377	VGND#8	a_110_48##3	6.323e-20
C378	B1	a_523_124##5	7.08665e-17
C379	a_110_48##12	VGND#9	2.18124e-17
C380	a_110_48##13	a_110_48##10	4.77266e-17
C381	VPWR#3	A3#5	8.07519e-18
C382	a_851_368#	VPWR#2	2.15006e-17
C383	a_523_124##2	A1	6.6947e-17
C384	a_523_124##4	A3#2	6.77721e-19
C385	a_523_124##2	A2#4	3.79728e-19
C386	A4#4	A3#2	1.14782e-17
C387	VPWR#3	A4#5	5.91317e-18
C388	X#6	a_110_48##12	3.15139e-17
C389	a_762_368##4	A4#4	2.92882e-19
C390	a_110_48##16	A4	1.8864e-18
C391	a_110_48##15	A3#5	4.26181e-19
C392	VGND#5	A3#4	3.31856e-19
C393	VPWR#3	A4#6	2.6276e-18
C394	a_110_48##10	a_110_48##6	4.95724e-17
C395	X#6	VGND#15	3.59668e-17
C396	VGND#9	a_110_48##9	1.24834e-18
C397	a_110_48##5	A3#3	6.69531e-19
C398	VGND#15	a_110_48##12	2.4673e-18
C399	a_523_124##3	A2#4	1.56493e-17
C400	VPWR#3	A3#1	2.06714e-19
C401	a_110_48##4	a_110_48##3	3.5767e-17
C402	a_110_48##14	A3#4	2.51148e-19
C403	VGND#4	A4#4	2.646e-19
C404	B1#1	A3#3	3.33587e-18
C405	a_110_48##9	X#6	1.26739e-17
C406	X#5	a_110_48##3	4.87549e-20
C407	a_110_48##4	a_110_48##11	2.73438e-17
C408	X#7	a_110_48##12	2.06733e-19
C409	a_110_48##6	a_110_48#	4.78863e-17
C410	A3#3	A3#4	1.61056e-18
C411	a_523_124##2	A1#4	1.49824e-17
C412	a_762_368##2	VPWR#2	1.85773e-17
C413	a_110_48##15	B1	6.30105e-17
C414	a_523_124##4	A2#4	6.49887e-20
C415	X#6	X#7	2.61152e-18
C416	A3#3	A4#7	2.24641e-17
C417	a_110_48##16	B1	4.00038e-17
C418	X	a_110_48##3	1.67295e-19
C419	a_110_48##15	A4#5	2.49342e-19
C420	a_523_124##4	A4	5.43019e-17
C421	X	a_110_48##11	1.71206e-17
C422	VGND#15	a_110_48##9	3.44438e-17
C423	VGND#5	VGND#4	2.25084e-18
C424	X#1	a_110_48##15	4.39898e-18
C425	VPWR#11	X#4	6.33985e-17
C426	VGND#5	A4#7	1.44262e-18
C427	A3#3	A3#2	5.95976e-19
C428	X#6	a_110_48##7	7.97418e-19
C429	a_110_48#	B1#5	3.63939e-17
C430	VPWR#8	a_110_48##13	5.42375e-19
C431	VPWR#9	a_110_48##4	1.19046e-18
C432	X#7	a_110_48##9	1.18689e-18
C433	a_110_48##4	X#1	4.3092e-17
C434	a_523_124##7	B1#3	2.82989e-19
C435	X#7	VGND#15	4.92677e-17
C436	X#1	a_110_48##16	8.59473e-19
C437	VPWR#11	VPWR#9	1.87864e-18
C438	VGND#8	a_110_48##11	1.17735e-19
C439	VGND#4	A4#1	5.97813e-19
C440	a_110_48##7	VGND#15	1.95799e-17
C441	a_110_48##4	VPWR#7	1.47203e-17
C442	VPWR#1	A1#1	4.40202e-18
C443	a_523_124##2	A1#5	1.36106e-17
C444	a_110_48##15	A4#6	1.71282e-19
C445	a_851_368##2	A4#4	2.85575e-19
C446	VGND#14	a_110_48##9	3.18276e-19
C447	a_110_48#	A3#5	1.27523e-19
C448	B1#5	B1#6	3.53398e-17
C449	VPWR#7	a_110_48##15	6.6992e-17
C450	a_1213_368##2	VPWR#2	1.98789e-17
C451	a_523_124##4	B1	2.50383e-18
C452	A1#2	A2#1	5.19506e-18
C453	VGND#7	B1#4	4.44791e-20
C454	VPWR#1	A2#1	6.90077e-18
C455	VGND#6	B1#7	1.11402e-18
C456	X#7	a_110_48##7	4.85073e-17
C457	X#4	VPWR#9	6.33313e-17
C458	VPWR#6	a_110_48##10	2.59902e-19
C459	VGND#3	A3#2	1.38089e-18
C460	VGND#15	VGND#14	1.88328e-18
C461	VGND#5	A4#4	6.51954e-20
C462	B1#4	a_523_124##7	3.69931e-18
C463	X#5	a_110_48##11	4.28152e-18
C464	VGND#6	B1#1	1.12027e-18
C465	VGND#8	X#5	3.32188e-19
C466	VGND#15	a_110_48##5	1.20865e-18
C467	VPWR#8	a_110_48##10	5.12845e-18
C468	A2#4	A1#3	1.23987e-17
C469	a_110_48##16	VPWR#7	4.5112e-18
C470	B1#6	A3#5	5.39316e-18
C471	VGND#14	a_110_48##7	2.4299e-18
C472	X#4	X#1	6.66138e-19
C473	VGND#4	A3#2	2.00089e-17
C474	a_110_48##15	a_110_48##18	6.70828e-19
C475	VGND#2	A2#4	3.17803e-19
C476	a_110_48##5	X#7	1.41995e-17
C477	A2#4	A2#5	7.11906e-19
C478	X#7	VGND#14	6.29176e-17
C479	VPWR#3	A3#4	1.06079e-19
C480	A3#5	A4#5	4.68936e-17
C481	a_762_368##2	A3#2	6.92142e-19
C482	VGND#5	A3#2	2.02228e-19
C483	X#1	VPWR#9	6.43461e-17
C484	VPWR#6	a_110_48##6	6.71791e-19
C485	VGND#14	a_110_48##5	4.84268e-17
C486	VGND#3	A2#4	2.26575e-17
C487	A2#5	A1#5	2.25758e-17
C488	a_110_48##3	a_110_48#	8.85952e-19
C489	B1#3	a_110_48##19	1.22644e-19
C490	a_762_368##4	A3#3	1.3682e-19
C491	VPWR#8	a_110_48##6	7.40079e-18
C492	A2#5	A2#2	8.84905e-19
C493	X#2	VPWR#8	2.42734e-19
C494	a_110_48##12	a_110_48##11	1.15105e-18
C495	A4#4	a_110_48##14	3.17254e-18
C496	a_110_48##15	VPWR#5	7.01179e-17
C497	a_523_124##7	a_110_48##5	1.27126e-18
C498	a_110_48##14	A3#3	4.14943e-19
C499	a_110_48##4	X#6	2.89237e-18
C500	VGND#4	A2#4	9.69935e-19
C501	A4#5	A4#6	4.47883e-17
C502	a_762_368##2	A2#4	3.90059e-19
C503	a_110_48##4	VGND#15	5.36422e-18
C504	VGND#14	B1#7	2.77402e-18
C505	a_110_48##4	X#7	5.76545e-17
C506	a_110_48##19	a_110_48##5	2.82469e-19
C507	a_110_48##4	VGND#14	4.3056e-17
C508	VGND#3	A1#4	2.54375e-18
C509	a_1213_368##2	A2#4	2.35929e-19
C510	VPWR#6	a_110_48#	1.02183e-17
C511	A4#3	a_110_48##14	1.95476e-17
C512	X#1	VPWR#7	7.91672e-17
C513	a_523_124##7	B1#7	3.88426e-17
C514	VGND#14	a_523_124##7	5.246e-17
C515	A4#6	A3#1	4.79825e-17
C516	a_110_48#	B1#4	4.61771e-19
C517	a_110_48##15	a_762_368##4	2.25326e-17
C518	VPWR#8	a_110_48#	2.85183e-19
C519	VGND#14	B1#1	3.47594e-19
C520	VPWR#6	a_110_48##3	4.02107e-20
C521	VGND#2	A1#5	8.41362e-19
C522	a_110_48##19	B1#7	1.98832e-17
C523	VGND#1	A1#5	3.06088e-18
C524	VGND#9	VGND#8	1.49153e-18
C525	A3#3	A4#4	1.26979e-18
C526	VGND#1	A2#2	7.02051e-19
C527	a_523_124##7	B1#1	1.21989e-18
C528	VGND#14	a_110_48##19	2.85395e-18
C529	A3#1	A2#6	5.94894e-17
C530	a_523_124##5	B1#3	2.78211e-18
C531	VGND#8	VGND#7	1.13428e-18
C532	a_523_124##5	B1#7	1.84886e-18
C533	a_762_368##2	A1#3	8.60357e-19
C534	VPWR#6	B1#5	4.1738e-18
C535	a_851_368#	A4#4	1.75159e-19
C536	a_1213_368##2	A1#3	3.55343e-19
C537	B1#1	a_110_48##19	1.03312e-17
C538	VPWR#1	A2#2	7.07359e-20
C539	VGND#14	A3#3	4.9495e-19
C540	VPWR#7	VPWR#3	9.87011e-19
C541	A1#3	VPWR#4	8.03731e-19
C542	VGND#7	a_110_48##16	4.85247e-19
C543	A2#6	A1#6	4.60554e-17
C544	a_523_124##7	a_110_48##19	4.8643e-17
C545	VGND#8	X#6	1.24365e-17
C546	B1#5	B1#3	6.20457e-18
C547	a_523_124##5	B1#1	4.44076e-17
C548	VPWR#7	VPWR#5	3.1981e-18
C549	a_762_368#	A1#3	4.60707e-19
C550	a_110_48##4	X#2	9.19974e-17
C551	a_523_124##5	A3#3	2.20074e-17
C552	a_110_48##15	a_110_48##14	4.27439e-22
C553	VPWR#3	a_762_368##4	2.33008e-17
C554	A3#3	VGND#13	5.76526e-18
C555	X#5	a_110_48##4	6.65418e-17
C556	VGND#13	B1#1	6.63725e-19
C557	a_523_124##10	A3#3	6.24283e-18
C558	VPWR#8	a_110_48##3	4.07541e-20
C559	A1#6	A1#1	3.65202e-17
C560	a_851_368##2	VPWR#3	3.07862e-17
C561	a_1213_368#	A2#5	1.63713e-19
C562	a_523_124##7	a_523_124##5	3.1466e-18
C563	A1	A4#4	1.6593e-18
C564	a_523_124##4	VGND#13	2.11799e-17
C565	X#5	a_110_48##12	2.81517e-17
C566	A1	A1#2	1.4249e-17
C567	VGND#12	A3#3	1.41765e-18
C568	a_523_124##5	A3#4	3.7103e-17
C569	A4#3	A4#4	9.00286e-18
C570	A2#5	a_762_368#	2.14696e-18
C571	VPWR#11	a_110_48##11	1.06543e-18
C572	a_110_48##13	VPWR#11	1.91902e-17
C573	a_523_124##10	B1#1	1.85718e-19
C574	a_851_368#	VPWR#3	9.31439e-18
C575	a_110_48##16	a_110_48##4	1.31552e-19
C576	X#4	a_110_48##13	4.90988e-17
C577	A3#4	VGND#13	1.81235e-17
C578	a_762_368##2	A4#4	3.56464e-19
C579	a_1213_368#	A2#2	3.88355e-19
C580	A1#1	A2#1	3.72276e-17
C581	a_110_48##19	a_523_124##5	4.44557e-17
C582	VGND#7	X#7	6.92519e-18
C583	VPWR#9	a_110_48##13	6.79311e-19
C584	VPWR#11	a_110_48##10	6.54315e-19
C585	a_523_124#	a_762_368#	1.91769e-17
C586	a_523_124##5	A4#7	1.31481e-18
C587	X#5	a_110_48##9	1.78895e-17
C588	VPWR#6	A3#5	1.02915e-19
C589	a_523_124##4	a_523_124##10	2.71073e-19
C590	A1#2	A2#2	1.63177e-17
C591	a_110_48##16	a_110_48##3	5.93777e-19
C592	a_523_124##10	A3#4	1.08615e-18
C593	X#4	a_110_48##10	5.62871e-17
C594	VPWR#5	a_762_368##4	4.64525e-17
C595	a_762_368#	A2#2	1.99918e-18
C596	a_523_124##3	VGND#12	1.5631e-17
C597	VPWR#11	a_110_48##6	1.53981e-19
C598	a_110_48##10	VPWR#9	2.8887e-17
C599	A4#7	VGND#13	1.74812e-17
C600	a_523_124##9	a_523_124##2	7.67465e-20
C601	VGND#8	X#7	7.00755e-18
C602	VGND#12	A3#4	1.10207e-19
C603	a_110_48##15	VPWR#6	3.84473e-18
C604	X#4	a_110_48##6	1.65985e-18
C605	X#1	a_110_48##10	2.06127e-18
C606	X#5	a_110_48##7	1.22072e-19
C607	VPWR#2	A4#5	2.25935e-20
C608	a_523_124##10	A4#7	2.75818e-17
C609	A4	A4#4	2.20657e-17
C610	VPWR#1	a_762_368##2	4.63272e-21
C611	a_110_48##15	B1#3	7.31774e-18
C612	a_110_48##6	VPWR#9	2.41323e-17
C613	a_523_124##4	a_523_124##3	7.82825e-19
C614	a_110_48##3	B1#4	1.26058e-17
C615	a_523_124##2	A1#2	6.54291e-19
C616	a_523_124##4	VGND#12	1.56315e-17
C617	VGND#13	A4#1	6.96562e-19
C618	VGND#6	a_523_124##7	3.53432e-17
C619	VPWR#1	a_1213_368##2	3.20757e-19
C620	VPWR#8	a_110_48##11	5.51539e-20
C621	A1#3	A1#2	7.36131e-19
C622	X#1	a_110_48##6	6.53142e-17
C623	VGND#1	a_762_368#	5.23424e-18
C624	a_523_124##5	VGND#13	6.28885e-18
C625	a_523_124##3	a_523_124##9	8.12595e-19
C626	VGND#12	A4#7	2.27781e-18
C627	a_762_368##4	a_851_368##2	7.71844e-17
C628	a_523_124##2	VGND#11	1.39258e-17
C629	VPWR#9	a_110_48#	3.44144e-19
C630	VGND#8	VGND#14	3.3939e-19
C631	VGND#6	a_523_124##5	3.0459e-17
C632	a_110_48##16	a_110_48##9	8.10734e-20
C633	VPWR#6	B1#4	3.25422e-20
C634	VGND#13	A4#4	3.23421e-19
C635	A4#1	a_523_124##10	1.14798e-17
C636	a_1213_368#	VPWR#1	4.03139e-17
C637	X#5	a_110_48##5	1.22639e-19
C638	a_110_48##16	VPWR#6	1.70977e-19
C639	X#1	a_110_48#	6.62599e-17
C640	a_523_124##9	A4#7	2.17355e-19
C641	a_110_48##16	a_110_48##11	1.19138e-19
C642	VGND#11	A2#5	6.99881e-19
C643	a_762_368#	VPWR#1	4.89742e-17
C644	VGND#13	A3#2	3.26921e-19
C645	VPWR#2	A4#6	3.0531e-18
C646	VGND#7	a_523_124##7	1.828e-17
C647	a_523_124##5	a_523_124##10	1.98278e-18
C648	B1#3	A3#5	5.64022e-18
C649	a_110_48##14	a_762_368##4	6.8998e-17
C650	a_110_48#	VPWR#7	2.93482e-17
C651	a_110_48##12	a_110_48##9	3.90178e-17
C652	a_523_124##8	A2#5	5.73773e-18
C653	VGND#12	A4#1	2.69467e-17
C654	a_523_124##3	VGND#11	1.05314e-17
C655	a_110_48##3	B1#7	2.20822e-18
C656	a_110_48##16	a_110_48##15	4.05239e-18
C657	VGND#10	A2#5	1.59716e-17
C658	X#1	B1#5	2.10522e-18
C659	a_523_124##10	A3#2	9.48083e-19
C660	a_523_124##2	a_523_124##8	3.15115e-19
C661	B1	B1#3	2.29845e-17
C662	A2#5	a_523_124#	2.75702e-17
C663	a_110_48##16	a_110_48##7	1.16953e-19
C664	VGND#7	a_110_48##4	1.24819e-18
C665	a_523_124##9	A4#1	5.1279e-19
C666	a_110_48##14	a_851_368##2	2.93747e-18
C667	B1#5	VPWR#7	2.21804e-17
C668	VPWR#5	a_110_48#	3.24474e-19
C669	B1	A4#4	3.88175e-18
C670	a_110_48##16	B1#3	1.24016e-17
C671	VGND#13	a_523_124##10	2.90009e-17
C672	X#5	VGND#9	4.66703e-17
C673	VGND#12	A3#2	3.10136e-17
C674	a_110_48##9	a_110_48##7	2.84965e-17
C675	B1#5	a_110_48##18	1.77983e-17
C676	a_762_368##4	a_110_48#	7.96625e-20
C677	A3#5	A4#4	1.05129e-17
C678	VPWR#2	A3#1	5.4924e-18
C679	A2#5	A1#2	3.84556e-19
C680	a_110_48##4	VPWR#6	3.12308e-19
C681	a_523_124##10	A2#4	2.3953e-19
C682	VPWR#7	B1#6	7.31273e-19
C683	a_762_368##4	a_762_368##2	8.1953e-19
C684	a_523_124##4	A3#3	1.67024e-18
C685	VPWR#5	B1#5	7.43414e-19
C686	A3#2	a_523_124##9	1.61518e-17
C687	a_110_48##16	a_110_48##5	3.69972e-19
C688	a_523_124##2	VGND#10	1.63529e-17
C689	X#1	A3#5	3.36945e-20
C690	X#1	a_110_48##3	2.85195e-18
C691	VGND#13	VGND#12	5.25604e-18
C692	B1#6	a_110_48##18	1.77983e-17
C693	X#5	X#6	5.88316e-19
C694	a_110_48##16	B1#4	2.54869e-17
C695	VGND#12	A2#4	1.97094e-18
C696	a_523_124##4	A4#4	6.80746e-18
C697	a_110_48##7	a_110_48##5	3.92737e-17
C698	VPWR#7	A3#5	1.38804e-19
C699	B1#6	VPWR#5	2.65547e-17
C700	a_762_368##2	a_851_368##2	3.78465e-18
C701	VGND#11	A3#2	1.69219e-18
C702	a_851_368#	a_110_48##14	6.98897e-19
C703	VGND#2	a_523_124##2	2.73186e-19
C704	A1#2	VPWR#4	4.2604e-19
C705	VGND#6	B1#3	6.06013e-20
C706	VPWR#2	A2#6	5.81958e-18
C707	a_762_368##4	B1#6	1.09785e-18
C708	A2#4	a_523_124##9	1.34442e-17
C709	a_523_124##4	A4#3	2.10208e-17
C710	VGND#6	B1#4	3.1668e-21
C711	a_110_48##16	B1#7	1.10915e-17
C712	VGND#4	A3#3	3.74832e-18
C713	a_523_124##10	VGND#12	3.00055e-17
C714	a_523_124##8	A3#2	2.6216e-19
C715	VPWR#5	A3#5	1.05638e-18
C716	VGND#5	A3#3	6.74399e-17
C717	X#5	VGND#15	1.92384e-17
C718	a_762_368##2	a_110_48##14	2.74088e-17
C719	VGND#1	a_523_124##8	3.50247e-18
C720	a_110_48##5	B1#7	4.4937e-18
C721	VGND#7	A3#3	1.86082e-19
C722	VGND#11	A2#4	2.73879e-17
C723	VGND#4	a_523_124##10	2.71439e-18
C724	a_762_368##4	A3#5	6.95932e-17
C725	a_523_124##2	A1#3	5.23155e-18
C726	VGND#3	a_523_124##2	2.73186e-19
C727	VGND#12	VGND#3	1.18375e-18
C728	a_523_124##9	A1#4	5.05891e-19
C729	VGND#1	a_523_124#	9.26567e-18
C730	a_851_368##2	A3#5	3.59541e-17
C731	a_523_124##10	a_523_124##9	2.88527e-18
C732	a_762_368##2	a_851_368#	8.5395e-17
C733	a_523_124##8	A2#4	2.49886e-18
C734	a_110_48##16	B1#1	3.32835e-18
C735	VPWR#2	A1#6	4.99733e-18
C736	X#4	VPWR#8	8.44749e-18
C737	a_762_368##4	A4#5	1.29253e-17
C738	a_110_48##14	A3#5	1.87028e-17
C739	a_110_48##16	A4#4	1.10452e-18
C740	VGND#5	a_523_124##10	2.73951e-18
C741	A1#4	VGND#11	1.5888e-17
C742	B1#7	B1#1	3.60819e-17
C743	a_110_48##15	VPWR#3	6.49829e-18
C744	a_110_48##15	A3#4	4.86327e-19
C745	VGND#10	A2#4	6.57412e-19
C746	a_851_368##2	A4#5	4.6662e-17
C747	VPWR#9	VPWR#6	1.94092e-18
C748	a_523_124##2	A2#5	2.68195e-19
C749	a_1213_368#	A1#2	1.98434e-19
C750	VGND#12	a_523_124##9	2.95411e-17
C751	VGND#3	a_523_124##3	2.5435e-19
C752	a_762_368##4	A4#6	2.02438e-19
C753	a_523_124##8	A1#4	2.72373e-17
C754	VGND#3	a_523_124##9	2.65236e-18
C755	a_110_48##14	A4#5	3.57547e-17
C756	VGND#2	A1#3	2.02106e-19
C757	a_762_368##2	A3#5	4.29837e-19
C758	a_110_48##16	A3#4	3.94584e-19
C759	VPWR#3	B1#4	8.22429e-20
C760	a_523_124##4	a_110_48##14	5.65783e-18
C761	a_523_124#	A2#4	2.61039e-19
C762	VGND#3	A1#3	1.22277e-19
C763	VGND#11	A1#5	7.53534e-19
C764	X#4	VPWR#10	8.49699e-18
C765	VPWR#10	a_110_48##10	5.30308e-19
C766	VPWR#10	a_110_48##11	4.07541e-20
C767	VPWR#10	a_110_48##6	8.1728e-20
C768	VPWR	VPWR#10	7.98753e-17
C769	VPWR#10	VNB	4.3153e-17
C770	X#2	VPWR#10	2.42734e-19
C771	X	VPWR#10	1.25921e-17
C772	VPWR#10	a_110_48##13	5.8178e-18
C773	VPWR#10	VPWR#8	6.93668e-19
*
*
.ENDS sky130_fd_sc_hs__o41a_4
*
