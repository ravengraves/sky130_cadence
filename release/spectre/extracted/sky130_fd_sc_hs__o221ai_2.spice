* Extracted by Quantus, converted by sky130cad/quantus.py
*
*
*
*                       LINUX           Wed Nov 18 08:58:01 2026
*
*
*
*  PROGRAM  advgen
*
*  Name           : advgen - Quantus - (64-bit)
*  Version        : 25.1.0-p047
*  Build Date     : Thu Dec 11 23:20:30 PST 2025
*
*  HSPICE LIBRARY
*
*  OPERATING_TEMPERATURE 150
*  QRC_TECH_DIR <path>/tech
*
*
*

*
.SUBCKT sky130_fd_sc_hs__o221ai_2 VNB VPB VGND VPWR Y C1 B1 B2 A1 A2
*
*
*  caps2d version: 10
*
*
*       TRANSISTOR CARDS
*
*
XM5 Y#6 C1#6 a_27_74##5 VNB sky130_fd_pr__nfet_01v8_lvt l=0.15 w=0.74 ad=0.2072 as=0.2109 pd=2.04 ps=2.05
XM18 a_27_74##3 C1#5 Y#6 VNB sky130_fd_pr__nfet_01v8_lvt l=0.15 w=0.74 ad=0.2109 as=0.2072 pd=2.05 ps=2.04
XM4 a_311_85##6 B1#1 a_27_74##6 VNB sky130_fd_pr__nfet_01v8_lvt l=0.15 w=0.74 ad=0.2109 as=0.2072 pd=2.05 ps=2.04
XM8 a_27_74##6 B2#6 a_311_85##8 VNB sky130_fd_pr__nfet_01v8_lvt l=0.15 w=0.74 ad=0.2072 as=0.2072 pd=2.04 ps=2.04
XM12 a_311_85##8 B2#1 a_27_74# VNB sky130_fd_pr__nfet_01v8_lvt l=0.15 w=0.74 ad=0.2072 as=0.2997 pd=2.04 ps=2.29
XM7 a_27_74# B1#4 a_311_85##3 VNB sky130_fd_pr__nfet_01v8_lvt l=0.15 w=0.74 ad=0.2997 as=0.2072 pd=2.29 ps=2.04
XM6 a_311_85##3 A1#3 VGND#6 VNB sky130_fd_pr__nfet_01v8_lvt l=0.15 w=0.74 ad=0.2072 as=0.2812 pd=2.04 ps=2.24
XM9 a_311_85##7 A2#5 VGND#6 VNB sky130_fd_pr__nfet_01v8_lvt l=0.15 w=0.74 ad=0.2442 as=0.2812 pd=2.14 ps=2.24
XM10 VGND#5 A2#1 a_311_85##7 VNB sky130_fd_pr__nfet_01v8_lvt l=0.15 w=0.74 ad=0.2516 as=0.2442 pd=2.16 ps=2.14
XM19 VGND#5 A1#4 a_311_85# VNB sky130_fd_pr__nfet_01v8_lvt l=0.15 w=0.74 ad=0.2516 as=0.2146 pd=2.16 ps=2.06
XM2 VPWR#5 C1#7 Y#4 VPB sky130_fd_pr__pfet_01v8 l=0.15 w=1.12 ad=0.3304 as=0.336 pd=2.83 ps=2.84
XM13 Y#4 C1#1 VPWR#7 VPB sky130_fd_pr__pfet_01v8 l=0.15 w=1.12 ad=0.336 as=0.7392 pd=2.84 ps=3.56
XM0 a_376_368##2 B1#3 VPWR#7 VPB sky130_fd_pr__pfet_01v8 l=0.15 w=1.12 ad=0.3752 as=0.7392 pd=2.91 ps=3.56
XM15 Y#2 B2#4 a_376_368##2 VPB sky130_fd_pr__pfet_01v8 l=0.15 w=1.12 ad=0.3528 as=0.3752 pd=2.87 ps=2.91
XM16 a_376_368# B2#5 Y#2 VPB sky130_fd_pr__pfet_01v8 l=0.15 w=1.12 ad=0.392 as=0.3528 pd=2.94 ps=2.87
XM1 VPWR#6 B1#6 a_376_368# VPB sky130_fd_pr__pfet_01v8 l=0.15 w=1.12 ad=0.448 as=0.392 pd=3.04 ps=2.94
XM17 VPWR#6 A1#1 a_776_368##2 VPB sky130_fd_pr__pfet_01v8 l=0.15 w=1.12 ad=0.448 as=0.392 pd=3.04 ps=2.94
XM11 Y#1 A2#7 a_776_368##2 VPB sky130_fd_pr__pfet_01v8 l=0.15 w=1.12 ad=0.336 as=0.392 pd=2.84 ps=2.94
XM3 a_776_368# A2#6 Y#1 VPB sky130_fd_pr__pfet_01v8 l=0.15 w=1.12 ad=0.336 as=0.336 pd=2.84 ps=2.84
XM14 a_776_368# A1#6 VPWR#1 VPB sky130_fd_pr__pfet_01v8 l=0.15 w=1.12 ad=0.336 as=0.3864 pd=2.84 ps=2.93
*
*
*       RESISTOR AND CAP/DIODE CARDS
*
Rg1	C1#1	C1#2	488.978058
Rg2	C1#2	C1#3	77.291557
Rg3	C1#3	C1#4	50.075356
Rg4	C1#2	C1#5	387.163208
Rg5	C1#3	C1#6	370.459167
Rg6	C1#3	C1#7	472.309845
Rg7	B1#1	B1#2	323.304688
Rg8	B1#2	B1#3	429.126801
Rg9	B2#1	B2#2	345.464905
Rg10	B2#2	B2#3	54.632076
Rg11	B2#3	B2#4	539.747803
Rg12	B2#2	B2#5	429.126801
Rg13	B2#3	B2#6	459.685944
Rg14	B1#4	B1#5	350.977325
Rg15	B1#5	B1#6	434.639221
Rg16	A1#1	A1#2	442.817719
Rg17	A1#2	A1#3	363.395935
Rg18	A2#1	A2#2	365.993317
Rg19	A2#2	A2#3	30.596949
Rg20	A2#3	A2#4	22.738758
Rg21	A2#4	A2#5	365.993317
Rg22	A2#2	A2#6	449.655212
Rg23	A2#4	A2#7	449.655212
Rg24	A1#4	A1#5	350.977325
Rg25	A1#5	A1#6	434.639221
Rf1	C1	C1#4	168.106262
Rf2	B2#7	B2#2	160.920410
Rf3	B2	B2#9	0.687606
Rf4	B2#7	B2#9	5.905091
Rf5	a_376_368#	a_376_368##2	104.092987
Rf6	a_27_74#	a_27_74##2	83.582428
Rf7	a_27_74##2	a_27_74##4	82.310654
Rf8	a_27_74##4	a_27_74##5	106.110001
Rf9	a_27_74##2	a_27_74##6	25.213726
Rf10	a_27_74##3	a_27_74##4	7.500000
Rf11	B1#5	B1	262.994263
Rf12	B1	B1#8	1.996126
Rf13	B1#8	B1	6.335529
Rf14	Y#1	Y#3	149.554764
Rf15	Y#3	Y#5	119.036362
Rf16	Y#5	Y	2.529711
Rf17	Y#5	Y	17.702692
Rf18	Y	Y#6	18.093828
Rf19	Y#5	Y	19.186016
Rf20	Y#2	Y#3	15.000000
Rf21	Y#4	Y#5	5.000000
Rf22	A2#3	A2#9	160.996811
Rf23	A2#10	A2	0.764007
Rf24	A2#9	A2#10	5.905091
Rf25	a_776_368#	a_776_368##2	99.632896
Rf26	A1	A1#2	272.610107
Rf27	A1	A1#5	163.051331
Rf28	a_311_85#	a_311_85##2	87.996284
Rf29	a_311_85##2	a_311_85##4	80.232536
Rf30	a_311_85##4	a_311_85##5	92.363838
Rf31	a_311_85##5	a_311_85##6	83.658142
Rf32	a_311_85##2	a_311_85##7	16.083078
Rf33	a_311_85##5	a_311_85##8	24.075169
Rf34	a_311_85##3	a_311_85##4	7.500000
Rf35	VPWR#1	VPWR#2	170.302231
Rf36	VPWR#2	VPWR#3	47.458290
Rf37	VPWR#3	VPWR#4	109.940987
Rf38	VPWR#4	VPWR#5	125.353287
Rf39	VPWR#2	VPWR#6	32.342297
Rf40	VPWR#4	VPWR#7	16.867140
Rf42	VGND#2	VGND#3	73.001427
Rf43	VGND#3	VGND#4	85.079300
Rf44	VGND#2	VGND#5	37.460041
Rf45	VGND#3	VGND#6	37.460041
Rf49	B1#2	B1#8	160.232803
Re1	VPWR#3	VPWR	0.818510
Re2	VGND	VGND#4	0.818540
*
*       CAPACITOR CARDS
*
*
C1	a_27_74##6	a_27_74#	4.0255e-18
C2	VGND#3	A1#3	2.14047e-18
C3	a_311_85#	VPWR#1	2.21209e-19
C4	a_311_85##2	A1#4	1.83849e-18
C5	A2#4	A1#5	2.44818e-17
C6	VGND#3	A2#4	6.79891e-20
C7	a_311_85##2	A2#1	4.7959e-17
C8	VPWR#4	VPWR#2	2.10002e-19
C9	a_311_85##6	a_27_74##6	2.74963e-17
C10	VGND#3	a_311_85##2	7.87865e-18
C11	a_311_85##5	A1#3	1.90599e-19
C12	a_311_85##2	A2#5	3.63604e-17
C13	a_27_74##3	a_27_74##6	3.82074e-18
C14	a_311_85##5	B1#4	5.46838e-19
C15	a_311_85##2	A1#3	5.70307e-19
C16	a_27_74##3	a_311_85##6	4.89074e-17
C17	a_311_85##5	B2#1	2.16438e-17
C18	a_311_85##3	Y#1	1.98976e-18
C19	A1#2	A2#4	3.41791e-17
C20	a_311_85##5	B2#6	1.79645e-17
C21	a_27_74##5	a_27_74##3	2.34428e-18
C22	a_27_74##5	Y#6	6.32151e-19
C23	a_311_85##5	B1#1	1.29176e-18
C24	a_311_85##3	Y#2	2.70538e-18
C25	a_776_368#	VPWR#1	1.06625e-16
C26	a_311_85#	A1#4	3.03852e-17
C27	B2#3	B2#2	2.53647e-18
C28	VPWR#2	A2#4	2.25602e-20
C29	VGND#5	A1#4	3.69138e-17
C30	a_311_85#	A2#1	8.75885e-19
C31	a_776_368#	Y#1	4.85579e-17
C32	A2#1	VGND#5	2.02312e-17
C33	a_27_74##2	B2#1	6.50689e-18
C34	VGND#6	A1#4	3.71334e-19
C35	a_776_368##2	a_776_368#	2.7787e-18
C36	VPWR#6	VPWR#1	3.95689e-20
C37	A2#1	a_311_85##7	1.66416e-17
C38	B1#2	B2#3	2.74081e-17
C39	VGND#5	A2#5	1.36203e-18
C40	VPWR#4	C1#2	4.05316e-20
C41	VGND#6	A2#1	1.52283e-18
C42	Y#1	a_776_368##2	6.29862e-17
C43	C1#2	B1#2	7.92514e-18
C44	a_27_74##2	B2#6	1.50856e-17
C45	A2#5	a_311_85##7	1.67997e-17
C46	VGND#5	A1#3	3.62338e-19
C47	a_311_85##3	A2#1	2.18577e-19
C48	VPWR#2	A2#7	4.46413e-18
C49	Y#1	VPWR#6	2.5332e-17
C50	A2#5	VGND#6	2.35442e-17
C51	a_27_74##2	B1#1	1.20829e-17
C52	A2#10	A1#6	4.12912e-19
C53	VPWR#4	A1#1	1.79542e-20
C54	a_311_85##3	A2#5	1.34955e-18
C55	VPWR#6	a_776_368##2	3.88749e-17
C56	A1#3	VGND#6	2.3927e-17
C57	VPWR#2	A1#1	4.20654e-18
C58	Y#2	Y#1	9.01373e-19
C59	C1#4	C1#2	5.44602e-18
C60	A2#10	A2#6	1.07896e-19
C61	a_311_85##3	A1#3	5.35424e-17
C62	VPWR#4	B1#6	2.95914e-20
C63	a_311_85##2	A2#9	3.6455e-17
C64	a_376_368#	VPWR#6	3.88989e-17
C65	a_27_74#	A1#3	1.26397e-18
C66	VPWR#2	B1#6	4.1987e-18
C67	a_311_85##3	B1#4	2.1501e-17
C68	a_27_74##5	VPWR#5	1.66276e-19
C69	A2#10	A2#7	1.18719e-18
C70	Y#2	VPWR#6	2.46785e-17
C71	a_27_74#	B1#4	4.41759e-17
C72	VPWR#4	B2#5	9.5749e-20
C73	a_311_85##3	B2#1	4.41555e-19
C74	a_376_368#	Y#2	6.53242e-17
C75	a_311_85##2	A2#4	5.08151e-18
C76	C1#2	B1#1	2.85623e-19
C77	A2#10	A1#1	3.77634e-19
C78	a_27_74#	B2#1	2.73764e-17
C79	a_27_74##6	B1#4	2.87859e-19
C80	a_376_368##2	a_376_368#	2.54825e-18
C81	VPWR#4	B2#4	1.87862e-18
C82	B2#1	a_311_85##8	1.44168e-17
C83	a_27_74#	B2#6	7.93412e-19
C84	Y#2	a_376_368##2	6.66837e-17
C85	a_27_74##6	B2#1	1.18219e-18
C86	B2#6	a_311_85##8	1.44168e-17
C87	VPWR#4	B1#3	1.70805e-17
C88	a_27_74#	B1#1	3.54847e-19
C89	B2#6	a_27_74##6	1.58894e-17
C90	a_311_85##6	B2#6	1.04811e-18
C91	VPWR#4	C1#1	2.43767e-17
C92	B1#1	a_27_74##6	1.82499e-17
C93	a_27_74##3	B2#6	2.98405e-19
C94	a_311_85##5	a_27_74##2	2.53088e-17
C95	a_311_85##6	B1#1	5.37553e-17
C96	a_27_74##6	C1#5	4.70782e-19
C97	a_27_74##3	B1#1	2.62847e-18
C98	VPWR#4	C1#7	5.75581e-18
C99	a_311_85##6	C1#5	1.62271e-18
C100	a_27_74##3	C1#5	2.96658e-17
C101	a_27_74##5	B1#1	6.43218e-20
C102	C1#5	Y#6	1.46693e-17
C103	a_27_74##3	C1#6	8.62722e-19
C104	a_27_74##5	C1#5	1.82031e-18
C105	C1#6	Y#6	4.92936e-18
C106	VPWR#3	VPWR#4	6.85709e-17
C107	a_27_74##5	C1#6	4.13821e-17
C108	a_27_74##3	C1#2	4.11366e-18
C109	VGND#4	VGND#3	4.52613e-17
C110	A2#10	A2#4	8.21419e-18
C111	VPWR#3	VPWR#2	5.90422e-17
C112	A2#1	A1#4	2.93965e-17
C113	VGND#4	a_311_85##5	8.3815e-17
C114	A1#6	VPWR#1	3.07149e-17
C115	A2#5	A2#1	2.93223e-17
C116	C1#2	Y#6	4.44003e-20
C117	a_776_368#	A1#6	4.79723e-17
C118	VGND#3	a_311_85##3	2.86784e-17
C119	VPWR#1	A2#6	5.10725e-18
C120	a_776_368#	A2#6	5.348e-17
C121	A1#3	A2#5	2.52349e-17
C122	a_311_85##2	A1#5	9.92978e-19
C123	VPWR#1	A2#7	9.53846e-20
C124	A2#6	Y#1	2.32311e-17
C125	VPWR#6	A1#6	8.45547e-20
C126	a_776_368#	A2#7	1.39076e-18
C127	a_776_368##2	A2#6	4.50208e-19
C128	a_311_85##2	a_311_85#	2.98467e-18
C129	VPWR#1	A1#1	2.58109e-20
C130	A2#10	A1#5	9.22174e-19
C131	Y#1	A2#7	4.53061e-17
C132	B1#4	A1#3	3.92475e-17
C133	a_27_74##5	C1#2	3.9703e-20
C134	VPWR#6	A2#6	8.43619e-20
C135	a_776_368#	A1#1	2.1004e-19
C136	A2#9	A2#4	1.29909e-17
C137	a_776_368##2	A2#7	3.60514e-17
C138	VPWR#2	A1#2	1.4384e-20
C139	A2#9	A1#5	1.38721e-18
C140	VPWR#1	B1#6	1.53406e-20
C141	Y#1	A1#1	1.93919e-17
C142	VPWR#6	A2#7	5.79061e-19
C143	a_311_85##2	VGND#5	6.13267e-17
C144	a_776_368##2	A1#1	4.1654e-17
C145	a_311_85##2	A1#2	7.13179e-18
C146	B2#1	B1#4	1.79793e-17
C147	Y#1	B1#6	2.17231e-19
C148	A1#1	VPWR#6	3.17354e-17
C149	a_776_368#	A2#4	1.13315e-19
C150	Y#2	A2#7	1.237e-19
C151	a_311_85##5	B1#5	3.76456e-19
C152	A1	A2#4	1.202e-17
C153	a_311_85##2	a_311_85##7	3.95128e-18
C154	A1#2	A2#10	2.04375e-17
C155	Y#1	B2#5	1.15277e-19
C156	B1#6	VPWR#6	3.38323e-17
C157	B2#6	B2#1	3.87393e-17
C158	Y#2	A1#1	2.28498e-19
C159	a_311_85##5	a_311_85##3	2.29724e-18
C160	A1#2	A2#9	1.20147e-17
C161	a_376_368#	B1#6	4.64034e-17
C162	VPWR#6	B2#5	5.84103e-19
C163	a_311_85##5	B2#2	1.01857e-18
C164	Y#2	B1#6	1.98185e-17
C165	a_311_85##2	VGND#6	6.09119e-17
C166	a_376_368#	B2#5	3.61715e-17
C167	B1#1	B2#6	3.80279e-17
C168	a_376_368##2	B1#6	1.98955e-19
C169	a_311_85##5	a_27_74#	5.82582e-17
C170	VPWR#4	B1#2	3.47602e-19
C171	VPWR#6	B2#4	8.39256e-20
C172	Y#2	B2#5	4.50274e-17
C173	a_311_85#	A1#5	2.46231e-18
C174	A2#4	Y#1	1.0989e-18
C175	a_376_368#	B2#4	4.5217e-19
C176	VGND#5	A1#5	4.30817e-19
C177	VGND#4	a_311_85##3	1.36662e-17
C178	a_376_368##2	B2#5	7.15814e-19
C179	a_311_85##3	a_311_85##2	3.01045e-18
C180	VPWR#6	B1#3	6.70886e-20
C181	Y#2	B2#4	4.3056e-17
C182	C1#5	B1#1	5.09699e-18
C183	B2	B2#3	2.38713e-19
C184	a_376_368#	B1#3	1.9409e-19
C185	a_311_85##5	a_311_85##8	6.57061e-19
C186	VPWR#4	C1#4	4.38758e-20
C187	a_376_368##2	B2#4	3.72018e-17
C188	Y#2	B1#3	2.23078e-17
C189	VGND#4	a_311_85##6	4.85174e-17
C190	C1#6	C1#5	3.90638e-17
C191	a_376_368##2	B1#3	4.11745e-17
C192	VGND#4	a_27_74##3	4.25475e-17
C193	Y#2	C1#1	3.55637e-19
C194	VPWR#3	VPWR#1	4.86571e-17
C195	B1#3	VPWR#7	2.4167e-17
C196	a_311_85##5	a_27_74##6	3.33229e-17
C197	B2#7	B1#5	1.82437e-17
C198	a_376_368##2	C1#1	2.28728e-19
C199	a_776_368##2	A2#4	5.72296e-20
C200	a_27_74##2	B2#2	3.97889e-18
C201	VGND#4	a_27_74##5	5.72886e-17
C202	A2#9	a_311_85##7	4.26802e-18
C203	A1#2	VGND#6	2.09774e-18
C204	Y#2	C1#7	2.86816e-19
C205	C1#1	VPWR#7	2.5619e-17
C206	a_311_85##3	A1#2	3.86179e-17
C207	B1	B2#3	1.35631e-17
C208	C1#1	Y#4	3.68427e-18
C209	B1	C1#2	1.52584e-17
C210	B2#7	B2#2	1.21935e-17
C211	a_311_85##6	a_311_85##5	3.22697e-18
C212	a_27_74##2	B1#2	2.98331e-17
C213	VPWR#5	C1#1	1.20836e-18
C214	A1#5	VPWR#1	1.28475e-18
C215	a_376_368#	VPWR#3	4.54313e-17
C216	C1#7	Y#4	2.43542e-17
C217	a_311_85##3	B1#5	3.03469e-18
C218	a_27_74##2	B2#7	2.22486e-17
C219	B1#5	a_27_74#	4.37563e-17
C220	C1#7	VPWR#5	3.52228e-17
C221	a_376_368##2	VPWR#3	1.96259e-17
C222	A2#6	A1#6	4.59381e-17
C223	VPWR#3	VPWR#5	2.60272e-17
C224	A2#7	A2#6	4.21743e-17
C225	A1#2	Y#1	7.12557e-17
C226	A1#2	a_776_368##2	4.82599e-18
C227	A1#2	VPWR#6	2.25832e-18
C228	VGND#4	A1#4	3.58743e-20
C229	A1#1	A2#7	3.53945e-17
C230	a_311_85##6	B1#2	1.17423e-18
C231	B1#5	VPWR#6	1.90737e-18
C232	VPWR#2	VPWR#1	2.2014e-19
C233	B1#5	a_376_368#	3.36874e-18
C234	B1#6	A1#1	3.10271e-17
C235	B1#5	Y#2	6.38506e-17
C236	Y	B2#3	2.7596e-19
C237	VGND#4	B1#4	3.84649e-18
C238	Y	C1#2	1.12046e-17
C239	C1#4	Y#6	3.2716e-19
C240	VGND#4	B2#1	3.84649e-18
C241	a_376_368#	B2#2	8.46999e-20
C242	C1#4	a_27_74##5	3.50044e-17
C243	B2#5	B1#6	3.54293e-17
C244	B2#2	Y#2	8.79897e-19
C245	VGND#4	B2#6	3.84649e-18
C246	a_776_368#	VPWR#2	9.58459e-18
C247	a_376_368##2	B2#2	9.04228e-20
C248	VGND#4	B1#1	3.814e-18
C249	B1#2	Y#2	2.5304e-17
C250	VGND#4	C1#5	4.43427e-18
C251	B2#4	B2#5	4.15709e-17
C252	B1#2	a_376_368##2	1.59057e-19
C253	VGND#4	C1#6	4.43427e-18
C254	Y#1	VPWR#2	8.52754e-19
C255	B1#3	B2#4	4.06825e-17
C256	a_311_85##2	A1	2.69511e-17
C257	A2#10	A1	3.49855e-17
C258	C1#4	VPWR#5	7.36275e-18
C259	C1#1	B1#3	1.20763e-17
C260	A2#9	A1	1.53042e-17
C261	Y#2	B2#3	3.35666e-20
C262	a_776_368##2	VPWR#2	4.67803e-17
C263	VPWR#3	B2#5	4.4526e-18
C264	VPWR#4	VPWR#6	3.78956e-20
C265	A1#2	A1#6	8.76978e-20
C266	C1#7	C1#1	4.79995e-17
C267	VPWR#3	B2#4	2.87935e-18
C268	B1#2	B2#6	1.62733e-18
C269	A1#2	A2#6	1.53292e-19
C270	a_311_85#	VGND#5	4.38893e-17
C271	A1#2	A2#7	1.7867e-17
C272	A1	a_311_85#	4.74662e-17
C273	A1#2	A1#1	1.21916e-17
C274	A1	VGND#5	1.59421e-19
C275	A1#2	B1#6	2.67323e-18
C276	B1#5	A1#1	2.59235e-18
C277	B1#5	B1#6	1.21794e-17
C278	a_27_74##2	a_27_74##6	2.34782e-19
C279	a_376_368##2	B2#3	9.38582e-21
C280	B1#5	B2#5	1.63045e-17
C281	a_376_368#	VPWR#2	3.16869e-18
C282	a_27_74##2	B1	4.28201e-17
C283	B1#5	B2#4	1.66312e-19
C284	Y#2	VPWR#4	1.55554e-17
C285	a_27_74#	B2#7	1.73355e-17
C286	A1	VPWR#1	4.21691e-17
C287	B1	B2#7	1.50603e-17
C288	A1	a_776_368#	4.61867e-17
C289	A1	Y#1	2.21766e-17
C290	a_27_74##2	a_311_85##6	2.34049e-17
C291	Y	VPWR#4	9.59767e-17
C292	Y#2	VPWR#2	8.52754e-19
C293	VGND#6	VGND#5	2.96836e-18
C294	B1#2	B1#3	1.62312e-17
C295	B2#7	a_311_85##8	2.29209e-18
C296	C1#1	B1#2	5.54325e-19
C297	VPWR#3	B1#5	1.58981e-20
C298	VPWR#4	a_376_368##2	7.11702e-17
C299	a_27_74##3	B1	4.68862e-17
C300	VGND#4	B1#5	3.87647e-20
C301	C1#4	C1#1	8.35919e-19
C302	VPWR#3	B2#2	2.31659e-20
C303	VGND#4	B2#2	4.36967e-20
C304	VPWR	VPWR#4	7.34419e-17
C305	VPWR	VPWR#2	3.51264e-17
C306	VGND#4	B1#2	5.93574e-20
C307	B1#5	A1#2	8.71493e-17
C308	B1	Y#2	6.17509e-17
C309	VPWR	A2#10	2.55418e-18
C310	B1	a_376_368##2	4.01185e-19
C311	VGND#4	C1#4	7.73266e-19
C312	VPWR#4	VPWR#7	1.13951e-17
C313	B1	VPWR#7	6.09699e-18
C314	B2#2	B1#5	3.11593e-17
C315	VGND	VGND#3	4.59208e-17
C316	a_27_74##3	Y	6.34824e-17
C317	Y	Y#6	1.23099e-18
C318	A1	A1#6	1.69398e-17
C319	a_27_74##5	Y	5.4971e-17
C320	VGND	a_311_85##5	3.15572e-17
C321	A2#4	VNB	5.05891e-17
C322	A1	A2#6	2.28205e-17
C323	B2#3	VNB	1.68227e-17
C324	VGND	a_311_85##2	1.91058e-17
C325	C1#2	VNB	2.96033e-17
C326	A1	A2#7	4.61323e-19
C327	C1	VPWR#5	3.27364e-17
C328	A1	A1#1	1.48007e-19
C329	VGND	A2#9	2.80787e-18
C330	a_311_85##3	VGND#6	5.60906e-17
C331	Y	Y#2	9.97672e-19
C332	VGND	a_27_74##2	4.68754e-18
C333	Y	VPWR#7	4.17708e-18
C334	Y	Y#4	6.31116e-18
C335	VPWR	VPWR#1	5.18744e-17
C336	VGND	B2#7	2.72859e-18
C337	VPWR#5	Y	7.85885e-17
C338	B2	B1#6	4.6342e-19
C339	VPWR	a_776_368#	2.21685e-17
C340	VGND	a_311_85#	1.37836e-17
C341	VPWR	Y#1	1.13002e-17
C342	B2	B2#5	2.04792e-18
C343	VPWR	a_776_368##2	2.04971e-17
C344	VPWR	VPWR#6	1.72456e-17
C345	B2	B2#4	1.00511e-18
C346	VPWR	a_376_368#	2.10632e-17
C347	VGND	a_311_85##3	1.97556e-17
C348	VGND	a_27_74#	8.85453e-18
C349	VPWR	Y#2	1.69825e-17
C350	B1	B1#6	1.22624e-19
C351	VPWR	a_376_368##2	2.10957e-17
C352	VGND	a_27_74##6	5.21332e-18
C353	Y	B2#1	1.63604e-19
C354	VGND	a_311_85##6	1.99855e-17
C355	B1	B2#5	6.88914e-19
C356	Y	B2#6	2.3072e-19
C357	VGND	a_27_74##3	2.04289e-17
C358	VPWR	VPWR#5	3.37262e-17
C359	Y	B1#1	7.55762e-19
C360	B1	B2#4	1.86093e-17
C361	VGND	a_27_74##5	2.37702e-17
C362	Y	C1#5	1.88879e-17
C363	A1	A1#5	2.65281e-17
C364	Y	C1#6	1.27143e-17
C365	VPWR#3	B2#3	1.45512e-21
C366	B1	C1#1	8.23068e-18
C367	VPWR#5	VPWR#4	2.69902e-18
C368	B1	C1#7	1.01085e-18
C369	A1#2	A1	2.01233e-18
C370	a_311_85##3	a_27_74#	5.63267e-17
C371	C1	C1#7	2.59109e-18
C372	VGND	A1#4	3.94743e-18
C373	VGND#3	VNB	3.70963e-17
C374	Y	B2#5	2.4878e-19
C375	VGND	A2#1	7.90043e-18
C376	VPWR#4	VNB	5.47867e-17
C377	VGND	A2#5	6.29886e-18
C378	VPWR	A1#6	1.79792e-18
C379	Y	B2#4	4.04157e-19
C380	B2	B1#5	3.06738e-17
C381	VPWR#2	VNB	4.57543e-17
C382	a_311_85##5	VNB	9.37358e-18
C383	VGND	A1#3	2.86312e-18
C384	VPWR	A2#6	1.36065e-18
C385	Y	B1#3	1.50651e-18
C386	a_311_85##2	VNB	6.54339e-18
C387	B2	B2#2	5.90975e-18
C388	VPWR	A2#7	1.43849e-18
C389	Y	C1#1	3.82214e-17
C390	A2#10	VNB	2.60814e-18
C391	VPWR	A1#1	1.55761e-18
C392	A2#9	VNB	8.01725e-19
C393	Y	C1#7	3.19368e-17
C394	VPWR	B1#6	1.5598e-18
C395	B1	B1#5	2.60454e-18
C396	VGND	C1#5	3.4903e-18
C397	VPWR	B2#5	1.44057e-18
C398	VGND	C1#6	3.06876e-18
C399	B1	B2#2	2.77309e-18
C400	a_27_74##2	VNB	2.20535e-18
C401	VPWR	B2#4	1.54011e-18
C402	VPWR	B1#3	1.42686e-18
C403	B2#7	VNB	4.30572e-19
C404	B1	B1#2	1.08958e-17
C405	a_311_85#	VNB	4.21169e-17
C406	VPWR	C1#1	3.35094e-20
C407	VGND#5	VNB	2.24685e-18
C408	B1	C1#4	2.38824e-19
C409	VPWR	C1#7	4.74462e-18
C410	VGND#6	VNB	3.81629e-18
C411	a_311_85##3	VNB	9.91715e-18
C412	a_27_74#	VNB	2.90166e-18
C413	VPWR	VPWR#3	1.69923e-17
C414	a_311_85##6	VNB	1.05881e-17
C415	a_27_74##3	VNB	1.49542e-17
C416	C1	C1#4	1.04804e-17
C417	a_27_74##5	VNB	4.49265e-17
C418	VPWR#1	VNB	7.85675e-17
C419	a_776_368#	VNB	3.76136e-18
C420	Y	B2#2	6.73663e-20
C421	a_776_368##2	VNB	3.23213e-18
C422	VPWR#6	VNB	3.68318e-18
C423	Y	B1#2	5.1448e-19
C424	a_376_368#	VNB	3.43941e-18
C425	VPWR	A1#2	5.64163e-18
C426	a_376_368##2	VNB	3.50624e-18
C427	Y	C1#4	4.13504e-17
C428	VPWR	B1#5	5.09721e-18
C429	VPWR#5	VNB	7.44996e-17
C430	VGND	VGND#4	6.43406e-17
C431	A1#4	VNB	3.6992e-17
C432	A2#1	VNB	3.08927e-17
C433	A2#5	VNB	3.11828e-17
C434	VPWR	B1#2	2.41986e-18
C435	A1#3	VNB	2.80111e-17
C436	B1#4	VNB	2.71678e-17
C437	VGND#3	A2#5	8.64867e-19
C438	B2#1	VNB	2.628e-17
C439	VGND	A1#2	3.62166e-18
C440	B2#6	VNB	2.59064e-17
C441	B1#1	VNB	3.31442e-17
C442	VGND	B1#5	4.44582e-18
C443	C1#5	VNB	3.25659e-17
C444	C1#6	VNB	3.6412e-17
C445	A1#6	VNB	4.20718e-17
C446	VGND	B1#2	2.25242e-18
C447	B1	B2	2.84092e-17
C448	A2#6	VNB	3.33239e-17
C449	A2#7	VNB	3.35156e-17
C450	VGND	C1#4	4.67349e-18
C451	A1#1	VNB	3.27159e-17
C452	B1#6	VNB	3.28595e-17
C453	B2#5	VNB	3.2521e-17
C454	B2#4	VNB	3.33342e-17
C455	B1#3	VNB	3.24134e-17
C456	C1#1	VNB	3.64117e-17
C457	C1#7	VNB	4.40519e-17
C458	VPWR#3	VNB	2.61566e-16
C459	VPWR	A1	9.33083e-18
C460	VGND#4	VNB	3.51227e-16
C461	Y	B1	1.09877e-16
C462	A1#5	VNB	4.63835e-17
C463	VPWR	B2	2.50819e-18
C464	A1#2	VNB	3.3911e-17
C465	C1	Y	2.84717e-17
C466	B1#5	VNB	3.34304e-17
C467	VGND	A1	6.76428e-18
C468	VPWR	B1	7.01809e-18
C469	B2#2	VNB	2.98782e-17
C470	B1#2	VNB	4.10226e-17
C471	VPWR	C1	1.41012e-18
C472	C1#4	VNB	7.04116e-17
C473	VGND	B1	8.17113e-18
C474	VPWR	Y	1.98673e-17
C475	VGND	Y	8.21426e-18
C476	A1	VNB	3.72544e-17
C477	B2	VNB	2.02507e-18
C478	B1	VNB	6.7935e-18
C479	C1	VNB	1.28344e-17
C480	Y	VNB	1.16471e-17
C481	VPWR	VNB	7.05366e-17
C482	VGND	VNB	9.37292e-17
C483	VGND#4	C1#2	3.06547e-20
C484	VGND#2	VNB	4.9773e-17
C485	VGND#3	VGND#2	1.38123e-18
C486	VGND	VGND#2	5.27135e-17
C487	VGND#2	a_311_85#	1.5093e-17
C488	VGND#2	A2#4	5.3938e-20
C489	VGND#2	A2#1	2.40353e-18
C490	VGND#2	A1#4	1.12853e-18
C491	VGND#2	a_311_85##2	7.19735e-18
C492	VGND#2	A1#5	5.66576e-20
C493	VGND#4	VGND#2	5.26508e-17
*
*
.ENDS sky130_fd_sc_hs__o221ai_2
*
