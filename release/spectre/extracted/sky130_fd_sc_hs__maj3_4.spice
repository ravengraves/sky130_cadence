* Extracted by Quantus, converted by sky130cad/quantus.py
*
*
*
*                       LINUX           Wed Nov 18 08:42:46 2026
*
*
*
*  PROGRAM  advgen
*
*  Name           : advgen - Quantus - (64-bit)
*  Version        : 25.1.0-p047
*  Build Date     : Thu Dec 11 23:20:30 PST 2025
*
*  HSPICE LIBRARY
*
*  OPERATING_TEMPERATURE 150
*  QRC_TECH_DIR <path>/tech
*
*
*

*
.SUBCKT sky130_fd_sc_hs__maj3_4 VPB VNB VGND VPWR X B C A
*
*
*  caps2d version: 10
*
*
*       TRANSISTOR CARDS
*
*
XM13 a_114_125##2 A#4 VGND#8 VNB sky130_fd_pr__nfet_01v8_lvt l=0.15 w=0.64 ad=0.34975 as=0.1824 pd=2.63 ps=1.85
XM8 a_219_392##22 B#6 a_114_125##2 VNB sky130_fd_pr__nfet_01v8_lvt l=0.15 w=0.64 ad=0.1792 as=0.34975 pd=1.84 ps=2.63
XM26 a_114_125# B#1 a_219_392##22 VNB sky130_fd_pr__nfet_01v8_lvt l=0.15 w=0.64 ad=0.224 as=0.1792 pd=1.98 ps=1.84
XM24 VGND#12 A#3 a_114_125# VNB sky130_fd_pr__nfet_01v8_lvt l=0.15 w=0.64 ad=0.1792 as=0.224 pd=1.84 ps=1.98
XM25 VGND#12 C#4 a_504_125##2 VNB sky130_fd_pr__nfet_01v8_lvt l=0.15 w=0.64 ad=0.1792 as=0.2176 pd=1.84 ps=1.96
XM30 a_504_125##2 B#12 a_219_392##24 VNB sky130_fd_pr__nfet_01v8_lvt l=0.15 w=0.64 ad=0.2176 as=0.1792 pd=1.96 ps=1.84
XM29 a_219_392##24 B#11 a_504_125# VNB sky130_fd_pr__nfet_01v8_lvt l=0.15 w=0.64 ad=0.1792 as=0.324175 pd=1.84 ps=2.64
XM11 a_504_125# C#3 VGND#11 VNB sky130_fd_pr__nfet_01v8_lvt l=0.15 w=0.64 ad=0.324175 as=0.224 pd=2.64 ps=1.98
XM31 a_906_78##2 A#8 VGND#11 VNB sky130_fd_pr__nfet_01v8_lvt l=0.15 w=0.64 ad=0.266275 as=0.224 pd=2.41 ps=1.98
XM21 a_219_392##15 C#11 a_906_78##2 VNB sky130_fd_pr__nfet_01v8_lvt l=0.15 w=0.64 ad=0.1792 as=0.266275 pd=1.84 ps=2.41
XM20 a_906_78# C#6 a_219_392##15 VNB sky130_fd_pr__nfet_01v8_lvt l=0.15 w=0.64 ad=0.1792 as=0.1792 pd=1.84 ps=1.84
XM4 VGND#10 A#7 a_906_78# VNB sky130_fd_pr__nfet_01v8_lvt l=0.15 w=0.64 ad=0.2589 as=0.1792 pd=2.2 ps=1.84
XM7 VGND#10 a_219_392##12 X#6 VNB sky130_fd_pr__nfet_01v8_lvt l=0.15 w=0.74 ad=0.2589 as=0.2368 pd=2.2 ps=2.12
XM16 X#6 a_219_392##10 VGND#9 VNB sky130_fd_pr__nfet_01v8_lvt l=0.15 w=0.74 ad=0.2368 as=0.2072 pd=2.12 ps=2.04
XM23 VGND#9 a_219_392##8 X#4 VNB sky130_fd_pr__nfet_01v8_lvt l=0.15 w=0.74 ad=0.2072 as=0.2072 pd=2.04 ps=2.04
XM12 X#4 a_219_392# VGND#1 VNB sky130_fd_pr__nfet_01v8_lvt l=0.15 w=0.74 ad=0.2072 as=0.1962 pd=2.04 ps=2.05
XM27 VPWR#8 A#5 a_119_392##2 VPB sky130_fd_pr__pfet_01v8 l=0.15 w=1 ad=0.295 as=0.35 pd=2.59 ps=2.7
XM19 a_219_392##20 B#4 a_119_392##2 VPB sky130_fd_pr__pfet_01v8 l=0.15 w=1 ad=0.3 as=0.35 pd=2.6 ps=2.7
XM1 a_119_392# B#5 a_219_392##20 VPB sky130_fd_pr__pfet_01v8 l=0.15 w=1 ad=0.3 as=0.3 pd=2.6 ps=2.6
XM5 a_119_392# A#1 VPWR#12 VPB sky130_fd_pr__pfet_01v8 l=0.15 w=1 ad=0.3 as=0.36 pd=2.6 ps=2.72
XM17 VPWR#12 C#5 a_501_392##2 VPB sky130_fd_pr__pfet_01v8 l=0.15 w=1 ad=0.36 as=0.3 pd=2.72 ps=2.6
XM10 a_219_392##23 B#10 a_501_392##2 VPB sky130_fd_pr__pfet_01v8 l=0.15 w=1 ad=0.35 as=0.3 pd=2.7 ps=2.6
XM2 a_501_392# B#7 a_219_392##23 VPB sky130_fd_pr__pfet_01v8 l=0.15 w=1 ad=0.35 as=0.35 pd=2.7 ps=2.7
XM15 a_501_392# C#1 VPWR#11 VPB sky130_fd_pr__pfet_01v8 l=0.15 w=1 ad=0.35 as=0.42 pd=2.7 ps=2.84
XM28 a_905_392##2 A#10 VPWR#11 VPB sky130_fd_pr__pfet_01v8 l=0.15 w=1 ad=0.3 as=0.42 pd=2.6 ps=2.84
XM6 a_905_392##2 C#9 a_219_392##17 VPB sky130_fd_pr__pfet_01v8 l=0.15 w=1 ad=0.3 as=0.3 pd=2.6 ps=2.6
XM9 a_219_392##17 C#10 a_905_392# VPB sky130_fd_pr__pfet_01v8 l=0.15 w=1 ad=0.3 as=0.3 pd=2.6 ps=2.6
XM22 VPWR#10 A#6 a_905_392# VPB sky130_fd_pr__pfet_01v8 l=0.15 w=1 ad=0.3868 as=0.3 pd=2.95 ps=2.6
XM18 VPWR#10 a_219_392##6 X#3 VPB sky130_fd_pr__pfet_01v8 l=0.15 w=1.12 ad=0.3868 as=0.336 pd=2.95 ps=2.84
XM0 X#3 a_219_392##11 VPWR#9 VPB sky130_fd_pr__pfet_01v8 l=0.15 w=1.12 ad=0.336 as=0.336 pd=2.84 ps=2.84
XM14 VPWR#9 a_219_392##9 X#1 VPB sky130_fd_pr__pfet_01v8 l=0.15 w=1.12 ad=0.336 as=0.336 pd=2.84 ps=2.84
XM3 X#1 a_219_392##7 VPWR#1 VPB sky130_fd_pr__pfet_01v8 l=0.15 w=1.12 ad=0.336 as=0.3304 pd=2.84 ps=2.83
*
*
*       RESISTOR AND CAP/DIODE CARDS
*
Rg1	B#1	B#2	267.459717
Rg2	B#2	B#3	32.826973
Rg3	B#3	B#4	473.800873
Rg4	B#2	B#5	430.617126
Rg5	B#3	B#6	322.727051
Rg6	A#1	A#2	412.311401
Rg7	A#2	A#3	396.096466
Rg8	A#3	A#4	1717.163208
Rg9	A#4	A#5	794.658203
Rg10	B#7	B#8	511.701172
Rg11	B#8	B#9	60.521545
Rg12	B#9	B#10	436.889557
Rg13	B#8	B#11	348.543762
Rg14	B#9	B#12	273.732178
Rg15	C#1	C#2	440.192200
Rg16	C#2	C#3	411.892365
Rg17	C#3	C#4	1513.985107
Rg18	C#4	C#5	798.663513
Rg19	C#6	C#7	366.028107
Rg20	C#7	C#8	50.683090
Rg21	C#8	C#9	389.432373
Rg22	C#7	C#10	415.059082
Rg23	C#8	C#11	340.202179
Rg24	A#6	A#7	807.708923
Rg25	A#7	A#8	1408.065063
Rg26	A#8	A#9	481.037659
Rg27	A#9	A#10	408.386017
Rg28	a_219_392#	a_219_392##2	377.236847
Rg29	a_219_392##2	a_219_392##3	62.750622
Rg30	a_219_392##3	a_219_392##4	100.051880
Rg31	a_219_392##4	a_219_392##5	43.804100
Rg32	a_219_392##5	a_219_392##6	454.573547
Rg33	a_219_392##2	a_219_392##7	506.159149
Rg34	a_219_392##3	a_219_392##8	350.753876
Rg35	a_219_392##3	a_219_392##9	439.702454
Rg36	a_219_392##4	a_219_392##10	305.145538
Rg37	a_219_392##4	a_219_392##11	428.761261
Rg38	a_219_392##5	a_219_392##12	319.563965
Rf1	a_119_392#	a_119_392##2	102.683861
Rf2	a_114_125#	a_114_125##2	114.468483
Rf3	B#9	B	164.838638
Rf4	B	B#2	265.213470
Rf5	a_501_392#	a_501_392##2	110.785423
Rf6	a_504_125#	a_504_125##2	107.403419
Rf7	A#9	A	345.624573
Rf8	A	A#2	168.020966
Rf9	C#8	C	281.210144
Rf10	C	C#2	166.411804
Rf11	a_905_392#	a_905_392##2	81.837753
Rf12	a_906_78#	a_906_78##2	110.732796
Rf13	a_219_392##4	a_219_392##14	96.144104
Rf14	a_219_392##14	a_219_392##16	54.367516
Rf15	a_219_392##14	a_219_392##18	61.797424
Rf16	a_219_392##18	a_219_392##19	145.090286
Rf17	a_219_392##19	a_219_392##21	137.953537
Rf18	a_219_392##21	a_219_392##22	139.301758
Rf19	a_219_392##19	a_219_392##23	11.063752
Rf20	a_219_392##16	a_219_392##24	160.211700
Rf21	a_219_392##15	a_219_392##16	7.500000
Rf22	a_219_392##17	a_219_392##18	15.000000
Rf23	a_219_392##20	a_219_392##21	7.500000
Rf24	X#1	X#2	39.431774
Rf25	X#2	X#3	78.071831
Rf26	X#2	X	67.599258
Rf27	X	X#5	40.308098
Rf28	X#5	X#6	81.455444
Rf29	X#4	X#5	15.000000
Rf30	VPWR#1	VPWR#2	66.771828
Rf31	VPWR#2	VPWR#3	30.714024
Rf32	VPWR#3	VPWR#4	69.828857
Rf33	VPWR#4	VPWR#5	139.534729
Rf34	VPWR#5	VPWR#6	58.050610
Rf35	VPWR#6	VPWR#7	85.493820
Rf36	VPWR#7	VPWR#8	186.752594
Rf37	VPWR#3	VPWR#9	41.422615
Rf38	VPWR#4	VPWR#10	45.190044
Rf39	VPWR#5	VPWR#11	35.688515
Rf40	VPWR#7	VPWR#12	40.917000
Rf41	VGND#1	VGND#2	66.536339
Rf42	VGND#2	VGND#3	30.656675
Rf43	VGND#3	VGND#4	68.675751
Rf44	VGND#4	VGND#5	139.534729
Rf45	VGND#5	VGND#6	59.146370
Rf46	VGND#6	VGND#7	82.645103
Rf47	VGND#7	VGND#8	181.823273
Rf48	VGND#3	VGND#9	38.050552
Rf49	VGND#4	VGND#10	45.387726
Rf50	VGND#5	VGND#11	32.735970
Rf51	VGND#7	VGND#12	66.852509
Re1	VPWR#2	VPWR	4.549932
Re2	VPWR	VPWR#6	0.974985
Re3	VGND#2	VGND	4.549932
Re4	VGND	VGND#6	0.974985
*
*       CAPACITOR CARDS
*
*
C1	VPWR#8	a_219_392##20	1.09148e-17
C2	a_906_78#	a_219_392##15	3.78995e-17
C3	VGND#8	C#4	1.17078e-19
C4	VPWR#5	B#7	5.84103e-19
C5	B#1	a_114_125#	2.07671e-17
C6	a_219_392##19	A#10	4.95426e-19
C7	a_114_125##2	A#3	1.9933e-18
C8	a_905_392##2	VPWR#5	2.30811e-17
C9	VPWR#8	a_119_392##2	1.06098e-16
C10	a_219_392##22	B#1	2.83407e-17
C11	a_219_392##17	A#8	2.21884e-19
C12	a_219_392##19	VPWR#7	7.51185e-19
C13	a_906_78##2	a_906_78#	2.82811e-18
C14	VGND#8	A#3	3.99278e-20
C15	VPWR#7	B#10	6.64516e-19
C16	a_114_125#	B#6	4.62933e-19
C17	a_114_125##2	B#1	4.4819e-19
C18	B#9	B#8	3.22906e-18
C19	a_219_392##19	C#1	2.11286e-17
C20	VPWR#5	B#10	8.26212e-20
C21	a_219_392##22	B#6	4.5702e-17
C22	a_219_392##15	a_906_78##2	5.96064e-17
C23	a_114_125#	A#4	2.11071e-19
C24	X#2	VPWR#3	1.5596e-19
C25	a_219_392##19	VPWR#5	7.51185e-19
C26	B#6	a_114_125##2	2.37814e-17
C27	VPWR#7	C#5	7.15277e-18
C28	VGND#4	a_219_392##14	2.96422e-19
C29	a_219_392##22	B#3	2.11913e-18
C30	a_219_392##22	A#4	1.22524e-17
C31	a_219_392##19	B#7	2.66152e-17
C32	VPWR#5	C#5	2.39058e-20
C33	VGND#8	B#6	4.49123e-18
C34	a_219_392##15	VGND#11	2.05842e-17
C35	a_501_392#	VPWR#5	1.14439e-17
C36	A#4	a_114_125##2	2.6978e-17
C37	a_219_392##14	X#3	1.12214e-18
C38	a_219_392##8	a_219_392#	3.99153e-17
C39	A#2	B#8	5.40469e-19
C40	VPWR#7	A#1	7.85493e-18
C41	VGND#8	A#4	6.03769e-17
C42	a_219_392##19	B#10	1.90241e-17
C43	B#3	A#2	4.04172e-17
C44	VGND#11	a_906_78##2	3.20779e-17
C45	VPWR#5	A#1	1.45452e-20
C46	a_219_392##10	a_219_392##8	3.77909e-17
C47	a_114_125##2	B#3	1.4661e-19
C48	VPWR#7	a_501_392##2	3.03471e-17
C49	VPWR#7	B#5	5.03392e-18
C50	a_219_392##19	C#5	1.9709e-17
C51	a_219_392##14	a_905_392#	3.15041e-18
C52	a_504_125#	VGND#11	2.97712e-17
C53	VPWR#1	a_219_392##7	4.82677e-17
C54	B#2	B#3	2.31683e-17
C55	a_219_392##12	a_219_392##10	3.23231e-17
C56	VPWR#7	B#4	1.88323e-18
C57	a_219_392##19	A#1	2.24349e-19
C58	A#7	a_219_392##5	2.05207e-17
C59	a_219_392##7	X#1	1.80521e-17
C60	a_219_392##19	VPWR#11	2.26033e-17
C61	a_219_392##14	a_219_392##17	6.57023e-20
C62	VGND#1	VPWR#1	2.70308e-19
C63	VPWR#1	a_219_392##9	3.60104e-18
C64	a_219_392##24	VGND#11	2.47422e-17
C65	VPWR#9	a_219_392##7	2.1426e-18
C66	a_219_392##14	VPWR#4	2.89492e-19
C67	a_219_392##9	X#1	2.55347e-17
C68	a_119_392#	VPWR#7	5.197e-17
C69	a_219_392##19	B#5	1.26579e-19
C70	A#7	a_219_392##12	3.04053e-17
C71	VPWR#7	A#5	8.33021e-20
C72	X#3	a_219_392##7	2.09026e-19
C73	a_219_392##19	a_501_392#	7.09388e-17
C74	VPWR#9	a_219_392##9	5.1853e-17
C75	a_219_392##24	a_504_125#	6.3783e-17
C76	a_219_392##3	X#1	2.04625e-19
C77	X#1	a_219_392##11	6.89853e-20
C78	X#3	a_219_392##9	1.96205e-18
C79	a_219_392##19	B#4	8.7688e-20
C80	a_219_392##20	VPWR#7	9.72122e-19
C81	a_219_392##11	VPWR#9	2.13071e-17
C82	a_219_392##3	a_219_392##2	1.00239e-18
C83	A#7	C#6	5.47791e-17
C84	a_219_392##2	X#1	2.47066e-19
C85	VPWR#10	a_219_392##9	1.77308e-19
C86	a_504_125##2	a_504_125#	2.86973e-18
C87	a_219_392##19	a_219_392##23	3.56623e-18
C88	X#3	a_219_392##11	7.4985e-17
C89	a_219_392##20	A#3	2.62085e-19
C90	VPWR#9	a_219_392##6	3.704e-19
C91	VPWR#10	a_219_392##11	7.41318e-19
C92	a_504_125##2	a_219_392##24	3.6287e-17
C93	a_119_392##2	VPWR#7	1.18498e-17
C94	X#3	a_219_392##6	5.63521e-17
C95	C#11	C#6	3.7627e-17
C96	A#8	A#7	4.49068e-19
C97	VPWR#9	a_219_392##3	2.67419e-19
C98	a_219_392##19	a_501_392##2	7.18961e-17
C99	VPWR#9	A#6	1.71861e-19
C100	a_219_392##6	VPWR#10	2.48964e-17
C101	VGND#12	a_219_392##24	6.8623e-19
C102	X#3	A#6	2.36579e-18
C103	VPWR#2	VPWR#3	5.12627e-17
C104	a_905_392#	a_219_392##6	8.35227e-19
C105	VGND#2	VGND#3	5.97956e-17
C106	VPWR#8	VPWR#7	1.44649e-19
C107	A#8	C#11	3.94202e-17
C108	A#6	VPWR#10	2.97301e-17
C109	a_219_392##19	VPWR#12	1.9657e-17
C110	a_219_392##17	a_219_392##6	1.77106e-18
C111	a_219_392##20	A#4	4.0779e-18
C112	X#2	VPWR#2	2.80406e-18
C113	VGND#12	a_504_125##2	4.31892e-17
C114	X#3	C#10	1.69532e-19
C115	a_905_392#	A#6	4.5638e-17
C116	a_119_392##2	A#4	1.20486e-18
C117	VPWR#10	C#10	2.42739e-18
C118	a_219_392##17	A#6	7.07412e-18
C119	VPWR#11	a_219_392##6	8.25015e-20
C120	C#3	A#8	3.37992e-17
C121	a_905_392#	C#10	4.57019e-17
C122	VGND#2	X#2	2.88512e-18
C123	VPWR#10	C#9	6.04075e-19
C124	a_219_392##17	C#10	4.20955e-17
C125	VGND#3	a_219_392##8	3.76939e-19
C126	VPWR#11	A#6	1.08528e-19
C127	a_905_392#	C#9	1.39089e-18
C128	a_905_392##2	C#10	1.39089e-18
C129	a_114_125#	VGND#12	4.47998e-17
C130	a_219_392##22	a_504_125##2	1.29668e-20
C131	C#3	B#11	3.01118e-17
C132	a_219_392##20	a_219_392##19	8.76742e-19
C133	VPWR#10	a_219_392##5	1.43893e-18
C134	VPWR#10	A#10	3.65828e-19
C135	a_219_392##17	C#9	4.43518e-17
C136	VGND#3	VGND#1	1.49673e-18
C137	VPWR#11	C#10	1.7956e-19
C138	a_905_392##2	C#9	4.42645e-17
C139	VGND#3	a_219_392##10	9.75606e-19
C140	VGND#4	a_219_392##4	8.31895e-19
C141	VPWR#10	C#1	3.39131e-19
C142	a_219_392##17	A#10	2.16006e-17
C143	VPWR#11	C#9	3.54193e-19
C144	VGND#3	a_219_392##4	6.87071e-20
C145	B#12	B#11	3.49027e-17
C146	C#4	C#3	4.43917e-19
C147	VGND#4	a_219_392##12	4.85905e-18
C148	a_905_392##2	A#10	3.58251e-17
C149	VGND#3	X#4	1.1677e-19
C150	a_114_125#	a_219_392##22	4.04834e-17
C151	VGND#4	VGND#9	6.42156e-19
C152	a_219_392##17	C#1	6.11933e-19
C153	X#4	a_219_392##3	4.09887e-18
C154	A#10	VPWR#11	2.70994e-17
C155	a_219_392##4	VPWR#4	3.65118e-19
C156	VGND#4	C#8	1.95993e-20
C157	VPWR#3	a_219_392##4	1.67083e-20
C158	a_905_392##2	C#1	7.18419e-19
C159	a_501_392#	A#10	2.89992e-19
C160	C#4	B#12	3.89615e-17
C161	VGND#4	A#7	2.05821e-17
C162	a_219_392##17	B#7	3.20692e-19
C163	C#1	VPWR#11	2.93595e-17
C164	a_114_125##2	a_114_125#	2.52246e-18
C165	a_219_392##4	X#2	4.3616e-17
C166	X#4	a_219_392##2	2.14401e-18
C167	VPWR#5	C#8	3.2539e-20
C168	VGND#2	VGND#1	2.29849e-17
C169	a_501_392#	C#1	4.645e-17
C170	VGND#4	X#6	4.11328e-18
C171	VPWR#4	C#8	2.52269e-20
C172	VGND#3	A#7	9.07004e-19
C173	VGND#2	X#4	8.86941e-18
C174	a_219_392##17	B#10	2.75156e-19
C175	A#3	C#4	5.65538e-17
C176	a_219_392##22	a_114_125##2	5.14981e-17
C177	a_501_392#	B#7	3.57106e-17
C178	a_501_392##2	C#1	1.98955e-19
C179	VGND#4	C#6	1.24128e-18
C180	VGND#2	X#6	4.11707e-18
C181	X#2	C#8	1.00619e-19
C182	VGND#9	a_219_392##3	6.79642e-19
C183	VGND#3	X#6	5.65357e-18
C184	a_219_392##14	a_219_392##4	4.15841e-20
C185	C#3	B#8	1.0861e-19
C186	B#7	a_219_392##23	2.20643e-17
C187	a_219_392##15	a_219_392##17	2.34106e-18
C188	VGND#8	a_219_392##22	3.0153e-17
C189	VGND#5	C#11	1.35725e-18
C190	a_501_392#	B#10	4.35441e-19
C191	A#3	B#1	3.80839e-17
C192	a_501_392##2	B#7	8.58074e-19
C193	B#10	a_219_392##23	1.44905e-17
C194	a_219_392##14	C#8	4.94627e-17
C195	VGND#8	a_114_125##2	6.61239e-17
C196	a_501_392##2	B#10	4.70074e-17
C197	VPWR#5	C#2	1.74676e-21
C198	VGND#4	a_906_78#	4.49748e-17
C199	A#9	a_219_392##19	6.95661e-17
C200	B#6	B#1	3.35017e-17
C201	A#4	A#3	3.79625e-19
C202	a_219_392##14	a_219_392#	9.88501e-20
C203	a_219_392##20	B#7	2.75911e-19
C204	VGND#5	A#8	1.96986e-17
C205	VGND#5	a_219_392##15	9.50558e-19
C206	a_501_392##2	C#5	3.68408e-17
C207	A#9	a_219_392##14	1.44686e-18
C208	VGND#4	A#8	2.02558e-18
C209	X#4	a_219_392##4	1.66442e-17
C210	C#5	VPWR#12	2.44012e-17
C211	a_219_392##20	B#10	4.11906e-19
C212	a_219_392##4	VGND#9	2.9923e-18
C213	A#4	B#6	3.13102e-17
C214	a_219_392##19	C#2	4.2126e-19
C215	a_219_392##14	a_219_392##8	1.06077e-19
C216	a_501_392##2	A#1	8.74309e-19
C217	a_119_392#	C#5	9.58882e-19
C218	a_219_392##4	X#6	6.25102e-17
C219	VGND#5	C#3	1.08441e-17
C220	VGND#5	a_906_78##2	4.49231e-17
C221	VPWR#2	VPWR#1	2.84021e-17
C222	A#1	VPWR#12	2.52068e-17
C223	a_219_392##20	C#5	1.49817e-18
C224	a_219_392##4	VGND#10	3.48016e-17
C225	VGND#10	a_219_392##5	2.68384e-18
C226	VGND#7	VGND#11	2.72494e-20
C227	X#1	VPWR#2	2.34121e-17
C228	a_119_392#	A#1	4.23797e-17
C229	VGND#6	a_504_125#	3.83768e-17
C230	VGND#4	C#3	5.26682e-20
C231	X#4	X#2	1.83807e-17
C232	a_219_392##20	A#1	3.00802e-17
C233	VPWR#8	C#5	1.40509e-20
C234	a_219_392##14	a_219_392##10	1.6679e-19
C235	a_219_392##19	B#9	7.919e-19
C236	VGND#2	VPWR#1	1.28513e-18
C237	VPWR#2	X#3	4.56253e-18
C238	VGND#4	a_906_78##2	6.48133e-18
C239	VGND#6	a_504_125##2	2.05616e-17
C240	a_119_392#	B#5	4.50096e-17
C241	a_906_78#	C#8	1.76948e-20
C242	a_219_392##20	B#5	5.76539e-17
C243	VPWR#8	A#1	2.33318e-20
C244	a_219_392##15	C#8	7.78399e-17
C245	X#1	VPWR#1	5.9415e-17
C246	a_119_392##2	B#5	1.24743e-18
C247	C#8	a_906_78##2	1.0363e-18
C248	a_119_392#	B#4	9.33095e-19
C249	a_219_392##14	a_219_392##12	7.13123e-19
C250	A#2	a_219_392##19	8.2781e-17
C251	VPWR#8	B#5	2.47948e-19
C252	a_219_392##20	B#4	5.27002e-17
C253	VGND#11	VGND#4	3.11279e-20
C254	VPWR#9	VPWR#1	2.66815e-18
C255	a_119_392##2	B#4	3.35696e-17
C256	VGND#5	a_504_125#	7.74524e-18
C257	a_219_392##15	A#9	5.47301e-19
C258	a_119_392#	A#5	2.1004e-19
C259	a_219_392##9	a_219_392##7	4.71325e-17
C260	VPWR#7	B#3	2.41509e-20
C261	VPWR#8	B#4	4.36638e-18
C262	a_219_392##20	A#5	1.05874e-17
C263	VGND#11	A#9	5.68093e-19
C264	a_219_392##14	A#7	1.15683e-17
C265	a_119_392##2	A#5	5.38523e-17
C266	VGND#7	C#4	1.70386e-17
C267	VPWR#9	X#1	5.69846e-17
C268	a_219_392##24	A#9	3.09568e-18
C269	a_219_392##11	a_219_392##9	4.75616e-17
C270	VPWR#8	A#5	2.96811e-17
C271	VGND#5	a_219_392##24	1.11651e-18
C272	VGND#1	a_219_392#	3.40441e-17
C273	a_219_392##4	VPWR#9	2.84076e-18
C274	VGND#7	a_504_125##2	3.30342e-17
C275	a_219_392##14	C#6	8.32673e-18
C276	X#3	X#1	4.69735e-19
C277	a_504_125#	C#2	3.36756e-19
C278	a_219_392##4	X#3	5.47175e-17
C279	a_501_392#	VPWR#6	3.99887e-17
C280	A#5	B#3	8.67923e-18
C281	a_219_392##24	C#2	4.5087e-19
C282	a_219_392##6	a_219_392##11	4.56956e-17
C283	VGND#7	A#3	2.5346e-17
C284	a_219_392##4	VPWR#10	2.06639e-17
C285	X#4	a_219_392#	3.37548e-17
C286	a_501_392##2	VPWR#6	2.43941e-17
C287	VGND#1	a_219_392##8	5.36949e-18
C288	X#3	VPWR#9	6.29501e-17
C289	VGND#5	A#3	2.64912e-20
C290	X#3	C#8	2.5006e-19
C291	a_504_125#	B#9	1.5438e-19
C292	VGND#9	a_219_392#	5.65075e-18
C293	a_219_392##14	C#11	3.82198e-20
C294	A#6	a_219_392##6	4.21993e-17
C295	a_219_392##24	B#9	3.07276e-19
C296	a_905_392#	C#8	2.02067e-19
C297	a_504_125##2	B#9	3.06539e-19
C298	X#4	a_219_392##8	3.98296e-17
C299	VGND#7	B#1	1.27352e-18
C300	a_219_392##19	C#3	1.39297e-19
C301	a_219_392##17	C#8	3.89261e-17
C302	VPWR#10	VPWR#9	2.07596e-18
C303	VGND#2	a_219_392#	7.45007e-18
C304	X#6	a_219_392#	5.47108e-19
C305	a_905_392##2	C#8	2.32104e-19
C306	A#3	B#3	2.48007e-18
C307	VGND#2	a_219_392##8	6.95888e-18
C308	C#10	A#6	4.25512e-17
C309	VGND#9	a_219_392##8	3.42989e-17
C310	a_219_392##24	A#2	4.0759e-19
C311	VGND#2	a_219_392##10	4.43117e-18
C312	A#9	a_219_392##17	4.35076e-17
C313	VPWR#10	X#3	8.87355e-17
C314	VGND#7	a_114_125#	5.06581e-17
C315	C	B#8	9.56149e-18
C316	a_114_125#	A#2	3.90509e-19
C317	X#6	a_219_392##8	7.91709e-19
C318	VGND#2	A#7	1.34248e-20
C319	VGND#7	B#6	8.12292e-19
C320	a_501_392#	B#8	2.56479e-20
C321	A#9	VPWR#11	1.59639e-18
C322	C#9	C#10	4.33492e-17
C323	VGND#9	a_219_392##10	3.05295e-17
C324	A#9	a_501_392#	1.85721e-20
C325	VPWR#2	a_219_392##3	1.83384e-20
C326	X#2	a_219_392##5	6.34037e-20
C327	VGND#7	VGND#5	1.14448e-19
C328	VPWR#2	a_219_392##2	2.21419e-20
C329	B#2	a_114_125#	3.56022e-17
C330	A#10	C#9	4.26955e-17
C331	X#6	a_219_392##10	2.53019e-17
C332	B#2	a_219_392##22	5.47291e-17
C333	a_501_392#	C#2	3.84027e-19
C334	VGND#1	A#7	2.15267e-19
C335	a_905_392#	VPWR#10	3.98726e-17
C336	a_219_392##17	X#3	1.58878e-18
C337	VGND#7	A#4	5.52984e-18
C338	VGND#9	a_219_392##12	1.64684e-18
C339	VGND#10	a_219_392##10	1.69397e-18
C340	X#2	a_219_392##3	8.82477e-18
C341	C#1	A#10	2.60542e-17
C342	a_501_392#	B#9	5.23644e-20
C343	a_219_392##4	A#7	1.11593e-17
C344	a_219_392##12	X#6	2.37925e-17
C345	B	B#8	9.54293e-18
C346	B	B#3	1.69333e-19
C347	a_219_392##17	VPWR#10	1.74127e-17
C348	a_219_392##14	VGND#10	3.65898e-18
C349	a_501_392##2	B#9	1.54956e-19
C350	VGND#7	a_114_125##2	2.19935e-17
C351	a_219_392##19	C#4	1.39297e-19
C352	VGND#9	A#7	7.85274e-19
C353	VGND#6	C#3	1.41076e-17
C354	A#7	C#8	1.33209e-17
C355	B#7	C#1	3.29337e-17
C356	a_219_392##12	VGND#10	2.15615e-17
C357	VGND#2	a_219_392##3	6.74995e-20
C358	VGND#6	B#11	1.93424e-18
C359	A#2	a_219_392##23	1.18707e-18
C360	C#8	C#6	4.51879e-19
C361	X#2	a_219_392##2	1.02382e-17
C362	a_905_392#	a_219_392##17	2.33169e-17
C363	VGND#2	a_219_392##2	1.36616e-19
C364	VGND#6	B#12	1.2572e-18
C365	X#6	A#7	1.12647e-18
C366	A#2	a_501_392##2	2.30437e-19
C367	C#8	C#11	5.47366e-18
C368	VGND#6	C#4	6.07411e-18
C369	VGND#5	VGND#4	1.30737e-19
C370	A#2	VPWR#12	2.00283e-18
C371	a_906_78#	a_219_392##12	1.0208e-18
C372	a_219_392##14	a_906_78#	1.86969e-17
C373	C#8	A#8	5.73826e-18
C374	VPWR#2	a_219_392##7	5.17603e-18
C375	B#10	B#7	3.23084e-17
C376	VGND#8	VGND#7	2.18872e-19
C377	A#7	VGND#10	2.30103e-17
C378	a_219_392##20	A#2	3.44049e-17
C379	A#9	C#11	3.24859e-18
C380	VPWR#2	a_219_392##9	1.84978e-18
C381	a_219_392##22	a_219_392##20	1.64136e-18
C382	a_905_392##2	a_905_392#	5.53634e-18
C383	VPWR#11	VPWR#10	7.55857e-19
C384	a_219_392##15	a_219_392##12	1.71465e-19
C385	VPWR#2	a_219_392##11	7.56941e-19
C386	X	a_219_392##2	1.53267e-17
C387	C#5	B#10	4.3355e-17
C388	A#9	C#3	2.02414e-19
C389	a_906_78#	A#7	5.01786e-17
C390	a_219_392##20	B#2	5.74874e-17
C391	a_219_392##14	a_219_392##15	1.32429e-20
C392	a_219_392##17	a_905_392##2	6.03384e-17
C393	C#2	A#8	1.48549e-18
C394	VGND#10	C#6	8.84558e-19
C395	C#3	C#2	8.63616e-19
C396	A#1	C#5	3.35781e-17
C397	a_219_392##15	A#7	9.30411e-19
C398	B#11	C#2	2.71724e-18
C399	a_906_78#	C#6	2.9514e-17
C400	a_114_125##2	a_119_392##2	3.14933e-18
C401	a_219_392##17	VPWR#11	2.58183e-17
C402	C#3	B#9	5.83367e-19
C403	a_906_78##2	A#7	3.0369e-20
C404	A#4	B#3	1.08211e-17
C405	B#5	A#1	4.2881e-17
C406	VGND#10	C#11	1.89459e-19
C407	VPWR#6	B#8	3.64542e-21
C408	VGND#4	VGND#3	1.45104e-18
C409	C#6	a_219_392##15	1.08252e-17
C410	C#4	B#9	1.57088e-17
C411	VPWR#11	a_905_392##2	3.53629e-17
C412	a_906_78#	C#11	1.29957e-18
C413	B#4	B#5	3.97159e-17
C414	a_219_392##4	A#6	5.24778e-18
C415	a_906_78##2	C#6	7.87263e-19
C416	A#2	C#4	1.99112e-17
C417	A#3	A#2	7.45763e-19
C418	C#8	A#6	1.46046e-17
C419	a_219_392##15	C#11	3.35928e-17
C420	VGND#8	VPWR#8	1.44186e-17
C421	VPWR#6	B#7	4.44716e-18
C422	A#5	B#4	3.54573e-17
C423	VGND#1	X#4	8.55978e-18
C424	B#2	C#4	9.12623e-20
C425	VPWR#6	B#10	4.43347e-18
C426	a_906_78#	A#8	2.2793e-19
C427	B#2	A#3	7.95943e-18
C428	VPWR#3	a_219_392##7	6.52765e-19
C429	C#11	a_906_78##2	1.9574e-17
C430	B#2	B#1	1.09932e-17
C431	A#9	C#10	2.11595e-19
C432	a_501_392#	VPWR#11	4.43554e-17
C433	B#2	B#6	4.5292e-18
C434	A#9	C#9	2.28761e-18
C435	a_219_392##15	A#8	2.21732e-17
C436	a_219_392##3	a_219_392##7	3.49672e-19
C437	B#2	A#4	1.27935e-19
C438	A#9	A#10	6.07334e-18
C439	a_504_125#	B#8	4.41085e-20
C440	VPWR#4	a_219_392##9	9.31203e-20
C441	VGND#7	B	1.19984e-18
C442	VGND#9	VGND#1	1.64826e-17
C443	A#9	C#1	1.65507e-17
C444	X#2	a_219_392##7	7.96096e-18
C445	a_219_392##24	C#6	1.82702e-19
C446	a_906_78##2	A#8	3.85503e-17
C447	A#9	B#7	2.10494e-17
C448	VPWR#3	a_219_392##9	4.1335e-18
C449	a_219_392##15	C#3	7.91645e-19
C450	a_219_392##4	a_219_392##5	1.98797e-17
C451	A#9	C#5	2.09589e-19
C452	A#8	VGND#11	1.72927e-17
C453	X#4	VGND#9	2.48787e-17
C454	a_501_392#	a_219_392##23	3.41118e-19
C455	a_219_392##4	a_219_392##3	1.15013e-17
C456	a_219_392##15	C	2.0841e-17
C457	VPWR#4	a_219_392##11	6.02307e-19
C458	a_219_392##24	C#11	2.4174e-19
C459	a_906_78##2	C#3	7.10669e-19
C460	a_119_392#	B#3	1.05797e-19
C461	X#2	a_219_392##9	1.69798e-17
C462	C	a_504_125#	7.61271e-19
C463	a_219_392##19	B#8	9.74646e-20
C464	a_219_392##24	C	6.66248e-17
C465	C#5	B#9	1.15823e-17
C466	VPWR#3	a_219_392##11	5.25956e-18
C467	VPWR#2	a_219_392##4	2.89291e-18
C468	a_219_392##15	B#11	4.16194e-19
C469	A#2	B#10	1.36099e-17
C470	a_501_392##2	a_501_392#	2.59148e-18
C471	VGND#11	C#3	2.70651e-17
C472	VGND#2	a_219_392##4	2.77424e-18
C473	VPWR#5	a_219_392##6	2.35054e-20
C474	A#2	C#5	3.64707e-17
C475	a_219_392##24	B#8	5.50345e-20
C476	a_219_392##24	A#8	3.90265e-19
C477	A#2	A#1	4.53093e-18
C478	B#5	A#2	3.56813e-18
C479	a_219_392##5	VNB	1.94664e-17
C480	VPWR#4	a_219_392##6	6.85025e-18
C481	a_219_392##3	VNB	1.97854e-17
C482	B	a_219_392##24	3.37231e-17
C483	a_219_392##2	VNB	2.79873e-17
C484	C#3	a_504_125#	3.04314e-17
C485	B	a_504_125##2	3.74421e-17
C486	B#8	VNB	1.98834e-17
C487	a_501_392##2	a_219_392##23	8.5619e-19
C488	B#3	VNB	5.59525e-17
C489	B	VGND#12	3.23328e-17
C490	X#2	a_219_392##11	9.65248e-19
C491	VPWR#7	VPWR#5	1.50077e-19
C492	a_114_125#	B	7.38791e-18
C493	a_219_392##14	a_219_392##7	1.46824e-19
C494	X	VGND#1	3.03681e-17
C495	VPWR#3	VPWR#1	1.48757e-18
C496	VPWR	VPWR#7	1.11795e-16
C497	X#4	X	3.54128e-18
C498	VPWR	VPWR#5	1.02448e-16
C499	VGND#11	B#11	3.39704e-19
C500	VPWR#3	a_219_392##6	2.99663e-19
C501	VPWR	VPWR#4	9.80919e-17
C502	VPWR	VPWR#3	6.89389e-18
C503	VPWR#6	C#2	1.70879e-20
C504	a_219_392##24	C#3	2.07658e-17
C505	X#6	VGND#9	4.26544e-17
C506	VPWR	a_219_392##19	1.71099e-17
C507	VPWR#5	A#6	3.62294e-20
C508	VPWR	a_219_392##14	2.64904e-18
C509	VPWR#6	B#9	2.94671e-20
C510	a_219_392##14	a_219_392##5	1.40092e-19
C511	B#11	a_504_125#	2.06819e-17
C512	a_219_392##20	B#3	1.20246e-17
C513	C#8	A#9	7.63616e-17
C514	VGND#6	B#9	6.91793e-20
C515	VPWR#4	A#6	7.50293e-18
C516	a_504_125##2	C#3	1.17653e-18
C517	C#8	C#2	1.2804e-19
C518	X#2	a_219_392##6	3.87467e-19
C519	X	VPWR#1	3.40595e-17
C520	VGND	VGND#7	1.19838e-16
C521	VGND	VGND#5	8.8482e-17
C522	VGND	VGND#4	1.019e-16
C523	C#2	A#9	4.16562e-17
C524	VGND	VGND#3	8.19697e-18
C525	a_219_392##24	B#11	4.39405e-17
C526	VPWR#12	a_501_392##2	4.03835e-17
C527	VPWR#3	A#6	8.3742e-20
C528	VGND#10	VGND#9	3.44622e-18
C529	a_219_392##11	a_219_392##3	4.28687e-19
C530	C	A#8	4.4113e-18
C531	A#9	B#9	1.28528e-19
C532	C	C#3	5.6773e-18
C533	a_504_125#	B#12	4.30415e-19
C534	C	B#11	4.25571e-18
C535	VPWR#5	C#10	1.07737e-19
C536	A#2	A#9	3.37298e-19
C537	VGND	a_219_392##14	4.25679e-18
C538	C	B#12	9.48533e-19
C539	X#2	VPWR#1	2.73954e-17
C540	a_219_392##14	a_219_392##3	1.72813e-19
C541	a_504_125##2	B#11	1.28878e-18
C542	A#2	C#2	1.32357e-19
C543	VGND#11	C#4	2.94486e-20
C544	VPWR#4	C#10	5.30744e-18
C545	VPWR	X#3	1.36119e-17
C546	A#2	B#9	4.39547e-18
C547	B	C#3	3.59924e-19
C548	a_219_392##14	a_219_392##11	2.54125e-19
C549	B#12	a_219_392##24	1.40281e-17
C550	VGND	X#6	1.01702e-17
C551	X	a_219_392#	7.60548e-18
C552	B	B#11	4.00102e-18
C553	VPWR	a_905_392#	2.02841e-17
C554	X#2	A#6	6.31275e-20
C555	X	a_219_392##8	3.25623e-19
C556	VPWR	a_219_392##17	1.1718e-17
C557	VGND	a_906_78#	1.98301e-17
C558	B	B#12	8.77417e-18
C559	VGND	a_219_392##15	1.2888e-17
C560	VPWR	a_905_392##2	1.88191e-17
C561	X	a_219_392##10	1.86905e-19
C562	B#2	B#9	4.11344e-19
C563	VPWR#5	VPWR#4	1.64087e-19
C564	VGND#10	X#6	4.86333e-17
C565	B	C#4	2.44128e-17
C566	VGND	a_906_78##2	2.21254e-17
C567	VGND#7	VNB	4.89415e-17
C568	X	a_219_392##12	1.12348e-19
C569	VGND#12	B#11	1.69869e-19
C570	VGND	VGND#11	1.55364e-17
C571	VGND#5	VNB	3.73572e-17
C572	VPWR	a_501_392#	2.2945e-17
C573	B	A#3	1.57121e-17
C574	VGND#4	VNB	4.00733e-17
C575	VGND	a_504_125#	2.12034e-17
C576	X	A#7	8.93715e-20
C577	VGND#3	VNB	2.54311e-17
C578	VGND	a_219_392##24	1.29887e-17
C579	VPWR#7	VNB	5.36657e-17
C580	B#2	A#2	3.33875e-17
C581	VGND	a_504_125##2	2.26102e-17
C582	VPWR	a_501_392##2	2.29447e-17
C583	VPWR#5	VNB	4.26425e-17
C584	VPWR#4	VNB	4.25556e-17
C585	VPWR#3	VNB	2.10896e-17
C586	VGND	a_114_125#	2.10221e-17
C587	VPWR	a_119_392#	2.23226e-17
C588	VGND	a_219_392##22	1.0968e-17
C589	X#2	VNB	3.34441e-18
C590	VPWR	a_219_392##20	1.62988e-17
C591	VGND	a_114_125##2	2.36625e-17
C592	a_119_392#	VPWR#12	3.49677e-17
C593	a_504_125##2	B#12	3.10532e-17
C594	VGND	VGND#8	8.87686e-17
C595	VPWR	a_119_392##2	2.52157e-17
C596	VPWR	VPWR#8	7.87448e-17
C597	X#3	VPWR#4	9.11222e-18
C598	a_219_392##14	VNB	2.67808e-18
C599	a_119_392##2	B#3	6.41197e-20
C600	VPWR#5	C#9	5.67705e-18
C601	a_219_392##14	a_219_392##2	2.40257e-20
C602	X#2	X#1	4.21e-18
C603	VGND#11	A#3	8.68543e-20
C604	VGND#1	VNB	2.95418e-17
C605	a_219_392##24	C#4	3.89306e-19
C606	VGND#9	VNB	1.36895e-18
C607	X#6	VNB	6.03163e-18
C608	VPWR#5	VPWR#10	5.6917e-20
C609	VGND#10	VNB	5.54989e-18
C610	a_906_78#	VNB	4.08819e-18
C611	a_219_392##15	VNB	2.92228e-19
C612	VPWR#4	C#9	8.92837e-20
C613	a_219_392##14	a_219_392##6	6.02979e-19
C614	VGND#12	B#12	4.00279e-19
C615	a_906_78##2	VNB	5.86274e-18
C616	VGND#11	VNB	6.01506e-19
C617	a_504_125#	VNB	8.9184e-18
C618	VGND	a_219_392##20	7.38813e-19
C619	A#9	B#8	2.60021e-19
C620	a_219_392##20	VPWR#12	2.15627e-17
C621	a_504_125##2	VNB	6.51189e-18
C622	VGND#12	VNB	6.0565e-18
C623	VGND	VPWR#8	4.38006e-18
C624	a_114_125#	VNB	6.75829e-18
C625	a_219_392##22	VNB	2.64732e-18
C626	a_114_125##2	VNB	1.3734e-17
C627	VGND#8	VNB	8.3447e-17
C628	B	C#5	3.44486e-18
C629	X#3	VPWR#3	8.04592e-18
C630	VPWR#1	VNB	5.72113e-17
C631	VGND	a_219_392##12	8.69359e-18
C632	a_504_125##2	C#4	4.23314e-17
C633	X#1	VNB	4.7183e-18
C634	VPWR#7	A#10	1.40749e-20
C635	VGND	A#7	8.06181e-18
C636	VPWR#9	VNB	4.09278e-19
C637	X#3	VNB	2.16516e-18
C638	VPWR#10	VNB	3.69728e-18
C639	a_905_392#	VNB	2.09325e-18
C640	VGND	A#8	1.07071e-17
C641	a_219_392##17	VNB	2.45899e-19
C642	a_905_392##2	VNB	2.09325e-18
C643	VGND	C#3	9.08351e-18
C644	VPWR#11	VNB	2.95478e-18
C645	a_501_392#	VNB	3.37061e-18
C646	VPWR	a_219_392##6	3.15025e-18
C647	VPWR	A#6	2.66787e-18
C648	a_501_392##2	VNB	3.56137e-18
C649	VGND	C#4	6.3207e-18
C650	VPWR#12	VNB	1.81595e-18
C651	a_219_392##24	A#3	1.99164e-19
C652	VGND	A#3	7.27971e-18
C653	VPWR	C#10	1.42119e-19
C654	a_119_392#	VNB	3.3971e-18
C655	a_219_392##20	VNB	8.99923e-18
C656	VPWR	C#9	3.26743e-20
C657	X#2	VPWR#9	2.18847e-17
C658	VPWR#5	A#10	7.39947e-18
C659	a_119_392##2	VNB	4.70613e-18
C660	a_119_392#	a_219_392##20	7.1623e-17
C661	VPWR	A#10	1.73913e-18
C662	VPWR#8	VNB	9.11015e-17
C663	VGND	A#4	1.13656e-17
C664	a_219_392#	VNB	2.1702e-17
C665	VPWR	C#1	1.66418e-18
C666	C#4	VGND#12	1.6921e-17
C667	C	C#8	2.51847e-18
C668	a_219_392##8	VNB	2.22201e-17
C669	a_219_392##19	C#10	3.02417e-19
C670	a_219_392##10	VNB	2.58725e-17
C671	VPWR	B#7	1.41465e-18
C672	a_219_392##12	VNB	3.15268e-17
C673	C	A#9	1.06191e-16
C674	VPWR	B#10	1.35155e-18
C675	A#7	VNB	8.66888e-17
C676	a_906_78#	VGND#10	5.31463e-17
C677	C#6	VNB	2.13932e-17
C678	VPWR	C#5	1.72118e-18
C679	C#11	VNB	2.34103e-17
C680	VPWR#2	X	2.39232e-18
C681	C	C#2	2.62077e-17
C682	A#8	VNB	7.66284e-17
C683	VPWR	A#1	2.21468e-18
C684	a_219_392##14	A#6	8.85558e-18
C685	a_219_392##22	B#12	1.48103e-19
C686	a_905_392#	VPWR#5	8.47212e-20
C687	C#3	VNB	8.48081e-17
C688	VGND#2	X	4.10816e-18
C689	VPWR	B#5	1.3647e-18
C690	B#11	VNB	2.2854e-17
C691	VPWR#4	A#10	2.63295e-20
C692	B#12	VNB	2.17561e-17
C693	VPWR	B#4	1.41868e-18
C694	C#4	VNB	9.35895e-17
C695	a_504_125##2	A#3	1.42376e-18
C696	A#3	VNB	8.80937e-17
C697	VPWR	A#5	5.92773e-18
C698	B#1	VNB	2.20809e-17
C699	B	C#2	1.92125e-18
C700	B#6	VNB	2.30217e-17
C701	a_219_392##4	X	2.67169e-18
C702	A#4	VNB	1.31994e-16
C703	B	B#9	2.34623e-17
C704	a_219_392##7	VNB	3.35046e-17
C705	VPWR#4	VPWR#3	7.36573e-19
C706	a_219_392##17	A#7	2.05797e-20
C707	a_114_125#	C#4	1.42106e-18
C708	B	A#2	1.11978e-16
C709	a_219_392##9	VNB	2.67098e-17
C710	VPWR	VPWR#6	4.8554e-17
C711	a_219_392##11	VNB	3.06723e-17
C712	a_219_392##6	VNB	3.51985e-17
C713	B#2	B	1.73299e-18
C714	a_119_392##2	a_119_392#	2.7787e-18
C715	A#6	VNB	4.57615e-17
C716	C#10	VNB	2.78193e-17
C717	VPWR	a_219_392##4	5.13087e-18
C718	VPWR#7	C#1	2.3705e-20
C719	C#9	VNB	2.91398e-17
C720	VPWR	C#8	3.41242e-18
C721	A#10	VNB	3.21969e-17
C722	C#1	VNB	3.25343e-17
C723	VPWR	A#9	8.36663e-18
C724	B#7	VNB	3.29676e-17
C725	B#10	VNB	3.2718e-17
C726	C#5	VNB	4.33281e-17
C727	A#3	VGND#12	1.80503e-17
C728	VGND	VGND#6	5.52001e-17
C729	A#1	VNB	3.25706e-17
C730	B#5	VNB	3.23797e-17
C731	VGND	a_219_392##4	5.56686e-18
C732	VPWR	A#2	7.66661e-18
C733	B#4	VNB	3.25616e-17
C734	VGND	C#8	4.75849e-18
C735	A#5	VNB	5.9648e-17
C736	VPWR	B#2	2.28087e-18
C737	a_905_392#	VPWR#4	2.29541e-17
C738	VGND	A#9	5.52372e-18
C739	X#3	X#2	2.02728e-18
C740	VPWR#2	VNB	1.30817e-16
C741	A#6	a_219_392##5	8.8556e-18
C742	a_219_392##22	C#4	2.26107e-19
C743	a_219_392##15	VGND#10	2.27239e-18
C744	VPWR#5	C#1	6.59567e-18
C745	VGND#2	VNB	1.31874e-16
C746	VPWR#6	VNB	2.8143e-17
C747	VGND	A#2	4.03435e-18
C748	VGND#6	VNB	2.37848e-17
C749	a_219_392##19	C#9	2.27442e-19
C750	a_219_392##4	VNB	2.40554e-17
C751	VGND	B#2	6.22657e-18
C752	C#8	VNB	5.35298e-17
C753	A#9	VNB	3.75792e-17
C754	C#2	VNB	4.1306e-17
C755	a_219_392##20	a_119_392##2	7.58572e-17
C756	B#9	VNB	3.91416e-17
C757	B#8	C#2	3.38562e-17
C758	A#2	VNB	3.24174e-17
C759	B	C	3.94158e-17
C760	B#2	VNB	5.00179e-18
C761	a_219_392##17	VPWR#5	8.98476e-19
C762	a_114_125#	A#3	5.32326e-17
C763	VPWR#4	C#1	1.62349e-20
C764	VPWR	C	4.31093e-18
C765	VPWR	B	5.53508e-18
C766	VGND	C	7.30754e-18
C767	VGND	B	1.08903e-17
C768	C	VNB	4.64999e-18
C769	B	VNB	5.1732e-18
C770	X	VNB	3.50688e-17
C771	VPWR	VNB	3.10442e-16
C772	VGND	VNB	2.77367e-16
C773	VPWR#7	B#7	9.28641e-20
C774	a_219_392##22	A#3	1.65978e-18
*
*
.ENDS sky130_fd_sc_hs__maj3_4
*
