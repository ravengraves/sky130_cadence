* Extracted by Quantus, converted by sky130cad/quantus.py
*
*
*
*                       LINUX           Wed Nov 18 08:05:01 2026
*
*
*
*  PROGRAM  advgen
*
*  Name           : advgen - Quantus - (64-bit)
*  Version        : 25.1.0-p047
*  Build Date     : Thu Dec 11 23:20:30 PST 2025
*
*  HSPICE LIBRARY
*
*  OPERATING_TEMPERATURE 150
*  QRC_TECH_DIR <path>/tech
*
*
*

*
.SUBCKT sky130_fd_sc_hs__a21boi_4 VPB VNB VGND VPWR Y A1 A2 B1_N
*
*
*  caps2d version: 10
*
*
*       TRANSISTOR CARDS
*
*
XM9 a_46_74##8 A1#10 Y#7 VNB sky130_fd_pr__nfet_01v8_lvt l=0.15 w=0.74 ad=0.1961 as=0.2072 pd=2.01 ps=2.04
XM17 Y#7 A1#8 a_46_74##6 VNB sky130_fd_pr__nfet_01v8_lvt l=0.15 w=0.74 ad=0.2072 as=0.2072 pd=2.04 ps=2.04
XM20 Y#2 A1#6 a_46_74##6 VNB sky130_fd_pr__nfet_01v8_lvt l=0.15 w=0.74 ad=0.2072 as=0.2072 pd=2.04 ps=2.04
XM24 a_46_74##4 A1#1 Y#2 VNB sky130_fd_pr__nfet_01v8_lvt l=0.15 w=0.74 ad=0.2072 as=0.2072 pd=2.04 ps=2.04
XM25 VGND#12 A2#10 a_46_74##4 VNB sky130_fd_pr__nfet_01v8_lvt l=0.15 w=0.74 ad=0.2072 as=0.2072 pd=2.04 ps=2.04
XM12 VGND#12 A2#7 a_46_74##2 VNB sky130_fd_pr__nfet_01v8_lvt l=0.15 w=0.74 ad=0.2072 as=0.2072 pd=2.04 ps=2.04
XM5 a_46_74##2 A2#5 VGND#11 VNB sky130_fd_pr__nfet_01v8_lvt l=0.15 w=0.74 ad=0.2072 as=0.2072 pd=2.04 ps=2.04
XM2 a_46_74# A2#4 VGND#11 VNB sky130_fd_pr__nfet_01v8_lvt l=0.15 w=0.74 ad=0.1961 as=0.2072 pd=2.01 ps=2.04
XM3 Y#4 a_803_323##10 VGND#10 VNB sky130_fd_pr__nfet_01v8_lvt l=0.15 w=0.74 ad=0.2072 as=0.1961 pd=2.04 ps=2.01
XM22 VGND#9 a_803_323##8 Y#4 VNB sky130_fd_pr__nfet_01v8_lvt l=0.15 w=0.74 ad=0.2072 as=0.2072 pd=2.04 ps=2.04
XM15 Y#1 a_803_323##6 VGND#9 VNB sky130_fd_pr__nfet_01v8_lvt l=0.15 w=0.74 ad=0.2072 as=0.2072 pd=2.04 ps=2.04
XM10 VGND#8 a_803_323# Y#1 VNB sky130_fd_pr__nfet_01v8_lvt l=0.15 w=0.74 ad=0.2072 as=0.2072 pd=2.04 ps=2.04
XM23 VGND#8 B1_N#3 a_803_323##15 VNB sky130_fd_pr__nfet_01v8_lvt l=0.15 w=0.74 ad=0.2072 as=0.1961 pd=2.04 ps=2.01
XM0 a_31_368##8 A1#12 VPWR#12 VPB sky130_fd_pr__pfet_01v8 l=0.15 w=1.12 ad=0.308 as=0.336 pd=2.79 ps=2.84
XM16 VPWR#12 A1#11 a_31_368##12 VPB sky130_fd_pr__pfet_01v8 l=0.15 w=1.12 ad=0.336 as=0.336 pd=2.84 ps=2.84
XM18 VPWR#10 A1#7 a_31_368##12 VPB sky130_fd_pr__pfet_01v8 l=0.15 w=1.12 ad=0.336 as=0.336 pd=2.84 ps=2.84
XM6 a_31_368##11 A1#5 VPWR#10 VPB sky130_fd_pr__pfet_01v8 l=0.15 w=1.12 ad=0.336 as=0.336 pd=2.84 ps=2.84
XM7 a_31_368##11 A2#12 VPWR#8 VPB sky130_fd_pr__pfet_01v8 l=0.15 w=1.12 ad=0.336 as=0.336 pd=2.84 ps=2.84
XM8 a_31_368##10 A2#11 VPWR#8 VPB sky130_fd_pr__pfet_01v8 l=0.15 w=1.12 ad=0.336 as=0.336 pd=2.84 ps=2.84
XM19 VPWR#6 A2#8 a_31_368##10 VPB sky130_fd_pr__pfet_01v8 l=0.15 w=1.12 ad=0.336 as=0.336 pd=2.84 ps=2.84
XM21 VPWR#6 A2#1 a_31_368##3 VPB sky130_fd_pr__pfet_01v8 l=0.15 w=1.12 ad=0.336 as=0.336 pd=2.84 ps=2.84
XM4 Y#6 a_803_323##5 a_31_368##3 VPB sky130_fd_pr__pfet_01v8 l=0.15 w=1.12 ad=0.336 as=0.336 pd=2.84 ps=2.84
XM11 a_31_368##9 a_803_323##11 Y#6 VPB sky130_fd_pr__pfet_01v8 l=0.15 w=1.12 ad=0.336 as=0.336 pd=2.84 ps=2.84
XM14 Y#8 a_803_323##9 a_31_368##9 VPB sky130_fd_pr__pfet_01v8 l=0.15 w=1.12 ad=0.336 as=0.336 pd=2.84 ps=2.84
XM1 a_31_368# a_803_323##7 Y#8 VPB sky130_fd_pr__pfet_01v8 l=0.15 w=1.12 ad=0.308 as=0.336 pd=2.79 ps=2.84
XM13 VPWR#4 B1_N#4 a_803_323##12 VPB sky130_fd_pr__pfet_01v8 l=0.15 w=0.84 ad=0.231 as=0.252 pd=2.23 ps=2.28
XM26 a_803_323##12 B1_N#1 VPWR#1 VPB sky130_fd_pr__pfet_01v8 l=0.15 w=0.84 ad=0.252 as=0.231 pd=2.28 ps=2.23
*
*
*       RESISTOR AND CAP/DIODE CARDS
*
Rg1	A1#1	A1#2	397.555725
Rg2	A1#2	A1#3	66.369736
Rg3	A1#3	A1#4	57.428749
Rg4	A1#2	A1#5	449.655212
Rg5	A1#3	A1#6	394.514160
Rg6	A1#3	A1#7	447.610504
Rg7	A1#4	A1#8	385.158295
Rg8	A1#4	A1#9	90.033310
Rg9	A1#9	A1#10	418.139221
Rg10	A1#4	A1#11	431.330811
Rg11	A1#9	A1#12	454.869080
Rg12	A2#1	A2#2	470.235199
Rg13	A2#2	A2#3	94.920517
Rg14	A2#2	A2#4	435.224701
Rg15	A2#3	A2#5	404.209686
Rg16	A2#3	A2#6	51.522579
Rg17	A2#6	A2#7	395.494293
Rg18	A2#3	A2#8	429.126801
Rg19	A2#6	A2#9	66.386436
Rg20	A2#9	A2#10	397.555725
Rg21	A2#6	A2#11	448.603302
Rg22	A2#9	A2#12	449.655212
Rg23	a_803_323#	a_803_323##2	432.173248
Rg24	a_803_323##2	a_803_323##3	70.538673
Rg25	a_803_323##3	a_803_323##4	185.273483
Rg26	a_803_323##4	a_803_323##5	602.350220
Rg27	a_803_323##2	a_803_323##6	363.531677
Rg28	a_803_323##2	a_803_323##7	446.171570
Rg29	a_803_323##3	a_803_323##8	405.827179
Rg30	a_803_323##3	a_803_323##9	437.389587
Rg31	a_803_323##4	a_803_323##10	477.364044
Rg32	a_803_323##4	a_803_323##11	405.631287
Rg33	B1_N#1	B1_N#2	461.894928
Rg34	B1_N#2	B1_N#3	499.751587
Rg35	B1_N#2	B1_N#4	408.309082
Rf1	A1	A1#13	4.094411
Rf2	A1#13	A1	13.772109
Rf3	A2	A2#13	2.977753
Rf4	A2#13	A2	14.888765
Rf5	a_46_74#	a_46_74##3	73.519249
Rf6	a_46_74##3	a_46_74##5	59.954357
Rf7	a_46_74##5	a_46_74##7	56.914433
Rf8	a_46_74##7	a_46_74##8	56.467007
Rf9	a_46_74##2	a_46_74##3	15.000000
Rf10	a_46_74##4	a_46_74##5	15.000000
Rf11	a_46_74##6	a_46_74##7	15.000000
Rf12	Y#1	Y	83.515305
Rf13	Y	Y#3	176.453156
Rf14	Y	Y#4	26.377922
Rf15	Y	Y#5	3.926359
Rf16	Y#5	Y#6	22.217108
Rf17	Y#3	Y#7	72.954132
Rf18	Y#5	Y#8	55.718254
Rf19	Y#2	Y#3	15.000000
Rf20	a_31_368#	a_31_368##2	93.654243
Rf21	a_31_368##2	a_31_368##4	86.022263
Rf22	a_31_368##4	a_31_368##5	77.568657
Rf23	a_31_368##5	a_31_368##6	66.866013
Rf24	a_31_368##6	a_31_368##7	66.988586
Rf25	a_31_368##7	a_31_368##8	90.417343
Rf26	a_31_368##2	a_31_368##9	26.057018
Rf27	a_31_368##5	a_31_368##10	18.602406
Rf28	a_31_368##6	a_31_368##11	27.563665
Rf29	a_31_368##7	a_31_368##12	31.284834
Rf30	a_31_368##3	a_31_368##4	5.000000
Rf31	a_803_323##12	a_803_323##13	102.369049
Rf32	a_803_323##13	a_803_323##2	77.248833
Rf33	a_803_323##13	a_803_323##15	70.594086
Rf34	B1_N	B1_N#5	16.927925
Rf35	B1_N#5	B1_N	1.968364
Rf36	VPWR#1	VPWR#2	48.214260
Rf37	VPWR#2	VPWR#3	74.377396
Rf38	VPWR#3	VPWR#4	32.322075
Rf39	VPWR#3	VPWR#5	208.571152
Rf40	VPWR#5	VPWR#6	58.891026
Rf41	VPWR#5	VPWR#7	63.586746
Rf42	VPWR#7	VPWR#8	38.736572
Rf43	VPWR#7	VPWR#9	62.831711
Rf44	VPWR#9	VPWR#10	31.534731
Rf45	VPWR#9	VPWR#11	65.696381
Rf46	VPWR#11	VPWR#12	31.534731
Rf48	VGND#1	VGND#2	82.887779
Rf49	VGND#2	VGND#3	65.753731
Rf50	VGND#3	VGND#4	62.889057
Rf51	VGND#4	VGND#5	70.307396
Rf52	VGND#5	VGND#6	63.602451
Rf54	VGND#2	VGND#8	31.042643
Rf55	VGND#3	VGND#9	43.678436
Rf56	VGND#4	VGND#10	47.259827
Rf57	VGND#5	VGND#11	34.659180
Rf58	VGND#6	VGND#12	31.161278
Rf62	B1_N#2	B1_N#5	160.232803
Rf59	A1#4	A1#13	40.058201
Rf60	A2#3	A2#13	40.058201
Re1	VPWR#2	VPWR	6.179563
Re2	VPWR	VPWR#5	0.882795
Re3	VGND#1	VGND	6.179563
Re4	VGND	VGND#5	0.882795
*
*       CAPACITOR CARDS
*
*
C1	a_31_368#	a_803_323##12	2.57724e-18
C2	VGND#4	VGND#9	7.21957e-19
C3	a_803_323##15	B1_N#3	2.2082e-17
C4	Y#5	a_803_323##10	2.25935e-17
C5	VGND#2	Y#1	7.17409e-18
C6	a_31_368#	VPWR#4	6.33911e-17
C7	VGND#8	B1_N#3	3.73213e-17
C8	VGND#4	Y#4	8.70086e-18
C9	a_803_323##15	a_803_323#	9.55284e-19
C10	Y#5	A2#4	1.26641e-18
C11	Y#1	B1_N#3	8.51574e-19
C12	VGND#8	a_803_323#	3.70002e-17
C13	VGND#3	Y#4	7.17409e-18
C14	a_31_368#	Y#8	9.47306e-17
C15	a_803_323##15	a_803_323##6	2.09456e-19
C16	Y#5	A2#5	4.21519e-19
C17	Y#1	a_803_323#	1.14654e-17
C18	a_31_368##9	a_31_368#	4.01585e-18
C19	VGND#8	a_803_323##6	2.72986e-18
C20	VGND#9	a_803_323#	1.12012e-19
C21	Y#1	a_803_323##6	4.83004e-17
C22	Y#5	A2#7	2.9829e-19
C23	a_31_368##9	Y#8	5.1421e-17
C24	VGND#4	a_46_74#	3.55917e-18
C25	VGND#8	a_803_323##8	3.18252e-19
C26	a_803_323##6	VGND#9	1.38942e-17
C27	Y#5	a_31_368##2	3.73623e-18
C28	Y#6	Y#8	2.73857e-18
C29	Y#1	a_803_323##8	1.39394e-18
C30	Y#4	a_803_323##6	3.76767e-19
C31	VGND#11	VGND#4	2.00048e-18
C32	VGND#9	a_803_323##8	2.7535e-17
C33	Y#6	a_31_368##9	5.14033e-17
C34	Y#1	a_803_323##10	2.03573e-19
C35	a_803_323##8	Y#4	1.16589e-17
C36	a_31_368##3	a_31_368##9	4.01585e-18
C37	VPWR#5	a_803_323##4	2.85678e-20
C38	VGND#9	a_803_323##10	1.07897e-18
C39	Y#4	a_803_323##10	3.07911e-17
C40	a_31_368##3	Y#6	6.05877e-17
C41	VPWR#5	A2#6	3.52104e-20
C42	VGND#9	A2#4	1.8513e-20
C43	a_803_323##10	VGND#10	1.98607e-17
C44	Y#4	A2#4	1.4602e-19
C45	Y#8	a_803_323##3	9.52772e-20
C46	a_46_74#	a_803_323##10	1.89575e-18
C47	VGND#4	a_803_323##4	1.1834e-20
C48	VPWR#3	B1_N#4	9.68081e-19
C49	a_31_368##3	VPWR#6	5.79867e-17
C50	VGND#8	a_803_323##13	2.81062e-17
C51	VGND#10	A2#4	2.22349e-18
C52	VGND#11	a_803_323##10	1.1047e-18
C53	a_46_74#	A2#4	3.77069e-17
C54	a_31_368##10	a_31_368##3	2.33151e-18
C55	a_46_74##2	a_803_323##10	5.70696e-20
C56	VGND#5	A2#6	3.57894e-20
C57	VPWR#3	a_803_323##7	4.4661e-18
C58	a_803_323##4	a_31_368##9	4.24035e-19
C59	VGND#11	A2#4	2.65992e-17
C60	a_31_368##10	VPWR#6	5.20507e-17
C61	a_46_74#	A2#5	4.33532e-19
C62	a_46_74##2	A2#4	7.1157e-19
C63	a_31_368##9	a_803_323##3	2.95391e-19
C64	VGND#3	a_803_323##4	1.30174e-20
C65	VGND#11	A2#5	2.6453e-17
C66	VGND#4	a_803_323##5	2.53465e-19
C67	VPWR#8	VPWR#6	1.94092e-18
C68	VPWR#3	a_803_323##9	4.4293e-18
C69	a_46_74#	A2#7	1.89459e-19
C70	a_46_74##2	A2#5	2.76091e-17
C71	a_803_323##13	a_803_323##7	1.71909e-18
C72	VPWR#8	a_31_368##10	5.30395e-17
C73	VGND#11	A2#7	2.02546e-18
C74	VGND#12	A2#5	2.02546e-18
C75	VGND#3	a_803_323##3	2.1893e-20
C76	Y#2	A2#4	1.5383e-19
C77	a_803_323##4	Y#6	7.46956e-19
C78	a_46_74##2	A2#7	2.87784e-17
C79	a_31_368##11	a_31_368##10	1.79241e-18
C80	a_46_74##4	A2#5	1.7432e-19
C81	VGND#12	A2#7	2.80574e-17
C82	a_31_368#	a_803_323#	3.19036e-18
C83	Y#2	A2#5	1.91081e-19
C84	a_31_368##11	VPWR#8	5.11921e-17
C85	a_46_74##2	A2#10	4.01452e-19
C86	a_46_74##4	A2#7	7.80429e-19
C87	a_803_323##2	a_803_323##4	1.37748e-18
C88	VGND#12	A2#10	2.47104e-17
C89	VPWR#10	VPWR#8	2.66815e-18
C90	Y#2	A2#7	8.08685e-18
C91	a_803_323##2	a_803_323##3	1.81508e-17
C92	a_46_74##2	A1#1	1.69348e-19
C93	Y#5	a_803_323##7	3.89604e-19
C94	a_46_74##4	A2#10	2.35651e-17
C95	VPWR#7	A2#1	8.74044e-20
C96	VPWR#10	a_31_368##11	5.20507e-17
C97	VGND#12	A1#1	2.05194e-18
C98	Y#2	A2#10	8.70683e-18
C99	a_31_368##2	a_803_323##9	1.54858e-17
C100	a_31_368##12	a_31_368##11	8.12386e-19
C101	a_46_74##4	A1#1	3.63326e-17
C102	Y#5	a_803_323##9	8.34731e-18
C103	VGND#12	A1#6	8.06543e-19
C104	VPWR#7	A2#8	3.00302e-19
C105	Y#2	A1#1	2.96754e-17
C106	a_31_368##12	VPWR#10	5.05943e-17
C107	Y#5	Y#1	2.2315e-19
C108	a_31_368##6	a_803_323##5	8.61809e-20
C109	a_31_368##2	a_803_323##11	1.46637e-17
C110	a_46_74##4	A1#6	3.79557e-19
C111	A2#3	a_803_323##4	5.13208e-19
C112	Y#5	a_803_323##11	1.34628e-17
C113	a_46_74##8	A2#10	9.66198e-20
C114	VGND#12	A1#8	3.61512e-19
C115	VPWR#12	VPWR#10	2.06271e-18
C116	A2#3	A2#9	6.04076e-18
C117	Y#2	A1#6	3.64998e-17
C118	A2#3	A2#6	3.31356e-17
C119	A2#3	A2#2	1.18779e-17
C120	VPWR#7	A2#11	5.25752e-18
C121	a_46_74##4	A1#8	1.85797e-19
C122	Y#5	VGND#9	1.79791e-17
C123	a_31_368##6	A2#1	1.28021e-19
C124	a_46_74##6	A1#6	3.39055e-17
C125	a_31_368##2	a_803_323##5	4.90111e-18
C126	VPWR#12	a_31_368##12	5.05407e-17
C127	a_46_74##8	A1#1	1.41678e-19
C128	a_803_323##4	a_803_323##3	8.65591e-18
C129	VGND#12	A1#10	3.2813e-19
C130	A2#3	A1#2	5.59342e-18
C131	a_31_368##5	A2#1	1.07385e-19
C132	Y#2	A1#8	1.88612e-18
C133	Y#5	a_803_323##5	1.15345e-17
C134	VGND#4	VGND#3	2.00228e-18
C135	Y#7	A1#6	1.0679e-18
C136	a_31_368##8	a_31_368##12	8.39315e-19
C137	a_46_74##4	A1#10	2.16356e-19
C138	a_46_74##6	A1#8	3.39361e-17
C139	a_46_74##8	A1#6	2.36421e-19
C140	Y#5	Y#4	4.94874e-19
C141	VPWR#7	A2#12	4.71655e-18
C142	a_31_368##6	A2#8	2.13148e-19
C143	Y#2	A1#10	8.0125e-19
C144	Y#7	A1#8	3.94389e-17
C145	a_31_368##8	VPWR#12	5.53712e-17
C146	Y#5	A2#1	6.8465e-19
C147	a_31_368##5	A2#8	1.75903e-17
C148	a_46_74##8	A1#8	2.01559e-18
C149	VPWR#9	A1#5	1.83922e-18
C150	A2#6	VPWR#6	6.2216e-19
C151	Y#5	VGND#10	2.20219e-17
C152	A1#10	Y#7	1.6667e-17
C153	A1#9	A1#4	4.03955e-18
C154	a_31_368##6	A2#11	4.81711e-19
C155	VPWR#7	A1#5	3.95329e-19
C156	Y#5	A2#8	3.04264e-19
C157	A1#4	A1#2	2.15759e-18
C158	a_31_368##5	A2#11	1.76118e-17
C159	a_46_74##8	A1#10	5.16017e-17
C160	A2#2	VPWR#6	5.98782e-19
C161	VGND#3	VGND#2	9.16608e-19
C162	a_31_368##7	A2#12	9.62907e-20
C163	a_46_74#	Y#5	1.25416e-18
C164	VPWR#9	A1#7	1.83922e-18
C165	a_31_368##6	A2#12	1.72013e-17
C166	Y#5	A2#11	1.64237e-19
C167	a_31_368##5	A2#12	1.11924e-19
C168	a_803_323#	B1_N#3	4.36496e-17
C169	a_31_368##7	A1#5	2.23229e-19
C170	A2#6	a_31_368##10	6.21314e-19
C171	a_31_368##6	A1#5	1.70155e-17
C172	VGND#8	a_803_323##15	5.63242e-17
C173	VPWR#1	B1_N#1	2.11975e-17
C174	Y#5	A2#12	1.15633e-19
C175	VGND#9	a_803_323##3	1.80044e-19
C176	a_31_368##5	A1#5	4.34608e-20
C177	VGND#10	a_803_323##5	8.50533e-19
C178	a_803_323##6	a_803_323#	3.95881e-17
C179	Y#2	a_31_368##6	1.5483e-17
C180	a_803_323##12	B1_N#1	5.17354e-17
C181	a_31_368##7	A1#7	1.44667e-17
C182	VPWR#1	B1_N#4	6.6723e-19
C183	VPWR#4	B1_N#1	2.69793e-18
C184	Y#1	a_803_323##15	3.07354e-18
C185	a_31_368##6	A1#7	4.87898e-19
C186	a_803_323##3	a_803_323##7	1.12133e-18
C187	a_803_323##12	B1_N#4	4.1723e-17
C188	A2#9	VPWR#8	6.29318e-19
C189	a_803_323##12	VPWR#3	8.8417e-18
C190	a_31_368#	B1_N#1	2.87642e-19
C191	a_803_323##8	a_803_323##6	3.65454e-17
C192	VPWR#4	B1_N#4	5.15829e-17
C193	a_31_368##7	A1#11	1.43544e-17
C194	Y#1	VGND#8	5.34535e-17
C195	A2#6	VPWR#8	6.13865e-19
C196	a_803_323##12	a_803_323##7	3.29223e-19
C197	a_31_368##6	A1#11	2.58886e-19
C198	a_31_368#	B1_N#4	2.66245e-18
C199	VPWR#4	a_803_323##7	2.29929e-18
C200	A2#2	a_803_323##4	2.24659e-18
C201	a_803_323##10	a_803_323##8	3.98484e-17
C202	a_31_368#	a_803_323##7	4.20339e-17
C203	VGND#9	VGND#8	7.42219e-19
C204	a_31_368##7	A1#12	4.70377e-19
C205	a_31_368##9	B1_N#4	1.02741e-19
C206	VPWR#3	a_803_323##4	5.62438e-22
C207	a_31_368##6	A1#12	2.19936e-19
C208	VPWR#4	a_803_323##9	2.03279e-19
C209	Y#8	a_803_323##7	5.53618e-17
C210	a_31_368#	a_803_323##9	7.64206e-19
C211	a_31_368#	VPWR#3	4.57829e-17
C212	a_31_368##9	a_803_323##7	1.22938e-18
C213	A2#4	a_803_323##10	4.73601e-18
C214	VGND#10	a_803_323##4	8.87541e-19
C215	Y#1	VGND#9	4.32887e-17
C216	VPWR#2	VPWR#3	2.54508e-18
C217	VPWR#4	a_803_323##11	6.99797e-20
C218	Y#8	a_803_323##9	4.73278e-17
C219	VPWR#3	a_803_323##3	1.11636e-20
C220	VPWR#7	A2#6	1.0918e-20
C221	a_31_368#	a_803_323##11	3.25217e-19
C222	a_803_323##9	a_31_368##9	2.47151e-17
C223	a_803_323##13	a_803_323##12	1.73891e-18
C224	A2#9	A2#6	2.85614e-18
C225	Y#4	Y#1	2.4284e-18
C226	VPWR#4	a_803_323##5	3.97099e-20
C227	Y#8	a_803_323##11	1.46973e-18
C228	Y#6	a_803_323##9	1.42627e-18
C229	A2#5	A2#4	4.00807e-17
C230	a_803_323##11	a_31_368##9	2.88042e-17
C231	a_31_368##3	a_803_323##9	3.25217e-19
C232	Y#6	a_803_323##11	4.63333e-17
C233	a_803_323##13	VPWR#4	1.71356e-17
C234	Y#4	VGND#9	3.76178e-17
C235	A2#7	A2#5	4.20326e-17
C236	a_31_368##9	a_803_323##5	7.30993e-19
C237	VGND#5	VGND#4	8.29526e-19
C238	a_31_368##3	a_803_323##11	7.64206e-19
C239	VPWR#7	VPWR#5	7.0017e-19
C240	Y#6	a_803_323##5	3.9742e-17
C241	a_31_368##9	A2#1	3.04727e-19
C242	a_31_368##3	a_803_323##5	3.09182e-17
C243	a_31_368#	a_803_323##13	3.93996e-17
C244	A2#10	A2#7	4.00511e-17
C245	Y#6	A2#1	1.08686e-18
C246	a_31_368##3	A2#1	6.69378e-17
C247	VGND#10	Y#4	4.08422e-17
C248	VGND#2	B1_N#2	4.22005e-20
C249	A2#1	VPWR#6	2.42056e-17
C250	a_31_368##5	VPWR#5	3.13618e-19
C251	A1#1	A2#10	4.1112e-17
C252	a_31_368##3	A2#8	1.91204e-18
C253	a_31_368##10	A2#1	1.66337e-18
C254	VPWR#9	VPWR#7	1.20296e-18
C255	a_31_368##2	VPWR#5	4.21817e-17
C256	A2#8	VPWR#6	2.83688e-17
C257	VPWR#8	A2#1	1.72497e-19
C258	a_46_74#	Y#4	7.47511e-19
C259	VPWR#3	B1_N#2	3.70744e-20
C260	VGND#3	a_803_323##2	2.67527e-20
C261	a_46_74#	A2#6	2.77391e-19
C262	a_31_368##10	A2#8	5.23881e-17
C263	VGND#2	a_803_323##2	6.60087e-19
C264	A1#6	A1#1	4.05125e-17
C265	A2#2	a_803_323##5	1.15222e-17
C266	A1#2	VPWR#10	6.13865e-19
C267	VPWR#6	A2#11	3.44144e-19
C268	VPWR#8	A2#8	3.71489e-19
C269	VGND#1	a_803_323##15	9.46745e-18
C270	A2#6	A2#2	2.85482e-18
C271	a_46_74#	VGND#10	2.88899e-17
C272	a_803_323##13	B1_N#2	1.43114e-17
C273	a_31_368##10	A2#11	4.59753e-17
C274	a_46_74#	A2#2	6.3513e-20
C275	a_803_323##2	VPWR#3	3.17121e-19
C276	A2#11	VPWR#8	2.21054e-17
C277	VPWR#6	A2#12	1.53981e-19
C278	A1#8	A1#6	4.18584e-17
C279	a_31_368##10	VPWR#7	6.7581e-18
C280	a_31_368##11	A2#11	2.63233e-19
C281	a_31_368##10	A2#12	1.67533e-18
C282	VGND#11	VGND#10	4.1002e-18
C283	VPWR#8	A2#12	4.28625e-17
C284	a_803_323##13	a_803_323##2	8.67735e-19
C285	Y#5	B1_N#2	1.59354e-19
C286	A2#12	a_31_368##11	1.98967e-17
C287	VGND#2	a_803_323##13	2.32806e-19
C288	a_31_368##10	A1#5	1.63495e-19
C289	A1#10	A1#8	4.12835e-17
C290	VGND#11	A2#6	5.27258e-19
C291	VPWR#10	A2#12	2.12694e-18
C292	VPWR#8	A1#5	1.65292e-18
C293	a_46_74#	VGND#11	2.4866e-17
C294	a_31_368##12	A2#12	6.41938e-20
C295	A1#5	a_31_368##11	2.52147e-17
C296	a_31_368##2	a_803_323##2	7.66405e-20
C297	a_31_368##2	Y#8	1.40437e-17
C298	Y#5	a_803_323##2	7.28082e-17
C299	VPWR#10	A1#5	5.22195e-17
C300	a_31_368##11	VPWR#9	5.25841e-18
C301	VPWR#9	A1#4	2.01982e-20
C302	VGND#11	A2#2	5.1126e-20
C303	A2#3	a_31_368##6	1.64769e-17
C304	a_31_368##12	A1#5	1.48819e-19
C305	a_803_323##15	B1_N#2	7.18924e-18
C306	a_46_74##2	a_46_74#	2.27239e-18
C307	a_31_368##11	A1#7	2.66014e-19
C308	A1#9	VPWR#12	6.06874e-19
C309	a_803_323##13	a_803_323##4	2.00216e-19
C310	A2#3	a_31_368##5	8.81376e-17
C311	a_803_323##12	VPWR#2	1.44229e-17
C312	Y#5	Y#8	2.51652e-19
C313	a_46_74##2	A2#9	1.08879e-19
C314	VGND#5	a_46_74#	5.18971e-18
C315	VPWR#10	A1#7	4.55295e-17
C316	a_31_368##11	VPWR#7	5.19734e-18
C317	VPWR#4	VPWR#2	5.18427e-20
C318	a_31_368##2	a_31_368##9	2.26845e-18
C319	a_31_368##6	a_31_368##3	1.25724e-20
C320	A1#7	a_31_368##12	2.10613e-17
C321	a_31_368##11	A1#11	1.14746e-19
C322	VGND#5	a_46_74##2	3.4563e-18
C323	A1	A2#9	5.98208e-18
C324	a_46_74##2	VGND#11	2.37359e-17
C325	a_31_368##7	A1#4	4.72169e-18
C326	VPWR#12	A1#7	2.64683e-18
C327	VPWR#10	A1#11	2.13205e-18
C328	A1	A1#9	2.05778e-17
C329	a_46_74##2	A2#6	1.44842e-18
C330	VGND#8	a_803_323##2	4.05264e-18
C331	a_803_323##13	a_803_323##3	5.38563e-19
C332	a_31_368##8	A1#7	1.8144e-19
C333	A1	A1#2	8.59569e-18
C334	A1#11	a_31_368##12	2.57546e-17
C335	a_31_368##5	a_31_368##3	6.12021e-19
C336	Y#5	a_31_368##9	2.50382e-17
C337	a_803_323##2	Y#1	5.18648e-17
C338	B1_N#4	B1_N#1	3.88247e-17
C339	a_803_323##2	VGND#9	3.13073e-18
C340	VPWR#12	A1#11	5.19089e-17
C341	VPWR#10	VPWR#7	6.61283e-20
C342	A1#2	A2#9	3.28736e-17
C343	a_31_368##2	Y#6	3.2321e-17
C344	VGND#12	VGND#11	7.37154e-18
C345	a_31_368##8	A1#11	7.88066e-19
C346	a_31_368##12	A1#12	3.08444e-19
C347	a_31_368##12	VPWR#9	5.20514e-18
C348	VPWR#12	A1#12	4.70804e-17
C349	a_803_323##7	B1_N#4	6.25694e-18
C350	Y#5	Y#6	1.80884e-19
C351	a_31_368##5	VPWR#6	1.77638e-17
C352	a_31_368##8	A1#12	3.75299e-17
C353	VGND#12	A2#9	4.08454e-19
C354	a_803_323##15	a_803_323##12	4.65983e-19
C355	a_46_74##2	VGND#12	2.47127e-17
C356	a_31_368##6	a_31_368##10	1.60699e-19
C357	a_803_323##9	a_803_323##7	4.56015e-17
C358	a_31_368##3	VPWR#5	3.57523e-17
C359	Y	A2#6	9.61325e-18
C360	Y	A2#2	1.541e-17
C361	a_803_323##12	B1_N#2	3.10152e-18
C362	a_31_368##7	VPWR#9	3.13618e-19
C363	VGND#12	A2#6	1.972e-19
C364	a_31_368##3	Y#5	1.33176e-17
C365	a_31_368##5	a_31_368##10	9.83678e-19
C366	VPWR#4	B1_N#2	5.49547e-19
C367	a_46_74##4	a_46_74##2	2.35493e-18
C368	a_31_368##10	VPWR#5	1.01705e-17
C369	a_31_368#	B1_N#2	3.72173e-19
C370	a_803_323##11	a_803_323##9	4.73277e-17
C371	a_31_368##6	VPWR#8	1.20651e-17
C372	VGND#2	B1_N#3	1.23573e-18
C373	Y#2	A2#3	5.42687e-17
C374	VGND#4	Y#5	4.60798e-19
C375	a_31_368##7	a_31_368##11	6.39754e-19
C376	a_46_74##4	VGND#12	4.0365e-17
C377	Y#2	a_46_74##2	3.39376e-17
C378	a_803_323##2	a_31_368#	4.2758e-17
C379	a_31_368##6	VPWR#9	3.13618e-19
C380	VGND#3	a_803_323#	5.72653e-19
C381	a_31_368##5	VPWR#8	1.31258e-17
C382	a_803_323##2	Y#8	5.00909e-17
C383	a_803_323##5	a_803_323##11	4.6221e-17
C384	Y#2	A1#4	8.99498e-18
C385	a_46_74##4	A2#9	3.62931e-19
C386	a_46_74##6	A1#4	8.31021e-19
C387	a_31_368##6	a_31_368##11	3.01325e-18
C388	VGND#3	Y#5	3.0608e-19
C389	Y#7	A1#4	3.80712e-18
C390	VGND#2	a_803_323#	3.84291e-18
C391	Y#2	VGND#12	9.73901e-20
C392	a_46_74##8	A1#4	2.76201e-19
C393	A2#1	a_803_323##5	5.04135e-17
C394	a_31_368##7	VPWR#10	1.56729e-17
C395	a_31_368##6	VPWR#7	3.13618e-19
C396	VGND#3	a_803_323##6	6.03502e-18
C397	A2#3	a_31_368##3	1.26863e-17
C398	a_46_74##4	Y#2	7.6922e-17
C399	A2#8	A2#1	4.74801e-17
C400	a_31_368##6	VPWR#10	1.56238e-17
C401	a_803_323##13	B1_N	3.45129e-17
C402	VGND#4	a_803_323##8	6.84664e-19
C403	a_803_323#	B1_N#2	1.86478e-17
C404	a_31_368##7	a_31_368##12	4.41789e-18
C405	A2#11	A2#8	4.58638e-17
C406	a_31_368##5	VPWR#7	3.13618e-19
C407	VGND#5	A2#4	1.2017e-18
C408	a_31_368##6	A2#9	4.04535e-19
C409	Y#2	A2#9	1.21774e-17
C410	VGND#5	A2#5	1.2017e-18
C411	VGND#3	a_803_323##8	5.84429e-18
C412	a_803_323##2	a_803_323#	1.2957e-17
C413	VGND	a_803_323##4	1.33524e-20
C414	A1#4	VPWR#10	6.47602e-19
C415	VPWR#2	B1_N#1	1.03863e-17
C416	A2#12	A2#11	4.70164e-17
C417	A1#4	a_31_368##12	6.57862e-19
C418	a_31_368##7	VPWR#12	2.78759e-17
C419	VPWR#2	B1_N#4	5.33834e-19
C420	VGND#4	a_803_323##10	6.68052e-18
C421	Y#2	a_46_74##6	3.7588e-17
C422	a_803_323##15	B1_N	3.41612e-17
C423	A1#4	VPWR#12	6.13865e-19
C424	Y#2	A2#6	8.50616e-18
C425	a_31_368##7	A1#9	8.71697e-19
C426	VPWR#3	a_803_323#	2.20846e-19
C427	A1#5	A2#12	4.61604e-17
C428	VGND#3	a_803_323##10	1.21263e-18
C429	Y#7	Y#2	5.02225e-18
C430	a_46_74##8	a_46_74##4	1.08955e-18
C431	A1	a_31_368##7	8.47503e-17
C432	A1#7	A1#5	4.65889e-17
C433	VPWR#5	a_803_323##7	3.85363e-20
C434	a_31_368##8	a_31_368##7	1.27996e-18
C435	A1	a_31_368##6	1.98608e-17
C436	VGND#4	Y	1.54572e-18
C437	VPWR#5	a_803_323##9	6.40414e-20
C438	VGND#4	A2#4	1.85214e-18
C439	a_46_74##4	A1#2	1.82633e-19
C440	a_31_368##5	A2#9	4.91425e-19
C441	B1_N#2	B1_N#1	2.42759e-18
C442	VPWR#5	a_803_323##11	4.62074e-18
C443	a_803_323##13	B1_N#3	6.65878e-18
C444	A1#11	A1#7	4.77552e-17
C445	B1_N	VPWR#1	2.47978e-17
C446	a_31_368##6	a_31_368##8	4.6216e-21
C447	a_46_74##6	Y#7	3.11996e-17
C448	VPWR#5	a_803_323##5	4.92198e-18
C449	B1_N	a_803_323##12	4.81188e-17
C450	Y#2	A1#9	9.16987e-19
C451	VGND#3	A2#4	6.23589e-20
C452	a_803_323##7	B1_N#2	1.85794e-18
C453	VPWR#5	A2#1	7.14112e-18
C454	a_803_323##4	VNB	2.39595e-17
C455	a_803_323##3	VNB	2.37674e-17
C456	A2#9	VNB	2.46228e-17
C457	A2#6	VNB	5.48528e-17
C458	A2#2	VNB	2.17905e-17
C459	A1#9	VNB	4.24197e-17
C460	A1#12	A1#11	4.63777e-17
C461	VPWR#5	A2#8	5.26209e-18
C462	A1#2	VNB	2.55744e-17
C463	VPWR#5	A2#11	5.30308e-19
C464	a_31_368##5	A2#6	4.68619e-18
C465	a_31_368##2	VPWR#3	3.1456e-17
C466	VPWR#5	A2#12	8.1728e-20
C467	a_803_323##13	a_803_323#	2.96726e-18
C468	VPWR	VPWR#9	5.39549e-17
C469	VPWR	VPWR#7	6.62473e-17
C470	VPWR	VPWR#3	1.08611e-16
C471	Y#2	A1	4.08204e-17
C472	Y#7	A1	2.52356e-17
C473	VPWR	a_803_323##13	1.64063e-18
C474	a_46_74##8	A1	3.09609e-17
C475	VPWR	a_31_368##7	3.6705e-18
C476	A2#3	a_803_323##5	3.29158e-18
C477	VPWR	a_31_368##6	3.12557e-18
C478	a_46_74##8	Y#7	4.59974e-17
C479	VPWR	a_31_368##5	2.93497e-18
C480	Y	a_46_74#	4.83008e-17
C481	A2#3	A2#1	1.88253e-18
C482	a_803_323##10	a_803_323##3	3.95516e-18
C483	VPWR	a_31_368##2	3.22792e-17
C484	Y	VGND#11	2.24562e-19
C485	Y#2	A1#2	1.04031e-17
C486	B1_N	a_803_323#	1.03792e-18
C487	VPWR	Y#5	4.1051e-18
C488	a_31_368##5	A2#2	8.60074e-19
C489	Y	a_46_74##2	3.27562e-17
C490	A2#3	A2#8	2.01987e-18
C491	a_31_368##2	a_803_323##4	1.70104e-19
C492	VGND	VGND#4	7.10806e-17
C493	A2#3	A2#11	2.03161e-18
C494	VGND	VGND#3	6.65237e-17
C495	VGND	VGND#2	5.7779e-17
C496	A2#3	A2#12	1.491e-18
C497	A2#3	A1#5	3.79827e-19
C498	VGND	a_803_323##13	1.99467e-18
C499	VGND	a_31_368##6	2.87651e-18
C500	a_31_368##7	a_31_368##6	5.78825e-19
C501	A1	a_31_368##8	4.00102e-17
C502	VPWR#2	B1_N#2	1.04885e-20
C503	Y	a_31_368##3	1.99886e-17
C504	VGND	Y#5	6.88313e-18
C505	a_31_368##6	A1#2	8.55302e-19
C506	VGND#1	B1_N#2	4.17207e-18
C507	a_31_368##2	a_803_323##3	5.55366e-21
C508	VPWR	a_803_323##12	9.16694e-18
C509	VGND	a_803_323##15	1.53157e-17
C510	VGND	VGND#8	2.28359e-17
C511	VPWR	VPWR#4	2.07056e-17
C512	VGND	Y#1	1.5031e-17
C513	VGND#4	VNB	3.18972e-17
C514	VPWR	a_31_368#	2.42168e-17
C515	VGND#3	VNB	2.70216e-17
C516	A2#2	a_803_323##10	4.47115e-19
C517	VPWR	Y#8	8.91396e-18
C518	VGND#2	VNB	3.02135e-17
C519	VGND	Y#4	1.53592e-17
C520	B1_N	a_803_323##7	9.47306e-20
C521	Y#5	B1_N#3	1.40762e-19
C522	VPWR#9	VNB	2.69791e-17
C523	VGND	a_46_74#	1.30993e-17
C524	VPWR	Y#6	1.02316e-17
C525	VPWR#7	VNB	2.54742e-17
C526	VGND	VGND#11	1.58657e-17
C527	VPWR	a_31_368##3	2.06669e-17
C528	VPWR#3	VNB	6.07514e-17
C529	VGND	a_46_74##2	1.33159e-17
C530	VGND	VGND#12	1.58288e-17
C531	VPWR	a_31_368##10	1.72175e-17
C532	VGND	a_46_74##4	1.93999e-17
C533	a_803_323##13	VNB	1.19149e-17
C534	VGND	Y#2	1.34853e-17
C535	a_31_368##6	VNB	3.91614e-18
C536	VGND	a_46_74##6	2.21808e-17
C537	VPWR	a_31_368##11	1.21964e-17
C538	VGND	Y#7	5.85938e-18
C539	a_803_323##2	B1_N#2	2.89417e-19
C540	VPWR	VPWR#10	2.17985e-17
C541	Y	A2#4	9.39952e-18
C542	VGND	a_46_74##8	2.3353e-17
C543	a_31_368##2	VNB	5.39756e-18
C544	VPWR	a_31_368##12	1.22396e-17
C545	Y#5	VNB	5.30986e-18
C546	Y	A2#5	7.73089e-18
C547	a_46_74##6	A1#2	1.05246e-19
C548	VPWR	VPWR#12	2.19926e-17
C549	VPWR	a_31_368##8	1.59555e-17
C550	VPWR	a_803_323#	9.43766e-19
C551	a_803_323##15	VNB	4.79683e-17
C552	VGND#8	VNB	2.48483e-18
C553	Y#1	VNB	2.79474e-18
C554	Y#5	a_803_323##4	2.91467e-17
C555	VGND#9	VNB	1.60815e-19
C556	Y#4	VNB	2.16576e-18
C557	VGND#10	VNB	3.41936e-18
C558	a_46_74#	VNB	4.8893e-18
C559	a_803_323##13	a_803_323##10	2.21675e-19
C560	VGND#11	VNB	2.01662e-19
C561	VGND#12	VNB	2.12167e-19
C562	Y#7	A1#9	4.96576e-19
C563	a_46_74##4	VNB	2.94442e-18
C564	Y#5	a_803_323#	9.18106e-20
C565	Y#2	VNB	2.82514e-18
C566	a_46_74##6	VNB	3.80412e-18
C567	Y#7	VNB	1.45272e-19
C568	a_46_74##8	VNB	4.53437e-17
C569	VGND	B1_N#3	1.80106e-18
C570	VPWR#1	VNB	4.50023e-17
C571	VGND	a_803_323#	2.4419e-19
C572	a_803_323##12	VNB	8.78562e-18
C573	VPWR#4	VNB	7.69961e-18
C574	VGND	a_803_323##6	2.87223e-19
C575	a_803_323##12	VPWR#1	6.63471e-17
C576	a_31_368#	VNB	1.53423e-17
C577	A1	A2#12	5.51915e-19
C578	B1_N	VPWR#2	1.29767e-17
C579	VGND	a_803_323##8	7.17665e-19
C580	Y#8	VNB	2.93546e-19
C581	Y	a_803_323##5	1.16854e-17
C582	A1	A1#5	1.57739e-18
C583	VGND	A2#4	6.92923e-19
C584	Y	A2#1	3.75736e-20
C585	VGND#1	B1_N	2.22565e-17
C586	a_31_368##3	VNB	2.29922e-18
C587	VGND	A2#5	6.22846e-19
C588	VPWR	B1_N#4	5.4384e-19
C589	A1	A1#7	2.09836e-18
C590	VPWR#6	VNB	2.92383e-18
C591	a_31_368##6	a_31_368##5	5.1918e-19
C592	VGND	A2#7	6.22846e-19
C593	a_31_368##10	VNB	2.1429e-18
C594	VPWR	a_803_323##7	2.00212e-18
C595	VPWR#8	VNB	4.09278e-19
C596	VGND	A2#10	7.62401e-19
C597	A1	A1#11	2.09839e-18
C598	a_31_368##11	VNB	4.60133e-18
C599	VPWR	a_803_323##9	1.57055e-18
C600	VGND	A1#1	6.08521e-19
C601	VPWR#10	VNB	2.18764e-19
C602	A1	A1#12	3.38376e-18
C603	VGND	A1#6	6.74838e-19
C604	VPWR	a_803_323##11	1.58438e-18
C605	a_31_368##12	VNB	4.61348e-18
C606	VPWR#12	VNB	2.49598e-18
C607	VGND	A1#8	7.8774e-19
C608	VPWR	a_803_323##5	1.48559e-18
C609	a_31_368##8	VNB	5.40547e-17
C610	B1_N	B1_N#2	3.38027e-17
C611	VGND	A1#10	1.55514e-18
C612	B1_N#3	VNB	3.11178e-17
C613	VPWR	A2#1	6.82038e-19
C614	Y#5	a_803_323##3	7.61835e-18
C615	a_803_323#	VNB	4.4922e-17
C616	VPWR	A2#8	8.27752e-19
C617	VGND#2	a_803_323##15	8.58992e-18
C618	a_803_323##6	VNB	2.64628e-17
C619	B1_N	a_803_323##2	3.39036e-20
C620	a_803_323##8	VNB	2.42425e-17
C621	VPWR	A2#11	7.02477e-19
C622	a_803_323##10	VNB	3.39423e-17
C623	A2#4	VNB	3.29964e-17
C624	VPWR	A2#12	1.11733e-18
C625	A2#5	VNB	2.32152e-17
C626	VPWR	A1#5	1.11915e-18
C627	A2#7	VNB	2.30209e-17
C628	A2#10	VNB	2.47381e-17
C629	VPWR	A1#7	1.08154e-18
C630	Y#5	a_803_323##6	6.49996e-20
C631	VPWR#4	VPWR#1	2.33032e-18
C632	A1#1	VNB	2.93518e-17
C633	VGND#3	VGND#8	1.1507e-18
C634	A1#6	VNB	2.92956e-17
C635	VPWR	A1#11	1.15118e-18
C636	A1#8	VNB	2.95576e-17
C637	VPWR	A1#12	2.08175e-18
C638	A1#10	VNB	3.98778e-17
C639	B1_N#1	VNB	4.49768e-17
C640	B1_N#4	VNB	3.03893e-17
C641	A1	A2#3	1.43495e-17
C642	a_803_323##7	VNB	4.0082e-17
C643	a_803_323##9	VNB	3.16783e-17
C644	A1	A1#4	3.39491e-17
C645	a_803_323##11	VNB	3.18503e-17
C646	VPWR	VPWR#5	1.12906e-16
C647	a_803_323##5	VNB	5.01801e-17
C648	A2#1	VNB	3.37207e-17
C649	Y	A2#3	9.10586e-17
C650	A2#8	VNB	3.25061e-17
C651	A2#11	VNB	3.06463e-17
C652	A2#12	VNB	2.69014e-17
C653	VGND	VGND#1	6.36621e-18
C654	VPWR	a_803_323##2	8.21532e-18
C655	A1#5	VNB	2.74284e-17
C656	A1#7	VNB	2.84494e-17
C657	VPWR	A2#3	5.50619e-18
C658	Y#5	a_803_323##13	3.42059e-18
C659	A1#11	VNB	2.86503e-17
C660	VGND	VGND#5	5.42925e-17
C661	A1#12	VNB	3.87771e-17
C662	VGND	B1_N#2	8.98176e-19
C663	VGND	a_803_323##2	8.01865e-18
C664	VPWR#2	VNB	1.27891e-16
C665	a_803_323##12	VPWR#4	6.58208e-17
C666	VGND#1	VNB	1.48832e-16
C667	VGND	A2#3	7.03514e-18
C668	VPWR#5	VNB	5.59565e-17
C669	VGND#5	VNB	2.87387e-17
C670	B1_N#2	VNB	8.74689e-17
C671	a_803_323##2	VNB	5.46255e-17
C672	A2#3	VNB	6.57514e-18
C673	VPWR	B1_N	1.55101e-18
C674	A1#4	VNB	4.93075e-17
C675	Y#5	a_803_323##8	1.42916e-17
C676	VGND	B1_N	1.58157e-18
C677	VPWR	A1	8.63119e-18
C678	a_46_74##8	A1#9	2.09443e-18
C679	VPWR	Y	1.57718e-18
C680	VGND	A1	1.1817e-17
C681	B1_N	VNB	5.06041e-17
C682	VGND	Y	9.52662e-18
C683	A1	VNB	3.23456e-17
C684	Y	VNB	7.37599e-18
C685	VGND#3	Y#1	6.81161e-18
C686	VPWR	VNB	2.95786e-16
C687	VGND	VNB	2.97764e-16
C688	VPWR#11	A1#12	1.83922e-18
C689	VGND#6	A2#7	1.2017e-18
C690	VGND#6	A1#4	1.7015e-19
C691	VGND#6	A1#6	5.35671e-18
C692	VGND#6	a_46_74##6	3.62464e-17
C693	VGND#6	A1#2	4.22022e-20
C694	VPWR#11	VPWR#9	1.22366e-18
C695	VPWR	VPWR#11	7.73713e-17
C696	VPWR#11	VNB	4.56688e-17
C697	VGND#6	A2#10	1.2017e-18
C698	VGND#6	a_46_74##4	2.34634e-17
C699	VGND#6	A1#9	5.2663e-20
C700	VGND#6	A1#8	5.35671e-18
C701	VGND#6	A1	8.97795e-19
C702	a_31_368##12	VPWR#11	5.25459e-18
C703	VPWR#11	A1#11	1.83922e-18
C704	VGND	VGND#6	1.77394e-16
C705	a_31_368##8	VPWR#11	1.78825e-17
C706	VPWR#11	A1#4	2.32007e-20
C707	VGND#6	VGND#5	1.14463e-18
C708	VGND#6	a_46_74##2	3.48472e-18
C709	VGND#6	A1#1	5.36658e-18
C710	VGND#6	A2#6	3.85076e-20
C711	a_31_368##7	VPWR#11	3.13618e-19
C712	VGND#6	a_46_74##8	3.30603e-17
C713	VGND#6	A1#10	5.35671e-18
C714	VGND#6	VNB	1.01772e-16
*
*
.ENDS sky130_fd_sc_hs__a21boi_4
*
