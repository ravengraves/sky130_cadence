* Extracted by Quantus, converted by sky130cad/quantus.py
*
*
*
*                       LINUX           Wed Nov 18 08:16:32 2026
*
*
*
*  PROGRAM  advgen
*
*  Name           : advgen - Quantus - (64-bit)
*  Version        : 25.1.0-p047
*  Build Date     : Thu Dec 11 23:20:30 PST 2025
*
*  HSPICE LIBRARY
*
*  OPERATING_TEMPERATURE 150
*  QRC_TECH_DIR <path>/tech
*
*
*

*
.SUBCKT sky130_fd_sc_hs__and2_4 VPB VNB VGND VPWR X B A
*
*
*  caps2d version: 10
*
*
*       TRANSISTOR CARDS
*
*
XM9 VGND#4 a_83_269##10 X#3 VNB sky130_fd_pr__nfet_01v8_lvt l=0.15 w=0.74 ad=0.2109 as=0.2072 pd=2.05 ps=2.04
XM6 VGND#6 a_83_269##7 X#3 VNB sky130_fd_pr__nfet_01v8_lvt l=0.15 w=0.74 ad=0.2072 as=0.2072 pd=2.04 ps=2.04
XM11 X#1 a_83_269##5 VGND#6 VNB sky130_fd_pr__nfet_01v8_lvt l=0.15 w=0.74 ad=0.3182 as=0.2072 pd=2.34 ps=2.04
XM15 X#1 a_83_269# VGND#5 VNB sky130_fd_pr__nfet_01v8_lvt l=0.15 w=0.74 ad=0.3182 as=0.2589 pd=2.34 ps=2.2
XM5 VGND#5 B#3 a_504_119##2 VNB sky130_fd_pr__nfet_01v8_lvt l=0.15 w=0.64 ad=0.2589 as=0.1952 pd=2.2 ps=1.89
XM12 a_504_119##2 A#7 a_83_269##17 VNB sky130_fd_pr__nfet_01v8_lvt l=0.15 w=0.64 ad=0.1952 as=0.208 pd=1.89 ps=1.93
XM13 a_83_269##17 A#1 a_504_119# VNB sky130_fd_pr__nfet_01v8_lvt l=0.15 w=0.64 ad=0.208 as=0.192 pd=1.93 ps=1.88
XM3 a_504_119# B#2 VGND#1 VNB sky130_fd_pr__nfet_01v8_lvt l=0.15 w=0.64 ad=0.192 as=0.1824 pd=1.88 ps=1.85
XM0 VPWR#5 a_83_269##12 X#5 VPB sky130_fd_pr__pfet_01v8 l=0.15 w=1.12 ad=0.3304 as=0.336 pd=2.83 ps=2.84
XM2 VPWR#8 a_83_269##11 X#5 VPB sky130_fd_pr__pfet_01v8 l=0.15 w=1.12 ad=0.336 as=0.336 pd=2.84 ps=2.84
XM8 X#6 a_83_269##8 VPWR#8 VPB sky130_fd_pr__pfet_01v8 l=0.15 w=1.12 ad=0.3584 as=0.336 pd=2.88 ps=2.84
XM10 X#6 a_83_269##4 VPWR#7 VPB sky130_fd_pr__pfet_01v8 l=0.15 w=1.12 ad=0.3584 as=0.39985 pd=2.88 ps=3.01
XM7 a_83_269##18 B#5 VPWR#7 VPB sky130_fd_pr__pfet_01v8 l=0.15 w=0.84 ad=0.273 as=0.39985 pd=2.33 ps=3.01
XM14 VPWR#6 A#5 a_83_269##18 VPB sky130_fd_pr__pfet_01v8 l=0.15 w=0.84 ad=0.273 as=0.273 pd=2.33 ps=2.33
XM4 a_83_269##13 A#6 VPWR#6 VPB sky130_fd_pr__pfet_01v8 l=0.15 w=0.84 ad=0.252 as=0.273 pd=2.28 ps=2.33
XM1 VPWR#1 B#1 a_83_269##13 VPB sky130_fd_pr__pfet_01v8 l=0.15 w=0.84 ad=0.2478 as=0.252 pd=2.27 ps=2.28
*
*
*       RESISTOR AND CAP/DIODE CARDS
*
Rg1	a_83_269#	a_83_269##2	318.816589
Rg2	a_83_269##2	a_83_269##3	54.221630
Rg3	a_83_269##2	a_83_269##4	452.270996
Rg4	a_83_269##3	a_83_269##5	324.760864
Rg5	a_83_269##3	a_83_269##6	98.163429
Rg6	a_83_269##6	a_83_269##7	320.203186
Rg7	a_83_269##3	a_83_269##8	431.347565
Rg8	a_83_269##6	a_83_269##9	66.386436
Rg9	a_83_269##9	a_83_269##10	322.953644
Rg10	a_83_269##6	a_83_269##11	450.251312
Rg11	a_83_269##9	a_83_269##12	451.875977
Rg12	A#1	A#2	373.826050
Rg13	A#2	A#3	23.798210
Rg14	A#3	A#4	15.233299
Rg15	A#4	A#5	375.299957
Rg16	A#2	A#6	375.299957
Rg17	A#4	A#7	373.826050
Rg18	B#1	B#2	802.782349
Rg19	B#2	B#3	1561.375854
Rg20	B#3	B#4	291.663208
Rg21	B#4	B#5	454.699371
Rf1	X#1	X#2	77.055130
Rf2	X#2	X#3	19.013641
Rf3	X#2	X	28.922405
Rf4	X	X#4	11.870840
Rf5	X#4	X#5	27.858217
Rf6	X#4	X#6	82.877319
Rf7	B#4	B#7	162.280548
Rf8	B#8	B	2.047745
Rf9	B#7	B#8	6.648888
Rf10	A#3	A	162.201172
Rf11	a_83_269##13	a_83_269##14	39.009758
Rf12	a_83_269##14	a_83_269##15	64.246559
Rf13	a_83_269##15	a_83_269##3	147.120422
Rf14	a_83_269##14	a_83_269##17	99.724739
Rf15	a_83_269##15	a_83_269##18	21.102406
Rf16	a_504_119#	a_504_119##2	131.099915
Rf17	VGND#1	VGND#2	175.006317
Rf18	VGND#2	VGND#3	75.765358
Rf19	VGND#3	VGND#4	113.193901
Rf20	VGND#2	VGND#5	42.906086
Rf21	VGND#3	VGND#6	38.050552
Rf22	VPWR#1	VPWR#2	100.291649
Rf23	VPWR#2	VPWR#3	71.966728
Rf24	VPWR#3	VPWR#4	76.187958
Rf25	VPWR#4	VPWR#5	114.076828
Rf26	VPWR#2	VPWR#6	33.503098
Rf27	VPWR#3	VPWR#7	35.032631
Rf28	VPWR#4	VPWR#8	41.422615
Re1	VPWR#3	VPWR	1.091357
Re2	VGND	VGND#2	1.091398
*
*       CAPACITOR CARDS
*
*
C1	X#2	a_83_269##6	4.17966e-18
C2	A#4	B#1	1.55205e-17
C3	a_504_119#	A#4	5.30439e-20
C4	a_83_269##15	VPWR#2	1.69201e-19
C5	a_83_269##17	A#4	8.95617e-18
C6	a_83_269##14	VPWR#2	3.18496e-19
C7	a_504_119##2	A#4	1.50748e-19
C8	a_83_269##15	a_83_269##14	4.73559e-19
C9	B#5	A#4	4.64326e-18
C10	a_83_269##9	a_83_269##6	9.98459e-19
C11	B#7	a_83_269##15	2.16225e-17
C12	VGND#3	X#2	7.84233e-18
C13	X#1	a_83_269##2	1.66602e-18
C14	VGND#6	a_83_269##6	6.2077e-19
C15	a_83_269##17	a_83_269##14	4.06672e-18
C16	a_504_119##2	a_83_269##15	2.04393e-18
C17	VGND#3	X#1	6.46455e-18
C18	VGND#5	a_83_269##15	3.60258e-18
C19	a_83_269##9	X#3	4.92263e-19
C20	a_83_269##6	X#3	2.90435e-19
C21	VGND#4	VGND#3	1.82716e-18
C22	VPWR#2	VPWR#1	1.77287e-18
C23	a_504_119##2	B#7	1.05693e-17
C24	VGND#1	a_504_119#	8.20072e-17
C25	a_83_269##13	VPWR#2	8.28024e-18
C26	B#7	VGND#5	2.2352e-17
C27	a_83_269##17	VGND#1	1.72378e-17
C28	a_83_269##17	a_504_119#	5.94678e-17
C29	a_83_269##14	VPWR#1	2.39646e-17
C30	a_83_269##18	VPWR#2	7.86028e-18
C31	a_504_119##2	a_504_119#	2.37093e-18
C32	VPWR#4	VPWR#7	2.67379e-19
C33	X#2	X#1	2.37989e-18
C34	a_83_269##14	a_83_269##13	3.31819e-18
C35	a_83_269##15	VPWR#6	1.76726e-17
C36	VPWR#7	VPWR#2	3.78062e-19
C37	a_504_119##2	a_83_269##17	7.4945e-17
C38	VPWR#3	a_83_269##2	1.11254e-20
C39	X#2	VGND#6	5.06404e-17
C40	X#6	VPWR#4	6.83726e-18
C41	a_83_269##14	VPWR#6	1.38583e-17
C42	a_83_269##15	a_83_269##18	8.07929e-19
C43	X#2	X#3	2.50422e-18
C44	a_83_269##18	a_83_269##14	9.02016e-19
C45	VGND#2	A#4	2.37343e-19
C46	VGND#5	a_504_119##2	7.05473e-17
C47	a_83_269##15	VPWR#7	3.58261e-17
C48	VPWR#6	A#4	1.23995e-18
C49	VGND#4	X#2	7.0465e-17
C50	X#5	VPWR#4	1.45692e-17
C51	VGND#2	a_83_269##2	1.08588e-19
C52	X#6	a_83_269##15	2.74392e-17
C53	X#1	VGND#5	4.28281e-17
C54	VPWR#5	VPWR#4	9.47412e-19
C55	VGND#1	VPWR#1	1.06363e-17
C56	VGND#6	VGND#5	3.10578e-18
C57	X#1	VGND#6	4.47767e-17
C58	B#4	A#4	3.65435e-17
C59	VGND#4	VGND#6	4.81381e-18
C60	a_83_269##14	B#2	3.08759e-18
C61	a_83_269##2	B#4	1.90516e-17
C62	VGND#3	B#3	7.25936e-19
C63	a_83_269##3	A#4	4.26298e-19
C64	a_83_269##3	a_83_269##9	2.69659e-20
C65	a_83_269##15	B#3	5.29267e-19
C66	a_83_269##3	a_83_269##6	1.13792e-17
C67	a_83_269##3	a_83_269##2	1.44004e-17
C68	a_83_269##13	VPWR#1	4.80335e-17
C69	VGND#3	a_83_269##5	7.49733e-19
C70	VGND#1	B#2	5.74144e-17
C71	VPWR#6	VPWR#1	4.63639e-18
C72	VGND#3	a_83_269##7	9.70243e-19
C73	B#2	a_504_119#	2.89067e-17
C74	VPWR#4	a_83_269##9	2.0376e-20
C75	VPWR#6	a_83_269##13	4.52113e-17
C76	VGND#1	A#1	3.07062e-18
C77	a_83_269##17	B#2	1.56297e-17
C78	X#2	A#7	8.22315e-20
C79	A#1	a_504_119#	2.35903e-17
C80	a_83_269##18	a_83_269##13	8.79466e-19
C81	VGND#3	a_83_269##10	4.3894e-18
C82	a_504_119##2	B#2	2.42764e-18
C83	VPWR#4	a_83_269##6	2.01043e-20
C84	a_83_269##17	A#1	5.00892e-17
C85	X#2	B#3	9.28522e-20
C86	a_83_269##18	VPWR#6	5.5856e-17
C87	a_504_119#	A#7	3.74945e-19
C88	a_504_119##2	A#1	1.3715e-18
C89	a_83_269##17	A#7	1.36446e-17
C90	VPWR#8	a_83_269##6	3.89445e-19
C91	VPWR#7	VPWR#6	4.53248e-18
C92	X#2	a_83_269#	3.66523e-19
C93	a_504_119#	B#3	1.64305e-19
C94	VPWR#2	B#1	2.7455e-18
C95	A#7	a_504_119##2	2.47808e-17
C96	VPWR#7	a_83_269##18	4.74037e-17
C97	a_83_269##17	B#3	2.573e-18
C98	VGND#4	VPWR#5	1.19093e-17
C99	X#2	a_83_269##5	7.23355e-19
C100	X#6	a_83_269##18	1.75568e-18
C101	a_504_119##2	B#3	4.73337e-17
C102	VPWR#2	A#6	1.59325e-18
C103	a_83_269##15	B#1	9.26876e-20
C104	a_83_269##17	a_83_269#	7.26736e-19
C105	B#3	VGND#5	1.65299e-17
C106	X#2	a_83_269##7	2.40906e-17
C107	X#6	VPWR#7	4.88278e-17
C108	a_83_269##9	X#5	2.27361e-19
C109	a_83_269##14	B#1	1.51695e-17
C110	a_504_119##2	a_83_269#	1.30892e-18
C111	a_83_269##17	a_83_269##5	3.99692e-19
C112	VPWR#2	A#5	8.46412e-19
C113	a_83_269##6	X#5	2.2433e-19
C114	VPWR#8	VPWR#7	2.2917e-18
C115	a_83_269##15	A#6	1.60829e-19
C116	VGND#5	a_83_269#	4.18494e-17
C117	X#2	a_83_269##10	2.13584e-17
C118	VGND#6	B#3	4.66879e-19
C119	a_83_269##14	A#6	9.82208e-18
C120	VGND#3	a_83_269##9	4.83329e-20
C121	a_83_269#	X#1	1.72368e-17
C122	X#6	VPWR#8	5.91359e-17
C123	a_83_269##17	a_83_269##7	3.23956e-19
C124	VGND#5	a_83_269##5	2.12436e-18
C125	a_83_269##15	A#5	1.19116e-17
C126	VGND#6	a_83_269#	1.00262e-18
C127	X#5	X#6	3.49127e-19
C128	VGND#4	B#3	2.36204e-19
C129	X#1	a_83_269##5	3.56045e-17
C130	a_83_269##14	A#5	2.17569e-19
C131	VGND#3	a_83_269##6	2.85164e-20
C132	VPWR#4	a_83_269##4	2.85644e-19
C133	VGND#6	a_83_269##5	3.41977e-17
C134	X#5	VPWR#8	5.83455e-17
C135	VPWR#2	a_83_269##4	3.31796e-19
C136	a_83_269##15	B#5	2.15311e-17
C137	X#1	a_83_269##7	4.47585e-19
C138	a_83_269##14	B#5	1.88769e-19
C139	VPWR#5	VPWR#8	2.2895e-18
C140	VGND#6	a_83_269##7	3.05e-17
C141	VPWR#4	a_83_269##8	7.51551e-18
C142	X#1	a_83_269##10	1.91698e-19
C143	a_83_269##15	a_83_269##4	4.90793e-18
C144	a_83_269##7	X#3	3.43101e-18
C145	VPWR#5	X#5	6.52045e-17
C146	A	A#4	3.15155e-17
C147	VGND#6	a_83_269##10	2.54956e-18
C148	B#2	A#4	1.49066e-17
C149	a_83_269##14	a_83_269##4	8.28861e-20
C150	VGND#4	a_83_269##7	1.34733e-18
C151	a_83_269##15	A#4	1.01321e-17
C152	VPWR#4	a_83_269##11	8.05332e-18
C153	a_83_269##10	X#3	1.54011e-17
C154	a_83_269##15	a_83_269##8	4.81136e-19
C155	VGND#4	a_83_269##10	2.37436e-17
C156	B#7	a_83_269##4	5.04887e-19
C157	VPWR#4	a_83_269##12	3.54332e-18
C158	B#2	A#1	5.1144e-17
C159	B	A#4	1.16313e-17
C160	VPWR#1	B#1	4.05638e-17
C161	a_83_269##14	A#4	1.66094e-17
C162	A#7	A#1	2.93428e-17
C163	B#3	B#2	4.57628e-19
C164	B#1	a_83_269##13	1.47757e-17
C165	VPWR#1	A#6	3.12467e-18
C166	VPWR#6	B#1	2.75833e-18
C167	VPWR#3	VPWR#4	4.43321e-17
C168	VPWR#3	VPWR#2	4.64871e-17
C169	A#6	a_83_269##13	1.95793e-17
C170	a_83_269##18	B#1	3.48682e-19
C171	B#3	A#7	4.68942e-17
C172	VPWR#6	A#6	4.74126e-17
C173	a_83_269##13	A#5	1.39102e-19
C174	a_83_269##15	VPWR#3	3.33425e-19
C175	a_83_269##18	A#6	1.49634e-18
C176	A#5	VPWR#6	3.44787e-17
C177	VPWR#7	A#6	3.48075e-19
C178	X	a_83_269##9	1.2413e-17
C179	VGND#2	VGND#3	5.00838e-17
C180	a_83_269#	B#3	2.97641e-17
C181	X	a_83_269##6	6.82939e-18
C182	a_83_269##13	B#5	6.00174e-20
C183	A#5	a_83_269##18	1.48421e-17
C184	X	a_83_269##2	2.74159e-20
C185	VPWR#1	a_83_269##4	1.05158e-19
C186	VPWR#6	B#5	1.77415e-18
C187	VPWR#7	A#5	7.29037e-19
C188	a_83_269##18	B#5	3.95521e-17
C189	a_83_269##5	a_83_269#	2.06687e-17
C190	VPWR#6	a_83_269##4	6.70288e-19
C191	B#5	VPWR#7	2.07561e-17
C192	a_83_269##18	a_83_269##4	1.34821e-18
C193	X#6	B#5	4.01808e-19
C194	VGND#2	B#7	4.43409e-19
C195	VPWR#7	a_83_269##4	4.90646e-17
C196	a_83_269##7	a_83_269##5	3.75755e-17
C197	a_83_269##18	a_83_269##8	1.51299e-19
C198	a_83_269##4	X#6	1.70374e-17
C199	a_83_269##15	B#4	2.65517e-18
C200	VGND#2	VGND#1	4.33855e-17
C201	VPWR#7	a_83_269##8	2.15686e-18
C202	VPWR#8	a_83_269##4	3.54892e-19
C203	B#3	A#4	4.96495e-19
C204	VPWR#4	a_83_269##3	1.22256e-20
C205	a_83_269##14	B#4	1.36305e-19
C206	VGND#2	a_504_119#	7.81764e-18
C207	X#6	a_83_269##8	6.547e-17
C208	a_83_269##10	a_83_269##7	3.74662e-17
C209	VGND#3	a_83_269##3	7.48428e-20
C210	VPWR#7	a_83_269##11	2.98039e-19
C211	a_83_269##8	VPWR#8	2.12949e-17
C212	VGND#2	a_504_119##2	5.73543e-17
C213	X#6	a_83_269##11	1.92372e-18
C214	X#5	a_83_269##8	5.59212e-20
C215	B#7	B#4	1.61471e-17
C216	a_83_269##3	a_83_269##14	1.24793e-18
C217	VGND#2	X#1	3.26619e-18
C218	VPWR#8	a_83_269##11	4.48384e-17
C219	VGND#6	VGND#2	3.56555e-19
C220	VPWR#3	VPWR#1	2.6288e-17
C221	X#6	a_83_269##12	3.21157e-19
C222	a_83_269##11	X#5	1.62586e-17
C223	VPWR#8	a_83_269##12	2.22632e-18
C224	VPWR#5	a_83_269##11	1.16752e-18
C225	a_83_269##3	B#7	3.70205e-17
C226	VGND#2	VGND#4	2.12524e-17
C227	a_83_269##17	B#4	2.36853e-19
C228	X#5	a_83_269##12	4.60848e-17
C229	a_83_269##18	VPWR#3	5.8263e-18
C230	a_504_119##2	B#4	1.58546e-18
C231	X#2	a_83_269##3	2.33209e-17
C232	VPWR#5	a_83_269##12	3.17948e-17
C233	VGND#5	B#4	2.77789e-18
C234	VGND	a_83_269##2	6.68243e-19
C235	X#6	VPWR#3	6.69271e-18
C236	A#6	B#1	3.88653e-17
C237	VGND#5	a_83_269##3	2.32254e-17
C238	a_83_269##3	X#1	6.32277e-17
C239	VPWR#3	VPWR#5	2.44223e-17
C240	a_83_269##3	VGND#6	2.69652e-18
C241	A#5	A#6	3.40157e-17
C242	VGND#2	B#2	4.75149e-18
C243	VPWR#7	B#4	3.70073e-19
C244	B#5	A#5	3.35371e-17
C245	VGND#2	A#1	5.72901e-19
C246	A	a_83_269##15	2.54167e-17
C247	VGND#2	A#7	1.53388e-18
C248	A	a_83_269##14	2.74016e-17
C249	A#4	VNB	7.31565e-17
C250	a_83_269##9	VNB	3.45393e-17
C251	VGND#2	B#3	2.26089e-17
C252	a_83_269##6	VNB	1.87151e-17
C253	a_83_269##4	B#5	3.25405e-17
C254	a_83_269##2	VNB	1.94125e-17
C255	a_83_269##3	X#6	5.31636e-17
C256	VGND#2	a_83_269#	3.05986e-18
C257	a_83_269##3	VPWR#8	2.72375e-18
C258	VGND#2	a_83_269##5	3.44143e-20
C259	B	a_83_269##15	2.86423e-17
C260	VGND#2	a_83_269##7	3.44143e-20
C261	a_83_269##8	a_83_269##4	4.2366e-17
C262	B#4	A#7	2.62166e-18
C263	B#3	B#4	5.53671e-19
C264	a_83_269##17	A	3.76356e-17
C265	a_504_119##2	A	2.37953e-18
C266	X	VPWR#4	2.82415e-19
C267	a_83_269##11	a_83_269##8	4.68049e-17
C268	VPWR#3	B#5	5.02591e-18
C269	B	a_83_269##17	2.79579e-18
C270	a_504_119##2	B	2.2764e-17
C271	a_83_269##12	a_83_269##11	4.65499e-17
C272	VPWR#3	a_83_269##4	2.72249e-18
C273	VPWR	VPWR#4	4.25048e-17
C274	X#2	X	2.228e-18
C275	VPWR	VPWR#2	4.85188e-17
C276	VPWR	a_83_269##15	4.22146e-18
C277	a_83_269##3	B#1	1.79855e-19
C278	VPWR	a_83_269##14	1.44316e-18
C279	VPWR	B#7	1.70886e-18
C280	a_83_269##4	B#4	3.73877e-18
C281	A	B#2	1.43832e-18
C282	a_83_269##3	B#5	8.43344e-19
C283	a_83_269##3	a_83_269##4	3.32912e-18
C284	VGND	VGND#3	5.05628e-17
C285	A	B#3	5.12427e-20
C286	a_83_269##3	a_83_269##8	5.42363e-19
C287	B	B#2	4.41299e-19
C288	X	X#6	2.16957e-18
C289	a_83_269##3	a_83_269##11	1.58175e-19
C290	X	VPWR#8	2.3191e-17
C291	VGND	B#7	2.40267e-18
C292	B#7	a_83_269##2	5.50473e-18
C293	B	B#3	5.90415e-19
C294	X	X#5	1.57704e-18
C295	a_83_269##3	a_83_269##12	1.64792e-19
C296	VPWR	VPWR#1	3.77337e-17
C297	VGND	X#2	1.37298e-17
C298	VPWR	a_83_269##13	1.14304e-17
C299	VPWR#5	X	3.53257e-17
C300	VGND	VGND#1	4.68393e-17
C301	VPWR#3	B#4	3.21356e-20
C302	VGND	a_504_119#	1.51207e-17
C303	VGND	a_83_269##17	1.1291e-17
C304	VPWR	a_83_269##18	1.51814e-17
C305	A	B#1	1.06338e-18
C306	VGND	a_504_119##2	2.38687e-17
C307	VPWR	VPWR#7	2.17612e-17
C308	VPWR#4	VNB	3.29031e-17
C309	a_83_269##3	VPWR#3	3.6234e-19
C310	VPWR	X#6	1.46633e-17
C311	VPWR#2	VNB	3.61636e-17
C312	VGND	X#1	1.28555e-17
C313	VGND#3	VNB	4.0479e-17
C314	a_83_269##15	VNB	2.62229e-18
C315	VPWR	X#5	1.4774e-17
C316	VGND#2	a_83_269##3	9.43197e-19
C317	a_83_269##14	VNB	7.87722e-18
C318	VGND	VGND#4	2.9757e-17
C319	VPWR	VPWR#5	3.0854e-17
C320	B#7	VNB	7.63894e-19
C321	X#2	VNB	7.49984e-18
C322	VGND#1	VNB	8.19287e-17
C323	a_83_269##3	B#4	5.26049e-18
C324	a_504_119#	VNB	8.58194e-18
C325	a_83_269##17	VNB	7.55234e-18
C326	a_504_119##2	VNB	8.7604e-18
C327	VGND#5	VNB	1.34442e-18
C328	X#1	VNB	5.70097e-18
C329	VGND	VPWR#5	3.872e-18
C330	VGND#6	VNB	1.41263e-18
C331	VGND	B#2	1.32128e-17
C332	VGND#4	VNB	7.26821e-17
C333	VPWR#1	VNB	7.81273e-17
C334	a_83_269##13	VNB	5.08873e-18
C335	X	a_83_269##4	1.67542e-19
C336	VPWR	B#1	4.29987e-18
C337	VGND	B#3	9.02506e-18
C338	VPWR#6	VNB	2.70624e-18
C339	a_83_269##18	VNB	3.12879e-18
C340	VGND	a_83_269#	3.7553e-18
C341	VPWR	A#6	4.39181e-18
C342	X	a_83_269##8	1.06867e-18
C343	VPWR#7	VNB	2.60221e-18
C344	VGND	a_83_269##5	4.07036e-18
C345	VPWR	A#5	6.24362e-18
C346	X#6	VNB	2.25414e-18
C347	X	a_83_269##11	1.92377e-17
C348	VGND	a_83_269##7	4.07036e-18
C349	VPWR#8	VNB	4.09278e-19
C350	VPWR	B#5	7.27874e-18
C351	X#5	VNB	2.33863e-18
C352	VGND	a_83_269##10	8.04821e-18
C353	X	a_83_269##12	9.08497e-18
C354	VPWR#5	VNB	7.90247e-17
C355	VPWR	a_83_269##4	3.01786e-18
C356	A	B#4	1.11041e-18
C357	B#2	VNB	1.11789e-16
C358	VPWR	a_83_269##8	3.39372e-19
C359	A#1	VNB	2.32313e-17
C360	A#7	VNB	2.44629e-17
C361	VPWR	a_83_269##11	2.54612e-19
C362	B#3	VNB	7.68911e-17
C363	B	B#4	6.00072e-18
C364	a_83_269#	VNB	2.70745e-17
C365	VPWR	a_83_269##12	4.40815e-18
C366	a_83_269##5	VNB	2.58995e-17
C367	a_83_269##7	VNB	2.51746e-17
C368	a_83_269##10	VNB	3.25145e-17
C369	VPWR	VPWR#3	2.25455e-17
C370	B#1	VNB	6.1257e-17
C371	A#6	VNB	2.71334e-17
C372	X	a_83_269##3	4.74796e-17
C373	A#5	VNB	3.06585e-17
C374	B#5	VNB	3.56662e-17
C375	a_83_269##4	VNB	3.44322e-17
C376	a_83_269##8	VNB	3.27784e-17
C377	VGND	VGND#2	6.34471e-17
C378	VPWR	a_83_269##3	4.7958e-18
C379	a_83_269##11	VNB	3.2242e-17
C380	B	A	3.59696e-17
C381	a_83_269##12	VNB	3.98227e-17
C382	VPWR#3	VNB	2.15969e-16
C383	VGND	a_83_269##3	8.37327e-18
C384	VGND#2	VNB	2.34338e-16
C385	VPWR	A	1.5608e-18
C386	B#4	VNB	2.64256e-17
C387	a_83_269##3	VNB	2.31868e-17
C388	VPWR	B	1.70775e-18
C389	VGND	A	2.69957e-18
C390	VPWR	X	2.48908e-18
C391	VGND	B	2.0896e-18
C392	A	VNB	1.20178e-18
C393	VGND	X	4.88821e-19
C394	B	VNB	4.47361e-19
C395	X	VNB	1.04993e-17
C396	X#2	a_83_269##9	5.43232e-18
C397	VPWR	VNB	6.66743e-17
C398	VGND	VNB	6.07294e-17
*
*
.ENDS sky130_fd_sc_hs__and2_4
*
