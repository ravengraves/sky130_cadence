* Extracted by Quantus, converted by sky130cad/quantus.py
*
*
*
*                       LINUX           Wed Nov 18 08:43:20 2026
*
*
*
*  PROGRAM  advgen
*
*  Name           : advgen - Quantus - (64-bit)
*  Version        : 25.1.0-p047
*  Build Date     : Thu Dec 11 23:20:30 PST 2025
*
*  HSPICE LIBRARY
*
*  OPERATING_TEMPERATURE 150
*  QRC_TECH_DIR <path>/tech
*
*
*

*
.SUBCKT sky130_fd_sc_hs__mux2_4 VPB VNB VGND VPWR X S A0 A1
*
*
*  caps2d version: 10
*
*
*       TRANSISTOR CARDS
*
*
XM22 a_27_368##10 S#1 VGND#13 VNB sky130_fd_pr__nfet_01v8_lvt l=0.15 w=0.64 ad=0.1824 as=0.2938 pd=1.85 ps=2.32
XM7 X#1 a_193_241##5 VGND#13 VNB sky130_fd_pr__nfet_01v8_lvt l=0.15 w=0.74 ad=0.2368 as=0.2938 pd=2.12 ps=2.32
XM10 X#1 a_193_241##11 VGND#12 VNB sky130_fd_pr__nfet_01v8_lvt l=0.15 w=0.74 ad=0.2368 as=0.3256 pd=2.12 ps=2.36
XM14 VGND#12 a_193_241##9 X#6 VNB sky130_fd_pr__nfet_01v8_lvt l=0.15 w=0.74 ad=0.3256 as=0.2072 pd=2.36 ps=2.04
XM21 VGND#11 a_193_241##7 X#6 VNB sky130_fd_pr__nfet_01v8_lvt l=0.15 w=0.74 ad=0.46585 as=0.2072 pd=2.91 ps=2.04
XM5 a_709_119##2 S#8 VGND#11 VNB sky130_fd_pr__nfet_01v8_lvt l=0.15 w=0.64 ad=0.224 as=0.46585 pd=1.98 ps=2.91
XM25 VGND#10 S#7 a_709_119##2 VNB sky130_fd_pr__nfet_01v8_lvt l=0.15 w=0.64 ad=0.3136 as=0.224 pd=2.26 ps=1.98
XM3 VGND#10 a_27_368##5 a_937_119##2 VNB sky130_fd_pr__nfet_01v8_lvt l=0.15 w=0.64 ad=0.3136 as=0.1792 pd=2.26 ps=1.84
XM23 a_937_119##2 a_27_368##4 VGND#9 VNB sky130_fd_pr__nfet_01v8_lvt l=0.15 w=0.64 ad=0.1792 as=0.3692 pd=1.84 ps=2.64
XM12 a_937_119# A0#4 a_193_241##22 VNB sky130_fd_pr__nfet_01v8_lvt l=0.15 w=0.64 ad=0.192 as=0.4992 pd=1.88 ps=2.84
XM18 a_193_241##13 A0#5 a_937_119# VNB sky130_fd_pr__nfet_01v8_lvt l=0.15 w=0.64 ad=0.2112 as=0.192 pd=1.94 ps=1.88
XM6 a_709_119# A1#7 a_193_241##13 VNB sky130_fd_pr__nfet_01v8_lvt l=0.15 w=0.64 ad=0.1984 as=0.2112 pd=1.9 ps=1.94
XM19 a_193_241##15 A1#1 a_709_119# VNB sky130_fd_pr__nfet_01v8_lvt l=0.15 w=0.64 ad=0.2112 as=0.1984 pd=1.94 ps=1.9
XM0 a_27_368##8 S#3 VPWR#11 VPB sky130_fd_pr__pfet_01v8 l=0.15 w=1 ad=0.295 as=0.4372 pd=2.59 ps=3.04
XM8 X#2 a_193_241##6 VPWR#11 VPB sky130_fd_pr__pfet_01v8 l=0.15 w=1.12 ad=0.5815 as=0.4372 pd=3.56 ps=3.04
XM24 VPWR#9 a_193_241##12 X#2 VPB sky130_fd_pr__pfet_01v8 l=0.15 w=1.12 ad=0.58005 as=0.5815 pd=3.55 ps=3.56
XM15 VPWR#9 a_193_241##10 X#4 VPB sky130_fd_pr__pfet_01v8 l=0.15 w=1.12 ad=0.58005 as=0.55105 pd=3.55 ps=3.35
XM20 X#4 a_193_241##8 VPWR#7 VPB sky130_fd_pr__pfet_01v8 l=0.15 w=1.12 ad=0.55105 as=0.556025 pd=3.35 ps=3.55
XM2 a_722_391##2 S#9 VPWR#7 VPB sky130_fd_pr__pfet_01v8 l=0.15 w=1 ad=0.3 as=0.556025 pd=2.6 ps=3.55
XM16 VPWR#6 S#4 a_722_391##2 VPB sky130_fd_pr__pfet_01v8 l=0.15 w=1 ad=0.5077 as=0.3 pd=3.2 ps=2.6
XM9 VPWR#6 a_27_368##6 a_936_391##2 VPB sky130_fd_pr__pfet_01v8 l=0.15 w=1 ad=0.5077 as=0.3 pd=3.2 ps=2.6
XM13 a_936_391##2 a_27_368# VPWR#5 VPB sky130_fd_pr__pfet_01v8 l=0.15 w=1 ad=0.3 as=0.4177 pd=2.6 ps=3.02
XM1 a_722_391# A0#6 a_193_241##20 VPB sky130_fd_pr__pfet_01v8 l=0.15 w=1 ad=0.3 as=0.33 pd=2.6 ps=2.66
XM11 a_193_241##18 A0#1 a_722_391# VPB sky130_fd_pr__pfet_01v8 l=0.15 w=1 ad=0.31 as=0.3 pd=2.62 ps=2.6
XM4 a_193_241##18 A1#5 a_936_391# VPB sky130_fd_pr__pfet_01v8 l=0.15 w=1 ad=0.31 as=0.3 pd=2.62 ps=2.6
XM17 a_936_391# A1#6 a_193_241##23 VPB sky130_fd_pr__pfet_01v8 l=0.15 w=1 ad=0.3 as=0.345 pd=2.6 ps=2.69
*
*
*       RESISTOR AND CAP/DIODE CARDS
*
Rg1	S#1	S#2	346.914032
Rg2	S#2	S#3	417.171356
Rg3	S#4	S#5	428.548065
Rg4	S#5	S#6	62.096523
Rg5	S#5	S#7	345.908142
Rg6	S#6	S#8	348.434235
Rg7	S#6	S#9	424.278534
Rg8	a_27_368#	a_27_368##2	428.548065
Rg9	a_27_368##2	a_27_368##3	62.096523
Rg10	a_27_368##2	a_27_368##4	345.908142
Rg11	a_27_368##3	a_27_368##5	336.931610
Rg12	a_27_368##3	a_27_368##6	425.890717
Rg13	a_193_241#	a_193_241##2	2427.363281
Rg14	a_193_241##2	a_193_241##3	208.089645
Rg15	a_193_241##3	a_193_241##4	314.718292
Rg16	a_193_241##4	a_193_241##5	528.189270
Rg17	a_193_241##5	a_193_241##6	862.519348
Rg18	a_193_241##2	a_193_241##7	297.133759
Rg19	a_193_241##7	a_193_241##8	900.051758
Rg20	a_193_241##3	a_193_241##9	299.867615
Rg21	a_193_241##9	a_193_241##10	868.313660
Rg22	a_193_241##4	a_193_241##11	299.867615
Rg23	a_193_241##11	a_193_241##12	868.313660
Rg24	A0#1	A0#2	478.389740
Rg25	A0#2	A0#3	49.693565
Rg26	A0#3	A0#4	462.704071
Rg27	A0#2	A0#5	537.918213
Rg28	A0#3	A0#6	403.175598
Rg29	A1#1	A1#2	483.635010
Rg30	A1#2	A1#3	30.596949
Rg31	A1#3	A1#4	22.738758
Rg32	A1#4	A1#5	424.119568
Rg33	A1#2	A1#6	424.106537
Rg34	A1#4	A1#7	480.312256
Rf1	X#1	X#3	43.007919
Rf2	X#3	X	4.350432
Rf3	X#3	X	8.402771
Rf4	X	X#5	10.932232
Rf5	X#5	X	0.777424
Rf6	X	X#6	28.744238
Rf7	X#2	X#3	15.000000
Rf8	X#4	X#5	15.000000
Rf9	S#6	S	412.078979
Rf10	S	S#2	165.031555
Rf11	a_27_368##3	a_27_368##9	420.827209
Rf12	a_27_368##9	a_27_368##10	101.334236
Rf13	a_27_368##8	a_27_368##9	7.500000
Rf14	A0#3	A0#8	160.988358
Rf15	A0#9	A0	0.755555
Rf16	A0#8	A0#9	6.101927
Rf17	a_937_119#	a_937_119##2	170.924011
Rf18	a_722_391#	a_722_391##2	227.967026
Rf19	a_709_119#	a_709_119##2	347.248169
Rf20	a_936_391#	a_936_391##2	246.558990
Rf21	A1	A1#8	3.149382
Rf22	A1#8	A1	15.746908
Rf23	a_193_241##13	a_193_241##14	16.967829
Rf24	a_193_241##14	a_193_241##16	75.049477
Rf25	a_193_241##16	a_193_241##17	89.109489
Rf26	a_193_241##17	a_193_241##19	42.014278
Rf27	a_193_241##19	a_193_241##21	47.325504
Rf28	a_193_241##14	a_193_241##22	82.733421
Rf29	a_193_241##17	a_193_241##23	21.155952
Rf30	a_193_241##21	a_193_241#	104.086868
Rf31	a_193_241##15	a_193_241##16	7.500000
Rf32	a_193_241##18	a_193_241##19	15.000000
Rf33	a_193_241##20	a_193_241##21	15.000000
Rf34	VGND#1	VGND#2	168.506897
Rf35	VGND#2	VGND#3	81.511429
Rf36	VGND#3	VGND#4	65.314827
Rf37	VGND#4	VGND#5	19.699100
Rf38	VGND#5	VGND#6	81.402237
Rf39	VGND#6	VGND#7	75.923454
Rf41	VGND#2	VGND#9	28.450712
Rf42	VGND#3	VGND#10	33.387405
Rf43	VGND#5	VGND#11	36.160385
Rf44	VGND#6	VGND#12	34.093605
Rf45	VGND#7	VGND#13	36.061966
Rf46	VPWR#1	VPWR#2	172.066727
Rf47	VPWR#2	VPWR#3	75.250298
Rf48	VPWR#3	VPWR#4	68.277679
Rf49	VPWR#2	VPWR#5	30.631947
Rf50	VPWR#3	VPWR#6	27.027714
Rf51	VPWR#4	VPWR#7	28.163580
Rf52	VPWR#4	VPWR#8	102.611412
Rf53	VPWR#8	VPWR#9	24.665678
Rf54	VPWR#8	VPWR#10	84.863747
Rf55	VPWR#10	VPWR#11	31.246290
Rf61	A1#3	A1#8	80.116402
Re1	VPWR#1	VPWR	3.735117
Re2	VPWR	VPWR#4	1.067176
Re3	VGND#1	VGND	3.735117
Re4	VGND	VGND#4	1.067176
*
*       CAPACITOR CARDS
*
*
C1	a_936_391##2	a_193_241##20	2.9516e-17
C2	a_193_241##22	A0#4	3.73896e-17
C3	VGND#2	a_193_241##22	3.103e-17
C4	a_937_119#	a_27_368##4	1.83308e-19
C5	a_193_241##15	a_193_241##17	4.59153e-18
C6	VGND#3	VGND#9	2.61364e-19
C7	a_936_391##2	VPWR#5	6.70517e-18
C8	VGND#9	A0#4	4.0382e-19
C9	a_193_241##5	a_193_241##4	2.85711e-19
C10	a_722_391##2	a_722_391#	1.09305e-18
C11	a_193_241##22	a_27_368##4	8.12598e-19
C12	A0#3	A0#2	8.26873e-18
C13	a_937_119##2	A0#4	2.53659e-19
C14	VPWR#6	VPWR#5	6.25047e-18
C15	a_27_368##4	VGND#9	1.69926e-17
C16	VGND#3	a_937_119##2	3.60478e-18
C17	a_27_368##2	A0#3	2.07605e-19
C18	a_936_391##2	VPWR#6	4.27872e-20
C19	a_722_391##2	VPWR#5	2.37418e-17
C20	a_937_119##2	a_27_368##4	3.85506e-17
C21	a_193_241##20	a_27_368##2	1.07563e-19
C22	VPWR#2	a_27_368#	8.00238e-18
C23	a_193_241##14	a_193_241##15	2.86408e-18
C24	a_193_241##17	A1#6	1.83544e-17
C25	VGND#9	a_27_368##5	8.45152e-19
C26	VGND#2	a_937_119##2	5.81662e-18
C27	VGND#10	a_27_368##4	1.46585e-18
C28	a_27_368##10	a_27_368##8	3.32257e-18
C29	a_722_391##2	a_936_391##2	6.7405e-17
C30	a_193_241##15	A1#4	4.74522e-18
C31	a_937_119##2	a_27_368##5	2.57167e-17
C32	VPWR#3	a_27_368##6	7.98617e-18
C33	a_709_119##2	a_27_368##4	1.82878e-17
C34	VGND#9	S#7	3.873e-19
C35	a_193_241##14	a_709_119#	8.8302e-17
C36	a_193_241##17	A1#5	8.33629e-20
C37	a_722_391##2	VPWR#6	6.02582e-17
C38	a_27_368##5	VGND#10	2.1198e-17
C39	VPWR#3	S#5	6.07846e-21
C40	a_937_119##2	S#7	6.08842e-19
C41	VGND#3	a_709_119##2	3.43867e-18
C42	a_709_119##2	a_27_368##5	2.44977e-17
C43	a_193_241#	a_27_368##2	3.43781e-17
C44	VPWR#7	VPWR#6	2.45295e-18
C45	VPWR#3	S#4	5.37908e-18
C46	VGND#10	S#7	3.55128e-17
C47	VPWR#2	a_27_368##2	1.04454e-20
C48	a_193_241##14	a_193_241##13	4.30151e-18
C49	A0#2	A1#4	3.36767e-17
C50	a_193_241##17	A0#1	4.48308e-20
C51	VGND#6	X#6	8.64626e-18
C52	a_937_119##2	S#8	2.27679e-19
C53	a_193_241##15	A0#2	3.23194e-19
C54	VPWR#7	a_722_391##2	1.74948e-17
C55	a_709_119##2	S#7	2.95391e-17
C56	a_709_119#	A1#4	1.44786e-17
C57	VPWR#8	S#9	5.99822e-19
C58	VGND#11	VGND#3	1.94823e-19
C59	VGND#10	S#8	2.22787e-18
C60	VGND#11	S#7	6.49152e-19
C61	VGND#5	X#6	9.34533e-18
C62	a_193_241##14	a_937_119#	4.80859e-17
C63	a_193_241##17	A0#6	3.51559e-20
C64	VPWR#3	VPWR#2	1.28814e-20
C65	a_709_119##2	S#8	4.01748e-17
C66	a_193_241##2	a_27_368##3	2.54321e-18
C67	VGND#10	a_193_241##7	8.46298e-19
C68	a_722_391##2	VPWR#9	6.46194e-20
C69	a_27_368##3	a_27_368##2	1.37472e-17
C70	S#8	VGND#11	2.01562e-17
C71	VPWR#8	a_193_241##8	2.40613e-18
C72	a_936_391##2	a_27_368##2	4.53789e-19
C73	a_27_368##3	S#5	4.17313e-17
C74	a_193_241##22	a_193_241##14	2.79837e-18
C75	a_709_119##2	a_193_241##7	9.33126e-19
C76	a_709_119#	A0#2	1.32672e-17
C77	VGND#6	X#1	7.92177e-18
C78	a_709_119#	A0#8	2.68482e-17
C79	a_193_241##7	VGND#11	2.95518e-17
C80	VGND#6	a_193_241##4	1.36158e-17
C81	VPWR#8	a_193_241##10	1.75575e-17
C82	X#6	a_193_241##7	3.8748e-17
C83	S#6	a_193_241##3	1.22605e-19
C84	VGND#11	a_193_241##9	1.68142e-19
C85	a_193_241##2	S#6	3.1796e-18
C86	VGND#12	a_193_241##7	3.58642e-19
C87	VGND#6	a_193_241##3	1.10874e-17
C88	S#6	S#5	3.56927e-18
C89	X#6	a_193_241##9	3.58721e-17
C90	VPWR#8	a_193_241##12	1.74902e-17
C91	VGND#11	a_193_241##11	8.54329e-20
C92	a_27_368##8	VPWR#7	1.10182e-20
C93	a_193_241##9	VGND#12	1.99282e-17
C94	X#6	a_193_241##11	1.40404e-18
C95	a_27_368##8	X#4	8.75084e-19
C96	X#1	a_193_241##9	1.31193e-18
C97	VGND#6	a_193_241##2	9.37001e-19
C98	S#2	a_193_241##4	2.76141e-19
C99	a_193_241##11	VGND#12	2.47538e-17
C100	S#2	a_193_241##3	5.00521e-20
C101	VGND#13	a_193_241##9	9.2299e-20
C102	VPWR#8	a_193_241##6	2.33823e-18
C103	a_27_368##8	VPWR#9	2.58893e-18
C104	X#1	a_193_241##11	4.6489e-17
C105	a_722_391##2	a_27_368##2	8.3087e-20
C106	VGND#12	a_193_241##5	3.89583e-19
C107	a_27_368##8	X#2	8.67698e-18
C108	VGND#13	a_193_241##11	1.36892e-18
C109	a_193_241##5	X#1	3.28992e-17
C110	a_722_391##2	S#5	1.22993e-19
C111	a_27_368##10	a_193_241##11	1.45594e-19
C112	a_27_368##8	VPWR#11	5.32678e-17
C113	VGND#12	S#1	3.32836e-19
C114	a_193_241##5	VGND#13	3.02797e-17
C115	VGND#5	a_193_241##2	2.04682e-17
C116	a_722_391#	VPWR#2	2.75418e-17
C117	X#1	S#1	1.18202e-18
C118	a_27_368##10	a_193_241##5	4.4119e-19
C119	S#1	VGND#13	2.62964e-17
C120	a_27_368##10	S#1	3.53445e-17
C121	VPWR#7	S#5	1.88143e-21
C122	a_193_241##15	a_709_119#	6.43453e-17
C123	VGND#3	a_193_241##2	4.12861e-17
C124	A1#7	A1#1	3.54968e-17
C125	A1#6	a_193_241##23	1.9452e-17
C126	VPWR#7	a_193_241##7	8.91978e-20
C127	A0#5	A1#7	3.01662e-17
C128	a_193_241##4	a_193_241##3	1.53468e-19
C129	VGND#6	VGND#5	5.00726e-19
C130	a_936_391#	A1#6	4.14111e-17
C131	a_193_241##23	A1#5	4.26833e-19
C132	VGND#3	S#5	5.68165e-20
C133	a_936_391#	A1#5	5.04598e-17
C134	A0#4	A0#5	3.63735e-17
C135	a_937_119#	a_709_119#	1.01704e-16
C136	a_193_241##23	A0#1	2.31507e-19
C137	a_193_241##18	A1#5	3.8582e-17
C138	a_193_241##20	A1#6	3.86249e-20
C139	VPWR#6	VPWR#2	5.02374e-19
C140	a_193_241##17	a_193_241##23	2.01074e-18
C141	a_936_391#	A0#1	1.98816e-17
C142	VGND#2	a_27_368##2	4.58133e-20
C143	a_722_391#	A1#5	2.05628e-18
C144	a_193_241##23	A0#6	2.2675e-19
C145	a_722_391##2	VPWR#3	1.0196e-17
C146	a_193_241##18	A0#1	4.10947e-17
C147	a_709_119#	a_193_241##22	1.51102e-19
C148	a_193_241##20	A1#5	4.55961e-20
C149	a_193_241##17	VPWR#1	2.94342e-18
C150	a_936_391##2	A1#6	1.55695e-19
C151	a_936_391#	A0#6	1.78847e-17
C152	VGND#5	VGND#3	5.26591e-19
C153	a_722_391#	A0#1	3.4264e-17
C154	VPWR#8	VPWR#7	3.99108e-18
C155	a_193_241##17	a_936_391#	1.62794e-17
C156	a_722_391##2	VPWR#2	3.72471e-18
C157	a_193_241##20	A0#1	7.72771e-20
C158	a_936_391##2	A1#5	1.26016e-19
C159	a_27_368##5	a_27_368##4	3.51547e-17
C160	a_722_391#	A0#6	4.9612e-17
C161	VPWR#7	VPWR#3	1.30581e-20
C162	VPWR#5	A0#1	2.70015e-19
C163	a_193_241##20	A0#6	4.03637e-17
C164	a_936_391##2	A0#1	2.05921e-19
C165	a_937_119#	a_193_241##22	9.56682e-17
C166	a_722_391#	a_27_368#	1.83066e-18
C167	VGND#1	a_193_241##14	1.04808e-16
C168	VPWR#5	A0#6	1.33216e-18
C169	VPWR#1	A0#8	6.99053e-19
C170	a_27_368##8	a_193_241##5	4.51548e-19
C171	a_193_241##3	a_193_241##2	3.42504e-19
C172	S#7	a_27_368##5	1.51002e-17
C173	a_193_241##20	a_27_368#	1.26781e-18
C174	a_936_391##2	A0#6	1.31383e-18
C175	a_722_391#	a_27_368##6	3.37728e-19
C176	VGND#3	VGND#2	7.82423e-19
C177	a_27_368#	VPWR#5	4.41741e-17
C178	a_937_119##2	a_193_241##2	3.01153e-18
C179	VPWR#8	VPWR#9	1.27003e-17
C180	VGND#1	A0#8	7.70127e-19
C181	a_193_241##20	a_27_368##6	2.27764e-19
C182	a_936_391##2	a_27_368#	4.7164e-17
C183	S#8	S#7	2.42913e-17
C184	a_722_391#	S#4	1.29946e-19
C185	VPWR#5	a_27_368##6	1.85894e-18
C186	VPWR#6	a_27_368#	3.80849e-18
C187	a_193_241##17	A1#4	1.33436e-17
C188	VGND#9	a_193_241##22	2.21581e-17
C189	a_937_119##2	a_27_368##2	1.12345e-19
C190	a_936_391##2	a_27_368##6	3.34517e-17
C191	a_722_391##2	a_27_368#	2.59718e-17
C192	VPWR#5	S#4	8.23588e-19
C193	a_27_368##6	VPWR#6	3.01535e-17
C194	a_193_241##7	S#8	1.36381e-17
C195	VPWR#2	a_193_241#	1.99211e-19
C196	a_936_391##2	S#4	2.24756e-18
C197	a_937_119##2	a_193_241##22	6.40759e-18
C198	a_722_391##2	a_27_368##6	3.25927e-17
C199	S#4	VPWR#6	3.27553e-17
C200	VGND#10	a_193_241##2	2.89202e-20
C201	VGND#1	a_193_241##15	7.44919e-17
C202	VPWR#7	a_27_368##6	3.50354e-19
C203	a_27_368##3	VPWR#8	2.09724e-18
C204	a_936_391##2	S#9	3.17959e-19
C205	VGND#1	a_709_119#	1.23816e-17
C206	a_722_391##2	S#4	5.85408e-17
C207	VPWR#3	a_27_368##3	2.74879e-20
C208	a_193_241##9	a_193_241##7	5.2531e-17
C209	a_937_119##2	VGND#9	4.91462e-17
C210	VPWR#11	VPWR#8	5.34109e-18
C211	VGND#3	a_193_241#	7.11214e-19
C212	a_937_119#	a_709_119##2	2.92359e-18
C213	VPWR#2	a_27_368##3	1.63095e-20
C214	VPWR#6	S#9	1.2897e-18
C215	VGND#2	a_193_241#	2.53177e-17
C216	VPWR#7	S#4	2.06845e-18
C217	a_193_241##17	A0#3	9.79781e-20
C218	a_193_241##17	A0#2	1.24231e-19
C219	VGND#1	a_937_119#	6.83402e-18
C220	S#9	a_722_391##2	1.99212e-17
C221	VGND#1	a_193_241##22	5.66074e-17
C222	a_193_241##14	A0#3	1.91673e-19
C223	VGND#10	VGND#9	8.00485e-18
C224	VPWR#6	a_193_241##8	4.21392e-19
C225	S#9	VPWR#7	4.24654e-17
C226	a_193_241##11	a_193_241##9	2.55308e-17
C227	VGND#3	a_27_368##3	2.15403e-19
C228	a_722_391##2	a_193_241##8	1.66156e-18
C229	a_27_368##8	VPWR#8	4.8659e-17
C230	VGND#2	a_27_368##3	7.1533e-20
C231	a_193_241##8	VPWR#7	3.3309e-17
C232	a_709_119##2	a_193_241##2	6.60736e-18
C233	A0#8	A0#3	1.15856e-17
C234	A0#8	a_722_391#	1.18556e-19
C235	VGND#10	a_937_119##2	3.18139e-17
C236	a_709_119##2	VGND#9	2.7319e-18
C237	a_193_241##14	a_193_241#	6.73593e-20
C238	a_193_241##5	a_193_241##11	4.12644e-17
C239	a_722_391##2	a_193_241##10	5.55379e-19
C240	a_193_241##8	X#4	2.63692e-17
C241	VGND#11	a_193_241##4	1.16908e-20
C242	VPWR#7	a_193_241##10	1.80544e-18
C243	VGND#3	S#6	1.43536e-19
C244	a_193_241##14	A1#4	3.46521e-19
C245	a_709_119##2	a_27_368##2	4.93808e-19
C246	a_722_391##2	a_193_241##12	3.58357e-19
C247	a_709_119##2	a_937_119##2	1.03406e-16
C248	a_193_241##10	X#4	2.81854e-17
C249	A0#8	a_193_241#	2.83043e-18
C250	a_193_241##20	A0#8	5.44872e-17
C251	S#1	a_193_241##5	2.64036e-17
C252	VGND#11	a_193_241##3	4.05352e-20
C253	a_193_241##2	S#5	1.03994e-19
C254	VPWR#7	a_193_241##12	5.08687e-19
C255	a_193_241##10	VPWR#9	2.59891e-17
C256	a_193_241##23	VPWR#1	4.45114e-17
C257	VPWR#11	a_193_241##8	4.18584e-19
C258	a_936_391#	VPWR#1	5.56947e-17
C259	a_193_241##15	A0#3	2.83251e-19
C260	a_709_119##2	S#5	9.23271e-19
C261	a_27_368##8	a_193_241##8	3.36841e-19
C262	a_709_119##2	VGND#10	7.41712e-17
C263	VGND#4	a_709_119##2	4.44877e-18
C264	a_709_119#	A0#3	1.74264e-17
C265	VPWR#1	a_193_241##18	4.44372e-18
C266	a_193_241##12	VPWR#9	2.6868e-17
C267	VPWR#11	a_193_241##10	1.09649e-18
C268	A1	A1#4	3.44412e-17
C269	VGND#11	a_193_241##2	1.3836e-17
C270	a_722_391#	VPWR#1	6.01641e-17
C271	A1	A0#2	1.08158e-17
C272	a_193_241##12	X#2	2.67277e-17
C273	a_27_368##8	a_193_241##10	2.5677e-17
C274	a_937_119#	A0#3	8.17657e-19
C275	VPWR#1	a_193_241##20	1.50101e-18
C276	a_193_241##22	A0#3	2.07724e-19
C277	VPWR#11	a_193_241##12	3.73371e-18
C278	VGND#11	VGND#10	6.545e-18
C279	a_709_119#	a_193_241#	3.69927e-17
C280	a_193_241##6	X#2	2.54684e-17
C281	a_27_368##8	a_193_241##12	3.03057e-17
C282	VPWR#11	a_193_241##6	3.50327e-17
C283	a_937_119#	a_193_241#	2.68112e-18
C284	X#6	a_193_241##3	2.83173e-18
C285	VGND#11	a_709_119##2	4.25099e-17
C286	a_193_241##22	a_193_241#	1.28497e-17
C287	a_27_368##8	a_193_241##6	1.96351e-17
C288	VGND#9	a_193_241#	1.70268e-17
C289	S#3	VPWR#11	2.73745e-17
C290	a_937_119##2	a_193_241#	3.73288e-17
C291	A1#5	A1#6	4.15441e-17
C292	X#6	a_193_241##2	2.01884e-18
C293	VGND#10	a_193_241#	1.1388e-18
C294	a_27_368##8	S#3	5.55659e-17
C295	A0	A1#4	1.93789e-18
C296	A0	A0#2	4.11166e-18
C297	a_709_119##2	a_193_241#	7.16853e-17
C298	VGND#12	a_193_241##4	1.19566e-18
C299	a_937_119##2	a_27_368##3	7.07577e-19
C300	A0#1	A1#5	4.25533e-17
C301	VGND#10	a_27_368##3	8.58371e-19
C302	a_709_119#	a_193_241##18	5.72067e-18
C303	X#6	VGND#11	6.78344e-17
C304	a_709_119##2	a_27_368##3	1.12252e-16
C305	a_936_391#	A0#3	4.77905e-19
C306	VGND#12	a_193_241##3	1.1657e-18
C307	a_193_241##10	a_193_241##7	1.26719e-18
C308	a_193_241##18	A0#3	8.93795e-19
C309	A0#6	A0#1	4.25887e-17
C310	a_722_391#	A0#3	3.4367e-19
C311	VGND#12	VGND#11	2.58968e-18
C312	a_709_119##2	S#6	3.42799e-17
C313	a_193_241##20	A0#3	9.70679e-18
C314	a_936_391#	a_193_241#	2.82533e-19
C315	VGND#12	a_193_241##2	5.57903e-20
C316	S#6	VGND#11	2.95219e-17
C317	VGND#1	A1#1	6.77444e-18
C318	a_27_368#	A0#6	2.05508e-18
C319	VGND#1	A1#7	6.03699e-18
C320	a_722_391#	a_193_241#	3.57898e-18
C321	X#1	a_193_241##4	5.04437e-18
C322	VGND#2	A1#7	3.14647e-20
C323	VGND#12	X#6	5.79135e-17
C324	a_193_241##20	a_193_241#	8.46769e-18
C325	VGND#1	A0#5	6.09463e-18
C326	a_709_119#	a_193_241##20	2.65552e-17
C327	a_193_241##5	a_193_241##12	1.73652e-18
C328	a_193_241#	VPWR#5	2.554e-18
C329	VGND#1	A0#4	5.76756e-18
C330	a_193_241#	a_936_391##2	5.66581e-17
C331	a_27_368##6	a_27_368#	4.56973e-17
C332	a_193_241##20	a_27_368##3	2.66532e-20
C333	X#1	X#6	1.63195e-18
C334	X#1	S#2	1.20157e-19
C335	VGND#13	S#2	1.9906e-17
C336	VGND#2	A0#5	3.98915e-20
C337	a_27_368##3	a_936_391##2	4.54842e-17
C338	a_27_368##10	S#2	6.57291e-17
C339	S#4	a_27_368##6	2.40348e-17
C340	a_27_368##3	VPWR#6	2.13731e-18
C341	a_27_368##3	a_722_391##2	8.79805e-17
C342	X#1	VGND#12	6.30691e-17
C343	a_27_368##3	VPWR#7	5.12642e-17
C344	X	a_193_241##4	3.93176e-19
C345	X	a_193_241##3	3.80812e-19
C346	S#9	S#4	4.3219e-17
C347	VGND#13	a_193_241##4	4.86047e-20
C348	a_27_368##3	X#4	5.25246e-18
C349	X	S#5	1.50448e-19
C350	VGND#2	A0#4	3.16559e-19
C351	S#6	a_722_391##2	1.46848e-18
C352	VGND#13	VGND#12	2.18189e-18
C353	VGND#4	S#8	5.72198e-18
C354	S#6	VPWR#7	5.21577e-18
C355	S#6	X#4	1.21619e-18
C356	a_193_241##8	S#9	2.56971e-17
C357	VGND#13	a_193_241##3	1.26304e-20
C358	S#6	VPWR#9	6.107e-19
C359	VPWR#1	A1#6	6.91217e-18
C360	a_193_241##14	A1#1	1.63626e-18
C361	a_193_241#	A0#4	6.02209e-18
C362	VPWR#1	A1#5	5.8801e-18
C363	VGND#13	X#1	5.8123e-17
C364	VGND#2	a_27_368##4	2.51925e-18
C365	a_193_241#	a_27_368##4	3.72532e-17
C366	a_193_241##10	a_193_241##8	3.17446e-17
C367	S#6	a_27_368##8	3.51567e-17
C368	VPWR#1	A0#1	8.80685e-18
C369	S#2	VPWR#9	2.36073e-18
C370	S#2	X#2	1.88677e-18
C371	a_193_241##2	a_27_368##5	2.36687e-17
C372	VPWR#1	A0#6	6.21718e-18
C373	S#2	VPWR#11	7.45702e-18
C374	VGND#3	a_27_368##5	2.6822e-18
C375	a_27_368##10	X#1	6.0198e-19
C376	a_193_241##14	A1#7	3.44971e-17
C377	a_27_368##8	S#2	1.57797e-16
C378	a_193_241##12	a_193_241##10	3.06029e-17
C379	VPWR#1	A1#4	4.47497e-20
C380	a_27_368##3	a_193_241##7	2.65399e-19
C381	A1	a_193_241##17	6.0446e-17
C382	a_27_368##10	VGND#13	6.08405e-17
C383	a_193_241##6	a_193_241##12	3.01614e-17
C384	VGND#3	S#7	6.55214e-19
C385	a_193_241##14	A0#5	2.52144e-17
C386	S#6	a_193_241##7	1.35853e-17
C387	S#3	a_193_241##6	2.95735e-17
C388	a_193_241##2	S#7	2.21297e-17
C389	a_936_391#	A1#4	6.09708e-19
C390	VGND	a_193_241##4	3.98983e-18
C391	a_193_241##15	A1	1.82596e-18
C392	a_27_368#	A0#3	2.07605e-20
C393	VGND	a_193_241##3	2.68388e-18
C394	VGND	a_193_241##2	1.70441e-17
C395	a_709_119#	A1	6.88659e-17
C396	a_193_241##14	A0#4	7.87597e-19
C397	S#2	a_193_241##5	2.51561e-17
C398	VGND#1	A1#4	4.83648e-20
C399	a_709_119##2	a_936_391##2	7.69552e-18
C400	VGND#5	a_193_241##7	2.28783e-19
C401	a_27_368##3	a_27_368#	5.3579e-19
C402	a_27_368##3	a_27_368##6	3.83384e-18
C403	a_709_119#	A0	2.27782e-17
C404	a_27_368##3	S#4	1.35939e-17
C405	VGND#6	X	5.22187e-19
C406	a_27_368##3	S#9	3.63766e-17
C407	A1	a_936_391#	2.37112e-18
C408	S#6	S#4	1.42108e-20
C409	a_27_368##3	a_193_241##8	2.83387e-17
C410	A1	a_193_241##18	5.17694e-17
C411	S#6	S#9	3.28021e-18
C412	a_936_391#	a_193_241##23	5.538e-17
C413	a_193_241##2	S#8	1.95893e-17
C414	a_27_368##3	a_193_241##10	1.93453e-19
C415	A1#4	VNB	8.18354e-17
C416	S#6	a_193_241##8	3.22822e-17
C417	A0#2	VNB	2.2844e-17
C418	a_27_368##3	a_193_241##12	7.96715e-20
C419	a_193_241##4	VNB	3.29705e-17
C420	a_193_241##18	A1#4	8.78517e-19
C421	a_193_241##3	VNB	2.44399e-17
C422	a_193_241##2	VNB	1.25578e-16
C423	S#2	S#9	1.38611e-19
C424	a_27_368##2	VNB	2.2953e-17
C425	S#6	a_193_241##10	1.76393e-17
C426	S#5	VNB	2.15264e-17
C427	VPWR	VPWR#8	8.69062e-17
C428	VPWR#1	A0#3	4.54956e-20
C429	VPWR	VPWR#3	5.78775e-17
C430	S#2	a_193_241##8	2.57592e-19
C431	VPWR	VPWR#2	7.86836e-17
C432	S#6	a_193_241##12	5.51809e-20
C433	A0	a_193_241##18	1.60241e-17
C434	A0	a_722_391#	2.27628e-18
C435	S#2	a_193_241##10	7.579e-19
C436	VGND#1	A0#3	3.80266e-20
C437	A0	a_193_241##20	7.1265e-18
C438	VPWR#1	a_193_241#	9.14386e-20
C439	S#2	a_193_241##12	2.05787e-17
C440	VGND#1	a_193_241#	4.38699e-20
C441	S#2	a_193_241##6	3.40083e-17
C442	S#2	S#3	9.15095e-18
C443	a_936_391#	a_193_241##18	7.44094e-17
C444	X	a_709_119##2	1.00928e-18
C445	VPWR	A0#8	3.29107e-19
C446	X	VGND#11	1.78182e-17
C447	VGND#12	X	2.524e-17
C448	a_193_241##15	A1#1	4.21601e-17
C449	X#1	X	3.23799e-18
C450	VGND#13	X	4.31309e-18
C451	VGND	VGND#6	6.75318e-17
C452	a_27_368##10	X	1.31934e-18
C453	a_193_241#	A0#3	2.76276e-17
C454	VGND	VGND#5	4.69585e-17
C455	VGND#4	S#6	1.29294e-18
C456	VGND	VGND#3	1.00766e-16
C457	VGND	VGND#2	1.00982e-16
C458	a_193_241##2	a_193_241##7	1.18e-18
C459	a_936_391#	a_722_391#	7.27957e-17
C460	a_193_241##23	a_193_241##20	8.00864e-21
C461	A1#1	a_709_119#	1.97485e-17
C462	a_193_241#	a_27_368##3	2.04602e-17
C463	VGND	A0#8	3.50995e-19
C464	X	X#4	6.54482e-18
C465	a_193_241##15	A1#7	2.15852e-18
C466	X	VPWR#9	1.01176e-18
C467	X	X#2	3.47879e-18
C468	S#6	a_27_368##3	1.70324e-16
C469	VPWR	a_936_391#	2.31897e-18
C470	VGND	a_709_119#	3.7794e-18
C471	VPWR#8	VNB	4.03236e-17
C472	VPWR	a_722_391#	3.40269e-17
C473	VPWR#3	VNB	2.96452e-17
C474	VPWR	a_193_241##20	3.29368e-18
C475	VPWR#2	VNB	4.22953e-17
C476	VGND	a_937_119#	6.04717e-18
C477	a_193_241##18	a_722_391#	5.07578e-20
C478	a_936_391#	a_193_241##20	4.99726e-17
C479	VGND	a_193_241##22	2.75025e-17
C480	VPWR	VPWR#5	1.37837e-17
C481	VGND#6	VNB	2.5658e-17
C482	VPWR	a_936_391##2	1.35933e-17
C483	VGND#5	VNB	1.72898e-17
C484	VGND	a_937_119##2	1.98137e-17
C485	VPWR	VPWR#6	2.05873e-17
C486	VGND#3	VNB	2.69847e-17
C487	VGND#2	VNB	3.77583e-17
C488	S#2	S#6	1.61972e-18
C489	VPWR	a_722_391##2	3.23287e-17
C490	VGND	a_709_119##2	2.47801e-17
C491	VGND	VGND#11	2.054e-17
C492	VPWR	VPWR#7	8.56332e-17
C493	a_709_119#	A1#7	2.69531e-17
C494	VGND	X#6	2.11886e-17
C495	X	a_27_368##5	1.38719e-19
C496	VGND	VGND#12	2.11458e-17
C497	a_193_241##17	VNB	4.22376e-17
C498	VGND	X#1	1.80778e-17
C499	X	S#7	2.1458e-19
C500	a_193_241##14	VNB	5.61276e-18
C501	X	S#8	1.94025e-19
C502	VGND	a_27_368##10	2.23701e-17
C503	X	a_193_241##7	1.60442e-17
C504	VPWR	a_27_368##8	4.50382e-17
C505	A0#8	VNB	1.12001e-18
C506	X	a_193_241##9	1.99621e-17
C507	X	a_193_241##11	1.76006e-17
C508	VGND	a_193_241##20	1.20896e-18
C509	X	a_193_241##5	1.00515e-17
C510	a_193_241##15	VNB	5.90551e-17
C511	VGND	a_936_391##2	1.38924e-18
C512	a_709_119#	VNB	1.89999e-17
C513	A1#7	a_193_241##13	1.43949e-17
C514	a_193_241##22	VNB	7.96291e-18
C515	VGND#9	VNB	8.63943e-18
C516	VPWR#1	A1	4.039e-18
C517	VGND#10	VNB	7.63365e-18
C518	a_709_119##2	VNB	7.4269e-18
C519	VGND#11	VNB	9.383e-18
C520	VGND#1	A1	5.33687e-18
C521	X#6	VNB	2.02715e-19
C522	VGND#12	VNB	2.86445e-18
C523	a_709_119#	A0#5	1.20955e-17
C524	X#1	VNB	6.54285e-19
C525	VGND#13	VNB	9.12936e-18
C526	a_27_368##10	VNB	6.65638e-17
C527	VPWR#1	A0	1.04819e-18
C528	a_193_241##23	VNB	3.49457e-17
C529	a_936_391#	VNB	2.14182e-18
C530	VGND	A0#4	1.19623e-18
C531	VGND#4	a_193_241##2	1.41256e-17
C532	a_193_241##18	VNB	2.16235e-18
C533	VGND	a_27_368##4	4.61412e-18
C534	VGND#1	A0	1.11675e-18
C535	a_722_391#	VNB	2.58691e-17
C536	X	S#9	3.27465e-19
C537	VGND	a_27_368##5	4.27561e-18
C538	a_193_241##20	VNB	8.75255e-18
C539	a_937_119#	A1#7	7.15093e-19
C540	VPWR#5	VNB	2.09693e-18
C541	VGND	S#7	3.07608e-18
C542	X	a_193_241##8	9.04589e-18
C543	a_722_391#	a_193_241##20	4.55108e-18
C544	a_936_391##2	VNB	1.54707e-17
C545	VGND	S#8	5.72787e-18
C546	VPWR#6	VNB	5.07595e-18
C547	X	a_193_241##10	2.51992e-17
C548	VPWR	A0#6	9.23936e-19
C549	a_936_391##2	a_936_391#	1.62769e-20
C550	VGND	a_193_241##7	1.13037e-18
C551	a_722_391##2	VNB	2.58583e-18
C552	a_193_241##20	A1#4	2.13551e-19
C553	VPWR#7	VNB	4.01976e-17
C554	VPWR	a_27_368#	9.00405e-18
C555	X	a_193_241##12	2.11571e-17
C556	VPWR	a_27_368##6	8.86063e-18
C557	X	a_193_241##6	1.0512e-17
C558	VGND	a_193_241##5	3.75543e-18
C559	VPWR	S#4	9.00405e-18
C560	VPWR#11	VNB	4.94682e-18
C561	VGND	S#1	8.73586e-18
C562	X	S#3	7.78293e-19
C563	A0	A0#3	4.20441e-18
C564	a_27_368##8	VNB	5.38814e-17
C565	VPWR	S#9	9.12536e-18
C566	A0#5	a_193_241##13	3.12165e-18
C567	A1#1	VNB	3.36511e-17
C568	VPWR	a_193_241##8	7.95244e-19
C569	A1#7	VNB	3.31097e-17
C570	A0#5	VNB	3.18495e-17
C571	VPWR	a_193_241##10	8.75352e-19
C572	A0#4	VNB	3.63446e-17
C573	a_27_368##4	VNB	2.48284e-17
C574	VPWR	a_193_241##12	7.72793e-19
C575	a_27_368##5	VNB	2.36312e-17
C576	VPWR	a_193_241##6	4.01765e-19
C577	S#7	VNB	2.26978e-17
C578	S#8	VNB	2.16983e-17
C579	a_193_241##22	A1#7	2.54108e-19
C580	VPWR	S#3	8.52713e-18
C581	a_193_241##7	VNB	4.67081e-17
C582	a_193_241##9	VNB	3.18796e-17
C583	a_709_119#	A0#4	1.01044e-17
C584	a_193_241##11	VNB	3.24815e-17
C585	VPWR	VPWR#1	2.84213e-17
C586	a_193_241##5	VNB	5.98374e-17
C587	S#1	VNB	3.7576e-17
C588	a_722_391#	VPWR#5	3.48823e-17
C589	A1#6	VNB	3.42199e-17
C590	A1#5	VNB	2.93359e-17
C591	A0#1	VNB	3.09502e-17
C592	X	a_27_368##3	9.72283e-20
C593	a_937_119#	A0#5	2.61591e-17
C594	A0#6	VNB	3.66897e-17
C595	a_27_368#	VNB	4.19991e-17
C596	X	S#6	1.0409e-16
C597	a_27_368##6	VNB	3.49715e-17
C598	S#4	VNB	3.46385e-17
C599	S#2	X	1.19721e-16
C600	VGND	VGND#1	2.24951e-17
C601	VPWR	a_193_241#	4.97557e-18
C602	S#9	VNB	3.62082e-17
C603	a_193_241##8	VNB	4.81523e-17
C604	VPWR	a_27_368##3	2.74734e-17
C605	a_193_241##10	VNB	5.0876e-17
C606	VGND	VGND#4	3.09177e-17
C607	a_193_241##12	VNB	5.05866e-17
C608	VPWR	S#6	1.18275e-17
C609	VGND#9	A1#7	1.35821e-20
C610	a_193_241##6	VNB	4.16074e-17
C611	VPWR	S#2	1.13753e-17
C612	S#3	VNB	4.25226e-17
C613	VGND	a_193_241#	1.19143e-17
C614	VPWR#1	VNB	2.08587e-16
C615	VGND	a_27_368##3	7.30004e-18
C616	VGND#1	VNB	2.11172e-16
C617	VGND	S#6	7.91185e-18
C618	A0	A1	2.15568e-17
C619	VGND#4	VNB	1.22292e-17
C620	VGND	S#2	4.95391e-18
C621	A0#3	VNB	4.39025e-17
C622	a_193_241##22	A0#5	4.55844e-19
C623	a_193_241#	VNB	2.39959e-16
C624	a_936_391##2	a_722_391#	9.50624e-17
C625	a_27_368##3	VNB	4.27598e-17
C626	S#6	VNB	3.79072e-17
C627	a_193_241##20	A0#2	2.03731e-19
C628	S#2	VNB	4.63606e-17
C629	a_937_119#	A0#4	3.37951e-17
C630	VPWR	X	1.50988e-17
C631	A1	VNB	9.90777e-18
C632	A0	VNB	2.78028e-18
C633	VGND	X	6.51888e-18
C634	X	VNB	7.40868e-18
C635	VPWR	VNB	2.91905e-16
C636	VGND	VNB	2.81023e-16
C637	VGND#9	A0#5	1.23217e-20
C638	VPWR#10	a_193_241##6	4.9988e-18
C639	VPWR#10	VPWR#8	6.22914e-19
C640	VPWR	VPWR#10	1.08428e-16
C641	VGND#7	S#2	5.01658e-19
C642	VGND#7	a_193_241##5	8.91887e-18
C643	VPWR#10	S#3	4.49578e-18
C644	VGND#7	X#1	6.4351e-18
C645	VPWR#10	VNB	5.4683e-17
C646	VGND#7	S#1	3.91476e-18
C647	a_27_368##8	VPWR#10	2.19796e-17
C648	VPWR#10	a_193_241##5	1.01063e-19
C649	VGND	VGND#7	1.15829e-16
C650	VPWR#10	a_193_241##10	5.25751e-20
C651	VGND#7	VGND#6	5.84649e-19
C652	VPWR#10	a_193_241##12	6.112e-19
C653	VGND#7	a_193_241##4	1.58266e-18
C654	VGND#7	VGND#12	6.46344e-19
C655	VGND#7	a_27_368##10	1.99561e-17
C656	VGND#7	X	2.83971e-19
C657	VGND#7	VNB	5.54063e-17
*
*
.ENDS sky130_fd_sc_hs__mux2_4
*
