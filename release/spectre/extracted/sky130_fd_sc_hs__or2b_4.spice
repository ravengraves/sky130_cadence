* Extracted by Quantus, converted by sky130cad/quantus.py
*
*
*
*                       LINUX           Wed Nov 18 09:05:47 2026
*
*
*
*  PROGRAM  advgen
*
*  Name           : advgen - Quantus - (64-bit)
*  Version        : 25.1.0-p047
*  Build Date     : Thu Dec 11 23:20:30 PST 2025
*
*  HSPICE LIBRARY
*
*  OPERATING_TEMPERATURE 150
*  QRC_TECH_DIR <path>/tech
*
*
*

*
.SUBCKT sky130_fd_sc_hs__or2b_4 VNB VPB VGND VPWR X B_N A
*
*
*  caps2d version: 10
*
*
*       TRANSISTOR CARDS
*
*
XM1 VGND#7 a_81_296##10 X#4 VNB sky130_fd_pr__nfet_01v8_lvt l=0.15 w=0.74 ad=0.2109 as=0.2072 pd=2.05 ps=2.04
XM5 X#4 a_81_296##7 VGND#11 VNB sky130_fd_pr__nfet_01v8_lvt l=0.15 w=0.74 ad=0.2072 as=0.259 pd=2.04 ps=2.18
XM14 X#1 a_81_296##5 VGND#11 VNB sky130_fd_pr__nfet_01v8_lvt l=0.15 w=0.74 ad=0.2257 as=0.259 pd=2.09 ps=2.18
XM17 VGND#10 a_81_296# X#1 VNB sky130_fd_pr__nfet_01v8_lvt l=0.15 w=0.74 ad=0.233 as=0.2257 pd=2.13 ps=2.09
XM12 a_81_296##18 A#4 VGND#10 VNB sky130_fd_pr__nfet_01v8_lvt l=0.15 w=0.64 ad=0.288 as=0.233 pd=2.18 ps=2.13
XM16 VGND#9 A#1 a_81_296##18 VNB sky130_fd_pr__nfet_01v8_lvt l=0.15 w=0.64 ad=0.224 as=0.288 pd=1.98 ps=2.18
XM6 VGND#9 a_676_48##4 a_81_296##17 VNB sky130_fd_pr__nfet_01v8_lvt l=0.15 w=0.64 ad=0.224 as=0.1792 pd=1.98 ps=1.84
XM13 a_81_296##17 a_676_48##6 VGND#8 VNB sky130_fd_pr__nfet_01v8_lvt l=0.15 w=0.64 ad=0.1792 as=0.224 pd=1.84 ps=1.98
XM8 VGND#8 B_N#3 a_676_48##9 VNB sky130_fd_pr__nfet_01v8_lvt l=0.15 w=0.64 ad=0.224 as=0.6272 pd=1.98 ps=3.24
XM0 X#6 a_81_296##12 VPWR#10 VPB sky130_fd_pr__pfet_01v8 l=0.15 w=1.12 ad=0.336 as=0.3192 pd=2.84 ps=2.81
XM3 X#6 a_81_296##11 VPWR#9 VPB sky130_fd_pr__pfet_01v8 l=0.15 w=1.12 ad=0.336 as=0.336 pd=2.84 ps=2.84
XM9 VPWR#9 a_81_296##8 X#7 VPB sky130_fd_pr__pfet_01v8 l=0.15 w=1.12 ad=0.336 as=0.336 pd=2.84 ps=2.84
XM11 VPWR#7 a_81_296##4 X#7 VPB sky130_fd_pr__pfet_01v8 l=0.15 w=1.12 ad=0.4092 as=0.336 pd=2.99 ps=2.84
XM15 VPWR#7 A#7 a_489_392##4 VPB sky130_fd_pr__pfet_01v8 l=0.15 w=1 ad=0.4092 as=0.3 pd=2.99 ps=2.6
XM4 a_489_392##4 A#6 VPWR#5 VPB sky130_fd_pr__pfet_01v8 l=0.15 w=1 ad=0.3 as=0.285 pd=2.6 ps=2.57
XM2 a_81_296##13 a_676_48##7 a_489_392##2 VPB sky130_fd_pr__pfet_01v8 l=0.15 w=1 ad=0.3 as=0.29 pd=2.6 ps=2.58
XM10 a_489_392# a_676_48# a_81_296##13 VPB sky130_fd_pr__pfet_01v8 l=0.15 w=1 ad=0.29 as=0.3 pd=2.58 ps=2.6
XM7 VPWR#4 B_N#1 a_676_48##8 VPB sky130_fd_pr__pfet_01v8 l=0.15 w=1 ad=0.29 as=0.285 pd=2.58 ps=2.57
*
*
*       RESISTOR AND CAP/DIODE CARDS
*
Rg1	a_81_296#	a_81_296##2	367.139069
Rg2	a_81_296##2	a_81_296##3	60.127804
Rg3	a_81_296##2	a_81_296##4	471.329315
Rg4	a_81_296##3	a_81_296##5	354.015564
Rg5	a_81_296##3	a_81_296##6	88.940331
Rg6	a_81_296##6	a_81_296##7	399.893494
Rg7	a_81_296##3	a_81_296##8	452.088287
Rg8	a_81_296##6	a_81_296##9	172.221237
Rg9	a_81_296##9	a_81_296##10	446.734314
Rg10	a_81_296##6	a_81_296##11	442.933136
Rg11	a_81_296##9	a_81_296##12	446.439362
Rg12	A#1	A#2	444.539581
Rg13	A#2	A#3	164.752762
Rg14	A#3	A#4	452.472961
Rg15	A#2	A#5	19.064896
Rg16	A#5	A#6	413.799408
Rg17	A#3	A#7	482.022339
Rg18	a_676_48#	a_676_48##2	381.775604
Rg19	a_676_48##2	a_676_48##3	224.278351
Rg20	a_676_48##3	a_676_48##4	605.062256
Rg21	a_676_48##2	a_676_48##5	37.528206
Rg22	a_676_48##3	a_676_48##6	470.957764
Rg23	a_676_48##3	a_676_48##7	469.880310
Rg24	B_N#1	B_N#2	461.854828
Rg25	B_N#2	B_N#3	596.542603
Rf1	X#1	X#2	76.956062
Rf2	X#2	X#3	14.221710
Rf3	X#3	X	17.568539
Rf4	X#2	X#4	23.227192
Rf5	X#3	X#5	41.880512
Rf6	X#5	X#6	37.735241
Rf7	X#5	X#7	79.860023
Rf8	A	A#8	10.038653
Rf9	A#8	A	8.857635
Rf10	a_81_296##13	a_81_296##14	81.356941
Rf11	a_81_296##14	a_81_296##15	65.995026
Rf12	a_81_296##15	a_81_296##3	128.188354
Rf13	a_81_296##14	a_81_296##17	33.339199
Rf14	a_81_296##15	a_81_296##18	24.054951
Rf15	a_489_392#	a_489_392##3	110.991020
Rf16	a_489_392##3	a_489_392##4	99.802124
Rf17	a_489_392##2	a_489_392##3	5.000000
Rf18	B_N	B_N#4	8.267126
Rf19	B_N#4	B_N	6.298763
Rf20	a_676_48##8	a_676_48##10	101.948448
Rf21	a_676_48##10	a_676_48##5	218.447403
Rf22	a_676_48##9	a_676_48##10	2.500000
Rf24	VPWR#2	VPWR#3	160.175201
Rf25	VPWR#2	VPWR#4	35.530331
Rf26	VPWR#3	VPWR#5	43.353802
Rf27	VPWR#3	VPWR#6	56.281700
Rf28	VPWR#6	VPWR#7	45.190044
Rf29	VPWR#6	VPWR#8	71.655113
Rf30	VPWR#8	VPWR#9	42.573776
Rf31	VPWR#8	VPWR#10	98.946312
Rf33	VGND#2	VGND#3	67.887894
Rf34	VGND#3	VGND#4	21.160110
Rf35	VGND#4	VGND#5	54.032833
Rf36	VGND#5	VGND#6	73.001427
Rf37	VGND#6	VGND#7	103.472992
Rf38	VGND#2	VGND#8	31.337896
Rf39	VGND#3	VGND#9	31.141060
Rf40	VGND#5	VGND#10	31.141060
Rf41	VGND#6	VGND#11	35.294842
Rf44	B_N#2	B_N#4	80.116402
Rf42	A#5	A#8	160.232803
Re1	VPWR#3	VPWR	0.818510
Re2	VGND	VGND#4	0.818540
*
*       CAPACITOR CARDS
*
*
C1	VGND#7	VGND#6	1.15638e-18
C2	VPWR#8	a_81_296##9	4.66614e-20
C3	VPWR#8	a_81_296##6	3.76119e-20
C4	A#7	A#2	4.36817e-18
C5	a_489_392#	a_676_48##3	5.5461e-20
C6	a_81_296##14	a_676_48##9	3.83848e-18
C7	a_489_392#	a_676_48##2	5.19935e-18
C8	X#2	X#5	3.43405e-18
C9	VGND#8	a_81_296##14	1.65552e-17
C10	a_81_296##4	A#3	1.35575e-18
C11	VGND#9	a_81_296##15	1.45492e-17
C12	a_81_296##13	a_676_48##3	1.94246e-18
C13	VPWR#6	a_81_296##2	1.43229e-20
C14	VGND#9	a_81_296##14	1.91195e-17
C15	a_81_296##13	a_676_48##2	3.85949e-18
C16	a_81_296##18	a_81_296##14	9.26729e-19
C17	VGND#10	a_81_296##15	3.05004e-18
C18	a_81_296##13	A#2	9.21906e-19
C19	a_489_392##2	a_676_48##3	6.23851e-18
C20	a_81_296##6	a_81_296##8	1.71475e-18
C21	VGND#8	a_676_48##9	7.0138e-17
C22	a_81_296##17	VGND#8	5.57387e-17
C23	VGND#9	VGND#8	1.89182e-18
C24	VGND#9	a_81_296##17	5.29001e-17
C25	VPWR#5	A#2	9.7167e-19
C26	a_489_392##4	VPWR#6	4.07832e-18
C27	a_81_296##18	a_81_296##17	2.1386e-18
C28	a_81_296##12	a_81_296##6	1.39869e-18
C29	X#2	VGND#11	1.50474e-17
C30	a_81_296##18	VGND#9	4.66097e-17
C31	X#2	X#4	4.59562e-19
C32	VGND#7	X#3	4.23589e-19
C33	a_489_392##4	A#3	4.58765e-19
C34	X#7	VPWR#8	8.79319e-18
C35	VGND#10	VGND#9	1.47156e-18
C36	a_676_48##3	a_676_48##2	5.08972e-18
C37	a_489_392##4	A#2	4.45163e-18
C38	VGND#7	X#2	1.12931e-17
C39	X#7	VPWR#6	8.44616e-18
C40	VGND#10	a_81_296##18	5.37255e-17
C41	X#1	a_81_296##18	3.70984e-18
C42	VPWR#3	a_676_48##3	1.55849e-19
C43	X#6	VPWR#8	1.20029e-17
C44	a_81_296##14	a_489_392##2	1.9396e-17
C45	VPWR#3	a_676_48##2	4.99344e-22
C46	VPWR#3	A#3	3.29462e-20
C47	X#1	VGND#10	5.91479e-17
C48	VPWR#3	A#2	3.2397e-20
C49	a_676_48##9	VPWR#4	2.76709e-18
C50	VPWR#10	VPWR#8	1.41623e-19
C51	VGND#11	VGND#10	2.24998e-18
C52	a_81_296##15	a_489_392##4	3.46617e-18
C53	X#1	VGND#11	5.11024e-17
C54	VGND#4	a_676_48##3	4.98215e-20
C55	VGND#3	a_676_48##4	2.75208e-18
C56	X#4	X#1	3.11662e-18
C57	VGND#4	A#3	8.99332e-21
C58	A#2	a_676_48##3	1.36034e-17
C59	VGND#4	A#2	7.13537e-20
C60	VGND#8	a_81_296##13	7.67022e-19
C61	VGND#4	a_81_296##9	2.53544e-20
C62	X#4	VGND#11	3.63643e-17
C63	VGND#4	a_81_296##6	1.20921e-20
C64	VGND#6	A#4	9.45583e-20
C65	VGND#7	VGND#11	2.42908e-18
C66	a_81_296##15	A#3	1.2899e-17
C67	VGND#5	A#4	9.63173e-19
C68	a_676_48##3	B_N#2	5.51272e-19
C69	X#7	a_81_296##2	4.55454e-19
C70	a_81_296##14	a_676_48##3	2.50549e-17
C71	a_676_48##2	B_N#2	1.95733e-17
C72	VGND#7	X#4	4.40666e-17
C73	X#5	X#7	2.55023e-18
C74	VGND#6	a_81_296#	3.37357e-19
C75	a_81_296##15	A#2	1.28731e-17
C76	VGND#5	a_81_296#	5.12812e-18
C77	a_81_296##14	a_676_48##2	8.15265e-18
C78	X#5	VPWR#9	2.42007e-17
C79	VGND#6	a_81_296##5	4.77904e-18
C80	VPWR#9	a_81_296##6	3.01813e-19
C81	a_81_296##14	A#3	2.17622e-19
C82	X#5	X#6	4.04835e-18
C83	a_676_48##5	a_676_48##3	5.30447e-19
C84	a_676_48##5	a_676_48##2	1.77389e-17
C85	VGND#6	a_81_296##7	4.40529e-18
C86	a_81_296##14	B_N#3	1.45958e-18
C87	A#3	A#2	1.03329e-17
C88	a_81_296##14	A#2	1.8708e-18
C89	VPWR#10	X#5	2.97209e-17
C90	VPWR#4	a_676_48##8	7.68244e-17
C91	a_81_296##9	X#6	1.26203e-19
C92	X#3	VPWR#10	2.82922e-18
C93	a_81_296##14	a_676_48##6	3.88427e-18
C94	VGND#6	a_81_296##10	2.55496e-18
C95	a_489_392#	a_676_48##8	2.36326e-18
C96	a_81_296##6	X#6	7.11324e-20
C97	a_489_392#	VPWR#4	8.28196e-17
C98	a_81_296##13	a_676_48##8	1.75862e-18
C99	a_81_296##14	a_676_48##4	2.24644e-17
C100	a_81_296##15	A#1	1.04452e-17
C101	A#5	A#2	6.70814e-18
C102	a_676_48##9	B_N#3	5.59267e-17
C103	a_81_296##14	A#1	1.99972e-19
C104	a_81_296##14	a_81_296##2	8.13063e-19
C105	a_489_392#	a_81_296##13	8.72741e-17
C106	a_676_48##3	B_N#3	1.26595e-18
C107	a_81_296##15	A#4	5.20742e-18
C108	VGND#8	B_N#3	1.8093e-17
C109	VGND#6	VGND#5	9.53351e-19
C110	a_676_48##9	a_676_48##6	1.79461e-18
C111	a_81_296##14	A#4	7.66283e-20
C112	B_N#3	a_676_48##2	2.28712e-17
C113	a_489_392##2	a_489_392#	2.59773e-18
C114	X#5	A#3	2.18336e-19
C115	VGND#8	a_676_48##6	3.93341e-17
C116	a_81_296##3	a_676_48##3	2.21973e-19
C117	a_489_392##2	a_81_296##13	6.25773e-17
C118	a_676_48##9	a_676_48##4	2.9701e-19
C119	a_81_296##17	a_676_48##6	1.01974e-17
C120	a_81_296##3	A#3	1.14335e-17
C121	X#5	A#2	5.37397e-19
C122	a_81_296##3	A#2	2.97867e-19
C123	VGND#8	a_676_48##4	2.80383e-18
C124	a_81_296##3	a_81_296##9	5.73901e-19
C125	VGND#9	a_676_48##6	7.30871e-19
C126	X#3	A#4	1.0064e-19
C127	a_81_296##3	a_81_296##6	1.57215e-17
C128	a_81_296##3	a_81_296##2	2.31143e-17
C129	a_81_296##17	a_676_48##4	3.18327e-17
C130	X#5	a_81_296##9	3.72249e-18
C131	a_489_392##2	VPWR#5	7.08616e-17
C132	VGND#8	A#1	3.18276e-19
C133	VGND#5	VGND#3	8.95033e-19
C134	a_676_48##4	VGND#9	1.6151e-17
C135	X#3	a_81_296#	1.01832e-19
C136	X#3	A#3	9.04809e-20
C137	a_81_296##17	A#1	1.311e-18
C138	a_489_392##4	a_489_392##2	2.68364e-18
C139	a_81_296##18	a_676_48##4	5.08748e-19
C140	X#5	a_81_296##6	9.59435e-18
C141	VGND#9	A#1	3.71654e-17
C142	VGND#7	VPWR#10	3.49688e-19
C143	X#3	a_81_296##5	3.94689e-19
C144	a_489_392##4	VPWR#5	6.93114e-17
C145	a_81_296##17	A#4	1.71505e-19
C146	a_81_296##2	A#3	1.97775e-17
C147	A#1	a_81_296##18	1.79415e-17
C148	X#5	a_81_296##2	2.00597e-19
C149	VGND#9	A#4	1.7645e-18
C150	VPWR#7	VPWR#5	2.01728e-18
C151	X#7	a_489_392##2	1.30427e-18
C152	VGND#10	A#1	9.28966e-19
C153	X#3	a_81_296##7	1.20957e-18
C154	a_676_48##4	a_676_48##3	4.25391e-18
C155	X#3	a_81_296##9	1.34726e-17
C156	A#4	a_81_296##18	2.26737e-17
C157	VPWR#7	a_489_392##4	7.88231e-17
C158	X#2	a_81_296##7	1.74921e-17
C159	X#1	A#1	2.71706e-19
C160	VGND#10	A#4	4.22155e-17
C161	X#3	a_81_296##10	1.48001e-17
C162	VPWR#6	A#6	5.30685e-19
C163	a_81_296##18	a_81_296#	5.35205e-19
C164	X#3	a_81_296##6	7.63795e-18
C165	X#1	A#4	1.76917e-18
C166	X#2	a_81_296##10	7.14409e-18
C167	a_81_296#	VGND#10	1.79437e-17
C168	a_81_296##9	a_81_296##6	7.6149e-18
C169	X#7	VPWR#7	7.85523e-17
C170	A#2	a_676_48##4	2.76151e-18
C171	VGND#11	A#4	1.7771e-19
C172	VPWR#8	A#7	8.45001e-20
C173	a_81_296##18	a_81_296##5	2.42175e-19
C174	X#3	a_81_296##2	8.36552e-20
C175	X#1	a_81_296#	2.07203e-17
C176	VPWR#6	A#7	1.03701e-17
C177	VPWR#9	VPWR#7	2.00319e-18
C178	VGND#10	a_81_296##5	1.67432e-18
C179	VGND#11	a_81_296#	3.92048e-19
C180	X#1	a_81_296##5	5.18299e-17
C181	VPWR#8	a_81_296##4	3.00302e-19
C182	X#7	VPWR#9	6.43662e-17
C183	VGND#10	a_81_296##7	2.84905e-19
C184	VPWR#6	a_81_296##4	9.75694e-18
C185	a_81_296##5	VGND#11	1.76143e-17
C186	X#2	a_81_296##6	1.24322e-18
C187	X#1	a_81_296##7	1.33771e-18
C188	X#4	a_81_296##5	5.05633e-19
C189	VGND#8	a_676_48##3	2.75594e-19
C190	VPWR#8	a_81_296##8	7.53935e-18
C191	VGND#11	a_81_296##7	3.1769e-17
C192	X#6	VPWR#9	6.04257e-17
C193	VPWR#6	a_81_296##8	3.00302e-19
C194	X#1	a_81_296##10	2.53065e-19
C195	a_81_296##7	X#4	1.22116e-17
C196	VPWR#10	VPWR#9	2.66815e-18
C197	VGND#8	a_676_48##2	8.7826e-18
C198	VGND#11	a_81_296##10	1.70274e-18
C199	VGND#7	a_81_296##7	1.21536e-18
C200	VPWR#8	a_81_296##11	4.87628e-18
C201	X#4	a_81_296##10	3.10794e-17
C202	VPWR#10	X#6	7.10487e-17
C203	VPWR#6	a_81_296##11	8.74044e-20
C204	a_81_296##10	VGND#7	2.6348e-17
C205	X#5	A#7	1.47717e-20
C206	VPWR#8	a_81_296##12	6.52765e-19
C207	VPWR#8	VPWR#6	7.06045e-19
C208	X#5	a_81_296##4	4.78698e-19
C209	a_676_48##6	B_N#3	3.06376e-17
C210	a_676_48##8	B_N#1	3.29465e-17
C211	X#5	a_81_296##8	1.17599e-18
C212	a_81_296##2	A#4	7.23933e-19
C213	VPWR#4	B_N#1	6.78442e-17
C214	VGND#4	VGND#6	4.58667e-17
C215	VPWR#3	VPWR#8	4.13877e-17
C216	a_676_48##8	a_676_48#	5.87275e-19
C217	a_489_392#	B_N#1	3.6239e-18
C218	VGND#4	VGND#5	3.66853e-17
C219	A	a_676_48##3	8.09914e-18
C220	VPWR#3	VPWR#6	3.65827e-17
C221	a_676_48##4	a_676_48##6	4.07725e-17
C222	VGND#4	VGND#3	2.61922e-17
C223	X#5	a_81_296##11	1.40862e-17
C224	VPWR#4	a_676_48#	1.93456e-18
C225	A	A#3	5.26475e-18
C226	a_81_296##13	B_N#1	8.09148e-19
C227	A	A#2	1.54242e-17
C228	A	a_81_296##9	1.23854e-19
C229	a_676_48##8	a_676_48##7	3.97874e-19
C230	A	a_81_296##6	4.3523e-19
C231	a_489_392#	a_676_48#	7.41498e-17
C232	A	a_81_296##2	3.0376e-18
C233	a_676_48#	a_81_296##13	1.93551e-17
C234	X#5	a_81_296##12	8.541e-18
C235	VPWR#5	B_N#1	6.28847e-21
C236	A#1	a_676_48##4	2.94018e-17
C237	a_489_392#	a_676_48##7	5.66987e-18
C238	a_489_392##2	a_676_48#	4.00009e-19
C239	VPWR#4	A#6	1.41963e-19
C240	a_81_296##13	a_676_48##7	4.38627e-17
C241	a_489_392#	A#6	6.88526e-20
C242	a_489_392##2	a_676_48##7	2.69069e-17
C243	A#4	A#1	2.05938e-17
C244	a_81_296##13	A#6	4.64354e-19
C245	VPWR#5	a_676_48##7	1.36615e-18
C246	B_N	a_676_48##3	8.64661e-20
C247	B_N	a_676_48##2	5.46122e-18
C248	a_489_392##2	A#6	2.58551e-18
C249	a_489_392##4	a_676_48##7	3.44138e-19
C250	a_81_296##13	A#7	3.45141e-19
C251	A#6	VPWR#5	3.53496e-17
C252	VGND#4	a_81_296##15	5.96607e-19
C253	a_81_296#	A#4	3.21066e-17
C254	VPWR#7	a_676_48##7	1.1024e-19
C255	VGND#5	a_81_296##15	1.93244e-19
C256	a_489_392##4	A#6	7.05007e-17
C257	X#7	a_676_48##7	8.82695e-19
C258	a_81_296##13	a_81_296##4	2.26751e-19
C259	VPWR#5	A#7	3.71272e-19
C260	VPWR#7	A#6	6.5369e-19
C261	a_489_392##4	A#7	5.14676e-17
C262	a_81_296##5	a_81_296#	3.4546e-17
C263	X#7	A#6	1.2854e-18
C264	VGND#6	a_81_296##3	4.71594e-20
C265	a_81_296##14	B_N#2	3.18656e-19
C266	VPWR#5	a_81_296##4	1.7359e-19
C267	A#7	VPWR#7	2.35998e-17
C268	VGND#5	a_81_296##3	4.59206e-19
C269	a_489_392##4	a_81_296##4	1.58933e-18
C270	X#7	A#7	3.6349e-18
C271	a_81_296##7	a_81_296##5	2.38188e-17
C272	a_81_296##4	VPWR#7	3.05979e-17
C273	VPWR#9	A#7	1.73776e-19
C274	VPWR#8	a_81_296##3	7.31383e-20
C275	a_81_296##14	a_676_48##5	3.25267e-17
C276	VGND#3	a_81_296##14	1.93187e-19
C277	X#7	a_81_296##4	6.80086e-17
C278	a_81_296##3	VPWR#6	4.75728e-19
C279	a_676_48##9	B_N#2	3.43661e-17
C280	VGND#4	a_81_296##18	1.36341e-17
C281	VPWR#7	a_81_296##8	3.71489e-19
C282	VPWR#9	a_81_296##4	3.71489e-19
C283	a_81_296##10	a_81_296##7	3.92867e-17
C284	a_81_296##15	A#5	1.27686e-17
C285	X#7	a_81_296##8	6.67842e-17
C286	VPWR#7	a_81_296##11	1.72497e-19
C287	a_81_296##8	VPWR#9	2.09722e-17
C288	VPWR#3	VPWR#4	8.07936e-20
C289	X#7	a_81_296##11	2.04001e-18
C290	VGND#4	VGND#7	2.39765e-17
C291	a_489_392#	VPWR#3	1.70555e-17
C292	VPWR#9	a_81_296##11	4.59325e-17
C293	a_81_296##3	a_81_296##14	3.60685e-18
C294	X#7	a_81_296##12	2.11095e-19
C295	a_81_296##11	X#6	2.29281e-17
C296	a_489_392##2	VPWR#3	3.20206e-17
C297	VPWR#9	a_81_296##12	2.21038e-18
C298	X#5	a_81_296##3	3.34258e-17
C299	VPWR#10	a_81_296##11	3.26734e-18
C300	X#3	a_81_296##3	3.1908e-17
C301	a_676_48##8	B_N#2	7.68681e-18
C302	a_81_296##12	X#6	2.30266e-17
C303	X#2	a_81_296##3	1.9702e-17
C304	a_489_392##4	VPWR#3	1.26636e-17
C305	VGND#6	X#2	3.16169e-19
C306	VPWR#10	a_81_296##12	5.65078e-17
C307	a_81_296##10	a_81_296##6	3.93221e-18
C308	a_676_48#	B_N#1	5.48246e-18
C309	VGND#6	a_81_296##9	2.9309e-20
C310	VGND#5	A#3	1.86069e-20
C311	VGND#3	a_676_48##3	1.39017e-20
C312	a_676_48##5	a_489_392#	3.20411e-17
C313	VGND#10	a_81_296##3	2.73532e-17
C314	a_81_296##13	a_676_48##5	1.6437e-17
C315	a_81_296##3	X#1	7.66645e-17
C316	VPWR#3	VPWR#10	2.7231e-17
C317	a_676_48##7	a_676_48#	4.2375e-17
C318	a_81_296##3	VGND#11	5.06557e-18
C319	VGND	a_676_48##3	1.02971e-18
C320	VGND	a_676_48##2	2.51818e-18
C321	VGND#6	a_81_296##6	1.84872e-20
C322	VGND	A#3	5.6762e-19
C323	VGND	a_81_296##9	1.15367e-19
C324	A#6	a_676_48##7	6.56766e-18
C325	VGND	a_81_296##6	9.48095e-19
C326	VGND	a_81_296##2	3.81078e-20
C327	X#5	VPWR#8	2.5317e-19
C328	A#5	a_489_392##4	1.26685e-17
C329	A#7	A#6	4.63422e-17
C330	VGND#4	A#1	5.16375e-18
C331	a_676_48##5	B_N#3	1.16129e-17
C332	a_81_296##3	VPWR#7	1.58826e-17
C333	a_676_48##5	a_676_48##6	7.06252e-20
C334	a_81_296##4	A#7	3.83502e-17
C335	a_676_48##2	B_N#1	1.84819e-18
C336	a_81_296##3	X#7	5.94364e-17
C337	a_676_48##5	a_676_48##4	2.60221e-20
C338	a_81_296##3	VPWR#9	2.83559e-18
C339	a_81_296##15	A	4.26533e-17
C340	a_81_296##14	A	1.35816e-17
C341	a_81_296##8	a_81_296##4	4.70385e-17
C342	VPWR#3	B_N#1	1.23448e-19
C343	X#1	a_81_296##2	1.43486e-18
C344	a_81_296##3	a_676_48##4	4.05135e-20
C345	VPWR#3	a_676_48##7	4.11571e-18
C346	a_81_296##11	a_81_296##8	4.73543e-17
C347	VPWR#3	A#6	5.93655e-18
C348	a_81_296##3	A#4	4.09075e-18
C349	VPWR#3	A#7	5.45103e-19
C350	a_81_296##3	a_81_296#	2.64881e-18
C351	VGND#3	a_81_296##17	5.62649e-18
C352	VGND#5	a_81_296##2	4.30545e-20
C353	a_676_48##9	B_N	7.15896e-17
C354	a_81_296##12	a_81_296##11	4.80385e-17
C355	a_81_296##3	a_81_296##5	3.37595e-19
C356	VPWR#3	a_81_296##4	8.44084e-20
C357	a_81_296##3	a_81_296##7	1.02854e-19
C358	a_81_296##3	a_81_296##10	1.71407e-19
C359	a_676_48##5	a_676_48##7	1.70135e-19
C360	VGND#11	a_81_296##6	5.09019e-19
C361	A	a_81_296##13	4.00623e-18
C362	VPWR	VPWR#8	3.9762e-17
C363	VPWR	VPWR#6	3.52844e-17
C364	A	a_489_392##2	1.22365e-17
C365	A	VPWR#5	1.04078e-18
C366	A	a_489_392##4	4.40842e-17
C367	B_N	a_676_48##8	3.24305e-17
C368	B_N	VPWR#4	3.22557e-17
C369	a_676_48##3	VNB	4.11932e-17
C370	a_676_48##2	VNB	3.90174e-17
C371	A#3	VNB	2.81969e-17
C372	a_81_296##13	B_N	7.79156e-19
C373	A#2	VNB	4.52907e-17
C374	a_81_296##9	VNB	3.2805e-17
C375	VGND#5	a_81_296##18	4.76761e-18
C376	VPWR	a_81_296##14	2.25788e-18
C377	a_81_296##6	VNB	2.96107e-17
C378	a_81_296##2	VNB	2.62277e-17
C379	VGND	VGND#6	4.49597e-17
C380	VGND	VGND#5	2.2582e-17
C381	VPWR	X#5	1.76722e-18
C382	VGND	VGND#3	1.62266e-17
C383	VPWR	X#3	1.25015e-18
C384	VGND#7	X	2.31424e-17
C385	VGND#6	VGND#10	3.8184e-19
C386	VGND	a_81_296##15	2.60178e-18
C387	VGND	a_81_296##14	4.9028e-18
C388	VGND	X#5	1.7467e-18
C389	VPWR	a_676_48##8	1.75201e-17
C390	VGND	X#3	1.53715e-18
C391	VPWR	VPWR#4	2.21991e-17
C392	VGND	X#2	1.62018e-18
C393	VGND	a_676_48##9	4.83972e-17
C394	VPWR	a_489_392#	2.98845e-17
C395	a_676_48##5	B_N#2	5.64617e-18
C396	VGND	VGND#8	1.97914e-17
C397	VPWR	a_81_296##13	7.75961e-18
C398	X	VPWR#10	1.41571e-17
C399	VGND	a_81_296##17	1.37115e-17
C400	VPWR	a_489_392##2	1.76832e-17
C401	VGND	VGND#9	2.19508e-17
C402	VGND	a_81_296##18	1.72331e-17
C403	VGND#6	X#1	8.72465e-18
C404	VGND	VGND#10	2.19615e-17
C405	VPWR	a_489_392##4	1.73542e-17
C406	a_676_48##7	a_676_48##2	4.1924e-18
C407	VGND	X#1	1.6946e-17
C408	VPWR	X#7	1.75853e-17
C409	VGND	X#4	1.31891e-17
C410	A	a_676_48##7	1.29815e-18
C411	VGND	VGND#7	3.4536e-17
C412	VPWR	X#6	1.25072e-17
C413	B_N	B_N#1	2.0282e-18
C414	VPWR	VPWR#10	3.85685e-17
C415	A	A#7	1.94746e-18
C416	VPWR	B_N#3	1.09776e-19
C417	VGND	a_489_392##2	2.26703e-18
C418	A	a_81_296##4	1.60647e-18
C419	B_N	a_676_48##7	2.00887e-19
C420	A	a_81_296##8	5.0354e-19
C421	VGND	VPWR#7	2.66437e-18
C422	VGND	X#7	2.57698e-18
C423	VGND#5	X#1	9.14872e-18
C424	A#2	a_676_48##7	9.46249e-19
C425	VGND#6	VNB	3.56077e-17
C426	A	a_81_296##12	2.95562e-19
C427	VGND#5	VNB	2.82171e-17
C428	VGND#3	VNB	2.06069e-17
C429	VGND	VPWR#10	3.11706e-18
C430	VGND	B_N#3	1.82948e-18
C431	VPWR#8	VNB	3.12265e-17
C432	VPWR#6	VNB	2.70662e-17
C433	VGND	a_676_48##6	9.1852e-19
C434	VGND	a_676_48##4	1.21662e-18
C435	VGND	A#1	1.28572e-18
C436	VPWR	B_N#1	5.05412e-18
C437	VGND	A#4	5.64498e-19
C438	a_81_296##15	VNB	2.18144e-18
C439	VGND	a_81_296#	9.50223e-19
C440	a_81_296##14	VNB	4.19852e-18
C441	VPWR	a_676_48##7	1.33258e-20
C442	VGND	a_81_296##5	2.34997e-19
C443	X#5	VNB	6.22947e-18
C444	VPWR	A#6	7.80322e-19
C445	VGND	a_81_296##7	7.03073e-19
C446	X#2	VNB	4.30584e-18
C447	a_676_48##9	VNB	7.49859e-17
C448	VGND	a_81_296##10	5.16542e-19
C449	VPWR	A#7	4.81396e-18
C450	VGND#8	VNB	1.96204e-18
C451	a_81_296##17	VNB	2.23795e-18
C452	VPWR	a_81_296##4	2.17308e-18
C453	VGND#9	VNB	9.03541e-19
C454	a_81_296##18	VNB	7.19907e-18
C455	B_N	B_N#2	2.88917e-17
C456	VGND#10	VNB	9.43277e-19
C457	VPWR	a_81_296##8	3.94344e-19
C458	X#1	VNB	3.73999e-18
C459	VGND#11	VNB	5.14977e-19
C460	VPWR	a_81_296##11	1.18101e-18
C461	a_676_48##5	B_N	3.20477e-17
C462	X#4	VNB	2.17669e-18
C463	a_81_296##3	A	1.1391e-17
C464	VGND#7	VNB	5.884e-17
C465	a_676_48##8	a_676_48##2	3.2274e-20
C466	a_676_48##8	VNB	6.8765e-17
C467	VPWR	a_81_296##12	2.75054e-18
C468	VPWR#4	VNB	1.45564e-17
C469	a_489_392#	VNB	1.78388e-17
C470	a_81_296##13	VNB	7.22061e-19
C471	a_489_392##2	VNB	1.8318e-17
C472	VPWR#5	VNB	8.80563e-18
C473	VPWR	VPWR#3	4.71154e-17
C474	a_489_392##4	VNB	3.67941e-18
C475	VPWR#7	VNB	3.38577e-18
C476	X#7	VNB	2.61404e-18
C477	VPWR#9	VNB	4.09278e-19
C478	X#6	VNB	4.78395e-18
C479	VPWR	B_N#2	7.89927e-19
C480	VPWR#10	VNB	8.13848e-17
C481	B_N#3	VNB	4.54307e-17
C482	VPWR	a_676_48##5	2.36325e-18
C483	a_676_48##6	VNB	2.87893e-17
C484	a_676_48##4	VNB	3.32333e-17
C485	A#1	VNB	3.39298e-17
C486	VPWR	A#5	4.93593e-19
C487	A#4	VNB	3.02579e-17
C488	VGND	VGND#4	9.97977e-18
C489	a_81_296#	VNB	2.86761e-17
C490	VPWR	a_81_296##3	8.00572e-18
C491	a_81_296##5	VNB	2.6691e-17
C492	VGND	B_N#2	2.77684e-18
C493	a_81_296##7	VNB	2.47085e-17
C494	VGND#6	X#4	1.36893e-17
C495	a_81_296##10	VNB	4.2606e-17
C496	VGND	a_676_48##5	2.19994e-18
C497	B_N#1	VNB	4.69168e-17
C498	VGND	A#5	5.62542e-19
C499	a_676_48#	VNB	3.34009e-17
C500	a_676_48##7	VNB	3.32985e-17
C501	VGND	a_81_296##3	8.36492e-18
C502	A#6	VNB	3.89469e-17
C503	A#7	VNB	4.14417e-17
C504	a_81_296##4	VNB	3.8431e-17
C505	a_81_296##8	VNB	3.41345e-17
C506	a_81_296##11	VNB	2.83287e-17
C507	a_81_296##12	VNB	4.34385e-17
C508	VPWR	A	2.79916e-18
C509	VPWR#3	VNB	2.81168e-16
C510	VPWR	B_N	2.23584e-18
C511	VGND#4	VNB	2.45808e-16
C512	B_N#2	VNB	6.63123e-17
C513	VGND	A	2.9051e-18
C514	a_676_48##5	VNB	9.46896e-19
C515	VPWR	X	1.90946e-18
C516	A#5	VNB	7.12644e-20
C517	VGND	B_N	3.52271e-18
C518	a_81_296##3	VNB	4.43173e-17
C519	VGND	X	1.65253e-18
C520	A	VNB	4.53577e-18
C521	B_N	VNB	2.19169e-18
C522	X	VNB	1.81648e-17
C523	VPWR	VNB	7.53274e-17
C524	VGND	VNB	6.94462e-17
C525	VGND#2	a_81_296##17	6.93878e-18
C526	VPWR#2	VNB	6.31806e-17
C527	VGND#3	VGND#2	1.13428e-18
C528	VGND#4	VGND#2	8.93764e-17
C529	VGND#2	a_676_48##6	1.50277e-18
C530	VPWR#2	B_N#2	7.25653e-19
C531	VGND#2	VNB	7.68976e-17
C532	VGND#2	a_676_48##9	6.46437e-17
C533	VPWR#3	VPWR#2	7.26772e-17
C534	VGND#2	a_676_48##3	3.52845e-20
C535	VGND#2	B_N#2	8.14931e-19
C536	VPWR#2	B_N#1	3.30728e-18
C537	VPWR	VPWR#2	4.26807e-17
C538	VGND#2	a_81_296##14	2.30374e-19
C539	VGND	VGND#2	5.37588e-17
C540	VPWR#2	B_N#3	2.02372e-19
C541	VGND#2	a_676_48##2	1.59361e-19
C542	VGND#2	a_676_48##5	6.83451e-19
C543	a_489_392#	VPWR#2	4.75722e-17
C544	a_676_48##8	VPWR#2	1.76458e-17
C545	VPWR#2	a_676_48##2	6.78948e-20
C546	VGND#2	B_N#3	5.74505e-18
C547	VPWR#2	a_676_48#	4.11601e-18
*
*
.ENDS sky130_fd_sc_hs__or2b_4
*
