* Extracted by Quantus, converted by sky130cad/quantus.py
*
*
*
*                       LINUX           Wed Nov 18 08:50:36 2026
*
*
*
*  PROGRAM  advgen
*
*  Name           : advgen - Quantus - (64-bit)
*  Version        : 25.1.0-p047
*  Build Date     : Thu Dec 11 23:20:30 PST 2025
*
*  HSPICE LIBRARY
*
*  OPERATING_TEMPERATURE 150
*  QRC_TECH_DIR <path>/tech
*
*
*

*
.SUBCKT sky130_fd_sc_hs__nor3b_1 VPB VNB VGND VPWR Y C_N A B
*
*
*  caps2d version: 10
*
*
*       TRANSISTOR CARDS
*
*
XM0 a_27_112##7 C_N#1 VGND#7 VNB sky130_fd_pr__nfet_01v8_lvt l=0.15 w=0.55 ad=0.2695 as=0.27435 pd=2.08 ps=2.26
XM4 VGND#7 A#1 Y#3 VNB sky130_fd_pr__nfet_01v8_lvt l=0.15 w=0.74 ad=0.27435 as=0.2368 pd=2.26 ps=2.12
XM7 Y#3 B#1 VGND#6 VNB sky130_fd_pr__nfet_01v8_lvt l=0.15 w=0.74 ad=0.2368 as=0.3108 pd=2.12 ps=2.32
XM2 VGND#6 a_27_112# Y#4 VNB sky130_fd_pr__nfet_01v8_lvt l=0.15 w=0.74 ad=0.3108 as=0.2109 pd=2.32 ps=2.05
XM6 a_27_112##6 C_N#3 VPWR#4 VPB sky130_fd_pr__pfet_01v8 l=0.15 w=0.84 ad=0.2478 as=0.4354 pd=2.27 ps=3.08
XM1 VPWR#4 A#3 a_260_368# VPB sky130_fd_pr__pfet_01v8 l=0.15 w=1.12 ad=0.4354 as=0.3024 pd=3.08 ps=2.78
XM3 a_260_368# B#3 a_344_368# VPB sky130_fd_pr__pfet_01v8 l=0.15 w=1.12 ad=0.3024 as=0.4704 pd=2.78 ps=3.08
XM5 a_344_368# a_27_112##3 Y#1 VPB sky130_fd_pr__pfet_01v8 l=0.15 w=1.12 ad=0.4704 as=0.3304 pd=3.08 ps=2.83
*
*
*       RESISTOR AND CAP/DIODE CARDS
*
Rg1	C_N#1	C_N#2	253.420792
Rg2	C_N#2	C_N#3	411.718903
Rg3	A#1	A#2	382.539734
Rg4	A#2	A#3	434.639221
Rg5	B#1	B#2	382.539734
Rg6	B#2	B#3	434.639221
Rg7	a_27_112#	a_27_112##2	382.539734
Rg8	a_27_112##2	a_27_112##3	434.639221
Rf1	C_N#4	C_N#2	161.821228
Rf2	C_N	C_N#6	1.588424
Rf3	C_N#4	C_N#6	3.882813
Rf4	A#2	A#5	160.996811
Rf5	A#6	A	0.764007
Rf6	A#5	A#6	5.905091
Rf7	B#4	B#2	160.844009
Rf8	B	B#6	0.611206
Rf9	B#4	B#6	5.905091
Rf10	a_27_112##2	a_27_112##5	311.702393
Rf11	a_27_112##5	a_27_112##6	13.545121
Rf12	a_27_112##5	a_27_112##7	98.587898
Rf13	Y#1	Y#2	111.973717
Rf14	Y#2	Y#3	80.470192
Rf15	Y#2	Y	5.418806
Rf16	Y	Y#5	5.243116
Rf17	Y#5	Y	5.243116
Rf18	Y#4	Y#5	7.500000
Rf20	VGND#2	VGND#3	40.518494
Rf21	VGND#3	VGND#4	32.482937
Rf23	VGND#2	VGND#6	38.247387
Rf24	VGND#4	VGND#7	32.223660
Rf25	VPWR#1	VPWR#2	32.117687
Rf27	VPWR#2	VPWR#4	31.534731
Re1	VPWR#1	VPWR	1.637070
Re2	VGND	VGND#3	1.637131
*
*       CAPACITOR CARDS
*
*
C1	VGND	VNB	5.79587e-17
C2	VPWR	VNB	6.20889e-17
C3	Y	VNB	3.12924e-17
C4	VGND	Y	2.41285e-17
C5	B	VNB	1.86305e-18
C6	C_N#2	VNB	4.27958e-17
C7	A#2	VNB	2.5158e-17
C8	B#2	VNB	3.54899e-17
C9	a_27_112##2	VNB	5.02393e-17
C10	VPWR	B	2.51368e-18
C11	VGND#3	VNB	1.51059e-16
C12	VPWR#1	VNB	2.00702e-16
C13	VGND	C_N#2	3.32079e-19
C14	C_N#3	VNB	4.92203e-17
C15	A#3	VNB	3.36423e-17
C16	B#3	VNB	2.6716e-17
C17	a_27_112##3	VNB	3.74027e-17
C18	VGND	a_27_112##2	2.72306e-18
C19	C_N#1	VNB	3.82961e-17
C20	VGND	VGND#3	1.00116e-17
C21	A#1	VNB	3.21534e-17
C22	B#1	VNB	3.08522e-17
C23	a_27_112#	VNB	3.06488e-17
C24	VPWR#4	VNB	1.14287e-17
C25	VPWR	a_27_112##2	1.36212e-17
C26	Y#1	VNB	6.53359e-17
C27	a_27_112##7	VNB	3.72553e-17
C28	VGND#7	VNB	1.03027e-17
C29	Y#3	VNB	9.00095e-18
C30	VPWR	VPWR#1	4.90662e-17
C31	VGND#6	VNB	2.03623e-18
C32	VGND	C_N#1	6.85601e-18
C33	C_N#4	VNB	7.11692e-18
C34	VGND	A#1	5.20498e-19
C35	C_N#6	a_27_112##5	6.39229e-18
C36	VPWR	C_N#3	8.11898e-18
C37	VGND	B#1	1.04726e-18
C38	C_N#6	VNB	3.89708e-18
C39	VPWR	A#3	7.16827e-19
C40	VGND	a_27_112#	1.01586e-18
C41	A#5	VNB	1.61001e-18
C42	A#6	VNB	1.06485e-18
C43	VPWR	B#3	1.50307e-18
C44	B#4	VNB	9.78236e-19
C45	VPWR	a_27_112##3	2.35948e-18
C46	a_27_112##5	VNB	6.88433e-17
C47	Y#2	VNB	4.31942e-17
C48	VGND	a_27_112##7	1.73289e-17
C49	VGND	VGND#7	2.01746e-17
C50	VGND	Y#3	1.77731e-17
C51	B	A#2	1.35218e-18
C52	VGND	C_N#4	1.85793e-18
C53	VPWR	VPWR#4	2.22163e-17
C54	B	B#2	6.02426e-18
C55	VGND	C_N#6	3.5462e-18
C56	VGND	A#5	3.89373e-18
C57	a_27_112##5	A#5	9.50929e-19
C58	B	a_27_112##2	5.02428e-17
C59	VPWR	Y#1	2.47484e-17
C60	VGND	B#4	2.59275e-18
C61	Y	B#1	5.16875e-19
C62	Y	a_27_112#	1.97295e-17
C63	VGND	a_27_112##5	2.23943e-18
C64	VGND	Y#2	1.79428e-18
C65	VPWR	C_N#4	1.2481e-18
C66	a_27_112##2	a_260_368#	1.50905e-18
C67	VPWR	C_N#6	1.34515e-18
C68	B#2	a_344_368#	5.29945e-19
C69	B	A#3	6.06813e-19
C70	B	B#3	2.04124e-18
C71	a_27_112##2	a_344_368#	9.61534e-18
C72	VPWR	A#6	2.51368e-18
C73	Y#3	Y	1.6132e-18
C74	C_N#2	A#2	3.26611e-17
C75	B	a_27_112##3	9.46037e-19
C76	VGND#6	Y	4.59837e-17
C77	Y	Y#4	2.37824e-18
C78	VPWR	a_27_112##5	2.51778e-17
C79	A#2	B#2	2.96558e-17
C80	A#3	a_260_368#	2.6874e-17
C81	B#3	a_260_368#	2.6874e-17
C82	a_27_112##5	A#6	4.1334e-17
C83	B#2	a_27_112##2	3.07679e-17
C84	B#3	a_344_368#	3.06704e-17
C85	a_27_112##3	a_344_368#	3.38701e-17
C86	VGND#3	B#2	4.13281e-20
C87	VPWR#1	B#2	1.62629e-19
C88	C_N#3	A#2	1.80637e-18
C89	a_27_112##2	VPWR#1	4.11567e-18
C90	a_27_112##2	C_N#3	6.91905e-20
C91	a_27_112##2	A#3	1.12865e-19
C92	C_N#2	A#1	1.40604e-18
C93	a_27_112##2	B#3	2.77919e-17
C94	A#6	B	1.10718e-17
C95	a_27_112##2	a_27_112##3	1.5018e-17
C96	VPWR#1	A#3	3.27612e-18
C97	VPWR#1	B#3	8.62136e-18
C98	VPWR#1	a_27_112##3	7.6366e-18
C99	A#2	VPWR#4	1.29566e-18
C100	C_N#3	A#3	2.40398e-17
C101	C_N#2	a_27_112##7	1.0446e-17
C102	VGND#3	A#1	3.83729e-18
C103	VGND#3	B#1	1.78557e-18
C104	A#3	B#3	5.99409e-17
C105	Y#3	C_N#2	7.57647e-19
C106	a_27_112##5	a_260_368#	6.09127e-18
C107	VGND#7	A#2	2.99993e-18
C108	B#3	a_27_112##3	3.27692e-17
C109	C_N#4	C_N#2	9.17293e-18
C110	a_27_112##2	Y#1	4.14384e-17
C111	C_N#6	C_N#2	8.93858e-18
C112	Y#3	B#2	3.49354e-18
C113	A#5	C_N#2	3.36778e-18
C114	VGND#6	B#2	5.95571e-19
C115	A#6	C_N#2	1.17196e-18
C116	C_N#6	A#2	5.16582e-18
C117	Y#3	a_27_112##2	2.99801e-18
C118	C_N#3	a_27_112##6	8.83312e-18
C119	A#5	A#2	1.15772e-17
C120	VGND#6	a_27_112##2	4.1779e-19
C121	Y#1	VPWR#1	3.27805e-17
C122	C_N#3	VPWR#4	2.60032e-17
C123	VGND#3	Y#3	1.75399e-17
C124	C_N#6	B#2	7.08169e-19
C125	A#6	A#2	7.4317e-18
C126	VPWR#4	A#3	6.02797e-17
C127	B#4	A#2	2.74955e-18
C128	A#5	B#2	2.03044e-18
C129	a_27_112##5	C_N#2	7.68244e-18
C130	C_N#1	A#1	2.20804e-17
C131	Y#2	C_N#2	1.52457e-19
C132	C_N#6	a_27_112##2	4.6405e-19
C133	Y#1	C_N#3	1.10102e-19
C134	A#6	B#2	1.39878e-18
C135	VPWR#4	B#3	5.53612e-18
C136	B#4	B#2	9.6245e-18
C137	a_27_112##5	A#2	3.15753e-18
C138	VPWR#4	a_27_112##3	4.14174e-18
C139	Y#1	A#3	3.44809e-18
C140	Y#2	A#2	9.66266e-20
C141	A#1	B#1	3.28081e-17
C142	VGND#3	A#5	5.71815e-19
C143	B#4	a_27_112##2	1.78214e-17
C144	Y#1	B#3	8.60659e-18
C145	Y#2	B#2	2.29956e-19
C146	B#1	a_27_112#	2.17801e-17
C147	Y#1	a_27_112##3	4.86956e-17
C148	a_27_112##5	a_27_112##2	1.5232e-18
C149	Y#2	a_27_112##2	8.37071e-17
C150	a_27_112##7	C_N#1	2.86078e-17
C151	C_N#1	VGND#7	2.53091e-17
C152	A#6	C_N#3	2.72665e-18
C153	a_27_112##5	VPWR#1	1.32016e-18
C154	a_27_112##7	A#1	1.30117e-18
C155	Y#3	C_N#1	1.94333e-18
C156	A#1	VGND#7	2.57163e-17
C157	a_27_112##7	B#1	1.84248e-19
C158	A#6	A#3	2.06734e-18
C159	A#1	Y#3	3.28929e-17
C160	VGND#7	B#1	2.38261e-18
C161	VGND#6	A#1	4.0017e-19
C162	A#6	B#3	6.29001e-19
C163	Y#3	B#1	6.05564e-17
C164	a_27_112##5	C_N#3	4.94189e-17
C165	VGND#7	a_27_112#	6.30104e-19
C166	VPWR#4	Y#1	1.23107e-17
C167	B#1	VGND#6	2.3502e-17
C168	Y#3	a_27_112#	8.38935e-19
C169	a_27_112##5	A#3	1.95337e-17
C170	a_27_112#	VGND#6	2.226e-17
C171	a_27_112#	Y#4	7.57551e-18
C172	a_27_112##5	B#3	4.08764e-19
C173	a_27_112##5	a_27_112##3	3.3741e-19
C174	a_27_112##7	VGND#7	2.90773e-17
C175	a_27_112##7	Y#3	3.48839e-18
C176	VGND#7	Y#3	5.96786e-17
C177	VGND#7	VGND#6	1.31117e-18
C178	a_27_112##7	C_N#4	4.34265e-17
C179	Y#3	VGND#6	5.62314e-17
C180	Y#2	B#1	3.53198e-19
C181	Y#2	a_27_112#	2.30617e-17
C182	a_27_112##5	a_27_112##6	3.73754e-18
C183	a_27_112##5	VPWR#4	6.9593e-17
C184	VGND#7	A#5	1.17088e-17
C185	Y#3	B#4	4.27909e-17
C186	Y#2	Y#1	1.791e-18
C187	a_27_112##7	a_27_112##5	2.91832e-18
C188	VGND#7	a_27_112##5	5.21319e-18
C189	C_N#6	A#5	1.90623e-17
C190	Y#3	a_27_112##5	6.90515e-18
C191	Y#3	Y#2	1.10235e-18
C192	Y#2	VGND#6	2.14509e-17
C193	A#5	B#4	1.53597e-17
C194	Y#2	Y#4	9.37836e-19
C195	a_27_112##5	C_N#4	2.43764e-17
C196	VGND#2	Y#3	5.53674e-19
C197	VGND	VGND#4	3.91849e-17
C198	VGND#4	A#5	1.19212e-19
C199	VGND#2	a_27_112#	6.49482e-18
C200	VGND#2	A#1	8.58061e-19
C201	VGND#4	C_N#2	4.64907e-19
C202	VGND#4	VGND#2	9.53351e-19
C203	VGND#3	VGND#4	5.44064e-17
C204	VGND#2	a_27_112##2	5.21403e-20
C205	VGND#4	C_N#1	5.5217e-18
C206	a_27_112##5	VPWR#2	1.26517e-17
C207	VGND#2	VNB	4.87407e-17
C208	VPWR#2	A#3	7.75922e-19
C209	VGND#7	VGND#2	4.95158e-19
C210	VGND#4	C_N#4	8.04102e-20
C211	VGND#4	VNB	5.13263e-17
C212	VGND#4	C_N#6	1.23468e-18
C213	VGND#2	B#1	5.48425e-18
C214	VPWR#2	VNB	5.08029e-17
C215	VGND#3	VGND#2	5.21463e-17
C216	VPWR#1	VPWR#2	5.41741e-17
C217	VGND#2	Y#2	2.25448e-19
C218	VPWR	VPWR#2	3.77672e-17
C219	VGND#4	A#1	8.60837e-19
C220	VPWR#2	C_N#3	3.39651e-18
C221	VGND#2	Y	2.75666e-17
C222	VPWR#2	C_N#2	9.47194e-20
C223	VGND	VGND#2	5.56292e-17
C224	VGND#4	a_27_112##7	1.16072e-17
*
*
.ENDS sky130_fd_sc_hs__nor3b_1
*
