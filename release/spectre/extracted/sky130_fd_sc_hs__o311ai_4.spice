* Extracted by Quantus, converted by sky130cad/quantus.py
*
*
*
*                       LINUX           Wed Nov 18 09:01:16 2026
*
*
*
*  PROGRAM  advgen
*
*  Name           : advgen - Quantus - (64-bit)
*  Version        : 25.1.0-p047
*  Build Date     : Thu Dec 11 23:20:30 PST 2025
*
*  HSPICE LIBRARY
*
*  OPERATING_TEMPERATURE 150
*  QRC_TECH_DIR <path>/tech
*
*
*

*
.SUBCKT sky130_fd_sc_hs__o311ai_4 VNB VPB VGND VPWR Y C1 A2 A1 B1 A3
*
*
*  caps2d version: 10
*
*
*       TRANSISTOR CARDS
*
*
XM2 a_27_74##8 C1#5 Y#5 VNB sky130_fd_pr__nfet_01v8_lvt l=0.15 w=0.74 ad=0.2109 as=0.2109 pd=2.05 ps=2.05
XM5 Y#5 C1#7 a_27_74##6 VNB sky130_fd_pr__nfet_01v8_lvt l=0.15 w=0.74 ad=0.2109 as=0.2072 pd=2.05 ps=2.04
XM33 a_27_74##6 C1#6 Y#3 VNB sky130_fd_pr__nfet_01v8_lvt l=0.15 w=0.74 ad=0.2072 as=0.2072 pd=2.04 ps=2.04
XM10 Y#3 C1#1 a_27_74##4 VNB sky130_fd_pr__nfet_01v8_lvt l=0.15 w=0.74 ad=0.2072 as=0.2072 pd=2.04 ps=2.04
XM15 a_459_74##10 B1#10 a_27_74##4 VNB sky130_fd_pr__nfet_01v8_lvt l=0.15 w=0.74 ad=0.2072 as=0.2072 pd=2.04 ps=2.04
XM23 a_27_74##2 B1#9 a_459_74##10 VNB sky130_fd_pr__nfet_01v8_lvt l=0.15 w=0.74 ad=0.2072 as=0.2072 pd=2.04 ps=2.04
XM8 a_27_74##2 B1#8 a_459_74##8 VNB sky130_fd_pr__nfet_01v8_lvt l=0.15 w=0.74 ad=0.2072 as=0.2146 pd=2.04 ps=2.06
XM35 a_459_74##8 B1#1 a_27_74# VNB sky130_fd_pr__nfet_01v8_lvt l=0.15 w=0.74 ad=0.2146 as=0.19515 pd=2.06 ps=2.05
XM9 a_459_74##14 A3#12 VGND#15 VNB sky130_fd_pr__nfet_01v8_lvt l=0.15 w=0.74 ad=0.2072 as=0.19445 pd=2.04 ps=2.05
XM11 VGND#14 A3#9 a_459_74##14 VNB sky130_fd_pr__nfet_01v8_lvt l=0.15 w=0.74 ad=0.3546 as=0.2072 pd=2.56 ps=2.04
XM31 VGND#14 A3#7 a_459_74##13 VNB sky130_fd_pr__nfet_01v8_lvt l=0.15 w=0.74 ad=0.3546 as=0.2072 pd=2.56 ps=2.04
XM20 a_459_74##13 A3#1 VGND#13 VNB sky130_fd_pr__nfet_01v8_lvt l=0.15 w=0.74 ad=0.2072 as=0.363 pd=2.04 ps=2.58
XM19 a_459_74##4 A2#12 VGND#13 VNB sky130_fd_pr__nfet_01v8_lvt l=0.15 w=0.74 ad=0.2072 as=0.363 pd=2.04 ps=2.58
XM16 VGND#12 A2#10 a_459_74##4 VNB sky130_fd_pr__nfet_01v8_lvt l=0.15 w=0.74 ad=0.2368 as=0.2072 pd=2.12 ps=2.04
XM12 a_459_74##12 A2#8 VGND#12 VNB sky130_fd_pr__nfet_01v8_lvt l=0.15 w=0.74 ad=0.2627 as=0.2368 pd=2.19 ps=2.12
XM30 VGND#11 A2#1 a_459_74##12 VNB sky130_fd_pr__nfet_01v8_lvt l=0.15 w=0.74 ad=0.2072 as=0.2627 pd=2.04 ps=2.19
XM28 VGND#11 A1#8 a_459_74##11 VNB sky130_fd_pr__nfet_01v8_lvt l=0.15 w=0.74 ad=0.2072 as=0.2072 pd=2.04 ps=2.04
XM13 a_459_74##11 A1#14 VGND#10 VNB sky130_fd_pr__nfet_01v8_lvt l=0.15 w=0.74 ad=0.2072 as=0.6253 pd=2.04 ps=3.17
XM29 VGND#10 A1#10 a_459_74# VNB sky130_fd_pr__nfet_01v8_lvt l=0.15 w=0.74 ad=0.6253 as=0.2183 pd=3.17 ps=2.07
XM24 a_459_74# A1#1 VGND#1 VNB sky130_fd_pr__nfet_01v8_lvt l=0.15 w=0.74 ad=0.2183 as=0.2109 pd=2.07 ps=2.05
XM0 VPWR#6 C1#9 Y#8 VPB sky130_fd_pr__pfet_01v8 l=0.15 w=1.12 ad=0.3304 as=0.588 pd=2.83 ps=3.29
XM14 Y#8 C1#8 VPWR#10 VPB sky130_fd_pr__pfet_01v8 l=0.15 w=1.12 ad=0.588 as=0.392 pd=3.29 ps=2.94
XM22 VPWR#10 B1#7 Y#10 VPB sky130_fd_pr__pfet_01v8 l=0.15 w=1.12 ad=0.392 as=0.336 pd=2.94 ps=2.84
XM6 Y#10 B1#11 VPWR#9 VPB sky130_fd_pr__pfet_01v8 l=0.15 w=1.12 ad=0.336 as=1.8984 pd=2.84 ps=5.63
XM34 a_841_368##5 A3#14 Y#9 VPB sky130_fd_pr__pfet_01v8 l=0.15 w=1.12 ad=0.3304 as=0.392 pd=2.83 ps=2.94
XM27 a_841_368##8 A3#13 Y#9 VPB sky130_fd_pr__pfet_01v8 l=0.15 w=1.12 ad=0.4144 as=0.392 pd=2.98 ps=2.94
XM32 Y#1 A3#8 a_841_368##8 VPB sky130_fd_pr__pfet_01v8 l=0.15 w=1.12 ad=0.5376 as=0.4144 pd=3.2 ps=2.98
XM18 Y#1 A3#6 a_841_368##7 VPB sky130_fd_pr__pfet_01v8 l=0.15 w=1.12 ad=0.5376 as=0.336 pd=3.2 ps=2.84
XM21 a_841_368##7 A2#6 a_1350_368##4 VPB sky130_fd_pr__pfet_01v8 l=0.15 w=1.12 ad=0.336 as=0.392 pd=2.84 ps=2.94
XM4 a_1350_368##4 A2#11 a_841_368##6 VPB sky130_fd_pr__pfet_01v8 l=0.15 w=1.12 ad=0.392 as=0.448 pd=2.94 ps=3.04
XM25 a_1350_368##6 A2#9 a_841_368##6 VPB sky130_fd_pr__pfet_01v8 l=0.15 w=1.12 ad=0.336 as=0.448 pd=2.84 ps=3.04
XM17 a_841_368# A2#7 a_1350_368##6 VPB sky130_fd_pr__pfet_01v8 l=0.15 w=1.12 ad=0.3304 as=0.336 pd=2.83 ps=2.84
XM3 a_1350_368##5 A1#13 VPWR#8 VPB sky130_fd_pr__pfet_01v8 l=0.15 w=1.12 ad=0.336 as=0.3304 pd=2.84 ps=2.83
XM7 VPWR#7 A1#12 a_1350_368##5 VPB sky130_fd_pr__pfet_01v8 l=0.15 w=1.12 ad=0.336 as=0.336 pd=2.84 ps=2.84
XM26 a_1350_368# A1#11 VPWR#7 VPB sky130_fd_pr__pfet_01v8 l=0.15 w=1.12 ad=0.336 as=0.336 pd=2.84 ps=2.84
XM1 VPWR#1 A1#9 a_1350_368# VPB sky130_fd_pr__pfet_01v8 l=0.15 w=1.12 ad=0.3304 as=0.336 pd=2.83 ps=2.84
*
*
*       RESISTOR AND CAP/DIODE CARDS
*
Rg1	C1#1	C1#2	473.208221
Rg2	C1#2	C1#3	119.453285
Rg3	C1#3	C1#4	13.272730
Rg4	C1#4	C1#5	302.411896
Rg5	C1#2	C1#6	262.702026
Rg6	C1#3	C1#7	303.631470
Rg7	C1#3	C1#8	479.821014
Rg8	C1#4	C1#9	491.370514
Rg9	B1#1	B1#2	444.929443
Rg10	B1#2	B1#3	24.674770
Rg11	B1#3	B1#4	43.275814
Rg12	B1#4	B1#5	62.900799
Rg13	B1#5	B1#6	51.642799
Rg14	B1#6	B1#7	586.156250
Rg15	B1#2	B1#8	372.817749
Rg16	B1#4	B1#9	372.817749
Rg17	B1#5	B1#10	417.453064
Rg18	B1#6	B1#11	402.971954
Rg19	A3#1	A3#2	397.555725
Rg20	A3#2	A3#3	60.954994
Rg21	A3#3	A3#4	35.394081
Rg22	A3#4	A3#5	44.410511
Rg23	A3#2	A3#6	449.655212
Rg24	A3#3	A3#7	370.752045
Rg25	A3#4	A3#8	419.554810
Rg26	A3#5	A3#9	379.618866
Rg27	A3#5	A3#10	44.136082
Rg28	A3#10	A3#11	49.175148
Rg29	A3#11	A3#12	370.752045
Rg30	A3#10	A3#13	419.554810
Rg31	A3#11	A3#14	462.677002
Rg32	A2#1	A2#2	336.815216
Rg33	A2#2	A2#3	88.631287
Rg34	A2#3	A2#4	121.841370
Rg35	A2#4	A2#5	75.364258
Rg36	A2#5	A2#6	452.833405
Rg37	A2#2	A2#7	487.361969
Rg38	A2#3	A2#8	357.016968
Rg39	A2#3	A2#9	522.776123
Rg40	A2#4	A2#10	375.486084
Rg41	A2#4	A2#11	427.585571
Rg42	A2#5	A2#12	370.752045
Rg43	A1#1	A1#2	359.923981
Rg44	A1#2	A1#3	29.082785
Rg45	A1#3	A1#4	52.744656
Rg46	A1#4	A1#5	36.535618
Rg47	A1#5	A1#6	74.484627
Rg48	A1#6	A1#7	9.510829
Rg49	A1#7	A1#8	670.785828
Rg50	A1#2	A1#9	525.683167
Rg51	A1#3	A1#10	417.800537
Rg52	A1#3	A1#11	555.979309
Rg53	A1#5	A1#12	419.554810
Rg54	A1#6	A1#13	425.304718
Rg55	A1#7	A1#14	429.281647
Rf1	C1#10	C1	1.206753
Rf2	C1#3	C1#12	54.617687
Rf3	C1#12	C1	1.206753
Rf4	C1#10	C1#12	13.193184
Rf5	a_27_74#	a_27_74##3	78.553932
Rf6	a_27_74##3	a_27_74##5	72.669960
Rf7	a_27_74##5	a_27_74##7	44.295650
Rf8	a_27_74##7	a_27_74##8	62.212914
Rf9	a_27_74##2	a_27_74##3	15.000000
Rf10	a_27_74##4	a_27_74##5	15.000000
Rf11	a_27_74##6	a_27_74##7	15.000000
Rf12	B1	B1#12	7.444383
Rf13	B1#12	B1	10.422136
Rf14	A3#5	A3	38.374287
Rf15	Y#1	Y#2	16.278900
Rf16	Y#2	Y	61.334435
Rf17	Y	Y#4	355.826965
Rf18	Y#4	Y#5	47.925724
Rf19	Y#2	Y#6	72.893234
Rf20	Y#6	Y#7	214.868256
Rf21	Y#7	Y#8	88.304253
Rf22	Y#6	Y#9	12.500479
Rf23	Y#7	Y#10	16.043533
Rf24	Y#3	Y#4	15.000000
Rf25	A2#13	A2	0.997598
Rf26	A2#4	A2#15	54.408531
Rf27	A2#13	A2#15	9.473685
Rf28	A2#16	A2	0.997598
Rf29	A2#15	A2#16	5.195247
Rf30	a_841_368#	a_841_368##2	84.654213
Rf31	a_841_368##2	a_841_368##3	73.001427
Rf32	a_841_368##3	a_841_368##4	80.306480
Rf33	a_841_368##4	a_841_368##5	87.959900
Rf34	a_841_368##2	a_841_368##6	18.149860
Rf35	a_841_368##3	a_841_368##7	18.149860
Rf36	a_841_368##4	a_841_368##8	18.149860
Rf37	a_459_74#	a_459_74##2	116.357391
Rf38	a_459_74##2	a_459_74##3	88.178368
Rf39	a_459_74##3	a_459_74##5	82.460243
Rf40	a_459_74##5	a_459_74##6	74.004417
Rf41	a_459_74##6	a_459_74##7	71.597771
Rf42	a_459_74##7	a_459_74##9	126.439369
Rf43	a_459_74##9	a_459_74##10	59.255741
Rf44	a_459_74##2	a_459_74##11	23.106659
Rf45	a_459_74##3	a_459_74##12	33.530968
Rf46	a_459_74##6	a_459_74##13	19.547934
Rf47	a_459_74##7	a_459_74##14	20.911032
Rf48	a_459_74##4	a_459_74##5	7.500000
Rf49	a_459_74##8	a_459_74##9	15.000000
Rf52	a_1350_368#	a_1350_368##2	74.837822
Rf53	a_1350_368##2	a_1350_368##3	93.831856
Rf54	a_1350_368##3	a_1350_368##4	83.542923
Rf55	a_1350_368##2	a_1350_368##5	20.680136
Rf56	a_1350_368##3	a_1350_368##6	14.538594
Rf57	VPWR#1	VPWR#2	115.584740
Rf58	VPWR#2	VPWR#3	73.354691
Rf59	VPWR#3	VPWR#4	407.840912
Rf60	VPWR#4	VPWR#5	150.970840
Rf61	VPWR#5	VPWR#6	115.784668
Rf62	VPWR#2	VPWR#7	32.322075
Rf63	VPWR#3	VPWR#8	35.819977
Rf64	VPWR#4	VPWR#9	7.151524
Rf65	VPWR#5	VPWR#10	31.534731
Rf66	VGND#1	VGND#2	116.428040
Rf67	VGND#2	VGND#3	50.983463
Rf68	VGND#3	VGND#4	33.636044
Rf69	VGND#4	VGND#5	68.310493
Rf70	VGND#5	VGND#6	68.977966
Rf71	VGND#6	VGND#7	74.822006
Rf72	VGND#7	VGND#8	68.618401
Rf73	VGND#8	VGND#9	88.731819
Rf74	VGND#2	VGND#10	16.115644
Rf75	VGND#4	VGND#11	41.038895
Rf76	VGND#5	VGND#12	37.656876
Rf77	VGND#6	VGND#13	27.647388
Rf78	VGND#7	VGND#14	28.011898
Rf79	VGND#8	VGND#15	31.161278
Rf84	A1#4	A1	40.058201
Rf81	B1#3	B1#12	40.058201
Re1	VPWR#3	VPWR	2.377092
Re2	VPWR	VPWR#4	1.528131
Re3	VGND#3	VGND	2.377092
Re4	VGND	VGND#9	1.528131
*
*       CAPACITOR CARDS
*
*
C1	a_27_74#	a_459_74##8	5.14167e-17
C2	a_27_74##4	C1#1	3.66361e-17
C3	A3#5	A3#11	1.85565e-17
C4	a_459_74##2	a_1350_368##3	7.98929e-18
C5	Y#2	A2#11	1.78112e-19
C6	Y#6	a_841_368##8	5.78637e-17
C7	A3#5	A3#10	1.9176e-17
C8	VGND#4	A1#8	3.39565e-18
C9	a_841_368##4	A3#8	2.02518e-17
C10	a_459_74##3	VGND#12	1.43555e-17
C11	a_1350_368##3	A2#3	2.30718e-18
C12	a_459_74##10	C1#6	5.5556e-19
C13	Y#3	C1#1	3.67694e-17
C14	Y#2	Y#1	2.36886e-17
C15	Y#6	A2#6	6.12573e-20
C16	a_27_74##4	C1#6	8.30726e-19
C17	VGND#2	A1#8	2.0546e-18
C18	a_459_74##6	VGND#13	4.06155e-17
C19	VGND#5	A2#1	4.84566e-19
C20	a_27_74##8	B1#10	8.47635e-20
C21	A2#3	a_841_368##6	3.00266e-19
C22	A1#7	A1#3	1.02957e-18
C23	a_459_74##10	C1#7	3.01854e-19
C24	a_459_74##7	a_459_74##6	2.50837e-18
C25	Y#3	C1#6	3.30319e-17
C26	Y#2	A2#6	3.60918e-19
C27	A3#4	A3#2	2.40499e-18
C28	Y#6	Y#9	5.65941e-18
C29	a_459_74##2	a_1350_368##2	1.38175e-17
C30	a_841_368##4	A3#13	1.61026e-17
C31	a_459_74##4	a_459_74##3	4.17183e-19
C32	VGND#4	A2#1	4.3297e-18
C33	Y#2	a_841_368##8	5.81297e-17
C34	a_27_74##4	C1#7	1.87322e-19
C35	a_459_74##8	a_27_74##2	3.5315e-17
C36	Y#6	A3#6	3.10579e-19
C37	a_27_74##6	C1#6	3.37502e-17
C38	A1#10	A1#1	3.37422e-17
C39	a_27_74##8	C1#1	1.23613e-19
C40	VPWR#5	B1#7	2.59841e-18
C41	a_459_74##10	C1#5	3.39553e-19
C42	Y#3	C1#7	1.68744e-19
C43	a_459_74##6	a_459_74##13	7.83611e-19
C44	VGND#2	A2#1	3.72657e-19
C45	Y#7	B1#6	5.69658e-18
C46	VGND#5	A2#8	7.62101e-18
C47	Y#2	A3#6	3.14083e-17
C48	Y#6	a_841_368##5	1.00044e-16
C49	A2#5	a_1350_368##4	3.11005e-18
C50	a_459_74##7	VGND#14	3.95312e-17
C51	a_27_74##4	C1#5	2.80812e-19
C52	a_27_74##6	C1#7	3.38605e-17
C53	a_459_74##8	a_459_74##10	1.60367e-20
C54	a_27_74##4	a_27_74#	3.90848e-20
C55	a_27_74##8	C1#6	2.05141e-19
C56	Y#6	A3#8	2.08494e-18
C57	VGND#4	A2#8	3.98502e-19
C58	Y#7	VPWR#9	1.08977e-16
C59	Y#3	C1#5	1.37745e-19
C60	A1#14	A1#10	3.24167e-18
C61	Y#5	C1#7	3.52201e-17
C62	VPWR#5	C1#8	9.77858e-19
C63	B1#4	B1#3	1.97476e-18
C64	a_459_74##6	VGND#14	3.98431e-17
C65	a_27_74##8	C1#7	9.86222e-19
C66	a_27_74##2	a_459_74##10	3.53704e-17
C67	Y#2	A3#8	2.91583e-17
C68	Y#3	a_27_74#	5.54966e-17
C69	Y#6	VPWR#9	6.3777e-17
C70	VGND#14	A3#10	5.63421e-19
C71	VGND#5	A2#10	5.21395e-18
C72	a_459_74##7	a_459_74##14	2.38858e-18
C73	Y#5	C1#5	2.61961e-17
C74	Y#2	A3#10	1.66772e-18
C75	Y#6	A3#13	4.41511e-17
C76	a_1350_368##3	a_841_368##2	1.49562e-17
C77	Y#7	Y#10	2.68731e-19
C78	A1#8	A1#14	4.05157e-17
C79	VGND#4	A2#10	9.16695e-20
C80	a_27_74##8	C1#5	3.49296e-17
C81	Y#3	a_459_74##8	5.53562e-18
C82	Y#7	B1#4	4.09601e-18
C83	VGND#6	A2#12	2.99968e-18
C84	VGND#14	A3#4	9.11383e-19
C85	Y#2	A3#13	7.27198e-19
C86	a_459_74##7	VGND#15	5.48834e-17
C87	Y#2	A3#4	3.88623e-18
C88	VGND#5	A2#12	6.22807e-19
C89	C1#3	B1#6	3.38104e-18
C90	Y#6	A3#14	3.23089e-17
C91	Y#7	VPWR#10	2.73969e-17
C92	a_27_74##4	a_459_74##10	3.98761e-17
C93	Y#3	a_27_74##2	6.80822e-17
C94	VPWR#5	B1#6	1.32736e-20
C95	A2#16	a_1350_368##3	2.86313e-17
C96	A2#1	A1#8	3.65266e-17
C97	A1#5	A1#3	4.36051e-18
C98	C1#3	C1#4	5.03555e-17
C99	VGND#6	A3#1	3.00479e-18
C100	Y#7	B1#11	3.29228e-17
C101	Y#3	a_459_74##10	9.73901e-20
C102	B1#1	VPWR#9	2.53393e-18
C103	a_459_74##2	A1#14	2.09862e-17
C104	a_27_74#	a_459_74##7	2.23643e-17
C105	VPWR#1	A1#9	3.1379e-17
C106	a_459_74##4	A2#16	1.18575e-17
C107	VGND#5	A3#1	1.91034e-19
C108	A2#8	A2#1	2.69032e-17
C109	VGND#7	A3#7	2.99968e-18
C110	a_1350_368#	A1#9	5.91524e-17
C111	a_459_74##3	A1#8	5.38039e-19
C112	VGND#15	A3#11	8.59339e-19
C113	a_27_74##4	Y#3	7.60924e-17
C114	Y#7	B1#7	2.45005e-17
C115	VPWR#1	A1#11	2.08837e-18
C116	VPWR#7	A1#9	2.71417e-18
C117	Y#2	A3#2	8.16891e-19
C118	a_459_74##2	A1#8	2.66762e-17
C119	VPWR#3	VPWR#2	6.65047e-17
C120	a_459_74##8	a_459_74##7	1.99807e-18
C121	a_1350_368#	A1#11	3.28705e-17
C122	a_1350_368##5	A1#9	4.24515e-19
C123	VGND#3	VGND#6	1.85316e-17
C124	A2#10	A2#8	2.86252e-17
C125	A2#3	A1#7	1.47065e-17
C126	a_1350_368##3	VPWR#3	1.56324e-17
C127	VGND#3	VGND#5	7.9002e-17
C128	Y#7	C1#2	2.89612e-18
C129	VPWR#1	A1#12	5.15526e-19
C130	VPWR#7	A1#11	5.1392e-17
C131	a_459_74##3	A2#1	3.31769e-18
C132	a_1350_368##2	VPWR#3	5.77697e-18
C133	VGND#7	A3#9	2.99968e-18
C134	VGND#3	VGND#4	5.92889e-17
C135	Y#7	C1#8	4.96047e-19
C136	Y#7	VPWR#5	1.6661e-19
C137	VGND#3	VGND#2	1.35924e-16
C138	a_1350_368#	A1#12	5.00453e-19
C139	a_1350_368##5	A1#11	8.28926e-19
C140	a_459_74##2	A2#1	5.96347e-19
C141	Y#3	a_27_74##6	3.4308e-17
C142	a_459_74##3	a_459_74##2	2.88426e-18
C143	VPWR#7	A1#12	4.44892e-17
C144	VPWR#1	A1#13	7.64883e-19
C145	A2#12	A2#10	3.91617e-17
C146	VGND#8	A3#12	1.21411e-18
C147	A1#12	a_1350_368##5	2.34866e-17
C148	a_1350_368#	A1#13	2.12974e-19
C149	a_459_74##3	A2#8	1.57344e-17
C150	Y#7	C1#9	3.57571e-19
C151	VPWR#3	a_459_74##3	3.96202e-18
C152	a_27_74##8	a_27_74##4	9.60049e-19
C153	VPWR#7	A1#13	2.35616e-18
C154	VPWR#8	A1#12	1.9428e-18
C155	A2#16	A1#8	6.86288e-20
C156	VPWR#3	a_459_74##2	4.68654e-18
C157	a_459_74##2	A2#8	5.07995e-20
C158	A1#13	a_1350_368##5	2.8462e-17
C159	A3#1	A2#12	2.04002e-17
C160	a_459_74##4	a_1350_368##4	8.80134e-20
C161	a_459_74##7	a_459_74##10	4.74685e-21
C162	VGND#8	VGND#7	2.35227e-19
C163	a_459_74##2	A1#7	1.48319e-17
C164	a_841_368##3	VPWR#3	5.01155e-17
C165	VPWR#8	A1#13	6.85963e-17
C166	a_27_74##6	Y#5	3.98415e-17
C167	A3#4	Y#1	9.6852e-19
C168	a_459_74##3	A2#10	6.9582e-20
C169	a_841_368##2	VPWR#3	9.4438e-17
C170	a_459_74##6	A2#12	5.60412e-19
C171	VPWR#5	C1#4	2.45591e-19
C172	a_841_368#	A1#13	1.34557e-18
C173	a_1350_368##5	A2#7	3.45599e-19
C174	VGND#3	a_459_74##3	4.67817e-18
C175	VPWR#3	A2#16	2.93983e-18
C176	a_459_74##4	a_841_368##7	1.37054e-18
C177	VGND#3	a_459_74##2	5.13269e-18
C178	A3#7	A3#1	3.94061e-17
C179	VPWR#8	A2#7	2.19806e-18
C180	a_459_74##7	A3#11	1.02951e-18
C181	a_841_368#	A2#7	7.09316e-17
C182	a_1350_368##5	A2#9	1.00683e-19
C183	a_459_74##3	A2#12	3.19292e-20
C184	A3#10	a_841_368##8	2.19539e-18
C185	A3#2	Y#1	2.33907e-19
C186	A2#7	a_1350_368##6	1.13653e-17
C187	VPWR#8	A2#9	1.87397e-19
C188	a_459_74##6	A3#1	3.21881e-17
C189	VGND#3	A2#16	2.55783e-18
C190	a_27_74##8	Y#5	4.30322e-17
C191	A3#9	A3#7	2.06747e-17
C192	a_841_368##6	A2#7	1.19177e-18
C193	a_841_368#	A2#9	1.59737e-18
C194	C1#10	C1#9	2.26154e-18
C195	a_459_74##7	A3#7	5.42406e-19
C196	A2#9	a_1350_368##6	2.32645e-17
C197	a_459_74##2	A1#5	2.93494e-18
C198	VPWR#8	A2#11	6.50879e-20
C199	a_459_74##7	A3#10	1.4732e-18
C200	VGND#7	VGND#6	1.5842e-19
C201	A2#9	a_841_368##6	2.86449e-17
C202	a_841_368#	A2#11	3.57922e-19
C203	B1#1	A3#11	5.52999e-18
C204	VGND#6	A2#4	6.17798e-21
C205	a_459_74##6	A3#7	2.98112e-17
C206	A3#12	A3#9	4.03952e-17
C207	VGND#5	A2#4	5.25128e-20
C208	a_1350_368##4	A2#9	1.05835e-18
C209	VPWR#8	A2#6	4.40717e-20
C210	VPWR#2	VPWR#1	9.86498e-19
C211	a_459_74##3	A2#16	3.98282e-17
C212	a_841_368##7	A2#9	3.34595e-19
C213	A2#11	a_841_368##6	3.26268e-17
C214	B1#6	B1#4	1.97476e-18
C215	a_459_74##2	A1#3	8.08476e-19
C216	a_459_74##7	A3#9	3.16554e-17
C217	a_459_74##7	A3#4	7.89343e-20
C218	a_1350_368##4	A2#11	6.55911e-17
C219	a_459_74##3	A2#5	6.48257e-20
C220	B1#1	A3#12	2.51975e-18
C221	a_1350_368##3	A2#4	1.35893e-18
C222	a_459_74##6	A3#9	5.56888e-19
C223	a_841_368##7	A2#11	2.00122e-18
C224	a_841_368##6	A2#6	7.23601e-19
C225	C1#10	VPWR#6	3.11731e-17
C226	A2#6	a_1350_368##4	2.29338e-17
C227	a_1350_368#	VPWR#2	1.52926e-17
C228	a_459_74##7	A3#12	2.49598e-17
C229	a_841_368##7	A2#6	4.47269e-17
C230	B1#8	B1#1	3.8351e-17
C231	a_1350_368#	VPWR#1	8.50142e-17
C232	a_841_368##5	A3#11	1.17323e-19
C233	A3#14	A3#10	1.12091e-18
C234	a_459_74##3	A2#3	3.46581e-17
C235	a_1350_368##4	A3#6	8.83112e-19
C236	a_459_74#	VGND#1	6.52808e-17
C237	VGND#6	VGND#5	1.91578e-19
C238	a_459_74##3	A2#4	6.82935e-19
C239	VGND#3	VGND#1	6.17819e-17
C240	Y#3	B1#7	3.2327e-18
C241	a_841_368##7	A3#6	3.89695e-17
C242	VGND#3	a_459_74#	1.69233e-17
C243	VPWR#7	VPWR#1	1.56532e-18
C244	a_459_74##6	A3#4	1.0398e-18
C245	VGND#1	A1#1	4.56845e-17
C246	B1#9	B1#8	4.0236e-17
C247	A3#6	Y#1	1.82628e-17
C248	a_1350_368##4	A3#8	1.9719e-19
C249	A2#4	a_841_368##3	1.83457e-18
C250	a_459_74##7	B1#1	7.74803e-19
C251	VGND#3	a_459_74##11	2.89205e-17
C252	a_841_368##2	A2#4	2.74702e-20
C253	a_841_368##8	A3#6	8.84438e-19
C254	a_1350_368##2	a_1350_368#	2.60616e-19
C255	a_841_368##7	A3#8	1.64504e-18
C256	A2#16	A2#4	6.8925e-18
C257	A3	A2#5	2.07363e-18
C258	a_459_74#	A1#1	1.57192e-17
C259	VGND#1	A1#3	8.83372e-20
C260	a_1350_368#	VPWR#7	6.60918e-17
C261	VGND#3	a_459_74##12	1.27196e-17
C262	A3#8	Y#1	2.2354e-17
C263	A3	A3#10	6.35405e-19
C264	B1#10	B1#9	4.0236e-17
C265	VGND#1	A1#10	3.49495e-18
C266	A3	A3#4	1.93669e-17
C267	A3#8	a_841_368##8	2.8701e-17
C268	a_841_368##7	A3#13	2.83934e-19
C269	VGND#3	a_459_74##4	1.72281e-17
C270	VPWR#9	A3#11	2.89568e-20
C271	A3	A3#2	1.2675e-17
C272	a_459_74##2	A2#3	7.67682e-19
C273	VPWR#9	A3#6	4.4526e-18
C274	a_1350_368##5	VPWR#2	6.68878e-18
C275	a_459_74#	VGND#10	1.09905e-18
C276	VGND#3	VGND#13	4.12813e-18
C277	a_459_74##7	B1#8	7.99507e-20
C278	a_1350_368##5	a_1350_368#	2.36923e-18
C279	VPWR#1	VPWR#8	1.24645e-20
C280	a_459_74#	A1#10	5.5131e-17
C281	a_1350_368##2	VPWR#7	2.2409e-17
C282	C1#3	VPWR#5	1.39287e-19
C283	a_841_368##5	A3#8	3.33426e-19
C284	A3#13	a_841_368##8	3.18557e-17
C285	C1#4	B1#6	9.29496e-19
C286	a_459_74#	A1#5	4.70978e-18
C287	C1#1	B1#10	4.11821e-17
C288	VPWR#9	A3#10	5.89841e-20
C289	VGND#1	A1#14	1.28264e-19
C290	VPWR#9	A3#8	4.51844e-18
C291	A3#13	Y#9	2.5626e-17
C292	VGND#5	VGND#4	1.02551e-18
C293	a_1350_368##3	a_1350_368##5	1.18692e-18
C294	A1#10	VGND#10	1.04584e-17
C295	a_1350_368##5	VPWR#7	5.76665e-17
C296	a_841_368##5	A3#13	1.54142e-18
C297	a_459_74##11	a_459_74#	1.29386e-18
C298	a_459_74##6	A3#2	5.17351e-19
C299	a_841_368##8	A3#14	1.37245e-18
C300	VPWR#9	A3#4	3.91938e-20
C301	A3#5	Y#6	7.16806e-17
C302	a_459_74#	A1#14	4.02576e-19
C303	VPWR#9	A3#13	4.61914e-18
C304	a_459_74##7	B1#9	4.83947e-20
C305	A3#14	Y#9	9.54017e-18
C306	A2#16	A1#7	2.32778e-18
C307	a_459_74#	A1#3	8.85045e-18
C308	a_459_74##11	A1#10	3.51088e-19
C309	C1#6	C1#1	3.69278e-17
C310	a_1350_368##2	a_1350_368##5	3.55085e-18
C311	B1	A3#11	7.79818e-18
C312	A3#5	Y#2	1.09326e-17
C313	VPWR#8	VPWR#7	2.06267e-18
C314	B1	A3#10	8.98907e-20
C315	a_841_368##5	A3#14	6.09509e-17
C316	B1	A3#4	3.33075e-20
C317	A1#14	VGND#10	2.40179e-17
C318	a_27_74##2	B1#4	3.29662e-19
C319	VPWR#9	A3#14	1.01308e-17
C320	B1	B1#6	1.71609e-17
C321	Y#7	B1#3	9.46817e-18
C322	a_459_74##10	B1#6	2.379e-19
C323	a_459_74#	A1#8	1.10942e-19
C324	B1	B1#4	1.45294e-17
C325	Y#6	B1#3	5.37232e-19
C326	a_841_368##5	B1#11	1.07702e-18
C327	C1#7	C1#6	3.69247e-17
C328	VPWR#8	a_1350_368##5	5.76466e-17
C329	A1#14	a_459_74##11	1.25932e-17
C330	B1	C1#4	2.82746e-18
C331	VPWR#9	A3#2	9.69029e-21
C332	VPWR#3	VPWR#1	5.36977e-17
C333	a_459_74##7	B1#10	3.36871e-20
C334	B1#11	VPWR#9	4.45436e-17
C335	VPWR#3	a_1350_368#	1.66256e-17
C336	a_1350_368##2	VPWR#8	3.42805e-17
C337	Y#10	B1#11	5.46491e-17
C338	A1	A1#7	1.769e-17
C339	a_841_368##3	A2#5	1.17323e-19
C340	VGND#11	A1#14	6.16939e-19
C341	VPWR#3	VPWR#7	2.17698e-17
C342	A1	A1#5	2.23565e-17
C343	B1#6	VPWR#9	1.63248e-18
C344	A1	A1#3	3.30283e-17
C345	VGND#9	a_459_74##8	5.05053e-17
C346	VPWR#10	B1#11	1.46132e-18
C347	C1#5	C1#7	3.57683e-17
C348	a_1350_368##5	VPWR#3	2.10425e-17
C349	VPWR#9	B1#7	6.20722e-19
C350	VGND#3	VPWR#1	4.93889e-18
C351	a_1350_368##3	a_841_368#	9.08936e-17
C352	VGND#4	VGND#2	1.23004e-18
C353	a_459_74##11	A1#8	3.06676e-17
C354	VGND#12	A2#4	7.13556e-19
C355	A1	A2#3	1.4149e-18
C356	VPWR#3	VPWR#8	2.21662e-17
C357	Y#10	B1#7	4.65415e-17
C358	a_459_74##4	A2#4	4.83728e-17
C359	VGND#9	a_459_74##10	3.19171e-17
C360	a_841_368#	VPWR#3	7.18829e-17
C361	VGND#9	a_27_74##4	2.51268e-17
C362	B1#7	VPWR#10	2.67117e-17
C363	a_459_74##10	B1#4	2.34926e-19
C364	a_841_368#	VPWR#8	5.40367e-17
C365	VPWR#9	C1#8	2.6787e-19
C366	VGND#11	a_459_74##11	4.40666e-17
C367	VGND#11	A1#8	1.33485e-17
C368	Y#8	B1#7	4.80266e-19
C369	Y#10	C1#8	1.99468e-18
C370	C1#4	B1#7	7.56553e-18
C371	a_27_74##4	B1#6	1.26798e-18
C372	VGND#9	a_27_74##6	3.8377e-17
C373	a_459_74##11	A2#1	9.78347e-19
C374	a_841_368##4	A3#11	6.94551e-20
C375	VPWR#3	a_1350_368##4	1.03517e-17
C376	Y#6	a_841_368##4	1.74419e-17
C377	VPWR#10	C1#8	4.95653e-17
C378	B1#4	VPWR#9	3.60551e-18
C379	C1#2	B1#7	2.56967e-18
C380	a_1350_368##3	a_1350_368##6	2.39124e-18
C381	VGND#9	a_27_74##8	2.99946e-17
C382	Y#8	C1#8	7.98034e-17
C383	Y#10	C1#9	3.85766e-19
C384	VGND#11	A2#1	3.56116e-17
C385	VPWR#6	C1#8	2.88165e-18
C386	a_841_368##2	A2#5	4.59905e-20
C387	VPWR#10	C1#9	1.40445e-18
C388	a_459_74##3	A3#2	4.54695e-20
C389	Y#3	Y#7	2.36222e-17
C390	Y#6	B1#1	3.22339e-18
C391	C1#9	Y#8	2.4464e-17
C392	a_841_368#	a_1350_368##6	5.95906e-19
C393	VGND#2	VGND#1	3.33159e-18
C394	A2#1	a_459_74##12	1.25386e-17
C395	VPWR#6	C1#9	5.32486e-17
C396	A1#11	A1#9	4.66482e-17
C397	a_1350_368##3	a_841_368##6	6.06268e-17
C398	a_459_74##12	VGND#11	4.52298e-17
C399	VGND#11	A2#8	1.57501e-18
C400	VGND#12	A2#1	2.06227e-18
C401	a_841_368##6	a_841_368#	4.61754e-18
C402	C1#1	B1#6	8.03114e-18
C403	Y#3	B1#6	1.57307e-17
C404	a_841_368##2	A2#3	5.55496e-20
C405	A2#8	a_459_74##12	1.92873e-17
C406	A1#12	A1#11	4.65513e-17
C407	a_27_74#	B1#3	4.96579e-19
C408	a_459_74##4	A2#1	2.53059e-19
C409	a_459_74##8	B1#3	8.34137e-19
C410	VGND#2	a_459_74#	8.74367e-17
C411	a_841_368##4	A3#4	1.61446e-19
C412	Y#2	a_841_368##4	2.2731e-17
C413	a_27_74##2	B1#3	1.03906e-18
C414	VGND#12	VGND#11	1.53274e-18
C415	VGND#11	A2#10	1.74456e-19
C416	A2#8	VGND#12	1.78735e-17
C417	a_459_74##10	B1#3	2.5723e-19
C418	a_1350_368##4	a_1350_368##3	3.56354e-18
C419	A1#13	A1#12	4.85863e-17
C420	Y#3	B1#3	1.23294e-17
C421	a_459_74##12	A2#10	9.3552e-19
C422	a_459_74##4	A2#8	5.40294e-19
C423	VGND#8	a_459_74##7	8.14385e-18
C424	VGND#3	A1#1	4.02826e-18
C425	VGND#12	a_459_74##12	2.63647e-17
C426	A2#4	a_841_368##6	1.65494e-18
C427	Y#3	B1#4	7.09727e-18
C428	Y#3	Y#8	1.46975e-18
C429	Y#2	a_841_368##3	1.5816e-17
C430	VPWR#2	A1#9	3.14408e-18
C431	VGND#12	A2#10	3.15356e-17
C432	A2#7	A1#13	4.69435e-18
C433	A2#4	a_1350_368##4	5.13467e-17
C434	VPWR#3	A1#7	2.88038e-19
C435	VGND#2	VGND#10	1.44401e-17
C436	VGND#3	A1#14	1.12604e-18
C437	Y#3	C1#3	1.25526e-17
C438	a_1350_368##4	a_841_368##6	5.49477e-17
C439	A2#16	A2#3	1.999e-17
C440	a_459_74##12	A2#12	1.34248e-19
C441	VGND#3	A1#8	2.53934e-18
C442	a_27_74##4	C1#2	1.04005e-19
C443	a_459_74##4	A2#10	2.88468e-17
C444	Y#5	C1#3	4.75027e-17
C445	VPWR#3	A1#5	1.77417e-21
C446	A1#3	a_1350_368#	3.08438e-18
C447	VGND#3	A2#1	7.11414e-19
C448	VGND#2	A1#7	7.88011e-19
C449	a_27_74##8	C1#3	1.49883e-18
C450	A2#9	A2#7	4.39668e-17
C451	a_459_74##4	a_459_74##12	2.59979e-18
C452	a_1350_368##2	A1#9	4.66966e-20
C453	VGND#5	VGND#11	8.0469e-19
C454	VGND#7	a_459_74##7	6.86897e-18
C455	a_841_368##3	A3#4	1.13533e-19
C456	VGND#3	A2#8	8.10141e-19
C457	VGND#6	A2#5	1.13348e-20
C458	VGND#12	A2#12	1.24639e-18
C459	a_841_368##7	a_841_368##6	4.30643e-18
C460	VGND#13	A2#10	7.0693e-19
C461	VGND#3	A2#10	7.53586e-19
C462	C1#1	B1#7	1.5203e-17
C463	VPWR#2	A1#11	9.75077e-19
C464	Y#7	C1#1	2.33051e-18
C465	VPWR#3	A2#5	2.5319e-20
C466	VGND#3	A2#12	1.43947e-19
C467	a_459_74##11	VGND#2	4.03145e-17
C468	a_459_74##4	A2#12	5.35849e-17
C469	A2#11	A2#9	3.01094e-17
C470	VPWR#3	A2#3	6.26263e-20
C471	Y#3	C1#4	3.46222e-18
C472	Y	A2#5	1.18369e-17
C473	a_459_74##4	VGND#12	5.73103e-17
C474	a_841_368##7	a_1350_368##4	4.6824e-17
C475	Y	A2#3	1.56128e-19
C476	VGND#12	A3#1	1.3802e-19
C477	Y	A3#11	1.07293e-17
C478	A1#5	VPWR#7	1.26866e-18
C479	Y	A3#10	1.13272e-17
C480	Y	A3#4	1.02672e-17
C481	A2#12	VGND#13	2.3976e-17
C482	a_1350_368##2	A1#11	9.11819e-20
C483	VGND#8	A3#10	5.28522e-20
C484	VGND#5	a_459_74##12	2.41214e-18
C485	Y	A3#2	1.91583e-17
C486	A2#6	A2#11	3.70458e-17
C487	VGND#7	a_459_74##6	8.87529e-18
C488	VGND#3	A1#7	4.6195e-20
C489	A3	Y#2	6.19811e-17
C490	a_459_74##4	A3#1	1.98766e-18
C491	Y#3	C1#2	1.31278e-17
C492	VPWR#10	C1#2	1.41372e-18
C493	B1#3	VPWR#9	6.7471e-18
C494	A1#7	a_1350_368##5	2.46698e-19
C495	VPWR#2	A1#12	9.75077e-19
C496	VGND#2	A1	6.03142e-20
C497	a_27_74##8	VPWR#6	3.06501e-19
C498	VGND#13	VGND#12	1.66875e-18
C499	VGND#11	VGND#2	2.75601e-18
C500	A3#6	A2#6	4.57679e-17
C501	VGND#3	A1#3	3.86055e-19
C502	a_1350_368##3	A1#12	1.21766e-19
C503	A3#1	VGND#13	2.54573e-17
C504	A1	a_1350_368##2	7.28086e-17
C505	VGND#4	a_459_74##12	8.07092e-18
C506	VGND#14	A2#12	2.79777e-19
C507	B1	Y#7	1.03374e-16
C508	B1	Y#6	7.68625e-17
C509	a_841_368##3	A3#2	4.57837e-21
C510	VGND#2	A1#5	2.78865e-18
C511	a_1350_368##2	A1#12	1.32981e-17
C512	a_459_74##4	A3#7	4.3802e-19
C513	C1#10	C1#4	1.97085e-17
C514	VGND#6	a_459_74##6	8.82635e-18
C515	A3#1	a_459_74##13	1.44708e-17
C516	A1#14	A1#3	1.13216e-18
C517	VGND#9	B1#1	5.19454e-18
C518	A3#8	A3#6	2.25191e-17
C519	a_459_74##2	A1	4.72479e-17
C520	a_27_74##6	C1#4	1.0672e-18
C521	a_459_74##4	VGND#13	4.05976e-17
C522	VGND#3	A2#3	2.11949e-18
C523	C1#3	Y#8	6.01552e-17
C524	VGND#9	B1#8	5.17745e-18
C525	C1#4	Y#8	6.12108e-18
C526	VGND#6	a_459_74##4	6.97193e-18
C527	C1#3	VPWR#6	6.6843e-19
C528	VGND#13	A3#7	7.42681e-19
C529	a_841_368##8	a_841_368##7	3.71573e-18
C530	A1#8	A1#7	1.20644e-17
C531	A2#16	A1	5.02386e-18
C532	VGND#9	B1#9	5.17745e-18
C533	VGND#14	A3#1	7.39855e-19
C534	A1#5	a_1350_368##5	2.97865e-19
C535	VGND#9	B1#10	4.81967e-18
C536	A3#13	A3#8	3.43396e-17
C537	VGND#7	A3#10	1.69663e-20
C538	VPWR#3	A1#9	5.40152e-18
C539	a_1350_368##3	A1#13	4.02302e-19
C540	a_459_74##4	A3#9	2.74141e-19
C541	VGND#5	A2#3	3.00441e-20
C542	VGND#9	C1#1	5.3329e-18
C543	A3#7	a_459_74##13	1.44708e-17
C544	VPWR	C1#4	5.60229e-23
C545	a_27_74##6	C1#2	2.27956e-19
C546	Y#8	C1#2	6.92072e-19
C547	a_1350_368##2	VPWR#2	1.74291e-19
C548	VPWR#3	A1#11	5.21061e-19
C549	VGND#9	C1#6	5.30069e-18
C550	a_1350_368##2	A1#13	1.96833e-17
C551	VGND#2	A1#3	2.08509e-19
C552	VPWR#3	A1#12	5.70443e-19
C553	a_841_368##2	a_1350_368##6	2.12272e-19
C554	VPWR#8	A1#7	1.46518e-18
C555	VGND#5	a_459_74##4	7.46705e-18
C556	A3#14	A3#13	3.31335e-17
C557	VGND#9	C1#7	5.34859e-18
C558	VGND#13	A3#9	2.83819e-19
C559	A2#3	a_459_74##12	9.41564e-19
C560	A3#7	VGND#14	2.37278e-17
C561	VPWR#3	A1#13	1.49513e-18
C562	A3#5	B1#1	2.17072e-18
C563	VGND#9	C1#5	5.31202e-18
C564	VPWR#3	A2#7	6.46749e-18
C565	VGND#1	A1	4.415e-19
C566	a_459_74#	A1	5.28556e-17
C567	VPWR#3	A2#9	6.02832e-18
C568	A3#11	A3#10	1.97476e-18
C569	B1#3	B1#1	1.85741e-18
C570	a_1350_368##3	A2#7	3.29573e-17
C571	VPWR#5	VPWR#9	1.04687e-18
C572	VGND#7	A3#4	2.94706e-20
C573	A3#2	A2#5	2.42149e-17
C574	Y#5	C1#4	7.68994e-18
C575	VPWR#3	A2#11	6.08518e-18
C576	a_1350_368##3	a_1350_368##2	1.30561e-19
C577	C1#4	VPWR#6	3.85394e-18
C578	A3#9	VGND#14	2.50018e-17
C579	a_1350_368##2	A2#7	3.80159e-20
C580	a_841_368##2	a_841_368##6	2.49071e-18
C581	VPWR#3	A2#6	5.38583e-18
C582	B1#7	B1#11	4.53565e-17
C583	VGND#15	A3#7	3.3223e-19
C584	VGND#8	VGND#14	6.79543e-19
C585	Y#3	B1	1.54301e-16
C586	VGND#13	VGND#5	1.0596e-18
C587	VGND	B1#6	2.61738e-20
C588	a_841_368##3	a_1350_368##4	1.7299e-17
C589	A3#9	a_459_74##14	1.44952e-17
C590	VGND#14	VGND#13	2.46843e-18
C591	VGND	C1#4	8.16073e-20
C592	VGND	C1#2	1.45431e-18
C593	VGND#4	A2#3	1.17574e-19
C594	C1#8	B1#7	3.7915e-17
C595	a_841_368##5	a_841_368##8	4.30643e-18
C596	VGND#14	A3#12	1.19005e-18
C597	a_1350_368##3	A2#9	3.50905e-17
C598	Y#10	VPWR#5	8.49478e-18
C599	VGND#15	A3#9	2.08708e-18
C600	VGND#12	A2#3	3.62889e-19
C601	a_459_74##7	Y	1.17195e-16
C602	a_459_74##6	Y	8.14566e-17
C603	C1#9	C1#8	2.04634e-17
C604	a_841_368##2	a_1350_368##4	1.73096e-17
C605	Y	a_459_74##3	8.97357e-19
C606	a_1350_368##2	A2#9	1.10751e-20
C607	a_1350_368##3	A1#7	4.87517e-18
C608	A3#12	a_459_74##14	6.8043e-18
C609	a_841_368##5	Y#9	6.52246e-19
C610	A1	a_1350_368#	4.23641e-17
C611	VGND#5	a_459_74##3	8.48234e-19
C612	A2#3	A1#8	1.49119e-17
C613	A1#7	A1#12	2.31942e-19
C614	A2#4	A2#11	2.07318e-18
C615	a_841_368##3	a_841_368##7	4.35239e-20
C616	a_27_74##8	C1#4	9.90692e-18
C617	A2#4	A2#6	1.44469e-18
C618	VPWR#2	A1#5	2.01982e-20
C619	Y#6	Y#2	2.58652e-18
C620	Y	Y#6	8.59668e-18
C621	VGND#15	A3#12	3.97462e-17
C622	A2#16	a_1350_368##4	5.69536e-18
C623	Y	Y#2	2.31588e-18
C624	a_459_74##8	A3#9	3.32038e-19
C625	VPWR	VPWR#5	7.04026e-17
C626	a_841_368##4	Y#1	8.71985e-19
C627	a_1350_368##3	A2#11	1.15441e-18
C628	a_459_74##4	A2#5	3.1345e-18
C629	VGND#7	A3#2	6.2655e-21
C630	a_27_74#	A3#12	3.03042e-19
C631	VPWR	a_841_368##4	2.89358e-17
C632	VPWR	a_841_368##3	2.16576e-17
C633	A3#5	A3#13	2.03399e-18
C634	VGND#4	a_459_74##3	1.89457e-19
C635	VGND#15	B1#1	1.7972e-18
C636	VPWR#9	a_841_368##5	9.90301e-17
C637	A3#5	A3#14	8.59121e-19
C638	a_841_368##3	Y#1	1.21028e-18
C639	a_459_74##4	Y	1.57079e-17
C640	a_459_74##8	A3#12	1.58286e-18
C641	VPWR	Y#7	7.95797e-18
C642	VPWR	Y#6	1.87807e-17
C643	VPWR#2	A1#3	4.13675e-20
C644	VPWR	Y#2	1.27764e-17
C645	Y	VGND#14	3.80074e-19
C646	VGND	VGND#8	6.45921e-17
C647	VGND	VGND#7	5.33565e-17
C648	VGND	VGND#6	3.51775e-17
C649	Y	VGND#15	1.73445e-19
C650	a_27_74#	B1#1	4.00299e-17
C651	A1	A1#8	5.84059e-19
C652	a_841_368##4	a_841_368##8	2.17687e-18
C653	VPWR	C1#10	2.73572e-18
C654	VGND#9	B1#6	9.76235e-20
C655	a_1350_368##2	A1#7	8.11167e-18
C656	a_27_74##8	C1#10	3.07408e-17
C657	VGND	a_459_74##7	2.06479e-17
C658	Y#8	VPWR#5	1.85886e-17
C659	B1	B1#1	1.57459e-17
C660	VGND	a_459_74##6	2.08466e-17
C661	VGND#15	B1#8	3.10497e-19
C662	VPWR#3	A2#4	5.10323e-18
C663	C1#3	B1#7	5.97157e-18
C664	A3#10	A3#4	1.35723e-18
C665	a_459_74##8	B1#1	3.96618e-17
C666	VGND#3	A2#4	3.26378e-18
C667	VGND#9	B1#4	2.91364e-20
C668	C1#3	C1#8	4.21035e-18
C669	VGND#4	a_459_74##2	2.45433e-19
C670	VGND	Y#7	3.88593e-18
C671	Y	a_841_368#	1.37405e-21
C672	A2#16	A2#7	8.0335e-19
C673	VGND	Y#6	3.20943e-18
C674	C1#3	C1#9	4.06621e-18
C675	Y#10	VPWR#9	7.93273e-17
C676	VGND#15	VGND#14	2.00719e-18
C677	A1#7	VNB	5.44284e-17
C678	Y	a_1350_368##4	2.16456e-17
C679	A1#5	VNB	4.21116e-17
C680	A1#3	VNB	7.73102e-17
C681	Y	a_841_368##7	3.05738e-17
C682	A2#5	VNB	2.85428e-17
C683	A2#3	VNB	5.31731e-17
C684	VGND#13	A2#5	6.57141e-19
C685	VGND#9	C1#4	6.05003e-19
C686	A3#11	VNB	3.96737e-17
C687	A3#10	VNB	3.58544e-17
C688	A3#4	VNB	3.19172e-17
C689	VGND#6	A3#2	3.53553e-20
C690	A3#2	VNB	2.35745e-17
C691	B1#6	VNB	4.22178e-17
C692	VGND	C1#10	2.271e-18
C693	B1#4	VNB	1.99491e-17
C694	C1#4	VNB	9.50262e-17
C695	a_841_368##4	Y#9	2.42895e-19
C696	VGND#9	C1#2	9.98401e-20
C697	C1#2	VNB	6.10027e-18
C698	VGND#15	B1#9	2.03306e-19
C699	a_459_74##8	B1#8	3.38719e-17
C700	VGND#9	B1#3	1.35724e-19
C701	VPWR#10	VPWR#9	2.32146e-18
C702	VGND	a_459_74##4	1.61189e-18
C703	A3	A2#6	1.94354e-19
C704	VGND	VGND#13	1.63634e-17
C705	A1	A1#9	2.4726e-18
C706	VPWR#6	VPWR#5	7.52387e-19
C707	a_841_368##2	A2#9	1.59073e-17
C708	VGND	VGND#14	1.98671e-17
C709	A3	A3#6	1.52572e-18
C710	A1	A1#11	2.10162e-18
C711	VGND	VGND#15	1.5807e-17
C712	VGND	a_27_74#	6.51703e-18
C713	A3	A3#8	2.1287e-18
C714	VGND	a_459_74##8	4.20151e-17
C715	A1	A1#12	2.1032e-18
C716	VGND	a_27_74##2	8.05918e-18
C717	VGND	a_459_74##10	1.84423e-17
C718	a_459_74##2	VGND#10	7.73237e-19
C719	a_27_74##2	B1#8	2.63441e-17
C720	VGND	a_27_74##4	2.10618e-17
C721	VPWR	a_841_368##5	2.52992e-17
C722	VGND	Y#3	2.11041e-17
C723	VGND#2	a_459_74##2	4.01229e-17
C724	A1	A2#7	8.24079e-19
C725	A2#16	A2#9	2.00772e-18
C726	VGND	a_27_74##6	2.35556e-17
C727	VPWR	VPWR#9	3.65287e-16
C728	a_27_74##4	B1#1	3.0173e-19
C729	VGND	Y#5	6.51324e-18
C730	Y	A2#12	2.20923e-18
C731	VPWR	Y#10	1.73186e-17
C732	A1	A2#9	1.83612e-19
C733	VGND	a_27_74##8	2.10466e-17
C734	VPWR	VPWR#10	2.1406e-17
C735	Y	A3#1	9.63044e-18
C736	B1	A3#8	1.40242e-19
C737	VGND#1	VPWR#1	1.3848e-17
C738	VPWR	Y#8	1.88265e-17
C739	Y	A3#7	8.3976e-18
C740	VPWR#10	Y#10	6.22435e-17
C741	VPWR	VPWR#6	7.44808e-17
C742	B1	A3#13	2.99636e-19
C743	Y	A3#9	8.39534e-18
C744	a_841_368#	A2#3	1.09988e-19
C745	Y	A3#12	9.72854e-18
C746	a_459_74##8	B1#9	1.63496e-19
C747	B1	A3#14	2.86194e-18
C748	VGND#2	A1#1	1.24765e-18
C749	VGND#8	a_459_74##8	1.73638e-17
C750	Y#3	B1#1	1.57927e-17
C751	VGND#8	VNB	3.57004e-17
C752	B1	C1#8	2.30305e-19
C753	VGND#7	VNB	2.8914e-17
C754	VGND#6	VNB	2.91746e-17
C755	VGND#5	VNB	2.99481e-17
C756	VGND#4	VNB	2.13022e-17
C757	VGND#2	VNB	4.7051e-17
C758	VPWR#5	VNB	3.67351e-17
C759	VPWR#2	VNB	3.40648e-17
C760	a_1350_368##3	VNB	3.76087e-18
C761	a_1350_368##2	VNB	2.34666e-18
C762	a_27_74##2	B1#9	2.62455e-17
C763	A2#4	A2#5	1.89609e-17
C764	a_1350_368##2	A1#5	3.21446e-18
C765	a_841_368##2	A2#11	1.62556e-17
C766	a_459_74##7	VNB	9.55907e-18
C767	Y#8	Y#10	2.85825e-18
C768	a_459_74##6	VNB	1.93071e-18
C769	a_27_74##4	B1#8	3.18991e-19
C770	a_459_74##3	VNB	2.47134e-18
C771	a_459_74##2	VNB	3.02765e-18
C772	a_841_368##4	VNB	5.33743e-18
C773	a_841_368##3	VNB	5.89472e-18
C774	a_841_368##2	VNB	4.75162e-18
C775	A2#4	A2#3	3.41634e-18
C776	A2#16	VNB	5.35989e-18
C777	Y#7	VNB	2.47005e-18
C778	Y#6	VNB	1.04372e-17
C779	Y	A2#7	3.80045e-19
C780	a_459_74##2	a_459_74##11	4.59562e-19
C781	VPWR#3	A1	8.6492e-18
C782	Y	A2#9	5.57648e-19
C783	a_459_74##8	B1#10	1.13808e-19
C784	VGND	A3#1	1.9668e-19
C785	VGND	A3#7	2.05709e-19
C786	Y	A2#11	1.48019e-18
C787	VGND#3	A1	9.36412e-18
C788	a_459_74##10	B1#9	3.31193e-17
C789	VGND	A3#9	8.7724e-20
C790	C1#10	VNB	2.6394e-17
C791	Y	A2#6	6.92059e-18
C792	VGND#1	VNB	6.90457e-17
C793	VGND	A3#12	5.14147e-19
C794	a_459_74#	VNB	3.00914e-18
C795	VGND	B1#1	1.63023e-18
C796	Y	A3#6	2.40353e-18
C797	a_459_74##3	VGND#11	3.38e-17
C798	a_459_74##11	VNB	2.18125e-18
C799	Y#3	B1#8	8.10003e-18
C800	VGND#11	VNB	1.77125e-18
C801	VGND	B1#8	9.34863e-19
C802	a_459_74##12	VNB	4.69493e-18
C803	Y	A3#8	4.95359e-19
C804	VGND#12	VNB	3.99568e-19
C805	VGND	B1#9	9.3389e-19
C806	a_459_74##4	VNB	2.63718e-18
C807	VGND#13	VNB	4.74841e-18
C808	VGND	B1#10	1.60984e-18
C809	Y	A3#13	8.70233e-20
C810	Y#8	VPWR#10	6.93873e-17
C811	B1	A3#5	1.78704e-17
C812	VGND#14	VNB	4.66689e-18
C813	VGND	C1#1	7.62464e-19
C814	VGND#15	VNB	3.79225e-18
C815	VGND	C1#6	2.1149e-18
C816	a_27_74#	VNB	1.76314e-18
C817	a_459_74##8	VNB	1.73502e-17
C818	VGND	C1#7	7.84484e-19
C819	B1	B1#3	2.58734e-17
C820	a_459_74##10	VNB	3.00172e-18
C821	VGND	C1#5	1.68657e-18
C822	VPWR	A2#6	7.1621e-19
C823	a_27_74##4	VNB	3.22475e-18
C824	Y#3	VNB	8.24202e-18
C825	VGND#2	A1#10	1.71258e-17
C826	a_841_368##3	A2#6	2.75373e-17
C827	a_27_74##6	VNB	4.19995e-18
C828	VPWR	A3#6	1.59032e-18
C829	C1#3	B1	1.10141e-17
C830	a_27_74##8	VNB	4.19989e-17
C831	a_841_368##4	VPWR#9	7.31635e-17
C832	VPWR	A3#8	1.65988e-18
C833	VPWR#1	VNB	8.12622e-17
C834	Y#2	a_1350_368##4	2.22149e-18
C835	a_27_74##4	B1#9	5.79884e-19
C836	a_1350_368#	VNB	2.79804e-18
C837	VPWR#7	VNB	2.33043e-19
C838	VPWR	A3#13	1.58629e-18
C839	a_1350_368##5	VNB	4.8673e-18
C840	VPWR#8	VNB	7.98072e-18
C841	VPWR	A3#14	2.05937e-18
C842	a_841_368#	VNB	1.22691e-17
C843	VPWR	B1#7	1.75358e-19
C844	VPWR	C1#8	4.91139e-19
C845	a_841_368##5	VNB	1.2219e-17
C846	VPWR#9	VNB	1.58436e-16
C847	VPWR	C1#9	1.55097e-18
C848	Y#10	VNB	2.19475e-18
C849	VPWR#10	VNB	9.17471e-19
C850	Y#6	A3#11	4.2516e-18
C851	Y#8	VNB	5.58408e-18
C852	VPWR#6	VNB	7.672e-17
C853	A1#1	VNB	2.52433e-17
C854	VPWR	VPWR#3	1.63798e-17
C855	a_459_74##10	B1#10	2.62385e-17
C856	VPWR#6	VPWR#10	1.08172e-18
C857	A1#10	VNB	2.52304e-17
C858	A1#14	VNB	2.73021e-17
C859	A1#8	VNB	3.81573e-17
C860	Y	A2#4	4.71625e-17
C861	A2#1	VNB	2.31103e-17
C862	A2#8	VNB	2.60148e-17
C863	VGND	B1#7	9.96063e-19
C864	Y#3	B1#9	8.30198e-18
C865	A2#10	VNB	2.57691e-17
C866	Y	A3#5	8.67364e-17
C867	A2#12	VNB	2.85622e-17
C868	A3#1	VNB	2.73928e-17
C869	A3#7	VNB	2.86401e-17
C870	A3#9	VNB	2.8622e-17
C871	A3#12	VNB	3.01036e-17
C872	a_459_74##3	a_1350_368##3	2.11237e-17
C873	VGND#11	a_459_74##2	3.28417e-17
C874	B1#1	VNB	5.95965e-17
C875	B1#8	VNB	2.94288e-17
C876	B1#9	VNB	2.92148e-17
C877	VGND#4	A1#14	5.02535e-19
C878	a_841_368##3	VPWR#9	3.11896e-17
C879	B1#10	VNB	2.76018e-17
C880	VPWR	A3#5	3.37469e-18
C881	A1#7	A1#5	8.81379e-19
C882	C1#1	VNB	3.713e-17
C883	C1#6	VNB	2.67034e-17
C884	C1#7	VNB	2.69503e-17
C885	C1#5	VNB	3.30493e-17
C886	VGND	VGND#9	2.29932e-16
C887	VPWR	C1#3	8.05843e-18
C888	A1#9	VNB	3.9043e-17
C889	A1#11	VNB	2.71109e-17
C890	a_459_74##8	VGND#15	2.78204e-17
C891	A1#12	VNB	2.79815e-17
C892	A1#13	VNB	2.86978e-17
C893	a_459_74##3	a_459_74##12	2.42192e-18
C894	a_27_74##4	B1#10	2.46384e-17
C895	A2#7	VNB	3.64432e-17
C896	VGND	A3#5	4.46622e-18
C897	A2#9	VNB	3.18603e-17
C898	A2#11	VNB	3.16819e-17
C899	A2#10	A2#3	2.34566e-18
C900	A2#6	VNB	3.36885e-17
C901	A3#6	VNB	3.38071e-17
C902	VGND	C1#3	5.01544e-18
C903	A3#8	VNB	3.22915e-17
C904	Y	A3	9.55166e-17
C905	A3#13	VNB	3.36384e-17
C906	A3#14	VNB	4.09153e-17
C907	VPWR#6	Y#8	5.68709e-17
C908	B1#11	VNB	3.16775e-17
C909	Y	B1	1.94357e-17
C910	B1#7	VNB	3.95283e-17
C911	C1#8	VNB	3.00495e-17
C912	VPWR	A3	2.95732e-18
C913	C1#9	VNB	4.41224e-17
C914	Y#2	a_841_368##7	3.21773e-17
C915	VPWR#3	VNB	3.119e-16
C916	VPWR	B1	8.20508e-18
C917	a_841_368##3	A3#6	2.35989e-17
C918	VGND#3	VNB	2.10612e-16
C919	A2#3	A2#7	1.04355e-18
C920	VGND#9	VNB	1.30923e-16
C921	VGND	A3	3.68773e-18
C922	A2#4	VNB	4.03646e-17
C923	VGND	B1	1.00516e-17
C924	A3#5	VNB	5.33046e-18
C925	VGND#2	A1#14	2.41412e-17
C926	a_459_74##10	C1#1	1.44972e-18
C927	B1#3	VNB	4.15681e-17
C928	C1#3	VNB	3.2471e-18
C929	VPWR	Y	3.35092e-18
C930	Y#3	B1#10	9.1884e-18
C931	VGND	Y	1.66438e-17
C932	A3	VNB	4.44398e-18
C933	a_459_74##6	a_459_74##4	2.47176e-18
C934	B1	VNB	2.72153e-17
C935	A1	VNB	3.45018e-17
C936	Y#6	A3#10	2.36156e-18
C937	Y	VNB	1.45241e-17
C938	VPWR	VNB	2.95521e-16
C939	VGND	VNB	3.10925e-16
*
*
.ENDS sky130_fd_sc_hs__o311ai_4
*
