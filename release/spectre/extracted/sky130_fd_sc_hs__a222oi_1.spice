* Extracted by Quantus, converted by sky130cad/quantus.py
*
*
*
*                       LINUX           Wed Nov 18 08:08:25 2026
*
*
*
*  PROGRAM  advgen
*
*  Name           : advgen - Quantus - (64-bit)
*  Version        : 25.1.0-p047
*  Build Date     : Thu Dec 11 23:20:30 PST 2025
*
*  HSPICE LIBRARY
*
*  OPERATING_TEMPERATURE 150
*  QRC_TECH_DIR <path>/tech
*
*
*

*
.SUBCKT sky130_fd_sc_hs__a222oi_1 VPB VNB VGND VPWR Y C1 C2 B2 B1 A1 A2
*
*
*  caps2d version: 10
*
*
*       TRANSISTOR CARDS
*
*
XM6 Y#4 C1#1 a_119_74# VNB sky130_fd_pr__nfet_01v8_lvt l=0.15 w=0.64 ad=0.1824 as=0.1536 pd=1.85 ps=1.76
XM5 a_119_74# C2#3 VGND#3 VNB sky130_fd_pr__nfet_01v8_lvt l=0.15 w=0.64 ad=0.1536 as=0.7488 pd=1.76 ps=3.62
XM3 VGND#3 B2#1 a_461_74# VNB sky130_fd_pr__nfet_01v8_lvt l=0.15 w=0.64 ad=0.7488 as=0.1536 pd=3.62 ps=1.76
XM10 a_461_74# B1#3 Y#1 VNB sky130_fd_pr__nfet_01v8_lvt l=0.15 w=0.64 ad=0.1536 as=0.4096 pd=1.76 ps=2.56
XM2 Y#1 A1#1 a_697_74# VNB sky130_fd_pr__nfet_01v8_lvt l=0.15 w=0.64 ad=0.4096 as=0.1536 pd=2.56 ps=1.76
XM1 a_697_74# A2#3 VGND#1 VNB sky130_fd_pr__nfet_01v8_lvt l=0.15 w=0.64 ad=0.1536 as=0.1824 pd=1.76 ps=1.85
XM7 Y#3 C1#3 a_116_392##2 VPB sky130_fd_pr__pfet_01v8 l=0.15 w=1 ad=0.295 as=0.35 pd=2.59 ps=2.7
XM8 a_116_392##2 C2#1 Y#5 VPB sky130_fd_pr__pfet_01v8 l=0.15 w=1 ad=0.35 as=0.345 pd=2.7 ps=2.69
XM11 a_369_392##3 B2#3 a_116_392# VPB sky130_fd_pr__pfet_01v8 l=0.15 w=1 ad=0.295 as=0.35 pd=2.59 ps=2.7
XM0 a_116_392# B1#1 a_369_392##4 VPB sky130_fd_pr__pfet_01v8 l=0.15 w=1 ad=0.35 as=0.35 pd=2.7 ps=2.7
XM4 a_369_392##4 A1#3 VPWR#4 VPB sky130_fd_pr__pfet_01v8 l=0.15 w=1 ad=0.35 as=0.45 pd=2.7 ps=2.9
XM9 VPWR#4 A2#4 a_369_392# VPB sky130_fd_pr__pfet_01v8 l=0.15 w=1 ad=0.45 as=0.295 pd=2.9 ps=2.59
*
*
*       RESISTOR AND CAP/DIODE CARDS
*
Rg1	C1#1	C1#2	279.244598
Rg2	C1#2	C1#3	553.333191
Rg3	C2#1	C2#2	417.342407
Rg4	C2#2	C2#3	403.031647
Rg5	B2#1	B2#2	337.550110
Rg6	B2#2	B2#3	454.474365
Rg7	B1#1	B1#2	444.448761
Rg8	B1#2	B1#3	390.954865
Rg9	A1#1	A1#2	367.233398
Rg10	A1#2	A1#3	472.559082
Rg11	A2#1	A2#2	188.877731
Rg12	A2#2	A2#3	328.692291
Rg13	A2#2	A2#4	542.247742
Rf1	C1#2	C1	164.010803
Rf2	C2	C2#4	8.267126
Rf3	C2#4	C2	6.298763
Rf4	B2	B2#4	8.267126
Rf5	B2#4	B2	6.298763
Rf6	a_116_392#	a_116_392##2	153.950043
Rf7	B1	B1#4	7.816602
Rf8	B1#4	B1	5.955506
Rf9	Y#1	Y	84.377365
Rf10	Y	Y#2	23.096361
Rf11	Y#2	Y#3	81.294151
Rf12	Y	Y#4	109.913582
Rf13	Y#2	Y#5	15.494309
Rf14	A1#4	A1	2.783787
Rf15	A1#2	A1#6	82.900192
Rf16	A1#4	A1#6	3.787991
Rf17	A1#7	A1	2.783787
Rf18	A1#6	A1#7	4.971738
Rf19	a_369_392#	a_369_392##2	91.427628
Rf20	a_369_392##2	a_369_392##3	85.893112
Rf21	a_369_392##2	a_369_392##4	18.405569
Rf22	A2	A2#1	12.597526
Rf23	A2#1	A2	1.968364
Rf24	VGND#1	VGND#2	162.993301
Rf25	VGND#2	VGND#4	11.480999
Rf27	VGND#3	VGND#4	5.000000
Rf29	VPWR#2	VPWR#3	97.132629
Rf30	VPWR#2	VPWR#4	31.337896
Rf32	C2#2	C2#4	80.116402
Rf33	B2#2	B2#4	80.116402
Rf34	B1#2	B1#4	80.116402
Re1	VPWR#3	VPWR	1.091357
Re2	VGND	VGND#2	1.091398
*
*       CAPACITOR CARDS
*
*
C1	VGND	VNB	6.77795e-17
C2	VPWR	VNB	7.89053e-17
C3	Y	VNB	2.47857e-17
C4	C1	VNB	3.6294e-17
C5	VGND	Y	1.38328e-17
C6	B2	VNB	1.64383e-18
C7	a_369_392##4	VPWR#4	6.13703e-17
C8	B1	VNB	4.51404e-19
C9	VGND	C1	3.61921e-18
C10	VPWR	Y	2.08672e-18
C11	A2	VNB	2.62502e-17
C12	VPWR	C1	2.08372e-18
C13	VGND	B2	3.2158e-18
C14	VGND	B1	3.51105e-18
C15	VPWR	B2	2.65057e-18
C16	VGND	A2	2.93808e-18
C17	C1#2	VNB	4.73676e-17
C18	VPWR	B1	2.84101e-18
C19	C2#2	VNB	6.61159e-17
C20	B2#2	VNB	3.99289e-17
C21	Y	B2	8.19828e-17
C22	B1#2	VNB	4.58087e-17
C23	A1#2	VNB	5.33453e-17
C24	VPWR	A2	3.94733e-18
C25	VGND#2	VNB	1.85183e-16
C26	VPWR#3	VNB	2.81354e-16
C27	VGND#1	A2#3	4.29718e-17
C28	C1#3	VNB	4.9253e-17
C29	VGND	C1#2	1.82698e-18
C30	C2#1	VNB	3.34022e-17
C31	VGND	C2#2	3.55073e-18
C32	B2#3	VNB	3.57604e-17
C33	B1#1	VNB	2.94877e-17
C34	A1#3	VNB	3.02762e-17
C35	a_369_392##4	a_369_392#	1.99295e-18
C36	A2#4	VNB	4.78007e-17
C37	VGND	A1#2	9.8956e-18
C38	C1#1	VNB	2.90211e-17
C39	C2#3	VNB	2.27022e-17
C40	B2#1	VNB	2.83671e-17
C41	B2	B1	4.60865e-17
C42	VPWR	C1#2	1.56742e-18
C43	B1#3	VNB	2.64243e-17
C44	A1#1	VNB	2.33292e-17
C45	VPWR	C2#2	2.67108e-18
C46	A2#3	VNB	2.23344e-17
C47	Y#3	VNB	5.23364e-17
C48	a_116_392##2	VNB	8.43547e-18
C49	a_369_392##3	VNB	8.19272e-18
C50	a_116_392#	VNB	8.22876e-18
C51	a_369_392##4	VNB	2.77485e-18
C52	Y	C1#2	3.37888e-19
C53	VPWR#4	VNB	4.36832e-18
C54	a_369_392#	VNB	4.96881e-17
C55	Y	C2#2	1.07087e-16
C56	Y#4	VNB	3.31926e-17
C57	VGND#3	VNB	9.02667e-17
C58	VPWR	VPWR#3	5.90224e-17
C59	Y	B2#2	1.10159e-17
C60	VGND	C1#1	1.12331e-18
C61	Y#1	VNB	5.22702e-18
C62	VGND	C2#3	5.38771e-19
C63	Y	B1#2	3.29776e-19
C64	C1	C1#2	1.32426e-17
C65	VPWR	C1#3	1.4568e-18
C66	VGND	B2#1	3.19981e-19
C67	VGND#1	VNB	7.67545e-17
C68	a_369_392#	VPWR#4	5.6212e-17
C69	VGND	B1#3	5.86379e-19
C70	VPWR	C2#1	1.64756e-18
C71	VGND	A1#1	1.19528e-18
C72	VPWR	B2#3	1.62252e-18
C73	VGND	A2#3	4.28507e-18
C74	Y#2	VNB	1.51475e-17
C75	VPWR	B1#1	2.53577e-18
C76	VPWR	A1#3	3.24894e-19
C77	A1#7	VNB	2.46062e-18
C78	VPWR	A2#4	9.56585e-19
C79	VGND	Y#4	2.211e-17
C80	VGND	VGND#3	1.20259e-16
C81	B2	C2#2	1.08232e-18
C82	VGND	Y#1	3.53017e-17
C83	VGND#1	A2#2	8.6972e-18
C84	B2	B2#2	2.5465e-17
C85	VPWR	Y#3	1.7752e-17
C86	VGND	VGND#1	5.59224e-17
C87	VPWR	a_116_392##2	3.13057e-17
C88	B2	B1#2	5.97434e-18
C89	Y	C1#1	2.87831e-19
C90	B1	C2#2	1.17609e-21
C91	VPWR	a_369_392##3	9.24148e-18
C92	Y	C2#3	8.40721e-18
C93	VPWR	a_116_392#	3.23308e-17
C94	Y	B2#1	1.53574e-17
C95	VPWR	a_369_392##4	1.60645e-17
C96	B1	B2#2	5.87951e-18
C97	Y#1	a_369_392##3	2.70763e-18
C98	VPWR	VPWR#4	2.24458e-17
C99	Y	B1#3	2.87028e-19
C100	VPWR	a_369_392#	1.73969e-17
C101	B1	B1#2	2.7893e-17
C102	Y	A1#1	1.25915e-19
C103	Y	A2#3	2.03697e-19
C104	B1	A1#2	3.24723e-17
C105	Y	a_369_392##3	2.70466e-18
C106	Y	a_116_392#	2.7302e-18
C107	VPWR	Y#2	1.43941e-17
C108	C1	Y#3	2.59286e-17
C109	A1#2	A2	3.6465e-17
C110	Y	VGND#3	1.12537e-16
C111	VPWR	A1#7	4.05789e-18
C112	VPWR	a_369_392##2	4.12224e-18
C113	B2	B2#1	3.49113e-18
C114	C1	Y#4	2.41465e-17
C115	Y	Y#2	1.90483e-18
C116	Y#3	Y#2	2.72737e-18
C117	A2#2	VNB	6.07959e-17
C118	B1	B2#1	1.04893e-18
C119	C1#2	C2#2	8.10299e-17
C120	B2	a_369_392##3	3.9633e-17
C121	VGND#3	Y#4	1.82179e-17
C122	A2	A2#4	1.85282e-18
C123	Y#2	a_116_392##2	1.14403e-16
C124	C2#2	B2#2	1.02821e-17
C125	B1	a_116_392#	3.27635e-19
C126	C2#2	B1#2	4.93556e-21
C127	B2	VGND#3	2.14142e-18
C128	B1	a_369_392##4	1.63178e-19
C129	C1#1	a_119_74#	1.26035e-17
C130	Y#1	B2	9.4026e-18
C131	C2#3	a_119_74#	1.20655e-17
C132	B2#2	B1#2	3.55607e-17
C133	Y#2	Y#5	1.13693e-17
C134	VPWR#3	C1#2	8.72613e-20
C135	B1#2	A1#2	4.50133e-17
C136	VGND	A2#2	9.13866e-19
C137	B2#1	a_461_74#	4.08676e-18
C138	B1	Y#1	4.08599e-17
C139	VPWR#3	C2#2	5.51115e-20
C140	B1#3	a_461_74#	1.14611e-17
C141	Y#2	a_369_392##3	8.44222e-17
C142	VGND#1	a_369_392#	1.99691e-18
C143	C1#2	C1#3	6.73964e-18
C144	VPWR#3	B2#2	3.75853e-20
C145	C1#3	C2#2	1.13356e-17
C146	A2	a_369_392#	2.89985e-17
C147	VPWR#3	B1#2	1.58257e-20
C148	A1#1	a_697_74#	1.48128e-17
C149	Y#2	a_116_392#	1.03571e-17
C150	A2#3	a_697_74#	1.54437e-17
C151	VGND#3	Y#1	5.44972e-17
C152	C2#2	B2#3	1.32442e-19
C153	B1	A1#7	1.3383e-17
C154	Y#4	a_119_74#	6.4892e-18
C155	B1	a_369_392##2	4.46533e-17
C156	A2	VGND#1	2.66195e-17
C157	B2#3	B1#2	1.21393e-18
C158	Y#1	a_119_74#	8.84622e-23
C159	VGND#3	VGND#1	3.15264e-19
C160	VPWR#3	C1#3	5.68935e-18
C161	Y#1	a_461_74#	7.75969e-18
C162	C2#2	B2#1	4.1626e-19
C163	A1#7	A2	1.9007e-17
C164	a_369_392##3	a_369_392##2	4.70024e-19
C165	VPWR#3	C2#1	4.46165e-18
C166	A1#2	A2#4	7.96095e-18
C167	C1#2	Y#3	2.62598e-17
C168	VPWR#3	B2#3	4.44772e-18
C169	VPWR#3	B1#1	5.07357e-18
C170	VGND#1	Y#1	3.3403e-17
C171	C1#3	C2#1	3.28818e-17
C172	B2#1	B1#2	5.0161e-18
C173	a_369_392##2	a_116_392#	1.7621e-17
C174	Y	A2#2	6.43255e-20
C175	a_116_392##2	C2#2	8.87261e-19
C176	Y#4	Y#2	3.56495e-18
C177	C2#2	Y#5	2.61085e-18
C178	C2#1	B2#3	3.12158e-18
C179	a_369_392##2	a_369_392##4	6.8118e-18
C180	A1#7	VPWR#4	2.08296e-18
C181	A1#2	A2#3	1.86941e-18
C182	B2#2	a_369_392##3	5.20847e-18
C183	C1#2	Y#4	2.92939e-17
C184	B2#3	B1#1	3.00415e-17
C185	a_116_392#	B2#2	3.98409e-19
C186	a_369_392##2	VPWR#4	2.7678e-17
C187	A1#7	a_369_392#	1.71956e-17
C188	a_116_392#	B1#2	4.70748e-19
C189	B1#1	A1#3	3.28237e-17
C190	C2#2	VGND#3	6.54784e-18
C191	a_369_392##2	a_369_392#	4.46903e-19
C192	A1#3	A2#4	2.27079e-17
C193	Y#3	VPWR#3	2.10129e-17
C194	VPWR#4	A1#2	1.40285e-18
C195	a_116_392##2	VPWR#3	7.97111e-17
C196	VGND#3	B1#2	2.05176e-19
C197	Y#3	C1#3	5.50824e-17
C198	Y#1	B1#2	3.70155e-18
C199	a_116_392#	VPWR#3	7.41648e-17
C200	VGND#3	A1#2	1.62405e-19
C201	C1#3	a_116_392##2	2.81602e-17
C202	Y#3	C2#1	2.59205e-18
C203	C2#2	Y#2	4.62153e-17
C204	a_369_392#	A2#2	2.07764e-18
C205	A1#2	Y#1	4.3727e-17
C206	a_116_392##2	C2#1	6.67411e-17
C207	Y#3	B2#3	6.21192e-20
C208	C2#1	Y#5	1.41782e-17
C209	VGND#1	A1#2	3.23909e-18
C210	a_116_392##2	B2#3	3.41598e-19
C211	C1#1	C2#3	4.40897e-17
C212	VGND#2	VGND#3	1.09898e-16
C213	a_369_392##3	C2#1	9.50128e-19
C214	a_116_392##2	B1#1	1.04982e-19
C215	a_116_392#	C2#1	3.13233e-19
C216	Y#2	B1#2	1.18521e-19
C217	a_369_392##3	B2#3	7.09151e-17
C218	C2#3	B2#1	1.6714e-18
C219	Y#1	a_369_392##2	7.35024e-18
C220	a_116_392#	B2#3	3.84956e-17
C221	a_369_392##3	B1#1	1.18162e-18
C222	VGND#2	VGND#1	4.86352e-17
C223	Y#2	A1#2	7.14975e-20
C224	a_369_392##4	B2#3	6.18657e-19
C225	a_116_392#	B1#1	5.46233e-17
C226	A1#7	B1#2	1.93728e-18
C227	B2#1	B1#3	4.17271e-17
C228	a_369_392##3	A1#3	1.97004e-19
C229	VPWR#4	B2#3	2.40266e-19
C230	a_369_392##2	B1#2	3.3078e-18
C231	B1#1	a_369_392##4	1.77478e-17
C232	A1#2	A2#2	4.68115e-17
C233	a_116_392#	A1#3	2.17836e-18
C234	VPWR#4	B1#1	1.12941e-18
C235	A1#7	A1#2	1.27593e-17
C236	a_369_392##4	A1#3	5.31584e-17
C237	B1#3	A1#1	7.41045e-18
C238	a_116_392#	A2#4	7.73124e-19
C239	a_369_392##2	A1#2	5.93983e-18
C240	A1#3	VPWR#4	3.52058e-17
C241	a_369_392##4	A2#4	7.17658e-19
C242	a_369_392#	A1#3	1.83248e-18
C243	A2#4	VPWR#4	3.29745e-17
C244	A1#1	A2#3	4.75613e-17
C245	a_369_392#	A2#4	5.59281e-17
C246	A1#7	A2#2	3.19322e-18
C247	Y#2	C1#3	1.5734e-18
C248	a_369_392##2	VPWR#3	6.46386e-19
C249	Y#4	C1#1	3.97714e-17
C250	Y#3	a_116_392##2	7.32504e-17
C251	Y#2	C2#1	2.95172e-17
C252	Y#4	C2#3	2.20412e-17
C253	VGND#3	C1#1	8.90328e-18
C254	A2	A2#2	2.95367e-17
C255	Y#2	B2#3	3.69418e-18
C256	a_116_392##2	Y#5	1.34243e-18
C257	Y#4	B2#1	4.71181e-19
C258	VGND#3	C2#3	4.22663e-17
C259	Y#1	C1#1	3.43714e-19
C260	Y#2	B1#1	4.60347e-19
C261	Y#4	B1#3	2.69992e-19
C262	VGND#3	B2#1	4.4161e-17
C263	a_116_392##2	a_116_392#	1.15132e-18
C264	Y#1	C2#3	5.96251e-19
C265	Y#2	A1#3	2.82141e-19
C266	VGND#3	B1#3	8.51236e-18
C267	a_369_392##2	B2#3	1.38729e-19
C268	Y#1	B2#1	1.4793e-17
C269	Y#2	A2#4	3.74778e-19
C270	a_116_392#	a_369_392##3	9.5703e-17
C271	VGND#3	A1#1	4.80268e-19
C272	a_369_392##2	B1#1	1.66067e-17
C273	Y#4	Y#3	1.66034e-18
C274	Y#1	B1#3	5.54523e-17
C275	a_369_392##3	a_369_392##4	2.09605e-18
C276	VGND#1	B2#1	1.91296e-19
C277	VGND#3	A2#3	3.08638e-19
C278	Y#1	A1#1	5.27532e-17
C279	A1#7	a_369_392##2	3.74126e-17
C280	a_116_392#	a_369_392##4	6.22499e-17
C281	a_369_392##2	A1#3	1.99524e-17
C282	VGND#1	B1#3	6.12091e-19
C283	A1#7	A2#4	3.40064e-18
C284	a_116_392#	VPWR#4	3.03567e-18
C285	Y#1	A2#3	7.17182e-18
C286	a_369_392##2	A2#4	1.60929e-19
C287	VGND#1	A1#1	1.55826e-17
C288	a_369_392##4	VPWR#2	1.75272e-17
C289	VGND#4	VNB	2.61677e-17
C290	VPWR	VPWR#2	4.04773e-17
C291	VGND#4	C1#1	1.79067e-18
C292	VPWR#2	B1#2	2.57974e-20
C293	VPWR#2	VNB	5.68802e-17
C294	VPWR#2	A1#3	2.56894e-18
C295	VGND	VGND#4	1.55862e-17
C296	VGND#4	C1	9.10131e-19
C297	VGND#4	C1#2	2.10758e-19
C298	VPWR#2	A2#2	3.6824e-19
C299	VGND#2	VGND#4	2.4703e-17
C300	VPWR#2	A2#4	5.69321e-18
C301	VPWR#3	VPWR#2	6.5168e-17
C302	a_369_392#	VPWR#2	2.11355e-17
C303	VGND#4	Y#4	2.05472e-17
C304	a_369_392##2	VPWR#2	1.69055e-19
C305	A2	VPWR#2	4.97625e-19
*
*
.ENDS sky130_fd_sc_hs__a222oi_1
*
