* Extracted by Quantus, converted by sky130cad/quantus.py
*
*
*
*                       LINUX           Wed Nov 18 08:13:26 2026
*
*
*
*  PROGRAM  advgen
*
*  Name           : advgen - Quantus - (64-bit)
*  Version        : 25.1.0-p047
*  Build Date     : Thu Dec 11 23:20:30 PST 2025
*
*  HSPICE LIBRARY
*
*  OPERATING_TEMPERATURE 150
*  QRC_TECH_DIR <path>/tech
*
*
*

*
.SUBCKT sky130_fd_sc_hs__a31oi_2 VPB VNB VGND VPWR Y A3 B1 A2 A1
*
*
*  caps2d version: 10
*
*
*       TRANSISTOR CARDS
*
*
XM10 a_114_74##2 A3#4 VGND#3 VNB sky130_fd_pr__nfet_01v8_lvt l=0.15 w=0.74 ad=0.2072 as=0.2109 pd=2.04 ps=2.05
XM1 a_200_74# A2#5 a_114_74##2 VNB sky130_fd_pr__nfet_01v8_lvt l=0.15 w=0.74 ad=0.259 as=0.2072 pd=2.18 ps=2.04
XM7 a_114_74# A2#6 a_200_74# VNB sky130_fd_pr__nfet_01v8_lvt l=0.15 w=0.74 ad=0.259 as=0.259 pd=2.18 ps=2.18
XM13 VGND#4 A3#7 a_114_74# VNB sky130_fd_pr__nfet_01v8_lvt l=0.15 w=0.74 ad=0.3108 as=0.259 pd=2.32 ps=2.18
XM4 VGND#4 B1#5 Y#4 VNB sky130_fd_pr__nfet_01v8_lvt l=0.15 w=0.74 ad=0.3108 as=0.4921 pd=2.32 ps=2.81
XM3 Y#4 A1#4 a_200_74##2 VNB sky130_fd_pr__nfet_01v8_lvt l=0.15 w=0.74 ad=0.4921 as=0.2183 pd=2.81 ps=2.07
XM12 a_200_74##2 A1#5 Y#2 VNB sky130_fd_pr__nfet_01v8_lvt l=0.15 w=0.74 ad=0.2183 as=0.2627 pd=2.07 ps=2.19
XM0 a_27_368##7 A3#1 VPWR#9 VPB sky130_fd_pr__pfet_01v8 l=0.15 w=1.12 ad=0.3304 as=0.3472 pd=2.83 ps=2.86
XM6 VPWR#9 A2#7 a_27_368##8 VPB sky130_fd_pr__pfet_01v8 l=0.15 w=1.12 ad=0.3472 as=0.3808 pd=2.86 ps=2.92
XM11 a_27_368##8 A2#1 VPWR#8 VPB sky130_fd_pr__pfet_01v8 l=0.15 w=1.12 ad=0.3808 as=0.392 pd=2.92 ps=2.94
XM2 VPWR#8 A3#5 a_27_368##4 VPB sky130_fd_pr__pfet_01v8 l=0.15 w=1.12 ad=0.392 as=0.3472 pd=2.94 ps=2.86
XM5 a_27_368##4 B1#4 Y#1 VPB sky130_fd_pr__pfet_01v8 l=0.15 w=1.12 ad=0.3472 as=0.336 pd=2.86 ps=2.84
XM9 Y#1 B1#1 a_27_368##2 VPB sky130_fd_pr__pfet_01v8 l=0.15 w=1.12 ad=0.336 as=0.392 pd=2.84 ps=2.94
XM14 a_27_368##2 A1#6 VPWR#7 VPB sky130_fd_pr__pfet_01v8 l=0.15 w=1.12 ad=0.392 as=0.336 pd=2.94 ps=2.84
XM8 VPWR#7 A1#1 a_27_368# VPB sky130_fd_pr__pfet_01v8 l=0.15 w=1.12 ad=0.336 as=0.3304 pd=2.84 ps=2.83
*
*
*       RESISTOR AND CAP/DIODE CARDS
*
Rg1	A3#1	A3#2	507.075531
Rg2	A3#2	A3#3	28.628225
Rg3	A3#2	A3#4	322.953644
Rg4	A2#1	A2#2	451.075073
Rg5	A2#2	A2#3	30.596947
Rg6	A2#3	A2#4	46.351898
Rg7	A2#4	A2#5	396.457733
Rg8	A2#2	A2#6	400.506866
Rg9	A2#4	A2#7	449.042694
Rg10	A3#5	A3#6	500.238068
Rg11	A3#6	A3#7	320.356293
Rg12	B1#1	B1#2	515.835632
Rg13	B1#2	B1#3	30.613651
Rg14	B1#3	B1#4	514.055847
Rg15	B1#3	B1#5	358.153564
Rg16	A1#1	A1#2	429.126801
Rg17	A1#2	A1#3	66.432877
Rg18	A1#3	A1#4	401.054016
Rg19	A1#2	A1#5	377.027313
Rg20	A1#3	A1#6	450.571655
Rf1	A2#8	A2	1.070568
Rf2	A2#3	A2#10	81.186966
Rf3	A2#10	A2	1.070568
Rf4	A2#8	A2#10	17.866518
Rf5	a_114_74#	a_114_74##2	99.126457
Rf6	A3#6	A3	282.425415
Rf7	A3	A3#3	163.775864
Rf8	B1	B1#2	81.905983
Rf9	a_200_74#	a_200_74##2	196.364990
Rf10	A1#2	A1#8	161.681931
Rf11	A1#9	A1	1.449128
Rf12	A1#8	A1#9	12.655451
Rf13	a_27_368#	a_27_368##3	91.723122
Rf14	a_27_368##3	a_27_368##5	108.663612
Rf15	a_27_368##5	a_27_368##6	81.741112
Rf16	a_27_368##6	a_27_368##7	90.621727
Rf17	a_27_368##6	a_27_368##8	17.126133
Rf18	a_27_368##2	a_27_368##3	5.000000
Rf19	a_27_368##4	a_27_368##5	5.000000
Rf20	Y#1	Y	159.767410
Rf21	Y	Y#3	7.282945
Rf22	Y#3	Y	7.282945
Rf23	Y	Y#4	83.026764
Rf24	Y#2	Y#3	7.500000
Rf26	VPWR#2	VPWR#3	104.437675
Rf27	VPWR#3	VPWR#4	32.175034
Rf28	VPWR#4	VPWR#5	72.328270
Rf30	VPWR#2	VPWR#7	30.353714
Rf31	VPWR#4	VPWR#8	38.736572
Rf32	VPWR#5	VPWR#9	32.420494
Rf34	VGND#2	VGND#3	188.907242
Rf35	VGND#2	VGND#4	34.659180
Re1	VPWR#3	VPWR	1.091357
Re2	VGND	VGND#2	1.091398
*
*       CAPACITOR CARDS
*
*
C1	a_114_74#	A2#4	1.58366e-19
C2	a_200_74#	B1#3	1.35906e-18
C3	a_200_74#	A2#4	1.13847e-18
C4	a_114_74##2	A2#4	3.26047e-19
C5	A3#1	A2#4	2.78937e-18
C6	VPWR#3	B1#3	5.46492e-20
C7	VPWR#4	VPWR#7	8.39583e-20
C8	VPWR#4	A2#4	2.83867e-20
C9	a_27_368##4	VPWR#4	2.27027e-18
C10	a_27_368##2	B1#3	1.25165e-19
C11	A1#3	A1#2	2.66309e-18
C12	a_27_368##8	VPWR#4	7.69774e-18
C13	Y#1	A1#3	4.28964e-18
C14	A1#8	a_27_368#	2.10664e-17
C15	Y#1	B1#3	3.70391e-18
C16	B1#2	A1#3	2.7517e-18
C17	VPWR#9	VPWR#4	4.52249e-20
C18	B1#2	B1#3	3.60634e-17
C19	a_200_74##2	Y#4	7.89112e-17
C20	Y#1	A2#4	4.68e-19
C21	a_27_368##6	VPWR#8	2.77294e-17
C22	A1#8	a_27_368##2	5.53217e-18
C23	VGND#4	Y#4	3.15181e-17
C24	a_200_74##2	a_114_74#	7.54778e-21
C25	a_27_368##6	a_27_368##8	2.47182e-18
C26	a_27_368##4	B1#3	5.09041e-20
C27	Y#1	A1#8	2.55449e-17
C28	A3#6	B1#3	3.69033e-17
C29	A3#6	A2#4	3.90196e-17
C30	a_27_368##6	VPWR#9	2.82862e-17
C31	a_114_74#	VGND#4	3.06484e-17
C32	a_200_74#	VGND#4	4.00279e-17
C33	a_114_74#	a_200_74#	5.85032e-17
C34	a_114_74##2	a_114_74#	2.7557e-18
C35	VGND#3	VGND#4	1.01252e-19
C36	a_114_74##2	a_200_74#	4.96251e-17
C37	a_27_368##6	A2#4	3.93664e-18
C38	A2#4	a_27_368##8	8.58876e-19
C39	a_200_74##2	Y#1	2.09969e-18
C40	A3#3	A2#4	3.2187e-17
C41	VGND#3	a_114_74##2	8.4616e-17
C42	a_27_368#	VPWR#7	7.04007e-17
C43	a_200_74#	a_27_368##4	4.49683e-18
C44	a_27_368##2	a_27_368#	2.4622e-18
C45	A1#5	Y#2	9.4826e-19
C46	VPWR#4	A1#6	2.42861e-20
C47	a_27_368##2	VPWR#7	7.70948e-17
C48	Y#1	a_27_368#	1.98947e-18
C49	a_200_74##2	A1#5	2.61291e-17
C50	VPWR#4	B1#1	9.02676e-20
C51	Y#4	A1#5	1.87587e-18
C52	a_200_74##2	A1#4	2.93852e-17
C53	a_27_368##2	Y#1	1.22492e-16
C54	VGND#4	A1#5	9.63516e-20
C55	Y#4	A1#4	4.42208e-17
C56	VPWR#4	B1#4	3.09498e-19
C57	a_200_74##2	B1#5	2.37068e-17
C58	a_27_368##4	a_27_368##2	2.34148e-18
C59	VGND#4	A1#4	5.23479e-19
C60	Y#4	B1#5	3.76651e-17
C61	a_27_368##4	Y#1	7.82459e-17
C62	a_200_74##2	A3#7	2.57099e-19
C63	VPWR#4	A3#5	3.41023e-18
C64	B1#5	VGND#4	2.33442e-17
C65	A1#8	A1#1	2.91695e-18
C66	a_200_74#	A1#4	4.23644e-19
C67	a_200_74##2	A2#6	1.69723e-19
C68	A3#7	VGND#4	2.41262e-17
C69	a_27_368##4	VPWR#8	7.02705e-17
C70	VPWR#4	A2#1	5.44391e-18
C71	a_200_74#	B1#5	9.21375e-19
C72	A1#8	A1#6	1.23969e-18
C73	a_114_74#	A3#7	3.40039e-17
C74	B1#3	A1#4	4.65898e-18
C75	VGND#4	A2#6	5.73508e-19
C76	a_114_74##2	B1#5	4.29325e-20
C77	a_27_368##8	a_27_368##4	2.66804e-18
C78	a_200_74#	A3#7	2.0094e-17
C79	a_27_368##6	A3#5	9.87998e-21
C80	a_114_74#	A2#6	3.17284e-17
C81	VPWR#4	A2#7	4.92341e-19
C82	VGND#3	B1#5	3.4683e-20
C83	A1#8	A1#3	3.64846e-18
C84	a_27_368##8	VPWR#8	5.29637e-17
C85	VGND#4	A2#5	8.04912e-20
C86	a_114_74##2	A3#7	2.46822e-19
C87	a_200_74#	A2#6	3.83079e-17
C88	a_114_74#	A2#5	7.16139e-19
C89	VGND#3	A3#7	2.34052e-20
C90	VPWR#9	VPWR#8	2.19083e-18
C91	a_27_368##7	a_27_368##4	3.80164e-21
C92	a_27_368##6	A2#1	1.81692e-17
C93	a_114_74##2	A2#6	1.13364e-18
C94	VGND#4	A3#4	8.47255e-20
C95	A2#5	a_200_74#	1.74643e-17
C96	VPWR#9	a_27_368##8	6.22197e-17
C97	VGND#3	A2#6	9.22435e-20
C98	a_114_74##2	A2#5	4.36061e-17
C99	a_27_368##6	A2#7	1.19565e-17
C100	a_27_368##7	a_27_368##8	2.3038e-18
C101	VGND#3	A2#5	2.90399e-18
C102	a_114_74##2	A3#4	3.52445e-17
C103	a_27_368##7	VPWR#9	5.81359e-17
C104	a_27_368##6	A3#1	1.84654e-20
C105	A3#4	VGND#3	2.48966e-17
C106	VPWR#3	VPWR#4	2.86484e-17
C107	A2	A1#3	1.21671e-19
C108	A2	B1#3	2.41662e-19
C109	A2	A2#4	3.17494e-17
C110	a_27_368#	A1#1	4.11133e-17
C111	A1#4	A1#5	3.71819e-17
C112	VPWR#7	A1#1	4.50092e-17
C113	a_27_368#	A1#6	2.15601e-18
C114	a_27_368##2	A1#1	8.78501e-19
C115	VPWR#7	A1#6	4.30026e-17
C116	B1#5	A1#4	8.49122e-18
C117	Y#1	A1#1	2.52185e-18
C118	a_27_368#	B1#1	4.72037e-19
C119	a_27_368##2	A1#6	6.33567e-17
C120	VPWR#7	B1#1	1.67609e-18
C121	Y#1	A1#6	7.66986e-18
C122	a_27_368##2	B1#1	3.4501e-17
C123	A3#7	B1#5	2.18438e-17
C124	a_27_368##4	A1#6	1.84487e-19
C125	VPWR#7	B1#4	9.49446e-20
C126	Y#1	B1#1	6.35631e-17
C127	a_27_368##2	B1#4	4.6339e-19
C128	a_27_368##4	B1#1	4.11951e-19
C129	VPWR#7	A3#5	2.63143e-20
C130	A2#6	A3#7	2.6482e-17
C131	Y#1	B1#4	5.15959e-17
C132	A1#8	A1#2	2.22665e-17
C133	a_27_368##2	A3#5	1.96835e-19
C134	a_27_368##4	B1#4	3.72986e-17
C135	VPWR#7	A2#1	1.58556e-20
C136	Y#1	A3#5	3.42578e-18
C137	A3#6	a_27_368##6	8.38926e-18
C138	A2#5	A2#6	2.40331e-17
C139	a_27_368##4	A3#5	7.00333e-17
C140	Y#1	A2#1	6.80965e-19
C141	A3#5	VPWR#8	2.75626e-17
C142	a_27_368##4	A2#1	1.57789e-18
C143	a_27_368##8	A3#5	1.58905e-18
C144	Y#1	A2#7	2.40799e-19
C145	A3#4	A2#5	3.69556e-17
C146	a_27_368##7	B1#4	1.8251e-19
C147	A2#1	VPWR#8	3.17459e-17
C148	VPWR#9	A3#5	2.81749e-19
C149	a_200_74##2	A1#2	4.80087e-19
C150	a_27_368##8	A2#1	5.57054e-17
C151	a_27_368##7	A3#5	1.57087e-19
C152	Y#1	A3#1	2.61336e-19
C153	VPWR#8	A2#7	3.52548e-19
C154	VPWR#9	A2#1	2.40005e-18
C155	A2#7	a_27_368##8	2.09641e-17
C156	a_27_368##7	A2#1	4.67224e-19
C157	a_200_74##2	B1#2	3.46094e-17
C158	Y	A1#3	1.12026e-17
C159	VPWR#9	A2#7	5.41685e-17
C160	Y	B1#3	4.25102e-18
C161	a_27_368##2	VPWR#3	1.67784e-17
C162	a_27_368##8	A3#1	9.14039e-19
C163	a_27_368##7	A2#7	1.22203e-18
C164	VPWR#9	A3#1	4.77736e-17
C165	a_27_368##4	VPWR#3	4.2433e-17
C166	a_200_74#	B1#2	4.84766e-18
C167	a_27_368##7	A3#1	4.00859e-17
C168	a_27_368#	A1#2	1.1413e-18
C169	A3#6	VGND#4	8.13878e-19
C170	A1#2	VPWR#7	1.29865e-18
C171	A1#6	A1#1	4.71393e-17
C172	A3#6	a_114_74#	7.42485e-19
C173	a_27_368##2	A1#2	6.6405e-19
C174	A3#6	a_200_74#	9.04089e-17
C175	B1#3	A1#3	2.2314e-17
C176	Y#1	A1#2	6.08947e-20
C177	B1#1	A1#6	3.70853e-17
C178	B1#2	Y#1	5.97455e-17
C179	B1#2	a_27_368##4	2.31055e-18
C180	B1#4	B1#1	4.81389e-17
C181	A3#3	a_200_74#	1.17235e-17
C182	Y#1	A3#6	6.45186e-20
C183	A3#3	a_114_74##2	4.15251e-17
C184	A3#6	a_27_368##4	1.71955e-17
C185	a_27_368##6	VPWR#4	3.13618e-19
C186	A3#3	VGND#3	3.69485e-17
C187	VPWR#8	A3#6	4.17108e-19
C188	A3#5	B1#4	4.85139e-17
C189	B1#2	A1#4	6.35024e-20
C190	A2#1	A3#5	3.77514e-17
C191	VGND	B1#3	6.86297e-19
C192	A3#6	A1#4	5.82532e-19
C193	A3#6	B1#5	2.25118e-18
C194	A2	a_27_368##6	8.44839e-17
C195	A2#7	A2#1	3.85825e-17
C196	A3#6	A3#7	4.39056e-18
C197	VPWR#3	B1#1	1.78521e-18
C198	A3#3	a_27_368##7	2.88733e-17
C199	A3#6	A2#6	1.15505e-17
C200	VPWR#3	B1#4	4.46319e-18
C201	A3#1	A2#7	4.41751e-17
C202	VPWR#3	A3#5	1.34175e-18
C203	A3#3	A2#5	1.38518e-17
C204	A1#3	VNB	2.23571e-17
C205	A3#3	A3#4	6.63286e-18
C206	B1#3	VNB	4.35521e-17
C207	A2#4	VNB	5.52389e-17
C208	A1	a_27_368#	2.69106e-17
C209	a_200_74##2	A1#3	3.08966e-19
C210	A2	Y#1	6.52535e-18
C211	a_200_74##2	B1#3	5.3602e-18
C212	B1#1	A1#3	2.3527e-18
C213	Y	A1#8	4.30309e-17
C214	VPWR	VPWR#4	3.47525e-17
C215	VPWR#3	A3#6	2.98831e-20
C216	A2	a_27_368##7	8.45973e-18
C217	VPWR	a_27_368##6	3.58577e-18
C218	Y	Y#2	1.25071e-17
C219	Y	a_200_74##2	9.83373e-17
C220	Y	Y#4	3.35684e-18
C221	Y	VGND#4	7.50273e-20
C222	VPWR	A1#8	2.13606e-18
C223	A3#6	B1#2	3.3129e-17
C224	Y	a_27_368#	4.02205e-19
C225	Y	a_27_368##2	1.90632e-18
C226	A3#3	A3#6	1.60372e-18
C227	VGND	A1#8	2.26625e-18
C228	A2	B1#4	3.9552e-19
C229	VPWR	a_27_368#	1.61021e-17
C230	A2	A3#5	1.53671e-18
C231	VPWR	VPWR#7	2.26704e-17
C232	B1#3	Y#4	3.58898e-18
C233	Y	A1#5	4.21364e-17
C234	VPWR	a_27_368##2	2.37563e-17
C235	A2	A2#1	1.98118e-18
C236	Y	A1#4	1.12025e-17
C237	VPWR	Y#1	1.04377e-17
C238	VPWR#4	VNB	2.24519e-17
C239	VGND	a_200_74##2	1.55846e-17
C240	Y	B1#5	2.13796e-18
C241	A2	A2#7	2.07907e-18
C242	VPWR	a_27_368##4	2.17441e-17
C243	VGND	Y#4	2.77971e-17
C244	Y	A3#7	7.36356e-19
C245	VGND	VGND#4	1.68329e-17
C246	A2	A3#1	4.13984e-18
C247	VPWR	a_27_368##8	1.60524e-17
C248	VGND	a_114_74#	2.03376e-17
C249	VGND	a_200_74#	1.49999e-17
C250	VPWR	VPWR#9	2.19803e-17
C251	VGND	a_114_74##2	2.26018e-17
C252	VPWR	a_27_368##7	1.49147e-17
C253	VGND	VGND#3	4.46998e-17
C254	VGND	Y#1	3.28517e-18
C255	a_200_74##2	VNB	9.85578e-20
C256	Y#4	VNB	4.9604e-18
C257	VGND#4	VNB	4.7104e-18
C258	VGND	a_27_368##7	2.59119e-18
C259	a_114_74#	VNB	3.3084e-18
C260	A3#6	A2	5.30897e-17
C261	VGND	A1#5	2.33562e-18
C262	VPWR	A1#1	1.63323e-18
C263	VGND	A1#4	1.45032e-18
C264	a_114_74##2	VNB	3.92951e-18
C265	VPWR	A1#6	6.22104e-19
C266	VGND#3	VNB	6.90375e-17
C267	VGND	B1#5	1.23678e-18
C268	a_27_368#	VNB	4.92579e-17
C269	VGND	A3#7	1.64633e-18
C270	VPWR	B1#1	1.41638e-18
C271	VPWR#7	VNB	2.63218e-18
C272	VGND	A2#6	1.4566e-18
C273	a_27_368##2	VNB	4.16747e-18
C274	VPWR	B1#4	1.53341e-18
C275	A3#3	A2	6.38564e-17
C276	Y#1	VNB	3.87919e-18
C277	VGND	A2#5	1.35015e-18
C278	VPWR	A3#5	8.97939e-19
C279	a_27_368##4	VNB	2.83965e-18
C280	VGND	A3#4	2.06639e-18
C281	VPWR#8	VNB	3.0111e-18
C282	VPWR	A2#1	7.46308e-19
C283	a_27_368##8	VNB	2.77131e-18
C284	VPWR#9	VNB	2.62951e-18
C285	VPWR	A2#7	5.25036e-19
C286	a_27_368##7	VNB	5.47354e-17
C287	VPWR	A3#1	2.11482e-18
C288	A1#5	VNB	2.86988e-17
C289	Y	A1#2	8.92599e-18
C290	A1#4	VNB	2.8267e-17
C291	B1#5	VNB	3.11911e-17
C292	B1#2	Y	2.8844e-17
C293	A3#7	VNB	2.71393e-17
C294	VPWR	VPWR#3	1.53872e-17
C295	A2#6	VNB	2.86682e-17
C296	A3#6	Y	2.28899e-18
C297	A2#5	VNB	2.83729e-17
C298	A3#4	VNB	3.62953e-17
C299	A1#1	VNB	3.56153e-17
C300	VPWR	B1#2	4.2254e-18
C301	A1#6	VNB	2.76391e-17
C302	VPWR	A3#6	2.97083e-18
C303	B1#1	VNB	3.5055e-17
C304	B1#4	VNB	3.55635e-17
C305	A3#5	VNB	3.45367e-17
C306	A2#1	VNB	3.23528e-17
C307	VPWR	A3#3	4.23351e-18
C308	A2#7	VNB	2.71931e-17
C309	VGND	B1#2	5.69693e-18
C310	B1#3	VGND#4	8.29683e-19
C311	A3#1	VNB	4.63996e-17
C312	VGND	A3#6	7.19292e-18
C313	VPWR#3	VNB	2.12252e-16
C314	VGND	A3#3	6.15058e-18
C315	Y	A1	2.69434e-17
C316	A1#2	VNB	4.59569e-17
C317	B1#2	VNB	6.50588e-18
C318	A3#6	VNB	3.21302e-17
C319	VPWR	A1	1.49291e-18
C320	A3#3	VNB	9.19105e-17
C321	VPWR	A2	4.17479e-18
C322	VGND	A1	1.92714e-18
C323	VGND	A2	5.70215e-18
C324	A1	VNB	2.38342e-17
C325	A2	VNB	8.64987e-18
C326	VGND	Y	3.06097e-17
C327	Y	VNB	5.74384e-17
C328	VPWR	VNB	6.69606e-17
C329	VGND	VNB	7.11426e-17
C330	A2#4	A3#5	2.50309e-18
C331	VGND#2	A1#4	4.41949e-18
C332	VGND#2	a_200_74#	1.07903e-18
C333	VPWR#5	VPWR#4	8.82913e-19
C334	VGND	VGND#2	7.30686e-17
C335	VPWR#4	VPWR#2	1.80075e-19
C336	VGND#2	A3#6	4.96401e-20
C337	a_27_368##6	VPWR#5	1.6661e-19
C338	VGND#2	a_200_74##2	1.50435e-18
C339	a_27_368#	VPWR#2	1.93525e-17
C340	VGND#2	Y	6.23301e-17
C341	VGND#2	A1#2	3.82786e-20
C342	VPWR#3	VPWR#2	6.31619e-17
C343	VPWR#5	A2#7	9.78637e-19
C344	a_27_368##2	VPWR#2	3.23899e-17
C345	VGND#2	A2#6	4.43427e-18
C346	VPWR#5	A3#1	1.84519e-18
C347	VGND#2	A2#4	4.77805e-20
C348	VPWR#3	VPWR#5	5.35723e-17
C349	VGND#2	B1#5	6.98439e-18
C350	VGND#2	a_114_74##2	1.99034e-17
C351	VGND#2	A1#3	1.39759e-20
C352	VGND#2	A1#5	4.43427e-18
C353	VGND#2	a_114_74#	4.81091e-17
C354	VPWR#2	A1#1	1.4854e-18
C355	VPWR	VPWR#2	3.69468e-17
C356	VPWR#5	A3#3	8.11678e-19
C357	VGND#2	VNB	3.02857e-16
C358	VPWR#2	A1#6	9.71249e-19
C359	VGND#2	Y#4	6.45248e-17
C360	VPWR#2	B1#1	2.66294e-18
C361	VPWR#5	A2#4	3.54834e-20
C362	VPWR#2	VNB	5.46928e-17
C363	VGND#2	A2#5	2.1654e-18
C364	VPWR	VPWR#5	3.38498e-17
C365	a_27_368##8	VPWR#5	9.95281e-18
C366	VPWR#5	VNB	4.79736e-17
C367	VGND#2	A3#7	4.26385e-18
C368	VGND#2	VGND#3	4.12821e-17
C369	a_27_368##7	VPWR#5	1.78953e-17
C370	VGND#2	B1#3	2.69614e-19
*
*
.ENDS sky130_fd_sc_hs__a31oi_2
*
