* Extracted by Quantus, converted by sky130cad/quantus.py
*
*
*
*                       LINUX           Wed Nov 18 08:51:16 2026
*
*
*
*  PROGRAM  advgen
*
*  Name           : advgen - Quantus - (64-bit)
*  Version        : 25.1.0-p047
*  Build Date     : Thu Dec 11 23:20:30 PST 2025
*
*  HSPICE LIBRARY
*
*  OPERATING_TEMPERATURE 150
*  QRC_TECH_DIR <path>/tech
*
*
*

*
.SUBCKT sky130_fd_sc_hs__nor4_2 VNB VPB VGND VPWR Y B D C A
*
*
*  caps2d version: 10
*
*
*       TRANSISTOR CARDS
*
*
XM2 VGND#8 D#1 Y#5 VNB sky130_fd_pr__nfet_01v8_lvt l=0.15 w=0.74 ad=0.3329 as=0.2368 pd=3 ps=2.12
XM7 Y#5 C#3 VGND#7 VNB sky130_fd_pr__nfet_01v8_lvt l=0.15 w=0.74 ad=0.2368 as=0.3108 pd=2.12 ps=2.32
XM11 VGND#7 B#1 Y#1 VNB sky130_fd_pr__nfet_01v8_lvt l=0.15 w=0.74 ad=0.3108 as=0.2072 pd=2.32 ps=2.04
XM3 Y#1 A#4 VGND#6 VNB sky130_fd_pr__nfet_01v8_lvt l=0.15 w=0.74 ad=0.2072 as=0.2627 pd=2.04 ps=2.19
XM0 a_27_368##5 C#1 a_116_368##2 VPB sky130_fd_pr__pfet_01v8 l=0.15 w=1.12 ad=0.3304 as=0.3528 pd=2.83 ps=2.87
XM1 a_116_368##2 D#6 Y#3 VPB sky130_fd_pr__pfet_01v8 l=0.15 w=1.12 ad=0.3528 as=0.364 pd=2.87 ps=2.89
XM4 Y#3 D#5 a_116_368# VPB sky130_fd_pr__pfet_01v8 l=0.15 w=1.12 ad=0.364 as=0.336 pd=2.89 ps=2.84
XM9 a_116_368# C#5 a_27_368##3 VPB sky130_fd_pr__pfet_01v8 l=0.15 w=1.12 ad=0.336 as=0.3696 pd=2.84 ps=2.9
XM8 a_27_368##3 B#3 a_490_368##2 VPB sky130_fd_pr__pfet_01v8 l=0.15 w=1.12 ad=0.3696 as=0.4368 pd=2.9 ps=3.02
XM10 VPWR#4 A#5 a_490_368##2 VPB sky130_fd_pr__pfet_01v8 l=0.15 w=1.12 ad=0.336 as=0.4368 pd=2.84 ps=3.02
XM5 a_490_368# A#1 VPWR#4 VPB sky130_fd_pr__pfet_01v8 l=0.15 w=1.12 ad=0.336 as=0.336 pd=2.84 ps=2.84
XM6 a_490_368# B#5 a_27_368# VPB sky130_fd_pr__pfet_01v8 l=0.15 w=1.12 ad=0.336 as=0.3304 pd=2.84 ps=2.83
*
*
*       RESISTOR AND CAP/DIODE CARDS
*
Rg1	C#1	C#2	513.810791
Rg2	D#1	D#2	303.578217
Rg3	D#2	D#3	57.213711
Rg4	D#3	D#4	639.337402
Rg5	D#2	D#5	520.835999
Rg6	D#3	D#6	542.848083
Rg7	C#3	C#4	377.742493
Rg8	C#4	C#5	456.142303
Rg9	B#1	B#2	365.323883
Rg10	B#2	B#3	447.963806
Rg11	A#1	A#2	509.023376
Rg12	A#2	A#3	50.300888
Rg13	A#3	A#4	322.953644
Rg14	A#3	A#5	507.075531
Rg15	B#4	B#5	544.050476
Rf1	D#4	D	162.594833
Rf2	a_116_368#	a_116_368##2	67.900635
Rf3	C	C#6	2.852120
Rf4	C#6	C#2	234.459518
Rf5	C#6	C#4	169.978500
Rf6	Y#1	Y#2	86.337730
Rf7	Y#2	Y#4	212.480972
Rf8	Y#4	Y	0.867881
Rf9	Y#2	Y#5	11.063752
Rf10	Y#3	Y#4	15.000000
Rf11	A#6	A#2	161.197830
Rf12	A	A#8	0.965023
Rf13	A#6	A#8	12.319763
Rf14	a_490_368#	a_490_368##2	91.828102
Rf15	a_27_368#	a_27_368##2	48.204216
Rf16	a_27_368##2	a_27_368##4	146.275436
Rf17	a_27_368##4	a_27_368##6	126.339035
Rf19	a_27_368#	a_27_368##2	15.000000
Rf20	a_27_368##3	a_27_368##4	5.000000
Rf21	a_27_368##5	a_27_368##6	5.000000
Rf22	B	B#2	280.817261
Rf23	B	B#4	13.384872
Rf24	B#4	B	1.181018
Rf26	VGND#2	VGND#3	78.650848
Rf27	VGND#3	VGND#4	86.220169
Rf29	VGND#2	VGND#6	30.747387
Rf30	VGND#3	VGND#7	40.564270
Rf31	VGND#4	VGND#8	14.925467
Rf33	VPWR#2	VPWR#3	71.564949
Rf34	VPWR#2	VPWR#4	31.948624
Re1	VPWR#3	VPWR	1.091357
Re2	VGND	VGND#3	1.091398
*
*       CAPACITOR CARDS
*
*
C1	C#1	D#3	3.4599e-19
C2	VPWR#3	D#3	4.8532e-20
C3	VPWR#3	D#2	4.8532e-20
C4	B#4	A#3	5.16725e-20
C5	A#3	A#2	4.79312e-18
C6	VGND#6	A#6	3.75125e-17
C7	B#2	A#3	4.22846e-17
C8	Y#2	Y#1	3.14145e-18
C9	Y#2	VGND#7	6.29315e-17
C10	Y#2	Y#5	4.87391e-18
C11	D#2	C#4	3.32047e-17
C12	Y#2	VGND#8	7.24739e-19
C13	D#3	D#2	4.10139e-18
C14	Y#1	VGND#6	6.01289e-17
C15	C#2	D#3	4.95885e-17
C16	VGND#7	VGND#6	1.69044e-18
C17	Y#1	VGND#7	5.46505e-17
C18	Y#2	a_27_368##3	5.79703e-18
C19	a_27_368##3	D#3	1.71793e-20
C20	a_27_368##3	D#2	2.28617e-19
C21	Y#1	a_27_368##3	1.68031e-18
C22	A#6	B#1	9.67638e-19
C23	a_116_368#	D#3	3.94805e-20
C24	a_27_368#	a_490_368#	9.76805e-17
C25	a_116_368#	D#2	1.66588e-19
C26	A#6	C#3	6.13901e-19
C27	a_27_368#	VPWR#4	2.33151e-18
C28	Y#2	B#1	7.59641e-19
C29	a_490_368#	VPWR#4	3.68304e-17
C30	a_27_368#	a_490_368##2	8.01463e-18
C31	Y#2	C#3	4.21899e-17
C32	a_490_368##2	a_490_368#	2.3755e-18
C33	a_27_368##3	a_27_368#	1.14698e-18
C34	Y#2	D#1	2.88496e-17
C35	a_490_368##2	VPWR#4	4.51877e-17
C36	A#4	VGND#6	2.57318e-17
C37	Y#1	A#4	5.02729e-17
C38	VGND#6	B#1	5.80865e-19
C39	VGND#7	A#4	5.13904e-19
C40	a_27_368##3	a_490_368##2	8.22859e-17
C41	Y#1	B#1	5.44306e-17
C42	VGND#6	C#3	2.10975e-19
C43	B#1	VGND#7	2.06067e-17
C44	a_116_368##2	D#3	2.01885e-19
C45	Y#1	C#3	5.46317e-19
C46	a_27_368##3	a_116_368#	6.19433e-17
C47	C#3	VGND#7	2.34608e-17
C48	a_27_368##3	Y#3	3.95665e-19
C49	C#3	Y#5	1.63435e-17
C50	VGND#7	D#1	4.74456e-19
C51	a_116_368#	Y#3	1.14315e-18
C52	D#1	Y#5	1.65016e-17
C53	a_27_368##5	D#3	2.8506e-19
C54	D#1	VGND#8	5.28045e-18
C55	a_27_368##5	a_27_368##3	2.07915e-18
C56	a_116_368##2	Y#3	3.81088e-19
C57	a_27_368##5	a_116_368#	1.22976e-18
C58	a_27_368##5	Y#3	3.65359e-19
C59	a_27_368##5	a_116_368##2	7.96546e-17
C60	a_27_368#	B#5	3.81438e-17
C61	C	D#3	2.43189e-18
C62	a_490_368#	B#5	4.41469e-17
C63	C	D#2	1.9862e-17
C64	a_27_368#	A#1	1.37857e-17
C65	VPWR#4	B#5	2.15553e-18
C66	a_490_368#	A#1	3.467e-17
C67	a_27_368#	A#5	2.10035e-19
C68	a_490_368##2	B#5	2.00227e-19
C69	VPWR#4	A#1	3.68732e-17
C70	a_490_368#	A#5	4.08201e-19
C71	a_27_368##3	B#5	6.87357e-19
C72	a_27_368#	B#3	1.35931e-19
C73	a_490_368##2	A#1	4.6642e-19
C74	B#1	A#4	3.60817e-17
C75	B#1	A#3	2.60374e-18
C76	VPWR#4	A#5	3.43719e-17
C77	a_490_368#	B#3	1.8344e-19
C78	a_27_368##3	A#1	5.95685e-19
C79	a_490_368##2	A#5	5.4649e-17
C80	a_27_368#	C#5	8.42978e-20
C81	VPWR#4	B#3	1.18438e-18
C82	C#3	B#1	2.16352e-17
C83	a_27_368##3	A#5	1.55575e-17
C84	A#8	B#4	5.03707e-17
C85	B#3	a_490_368##2	2.65546e-17
C86	VPWR#4	C#5	4.86939e-19
C87	VGND#3	Y#2	8.66831e-18
C88	a_27_368##3	B#3	3.48636e-17
C89	a_490_368##2	C#5	1.67208e-18
C90	D#1	C#3	3.01931e-17
C91	A#8	A#2	5.617e-18
C92	a_116_368#	B#3	7.33316e-19
C93	VPWR#4	D#5	2.51113e-19
C94	a_27_368##3	C#5	4.59454e-17
C95	a_490_368##2	D#5	4.37328e-19
C96	A#6	A#2	1.78236e-17
C97	a_116_368#	C#5	3.40326e-17
C98	VPWR#4	D#6	1.68918e-19
C99	B	A#3	3.78932e-20
C100	a_27_368##3	D#5	2.01228e-17
C101	VGND#3	VGND#6	8.51482e-19
C102	a_490_368##2	D#6	2.6655e-19
C103	a_116_368#	D#5	4.30824e-17
C104	a_27_368##5	B#3	3.45578e-19
C105	D#2	C#3	2.69464e-18
C106	VGND#3	Y#1	8.7177e-18
C107	B#2	A#6	2.62692e-17
C108	a_27_368##3	D#6	4.02864e-19
C109	D#5	Y#3	2.38677e-17
C110	a_490_368##2	C#1	2.54903e-19
C111	VGND#6	B#4	4.10972e-17
C112	a_27_368##5	C#5	4.97863e-19
C113	a_27_368##3	C#1	3.17398e-19
C114	Y#1	B#4	8.96069e-18
C115	D#6	Y#3	2.38677e-17
C116	A#6	C#4	1.90877e-19
C117	a_27_368##5	D#5	8.31459e-19
C118	VGND#7	B#4	1.0523e-19
C119	A#2	VGND#6	9.08313e-18
C120	a_116_368##2	D#6	4.69836e-17
C121	Y#2	C#4	3.42309e-17
C122	A#1	B#5	4.71863e-17
C123	a_27_368##5	D#6	1.5426e-17
C124	a_490_368##2	VPWR#3	1.16698e-17
C125	D#3	D#1	1.97231e-17
C126	Y	D#3	1.14696e-17
C127	a_116_368##2	C#1	3.07913e-17
C128	Y	D#2	5.7548e-18
C129	a_27_368##3	VPWR#3	1.71452e-18
C130	VGND#6	B#2	1.77775e-18
C131	B#4	a_27_368#	3.13422e-18
C132	a_27_368##5	C#1	4.62228e-17
C133	Y#1	B#2	4.00456e-17
C134	Y#2	C#2	5.07244e-17
C135	a_116_368#	VPWR#3	3.21662e-17
C136	A#5	A#1	4.82812e-17
C137	B#2	VGND#7	1.96748e-18
C138	a_27_368#	A#2	5.76823e-19
C139	a_490_368#	A#2	1.45718e-19
C140	a_116_368##2	VPWR#3	2.79549e-17
C141	Y#2	D#4	2.16277e-17
C142	VPWR#4	A#2	3.69078e-19
C143	C#4	VGND#7	5.95325e-19
C144	a_27_368##5	VPWR#3	2.35889e-17
C145	B#3	A#5	3.34275e-17
C146	B#2	a_27_368#	1.52816e-17
C147	a_490_368##2	A#2	2.39451e-19
C148	B#2	VPWR#4	1.2681e-18
C149	B#2	a_490_368##2	1.73921e-18
C150	VGND#3	A#4	7.59328e-19
C151	C#5	B#3	4.13027e-17
C152	B#2	a_27_368##3	6.23234e-17
C153	VGND#3	B#1	5.34595e-18
C154	VGND#7	D#4	1.45348e-19
C155	A#4	B#4	1.61175e-17
C156	VGND#3	C#3	5.36923e-18
C157	D#5	C#5	4.81996e-17
C158	B#4	B#1	7.67562e-20
C159	C#4	a_27_368##3	1.81213e-17
C160	VGND#3	D#1	7.01167e-19
C161	B#4	C#3	6.03005e-20
C162	D#6	D#5	4.47635e-17
C163	VPWR#3	B#3	4.91122e-18
C164	VGND	A#3	2.1457e-19
C165	a_116_368##2	C#2	1.81815e-19
C166	A#1	B#4	1.11268e-18
C167	C#1	D#6	4.52381e-17
C168	VPWR#3	C#5	5.30095e-18
C169	a_27_368##5	C#2	2.55413e-19
C170	VPWR#3	D#5	5.35183e-18
C171	a_116_368##2	D#4	6.93594e-20
C172	C#2	B#1	2.78746e-19
C173	a_27_368##5	D#4	9.3913e-19
C174	VPWR#3	D#6	5.35183e-18
C175	C#2	C#3	4.17212e-19
C176	VPWR#3	C#1	5.31154e-18
C177	B#2	A#5	1.92902e-17
C178	D#4	C#3	2.73084e-19
C179	B#2	B#3	2.81701e-18
C180	Y#2	C	4.66457e-17
C181	D#4	D#1	4.10263e-18
C182	B#2	C#5	5.94086e-19
C183	B#2	D#5	2.79204e-19
C184	D#5	C#4	2.97529e-18
C185	C	Y#5	7.91484e-19
C186	VGND#3	B#4	1.2764e-19
C187	A#8	B	2.50072e-17
C188	A#6	D#2	6.08842e-19
C189	A#6	B	1.46594e-17
C190	VPWR#3	B#2	2.18571e-20
C191	A#2	B#4	2.9687e-17
C192	VPWR#3	C#4	2.74064e-20
C193	C	a_27_368##3	5.67906e-17
C194	C	a_116_368#	1.16457e-17
C195	B#2	B#4	1.4442e-18
C196	VGND#3	C#4	6.62822e-20
C197	VPWR#3	C#2	5.77064e-20
C198	B#2	A#2	2.93329e-18
C199	Y#2	Y	3.57529e-18
C200	B	a_27_368#	7.82972e-17
C201	VGND#3	D#4	1.752e-21
C202	B	a_490_368#	2.99364e-19
C203	A#3	VNB	2.03582e-17
C204	C#4	B#2	6.29514e-17
C205	D#3	VNB	4.93184e-17
C206	D#2	VNB	2.49332e-17
C207	VPWR	A#8	1.47826e-18
C208	C#2	B#2	7.99503e-20
C209	VPWR	A#6	1.62542e-18
C210	C#2	C#4	1.19665e-19
C211	C	B#3	9.6885e-19
C212	Y	a_27_368##3	2.16166e-17
C213	C	C#5	8.3239e-18
C214	D#4	C#2	2.23514e-17
C215	VGND	A#8	6.15592e-18
C216	Y	Y#3	5.07242e-19
C217	C	D#5	7.96142e-18
C218	VGND	A#6	2.14314e-18
C219	Y	a_116_368##2	4.21902e-18
C220	VPWR	a_27_368#	1.86927e-17
C221	Y	a_27_368##5	9.92782e-17
C222	VGND	Y#2	2.62729e-17
C223	VPWR	a_490_368#	1.52825e-17
C224	B	B#5	7.54666e-18
C225	VPWR	VPWR#4	1.58509e-17
C226	VPWR	a_490_368##2	1.78528e-17
C227	B	A#1	1.33543e-17
C228	VPWR	a_27_368##3	1.11283e-17
C229	Y	C#3	1.64382e-19
C230	VPWR	a_116_368#	2.0161e-17
C231	Y	D#1	2.72811e-19
C232	VGND	Y#1	1.67996e-17
C233	VPWR	a_116_368##2	1.93499e-17
C234	VPWR	a_27_368##5	2.04108e-17
C235	VGND	a_27_368##3	2.6185e-18
C236	Y#2	D#3	2.59469e-17
C237	Y	C#5	9.71894e-19
C238	C	B#2	3.44229e-18
C239	Y	D#5	1.33979e-17
C240	VPWR	B#5	2.51369e-18
C241	C	C#4	6.19203e-18
C242	VPWR	A#1	9.90199e-19
C243	Y	D#6	2.18772e-17
C244	VPWR	A#5	5.69033e-19
C245	VGND	A#4	1.60095e-18
C246	Y	C#1	1.85383e-17
C247	C	C#2	8.44391e-20
C248	VGND	B#1	1.57311e-19
C249	VPWR	B#3	9.77692e-19
C250	B	B#4	5.84008e-18
C251	VGND	C#3	1.91129e-19
C252	VPWR	C#5	1.88123e-18
C253	B	A#2	1.73468e-19
C254	Y	VPWR#3	6.53859e-19
C255	VPWR	D#5	9.43267e-19
C256	B#2	B	2.12689e-19
C257	VPWR	D#6	9.44636e-19
C258	VPWR	C#1	2.80317e-18
C259	A#8	VNB	4.52803e-18
C260	A#6	VNB	1.71898e-18
C261	Y#2	VNB	6.90292e-18
C262	VPWR	VPWR#3	6.50599e-17
C263	Y#2	D#2	3.92827e-18
C264	Y	C#4	1.26333e-19
C265	VGND#6	VNB	1.31729e-18
C266	Y#1	VNB	4.40227e-18
C267	VGND#7	VNB	2.46232e-18
C268	Y	C#2	1.11895e-16
C269	a_27_368#	VNB	4.59372e-17
C270	VPWR	B#2	4.37018e-18
C271	Y	D#4	3.21895e-17
C272	a_490_368#	VNB	4.29644e-18
C273	VPWR#4	VNB	3.47481e-19
C274	VPWR	C#4	1.24099e-18
C275	a_490_368##2	VNB	5.79156e-18
C276	VGND	VGND#3	4.42014e-17
C277	a_27_368##3	VNB	2.64712e-18
C278	a_116_368#	VNB	3.4245e-18
C279	VGND	B#4	2.84326e-17
C280	a_116_368##2	VNB	3.23786e-18
C281	VGND	A#2	4.4314e-19
C282	a_27_368##5	VNB	4.88907e-17
C283	A#4	VNB	2.87791e-17
C284	VGND	B#2	4.94442e-18
C285	B#1	VNB	2.78146e-17
C286	C#3	VNB	2.85238e-17
C287	VGND	C#4	1.88816e-18
C288	D#1	VNB	2.42546e-17
C289	VGND	C#2	4.95043e-18
C290	B#5	VNB	4.31001e-17
C291	A#1	VNB	3.11614e-17
C292	VGND	D#4	2.01173e-17
C293	A#5	VNB	3.10194e-17
C294	B#3	VNB	3.01469e-17
C295	C#5	VNB	3.31694e-17
C296	C	Y	6.55305e-17
C297	D#5	VNB	3.90651e-17
C298	D#6	VNB	3.63388e-17
C299	C#1	VNB	5.07092e-17
C300	VPWR	C	4.02057e-18
C301	VPWR#3	VNB	2.74933e-16
C302	VGND#3	VNB	2.18142e-16
C303	B#4	VNB	2.16714e-16
C304	A#2	VNB	3.53696e-17
C305	B#2	VNB	3.37975e-17
C306	VGND	C	3.13412e-18
C307	VPWR	B	6.3613e-18
C308	C#4	VNB	3.74467e-17
C309	C#2	VNB	4.82023e-17
C310	D#4	VNB	9.01222e-17
C311	VPWR	Y	9.43974e-18
C312	VGND	B	2.36273e-18
C313	VGND	Y	9.54859e-18
C314	C	VNB	3.91937e-18
C315	B	VNB	1.81687e-17
C316	Y	VNB	6.15909e-17
C317	VPWR	VNB	7.35105e-17
C318	VGND	VNB	5.7597e-17
C319	VGND#2	B#2	2.474e-19
C320	VPWR#2	B#2	2.03143e-20
C321	VGND	VGND#2	6.75238e-17
C322	a_27_368##4	a_490_368##2	1.85827e-17
C323	VPWR#2	A#1	1.78651e-18
C324	VGND#2	A#4	7.05268e-18
C325	VGND	VGND#4	7.92883e-17
C326	VGND#4	C#3	1.79529e-18
C327	a_490_368##2	VPWR#2	1.17586e-17
C328	a_27_368#	VPWR#2	1.9009e-17
C329	a_27_368##4	VNB	4.97008e-18
C330	VGND#3	VGND#4	7.52871e-17
C331	B	VPWR#2	5.72833e-19
C332	VGND#2	A#2	3.43501e-19
C333	VPWR#3	VPWR#2	7.21897e-17
C334	VGND#4	VGND#7	1.85448e-18
C335	VGND#4	D#4	6.93172e-17
C336	VPWR#2	B#5	4.86011e-18
C337	VGND#2	VNB	6.07984e-17
C338	VGND#4	B#1	3.52176e-19
C339	a_27_368##4	C#5	4.72344e-18
C340	VGND#4	D#2	6.61832e-19
C341	VGND#4	VNB	7.09049e-17
C342	VGND#4	Y#2	9.11479e-17
C343	VGND#2	C#3	7.5026e-20
C344	VGND#2	B#4	4.31335e-17
C345	VPWR#2	VNB	6.15397e-17
C346	VPWR	VPWR#2	4.46438e-17
C347	VGND#2	A#8	3.03632e-18
C348	a_27_368##4	VPWR#3	1.67998e-17
C349	a_27_368##4	B#3	5.24553e-18
C350	VPWR#2	B#4	4.70443e-19
C351	a_116_368#	a_27_368##4	1.92022e-17
C352	VGND#4	Y	1.49702e-18
C353	VPWR	a_27_368##4	1.12219e-17
C354	VPWR#2	A#5	9.49107e-19
C355	VGND#2	Y#1	8.43179e-18
C356	VGND#4	D#3	7.27203e-18
C357	VGND#4	VGND#8	1.14713e-17
C358	VGND#2	B#1	5.31969e-19
C359	a_27_368##4	A#5	3.74125e-19
C360	VGND#3	VGND#2	6.97457e-17
C361	a_490_368#	VPWR#2	1.8406e-17
C362	VGND#4	D#1	1.3024e-17
C363	a_27_368##4	a_27_368##3	6.85729e-18
C364	VGND#2	B	3.05795e-19
*
*
.ENDS sky130_fd_sc_hs__nor4_2
*
