* Extracted by Quantus, converted by sky130cad/quantus.py
*
*
*
*                       LINUX           Wed Nov 18 09:12:58 2026
*
*
*
*  PROGRAM  advgen
*
*  Name           : advgen - Quantus - (64-bit)
*  Version        : 25.1.0-p047
*  Build Date     : Thu Dec 11 23:20:30 PST 2025
*
*  HSPICE LIBRARY
*
*  OPERATING_TEMPERATURE 150
*  QRC_TECH_DIR <path>/tech
*
*
*

*
.SUBCKT sky130_fd_sc_hs__sedfxtp_2 VNB VPB VGND VPWR Q D SCE SCD CLK DE
*
*
*  caps2d version: 10
*
*
*       TRANSISTOR CARDS
*
*
XM37 a_40_464# D#3 a_138_74# VNB sky130_fd_pr__nfet_01v8_lvt l=0.15 w=0.42 ad=0.1197 as=0.1008 pd=1.41 ps=1.32
XM17 a_138_74# DE#5 VGND#22 VNB sky130_fd_pr__nfet_01v8_lvt l=0.15 w=0.42 ad=0.1008 as=0.1197 pd=1.32 ps=1.41
XM43 a_180_290##9 DE#7 VGND#21 VNB sky130_fd_pr__nfet_01v8_lvt l=0.15 w=0.42 ad=0.1197 as=0.1176 pd=1.41 ps=1.4
XM9 VGND#21 a_180_290##3 a_500_113# VNB sky130_fd_pr__nfet_01v8_lvt l=0.15 w=0.42 ad=0.1176 as=0.1008 pd=1.4 ps=1.32
XM18 a_500_113# a_548_87##3 a_40_464##5 VNB sky130_fd_pr__nfet_01v8_lvt l=0.15 w=0.42 ad=0.1008 as=0.1785 pd=1.32 ps=1.69
XM1 a_40_464##5 a_663_87##2 a_693_113##8 VNB sky130_fd_pr__nfet_01v8_lvt l=0.15 w=0.42 ad=0.1785 as=0.1491 pd=1.69 ps=1.55
XM41 a_663_87##10 SCE#2 VGND#20 VNB sky130_fd_pr__nfet_01v8_lvt l=0.15 w=0.42 ad=0.1197 as=0.147 pd=1.41 ps=1.54
XM38 VGND#20 SCD#3 a_1068_125# VNB sky130_fd_pr__nfet_01v8_lvt l=0.15 w=0.42 ad=0.147 as=0.0882 pd=1.54 ps=1.26
XM7 a_1068_125# SCE#1 a_693_113##10 VNB sky130_fd_pr__nfet_01v8_lvt l=0.15 w=0.42 ad=0.0882 as=0.1197 pd=1.26 ps=1.41
XM19 VGND#19 CLK#3 a_1340_74##16 VNB sky130_fd_pr__nfet_01v8_lvt l=0.15 w=0.74 ad=0.2183 as=0.2109 pd=2.07 ps=2.05
XM2 VGND#18 a_1340_74##9 a_1538_74##16 VNB sky130_fd_pr__nfet_01v8_lvt l=0.15 w=0.74 ad=0.2109 as=0.2109 pd=2.05 ps=2.05
XM25 a_693_113# a_1340_74# a_1736_97##6 VNB sky130_fd_pr__nfet_01v8_lvt l=0.15 w=0.42 ad=0.1197 as=0.2226 pd=1.41 ps=1.9
XM4 a_1736_97##6 a_1538_74##4 a_1872_97# VNB sky130_fd_pr__nfet_01v8_lvt l=0.15 w=0.42 ad=0.2226 as=0.2247 pd=1.9 ps=1.91
XM5 a_1872_97# a_1979_71##3 VGND#17 VNB sky130_fd_pr__nfet_01v8_lvt l=0.15 w=0.42 ad=0.2247 as=0.352 pd=1.91 ps=2.53
XM39 VGND#17 a_1736_97# a_1979_71##11 VNB sky130_fd_pr__nfet_01v8_lvt l=0.15 w=0.64 ad=0.352 as=0.1824 pd=2.53 ps=1.85
XM34 VGND#16 a_1979_71##4 a_2402_74# VNB sky130_fd_pr__nfet_01v8_lvt l=0.15 w=0.64 ad=0.1824 as=0.1344 pd=1.85 ps=1.7
XM10 a_2402_74# a_1538_74##5 a_2474_74##13 VNB sky130_fd_pr__nfet_01v8_lvt l=0.15 w=0.64 ad=0.1344 as=0.1915 pd=1.7 ps=1.93
XM14 a_2474_74##13 a_1340_74##10 a_2569_74# VNB sky130_fd_pr__nfet_01v8_lvt l=0.15 w=0.42 ad=0.1915 as=0.1008 pd=1.93 ps=1.32
XM11 a_2569_74# a_548_87##4 VGND#14 VNB sky130_fd_pr__nfet_01v8_lvt l=0.15 w=0.42 ad=0.1008 as=0.4011 pd=1.32 ps=2.75
XM32 VGND#14 a_2474_74##9 a_548_87##13 VNB sky130_fd_pr__nfet_01v8_lvt l=0.15 w=0.42 ad=0.4011 as=0.1197 pd=2.75 ps=1.41
XM33 Q#1 a_2474_74##7 VGND#13 VNB sky130_fd_pr__nfet_01v8_lvt l=0.15 w=0.74 ad=0.2072 as=0.2627 pd=2.04 ps=2.19
XM42 VGND#1 a_2474_74##6 Q#1 VNB sky130_fd_pr__nfet_01v8_lvt l=0.15 w=0.74 ad=0.2627 as=0.2072 pd=2.19 ps=2.04
XM35 a_40_464##3 D#1 a_129_464# VPB sky130_fd_pr__pfet_01v8 l=0.15 w=0.64 ad=0.1888 as=0.1728 pd=1.87 ps=1.82
XM24 a_129_464# a_180_290# VPWR#21 VPB sky130_fd_pr__pfet_01v8 l=0.15 w=0.64 ad=0.1728 as=0.1888 pd=1.82 ps=1.87
XM12 a_180_290##8 DE#6 VPWR#19 VPB sky130_fd_pr__pfet_01v8 l=0.15 w=0.64 ad=0.1888 as=0.3392 pd=1.87 ps=2.34
XM40 VPWR#19 DE#1 a_575_463# VPB sky130_fd_pr__pfet_01v8 l=0.15 w=0.64 ad=0.3392 as=0.1536 pd=2.34 ps=1.76
XM6 a_575_463# a_548_87# a_40_464##6 VPB sky130_fd_pr__pfet_01v8 l=0.15 w=0.64 ad=0.1536 as=0.192 pd=1.76 ps=1.88
XM30 a_40_464##6 SCE#5 a_693_113##6 VPB sky130_fd_pr__pfet_01v8 l=0.15 w=0.64 ad=0.192 as=0.1856 pd=1.88 ps=1.86
XM15 a_663_87##9 SCE#4 VPWR#16 VPB sky130_fd_pr__pfet_01v8 l=0.15 w=0.64 ad=0.1856 as=0.3392 pd=1.86 ps=2.34
XM0 VPWR#16 SCD#1 a_1079_455# VPB sky130_fd_pr__pfet_01v8 l=0.15 w=0.64 ad=0.3392 as=0.1728 pd=2.34 ps=1.82
XM27 a_1079_455# a_663_87##4 a_693_113##4 VPB sky130_fd_pr__pfet_01v8 l=0.15 w=0.64 ad=0.1728 as=0.1888 pd=1.82 ps=1.87
XM3 VPWR#14 CLK#1 a_1340_74##14 VPB sky130_fd_pr__pfet_01v8 l=0.15 w=1.12 ad=0.336 as=0.3304 pd=2.84 ps=2.83
XM28 VPWR#12 a_1340_74##8 a_1538_74##17 VPB sky130_fd_pr__pfet_01v8 l=0.15 w=1.12 ad=0.3304 as=0.3304 pd=2.83 ps=2.83
XM29 a_693_113##9 a_1538_74# a_1736_97##7 VPB sky130_fd_pr__pfet_01v8 l=0.15 w=0.42 ad=0.1239 as=0.126 pd=1.43 ps=1.44
XM8 a_1736_97##7 a_1340_74##7 a_1936_508# VPB sky130_fd_pr__pfet_01v8 l=0.15 w=0.42 ad=0.126 as=0.168 pd=1.44 ps=1.64
XM36 a_1936_508# a_1979_71# VPWR#9 VPB sky130_fd_pr__pfet_01v8 l=0.15 w=0.42 ad=0.168 as=0.29575 pd=1.64 ps=2.71
XM20 VPWR#9 a_1736_97##3 a_1979_71##8 VPB sky130_fd_pr__pfet_01v8 l=0.15 w=0.84 ad=0.29575 as=0.2478 pd=2.71 ps=2.27
XM16 VPWR#7 a_1979_71##7 a_2357_392# VPB sky130_fd_pr__pfet_01v8 l=0.15 w=1 ad=0.305 as=0.81 pd=2.61 ps=3.62
XM31 a_2357_392# a_1340_74##12 a_2474_74##11 VPB sky130_fd_pr__pfet_01v8 l=0.15 w=1 ad=0.81 as=0.3175 pd=3.62 ps=2.78
XM21 a_2474_74##11 a_1538_74##7 a_2657_508# VPB sky130_fd_pr__pfet_01v8 l=0.15 w=0.42 ad=0.3175 as=0.1134 pd=2.78 ps=1.38
XM13 a_2657_508# a_548_87##6 VPWR#5 VPB sky130_fd_pr__pfet_01v8 l=0.15 w=0.42 ad=0.1134 as=0.2935 pd=1.38 ps=2.4
XM22 VPWR#5 a_2474_74##10 a_548_87##14 VPB sky130_fd_pr__pfet_01v8 l=0.15 w=0.64 ad=0.2935 as=0.1888 pd=2.4 ps=1.87
XM26 VPWR#3 a_2474_74##8 Q#2 VPB sky130_fd_pr__pfet_01v8 l=0.15 w=1.12 ad=0.3304 as=0.3528 pd=2.83 ps=2.87
XM23 Q#2 a_2474_74# VPWR#1 VPB sky130_fd_pr__pfet_01v8 l=0.15 w=1.12 ad=0.3528 as=0.3304 pd=2.87 ps=2.83
*
*
*       RESISTOR AND CAP/DIODE CARDS
*
Rg1	D#1	D#2	446.848755
Rg2	D#2	D#3	353.802551
Rg3	a_180_290#	a_180_290##2	414.090027
Rg4	a_180_290##3	a_180_290##4	486.740265
Rg5	DE#1	DE#2	587.980652
Rg6	DE#2	DE#3	486.548340
Rg7	DE#3	DE#4	54.238338
Rg8	DE#4	DE#5	611.094482
Rg9	DE#2	DE#6	234.008942
Rg10	DE#4	DE#7	292.601105
Rg11	a_548_87#	a_548_87##2	472.162933
Rg12	a_548_87##2	a_548_87##3	483.995209
Rg13	a_663_87#	a_663_87##2	509.704773
Rg15	SCD#1	SCD#2	458.738525
Rg16	SCD#2	SCD#3	365.323883
Rg17	SCE#1	SCE#2	1137.625000
Rg18	SCE#2	SCE#3	229.884171
Rg19	SCE#3	SCE#4	560.387146
Rg20	SCE#4	SCE#5	1013.675781
Rg21	a_663_87##4	a_663_87##5	343.705231
Rg22	CLK#1	CLK#2	501.658508
Rg23	CLK#2	CLK#3	312.076324
Rg24	a_1538_74#	a_1538_74##2	474.028198
Rg25	a_1538_74##3	a_1538_74##4	253.533188
Rg26	a_1340_74#	a_1340_74##2	499.902802
Rg27	a_1340_74##2	a_1340_74##3	138.393555
Rg28	a_1340_74##3	a_1340_74##4	159.377762
Rg29	a_1340_74##4	a_1340_74##5	29.296654
Rg30	a_1340_74##2	a_1340_74##6	711.244873
Rg31	a_1340_74##6	a_1340_74##7	244.902328
Rg32	a_1340_74##3	a_1340_74##8	378.438324
Rg33	a_1340_74##4	a_1340_74##9	470.717743
Rg34	a_1979_71#	a_1979_71##2	637.686829
Rg35	a_1979_71##2	a_1979_71##3	329.630157
Rg36	a_1736_97#	a_1736_97##2	493.632751
Rg37	a_1736_97##2	a_1736_97##3	350.619171
Rg38	a_1979_71##4	a_1979_71##5	354.974213
Rg39	a_1979_71##5	a_1979_71##6	37.804382
Rg40	a_1979_71##5	a_1979_71##7	507.442535
Rg41	a_1538_74##5	a_1538_74##6	480.096283
Rg42	a_1340_74##10	a_1340_74##11	543.221130
Rg43	a_1340_74##11	a_1340_74##12	400.207520
Rg44	a_1538_74##7	a_1538_74##8	580.499084
Rg45	a_548_87##4	a_548_87##5	1143.037354
Rg46	a_548_87##5	a_548_87##6	233.787552
Rg47	a_2474_74#	a_2474_74##2	515.031616
Rg48	a_2474_74##2	a_2474_74##3	94.288521
Rg49	a_2474_74##3	a_2474_74##4	241.344833
Rg50	a_2474_74##4	a_2474_74##5	73.601135
Rg51	a_2474_74##2	a_2474_74##6	449.889130
Rg52	a_2474_74##3	a_2474_74##7	426.131927
Rg53	a_2474_74##3	a_2474_74##8	434.739838
Rg54	a_2474_74##4	a_2474_74##9	487.269745
Rg55	a_2474_74##5	a_2474_74##10	357.674103
Rf1	D#4	D	1.296877
Rf2	D#2	D#6	54.707813
Rf3	D#4	D#6	6.537743
Rf4	D#7	D	1.296877
Rf5	D#6	D#7	6.193651
Rf6	DE	DE#3	167.318909
Rf7	a_180_290##4	a_180_290##6	190.868851
Rf8	a_180_290##6	a_180_290##2	58.551537
Rf9	a_180_290##6	a_180_290##8	44.937363
Rf10	a_180_290##2	a_180_290##9	89.681847
Rf11	a_548_87##2	a_548_87##8	170.665131
Rf12	a_40_464#	a_40_464##2	140.053284
Rf13	a_40_464##2	a_40_464##3	16.298851
Rf14	a_40_464##2	a_40_464##4	277.477966
Rf15	a_40_464##4	a_40_464##5	115.554611
Rf16	a_40_464##4	a_40_464##6	21.310108
Rf17	SCE	SCE#6	1.013386
Rf18	SCE#7	SCE#3	161.246185
Rf19	SCE#6	SCE#7	4.330400
Rf20	SCD	SCD#4	2.405834
Rf21	SCD#5	SCD#2	162.638641
Rf22	SCD#4	SCD#5	8.248361
Rf23	a_663_87##5	a_663_87##7	195.600555
Rf24	a_663_87##7	a_663_87##8	41.275391
Rf25	a_663_87##7	a_663_87##9	47.403221
Rf26	a_663_87##8	a_663_87##10	37.285294
Rf27	CLK	CLK#4	1.411932
Rf28	CLK#5	CLK#2	161.644730
Rf29	CLK#4	CLK#5	3.543054
Rf30	a_1340_74##5	a_1340_74##15	89.504860
Rf31	a_1340_74##15	a_1340_74##16	97.016479
Rf32	a_1340_74##14	a_1340_74##15	15.000000
Rf33	a_693_113#	a_693_113##2	134.891144
Rf34	a_693_113##2	a_693_113##3	130.595306
Rf35	a_693_113##3	a_693_113##5	5.750323
Rf36	a_693_113##5	a_693_113##7	197.142059
Rf37	a_693_113##7	a_693_113##8	138.678162
Rf38	a_693_113##2	a_693_113##9	76.685242
Rf39	a_693_113##3	a_693_113##10	123.857605
Rf40	a_693_113##4	a_693_113##5	7.500000
Rf41	a_693_113##6	a_693_113##7	7.500000
Rf42	a_1736_97##2	a_1736_97##5	256.284515
Rf43	a_1736_97##5	a_1736_97##6	96.899315
Rf44	a_1736_97##5	a_1736_97##7	78.291382
Rf45	a_1979_71##8	a_1979_71##9	75.986488
Rf46	a_1979_71##9	a_1979_71##2	228.475525
Rf47	a_1979_71##9	a_1979_71##11	52.507526
Rf48	a_1979_71##9	a_1979_71##6	103.447784
Rf49	a_1340_74##11	a_1340_74##6	593.047424
Rf50	a_1538_74##8	a_1538_74##10	223.773849
Rf51	a_1538_74##10	a_1538_74##11	269.406036
Rf52	a_1538_74##11	a_1538_74##12	86.213364
Rf53	a_1538_74##12	a_1538_74##2	112.395523
Rf54	a_1538_74##10	a_1538_74##6	175.007614
Rf55	a_1538_74##11	a_1538_74##3	170.480377
Rf56	a_1538_74##12	a_1538_74##16	82.548958
Rf57	a_1538_74##2	a_1538_74##17	30.539669
Rf58	a_2474_74##11	a_2474_74##12	77.582031
Rf59	a_2474_74##12	a_2474_74##13	162.662247
Rf60	a_2474_74##12	a_2474_74##5	110.889275
Rf61	a_548_87##9	a_548_87##10	20.490664
Rf62	a_548_87##10	a_548_87##11	50.208111
Rf63	a_548_87##11	a_548_87##5	216.840927
Rf64	a_548_87##10	a_548_87##13	57.874352
Rf65	a_548_87##11	a_548_87##14	17.599407
Rf66	Q	Q#1	52.015247
Rf67	Q	Q#2	45.076874
Rf68	VPWR#1	VPWR#2	116.596130
Rf69	VPWR#2	VPWR#3	40.799759
Rf70	VPWR#2	VPWR#4	67.153305
Rf71	VPWR#4	VPWR#5	25.558413
Rf72	VPWR#4	VPWR#6	181.081863
Rf73	VPWR#6	VPWR#7	31.473843
Rf74	VPWR#6	VPWR#8	80.300789
Rf75	VPWR#8	VPWR#9	31.948624
Rf76	VPWR#8	VPWR#10	21.890615
Rf77	VPWR#10	VPWR#11	157.764526
Rf78	VPWR#11	VPWR#12	32.342297
Rf79	VPWR#11	VPWR#13	101.670860
Rf80	VPWR#13	VPWR#14	32.484024
Rf81	VPWR#13	VPWR#15	101.728203
Rf82	VPWR#15	VPWR#16	39.585419
Rf83	VPWR#15	VPWR#17	129.697449
Rf84	VPWR#17	VPWR#18	54.455437
Rf85	VPWR#18	VPWR#19	37.794724
Rf86	VPWR#18	VPWR#20	105.258347
Rf87	VPWR#20	VPWR#21	37.538910
Rf89	VGND#1	VGND#2	116.762550
Rf90	VGND#2	VGND#3	88.198669
Rf91	VGND#3	VGND#4	140.462585
Rf92	VGND#4	VGND#5	124.839584
Rf93	VGND#5	VGND#6	198.730164
Rf94	VGND#6	VGND#7	72.742805
Rf95	VGND#7	VGND#8	96.061615
Rf96	VGND#8	VGND#9	123.430809
Rf97	VGND#9	VGND#10	83.983536
Rf98	VGND#10	VGND#11	72.270927
Rf100	VGND#2	VGND#13	34.835796
Rf101	VGND#3	VGND#15	6.177463
Rf102	VGND#15	VGND#14	15.000000
Rf103	VGND#4	VGND#16	37.027283
Rf104	VGND#5	VGND#17	40.211403
Rf105	VGND#6	VGND#18	41.038895
Rf106	VGND#7	VGND#19	36.232010
Rf107	VGND#8	VGND#20	43.365131
Rf108	VGND#10	VGND#21	42.184113
Rf109	VGND#11	VGND#22	34.507496
Rf110	VGND#14	VGND#15	15.000000
Rf119	a_663_87#	a_663_87##8	32.046562
Re1	a_548_87##9	a_548_87##8	40.765961
Re2	VPWR#2	VPWR#24	3.473447
Re3	VPWR#24	VPWR	0.737527
Re4	VPWR	VPWR#17	2.542229
Re5	VGND#2	VGND#24	3.473447
Re6	VGND#24	VGND	0.737527
Re7	VGND	VGND#9	2.542229
Re11	VPWR#10	VPWR#24	0.698413
Re14	VGND#5	VGND#24	0.698413
*
*       CAPACITOR CARDS
*
*
C1	a_548_87##9	a_1736_97##7	1.19274e-18
C2	a_40_464##6	a_548_87#	2.99034e-17
C3	DE#5	DE#7	3.65956e-18
C4	a_663_87##5	SCE#2	6.97767e-20
C5	a_1340_74##14	a_1340_74##9	1.29586e-18
C6	SCE#1	SCD#2	3.32504e-19
C7	a_548_87##8	DE#1	9.32439e-18
C8	a_180_290##2	VPWR#21	3.88961e-18
C9	a_1538_74##16	a_1538_74##12	2.66851e-18
C10	VPWR#19	SCE#5	4.03832e-19
C11	a_1979_71##9	a_1979_71##7	5.01795e-19
C12	a_1736_97##5	VPWR#10	2.99631e-19
C13	VPWR#17	a_548_87#	1.58815e-17
C14	a_1736_97##2	a_1979_71##7	1.54668e-18
C15	VGND#6	a_1340_74##14	6.45747e-19
C16	VGND#9	SCE#5	1.74409e-19
C17	a_693_113##6	DE#1	3.76287e-19
C18	a_40_464##2	DE#6	2.33794e-18
C19	SCD#4	CLK#2	9.48637e-19
C20	a_548_87##9	VPWR#2	3.48919e-17
C21	DE#4	DE#2	8.96136e-20
C22	a_548_87##9	a_693_113##9	1.6388e-18
C23	a_663_87##7	a_663_87##5	1.43469e-18
C24	a_1979_71##3	VGND#17	1.29664e-17
C25	a_40_464##4	VPWR#18	3.59403e-17
C26	VGND#3	a_548_87##4	3.39962e-17
C27	VGND#17	VGND#4	3.50804e-20
C28	a_693_113##2	VPWR#12	5.00858e-17
C29	VPWR#17	DE#1	4.40583e-18
C30	a_1538_74##16	a_693_113#	5.11941e-17
C31	SCE#2	SCD#2	4.2804e-19
C32	a_548_87##8	a_1340_74##4	2.11621e-18
C33	VPWR#1	a_2474_74#	4.17981e-17
C34	a_40_464##6	DE#1	2.8275e-18
C35	VPWR#8	VPWR#6	7.61879e-19
C36	VGND#2	a_548_87##9	3.5079e-17
C37	VGND#13	VGND#1	1.84033e-18
C38	a_40_464##4	DE#2	5.83021e-18
C39	a_693_113##9	a_1736_97##7	4.49835e-17
C40	a_2474_74##5	a_548_87##11	3.66024e-17
C41	VPWR#19	a_548_87#	2.6482e-18
C42	CLK#2	a_1340_74##4	7.19049e-18
C43	VPWR#17	DE#6	4.41508e-18
C44	a_40_464##2	VPWR#21	7.32265e-17
C45	VPWR#11	a_1340_74##3	3.34495e-20
C46	VGND#3	a_1340_74##11	1.27671e-19
C47	VGND#9	a_40_464#	2.36572e-17
C48	SCE#3	SCD#3	4.84771e-18
C49	VGND#9	DE#1	1.76456e-19
C50	a_40_464##4	a_180_290#	1.00991e-19
C51	a_548_87##8	a_1340_74##3	9.32918e-19
C52	CLK#4	SCD#2	7.30425e-20
C53	a_1979_71##2	a_1736_97##3	5.45771e-18
C54	VGND#3	a_2474_74##12	3.09976e-17
C55	D#3	DE#5	4.79478e-17
C56	a_40_464#	a_180_290##9	3.83344e-19
C57	a_548_87##9	VPWR#10	4.78509e-18
C58	VPWR#15	SCE#4	1.46204e-17
C59	a_40_464##2	DE#5	1.05908e-18
C60	a_548_87##5	VPWR#4	4.19076e-17
C61	SCD#5	a_663_87##5	5.55418e-17
C62	a_548_87##10	a_2474_74##5	6.46651e-17
C63	a_2474_74#	Q#2	2.73814e-17
C64	a_1340_74##6	a_1979_71##7	4.34257e-19
C65	a_40_464##2	a_40_464##4	3.10847e-18
C66	VPWR#17	a_180_290#	6.01681e-19
C67	VGND#4	a_1340_74##10	1.33169e-19
C68	a_40_464##2	DE#4	2.87072e-19
C69	a_548_87##8	a_1340_74##2	2.10603e-18
C70	VGND#17	a_1538_74##4	2.11451e-18
C71	a_40_464##2	a_180_290#	2.81366e-17
C72	VPWR#18	DE#2	2.48323e-19
C73	a_40_464##6	DE#6	3.79243e-19
C74	SCD#4	a_663_87##5	8.63112e-18
C75	VGND#10	DE#1	4.61273e-19
C76	VPWR#1	a_2474_74##8	2.83999e-18
C77	a_1340_74##6	a_1736_97##3	3.17963e-17
C78	a_548_87##9	VGND#5	5.60184e-18
C79	a_663_87##7	SCD#2	7.30447e-19
C80	VPWR#19	DE#1	3.05248e-17
C81	a_1736_97##5	VPWR#11	1.00917e-19
C82	VPWR#13	SCE#4	2.53322e-19
C83	VPWR#17	D#1	1.83353e-18
C84	a_180_290##6	DE#7	7.29256e-19
C85	a_693_113##2	a_1340_74##14	9.61665e-17
C86	VPWR#3	a_2474_74#	3.33337e-18
C87	VGND#13	Q#1	5.46095e-17
C88	a_1340_74##6	a_1979_71#	5.83483e-17
C89	a_2474_74##7	a_2474_74##6	3.97221e-17
C90	a_2474_74##12	a_2474_74##5	1.95982e-17
C91	a_1736_97##5	a_1736_97##3	1.77166e-19
C92	a_2474_74##3	a_2474_74##2	5.20675e-18
C93	VGND#3	a_1340_74##10	8.29556e-18
C94	a_2474_74##3	a_2474_74#	1.68878e-18
C95	a_40_464#	VGND#22	1.68101e-17
C96	VGND#4	a_1538_74##6	1.71665e-19
C97	a_40_464#	D#6	1.31062e-17
C98	VGND#20	a_663_87##7	1.79304e-18
C99	a_2474_74##8	Q#2	2.12301e-17
C100	VPWR#18	SCE#5	1.19061e-18
C101	a_1340_74##6	a_1340_74##7	2.13802e-18
C102	VGND#17	a_1979_71##2	1.99803e-18
C103	a_548_87##5	a_548_87##11	2.43011e-18
C104	a_693_113##9	VPWR#11	2.30818e-17
C105	DE#6	VPWR#19	2.29074e-17
C106	VPWR#11	a_1340_74##2	1.21169e-19
C107	SCD#5	SCD#2	1.42509e-17
C108	a_1736_97##7	VPWR#10	2.08337e-17
C109	a_693_113##9	a_1538_74##17	1.11266e-17
C110	a_1538_74#	a_1340_74##6	1.44885e-18
C111	a_548_87##8	DE#2	3.0764e-19
C112	a_40_464##2	DE#2	1.41993e-18
C113	VGND#18	a_1538_74##16	7.07657e-17
C114	a_1340_74##16	a_693_113#	9.23297e-19
C115	VPWR#4	a_1538_74##8	4.03621e-19
C116	a_40_464##2	D#1	4.72492e-17
C117	SCD#4	SCD#2	9.26261e-18
C118	VPWR#3	a_2474_74##8	7.08184e-17
C119	a_1736_97##6	a_1538_74##4	6.11928e-18
C120	a_180_290##6	a_180_290#	1.74918e-19
C121	a_693_113##4	a_1079_455#	2.62502e-18
C122	VGND#4	a_1538_74##5	5.70013e-18
C123	DE#6	a_180_290##8	9.208e-18
C124	SCE#3	a_663_87##7	8.59455e-18
C125	a_1340_74##8	a_1340_74##6	6.52238e-19
C126	a_693_113##4	SCE#1	9.36451e-19
C127	a_548_87##13	Q#1	8.55345e-18
C128	VPWR#3	a_2474_74##5	4.96338e-19
C129	D#4	a_40_464#	5.89643e-17
C130	a_693_113##2	VPWR#14	1.74858e-20
C131	VPWR#21	DE#6	4.8684e-19
C132	a_548_87##9	a_2474_74##5	3.77711e-17
C133	a_40_464##2	a_40_464##3	3.07118e-18
C134	VPWR#12	a_693_113##9	8.0753e-18
C135	a_2474_74##9	a_2474_74##7	4.35582e-18
C136	a_2474_74##12	a_548_87##5	6.31548e-17
C137	a_663_87##10	a_663_87##7	1.25315e-18
C138	VGND#3	a_1538_74##5	3.06612e-19
C139	a_548_87##8	VGND#5	4.59916e-19
C140	a_180_290##8	a_180_290#	4.29846e-19
C141	VGND#4	a_1979_71##6	4.94183e-19
C142	VPWR#3	a_2474_74##10	3.10524e-18
C143	VPWR#2	a_2474_74##5	3.61801e-18
C144	CLK#4	a_1340_74##4	1.04589e-20
C145	SCE#3	SCD#5	1.39864e-17
C146	SCD#4	a_693_113##10	8.78067e-18
C147	VPWR#18	a_548_87#	7.8712e-19
C148	a_1538_74##10	a_2474_74##12	3.49444e-19
C149	a_548_87##9	a_548_87##5	7.09074e-18
C150	a_2474_74##5	VPWR#5	1.75065e-18
C151	a_1340_74##11	VPWR#6	1.18671e-17
C152	a_1340_74#	a_1736_97##6	1.49976e-17
C153	a_1340_74##8	a_1538_74##2	1.15007e-17
C154	SCE#3	SCD#4	2.67673e-17
C155	a_180_290##6	D#1	5.37072e-19
C156	VGND#4	VGND#3	1.73025e-20
C157	VGND#2	a_2474_74##5	4.47382e-18
C158	VPWR#21	a_180_290#	3.44218e-17
C159	VPWR#2	a_548_87##5	7.54589e-18
C160	a_548_87##13	VGND#13	4.59332e-17
C161	a_1340_74##11	VPWR#4	1.37224e-18
C162	DE#7	a_180_290##4	4.98251e-18
C163	a_548_87##9	a_1538_74##8	2.32954e-17
C164	VPWR#15	a_548_87#	1.86162e-19
C165	a_1538_74##2	CLK#1	9.9073e-20
C166	a_2474_74##10	a_548_87##14	2.18671e-17
C167	a_548_87##13	a_548_87##11	6.87305e-19
C168	VGND#4	a_1979_71##4	6.88608e-18
C169	a_548_87##8	VPWR#17	7.96476e-17
C170	VGND#6	a_1538_74##12	3.09059e-17
C171	a_693_113##4	a_693_113##2	1.22138e-18
C172	VPWR#13	VPWR#12	2.8307e-19
C173	a_2474_74##11	a_2474_74##5	2.50039e-18
C174	a_693_113#	a_1340_74#	1.1828e-17
C175	VPWR#2	a_1538_74##8	7.4444e-19
C176	a_548_87##8	a_693_113##9	2.79042e-18
C177	VPWR#3	a_548_87##6	1.93029e-19
C178	a_548_87##9	a_1340_74##11	4.90726e-17
C179	a_693_113##4	SCE#2	1.37343e-19
C180	a_693_113#	a_1538_74##17	2.18464e-17
C181	a_180_290##2	a_663_87##2	4.34892e-19
C182	a_2474_74##8	a_2474_74#	4.46284e-17
C183	a_548_87##5	VPWR#5	1.2028e-18
C184	a_693_113##8	a_663_87##7	1.19672e-17
C185	a_1340_74##16	VGND#18	7.28806e-17
C186	a_548_87##8	a_693_113##2	4.01819e-17
C187	VGND#9	a_548_87##8	8.40506e-17
C188	a_2474_74##10	VPWR#5	5.56096e-18
C189	VPWR#21	D#1	4.69045e-18
C190	a_1538_74##8	a_2474_74##12	4.58295e-17
C191	a_548_87##4	a_2474_74##9	1.20435e-17
C192	a_180_290##2	a_548_87##3	1.69007e-19
C193	VGND#2	a_1538_74##8	4.30129e-19
C194	a_180_290##6	a_40_464##4	3.7252e-17
C195	a_548_87##8	a_1538_74##17	1.47076e-17
C196	a_548_87##9	a_1538_74##6	3.75847e-17
C197	a_2474_74##5	a_2474_74##3	1.44875e-18
C198	a_1736_97##6	a_1538_74##3	4.99882e-18
C199	VGND#7	CLK#4	5.77679e-19
C200	VGND#3	a_1979_71##4	1.67873e-19
C201	a_180_290##2	a_180_290##3	1.4464e-19
C202	VGND#1	VPWR#1	2.30757e-19
C203	a_1538_74##16	a_1340_74#	1.99856e-18
C204	VPWR#18	DE#1	7.00939e-18
C205	VPWR#6	a_1538_74##6	1.86535e-19
C206	D#7	D#1	4.20118e-18
C207	a_548_87##8	VPWR#12	3.6532e-18
C208	a_663_87##7	a_548_87##2	1.14517e-19
C209	a_2474_74##11	a_548_87##5	3.38249e-17
C210	a_548_87##9	a_1979_71##6	3.51443e-17
C211	a_693_113#	a_1340_74##9	3.19159e-18
C212	VGND#6	a_1538_74##16	5.16622e-17
C213	a_180_290##2	DE#5	1.73138e-17
C214	D#1	a_40_464##3	6.79375e-18
C215	a_548_87##6	VPWR#5	1.23391e-17
C216	a_663_87##5	CLK#1	5.6919e-18
C217	VGND#19	VGND#18	2.15684e-18
C218	a_548_87##8	a_1340_74##14	7.98716e-17
C219	a_2474_74##10	a_2474_74##8	4.81874e-18
C220	VGND#9	DE#4	1.33846e-18
C221	a_548_87##9	a_1736_97##2	4.68392e-17
C222	VGND#4	a_1736_97#	6.46829e-19
C223	a_2474_74##11	a_2474_74##10	5.06989e-19
C224	CLK#4	a_1340_74##14	1.16377e-17
C225	a_1538_74##2	a_1736_97##6	1.24683e-17
C226	a_180_290##6	a_40_464##2	9.95425e-18
C227	a_548_87##8	VPWR#14	2.67224e-18
C228	VGND#20	SCD#4	3.53372e-17
C229	D#2	DE#5	9.57441e-18
C230	VGND#9	DE#2	4.57595e-19
C231	a_1538_74##16	a_1340_74##9	5.88882e-17
C232	a_1340_74##11	a_2474_74##12	1.16013e-18
C233	a_1340_74##10	a_548_87##4	4.57632e-17
C234	a_663_87##5	SCD#1	2.28484e-17
C235	a_2474_74##11	a_1538_74##8	4.8566e-17
C236	a_548_87##9	a_1979_71##2	1.78422e-17
C237	a_693_113#	a_1538_74##2	4.27752e-17
C238	a_1340_74##16	a_1340_74#	9.89939e-20
C239	a_548_87##8	a_693_113##4	4.33409e-17
C240	D#4	DE#5	5.15434e-18
C241	a_40_464##5	DE#4	5.08992e-19
C242	a_693_113#	CLK#3	5.86735e-20
C243	VPWR#15	VPWR#14	2.51745e-19
C244	a_548_87##5	a_2474_74##5	6.59405e-17
C245	VPWR#14	VPWR#12	6.05584e-18
C246	VPWR#6	a_1979_71##6	2.64354e-19
C247	a_1340_74##14	a_693_113#	3.19464e-18
C248	a_548_87##9	a_1340_74##6	2.50639e-17
C249	VPWR#18	DE#6	6.14426e-18
C250	VGND#19	a_1340_74##16	2.9905e-17
C251	Q#2	VPWR#1	5.86798e-17
C252	a_2474_74##11	a_548_87##6	6.13843e-18
C253	a_180_290##6	DE#4	1.6333e-19
C254	a_1340_74##9	VGND#18	1.84717e-17
C255	a_548_87##6	a_2474_74##10	9.50998e-18
C256	SCE#4	SCD#2	1.80736e-18
C257	a_2474_74##5	a_1538_74##8	2.8139e-20
C258	a_548_87##9	a_1538_74##3	1.56388e-18
C259	a_1340_74##11	a_2474_74##11	6.83503e-17
C260	VGND#5	a_1736_97##2	8.64473e-20
C261	a_1538_74##16	CLK#3	2.06419e-19
C262	VPWR#10	a_1979_71##2	1.10171e-19
C263	a_548_87##8	VPWR#16	1.64743e-18
C264	a_1736_97##5	a_1340_74##8	1.56195e-19
C265	VPWR#17	a_693_113##4	3.06812e-17
C266	a_1538_74##8	a_548_87##5	4.04145e-17
C267	a_40_464##4	a_548_87##2	1.33782e-17
C268	a_548_87##8	a_663_87##7	6.0688e-17
C269	a_1340_74##16	a_1340_74##9	1.84905e-18
C270	a_2474_74##12	a_548_87##13	1.75129e-17
C271	a_548_87##9	a_1538_74##2	4.47533e-18
C272	VGND#7	a_1340_74##16	9.64681e-18
C273	a_1538_74##5	a_1340_74##10	3.13119e-17
C274	a_1340_74##6	VPWR#10	8.29282e-18
C275	VPWR#3	VPWR#1	1.98293e-18
C276	a_2474_74##11	a_1538_74##7	4.72111e-17
C277	a_548_87##8	a_663_87##9	2.62323e-18
C278	D#4	D#3	6.16757e-18
C279	a_1340_74##11	a_548_87##5	2.64758e-19
C280	a_693_113##2	VPWR#13	2.55204e-18
C281	a_693_113##10	a_1340_74##16	1.55736e-17
C282	a_1538_74##12	a_1538_74##11	3.09956e-18
C283	a_1340_74##11	VPWR#7	1.73618e-17
C284	VGND#18	CLK#3	2.10517e-18
C285	VPWR#7	a_548_87##6	1.99994e-19
C286	a_548_87##4	a_2569_74#	8.35249e-18
C287	VGND#5	a_1340_74##6	1.41274e-19
C288	a_180_290##6	DE#2	4.6239e-17
C289	a_548_87##10	a_2474_74##3	2.44698e-19
C290	a_1538_74##7	a_548_87##6	2.6365e-17
C291	a_548_87##8	a_693_113##6	5.20644e-18
C292	a_1340_74##10	a_2569_74#	8.35249e-18
C293	a_1538_74##8	a_1340_74##11	7.80987e-17
C294	VGND#8	VGND#19	1.90453e-18
C295	a_693_113##4	VPWR#15	4.74081e-18
C296	VGND#19	a_1340_74##9	4.01017e-19
C297	VPWR#18	a_180_290#	1.44216e-19
C298	a_1979_71##8	a_1340_74##11	6.21497e-18
C299	a_693_113##4	a_1340_74##14	2.83438e-17
C300	a_1538_74##10	a_1340_74##11	2.28892e-17
C301	VGND#18	a_1340_74##14	1.08087e-17
C302	VGND#5	a_1538_74##3	9.27736e-19
C303	a_693_113#	CLK#2	7.48402e-19
C304	a_548_87##2	SCE#4	3.43807e-19
C305	a_1538_74##6	a_1538_74##8	3.10816e-18
C306	a_180_290##6	a_548_87##2	1.07974e-18
C307	VPWR#17	a_663_87##9	3.96645e-18
C308	a_1340_74##16	CLK#3	5.02543e-17
C309	a_2474_74##13	a_548_87##13	9.94241e-19
C310	a_2474_74##11	a_1340_74##12	1.75956e-17
C311	VPWR#3	Q#2	6.56509e-17
C312	VGND#6	a_1340_74##16	1.09491e-17
C313	a_180_290##4	a_40_464##4	5.06249e-18
C314	a_548_87##8	SCD#5	3.95032e-17
C315	a_548_87##6	a_2657_508#	1.06762e-17
C316	VPWR#17	a_663_87##7	5.15294e-18
C317	a_693_113##10	VGND#19	1.30717e-17
C318	VPWR#7	a_1538_74##7	7.77535e-19
C319	a_1538_74##6	a_1340_74##11	8.26296e-17
C320	VGND#4	a_1538_74##10	4.22632e-17
C321	a_693_113##10	a_1340_74##9	2.58495e-19
C322	a_548_87##9	a_548_87##4	6.23433e-21
C323	a_693_113##6	VPWR#17	9.31511e-17
C324	a_1538_74##7	a_2657_508#	1.06762e-17
C325	VGND#18	SCE#1	6.40625e-20
C326	a_693_113##4	VPWR#13	1.85825e-17
C327	a_1979_71##4	a_1538_74##5	5.31411e-17
C328	a_693_113##2	VPWR#11	1.14906e-17
C329	a_548_87##8	a_1538_74##2	2.92564e-17
C330	a_1979_71##8	a_1538_74##6	2.05004e-18
C331	a_693_113##4	VPWR#14	5.90083e-17
C332	a_1340_74##12	a_1538_74##7	2.85929e-17
C333	a_1979_71##6	a_1340_74##11	3.38813e-18
C334	CLK#3	VGND#19	1.17477e-17
C335	a_548_87##2	DE#1	1.0194e-17
C336	VGND#9	CLK#4	4.06158e-18
C337	a_40_464##6	VPWR#17	3.00892e-17
C338	a_548_87##8	VPWR#19	2.47239e-18
C339	a_1340_74##16	CLK#2	2.34623e-18
C340	VGND#2	a_2474_74##7	1.04439e-17
C341	a_2474_74##11	a_1979_71##7	2.72032e-18
C342	a_1979_71##6	a_1538_74##6	4.57164e-17
C343	a_548_87##11	VPWR#4	4.9452e-17
C344	a_1340_74##11	a_1736_97##2	1.69096e-19
C345	a_1340_74##16	SCE#1	1.42827e-18
C346	CLK#2	VGND#19	1.91059e-18
C347	VPWR#7	a_1979_71##6	7.43992e-19
C348	a_40_464##2	D#7	5.86504e-17
C349	VPWR#7	a_1340_74##12	3.18042e-18
C350	a_1538_74##5	a_2402_74#	1.01094e-17
C351	VGND#8	a_693_113##10	7.50676e-19
C352	a_1340_74##12	a_2357_392#	3.40554e-17
C353	a_180_290##4	DE#1	1.45045e-18
C354	a_1538_74##10	a_1538_74##6	5.36249e-18
C355	a_2474_74##12	a_2474_74##9	1.42585e-18
C356	VGND#6	a_1340_74#	3.27853e-18
C357	a_1979_71##4	a_2402_74#	1.25298e-17
C358	a_1538_74##6	a_1736_97##2	5.65969e-19
C359	a_693_113##2	a_1340_74##8	2.85446e-17
C360	a_693_113##10	CLK#3	6.704e-18
C361	a_40_464##4	DE#3	9.24513e-20
C362	a_548_87##8	CLK#2	2.2488e-17
C363	a_1979_71##7	a_2357_392#	1.94662e-17
C364	VPWR#17	SCD#5	1.3447e-18
C365	a_693_113##10	CLK#2	2.56246e-17
C366	a_663_87##2	SCE#5	1.16922e-18
C367	VGND#9	a_663_87##7	2.41654e-18
C368	a_663_87##7	a_693_113##4	3.35978e-17
C369	a_40_464##2	DE#3	6.0323e-19
C370	VGND#13	a_548_87##9	1.33807e-17
C371	VPWR#17	CLK#2	3.77306e-18
C372	a_1736_97##2	a_1979_71##6	1.49306e-17
C373	a_1979_71##8	a_1340_74##12	1.24938e-18
C374	VGND#19	SCE#1	4.11634e-18
C375	a_1979_71##7	a_1340_74##12	8.62999e-18
C376	a_548_87##8	a_663_87##5	4.73326e-17
C377	a_1340_74##9	a_1340_74##2	7.22266e-19
C378	SCE#4	a_663_87##10	5.98251e-19
C379	VPWR#4	a_2474_74##8	8.75661e-19
C380	a_1736_97#	a_1979_71##4	3.15602e-18
C381	VPWR#17	a_180_290##8	6.40441e-18
C382	CLK#4	a_1340_74##9	9.77681e-20
C383	a_1979_71##2	a_1979_71##6	4.9896e-19
C384	VPWR#7	a_1979_71##7	4.49644e-17
C385	VPWR#17	a_663_87##5	4.75114e-18
C386	a_548_87##9	a_548_87##13	5.91408e-18
C387	a_1538_74##11	a_1538_74##10	2.72841e-18
C388	a_548_87##8	a_40_464##4	5.52385e-17
C389	a_548_87##8	SCD#2	3.10758e-20
C390	VGND#7	a_1340_74##9	1.97017e-19
C391	VPWR#19	DE#2	4.23615e-19
C392	VGND#7	a_693_113##10	9.73371e-18
C393	VPWR#16	VPWR#14	1.70952e-18
C394	a_1538_74##11	a_1979_71##6	2.12097e-19
C395	a_1340_74##6	VPWR#8	3.5592e-18
C396	VGND#20	VGND#19	4.24169e-18
C397	a_693_113##10	a_1340_74##14	4.57961e-19
C398	a_1736_97##2	a_1979_71##8	1.70562e-17
C399	VGND#9	a_663_87##5	4.51114e-18
C400	DE#3	a_180_290##6	2.46103e-17
C401	a_1736_97##2	a_1979_71##2	1.08936e-16
C402	a_1979_71#	a_1936_508#	1.06888e-17
C403	a_1979_71##6	a_1340_74##6	4.30039e-18
C404	a_693_113##10	SCE#1	4.13054e-17
C405	a_693_113##10	a_663_87##5	4.53937e-17
C406	a_548_87##9	VGND#4	3.95434e-18
C407	a_548_87##8	SCE#3	1.44387e-17
C408	a_1340_74##7	a_1936_508#	1.21508e-17
C409	a_1979_71##8	a_1979_71##7	5.40394e-18
C410	a_1340_74##6	VPWR#6	4.58975e-18
C411	a_1538_74##10	a_1979_71##6	8.36386e-17
C412	a_2474_74##12	a_548_87##4	1.78444e-17
C413	a_693_113##2	CLK#1	1.56649e-18
C414	VGND#20	CLK#3	6.44272e-19
C415	a_1736_97##2	VPWR#9	1.81567e-18
C416	a_1736_97##2	a_1340_74##6	2.10934e-17
C417	a_548_87##10	a_2474_74#	2.48404e-19
C418	a_1340_74##16	a_693_113##4	3.6711e-19
C419	VGND#19	SCD#3	2.93549e-19
C420	a_40_464##2	a_180_290##2	5.96597e-17
C421	a_1736_97##3	a_1979_71##7	3.84913e-18
C422	VPWR#17	SCE#3	1.07449e-18
C423	D#1	a_180_290##2	1.84412e-17
C424	VGND#6	a_1340_74##9	7.5354e-18
C425	DE#2	a_548_87##2	4.2664e-19
C426	VPWR#7	a_1736_97##3	4.50688e-18
C427	a_663_87##7	SCD#5	6.69922e-18
C428	a_548_87##9	VGND#3	1.47841e-17
C429	a_1340_74##6	a_1979_71##2	1.74377e-17
C430	VGND#9	SCD#4	5.33908e-18
C431	a_1979_71##3	a_1872_97#	1.57785e-18
C432	a_693_113##4	VPWR#16	4.39023e-17
C433	a_693_113#	a_1340_74##4	9.68815e-19
C434	VGND#2	VGND#1	6.87042e-17
C435	a_40_464##2	a_138_74#	2.32468e-19
C436	VGND#8	CLK#3	3.76613e-19
C437	VGND#9	SCE#3	2.15279e-18
C438	VPWR#9	a_1979_71##7	2.07687e-18
C439	a_1538_74##4	a_1872_97#	1.21366e-17
C440	a_1979_71##8	a_1979_71##2	4.42042e-19
C441	a_693_113##8	SCE#5	3.06097e-19
C442	a_1979_71##3	a_1736_97#	8.65809e-18
C443	a_1979_71##9	a_1538_74##6	1.04068e-18
C444	VGND#20	a_693_113##10	1.62369e-17
C445	VPWR#4	a_2474_74##10	1.60227e-17
C446	VGND#1	a_2474_74##6	2.63136e-17
C447	a_2474_74##13	a_2474_74##12	5.05283e-19
C448	a_1538_74##3	a_1979_71##2	2.50412e-17
C449	a_1736_97##6	a_1340_74##2	1.74881e-19
C450	a_548_87##8	a_548_87##2	2.47094e-17
C451	a_1979_71#	a_1979_71##7	3.3824e-19
C452	a_40_464##4	VPWR#17	2.66331e-17
C453	a_548_87##9	a_2474_74##13	7.93445e-18
C454	a_693_113##10	SCD#3	2.92281e-18
C455	a_693_113##10	SCD#2	7.07254e-19
C456	a_1979_71##8	a_1736_97##3	3.98914e-17
C457	VGND#2	Q#1	3.34257e-17
C458	a_180_290##9	DE#4	2.40631e-17
C459	a_180_290##6	a_180_290##2	2.94599e-19
C460	VGND#6	a_1340_74##4	2.0685e-20
C461	VGND#19	a_693_113##4	1.02991e-18
C462	a_40_464##2	D#6	2.07376e-18
C463	a_548_87##11	a_2474_74##8	1.42139e-18
C464	D#6	DE#3	8.44713e-20
C465	VPWR#17	a_548_87##2	2.78911e-20
C466	a_1538_74##3	a_1340_74##6	2.12378e-17
C467	a_1538_74##2	a_1979_71##2	1.71023e-19
C468	VGND#20	SCE#1	6.23878e-18
C469	a_1538_74##11	a_1736_97##2	1.0977e-18
C470	VPWR#17	a_40_464##2	5.00859e-17
C471	a_548_87##8	a_180_290##4	4.86394e-17
C472	VGND#7	CLK#3	7.30486e-18
C473	VGND#19	SCE#2	2.71285e-19
C474	a_1340_74##6	VPWR#7	2.79167e-17
C475	VPWR#7	a_1979_71#	1.86964e-18
C476	D#4	DE#3	6.01321e-20
C477	VGND#9	a_548_87##2	1.89023e-19
C478	a_1979_71#	a_1736_97##3	3.04846e-17
C479	a_663_87##9	a_693_113##4	3.36221e-17
C480	a_663_87##4	a_1079_455#	1.53973e-17
C481	VGND#2	VGND#13	1.11241e-17
C482	a_1340_74##6	a_1538_74##2	1.98504e-17
C483	a_693_113##2	a_663_87##4	4.70647e-20
C484	VPWR#17	a_180_290##4	6.55337e-19
C485	a_1736_97##3	VPWR#9	2.26267e-17
C486	a_40_464##2	D#2	8.10346e-18
C487	VGND#20	SCD#2	7.36702e-19
C488	DE#2	a_180_290##8	1.07144e-18
C489	Q#1	a_2474_74##6	4.08958e-17
C490	a_40_464##4	a_693_113##8	6.35135e-18
C491	SCD#1	a_1079_455#	1.53973e-17
C492	a_1340_74##6	a_1979_71##8	5.32797e-17
C493	a_2474_74##12	a_1340_74##10	2.35466e-19
C494	a_693_113#	a_1340_74##3	9.3257e-18
C495	DE#3	a_548_87##8	5.03377e-18
C496	a_548_87##10	a_2474_74##8	1.13793e-18
C497	VGND#1	a_2474_74##2	1.80744e-18
C498	a_548_87##9	VGND#16	2.41113e-18
C499	a_1736_97##7	a_1979_71##7	5.44592e-19
C500	VGND#9	a_180_290##4	4.13219e-18
C501	D#7	a_180_290##2	4.45951e-17
C502	VGND#10	DE#4	2.63377e-19
C503	a_1538_74##2	a_1538_74##3	5.87511e-19
C504	VGND#2	a_548_87##13	3.30601e-17
C505	a_1979_71##8	a_1979_71#	3.06336e-18
C506	a_693_113##10	a_693_113##4	7.57185e-19
C507	VPWR#17	DE#3	3.08607e-18
C508	VGND#6	CLK#3	8.52646e-19
C509	a_1340_74##6	VPWR#9	4.09449e-17
C510	VGND#5	a_1979_71##4	1.007e-19
C511	DE#4	a_180_290##4	2.16186e-18
C512	VGND#1	a_2474_74##7	1.41935e-18
C513	a_693_113##10	SCE#3	1.37316e-19
C514	a_548_87##8	a_180_290##2	2.02615e-18
C515	VGND#8	SCD#4	1.15004e-18
C516	VGND#9	DE#3	2.27525e-18
C517	VGND#8	SCE#1	2.10789e-17
C518	a_1979_71##9	a_1979_71##6	1.14817e-17
C519	a_1538_74##4	a_1979_71##3	9.15256e-18
C520	VGND#20	SCD#3	3.19831e-17
C521	a_180_290##4	DE#2	2.68924e-17
C522	D#6	a_180_290##2	1.84553e-17
C523	VPWR#17	a_180_290##2	5.56084e-18
C524	VPWR#4	a_548_87##6	2.34751e-17
C525	VGND#13	a_2474_74##6	1.465e-18
C526	VGND#5	a_1736_97#	6.34525e-18
C527	a_693_113#	a_693_113##2	1.07612e-18
C528	VPWR#18	a_693_113##6	1.98328e-18
C529	VPWR#9	a_1979_71#	2.49344e-17
C530	VPWR#17	a_180_290##6	3.16228e-18
C531	a_1538_74##16	a_1340_74##4	1.41905e-18
C532	a_1340_74##7	a_1979_71#	1.64651e-17
C533	VPWR#11	a_1538_74##2	8.18512e-19
C534	D#4	a_180_290##2	1.95537e-17
C535	a_1736_97##5	a_1979_71##6	2.52497e-19
C536	VGND#9	a_180_290##2	1.46924e-18
C537	a_548_87##11	a_2474_74##10	3.48584e-17
C538	a_1736_97##7	a_1340_74##6	3.18967e-17
C539	a_1538_74##11	a_1979_71##2	7.87519e-17
C540	a_548_87##9	VGND#17	1.61631e-18
C541	a_1736_97##7	a_1736_97##3	8.66646e-19
C542	VGND#6	a_1340_74##3	1.2192e-19
C543	a_548_87#	a_575_463#	1.41968e-17
C544	a_693_113#	a_1340_74##2	1.04288e-17
C545	Q#1	a_2474_74##7	4.2121e-17
C546	VGND#5	a_1979_71##3	4.71627e-18
C547	a_40_464##5	a_40_464##4	1.30888e-18
C548	VGND#7	CLK#2	1.2817e-19
C549	SCE#3	a_663_87##10	1.96837e-17
C550	VGND#7	SCE#1	1.39136e-18
C551	a_663_87##10	SCD#3	1.01686e-18
C552	a_693_113##9	a_1340_74##2	1.40837e-18
C553	VGND#22	DE#4	4.50927e-18
C554	a_2474_74##5	a_2474_74##7	8.31825e-19
C555	DE#1	a_575_463#	1.41968e-17
C556	a_663_87##7	a_663_87##9	1.92068e-17
C557	a_2474_74##12	VPWR#4	4.81644e-19
C558	D#7	D#2	1.34891e-17
C559	a_2474_74##12	a_1538_74##5	4.43634e-20
C560	a_548_87##9	VPWR#11	7.15999e-19
C561	VGND#16	a_2474_74##13	1.19298e-17
C562	a_548_87##13	a_2474_74##6	1.67628e-19
C563	VGND#2	a_2474_74##13	9.21964e-19
C564	VGND#1	a_2474_74##9	1.44934e-19
C565	VGND#5	a_1538_74##4	3.21523e-18
C566	a_693_113##6	VPWR#15	4.76767e-17
C567	SCE#2	VGND#20	1.29212e-17
C568	VPWR#9	a_1340_74##7	3.95443e-18
C569	CLK#4	SCD#3	6.70114e-21
C570	VGND#10	DE#2	5.22794e-19
C571	VGND#8	a_663_87##10	7.57924e-18
C572	D#6	D#2	6.3087e-18
C573	VGND#13	a_2474_74##7	1.65725e-17
C574	a_1736_97##7	a_1979_71#	3.40475e-18
C575	VGND#6	SCE#1	6.31274e-20
C576	a_548_87##9	VPWR#8	1.36755e-18
C577	a_1538_74##16	a_1340_74##3	4.41582e-18
C578	a_1538_74#	a_1340_74##7	2.12231e-17
C579	a_1979_71##9	a_1736_97##2	5.31575e-17
C580	a_1340_74#	a_1538_74##4	9.32469e-18
C581	VGND#2	VGND#3	9.79208e-17
C582	VPWR#17	D#7	5.42888e-18
C583	a_548_87##4	a_2474_74##5	5.99667e-18
C584	a_663_87##5	CLK#2	8.92626e-18
C585	D#4	D#2	1.13376e-17
C586	a_1538_74##16	a_693_113##2	1.18089e-17
C587	a_1538_74##12	a_1340_74##6	1.57048e-20
C588	a_180_290#	a_129_464#	1.53896e-17
C589	VGND#8	SCD#3	2.51976e-18
C590	a_1979_71##9	a_1979_71##8	1.01248e-18
C591	DE#3	DE#4	5.50459e-18
C592	a_1538_74##12	a_1538_74##17	6.80807e-19
C593	VPWR#4	a_1538_74##7	7.22619e-18
C594	a_693_113##6	VPWR#16	3.80463e-17
C595	a_1538_74##17	a_1340_74##3	2.43796e-18
C596	a_663_87##10	SCE#2	2.5995e-17
C597	Q#1	a_2474_74##9	3.25197e-19
C598	a_663_87##10	VGND#20	3.76949e-17
C599	a_1736_97##5	a_1736_97##2	2.33785e-18
C600	D#1	a_129_464#	1.59113e-17
C601	SCD#2	CLK#2	6.61676e-19
C602	a_548_87##9	VPWR#6	7.19554e-18
C603	SCE#1	a_1068_125#	8.8457e-18
C604	a_1340_74##4	a_1340_74##2	1.3821e-18
C605	a_1538_74##11	a_1340_74##6	5.4446e-18
C606	a_548_87##11	a_548_87##6	6.32922e-19
C607	SCD#3	a_1068_125#	8.8457e-18
C608	VGND#8	a_663_87##5	1.16001e-18
C609	VPWR#9	a_1538_74#	6.74543e-19
C610	VGND#6	a_1340_74##2	1.49568e-20
C611	a_693_113##6	a_663_87##7	3.52555e-17
C612	a_548_87##13	a_2474_74##7	3.38643e-18
C613	a_663_87##5	SCD#2	5.67682e-17
C614	VGND#18	a_1340_74##4	4.83122e-18
C615	a_1736_97##7	a_1538_74##2	1.45937e-17
C616	a_1736_97##5	a_1340_74##2	2.29375e-17
C617	a_1736_97##7	a_1340_74##7	2.76737e-17
C618	a_548_87##4	a_548_87##5	1.32094e-18
C619	VGND#13	a_2474_74##3	8.12623e-18
C620	a_548_87##9	VPWR#4	1.1114e-17
C621	VGND#7	a_663_87##5	1.5086e-19
C622	a_663_87##5	SCE#3	1.45254e-19
C623	a_1538_74##10	a_548_87##4	9.19771e-20
C624	a_180_290#	DE#2	5.24424e-19
C625	a_1340_74##8	a_1538_74#	4.57948e-18
C626	VGND#13	a_2474_74##9	2.98857e-18
C627	a_693_113##6	a_663_87##9	9.7263e-17
C628	a_1538_74##2	a_693_113##9	4.23937e-17
C629	a_1736_97##5	a_1979_71##8	9.88262e-19
C630	a_1538_74##17	a_1340_74##2	8.0155e-18
C631	VPWR#6	a_1340_74##12	4.1684e-18
C632	SCE#3	SCD#2	3.0363e-17
C633	a_1340_74##4	VPWR#12	7.35649e-19
C634	a_1340_74##9	a_1340_74#	5.05242e-18
C635	a_1979_71##2	a_1979_71##9	2.96333e-18
C636	a_1340_74##11	a_2357_392#	1.46383e-17
C637	VPWR#9	a_1340_74##8	4.54096e-19
C638	a_548_87##4	a_1538_74##8	2.69728e-17
C639	VPWR#12	a_1979_71#	3.34224e-19
C640	Q	a_2474_74##3	1.57339e-17
C641	a_693_113##8	a_548_87##2	7.48911e-19
C642	a_1538_74##12	a_1538_74##3	2.95017e-19
C643	Q	a_2474_74##2	2.24963e-17
C644	VPWR#4	VPWR#3	1.78667e-18
C645	a_1538_74##6	a_2357_392#	5.45079e-18
C646	a_1736_97##7	a_1538_74#	2.49392e-17
C647	a_1736_97##5	a_1979_71##2	1.05007e-17
C648	VPWR#4	a_1340_74##12	2.56132e-18
C649	VGND#8	SCE#2	1.86789e-17
C650	a_548_87##13	a_2474_74##9	3.75516e-17
C651	a_40_464##5	a_548_87##2	1.79762e-17
C652	a_1538_74##11	a_1538_74##3	2.08278e-17
C653	a_548_87##8	SCE#1	2.84684e-18
C654	a_693_113##8	a_663_87##2	1.88527e-17
C655	a_548_87##11	a_1538_74##7	1.7424e-19
C656	VPWR#3	a_2474_74##3	2.52574e-18
C657	CLK#1	a_1340_74##8	2.22617e-18
C658	a_180_290##2	DE#4	1.85688e-17
C659	a_548_87##9	a_548_87##11	4.42363e-18
C660	VGND#8	SCD#2	4.47672e-19
C661	a_1340_74##3	VPWR#12	1.16534e-18
C662	a_1538_74#	a_693_113##9	1.3048e-17
C663	VGND#3	VGND#13	2.07529e-18
C664	VGND#13	a_548_87##4	8.29976e-20
C665	a_1340_74##11	a_548_87##4	8.00085e-19
C666	VPWR#2	VPWR#4	9.21499e-17
C667	a_663_87##7	SCE#2	7.44539e-20
C668	a_180_290##2	DE#2	1.10853e-17
C669	a_1538_74##10	a_1340_74##10	7.32168e-19
C670	VPWR#12	a_1340_74##7	3.48785e-19
C671	VGND#9	D#4	9.31202e-18
C672	SCD#4	SCE#1	1.20819e-18
C673	a_2474_74##9	VGND#14	4.76563e-18
C674	a_1736_97##7	a_1340_74##8	1.16111e-18
C675	a_548_87##9	a_548_87##10	2.1517e-17
C676	a_40_464##5	a_663_87##2	4.63655e-17
C677	SCE	a_663_87##7	4.17625e-18
C678	VGND#10	a_548_87##8	5.13633e-18
C679	a_40_464##6	a_693_113##6	4.13049e-17
C680	VPWR#6	a_1979_71##7	3.95958e-18
C681	CLK#3	a_1340_74##9	4.78164e-18
C682	a_548_87##13	a_2474_74##3	7.61379e-19
C683	VGND#5	VGND#4	4.82117e-19
C684	a_663_87##7	SCD#1	8.89285e-20
C685	a_1979_71##9	a_1340_74##6	1.57632e-19
C686	a_1340_74##6	a_1936_508#	4.35084e-18
C687	a_40_464##5	a_180_290##4	8.80474e-19
C688	a_180_290##4	a_548_87##2	3.77917e-17
C689	a_548_87##13	a_548_87##4	3.73841e-18
C690	a_548_87##9	a_2474_74#	3.05512e-19
C691	a_693_113##8	a_548_87##3	1.03887e-18
C692	a_1538_74##5	a_1340_74##11	3.63246e-18
C693	a_1538_74##12	a_1538_74##2	4.90405e-19
C694	a_548_87##9	a_2474_74##3	1.87417e-17
C695	a_693_113##9	a_1340_74##8	3.76581e-18
C696	a_663_87##4	CLK#1	4.50666e-18
C697	a_1736_97##5	a_1340_74##6	8.08636e-17
C698	a_548_87##8	VGND#8	5.17243e-18
C699	a_548_87##8	a_663_87##2	9.74503e-19
C700	DE#3	a_548_87##2	6.28056e-19
C701	VPWR#13	a_663_87##5	1.03277e-19
C702	a_1340_74##14	a_1340_74##4	4.53561e-17
C703	VGND#9	SCE#1	3.8918e-18
C704	VPWR#12	a_1538_74#	2.71554e-18
C705	VPWR#4	a_1979_71##7	4.24332e-19
C706	D#4	DE#4	1.10242e-19
C707	VGND#21	a_180_290##4	1.81367e-17
C708	DE#3	a_180_290##4	5.38235e-17
C709	a_180_290##2	a_548_87##2	2.45998e-19
C710	a_1736_97##2	a_1340_74##2	3.81399e-20
C711	a_548_87##9	a_2474_74##12	3.38719e-17
C712	a_548_87##9	a_2474_74##2	1.47396e-19
C713	a_548_87##3	a_500_113#	9.87534e-18
C714	a_548_87##8	VGND#7	3.90872e-18
C715	VPWR#2	a_2474_74#	5.21533e-19
C716	a_180_290##3	a_500_113#	9.87534e-18
C717	a_1538_74##17	a_1340_74##8	3.16067e-17
C718	a_548_87##11	VPWR#2	3.50911e-17
C719	a_40_464##5	a_548_87##3	3.41377e-17
C720	VGND#9	SCD#3	2.16632e-18
C721	a_180_290##2	a_180_290##4	5.15844e-18
C722	a_548_87##4	VGND#14	1.76189e-17
C723	VPWR#8	a_1736_97##3	6.39015e-18
C724	SCD#4	SCD#3	2.63156e-18
C725	CLK#2	a_1340_74##14	3.02707e-17
C726	VGND#8	SCE#3	1.06913e-18
C727	VPWR#17	a_663_87##2	4.13716e-19
C728	VGND#3	a_548_87##13	4.02309e-17
C729	a_1538_74##10	a_1538_74##5	7.99911e-18
C730	DE#3	a_40_464##5	3.59175e-18
C731	a_548_87##13	a_2474_74##2	2.93024e-19
C732	VGND#21	a_663_87##2	8.45526e-19
C733	a_180_290##2	DE#3	7.79896e-17
C734	a_548_87##8	VGND#6	5.38512e-18
C735	VPWR#15	SCE#1	8.20988e-20
C736	D#2	DE#4	5.70029e-19
C737	a_1538_74##10	a_2474_74##13	4.88965e-17
C738	a_693_113##8	a_180_290##3	3.42271e-19
C739	VPWR#2	a_2474_74##8	5.82768e-18
C740	VGND#9	SCE#2	4.79655e-18
C741	a_2474_74##13	a_2474_74##9	4.0665e-19
C742	VPWR#14	CLK#2	6.59515e-19
C743	a_548_87##10	VPWR#2	1.1328e-18
C744	a_663_87##7	SCE#4	3.34823e-17
C745	SCE#1	CLK#3	5.89018e-18
C746	a_548_87##13	a_1340_74##10	1.1303e-19
C747	SCD#1	a_663_87##4	3.68278e-17
C748	VPWR#12	a_1340_74##8	3.84352e-17
C749	SCE#4	CLK#1	1.01141e-19
C750	a_1979_71##9	a_1538_74##3	1.5102e-19
C751	a_548_87##10	Q	3.92625e-18
C752	D#2	DE#3	1.26541e-18
C753	VPWR#7	a_2474_74##11	5.48679e-18
C754	VPWR#19	a_693_113##6	1.90309e-18
C755	CLK#2	a_693_113##4	5.65651e-18
C756	VGND#10	a_548_87##3	3.21899e-18
C757	Q#1	a_2474_74##5	4.06115e-19
C758	a_40_464##5	a_693_113##8	8.41996e-17
C759	D#2	a_180_290##2	4.6642e-17
C760	VGND#9	a_663_87##2	1.36814e-17
C761	a_1979_71##6	a_1538_74##5	1.00014e-17
C762	a_548_87##11	VPWR#3	7.3981e-17
C763	a_1736_97##5	a_1538_74##3	6.76911e-18
C764	a_1538_74##11	a_1979_71##4	1.88148e-19
C765	a_180_290##9	a_663_87##2	6.62052e-19
C766	a_1340_74##14	a_663_87##5	2.25371e-18
C767	a_180_290##9	DE#3	3.01241e-17
C768	a_1538_74##11	a_1979_71##9	1.41279e-17
C769	a_40_464##5	a_180_290##3	3.51503e-18
C770	VPWR#4	VPWR#5	6.9536e-18
C771	a_1340_74##14	a_1340_74##8	2.71656e-18
C772	a_1538_74##12	a_1736_97##5	2.62987e-19
C773	VPWR#15	VPWR#13	6.46899e-19
C774	VGND#9	a_548_87##3	1.00244e-17
C775	SCE	a_663_87##10	1.65e-17
C776	VGND#21	a_548_87##3	4.00074e-18
C777	VPWR#2	a_2474_74##12	2.03701e-18
C778	a_1340_74##14	a_1340_74##2	3.481e-19
C779	VPWR#2	a_2474_74##3	1.96517e-19
C780	SCD#4	SCE#2	6.57246e-19
C781	VPWR#12	CLK#1	3.83199e-18
C782	DE#5	a_138_74#	9.7209e-18
C783	VPWR#19	a_40_464##6	1.20038e-17
C784	D#3	a_138_74#	1.01349e-17
C785	SCE#4	SCD#1	1.75222e-17
C786	a_548_87##13	a_2474_74##5	3.75174e-17
C787	a_1736_97#	a_1979_71##6	8.5979e-18
C788	a_2474_74##13	a_548_87##4	2.35489e-17
C789	VPWR#14	a_1340_74##8	1.42239e-18
C790	a_40_464##4	a_575_463#	2.43631e-18
C791	a_663_87##5	a_693_113##4	1.2804e-16
C792	VGND#9	a_180_290##3	4.41093e-18
C793	a_548_87##9	a_1538_74##12	1.70737e-18
C794	a_548_87##9	a_1340_74##2	1.62135e-18
C795	a_1538_74##10	a_1979_71##4	2.03624e-17
C796	a_2474_74##12	a_548_87##10	7.32147e-19
C797	a_1736_97##5	a_1736_97##7	1.81632e-18
C798	a_1340_74##2	a_1979_71##2	1.50062e-18
C799	VGND#3	VGND#14	1.52837e-17
C800	a_663_87##7	SCE#5	1.03644e-18
C801	VPWR	VPWR#13	2.83914e-17
C802	VPWR#2	a_2474_74##2	5.53491e-20
C803	VPWR	VPWR#11	1.10498e-16
C804	a_548_87##10	VPWR#3	8.28459e-18
C805	SCE#1	SCD#3	6.05724e-17
C806	VPWR	VPWR#8	4.77849e-17
C807	VPWR	VPWR#6	1.10554e-16
C808	CLK#1	a_1340_74##14	3.3559e-17
C809	a_1538_74##10	a_2402_74#	2.9904e-18
C810	VPWR	VPWR#4	4.01724e-17
C811	VGND#2	a_548_87##10	1.51021e-20
C812	a_180_290##9	a_548_87##3	4.47395e-19
C813	VGND#9	DE#7	4.00999e-18
C814	a_180_290##9	a_180_290##2	2.90968e-18
C815	a_1538_74##3	a_1872_97#	1.50578e-18
C816	a_40_464##5	DE#7	1.13288e-18
C817	a_548_87##9	a_1538_74##11	2.19404e-17
C818	a_693_113##4	a_1340_74##8	5.76005e-19
C819	a_548_87##8	a_693_113#	2.12068e-17
C820	a_1736_97##5	a_1538_74##2	7.86701e-17
C821	VGND#21	a_180_290##3	3.55169e-17
C822	VGND#9	VGND#10	9.25682e-17
C823	a_548_87##8	VPWR#18	1.02173e-18
C824	a_548_87##11	a_548_87##14	2.39796e-18
C825	VGND#10	a_180_290##3	4.46424e-18
C826	a_1538_74##11	a_1736_97#	4.06702e-17
C827	VGND#9	DE#5	1.805e-18
C828	VPWR#15	SCE#3	9.72628e-20
C829	VPWR#14	CLK#1	3.1882e-17
C830	a_1538_74##10	a_1979_71##9	1.78133e-18
C831	a_693_113##4	SCD#2	5.98219e-19
C832	VGND#1	Q	1.73592e-17
C833	a_1736_97##5	a_1538_74##11	2.3765e-17
C834	a_663_87##9	a_663_87##5	2.20975e-20
C835	SCE#2	SCE#1	1.84894e-18
C836	a_548_87##9	a_1538_74##10	1.24102e-17
C837	SCE#5	SCE#4	4.53115e-18
C838	VPWR	a_1979_71##9	1.53229e-19
C839	a_548_87##8	a_1538_74##16	1.06082e-17
C840	VPWR	a_1736_97##5	3.3301e-18
C841	a_548_87##13	Q	4.42093e-18
C842	a_2474_74##13	a_1340_74##10	4.7553e-17
C843	a_548_87##13	a_548_87##5	7.35869e-19
C844	VGND#9	VGND#8	1.11924e-16
C845	VPWR	a_693_113##2	2.17104e-17
C846	a_548_87##8	VPWR#15	3.89938e-18
C847	a_1340_74##14	a_663_87##4	6.72012e-20
C848	VGND#9	D#3	2.06394e-18
C849	VGND#2	a_2474_74##12	4.86944e-18
C850	VGND#21	a_693_113##8	3.06879e-18
C851	a_693_113##10	a_1340_74##4	3.19312e-19
C852	a_693_113##4	CLK#1	4.89208e-17
C853	a_180_290##9	a_180_290##3	7.61798e-19
C854	a_1979_71##2	a_1736_97#	5.52957e-18
C855	a_548_87##8	VGND#18	8.10805e-18
C856	a_40_464##2	a_129_464#	3.16339e-18
C857	a_180_290##9	D#2	1.11138e-18
C858	VPWR#16	SCD#2	5.64171e-19
C859	a_548_87#	SCE#4	3.50799e-19
C860	VGND#16	a_548_87##4	1.19392e-19
C861	a_663_87##7	a_548_87#	1.61479e-19
C862	a_1736_97##5	a_693_113##9	6.28405e-19
C863	a_1538_74##10	a_1736_97#	1.99484e-18
C864	VGND	VGND#7	5.33994e-18
C865	VGND#9	VGND#7	7.53818e-17
C866	VGND	VGND#6	1.17552e-16
C867	SCE#2	SCD#3	2.10855e-17
C868	VGND	VGND#4	1.01067e-16
C869	a_548_87##8	VPWR#13	4.49087e-18
C870	VGND	VGND#3	5.87584e-17
C871	VGND#10	a_180_290##9	4.46812e-18
C872	a_1538_74##10	VGND#16	6.38568e-17
C873	VPWR#14	a_663_87##4	2.69853e-18
C874	a_693_113##4	SCE#3	7.51437e-19
C875	VGND#2	a_2474_74##3	4.67772e-19
C876	VGND#21	DE#7	2.91651e-17
C877	a_180_290##9	a_180_290##6	2.86373e-18
C878	a_548_87##8	a_1340_74##16	3.02154e-18
C879	a_693_113##4	a_1340_74##4	1.31336e-18
C880	a_548_87#	SCE#5	4.56439e-17
C881	a_40_464##4	a_693_113##6	6.31089e-17
C882	a_548_87##8	VPWR#11	5.4473e-18
C883	a_1538_74##11	a_1979_71##11	4.40463e-17
C884	VGND	a_1538_74##12	3.72513e-17
C885	Q	VPWR#1	3.45081e-17
C886	VGND#2	a_2474_74##2	3.51216e-20
C887	VGND	a_1538_74##11	3.78431e-17
C888	a_40_464#	D#2	9.18641e-18
C889	Q	Q#2	2.55585e-18
C890	VGND	a_1538_74##10	3.58594e-17
C891	a_693_113##4	a_663_87##4	5.73061e-17
C892	VGND#4	a_2474_74##13	8.81588e-18
C893	a_548_87##8	VGND#19	7.09335e-18
C894	VPWR#3	Q	3.05883e-17
C895	a_2474_74##13	a_1538_74##5	1.46579e-17
C896	a_1538_74##11	a_1979_71##3	3.53618e-17
C897	VGND#21	a_40_464##5	1.44816e-17
C898	a_548_87##11	VPWR#5	3.04833e-19
C899	a_693_113##2	a_1538_74##2	4.23606e-18
C900	VPWR#17	VPWR#18	7.46718e-17
C901	a_693_113##2	a_1340_74##4	2.86286e-17
C902	VGND	a_1979_71##9	7.99959e-19
C903	DE#7	a_180_290##9	1.0428e-17
C904	VGND	a_1736_97##5	2.98951e-18
C905	VPWR#16	CLK#1	2.84601e-19
C906	VGND#10	DE#7	2.9593e-18
C907	a_2474_74##11	VPWR#4	3.6514e-17
C908	a_40_464#	a_40_464##2	1.31981e-18
C909	VPWR	a_693_113#	6.42251e-19
C910	VGND	a_693_113##2	1.10069e-18
C911	VPWR#14	SCD#1	3.52164e-19
C912	VGND#16	a_1340_74##10	1.10682e-18
C913	a_548_87##8	a_693_113##10	2.0729e-17
C914	VGND#8	VGND#7	4.60232e-19
C915	VPWR#13	VPWR#11	5.21825e-19
C916	VPWR#9	VPWR#7	8.00799e-18
C917	VPWR#17	VPWR#15	9.72965e-17
C918	VGND#21	DE#5	1.67106e-18
C919	a_40_464##4	SCE#4	1.34736e-19
C920	DE#1	a_548_87#	5.35518e-17
C921	a_1340_74##16	CLK#4	1.03043e-17
C922	VPWR#10	a_1979_71#	5.11826e-18
C923	a_2474_74##5	a_2474_74##8	2.38377e-18
C924	VGND#22	DE#7	2.47131e-18
C925	a_1538_74##12	a_1538_74##4	4.44012e-18
C926	a_1979_71##9	a_1538_74##5	2.14296e-19
C927	a_1538_74##11	a_1872_97#	1.95382e-18
C928	a_693_113##4	SCD#1	2.42754e-17
C929	a_1538_74##10	a_1979_71##11	5.86579e-17
C930	VPWR#17	VPWR#13	6.13497e-17
C931	a_1538_74##3	a_1979_71##3	5.46103e-18
C932	VPWR#16	a_663_87##4	3.08702e-18
C933	a_40_464##4	a_40_464##6	2.73037e-18
C934	a_180_290##9	a_40_464##5	2.17301e-18
C935	VPWR	a_2474_74##11	2.01438e-17
C936	VGND#22	VGND#10	3.15194e-18
C937	VGND#3	a_2474_74##13	5.16558e-17
C938	a_180_290##9	DE#5	1.08603e-17
C939	a_2474_74##5	a_2474_74##10	2.22882e-18
C940	VPWR	VPWR#7	2.58711e-18
C941	Q	a_2474_74##6	1.92944e-19
C942	a_2474_74##13	a_1979_71##4	4.92566e-18
C943	VPWR#10	a_1340_74##7	4.555e-18
C944	a_2474_74##13	a_1538_74##8	6.38268e-17
C945	VPWR#14	SCE#4	9.52164e-20
C946	VGND	a_2474_74##13	2.45636e-17
C947	VPWR	a_1979_71##8	3.5341e-18
C948	Q	a_2474_74##7	1.50111e-19
C949	a_548_87##8	VGND#20	7.94349e-18
C950	a_693_113##6	CLK#1	1.09156e-19
C951	VPWR	VPWR#9	2.45482e-18
C952	a_1538_74##11	VGND#17	8.18522e-17
C953	VGND	a_1979_71##11	7.09924e-18
C954	VPWR	a_1736_97##7	1.99914e-17
C955	VPWR	a_693_113##9	2.19099e-17
C956	a_548_87##9	VPWR#3	3.77378e-17
C957	VGND	a_1736_97##6	3.00677e-18
C958	a_548_87##9	a_1979_71##9	3.56723e-17
C959	a_548_87##5	a_2474_74##8	1.5941e-19
C960	VPWR	a_1538_74##17	2.68414e-18
C961	VGND	a_693_113#	4.25486e-18
C962	VPWR#13	a_1340_74##8	2.01773e-19
C963	VPWR	VPWR#12	1.4391e-17
C964	VGND	a_1538_74##16	3.18109e-17
C965	VPWR#2	VPWR#1	6.77688e-17
C966	VPWR	a_1340_74##14	8.48102e-18
C967	VGND	a_1340_74##16	1.66259e-17
C968	VPWR#18	a_548_87##2	1.04038e-19
C969	VGND#16	a_1538_74##5	2.68925e-18
C970	a_1538_74##11	a_1538_74##4	1.48362e-17
C971	a_693_113##2	a_1340_74##3	8.60472e-18
C972	VPWR	a_693_113##4	5.4271e-18
C973	a_663_87##9	a_663_87##4	1.32585e-20
C974	a_1340_74#	a_1538_74##3	4.77905e-18
C975	VPWR#10	a_1538_74#	5.43215e-18
C976	DE#6	DE#1	1.19331e-17
C977	a_548_87##8	a_663_87##10	4.27127e-18
C978	a_693_113##4	SCE#4	1.24983e-17
C979	a_1340_74##2	a_1538_74##3	4.02279e-18
C980	VGND#9	a_1340_74##16	7.07191e-18
C981	SCE	SCE#4	4.21965e-20
C982	a_548_87##5	a_2474_74##10	1.44153e-17
C983	VGND#22	DE#5	3.3531e-17
C984	a_548_87##9	a_1736_97##5	5.42209e-17
C985	VGND#10	DE#5	1.13043e-18
C986	VPWR#16	SCD#1	3.39366e-17
C987	Q#2	VPWR#2	2.91656e-17
C988	a_2474_74##3	VNB	4.13049e-17
C989	a_2474_74##2	VNB	3.92286e-17
C990	a_40_464##4	SCE#5	4.44214e-18
C991	a_1340_74##4	VNB	9.50895e-17
C992	VPWR#11	a_1340_74##8	9.52995e-19
C993	a_1340_74##3	VNB	2.77632e-17
C994	a_2474_74##5	a_1538_74##7	7.09102e-20
C995	a_1340_74##2	VNB	5.92512e-17
C996	DE#4	VNB	3.47637e-17
C997	a_548_87##3	a_663_87##2	2.09798e-17
C998	DE#2	VNB	4.15885e-17
C999	a_40_464#	DE#7	9.48313e-20
C1000	a_548_87##8	a_693_113##8	3.39488e-17
C1001	VGND#19	CLK#4	6.10334e-18
C1002	VGND#3	a_2474_74##5	7.76419e-18
C1003	Q	a_2474_74#	2.26527e-17
C1004	a_548_87##5	a_548_87##6	3.3249e-18
C1005	a_180_290##9	D#3	1.76311e-18
C1006	Q	a_2474_74##8	7.36141e-18
C1007	a_1979_71##9	a_1979_71##4	4.60563e-19
C1008	a_1538_74##12	a_1340_74#	3.08979e-17
C1009	VGND	a_1538_74##17	1.02065e-18
C1010	a_693_113##6	a_548_87##2	1.06615e-18
C1011	a_1538_74##2	a_1340_74#	2.12002e-18
C1012	VGND	a_1340_74##14	2.81605e-18
C1013	a_2474_74##13	a_1736_97#	3.5092e-19
C1014	VPWR#2	VPWR#3	1.60506e-17
C1015	a_2474_74##13	a_1340_74##11	1.10267e-18
C1016	a_663_87##9	SCD#1	9.44866e-20
C1017	a_1340_74##4	a_1340_74##8	1.42123e-17
C1018	VPWR#15	CLK#1	4.96571e-19
C1019	a_548_87##8	a_40_464##5	3.55446e-17
C1020	a_548_87##8	SCE	7.93825e-18
C1021	VGND#10	VNB	4.02649e-17
C1022	VGND#8	VNB	4.38308e-17
C1023	a_1538_74##7	a_548_87##5	3.04931e-17
C1024	VGND#9	a_693_113##10	1.82356e-17
C1025	VGND#7	VNB	3.80559e-17
C1026	VPWR#17	SCE	1.05172e-18
C1027	VGND#6	VNB	6.03887e-17
C1028	VGND#4	VNB	5.0131e-17
C1029	VGND#3	VNB	6.5252e-17
C1030	a_180_290#	DE#6	3.73453e-18
C1031	VGND#9	SCE	1.24936e-18
C1032	a_1538_74##2	a_1340_74##9	1.33119e-19
C1033	VPWR#18	VNB	3.54006e-17
C1034	VGND#16	a_1979_71##4	4.38996e-17
C1035	VPWR#15	VNB	4.90376e-17
C1036	VPWR#13	VNB	4.84725e-17
C1037	VPWR#11	VNB	5.98248e-17
C1038	VPWR#8	VNB	2.42297e-17
C1039	VPWR#6	VNB	5.97473e-17
C1040	SCE#4	VPWR#16	2.15775e-17
C1041	VPWR#4	VNB	6.01161e-17
C1042	a_548_87##11	VNB	1.52688e-17
C1043	a_548_87##10	VNB	5.41259e-18
C1044	VGND#22	D#3	6.15811e-18
C1045	a_2474_74##12	VNB	6.49035e-18
C1046	a_1538_74##12	VNB	1.3729e-17
C1047	a_1538_74##11	VNB	8.64356e-18
C1048	a_693_113##2	a_1340_74##2	7.68666e-20
C1049	a_1538_74##10	VNB	2.21461e-17
C1050	a_693_113##6	SCD#1	6.34145e-19
C1051	VGND	a_1979_71##3	7.47304e-18
C1052	a_1538_74##11	a_1340_74#	5.151e-19
C1053	a_1979_71##9	VNB	6.27096e-18
C1054	VPWR#13	CLK#1	7.10182e-18
C1055	a_1736_97##5	VNB	7.01175e-18
C1056	VPWR	a_1736_97##3	7.24448e-18
C1057	a_1538_74##2	a_1340_74##4	9.88603e-20
C1058	VGND	a_1340_74##9	3.8864e-19
C1059	a_40_464#	DE#5	6.30359e-18
C1060	a_693_113##2	VNB	1.48196e-17
C1061	a_1538_74##12	a_1736_97##6	6.85484e-17
C1062	a_2474_74##11	a_548_87##11	1.66093e-18
C1063	a_180_290##9	VGND#21	4.56268e-17
C1064	a_548_87##9	Q	2.61284e-17
C1065	CLK#4	VNB	2.54007e-18
C1066	a_663_87##7	VNB	4.92753e-18
C1067	VPWR#2	Q	5.07858e-18
C1068	a_548_87##9	a_2474_74##11	1.72563e-17
C1069	VPWR	CLK#1	4.03903e-18
C1070	a_40_464##4	a_548_87#	2.0179e-17
C1071	SCD#5	VNB	1.08726e-18
C1072	VGND#2	Q	4.32002e-18
C1073	SCD#4	VNB	4.92193e-18
C1074	SCE#4	a_663_87##9	1.5988e-17
C1075	VGND#3	a_2474_74##7	6.50764e-19
C1076	a_1538_74##12	a_1340_74##3	9.07326e-20
C1077	a_40_464##4	VNB	1.50907e-17
C1078	a_40_464##2	VNB	9.5304e-17
C1079	a_180_290##3	a_548_87##3	4.73344e-17
C1080	a_180_290##6	VNB	2.52104e-18
C1081	a_1979_71##11	a_1979_71##4	5.01145e-19
C1082	D#6	VNB	8.34676e-19
C1083	D#4	VNB	5.26426e-18
C1084	VGND#1	VNB	7.25639e-17
C1085	a_693_113##10	CLK#4	1.48234e-17
C1086	Q#1	VNB	4.8696e-18
C1087	VGND#13	VNB	9.80707e-18
C1088	Q	a_2474_74##5	1.0552e-18
C1089	a_548_87##13	VNB	1.45235e-17
C1090	a_1340_74##12	a_1538_74##8	6.08508e-18
C1091	a_2474_74##13	VNB	5.48985e-18
C1092	SCE	SCE#3	6.81151e-18
C1093	a_548_87##8	CLK#1	1.36018e-18
C1094	VGND#16	VNB	6.71721e-19
C1095	D#1	a_180_290#	3.83444e-17
C1096	a_1979_71##11	VNB	2.72264e-18
C1097	VGND#17	VNB	3.30992e-18
C1098	a_548_87##9	VPWR	7.5797e-17
C1099	a_40_464##4	VPWR#19	6.48435e-17
C1100	VPWR#10	a_1340_74##2	1.66688e-19
C1101	a_1736_97##6	VNB	7.10528e-18
C1102	a_693_113#	VNB	1.59582e-17
C1103	a_1538_74##16	VNB	1.13485e-17
C1104	a_1979_71##9	a_1736_97#	7.49791e-18
C1105	VGND#18	VNB	8.82728e-18
C1106	a_1340_74##16	VNB	1.3175e-17
C1107	a_1538_74##2	a_1340_74##2	4.68706e-17
C1108	VGND#19	VNB	7.01654e-18
C1109	VPWR	VPWR#10	6.80634e-17
C1110	VGND#7	VGND#6	1.14572e-18
C1111	a_693_113##10	VNB	1.98506e-17
C1112	VGND#5	a_1538_74##12	3.97535e-17
C1113	VGND#20	VNB	2.9918e-18
C1114	a_1340_74##11	a_1538_74##7	1.55212e-18
C1115	a_663_87##10	VNB	4.96596e-18
C1116	a_693_113##6	SCE#4	3.42019e-17
C1117	a_693_113##8	VNB	1.56975e-17
C1118	a_548_87##8	VPWR	3.4407e-17
C1119	VGND#9	a_663_87##10	1.1211e-17
C1120	a_1538_74##12	a_1340_74##9	3.90791e-19
C1121	a_40_464##5	VNB	7.36471e-18
C1122	VGND#21	VNB	2.2125e-18
C1123	VGND#16	a_1736_97#	4.38408e-19
C1124	a_180_290##9	VNB	1.02265e-17
C1125	VGND#22	VNB	7.37645e-18
C1126	a_40_464#	VNB	6.16889e-17
C1127	VPWR#1	VNB	6.08997e-17
C1128	Q#2	VNB	5.15175e-18
C1129	VPWR#3	VNB	9.52918e-18
C1130	VPWR	a_1538_74##8	6.54061e-19
C1131	a_180_290##6	SCE#5	9.09117e-20
C1132	a_2474_74##11	VNB	8.02723e-18
C1133	VPWR	a_1340_74##11	2.54143e-17
C1134	VPWR#7	VNB	3.66481e-18
C1135	a_1979_71##8	VNB	3.34246e-18
C1136	VPWR#9	VNB	2.25976e-18
C1137	VPWR	a_1538_74##6	2.67743e-18
C1138	CLK#2	a_1340_74##9	2.04578e-18
C1139	a_1736_97##7	VNB	3.02829e-18
C1140	VGND	a_548_87##9	7.45804e-17
C1141	VPWR	a_1979_71##6	2.70374e-18
C1142	a_693_113##9	VNB	9.22134e-18
C1143	VPWR#15	a_663_87##4	3.8028e-18
C1144	a_1538_74##17	VNB	1.94563e-18
C1145	a_40_464#	D#3	3.90385e-17
C1146	VPWR#17	CLK#1	1.17915e-18
C1147	a_663_87##9	SCE#5	3.38644e-18
C1148	VPWR#12	VNB	4.3631e-18
C1149	VPWR	a_1736_97##2	3.70421e-18
C1150	a_548_87##9	VPWR#7	3.30998e-18
C1151	a_1340_74##14	VNB	1.62592e-17
C1152	a_1340_74##11	a_1340_74##12	2.26151e-17
C1153	VPWR#14	VNB	2.93402e-18
C1154	a_693_113##4	VNB	2.14865e-17
C1155	VGND#17	a_1979_71##4	9.27305e-21
C1156	a_1736_97##7	VPWR#9	7.63138e-18
C1157	VPWR#2	a_2474_74##11	4.71488e-19
C1158	VGND#5	a_1538_74##11	5.20088e-17
C1159	VPWR#16	VNB	5.2849e-19
C1160	VGND	VGND#5	1.38541e-16
C1161	VPWR	a_1340_74##6	2.61068e-17
C1162	VGND#22	VGND#21	5.37246e-18
C1163	a_663_87##9	VNB	8.70315e-18
C1164	VGND#9	a_693_113##8	2.88243e-17
C1165	a_693_113##6	VNB	1.6846e-17
C1166	VGND	a_548_87##8	3.09614e-17
C1167	a_40_464##6	VNB	2.63503e-18
C1168	VPWR#19	VNB	3.26483e-19
C1169	VPWR	a_1538_74##2	2.45714e-18
C1170	a_1736_97##6	a_1538_74##11	5.73748e-17
C1171	a_180_290##8	VNB	3.90193e-19
C1172	VPWR#21	VNB	1.14508e-18
C1173	a_2474_74##6	VNB	3.41116e-17
C1174	a_2474_74##7	VNB	3.34262e-17
C1175	a_2474_74##9	VNB	3.81991e-17
C1176	VGND	a_1538_74##8	1.94582e-18
C1177	a_548_87##4	VNB	6.0673e-17
C1178	a_1340_74##10	VNB	2.99599e-17
C1179	VGND	a_1340_74##11	1.991e-18
C1180	a_1538_74##5	VNB	2.78596e-17
C1181	a_1979_71##4	VNB	2.76521e-17
C1182	VGND#16	VGND#3	1.27558e-18
C1183	a_1736_97#	VNB	4.57638e-17
C1184	CLK#4	CLK#2	9.83897e-18
C1185	CLK#1	a_1340_74##4	1.46281e-17
C1186	a_1979_71##3	VNB	3.18405e-17
C1187	VGND	a_1979_71##6	3.92182e-18
C1188	a_1538_74##4	VNB	2.35518e-17
C1189	a_1340_74#	VNB	4.32793e-17
C1190	VGND	a_1736_97##2	9.17738e-19
C1191	a_1340_74##9	VNB	4.62175e-17
C1192	CLK#3	VNB	4.00377e-17
C1193	VGND	a_1979_71##2	2.56161e-18
C1194	SCE#1	VNB	7.18865e-17
C1195	a_1340_74##11	a_1979_71##7	4.22509e-17
C1196	VPWR#17	a_663_87##4	9.76403e-18
C1197	SCD#3	VNB	1.79621e-17
C1198	a_40_464##4	DE#1	2.80554e-17
C1199	SCE#2	VNB	6.00625e-17
C1200	a_663_87##2	VNB	4.94345e-17
C1201	a_1736_97#	a_1979_71##11	1.0713e-17
C1202	a_548_87##3	VNB	2.7623e-17
C1203	a_548_87##9	a_1979_71##8	3.79865e-18
C1204	a_180_290##3	VNB	2.54473e-17
C1205	VGND#5	a_1538_74##10	4.84696e-18
C1206	DE#7	VNB	3.21221e-17
C1207	VGND#9	a_40_464##5	2.84526e-17
C1208	DE#5	VNB	3.66892e-17
C1209	VPWR#13	a_663_87##4	1.33301e-18
C1210	a_693_113##6	SCE#5	6.45891e-17
C1211	D#3	VNB	4.23704e-17
C1212	a_1538_74##12	a_693_113#	5.95089e-17
C1213	a_2474_74#	VNB	4.10154e-17
C1214	DE#7	a_180_290##3	3.38354e-17
C1215	a_2474_74##8	VNB	3.14578e-17
C1216	a_2474_74##10	VNB	3.84634e-17
C1217	SCE#1	CLK#2	5.95671e-19
C1218	a_548_87##6	VNB	1.88809e-17
C1219	a_1538_74##7	VNB	3.78894e-17
C1220	a_1340_74##12	VNB	2.93916e-17
C1221	a_1979_71##7	VNB	4.78683e-17
C1222	a_1736_97##3	VNB	4.1007e-17
C1223	a_1979_71#	VNB	4.46377e-17
C1224	a_1340_74##7	VNB	1.81059e-17
C1225	a_1538_74#	VNB	2.36315e-17
C1226	a_1538_74##12	a_1340_74##2	8.4967e-19
C1227	a_1340_74##8	VNB	4.07243e-17
C1228	CLK#1	VNB	6.53188e-17
C1229	a_663_87##4	VNB	3.1413e-17
C1230	SCD#1	VNB	3.24336e-17
C1231	SCE#4	VNB	7.39526e-17
C1232	SCE#5	VNB	6.75679e-17
C1233	a_1340_74##11	a_1736_97##3	7.57401e-19
C1234	a_548_87#	VNB	3.8916e-17
C1235	a_40_464##4	a_180_290##8	5.04101e-17
C1236	DE#1	VNB	4.65566e-17
C1237	VGND#3	a_2474_74##9	1.61781e-17
C1238	DE#6	VNB	2.87299e-17
C1239	VPWR#17	SCD#1	4.47975e-18
C1240	a_180_290#	VNB	2.74327e-17
C1241	D#1	VNB	4.68821e-17
C1242	a_663_87##9	a_548_87#	3.07975e-20
C1243	a_548_87##9	VNB	1.90414e-17
C1244	VPWR#2	VNB	1.80985e-16
C1245	SCD#3	CLK#2	4.47138e-19
C1246	VGND#2	VNB	1.8068e-16
C1247	VPWR#10	VNB	3.52167e-17
C1248	a_548_87##9	VPWR#9	2.34344e-18
C1249	VGND#5	VNB	7.33016e-17
C1250	a_548_87##8	VNB	2.34979e-17
C1251	VPWR#17	VNB	3.19577e-16
C1252	VGND#9	VNB	3.28518e-16
C1253	a_1979_71##7	a_1538_74##6	9.50601e-18
C1254	a_2474_74##5	VNB	9.49412e-17
C1255	a_548_87##5	VNB	6.23458e-17
C1256	SCE#5	a_40_464##6	6.58839e-18
C1257	a_1538_74##8	VNB	4.40477e-17
C1258	a_1340_74##11	VNB	4.78611e-17
C1259	a_1538_74##6	VNB	2.7501e-17
C1260	a_1340_74##14	a_1340_74#	4.714e-20
C1261	a_1979_71##6	VNB	9.41612e-17
C1262	a_693_113##2	a_1538_74##17	5.83224e-17
C1263	a_1736_97##2	VNB	4.92869e-17
C1264	a_1979_71##2	VNB	6.53424e-17
C1265	VGND#22	a_180_290##9	5.968e-17
C1266	a_1340_74##6	VNB	8.11154e-17
C1267	a_1538_74##3	VNB	3.63495e-17
C1268	a_548_87##8	a_1538_74##12	1.25439e-18
C1269	a_180_290##6	a_548_87#	6.19579e-19
C1270	a_1538_74##2	VNB	4.98844e-17
C1271	a_548_87##8	SCE#5	1.67887e-18
C1272	CLK#2	VNB	4.32854e-17
C1273	a_663_87##5	VNB	7.6451e-17
C1274	SCD#2	VNB	5.35758e-17
C1275	a_1736_97#	VGND#17	2.22639e-17
C1276	SCE#3	VNB	4.27943e-17
C1277	a_548_87##2	VNB	8.29054e-17
C1278	a_180_290##4	VNB	5.00297e-17
C1279	DE#3	VNB	3.43568e-17
C1280	a_180_290##2	VNB	6.66942e-17
C1281	SCE#1	a_663_87##5	1.89137e-17
C1282	D#2	VNB	7.21857e-17
C1283	DE#7	DE#2	8.74854e-19
C1284	VGND#16	a_1979_71##6	1.5617e-18
C1285	VPWR#11	a_1340_74##4	1.98858e-18
C1286	a_693_113##6	a_548_87#	2.10806e-18
C1287	VGND#5	a_1340_74##2	6.1158e-20
C1288	VGND#1	Q#1	7.1818e-17
C1289	D#4	a_180_290##9	1.70791e-17
C1290	VPWR#15	SCD#1	3.66851e-18
C1291	a_40_464##2	a_180_290##8	5.07507e-17
C1292	VPWR#4	a_2474_74##5	1.31263e-20
C1293	VPWR#17	SCE#5	1.37436e-17
C1294	SCE	VNB	1.18142e-18
C1295	VGND#4	a_548_87##4	9.31996e-20
C1296	Q	VNB	3.78508e-17
C1297	a_40_464##4	DE#6	3.23951e-17
C1298	VPWR	VNB	2.15686e-16
C1299	VGND#9	a_180_290##9	1.94235e-17
C1300	VGND	VNB	2.1698e-16
C1301	VPWR#20	DE#3	2.29836e-20
C1302	a_693_113##8	a_663_87#	1.14757e-16
C1303	VGND#9	VGND#11	1.3213e-16
C1304	VPWR#20	a_180_290#	7.19528e-18
C1305	a_180_290##4	a_663_87#	2.16913e-19
C1306	VGND#11	D#4	2.70244e-18
C1307	a_663_87#	SCD#5	1.89346e-18
C1308	a_663_87#	VNB	1.54045e-16
C1309	a_663_87#	VGND#20	6.24608e-18
C1310	a_548_87##2	a_663_87#	7.19136e-18
C1311	VPWR#20	DE#6	8.967e-19
C1312	VGND#11	VGND#10	1.41197e-18
C1313	VPWR#20	VNB	6.97068e-17
C1314	VGND#11	D#3	8.3886e-18
C1315	a_663_87#	SCE#3	5.16537e-17
C1316	VPWR#20	DE#1	2.25396e-19
C1317	a_663_87##7	a_663_87#	2.05869e-17
C1318	a_40_464##2	VPWR#20	6.4566e-17
C1319	a_180_290##6	a_663_87#	1.95577e-19
C1320	a_40_464##4	VPWR#20	1.0933e-18
C1321	a_663_87#	a_180_290##3	1.96131e-19
C1322	a_663_87##5	a_663_87#	1.63796e-19
C1323	VPWR#20	VPWR#18	5.53051e-19
C1324	VGND#11	a_40_464#	2.79954e-17
C1325	a_663_87#	a_548_87##3	3.75344e-19
C1326	VGND#11	DE#4	6.69156e-19
C1327	a_693_113##6	a_663_87#	5.81863e-18
C1328	VGND#11	a_180_290##9	4.86406e-18
C1329	VPWR#20	DE#2	3.45957e-19
C1330	VGND#11	DE#5	7.14077e-18
C1331	VGND#9	a_663_87#	4.72493e-17
C1332	a_663_87##2	a_663_87#	1.51515e-17
C1333	VGND#11	a_180_290##2	5.23382e-19
C1334	a_663_87#	SCE	3.68731e-17
C1335	a_40_464##4	a_663_87#	5.78435e-19
C1336	VGND#11	VNB	6.51745e-17
C1337	a_663_87#	SCE#2	3.19915e-17
C1338	VPWR#20	DE#4	2.07133e-20
C1339	VGND#21	a_663_87#	2.89857e-18
C1340	a_663_87#	SCE#5	1.81925e-18
C1341	a_548_87##8	a_663_87#	2.67081e-18
C1342	a_663_87#	SCD#3	5.02026e-19
C1343	VPWR#17	VPWR#20	1.32442e-16
C1344	a_663_87#	SCE#4	7.30591e-18
C1345	a_663_87#	SCE#1	5.22723e-19
C1346	VGND#8	a_663_87#	1.81884e-17
C1347	VPWR#20	D#1	7.81669e-18
C1348	a_40_464##5	a_663_87#	5.7885e-19
C1349	VGND#10	a_663_87#	2.8882e-18
*
*
.ENDS sky130_fd_sc_hs__sedfxtp_2
*
