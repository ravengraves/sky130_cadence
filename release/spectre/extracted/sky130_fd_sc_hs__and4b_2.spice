* Extracted by Quantus, converted by sky130cad/quantus.py
*
*
*
*                       LINUX           Wed Nov 18 08:18:57 2026
*
*
*
*  PROGRAM  advgen
*
*  Name           : advgen - Quantus - (64-bit)
*  Version        : 25.1.0-p047
*  Build Date     : Thu Dec 11 23:20:30 PST 2025
*
*  HSPICE LIBRARY
*
*  OPERATING_TEMPERATURE 150
*  QRC_TECH_DIR <path>/tech
*
*
*

*
.SUBCKT sky130_fd_sc_hs__and4b_2 VPB VNB VGND VPWR X A_N D C B
*
*
*  caps2d version: 10
*
*
*       TRANSISTOR CARDS
*
*
XM10 a_27_112##6 A_N#4 VGND#5 VNB sky130_fd_pr__nfet_01v8_lvt l=0.15 w=0.55 ad=0.15675 as=0.25215 pd=1.67 ps=2.2
XM8 VGND#5 a_186_48##4 X#3 VNB sky130_fd_pr__nfet_01v8_lvt l=0.15 w=0.74 ad=0.25215 as=0.2072 pd=2.2 ps=2.04
XM12 X#3 a_186_48##5 VGND#1 VNB sky130_fd_pr__nfet_01v8_lvt l=0.15 w=0.74 ad=0.2072 as=0.4699 pd=2.04 ps=2.75
XM5 VGND#1 D#1 a_459_74# VNB sky130_fd_pr__nfet_01v8_lvt l=0.15 w=0.74 ad=0.4699 as=0.1776 pd=2.75 ps=1.96
XM2 a_459_74# C#1 a_537_74# VNB sky130_fd_pr__nfet_01v8_lvt l=0.15 w=0.74 ad=0.1776 as=0.2886 pd=1.96 ps=2.26
XM6 a_537_74# B#3 a_645_74# VNB sky130_fd_pr__nfet_01v8_lvt l=0.15 w=0.74 ad=0.2886 as=0.2886 pd=2.26 ps=2.26
XM7 a_645_74# a_27_112##3 a_186_48##7 VNB sky130_fd_pr__nfet_01v8_lvt l=0.15 w=0.74 ad=0.2886 as=0.2109 pd=2.26 ps=2.05
XM0 a_27_112##7 A_N#1 VPWR#9 VPB sky130_fd_pr__pfet_01v8 l=0.15 w=0.84 ad=0.2478 as=0.4172 pd=2.27 ps=3.03
XM4 VPWR#9 a_186_48##6 X#1 VPB sky130_fd_pr__pfet_01v8 l=0.15 w=1.12 ad=0.4172 as=0.336 pd=3.03 ps=2.84
XM11 X#1 a_186_48# VPWR#8 VPB sky130_fd_pr__pfet_01v8 l=0.15 w=1.12 ad=0.336 as=0.5156 pd=2.84 ps=3.18
XM1 VPWR#8 D#3 a_186_48##9 VPB sky130_fd_pr__pfet_01v8 l=0.15 w=1 ad=0.5156 as=0.325 pd=3.18 ps=2.65
XM3 a_186_48##9 C#3 VPWR#7 VPB sky130_fd_pr__pfet_01v8 l=0.15 w=1 ad=0.325 as=0.4961 pd=2.65 ps=3.12
XM13 VPWR#7 B#1 a_186_48##11 VPB sky130_fd_pr__pfet_01v8 l=0.15 w=1 ad=0.4961 as=0.34 pd=3.12 ps=2.68
XM9 a_186_48##11 a_27_112# VPWR#1 VPB sky130_fd_pr__pfet_01v8 l=0.15 w=1 ad=0.34 as=0.43335 pd=2.68 ps=2.99
*
*
*       RESISTOR AND CAP/DIODE CARDS
*
Rg1	A_N#1	A_N#2	391.522156
Rg2	A_N#2	A_N#3	24.690777
Rg3	A_N#2	A_N#4	314.345734
Rg4	a_186_48#	a_186_48##2	452.618774
Rg5	a_186_48##2	a_186_48##3	93.511780
Rg6	a_186_48##3	a_186_48##4	368.897400
Rg7	a_186_48##2	a_186_48##5	361.117523
Rg8	a_186_48##3	a_186_48##6	471.698395
Rg9	D#1	D#2	382.539734
Rg10	D#2	D#3	400.207520
Rg11	C#1	C#2	382.539734
Rg12	C#2	C#3	400.207520
Rg13	B#1	B#2	400.207520
Rg14	B#2	B#3	382.539734
Rg15	a_27_112#	a_27_112##2	400.207520
Rg16	a_27_112##2	a_27_112##3	382.539734
Rf1	A_N#5	A_N#3	160.919952
Rf2	A_N	A_N#7	0.687145
Rf3	A_N#5	A_N#7	7.873454
Rf4	X	X#2	0.849530
Rf5	X#2	X#3	86.487083
Rf6	X#1	X#2	15.000000
Rf7	D#2	D	166.137894
Rf8	C#2	C	166.137894
Rf9	B#4	B#2	162.066422
Rf10	B	B#6	1.833616
Rf11	B#4	B#6	4.913828
Rf12	a_27_112##2	a_27_112##5	454.355591
Rf13	a_27_112##5	a_27_112##6	114.935143
Rf14	a_27_112##5	a_27_112##7	17.236382
Rf15	a_186_48##7	a_186_48##8	193.437866
Rf16	a_186_48##8	a_186_48##10	66.533630
Rf17	a_186_48##10	a_186_48##11	71.534790
Rf18	a_186_48##9	a_186_48##10	15.000000
Rf19	VPWR#1	VPWR#2	108.792976
Rf20	VPWR#2	VPWR#3	54.398087
Rf21	VPWR#3	VPWR#4	25.543140
Rf22	VPWR#4	VPWR#5	72.636177
Rf24	VPWR#2	VPWR#7	32.342297
Rf25	VPWR#4	VPWR#8	32.342297
Rf26	VPWR#5	VPWR#9	32.342297
Rf27	VGND#1	VGND#2	21.168480
Rf28	VGND#2	VGND#3	107.453575
Rf30	VGND#3	VGND#5	42.655182
Rf36	a_186_48##2	a_186_48##8	160.232803
Re1	VPWR#3	VPWR	1.091357
Re2	VGND	VGND#2	1.091398
*
*       CAPACITOR CARDS
*
*
C1	X#3	a_186_48##3	7.18813e-18
C2	a_27_112##6	a_186_48##3	3.77595e-18
C3	VGND#2	a_186_48##3	3.4237e-20
C4	a_186_48##7	B#4	3.72418e-17
C5	VPWR#2	VPWR#1	8.37136e-19
C6	a_27_112##7	VPWR#4	2.64424e-18
C7	VGND#1	a_186_48##7	5.70988e-18
C8	a_27_112##7	VPWR#2	1.29346e-18
C9	a_186_48##3	a_186_48##2	3.79457e-18
C10	A_N#5	a_27_112##6	4.98752e-17
C11	a_186_48##3	X#1	4.02949e-20
C12	a_186_48##7	VPWR#1	2.53806e-18
C13	A_N#3	a_186_48##3	1.91225e-17
C14	X#3	VGND#1	4.0431e-17
C15	a_186_48##7	a_186_48##11	7.05846e-18
C16	VGND#5	VGND#1	9.66494e-19
C17	VGND#5	X#3	4.17295e-17
C18	a_186_48##7	a_186_48##9	1.64124e-18
C19	a_27_112##6	X#3	2.8795e-17
C20	a_27_112##6	VGND#5	4.34694e-17
C21	a_27_112##7	a_186_48##3	3.07395e-18
C22	A_N#5	a_27_112##7	9.37374e-18
C23	VPWR#2	a_27_112#	1.70088e-18
C24	a_186_48##7	a_27_112##3	5.06893e-17
C25	VPWR#7	VPWR#1	7.58043e-18
C26	VPWR#2	B#1	6.59542e-18
C27	a_186_48##7	B#3	3.4596e-17
C28	a_186_48##11	VPWR#7	2.66821e-18
C29	VPWR#2	C#3	6.54863e-18
C30	a_186_48##7	C#1	1.59807e-18
C31	VGND#1	a_27_112##3	1.15575e-18
C32	a_186_48##7	D#1	1.25283e-18
C33	a_186_48##9	VPWR#7	2.39032e-18
C34	VGND#5	a_27_112##7	1.10547e-18
C35	VGND#1	B#3	1.9191e-18
C36	VPWR#8	VPWR#7	7.59944e-18
C37	VPWR#4	a_186_48#	8.40025e-18
C38	a_27_112##6	a_27_112##7	2.12462e-18
C39	X#3	B#3	2.60686e-19
C40	a_186_48##9	VPWR#8	4.05518e-18
C41	VGND#1	C#1	3.75101e-18
C42	X#3	C#1	3.66079e-19
C43	VGND#1	D#1	4.63821e-17
C44	X#3	D#1	1.50152e-18
C45	a_186_48##5	VGND#1	1.77747e-17
C46	VGND#5	D#1	8.10505e-20
C47	VPWR#9	VPWR#8	8.49532e-18
C48	a_27_112##7	a_186_48##9	6.77186e-17
C49	X#3	a_186_48##5	4.17144e-17
C50	VGND#1	a_186_48##4	3.74816e-19
C51	a_27_112##7	VPWR#8	4.93174e-17
C52	VGND#5	a_186_48##5	3.09396e-19
C53	X#3	a_186_48##4	3.76201e-17
C54	a_27_112##7	X#1	3.88185e-18
C55	a_186_48##4	VGND#5	1.63738e-17
C56	X#3	A_N#4	2.9348e-18
C57	VPWR#3	VPWR#4	2.85481e-17
C58	a_27_112##7	VPWR#9	4.47652e-17
C59	a_27_112##6	a_186_48##4	6.29248e-18
C60	VPWR#3	VPWR#2	4.5701e-17
C61	A_N#4	VGND#5	2.10489e-17
C62	a_27_112##6	A_N#4	3.75484e-17
C63	a_27_112##2	VPWR#2	5.30943e-18
C64	B#3	a_27_112##3	2.91809e-17
C65	a_27_112#	VPWR#1	2.17256e-17
C66	a_186_48##11	a_27_112#	3.54466e-17
C67	VPWR#2	B#2	4.08695e-20
C68	VPWR#1	B#1	3.0206e-18
C69	C#1	B#3	2.94152e-17
C70	VPWR#7	a_27_112#	3.30439e-18
C71	a_186_48##11	B#1	4.057e-17
C72	VPWR#1	C#3	7.47662e-19
C73	B#1	VPWR#7	3.37407e-17
C74	D#1	C#1	5.35438e-17
C75	B#4	a_27_112##2	2.08227e-17
C76	C#3	VPWR#7	3.46482e-17
C77	VPWR#8	B#1	7.47487e-19
C78	a_186_48##9	C#3	3.91666e-17
C79	VPWR#7	D#3	2.81705e-18
C80	a_186_48##5	D#1	1.05735e-17
C81	B#4	B#2	1.08722e-17
C82	VPWR#8	C#3	1.66782e-18
C83	a_186_48##9	D#3	3.89089e-17
C84	VPWR#4	a_186_48##2	2.6093e-20
C85	VGND#2	a_186_48##7	3.0957e-17
C86	VPWR#7	a_186_48#	1.40201e-18
C87	D#3	VPWR#8	2.64164e-17
C88	B#4	C#2	2.52714e-18
C89	a_186_48##4	a_186_48##5	3.85575e-17
C90	a_186_48##7	a_27_112##2	4.25308e-17
C91	a_186_48#	VPWR#8	3.47877e-17
C92	a_27_112##7	C#3	1.31312e-17
C93	VPWR#9	D#3	8.73086e-19
C94	a_186_48#	X#1	2.38609e-17
C95	A_N#4	a_186_48##4	2.48608e-17
C96	a_27_112##7	D#3	2.33763e-17
C97	VPWR#8	a_186_48##6	3.76733e-18
C98	a_186_48##7	B#2	2.99671e-18
C99	VPWR#9	a_186_48#	4.8584e-18
C100	VGND#2	X#3	8.67788e-18
C101	a_186_48##6	X#1	2.38609e-17
C102	VPWR#3	VPWR#1	3.12032e-17
C103	a_27_112##7	a_186_48#	3.1151e-17
C104	VPWR#9	a_186_48##6	3.2902e-17
C105	a_186_48##7	C#2	2.28655e-18
C106	a_27_112##7	a_186_48##6	3.03673e-17
C107	A_N	a_186_48##3	2.81021e-19
C108	A_N#1	VPWR#9	2.66395e-17
C109	a_27_112##7	A_N#1	5.78497e-17
C110	a_27_112##2	VPWR#1	3.86249e-17
C111	a_27_112##2	a_186_48##11	9.6631e-17
C112	VPWR#4	VPWR#2	8.53856e-19
C113	a_27_112##2	VPWR#7	4.8558e-17
C114	B#1	a_27_112#	3.71338e-17
C115	a_186_48##9	a_27_112##2	2.09262e-17
C116	VGND#1	D#2	8.35012e-19
C117	B#2	a_186_48##11	1.76928e-18
C118	a_27_112##7	VPWR#3	5.21931e-18
C119	A_N#5	A_N#3	1.61887e-17
C120	X#3	D#2	2.04537e-21
C121	X	a_186_48##3	1.29104e-17
C122	a_186_48##2	VGND#1	6.01511e-17
C123	C#3	B#1	2.20307e-17
C124	C#2	VPWR#7	9.70067e-19
C125	VGND#2	a_27_112##3	5.78635e-18
C126	X#3	a_186_48##2	3.2422e-17
C127	a_186_48##9	C#2	2.04036e-18
C128	VGND#2	B#3	9.06778e-18
C129	VGND#2	C#1	9.75682e-18
C130	D#3	C#3	4.01845e-17
C131	X#3	A_N#3	1.03192e-18
C132	D#2	a_186_48##9	3.71359e-18
C133	VGND#2	D#1	8.73015e-18
C134	a_186_48##2	a_186_48##11	2.12144e-20
C135	a_186_48##7	a_645_74#	5.18435e-18
C136	D#2	VPWR#8	4.3268e-19
C137	a_27_112##6	A_N#3	1.1485e-17
C138	VGND#2	a_186_48##5	8.7032e-18
C139	a_186_48#	D#3	2.4007e-17
C140	a_186_48##2	a_186_48##9	6.8863e-18
C141	A_N#5	a_186_48##3	8.18146e-19
C142	VGND#2	a_186_48##4	1.12654e-18
C143	a_186_48##2	VPWR#8	5.58685e-18
C144	a_186_48##7	a_537_74#	5.1653e-18
C145	a_27_112##7	D#2	1.11693e-18
C146	a_186_48##6	a_186_48#	5.03238e-17
C147	a_186_48##2	a_27_112##7	3.20808e-17
C148	a_186_48##2	a_27_112##3	7.70456e-20
C149	a_27_112##2	a_27_112#	2.41447e-17
C150	a_186_48##2	B#3	7.27736e-20
C151	A_N#1	a_186_48##6	2.53774e-17
C152	A_N#3	a_27_112##7	8.53209e-18
C153	VPWR#3	D#3	6.57053e-18
C154	a_186_48##2	C#1	2.82667e-17
C155	a_27_112##2	B#1	2.41686e-17
C156	a_186_48##2	D#1	2.41231e-17
C157	a_27_112##2	C#3	1.00858e-17
C158	a_186_48##2	a_186_48##5	3.60472e-18
C159	a_27_112##2	D#3	3.25876e-19
C160	VGND	a_186_48##3	6.32063e-19
C161	a_186_48##2	a_186_48##4	2.88512e-20
C162	a_27_112##3	a_645_74#	2.20289e-17
C163	B#3	a_645_74#	2.16982e-17
C164	a_186_48##2	a_27_112#	1.25011e-19
C165	C	B#4	2.07583e-17
C166	a_186_48##2	B#1	1.52844e-19
C167	B#3	a_537_74#	2.14361e-17
C168	a_186_48##2	C#3	3.08647e-19
C169	C#1	a_537_74#	2.14361e-17
C170	a_186_48#	D#2	5.60877e-19
C171	a_186_48##2	D#3	1.37583e-18
C172	VGND#2	a_27_112##2	8.84118e-20
C173	a_186_48##7	C	1.45385e-17
C174	a_186_48##2	a_186_48#	6.92158e-18
C175	C#1	a_459_74#	1.65187e-17
C176	a_186_48##2	a_186_48##6	5.50219e-20
C177	VGND#2	B#2	2.27934e-19
C178	D#1	a_459_74#	1.65187e-17
C179	a_186_48##3	VNB	2.68735e-17
C180	B	a_186_48##11	4.35178e-17
C181	B#2	a_27_112##2	3.83607e-17
C182	VGND#2	C#2	1.95026e-19
C183	VPWR#3	D#2	3.55914e-20
C184	a_27_112##2	C#2	4.73817e-19
C185	C#2	B#2	2.5269e-17
C186	VGND#2	a_186_48##2	3.94292e-18
C187	C	a_186_48##9	4.26548e-17
C188	a_186_48##2	a_27_112##2	1.42053e-19
C189	D#2	C#2	3.59207e-17
C190	a_186_48##2	B#2	1.38505e-19
C191	VPWR	VPWR#4	2.0861e-17
C192	D	a_186_48##9	3.67912e-17
C193	a_186_48##2	C#2	2.5368e-19
C194	VPWR	VPWR#2	3.06954e-17
C195	a_186_48##2	D#2	3.06833e-17
C196	B	a_27_112#	1.16128e-18
C197	B	B#1	2.03283e-18
C198	X#3	X	3.09456e-18
C199	B	C#3	3.97121e-19
C200	a_27_112##6	X	3.24135e-18
C201	A_N	a_27_112##7	5.10935e-17
C202	C	B#1	4.29946e-19
C203	C	C#3	2.04601e-18
C204	C	D#3	4.60674e-19
C205	X	X#1	2.73291e-19
C206	VGND	B#4	3.00992e-18
C207	a_27_112##7	X	8.5703e-17
C208	VPWR	VPWR#1	3.76125e-17
C209	D	C#3	7.46699e-19
C210	VPWR	a_186_48##11	4.57276e-18
C211	a_186_48##2	a_459_74#	3.09316e-18
C212	D	D#3	2.056e-18
C213	VPWR	VPWR#7	1.61355e-17
C214	VGND	A_N#5	2.79359e-18
C215	VPWR	a_186_48##9	5.68671e-18
C216	VGND	a_186_48##7	2.80313e-17
C217	D	a_186_48#	2.29363e-19
C218	VPWR	VPWR#8	1.60889e-17
C219	B	a_27_112##2	1.11974e-17
C220	VPWR#4	VNB	2.29895e-17
C221	VPWR#2	VNB	3.71711e-17
C222	VPWR	VPWR#9	1.60884e-17
C223	B	B#2	5.6442e-18
C224	VPWR	a_27_112##7	4.063e-17
C225	VGND	X#3	1.6543e-17
C226	B	C#2	1.82239e-18
C227	VGND	a_27_112##6	1.64022e-17
C228	B#4	VNB	2.29739e-18
C229	A_N	a_186_48##6	1.43927e-19
C230	C	B#2	3.31961e-18
C231	A_N	A_N#1	3.22515e-18
C232	C	C#2	1.60766e-17
C233	X	D#3	1.48584e-19
C234	A_N#5	VNB	9.89483e-18
C235	C	D#2	4.30264e-18
C236	a_186_48##7	VNB	5.3315e-17
C237	X	a_186_48#	1.05725e-17
C238	X	a_186_48##6	1.2292e-17
C239	a_186_48##2	C	1.84362e-17
C240	VGND	a_27_112##3	1.06893e-18
C241	VPWR	a_27_112#	7.43629e-18
C242	D	C#2	2.9952e-18
C243	VGND#1	VNB	9.3695e-19
C244	VGND	B#3	1.30308e-18
C245	X	A_N#1	3.01879e-18
C246	VPWR	B#1	7.59167e-18
C247	X#3	VNB	2.5577e-18
C248	VGND	C#1	1.32687e-18
C249	D	D#2	1.71904e-17
C250	VGND#5	VNB	6.36774e-18
C251	VPWR	C#3	7.25174e-18
C252	VGND	D#1	5.79544e-19
C253	a_27_112##6	VNB	3.76808e-17
C254	VPWR	D#3	7.25174e-18
C255	VPWR#1	VNB	5.87087e-17
C256	VGND	a_186_48##5	1.95855e-18
C257	a_186_48##2	D	6.95847e-17
C258	VGND	a_186_48##4	4.71247e-18
C259	VPWR	a_186_48#	6.69145e-19
C260	VPWR#7	VNB	7.24182e-18
C261	VGND	A_N#4	7.79466e-18
C262	VPWR	a_186_48##6	4.34847e-19
C263	VPWR#8	VNB	5.40307e-18
C264	VPWR	A_N#1	6.66191e-18
C265	VPWR#9	VNB	1.18384e-17
C266	a_27_112##7	VNB	4.76645e-17
C267	a_27_112##3	VNB	3.50811e-17
C268	VPWR	VPWR#3	1.26403e-17
C269	A_N	A_N#3	8.95309e-18
C270	B#3	VNB	2.77646e-17
C271	C#1	VNB	2.75156e-17
C272	X	D#2	1.91782e-20
C273	D#1	VNB	2.83828e-17
C274	VPWR	a_27_112##2	1.78679e-17
C275	a_186_48##5	VNB	2.74363e-17
C276	X	a_186_48##2	6.82244e-17
C277	a_186_48##4	VNB	3.12395e-17
C278	A_N#4	VNB	3.7843e-17
C279	X	A_N#3	1.51598e-18
C280	a_27_112#	VNB	4.25334e-17
C281	B#1	VNB	3.3263e-17
C282	VGND	VGND#2	1.22918e-16
C283	C#3	VNB	3.4124e-17
C284	VPWR	a_186_48##2	3.25187e-18
C285	C	B	1.65419e-17
C286	VGND	a_27_112##2	3.4114e-18
C287	D#3	VNB	3.34827e-17
C288	a_186_48#	VNB	3.61398e-17
C289	a_186_48##6	VNB	3.70725e-17
C290	A_N#1	VNB	4.67383e-17
C291	VPWR#3	VNB	2.01023e-16
C292	VGND	a_186_48##2	1.44312e-17
C293	D	C	3.02588e-17
C294	VGND#2	VNB	3.00117e-16
C295	a_27_112##2	VNB	9.11238e-17
C296	B#2	VNB	3.3617e-17
C297	C#2	VNB	2.73758e-17
C298	D#2	VNB	2.71144e-17
C299	a_186_48##2	VNB	3.76761e-17
C300	A_N#3	VNB	6.5173e-17
C301	VPWR	B	2.89778e-18
C302	VPWR	C	2.51368e-18
C303	VPWR	D	2.51368e-18
C304	VGND	C	2.58018e-18
C305	VPWR	A_N	2.65032e-18
C306	VGND	D	2.48868e-18
C307	B	VNB	2.37386e-18
C308	VPWR	X	4.06466e-18
C309	C	VNB	3.50945e-18
C310	D	VNB	4.06931e-18
C311	VGND	X	1.19279e-18
C312	A_N	VNB	1.01475e-17
C313	X	VNB	4.97885e-19
C314	VPWR	VNB	5.9239e-17
C315	VGND	VNB	6.76074e-17
C316	VGND#3	a_186_48##5	1.05716e-18
C317	a_27_112##7	VPWR#5	1.36586e-17
C318	VPWR#5	VPWR#4	1.04452e-18
C319	VPWR#5	a_186_48##2	2.6093e-20
C320	VGND	VGND#3	4.92496e-17
C321	VPWR#3	VPWR#5	5.62806e-17
C322	VPWR#5	A_N#1	3.26111e-18
C323	VGND#2	VGND#3	5.44653e-17
C324	VGND#3	VGND#1	7.73195e-20
C325	VGND#3	a_186_48##4	9.55994e-18
C326	VPWR#5	VNB	5.303e-17
C327	VPWR	VPWR#5	4.04111e-17
C328	VGND#3	a_186_48##3	4.34612e-20
C329	VGND#3	D#1	1.71926e-19
C330	VPWR#5	a_186_48##3	5.65836e-20
C331	VGND#3	a_27_112##6	1.12516e-17
C332	VGND#3	VNB	5.26071e-17
C333	VPWR#5	A_N#3	2.61368e-19
C334	VGND#3	X#3	7.89366e-18
C335	VGND#3	A_N#4	2.20851e-18
C336	VGND#3	A_N#3	2.86211e-19
C337	VPWR#5	a_186_48##6	4.25109e-18
*
*
.ENDS sky130_fd_sc_hs__and4b_2
*
