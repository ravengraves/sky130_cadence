* Extracted by Quantus, converted by sky130cad/quantus.py
*
*
*
*                       LINUX           Wed Nov 18 08:23:32 2026
*
*
*
*  PROGRAM  advgen
*
*  Name           : advgen - Quantus - (64-bit)
*  Version        : 25.1.0-p047
*  Build Date     : Thu Dec 11 23:20:30 PST 2025
*
*  HSPICE LIBRARY
*
*  OPERATING_TEMPERATURE 150
*  QRC_TECH_DIR <path>/tech
*
*
*

*
.SUBCKT sky130_fd_sc_hs__clkdlyinv5sd2_1 VPB VNB VGND VPWR Y A
*
*
*  caps2d version: 10
*
*
*       TRANSISTOR CARDS
*
*
XM2 a_28_74##7 A#3 VGND#9 VNB sky130_fd_pr__nfet_01v8_lvt l=0.15 w=0.42 ad=0.1113 as=0.2961 pd=1.37 ps=2.25
XM6 VGND#9 a_28_74# a_288_74##7 VNB sky130_fd_pr__nfet_01v8_lvt l=0.18 w=0.42 ad=0.2961 as=0.1113 pd=2.25 ps=1.37
XM7 VGND#8 a_288_74# a_549_74##7 VNB sky130_fd_pr__nfet_01v8_lvt l=0.18 w=0.42 ad=0.2478 as=0.1113 pd=2.02 ps=1.37
XM8 a_682_74##6 a_549_74# VGND#7 VNB sky130_fd_pr__nfet_01v8_lvt l=0.18 w=0.42 ad=0.2457 as=0.1932 pd=2.01 ps=1.76
XM1 VGND#7 a_682_74##3 Y#3 VNB sky130_fd_pr__nfet_01v8_lvt l=0.15 w=0.42 ad=0.1932 as=0.1113 pd=1.76 ps=1.37
XM3 a_28_74##5 A#1 VPWR#9 VPB sky130_fd_pr__pfet_01v8 l=0.15 w=1.12 ad=0.3136 as=0.6568 pd=2.8 ps=3.49
XM9 VPWR#9 a_28_74##4 a_288_74##8 VPB sky130_fd_pr__pfet_01v8 l=0.25 w=1 ad=0.6568 as=0.26 pd=3.49 ps=2.52
XM4 VPWR#8 a_288_74##4 a_549_74##8 VPB sky130_fd_pr__pfet_01v8 l=0.25 w=1 ad=0.52 as=0.265 pd=3.04 ps=2.53
XM0 a_682_74##4 a_549_74##4 VPWR#7 VPB sky130_fd_pr__pfet_01v8 l=0.25 w=1 ad=0.51 as=0.508 pd=3.02 ps=3.19
XM5 VPWR#7 a_682_74# Y#1 VPB sky130_fd_pr__pfet_01v8 l=0.15 w=1.12 ad=0.508 as=0.3136 pd=3.19 ps=2.8
*
*
*       RESISTOR AND CAP/DIODE CARDS
*
Rg1	A#1	A#2	505.110291
Rg2	A#2	A#3	382.539764
Rg3	a_28_74#	a_28_74##2	283.440552
Rg4	a_28_74##2	a_28_74##3	183.939224
Rg5	a_28_74##2	a_28_74##4	328.301208
Rg6	a_288_74#	a_288_74##2	288.514343
Rg7	a_288_74##2	a_288_74##3	27.643862
Rg8	a_288_74##2	a_288_74##4	327.176300
Rg9	a_549_74#	a_549_74##2	286.223480
Rg10	a_549_74##2	a_549_74##3	45.860924
Rg11	a_549_74##2	a_549_74##4	316.909668
Rg12	a_682_74#	a_682_74##2	467.246124
Rg13	a_682_74##2	a_682_74##3	455.213867
Rf1	A	A#4	3.280892
Rf2	A#5	A#2	163.513702
Rf3	A#4	A#5	1.266811
Rf4	A	A#7	3.280892
Rf5	A#5	A#7	6.545189
Rf6	a_28_74##5	a_28_74##3	99.886612
Rf7	a_28_74##3	a_28_74##7	87.592514
Rf8	a_288_74##3	a_288_74##6	194.951324
Rf9	a_288_74##6	a_288_74##7	52.096035
Rf10	a_288_74##6	a_288_74##8	17.895864
Rf11	a_549_74##3	a_549_74##6	224.869141
Rf12	a_549_74##6	a_549_74##7	68.059647
Rf13	a_549_74##6	a_549_74##8	89.471367
Rf14	a_682_74##4	a_682_74##5	129.092072
Rf15	a_682_74##5	a_682_74##6	127.751671
Rf16	Y#2	Y	1.177624
Rf17	Y	Y#4	15.111293
Rf18	Y#4	Y	1.268211
Rf19	Y#2	Y	12.229176
Rf20	Y#1	Y#2	5.000000
Rf21	Y#3	Y#4	15.000000
Rf23	VPWR#2	VPWR#3	135.484131
Rf24	VPWR#3	VPWR#4	40.142254
Rf25	VPWR#4	VPWR#5	98.558121
Rf27	VPWR#2	VPWR#7	38.384460
Rf28	VPWR#4	VPWR#8	34.238716
Rf29	VPWR#5	VPWR#9	30.944223
Rf31	VGND#2	VGND#3	135.484131
Rf32	VGND#3	VGND#4	40.142254
Rf33	VGND#4	VGND#5	97.827614
Rf35	VGND#2	VGND#7	34.704330
Rf36	VGND#4	VGND#8	33.444363
Rf37	VGND#5	VGND#9	33.916985
Rf42	a_682_74##2	a_682_74##5	160.232803
Re1	VPWR#3	VPWR	1.165462
Re2	VGND#3	VGND	1.165462
*
*       CAPACITOR CARDS
*
*
C1	VGND	VNB	2.957e-16
C2	VPWR	VNB	2.93467e-16
C3	Y	VNB	2.4356e-17
C4	VPWR	Y	2.46636e-17
C5	A#2	VNB	7.27539e-17
C6	a_28_74##3	VNB	8.02304e-17
C7	a_288_74##3	VNB	9.00835e-17
C8	a_549_74##3	VNB	7.86367e-17
C9	a_682_74##2	VNB	6.67509e-17
C10	VGND#3	VNB	3.7824e-17
C11	VPWR#3	VNB	4.03537e-17
C12	VGND	A#2	6.43288e-18
C13	a_682_74##6	Y#3	2.48329e-18
C14	VGND	a_28_74##3	1.35383e-17
C15	A#1	VNB	6.04827e-17
C16	a_28_74##4	VNB	7.17268e-17
C17	VGND	a_288_74##3	1.23972e-17
C18	a_288_74##4	VNB	7.56467e-17
C19	VGND	a_549_74##3	3.39214e-18
C20	a_549_74##4	VNB	6.81975e-17
C21	a_682_74#	VNB	3.73814e-17
C22	VGND	a_682_74##2	8.01548e-18
C23	VGND	VGND#3	6.46364e-17
C24	A#3	VNB	3.79862e-17
C25	VPWR	a_28_74##3	9.66375e-18
C26	a_28_74#	VNB	3.97394e-17
C27	a_288_74#	VNB	4.43571e-17
C28	VPWR	a_288_74##3	7.9697e-18
C29	a_549_74#	VNB	3.41555e-17
C30	a_288_74##8	VPWR#4	1.3381e-17
C31	a_682_74##3	VNB	3.35949e-17
C32	VPWR	a_549_74##3	8.38336e-19
C33	a_28_74##5	VNB	3.55693e-17
C34	VPWR#9	VNB	5.63845e-18
C35	VPWR	a_682_74##2	7.12336e-18
C36	a_288_74##8	VNB	5.33872e-18
C37	VPWR#8	VNB	1.56997e-17
C38	a_549_74##8	VNB	7.98285e-18
C39	VPWR	VPWR#3	6.57363e-17
C40	a_682_74##4	VNB	1.59885e-17
C41	VPWR#7	VNB	3.37865e-18
C42	Y#1	VNB	8.55623e-17
C43	VGND	A#3	1.08819e-18
C44	a_28_74##7	VNB	3.80407e-17
C45	VPWR	A#1	1.30244e-18
C46	VGND#9	VNB	2.39501e-18
C47	VGND	a_28_74#	5.82703e-18
C48	a_288_74##7	VNB	1.05249e-17
C49	VGND#7	Y#3	3.04946e-17
C50	VPWR	a_28_74##4	5.90554e-18
C51	VGND#8	VNB	1.0573e-17
C52	VGND	a_288_74#	6.84148e-18
C53	a_549_74##7	VNB	2.59809e-18
C54	VGND	a_549_74#	1.42974e-18
C55	VPWR	a_288_74##4	9.31318e-18
C56	a_682_74##6	VNB	1.76841e-17
C57	VGND#7	VNB	3.26504e-18
C58	VGND	a_682_74##3	1.6316e-18
C59	VPWR	a_549_74##4	4.06982e-18
C60	Y#3	VNB	2.64043e-17
C61	VPWR	a_682_74#	2.72975e-18
C62	A#7	VNB	1.97483e-17
C63	VGND	VPWR#8	4.56327e-18
C64	a_288_74##6	VNB	2.25088e-17
C65	VGND	a_682_74##4	4.31819e-18
C66	a_549_74##6	VNB	2.07596e-17
C67	VGND	Y#1	1.06696e-18
C68	VGND	a_28_74##7	1.87578e-17
C69	VGND	VGND#9	1.50108e-17
C70	Y	a_682_74#	1.04357e-17
C71	VGND	a_288_74##7	1.8798e-17
C72	VPWR#4	VNB	3.35553e-17
C73	VPWR	a_28_74##5	1.62672e-17
C74	VPWR	VPWR#9	2.31189e-17
C75	VGND	a_549_74##7	1.37836e-17
C76	VPWR	a_288_74##8	1.70906e-17
C77	VGND	a_682_74##6	2.25654e-17
C78	VGND#4	VNB	3.4369e-17
C79	VPWR	VPWR#8	2.00802e-17
C80	VGND	Y#3	2.08377e-17
C81	VPWR	a_549_74##8	1.28416e-17
C82	VPWR	a_682_74##4	1.83199e-17
C83	VPWR	VPWR#7	2.20618e-17
C84	A#2	a_28_74##3	7.18947e-17
C85	VGND	a_288_74##6	3.28876e-18
C86	VGND	a_549_74##6	6.83093e-18
C87	a_28_74##3	a_288_74##3	5.12776e-18
C88	VPWR#7	Y	3.54634e-17
C89	Y	Y#1	4.16662e-18
C90	VPWR	A#7	5.56552e-18
C91	VGND	VGND#4	8.14097e-17
C92	a_288_74##3	a_549_74##3	4.68512e-18
C93	VPWR	a_288_74##6	1.27095e-18
C94	VPWR	a_549_74##6	5.28233e-18
C95	a_682_74##2	a_288_74##3	5.01385e-20
C96	VGND#3	a_288_74##3	1.5539e-18
C97	VGND#8	a_288_74##6	5.71588e-18
C98	a_682_74##2	a_549_74##3	5.29797e-17
C99	VPWR	VPWR#4	6.32431e-17
C100	VPWR#3	a_288_74##3	1.88507e-19
C101	VGND#3	a_549_74##3	4.9442e-20
C102	A#1	a_28_74##3	4.10857e-18
C103	a_28_74##3	a_28_74##4	2.68798e-17
C104	a_28_74##3	a_288_74##4	3.93383e-19
C105	a_288_74##6	a_549_74##7	4.49436e-19
C106	a_28_74##4	a_288_74##3	2.01911e-20
C107	A#3	a_28_74##3	2.85271e-19
C108	a_28_74##3	a_28_74#	8.46112e-18
C109	a_28_74##3	a_288_74#	4.29649e-19
C110	a_682_74##2	a_549_74##4	1.37307e-17
C111	a_28_74##5	A#2	1.74609e-18
C112	VPWR#9	A#2	6.29041e-19
C113	VPWR#3	a_288_74##4	1.29634e-17
C114	a_28_74##3	a_28_74##5	6.41214e-18
C115	a_28_74##3	VPWR#9	3.37293e-18
C116	A#1	a_28_74##4	1.63174e-17
C117	a_549_74##6	a_682_74##6	6.75623e-18
C118	a_549_74##3	a_682_74##3	1.68944e-18
C119	a_549_74##8	a_28_74##3	9.94028e-21
C120	a_28_74##4	a_288_74##4	5.23317e-18
C121	a_28_74##7	A#2	6.21166e-17
C122	a_288_74##3	VPWR#8	1.56798e-17
C123	VGND#3	a_288_74#	1.06948e-17
C124	a_682_74##2	a_682_74##3	4.93178e-18
C125	VGND#9	A#2	8.77831e-19
C126	a_549_74##8	a_288_74##3	2.52233e-19
C127	a_682_74##4	a_288_74##3	2.00812e-18
C128	a_288_74##4	a_549_74##4	4.30491e-18
C129	VGND#9	a_28_74##3	2.26944e-17
C130	a_549_74##8	a_549_74##3	1.21821e-20
C131	a_28_74##3	a_288_74##7	1.01689e-17
C132	a_682_74##4	a_549_74##3	5.49595e-17
C133	a_549_74##4	a_682_74#	2.69399e-17
C134	VGND#8	a_288_74##3	1.66336e-17
C135	a_682_74##2	VPWR#7	3.69003e-17
C136	A#7	A#2	8.18769e-18
C137	a_682_74##2	Y#1	9.21702e-17
C138	a_682_74##6	a_288_74##3	1.15425e-18
C139	a_28_74##5	A#1	4.30511e-17
C140	a_549_74##8	VPWR#3	1.36807e-17
C141	A#1	VPWR#9	4.50412e-17
C142	a_682_74##4	VPWR#3	9.78867e-18
C143	A#7	a_28_74##3	2.73651e-17
C144	a_28_74##5	a_28_74##4	1.92237e-18
C145	a_682_74##6	a_549_74##3	7.46211e-17
C146	a_288_74##8	A#1	3.57585e-18
C147	a_28_74##4	VPWR#9	3.34318e-17
C148	VPWR#8	A#1	5.94554e-19
C149	a_28_74##5	a_288_74##4	3.28091e-19
C150	a_28_74##3	a_288_74##6	1.34774e-16
C151	a_288_74##8	a_28_74##4	4.41188e-17
C152	VGND#9	VGND#4	1.37413e-20
C153	A#3	a_28_74#	6.95627e-18
C154	a_682_74##6	a_682_74##2	5.33879e-18
C155	VPWR#9	a_288_74##4	1.02801e-18
C156	VPWR#8	a_28_74##4	5.98629e-18
C157	a_549_74##6	a_28_74##3	8.06149e-19
C158	VGND#7	a_682_74##2	2.81763e-17
C159	a_288_74##8	a_288_74##4	1.53135e-18
C160	VGND#3	a_549_74##7	8.52972e-18
C161	a_549_74##8	a_28_74##4	1.35749e-18
C162	a_288_74##6	a_288_74##3	2.16942e-18
C163	a_288_74##4	VPWR#8	3.64332e-17
C164	VGND#3	a_682_74##6	1.00789e-17
C165	a_28_74#	a_288_74#	2.44903e-18
C166	VGND#4	a_288_74##7	1.71263e-17
C167	a_288_74##4	a_549_74##8	7.26331e-17
C168	a_288_74##3	a_549_74##6	4.64638e-17
C169	VPWR#8	a_549_74##4	1.48659e-18
C170	a_682_74##4	a_288_74##4	1.01179e-17
C171	a_549_74##8	a_549_74##4	1.76501e-18
C172	a_288_74#	a_549_74#	2.82482e-18
C173	VPWR#7	a_288_74##4	1.54219e-18
C174	a_549_74##6	a_549_74##3	2.0233e-18
C175	a_682_74##4	a_549_74##4	9.1231e-17
C176	VPWR#7	a_549_74##4	3.18165e-17
C177	a_682_74##4	a_682_74#	4.90357e-18
C178	VPWR#4	a_288_74##3	6.04792e-19
C179	a_549_74#	a_682_74##3	1.33761e-17
C180	Y#1	a_549_74##4	6.23709e-20
C181	a_549_74##6	a_682_74##2	8.91094e-19
C182	VPWR#7	a_682_74#	6.40065e-17
C183	a_682_74#	Y#1	1.84824e-17
C184	a_288_74##6	a_549_74##6	4.58393e-18
C185	VGND#3	a_549_74##6	2.4683e-18
C186	VGND#4	a_288_74##3	7.86324e-19
C187	a_28_74##5	VPWR#9	7.21782e-17
C188	A#7	A#1	9.40117e-18
C189	a_28_74##7	A#3	4.00636e-17
C190	a_28_74##5	a_288_74##8	3.50209e-19
C191	A#3	VGND#9	2.1631e-17
C192	A#7	a_28_74##4	1.67272e-18
C193	a_28_74##7	a_28_74#	1.80157e-18
C194	VPWR#9	a_288_74##8	1.76183e-17
C195	a_288_74##6	A#1	5.91513e-19
C196	a_288_74##7	A#3	3.0678e-18
C197	a_28_74#	VGND#9	1.63252e-17
C198	VPWR#9	VPWR#8	2.384e-18
C199	VGND#8	A#3	1.36423e-19
C200	Y#1	a_549_74#	5.45338e-20
C201	a_28_74#	a_288_74##7	2.36776e-17
C202	a_288_74##6	a_28_74##4	1.32026e-17
C203	VGND#9	a_288_74#	5.15727e-19
C204	a_288_74##8	VPWR#8	5.2351e-17
C205	VGND#8	a_28_74#	1.66201e-18
C206	Y#1	a_682_74##3	2.05888e-18
C207	a_288_74##7	a_288_74#	2.23516e-18
C208	a_549_74##7	a_28_74#	7.28973e-19
C209	a_288_74##6	a_288_74##4	2.86575e-18
C210	a_288_74#	VGND#8	1.52558e-17
C211	a_682_74##6	a_28_74#	2.14718e-19
C212	VPWR#8	a_549_74##8	3.38713e-17
C213	a_288_74#	a_549_74##7	2.38582e-17
C214	a_28_74##7	a_28_74##5	1.1762e-19
C215	VGND#8	a_549_74#	8.58356e-19
C216	a_682_74##6	a_288_74#	5.64585e-18
C217	a_549_74##7	a_549_74#	5.73468e-19
C218	a_549_74##8	a_682_74##4	5.11807e-17
C219	VGND#7	a_288_74#	1.16458e-18
C220	a_682_74##6	a_549_74#	3.16815e-17
C221	Y#3	a_288_74#	4.85257e-19
C222	VPWR#4	a_28_74##4	2.24403e-18
C223	a_549_74#	VGND#7	1.54077e-17
C224	a_682_74##6	a_682_74##3	2.21714e-18
C225	a_682_74##4	VPWR#7	2.89452e-17
C226	Y#3	a_549_74#	1.72202e-18
C227	VGND#7	a_682_74##3	2.65212e-17
C228	a_682_74##4	Y#1	4.04678e-19
C229	Y#3	a_682_74##3	1.38239e-17
C230	VPWR#7	Y#1	6.52116e-17
C231	a_288_74##6	a_28_74#	9.32171e-19
C232	a_288_74##6	a_288_74#	3.30584e-19
C233	a_549_74##6	a_28_74#	4.4799e-20
C234	a_549_74##6	a_288_74#	5.69665e-19
C235	A#7	a_28_74##5	5.8611e-17
C236	a_28_74##7	VGND#9	4.43527e-17
C237	VGND#4	a_288_74##6	8.83117e-19
C238	a_549_74##6	a_549_74#	1.98166e-20
C239	a_28_74##7	a_288_74##7	1.50063e-18
C240	A#7	VPWR#9	3.24686e-19
C241	VGND#9	a_288_74##7	1.17317e-17
C242	a_28_74##5	a_288_74##6	1.16498e-18
C243	a_682_74##6	Y#1	8.44886e-20
C244	VGND#9	VGND#8	7.53127e-19
C245	a_288_74##7	VGND#8	3.65628e-17
C246	VGND#4	A#3	1.05961e-19
C247	Y#3	Y#1	5.25545e-19
C248	a_288_74##6	a_288_74##8	4.47883e-18
C249	a_288_74##7	a_549_74##7	2.65192e-18
C250	a_288_74##6	VPWR#8	4.40832e-17
C251	VGND#8	a_549_74##7	1.15146e-17
C252	VGND#4	a_28_74#	1.30894e-18
C253	VGND#8	a_682_74##6	1.69003e-18
C254	a_288_74##6	a_549_74##8	3.66983e-18
C255	VGND#4	a_288_74#	2.19741e-18
C256	a_549_74##7	a_682_74##6	2.39756e-17
C257	VGND#4	a_549_74#	1.80924e-19
C258	a_549_74##6	a_682_74##4	8.05504e-18
C259	a_682_74##6	VGND#7	8.70671e-18
C260	VPWR#9	VPWR#4	1.93468e-19
C261	Y	VPWR#2	3.28847e-17
C262	VPWR	VPWR#5	9.36097e-17
C263	VGND	VGND#2	1.29019e-16
C264	VPWR#5	VPWR#4	4.40448e-19
C265	VPWR#2	a_549_74##4	1.16888e-17
C266	VGND#5	a_28_74##7	2.46863e-17
C267	VGND#5	A#3	4.84508e-18
C268	VGND#2	a_682_74##3	6.1519e-18
C269	VGND	VGND#5	9.39338e-17
C270	VGND#2	a_549_74##3	8.08583e-19
C271	VGND#5	a_28_74##3	5.23336e-18
C272	VPWR#2	a_682_74#	4.54745e-18
C273	a_682_74##4	VPWR#2	8.1349e-18
C274	VPWR#5	A#1	1.11819e-18
C275	VGND#2	Y#3	2.25397e-17
C276	VGND#5	a_28_74#	8.17652e-18
C277	VGND#2	a_682_74##2	7.1945e-19
C278	VPWR#2	VNB	6.45784e-17
C279	VGND#5	VGND#4	7.36092e-19
C280	VPWR#5	a_28_74##4	8.65058e-18
C281	VPWR#5	VNB	5.52666e-17
C282	a_28_74##5	VPWR#5	9.48505e-18
C283	VGND#2	a_288_74#	1.60027e-19
C284	VPWR#2	a_549_74##3	3.76213e-19
C285	VGND#5	a_288_74#	5.89398e-20
C286	VGND#2	VNB	6.49974e-17
C287	VPWR	VPWR#2	1.12822e-16
C288	a_682_74##2	VPWR#2	1.04459e-18
C289	VGND#2	a_682_74##6	1.18335e-17
C290	a_28_74##3	VPWR#5	2.90125e-18
C291	VGND#5	VNB	5.56883e-17
C292	VGND#2	a_549_74#	1.11497e-17
*
*
.ENDS sky130_fd_sc_hs__clkdlyinv5sd2_1
*
