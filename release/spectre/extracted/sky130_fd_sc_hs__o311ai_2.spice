* Extracted by Quantus, converted by sky130cad/quantus.py
*
*
*
*                       LINUX           Wed Nov 18 09:01:07 2026
*
*
*
*  PROGRAM  advgen
*
*  Name           : advgen - Quantus - (64-bit)
*  Version        : 25.1.0-p047
*  Build Date     : Thu Dec 11 23:20:30 PST 2025
*
*  HSPICE LIBRARY
*
*  OPERATING_TEMPERATURE 150
*  QRC_TECH_DIR <path>/tech
*
*
*

*
.SUBCKT sky130_fd_sc_hs__o311ai_2 VNB VPB VGND VPWR Y C1 A1 A2 A3 B1
*
*
*  caps2d version: 10
*
*
*       TRANSISTOR CARDS
*
*
XM0 VGND#8 A1#5 a_27_74##5 VNB sky130_fd_pr__nfet_01v8_lvt l=0.15 w=0.74 ad=0.2516 as=0.2109 pd=2.16 ps=2.05
XM17 a_27_74##8 A1#1 VGND#8 VNB sky130_fd_pr__nfet_01v8_lvt l=0.15 w=0.74 ad=0.2516 as=0.2516 pd=2.16 ps=2.16
XM2 a_27_74##8 A2#7 VGND#7 VNB sky130_fd_pr__nfet_01v8_lvt l=0.15 w=0.74 ad=0.2516 as=0.2146 pd=2.16 ps=2.06
XM11 VGND#7 A2#6 a_27_74##7 VNB sky130_fd_pr__nfet_01v8_lvt l=0.15 w=0.74 ad=0.2146 as=0.2368 pd=2.06 ps=2.12
XM13 VGND#6 A3#6 a_27_74##7 VNB sky130_fd_pr__nfet_01v8_lvt l=0.15 w=0.74 ad=0.2294 as=0.2368 pd=2.1 ps=2.12
XM5 a_27_74##6 A3#5 VGND#6 VNB sky130_fd_pr__nfet_01v8_lvt l=0.15 w=0.74 ad=0.2072 as=0.2294 pd=2.04 ps=2.1
XM6 a_670_74##2 B1#5 a_27_74##6 VNB sky130_fd_pr__nfet_01v8_lvt l=0.15 w=0.74 ad=0.3108 as=0.2072 pd=2.32 ps=2.04
XM19 a_27_74# B1#7 a_670_74##2 VNB sky130_fd_pr__nfet_01v8_lvt l=0.15 w=0.74 ad=0.2109 as=0.3108 pd=2.05 ps=2.32
XM3 Y#6 C1#6 a_670_74# VNB sky130_fd_pr__nfet_01v8_lvt l=0.15 w=0.74 ad=0.2109 as=0.2072 pd=2.05 ps=2.04
XM8 a_670_74# C1#1 Y#1 VNB sky130_fd_pr__nfet_01v8_lvt l=0.15 w=0.74 ad=0.2072 as=0.2109 pd=2.04 ps=2.05
XM1 VPWR#9 A1#6 a_28_368##3 VPB sky130_fd_pr__pfet_01v8 l=0.15 w=1.12 ad=0.3472 as=0.3304 pd=2.86 ps=2.83
XM15 a_28_368##4 A1#4 VPWR#9 VPB sky130_fd_pr__pfet_01v8 l=0.15 w=1.12 ad=0.3808 as=0.3472 pd=2.92 ps=2.86
XM9 a_28_368##4 A2#5 a_307_368##2 VPB sky130_fd_pr__pfet_01v8 l=0.15 w=1.12 ad=0.3808 as=0.4144 pd=2.92 ps=2.98
XM10 a_307_368##2 A2#1 a_28_368# VPB sky130_fd_pr__pfet_01v8 l=0.15 w=1.12 ad=0.4144 as=0.3304 pd=2.98 ps=2.83
XM4 a_307_368# A3#4 Y#5 VPB sky130_fd_pr__pfet_01v8 l=0.15 w=1.12 ad=0.336 as=0.3304 pd=2.84 ps=2.83
XM12 Y#9 A3#1 a_307_368# VPB sky130_fd_pr__pfet_01v8 l=0.15 w=1.12 ad=0.336 as=0.336 pd=2.84 ps=2.84
XM7 VPWR#8 B1#6 Y#9 VPB sky130_fd_pr__pfet_01v8 l=0.15 w=1.12 ad=0.336 as=0.336 pd=2.84 ps=2.84
XM14 Y#7 B1#1 VPWR#8 VPB sky130_fd_pr__pfet_01v8 l=0.15 w=1.12 ad=0.336 as=0.336 pd=2.84 ps=2.84
XM18 VPWR#7 C1#4 Y#7 VPB sky130_fd_pr__pfet_01v8 l=0.15 w=1.12 ad=0.336 as=0.336 pd=2.84 ps=2.84
XM16 Y#8 C1#5 VPWR#7 VPB sky130_fd_pr__pfet_01v8 l=0.15 w=1.12 ad=0.3304 as=0.336 pd=2.83 ps=2.84
*
*
*       RESISTOR AND CAP/DIODE CARDS
*
Rg1	A1#1	A1#2	397.555725
Rg2	A1#2	A1#3	58.159081
Rg3	A1#2	A1#4	449.655212
Rg4	A1#3	A1#5	402.789612
Rg5	A1#3	A1#6	451.603058
Rg6	A2#1	A2#2	454.869080
Rg7	A2#2	A2#3	30.596947
Rg8	A2#3	A2#4	36.519821
Rg9	A2#4	A2#5	462.000427
Rg10	A2#2	A2#6	418.139221
Rg11	A2#4	A2#7	403.815002
Rg12	A3#1	A3#2	623.825378
Rg13	A3#2	A3#3	54.972351
Rg14	A3#2	A3#4	393.220184
Rg15	A3#3	A3#5	376.382294
Rg16	A3#3	A3#6	436.005524
Rg17	B1#1	B1#2	538.511230
Rg18	B1#2	B1#3	16.609240
Rg19	B1#3	B1#4	49.580112
Rg20	B1#4	B1#5	546.072144
Rg21	B1#2	B1#6	423.989929
Rg22	B1#4	B1#7	269.511658
Rg23	C1#1	C1#2	341.364044
Rg24	C1#2	C1#3	71.234978
Rg25	C1#3	C1#4	474.792969
Rg26	C1#2	C1#5	444.364258
Rg27	C1#3	C1#6	377.321411
Rf1	A1#7	A1	1.409262
Rf2	A1#3	A1#9	161.642059
Rf3	A1#7	A1#9	10.543295
Rf4	A1#10	A1	1.409262
Rf5	A1#9	A1#10	4.125637
Rf6	A2	A2#8	12.988117
Rf7	A2#8	A2	1.680815
Rf8	a_28_368#	a_28_368##2	91.349487
Rf9	a_28_368##2	a_28_368##3	84.759918
Rf10	a_28_368##2	a_28_368##4	18.602406
Rf11	A3#7	A3	1.409262
Rf12	A3#3	A3#9	161.642059
Rf13	A3#7	A3#9	1.528014
Rf14	A3#10	A3	1.409262
Rf15	A3#9	A3#10	13.140918
Rf16	a_307_368#	a_307_368##2	150.257019
Rf17	B1#8	B1	1.409262
Rf18	B1#3	B1#10	161.642059
Rf19	B1#8	B1#10	10.237692
Rf20	B1#11	B1	1.409262
Rf21	B1#10	B1#11	4.431240
Rf22	a_27_74#	a_27_74##2	87.430649
Rf23	a_27_74##2	a_27_74##3	68.002594
Rf24	a_27_74##3	a_27_74##4	68.002594
Rf25	a_27_74##4	a_27_74##5	93.397949
Rf26	a_27_74##2	a_27_74##6	21.341251
Rf27	a_27_74##3	a_27_74##7	21.341251
Rf28	a_27_74##4	a_27_74##8	21.341251
Rf29	a_670_74#	a_670_74##2	144.414978
Rf30	C1#7	C1	1.879015
Rf31	C1#2	C1#9	81.995415
Rf32	C1#7	C1#9	6.046876
Rf33	C1#10	C1	1.879015
Rf34	C1#9	C1#10	7.146308
Rf35	Y#1	Y#2	79.130768
Rf36	Y#2	Y	9.910665
Rf37	Y	Y#3	14.938159
Rf38	Y#3	Y#4	67.917450
Rf39	Y#4	Y#5	75.920235
Rf40	Y#2	Y	4.899895
Rf41	Y	Y#6	17.757542
Rf42	Y#3	Y#7	30.615402
Rf43	Y#3	Y#8	80.349091
Rf44	Y#4	Y#9	22.678455
Rf46	VPWR#2	VPWR#3	62.831711
Rf47	VPWR#3	VPWR#4	90.192833
Rf48	VPWR#4	VPWR#5	153.804108
Rf50	VPWR#2	VPWR#7	38.736572
Rf51	VPWR#3	VPWR#8	31.534731
Rf52	VPWR#5	VPWR#9	38.736572
Rf53	VGND#1	VGND#2	18.238092
Rf54	VGND#2	VGND#3	67.887894
Rf55	VGND#3	VGND#4	72.270927
Rf57	VGND#2	VGND#6	35.098007
Rf58	VGND#3	VGND#7	35.098007
Rf59	VGND#4	VGND#8	35.098007
Rf61	A2#3	A2#8	80.116402
Re1	VPWR#4	VPWR	0.818510
Re2	VGND	VGND#1	0.818540
*
*       CAPACITOR CARDS
*
*
C1	VGND#6	a_670_74##2	3.17539e-18
C2	VGND#3	A3#6	4.13261e-19
C3	VGND#6	a_27_74##6	4.2284e-17
C4	VGND#2	A3#6	3.0271e-18
C5	Y#4	B1#4	8.39399e-19
C6	a_27_74##7	a_27_74##6	1.80421e-18
C7	VGND#3	A2#6	4.36913e-18
C8	A3#9	Y#5	2.35131e-17
C9	Y#4	B1#5	1.93889e-18
C10	a_27_74##7	VGND#6	4.45144e-17
C11	C1#7	Y#3	1.74354e-17
C12	VGND#2	A2#6	5.79781e-19
C13	Y#3	C1#3	7.40011e-19
C14	A1#2	VPWR#9	1.53466e-19
C15	Y#4	B1#2	3.34166e-19
C16	VGND#7	VGND#6	2.5909e-18
C17	VGND#3	A2#7	4.03679e-18
C18	VGND#1	B1#2	2.91583e-20
C19	VGND#7	a_27_74##7	4.2284e-17
C20	a_670_74#	C1#3	1.9227e-19
C21	a_28_368##2	a_28_368#	4.83358e-19
C22	VGND#3	A1#1	3.93131e-19
C23	a_27_74##8	a_27_74##7	1.80687e-18
C24	a_27_74##2	Y#4	4.88446e-18
C25	Y#3	B1#2	1.08843e-18
C26	C1#3	C1#2	3.8654e-18
C27	a_28_368##2	a_307_368##2	2.17578e-17
C28	a_27_74##8	VGND#7	4.45253e-17
C29	VGND#3	A1#5	1.48397e-19
C30	a_670_74#	B1#2	3.79324e-19
C31	a_27_74##2	B1#7	1.71226e-19
C32	B1#4	C1#6	1.14117e-18
C33	a_28_368##2	a_28_368##4	2.36655e-18
C34	VGND#8	VGND#7	2.38201e-18
C35	a_27_74##3	B1#5	4.41656e-20
C36	VGND#8	a_27_74##8	3.29173e-17
C37	a_27_74##2	B1#5	2.30006e-17
C38	a_28_368##2	VPWR#9	2.15485e-17
C39	a_27_74##3	A3#5	1.09483e-19
C40	a_27_74##5	a_27_74##8	1.62669e-18
C41	a_28_368##3	a_28_368##2	5.71542e-19
C42	a_27_74##2	A3#5	1.49161e-17
C43	a_27_74##4	A3#6	4.40344e-20
C44	B1#10	Y#4	1.76212e-17
C45	a_27_74##5	VGND#8	5.13382e-17
C46	a_27_74##3	A3#6	2.36419e-17
C47	a_27_74##2	A3#6	9.54768e-20
C48	a_27_74##4	A2#6	1.78075e-19
C49	a_27_74#	B1#4	1.12006e-17
C50	A3#3	B1#4	5.19351e-19
C51	a_27_74##3	A2#6	1.73804e-17
C52	A3#3	B1#2	7.28486e-19
C53	a_27_74#	B1#2	3.00292e-18
C54	a_27_74##2	A2#6	4.17161e-20
C55	a_27_74##4	A2#7	1.43909e-17
C56	A1#9	a_28_368##3	1.7833e-17
C57	a_27_74##3	A2#7	9.84433e-20
C58	a_27_74##4	a_27_74##3	5.47891e-19
C59	Y#8	VPWR#7	5.35877e-17
C60	a_27_74##4	A1#1	2.84177e-17
C61	a_670_74##2	B1#4	1.47735e-18
C62	a_27_74##3	A1#1	4.27198e-20
C63	Y#7	Y#8	1.79241e-18
C64	Y#3	C1#5	8.94386e-19
C65	a_670_74##2	B1#2	7.75061e-19
C66	Y#1	C1#1	3.3375e-17
C67	VPWR#3	B1#1	1.84352e-18
C68	A2#4	A2#3	3.74214e-18
C69	a_27_74##4	A1#5	1.7864e-19
C70	Y#7	VPWR#7	5.11921e-17
C71	Y#4	C1#4	1.07786e-19
C72	a_670_74#	C1#1	3.46206e-17
C73	a_27_74##3	a_27_74##2	5.47082e-19
C74	Y#3	C1#4	1.91558e-17
C75	Y#1	C1#6	1.41184e-18
C76	VPWR#8	VPWR#7	2.66815e-18
C77	C1#7	C1#3	8.68797e-18
C78	VPWR#3	B1#6	1.83922e-18
C79	a_670_74#	C1#6	4.40307e-17
C80	Y#4	B1#1	2.40966e-19
C81	VPWR#8	Y#7	5.20507e-17
C82	Y#1	B1#7	1.02473e-19
C83	C1#6	Y#6	7.70656e-18
C84	Y#3	B1#1	1.75457e-17
C85	a_670_74#	B1#7	4.28801e-19
C86	Y#9	Y#7	8.39315e-19
C87	VPWR#3	A3#1	1.60996e-18
C88	a_27_74#	C1#6	8.70206e-19
C89	A1#3	A1#2	3.45341e-18
C90	Y#4	B1#6	1.44614e-17
C91	C1#7	C1#4	1.73084e-18
C92	Y#9	VPWR#8	5.15009e-17
C93	a_670_74##2	C1#6	3.71018e-19
C94	a_670_74#	B1#5	1.28929e-19
C95	Y#3	B1#6	6.23613e-19
C96	a_27_74#	B1#7	4.70578e-17
C97	a_307_368#	VPWR#8	3.04242e-18
C98	VGND#2	Y#1	1.83985e-17
C99	a_670_74##2	B1#7	5.02371e-17
C100	Y#4	A3#1	2.11623e-17
C101	a_27_74#	B1#5	5.40961e-19
C102	Y#3	A3#1	3.43894e-19
C103	a_307_368#	Y#9	5.07108e-17
C104	a_27_74##6	B1#7	1.02666e-18
C105	B1#5	a_670_74##2	1.98103e-17
C106	VGND#6	B1#7	2.12477e-19
C107	Y#5	Y#9	1.15379e-18
C108	VGND#2	a_670_74#	7.05759e-17
C109	Y#4	A3#4	4.51745e-19
C110	a_27_74##6	B1#5	3.49556e-17
C111	Y#3	A3#4	2.7588e-19
C112	a_27_74##5	a_28_368##3	1.6024e-19
C113	a_670_74##2	A3#5	6.75181e-19
C114	a_307_368#	Y#5	7.8924e-17
C115	VGND#6	B1#5	1.44859e-18
C116	A3#5	a_27_74##6	1.12761e-17
C117	a_27_74##7	B1#5	1.45653e-19
C118	VGND#6	A3#5	3.71436e-17
C119	a_27_74##6	A3#6	3.1487e-19
C120	a_28_368#	Y#5	5.88091e-17
C121	a_307_368##2	a_307_368#	1.26297e-18
C122	a_27_74##7	A3#5	1.06808e-18
C123	a_27_74##2	A3#1	2.18366e-18
C124	A3#6	VGND#6	2.74391e-17
C125	B1#10	B1#6	2.0944e-18
C126	VGND#7	A3#5	1.92033e-19
C127	a_27_74##6	A2#6	1.37574e-19
C128	A3#6	a_27_74##7	1.63556e-17
C129	VGND#6	A2#6	1.18322e-18
C130	a_28_368#	a_307_368##2	7.59551e-17
C131	VGND#7	A3#6	1.32982e-18
C132	A2#6	a_27_74##7	1.93282e-17
C133	a_27_74##2	B1#4	7.82983e-19
C134	VGND#2	a_670_74##2	6.77276e-17
C135	a_27_74##8	A3#6	1.4522e-19
C136	a_28_368##4	a_28_368#	1.84136e-18
C137	VGND#7	A2#6	3.4455e-17
C138	a_27_74##2	A3#9	1.95497e-17
C139	a_27_74##7	A2#7	3.24653e-19
C140	a_28_368##4	a_307_368##2	5.71368e-17
C141	a_27_74##4	a_28_368##2	4.68357e-18
C142	a_27_74##8	A2#6	5.87268e-19
C143	a_27_74##4	A1#2	9.33299e-19
C144	VGND#7	A2#7	2.94492e-17
C145	VPWR#9	a_307_368##2	2.75174e-18
C146	VGND#2	a_27_74##6	1.36929e-17
C147	a_27_74##7	A1#1	1.40884e-19
C148	A2#7	a_27_74##8	1.64476e-17
C149	VGND#7	A1#1	1.22071e-18
C150	VPWR#9	a_28_368##4	6.1225e-17
C151	VGND#8	A2#7	1.44202e-18
C152	VPWR#4	VPWR#3	4.4397e-17
C153	VGND#1	VGND#3	3.87032e-17
C154	A1#1	a_27_74##8	2.05327e-17
C155	a_28_368##3	a_28_368##4	2.1773e-18
C156	a_27_74##5	A2#7	1.74222e-19
C157	VGND#1	VGND#2	1.48743e-16
C158	VGND#7	A1#5	2.81067e-19
C159	A1#1	VGND#8	1.82222e-17
C160	a_28_368##2	A3#4	1.43854e-20
C161	VGND#3	a_27_74##7	6.9777e-18
C162	a_28_368##3	VPWR#9	5.65546e-17
C163	a_27_74##8	A1#5	1.30203e-18
C164	a_670_74#	Y#3	2.68011e-19
C165	a_27_74##5	A1#1	7.40254e-19
C166	Y#4	VPWR#4	5.82115e-19
C167	VGND#8	A1#5	3.40498e-17
C168	C1#10	Y#1	2.50023e-17
C169	B1#4	C1#3	3.22539e-18
C170	VGND#2	a_27_74##7	7.43788e-18
C171	VGND#2	C1#2	1.88552e-19
C172	a_28_368##2	A2#1	1.64493e-19
C173	a_27_74##5	A1#5	3.37619e-17
C174	a_28_368##2	A2#5	1.90971e-17
C175	a_27_74##4	A1#9	3.35196e-19
C176	C1#6	C1#1	3.82764e-17
C177	a_27_74#	Y#3	1.22748e-18
C178	VGND#3	a_27_74##8	8.90428e-18
C179	a_28_368##2	A1#4	2.02034e-17
C180	Y#8	C1#5	5.58897e-17
C181	B1	C1#3	6.95187e-19
C182	Y#3	C1#2	7.62392e-19
C183	B1#2	C1#3	1.15639e-17
C184	B1	B1#4	7.21917e-18
C185	B1	B1#2	7.72507e-18
C186	Y#1	C1#7	1.60282e-18
C187	C1#5	VPWR#7	2.42741e-17
C188	VGND#3	VGND#2	1.22289e-18
C189	VGND#2	A3#3	6.15007e-20
C190	B1#7	C1#6	4.01571e-18
C191	C1#10	C1#2	1.48993e-17
C192	a_670_74##2	Y#3	8.115e-19
C193	Y#8	C1#4	2.21349e-18
C194	B1#10	B1#4	4.40179e-18
C195	a_28_368##2	A1#6	1.79067e-19
C196	Y#7	C1#5	5.28941e-19
C197	VPWR#7	C1#4	4.30725e-17
C198	VGND#8	A1#2	2.33578e-19
C199	C1#7	C1#2	4.72724e-18
C200	Y#8	B1#1	2.09026e-19
C201	VGND#3	A2#3	4.13281e-20
C202	C1#7	a_670_74#	2.53776e-18
C203	C1#4	Y#7	2.16321e-17
C204	B1#5	B1#7	1.94483e-17
C205	B1#10	B1#2	1.0208e-17
C206	VPWR#7	B1#1	1.95044e-18
C207	VPWR#8	C1#4	2.3551e-18
C208	A1#9	A1#6	3.33577e-18
C209	Y#4	A3#3	1.41575e-18
C210	B1#1	Y#7	2.63291e-17
C211	A3	B1#4	3.86651e-19
C212	Y#9	C1#4	7.18573e-20
C213	A3	B1#2	2.53323e-19
C214	VPWR#8	B1#1	5.22195e-17
C215	A3#5	B1#5	4.08762e-17
C216	Y#7	B1#6	2.66014e-19
C217	Y#9	B1#1	1.60644e-19
C218	VPWR#8	B1#6	4.55669e-17
C219	C1#3	VPWR#7	4.52035e-19
C220	Y#7	A3#1	1.14746e-19
C221	B1#6	Y#9	1.74174e-17
C222	A3#6	A3#5	3.08025e-17
C223	VPWR#8	A3#1	2.36931e-18
C224	a_27_74##3	A3#3	1.6413e-18
C225	a_307_368#	B1#6	6.25022e-19
C226	a_27_74##2	A3#3	2.7732e-18
C227	Y#9	A3#1	4.36234e-17
C228	VPWR#8	A3#4	4.81707e-19
C229	A3#1	a_307_368#	2.62836e-17
C230	A2#6	A3#6	3.36271e-17
C231	A2	A2#4	1.35815e-17
C232	a_27_74##4	A2#3	2.06647e-18
C233	Y#9	A3#4	1.49331e-18
C234	B1#1	C1#3	2.22664e-18
C235	A2	A1#2	1.12493e-17
C236	a_27_74##3	A2#3	2.81641e-18
C237	Y#5	A3#1	1.37187e-18
C238	VPWR#8	A2#1	7.21357e-20
C239	a_307_368#	A3#4	4.46255e-17
C240	A2#7	A2#6	3.77908e-17
C241	Y#5	A3#4	7.57662e-17
C242	a_307_368##2	A3#1	1.18737e-19
C243	B1#2	B1#1	3.39644e-18
C244	A3#9	A3#3	1.10576e-17
C245	a_27_74##4	A1#3	2.02948e-18
C246	a_307_368#	A2#1	3.1014e-19
C247	a_28_368#	A3#4	1.36748e-18
C248	Y#1	C1#2	2.46446e-17
C249	a_27_74##2	a_27_74#	5.94527e-19
C250	a_670_74#	C1#2	4.99808e-19
C251	Y#5	A2#1	1.40744e-18
C252	a_307_368##2	A3#4	4.11646e-19
C253	A1#1	A2#7	3.06729e-17
C254	a_28_368#	A2#1	4.4251e-17
C255	a_28_368##4	A3#4	5.48016e-20
C256	A1	A2#4	1.21495e-18
C257	a_307_368##2	A2#1	7.07749e-17
C258	a_27_74##2	a_670_74##2	1.51193e-17
C259	A1	A1#2	5.85588e-18
C260	a_28_368##2	A2#3	3.22129e-18
C261	a_28_368#	A2#5	4.0834e-19
C262	a_28_368##4	A2#1	1.65108e-18
C263	A1#5	A1#1	2.61411e-17
C264	A2#5	a_307_368##2	2.6024e-17
C265	VPWR#9	A2#1	2.58806e-19
C266	a_28_368##4	A2#5	5.39901e-17
C267	a_27_74##2	a_27_74##6	5.26243e-19
C268	a_28_368##2	A1#3	1.49678e-18
C269	a_307_368##2	A1#4	6.16128e-19
C270	VPWR#9	A2#5	1.70648e-18
C271	B1#5	A3#1	1.5466e-17
C272	a_27_74##3	VGND#6	1.66725e-17
C273	A1#4	a_28_368##4	2.0481e-17
C274	a_27_74#	B1#10	2.0099e-17
C275	a_28_368##3	A2#5	2.03404e-19
C276	Y#7	VPWR#3	5.27695e-18
C277	VPWR#9	A1#4	5.10298e-17
C278	A1#9	A1#3	1.9461e-17
C279	VGND#2	C1#3	1.18038e-20
C280	a_28_368##4	A1#6	6.82159e-19
C281	B1#2	VPWR#8	1.20581e-18
C282	VGND#6	A3#3	9.73018e-19
C283	C1#2	Y#8	2.25288e-17
C284	a_307_368#	VPWR#4	5.65728e-17
C285	a_28_368##3	A1#4	2.12703e-18
C286	a_27_74##2	VGND#6	1.42413e-17
C287	C1#2	VPWR#7	4.60757e-19
C288	A1#6	VPWR#9	2.46398e-17
C289	a_27_74##3	a_27_74##7	1.5269e-18
C290	B1#4	A3#1	1.35645e-18
C291	a_28_368##3	A1#6	5.83085e-17
C292	a_27_74##4	VGND#7	1.33403e-17
C293	Y#3	Y#8	7.04602e-19
C294	a_307_368##2	VPWR#4	4.76795e-17
C295	C1#4	C1#5	4.80041e-17
C296	A3#1	B1#2	1.25424e-17
C297	VGND#2	B1#4	2.5037e-19
C298	VGND#7	A2#3	1.10176e-18
C299	a_27_74##3	VGND#7	1.42555e-17
C300	a_27_74##4	a_27_74##8	1.55027e-18
C301	Y	C1#3	1.35019e-17
C302	B1#1	C1#4	4.85512e-17
C303	Y#3	VPWR#7	2.35882e-17
C304	Y	B1#4	5.70142e-18
C305	Y	B1#2	1.00423e-17
C306	Y#9	VPWR#3	1.36977e-17
C307	C1#10	Y#8	2.33295e-17
C308	B1	Y#4	3.80393e-17
C309	Y#4	Y#7	6.60961e-19
C310	B1	Y#3	1.2195e-17
C311	VGND#2	B1#2	5.22335e-20
C312	VGND#8	A1#3	9.77251e-19
C313	B1#6	B1#1	4.65946e-17
C314	A3#3	a_307_368#	1.87061e-18
C315	a_27_74##5	A1#3	6.81647e-19
C316	a_27_74##4	VGND#8	2.12114e-17
C317	A3#3	Y#5	7.10442e-18
C318	Y#3	Y#7	1.55956e-18
C319	a_28_368#	A3#3	8.34808e-18
C320	a_307_368##2	A3#3	3.50923e-18
C321	A3	Y#4	1.15212e-17
C322	A3#1	B1#6	4.67987e-17
C323	a_27_74##2	B1	1.33239e-17
C324	Y#4	VPWR#8	1.21474e-17
C325	a_28_368#	A2#3	1.20794e-19
C326	a_27_74##5	a_27_74##4	4.93253e-19
C327	A2#3	a_307_368##2	2.42971e-18
C328	A3#4	A3#1	4.91121e-17
C329	Y#3	VPWR#8	1.90448e-17
C330	C1#7	Y#8	3.91807e-18
C331	a_27_74##3	A3	1.63408e-17
C332	a_27_74##2	A3	3.59527e-17
C333	Y#4	Y#9	1.79072e-18
C334	Y#4	VPWR#3	3.13618e-19
C335	A2#1	A3#4	6.09278e-18
C336	A1#3	VPWR#9	1.16419e-18
C337	A3#3	B1#5	1.24093e-17
C338	a_28_368##3	A1#3	1.15581e-19
C339	a_27_74##4	A2	6.17333e-17
C340	a_27_74##3	A2	4.96742e-17
C341	A3#6	A3#3	2.26128e-18
C342	A2#5	A2#1	3.4031e-17
C343	Y#4	a_307_368#	1.21388e-17
C344	Y#3	VPWR#3	3.13951e-19
C345	a_27_74#	B1	3.34811e-17
C346	A2#3	A3#6	2.19304e-18
C347	C1#2	C1#5	4.29488e-18
C348	VGND	C1#3	1.89619e-19
C349	A1#4	A2#5	4.13575e-17
C350	VGND	B1#4	9.28377e-21
C351	VGND	B1#2	4.39173e-21
C352	VPWR#4	A3#1	4.84166e-18
C353	a_27_74##4	A1	2.22486e-17
C354	A2	a_28_368##2	6.36581e-17
C355	VPWR#4	A3#4	4.48035e-18
C356	A1#6	A1#4	4.46073e-17
C357	Y#5	Y#4	1.75954e-18
C358	VPWR#4	A2#1	4.47364e-18
C359	A1	a_28_368##2	2.16511e-17
C360	Y#1	a_670_74#	4.64321e-17
C361	VPWR#3	B1#4	4.87309e-20
C362	Y	Y#3	2.2121e-18
C363	A1#2	A2#4	2.0462e-17
C364	A2#1	A3#3	2.76099e-20
C365	Y	C1#7	5.83043e-17
C366	A3	a_307_368#	1.12433e-18
C367	A3	Y#5	3.50541e-17
C368	A3	a_307_368##2	1.37593e-18
C369	VGND#3	a_27_74##4	2.25448e-19
C370	VPWR	VPWR#3	2.60219e-17
C371	VPWR	Y#4	4.07757e-18
C372	a_27_74##5	A1	2.7786e-17
C373	B1	B1#5	2.09775e-18
C374	VPWR	Y#3	4.02605e-18
C375	a_670_74#	Y#6	8.11926e-19
C376	a_28_368##2	A1#2	2.13826e-19
C377	VPWR	C1#10	2.88944e-18
C378	A2	a_28_368#	4.56672e-17
C379	VPWR#4	A3#3	1.73152e-19
C380	VPWR	C1#7	1.7423e-18
C381	A3	B1#5	4.21976e-18
C382	Y	Y#1	3.81311e-18
C383	Y	a_670_74#	7.73267e-17
C384	VPWR	B1#10	1.08151e-18
C385	VGND	VGND#3	4.28278e-17
C386	Y	Y#6	5.84044e-18
C387	VGND#2	C1#1	4.65614e-18
C388	VGND	VGND#2	9.80094e-17
C389	a_27_74#	Y	5.82506e-17
C390	VGND#3	a_27_74##3	2.91756e-19
C391	VPWR	A3#9	1.31145e-18
C392	VPWR	a_28_368##2	4.10706e-18
C393	A1	a_28_368##3	2.91981e-17
C394	VGND	C1#10	1.96596e-18
C395	Y#4	Y#3	5.98012e-19
C396	VPWR	A1#9	1.08151e-18
C397	C1#3	VNB	2.64373e-17
C398	B1	B1#1	2.48863e-18
C399	B1#4	VNB	4.0145e-17
C400	B1#2	VNB	3.41807e-17
C401	VGND	C1#7	1.81665e-18
C402	A2#4	VNB	1.93965e-17
C403	VGND	a_27_74##4	3.81367e-18
C404	A2#3	A3#3	2.95379e-17
C405	A1#2	VNB	2.26221e-17
C406	VGND	a_27_74##3	2.89135e-18
C407	VGND	a_27_74##2	3.71861e-18
C408	B1	A3#1	1.06996e-17
C409	VGND	B1#10	1.0469e-18
C410	a_670_74##2	a_670_74#	1.41931e-18
C411	VGND	A3#9	1.16652e-18
C412	VGND#2	a_27_74##3	2.25484e-19
C413	VGND#2	C1#6	4.5397e-18
C414	VPWR	Y#8	1.76333e-17
C415	VGND	A1#9	1.14534e-18
C416	A3	A2#1	4.09473e-19
C417	VGND	Y#1	1.50391e-17
C418	VPWR	Y#7	1.20453e-17
C419	VGND	a_670_74#	2.77375e-17
C420	VPWR	VPWR#8	2.18155e-17
C421	Y	C1#1	1.4864e-18
C422	VPWR	Y#9	1.34766e-17
C423	VGND	a_27_74#	8.76558e-18
C424	Y	C1#6	2.36027e-17
C425	VGND	a_670_74##2	2.90606e-17
C426	VPWR	a_307_368#	2.46866e-17
C427	Y	B1#7	9.87339e-19
C428	VGND	a_27_74##6	1.32955e-17
C429	VPWR	Y#5	8.67618e-18
C430	A2	A2#1	2.07794e-18
C431	VPWR	a_28_368#	7.94994e-18
C432	VGND	a_27_74##7	1.39474e-17
C433	Y	A3#5	1.2659e-19
C434	VPWR	a_307_368##2	3.03222e-17
C435	A2	A2#5	2.04147e-18
C436	VGND	a_27_74##8	1.34941e-17
C437	VPWR	a_28_368##4	1.6085e-17
C438	Y	A3#6	2.00605e-19
C439	A2	A1#4	1.33976e-18
C440	VGND	a_27_74##5	1.45208e-17
C441	VPWR	a_28_368##3	1.68673e-17
C442	A2	A1#6	4.17629e-19
C443	A1	A2#5	8.97239e-21
C444	B1	A3#3	7.44054e-19
C445	A1	A1#4	1.50168e-18
C446	Y	C1#5	1.8888e-19
C447	VGND#3	VNB	2.97243e-17
C448	VGND#2	a_27_74##2	7.02883e-19
C449	VGND#2	B1#7	4.72721e-18
C450	VGND#2	VNB	1.22054e-16
C451	Y	C1#4	1.21269e-18
C452	VPWR#3	VNB	3.35303e-17
C453	Y	B1#1	2.53282e-18
C454	a_27_74#	a_670_74##2	7.6648e-17
C455	A3	A3#3	2.56611e-17
C456	Y	B1#6	1.48905e-19
C457	Y#3	VNB	1.96041e-19
C458	C1#10	VNB	2.70434e-17
C459	VGND	C1#1	2.82535e-18
C460	A3	A2#3	2.28013e-18
C461	VGND	C1#6	1.97679e-18
C462	C1#7	VNB	3.10621e-18
C463	Y	A3#4	8.88182e-20
C464	a_27_74##4	VNB	3.26461e-18
C465	VGND	B1#7	1.60911e-18
C466	A2	A3#3	1.33555e-17
C467	a_27_74##3	VNB	5.12714e-18
C468	VPWR	C1#5	6.92518e-19
C469	a_27_74##2	VNB	1.41621e-18
C470	VGND	B1#5	2.55666e-19
C471	VPWR	C1#4	1.06275e-18
C472	VGND	A3#5	8.39544e-19
C473	A2	A2#3	2.51127e-17
C474	VGND	A3#6	2.75352e-19
C475	VPWR	B1#1	1.10943e-18
C476	VGND	A2#6	6.41802e-19
C477	VPWR	B1#6	1.28992e-18
C478	A3#9	VNB	2.37346e-18
C479	A2	A1#3	9.91868e-20
C480	VGND	A2#7	4.89838e-19
C481	a_27_74##3	a_28_368#	3.76795e-18
C482	VPWR	A3#1	9.4093e-19
C483	VGND	A1#1	1.53258e-18
C484	VPWR	A3#4	1.57175e-18
C485	VGND	A1#5	1.6266e-18
C486	VPWR	A2#1	1.52405e-18
C487	Y#1	VNB	4.35992e-17
C488	a_670_74#	VNB	1.13903e-17
C489	A1	A1#3	5.6041e-18
C490	VPWR	A2#5	4.23136e-19
C491	a_27_74#	VNB	6.26375e-18
C492	a_670_74##2	VNB	6.93888e-18
C493	VPWR	A1#4	7.11802e-19
C494	a_27_74##6	VNB	2.1281e-18
C495	VGND#6	VNB	5.72519e-19
C496	Y	C1#2	2.04722e-18
C497	VPWR	A1#6	1.44038e-18
C498	a_27_74##6	a_27_74#	1.96067e-18
C499	a_27_74##7	VNB	4.926e-18
C500	VGND#7	VNB	5.30049e-20
C501	a_27_74##8	VNB	4.9526e-18
C502	VGND	A3#1	6.45895e-19
C503	VGND#8	VNB	2.82481e-18
C504	a_27_74##5	VNB	4.70838e-17
C505	VPWR	VPWR#4	3.12407e-17
C506	Y#8	VNB	4.97364e-17
C507	Y	A3#3	2.88383e-19
C508	VPWR#7	VNB	1.3526e-18
C509	Y#7	VNB	4.80686e-18
C510	A3	B1	2.95876e-17
C511	VPWR#8	VNB	2.40442e-19
C512	Y#9	VNB	2.24978e-18
C513	VPWR	C1#2	1.11402e-18
C514	a_307_368#	VNB	6.55334e-18
C515	Y#5	VNB	8.35093e-18
C516	VGND#2	B1#5	6.19817e-18
C517	a_28_368#	VNB	7.5547e-18
C518	a_307_368##2	VNB	1.08096e-17
C519	a_28_368##4	VNB	2.77844e-18
C520	VPWR#9	VNB	1.38363e-18
C521	a_28_368##3	VNB	4.98471e-17
C522	C1#1	VNB	3.21581e-17
C523	A2	A3	2.8943e-17
C524	C1#6	VNB	2.82539e-17
C525	B1#7	VNB	2.738e-17
C526	B1#5	VNB	4.17135e-17
C527	VGND	C1#2	1.23561e-18
C528	A3#5	VNB	2.52493e-17
C529	A3#6	VNB	2.88231e-17
C530	A2#6	VNB	2.56082e-17
C531	A2#7	VNB	2.51311e-17
C532	VGND	A3#3	1.51279e-19
C533	A1#1	VNB	2.74263e-17
C534	A1#5	VNB	3.40429e-17
C535	A1	A2	2.96973e-17
C536	C1#5	VNB	4.19756e-17
C537	C1#4	VNB	3.06771e-17
C538	B1	Y	3.34061e-17
C539	B1#1	VNB	3.26871e-17
C540	B1#6	VNB	2.8577e-17
C541	a_27_74##6	a_670_74##2	4.53315e-17
C542	A3#1	VNB	4.07645e-17
C543	A3#4	VNB	3.4136e-17
C544	A2#1	VNB	3.4875e-17
C545	VPWR	B1	3.32457e-18
C546	A2#5	VNB	3.18083e-17
C547	A1#4	VNB	2.97112e-17
C548	A1#6	VNB	4.08197e-17
C549	VPWR	A3	4.34803e-18
C550	VPWR#4	VNB	2.84662e-16
C551	VPWR	A2	6.99178e-18
C552	VGND#1	VNB	2.34074e-16
C553	VGND	B1	3.04731e-18
C554	C1#2	VNB	5.60542e-17
C555	VGND#3	A3#5	1.01475e-19
C556	VGND	A3	3.61083e-18
C557	VPWR	A1	3.50328e-18
C558	A3#3	VNB	6.55862e-17
C559	A2#3	VNB	3.95788e-17
C560	VGND	A2	7.33522e-18
C561	A1#3	VNB	4.47404e-17
C562	VGND	A1	3.6258e-18
C563	VGND	Y	1.16245e-17
C564	B1	VNB	7.00047e-18
C565	A3	VNB	8.61318e-18
C566	a_27_74##5	A1#9	1.85329e-17
C567	A2	VNB	7.9464e-18
C568	A1	VNB	3.12101e-17
C569	Y	VNB	1.10718e-17
C570	VPWR	VNB	7.3587e-17
C571	VGND	VNB	7.49544e-17
C572	VGND#2	A3#5	4.12779e-18
C573	VGND#4	A1#1	5.01846e-18
C574	VGND	VGND#4	5.48027e-17
C575	VPWR#2	B1#1	6.31563e-19
C576	VGND#4	a_27_74##4	6.89606e-19
C577	VPWR#8	VPWR#2	6.61283e-20
C578	a_28_368##4	VPWR#5	1.75281e-17
C579	VPWR#5	A2#1	2.59964e-19
C580	VPWR#2	VNB	4.7255e-17
C581	VPWR#5	A1#6	5.53478e-18
C582	VPWR#2	C1#5	7.60895e-18
C583	VPWR	VPWR#5	6.39074e-17
C584	VGND#4	A1#5	4.1091e-18
C585	VPWR#5	VNB	6.67405e-17
C586	VGND#4	a_27_74##8	5.49571e-18
C587	VGND#4	VGND#3	1.00007e-18
C588	VPWR#2	C1#2	2.00521e-19
C589	VGND#4	VNB	4.74393e-17
C590	C1#10	VPWR#2	4.68735e-19
C591	VPWR#5	A2#5	6.22737e-18
C592	VPWR#2	C1#4	4.87373e-18
C593	VGND#1	VGND#4	5.22876e-17
C594	a_28_368##2	VPWR#5	5.46829e-19
C595	VPWR#3	VPWR#2	1.20296e-18
C596	VPWR#5	A2#3	6.67546e-20
C597	VPWR#4	VPWR#2	5.15259e-17
C598	Y#3	VPWR#2	3.1463e-19
C599	Y#7	VPWR#2	5.22729e-18
C600	VGND#4	A2#7	5.17518e-19
C601	VPWR#5	a_307_368##2	2.19831e-17
C602	VPWR#5	A3#4	8.65113e-20
C603	a_28_368##3	VPWR#5	2.11169e-17
C604	VPWR#5	A1#4	3.76036e-18
C605	Y#8	VPWR#2	2.07677e-17
C606	VGND#4	a_27_74##5	1.7841e-17
C607	VPWR#4	VPWR#5	7.77469e-17
C608	VPWR	VPWR#2	5.16259e-17
*
*
.ENDS sky130_fd_sc_hs__o311ai_2
*
