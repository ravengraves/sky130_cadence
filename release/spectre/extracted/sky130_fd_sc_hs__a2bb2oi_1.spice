* Extracted by Quantus, converted by sky130cad/quantus.py
*
*
*
*                       LINUX           Wed Nov 18 08:10:24 2026
*
*
*
*  PROGRAM  advgen
*
*  Name           : advgen - Quantus - (64-bit)
*  Version        : 25.1.0-p047
*  Build Date     : Thu Dec 11 23:20:30 PST 2025
*
*  HSPICE LIBRARY
*
*  OPERATING_TEMPERATURE 150
*  QRC_TECH_DIR <path>/tech
*
*
*

*
.SUBCKT sky130_fd_sc_hs__a2bb2oi_1 VPB VNB VGND VPWR Y B1 B2 A1_N A2_N
*
*
*  caps2d version: 10
*
*
*       TRANSISTOR CARDS
*
*
XM5 VGND#3 A1_N#1 a_126_112##7 VNB sky130_fd_pr__nfet_01v8_lvt l=0.15 w=0.55 ad=0.14575 as=0.154 pd=1.63 ps=1.66
XM7 a_126_112##7 A2_N#1 VGND#4 VNB sky130_fd_pr__nfet_01v8_lvt l=0.15 w=0.55 ad=0.154 as=0.49035 pd=1.66 ps=3.08
XM6 VGND#4 a_126_112# Y#3 VNB sky130_fd_pr__nfet_01v8_lvt l=0.15 w=0.74 ad=0.49035 as=0.2072 pd=3.08 ps=2.04
XM3 Y#3 B2#3 a_488_74# VNB sky130_fd_pr__nfet_01v8_lvt l=0.15 w=0.74 ad=0.2072 as=0.2368 pd=2.04 ps=2.12
XM9 a_488_74# B1#3 VGND#1 VNB sky130_fd_pr__nfet_01v8_lvt l=0.15 w=0.74 ad=0.2368 as=0.1961 pd=2.12 ps=2.01
XM0 VPWR#4 A1_N#4 a_117_392# VPB sky130_fd_pr__pfet_01v8 l=0.15 w=1 ad=0.275 as=0.24 pd=2.55 ps=2.48
XM4 a_117_392# A2_N#3 a_126_112##8 VPB sky130_fd_pr__pfet_01v8 l=0.15 w=1 ad=0.24 as=0.275 pd=2.48 ps=2.55
XM8 Y#2 a_126_112##4 a_399_368# VPB sky130_fd_pr__pfet_01v8 l=0.15 w=1.12 ad=0.308 as=0.336 pd=2.79 ps=2.84
XM2 a_399_368# B2#1 VPWR#5 VPB sky130_fd_pr__pfet_01v8 l=0.15 w=1.12 ad=0.336 as=0.3696 pd=2.84 ps=2.9
XM1 VPWR#5 B1#4 a_399_368##2 VPB sky130_fd_pr__pfet_01v8 l=0.15 w=1.12 ad=0.3696 as=0.308 pd=2.9 ps=2.79
*
*
*       RESISTOR AND CAP/DIODE CARDS
*
Rg1	A1_N#1	A1_N#2	291.426056
Rg2	A1_N#2	A1_N#3	45.367535
Rg3	A1_N#2	A1_N#4	507.281372
Rg4	A2_N#1	A2_N#2	386.482941
Rg5	A2_N#2	A2_N#3	409.042694
Rg6	a_126_112#	a_126_112##2	322.953644
Rg7	a_126_112##2	a_126_112##3	56.190353
Rg8	a_126_112##2	a_126_112##4	507.075531
Rg9	B2#1	B2#2	492.059540
Rg10	B2#2	B2#3	307.937683
Rg11	B1#1	B1#2	29.629290
Rg12	B1#2	B1#3	322.953644
Rg13	B1#2	B1#4	507.075531
Rf1	A1_N	A1_N#3	169.680954
Rf2	A2_N#2	A2_N	171.452469
Rf3	a_126_112##3	a_126_112##6	164.386047
Rf4	a_126_112##6	a_126_112##7	79.509285
Rf5	a_126_112##6	a_126_112##8	66.917587
Rf6	Y	Y#1	6.598148
Rf7	Y#1	Y#2	27.325571
Rf8	Y#1	Y#3	96.161514
Rf9	B2	B2#2	180.812363
Rf11	a_399_368##3	a_399_368#	89.690285
Rf12	a_399_368##2	a_399_368##3	5.000000
Rf13	B1	B1#1	163.775864
Rf14	VGND#1	VGND#2	129.848694
Rf15	VGND#2	VGND#3	158.009033
Rf16	VGND#2	VGND#4	18.244144
Rf18	VPWR#2	VPWR#3	61.095207
Rf19	VPWR#3	VPWR#4	135.580780
Rf20	VPWR#2	VPWR#5	41.419502
Re1	VPWR#3	VPWR	1.403190
Re2	VGND	VGND#2	1.403242
*
*       CAPACITOR CARDS
*
*
C1	Y#1	B1#2	1.90364e-19
C2	Y#1	a_126_112##2	5.05261e-18
C3	a_126_112##6	a_126_112##2	6.77893e-19
C4	VGND#2	a_126_112##2	5.02572e-19
C5	B1#2	VGND#1	8.20611e-18
C6	B2#2	B1#2	4.31142e-17
C7	a_126_112##2	B2#2	3.98084e-17
C8	a_126_112##6	Y#1	4.17903e-17
C9	Y#3	a_126_112##2	5.521e-18
C10	A2_N#2	a_126_112##2	1.04468e-18
C11	Y#3	Y#1	3.56245e-18
C12	a_126_112##6	Y#3	3.3357e-17
C13	a_126_112##6	VGND#4	5.85131e-18
C14	Y#1	a_399_368##2	2.25492e-18
C15	Y#3	VGND#1	1.99854e-17
C16	a_399_368##2	B1#2	5.40397e-18
C17	Y#1	a_399_368#	3.39794e-17
C18	Y#1	Y#2	4.58351e-18
C19	a_126_112##6	Y#2	9.35646e-19
C20	a_126_112##7	Y#3	2.15105e-18
C21	VGND#1	a_399_368##2	1.41904e-18
C22	a_126_112##8	Y#1	3.11991e-17
C23	a_126_112##6	a_126_112##8	1.34066e-18
C24	VGND#3	a_126_112##7	4.59315e-17
C25	a_399_368##2	VPWR#5	2.34033e-17
C26	a_126_112##6	a_126_112#	2.85674e-18
C27	a_399_368#	a_399_368##2	2.11431e-18
C28	VGND#1	B1#3	4.61381e-17
C29	a_126_112##7	a_126_112##8	1.08705e-18
C30	a_126_112##6	A2_N#1	1.57766e-18
C31	a_399_368#	VPWR#5	3.65746e-17
C32	Y#2	a_399_368##2	7.98134e-19
C33	VGND#1	B2#3	7.91893e-18
C34	Y#3	B1#3	8.22183e-18
C35	VGND#1	a_126_112#	5.90727e-19
C36	Y#3	B2#3	4.37137e-17
C37	Y#2	a_399_368#	4.48614e-17
C38	Y#1	B1#4	2.71064e-18
C39	Y#3	a_126_112#	2.35446e-17
C40	a_126_112##7	B2#3	2.68228e-20
C41	a_126_112#	VGND#4	1.71065e-17
C42	a_126_112##8	Y#2	4.80473e-17
C43	Y#1	B2#1	1.15362e-17
C44	Y#3	A2_N#1	1.63267e-18
C45	a_126_112##7	a_126_112#	1.49381e-19
C46	A2_N#1	VGND#4	1.07238e-17
C47	Y#1	a_126_112##4	3.42134e-17
C48	VGND#3	a_126_112#	4.78797e-19
C49	a_126_112##7	A2_N#1	4.86212e-17
C50	a_126_112##6	a_126_112##4	2.4762e-19
C51	VGND#3	A2_N#1	1.52635e-18
C52	Y#1	A2_N#3	7.79251e-19
C53	VPWR#4	a_126_112##8	3.44267e-17
C54	a_126_112##7	A1_N#1	3.3987e-17
C55	a_126_112##6	A2_N#3	2.52964e-18
C56	A1_N#1	VGND#3	1.91377e-17
C57	a_126_112##6	A1_N#4	1.01564e-18
C58	B2	B1#2	2.36246e-18
C59	B2	a_126_112##2	4.67103e-19
C60	a_399_368##2	B1#4	3.83607e-17
C61	Y#1	VPWR#3	7.65921e-19
C62	a_126_112##6	VPWR#3	6.47645e-20
C63	B2#3	B1#3	3.55757e-17
C64	VPWR#5	B1#4	3.32806e-17
C65	a_399_368##2	B2#1	2.18482e-18
C66	VGND#2	Y#1	6.65021e-19
C67	a_399_368#	B1#4	7.47987e-19
C68	VPWR#5	B2#1	3.42627e-17
C69	VGND#2	a_126_112##6	3.6647e-17
C70	a_399_368##2	a_126_112##4	6.86961e-19
C71	Y#2	B1#4	1.1928e-19
C72	a_126_112#	B2#3	3.78851e-17
C73	a_399_368#	B2#1	3.92954e-17
C74	B1	B1#2	2.1659e-17
C75	VPWR#5	a_126_112##4	2.12126e-18
C76	Y#2	B2#1	2.42557e-19
C77	a_399_368##2	A2_N#3	7.60475e-20
C78	a_399_368#	a_126_112##4	4.12507e-17
C79	VPWR#5	A2_N#3	4.22907e-19
C80	A2_N#1	a_126_112#	4.17279e-18
C81	Y#1	B2#2	1.62419e-17
C82	a_126_112##4	Y#2	4.86889e-17
C83	VGND#2	VGND#1	3.86703e-17
C84	a_126_112##8	a_126_112##4	1.96454e-18
C85	VPWR#5	A1_N#4	2.68852e-19
C86	Y#2	A2_N#3	1.25997e-18
C87	VGND#2	Y#3	6.48202e-17
C88	VPWR#4	B2#1	2.05058e-19
C89	Y#1	a_126_112##3	3.43413e-18
C90	A1_N#1	A2_N#1	2.85162e-17
C91	a_126_112##8	A2_N#3	7.12949e-17
C92	VGND#2	VGND#4	1.17509e-17
C93	a_126_112##6	a_126_112##3	2.17629e-17
C94	VPWR#4	a_126_112##4	4.9976e-19
C95	VGND#2	a_126_112##7	4.01496e-17
C96	VGND#1	B2#2	2.43805e-18
C97	a_126_112##8	A1_N#4	1.09731e-17
C98	Y#1	A2_N#2	6.79581e-19
C99	VGND#2	VGND#3	3.00919e-17
C100	VPWR#4	A2_N#3	1.58449e-17
C101	A2_N#2	a_126_112##6	4.22383e-17
C102	a_399_368#	VPWR#3	8.45861e-18
C103	B2#2	Y#3	4.23588e-17
C104	VPWR#4	A1_N#4	5.95513e-17
C105	Y#2	VPWR#3	2.07943e-17
C106	A1_N#3	a_126_112##6	7.32972e-18
C107	a_126_112##8	VPWR#3	2.20345e-17
C108	a_126_112##3	VGND#4	6.13036e-19
C109	VPWR#3	VPWR#4	3.93684e-17
C110	VPWR#5	B2#2	2.7211e-19
C111	B2#1	B1#4	4.34697e-17
C112	VPWR	B1#2	1.06636e-18
C113	B2#2	a_399_368#	3.51037e-18
C114	a_126_112##7	A2_N#2	1.23102e-17
C115	VGND#2	B1#3	5.8411e-19
C116	a_126_112##4	B2#1	5.02333e-17
C117	VGND#2	B2#3	9.61189e-18
C118	Y#2	a_126_112##3	1.1084e-18
C119	A1_N#3	VGND#3	4.45173e-17
C120	VGND#2	a_126_112#	2.83666e-17
C121	VGND#2	A2_N#1	1.36324e-17
C122	A2_N#3	a_126_112##4	6.27202e-18
C123	VGND#2	A1_N#1	4.88816e-18
C124	A2_N#2	a_126_112##8	2.87577e-17
C125	VGND	B1#2	2.71218e-19
C126	A1_N#4	A2_N#3	6.96477e-17
C127	VGND	a_126_112##2	1.87234e-18
C128	VPWR#3	a_126_112##4	5.37954e-18
C129	VPWR#4	A1_N#3	2.6311e-18
C130	A2_N#1	a_126_112##3	6.5378e-18
C131	VPWR#3	A2_N#3	3.58845e-18
C132	A1_N#3	A2_N#1	8.36595e-18
C133	B1#2	VNB	6.15355e-17
C134	a_126_112##2	VNB	1.87607e-17
C135	A2_N#2	a_126_112##4	2.72199e-18
C136	a_126_112##7	A2_N	1.63101e-17
C137	Y#1	B2	2.552e-17
C138	B1#3	a_488_74#	2.11762e-17
C139	A1_N#4	A2_N#2	3.63018e-18
C140	VGND#2	B2#2	1.17872e-18
C141	B2#3	a_488_74#	2.06918e-17
C142	VPWR#3	a_126_112##3	5.54912e-19
C143	VGND#2	a_126_112##3	6.38532e-18
C144	A2_N#2	VPWR#3	2.2432e-19
C145	VGND#2	A2_N#2	6.13136e-19
C146	A2_N	VPWR#4	1.46811e-18
C147	VGND#1	B1	2.71408e-17
C148	B2	a_399_368##2	3.50943e-17
C149	A2_N#3	a_117_392#	2.3145e-17
C150	B2	VPWR#5	1.09059e-17
C151	Y#3	B1	2.24949e-18
C152	A1_N	VPWR#4	2.59612e-17
C153	B2	a_399_368#	5.70583e-18
C154	A1_N#4	a_117_392#	2.41308e-17
C155	A2_N#2	a_126_112##3	2.09259e-17
C156	A1_N#3	a_126_112##3	7.1977e-19
C157	B1	a_399_368##2	1.72447e-17
C158	A1_N#3	A2_N#2	3.63283e-17
C159	VPWR	Y#1	4.91533e-18
C160	VPWR	a_126_112##6	1.28526e-18
C161	A2_N	A1_N#4	1.58691e-18
C162	B2#2	a_488_74#	7.78751e-19
C163	B2	B1#4	1.15325e-17
C164	A2_N	VPWR#3	4.26895e-20
C165	B2	B2#1	7.83349e-18
C166	A1_N	A1_N#4	2.53359e-19
C167	VGND	Y#1	3.27798e-18
C168	B2	a_126_112##4	1.28768e-18
C169	VPWR	a_399_368##2	5.25987e-18
C170	VGND	a_126_112##6	5.06555e-18
C171	VPWR	VPWR#5	1.43052e-17
C172	VPWR	a_399_368#	1.53678e-17
C173	VPWR	Y#2	1.40509e-17
C174	VGND	VGND#1	4.80281e-17
C175	VPWR	a_126_112##8	1.86952e-17
C176	VGND	Y#3	1.50537e-17
C177	VPWR	VPWR#4	5.08829e-17
C178	VGND	a_126_112##7	1.32669e-17
C179	A2_N	A2_N#2	8.4247e-18
C180	VGND	VGND#3	3.38986e-17
C181	VGND	a_399_368##2	2.59119e-18
C182	A1_N#3	A2_N	1.86365e-17
C183	Y#1	VNB	1.93616e-18
C184	a_126_112##6	VNB	1.40561e-17
C185	A1_N	A2_N#2	1.00221e-18
C186	B2	B2#2	1.68708e-18
C187	A1_N	A1_N#3	1.32479e-17
C188	VGND#1	VNB	7.10335e-17
C189	VPWR	B1#4	1.74139e-18
C190	VGND	B1#3	4.18592e-18
C191	Y#3	VNB	3.44379e-18
C192	VPWR	B2#1	9.9013e-19
C193	B2#2	B1	3.12819e-17
C194	VGND	B2#3	1.25438e-18
C195	VPWR	a_126_112##4	2.02382e-18
C196	a_126_112##7	VNB	6.85482e-18
C197	VGND	a_126_112#	9.09243e-19
C198	VGND#3	VNB	6.49394e-17
C199	VPWR	A2_N#3	2.67911e-18
C200	VGND	A2_N#1	7.3513e-18
C201	a_399_368##2	VNB	4.07314e-17
C202	VPWR#5	VNB	1.52542e-18
C203	VGND	A1_N#1	6.8507e-18
C204	VPWR	A1_N#4	4.4328e-18
C205	a_399_368#	VNB	2.16814e-18
C206	Y#2	VNB	1.12746e-17
C207	a_126_112##8	VNB	1.74461e-17
C208	VPWR	VPWR#3	2.7408e-17
C209	VPWR#4	VNB	8.99209e-17
C210	B1#3	VNB	2.3157e-17
C211	B2#3	VNB	2.42627e-17
C212	a_126_112#	VNB	2.54398e-17
C213	VPWR	B2#2	1.97366e-18
C214	A2_N#1	VNB	3.29794e-17
C215	A1_N#1	VNB	3.10674e-17
C216	VPWR	a_126_112##3	6.51667e-19
C217	A1_N	A2_N	2.38072e-17
C218	VPWR	A2_N#2	1.40805e-18
C219	B1#4	VNB	4.76318e-17
C220	VGND	VGND#2	9.11591e-17
C221	B2#1	VNB	3.64014e-17
C222	a_126_112##4	VNB	3.61773e-17
C223	VGND	B2#2	1.21483e-17
C224	A2_N#3	VNB	3.04186e-17
C225	A1_N#4	VNB	3.63515e-17
C226	VGND	a_126_112##3	1.30734e-18
C227	VGND	A2_N#2	1.48633e-18
C228	VPWR#3	VNB	1.9019e-16
C229	VGND	A1_N#3	4.05591e-18
C230	VGND#2	VNB	2.26805e-16
C231	B2#2	VNB	2.45992e-17
C232	a_126_112##3	VNB	2.89082e-17
C233	A2_N#2	VNB	4.4632e-17
C234	VPWR	A2_N	5.02071e-18
C235	A1_N#3	VNB	7.3516e-17
C236	VPWR	A1_N	2.27346e-18
C237	VGND	A2_N	2.63665e-18
C238	VPWR	B2	3.95658e-18
C239	VPWR	B1	2.77989e-18
C240	VGND	B1	2.19229e-18
C241	A1_N	VNB	1.14061e-17
C242	B2	VNB	6.38819e-18
C243	B1	VNB	2.10479e-17
C244	VPWR	VNB	6.13812e-17
C245	VGND	VNB	5.61028e-17
C246	VPWR#2	VNB	4.91453e-17
C247	VPWR	VPWR#2	3.64948e-17
C248	VPWR#2	B1#2	5.55798e-19
C249	B1	VPWR#2	2.94403e-19
C250	VPWR#3	VPWR#2	5.42343e-17
C251	VPWR#2	B2#1	1.78689e-18
C252	VPWR#2	B1#4	7.47723e-18
C253	a_399_368#	VPWR#2	8.12798e-18
C254	VPWR#5	VPWR#2	8.7942e-18
C255	a_399_368##2	VPWR#2	1.77137e-18
C256	a_399_368##3	VPWR#2	2.07862e-17
C257	a_399_368##3	B1#4	6.28038e-18
C258	VPWR	a_399_368##3	1.3926e-17
C259	a_399_368##3	VNB	1.41689e-17
C260	a_399_368##3	a_399_368##2	2.4789e-18
C261	VPWR#5	a_399_368##3	1.51817e-17
*
*
.ENDS sky130_fd_sc_hs__a2bb2oi_1
*
