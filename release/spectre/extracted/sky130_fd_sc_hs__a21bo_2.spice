* Extracted by Quantus, converted by sky130cad/quantus.py
*
*
*
*                       LINUX           Wed Nov 18 08:04:14 2026
*
*
*
*  PROGRAM  advgen
*
*  Name           : advgen - Quantus - (64-bit)
*  Version        : 25.1.0-p047
*  Build Date     : Thu Dec 11 23:20:30 PST 2025
*
*  HSPICE LIBRARY
*
*  OPERATING_TEMPERATURE 150
*  QRC_TECH_DIR <path>/tech
*
*
*

*
.SUBCKT sky130_fd_sc_hs__a21bo_2 VPB VNB VGND VPWR X B1_N A1 A2
*
*
*  caps2d version: 10
*
*
*       TRANSISTOR CARDS
*
*
XM3 a_32_368##8 B1_N#1 VGND#6 VNB sky130_fd_pr__nfet_01v8_lvt l=0.15 w=0.55 ad=0.14575 as=0.2659 pd=1.63 ps=2.25
XM4 X#1 a_187_244##7 VGND#6 VNB sky130_fd_pr__nfet_01v8_lvt l=0.15 w=0.74 ad=0.2072 as=0.2659 pd=2.04 ps=2.25
XM7 VGND#5 a_187_244# X#1 VNB sky130_fd_pr__nfet_01v8_lvt l=0.15 w=0.74 ad=0.4921 as=0.2072 pd=2.81 ps=2.04
XM5 VGND#5 a_32_368##4 a_187_244##11 VNB sky130_fd_pr__nfet_01v8_lvt l=0.15 w=0.74 ad=0.4921 as=0.2072 pd=2.81 ps=2.04
XM2 a_187_244##11 A1#3 a_587_74# VNB sky130_fd_pr__nfet_01v8_lvt l=0.15 w=0.74 ad=0.2072 as=0.2368 pd=2.04 ps=2.12
XM10 a_587_74# A2#3 VGND#1 VNB sky130_fd_pr__nfet_01v8_lvt l=0.15 w=0.74 ad=0.2368 as=0.2109 pd=2.12 ps=2.05
XM9 a_32_368##7 B1_N#3 VPWR#7 VPB sky130_fd_pr__pfet_01v8 l=0.15 w=0.84 ad=0.231 as=0.3836 pd=2.23 ps=2.97
XM8 X#2 a_187_244##4 VPWR#7 VPB sky130_fd_pr__pfet_01v8 l=0.15 w=1.12 ad=0.336 as=0.3836 pd=2.84 ps=2.97
XM1 VPWR#5 a_187_244##6 X#2 VPB sky130_fd_pr__pfet_01v8 l=0.15 w=1.12 ad=0.308 as=0.336 pd=2.79 ps=2.84
XM11 a_187_244##10 a_32_368# a_504_392##2 VPB sky130_fd_pr__pfet_01v8 l=0.15 w=1 ad=0.275 as=0.3 pd=2.55 ps=2.6
XM6 a_504_392##2 A1#1 VPWR#4 VPB sky130_fd_pr__pfet_01v8 l=0.15 w=1 ad=0.3 as=0.3 pd=2.6 ps=2.6
XM0 VPWR#4 A2#4 a_504_392# VPB sky130_fd_pr__pfet_01v8 l=0.15 w=1 ad=0.3 as=0.275 pd=2.6 ps=2.55
*
*
*       RESISTOR AND CAP/DIODE CARDS
*
Rg1	B1_N#1	B1_N#2	300.159424
Rg2	B1_N#2	B1_N#3	400.426849
Rg3	a_187_244#	a_187_244##2	289.596832
Rg4	a_187_244##2	a_187_244##3	98.921783
Rg5	a_187_244##3	a_187_244##4	592.479492
Rg6	a_187_244##2	a_187_244##5	17.096172
Rg7	a_187_244##5	a_187_244##6	496.520538
Rg8	a_187_244##3	a_187_244##7	283.398102
Rg9	a_32_368#	a_32_368##2	535.743774
Rg10	a_32_368##2	a_32_368##3	57.174717
Rg11	a_32_368##2	a_32_368##4	352.167450
Rg12	A1#1	A1#2	500.608307
Rg13	A1#2	A1#3	343.310760
Rg14	A2#1	A2#2	26.676205
Rg15	A2#2	A2#3	454.941925
Rg16	A2#2	A2#4	424.106537
Rf1	B1_N	B1_N#4	1.529154
Rf2	B1_N#5	B1_N#2	161.761963
Rf3	B1_N#4	B1_N#5	3.706322
Rf4	X#1	X	41.664177
Rf5	X	X#2	88.331223
Rf6	a_32_368##3	a_32_368##6	292.160767
Rf7	a_32_368##6	a_32_368##7	33.121738
Rf8	a_32_368##6	a_32_368##8	124.061859
Rf9	a_187_244##5	a_187_244##9	234.381577
Rf10	a_187_244##9	a_187_244##10	104.112747
Rf11	a_187_244##9	a_187_244##11	18.932621
Rf12	A1#2	A1#5	163.285416
Rf13	A1#6	A1	3.052613
Rf14	A1#5	A1#6	6.221075
Rf15	a_504_392#	a_504_392##2	102.671669
Rf16	A2#1	A2	162.201172
Rf17	VGND#1	VGND#2	150.418503
Rf18	VGND#2	VGND#3	73.704239
Rf20	VGND#2	VGND#5	21.056906
Rf21	VGND#3	VGND#6	36.515656
Rf23	VPWR#2	VPWR#3	84.771393
Rf24	VPWR#2	VPWR#4	42.399368
Rf25	VPWR#3	VPWR#5	38.202232
Rf26	VPWR#3	VPWR#6	84.604469
Rf27	VPWR#6	VPWR#7	34.704330
Re1	VPWR#3	VPWR	1.227783
Re2	VGND	VGND#2	1.227829
*
*       CAPACITOR CARDS
*
*
C1	a_187_244##6	a_32_368##2	1.83033e-18
C2	a_187_244##4	a_187_244##2	3.2815e-19
C3	VGND#1	A2#2	8.25303e-18
C4	a_187_244##9	A1#6	1.59062e-17
C5	VPWR#3	a_32_368##2	8.87577e-22
C6	VPWR#3	a_187_244##3	3.22075e-20
C7	VGND#5	a_32_368##2	7.04737e-21
C8	VGND#2	a_187_244##2	6.6554e-20
C9	a_187_244##9	VGND#1	2.33815e-17
C10	X#1	a_187_244##2	2.24315e-19
C11	A1#2	A2#2	3.65762e-17
C12	a_32_368##2	A1#2	4.20828e-17
C13	a_187_244##3	VGND#6	4.03168e-18
C14	a_187_244##9	a_187_244##11	3.44887e-18
C15	a_187_244##9	VGND#5	6.77942e-17
C16	a_187_244##2	a_32_368##2	4.11054e-19
C17	a_32_368##3	a_32_368##2	1.02574e-18
C18	a_32_368##8	a_187_244##3	4.79006e-18
C19	A1#6	a_504_392#	1.8201e-17
C20	a_187_244##2	a_32_368##3	3.52832e-17
C21	a_504_392#	A2#2	4.61096e-18
C22	VGND#6	a_32_368##6	1.19035e-18
C23	A1#6	a_504_392##2	1.47216e-17
C24	a_187_244##3	a_187_244##2	1.04291e-17
C25	a_187_244##5	a_32_368##2	2.44419e-19
C26	a_187_244##5	a_187_244##3	1.16114e-18
C27	a_32_368##8	a_32_368##6	5.24113e-19
C28	a_187_244##5	a_187_244##2	1.90249e-17
C29	a_187_244##10	A1#6	5.89483e-18
C30	VGND#5	VGND#1	1.02451e-18
C31	a_187_244##9	a_504_392##2	2.9e-18
C32	a_32_368##8	B1_N#5	5.46576e-17
C33	B1_N#2	a_187_244##3	3.1088e-17
C34	a_187_244##9	a_187_244##10	2.63989e-18
C35	a_32_368##8	B1_N#4	9.2127e-18
C36	X#1	VGND#5	3.68573e-17
C37	VGND#6	VGND#5	1.5976e-18
C38	a_32_368##6	X#2	8.20926e-17
C39	VGND#6	X#1	3.0387e-17
C40	a_187_244##10	A2#2	6.56629e-19
C41	a_32_368##6	VPWR#7	5.32203e-17
C42	a_32_368##8	X#1	2.84076e-18
C43	a_187_244##10	a_32_368##2	7.69882e-19
C44	a_187_244##9	A2#3	8.30792e-18
C45	a_32_368##7	a_32_368##6	2.34421e-17
C46	a_32_368##8	VGND#6	3.01828e-17
C47	a_187_244##9	A1#3	3.05621e-17
C48	a_187_244##9	a_32_368##4	3.65285e-17
C49	B1_N#5	a_32_368##7	1.09067e-17
C50	B1_N#4	a_32_368##7	1.01155e-17
C51	a_187_244##9	a_187_244#	4.61519e-19
C52	a_504_392#	VPWR#4	6.48867e-17
C53	VPWR#5	a_187_244##2	6.2417e-19
C54	a_187_244##9	a_187_244##7	1.04164e-19
C55	a_504_392##2	a_504_392#	2.52173e-18
C56	VGND#1	A2#3	4.55081e-17
C57	a_504_392##2	VPWR#4	4.26897e-17
C58	a_187_244##10	a_504_392#	3.14552e-18
C59	X#2	a_32_368##2	9.9405e-20
C60	VGND#1	A1#3	8.60753e-18
C61	X#2	a_187_244##3	3.96745e-18
C62	a_32_368##8	X#2	1.26874e-17
C63	VGND#1	a_32_368##4	5.68971e-19
C64	VGND#5	A2#3	2.64301e-19
C65	a_187_244##10	a_504_392##2	8.18173e-17
C66	X#2	a_187_244##2	1.89736e-18
C67	VPWR#5	VPWR#4	6.22702e-19
C68	A1#3	a_187_244##11	1.4526e-17
C69	A1#6	A1#1	3.3886e-18
C70	VGND#1	a_187_244#	1.50843e-19
C71	VGND#5	A1#3	3.02432e-19
C72	a_32_368##4	a_187_244##11	1.49349e-17
C73	a_32_368##8	a_32_368##7	6.47802e-19
C74	A1#6	a_32_368#	6.91713e-19
C75	VPWR#5	a_187_244##10	3.6748e-17
C76	a_32_368##4	VGND#5	2.47718e-17
C77	a_187_244#	VGND#5	2.84866e-17
C78	VGND#6	a_32_368##4	2.01939e-19
C79	X#1	a_187_244#	2.82766e-17
C80	VGND#5	a_187_244##7	5.31513e-19
C81	VPWR#7	VPWR#5	1.4729e-17
C82	VGND#6	a_187_244#	7.96179e-19
C83	a_32_368##7	a_187_244##10	1.04104e-18
C84	a_32_368##6	a_32_368#	6.04727e-20
C85	X#1	a_187_244##7	2.93183e-17
C86	a_187_244##9	a_187_244##6	8.57111e-20
C87	a_187_244##7	VGND#6	2.18348e-17
C88	A2	A2#2	2.05727e-17
C89	X#1	B1_N#1	1.58361e-18
C90	a_32_368##6	a_187_244##6	1.61034e-17
C91	a_32_368##8	a_187_244##7	4.45262e-18
C92	B1_N#1	VGND#6	2.06878e-17
C93	a_32_368##7	VPWR#7	1.28025e-17
C94	a_32_368##6	a_187_244##4	2.42805e-17
C95	a_32_368##8	B1_N#1	3.64638e-17
C96	a_32_368##6	B1_N#3	1.73803e-17
C97	a_504_392#	A2#4	5.56064e-17
C98	A1#3	A2#3	3.58e-17
C99	A2#4	VPWR#4	2.14799e-17
C100	a_504_392#	A1#1	3.87976e-18
C101	a_32_368##6	VPWR#3	2.32263e-18
C102	a_504_392##2	A2#4	7.17196e-19
C103	VGND#2	a_187_244##9	1.71989e-17
C104	VPWR#4	A1#1	3.63509e-17
C105	a_32_368##4	A1#3	3.78248e-17
C106	a_187_244##10	A2#4	8.70432e-19
C107	a_504_392#	a_32_368#	1.05332e-18
C108	a_504_392##2	A1#1	5.72786e-17
C109	VPWR#4	a_32_368#	1.36581e-18
C110	A1#6	A1#2	7.32551e-18
C111	a_187_244##10	A1#1	4.69237e-18
C112	a_32_368#	a_504_392##2	1.67485e-17
C113	a_187_244#	a_32_368##4	8.99348e-18
C114	VPWR#5	A1#1	1.91432e-19
C115	VPWR#4	a_187_244##6	1.21057e-19
C116	A1#6	A2#2	5.40001e-18
C117	a_187_244##10	a_32_368#	7.96462e-17
C118	a_187_244##9	A1#2	5.09448e-17
C119	VPWR#5	a_32_368#	1.92078e-18
C120	VGND#2	VGND#1	3.87748e-17
C121	a_187_244##10	a_187_244##6	3.41133e-18
C122	a_187_244##7	a_187_244#	3.81927e-17
C123	A1#6	a_32_368##2	1.43906e-18
C124	VPWR#5	a_187_244##6	3.51853e-17
C125	a_187_244##9	a_32_368##3	5.83339e-17
C126	a_187_244##10	a_187_244##4	2.21148e-19
C127	X#2	a_187_244##6	3.81478e-17
C128	VPWR#5	a_187_244##4	2.97866e-18
C129	a_32_368##7	a_32_368#	1.42183e-19
C130	a_32_368##6	a_32_368##3	2.03019e-18
C131	B1_N#1	a_187_244##7	2.11888e-17
C132	VPWR#7	a_187_244##6	4.71313e-18
C133	VGND#2	X#1	8.5005e-18
C134	a_187_244##10	B1_N#3	1.34298e-19
C135	X	a_187_244##3	1.14934e-17
C136	a_187_244##5	a_187_244##9	2.59659e-18
C137	X#2	a_187_244##4	3.78699e-17
C138	X	a_187_244##2	3.6103e-18
C139	VGND#1	A1#2	2.36474e-18
C140	VGND#6	VGND#2	8.69096e-19
C141	a_32_368##7	a_187_244##6	4.97301e-19
C142	VPWR#7	a_187_244##4	3.7299e-17
C143	a_187_244##2	a_32_368##4	2.41797e-19
C144	a_187_244##5	a_32_368##6	2.54709e-18
C145	X#2	B1_N#3	8.75972e-19
C146	a_32_368##7	a_187_244##4	2.12007e-18
C147	B1_N#3	VPWR#7	2.20638e-17
C148	a_187_244##10	VPWR#3	2.17314e-17
C149	a_32_368##7	B1_N#3	3.93843e-17
C150	a_32_368##6	B1_N#2	2.08932e-18
C151	a_32_368##3	VGND#5	7.15566e-18
C152	B1_N#5	B1_N#2	1.35005e-17
C153	B1_N#4	B1_N#2	1.03265e-17
C154	A1#1	A2#4	4.31916e-17
C155	a_187_244##5	VGND#5	2.32727e-17
C156	a_504_392##2	A1#2	1.80507e-18
C157	a_187_244##5	X#1	3.22363e-18
C158	a_187_244##10	A1#2	1.9524e-19
C159	a_32_368#	A1#1	4.92877e-17
C160	VGND#2	A2#3	3.17376e-19
C161	a_32_368##3	a_187_244##10	6.09997e-17
C162	VGND#2	A1#3	7.97175e-18
C163	a_32_368##3	VPWR#5	3.71524e-17
C164	a_32_368##8	B1_N#2	1.6879e-17
C165	VGND#2	a_32_368##4	6.08627e-18
C166	a_187_244##6	a_32_368#	7.68408e-18
C167	X#2	a_32_368##3	2.67978e-17
C168	VGND#2	a_187_244#	7.97211e-18
C169	A1#2	A2#3	9.29671e-18
C170	VGND#2	a_187_244##7	8.52855e-19
C171	VGND	A2#2	6.11352e-19
C172	VGND	a_32_368##2	5.97527e-19
C173	VGND	a_187_244##3	2.37619e-18
C174	X#2	a_187_244##5	1.76111e-17
C175	VGND	a_187_244##2	9.40057e-19
C176	a_187_244##4	a_187_244##6	5.59019e-17
C177	X#2	B1_N#2	1.48026e-18
C178	VPWR#3	A1#1	7.81281e-20
C179	VPWR#7	B1_N#2	5.93906e-19
C180	B1_N#3	a_187_244##4	3.21901e-17
C181	VPWR#3	a_32_368#	3.66974e-18
C182	A1#6	A2	2.02941e-17
C183	a_32_368##7	B1_N#2	4.1519e-18
C184	a_187_244##5	a_32_368##4	1.86909e-19
C185	VPWR#3	a_187_244##6	8.80621e-18
C186	a_187_244##9	a_32_368##2	1.1702e-17
C187	a_187_244##5	a_187_244#	1.18831e-17
C188	VPWR#3	a_187_244##4	5.51273e-19
C189	a_187_244##5	a_187_244##7	1.32039e-18
C190	A2#2	VNB	6.16815e-17
C191	a_32_368##2	VNB	2.06962e-17
C192	a_187_244##3	VNB	1.82928e-17
C193	a_187_244##2	VNB	2.41261e-17
C194	VGND#1	A2	1.79918e-17
C195	a_32_368##3	a_32_368#	1.92163e-18
C196	a_32_368##3	a_187_244##6	1.50994e-17
C197	A2#3	a_587_74#	2.11762e-17
C198	a_187_244##9	a_187_244##2	4.33792e-19
C199	A1#3	a_587_74#	2.06918e-17
C200	a_32_368##3	a_187_244##4	9.78462e-19
C201	a_32_368##3	B1_N#3	1.77008e-19
C202	A2	a_504_392#	3.30819e-17
C203	B1_N#2	a_187_244##4	3.14439e-18
C204	VGND#2	A1#2	8.70566e-19
C205	a_32_368##3	VPWR#3	1.18374e-18
C206	X	a_187_244##9	1.11356e-18
C207	VGND#2	a_187_244##5	9.59632e-19
C208	VPWR	A1#6	4.71792e-18
C209	VPWR	a_32_368##6	1.036e-17
C210	a_187_244##5	a_32_368##3	5.98756e-17
C211	X	VGND#6	1.54468e-17
C212	a_32_368##8	X	4.99469e-17
C213	VPWR	B1_N#5	8.15278e-19
C214	VPWR	B1_N#4	1.36266e-18
C215	A2	A1#1	1.46203e-19
C216	VGND	a_187_244##9	1.8853e-17
C217	X	X#2	2.03253e-18
C218	A1#2	a_587_74#	7.90375e-19
C219	VPWR	a_504_392#	1.79886e-17
C220	VGND	B1_N#5	1.75865e-18
C221	VPWR	a_504_392##2	1.25416e-17
C222	VGND	B1_N#4	3.99138e-18
C223	VGND	VGND#1	4.8762e-17
C224	VPWR	a_187_244##10	2.02695e-17
C225	X	a_32_368##4	2.57483e-19
C226	X	a_187_244#	4.01476e-18
C227	VPWR	X#2	3.51042e-18
C228	X	a_187_244##7	1.56759e-17
C229	VGND	X#1	1.54718e-17
C230	A1#6	VNB	4.11213e-18
C231	VPWR	a_32_368##7	1.37134e-17
C232	X	B1_N#1	3.29033e-18
C233	VGND	a_32_368##8	1.57717e-17
C234	a_187_244##9	VNB	3.9446e-18
C235	a_32_368##6	VNB	6.29336e-18
C236	a_32_368##6	a_187_244##3	2.43592e-19
C237	A1#2	A2	1.09441e-17
C238	VGND	a_187_244##10	1.12816e-18
C239	B1_N#5	VNB	2.55332e-18
C240	B1_N#4	VNB	2.25362e-17
C241	VGND	X#2	1.20336e-18
C242	VGND#1	VNB	7.48892e-17
C243	VGND	a_32_368##7	4.11632e-18
C244	VGND#5	VNB	2.87741e-18
C245	VGND	A2#3	4.13995e-18
C246	VPWR	A2#4	1.1848e-18
C247	X#1	VNB	2.00637e-18
C248	VGND	A1#3	1.21228e-18
C249	VGND#6	VNB	9.61652e-18
C250	VPWR	A1#1	9.29309e-19
C251	a_32_368##8	VNB	3.15457e-17
C252	VGND	a_32_368##4	8.4895e-20
C253	VPWR	a_32_368#	1.74023e-20
C254	a_504_392#	VNB	4.95606e-17
C255	VGND	a_187_244#	1.04497e-18
C256	VPWR#4	VNB	6.26204e-19
C257	VPWR	a_187_244##6	1.48295e-18
C258	VGND	a_187_244##7	1.07016e-18
C259	a_504_392##2	VNB	4.51472e-18
C260	a_187_244##10	VNB	1.62651e-17
C261	VGND	B1_N#1	9.69474e-18
C262	VPWR	a_187_244##4	4.26323e-19
C263	VPWR#5	VNB	4.75183e-18
C264	VPWR	B1_N#3	6.54029e-18
C265	X#2	VNB	5.25741e-19
C266	VPWR#7	VNB	1.12328e-17
C267	a_32_368##7	VNB	4.75931e-17
C268	A2#3	VNB	2.82742e-17
C269	VPWR	VPWR#3	5.03329e-17
C270	A1#3	VNB	2.41946e-17
C271	a_32_368##4	VNB	2.71234e-17
C272	a_187_244#	VNB	2.87778e-17
C273	X	a_187_244##5	4.23195e-17
C274	a_187_244##7	VNB	2.66336e-17
C275	B1_N#1	VNB	3.9514e-17
C276	X	B1_N#2	1.2958e-18
C277	VPWR	a_32_368##3	6.24999e-18
C278	A2#4	VNB	3.65141e-17
C279	A1#1	VNB	3.39519e-17
C280	VGND	VGND#2	7.28162e-17
C281	VPWR	a_187_244##5	2.60013e-18
C282	a_32_368#	VNB	4.23728e-17
C283	a_187_244##6	VNB	4.20004e-17
C284	a_187_244##4	VNB	4.32233e-17
C285	VGND	A1#2	1.11608e-17
C286	B1_N#3	VNB	5.06723e-17
C287	VGND	a_32_368##3	4.54837e-18
C288	VGND	a_187_244##5	5.52267e-18
C289	VPWR#3	VNB	2.09752e-16
C290	VGND#2	VNB	2.21063e-16
C291	VGND	B1_N#2	5.43911e-19
C292	A1#1	A2#2	5.21269e-18
C293	A1#2	VNB	3.88578e-17
C294	a_32_368##3	VNB	3.4097e-17
C295	a_187_244##5	VNB	1.86401e-20
C296	B1_N#2	VNB	6.45971e-17
C297	VPWR	A2	1.80705e-18
C298	VGND	A2	2.31376e-18
C299	A2	VNB	1.78691e-17
C300	VGND	X	2.06628e-18
C301	X	VNB	6.46964e-19
C302	VPWR	VNB	6.68992e-17
C303	VGND	VNB	6.82998e-17
C304	VPWR#3	VPWR#6	5.47293e-17
C305	VPWR	VPWR#6	5.69502e-17
C306	VGND#2	VGND#3	6.12926e-17
C307	VGND#3	B1_N#1	3.83262e-18
C308	VGND#3	VNB	5.52288e-17
C309	VPWR#2	A1#2	5.83121e-20
C310	VGND#3	a_187_244##2	6.46546e-20
C311	a_504_392##2	VPWR#2	1.40429e-17
C312	VPWR#6	B1_N#2	1.78213e-19
C313	VPWR#2	A1#1	7.25381e-18
C314	VGND#3	a_32_368##4	3.95645e-20
C315	a_32_368##7	VPWR#6	9.02429e-18
C316	VGND#3	X	3.00107e-19
C317	VPWR#6	a_187_244##3	4.09417e-20
C318	VPWR#6	a_187_244##6	6.03848e-19
C319	VGND#3	X#1	8.28513e-18
C320	VPWR#2	VNB	5.0267e-17
C321	a_187_244##10	VPWR#2	4.64033e-19
C322	VPWR#2	a_32_368#	3.84676e-18
C323	VPWR#6	VNB	5.07359e-17
C324	VPWR#3	VPWR#2	5.75255e-17
C325	VPWR#6	a_187_244##4	7.84508e-18
C326	VGND#3	a_187_244#	5.7038e-19
C327	VGND#3	B1_N#2	8.56795e-19
C328	VPWR#5	VPWR#2	8.79566e-19
C329	VPWR#2	a_187_244##6	2.47221e-19
C330	a_32_368##6	VPWR#6	1.86256e-18
C331	VPWR#6	B1_N#3	1.86167e-18
C332	VPWR#2	A2#2	9.36761e-20
C333	a_504_392#	VPWR#2	2.11959e-17
C334	VGND#3	a_187_244##7	5.26399e-18
C335	VGND	VGND#3	5.099e-17
C336	VGND#3	B1_N#4	1.89374e-18
C337	VPWR	VPWR#2	5.21951e-17
C338	VGND#3	a_32_368##8	1.13367e-17
C339	VPWR#2	A2#4	6.70737e-18
*
*
.ENDS sky130_fd_sc_hs__a21bo_2
*
