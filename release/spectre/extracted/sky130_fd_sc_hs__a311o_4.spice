* Extracted by Quantus, converted by sky130cad/quantus.py
*
*
*
*                       LINUX           Wed Nov 18 08:11:44 2026
*
*
*
*  PROGRAM  advgen
*
*  Name           : advgen - Quantus - (64-bit)
*  Version        : 25.1.0-p047
*  Build Date     : Thu Dec 11 23:20:30 PST 2025
*
*  HSPICE LIBRARY
*
*  OPERATING_TEMPERATURE 150
*  QRC_TECH_DIR <path>/tech
*
*
*

*
.SUBCKT sky130_fd_sc_hs__a311o_4 VPB VNB VGND X VPWR A3 A1 A2 C1 B1
*
*
*  caps2d version: 10
*
*
*       TRANSISTOR CARDS
*
*
XM4 a_154_392##19 C1#5 VGND#14 VNB sky130_fd_pr__nfet_01v8_lvt l=0.15 w=0.64 ad=0.1792 as=0.1696 pd=1.84 ps=1.81
XM10 VGND#13 C1#1 a_154_392##19 VNB sky130_fd_pr__nfet_01v8_lvt l=0.15 w=0.64 ad=0.1792 as=0.1792 pd=1.84 ps=1.84
XM13 VGND#13 B1#6 a_154_392##18 VNB sky130_fd_pr__nfet_01v8_lvt l=0.15 w=0.64 ad=0.1792 as=0.1792 pd=1.84 ps=1.84
XM25 a_154_392##18 B1#1 VGND#12 VNB sky130_fd_pr__nfet_01v8_lvt l=0.15 w=0.64 ad=0.1792 as=0.233 pd=1.84 ps=2.13
XM6 VGND#12 a_154_392##6 X#2 VNB sky130_fd_pr__nfet_01v8_lvt l=0.15 w=0.74 ad=0.233 as=0.2072 pd=2.13 ps=2.04
XM15 VGND#11 a_154_392##11 X#2 VNB sky130_fd_pr__nfet_01v8_lvt l=0.15 w=0.74 ad=0.243125 as=0.2072 pd=2.16 ps=2.04
XM12 X#1 a_154_392##9 VGND#11 VNB sky130_fd_pr__nfet_01v8_lvt l=0.15 w=0.74 ad=0.2072 as=0.243125 pd=2.04 ps=2.16
XM16 X#1 a_154_392##7 VGND#4 VNB sky130_fd_pr__nfet_01v8_lvt l=0.15 w=0.74 ad=0.2072 as=0.2441 pd=2.04 ps=2.16
XM26 VGND#4 A3#5 a_888_105##2 VNB sky130_fd_pr__nfet_01v8_lvt l=0.15 w=0.64 ad=0.2441 as=0.1792 pd=2.16 ps=1.84
XM11 a_888_105##2 A3#7 VGND#6 VNB sky130_fd_pr__nfet_01v8_lvt l=0.15 w=0.64 ad=0.1792 as=0.1696 pd=1.84 ps=1.81
XM1 a_154_392##13 A1#6 a_1081_39##4 VNB sky130_fd_pr__nfet_01v8_lvt l=0.15 w=0.64 ad=0.1792 as=0.3055 pd=1.84 ps=2.71
XM21 a_1081_39# A1#1 a_154_392##13 VNB sky130_fd_pr__nfet_01v8_lvt l=0.15 w=0.64 ad=0.2176 as=0.1792 pd=1.96 ps=1.84
XM9 a_1081_39# A2#7 a_888_105# VNB sky130_fd_pr__nfet_01v8_lvt l=0.15 w=0.64 ad=0.2176 as=0.1792 pd=1.96 ps=1.84
XM8 a_888_105# A2#5 a_1081_39##2 VNB sky130_fd_pr__nfet_01v8_lvt l=0.15 w=0.64 ad=0.1792 as=0.1696 pd=1.84 ps=1.81
XM18 a_154_392##17 C1#6 a_69_392##4 VPB sky130_fd_pr__pfet_01v8 l=0.15 w=1 ad=0.3 as=0.275 pd=2.6 ps=2.55
XM27 a_69_392##2 C1#4 a_154_392##17 VPB sky130_fd_pr__pfet_01v8 l=0.15 w=1 ad=0.3 as=0.3 pd=2.6 ps=2.6
XM7 a_334_392##5 B1#4 a_69_392##2 VPB sky130_fd_pr__pfet_01v8 l=0.15 w=1 ad=0.3 as=0.3 pd=2.6 ps=2.6
XM2 a_69_392# B1#5 a_334_392##5 VPB sky130_fd_pr__pfet_01v8 l=0.15 w=1 ad=0.275 as=0.3 pd=2.55 ps=2.6
XM14 X#6 a_154_392##12 VPWR#13 VPB sky130_fd_pr__pfet_01v8 l=0.15 w=1.12 ad=0.336 as=0.308 pd=2.84 ps=2.79
XM17 X#6 a_154_392##10 VPWR#10 VPB sky130_fd_pr__pfet_01v8 l=0.15 w=1.12 ad=0.336 as=0.336 pd=2.84 ps=2.84
XM22 VPWR#10 a_154_392##8 X#5 VPB sky130_fd_pr__pfet_01v8 l=0.15 w=1.12 ad=0.336 as=0.336 pd=2.84 ps=2.84
XM23 VPWR#8 a_154_392# X#5 VPB sky130_fd_pr__pfet_01v8 l=0.15 w=1.12 ad=0.398 as=0.336 pd=2.97 ps=2.84
XM24 VPWR#8 A3#6 a_334_392##6 VPB sky130_fd_pr__pfet_01v8 l=0.15 w=1 ad=0.398 as=0.3 pd=2.97 ps=2.6
XM0 a_334_392##6 A3#1 VPWR#6 VPB sky130_fd_pr__pfet_01v8 l=0.15 w=1 ad=0.3 as=0.3 pd=2.6 ps=2.6
XM5 a_334_392##2 A1#4 VPWR#6 VPB sky130_fd_pr__pfet_01v8 l=0.15 w=1 ad=0.3 as=0.3 pd=2.6 ps=2.6
XM20 VPWR#4 A1#5 a_334_392##2 VPB sky130_fd_pr__pfet_01v8 l=0.15 w=1 ad=0.33 as=0.3 pd=2.66 ps=2.6
XM19 VPWR#4 A2#4 a_334_392# VPB sky130_fd_pr__pfet_01v8 l=0.15 w=1 ad=0.33 as=0.3 pd=2.66 ps=2.6
XM3 a_334_392# A2#1 VPWR#1 VPB sky130_fd_pr__pfet_01v8 l=0.15 w=1 ad=0.3 as=0.275 pd=2.6 ps=2.55
*
*
*       RESISTOR AND CAP/DIODE CARDS
*
Rg1	C1#1	C1#2	449.830200
Rg2	C1#2	C1#3	60.582565
Rg3	C1#2	C1#4	428.990967
Rg4	C1#3	C1#5	492.907227
Rg5	C1#3	C1#6	410.270447
Rg6	B1#1	B1#2	468.979218
Rg7	B1#2	B1#3	60.526707
Rg8	B1#3	B1#4	392.447479
Rg9	B1#2	B1#5	412.766663
Rg10	B1#3	B1#6	449.381775
Rg11	a_154_392#	a_154_392##2	574.372375
Rg12	a_154_392##2	a_154_392##3	59.460350
Rg13	a_154_392##3	a_154_392##4	30.317850
Rg14	a_154_392##4	a_154_392##5	32.346050
Rg15	a_154_392##5	a_154_392##6	412.859863
Rg16	a_154_392##2	a_154_392##7	387.107544
Rg17	a_154_392##2	a_154_392##8	450.232361
Rg18	a_154_392##3	a_154_392##9	376.375427
Rg19	a_154_392##3	a_154_392##10	439.500244
Rg20	a_154_392##5	a_154_392##11	399.230408
Rg21	a_154_392##5	a_154_392##12	453.747284
Rg22	A3#1	A3#2	445.206848
Rg23	A3#2	A3#3	31.598013
Rg24	A3#3	A3#4	129.763977
Rg25	A3#4	A3#5	426.941864
Rg26	A3#3	A3#6	484.571960
Rg27	A3#4	A3#7	251.582199
Rg28	A1#1	A1#2	345.719971
Rg29	A1#2	A1#3	70.417664
Rg30	A1#3	A1#4	425.091339
Rg31	A1#2	A1#5	409.571808
Rg32	A1#3	A1#6	361.974152
Rg33	A2#1	A2#2	398.470581
Rg34	A2#2	A2#3	63.822582
Rg35	A2#3	A2#4	478.389740
Rg36	A2#2	A2#5	381.254730
Rg37	A2#2	A2#6	42.828468
Rg38	A2#3	A2#7	414.537872
Rf1	C1#3	C1	162.594833
Rf2	B1#3	B1	161.413818
Rf3	a_69_392#	a_69_392##3	75.727219
Rf4	a_69_392##3	a_69_392##4	54.556080
Rf5	a_69_392##2	a_69_392##3	15.000000
Rf6	X#1	X#3	75.264572
Rf7	X#3	X#4	2.021816
Rf8	X#2	X#3	7.500000
Rf9	X#5	X#7	50.430542
Rf10	X#7	X	331.675079
Rf11	X#6	X#7	15.000000
Rf12	A3#8	A3	1.411932
Rf13	A3#2	A3#10	161.644730
Rf14	A3#8	A3#10	3.261114
Rf15	a_154_392##13	a_154_392##14	267.187073
Rf16	a_154_392##14	a_154_392##15	67.655746
Rf17	a_154_392##15	a_154_392##16	51.656635
Rf18	a_154_392##16	a_154_392##17	77.080650
Rf19	a_154_392##15	a_154_392##18	36.064137
Rf20	a_154_392##16	a_154_392##19	40.553268
Rf21	a_334_392#	a_334_392##3	127.511635
Rf22	a_334_392##3	a_334_392##4	67.083878
Rf23	a_334_392##4	a_334_392##5	252.796494
Rf24	a_334_392##4	a_334_392##6	14.409969
Rf25	a_334_392##2	a_334_392##3	5.000000
Rf26	A1	A1#7	9.251308
Rf27	A1#7	A1	9.644981
Rf28	a_888_105#	a_888_105##2	198.034821
Rf29	a_1081_39#	a_1081_39##3	60.644505
Rf30	a_1081_39##3	a_1081_39##4	175.602341
Rf31	a_1081_39##2	a_1081_39##3	7.500000
Rf32	A2#6	A2	162.201172
Rf33	VPWR#1	VPWR#2	39.269733
Rf34	VPWR#2	VPWR#3	53.286453
Rf35	VPWR#3	VPWR#4	29.622076
Rf36	VPWR#3	VPWR#5	63.911594
Rf37	VPWR#5	VPWR#6	37.538910
Rf38	VPWR#5	VPWR#7	73.424034
Rf39	VPWR#7	VPWR#8	33.326477
Rf40	VPWR#7	VPWR#9	65.696381
Rf41	VPWR#9	VPWR#10	33.326477
Rf42	VPWR#9	VPWR#11	24.082130
Rf43	VPWR#11	VPWR#12	41.614250
Rf44	VPWR#12	VPWR#13	33.326477
Rf46	VGND#1	VGND#2	230.141876
Rf47	VGND#2	VGND#3	50.437660
Rf48	VGND#2	VGND#5	35.457493
Rf49	VGND#5	VGND#6	73.696716
Rf50	VGND#3	VGND#7	83.748680
Rf51	VGND#7	VGND#8	59.909691
Rf52	VGND#8	VGND#9	62.774361
Rf54	VGND#3	VGND#11	51.018875
Rf55	VGND#7	VGND#12	51.352844
Rf56	VGND#8	VGND#13	31.928406
Rf57	VGND#9	VGND#14	33.523315
Rf58	VGND#4	VGND#5	7.500000
Rf62	a_154_392##4	a_154_392##14	40.058201
Rf63	A1#2	A1#7	160.232803
Re1	X#4	X	13.698293
Re3	VPWR#2	VPWR	6.179563
Re4	VPWR	VPWR#11	0.882795
Re5	VGND#1	VGND	6.179563
Re6	VGND	VGND#3	0.882795
*
*       CAPACITOR CARDS
*
*
C1	a_334_392##5	VPWR#13	4.45189e-17
C2	a_334_392##4	A3#3	8.24747e-19
C3	X#6	a_69_392##2	4.67886e-17
C4	a_1081_39##2	a_888_105#	7.96241e-17
C5	a_154_392##15	X#2	1.48024e-17
C6	a_334_392##4	A3#6	3.38628e-17
C7	X#2	a_154_392##6	4.12467e-17
C8	a_69_392#	a_334_392##5	5.68879e-17
C9	X#6	a_154_392##17	3.57608e-17
C10	VGND#11	B1#1	1.80129e-19
C11	VPWR#7	VPWR#5	1.09138e-18
C12	a_154_392##6	VGND#12	1.18042e-17
C13	a_334_392##4	a_154_392##5	2.15509e-19
C14	a_154_392##15	VGND#12	1.9826e-17
C15	a_154_392##4	A1#3	2.74705e-19
C16	X#1	a_154_392##5	2.60943e-18
C17	X#2	B1#1	2.03463e-18
C18	a_69_392##2	a_69_392#	3.4612e-18
C19	a_334_392#	VPWR#3	2.97182e-18
C20	a_154_392##4	A3#4	5.26953e-18
C21	a_154_392##16	a_154_392##18	4.66344e-19
C22	a_334_392##4	a_154_392#	2.5078e-17
C23	a_154_392##18	a_154_392##6	3.22647e-19
C24	a_154_392##4	A3#3	1.35809e-17
C25	VPWR#5	VPWR#4	6.63176e-20
C26	a_154_392##4	a_154_392##5	4.56121e-17
C27	VGND#12	B1#1	2.76731e-17
C28	a_888_105#	a_1081_39#	4.90136e-17
C29	a_69_392##2	a_334_392##5	1.61206e-17
C30	X#2	B1#6	1.72013e-19
C31	a_154_392##4	a_154_392##2	2.54948e-17
C32	a_154_392##13	A2#1	9.36392e-20
C33	B1#1	a_154_392##18	1.31624e-17
C34	A3#1	A1#3	6.07134e-19
C35	VGND#13	a_154_392##16	1.60808e-17
C36	a_334_392##4	a_154_392##8	1.69274e-17
C37	VGND#12	B1#6	9.4141e-19
C38	VGND#8	a_154_392##16	1.84574e-19
C39	VGND#13	B1#1	1.93309e-18
C40	a_334_392##2	VPWR#5	5.78965e-18
C41	a_888_105#	a_154_392##13	3.72888e-17
C42	a_1081_39##2	a_1081_39##4	1.36801e-20
C43	X#1	a_154_392##2	1.15465e-18
C44	B1#6	a_154_392##18	1.66926e-17
C45	VPWR#5	VPWR#3	1.0654e-18
C46	a_154_392##13	A2#4	4.44876e-19
C47	a_69_392##2	a_154_392##17	1.63609e-18
C48	a_334_392##4	a_154_392##2	5.26279e-19
C49	VGND#13	a_154_392##15	9.92687e-18
C50	VGND#11	a_154_392##5	1.57414e-18
C51	a_154_392##19	B1#1	1.08579e-20
C52	a_154_392##16	a_154_392##19	1.42908e-18
C53	a_334_392##2	VPWR#3	5.51875e-18
C54	a_334_392##4	a_154_392##10	8.63753e-18
C55	VGND#13	B1#6	3.58935e-17
C56	a_154_392##13	a_1081_39#	2.69347e-17
C57	a_1081_39##4	a_888_105#	7.22941e-17
C58	VPWR#8	A3#5	1.93329e-19
C59	VGND#8	a_154_392##15	1.82887e-19
C60	a_154_392##18	C1#1	3.80886e-19
C61	a_154_392##13	A1#5	1.26057e-18
C62	a_154_392##19	B1#6	4.2468e-20
C63	B1#3	B1#2	7.5444e-18
C64	VGND#13	C1#1	3.18712e-17
C65	a_69_392##4	a_154_392##17	1.79241e-19
C66	a_334_392##4	a_154_392##12	4.64792e-19
C67	a_154_392##18	C1#5	2.30422e-19
C68	C1#1	a_154_392##19	1.20463e-17
C69	VGND#7	a_154_392##15	5.56326e-19
C70	a_154_392##13	A1#4	6.57343e-18
C71	VGND#13	C1#5	2.91773e-18
C72	X#2	a_154_392##5	5.52048e-18
C73	a_154_392##17	B1#2	4.03097e-20
C74	VGND#14	C1#1	2.07196e-18
C75	a_154_392##13	a_1081_39##4	3.26758e-18
C76	C1#5	a_154_392##19	1.82419e-17
C77	a_154_392##13	A3#1	1.44698e-17
C78	VGND#14	C1#5	3.02427e-17
C79	VPWR#8	VPWR#5	7.94397e-20
C80	VGND#6	a_154_392##13	1.74515e-17
C81	a_334_392##4	VPWR#9	2.16429e-18
C82	a_154_392##13	A3#6	1.00113e-17
C83	A2#7	A2#5	3.67145e-17
C84	a_154_392##15	a_154_392##5	2.26666e-19
C85	a_334_392##4	a_334_392##2	3.4612e-18
C86	a_154_392#	A3#3	1.02513e-17
C87	a_888_105##2	a_154_392##13	2.75197e-17
C88	a_334_392##4	VPWR#7	1.14272e-17
C89	a_154_392##13	a_154_392#	8.31715e-20
C90	A2#3	A2#2	4.39436e-18
C91	A1#1	A2#7	2.85549e-17
C92	VPWR#1	A2#1	4.53546e-17
C93	X#6	a_154_392##6	6.82332e-18
C94	a_888_105##2	a_1081_39##4	4.232e-17
C95	a_154_392##16	B1#2	1.68236e-19
C96	a_334_392##4	VPWR#6	4.30119e-17
C97	VGND#6	a_154_392#	3.41708e-18
C98	A2#1	a_334_392#	2.20438e-17
C99	VPWR#13	a_154_392##6	5.18122e-19
C100	a_334_392##4	VPWR#5	8.58947e-18
C101	VPWR#1	A2#4	3.19872e-18
C102	VPWR#4	A2#1	2.77902e-18
C103	VGND#6	a_888_105##2	7.35633e-17
C104	VGND#4	a_1081_39##4	2.26923e-18
C105	a_154_392##15	a_154_392##2	3.856e-20
C106	A1#6	A1#1	3.77263e-17
C107	X#4	VGND#8	6.14607e-19
C108	a_334_392#	A2#4	3.71892e-17
C109	a_334_392##4	a_334_392##6	1.06721e-18
C110	a_334_392##2	A2#1	3.93882e-19
C111	VPWR#2	VPWR#3	1.23815e-17
C112	X#4	VGND#7	2.44058e-18
C113	a_334_392##5	a_154_392##6	5.93136e-19
C114	VPWR#4	A2#4	5.13666e-17
C115	VGND#6	VGND#4	1.84517e-18
C116	a_334_392#	A1#5	3.6552e-19
C117	A3#10	A1#3	3.20527e-18
C118	a_154_392##15	B1#2	2.30815e-17
C119	a_334_392##2	A2#4	7.10116e-19
C120	A3#7	A1#6	4.69306e-18
C121	a_334_392##4	VPWR#8	6.82493e-17
C122	VPWR#4	A1#5	4.51151e-17
C123	VGND#4	a_888_105##2	2.09755e-17
C124	X#1	VGND#6	2.24484e-17
C125	a_334_392#	A1#4	1.57965e-19
C126	a_334_392##2	A1#5	3.66863e-17
C127	VPWR#4	A1#4	2.16367e-18
C128	VPWR#6	A1#5	1.10442e-18
C129	a_334_392##4	X#5	6.13283e-17
C130	A3#5	A3#7	3.22075e-17
C131	a_334_392##2	A1#4	3.62694e-17
C132	VPWR#6	A1#4	3.58917e-17
C133	A3#10	A3#3	1.52405e-17
C134	A3#4	A1#6	8.60661e-19
C135	a_334_392##2	A3#1	1.29885e-18
C136	X#1	VGND#4	3.84972e-17
C137	a_334_392##4	VPWR#10	4.39722e-17
C138	a_154_392##7	A3#5	2.91661e-17
C139	X#5	A1#5	1.19022e-19
C140	A3#1	VPWR#6	2.14898e-17
C141	VPWR#8	A1#4	2.7834e-19
C142	VGND#7	VGND#3	1.40999e-18
C143	a_334_392##2	A3#6	3.74696e-19
C144	A3#1	a_334_392##6	2.06893e-17
C145	VGND#11	VGND#4	4.2764e-19
C146	X#5	A1#4	1.61994e-19
C147	VPWR#6	A3#6	3.50791e-19
C148	X#6	a_334_392##4	2.17142e-17
C149	VGND#3	VGND#2	1.64157e-18
C150	VPWR#8	A3#1	7.28623e-19
C151	a_154_392##9	a_154_392##7	3.88962e-17
C152	X#4	a_154_392##16	3.82265e-19
C153	a_334_392##2	a_154_392#	2.30727e-19
C154	A3#6	a_334_392##6	2.06893e-17
C155	X#4	a_154_392##15	1.55836e-17
C156	a_1081_39##2	VPWR#1	2.96989e-18
C157	X#5	A3#1	2.25282e-19
C158	X#1	VGND#11	4.04511e-17
C159	a_334_392##4	VPWR#11	5.42022e-19
C160	VPWR#1	A2#2	6.37776e-18
C161	VPWR#6	a_154_392#	1.63498e-19
C162	A3#6	VPWR#8	2.3566e-17
C163	a_334_392##2	a_154_392##8	1.28221e-19
C164	B1#2	a_154_392##12	3.93237e-19
C165	X#5	A3#6	1.33867e-18
C166	a_154_392##11	a_154_392##9	3.42391e-17
C167	a_1081_39##2	a_334_392#	1.15986e-19
C168	a_154_392##16	X#6	4.48549e-18
C169	X#2	X#1	2.97245e-18
C170	VPWR#8	a_154_392#	3.89057e-17
C171	X#5	a_154_392#	4.21071e-17
C172	a_334_392#	A2#3	1.58502e-18
C173	a_154_392##15	X#6	4.23686e-17
C174	VPWR#8	a_154_392##8	2.95157e-18
C175	a_154_392##6	a_154_392##11	3.79121e-17
C176	VGND#1	a_1081_39##2	1.03017e-16
C177	VPWR#10	a_154_392#	2.95157e-18
C178	X#2	VGND#11	5.22108e-17
C179	VGND#1	a_888_105#	6.09156e-18
C180	X#5	a_154_392##8	4.55851e-17
C181	A3#4	A1#3	4.63195e-19
C182	a_334_392#	A2#2	1.27762e-18
C183	VGND#1	a_1081_39#	1.14798e-18
C184	VPWR#10	a_154_392##8	3.90792e-17
C185	B1#1	a_154_392##6	3.2666e-17
C186	VGND#7	a_154_392##5	2.11423e-20
C187	VGND#1	a_1081_39##4	8.17423e-17
C188	VPWR#10	a_154_392##10	3.7687e-17
C189	VPWR#3	A1#2	2.20765e-20
C190	VGND#12	X#2	4.59567e-17
C191	X#6	a_154_392##10	4.58846e-17
C192	B1#6	B1#1	4.09799e-17
C193	VPWR#10	a_154_392##12	4.36428e-18
C194	VPWR#13	a_154_392##10	2.95157e-18
C195	a_334_392##5	a_154_392##8	1.90918e-19
C196	X#4	VGND#6	1.29657e-18
C197	A3#3	A1#3	2.2938e-17
C198	X#6	a_154_392##12	4.83392e-17
C199	a_154_392##18	X#2	1.14833e-18
C200	VGND#2	a_154_392##4	1.09111e-18
C201	a_154_392##2	A3#5	1.17191e-17
C202	VGND#2	A3#4	1.12263e-19
C203	VPWR#13	a_154_392##12	5.20745e-17
C204	X#4	VGND#4	6.75004e-19
C205	a_334_392##5	a_154_392##10	8.963e-18
C206	C1#1	B1#6	3.9718e-17
C207	X#6	B1#5	2.05276e-17
C208	VGND#8	B1#3	3.12155e-20
C209	X#4	X#1	1.34034e-18
C210	a_69_392#	a_154_392##12	1.16181e-18
C211	a_154_392##13	a_334_392##2	2.97803e-17
C212	VGND#2	A3#7	3.63538e-18
C213	VGND#7	B1#3	2.30214e-20
C214	a_154_392##18	VGND#12	4.16741e-17
C215	VPWR#13	B1#5	1.79246e-18
C216	a_334_392##5	a_154_392##12	1.91637e-17
C217	X#4	X#2	3.84793e-17
C218	X#6	B1#4	2.40283e-17
C219	a_69_392#	B1#5	5.63392e-17
C220	VPWR#2	VPWR#1	2.15999e-17
C221	C1#5	C1#1	4.04948e-17
C222	VGND#2	A3#3	2.3725e-19
C223	X#4	VGND#12	1.9531e-17
C224	a_154_392##13	VPWR#6	1.2617e-19
C225	a_334_392#	VPWR#2	2.07413e-17
C226	VPWR#13	B1#4	2.03279e-19
C227	a_334_392##5	B1#5	3.3026e-17
C228	a_154_392##17	a_154_392##12	1.24375e-19
C229	X#4	a_154_392##18	2.58634e-17
C230	VGND#8	C1#3	3.12627e-20
C231	a_154_392##16	a_154_392##17	2.40488e-18
C232	VPWR#4	VPWR#2	1.4514e-19
C233	X#6	C1#4	1.88642e-17
C234	a_69_392#	B1#4	7.79818e-19
C235	VGND#2	A3#5	5.57723e-18
C236	a_69_392##2	B1#5	9.93073e-19
C237	X#4	VGND#13	9.44391e-18
C238	a_154_392##16	a_154_392##15	3.56533e-18
C239	VGND#7	B1#2	7.33762e-21
C240	a_154_392##4	a_334_392##4	2.84555e-17
C241	VPWR#13	C1#4	6.99797e-20
C242	B1#4	a_334_392##5	2.64039e-17
C243	a_154_392##17	B1#5	1.69725e-19
C244	VGND#13	a_154_392##18	4.71958e-17
C245	A3#5	a_154_392#	1.27942e-17
C246	X#6	C1#6	7.69293e-19
C247	a_69_392##2	B1#4	4.13934e-17
C248	a_334_392##2	A1#3	1.44092e-18
C249	a_334_392##5	C1#4	1.82693e-18
C250	VPWR#13	C1#6	4.99852e-20
C251	a_154_392##17	B1#4	1.0795e-18
C252	VGND#2	a_154_392##7	1.17061e-17
C253	a_154_392##5	a_154_392##9	3.05287e-19
C254	VGND#3	X#1	9.32065e-18
C255	VGND#7	a_154_392##9	3.10216e-19
C256	a_154_392##19	a_154_392##18	1.07039e-19
C257	a_69_392##2	C1#4	3.58339e-17
C258	a_888_105#	A1#2	6.13031e-19
C259	a_1081_39#	A1#2	1.65195e-18
C260	a_334_392##5	C1#6	9.33246e-19
C261	a_154_392##17	C1#4	2.87983e-17
C262	VGND#3	X#2	8.53704e-18
C263	a_154_392##16	B1#3	2.00129e-18
C264	a_154_392##13	A1#2	2.15337e-18
C265	a_69_392##2	C1#6	1.27489e-18
C266	a_154_392##15	B1#3	1.3822e-17
C267	a_1081_39##4	A1#2	4.31182e-19
C268	a_154_392##19	VGND#13	4.72126e-17
C269	a_1081_39##2	A2#3	6.01665e-19
C270	A2#4	A2#1	4.30432e-17
C271	a_154_392##17	C1#6	2.81877e-17
C272	VGND#2	a_154_392##9	1.53381e-18
C273	VGND#7	a_154_392##11	6.80456e-19
C274	a_69_392##4	C1#6	2.99039e-17
C275	a_154_392##16	C1#3	2.38135e-17
C276	VGND#14	VGND#13	3.64053e-18
C277	a_154_392##15	C1#3	2.70444e-19
C278	VGND#2	a_154_392##2	1.5512e-20
C279	VGND#2	a_1081_39##4	2.25113e-17
C280	A1#5	A2#4	3.67173e-17
C281	a_1081_39##2	A2#2	7.75419e-18
C282	A2	A2#2	1.86005e-17
C283	X#4	X#6	7.23129e-18
C284	VGND#2	a_154_392##11	9.26591e-19
C285	a_154_392##4	a_154_392##13	4.15115e-18
C286	X#4	VPWR#13	1.13291e-18
C287	VGND#14	a_154_392##19	2.28894e-17
C288	VGND#7	a_154_392##6	1.04076e-17
C289	VPWR#2	A2#3	1.76016e-20
C290	X#4	a_69_392#	1.45351e-18
C291	A1#4	A1#5	4.34409e-17
C292	VGND#6	a_154_392##4	4.13615e-17
C293	VPWR#2	A2#2	7.27017e-19
C294	X#4	a_334_392##5	3.95065e-18
C295	a_888_105#	A2#3	2.54419e-19
C296	VGND#2	VGND#6	1.11776e-18
C297	X#4	a_69_392##2	2.31783e-20
C298	a_154_392##4	X#1	5.10135e-17
C299	VGND#1	A2#5	1.2035e-18
C300	a_154_392##4	VGND#11	3.73669e-18
C301	A3#1	A1#4	4.2484e-17
C302	a_334_392##5	VPWR#11	3.36011e-18
C303	VGND#7	B1#1	7.63509e-18
C304	VGND#1	A2#7	1.21364e-18
C305	a_154_392##4	X#2	5.72049e-17
C306	A1	A2#3	2.17236e-17
C307	VPWR#4	A1#2	5.6811e-19
C308	a_888_105#	A2#2	2.3881e-19
C309	a_154_392##6	a_154_392##5	1.30187e-18
C310	A1	A2#2	1.00042e-17
C311	VGND#1	A1#1	1.20633e-18
C312	A1	A1#3	7.69767e-18
C313	a_334_392##2	A1#2	2.9093e-18
C314	VGND#2	a_888_105##2	2.18019e-17
C315	VGND#1	A1#6	1.20237e-18
C316	VGND#8	B1#6	9.08372e-19
C317	A3#6	A3#1	4.22758e-17
C318	VGND#1	A2#3	1.48331e-20
C319	VGND#7	B1#6	9.6471e-19
C320	a_334_392##4	A3#5	1.36236e-19
C321	a_888_105#	A1#3	1.87358e-19
C322	VGND#8	VGND#7	1.54741e-18
C323	VGND#1	A2#2	1.01802e-18
C324	a_1081_39#	A2#3	7.39788e-19
C325	A3#3	a_334_392##6	2.65268e-19
C326	a_154_392#	A3#6	3.56469e-17
C327	VGND#1	A1#3	1.16867e-20
C328	X#4	A3#5	2.53113e-21
C329	B1#2	a_154_392##6	2.49415e-17
C330	a_334_392#	VPWR#1	7.6083e-17
C331	VGND#8	C1#1	9.03552e-19
C332	VPWR#3	A2#3	6.71246e-21
C333	a_154_392##8	a_154_392#	4.83775e-17
C334	X#4	a_154_392##9	8.73239e-19
C335	VGND#7	VGND#11	2.07223e-18
C336	VPWR#5	A1#3	2.23749e-20
C337	a_154_392##4	VPWR#8	3.1493e-18
C338	A3	A3#3	8.51221e-18
C339	VPWR#4	VPWR#1	2.08598e-18
C340	VPWR#7	A3#3	2.39841e-20
C341	VGND#14	C1#3	1.68019e-18
C342	VPWR#8	A3#4	2.57404e-19
C343	a_154_392##4	X#5	8.32842e-17
C344	A3	a_154_392##2	2.01372e-19
C345	a_154_392##15	A3#5	2.5745e-19
C346	X#4	a_154_392##6	3.25202e-18
C347	VGND#2	X#1	2.24849e-18
C348	a_154_392##10	a_154_392##8	4.63431e-17
C349	a_154_392##2	A3#3	3.00178e-18
C350	X#4	B1#1	2.75613e-18
C351	a_154_392##4	X#6	9.02079e-17
C352	a_334_392#	VPWR#4	6.54426e-17
C353	X#4	B1#6	2.72371e-18
C354	VPWR#8	A3#3	1.5239e-19
C355	a_154_392##13	A2#3	3.58046e-19
C356	VGND#7	X#2	1.06467e-17
C357	VPWR#2	A2#1	8.86834e-18
C358	a_1081_39##2	A2#5	4.65241e-17
C359	a_154_392##12	a_154_392##10	4.85929e-17
C360	a_154_392##15	a_154_392##7	1.34376e-19
C361	X#6	B1#3	3.64231e-18
C362	VGND#3	a_154_392##9	2.802e-18
C363	VPWR#2	A2#4	1.10565e-18
C364	VPWR#9	a_154_392##2	5.62649e-20
C365	VGND#11	VGND#2	2.39738e-18
C366	a_334_392##2	a_334_392#	1.98157e-18
C367	VGND#3	a_154_392##11	5.11893e-18
C368	a_69_392#	B1#3	1.46413e-19
C369	a_888_105#	A2#5	2.28548e-17
C370	a_154_392##13	A2#2	5.79135e-19
C371	VGND#3	a_154_392##6	3.5743e-19
C372	a_334_392##5	B1#3	1.36908e-18
C373	B1#5	a_154_392##12	5.14335e-18
C374	X#6	C1#3	2.44146e-19
C375	a_1081_39##2	A2#7	1.20515e-17
C376	a_69_392##2	B1#3	3.00413e-19
C377	VPWR	a_154_392##5	3.17746e-21
C378	VGND#3	B1#1	1.59807e-19
C379	VPWR#5	A3#3	1.93327e-20
C380	a_154_392##17	B1#3	1.50352e-18
C381	a_334_392##2	VPWR#4	7.55789e-17
C382	a_154_392##15	a_154_392##9	2.26037e-19
C383	a_154_392##5	a_154_392##2	8.95034e-19
C384	VGND#8	a_154_392##18	5.00816e-18
C385	a_154_392##16	B1	8.88236e-18
C386	B1#4	B1#5	4.30135e-17
C387	a_888_105#	A2#7	3.0288e-17
C388	a_154_392##4	A1#6	2.23358e-19
C389	a_154_392##13	A1#3	1.02431e-17
C390	a_69_392##2	C1#3	2.5367e-19
C391	a_154_392##15	B1	4.96989e-17
C392	X#5	A3#3	5.42217e-20
C393	a_154_392##17	C1#3	1.27119e-17
C394	a_154_392##13	A2#5	7.08247e-19
C395	a_1081_39##2	A1#1	5.4365e-19
C396	VPWR#6	VPWR#4	2.54316e-18
C397	a_69_392##4	C1#3	4.24599e-19
C398	a_154_392##4	A3#5	9.8158e-18
C399	a_1081_39#	A2#7	3.29519e-17
C400	C1#4	B1#4	4.19321e-17
C401	a_154_392##15	a_154_392##11	3.34698e-19
C402	VGND#7	a_154_392##18	6.67079e-18
C403	VPWR#7	a_154_392##2	1.23783e-20
C404	a_888_105#	A1#1	2.31067e-17
C405	a_154_392##13	A3#4	2.50232e-18
C406	C1	a_154_392##16	2.2381e-17
C407	a_334_392##2	VPWR#6	3.94361e-17
C408	a_154_392##13	A2#7	8.37992e-19
C409	a_154_392##4	a_154_392##6	2.88556e-18
C410	VPWR#11	a_154_392##5	1.62315e-19
C411	a_1081_39##2	A1#6	3.72628e-19
C412	C1#6	C1#4	4.18214e-17
C413	a_1081_39#	A1#1	2.61819e-17
C414	a_154_392##13	a_334_392##4	6.21116e-17
C415	a_154_392##15	a_154_392##6	1.55238e-17
C416	a_888_105#	A1#6	9.04825e-18
C417	a_154_392##13	A3#3	8.09512e-18
C418	VPWR#11	a_154_392##10	4.69507e-18
C419	VGND#13	VGND#7	3.76182e-18
C420	A1#1	a_154_392##13	1.33428e-17
C421	a_1081_39##4	A1#3	1.34507e-19
C422	a_154_392##16	B1#1	1.31532e-19
C423	X#5	a_154_392##2	4.08298e-18
C424	VGND#8	a_154_392##19	4.9814e-18
C425	a_1081_39#	A1#6	7.00226e-19
C426	C1#3	B1#6	6.60109e-19
C427	a_1081_39##4	A1#1	1.11598e-17
C428	a_154_392##13	a_154_392##5	4.04914e-20
C429	a_154_392##15	B1#1	9.13054e-18
C430	VPWR#10	a_154_392##5	2.08611e-19
C431	a_888_105##2	A2#7	1.84777e-19
C432	a_154_392##13	A1#6	3.71196e-17
C433	a_154_392##4	A1#4	1.76992e-20
C434	a_1081_39##2	A2	2.8414e-17
C435	VPWR#8	VPWR#6	1.99407e-18
C436	a_154_392##4	A3#1	7.121e-20
C437	a_154_392##16	B1#6	3.42501e-19
C438	X#5	a_334_392##2	1.40131e-18
C439	VGND	A3#4	7.18262e-19
C440	a_154_392##4	A3#6	4.43665e-18
C441	A1#6	a_1081_39##4	3.11315e-17
C442	VGND#14	C1	3.00432e-18
C443	a_154_392##4	a_154_392#	1.67208e-17
C444	a_154_392##15	B1#6	7.51387e-18
C445	a_888_105##2	A1#1	2.35466e-19
C446	a_1081_39##4	A3#3	3.72056e-19
C447	a_154_392##13	A3#7	1.51665e-18
C448	a_154_392##4	a_154_392##8	1.38359e-19
C449	a_1081_39##2	A1	1.77345e-17
C450	B1	X#6	3.41723e-17
C451	a_888_105#	A1	3.7344e-18
C452	a_154_392##4	a_154_392##10	7.68353e-20
C453	VGND#6	A1#6	1.83985e-18
C454	a_1081_39#	A1	4.70223e-17
C455	a_154_392##13	A1	5.86251e-17
C456	VPWR#10	a_154_392##2	2.58065e-19
C457	a_154_392##4	a_154_392##12	5.227e-20
C458	a_154_392##16	C1#1	7.29877e-18
C459	B1	a_334_392##5	2.45016e-18
C460	VGND#4	A1#1	1.79337e-19
C461	a_1081_39##4	A3#7	3.83447e-18
C462	a_154_392##13	a_154_392##2	9.112e-19
C463	A2	VPWR#1	3.15726e-17
C464	VPWR	VPWR#9	4.38905e-17
C465	a_154_392##17	B1	6.84674e-18
C466	VPWR	VPWR#7	6.12966e-17
C467	a_888_105##2	A1#6	1.0795e-17
C468	VPWR	VPWR#5	6.71848e-17
C469	VPWR	VPWR#3	4.08269e-17
C470	a_154_392##13	A3#5	7.48044e-20
C471	X#4	VGND#3	4.88524e-19
C472	a_154_392##15	C1#1	4.08267e-21
C473	X#6	a_154_392##5	1.2792e-17
C474	VGND#6	A3#4	2.53092e-18
C475	VGND#6	A3#7	4.28199e-17
C476	VPWR	a_334_392##4	3.21451e-17
C477	A3	a_154_392##13	1.46702e-17
C478	VGND#1	A1#2	3.75652e-20
C479	C1	a_154_392##17	2.05577e-17
C480	VPWR	a_154_392##15	4.00597e-18
C481	VGND#3	a_154_392##5	1.09452e-19
C482	VGND#4	A1#6	2.9562e-19
C483	A2#3	VNB	2.64713e-17
C484	VGND#6	A3	1.57414e-17
C485	A2#2	VNB	7.92708e-17
C486	C1	a_69_392##4	7.9275e-19
C487	a_1081_39##4	A3#5	3.69823e-19
C488	A1#3	VNB	2.8825e-17
C489	A3#4	VNB	1.79934e-17
C490	a_154_392##16	C1#5	4.17508e-18
C491	A1	a_334_392#	5.29244e-17
C492	A3#3	VNB	6.06764e-17
C493	a_154_392##5	VNB	6.65353e-17
C494	VPWR	A3#10	1.43962e-18
C495	VPWR#3	A2#4	1.83284e-18
C496	A1	VPWR#4	4.74225e-19
C497	a_154_392##2	VNB	3.31394e-17
C498	B1#2	VNB	2.54155e-17
C499	A1	a_334_392##2	5.26996e-17
C500	a_888_105##2	A3#7	3.50146e-17
C501	a_154_392##13	a_154_392##7	1.72735e-19
C502	VGND#3	a_154_392##2	1.60563e-20
C503	B1	a_154_392##6	1.92923e-18
C504	a_154_392##15	C1#5	2.88813e-21
C505	VGND#6	A3#3	4.49965e-18
C506	VGND#6	A3#5	2.32666e-17
C507	X#4	a_154_392##4	3.02903e-18
C508	VPWR	a_154_392##13	5.83198e-18
C509	VPWR#10	VPWR#8	1.03307e-17
C510	VPWR#5	A1#5	4.20114e-19
C511	VGND#4	A3#7	1.02769e-18
C512	a_1081_39##4	a_154_392##7	1.44484e-18
C513	X#6	a_154_392##2	2.36549e-19
C514	a_888_105##2	A3#5	2.36944e-17
C515	VPWR#3	A1#5	1.83284e-18
C516	a_154_392##13	a_154_392##9	1.41107e-19
C517	VGND	VGND#8	5.15333e-17
C518	VGND	VGND#7	6.38478e-17
C519	VGND	VGND#2	1.26598e-16
C520	VGND#6	a_154_392##7	7.89979e-18
C521	X#5	VPWR#10	2.41481e-19
C522	VPWR	a_334_392#	6.06349e-19
C523	VPWR#13	a_154_392##5	6.46696e-19
C524	X#6	B1#2	2.26058e-18
C525	VPWR	VPWR#4	2.43093e-17
C526	A3#5	VGND#4	1.26579e-17
C527	a_888_105##2	A3#4	4.40817e-19
C528	VPWR	a_334_392##2	1.58942e-17
C529	A3#10	a_154_392##13	4.25386e-17
C530	VPWR	VPWR#8	1.6053e-17
C531	VPWR#5	A1#4	4.99443e-18
C532	VGND	a_154_392##16	2.76291e-19
C533	VPWR	X#5	3.66956e-18
C534	a_888_105##2	a_154_392##7	1.82162e-18
C535	VGND	a_154_392##15	9.16592e-19
C536	VPWR	VPWR#10	1.61687e-17
C537	A2#4	A2#2	8.46833e-19
C538	VPWR	X#6	1.68282e-17
C539	VGND	A3#10	2.26878e-18
C540	VPWR	VPWR#13	1.62697e-17
C541	VPWR	a_69_392#	2.01222e-17
C542	VPWR	a_334_392##5	1.78756e-17
C543	VGND#6	a_154_392##9	5.60402e-19
C544	VPWR	a_69_392##2	2.75323e-17
C545	VPWR	a_154_392##17	4.229e-18
C546	VGND	a_1081_39##2	4.30311e-19
C547	VGND	a_888_105#	1.02317e-17
C548	VPWR	a_69_392##4	1.66931e-17
C549	VGND	a_1081_39#	3.07343e-18
C550	VGND#8	VNB	2.69473e-17
C551	VGND#4	a_154_392##7	2.59483e-17
C552	VGND	a_154_392##13	7.81244e-18
C553	VGND#7	VNB	2.89935e-17
C554	a_888_105##2	A3#3	4.87645e-18
C555	VGND	a_1081_39##4	3.8508e-17
C556	VGND#2	VNB	6.2502e-17
C557	VGND	VGND#6	9.42389e-18
C558	C1#3	B1#3	4.14896e-17
C559	VGND	a_888_105##2	3.06005e-17
C560	VPWR#9	VNB	2.20998e-17
C561	VPWR#7	VNB	3.1443e-17
C562	VGND	X#1	1.43202e-17
C563	VPWR#5	VNB	2.7155e-17
C564	VPWR#3	VNB	2.60745e-17
C565	VGND	X#2	1.79369e-17
C566	A1#2	A2#3	3.43672e-17
C567	X#6	VPWR#10	2.55475e-19
C568	VGND	a_154_392##18	1.05923e-17
C569	a_334_392##4	VNB	2.08637e-18
C570	VGND	VGND#13	1.21537e-17
C571	VGND	a_154_392##19	1.08316e-17
C572	a_154_392##16	VNB	2.85741e-18
C573	VGND	VGND#14	7.16784e-18
C574	a_154_392##15	VNB	5.51477e-18
C575	VPWR#5	A3#1	5.30182e-18
C576	a_154_392##7	X#1	1.23068e-17
C577	X#4	B1	5.14085e-18
C578	A3#10	VNB	4.57153e-18
C579	VGND#6	a_154_392##2	5.69119e-19
C580	A1#3	A1#2	4.45118e-18
C581	a_1081_39##2	VNB	6.37411e-17
C582	VGND#2	a_154_392#	3.76599e-20
C583	a_888_105#	VNB	1.31097e-18
C584	a_334_392##4	A1#5	2.89738e-19
C585	VGND#4	a_154_392##9	9.17008e-19
C586	a_1081_39#	VNB	1.01375e-18
C587	A3	a_154_392#	2.92565e-18
C588	a_154_392##13	VNB	5.24355e-18
C589	a_1081_39##4	VNB	2.33031e-17
C590	VPWR#2	A2	1.47758e-18
C591	VGND#6	VNB	4.86805e-18
C592	VPWR	A2#4	3.36449e-21
C593	VPWR#13	VPWR#10	1.03307e-17
C594	a_888_105##2	VNB	7.71278e-18
C595	VGND#4	VNB	2.20973e-19
C596	VPWR	A1#5	1.18069e-18
C597	VGND#1	A2	4.71584e-18
C598	X#1	VNB	2.31879e-18
C599	VGND#11	a_154_392##7	7.24671e-19
C600	VGND#11	VNB	3.23793e-18
C601	VPWR	A1#4	9.42711e-19
C602	X#2	VNB	1.93467e-18
C603	VGND#12	VNB	3.50399e-20
C604	VPWR	A3#1	5.77007e-19
C605	a_154_392##18	VNB	4.70436e-18
C606	VGND#13	VNB	7.36278e-19
C607	VPWR	A3#6	2.766e-19
C608	A1	VPWR#2	3.7737e-18
C609	a_154_392##19	VNB	4.94541e-18
C610	VGND#6	A3#10	7.08364e-18
C611	VPWR#7	A3#6	2.97919e-18
C612	VGND#14	VNB	1.77221e-17
C613	VPWR	a_154_392#	3.96397e-19
C614	VPWR#1	VNB	4.7617e-17
C615	VGND#1	A1	2.65762e-18
C616	a_334_392#	VNB	5.15082e-18
C617	VPWR	a_154_392##8	3.62971e-19
C618	VGND	A3#7	1.22936e-17
C619	VPWR#4	VNB	4.56114e-19
C620	X#1	a_154_392##9	4.77015e-17
C621	a_334_392##2	VNB	5.29535e-18
C622	VGND	A3#5	9.90158e-18
C623	VPWR	a_154_392##10	7.80442e-19
C624	VPWR#6	VNB	3.91088e-19
C625	VGND	a_154_392##7	4.99759e-18
C626	VPWR	a_154_392##12	3.33281e-19
C627	B1	B1#3	1.99377e-17
C628	VGND	a_154_392##9	9.81067e-18
C629	VPWR#8	VNB	8.50866e-19
C630	X#5	VNB	2.32773e-19
C631	VGND	a_154_392##11	9.88862e-18
C632	VPWR	B1#5	1.96451e-18
C633	VGND	a_154_392##6	7.014e-18
C634	X#6	VNB	4.64404e-18
C635	VPWR	B1#4	1.52942e-18
C636	B1	C1#3	6.68372e-18
C637	VGND	B1#1	4.38636e-18
C638	VPWR#13	VNB	3.74035e-18
C639	a_69_392#	VNB	8.04424e-18
C640	VGND	B1#6	4.53844e-18
C641	VPWR	C1#4	4.40211e-19
C642	VPWR#5	A3#6	3.19964e-19
C643	X#6	VPWR#13	1.6721e-18
C644	a_334_392##5	VNB	3.97004e-18
C645	VGND	C1#1	4.35772e-18
C646	a_69_392##2	VNB	4.46789e-18
C647	VPWR	C1#6	1.63749e-18
C648	VGND#4	a_154_392##11	3.4378e-20
C649	VGND	C1#5	4.53844e-18
C650	a_154_392##17	VNB	2.83371e-19
C651	a_69_392##4	VNB	2.27896e-17
C652	C1	C1#3	2.94265e-17
C653	A2#5	VNB	2.86688e-17
C654	A1	A1#2	2.24645e-17
C655	A2#7	VNB	2.92044e-17
C656	A1#1	VNB	2.97562e-17
C657	A1#6	VNB	3.36324e-17
C658	A3#7	VNB	3.09968e-17
C659	a_334_392##4	A1#4	2.03513e-18
C660	a_154_392##9	VGND#11	2.02556e-17
C661	A3#5	VNB	3.92696e-17
C662	a_154_392##7	VNB	3.01351e-17
C663	a_154_392##9	VNB	3.06861e-17
C664	VPWR	VPWR#11	2.33774e-17
C665	a_154_392##11	VNB	3.25382e-17
C666	a_154_392##6	VNB	5.48959e-17
C667	B1#1	VNB	3.14295e-17
C668	B1#6	VNB	3.06399e-17
C669	C1#1	VNB	2.80882e-17
C670	a_154_392##4	A3	2.0969e-17
C671	C1#5	VNB	4.34816e-17
C672	VPWR#9	VPWR#7	1.55834e-18
C673	X#1	a_154_392##11	1.18594e-18
C674	A2#1	VNB	2.91745e-17
C675	a_888_105##2	A3#10	3.77095e-18
C676	A2#4	VNB	2.76005e-17
C677	A1#5	VNB	2.72594e-17
C678	X#6	a_69_392#	2.41155e-18
C679	A1#4	VNB	2.7138e-17
C680	a_334_392##5	VPWR#10	3.07643e-20
C681	A3#1	VNB	2.96448e-17
C682	VPWR	a_154_392##4	1.28212e-17
C683	VPWR#7	a_154_392#	4.03587e-18
C684	A3#6	VNB	2.96634e-17
C685	a_154_392#	VNB	4.36113e-17
C686	X#2	a_154_392##9	1.30568e-18
C687	VGND	VGND#1	5.78231e-17
C688	a_154_392##8	VNB	2.85719e-17
C689	a_154_392##10	VNB	2.95507e-17
C690	VGND	X#4	5.46778e-17
C691	a_154_392##12	VNB	2.90531e-17
C692	B1#5	VNB	3.46951e-17
C693	B1#4	VNB	3.04237e-17
C694	a_334_392##4	A3#4	2.37275e-19
C695	C1#4	VNB	2.875e-17
C696	VGND	VGND#3	7.15659e-17
C697	C1#6	VNB	4.48885e-17
C698	VPWR#2	VNB	1.14704e-16
C699	VGND#1	VNB	1.66543e-16
C700	a_154_392##11	VGND#11	2.10204e-17
C701	X#4	VNB	1.4978e-19
C702	VPWR#5	a_154_392#	9.35168e-20
C703	VGND	a_154_392##4	1.2355e-17
C704	VPWR#11	VNB	1.26108e-17
C705	VGND#3	VNB	3.27254e-17
C706	VGND	C1#3	2.21369e-20
C707	A1	A2	2.97214e-17
C708	A1#2	VNB	3.80192e-17
C709	VPWR	B1	2.54541e-18
C710	a_334_392##4	A3#1	3.57086e-17
C711	a_69_392#	VPWR#13	3.66602e-17
C712	a_154_392##4	VNB	5.13229e-18
C713	VPWR	C1	3.98352e-18
C714	X#6	a_334_392##5	1.66556e-16
C715	B1#3	VNB	3.44118e-17
C716	C1#3	VNB	6.84746e-17
C717	a_334_392##5	a_154_392##5	1.34776e-18
C718	VPWR	A1	3.2328e-18
C719	VPWR#9	a_154_392##8	3.94497e-18
C720	VPWR	A3	8.67004e-19
C721	VGND	C1	1.4219e-18
C722	B1	VNB	1.54497e-18
C723	VGND	A1	4.72867e-18
C724	X#2	a_154_392##11	5.62928e-17
C725	C1	VNB	5.7965e-18
C726	VGND	A3	1.23712e-18
C727	A2	VNB	1.95039e-17
C728	A1	VNB	8.00509e-18
C729	A3	VNB	3.05907e-18
C730	VPWR	VNB	2.9371e-16
C731	VGND	VNB	2.99405e-16
C732	VGND#11	a_154_392##6	4.02883e-19
C733	VPWR#12	B1#3	3.35198e-20
C734	VPWR#12	VPWR#9	1.56089e-18
C735	VGND#9	X	1.02735e-17
C736	X	a_69_392##4	4.96664e-17
C737	VPWR#12	VNB	1.08362e-16
C738	VGND#9	C1	3.6336e-19
C739	X	C1#6	2.61851e-17
C740	X	C1#5	1.09156e-17
C741	X	a_154_392##17	4.01542e-17
C742	a_69_392##4	VPWR#12	2.98733e-17
C743	X	VGND#14	1.49213e-17
C744	X	VPWR#12	4.0515e-18
C745	VPWR	VPWR#12	1.86189e-16
C746	X	C1#4	1.00809e-18
C747	X	C1	4.82041e-17
C748	X	C1#1	4.75331e-18
C749	a_69_392##2	VPWR#12	6.03308e-17
C750	X	a_69_392##2	1.40752e-17
C751	X	VNB	1.05422e-16
C752	X	a_154_392##19	2.15078e-17
C753	a_334_392##5	VPWR#12	2.19047e-18
C754	X	C1#3	1.7938e-17
C755	X	B1#4	1.13073e-19
C756	a_69_392#	VPWR#12	4.54743e-17
C757	VGND#9	VGND#8	1.57254e-18
C758	VGND	X	6.54429e-17
C759	X	VGND#13	1.14043e-17
C760	VGND#9	VNB	4.31965e-17
C761	VGND#9	a_154_392##19	4.57735e-18
C762	VPWR#12	C1#6	5.31936e-18
C763	VPWR#12	a_154_392##6	1.65135e-19
C764	VPWR#12	C1#4	3.84775e-18
C765	X	a_154_392##16	3.40953e-17
C766	VPWR#12	B1#4	4.43306e-18
C767	VPWR	X	1.38471e-17
C768	VPWR#12	B1#5	4.43306e-18
C769	VGND	VGND#9	6.87762e-17
C770	VGND#9	VGND#13	1.92555e-19
C771	VGND#9	C1#3	3.1827e-20
C772	VPWR#12	a_154_392##12	3.98304e-18
C773	X	X#6	3.8559e-18
C774	X	VGND#8	6.41203e-19
C775	VGND#9	C1#5	4.88019e-18
C776	VPWR#12	C1#3	8.34741e-20
*
*
.ENDS sky130_fd_sc_hs__a311o_4
*
