* Extracted by Quantus, converted by sky130cad/quantus.py
*
*
*
*                       LINUX           Wed Nov 18 09:12:19 2026
*
*
*
*  PROGRAM  advgen
*
*  Name           : advgen - Quantus - (64-bit)
*  Version        : 25.1.0-p047
*  Build Date     : Thu Dec 11 23:20:30 PST 2025
*
*  HSPICE LIBRARY
*
*  OPERATING_TEMPERATURE 150
*  QRC_TECH_DIR <path>/tech
*
*
*

*
.SUBCKT sky130_fd_sc_hs__sedfxbp_1 VNB VPB VGND VPWR Q Q_N D SCD CLK DE SCE
*
*
*  caps2d version: 10
*
*
*       TRANSISTOR CARDS
*
*
XM8 a_27_90##6 D#1 a_157_90# VNB sky130_fd_pr__nfet_01v8_lvt l=0.15 w=0.42 ad=0.21 as=0.1008 pd=1.84 ps=1.32
XM6 a_157_90# DE#6 VGND#22 VNB sky130_fd_pr__nfet_01v8_lvt l=0.15 w=0.42 ad=0.1008 as=0.1197 pd=1.32 ps=1.41
XM42 a_161_394##9 DE#7 VGND#21 VNB sky130_fd_pr__nfet_01v8_lvt l=0.15 w=0.42 ad=0.1197 as=0.147 pd=1.41 ps=1.54
XM9 VGND#21 a_161_394##3 a_533_113# VNB sky130_fd_pr__nfet_01v8_lvt l=0.15 w=0.42 ad=0.147 as=0.1008 pd=1.54 ps=1.32
XM11 a_533_113# a_575_305##3 a_27_90# VNB sky130_fd_pr__nfet_01v8_lvt l=0.15 w=0.42 ad=0.1008 as=0.1176 pd=1.32 ps=1.4
XM12 a_27_90# a_667_87##3 a_697_113##7 VNB sky130_fd_pr__nfet_01v8_lvt l=0.15 w=0.42 ad=0.1176 as=0.1491 pd=1.4 ps=1.55
XM20 a_667_87##10 SCE#2 VGND#20 VNB sky130_fd_pr__nfet_01v8_lvt l=0.15 w=0.42 ad=0.1197 as=0.1512 pd=1.41 ps=1.56
XM23 VGND#20 SCD#3 a_1075_125# VNB sky130_fd_pr__nfet_01v8_lvt l=0.15 w=0.42 ad=0.1512 as=0.1008 pd=1.56 ps=1.32
XM5 a_1075_125# SCE#1 a_697_113##9 VNB sky130_fd_pr__nfet_01v8_lvt l=0.15 w=0.42 ad=0.1008 as=0.1197 pd=1.32 ps=1.41
XM25 VGND#19 CLK#1 a_1348_368##13 VNB sky130_fd_pr__nfet_01v8_lvt l=0.15 w=0.74 ad=0.2109 as=0.2109 pd=2.05 ps=2.05
XM43 VGND#18 a_1348_368##9 a_1549_74##13 VNB sky130_fd_pr__nfet_01v8_lvt l=0.15 w=0.74 ad=0.2109 as=0.2109 pd=2.05 ps=2.05
XM30 a_697_113##8 a_1348_368# a_1747_118##6 VNB sky130_fd_pr__nfet_01v8_lvt l=0.15 w=0.42 ad=0.1197 as=0.2478 pd=1.41 ps=2.02
XM31 a_1747_118##6 a_1549_74##3 a_1895_118# VNB sky130_fd_pr__nfet_01v8_lvt l=0.15 w=0.42 ad=0.2478 as=0.1617 pd=2.02 ps=1.61
XM21 a_1895_118# a_1972_92##3 VGND#17 VNB sky130_fd_pr__nfet_01v8_lvt l=0.15 w=0.42 ad=0.1617 as=0.4123 pd=1.61 ps=2.62
XM28 VGND#17 a_1747_118# a_1972_92##8 VNB sky130_fd_pr__nfet_01v8_lvt l=0.15 w=0.64 ad=0.4123 as=0.192 pd=2.62 ps=1.88
XM40 VGND#9 a_1972_92##4 a_2391_74# VNB sky130_fd_pr__nfet_01v8_lvt l=0.15 w=0.64 ad=0.1824 as=0.1344 pd=1.85 ps=1.7
XM16 a_2391_74# a_1549_74##5 a_2463_74##10 VNB sky130_fd_pr__nfet_01v8_lvt l=0.15 w=0.64 ad=0.1344 as=0.2139 pd=1.7 ps=2
XM35 a_2463_74##10 a_1348_368##10 a_2565_74# VNB sky130_fd_pr__nfet_01v8_lvt l=0.15 w=0.42 ad=0.2139 as=0.1008 pd=2 ps=1.32
XM32 a_2565_74# a_575_305##4 VGND#8 VNB sky130_fd_pr__nfet_01v8_lvt l=0.15 w=0.42 ad=0.1008 as=0.4183 pd=1.32 ps=3.01
XM37 VGND#8 a_2463_74##7 a_575_305##15 VNB sky130_fd_pr__nfet_01v8_lvt l=0.15 w=0.64 ad=0.4183 as=0.1824 pd=3.01 ps=1.85
XM22 Q#3 a_2463_74##5 VGND#7 VNB sky130_fd_pr__nfet_01v8_lvt l=0.15 w=0.74 ad=0.2109 as=0.3922 pd=2.05 ps=2.54
XM41 VGND#7 a_575_305##7 Q_N#1 VNB sky130_fd_pr__nfet_01v8_lvt l=0.15 w=0.74 ad=0.3922 as=0.2109 pd=2.54 ps=2.05
XM33 a_27_90##4 D#3 a_116_464# VPB sky130_fd_pr__pfet_01v8 l=0.15 w=0.64 ad=0.1888 as=0.1536 pd=1.87 ps=1.76
XM3 a_116_464# a_161_394##2 VPWR#21 VPB sky130_fd_pr__pfet_01v8 l=0.15 w=0.64 ad=0.1536 as=0.1888 pd=1.76 ps=1.87
XM14 a_161_394##8 DE#4 VPWR#19 VPB sky130_fd_pr__pfet_01v8 l=0.15 w=0.64 ad=0.1888 as=0.3392 pd=1.87 ps=2.34
XM36 VPWR#19 DE#1 a_556_464# VPB sky130_fd_pr__pfet_01v8 l=0.15 w=0.64 ad=0.3392 as=0.1728 pd=2.34 ps=1.82
XM27 a_556_464# a_575_305# a_27_90##5 VPB sky130_fd_pr__pfet_01v8 l=0.15 w=0.64 ad=0.1728 as=0.192 pd=1.82 ps=1.88
XM4 a_27_90##5 SCE#5 a_697_113##5 VPB sky130_fd_pr__pfet_01v8 l=0.15 w=0.64 ad=0.192 as=0.1888 pd=1.88 ps=1.87
XM13 a_667_87##9 SCE#4 VPWR#16 VPB sky130_fd_pr__pfet_01v8 l=0.15 w=0.64 ad=0.2304 as=0.2976 pd=2 ps=2.21
XM34 VPWR#16 SCD#1 a_1068_462# VPB sky130_fd_pr__pfet_01v8 l=0.15 w=0.64 ad=0.2976 as=0.1536 pd=2.21 ps=1.76
XM1 a_1068_462# a_667_87##4 a_697_113##10 VPB sky130_fd_pr__pfet_01v8 l=0.15 w=0.64 ad=0.1536 as=0.1888 pd=1.76 ps=1.87
XM15 VPWR#14 CLK#3 a_1348_368##15 VPB sky130_fd_pr__pfet_01v8 l=0.15 w=1.12 ad=0.3304 as=0.3304 pd=2.83 ps=2.83
XM19 VPWR#12 a_1348_368##8 a_1549_74##17 VPB sky130_fd_pr__pfet_01v8 l=0.15 w=1.12 ad=0.3304 as=0.3304 pd=2.83 ps=2.83
XM38 a_697_113# a_1549_74# a_1747_118##7 VPB sky130_fd_pr__pfet_01v8 l=0.15 w=0.42 ad=0.1302 as=0.147 pd=1.46 ps=1.54
XM7 a_1747_118##7 a_1348_368##7 a_1931_508# VPB sky130_fd_pr__pfet_01v8 l=0.15 w=0.42 ad=0.147 as=0.1176 pd=1.54 ps=1.4
XM17 a_1931_508# a_1972_92# VPWR#10 VPB sky130_fd_pr__pfet_01v8 l=0.15 w=0.42 ad=0.1176 as=0.29995 pd=1.4 ps=2.73
XM26 VPWR#10 a_1747_118##3 a_1972_92##11 VPB sky130_fd_pr__pfet_01v8 l=0.15 w=0.84 ad=0.29995 as=0.2478 pd=2.73 ps=2.27
XM2 VPWR#9 a_1972_92##7 a_2345_392# VPB sky130_fd_pr__pfet_01v8 l=0.15 w=1 ad=0.4032 as=0.825 pd=2.92 ps=3.65
XM18 a_2345_392# a_1348_368##12 a_2463_74##11 VPB sky130_fd_pr__pfet_01v8 l=0.15 w=1 ad=0.825 as=0.3328 pd=3.65 ps=2.77
XM39 a_2463_74##11 a_1549_74##8 a_2647_508# VPB sky130_fd_pr__pfet_01v8 l=0.15 w=0.42 ad=0.3328 as=0.1134 pd=2.77 ps=1.38
XM29 a_2647_508# a_575_305##6 VPWR#8 VPB sky130_fd_pr__pfet_01v8 l=0.15 w=0.42 ad=0.1134 as=0.3889 pd=1.38 ps=3.12
XM24 VPWR#8 a_2463_74##6 a_575_305##17 VPB sky130_fd_pr__pfet_01v8 l=0.15 w=1 ad=0.3889 as=0.295 pd=3.12 ps=2.59
XM0 Q#1 a_2463_74# VPWR#7 VPB sky130_fd_pr__pfet_01v8 l=0.15 w=1.12 ad=0.3304 as=0.392 pd=2.83 ps=2.94
XM10 VPWR#7 a_575_305##9 Q_N#2 VPB sky130_fd_pr__pfet_01v8 l=0.15 w=1.12 ad=0.392 as=0.3304 pd=2.94 ps=2.83
*
*
*       RESISTOR AND CAP/DIODE CARDS
*
Rg1	D#1	D#2	350.017548
Rg2	D#2	D#3	552.750061
Rg3	a_161_394#	a_161_394##2	496.484589
Rg4	a_161_394##3	a_161_394##4	462.880432
Rg5	DE#1	DE#2	578.386353
Rg6	DE#2	DE#3	265.838684
Rg7	DE#2	DE#4	255.111923
Rg8	DE#3	DE#5	204.397659
Rg9	DE#5	DE#6	619.543030
Rg10	DE#5	DE#7	283.833771
Rg11	a_575_305#	a_575_305##2	447.425812
Rg12	a_575_305##2	a_575_305##3	476.067657
Rg14	a_667_87#	a_667_87##3	512.574036
Rg15	SCD#1	SCD#2	584.373657
Rg16	SCD#2	SCD#3	242.884933
Rg17	SCE#1	SCE#2	1160.579468
Rg18	SCE#2	SCE#3	385.409058
Rg19	SCE#3	SCE#4	458.738556
Rg20	SCE#4	SCE#5	1045.978638
Rg21	a_667_87##4	a_667_87##5	310.236938
Rg22	CLK#1	CLK#2	307.937683
Rg23	CLK#2	CLK#3	492.059540
Rg24	a_1549_74#	a_1549_74##2	469.311584
Rg25	a_1549_74##3	a_1549_74##4	216.119781
Rg26	a_1348_368#	a_1348_368##2	477.805756
Rg27	a_1348_368##2	a_1348_368##3	318.023682
Rg28	a_1348_368##3	a_1348_368##4	184.670990
Rg29	a_1348_368##4	a_1348_368##5	300.272736
Rg30	a_1348_368##2	a_1348_368##6	515.664551
Rg31	a_1348_368##6	a_1348_368##7	289.032745
Rg32	a_1348_368##3	a_1348_368##8	371.735809
Rg33	a_1348_368##4	a_1348_368##9	509.462677
Rg34	a_1972_92#	a_1972_92##2	624.001587
Rg35	a_1972_92##2	a_1972_92##3	236.204941
Rg36	a_1747_118#	a_1747_118##2	521.088196
Rg37	a_1747_118##2	a_1747_118##3	364.523010
Rg38	a_1972_92##4	a_1972_92##5	357.843536
Rg39	a_1972_92##5	a_1972_92##6	37.804382
Rg40	a_1972_92##5	a_1972_92##7	507.442535
Rg41	a_1549_74##5	a_1549_74##6	476.416901
Rg42	a_1348_368##10	a_1348_368##11	558.129395
Rg43	a_1348_368##11	a_1348_368##12	414.956360
Rg44	a_1549_74##7	a_1549_74##8	664.172119
Rg45	a_575_305##4	a_575_305##5	1201.442505
Rg46	a_575_305##5	a_575_305##6	245.891434
Rg47	a_2463_74#	a_2463_74##2	599.960938
Rg48	a_2463_74##2	a_2463_74##3	428.788910
Rg49	a_2463_74##3	a_2463_74##4	13.202208
Rg50	a_2463_74##2	a_2463_74##5	264.238068
Rg51	a_2463_74##3	a_2463_74##6	365.750427
Rg52	a_2463_74##4	a_2463_74##7	359.610107
Rg53	a_575_305##7	a_575_305##8	366.265259
Rg54	a_575_305##8	a_575_305##9	456.142303
Rf1	D#4	D	0.926760
Rf2	D#2	D#6	81.043159
Rf3	D#4	D#6	3.440917
Rf4	D#7	D	0.926760
Rf5	D#6	D#7	9.290477
Rf6	DE#8	DE	0.635961
Rf7	DE#3	DE#10	160.868759
Rf8	DE#8	DE#10	9.448145
Rf9	a_161_394##4	a_161_394##6	218.065948
Rf10	a_161_394##6	a_161_394#	47.959217
Rf11	a_161_394##6	a_161_394##8	44.937363
Rf12	a_161_394#	a_161_394##9	91.277138
Rf13	a_575_305##2	a_575_305##11	161.097382
Rf14	a_575_305##12	a_575_305##13	0.864585
Rf15	a_575_305##11	a_575_305##12	13.581708
Rf16	a_27_90#	a_27_90##2	122.101036
Rf17	a_27_90##2	a_27_90##3	276.372101
Rf18	a_27_90##3	a_27_90##4	18.534916
Rf19	a_27_90##2	a_27_90##5	17.170738
Rf20	a_27_90##3	a_27_90##6	144.188766
Rf21	SCE#6	SCE	0.839094
Rf22	SCE#3	SCE#8	161.071899
Rf23	SCE#6	SCE#8	5.511418
Rf24	SCD	SCD#2	171.255646
Rf25	a_667_87##5	a_667_87##7	261.088715
Rf26	a_667_87##7	a_667_87##8	40.414715
Rf27	a_667_87##7	a_667_87##9	45.190701
Rf28	a_667_87##8	a_667_87##10	42.379066
Rf29	CLK#4	CLK#2	161.421814
Rf30	CLK	CLK#6	1.189013
Rf31	CLK#4	CLK#6	7.765626
Rf32	a_1348_368##13	a_1348_368##5	113.187393
Rf33	a_1348_368##5	a_1348_368##15	34.708458
Rf34	a_697_113#	a_697_113##2	97.229698
Rf35	a_697_113##2	a_697_113##3	126.495995
Rf36	a_697_113##3	a_697_113##4	16.895607
Rf37	a_697_113##4	a_697_113##6	196.271133
Rf38	a_697_113##6	a_697_113##7	140.058075
Rf39	a_697_113##2	a_697_113##8	138.833710
Rf40	a_697_113##3	a_697_113##9	123.980698
Rf41	a_697_113##4	a_697_113##10	13.425789
Rf42	a_697_113##5	a_697_113##6	7.500000
Rf43	a_1747_118##2	a_1747_118##5	255.355637
Rf44	a_1747_118##5	a_1747_118##6	79.705093
Rf45	a_1747_118##5	a_1747_118##7	79.709930
Rf46	a_1972_92##8	a_1972_92##9	54.029686
Rf47	a_1972_92##9	a_1972_92##2	228.288452
Rf48	a_1972_92##9	a_1972_92##11	81.408340
Rf49	a_1972_92##9	a_1972_92##6	97.022926
Rf50	a_1348_368##11	a_1348_368##6	606.192261
Rf51	a_1549_74##7	a_1549_74##10	234.371170
Rf52	a_1549_74##10	a_1549_74##11	254.674530
Rf53	a_1549_74##11	a_1549_74##12	91.389732
Rf54	a_1549_74##12	a_1549_74##13	85.538429
Rf55	a_1549_74##10	a_1549_74##6	178.634460
Rf56	a_1549_74##11	a_1549_74##4	180.362167
Rf57	a_1549_74##12	a_1549_74##2	123.889412
Rf58	a_1549_74##2	a_1549_74##17	33.731918
Rf59	a_2463_74##4	a_2463_74##9	170.291138
Rf60	a_2463_74##9	a_2463_74##10	137.641052
Rf61	a_2463_74##9	a_2463_74##11	154.625443
Rf62	Q	Q#2	0.165782
Rf63	Q#2	Q	12.102091
Rf64	Q	Q#3	95.646973
Rf65	Q#1	Q#2	5.000000
Rf66	a_575_305##8	a_575_305##16	318.837219
Rf67	a_575_305##16	a_575_305##18	123.800491
Rf68	a_575_305##18	a_575_305##19	10.256538
Rf69	a_575_305##19	a_575_305##5	181.235657
Rf70	a_575_305##15	a_575_305##16	7.500000
Rf71	a_575_305##17	a_575_305##18	5.000000
Rf72	Q_N#1	Q_N	85.290947
Rf73	Q_N	Q_N#3	12.719545
Rf74	Q_N#3	Q_N	0.174240
Rf75	Q_N#2	Q_N#3	5.000000
Rf77	VGND#2	VGND#3	53.424908
Rf78	VGND#3	VGND#4	92.811768
Rf79	VGND#4	VGND#5	139.596909
Rf80	VGND#5	VGND#6	121.004440
Rf81	VGND#2	VGND#7	57.891499
Rf82	VGND#4	VGND#8	14.322456
Rf83	VGND#5	VGND#9	37.027283
Rf84	VGND#6	VGND#10	191.733017
Rf85	VGND#10	VGND#11	72.393501
Rf86	VGND#11	VGND#12	101.613701
Rf87	VGND#12	VGND#13	125.257065
Rf88	VGND#13	VGND#14	71.930206
Rf89	VGND#14	VGND#15	77.384460
Rf91	VGND#6	VGND#17	35.748142
Rf92	VGND#10	VGND#18	33.326477
Rf93	VGND#11	VGND#19	59.547459
Rf94	VGND#12	VGND#20	43.365131
Rf95	VGND#14	VGND#21	42.184113
Rf96	VGND#15	VGND#22	37.656876
Rf98	VPWR#2	VPWR#3	50.072407
Rf99	VPWR#3	VPWR#4	69.001129
Rf100	VPWR#4	VPWR#5	189.509918
Rf101	VPWR#5	VPWR#6	94.429756
Rf102	VPWR#2	VPWR#7	48.259808
Rf103	VPWR#4	VPWR#8	24.688660
Rf104	VPWR#5	VPWR#9	28.799242
Rf105	VPWR#6	VPWR#10	35.446526
Rf106	VPWR#6	VPWR#11	164.339081
Rf107	VPWR#11	VPWR#12	31.948624
Rf108	VPWR#11	VPWR#13	101.491127
Rf109	VPWR#13	VPWR#14	31.948624
Rf110	VPWR#13	VPWR#15	99.356956
Rf111	VPWR#15	VPWR#16	37.794724
Rf112	VPWR#15	VPWR#17	125.679665
Rf113	VPWR#17	VPWR#18	61.395233
Rf114	VPWR#18	VPWR#19	37.027283
Rf115	VPWR#18	VPWR#20	105.258347
Rf116	VPWR#20	VPWR#21	37.538910
Rf126	a_667_87#	a_667_87##8	32.046562
Re1	a_575_305##19	a_575_305##13	38.295979
Re2	VPWR#3	VPWR#24	3.473447
Re3	VPWR#24	VPWR	0.737527
Re4	VPWR	VPWR#17	2.542229
Re5	VGND#3	VGND#24	3.473447
Re6	VGND#24	VGND	0.737527
Re7	VGND	VGND#13	2.542229
Re11	VPWR#6	VPWR#24	0.698413
Re14	VGND#6	VGND#24	0.698413
*
*       CAPACITOR CARDS
*
*
C1	a_1747_118##7	VPWR#6	2.23912e-17
C2	DE#4	VPWR#19	2.28938e-17
C3	VPWR#12	a_697_113#	2.59494e-17
C4	VPWR#17	DE#2	1.15076e-20
C5	VPWR#17	D#3	1.51778e-18
C6	a_575_305##8	VPWR#7	4.40718e-17
C7	VPWR#4	a_575_305##6	2.44481e-17
C8	VPWR#7	a_2463_74##6	5.56026e-19
C9	a_1348_368##6	a_1972_92##7	3.39613e-19
C10	a_575_305##13	a_697_113##4	7.75069e-17
C11	a_2463_74##9	a_575_305##15	1.68893e-17
C12	a_697_113#	VPWR#6	4.17119e-18
C13	a_697_113##4	VPWR#16	3.80443e-17
C14	a_1348_368#	a_1747_118##6	1.56949e-17
C15	DE#4	a_161_394##8	8.91621e-18
C16	a_1348_368##6	a_1747_118##3	3.46365e-17
C17	a_2463_74##7	a_2463_74##5	4.28127e-18
C18	a_2463_74##9	a_575_305##5	6.19598e-17
C19	VGND#5	a_1549_74##5	5.60385e-18
C20	a_667_87##7	SCE#3	4.39088e-17
C21	VGND#17	a_1972_92##2	1.01249e-18
C22	a_1348_368##13	VGND#18	5.56265e-17
C23	Q_N#2	a_2463_74##4	1.38343e-19
C24	VPWR#5	a_1747_118##2	4.45024e-20
C25	a_1348_368##6	a_1972_92#	5.32604e-17
C26	a_697_113##8	a_1549_74##17	3.25522e-17
C27	VPWR#21	DE#4	4.8684e-19
C28	a_1747_118##6	a_1747_118##5	1.8285e-18
C29	a_575_305##8	a_2463_74##2	4.60841e-17
C30	VGND#11	VGND#10	1.02497e-18
C31	a_575_305##13	a_697_113##2	5.69608e-17
C32	VGND#5	a_1549_74##6	1.3205e-19
C33	a_27_90#	DE#5	9.07479e-20
C34	Q_N#1	Q_N#2	3.83176e-18
C35	a_1348_368#	a_697_113##8	1.8156e-17
C36	a_1348_368##6	a_1348_368##7	3.87546e-18
C37	a_161_394##8	a_161_394##2	4.30037e-19
C38	VGND#4	a_1549_74##5	1.42337e-18
C39	VGND#10	a_1549_74##12	3.20475e-17
C40	a_2463_74##6	a_575_305##17	1.44157e-17
C41	VGND#13	DE#5	1.61633e-18
C42	VPWR#17	a_697_113##4	3.01582e-17
C43	VGND#19	VGND#18	2.31557e-19
C44	VPWR#21	a_161_394##2	3.44077e-17
C45	VPWR#4	a_1549_74##8	9.61059e-18
C46	a_667_87##9	a_697_113##4	2.33787e-17
C47	a_1348_368##8	a_1348_368##6	5.3354e-19
C48	a_1549_74##13	a_1348_368#	1.96577e-18
C49	VGND#13	DE#2	4.59463e-19
C50	a_2463_74##6	VPWR#8	1.98384e-17
C51	SCE#6	SCE#3	5.49667e-18
C52	a_667_87##10	SCE#6	7.93094e-18
C53	a_2463_74##9	a_1549_74##7	6.87467e-17
C54	a_575_305##4	a_2463_74##7	1.4439e-17
C55	VGND#5	a_1972_92##4	6.91647e-18
C56	VPWR#3	a_575_305##8	6.46914e-18
C57	a_575_305##13	a_697_113#	1.65159e-18
C58	a_2463_74##11	a_2463_74#	2.41768e-19
C59	a_575_305##19	a_2463_74##4	5.03765e-17
C60	a_697_113##8	a_1348_368##9	3.38672e-18
C61	a_1549_74##2	a_1348_368##7	9.2828e-19
C62	a_1549_74##11	a_1549_74##10	3.113e-18
C63	a_1747_118##6	a_1348_368##6	1.32816e-18
C64	a_2463_74#	a_575_305##9	3.81465e-17
C65	VPWR#21	D#3	4.69187e-18
C66	VGND#18	a_1348_368#	2.87133e-19
C67	VGND#3	a_575_305##8	3.83794e-18
C68	VGND#5	a_1972_92##6	4.98341e-19
C69	a_575_305##13	a_1549_74##17	2.59939e-17
C70	VPWR#3	a_2463_74##4	1.10687e-18
C71	a_2463_74##9	a_2463_74##5	2.56332e-20
C72	a_575_305##19	a_575_305##5	2.3609e-17
C73	VGND#19	a_1348_368##13	5.22287e-17
C74	DE#10	DE#5	2.50345e-19
C75	VPWR#5	a_1348_368##12	2.70946e-18
C76	a_2463_74##11	VPWR#4	3.97143e-17
C77	VGND#4	a_1972_92##4	2.85648e-19
C78	a_575_305##6	VPWR#8	1.23391e-17
C79	a_1348_368##8	a_1549_74##2	1.27337e-17
C80	a_2463_74##4	a_2463_74##2	1.40934e-18
C81	a_1348_368##9	a_1549_74##13	3.02719e-17
C82	a_575_305##13	VPWR#17	9.73972e-17
C83	VGND#3	a_2463_74##4	6.79624e-18
C84	a_575_305##13	VPWR#12	5.89903e-18
C85	VPWR#3	a_575_305##5	4.03939e-18
C86	a_2463_74##11	a_2463_74##6	7.09346e-19
C87	a_575_305##19	a_1549_74##7	1.06293e-17
C88	a_575_305##5	VPWR#8	9.4845e-19
C89	VPWR#7	Q_N#2	9.85554e-17
C90	a_697_113##5	a_697_113##4	1.51105e-18
C91	a_697_113##2	a_1348_368##7	1.05919e-19
C92	a_1549_74##2	CLK#3	1.9184e-20
C93	D#4	DE#6	2.07809e-18
C94	a_1747_118##5	a_1348_368##8	7.31919e-20
C95	a_1348_368##13	a_1348_368#	8.87283e-19
C96	a_697_113##8	CLK#1	2.41548e-20
C97	VPWR#4	a_1348_368##12	4.8693e-18
C98	a_1348_368##5	a_1348_368##8	1.18868e-17
C99	a_575_305##13	a_1348_368##15	2.34774e-17
C100	D#3	a_27_90##4	6.89143e-18
C101	a_1747_118##6	a_1549_74##4	1.65313e-17
C102	VPWR#14	VPWR#12	5.61521e-18
C103	VPWR#3	a_1549_74##7	3.3144e-19
C104	a_575_305##13	a_667_87##7	5.25883e-17
C105	a_1348_368##11	a_2463_74##9	2.25425e-18
C106	a_1348_368##10	a_575_305##4	4.742e-17
C107	a_575_305##19	a_1348_368##11	6.94747e-17
C108	VGND#18	a_1348_368##9	3.93659e-17
C109	a_2463_74##6	a_2463_74#	5.6192e-18
C110	a_697_113##4	VPWR#15	5.13014e-18
C111	VGND#5	a_1747_118#	7.10979e-19
C112	VGND#10	a_1549_74##13	4.4247e-17
C113	a_575_305##19	VPWR#11	1.69469e-18
C114	CLK#3	a_1348_368##5	1.58848e-17
C115	DE#7	DE#3	5.87265e-18
C116	a_697_113##9	a_1348_368##13	1.45729e-18
C117	a_575_305##13	VPWR#14	1.09959e-17
C118	DE#10	a_161_394##6	2.56553e-17
C119	VGND#3	a_1549_74##7	6.61454e-19
C120	a_2463_74##11	a_575_305##5	2.66095e-17
C121	a_1348_368##6	VPWR#5	4.60455e-18
C122	a_1549_74##13	CLK#1	5.95931e-19
C123	a_697_113##4	SCE#1	1.14067e-19
C124	a_575_305##19	a_1549_74##6	2.77989e-17
C125	a_2463_74##11	a_575_305##6	6.372e-18
C126	a_667_87##7	SCE#6	2.49473e-17
C127	a_2463_74##9	a_2463_74##7	3.72607e-18
C128	a_575_305##19	VPWR#5	8.80914e-18
C129	VGND#11	VGND#18	1.06743e-18
C130	VPWR#17	a_1348_368##15	6.17074e-19
C131	a_2463_74##10	a_575_305##15	9.98599e-19
C132	a_1348_368##13	a_1348_368##9	1.16848e-17
C133	VPWR#5	a_1972_92##7	8.36531e-18
C134	a_575_305##19	a_1972_92##6	2.75226e-17
C135	a_697_113##2	a_1549_74#	1.82711e-18
C136	a_1549_74##2	a_1747_118##6	1.18233e-17
C137	a_575_305##19	VPWR#4	6.98691e-17
C138	DE#8	DE#5	2.77828e-18
C139	a_1549_74##10	a_1549_74##7	7.50354e-19
C140	a_161_394#	DE#6	3.08379e-17
C141	VGND#18	CLK#1	2.5096e-18
C142	VPWR#17	VPWR#14	2.61691e-18
C143	a_667_87##5	CLK#3	6.26571e-18
C144	a_575_305##6	a_2463_74##6	9.95273e-18
C145	VPWR#17	a_667_87##7	3.51037e-18
C146	a_697_113##4	a_1348_368##8	9.88609e-19
C147	a_2463_74##11	a_1549_74##7	2.08409e-17
C148	a_697_113##9	VGND#19	4.31667e-17
C149	a_697_113##8	a_1549_74##2	5.01961e-17
C150	a_575_305##19	a_1747_118##2	3.29639e-17
C151	a_2463_74##11	a_1549_74##8	4.43243e-17
C152	VGND#19	a_1348_368##9	4.06538e-20
C153	VPWR#4	a_1972_92##7	5.09424e-19
C154	a_1549_74##5	a_1348_368##10	2.75606e-17
C155	a_697_113##4	VPWR#13	1.98492e-17
C156	DE#8	a_161_394##6	2.05828e-17
C157	a_575_305##13	VPWR#16	2.1254e-18
C158	a_575_305##2	a_27_90##2	1.92788e-17
C159	VGND#13	a_1348_368##15	5.82075e-19
C160	VPWR#9	a_575_305##6	2.5339e-19
C161	D#2	DE#6	1.84384e-17
C162	SCD#2	CLK#3	5.71287e-19
C163	a_575_305##8	a_2463_74##4	4.85941e-19
C164	a_1348_368##13	CLK#1	5.1624e-17
C165	a_575_305##12	a_575_305##2	5.63114e-18
C166	a_667_87##5	SCD#1	4.59656e-17
C167	a_575_305##19	a_1972_92##2	7.42572e-18
C168	a_1348_368##9	a_1348_368##2	3.52325e-19
C169	a_575_305##13	a_667_87##9	2.98838e-18
C170	a_575_305##13	SCE#6	4.41756e-18
C171	a_2463_74##9	a_575_305##4	2.10069e-17
C172	a_697_113##9	a_1348_368##9	2.98968e-19
C173	VGND#18	SCE#1	9.38043e-20
C174	a_1348_368##11	a_2463_74##11	4.40645e-17
C175	VGND#11	a_1348_368##13	9.64681e-18
C176	VGND#21	DE#2	1.41513e-18
C177	SCE#3	CLK#3	3.27296e-19
C178	a_575_305##19	a_1348_368##6	5.82235e-17
C179	VGND#5	a_1549_74##10	3.88222e-17
C180	a_2463_74##11	a_1348_368##12	1.82143e-17
C181	a_697_113##2	a_1348_368##8	2.66871e-17
C182	a_575_305##13	a_697_113##5	3.7489e-17
C183	a_1348_368##5	a_697_113##8	3.19177e-18
C184	VPWR#6	a_1747_118##2	3.49234e-20
C185	a_697_113##8	a_1348_368##4	5.18337e-19
C186	a_1549_74##8	a_575_305##6	2.61785e-17
C187	CLK#1	VGND#19	1.40143e-17
C188	a_1549_74##10	a_1348_368##11	2.49043e-17
C189	a_575_305##5	a_2463_74##4	3.02026e-17
C190	VPWR#9	a_1549_74##8	7.05805e-19
C191	a_697_113##4	CLK#3	4.43979e-17
C192	VPWR#3	VPWR#4	9.4019e-17
C193	a_575_305##19	a_1549_74##4	4.85944e-18
C194	VGND#12	VGND#19	3.31594e-19
C195	VGND#6	a_1747_118##2	4.21763e-20
C196	VPWR#17	a_667_87##9	6.27884e-18
C197	a_161_394##4	a_27_90##2	3.97859e-17
C198	SCE#3	SCD#1	2.63826e-18
C199	a_575_305##13	a_27_90##2	3.99026e-17
C200	a_1348_368##13	SCE#1	6.93404e-19
C201	a_1972_92##4	a_1549_74##5	5.29814e-17
C202	a_1348_368##11	VPWR#9	2.34019e-17
C203	VGND#18	a_1348_368##5	1.35925e-18
C204	a_27_90#	a_27_90##2	1.6495e-18
C205	a_161_394##4	a_575_305##12	1.9823e-17
C206	a_161_394##9	DE#5	2.87427e-17
C207	a_697_113##4	a_697_113##2	1.56683e-18
C208	a_697_113##9	CLK#1	2.49049e-18
C209	a_575_305##19	a_1549_74##2	2.95924e-17
C210	a_697_113##5	VPWR#17	8.29304e-17
C211	a_697_113##4	SCE#2	1.06992e-19
C212	a_2463_74##11	a_1972_92##7	3.22237e-18
C213	VGND#10	a_1348_368##13	9.13007e-18
C214	a_575_305##13	a_575_305##12	2.70023e-17
C215	a_1348_368##6	VPWR#6	8.78837e-18
C216	a_1972_92##11	a_1348_368##11	4.20958e-18
C217	VPWR#11	a_1549_74##2	6.14188e-19
C218	a_1549_74##7	a_575_305##5	4.06535e-17
C219	a_1348_368##13	a_1348_368##5	7.16365e-18
C220	Q_N#1	a_2463_74##2	3.83262e-19
C221	VGND#3	a_575_305##7	9.35138e-18
C222	VGND#20	VGND#19	3.64288e-18
C223	VPWR#9	a_1348_368##12	2.69265e-18
C224	a_697_113##8	CLK#2	5.89879e-19
C225	a_697_113##8	a_1348_368##3	8.13196e-18
C226	a_575_305##4	a_2565_74#	8.30758e-18
C227	a_2463_74##9	a_1348_368##10	1.24314e-20
C228	VGND#19	SCE#1	2.77215e-18
C229	a_1348_368##12	a_1549_74##8	2.9925e-17
C230	VGND#6	a_1348_368##6	8.20169e-20
C231	a_697_113##2	CLK#3	1.4084e-18
C232	VGND#5	VGND#4	1.628e-20
C233	a_1348_368##10	a_2565_74#	8.30758e-18
C234	a_1348_368##11	a_575_305##5	1.25644e-19
C235	VPWR#17	a_27_90##3	4.47297e-17
C236	a_575_305##19	Q#3	7.83638e-18
C237	DE#10	a_575_305##2	2.58095e-19
C238	a_1747_118##5	a_1348_368##2	1.08186e-17
C239	a_27_90##3	DE#3	1.67109e-19
C240	VGND#3	a_2463_74##5	7.01271e-18
C241	VPWR#3	a_575_305##4	8.53196e-20
C242	a_697_113##9	a_1348_368##5	2.6e-18
C243	a_1549_74##10	a_1549_74##6	3.97145e-18
C244	a_697_113##4	a_667_87##4	3.79497e-17
C245	SCE#4	a_667_87##10	9.22562e-19
C246	a_27_90##2	a_533_113#	2.74467e-18
C247	VGND#6	a_1549_74##4	1.45188e-19
C248	a_1972_92##11	a_1348_368##12	8.98801e-19
C249	a_1549_74##7	a_1348_368##11	9.70829e-17
C250	a_27_90##2	DE#3	9.22441e-20
C251	VGND#10	a_1348_368#	1.19473e-18
C252	a_27_90##2	VPWR#17	6.39174e-17
C253	a_575_305##15	a_575_305##19	3.54623e-18
C254	VPWR#16	VPWR#14	1.52248e-18
C255	a_697_113##9	SCE#1	4.27167e-17
C256	a_697_113##8	a_697_113##2	4.15357e-19
C257	a_1348_368##4	a_1348_368##2	1.26994e-18
C258	VGND#3	a_2463_74##7	1.92705e-18
C259	VGND#12	a_697_113##9	1.98597e-18
C260	a_1549_74##13	a_1348_368##4	6.76046e-19
C261	a_1747_118#	a_1972_92##4	3.53497e-18
C262	a_575_305##12	DE#3	2.3341e-20
C263	a_1972_92##7	VPWR#9	3.55728e-17
C264	a_575_305##6	a_2647_508#	1.06762e-17
C265	CLK#2	a_1348_368##13	2.11913e-17
C266	a_1549_74##6	a_1549_74##7	1.70171e-18
C267	VGND#20	a_697_113##9	1.67564e-17
C268	a_667_87##3	SCE#5	1.66179e-18
C269	VGND#20	CLK#1	6.05226e-19
C270	VPWR#17	a_575_305##12	3.01896e-18
C271	a_697_113##8	a_1348_368##2	1.24821e-17
C272	VGND#13	SCE#6	1.47788e-18
C273	VGND#19	SCD#3	2.4104e-19
C274	a_575_305##19	VGND#8	2.6572e-19
C275	a_1549_74##8	a_2647_508#	1.06762e-17
C276	a_1972_92##7	a_1348_368##12	8.19403e-18
C277	a_697_113##2	VPWR#13	1.82577e-18
C278	VPWR#9	a_1972_92##6	8.71419e-19
C279	Q_N#1	a_575_305##7	3.50092e-17
C280	a_575_305##13	a_1549_74##2	8.63103e-18
C281	a_1549_74##6	a_1348_368##11	8.21718e-17
C282	VPWR#17	a_161_394##8	6.43973e-18
C283	a_667_87##7	a_667_87##9	1.21592e-17
C284	DE#10	a_161_394##4	2.39468e-17
C285	a_575_305##13	a_161_394##6	1.16615e-18
C286	VPWR#11	a_1348_368##5	1.66056e-18
C287	a_1972_92##11	a_1972_92##7	4.53497e-18
C288	VGND#22	DE#5	3.73567e-18
C289	VGND#11	a_1348_368##9	5.35187e-19
C290	a_697_113##9	CLK#2	3.16225e-17
C291	a_2463_74##9	a_1549_74##5	6.51561e-20
C292	a_697_113##2	a_667_87##4	9.98305e-20
C293	a_27_90##3	a_161_394#	6.38653e-17
C294	a_697_113#	a_1348_368##2	1.23508e-18
C295	VGND#3	Q_N#1	1.97574e-17
C296	a_161_394##4	a_575_305#	5.79312e-19
C297	a_1972_92##6	a_1348_368##11	4.8526e-18
C298	a_575_305##13	a_1348_368##5	3.97814e-17
C299	a_697_113##9	SCD#3	3.45e-18
C300	a_2463_74##2	VGND#7	4.60966e-19
C301	VPWR#9	a_1747_118##3	4.60602e-18
C302	a_2463_74##9	a_2463_74#	3.81952e-19
C303	VGND#11	a_697_113##9	9.46595e-18
C304	a_1549_74##5	a_2391_74#	1.01094e-17
C305	CLK	a_1348_368##4	1.17447e-18
C306	a_161_394##6	DE#3	3.35636e-18
C307	a_697_113##4	SCD#1	2.42827e-17
C308	a_1549_74##13	a_1348_368##3	5.8636e-18
C309	a_1549_74##10	a_1972_92##6	8.38984e-17
C310	a_1348_368##12	a_2345_392#	3.4112e-17
C311	a_161_394##4	DE#1	2.98955e-17
C312	VPWR#6	VPWR#5	2.92929e-19
C313	a_575_305##19	a_2463_74##10	5.72953e-18
C314	VPWR#10	a_1972_92##7	1.90438e-18
C315	a_575_305##7	VGND#7	1.73698e-17
C316	a_1972_92##4	a_2391_74#	1.25411e-17
C317	a_1972_92##6	a_1549_74##6	4.70865e-17
C318	a_1348_368##11	a_1747_118##2	1.76866e-19
C319	a_697_113##7	SCE#5	2.72241e-19
C320	a_575_305##19	VGND#4	5.49042e-18
C321	VGND#20	SCE#1	5.92794e-18
C322	a_1549_74##13	a_697_113##2	9.79755e-18
C323	a_575_305##13	CLK#2	7.52688e-18
C324	a_1972_92##7	a_2345_392#	1.95606e-17
C325	VGND#19	SCE#2	2.19929e-19
C326	VGND#10	a_1348_368##9	6.22133e-19
C327	DE#2	a_575_305##2	7.62631e-19
C328	a_1972_92##3	a_1747_118#	6.52778e-18
C329	a_1972_92##11	a_1747_118##3	3.85356e-17
C330	a_1747_118##3	a_1972_92##7	5.34206e-18
C331	VGND#12	CLK#1	4.76771e-19
C332	a_1549_74##6	a_1747_118##2	9.86155e-19
C333	VPWR#17	CLK#2	1.06939e-18
C334	a_2463_74##9	VPWR#4	1.0217e-18
C335	a_1747_118##2	a_1972_92##11	1.87704e-17
C336	a_575_305##13	a_667_87##5	4.81032e-17
C337	VGND#3	Q#3	7.40001e-18
C338	a_697_113##9	a_667_87##5	9.3172e-18
C339	a_697_113##2	VPWR#11	6.24265e-18
C340	a_1972_92##9	a_1972_92##11	1.03366e-18
C341	a_2463_74##2	a_575_305##7	4.65502e-18
C342	a_1972_92##9	a_1549_74##6	4.67956e-18
C343	DE#10	DE#3	1.34362e-17
C344	a_697_113##5	a_667_87##7	4.33081e-17
C345	a_1549_74##17	a_1348_368##3	4.00335e-18
C346	VPWR#17	a_161_394##6	1.22702e-18
C347	VPWR#9	a_1972_92#	2.17274e-18
C348	VGND#13	CLK#2	4.80305e-18
C349	a_1747_118##2	a_1972_92##6	2.06116e-17
C350	a_667_87##10	SCE#1	1.94591e-19
C351	VPWR#13	CLK#2	1.23366e-19
C352	a_697_113##9	SCE#2	9.59236e-20
C353	VPWR#17	a_667_87##5	4.53548e-18
C354	a_27_90##3	D#2	1.55768e-17
C355	a_1747_118##2	VPWR#10	3.15054e-19
C356	VGND#9	a_2463_74##10	1.3022e-17
C357	DE#8	DE#3	5.83246e-18
C358	a_575_305##19	VGND#9	2.92196e-18
C359	a_1747_118##3	VPWR#10	2.29184e-17
C360	a_1972_92#	a_1972_92##7	3.1678e-19
C361	a_575_305##13	SCD#2	5.98459e-18
C362	a_1549_74##13	a_1348_368##2	2.02967e-20
C363	VGND#3	a_575_305##15	1.09838e-16
C364	a_27_90##3	a_157_90#	3.44957e-18
C365	a_1549_74##11	a_1747_118##2	3.06744e-18
C366	VGND#11	CLK#1	1.19372e-17
C367	a_1972_92##2	a_1972_92##6	3.46474e-19
C368	VGND#20	SCD#3	2.99676e-17
C369	a_161_394##6	a_161_394#	1.09329e-20
C370	VGND#13	a_667_87##5	4.85587e-18
C371	a_1747_118##7	a_1972_92##7	6.84872e-19
C372	a_1972_92#	a_1931_508#	9.15884e-18
C373	VGND#20	a_667_87##5	3.16146e-18
C374	a_2463_74##5	VGND#7	2.60536e-17
C375	a_697_113##4	SCE#4	1.06694e-17
C376	a_1972_92##11	a_1972_92#	2.70741e-18
C377	a_575_305##13	SCE#3	6.23206e-18
C378	a_575_305##19	a_1972_92##8	5.39768e-19
C379	a_1348_368##7	a_1931_508#	1.03857e-17
C380	a_1972_92##11	a_1972_92##2	1.9041e-19
C381	VGND#18	a_697_113##2	5.02944e-19
C382	a_1747_118##2	a_1972_92##2	1.1969e-16
C383	a_1972_92##6	a_1348_368##6	2.67084e-18
C384	a_1972_92#	a_1747_118##3	3.01304e-17
C385	a_1747_118##5	a_1972_92##11	9.92302e-19
C386	VGND#13	SCD#2	2.06155e-18
C387	a_1549_74##17	a_1348_368##2	3.25965e-18
C388	a_575_305##15	a_575_305##7	1.42055e-18
C389	a_697_113##9	SCD#2	3.03365e-18
C390	D#3	a_161_394#	1.34553e-17
C391	a_1549_74##3	a_1972_92##3	1.58861e-17
C392	a_1348_368##4	VPWR#12	1.55342e-18
C393	Q#3	a_2463_74##2	2.50808e-17
C394	a_1549_74##10	a_575_305##4	3.85875e-19
C395	VPWR#10	a_1972_92##2	1.78592e-19
C396	a_667_87##10	SCD#3	1.09107e-18
C397	a_1747_118##2	a_1348_368##6	2.46362e-17
C398	a_1972_92##3	a_1895_118#	2.78082e-18
C399	a_1549_74##4	a_1972_92##6	1.66384e-19
C400	a_575_305##19	VGND#17	3.74069e-18
C401	VPWR#10	a_1972_92#	2.45912e-17
C402	DE#5	a_161_394##4	1.0544e-18
C403	VPWR#17	DE#10	1.51368e-18
C404	VGND#13	SCE#3	3.20311e-18
C405	D#4	DE#3	1.294e-20
C406	a_2463_74##5	Q#3	1.09968e-17
C407	VGND#12	SCE#1	1.76271e-17
C408	a_1549_74##3	a_1895_118#	5.19495e-18
C409	a_1549_74##11	a_1972_92##9	1.79337e-17
C410	a_1348_368##6	VPWR#9	2.46615e-17
C411	a_575_305##13	VPWR#15	4.25633e-18
C412	VGND#19	a_697_113##4	2.13183e-18
C413	a_1549_74##12	a_1747_118##5	6.99389e-19
C414	a_1972_92##9	a_1972_92##6	1.10171e-17
C415	a_1747_118##7	a_1747_118##3	1.16612e-18
C416	a_667_87##10	VGND#20	4.92391e-17
C417	VGND#10	a_1348_368##4	8.3228e-21
C418	a_161_394#	DE#8	3.256e-17
C419	a_1348_368##6	a_1972_92##2	1.95631e-17
C420	a_161_394##4	DE#2	1.1102e-17
C421	SCE#2	VGND#20	1.36824e-17
C422	a_161_394##2	DE#2	3.33951e-19
C423	a_575_305##13	a_575_305##2	3.80937e-18
C424	VGND#20	SCD#2	2.83973e-17
C425	VPWR#17	DE#8	1.26959e-18
C426	a_1348_368##6	a_1972_92##11	5.1763e-17
C427	VGND#6	a_1747_118#	4.48061e-18
C428	a_1747_118##5	a_1972_92##6	1.71583e-19
C429	VPWR#13	a_667_87##5	1.38701e-19
C430	a_575_305##13	VPWR#13	5.58181e-18
C431	a_1549_74##11	a_1972_92##2	6.08264e-17
C432	VPWR#17	a_575_305##2	1.19917e-20
C433	a_1549_74##4	a_1972_92##2	6.00664e-17
C434	a_575_305##8	a_575_305##7	8.34552e-19
C435	a_1348_368##3	VPWR#12	5.5401e-19
C436	VGND#10	a_1348_368##5	4.89335e-20
C437	a_1348_368##7	a_1972_92#	2.93252e-17
C438	a_575_305##13	a_161_394##4	8.55518e-18
C439	VGND#11	SCE#1	1.99083e-18
C440	a_667_87##7	a_667_87##4	2.17259e-19
C441	SCE#3	a_697_113##9	2.32248e-18
C442	a_1348_368##6	VPWR#10	4.12115e-17
C443	a_575_305##15	a_2463_74##5	2.23925e-17
C444	a_575_305##19	a_1747_118##6	1.2838e-18
C445	VPWR#10	a_1348_368##7	4.0045e-18
C446	VGND#13	a_575_305##2	6.44478e-18
C447	VGND#14	DE#5	2.619e-19
C448	a_667_87##4	a_1068_462#	1.41674e-17
C449	a_1549_74##4	a_1348_368##6	1.93739e-17
C450	a_667_87##10	SCE#2	3.51347e-17
C451	a_1549_74##2	a_1972_92##2	1.45124e-19
C452	VGND#6	a_1972_92##3	3.69501e-18
C453	a_575_305##13	VPWR#11	5.9556e-18
C454	a_697_113##5	VPWR#16	4.18321e-17
C455	VPWR#17	a_161_394##4	3.82689e-18
C456	a_575_305##8	a_2463_74##5	1.0759e-17
C457	a_1747_118##7	a_1972_92#	4.08231e-18
C458	a_667_87##7	SCE#2	3.43487e-20
C459	SCD#1	a_1068_462#	1.41674e-17
C460	VPWR#11	a_1348_368##8	9.56518e-19
C461	D#4	DE#5	5.5457e-20
C462	a_1348_368#	a_1549_74##3	7.6733e-18
C463	Q#3	a_2463_74##7	6.62047e-19
C464	VGND#13	DE#10	2.47105e-18
C465	a_1348_368##6	a_1549_74##2	1.73298e-17
C466	D#4	a_161_394#	2.68121e-17
C467	VGND#13	a_161_394##4	5.11115e-18
C468	VGND#3	VGND#4	9.19757e-17
C469	a_1549_74##10	a_1348_368##10	3.77431e-19
C470	VGND#6	a_1549_74##3	1.1839e-18
C471	VPWR#17	VPWR#18	8.04985e-17
C472	VGND#10	SCE#1	4.08021e-20
C473	a_1747_118##7	a_1348_368##6	5.48638e-17
C474	a_697_113#	VPWR#11	4.05843e-17
C475	a_1549_74##10	a_1972_92##9	1.89672e-18
C476	a_697_113##9	a_697_113##4	6.62063e-19
C477	a_1549_74##11	a_1747_118##5	1.38947e-18
C478	a_1972_92##9	a_1747_118##2	5.84389e-17
C479	a_575_305##13	a_161_394#	2.25075e-19
C480	a_1549_74##2	a_1549_74##4	6.74199e-19
C481	VGND#13	DE#8	1.30816e-18
C482	a_667_87##10	SCE#3	1.15057e-17
C483	VGND#13	DE#3	1.00041e-18
C484	VGND#12	SCD#3	1.71011e-18
C485	VGND#12	a_667_87##10	1.2657e-17
C486	a_1549_74##12	a_1348_368##6	4.09091e-19
C487	VPWR#15	CLK#3	1.72199e-19
C488	a_1549_74##10	a_2463_74##10	4.27583e-17
C489	a_575_305##15	a_2463_74##2	2.44692e-18
C490	VPWR#10	a_1549_74#	8.5502e-19
C491	a_2463_74##4	a_2463_74##5	3.90135e-19
C492	VGND#10	a_1348_368##3	1.45455e-19
C493	VPWR#17	VPWR#15	9.55761e-17
C494	a_697_113##5	a_667_87##9	8.98203e-17
C495	a_1549_74#	a_1348_368##7	1.8604e-17
C496	VPWR#17	a_161_394#	6.78546e-18
C497	DE#5	DE#3	1.722e-18
C498	a_1747_118##5	a_1747_118##2	1.85942e-18
C499	a_1747_118##7	a_1348_368##7	2.97359e-17
C500	a_667_87##10	a_667_87##3	1.23254e-18
C501	VGND#11	CLK#2	1.34596e-18
C502	a_575_305##15	a_2463_74##7	5.22481e-17
C503	VGND#13	a_161_394#	6.67746e-18
C504	a_667_87##7	SCD#1	6.7861e-19
C505	a_575_305##19	a_2345_392#	9.03123e-18
C506	VPWR#17	VPWR#13	6.2968e-17
C507	VPWR#13	CLK#3	3.98669e-18
C508	a_575_305#	a_556_464#	1.53392e-17
C509	a_697_113##7	a_667_87##10	4.946e-17
C510	a_27_90##6	a_27_90##3	1.26794e-18
C511	a_697_113##4	a_1068_462#	2.33982e-18
C512	DE#1	a_556_464#	1.53392e-17
C513	D#4	D#2	1.27905e-17
C514	VGND#14	DE#2	2.22024e-19
C515	a_697_113#	a_1348_368##7	7.51726e-19
C516	a_575_305##4	a_2463_74##4	1.02853e-17
C517	a_1348_368##9	a_1348_368#	5.69683e-18
C518	a_667_87##3	a_697_113##7	1.58679e-17
C519	VPWR#10	a_1348_368##8	4.76173e-19
C520	a_2463_74##9	a_575_305##19	3.53585e-17
C521	VPWR#12	a_1972_92#	2.50422e-19
C522	VGND#12	SCD	1.90905e-18
C523	a_575_305##19	a_2463_74##2	2.28361e-19
C524	a_2463_74##7	VGND#8	7.1278e-18
C525	a_1549_74##10	a_1549_74##5	1.086e-17
C526	a_1747_118##7	a_1549_74#	1.73536e-17
C527	CLK#2	a_1348_368##5	9.2818e-18
C528	a_1348_368##8	a_1549_74#	4.28544e-18
C529	a_1972_92##2	a_1972_92##9	2.19646e-18
C530	a_27_90##3	DE#5	8.38749e-19
C531	a_667_87##10	a_575_305##3	3.39981e-19
C532	a_697_113##2	a_1348_368##4	1.20969e-17
C533	a_1549_74##12	a_1549_74##4	8.82796e-19
C534	a_575_305##15	a_575_305##4	2.80437e-18
C535	a_1747_118##7	a_1549_74##2	3.50444e-17
C536	VGND#12	a_667_87##5	5.53199e-19
C537	VGND#13	D#4	7.59288e-18
C538	VGND#12	SCE#2	2.79253e-17
C539	a_27_90#	a_667_87##3	4.09032e-17
C540	a_575_305##4	a_575_305##5	1.05328e-18
C541	a_1747_118##5	a_1972_92##2	1.4199e-18
C542	a_161_394##2	a_116_464#	1.40434e-17
C543	VPWR#15	a_667_87##4	6.32933e-18
C544	VGND#10	a_1348_368##2	2.74503e-20
C545	a_697_113#	a_1549_74#	2.18993e-17
C546	a_27_90##3	a_27_90##2	3.10847e-18
C547	a_667_87##7	SCE#4	1.45893e-17
C548	SCE#1	a_1075_125#	9.87534e-18
C549	a_1549_74##11	a_1549_74##4	9.92229e-19
C550	a_1348_368##5	SCD#2	2.6722e-19
C551	a_1549_74##11	a_1972_92##4	1.03077e-19
C552	D#3	a_116_464#	1.46614e-17
C553	VPWR#15	SCE#3	7.33367e-20
C554	VGND#11	a_667_87##5	1.10379e-19
C555	a_1549_74##2	a_697_113#	2.31343e-17
C556	VPWR#12	a_1348_368##7	3.41102e-19
C557	SCD#3	a_1075_125#	9.87534e-18
C558	a_1747_118##7	a_1348_368##8	1.28742e-18
C559	a_161_394#	DE#5	2.07762e-18
C560	a_575_305##13	SCE#1	2.13934e-19
C561	SCD#2	CLK#2	2.92256e-18
C562	DE#10	a_27_90#	2.07519e-18
C563	a_1747_118##5	a_1747_118##7	1.45118e-18
C564	a_575_305##4	VGND#8	1.70576e-17
C565	VGND#11	SCE#2	5.3004e-20
C566	CLK#3	a_1348_368##8	1.93165e-18
C567	a_161_394#	DE#2	3.88873e-18
C568	CLK#1	a_1348_368##9	4.4337e-18
C569	a_667_87##7	a_697_113##4	2.84775e-17
C570	VGND#6	VGND#5	5.09889e-19
C571	a_697_113##7	a_575_305##2	5.08326e-19
C572	a_667_87##10	a_161_394##3	2.08714e-19
C573	a_575_305##4	a_1549_74##7	3.59896e-17
C574	SCD#2	a_667_87##5	2.68111e-17
C575	SCE#3	CLK#2	3.22781e-19
C576	VPWR#3	a_2463_74##9	6.77795e-19
C577	a_1549_74##10	a_1972_92##4	1.876e-17
C578	a_697_113#	a_1348_368##8	7.04709e-18
C579	a_2463_74##10	a_2463_74##7	3.18252e-19
C580	a_27_90##3	DE#2	8.75624e-19
C581	a_27_90#	a_575_305##2	5.59415e-17
C582	a_27_90#	a_575_305##3	3.17326e-17
C583	a_575_305##15	a_1348_368##10	1.36563e-19
C584	a_27_90#	a_697_113##7	8.89853e-17
C585	a_575_305##19	a_2565_74#	7.98836e-20
C586	a_667_87##5	SCE#3	1.48856e-19
C587	a_1972_92##9	a_1348_368##6	1.3633e-19
C588	a_697_113##2	a_1348_368##3	8.9802e-18
C589	VPWR#12	a_1549_74#	1.43209e-18
C590	a_161_394##9	a_161_394##6	8.51784e-19
C591	VPWR#9	a_2463_74##11	5.37226e-18
C592	a_27_90##2	a_697_113##5	1.06952e-16
C593	a_575_305##19	a_1348_368##2	2.98484e-18
C594	VGND#21	a_667_87##3	4.52402e-19
C595	a_1549_74##12	a_1549_74##2	1.15874e-18
C596	a_1549_74##10	VGND#9	6.37188e-17
C597	SCE#3	SCD#2	5.88233e-17
C598	VPWR#3	a_2463_74##2	2.09977e-18
C599	VGND#13	CLK#1	1.37125e-18
C600	a_1747_118##5	a_1348_368##6	7.25294e-17
C601	a_667_87##7	SCE#5	1.66417e-18
C602	a_1348_368##11	a_575_305##4	6.9262e-19
C603	a_1549_74##17	a_1348_368##8	2.8364e-17
C604	a_1348_368##11	a_2345_392#	1.30317e-17
C605	a_1747_118##2	a_1348_368##2	1.52256e-20
C606	VGND#12	SCD#2	1.50275e-19
C607	Q_N#1	a_575_305##8	3.03264e-17
C608	a_1549_74##11	a_1747_118#	3.93297e-17
C609	a_1549_74##11	a_1972_92##8	3.67392e-17
C610	a_575_305##19	a_1549_74##12	3.18595e-18
C611	a_575_305##13	a_667_87##3	1.9451e-18
C612	VPWR#15	SCD#1	8.71722e-18
C613	a_667_87##4	CLK#3	4.58878e-18
C614	a_1549_74##6	a_2345_392#	4.96188e-18
C615	VPWR#19	a_697_113##5	1.63451e-18
C616	VGND#13	SCE#1	7.70233e-18
C617	a_161_394##9	a_575_305##2	2.07301e-19
C618	a_575_305##8	VGND#7	7.91413e-17
C619	a_575_305##19	a_2391_74#	2.7801e-19
C620	a_27_90#	a_161_394##4	3.61223e-19
C621	a_27_90#	a_161_394##3	4.34606e-18
C622	a_575_305##19	a_2463_74#	1.76576e-18
C623	VPWR#12	a_1348_368##8	4.5331e-17
C624	SCE#1	CLK#1	6.13289e-18
C625	VGND#21	a_667_87##10	2.36964e-18
C626	a_2463_74##10	a_575_305##4	2.06242e-17
C627	a_1348_368##5	a_1348_368##15	2.51771e-20
C628	a_575_305##19	a_1549_74##11	7.55429e-18
C629	a_575_305##15	a_1549_74##5	1.02489e-19
C630	VPWR#3	a_575_305##9	3.99385e-18
C631	VGND#13	SCD#3	2.02383e-18
C632	Q	a_2463_74##2	1.39969e-18
C633	a_1549_74##5	a_1348_368##11	3.42108e-18
C634	VGND#21	a_575_305##3	3.97717e-18
C635	D#2	DE#5	3.34055e-19
C636	Q#3	a_575_305##8	6.80386e-17
C637	VPWR#17	a_667_87##3	2.18919e-19
C638	a_1549_74##10	a_1747_118#	2.39617e-18
C639	a_1549_74##12	a_1972_92##3	2.28226e-19
C640	VGND#3	a_2463_74##9	9.06106e-18
C641	a_575_305##19	a_2463_74##6	3.53214e-17
C642	a_1549_74##4	a_1972_92##9	4.69247e-19
C643	VGND#4	a_575_305##15	5.27004e-17
C644	VGND#14	a_575_305##3	1.54846e-18
C645	a_27_90##2	a_27_90##5	5.11107e-19
C646	VGND#21	a_161_394##4	1.52882e-17
C647	a_575_305##19	a_1549_74##10	9.14808e-18
C648	VGND#13	SCE#2	6.17142e-18
C649	VPWR#3	a_2463_74#	2.446e-18
C650	a_575_305##12	a_27_90##2	5.39447e-17
C651	SCE#6	SCE#4	1.69256e-19
C652	a_1549_74##10	a_1972_92##8	5.61421e-17
C653	SCD#1	a_667_87##4	4.27281e-17
C654	a_667_87##7	a_575_305#	1.02804e-19
C655	SCE#4	CLK#3	1.02862e-19
C656	a_161_394##9	a_161_394##4	1.16877e-18
C657	a_1747_118##5	a_1549_74##4	6.1998e-17
C658	a_27_90##2	DE#2	4.85696e-18
C659	VPWR#12	CLK#3	2.8017e-18
C660	a_575_305##19	a_575_305##6	8.96676e-19
C661	a_161_394##9	a_575_305##3	4.83991e-19
C662	CLK#2	a_1348_368##15	1.07441e-17
C663	a_1348_368##6	a_1931_508#	2.90129e-18
C664	VGND#13	a_667_87##3	1.62847e-17
C665	a_27_90#	DE#3	1.61058e-19
C666	a_1348_368##13	CLK	2.97949e-17
C667	a_27_90#	DE#7	1.21977e-18
C668	a_161_394##4	a_575_305##2	7.2672e-17
C669	VPWR#15	VPWR#14	4.26804e-19
C670	VPWR#3	a_2463_74##6	8.4856e-19
C671	a_1549_74##11	a_1972_92##3	2.91808e-17
C672	VPWR#14	a_1348_368##8	1.75189e-18
C673	a_1549_74##11	VGND#17	9.41661e-17
C674	VGND#12	SCE#3	8.11201e-19
C675	a_2463_74##10	a_1348_368##10	2.70784e-17
C676	VGND#3	a_2463_74##2	5.64636e-18
C677	VPWR#18	a_575_305##2	1.37048e-19
C678	VGND#21	a_161_394##3	3.84902e-17
C679	a_575_305##3	a_533_113#	9.87534e-18
C680	DE#3	a_575_305##2	1.26422e-19
C681	VPWR#15	SCE#4	1.51221e-17
C682	a_575_305##19	a_1549_74##8	1.01847e-18
C683	VGND#13	a_575_305##3	1.50743e-17
C684	a_1348_368##15	CLK#3	3.207e-17
C685	SCE#1	SCD#3	4.677e-17
C686	a_161_394##3	a_533_113#	9.87534e-18
C687	a_1348_368##2	a_1972_92##2	7.15909e-19
C688	a_575_305##13	a_697_113##8	8.73338e-18
C689	a_27_90##3	D	3.68643e-17
C690	Q#3	a_2463_74##4	4.12527e-19
C691	a_27_90#	a_697_113##5	4.72934e-18
C692	DE#3	a_161_394##4	2.87286e-17
C693	a_27_90##2	a_556_464#	2.98549e-18
C694	VPWR#17	DE#7	4.88675e-21
C695	a_161_394#	a_575_305##2	9.46034e-20
C696	VGND#9	a_575_305##4	1.16679e-19
C697	a_27_90##2	SCE#4	6.12912e-20
C698	a_1972_92##6	a_1549_74##5	9.3537e-18
C699	a_27_90##2	a_667_87##3	4.11379e-19
C700	SCE#4	SCD#1	2.19921e-17
C701	VGND#13	VGND#14	8.79698e-17
C702	a_161_394##9	DE#3	2.4671e-18
C703	VGND#13	a_161_394##3	4.52641e-18
C704	a_1348_368##15	a_667_87##5	1.98209e-18
C705	a_575_305##19	a_1348_368##12	2.06718e-18
C706	a_1549_74##12	a_1549_74##3	8.73159e-18
C707	a_161_394#	a_161_394##4	2.3536e-18
C708	a_575_305##13	a_1549_74##13	7.99816e-18
C709	VPWR#13	SCE#4	8.28225e-20
C710	a_575_305##15	a_2463_74##4	5.31136e-17
C711	VPWR#14	CLK#3	3.465e-17
C712	a_161_394##9	a_161_394##3	2.09758e-18
C713	VGND#4	VGND#8	8.29904e-18
C714	VGND#21	a_27_90#	1.70167e-17
C715	VGND#14	a_161_394##3	2.66493e-18
C716	a_161_394#	DE#3	1.69306e-17
C717	SCE#2	SCE#1	1.63936e-18
C718	a_1549_74##12	a_1348_368##2	1.03034e-18
C719	a_161_394##9	DE#10	2.85829e-17
C720	VGND#13	VGND#12	1.22698e-16
C721	a_1549_74##2	a_1747_118##5	6.92033e-17
C722	VGND#13	DE#7	7.63561e-18
C723	a_1549_74##10	a_2391_74#	3.03175e-18
C724	SCD	a_697_113##9	1.96561e-17
C725	a_575_305##13	VGND#18	5.10342e-18
C726	a_575_305##19	a_1972_92##7	2.87152e-18
C727	a_2463_74##4	VGND#8	8.69412e-19
C728	VGND#21	DE#7	1.35069e-17
C729	D#2	DE#3	7.41065e-19
C730	a_2463_74##10	a_1549_74##5	3.46544e-17
C731	a_1747_118#	a_1972_92##6	1.19277e-17
C732	a_667_87##5	a_697_113##10	1.02749e-18
C733	VPWR#18	SCE#5	1.1186e-18
C734	a_1549_74##11	a_1549_74##3	1.04308e-17
C735	VGND#22	a_161_394##3	3.5478e-19
C736	VGND#13	VGND#11	7.10078e-17
C737	D#2	a_161_394#	6.38444e-17
C738	VGND#13	DE#6	4.11942e-18
C739	a_27_90##3	a_116_464#	2.78569e-18
C740	a_575_305##13	a_1348_368##13	4.7596e-18
C741	a_575_305##12	DE#2	1.54569e-19
C742	VGND#9	a_1348_368##10	2.2846e-19
C743	a_575_305##19	a_1747_118##3	5.07387e-18
C744	SCE#2	SCD#3	2.0879e-17
C745	a_161_394##9	a_161_394#	2.0654e-18
C746	SCE#5	SCE#4	3.62977e-18
C747	VPWR#14	a_667_87##4	2.81034e-18
C748	VPWR#10	VPWR#9	7.98157e-18
C749	a_1549_74##12	a_1747_118##6	7.27133e-17
C750	DE#6	a_157_90#	9.7209e-18
C751	a_27_90##2	SCE#5	3.39592e-17
C752	a_161_394##9	DE#7	3.93135e-17
C753	a_697_113##2	a_1747_118##7	9.37057e-18
C754	D#1	a_157_90#	1.01349e-17
C755	VGND#13	D#1	1.1285e-17
C756	VPWR#4	a_2463_74##4	7.36363e-19
C757	a_27_90##2	VPWR#19	7.64429e-17
C758	VGND#22	a_161_394#	2.86573e-17
C759	CLK	a_1348_368##15	1.08073e-17
C760	a_161_394##9	a_27_90#	7.15459e-18
C761	a_575_305##13	VGND#19	8.86276e-18
C762	a_161_394##9	DE#8	1.9784e-17
C763	a_575_305##19	a_1972_92#	1.76804e-18
C764	a_1972_92##9	a_1972_92##4	4.63616e-19
C765	a_575_305##19	a_1972_92##9	3.36659e-18
C766	a_1549_74##12	a_1348_368#	2.18552e-17
C767	a_575_305#	SCE#4	2.04994e-19
C768	VGND#21	DE#6	1.21304e-18
C769	a_667_87##4	a_697_113##10	2.16399e-17
C770	VGND#14	a_161_394##9	5.04712e-18
C771	VPWR	VPWR#13	2.27139e-17
C772	VPWR	VPWR#11	1.11599e-16
C773	a_2463_74##10	a_1972_92##4	5.65043e-18
C774	a_27_90##3	a_161_394##8	5.29542e-17
C775	a_575_305##13	a_697_113##9	4.16094e-18
C776	VPWR#16	CLK#3	2.39739e-19
C777	VPWR	VPWR#5	1.09277e-16
C778	VPWR	VPWR#4	4.63995e-17
C779	VGND#22	DE#7	2.75538e-18
C780	VPWR#14	SCD#1	3.44636e-19
C781	a_575_305##19	Q_N#2	1.61146e-18
C782	VGND#14	DE#7	3.94938e-18
C783	a_575_305##19	a_1747_118##5	3.18669e-17
C784	a_161_394##9	D#2	5.30825e-19
C785	a_575_305#	SCE#5	4.48985e-17
C786	a_697_113##2	a_1549_74##2	1.35668e-17
C787	a_1549_74##4	a_1895_118#	4.05213e-19
C788	VGND#9	a_1549_74##5	2.62983e-18
C789	a_1972_92##2	a_1747_118#	3.94507e-18
C790	VPWR#16	SCD#2	2.74039e-19
C791	VPWR#11	a_1348_368##4	5.50251e-20
C792	a_161_394##9	DE#6	2.0247e-18
C793	a_1549_74##11	a_1348_368#	6.57486e-19
C794	a_1747_118##6	a_1549_74##11	3.55797e-17
C795	VGND#5	a_2463_74##10	1.11175e-17
C796	VGND#14	a_575_305##2	4.6755e-19
C797	VGND	a_1348_368##4	1.16709e-18
C798	a_575_305##19	VPWR#7	1.18111e-18
C799	VGND	a_1348_368##2	5.01025e-20
C800	VPWR#18	a_575_305#	6.10662e-19
C801	a_27_90##2	a_575_305#	3.69109e-17
C802	VPWR	a_2463_74##9	1.42142e-18
C803	a_27_90##2	a_161_394##8	4.71716e-17
C804	a_1549_74##12	a_697_113##8	5.99478e-17
C805	a_575_305##13	VGND#20	9.4136e-18
C806	VPWR#16	a_667_87##4	2.6512e-18
C807	VPWR#6	a_1747_118##3	6.39015e-18
C808	a_161_394##6	a_27_90##3	4.2349e-18
C809	VPWR#14	SCE#4	6.56653e-20
C810	a_27_90##6	D#2	3.19325e-17
C811	a_697_113##4	a_1348_368##5	2.13816e-18
C812	VGND#22	DE#6	3.68521e-17
C813	VPWR#18	DE#3	1.13406e-20
C814	a_2463_74##10	a_1747_118#	3.32978e-19
C815	a_1348_368##8	a_1348_368##2	2.13512e-18
C816	VPWR#3	Q_N#2	2.12123e-17
C817	a_575_305##5	VPWR#4	2.11655e-17
C818	a_1972_92##9	a_1747_118#	7.72107e-18
C819	VPWR#15	a_575_305#	4.53687e-20
C820	VPWR	a_1972_92##9	1.17243e-19
C821	a_575_305##12	a_575_305#	2.37283e-18
C822	VPWR	a_1747_118##5	4.40248e-19
C823	a_1549_74##12	a_1348_368##9	3.90791e-19
C824	a_575_305##15	Q	3.97336e-19
C825	DE#1	a_575_305#	4.81975e-17
C826	a_575_305##13	a_667_87##10	4.66215e-18
C827	CLK	a_1348_368##9	6.12109e-19
C828	a_27_90##3	VPWR#21	7.5333e-17
C829	VGND#13	a_1348_368##13	3.91826e-18
C830	VPWR	a_697_113##4	2.962e-18
C831	a_575_305##8	a_2463_74#	2.10196e-17
C832	VPWR#6	a_1972_92#	4.22733e-18
C833	a_27_90##6	DE#7	1.47487e-19
C834	VPWR	a_697_113##2	1.36404e-17
C835	VGND#22	VGND#14	1.63526e-18
C836	VPWR#6	a_1348_368##2	1.21637e-20
C837	a_161_394##9	D#1	4.30737e-19
C838	a_1549_74##11	a_1895_118#	1.00174e-17
C839	VGND#9	a_1972_92##4	4.34521e-17
C840	a_575_305##19	a_575_305##17	1.45244e-17
C841	a_161_394##9	VGND#21	4.80981e-17
C842	VGND#4	a_2463_74##10	3.01126e-17
C843	a_1348_368##5	a_697_113##2	9.444e-17
C844	a_575_305##13	a_697_113##7	2.359e-18
C845	VPWR#16	SCD#1	2.81014e-17
C846	a_1348_368##2	a_1549_74##4	2.38655e-18
C847	VPWR#6	a_1348_368##7	4.5537e-18
C848	VGND#14	DE#6	7.09324e-19
C849	VPWR#15	VPWR#13	4.67448e-19
C850	a_2463_74##10	a_1549_74##7	4.88206e-17
C851	VGND	VGND#11	8.44784e-18
C852	a_697_113##5	a_667_87##4	1.54811e-19
C853	a_575_305##3	a_667_87##3	3.50966e-17
C854	VGND	VGND#10	1.05539e-16
C855	a_2463_74##4	a_2463_74#	2.74822e-18
C856	VGND	VGND#5	1.02601e-16
C857	a_161_394##6	SCE#5	2.58503e-19
C858	VGND	VGND#4	6.3315e-17
C859	a_575_305##19	VPWR#8	2.90018e-18
C860	a_1549_74##10	a_2463_74##9	4.55941e-19
C861	VGND#6	a_1549_74##12	4.2803e-17
C862	a_27_90##2	DE#1	2.97944e-17
C863	VGND#22	D#1	6.76637e-18
C864	VPWR#11	a_1348_368##3	4.69667e-20
C865	a_1549_74##4	a_1972_92##3	5.0761e-19
C866	SCD	SCE#1	8.79374e-18
C867	a_575_305##13	a_27_90#	7.08625e-18
C868	VGND#3	Q_N#2	1.00526e-18
C869	VGND#14	a_161_394##4	4.67527e-19
C870	VGND#13	a_697_113##9	1.88592e-17
C871	a_1972_92##8	a_1972_92##4	4.18439e-19
C872	a_697_113##2	a_1549_74##17	4.76078e-17
C873	VPWR#6	a_1549_74#	4.5742e-18
C874	a_161_394##6	a_27_90##2	1.12228e-17
C875	VGND	a_2463_74##9	1.30971e-18
C876	DE#4	DE#1	1.16688e-17
C877	a_1549_74##13	a_1549_74##12	2.59386e-18
C878	a_27_90##6	DE#6	6.15118e-18
C879	VPWR#18	DE#1	6.90805e-18
C880	VGND	a_1549_74##12	3.23555e-17
C881	Q	Q_N#2	1.40867e-18
C882	VGND	a_1549_74##11	3.18201e-17
C883	VGND#6	a_1549_74##11	4.94348e-17
C884	CLK#2	a_697_113##4	3.42432e-18
C885	Q	VPWR#7	8.60294e-17
C886	VGND	a_1549_74##10	3.38995e-17
C887	Q	Q#1	3.27695e-18
C888	a_575_305##12	DE#1	1.74569e-18
C889	a_1747_118##5	a_1972_92##9	8.02942e-19
C890	SCE#4	VPWR#16	2.09118e-17
C891	a_1972_92##9	a_1972_92##3	2.03772e-19
C892	VGND#9	a_1747_118#	4.69938e-19
C893	VGND	a_1972_92##9	2.01123e-18
C894	VGND#22	VGND#21	5.35503e-18
C895	VGND	a_1747_118##5	2.11123e-18
C896	a_27_90##3	DE#6	2.87072e-20
C897	a_697_113##5	SCD#1	1.68914e-18
C898	a_1348_368#	a_1549_74##4	4.07069e-18
C899	VGND	a_697_113##2	4.10817e-18
C900	VPWR	a_697_113##8	1.78142e-19
C901	DE#7	DE#2	8.79778e-19
C902	VPWR#4	a_1549_74##7	2.39993e-19
C903	a_27_90##3	DE#4	2.31935e-18
C904	VGND#6	a_1549_74##10	7.94464e-18
C905	a_575_305##19	a_2463_74##11	4.00037e-17
C906	VGND#17	a_1972_92##4	1.11975e-19
C907	a_575_305##5	a_2463_74##6	1.40017e-17
C908	a_1549_74##2	a_1348_368##4	7.60213e-20
C909	a_2463_74##10	a_1348_368##11	7.38663e-19
C910	VPWR#4	VPWR#7	1.28624e-18
C911	a_1747_118##7	VPWR#10	8.77324e-18
C912	a_697_113##2	CLK#2	3.94514e-19
C913	SCE#4	a_667_87##9	1.99265e-17
C914	VPWR#18	DE#2	1.91683e-19
C915	a_161_394##6	a_575_305#	5.44427e-19
C916	a_697_113##4	a_1348_368##15	3.28284e-17
C917	a_161_394##3	a_575_305##3	4.72403e-17
C918	a_161_394##2	DE#4	3.3237e-18
C919	a_27_90##2	DE#4	3.19999e-17
C920	a_1747_118#	a_1972_92##8	9.6245e-18
C921	VGND#7	Q_N#1	6.2889e-17
C922	a_27_90##6	D#1	2.83998e-17
C923	VGND#6	a_1348_368##2	8.12259e-20
C924	VGND#13	a_667_87##10	3.36943e-17
C925	a_697_113##5	a_575_305##2	5.81312e-19
C926	VGND#4	a_2463_74##4	7.20226e-18
C927	a_575_305##13	a_1549_74##12	1.29888e-18
C928	a_1549_74##2	a_1348_368#	4.04563e-18
C929	VPWR#4	a_575_305##9	4.0921e-19
C930	a_697_113##5	SCE#4	3.58739e-17
C931	VGND#10	a_697_113##2	6.33068e-19
C932	VPWR	a_2463_74##11	2.18787e-17
C933	a_697_113##2	VPWR#12	5.26173e-17
C934	a_1549_74##2	a_1348_368##2	5.01695e-17
C935	VGND#22	a_161_394##9	3.23375e-17
C936	VPWR	VPWR#9	3.50758e-17
C937	VPWR	a_1972_92##11	3.25389e-18
C938	VGND	a_2463_74##10	2.47131e-17
C939	a_1549_74##8	a_575_305##5	3.72038e-17
C940	VPWR	VPWR#10	2.40801e-18
C941	a_575_305##13	a_1348_368##8	1.23108e-18
C942	VPWR#11	a_1348_368##2	4.66863e-20
C943	VGND#14	DE#3	9.75268e-19
C944	VGND	a_1972_92##8	7.4001e-18
C945	VGND#13	a_697_113##7	2.98569e-17
C946	VPWR	a_1747_118##7	2.08145e-17
C947	VGND	VGND#17	1.61546e-17
C948	a_1549_74##2	a_1348_368##9	1.55958e-19
C949	a_667_87##5	a_697_113##4	1.11285e-16
C950	a_575_305##19	VPWR#9	1.01221e-17
C951	VPWR	a_697_113#	3.54778e-17
C952	VGND#20	a_667_87##7	2.50187e-18
C953	VGND	a_1747_118##6	7.86545e-18
C954	VPWR	a_1549_74##17	2.12266e-18
C955	VGND	a_697_113##8	9.68061e-18
C956	a_27_90##3	a_27_90##4	3.39788e-18
C957	VPWR	VPWR#12	1.44204e-17
C958	a_667_87##9	SCE#5	7.89604e-19
C959	VGND	a_1549_74##13	2.30456e-17
C960	VPWR	a_1348_368##15	1.49055e-18
C961	VGND	VGND#18	1.49445e-17
C962	VGND	a_1348_368##13	1.91982e-17
C963	a_1972_92##9	a_1549_74##3	4.31627e-20
C964	a_1972_92##9	a_1972_92##7	6.64659e-19
C965	VPWR#18	DE#4	5.98966e-18
C966	a_1747_118#	VGND#17	2.5488e-17
C967	a_575_305##13	CLK	4.11528e-18
C968	a_1348_368##11	VPWR#5	1.25352e-17
C969	a_27_90##3	a_161_394##2	2.7699e-17
C970	a_575_305##13	CLK#3	1.53776e-18
C971	a_1348_368##5	a_1348_368#	1.19162e-19
C972	D#3	a_161_394##2	4.66569e-17
C973	VGND#13	a_27_90#	2.58553e-17
C974	a_575_305##19	a_1972_92##11	4.68172e-17
C975	a_575_305##13	a_1348_368##4	2.42102e-18
C976	a_697_113##5	SCE#5	4.26545e-17
C977	a_2463_74##2	VNB	3.76722e-17
C978	a_697_113##2	a_667_87##5	3.71709e-20
C979	a_1348_368##4	VNB	2.08376e-17
C980	a_1348_368##11	VPWR#4	8.44269e-19
C981	a_1348_368##3	VNB	2.59879e-17
C982	a_1348_368##2	VNB	5.20857e-17
C983	a_575_305##13	SCD	5.10565e-18
C984	a_2463_74##10	a_2565_74#	2.39505e-18
C985	DE#5	VNB	3.48566e-17
C986	a_1348_368##5	a_1348_368##9	2.18018e-18
C987	DE#2	VNB	3.64153e-17
C988	VGND	a_2463_74##11	5.07462e-19
C989	DE#7	a_161_394##3	2.79372e-17
C990	a_27_90##2	a_161_394##2	1.00991e-19
C991	Q	a_575_305##9	1.8854e-18
C992	VGND#13	SCD	6.24291e-18
C993	a_697_113##4	VPWR#14	6.64133e-17
C994	Q	a_2463_74#	4.75146e-17
C995	a_1549_74##13	a_697_113##8	5.17103e-17
C996	Q	a_2463_74##6	4.40832e-18
C997	a_1348_368##12	a_1549_74##7	4.06355e-18
C998	VGND#4	a_2463_74##9	5.20174e-17
C999	a_575_305##19	VPWR#10	5.17957e-18
C1000	VGND	a_1549_74##17	1.88406e-18
C1001	VGND	a_1348_368##15	1.58146e-18
C1002	VGND#9	VGND#4	1.21803e-18
C1003	a_1348_368##5	a_1348_368##4	2.4321e-18
C1004	a_1348_368##11	a_1549_74##8	2.53833e-18
C1005	SCE#5	a_27_90##5	1.35606e-17
C1006	VPWR#18	VNB	3.59836e-17
C1007	VGND#4	a_2463_74##7	1.51719e-17
C1008	VPWR#15	VNB	4.58909e-17
C1009	VGND#14	DE#10	5.35312e-19
C1010	VPWR#13	VNB	4.66376e-17
C1011	VPWR#11	VNB	6.13455e-17
C1012	VPWR#17	D	5.03413e-18
C1013	a_697_113##2	a_1348_368##15	3.97524e-18
C1014	VPWR#5	VNB	5.9557e-17
C1015	VPWR#4	VNB	6.16273e-17
C1016	a_575_305##13	SCD#1	3.08463e-20
C1017	VPWR#18	a_697_113##5	1.52146e-18
C1018	VGND#14	VNB	4.14414e-17
C1019	VGND#12	VNB	4.80498e-17
C1020	VGND#11	VNB	3.83715e-17
C1021	VPWR#17	a_667_87##4	9.81774e-18
C1022	VGND#10	VNB	6.19419e-17
C1023	CLK	a_1348_368##5	2.65424e-17
C1024	VGND#5	VNB	4.88366e-17
C1025	VGND#4	VNB	6.42232e-17
C1026	VPWR#13	VPWR#11	4.83214e-19
C1027	a_1972_92##3	VGND#17	1.32827e-17
C1028	CLK	CLK#2	8.50462e-18
C1029	a_667_87##10	a_667_87##7	2.29592e-18
C1030	VPWR#4	a_2463_74#	1.14227e-18
C1031	CLK#2	a_1348_368##9	2.43624e-18
C1032	a_697_113##4	SCD#2	1.42767e-18
C1033	a_697_113##5	a_575_305#	5.43997e-19
C1034	a_575_305##13	a_1348_368##2	1.46783e-18
C1035	a_1348_368##11	a_1348_368##12	2.32787e-17
C1036	a_161_394##6	DE#7	6.43245e-19
C1037	a_2463_74##9	VNB	6.60495e-18
C1038	VGND	a_575_305##4	3.65022e-19
C1039	VGND	a_1348_368##10	1.20748e-18
C1040	VGND	a_1549_74##5	1.53515e-18
C1041	a_1549_74##12	VNB	1.79391e-17
C1042	a_1549_74##11	VNB	1.44566e-17
C1043	VGND	a_1972_92##4	1.80921e-18
C1044	a_1549_74##10	VNB	2.142e-17
C1045	VGND	a_1747_118#	1.68849e-18
C1046	VPWR	a_1348_368##12	9.54505e-19
C1047	a_27_90##3	D#3	4.43298e-17
C1048	VGND	a_1972_92##3	9.00756e-18
C1049	VGND#13	a_161_394##9	1.61051e-17
C1050	VGND	a_1549_74##3	1.38629e-20
C1051	a_1972_92##9	VNB	6.41341e-18
C1052	VPWR	a_1747_118##3	6.92818e-18
C1053	a_1747_118##5	VNB	7.11793e-18
C1054	a_161_394##6	DE#5	6.82601e-19
C1055	SCD	CLK#2	8.49421e-19
C1056	VGND	a_1348_368##9	5.93893e-18
C1057	a_697_113##4	VNB	1.82599e-17
C1058	VPWR#17	SCD#1	4.58359e-18
C1059	a_1348_368##5	a_1348_368##2	3.42937e-19
C1060	a_697_113##2	VNB	1.67785e-17
C1061	a_575_305##19	Q	1.04772e-16
C1062	SCD	a_667_87##5	1.73701e-17
C1063	Q	VPWR#3	4.25423e-17
C1064	SCD	SCD#2	7.92291e-18
C1065	a_667_87##7	VNB	4.80543e-18
C1066	VGND#3	Q	3.53861e-19
C1067	a_1348_368##11	a_1972_92##7	4.90503e-17
C1068	a_27_90##6	a_161_394##9	1.89964e-18
C1069	a_575_305##19	a_1747_118##7	1.42923e-17
C1070	SCE#6	VNB	7.28274e-19
C1071	a_27_90##3	VNB	9.0765e-17
C1072	a_697_113#	a_1747_118##7	2.98648e-17
C1073	a_27_90##2	VNB	1.53818e-17
C1074	VPWR#18	a_161_394##2	1.08864e-19
C1075	a_575_305##12	VNB	1.92435e-18
C1076	VPWR#5	a_1549_74##6	2.00125e-19
C1077	a_575_305#	a_27_90##5	1.35606e-17
C1078	VGND#5	a_575_305##4	8.27793e-20
C1079	a_161_394##6	VNB	3.25619e-18
C1080	DE#6	DE#7	3.40734e-18
C1081	DE#10	VNB	1.27082e-18
C1082	SCE#1	CLK#2	6.13219e-19
C1083	DE#8	VNB	9.12357e-19
C1084	a_575_305##13	SCE#5	2.3003e-18
C1085	a_27_90##3	VPWR#18	2.91546e-19
C1086	Q	a_575_305##8	3.10494e-17
C1087	a_697_113##5	VPWR#15	4.37355e-17
C1088	D#4	VNB	3.81962e-18
C1089	Q_N#1	VNB	5.15953e-17
C1090	VPWR#19	SCE#5	6.64595e-19
C1091	VGND#7	VNB	4.26955e-18
C1092	Q	a_2463_74##4	1.57168e-18
C1093	Q_N#2	a_575_305##9	4.73925e-17
C1094	Q#3	VNB	2.88137e-18
C1095	a_575_305##15	VNB	2.15737e-17
C1096	a_2463_74##10	VNB	2.76544e-18
C1097	a_1747_118##5	a_1747_118##3	1.16611e-19
C1098	a_575_305##19	VPWR	1.1161e-16
C1099	a_697_113##4	a_697_113##10	2.2459e-18
C1100	VGND#9	a_1972_92##6	1.55586e-18
C1101	a_1348_368##11	a_1747_118##3	5.61625e-19
C1102	VGND#9	VNB	6.58527e-19
C1103	a_1972_92##8	VNB	2.59019e-19
C1104	VGND#17	VNB	4.14288e-18
C1105	a_697_113##5	DE#1	3.36072e-19
C1106	a_1747_118##6	VNB	4.64991e-18
C1107	a_697_113##8	VNB	1.7536e-17
C1108	a_1549_74##13	VNB	1.29718e-17
C1109	a_575_305##19	a_697_113#	4.76787e-18
C1110	VPWR	VPWR#6	1.10041e-16
C1111	VGND#18	VNB	3.31584e-18
C1112	a_1747_118##5	a_1348_368#	4.18042e-19
C1113	a_1348_368##13	VNB	1.2033e-17
C1114	VGND#19	VNB	3.99916e-19
C1115	a_697_113##9	VNB	2.15875e-17
C1116	a_575_305##13	VPWR	4.43011e-17
C1117	VGND#12	VGND#11	1.67369e-18
C1118	VGND#20	VNB	4.2256e-18
C1119	a_667_87##10	VNB	7.96864e-18
C1120	a_697_113##7	VNB	1.56749e-17
C1121	a_1972_92##7	a_1549_74##6	1.08431e-17
C1122	a_27_90#	VNB	1.0683e-17
C1123	D	a_161_394#	2.83606e-17
C1124	VGND#21	VNB	7.95722e-18
C1125	a_667_87##7	a_667_87##5	2.6156e-18
C1126	a_575_305##13	a_575_305#	9.31679e-20
C1127	a_161_394##9	VNB	1.02976e-17
C1128	VGND#22	VNB	8.06812e-18
C1129	VGND#17	a_1549_74##3	1.34993e-18
C1130	D	D#2	1.36234e-17
C1131	a_27_90##6	VNB	4.96746e-17
C1132	Q_N#2	VNB	6.93565e-17
C1133	VPWR#7	VNB	5.80163e-18
C1134	a_697_113##2	VPWR#14	9.60977e-21
C1135	VPWR#17	SCE#5	1.54957e-17
C1136	VPWR	a_1549_74##7	3.95039e-19
C1137	a_2463_74##11	VNB	2.69273e-18
C1138	VPWR	a_1348_368##11	2.39061e-17
C1139	VPWR#9	VNB	6.74494e-18
C1140	a_1972_92##11	VNB	3.40161e-18
C1141	VPWR	a_1549_74##6	2.86027e-18
C1142	VPWR#10	VNB	2.51365e-18
C1143	a_1747_118##7	VNB	4.86641e-18
C1144	VPWR	a_1972_92##6	1.10468e-18
C1145	a_697_113#	VNB	9.85402e-18
C1146	VGND#4	a_575_305##4	3.16238e-17
C1147	SCE#1	a_667_87##5	7.35447e-18
C1148	a_1549_74##17	VNB	1.89089e-18
C1149	VPWR	a_1747_118##2	2.60459e-18
C1150	VPWR#12	VNB	3.91867e-18
C1151	a_1348_368##15	VNB	9.62386e-19
C1152	a_575_305##9	VPWR#7	2.91451e-17
C1153	VPWR#14	VNB	3.90822e-18
C1154	VGND	VGND#6	1.21682e-16
C1155	VPWR	a_1348_368##6	2.26532e-17
C1156	VPWR#16	VNB	6.23633e-19
C1157	a_1747_118##6	a_1972_92##3	4.26123e-19
C1158	SCE#3	a_697_113##4	5.36214e-18
C1159	VPWR#6	VPWR#9	4.86137e-19
C1160	a_667_87##9	VNB	5.55448e-18
C1161	a_697_113##5	VNB	1.81454e-17
C1162	a_27_90##6	VGND#22	1.50387e-17
C1163	VGND#13	a_27_90##6	2.27039e-17
C1164	VPWR	a_1549_74##2	1.98384e-18
C1165	VPWR#19	VNB	3.14782e-19
C1166	a_161_394##8	VNB	3.94709e-19
C1167	a_575_305##13	DE#1	1.30851e-18
C1168	VPWR#21	VNB	1.14508e-18
C1169	VPWR	a_1348_368##5	3.67434e-18
C1170	VPWR#19	a_575_305#	2.56599e-18
C1171	a_161_394##6	DE#2	2.21294e-17
C1172	a_575_305##7	VNB	3.59574e-17
C1173	a_2463_74##5	VNB	3.1904e-17
C1174	VPWR#17	a_575_305#	4.51048e-18
C1175	a_2463_74##7	VNB	3.05128e-17
C1176	VGND	a_1549_74##7	5.20288e-18
C1177	a_575_305##4	VNB	5.70643e-17
C1178	a_1348_368##10	VNB	3.12813e-17
C1179	VGND	a_1348_368##11	3.91048e-18
C1180	a_1549_74##5	VNB	2.83483e-17
C1181	CLK#2	a_1348_368##4	2.92909e-18
C1182	a_1972_92##4	VNB	2.66836e-17
C1183	VGND	a_1549_74##6	7.22535e-20
C1184	VGND#18	a_1549_74##13	4.13908e-17
C1185	VPWR#4	a_2463_74##6	2.31713e-17
C1186	a_1747_118#	VNB	4.54526e-17
C1187	a_1348_368##13	a_697_113##8	3.01468e-18
C1188	a_1972_92##3	VNB	2.99823e-17
C1189	VGND	a_1972_92##6	6.19352e-18
C1190	VGND#13	SCE#5	6.98423e-19
C1191	VGND#17	VGND#5	3.56538e-20
C1192	a_1549_74##3	VNB	2.23962e-17
C1193	a_575_305##15	VGND#7	3.49342e-17
C1194	a_1348_368#	VNB	3.75292e-17
C1195	VGND	a_1747_118##2	3.99211e-18
C1196	a_1348_368##9	VNB	4.39896e-17
C1197	CLK#1	VNB	3.83814e-17
C1198	VGND	a_1972_92##2	3.59741e-18
C1199	Q_N#2	a_2463_74#	2.58131e-18
C1200	SCE#1	VNB	7.65559e-17
C1201	SCD#3	VNB	1.41141e-17
C1202	VGND	a_1348_368##6	5.13048e-20
C1203	SCE#2	VNB	7.00115e-17
C1204	a_161_394##6	a_161_394##2	1.42128e-18
C1205	a_667_87##3	VNB	4.54689e-17
C1206	VGND	a_1549_74##4	1.1793e-18
C1207	a_575_305##19	VPWR#3	4.81999e-17
C1208	a_575_305##3	VNB	2.95054e-17
C1209	a_161_394##3	VNB	2.51126e-17
C1210	VGND	a_1549_74##2	1.69555e-18
C1211	DE#7	VNB	3.80138e-17
C1212	DE#6	VNB	4.16401e-17
C1213	VGND	a_1348_368##5	2.898e-18
C1214	D#1	VNB	2.99945e-17
C1215	VGND	CLK#2	7.72975e-19
C1216	a_575_305##9	VNB	3.74167e-17
C1217	a_2463_74#	VNB	5.00034e-17
C1218	a_2463_74##6	VNB	2.88362e-17
C1219	D#1	DE#6	3.79733e-17
C1220	a_575_305##6	VNB	1.88185e-17
C1221	a_1549_74##8	VNB	3.98805e-17
C1222	a_667_87##5	SCE#2	4.77447e-19
C1223	a_1348_368##12	VNB	3.17387e-17
C1224	a_1972_92##7	VNB	4.21923e-17
C1225	a_1747_118##3	VNB	4.28697e-17
C1226	a_1972_92#	VNB	4.14881e-17
C1227	VPWR#17	DE#1	2.05186e-18
C1228	a_1348_368##7	VNB	2.15235e-17
C1229	a_1549_74#	VNB	2.16844e-17
C1230	SCD#2	SCE#1	5.11306e-18
C1231	DE#10	DE#7	2.43723e-18
C1232	a_1348_368##8	VNB	3.16064e-17
C1233	a_161_394#	VPWR#21	5.21118e-18
C1234	CLK#3	VNB	5.56293e-17
C1235	a_667_87##4	VNB	3.20749e-17
C1236	SCD#1	VNB	3.74775e-17
C1237	SCE#4	VNB	7.02299e-17
C1238	VGND#14	DE#1	1.25008e-18
C1239	SCE#5	VNB	6.94562e-17
C1240	D#4	a_27_90##6	4.37205e-17
C1241	a_575_305#	VNB	3.07158e-17
C1242	DE#1	VNB	4.69185e-17
C1243	DE#4	VNB	3.12296e-17
C1244	a_161_394##2	VNB	3.01548e-17
C1245	VGND#5	a_1348_368##10	1.38176e-19
C1246	D#3	VNB	3.9195e-17
C1247	a_2463_74##5	a_575_305##7	1.40108e-17
C1248	a_1747_118##2	a_1972_92##7	2.10676e-18
C1249	a_575_305##19	VNB	3.06983e-17
C1250	VPWR#5	a_1972_92##6	1.7336e-19
C1251	VPWR#3	VNB	1.78361e-16
C1252	a_2463_74##9	a_2463_74##4	4.29275e-18
C1253	VGND#3	VNB	1.85462e-16
C1254	VPWR#6	VNB	5.59312e-17
C1255	VGND#3	a_575_305##19	2.61861e-18
C1256	VGND#6	VNB	7.01664e-17
C1257	a_575_305##13	VNB	1.61221e-17
C1258	VPWR#17	VNB	3.21403e-16
C1259	VGND#13	VNB	3.64045e-16
C1260	a_575_305##8	VNB	4.98154e-17
C1261	a_697_113#	a_1549_74##17	3.19566e-18
C1262	a_2463_74##4	VNB	6.78674e-17
C1263	a_575_305##5	VNB	6.0722e-17
C1264	a_2463_74#	VPWR#7	3.34696e-17
C1265	a_1549_74##7	VNB	4.90656e-17
C1266	VPWR#19	DE#1	3.00749e-17
C1267	a_27_90##2	VPWR#18	3.5989e-17
C1268	a_1348_368##11	VNB	4.10748e-17
C1269	a_1549_74##6	VNB	3.04726e-17
C1270	a_1972_92##6	VNB	8.18065e-17
C1271	a_1747_118##2	VNB	6.23069e-17
C1272	VPWR#17	DE#4	1.51966e-18
C1273	a_667_87##7	SCD#2	1.30984e-19
C1274	a_1972_92##2	VNB	5.65915e-17
C1275	a_1348_368##6	VNB	6.28737e-17
C1276	a_1549_74##4	VNB	2.8324e-17
C1277	a_1549_74##2	VNB	4.68561e-17
C1278	a_1348_368##5	VNB	6.22651e-17
C1279	CLK#2	VNB	4.09827e-17
C1280	VGND#13	DE#1	1.55532e-18
C1281	a_667_87##5	VNB	4.86214e-17
C1282	SCD#2	VNB	5.86722e-17
C1283	SCE#3	VNB	5.45047e-17
C1284	a_1747_118##6	a_1549_74##3	9.86593e-18
C1285	a_575_305##2	VNB	6.60754e-17
C1286	a_161_394##4	VNB	4.83216e-17
C1287	DE#3	VNB	3.80966e-17
C1288	a_161_394#	VNB	7.07093e-17
C1289	D#2	VNB	8.61849e-17
C1290	SCE#2	SCD#2	1.25793e-17
C1291	a_1549_74##12	a_1549_74##11	3.3884e-18
C1292	a_575_305##19	VPWR#6	6.8836e-18
C1293	a_1348_368##13	a_1549_74##13	2.11235e-17
C1294	VPWR#4	VPWR#8	3.87151e-18
C1295	VPWR#17	a_161_394##2	5.80367e-19
C1296	VGND	CLK	1.8284e-18
C1297	a_575_305##8	Q_N#2	3.55976e-17
C1298	a_575_305##15	Q#3	6.75024e-17
C1299	VGND#4	a_1348_368##10	9.16868e-18
C1300	a_2463_74#	Q#1	3.58095e-17
C1301	CLK	VNB	5.54145e-18
C1302	SCD	VNB	7.62831e-18
C1303	D	VNB	1.70117e-18
C1304	VGND#4	a_1348_368##11	5.04183e-20
C1305	Q	VNB	1.98484e-17
C1306	a_161_394##6	D#3	5.64282e-19
C1307	VPWR	VNB	2.1739e-16
C1308	VGND	VNB	2.63601e-16
C1309	a_1972_92##2	a_1747_118##3	4.72147e-18
C1310	VPWR#20	a_161_394##2	6.9535e-18
C1311	VPWR#20	VNB	6.6032e-17
C1312	VPWR#20	D#2	1.65146e-19
C1313	VPWR#20	DE#4	7.03452e-19
C1314	VPWR#20	a_161_394#	1.08158e-19
C1315	VPWR#20	DE#1	6.93565e-20
C1316	VPWR#20	DE#3	1.86421e-20
C1317	VPWR#20	DE#5	7.51385e-20
C1318	VPWR#20	VPWR#18	3.73097e-19
C1319	VPWR#17	VPWR#20	1.23878e-16
C1320	a_575_305##13	a_667_87#	2.46817e-18
C1321	a_27_90##3	VPWR#20	6.04292e-17
C1322	VPWR#20	D#3	7.28725e-18
C1323	VPWR#2	a_2463_74##6	3.32236e-19
C1324	a_27_90##2	a_667_87#	7.28279e-19
C1325	VGND#2	a_2463_74##5	7.37818e-19
C1326	VGND#15	a_161_394##9	4.7629e-18
C1327	VGND#2	Q_N#1	2.07548e-17
C1328	a_667_87#	SCE#5	1.34723e-18
C1329	VGND#15	D#1	6.66968e-18
C1330	VGND#15	DE#5	7.55795e-19
C1331	VGND#15	D#2	4.35132e-19
C1332	a_27_90#	a_667_87#	7.48324e-19
C1333	VGND#20	a_667_87#	1.49084e-18
C1334	VGND#3	VGND#2	8.36066e-17
C1335	a_667_87#	SCE#2	2.72123e-17
C1336	a_667_87#	SCE#3	4.929e-17
C1337	Q	VPWR#2	2.13519e-18
C1338	VGND#13	VGND#15	1.42979e-16
C1339	VPWR#17	a_667_87#	2.25964e-20
C1340	VGND#2	a_2463_74##7	2.62074e-19
C1341	a_667_87#	VNB	1.52692e-16
C1342	a_575_305##8	VPWR#2	5.96264e-19
C1343	a_667_87#	SCE#6	2.44777e-17
C1344	a_575_305#	a_667_87#	7.04058e-19
C1345	VGND#2	VNB	4.47728e-17
C1346	VGND#4	VGND#2	3.60997e-19
C1347	a_667_87##10	a_667_87#	3.00443e-17
C1348	a_697_113##9	a_667_87#	5.63261e-19
C1349	a_667_87##3	a_667_87#	1.12657e-17
C1350	VPWR#3	VPWR#2	9.38553e-17
C1351	a_667_87#	SCE#1	3.78727e-19
C1352	VGND#15	a_27_90##6	1.98232e-17
C1353	a_667_87##5	a_667_87#	7.40155e-20
C1354	DE#10	a_667_87#	2.19882e-19
C1355	VGND#15	D#4	1.72015e-18
C1356	a_697_113##5	a_667_87#	1.03294e-17
C1357	VGND#13	a_667_87#	1.38041e-17
C1358	VGND#15	VNB	7.29059e-17
C1359	VPWR#4	VPWR#2	2.00987e-20
C1360	Q_N#2	VPWR#2	2.30911e-17
C1361	a_667_87##7	a_667_87#	2.06757e-17
C1362	a_667_87#	SCE#4	8.64031e-18
C1363	VPWR#2	VNB	4.42009e-17
C1364	VPWR#2	a_575_305##9	7.18467e-18
C1365	VGND#2	a_575_305##7	7.4207e-18
C1366	VGND#15	VGND#14	1.22421e-18
C1367	VGND#21	a_667_87#	8.47563e-19
C1368	a_697_113##7	a_667_87#	7.58028e-17
C1369	VGND#2	a_575_305##8	7.06254e-19
C1370	a_667_87#	SCD#3	1.06149e-19
C1371	a_575_305##2	a_667_87#	6.39128e-18
C1372	VPWR#2	a_2463_74#	7.73027e-18
C1373	VGND#2	a_575_305##15	1.31047e-17
C1374	a_667_87#	SCD#2	9.72366e-18
C1375	VGND#15	DE#6	3.20976e-18
C1376	VGND#15	a_161_394#	2.02368e-18
C1377	VGND#12	a_667_87#	1.52167e-18
C1378	VGND#2	a_2463_74##2	4.73511e-20
*
*
.ENDS sky130_fd_sc_hs__sedfxbp_1
*
