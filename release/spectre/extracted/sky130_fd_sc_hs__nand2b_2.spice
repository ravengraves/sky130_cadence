* Extracted by Quantus, converted by sky130cad/quantus.py
*
*
*
*                       LINUX           Wed Nov 18 08:45:32 2026
*
*
*
*  PROGRAM  advgen
*
*  Name           : advgen - Quantus - (64-bit)
*  Version        : 25.1.0-p047
*  Build Date     : Thu Dec 11 23:20:30 PST 2025
*
*  HSPICE LIBRARY
*
*  OPERATING_TEMPERATURE 150
*  QRC_TECH_DIR <path>/tech
*
*
*

*
.SUBCKT sky130_fd_sc_hs__nand2b_2 VPB VNB VGND VPWR Y A_N B
*
*
*  caps2d version: 10
*
*
*       TRANSISTOR CARDS
*
*
XM8 a_27_74##10 A_N#3 VGND#7 VNB sky130_fd_pr__nfet_01v8_lvt l=0.15 w=0.64 ad=0.1824 as=0.16675 pd=1.85 ps=1.81
XM3 Y#3 a_27_74##6 a_242_74##2 VNB sky130_fd_pr__nfet_01v8_lvt l=0.15 w=0.74 ad=0.2072 as=0.20635 pd=2.04 ps=2.05
XM9 a_242_74##4 a_27_74# Y#3 VNB sky130_fd_pr__nfet_01v8_lvt l=0.15 w=0.74 ad=0.2072 as=0.2072 pd=2.04 ps=2.04
XM4 VGND#6 B#7 a_242_74##4 VNB sky130_fd_pr__nfet_01v8_lvt l=0.15 w=0.74 ad=0.2109 as=0.2072 pd=2.05 ps=2.04
XM5 a_242_74# B#1 VGND#6 VNB sky130_fd_pr__nfet_01v8_lvt l=0.15 w=0.74 ad=0.2109 as=0.2109 pd=2.05 ps=2.05
XM0 a_27_74##8 A_N#1 VPWR#7 VPB sky130_fd_pr__pfet_01v8 l=0.15 w=1 ad=0.295 as=0.9226 pd=2.59 ps=3.94
XM6 VPWR#7 a_27_74##7 Y#2 VPB sky130_fd_pr__pfet_01v8 l=0.15 w=1.12 ad=0.9226 as=0.336 pd=3.94 ps=2.84
XM1 Y#2 a_27_74##5 VPWR#6 VPB sky130_fd_pr__pfet_01v8 l=0.15 w=1.12 ad=0.336 as=0.336 pd=2.84 ps=2.84
XM7 VPWR#6 B#5 Y#1 VPB sky130_fd_pr__pfet_01v8 l=0.15 w=1.12 ad=0.336 as=0.336 pd=2.84 ps=2.84
XM2 Y#1 B#6 VPWR#1 VPB sky130_fd_pr__pfet_01v8 l=0.15 w=1.12 ad=0.336 as=0.3304 pd=2.84 ps=2.83
*
*
*       RESISTOR AND CAP/DIODE CARDS
*
Rg1	A_N#1	A_N#2	406.597473
Rg2	A_N#2	A_N#3	411.232849
Rg3	a_27_74#	a_27_74##2	353.734253
Rg4	a_27_74##2	a_27_74##3	193.186951
Rg5	a_27_74##3	a_27_74##4	381.039856
Rg6	a_27_74##2	a_27_74##5	517.475891
Rg7	a_27_74##3	a_27_74##6	367.091797
Rg8	a_27_74##3	a_27_74##7	517.148193
Rg9	B#1	B#2	397.555725
Rg10	B#2	B#3	30.596949
Rg11	B#3	B#4	22.738756
Rg12	B#4	B#5	450.639984
Rg13	B#2	B#6	449.655212
Rg14	B#4	B#7	399.275177
Rf1	A_N#4	A_N	2.217604
Rf2	A_N#2	A_N#6	162.450409
Rf3	A_N#4	A_N#6	5.042445
Rf4	a_27_74##8	a_27_74##4	102.650299
Rf5	a_27_74##4	a_27_74##10	68.592316
Rf6	B#3	B	166.137894
Rf7	Y#1	Y	38.767288
Rf8	Y	Y#2	29.972971
Rf9	Y	Y#3	87.241310
Rf10	a_242_74#	a_242_74##3	363.445374
Rf11	a_242_74##3	a_242_74##4	86.128647
Rf12	a_242_74##2	a_242_74##3	7.500000
Rf13	VPWR#1	VPWR#2	94.406776
Rf14	VPWR#2	VPWR#3	36.500717
Rf15	VPWR#3	VPWR#4	56.204002
Rf17	VPWR#2	VPWR#6	32.342297
Rf18	VPWR#4	VPWR#7	37.169037
Rf20	VGND#2	VGND#3	70.591774
Rf21	VGND#3	VGND#4	68.326958
Rf23	VGND#2	VGND#6	56.430489
Rf24	VGND#4	VGND#7	44.122520
Re1	VPWR#3	VPWR	1.403190
Re2	VGND	VGND#3	1.403242
*
*       CAPACITOR CARDS
*
*
C1	VGND	VNB	6.55471e-17
C2	VPWR	VNB	5.96146e-17
C3	Y	VNB	5.24093e-18
C4	A_N	VNB	2.29634e-17
C5	B	VNB	5.1601e-18
C6	VGND	Y	3.55062e-18
C7	VGND	A_N	1.61153e-18
C8	VPWR	Y	3.3069e-18
C9	VGND	B	2.61475e-18
C10	A_N#2	VNB	5.42242e-17
C11	a_27_74##4	VNB	5.04173e-17
C12	VPWR	A_N	1.55245e-18
C13	VGND#3	a_27_74##2	3.11279e-20
C14	VGND#3	VNB	1.82857e-16
C15	VPWR	B	2.55966e-18
C16	VPWR#3	VNB	1.7166e-16
C17	VGND	A_N#2	1.56308e-18
C18	A_N#1	VNB	4.88763e-17
C19	Y	B	4.50078e-17
C20	a_27_74##7	VNB	4.32983e-17
C21	VGND	a_27_74##4	1.17086e-17
C22	a_27_74##5	VNB	3.57954e-17
C23	VGND#3	a_27_74##3	4.27267e-20
C24	B#5	VNB	2.90093e-17
C25	VGND	VGND#3	1.70925e-17
C26	B#6	VNB	3.4964e-17
C27	VPWR	A_N#2	1.47411e-18
C28	A_N#3	VNB	4.43299e-17
C29	a_27_74##6	VNB	3.30548e-17
C30	VPWR	a_27_74##4	3.80773e-18
C31	a_27_74#	VNB	2.75941e-17
C32	B#7	VNB	3.15863e-17
C33	B#1	VNB	3.58289e-17
C34	a_27_74##8	VNB	4.46565e-17
C35	Y#2	VNB	4.02226e-19
C36	VPWR	VPWR#3	1.5976e-17
C37	VPWR#6	VNB	3.25422e-20
C38	Y#1	VNB	1.60855e-19
C39	A_N	A_N#2	1.10746e-17
C40	VPWR#1	VNB	4.55226e-17
C41	a_27_74##10	VNB	4.16564e-17
C42	VPWR	A_N#1	9.40336e-18
C43	VGND	A_N#3	1.18579e-18
C44	VGND#7	VNB	5.26665e-18
C45	a_242_74##2	VNB	1.63677e-17
C46	VPWR	a_27_74##7	7.17297e-19
C47	VGND	a_27_74##6	3.02425e-18
C48	Y#3	VNB	2.40149e-18
C49	VGND	a_27_74#	1.29033e-18
C50	a_242_74##4	VNB	3.49273e-18
C51	VPWR	a_27_74##5	3.42184e-19
C52	VGND	B#7	3.6698e-18
C53	VGND#6	VNB	5.38789e-18
C54	VPWR	B#5	2.8193e-19
C55	a_242_74#	VNB	9.7608e-17
C56	VGND	B#1	5.32909e-18
C57	VPWR	B#6	2.72121e-19
C58	VGND	Y#2	2.56023e-18
C59	Y	a_27_74##7	4.44596e-19
C60	Y	a_27_74##5	9.39548e-18
C61	VPWR#2	VNB	2.9006e-17
C62	Y	B#5	1.09763e-17
C63	VGND	a_27_74##10	1.62474e-17
C64	Y	B#6	5.30677e-19
C65	VGND	a_242_74##2	2.08078e-17
C66	VGND	Y#3	5.47611e-18
C67	VPWR	a_27_74##8	1.67679e-17
C68	VGND	a_242_74##4	2.22293e-17
C69	VPWR	Y#2	2.599e-18
C70	VGND	a_242_74#	1.60851e-17
C71	VPWR	VPWR#6	1.56408e-17
C72	VPWR	Y#1	2.37725e-18
C73	Y	B#7	2.07546e-18
C74	VPWR	VPWR#1	3.56047e-17
C75	A_N#2	a_27_74##4	6.17179e-17
C76	B	a_27_74##5	3.18243e-19
C77	Y	B#1	8.00311e-19
C78	B	B#5	8.27141e-19
C79	VPWR	a_242_74##2	1.57352e-17
C80	B	B#6	1.18451e-19
C81	VPWR	Y#3	1.55745e-18
C82	Y	Y#2	1.44677e-18
C83	Y	VPWR#6	1.32461e-18
C84	VPWR	a_242_74#	1.31796e-17
C85	VPWR#3	a_27_74##2	4.55917e-20
C86	A_N	a_27_74##8	1.9048e-17
C87	VGND#3	a_27_74##4	8.60138e-21
C88	Y	a_242_74##2	2.94427e-17
C89	VPWR#3	a_27_74##3	4.81799e-20
C90	A_N#2	A_N#1	3.45757e-18
C91	a_242_74##4	Y	2.61034e-17
C92	VPWR	VPWR#2	2.48412e-17
C93	A_N#2	a_27_74##7	1.23745e-18
C94	Y	a_242_74#	1.79844e-17
C95	a_27_74##10	A_N	1.81983e-17
C96	a_27_74##4	A_N#1	1.38327e-18
C97	a_27_74##4	a_27_74##7	3.6434e-18
C98	B	Y#1	2.87522e-17
C99	VPWR#3	a_27_74##7	8.39477e-18
C100	VGND#6	B	2.08406e-17
C101	A_N#3	a_27_74##4	6.40353e-18
C102	B	a_242_74#	2.67553e-17
C103	a_27_74##2	VNB	2.27976e-17
C104	a_27_74##3	VNB	2.21425e-17
C105	VPWR#3	a_27_74##5	2.37852e-18
C106	B#4	VNB	6.08001e-17
C107	a_27_74##4	a_27_74##6	6.37389e-18
C108	A_N#1	a_27_74##7	6.8619e-18
C109	A_N#2	a_27_74##8	2.57007e-17
C110	Y#2	a_27_74##2	1.18621e-18
C111	a_27_74##4	a_27_74##8	2.61781e-18
C112	VGND#3	a_27_74##6	4.43631e-18
C113	a_27_74##7	a_27_74##5	5.53122e-17
C114	a_27_74##4	VPWR#7	2.97111e-17
C115	VGND#3	a_27_74#	4.43631e-18
C116	Y#2	a_27_74##3	1.53486e-18
C117	a_27_74##10	A_N#2	2.74689e-17
C118	a_27_74##5	B#5	4.63688e-17
C119	a_242_74##2	A_N#2	7.95486e-19
C120	a_27_74##4	VGND#7	2.88636e-17
C121	B#5	B#6	4.89689e-17
C122	VGND	a_27_74##2	7.53842e-19
C123	VGND	a_27_74##3	2.08095e-18
C124	a_27_74##4	a_242_74##2	8.4066e-17
C125	VGND	B#4	2.26453e-19
C126	Y#3	a_27_74##4	2.87498e-19
C127	a_27_74##8	A_N#1	5.61207e-17
C128	A_N#1	VPWR#7	1.81516e-17
C129	VPWR#3	VPWR#1	2.73915e-17
C130	VGND#3	a_242_74##2	3.58157e-17
C131	a_27_74##8	a_27_74##7	1.66319e-18
C132	a_27_74##7	VPWR#7	4.17361e-17
C133	VPWR#6	A_N#1	1.14473e-18
C134	VGND#3	a_242_74##4	2.85591e-17
C135	a_27_74##3	a_27_74##2	8.66904e-18
C136	a_27_74##7	Y#2	2.30195e-17
C137	a_242_74##2	VPWR#3	5.57457e-18
C138	VPWR#7	a_27_74##5	1.30496e-18
C139	A_N#3	a_27_74##6	3.71889e-18
C140	VPWR#6	a_27_74##7	4.58993e-18
C141	VPWR	a_27_74##3	1.57089e-19
C142	Y#2	a_27_74##5	3.70876e-17
C143	VPWR#7	B#5	5.32956e-19
C144	VPWR#6	a_27_74##5	3.92267e-17
C145	a_27_74##6	a_27_74#	4.0127e-17
C146	VPWR#7	B#6	4.96165e-19
C147	a_242_74##2	A_N#1	2.24222e-18
C148	VPWR#6	B#5	3.53289e-17
C149	Y#1	B#5	3.19615e-17
C150	a_242_74##2	a_27_74##7	4.02411e-17
C151	a_27_74#	B#7	3.99122e-17
C152	VPWR#6	B#6	4.86006e-18
C153	VPWR#1	B#5	4.4359e-18
C154	Y#1	B#6	3.76823e-17
C155	a_242_74##2	a_27_74##5	1.73712e-17
C156	VPWR#1	B#6	2.776e-17
C157	B#7	B#1	4.06637e-17
C158	Y	a_27_74##2	1.42163e-17
C159	Y	a_27_74##3	5.48301e-19
C160	B#4	Y#1	3.31602e-18
C161	VPWR#3	VPWR#2	3.51685e-17
C162	a_242_74#	a_27_74##7	2.15497e-19
C163	Y	B#4	9.76267e-18
C164	a_242_74##2	B#5	2.05209e-19
C165	a_242_74##2	B#6	2.59488e-19
C166	a_242_74#	a_27_74##5	2.48443e-19
C167	a_27_74##10	A_N#3	4.89689e-17
C168	a_27_74##5	B#4	4.86218e-18
C169	a_242_74#	B#5	1.70971e-17
C170	A_N#3	VGND#7	2.83643e-17
C171	a_27_74##8	VPWR#7	4.37802e-17
C172	a_27_74##2	B#4	2.47099e-17
C173	a_27_74##10	a_27_74##6	7.2427e-19
C174	a_242_74##2	A_N#3	7.04301e-18
C175	a_242_74#	B#6	3.31755e-17
C176	VGND#7	a_27_74##6	1.9936e-18
C177	a_242_74##2	a_27_74##6	6.67389e-17
C178	a_27_74##6	Y#3	1.82409e-17
C179	VPWR#7	VPWR#6	3.87244e-18
C180	a_242_74##2	a_27_74#	1.6774e-18
C181	a_242_74##4	a_27_74##6	1.5522e-18
C182	VPWR#2	a_27_74##5	1.56702e-18
C183	a_27_74#	Y#3	1.5348e-17
C184	VGND#6	a_27_74##6	2.80455e-19
C185	a_242_74##4	a_27_74#	4.75169e-17
C186	a_27_74##10	a_27_74##8	1.15083e-18
C187	VPWR#2	B#5	3.96325e-18
C188	Y#3	B#7	3.14864e-19
C189	VGND#6	a_27_74#	6.49408e-19
C190	B	a_27_74##2	1.08673e-18
C191	a_242_74##4	B#7	4.80431e-17
C192	Y#3	B#1	1.34097e-19
C193	B	B#4	2.4746e-17
C194	a_27_74##8	a_242_74##2	2.05013e-18
C195	B#7	VGND#6	2.07622e-17
C196	VPWR#6	VPWR#1	9.08114e-18
C197	a_242_74##4	B#1	1.79751e-18
C198	a_242_74#	B#7	1.62373e-18
C199	a_242_74##2	VPWR#7	3.66396e-17
C200	B#1	VGND#6	1.79937e-17
C201	VPWR#2	B#4	7.2501e-20
C202	a_242_74##2	Y#2	7.73939e-17
C203	a_242_74#	B#1	3.7773e-17
C204	Y#3	Y#2	9.63725e-18
C205	a_242_74##2	VPWR#6	2.84999e-17
C206	a_242_74##2	a_27_74##2	8.60718e-19
C207	a_27_74##10	VGND#7	4.57694e-17
C208	a_242_74##2	a_27_74##3	2.05527e-17
C209	a_27_74##10	a_242_74##2	5.26752e-18
C210	a_242_74#	VPWR#6	1.48373e-17
C211	VGND#7	a_242_74##2	3.01973e-17
C212	a_242_74#	Y#1	5.78815e-17
C213	a_242_74##2	B#4	5.17843e-19
C214	Y#3	a_27_74##2	8.33612e-18
C215	a_242_74#	VPWR#1	4.75548e-17
C216	a_242_74##2	Y#3	6.31425e-17
C217	Y#3	a_27_74##3	3.29327e-18
C218	a_242_74##2	a_242_74##4	4.33427e-18
C219	a_242_74##4	Y#3	4.83671e-17
C220	a_242_74##2	a_242_74#	8.35582e-19
C221	Y#3	VGND#6	2.18432e-18
C222	a_242_74##4	a_27_74##2	3.02006e-19
C223	a_242_74##4	VGND#6	6.94798e-17
C224	VGND#6	a_242_74#	6.1097e-17
C225	A_N#2	a_27_74##3	1.05929e-18
C226	VPWR#2	VPWR#1	1.32001e-18
C227	a_27_74##4	a_27_74##3	2.1459e-18
C228	a_27_74##2	B#7	4.42109e-19
C229	VGND#6	B#4	4.4076e-18
C230	a_242_74##2	VPWR#2	5.40568e-19
C231	a_242_74#	a_27_74##2	1.55606e-19
C232	a_242_74#	B#4	1.50231e-17
C233	a_242_74#	VPWR#2	4.23103e-18
C234	VGND#4	a_242_74##2	1.11903e-17
C235	a_242_74##2	VPWR#4	9.57105e-19
C236	VGND#4	A_N#3	8.25101e-18
C237	VPWR#4	a_27_74##5	1.29491e-18
C238	VPWR#4	VNB	6.25074e-17
C239	VGND#4	a_27_74##10	2.10084e-17
C240	VGND#2	B#1	1.05603e-17
C241	a_27_74##8	VPWR#4	1.7276e-17
C242	VPWR#4	A_N#2	6.42603e-20
C243	VPWR#4	VPWR#2	6.57372e-19
C244	VPWR#4	VPWR#6	4.01522e-18
C245	VGND#2	a_27_74#	6.28125e-19
C246	VPWR#4	a_27_74##3	2.46442e-20
C247	VGND#2	VNB	4.75762e-17
C248	VPWR#4	A_N#1	1.13789e-17
C249	VGND#4	VGND#2	2.50007e-19
C250	VGND#2	A_N#3	6.68708e-20
C251	VGND#4	VNB	5.1244e-17
C252	VGND#4	B#7	2.313e-20
C253	VGND#2	B	5.33424e-19
C254	VGND#4	a_27_74##6	1.43683e-18
C255	VGND#3	VGND#2	5.19445e-17
C256	VGND#4	A_N#2	1.12895e-19
C257	VPWR#4	VPWR#7	2.27368e-18
C258	VPWR#4	a_27_74##4	7.34968e-19
C259	VPWR#3	VPWR#4	5.75846e-17
C260	VGND#2	B#7	6.82568e-18
C261	VPWR#4	a_27_74##7	6.64369e-18
C262	VGND	VGND#2	4.36034e-17
C263	VGND#2	a_242_74#	2.07774e-17
C264	VPWR	VPWR#4	6.14617e-17
C265	VGND#2	a_27_74##6	2.10147e-19
C266	VGND	VGND#4	4.99913e-17
C267	VGND#4	B#1	3.45231e-20
C268	VGND#2	a_242_74##4	1.93421e-17
C269	VGND#3	VGND#4	5.34983e-17
C270	VGND#4	a_27_74#	1.63252e-19
C271	VGND#4	a_27_74##4	3.17801e-18
*
*
.ENDS sky130_fd_sc_hs__nand2b_2
*
