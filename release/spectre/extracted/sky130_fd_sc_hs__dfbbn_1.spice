* Extracted by Quantus, converted by sky130cad/quantus.py
*
*
*
*                       LINUX           Wed Nov 18 08:25:55 2026
*
*
*
*  PROGRAM  advgen
*
*  Name           : advgen - Quantus - (64-bit)
*  Version        : 25.1.0-p047
*  Build Date     : Thu Dec 11 23:20:30 PST 2025
*
*  HSPICE LIBRARY
*
*  OPERATING_TEMPERATURE 150
*  QRC_TECH_DIR <path>/tech
*
*
*

*
.SUBCKT sky130_fd_sc_hs__dfbbn_1 VPB VNB VGND SET_B VPWR Q Q_N D CLK_N RESET_B
*
*
*  caps2d version: 10
*
*
*       TRANSISTOR CARDS
*
*
XM37 a_27_74##12 CLK_N#3 VGND#16 VNB sky130_fd_pr__nfet_01v8_lvt l=0.15 w=0.74 ad=0.2109 as=0.2072 pd=2.05 ps=2.04
XM11 VGND#16 a_27_74##3 a_200_74##14 VNB sky130_fd_pr__nfet_01v8_lvt l=0.15 w=0.74 ad=0.2072 as=0.2109 pd=2.04 ps=2.05
XM18 a_311_119##4 D#3 VGND#15 VNB sky130_fd_pr__nfet_01v8_lvt l=0.15 w=0.42 ad=0.1197 as=0.275875 pd=1.41 ps=2.26
XM30 VGND#15 a_474_405# a_523_119# VNB sky130_fd_pr__nfet_01v8_lvt l=0.15 w=0.42 ad=0.275875 as=0.0882 pd=2.26 ps=1.26
XM31 a_523_119# a_27_74##5 a_595_119##7 VNB sky130_fd_pr__nfet_01v8_lvt l=0.15 w=0.42 ad=0.0882 as=0.1176 pd=1.26 ps=1.4
XM1 a_595_119##7 a_200_74##3 a_311_119##2 VNB sky130_fd_pr__nfet_01v8_lvt l=0.15 w=0.42 ad=0.1176 as=0.40005 pd=1.4 ps=2.58
XM20 a_867_119##2 a_595_119# a_474_405##14 VNB sky130_fd_pr__nfet_01v8_lvt l=0.15 w=0.55 ad=0.15675 as=0.1925 pd=1.67 ps=1.8
XM19 a_474_405##14 a_978_357# a_867_119# VNB sky130_fd_pr__nfet_01v8_lvt l=0.15 w=0.55 ad=0.1925 as=0.1925 pd=1.8 ps=1.8
XM27 a_867_119# SET_B#1 VGND#14 VNB sky130_fd_pr__nfet_01v8_lvt l=0.15 w=0.55 ad=0.1925 as=0.1925 pd=1.8 ps=1.8
XM38 VGND#14 a_474_405##6 a_1254_119# VNB sky130_fd_pr__nfet_01v8_lvt l=0.15 w=0.55 ad=0.1925 as=0.183125 pd=1.8 ps=1.8
XM22 a_1254_119# a_27_74##7 a_1349_114##6 VNB sky130_fd_pr__nfet_01v8_lvt l=0.15 w=0.55 ad=0.183125 as=0.62825 pd=1.8 ps=3.42
XM33 a_1349_114##6 a_200_74##7 a_1611_140# VNB sky130_fd_pr__nfet_01v8_lvt l=0.15 w=0.42 ad=0.62825 as=0.1008 pd=3.42 ps=1.32
XM8 a_1611_140# a_1534_446# VGND#13 VNB sky130_fd_pr__nfet_01v8_lvt l=0.15 w=0.42 ad=0.1008 as=0.2991 pd=1.32 ps=2.47
XM23 VGND#13 SET_B#4 a_1818_76##2 VNB sky130_fd_pr__nfet_01v8_lvt l=0.15 w=0.74 ad=0.2991 as=0.2072 pd=2.47 ps=2.04
XM35 a_1818_76##2 a_978_357##6 a_1534_446##10 VNB sky130_fd_pr__nfet_01v8_lvt l=0.15 w=0.74 ad=0.2072 as=0.2368 pd=2.04 ps=2.12
XM2 a_1534_446##10 a_1349_114##3 a_1818_76# VNB sky130_fd_pr__nfet_01v8_lvt l=0.15 w=0.74 ad=0.2368 as=0.296 pd=2.12 ps=2.52
XM24 a_978_357##7 RESET_B#3 VGND#12 VNB sky130_fd_pr__nfet_01v8_lvt l=0.15 w=0.42 ad=0.1134 as=0.34405 pd=1.38 ps=2.77
XM5 VGND#12 a_1534_446##8 Q_N#1 VNB sky130_fd_pr__nfet_01v8_lvt l=0.15 w=0.74 ad=0.34405 as=0.1998 pd=2.77 ps=2.02
XM36 a_2412_410##8 a_1534_446##4 VGND#11 VNB sky130_fd_pr__nfet_01v8_lvt l=0.15 w=0.42 ad=0.1134 as=0.2313 pd=1.38 ps=2.17
XM29 VGND#11 a_2412_410# Q#3 VNB sky130_fd_pr__nfet_01v8_lvt l=0.15 w=0.74 ad=0.2313 as=0.1998 pd=2.17 ps=2.02
XM15 a_27_74##11 CLK_N#1 VPWR#20 VPB sky130_fd_pr__pfet_01v8 l=0.15 w=1.12 ad=0.3192 as=0.336 pd=2.81 ps=2.84
XM0 VPWR#20 a_27_74# a_200_74##12 VPB sky130_fd_pr__pfet_01v8 l=0.15 w=1.12 ad=0.336 as=0.3136 pd=2.84 ps=2.8
XM3 a_311_119##6 D#1 VPWR#19 VPB sky130_fd_pr__pfet_01v8 l=0.15 w=0.42 ad=0.17805 as=0.189 pd=1.75 ps=1.74
XM6 VPWR#19 a_474_405##3 a_537_503# VPB sky130_fd_pr__pfet_01v8 l=0.15 w=0.42 ad=0.189 as=0.1134 pd=1.74 ps=1.38
XM13 a_537_503# a_200_74# a_595_119##5 VPB sky130_fd_pr__pfet_01v8 l=0.15 w=0.42 ad=0.1134 as=0.1512 pd=1.38 ps=1.56
XM9 a_595_119##5 a_27_74##6 a_311_119# VPB sky130_fd_pr__pfet_01v8 l=0.15 w=0.42 ad=0.1512 as=0.1704 pd=1.56 ps=1.72
XM39 a_474_405##10 a_595_119##4 a_933_424# VPB sky130_fd_pr__pfet_01v8 l=0.15 w=0.84 ad=0.2352 as=0.2016 pd=2.24 ps=2.16
XM28 a_933_424# a_978_357##3 VPWR#18 VPB sky130_fd_pr__pfet_01v8 l=0.15 w=0.84 ad=0.2016 as=0.252 pd=2.16 ps=2.28
XM34 VPWR#18 SET_B#3 a_474_405##13 VPB sky130_fd_pr__pfet_01v8 l=0.15 w=0.84 ad=0.252 as=0.2352 pd=2.28 ps=2.24
XM17 VPWR#17 a_474_405##4 a_1297_424# VPB sky130_fd_pr__pfet_01v8 l=0.15 w=0.84 ad=0.2352 as=0.2016 pd=2.24 ps=2.16
XM25 a_1297_424# a_200_74##5 a_1349_114##7 VPB sky130_fd_pr__pfet_01v8 l=0.15 w=0.84 ad=0.2016 as=0.2877 pd=2.16 ps=2.46
XM4 a_1349_114##7 a_27_74##8 a_1483_508# VPB sky130_fd_pr__pfet_01v8 l=0.15 w=0.42 ad=0.2877 as=0.1134 pd=2.46 ps=1.38
XM10 a_1483_508# a_1534_446##3 VPWR#16 VPB sky130_fd_pr__pfet_01v8 l=0.15 w=0.42 ad=0.1134 as=0.250675 pd=1.38 ps=2.14
XM32 a_1534_446##14 SET_B#6 VPWR#15 VPB sky130_fd_pr__pfet_01v8 l=0.15 w=1 ad=0.295 as=0.53815 pd=2.59 ps=3.41
XM21 VPWR#15 a_978_357##4 a_1917_392# VPB sky130_fd_pr__pfet_01v8 l=0.15 w=1 ad=0.53815 as=0.27 pd=3.41 ps=2.54
XM12 a_1917_392# a_1349_114# a_1534_446##12 VPB sky130_fd_pr__pfet_01v8 l=0.15 w=1 ad=0.27 as=0.28 pd=2.54 ps=2.56
XM14 a_978_357##11 RESET_B#1 VPWR#14 VPB sky130_fd_pr__pfet_01v8 l=0.15 w=0.64 ad=0.1792 as=0.3768 pd=1.84 ps=2.99
XM7 VPWR#14 a_1534_446##9 Q_N#2 VPB sky130_fd_pr__pfet_01v8 l=0.15 w=1.12 ad=0.3768 as=0.3136 pd=2.99 ps=2.8
XM26 a_2412_410##7 a_1534_446##7 VPWR#13 VPB sky130_fd_pr__pfet_01v8 l=0.15 w=0.84 ad=0.2394 as=0.3948 pd=2.25 ps=2.99
XM16 VPWR#13 a_2412_410##4 Q#1 VPB sky130_fd_pr__pfet_01v8 l=0.15 w=1.12 ad=0.3948 as=0.3192 pd=2.99 ps=2.81
*
*
*       RESISTOR AND CAP/DIODE CARDS
*
Rg1	CLK_N#1	CLK_N#2	448.815094
Rg2	CLK_N#2	CLK_N#3	345.814911
Rg3	D#1	D#2	613.831787
Rg4	D#2	D#3	275.848572
Rg5	a_474_405#	a_474_405##2	745.014160
Rg6	a_474_405##2	a_474_405##3	250.144562
Rg7	a_200_74#	a_200_74##2	233.787552
Rg8	a_200_74##3	a_200_74##4	216.119781
Rg9	a_595_119#	a_595_119##2	386.408234
Rg10	a_595_119##2	a_595_119##3	268.778473
Rg11	a_595_119##2	a_595_119##4	506.661285
Rg12	a_978_357#	a_978_357##2	299.329773
Rg13	a_978_357##2	a_978_357##3	489.885803
Rg14	SET_B#1	SET_B#2	477.838928
Rg15	SET_B#2	SET_B#3	392.021393
Rg16	a_474_405##4	a_474_405##5	371.262421
Rg17	a_474_405##5	a_474_405##6	495.472443
Rg18	a_200_74##5	a_200_74##6	367.623138
Rg19	a_27_74#	a_27_74##2	456.846832
Rg20	a_27_74##2	a_27_74##3	353.846649
Rg21	a_27_74##3	a_27_74##4	1382.779419
Rg22	a_27_74##4	a_27_74##5	322.957550
Rg23	a_27_74##5	a_27_74##6	1291.804565
Rg24	a_27_74##4	a_27_74##7	2473.117188
Rg25	a_27_74##7	a_27_74##8	1274.033325
Rg26	a_200_74##7	a_200_74##8	242.848938
Rg27	a_1534_446#	a_1534_446##2	735.071716
Rg28	a_1534_446##2	a_1534_446##3	287.235870
Rg29	SET_B#4	SET_B#5	317.183502
Rg30	SET_B#5	SET_B#6	491.267609
Rg31	a_978_357##4	a_978_357##5	513.659058
Rg32	a_978_357##5	a_978_357##6	320.356293
Rg33	a_1349_114#	a_1349_114##2	422.415131
Rg34	a_1349_114##2	a_1349_114##3	416.971466
Rg35	RESET_B#1	RESET_B#2	296.912354
Rg36	RESET_B#2	RESET_B#3	259.159424
Rg37	a_1534_446##4	a_1534_446##5	526.151550
Rg38	a_1534_446##5	a_1534_446##6	139.487274
Rg39	a_1534_446##5	a_1534_446##7	553.725464
Rg40	a_1534_446##6	a_1534_446##8	347.615448
Rg41	a_1534_446##6	a_1534_446##9	448.445038
Rg42	a_2412_410#	a_2412_410##2	343.038818
Rg43	a_2412_410##2	a_2412_410##3	36.503117
Rg44	a_2412_410##2	a_2412_410##4	491.849670
Rf1	CLK_N#4	CLK_N#2	161.469666
Rf2	CLK_N	CLK_N#6	1.236861
Rf3	CLK_N#4	CLK_N#6	7.059660
Rf4	a_27_74##2	a_27_74##10	165.173401
Rf5	a_27_74##10	a_27_74##11	87.301407
Rf6	a_27_74##10	a_27_74##12	80.905365
Rf7	D	D#2	162.988510
Rf8	a_200_74##4	a_200_74##10	169.530640
Rf9	a_200_74##10	a_200_74##11	23.502920
Rf10	a_200_74##11	a_200_74##13	222.437225
Rf11	a_200_74##13	a_200_74##14	95.507690
Rf12	a_200_74##11	a_200_74##2	180.574249
Rf13	a_200_74##12	a_200_74##13	5.000000
Rf14	a_595_119##5	a_595_119##6	107.318192
Rf15	a_595_119##6	a_595_119##7	90.685387
Rf16	a_595_119##6	a_595_119##3	169.201584
Rf17	a_311_119#	a_311_119##3	192.200089
Rf18	a_311_119##3	a_311_119##5	173.214828
Rf19	a_311_119##5	a_311_119##6	140.189270
Rf20	a_311_119##2	a_311_119##3	15.000000
Rf21	a_311_119##4	a_311_119##5	15.000000
Rf22	a_867_119#	a_867_119##2	126.138664
Rf23	SET_B#2	SET_B#8	167.821945
Rf24	a_474_405##5	a_474_405##8	220.397491
Rf25	a_474_405##8	a_474_405##9	70.383659
Rf26	a_474_405##9	a_474_405##11	26.766069
Rf27	a_474_405##11	a_474_405##2	343.092041
Rf28	a_474_405##8	a_474_405##13	13.666845
Rf29	a_474_405##9	a_474_405##14	120.662384
Rf30	a_474_405##10	a_474_405##11	7.500000
Rf31	a_200_74##8	a_200_74##17	188.453308
Rf32	a_200_74##17	a_200_74##6	177.481522
Rf33	SET_B#5	SET_B	194.418289
Rf34	a_1349_114##2	a_1349_114##5	355.455536
Rf35	a_1349_114##5	a_1349_114##6	97.062325
Rf36	a_1349_114##5	a_1349_114##7	98.304443
Rf37	a_1818_76#	a_1818_76##2	109.323425
Rf38	a_978_357##7	a_978_357##8	36.647942
Rf39	a_978_357##8	a_978_357##9	70.567238
Rf40	a_978_357##9	a_978_357##2	568.840454
Rf41	a_978_357##8	a_978_357##11	97.883690
Rf42	a_978_357##9	a_978_357##5	171.670013
Rf43	RESET_B#4	RESET_B#2	160.996811
Rf44	RESET_B	RESET_B#6	0.764007
Rf45	RESET_B#4	RESET_B#6	5.905091
Rf46	a_1534_446##10	a_1534_446##11	181.154770
Rf47	a_1534_446##11	a_1534_446##13	141.359116
Rf48	a_1534_446##13	a_1534_446##15	100.598137
Rf49	a_1534_446##15	a_1534_446##2	212.024078
Rf50	a_1534_446##12	a_1534_446##13	7.500000
Rf51	a_1534_446##14	a_1534_446##15	15.000000
Rf52	Q_N#1	Q_N	84.532700
Rf53	Q_N	Q_N#3	13.585999
Rf54	Q_N#3	Q_N	0.186110
Rf55	Q_N#2	Q_N#3	5.000000
Rf56	a_2412_410##3	a_2412_410##6	172.456345
Rf57	a_2412_410##6	a_2412_410##7	61.029316
Rf58	a_2412_410##6	a_2412_410##8	57.785145
Rf59	Q	Q#2	0.194040
Rf60	Q#2	Q	14.164948
Rf61	Q	Q#4	7.179494
Rf62	Q#4	Q	7.179494
Rf63	Q#1	Q#2	5.000000
Rf64	Q#3	Q#4	7.500000
Rf66	VGND#2	VGND#3	108.488266
Rf67	VGND#3	VGND#4	83.253036
Rf68	VGND#4	VGND#5	93.602676
Rf69	VGND#5	VGND#6	206.075912
Rf70	VGND#6	VGND#7	191.367767
Rf71	VGND#7	VGND#8	82.686989
Rf72	VGND#8	VGND#9	110.786896
Rf74	VGND#2	VGND#11	40.352859
Rf75	VGND#3	VGND#12	25.059351
Rf76	VGND#5	VGND#13	50.781399
Rf77	VGND#6	VGND#14	45.924004
Rf78	VGND#8	VGND#15	30.038048
Rf79	VGND#9	VGND#16	36.279022
Rf81	VPWR#2	VPWR#3	107.392517
Rf82	VPWR#3	VPWR#4	82.522530
Rf83	VPWR#4	VPWR#5	64.259903
Rf84	VPWR#5	VPWR#6	81.201447
Rf85	VPWR#6	VPWR#7	138.911331
Rf86	VPWR#7	VPWR#8	71.540421
Rf87	VPWR#8	VPWR#9	134.753632
Rf88	VPWR#9	VPWR#10	71.687523
Rf89	VPWR#10	VPWR#11	121.459908
Rf91	VPWR#2	VPWR#13	48.259808
Rf92	VPWR#3	VPWR#14	32.342297
Rf93	VPWR#5	VPWR#15	22.500479
Rf94	VPWR#6	VPWR#16	21.813175
Rf95	VPWR#7	VPWR#17	33.326477
Rf96	VPWR#8	VPWR#18	33.326477
Rf97	VPWR#10	VPWR#19	52.972916
Rf98	VPWR#11	VPWR#20	53.143215
Rf115	a_1534_446##6	a_1534_446##11	160.232803
Re1	a_200_74##17	a_200_74##10	25.946058
Re3	SET_B	SET_B#8	15.344948
Re4	VPWR#4	VPWR	1.989084
Re5	VPWR	VPWR#9	1.989084
Re6	VGND#4	VGND	1.989084
Re7	VGND	VGND#7	1.989084
*
*       CAPACITOR CARDS
*
*
C1	a_27_74##12	CLK_N#2	5.78863e-18
C2	VGND#4	Q_N#1	1.98162e-17
C3	SET_B#5	a_27_74##7	6.72831e-20
C4	a_27_74##7	a_474_405##6	4.95763e-17
C5	a_978_357##5	a_978_357##8	6.65242e-18
C6	a_867_119#	SET_B#1	3.88882e-17
C7	VGND#16	a_27_74##4	1.90385e-19
C8	a_1349_114##7	a_27_74##8	7.49158e-17
C9	VPWR#9	a_27_74##10	2.92936e-18
C10	VGND#7	a_200_74##11	5.87522e-18
C11	VGND#6	a_474_405##5	1.88047e-19
C12	VGND#4	VGND#12	2.03621e-17
C13	VPWR#17	a_1534_446##3	1.51985e-19
C14	a_474_405##3	a_200_74#	2.46829e-17
C15	VPWR#5	VPWR#15	6.01079e-18
C16	a_27_74##10	a_200_74##14	5.30473e-17
C17	a_27_74##7	a_1534_446##2	1.90548e-19
C18	a_27_74##7	SET_B#1	2.11336e-17
C19	a_200_74##8	a_1534_446#	2.19218e-17
C20	a_474_405##14	SET_B#1	1.76225e-18
C21	a_978_357##9	a_27_74##7	2.29594e-18
C22	VPWR#4	a_200_74##5	8.94691e-19
C23	VGND#4	a_978_357##7	3.19095e-18
C24	VGND#3	a_1534_446##10	3.37604e-18
C25	a_595_119##5	a_200_74##4	5.2446e-20
C26	a_1349_114##7	a_1349_114##5	5.74882e-19
C27	a_978_357##9	SET_B#5	3.60674e-17
C28	a_1349_114##7	a_200_74##5	4.18653e-17
C29	a_978_357#	a_867_119#	2.02903e-17
C30	a_1534_446##14	VPWR#6	1.89354e-17
C31	VGND#4	a_1818_76#	7.07351e-17
C32	VPWR#17	a_27_74##8	3.74303e-19
C33	VGND#5	a_1818_76##2	3.19783e-17
C34	a_200_74##8	a_27_74##7	3.71659e-17
C35	SET_B#1	a_474_405##6	2.94655e-17
C36	a_27_74##7	a_978_357#	1.91835e-17
C37	VGND#7	a_27_74##10	5.59849e-18
C38	a_867_119##2	SET_B#1	4.46172e-19
C39	a_200_74##6	a_1534_446#	9.35468e-20
C40	D#1	a_474_405##3	1.17769e-17
C41	a_474_405##10	VPWR#18	1.53457e-17
C42	a_2412_410##3	a_1534_446##7	3.85661e-18
C43	a_311_119##4	a_27_74#	1.23662e-20
C44	VGND#4	a_1534_446##10	2.48274e-17
C45	a_27_74##10	a_200_74##12	4.65637e-17
C46	a_1349_114##5	SET_B#5	1.94843e-17
C47	Q_N#1	a_2412_410##6	3.51095e-17
C48	a_474_405##14	a_978_357#	3.77586e-17
C49	a_27_74##10	VGND#16	2.47689e-17
C50	a_200_74##2	a_595_119##5	3.57048e-17
C51	a_1349_114##5	VPWR#6	1.36408e-18
C52	VPWR#8	a_595_119##3	2.22724e-20
C53	a_1349_114##7	a_474_405##4	7.52521e-18
C54	a_27_74##7	a_200_74##6	2.41793e-17
C55	VGND#4	a_1818_76##2	3.81035e-17
C56	a_474_405##2	a_474_405##10	1.13878e-18
C57	a_1534_446##14	VPWR#5	4.74161e-17
C58	VPWR#17	a_200_74##5	3.06339e-18
C59	a_1349_114##5	a_27_74##7	4.80992e-19
C60	a_867_119#	a_595_119#	1.50709e-18
C61	a_1349_114##6	a_200_74##17	6.22078e-17
C62	a_27_74#	D#1	5.70355e-18
C63	SET_B#8	a_200_74##5	2.33925e-18
C64	a_978_357##9	a_1534_446##2	1.59542e-19
C65	a_1534_446##6	a_1534_446##9	2.17277e-17
C66	a_867_119##2	a_978_357#	1.42247e-18
C67	VGND#4	VGND#13	7.88918e-20
C68	a_1534_446##5	a_2412_410##4	1.89266e-18
C69	a_200_74##11	a_27_74##4	2.6115e-19
C70	a_474_405##2	a_595_119##5	3.35055e-17
C71	a_978_357#	SET_B#1	2.4537e-17
C72	a_27_74##7	a_474_405##5	1.70698e-18
C73	SET_B#8	a_474_405##4	1.15633e-18
C74	a_1534_446##6	RESET_B#1	3.63357e-18
C75	VPWR#6	VPWR#16	3.11987e-18
C76	a_474_405##14	a_595_119#	2.02445e-17
C77	a_1349_114##7	SET_B#3	2.41e-19
C78	a_27_74##10	VPWR#20	2.00909e-17
C79	VGND#7	CLK_N#4	3.35985e-18
C80	a_978_357##8	RESET_B#4	1.98637e-17
C81	VPWR#17	a_474_405##4	3.28502e-17
C82	RESET_B#2	a_1534_446##9	5.10642e-19
C83	VPWR#8	a_595_119##2	1.1276e-19
C84	a_1349_114##5	a_1534_446##2	1.03942e-16
C85	a_200_74##17	VGND#14	1.37434e-17
C86	a_311_119##2	a_978_357#	1.72202e-19
C87	a_474_405##2	VPWR#19	6.06551e-17
C88	a_1534_446##6	a_1349_114#	1.81736e-19
C89	SET_B#8	SET_B#3	6.42809e-18
C90	VGND#6	a_978_357##2	4.27488e-17
C91	CLK_N#1	a_27_74#	4.86413e-17
C92	VPWR#4	VPWR#7	2.11648e-17
C93	VGND#4	a_1349_114##6	1.92251e-17
C94	SET_B#1	a_474_405##5	2.61186e-18
C95	a_27_74##7	SET_B#2	7.77784e-19
C96	a_867_119##2	a_595_119#	3.66233e-17
C97	a_474_405##8	a_200_74##5	2.10712e-18
C98	a_1534_446##12	a_1917_392#	3.74777e-18
C99	a_200_74##17	a_867_119#	1.14122e-17
C100	a_978_357##2	a_1534_446#	1.26098e-19
C101	a_1534_446##6	a_978_357##4	5.89738e-20
C102	a_1534_446##4	a_1534_446##7	1.3319e-18
C103	a_1349_114##2	a_1534_446##9	6.56999e-20
C104	SET_B#8	a_978_357##3	4.22092e-18
C105	a_2412_410##6	a_1534_446##5	2.94061e-17
C106	a_200_74##12	a_474_405##2	3.6504e-18
C107	VPWR#4	VPWR#6	1.08975e-16
C108	a_978_357##9	a_200_74##8	7.727e-19
C109	a_978_357##2	a_200_74##7	6.72737e-19
C110	VPWR#17	SET_B#3	2.61242e-18
C111	a_474_405##14	a_200_74##3	7.94733e-20
C112	a_474_405##10	a_311_119#	1.05324e-16
C113	a_200_74##17	a_474_405##14	5.20505e-18
C114	a_1349_114##2	RESET_B#1	1.37251e-18
C115	a_2412_410##6	VPWR#13	3.13088e-18
C116	VPWR#5	a_1534_446##9	3.63446e-19
C117	SET_B#8	a_595_119##4	2.54904e-19
C118	a_27_74##10	a_27_74##11	1.62206e-18
C119	VPWR#18	a_474_405##4	5.32446e-19
C120	a_595_119#	a_978_357#	2.42106e-17
C121	a_978_357##2	a_27_74##7	5.11861e-17
C122	a_311_119##2	a_595_119#	6.36374e-18
C123	VPWR#4	VPWR#5	7.01859e-17
C124	a_311_119##6	D#2	2.73722e-18
C125	a_474_405##9	a_474_405##4	2.16599e-19
C126	CLK_N#4	a_27_74##10	2.46814e-17
C127	a_1349_114##2	a_1349_114#	1.28002e-17
C128	a_200_74##17	a_867_119##2	1.60089e-20
C129	SET_B#3	a_474_405##13	1.49045e-17
C130	SET_B#8	a_1349_114##6	5.32778e-19
C131	a_1349_114##5	a_200_74##8	6.35885e-17
C132	a_978_357##2	a_474_405##6	1.73812e-17
C133	a_200_74##12	D#2	1.06355e-18
C134	a_867_119##2	a_200_74##3	4.61073e-19
C135	VPWR#3	a_1534_446##9	3.91793e-18
C136	VPWR#4	VPWR#3	8.37371e-17
C137	VPWR#9	a_978_357##3	7.64081e-19
C138	a_1349_114##2	a_978_357##4	2.71774e-17
C139	a_978_357##2	SET_B#1	2.54837e-17
C140	a_474_405##10	a_595_119##5	3.17791e-17
C141	a_474_405##8	a_474_405##4	1.33182e-17
C142	a_595_119##7	a_595_119#	4.07791e-19
C143	a_2412_410##7	VPWR#13	7.87686e-17
C144	a_2412_410##3	VGND#11	2.07658e-17
C145	VPWR#18	SET_B#3	3.4396e-17
C146	a_200_74##10	a_27_74##6	2.17722e-18
C147	a_978_357##2	a_978_357#	2.15668e-19
C148	VPWR#9	a_595_119##4	1.66025e-18
C149	a_1349_114##2	SET_B#6	3.23904e-18
C150	a_1349_114##7	VPWR#7	1.35013e-17
C151	a_474_405##10	a_474_405##4	1.34188e-19
C152	a_200_74##3	a_311_119##2	1.67848e-17
C153	a_200_74##12	a_27_74##2	4.36773e-18
C154	a_595_119#	a_978_357##2	9.74389e-19
C155	a_200_74##3	a_595_119#	1.66092e-18
C156	VPWR#9	a_27_74##6	4.15097e-18
C157	a_474_405##9	SET_B#3	1.50194e-18
C158	a_867_119##2	a_27_74##5	4.82491e-20
C159	a_595_119##5	a_311_119#	4.63342e-17
C160	VPWR#18	a_978_357##3	3.24237e-17
C161	a_1349_114##7	a_1483_508#	2.4111e-20
C162	a_200_74##6	a_1349_114##5	1.47414e-18
C163	SET_B#5	a_978_357##4	2.09097e-19
C164	VPWR#9	a_200_74#	3.97716e-18
C165	Q_N#2	VPWR#13	2.51037e-18
C166	a_595_119##7	a_200_74##3	3.34123e-17
C167	a_474_405##10	SET_B#3	2.34714e-19
C168	a_1349_114##7	VPWR#6	1.6097e-17
C169	a_1534_446##2	a_1349_114#	2.85863e-19
C170	a_474_405##14	SET_B#8	2.23376e-18
C171	a_200_74##12	CLK_N#2	1.14341e-19
C172	a_474_405##8	SET_B#3	3.17057e-17
C173	VPWR#3	RESET_B#1	2.15579e-18
C174	a_311_119##2	a_27_74##5	1.26392e-17
C175	VPWR#9	a_474_405##3	2.52462e-18
C176	a_1534_446##2	a_978_357##4	4.10498e-19
C177	a_474_405##2	VPWR#10	2.4286e-17
C178	a_1534_446##9	a_1534_446##5	1.41566e-18
C179	CLK_N#2	a_27_74##11	4.07047e-18
C180	a_27_74##5	a_595_119##3	1.10861e-18
C181	VPWR#18	a_595_119##4	3.73917e-18
C182	a_200_74##4	a_595_119#	8.5587e-19
C183	a_1534_446##2	SET_B#6	2.25338e-17
C184	a_27_74##5	a_200_74##3	2.63605e-17
C185	a_474_405##10	a_978_357##3	3.6229e-18
C186	Q_N#2	a_2412_410##7	9.02895e-17
C187	Q_N#1	a_1534_446##6	8.30548e-17
C188	VPWR#14	VPWR#13	1.30592e-18
C189	a_311_119##4	a_595_119#	6.84005e-20
C190	SET_B#5	a_27_74##8	7.06287e-21
C191	a_474_405##9	a_978_357##3	2.74494e-17
C192	a_595_119##7	a_27_74##5	1.83608e-17
C193	Q_N#2	a_2412_410##6	3.42415e-17
C194	CLK_N#4	a_27_74##12	3.5912e-17
C195	a_474_405##9	a_27_74##7	4.90829e-21
C196	VPWR#9	a_27_74#	4.21705e-18
C197	a_1534_446##2	a_1534_446##3	1.0158e-17
C198	a_200_74##10	a_474_405##14	3.91511e-17
C199	a_1349_114##5	a_474_405##5	7.62685e-21
C200	VPWR#5	a_1349_114#	2.21949e-18
C201	a_1534_446##6	VGND#12	5.4638e-17
C202	a_27_74##5	a_200_74##4	3.1564e-17
C203	a_311_119##2	a_474_405#	5.17812e-18
C204	a_474_405##8	a_978_357##3	7.6142e-19
C205	a_27_74##8	a_1534_446##2	2.78226e-17
C206	VPWR#9	CLK_N#1	1.12951e-18
C207	a_200_74##10	a_867_119##2	6.54461e-18
C208	a_1534_446##6	a_978_357##7	2.32209e-17
C209	a_474_405##10	a_595_119##4	4.82703e-17
C210	a_474_405##10	a_27_74##4	3.42501e-20
C211	SET_B#8	VPWR#8	8.22161e-19
C212	VPWR#3	a_1534_446##5	4.09467e-19
C213	a_474_405##8	a_27_74##7	1.57627e-19
C214	VGND#4	a_200_74##17	1.39073e-17
C215	SET_B#8	VPWR#4	8.46983e-18
C216	a_311_119##4	a_200_74##3	6.15088e-19
C217	a_27_74##5	a_200_74##2	2.58385e-17
C218	a_595_119##7	a_474_405#	2.59871e-18
C219	a_200_74##10	a_311_119##2	5.16744e-17
C220	VPWR#10	D#2	1.15466e-19
C221	a_474_405#	a_27_74##5	6.56014e-17
C222	a_474_405##8	a_1349_114##7	1.595e-17
C223	SET_B#8	VPWR#7	4.72839e-18
C224	a_311_119#	a_595_119##4	7.87472e-18
C225	VPWR#4	a_2412_410##7	1.43371e-17
C226	a_200_74##17	SET_B#8	7.69251e-17
C227	a_474_405##9	a_595_119##4	1.54839e-17
C228	VGND#15	a_27_74##5	1.80232e-19
C229	VPWR#6	a_978_357##4	3.17787e-19
C230	a_311_119##2	D#3	2.31816e-19
C231	a_595_119##7	a_200_74##10	5.11991e-17
C232	a_978_357##9	a_1349_114##5	6.79596e-18
C233	a_474_405##10	a_27_74##6	1.71188e-17
C234	a_474_405##10	a_595_119##2	4.13782e-19
C235	a_200_74##6	a_27_74##8	2.61728e-17
C236	SET_B#8	VPWR#6	2.91718e-19
C237	a_474_405##2	a_27_74##5	2.47234e-17
C238	VPWR#4	Q_N#2	2.06903e-17
C239	a_978_357##7	RESET_B#2	2.59641e-18
C240	a_474_405##8	a_595_119##4	2.01129e-19
C241	VPWR#14	Q_N#2	2.89653e-17
C242	VPWR#5	a_978_357##4	1.3465e-17
C243	a_200_74##17	VGND#6	4.92839e-18
C244	VGND#7	a_867_119#	2.45985e-17
C245	a_311_119##4	a_27_74##5	5.41596e-18
C246	Q_N#2	a_1534_446##5	9.63772e-18
C247	a_27_74##6	a_311_119#	1.35951e-17
C248	VPWR#4	VPWR#14	1.7734e-17
C249	a_474_405##5	a_27_74##8	7.01698e-20
C250	VGND#3	a_1534_446##8	7.35069e-18
C251	a_2412_410#	Q#3	7.35092e-18
C252	VGND#8	a_474_405##2	8.05516e-20
C253	VPWR#17	VPWR#6	3.21142e-19
C254	a_474_405#	VGND#15	1.59335e-17
C255	VGND#7	a_474_405##14	8.06802e-18
C256	a_474_405##10	a_200_74#	1.94494e-19
C257	D#3	a_474_405#	1.28293e-17
C258	a_311_119##2	a_27_74##3	7.60438e-20
C259	a_474_405##9	a_474_405##5	1.67574e-18
C260	a_27_74##3	a_27_74##5	2.88293e-20
C261	a_474_405##5	a_200_74##5	2.65667e-18
C262	VGND#6	a_867_119#	5.82187e-17
C263	a_1534_446##10	RESET_B#2	4.88711e-19
C264	a_595_119##5	a_27_74##6	2.52399e-17
C265	D#2	a_474_405#	3.13803e-17
C266	VGND#7	a_200_74##17	3.8781e-17
C267	VPWR#4	a_978_357##11	5.2376e-18
C268	a_474_405##9	a_27_74##6	3.04596e-19
C269	a_200_74##14	a_27_74##5	3.59038e-20
C270	VPWR#4	a_2412_410##3	2.64816e-18
C271	a_311_119##4	a_200_74##10	3.52578e-18
C272	a_311_119#	a_27_74##4	3.12734e-19
C273	VGND#7	a_867_119##2	5.53337e-17
C274	VGND#4	VPWR#13	3.4062e-18
C275	VGND#6	a_978_357##9	1.6734e-17
C276	a_474_405##5	a_474_405##4	6.8603e-18
C277	VPWR#6	SET_B#6	2.15911e-18
C278	SET_B#8	VPWR#9	3.69796e-17
C279	a_311_119##4	a_474_405#	2.0455e-17
C280	a_2412_410#	VGND#11	1.71194e-17
C281	a_1534_446##12	VPWR#4	6.56801e-17
C282	a_474_405##14	a_474_405##9	5.72446e-19
C283	VPWR#4	a_1534_446##6	5.18945e-18
C284	a_2412_410##6	a_2412_410##4	1.41814e-18
C285	a_200_74##10	a_200_74##14	1.47728e-18
C286	a_27_74##3	D#2	6.82033e-19
C287	SET_B#3	a_474_405##5	1.93003e-18
C288	VGND#7	a_311_119##2	1.54818e-16
C289	a_867_119#	VGND#14	5.39003e-17
C290	a_27_74##4	a_595_119##2	9.87799e-19
C291	a_474_405##10	a_474_405##3	1.10429e-19
C292	VGND#16	a_27_74##5	2.27388e-20
C293	a_1818_76#	a_1349_114##2	3.7887e-19
C294	D#3	VGND#15	1.80468e-17
C295	VPWR#9	a_200_74##10	7.61327e-19
C296	VGND#4	a_2412_410##3	4.35384e-18
C297	a_595_119##5	a_200_74#	1.65672e-17
C298	VGND#4	VGND#6	3.68411e-17
C299	a_474_405##5	a_978_357##3	2.52745e-19
C300	VPWR#5	SET_B#6	1.11325e-17
C301	a_474_405##9	VPWR#8	3.73391e-18
C302	VGND#7	a_595_119##7	8.11519e-18
C303	a_311_119#	a_595_119##2	3.28465e-18
C304	VPWR#9	VPWR#10	8.11073e-17
C305	a_200_74##14	a_474_405#	4.1827e-19
C306	VGND#4	Q_N#2	8.10657e-19
C307	a_1534_446##10	a_1349_114##2	5.7472e-19
C308	VGND#3	RESET_B#3	1.72371e-18
C309	a_1534_446##12	Q_N#2	1.39876e-18
C310	a_27_74##3	D#3	1.07993e-17
C311	a_27_74##3	a_27_74##2	7.43549e-19
C312	a_474_405##5	a_595_119##4	1.48489e-19
C313	a_2412_410##6	a_2412_410#	1.43066e-18
C314	a_2412_410##8	a_2412_410#	1.76529e-18
C315	VGND#7	a_200_74##10	5.37487e-17
C316	a_474_405##9	SET_B#2	9.3955e-19
C317	a_474_405##8	VPWR#17	6.31901e-17
C318	VGND#4	a_1534_446##6	1.80356e-17
C319	VGND#4	VGND#5	1.25677e-16
C320	VPWR#4	a_2412_410##6	5.33987e-20
C321	a_978_357##3	SET_B#2	1.0686e-17
C322	VPWR#4	a_1349_114##2	1.18656e-17
C323	a_311_119##4	D#3	3.16564e-17
C324	VPWR#9	VPWR#8	8.84616e-17
C325	a_474_405##8	SET_B#2	3.82192e-18
C326	a_1534_446##4	VGND#11	1.55728e-17
C327	VGND#5	a_978_357##9	5.66211e-17
C328	a_595_119##5	a_474_405##3	1.82309e-18
C329	VGND#4	VGND#3	7.81772e-17
C330	VGND#7	VGND#15	1.87327e-17
C331	VPWR#4	a_1534_446##14	2.23399e-17
C332	VGND#15	a_27_74##3	8.89366e-19
C333	VPWR#4	a_978_357##5	3.71935e-18
C334	VPWR#9	VPWR#7	6.31839e-17
C335	a_200_74##12	VPWR#19	4.70769e-17
C336	VGND#5	a_1349_114##3	4.75835e-19
C337	VPWR#6	a_1534_446##3	1.59387e-17
C338	a_2412_410##6	a_1534_446##7	7.00605e-18
C339	a_200_74##14	D#3	3.32495e-18
C340	a_1534_446##12	VPWR#14	1.75874e-17
C341	VGND#4	a_1349_114##2	4.31207e-18
C342	VGND#7	a_311_119##4	1.66767e-17
C343	a_595_119##4	a_978_357##2	3.76586e-18
C344	a_978_357##5	a_1534_446##10	9.02233e-19
C345	a_595_119##6	a_595_119##4	1.55738e-19
C346	a_2412_410##8	a_1534_446##4	2.11178e-17
C347	a_311_119##4	a_27_74##3	7.71421e-18
C348	CLK_N#3	a_27_74##3	4.23753e-17
C349	VPWR#5	a_1534_446##3	5.44439e-19
C350	VPWR#7	a_27_74##7	8.22018e-19
C351	a_474_405##8	a_474_405##13	6.58697e-18
C352	a_978_357##2	a_474_405##9	8.83452e-18
C353	VGND#7	a_200_74##14	2.01688e-17
C354	VGND#4	a_978_357##5	3.81028e-19
C355	a_474_405##8	VPWR#8	7.77142e-18
C356	a_867_119##2	a_474_405##10	3.84591e-19
C357	a_978_357##5	a_1818_76##2	1.0445e-18
C358	a_200_74##17	SET_B#5	2.4354e-18
C359	VPWR#19	a_474_405##3	7.98795e-18
C360	a_200_74##12	a_311_119##6	1.38112e-16
C361	a_2412_410##6	a_1534_446##4	7.31909e-18
C362	a_867_119#	a_474_405##14	3.63748e-17
C363	VGND#16	D#3	3.76377e-19
C364	VPWR#4	a_1534_446##2	5.84618e-18
C365	VGND#12	a_2412_410#	3.32007e-19
C366	VGND#11	a_1534_446##8	9.17458e-19
C367	a_311_119#	a_474_405##14	8.8657e-18
C368	a_978_357##2	a_474_405##8	8.78387e-18
C369	VPWR#8	VPWR#7	1.28023e-18
C370	VGND#4	SET_B#5	3.44895e-18
C371	a_474_405##9	VPWR#18	1.44519e-17
C372	VGND#6	a_867_119##2	2.781e-17
C373	a_27_74##6	a_595_119##3	1.3635e-17
C374	a_1534_446##12	a_978_357##11	4.86445e-17
C375	a_27_74##3	a_200_74##14	3.7671e-17
C376	VPWR#4	a_1349_114##7	2.6981e-17
C377	Q_N#1	a_1534_446##4	3.61485e-18
C378	VPWR#4	a_200_74##8	1.35179e-18
C379	VPWR#6	a_27_74##7	1.68092e-20
C380	VGND#7	a_27_74##12	1.5941e-17
C381	a_200_74##6	a_595_119##2	2.68269e-20
C382	a_27_74##12	D#3	6.43218e-20
C383	VGND#5	a_978_357##6	2.61819e-18
C384	D#1	VPWR#19	1.67104e-17
C385	a_2412_410##6	a_1534_446##9	1.58921e-19
C386	a_200_74##17	a_200_74##8	1.16464e-20
C387	VGND#8	a_311_119##2	1.93649e-17
C388	a_200_74##4	a_27_74##6	1.92499e-17
C389	a_2412_410##8	a_1534_446##8	2.1819e-18
C390	VPWR#6	a_27_74##8	7.10029e-18
C391	a_595_119##6	a_27_74##6	2.16107e-17
C392	VPWR#4	a_200_74##6	8.99598e-19
C393	a_200_74##12	a_474_405##3	1.80653e-18
C394	a_1349_114##6	a_978_357##5	1.69755e-18
C395	VGND#16	a_27_74##3	3.22677e-17
C396	a_867_119##2	a_867_119#	5.65142e-18
C397	VGND#4	a_200_74##8	4.43851e-18
C398	a_474_405##8	VPWR#18	4.33176e-17
C399	a_474_405##8	VPWR#7	9.04792e-18
C400	VGND#12	a_1534_446##4	1.24266e-18
C401	RESET_B#2	a_1534_446##6	3.03765e-17
C402	D#1	a_311_119##6	1.21316e-17
C403	a_200_74##10	VGND#6	4.68929e-20
C404	a_200_74##17	a_1349_114##7	1.34205e-17
C405	a_27_74##6	a_200_74##2	3.19334e-17
C406	VGND#13	SET_B#5	1.32146e-18
C407	a_200_74##14	CLK_N#3	1.49418e-18
C408	a_2412_410##6	a_1534_446##8	3.66087e-19
C409	a_474_405##2	a_595_119##4	1.46861e-19
C410	VPWR#20	a_200_74##12	5.85517e-17
C411	VGND#4	a_2412_410##6	7.52172e-20
C412	Q_N#1	a_1534_446##8	4.31431e-17
C413	a_1534_446##6	a_1349_114##2	8.3344e-20
C414	a_27_74##12	a_27_74##3	9.1599e-19
C415	a_200_74##17	a_474_405##5	7.10163e-18
C416	a_200_74##12	D#1	2.61204e-17
C417	D	a_27_74##4	7.62569e-19
C418	a_474_405##10	VPWR#8	2.26749e-17
C419	a_311_119##2	a_311_119#	9.32016e-19
C420	a_474_405##2	a_27_74##6	1.44706e-18
C421	SET_B#8	a_200_74##6	1.85047e-17
C422	a_1349_114##7	a_27_74##7	2.887e-19
C423	VPWR#7	a_200_74##5	7.65955e-18
C424	a_1349_114##2	RESET_B#2	1.10434e-17
C425	VGND#16	CLK_N#3	2.84178e-17
C426	a_1349_114#	a_1917_392#	2.06346e-17
C427	a_1349_114##6	SET_B#5	1.14073e-18
C428	a_311_119##6	a_27_74#	1.13922e-18
C429	a_474_405##2	a_200_74#	1.52787e-17
C430	a_200_74##17	SET_B#2	2.32074e-20
C431	VPWR#4	a_1534_446##5	1.14315e-18
C432	a_867_119##2	a_474_405##14	3.20526e-17
C433	VGND#4	a_1349_114##7	2.52843e-18
C434	a_978_357##4	a_1917_392#	2.06346e-17
C435	VGND#5	SET_B#4	7.42128e-18
C436	SET_B#8	a_474_405##5	6.5229e-17
C437	a_978_357##5	RESET_B#2	3.48235e-19
C438	a_1534_446##8	VGND#12	1.81794e-17
C439	a_27_74##11	a_200_74##12	3.07596e-18
C440	a_474_405##2	a_474_405##3	1.1102e-17
C441	a_200_74##11	a_27_74##6	7.90021e-18
C442	a_2412_410##3	VPWR#13	2.52843e-17
C443	VPWR#6	a_200_74##5	3.09949e-19
C444	a_474_405##9	a_27_74##4	3.32249e-20
C445	a_200_74##12	a_27_74#	6.65099e-17
C446	a_200_74##17	a_978_357##2	1.10056e-16
C447	VPWR#9	a_200_74##6	1.2018e-18
C448	a_27_74##12	CLK_N#3	2.5581e-17
C449	D#1	a_474_405##2	2.76229e-17
C450	a_978_357##5	a_1349_114##2	7.13322e-17
C451	RESET_B#4	a_978_357##7	1.66154e-17
C452	SET_B#8	SET_B#2	2.72027e-17
C453	a_1818_76#	a_1534_446##4	2.73197e-19
C454	Q_N#1	RESET_B#3	6.19558e-19
C455	a_2412_410##8	VGND#11	3.28583e-17
C456	VGND#4	a_978_357##2	7.89873e-18
C457	a_474_405##2	a_27_74#	2.3917e-19
C458	a_27_74#	VPWR#20	1.88053e-17
C459	a_200_74##17	VPWR#18	2.78593e-18
C460	SET_B#5	a_1349_114##2	5.76702e-18
C461	SET_B#8	a_1349_114##7	1.82175e-17
C462	a_978_357##7	a_1534_446##8	1.28541e-18
C463	a_978_357##2	SET_B#8	5.43343e-17
C464	a_1349_114##6	a_1534_446##2	6.19037e-19
C465	a_27_74##11	VPWR#20	5.3053e-17
C466	a_311_119##2	a_474_405##14	5.05572e-17
C467	a_311_119##4	a_523_119#	2.29349e-20
C468	a_595_119##6	a_595_119##3	2.11469e-17
C469	a_200_74##12	CLK_N#1	3.415e-18
C470	Q_N#1	Q_N#2	3.2572e-18
C471	VPWR#9	SET_B#2	6.93057e-20
C472	a_27_74#	D#2	1.72199e-18
C473	SET_B#5	a_978_357##5	6.35371e-17
C474	a_1349_114##2	a_1534_446##2	2.80809e-19
C475	a_200_74##10	a_978_357##2	5.57385e-18
C476	VPWR#7	VPWR#6	2.88686e-19
C477	a_1534_446##7	a_2412_410##4	3.62912e-17
C478	a_27_74##11	a_27_74#	2.64567e-18
C479	a_27_74##8	a_1483_508#	8.37912e-18
C480	RESET_B#3	VGND#12	5.99792e-18
C481	VPWR#7	a_474_405##4	4.41255e-18
C482	VPWR#9	a_978_357##2	7.84686e-18
C483	a_474_405##10	a_474_405##8	1.5631e-18
C484	a_200_74##7	a_1611_140#	7.46858e-18
C485	CLK_N#1	VPWR#20	2.9432e-17
C486	a_474_405##9	a_595_119##2	1.47785e-18
C487	VGND#5	a_1534_446#	2.04229e-18
C488	a_200_74##10	a_595_119##3	6.79186e-18
C489	a_1818_76#	a_1534_446##8	8.32679e-19
C490	Q_N#1	a_1349_114##3	5.22317e-19
C491	a_474_405##14	a_27_74##4	2.24876e-18
C492	SET_B#8	VPWR#17	3.51183e-18
C493	VGND#7	VGND#8	8.41777e-17
C494	VGND#7	a_978_357##2	1.98806e-17
C495	VPWR#6	a_474_405##4	1.44146e-19
C496	a_1534_446##9	a_2412_410##4	2.22034e-19
C497	a_1534_446##14	a_1534_446##12	1.45473e-18
C498	a_1534_446##2	SET_B#5	5.52745e-18
C499	a_978_357##5	a_200_74##8	1.66371e-19
C500	Q_N#2	a_1534_446##6	8.71302e-17
C501	VPWR#9	a_595_119##3	8.65994e-20
C502	a_1349_114##6	a_200_74##8	6.3398e-17
C503	a_311_119#	a_474_405##9	3.5411e-17
C504	a_311_119##2	a_867_119##2	8.54466e-17
C505	a_978_357##7	RESET_B#3	2.38827e-17
C506	a_27_74##11	CLK_N#1	6.07234e-17
C507	a_200_74##10	a_200_74##4	1.74987e-17
C508	a_200_74##5	a_1297_424#	1.97507e-17
C509	VGND#7	VGND#6	1.41356e-16
C510	SET_B#8	a_474_405##13	7.74559e-19
C511	VGND#7	a_595_119##3	4.30277e-19
C512	SET_B#5	a_200_74##8	1.51758e-18
C513	a_595_119##6	a_200_74##4	1.08073e-17
C514	a_474_405##4	a_1297_424#	1.97507e-17
C515	a_1534_446##6	VPWR#14	3.02111e-17
C516	VPWR#9	a_200_74##4	2.49795e-19
C517	VPWR#8	SET_B#3	1.78006e-18
C518	VGND#12	a_1349_114##3	2.29968e-18
C519	a_200_74##10	a_200_74##2	1.93338e-18
C520	a_1534_446##9	a_1534_446##7	1.02617e-17
C521	a_200_74##8	a_1534_446##2	9.19374e-18
C522	VPWR#4	a_1349_114##5	6.92272e-18
C523	a_595_119##6	a_595_119#	1.75825e-19
C524	a_978_357##11	a_1534_446##6	1.17468e-17
C525	VPWR#9	a_200_74##2	5.50314e-18
C526	a_474_405##14	a_595_119##2	1.07149e-17
C527	Q_N#1	a_978_357##6	2.45924e-19
C528	a_200_74##10	a_474_405##2	1.67029e-18
C529	Q_N#1	a_2412_410##8	4.88136e-17
C530	VGND#12	VGND#11	7.73955e-19
C531	a_200_74##6	a_1534_446##2	1.33391e-19
C532	a_1534_446##6	VPWR#3	4.65934e-19
C533	a_2412_410##4	Q#1	1.16721e-17
C534	a_1534_446##6	a_1534_446##12	5.13914e-19
C535	a_200_74##17	a_978_357##9	2.04963e-19
C536	VGND#5	a_200_74##7	2.03052e-18
C537	a_27_74##7	a_1254_119#	1.21066e-17
C538	a_474_405##2	VPWR#9	5.61889e-17
C539	VGND#4	RESET_B#4	4.32072e-18
C540	a_978_357##3	a_933_424#	1.405e-17
C541	a_200_74##10	D#2	1.22023e-19
C542	Q	a_1534_446##5	1.78077e-18
C543	a_595_119##4	a_933_424#	1.76065e-17
C544	VPWR#9	VPWR#17	1.03755e-17
C545	a_200_74##2	a_595_119##6	1.79989e-17
C546	VGND#12	a_978_357##6	1.92088e-19
C547	RESET_B#2	a_978_357##11	4.5946e-18
C548	a_2412_410##4	VPWR#13	2.72737e-17
C549	RESET_B#1	a_1534_446##9	2.4754e-17
C550	a_867_119##2	a_27_74##4	1.74319e-17
C551	a_1534_446##14	VPWR#15	4.68488e-18
C552	SET_B#8	a_311_119#	2.39078e-18
C553	VGND#4	a_1534_446##5	1.42729e-18
C554	a_200_74##11	D#1	7.51744e-18
C555	a_474_405##5	a_200_74##6	6.1501e-17
C556	a_595_119##6	a_200_74##3	2.06549e-19
C557	a_1818_76#	a_1349_114##3	3.92044e-17
C558	a_200_74##17	a_1349_114##5	9.12419e-19
C559	VGND#6	a_27_74##7	5.7074e-17
C560	a_978_357##11	RESET_B#4	1.65359e-18
C561	a_1534_446##12	RESET_B#2	5.07983e-19
C562	a_27_74##4	a_978_357##2	2.47734e-19
C563	VPWR#8	a_978_357##3	3.96012e-18
C564	VGND#12	a_2412_410##8	1.85497e-18
C565	a_1534_446##4	a_2412_410#	2.45217e-17
C566	a_595_119##7	a_311_119##2	9.74876e-17
C567	VGND#7	a_27_74##2	6.46791e-19
C568	a_1349_114##2	VPWR#14	5.03186e-21
C569	a_200_74##6	SET_B#2	3.8149e-19
C570	a_200_74##10	a_474_405##10	8.51836e-18
C571	a_2412_410##7	a_2412_410##4	1.36848e-18
C572	a_1349_114#	a_1534_446##9	1.05358e-18
C573	VPWR#9	VPWR#18	1.61588e-17
C574	a_595_119##2	a_978_357##2	4.09139e-17
C575	a_200_74#	a_537_503#	5.88358e-19
C576	a_200_74##11	a_200_74##2	1.05296e-18
C577	a_474_405##14	a_200_74##6	1.82536e-20
C578	VPWR#6	VPWR#5	2.06006e-18
C579	VGND#4	a_978_357##9	5.17832e-17
C580	VPWR#3	RESET_B#2	1.4357e-19
C581	SET_B#2	a_474_405##5	3.16788e-17
C582	a_474_405##3	a_537_503#	8.31032e-18
C583	a_978_357##2	a_200_74##6	2.10839e-18
C584	a_1349_114##2	a_978_357##11	5.08946e-17
C585	a_1534_446##7	VPWR#13	3.43272e-17
C586	a_200_74##10	a_311_119#	8.85335e-18
C587	a_1534_446##10	a_1349_114##3	3.20586e-17
C588	VGND#5	a_27_74##7	5.11455e-19
C589	a_867_119##2	a_595_119##2	1.37489e-18
C590	VGND#12	SET_B#4	1.99727e-19
C591	VGND#8	a_27_74##4	2.10038e-17
C592	a_595_119##6	a_474_405##2	7.01711e-20
C593	VGND#8	a_311_119##4	6.7944e-18
C594	a_27_74##4	a_595_119#	1.91808e-17
C595	a_1349_114#	RESET_B#1	4.01189e-18
C596	a_978_357##2	a_474_405##5	4.50953e-17
C597	Q_N#2	a_2412_410##4	4.9653e-19
C598	VGND#4	a_978_357##8	5.27205e-18
C599	a_1349_114##2	a_1534_446##12	4.99089e-17
C600	a_200_74##10	a_595_119##5	1.60328e-18
C601	CLK_N	a_27_74##10	1.95993e-17
C602	a_474_405##10	VPWR#9	1.10678e-16
C603	VPWR#10	a_595_119##4	1.87552e-19
C604	a_978_357##2	SET_B#2	4.26193e-17
C605	a_595_119##6	a_27_74##5	2.25739e-19
C606	VGND#12	Q_N#1	1.07877e-17
C607	a_2412_410##7	a_1534_446##7	7.35126e-17
C608	VPWR#4	a_1534_446##4	3.89573e-19
C609	a_978_357##9	a_1818_76#	4.15233e-20
C610	a_978_357##7	a_978_357##11	1.99319e-18
C611	VGND#4	a_1349_114##5	4.75305e-18
C612	a_1818_76##2	a_1349_114##3	8.37553e-19
C613	VPWR#14	a_2412_410##4	5.44433e-19
C614	a_474_405##14	a_474_405##5	2.83196e-20
C615	VPWR#9	a_311_119#	1.18066e-17
C616	VGND#6	a_474_405##6	5.22375e-19
C617	a_595_119##6	a_311_119##2	5.04117e-17
C618	a_1534_446##14	VPWR#16	1.45515e-19
C619	VPWR#13	a_1534_446##9	9.23681e-19
C620	a_1534_446##8	a_1534_446##4	9.53763e-18
C621	a_200_74##11	a_474_405##2	8.67888e-17
C622	a_311_119##2	a_27_74##4	3.84307e-17
C623	VPWR#8	a_595_119##4	5.56158e-18
C624	a_1349_114##2	VPWR#15	7.35774e-18
C625	a_200_74##11	a_595_119##6	3.02969e-17
C626	a_1534_446##10	a_978_357##6	2.21998e-17
C627	Q_N#2	a_1534_446##7	5.99248e-18
C628	SET_B#8	a_978_357##9	2.96643e-19
C629	VPWR#9	a_595_119##5	9.1757e-18
C630	VGND#14	SET_B#2	5.33039e-19
C631	VGND#3	a_1534_446##6	5.32688e-18
C632	VPWR#10	a_27_74##5	5.48671e-20
C633	a_27_74##4	a_595_119##3	3.40666e-18
C634	a_978_357##4	a_1349_114#	5.09134e-17
C635	a_1349_114##2	a_1534_446##14	3.30811e-17
C636	a_595_119##6	D#2	4.78294e-20
C637	D	a_200_74##11	6.63082e-17
C638	a_200_74##10	a_933_424#	6.70642e-19
C639	a_2412_410##7	a_1534_446##9	1.2611e-18
C640	VGND#15	a_311_119##2	3.23577e-17
C641	a_867_119#	SET_B#2	7.61712e-19
C642	a_595_119##3	a_595_119##2	6.3438e-18
C643	a_1349_114##2	a_1917_392#	8.34927e-19
C644	a_200_74##4	a_595_119##3	6.57254e-18
C645	VPWR#9	a_933_424#	3.49441e-19
C646	VGND#4	a_2412_410#	4.92877e-18
C647	a_978_357##2	a_1349_114##6	5.82199e-17
C648	VPWR#14	a_1534_446##7	8.26129e-19
C649	a_595_119##6	a_474_405#	1.48155e-19
C650	a_978_357##8	a_1818_76#	3.50713e-18
C651	a_1818_76##2	a_978_357##6	2.85809e-17
C652	a_474_405##14	SET_B#2	3.59038e-20
C653	a_27_74##10	a_27_74#	7.03794e-18
C654	a_595_119##6	a_474_405##10	1.99974e-18
C655	SET_B#8	a_595_119##2	3.79519e-19
C656	a_311_119##2	a_595_119##2	9.74495e-18
C657	a_978_357##9	a_1534_446##10	4.70555e-17
C658	a_27_74##5	a_523_119#	1.14255e-19
C659	VGND#6	a_27_74##4	6.69087e-18
C660	a_2412_410##6	a_2412_410##3	7.69783e-19
C661	Q_N#2	a_1534_446##9	2.26173e-17
C662	a_27_74##4	a_200_74##3	1.55972e-17
C663	a_595_119##7	a_595_119##6	1.39192e-18
C664	VGND#4	a_1534_446##4	1.56397e-18
C665	a_474_405#	a_523_119#	6.41029e-18
C666	a_978_357##11	RESET_B	3.4312e-17
C667	a_200_74##11	D#2	1.69659e-17
C668	a_2412_410##6	Q	1.04404e-17
C669	a_1534_446##10	SET_B#4	5.50995e-19
C670	RESET_B	a_1534_446##12	4.47989e-18
C671	a_1534_446##14	a_978_357##5	2.26767e-19
C672	a_311_119##4	a_311_119##6	1.31639e-18
C673	a_200_74##17	a_474_405##9	1.19288e-18
C674	VGND#14	a_978_357##2	7.29433e-17
C675	VGND#6	SET_B#1	2.10576e-18
C676	VPWR#9	a_311_119##6	5.03742e-18
C677	RESET_B#3	a_1534_446##8	1.66191e-17
C678	a_200_74##11	a_27_74##5	2.15079e-17
C679	SET_B#6	a_978_357##4	2.4731e-17
C680	VGND#4	a_1534_446##8	9.11121e-18
C681	a_867_119#	a_978_357##2	1.78499e-17
C682	VPWR#5	a_978_357##5	2.07343e-19
C683	VPWR#14	a_1534_446##9	5.08671e-17
C684	a_1349_114##7	a_1534_446##14	1.85936e-18
C685	a_200_74##17	a_474_405##8	2.88845e-18
C686	a_474_405##2	a_200_74##2	7.17694e-17
C687	VGND#3	RESET_B#2	1.10336e-19
C688	VPWR#9	a_200_74##12	4.77187e-17
C689	VPWR	VPWR#7	3.91899e-18
C690	a_595_119##7	a_27_74##4	2.83508e-18
C691	a_474_405##14	a_978_357##2	6.06968e-17
C692	a_1534_446##12	a_1534_446##7	2.10268e-19
C693	VPWR#5	VPWR#3	1.98976e-19
C694	a_1818_76##2	SET_B#4	3.10007e-17
C695	a_27_74##10	D#2	8.80652e-20
C696	a_595_119##6	D#3	4.33802e-20
C697	Q_N#2	RESET_B#1	6.28057e-19
C698	a_200_74##2	D#2	1.01468e-19
C699	a_27_74##10	CLK_N#1	2.55213e-18
C700	a_1534_446##10	a_978_357##8	4.89879e-17
C701	a_1534_446##14	SET_B#5	3.23302e-19
C702	a_1349_114##3	a_1534_446##8	9.30159e-19
C703	a_595_119##6	a_311_119#	7.33542e-17
C704	a_867_119##2	a_978_357##2	3.27338e-19
C705	a_27_74##4	a_200_74##4	1.54345e-18
C706	a_978_357##11	a_1534_446##9	1.65495e-18
C707	a_200_74##12	a_311_119##4	4.17042e-18
C708	D#2	a_474_405##2	1.61138e-17
C709	a_978_357##9	a_1818_76##2	3.90683e-17
C710	a_200_74##11	a_27_74##2	7.68659e-20
C711	VGND#4	a_1349_114##3	9.48386e-18
C712	a_311_119##4	D	1.08006e-16
C713	a_200_74##10	a_27_74##4	1.38168e-19
C714	a_200_74##17	SET_B#4	6.79226e-20
C715	a_200_74##4	a_595_119##2	2.54025e-19
C716	a_2412_410##6	a_1534_446##6	6.61656e-20
C717	a_311_119##4	a_595_119##7	2.68489e-17
C718	a_1534_446##3	SET_B#6	2.88135e-18
C719	VGND#7	a_200_74##12	2.03639e-18
C720	VPWR#9	a_27_74##11	1.9578e-17
C721	RESET_B#1	VPWR#14	4.56098e-18
C722	SET_B#4	VGND#13	1.40215e-17
C723	a_200_74##12	VPWR#10	4.94033e-17
C724	VGND#4	a_978_357##6	7.39683e-18
C725	a_27_74##2	D#2	5.10347e-18
C726	a_1534_446##12	a_1534_446##9	2.57902e-18
C727	VGND#6	a_978_357#	1.29166e-18
C728	a_1349_114##3	RESET_B#3	2.99354e-18
C729	a_1818_76#	VGND#12	6.44913e-18
C730	a_200_74##10	a_595_119##2	1.17206e-18
C731	a_200_74##17	a_1534_446#	3.17609e-21
C732	a_474_405##14	a_595_119##3	2.63918e-19
C733	a_311_119##2	a_200_74##11	1.12499e-18
C734	Q_N#1	a_1534_446##5	7.74282e-18
C735	Q_N#2	a_1349_114#	1.95252e-19
C736	a_1349_114##6	a_978_357##6	8.94797e-21
C737	a_27_74##4	a_27_74##5	4.27065e-19
C738	a_200_74##14	a_200_74##12	3.39021e-18
C739	a_1534_446##14	a_1534_446##2	6.28205e-18
C740	a_27_74##10	a_27_74##2	1.84217e-17
C741	a_978_357##11	RESET_B#1	2.22567e-17
C742	VPWR#5	SET_B#5	1.8553e-19
C743	VGND#4	SET_B#4	4.93727e-18
C744	a_867_119##2	a_595_119##3	3.20867e-19
C745	Q	Q#3	3.68207e-18
C746	VGND#11	Q	4.10014e-17
C747	CLK_N#2	a_27_74##2	2.99509e-17
C748	a_2412_410##8	Q	4.18796e-18
C749	a_1534_446##2	VPWR#16	4.1385e-18
C750	a_978_357##8	a_1534_446##8	1.56439e-19
C751	VGND#3	a_1534_446##5	2.85953e-19
C752	a_978_357##8	a_1534_446##12	2.27766e-18
C753	a_311_119##2	a_595_119##3	1.35281e-17
C754	VPWR#14	a_1349_114#	2.73525e-18
C755	a_27_74##8	a_1534_446##3	2.65437e-17
C756	CLK_N	a_27_74##11	3.62704e-17
C757	a_978_357##9	VGND#13	6.75694e-17
C758	a_1534_446#	VGND#13	1.34615e-17
C759	a_1534_446##12	RESET_B#1	2.68513e-17
C760	a_200_74##17	a_27_74##7	3.92453e-17
C761	a_474_405##9	SET_B#8	1.31852e-17
C762	a_1349_114##7	a_1534_446##2	3.33354e-17
C763	VGND#4	a_200_74##7	1.93655e-18
C764	a_1349_114##6	SET_B#4	6.72958e-20
C765	a_978_357##11	a_1349_114#	1.76246e-18
C766	CLK_N#4	a_27_74##2	1.97994e-18
C767	a_200_74##17	a_474_405##6	4.2569e-18
C768	VPWR#10	a_474_405##3	6.06702e-18
C769	SET_B#8	a_474_405##8	3.61607e-17
C770	a_27_74##10	CLK_N#2	7.65513e-18
C771	a_978_357##6	a_1349_114##3	3.08208e-17
C772	VGND#6	a_595_119#	8.27906e-19
C773	a_1534_446##2	VPWR#6	3.00483e-17
C774	VGND#5	a_978_357##5	5.11079e-20
C775	a_474_405##2	a_537_503#	2.01286e-19
C776	a_1534_446##5	a_2412_410#	1.54278e-18
C777	VPWR#14	a_978_357##4	3.50764e-19
C778	a_311_119##2	a_200_74##4	1.06064e-18
C779	a_311_119##4	VGND#15	5.57244e-17
C780	Q	Q#1	5.74789e-18
C781	a_200_74##17	SET_B#1	3.47153e-18
C782	VPWR#13	Q	8.71621e-17
C783	a_311_119##4	a_595_119##3	1.8544e-19
C784	a_1534_446##12	a_1349_114#	6.92342e-17
C785	a_200_74##5	a_27_74##8	2.93734e-17
C786	a_978_357##8	RESET_B#3	1.33925e-18
C787	a_595_119##7	a_200_74##4	4.3181e-18
C788	a_311_119##4	a_595_119##6	2.04174e-18
C789	a_1534_446##4	a_2412_410##3	6.02915e-18
C790	RESET_B	a_1534_446##9	4.81135e-19
C791	a_200_74##8	a_1349_114##7	1.77537e-17
C792	a_27_74##4	a_474_405#	1.87674e-17
C793	RESET_B	RESET_B#1	4.61698e-18
C794	a_200_74##17	a_978_357#	5.65241e-19
C795	Q_N#2	VPWR#3	1.94597e-17
C796	a_1534_446##10	a_978_357##7	1.71371e-17
C797	a_1349_114##6	a_1534_446#	7.35717e-18
C798	SET_B#8	a_27_74##7	1.74397e-18
C799	a_200_74##10	a_474_405##9	1.76021e-18
C800	a_200_74##11	VPWR#10	1.88053e-19
C801	a_1349_114##5	a_978_357##4	2.40568e-19
C802	CLK_N#4	CLK_N#2	1.56969e-17
C803	VGND	VGND#6	3.51e-18
C804	a_978_357##9	a_1349_114##3	9.67435e-18
C805	VPWR#14	SET_B#6	2.19635e-19
C806	a_978_357##2	a_1254_119#	1.29325e-17
C807	a_1534_446##5	VNB	4.73495e-17
C808	D	a_27_74##5	7.18037e-18
C809	a_200_74##14	VGND#15	7.09676e-18
C810	a_27_74##4	VNB	1.92354e-16
C811	a_595_119##2	VNB	3.51787e-17
C812	a_1534_446##12	a_978_357##4	2.89638e-17
C813	D	a_474_405#	2.08601e-17
C814	VPWR#5	VPWR#14	4.40918e-19
C815	VGND#15	a_27_74##4	1.91196e-17
C816	SET_B#4	a_978_357##6	3.6245e-17
C817	a_200_74##6	a_1349_114##7	4.94232e-17
C818	a_474_405##4	a_200_74##5	5.44232e-17
C819	VPWR#10	D#1	5.11028e-18
C820	a_1534_446##6	RESET_B#4	2.62613e-17
C821	VGND#13	a_27_74##7	5.05381e-19
C822	VPWR#6	a_200_74##8	2.77571e-19
C823	a_1534_446##6	a_1534_446##8	1.0041e-17
C824	Q	a_2412_410#	2.68452e-17
C825	VPWR#17	a_1349_114##7	1.23754e-17
C826	Q	a_1534_446##4	3.71264e-18
C827	a_978_357##8	a_1349_114##3	9.40694e-18
C828	a_27_74##4	a_474_405##2	7.0922e-19
C829	a_1818_76#	a_1534_446##10	6.34656e-17
C830	a_1349_114##6	a_200_74##7	4.50331e-17
C831	VGND#3	Q_N#1	1.62832e-17
C832	VGND#7	a_27_74##4	3.96814e-17
C833	a_1534_446##6	RESET_B#3	2.11304e-17
C834	a_1534_446##14	a_1349_114#	3.48615e-19
C835	a_978_357##9	a_1349_114##6	1.39462e-16
C836	VPWR#9	a_474_405##9	1.01227e-17
C837	a_1534_446##12	SET_B#6	1.74075e-18
C838	a_200_74##14	a_311_119##4	1.00558e-16
C839	VPWR#9	a_27_74##7	1.32849e-18
C840	VGND#16	VGND#15	1.21168e-18
C841	a_27_74##12	a_27_74##11	9.46745e-19
C842	VPWR#10	VNB	4.07977e-17
C843	VPWR#8	VNB	4.57408e-17
C844	VPWR#4	RESET_B	3.73717e-18
C845	VPWR#7	VNB	4.55693e-17
C846	a_1349_114##5	SET_B#6	2.50192e-17
C847	VPWR#6	VNB	4.82696e-17
C848	VPWR#5	VNB	3.51908e-17
C849	a_474_405##5	a_1349_114##7	7.93164e-18
C850	VPWR#3	VNB	4.41443e-17
C851	CLK_N	a_27_74#	2.65095e-19
C852	a_978_357##9	a_978_357##6	1.13177e-17
C853	a_978_357##4	VPWR#15	1.90358e-17
C854	VGND#7	a_595_119##2	2.75496e-19
C855	a_1534_446##6	a_1349_114##3	2.87985e-19
C856	VGND#8	VNB	3.29485e-17
C857	CLK_N	CLK_N#1	3.73738e-18
C858	VGND#6	VNB	7.91477e-17
C859	VGND#5	VNB	6.55015e-17
C860	SET_B#3	a_474_405##4	5.12683e-18
C861	VGND#3	VNB	4.224e-17
C862	VPWR#9	a_474_405##8	2.17201e-17
C863	a_27_74##4	D#3	1.71626e-17
C864	a_27_74##10	a_27_74##3	5.46412e-18
C865	a_311_119##2	a_27_74##6	2.74881e-19
C866	a_2412_410##6	VNB	2.51768e-18
C867	a_1349_114##5	VPWR#15	2.32219e-19
C868	VGND	a_1349_114##6	1.30373e-18
C869	a_1534_446##6	a_978_357##6	5.83785e-20
C870	Q	a_2412_410##4	3.727e-17
C871	RESET_B#4	VNB	9.27598e-20
C872	Q	a_1534_446##7	2.63917e-18
C873	a_1534_446#	SET_B#4	1.27563e-17
C874	VGND#7	a_27_74##7	3.55813e-18
C875	RESET_B	a_1534_446##6	1.65861e-17
C876	a_200_74##6	VPWR#7	1.02586e-18
C877	RESET_B#4	RESET_B#2	1.36045e-17
C878	a_978_357##9	VNB	3.05067e-17
C879	a_978_357##8	VNB	8.80173e-18
C880	a_1349_114##6	a_27_74##7	4.70073e-17
C881	a_474_405##5	VPWR#17	1.77134e-18
C882	a_1534_446##14	a_978_357##4	9.51674e-19
C883	a_1349_114##5	VNB	1.27598e-17
C884	RESET_B	RESET_B#2	5.47082e-18
C885	a_978_357##8	a_1534_446##6	4.686e-18
C886	VGND#15	a_474_405##2	1.19979e-19
C887	VPWR#9	CLK_N	3.36636e-18
C888	RESET_B	a_1349_114##2	3.02785e-19
C889	a_978_357##8	a_978_357##6	1.5749e-20
C890	VGND#5	a_1534_446##2	5.03534e-20
C891	VPWR#10	a_27_74#	2.56811e-19
C892	a_200_74##10	a_595_119#	1.63572e-19
C893	a_595_119##7	a_27_74##6	6.06746e-19
C894	a_474_405##9	VNB	1.84487e-19
C895	a_1349_114##3	RESET_B#2	7.815e-20
C896	a_474_405##8	VNB	1.13055e-17
C897	a_474_405##9	a_933_424#	2.89516e-18
C898	VGND#7	a_474_405##6	1.33895e-18
C899	a_595_119##6	VNB	1.1955e-17
C900	SET_B#6	VPWR#15	2.43397e-17
C901	a_311_119##4	a_474_405##2	5.97878e-19
C902	a_311_119##4	a_27_74##4	1.96682e-18
C903	a_200_74##11	VNB	6.21807e-18
C904	D	a_200_74##10	2.81479e-17
C905	a_27_74##10	VNB	6.33442e-18
C906	VPWR#9	D	4.21182e-18
C907	a_311_119##4	a_200_74##11	6.97692e-18
C908	CLK_N#4	VNB	1.12552e-17
C909	VGND#7	D	4.88523e-18
C910	a_978_357##3	SET_B#3	3.70836e-17
C911	VGND#11	VNB	3.80696e-18
C912	a_1534_446##5	a_2412_410##3	2.15144e-17
C913	a_2412_410##8	VNB	9.69816e-18
C914	Q_N#1	VNB	1.34161e-17
C915	a_1349_114##5	a_1534_446##3	1.98585e-19
C916	VGND#12	VNB	7.14495e-18
C917	a_978_357##7	VNB	4.43611e-19
C918	a_200_74##10	a_595_119##6	8.04351e-17
C919	VGND#7	SET_B#1	1.34316e-18
C920	a_1818_76#	VNB	5.26794e-18
C921	a_27_74##4	D#2	1.64858e-18
C922	a_1534_446##10	VNB	8.43333e-18
C923	a_1818_76##2	VNB	4.308e-18
C924	a_978_357##9	SET_B#4	2.65271e-17
C925	VGND#13	VNB	2.36357e-18
C926	VPWR	a_200_74##5	2.92317e-19
C927	a_27_74##10	CLK_N#3	6.80392e-18
C928	VGND#14	VNB	1.6974e-18
C929	a_1534_446##14	SET_B#6	4.1714e-17
C930	a_867_119#	VNB	8.68826e-18
C931	a_595_119##6	a_27_74##4	1.90297e-19
C932	a_474_405##14	VNB	9.08797e-19
C933	a_867_119##2	VNB	1.28428e-17
C934	a_200_74##10	a_27_74##5	1.24467e-17
C935	a_311_119##2	VNB	2.59851e-17
C936	VPWR#4	a_2412_410##4	5.52481e-18
C937	VGND#8	a_474_405#	1.48598e-18
C938	a_200_74##11	VPWR#19	2.98837e-18
C939	VPWR#4	Q	2.11672e-17
C940	VGND#15	VNB	6.62082e-18
C941	a_1534_446##8	a_1534_446##5	3.0624e-18
C942	a_311_119##4	VNB	1.50768e-17
C943	a_1349_114##6	a_474_405##6	1.84293e-18
C944	a_1349_114##5	a_1534_446##14	5.63105e-17
C945	a_200_74##14	VNB	1.9845e-17
C946	VGND#15	D#2	7.08931e-19
C947	VGND#16	VNB	1.90168e-18
C948	VGND#4	Q	2.11052e-17
C949	a_1818_76##2	a_1534_446##10	3.44562e-17
C950	a_27_74##12	VNB	3.96722e-17
C951	SET_B#2	a_474_405##13	3.3137e-19
C952	VPWR#13	VNB	5.80763e-18
C953	a_2412_410##7	VNB	4.18974e-18
C954	VGND#16	a_200_74##14	3.91175e-17
C955	Q_N#2	VNB	2.29143e-17
C956	VPWR#14	VNB	6.04814e-18
C957	a_978_357##11	VNB	7.75736e-18
C958	VGND	a_27_74##7	9.07137e-19
C959	a_1534_446##12	VNB	1.41289e-17
C960	a_978_357##5	RESET_B#3	1.69329e-19
C961	a_1349_114##6	a_1349_114##5	2.23255e-18
C962	a_200_74##7	a_1534_446#	3.07618e-17
C963	RESET_B#4	a_1349_114##2	5.06102e-19
C964	a_311_119##4	D#2	1.43199e-17
C965	a_1534_446##14	VNB	4.22912e-18
C966	a_200_74##10	a_474_405#	2.32198e-18
C967	VGND#14	a_27_74##7	1.23011e-18
C968	Q	a_2412_410##3	6.13645e-17
C969	VPWR#4	a_1534_446##7	8.88435e-18
C970	a_978_357##8	RESET_B#2	3.59121e-18
C971	a_1349_114##7	VNB	3.50989e-18
C972	VPWR#17	VNB	3.40373e-18
C973	VGND#7	a_595_119#	3.39171e-19
C974	D	a_200_74##4	1.57344e-18
C975	a_27_74##3	a_27_74##4	1.35526e-19
C976	a_1534_446##12	VPWR#5	6.83552e-18
C977	CLK_N	a_27_74##2	1.15324e-18
C978	a_474_405##10	VNB	1.33596e-17
C979	a_311_119#	VNB	1.36151e-17
C980	SET_B#8	VPWR	1.60425e-18
C981	a_595_119##4	a_978_357##3	6.07663e-17
C982	a_595_119##5	VNB	2.202e-19
C983	a_200_74##14	D#2	8.83355e-19
C984	VPWR#9	a_27_74##5	1.78318e-20
C985	CLK_N	CLK_N#2	9.14426e-18
C986	a_978_357##5	a_1349_114##3	8.15197e-18
C987	VGND#5	a_200_74##8	2.32027e-19
C988	VPWR#19	VNB	1.69106e-18
C989	D	a_474_405##2	6.17189e-19
C990	a_311_119##6	VNB	1.06644e-17
C991	a_200_74##12	VNB	2.94749e-17
C992	VPWR#20	VNB	2.82484e-18
C993	D	D#2	1.95588e-17
C994	a_27_74##11	VNB	5.22806e-17
C995	VPWR#10	CLK_N#1	6.67168e-20
C996	a_2412_410#	VNB	3.59428e-17
C997	a_1534_446##14	a_1534_446##3	1.26953e-18
C998	a_1534_446##4	VNB	4.95754e-17
C999	a_1534_446##8	VNB	3.54681e-17
C1000	RESET_B#3	VNB	3.08387e-17
C1001	VPWR#4	a_1534_446##9	4.36355e-18
C1002	a_1349_114##3	VNB	3.05316e-17
C1003	VGND#7	a_200_74##3	1.18832e-18
C1004	a_978_357##6	VNB	2.19305e-17
C1005	SET_B#4	VNB	2.73437e-17
C1006	a_1534_446#	VNB	4.27303e-17
C1007	VPWR#9	a_595_119##6	4.14251e-18
C1008	a_200_74##7	VNB	2.76038e-17
C1009	a_27_74##7	VNB	1.86021e-16
C1010	a_978_357##5	a_978_357##6	2.02013e-19
C1011	a_474_405##6	VNB	2.68884e-17
C1012	a_1349_114##5	a_27_74##8	1.63098e-19
C1013	SET_B#1	VNB	2.94119e-17
C1014	a_27_74##7	a_1534_446#	4.04094e-19
C1015	a_978_357#	VNB	2.13241e-17
C1016	a_595_119#	VNB	2.55194e-17
C1017	a_867_119#	a_27_74##7	9.95397e-18
C1018	a_200_74##3	VNB	1.61915e-17
C1019	a_27_74##5	VNB	6.07088e-17
C1020	a_474_405#	VNB	3.23835e-17
C1021	VPWR	a_200_74##6	5.8544e-19
C1022	a_978_357##9	a_1534_446#	2.41787e-17
C1023	D#3	VNB	2.44067e-17
C1024	a_595_119##6	a_595_119##2	8.43744e-19
C1025	a_200_74##12	a_27_74##3	1.76407e-19
C1026	a_200_74##10	a_27_74##3	2.12894e-19
C1027	a_27_74##3	VNB	9.5759e-17
C1028	VPWR#18	VPWR#17	1.78315e-18
C1029	a_311_119##6	a_200_74##11	4.85665e-17
C1030	a_27_74##12	a_200_74##14	2.43557e-18
C1031	CLK_N#3	VNB	3.48328e-17
C1032	a_2412_410##4	VNB	4.74151e-17
C1033	a_1534_446##7	VNB	6.07903e-17
C1034	VPWR#4	RESET_B#1	6.39643e-18
C1035	a_1534_446##9	VNB	3.94784e-17
C1036	VPWR#18	a_978_357##2	4.51558e-19
C1037	RESET_B#1	VNB	3.11982e-17
C1038	a_200_74##14	a_27_74##4	1.42718e-19
C1039	a_1534_446##3	VPWR#16	4.72429e-18
C1040	a_1349_114#	VNB	3.32444e-17
C1041	SET_B#4	a_978_357##5	6.26703e-19
C1042	VGND	a_200_74##17	1.54982e-18
C1043	a_311_119##4	a_27_74##2	8.10973e-19
C1044	a_978_357##4	VNB	4.03008e-17
C1045	SET_B#6	VNB	4.75568e-17
C1046	a_1534_446##3	VNB	3.76565e-17
C1047	a_978_357##9	a_1349_114##2	1.01898e-17
C1048	a_27_74##8	VNB	6.05955e-17
C1049	VGND#14	a_474_405##6	3.87139e-17
C1050	a_1534_446##12	VPWR#3	3.73738e-18
C1051	a_200_74##5	VNB	2.63731e-17
C1052	a_474_405##4	VNB	2.64416e-17
C1053	SET_B#3	VNB	2.72372e-17
C1054	VGND#8	D#3	2.00048e-18
C1055	a_978_357##3	VNB	3.04723e-17
C1056	a_595_119##4	VNB	4.06757e-17
C1057	a_1534_446##6	a_1534_446##5	9.98559e-19
C1058	a_1349_114##7	SET_B#6	6.20058e-19
C1059	a_27_74##6	VNB	7.58544e-17
C1060	a_200_74#	VNB	2.16476e-17
C1061	a_200_74##14	a_27_74##2	1.14173e-17
C1062	VGND#4	a_1534_446##7	6.54275e-21
C1063	a_27_74##6	a_595_119##4	6.97517e-18
C1064	a_474_405##3	VNB	2.17709e-17
C1065	D#1	VNB	4.45636e-17
C1066	VGND#7	a_474_405#	2.2169e-18
C1067	a_27_74#	VNB	3.87812e-17
C1068	CLK_N#1	VNB	4.74172e-17
C1069	a_1534_446##14	a_27_74##8	3.73956e-19
C1070	a_978_357##5	a_1534_446#	1.30782e-19
C1071	VPWR#4	a_1349_114#	5.31585e-18
C1072	a_27_74##7	a_200_74##7	1.80072e-18
C1073	VPWR#4	VNB	3.29154e-16
C1074	a_474_405##14	a_27_74##7	1.509e-18
C1075	a_200_74##17	VNB	5.89562e-18
C1076	a_978_357##8	a_1349_114##2	2.9941e-17
C1077	VGND#4	VNB	3.58952e-16
C1078	SET_B#8	VNB	7.59841e-18
C1079	VPWR#8	SET_B#2	6.43886e-20
C1080	a_200_74##10	VNB	4.96219e-18
C1081	VPWR#9	VNB	3.53439e-16
C1082	VGND	a_978_357##2	1.57294e-18
C1083	VGND#7	VNB	3.26886e-16
C1084	a_2412_410##3	VNB	6.36465e-17
C1085	a_1534_446##6	VNB	3.61731e-17
C1086	RESET_B#2	VNB	2.49189e-17
C1087	a_1349_114##2	VNB	3.66916e-17
C1088	a_978_357##5	VNB	3.61418e-17
C1089	SET_B#5	VNB	3.38786e-17
C1090	VGND#7	D#3	6.45764e-18
C1091	a_978_357##5	a_200_74##7	8.67831e-21
C1092	a_1534_446##2	VNB	8.01853e-17
C1093	a_200_74##8	VNB	4.21862e-17
C1094	a_200_74##6	VNB	2.9403e-17
C1095	a_474_405##5	VNB	4.60239e-17
C1096	a_867_119#	a_474_405##6	9.73922e-19
C1097	VPWR#7	SET_B#2	6.94277e-20
C1098	VPWR#9	a_200_74##11	3.08085e-18
C1099	a_1349_114##5	a_1349_114##2	2.03718e-18
C1100	SET_B#2	VNB	4.76081e-17
C1101	VPWR#4	a_978_357##4	9.0735e-19
C1102	a_978_357##2	VNB	6.0537e-17
C1103	a_27_74##12	VGND#16	3.83514e-17
C1104	VGND#7	a_595_119##6	1.31623e-18
C1105	a_595_119##3	VNB	5.27289e-17
C1106	a_27_74##4	a_27_74##6	4.86081e-19
C1107	a_200_74##4	VNB	3.40971e-17
C1108	a_200_74##2	VNB	2.0554e-17
C1109	a_474_405##2	VNB	4.32846e-17
C1110	D#2	VNB	6.10832e-17
C1111	a_27_74##2	VNB	4.44503e-17
C1112	VGND#13	a_1818_76##2	3.8353e-17
C1113	CLK_N#2	VNB	5.38375e-17
C1114	a_1534_446#	SET_B#5	2.64644e-17
C1115	VGND#7	a_27_74##3	1.04445e-17
C1116	a_1349_114##7	a_1534_446##3	7.31781e-18
C1117	a_867_119##2	a_27_74##7	1.30775e-18
C1118	SET_B#1	VGND#14	1.41608e-17
C1119	a_978_357##9	a_200_74##7	1.32723e-17
C1120	a_1349_114##5	a_1534_446#	5.68993e-18
C1121	a_200_74##14	CLK_N#2	7.6609e-20
C1122	a_200_74#	a_27_74##6	1.61542e-17
C1123	VGND#4	a_2412_410##8	1.79839e-17
C1124	a_27_74##6	a_595_119##2	6.51835e-19
C1125	a_474_405##10	a_595_119##3	1.491e-18
C1126	a_474_405##9	a_474_405##8	1.80835e-19
C1127	RESET_B	VNB	2.24943e-18
C1128	a_474_405##14	a_474_405##6	5.27456e-19
C1129	VGND#7	CLK_N#3	2.59646e-18
C1130	CLK_N	VNB	1.20455e-17
C1131	D	VNB	1.8289e-18
C1132	Q	VNB	1.12802e-16
C1133	VPWR	VNB	1.69742e-18
C1134	VGND	VNB	9.24053e-19
C1135	a_311_119#	a_595_119##3	1.10716e-17
C1136	VGND#8	a_27_74##3	1.2619e-17
C1137	VPWR#11	a_27_74#	6.49862e-18
C1138	SET_B	a_978_357##11	2.02967e-18
C1139	VGND#9	VGND#8	2.63283e-19
C1140	VPWR#2	VNB	5.68587e-17
C1141	a_2412_410##7	VPWR#2	1.07504e-17
C1142	VGND#7	VGND#9	1.17442e-16
C1143	SET_B	a_978_357##4	2.05367e-18
C1144	a_27_74##10	VPWR#11	2.51872e-19
C1145	VGND#2	a_1534_446##4	6.05896e-18
C1146	SET_B	a_1349_114#	6.98744e-19
C1147	VPWR#11	a_27_74##2	3.6845e-20
C1148	VGND#9	a_27_74##3	1.9516e-17
C1149	VPWR#2	a_2412_410##4	1.13766e-17
C1150	a_2412_410##3	VPWR#2	1.32182e-19
C1151	SET_B	RESET_B#1	3.20388e-19
C1152	SET_B	VNB	1.31972e-17
C1153	VPWR#11	a_200_74##12	4.39271e-17
C1154	VGND#2	a_2412_410#	1.16884e-17
C1155	VGND#9	a_27_74##10	5.28711e-19
C1156	VPWR#14	VPWR#2	2.07569e-20
C1157	VGND#2	a_1534_446##5	2.9067e-19
C1158	VGND#9	a_200_74##14	1.69179e-17
C1159	a_27_74##11	VPWR#11	2.11451e-17
C1160	VPWR#11	VNB	5.67532e-17
C1161	VPWR#11	VPWR#10	2.33391e-19
C1162	Q	VPWR#2	2.11441e-17
C1163	SET_B	a_1349_114##7	3.24396e-17
C1164	VGND#9	CLK_N#2	1.61521e-19
C1165	VGND#2	Q	2.11084e-17
C1166	a_1349_114##5	SET_B	1.11667e-16
C1167	VPWR#2	a_1534_446##9	4.72241e-19
C1168	SET_B	a_200_74##8	7.70544e-18
C1169	VGND#12	VGND#2	6.86556e-19
C1170	VPWR#11	CLK_N#1	7.91686e-18
C1171	SET_B	a_1349_114##6	4.5866e-18
C1172	VPWR#3	VPWR#2	4.25213e-19
C1173	SET_B	a_200_74##17	1.48647e-18
C1174	SET_B	a_1534_446##2	3.10477e-17
C1175	SET_B	a_1534_446#	2.08249e-18
C1176	VGND#2	a_1534_446##7	2.36405e-19
C1177	VPWR#4	VPWR#2	1.10519e-16
C1178	VGND#2	VNB	5.83977e-17
C1179	VGND#2	a_2412_410##3	8.20489e-19
C1180	SET_B	a_978_357##9	1.03484e-17
C1181	SET_B	a_1534_446##14	7.70041e-18
C1182	VPWR#4	SET_B	4.09841e-17
C1183	SET_B	SET_B#5	1.39142e-19
C1184	VPWR#11	CLK_N#2	1.54809e-19
C1185	VGND#2	a_2412_410##6	2.18098e-20
C1186	SET_B	VGND#13	2.13626e-18
C1187	VGND#4	VGND#2	1.11225e-16
C1188	VGND#9	a_27_74##2	2.83249e-19
C1189	a_2412_410##6	VPWR#2	1.11181e-20
C1190	SET_B	VPWR#15	5.97422e-19
C1191	VGND#9	a_27_74##12	1.82593e-17
C1192	VPWR#2	a_1534_446##5	7.61361e-19
C1193	SET_B	a_27_74##8	7.10886e-19
C1194	SET_B	a_1349_114##2	3.91075e-17
C1195	VPWR#2	a_1534_446##7	3.12306e-18
C1196	VPWR#9	VPWR#11	1.06393e-16
C1197	VGND#9	VNB	5.11161e-17
C1198	SET_B	VPWR#5	1.0826e-18
C1199	VGND#9	CLK_N#3	7.03105e-18
C1200	VGND#9	VGND#15	3.2289e-19
C1201	VGND#2	a_2412_410##8	1.45289e-17
C1202	SET_B	VPWR#6	8.42809e-18
C1203	SET_B	SET_B#6	1.15011e-17
*
*
.ENDS sky130_fd_sc_hs__dfbbn_1
*
