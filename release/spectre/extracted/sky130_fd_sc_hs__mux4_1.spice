* Extracted by Quantus, converted by sky130cad/quantus.py
*
*
*
*                       LINUX           Wed Nov 18 08:44:06 2026
*
*
*
*  PROGRAM  advgen
*
*  Name           : advgen - Quantus - (64-bit)
*  Version        : 25.1.0-p047
*  Build Date     : Thu Dec 11 23:20:30 PST 2025
*
*  HSPICE LIBRARY
*
*  OPERATING_TEMPERATURE 150
*  QRC_TECH_DIR <path>/tech
*
*
*

*
.SUBCKT sky130_fd_sc_hs__mux4_1 VPB VNB VGND VPWR X S0 A0 A1 A2 S1 A3
*
*
*  caps2d version: 10
*
*
*       TRANSISTOR CARDS
*
*
XM25 a_27_74##14 S0#6 VGND#11 VNB sky130_fd_pr__nfet_01v8_lvt l=0.15 w=0.64 ad=0.1824 as=0.384 pd=1.85 ps=2.48
XM7 VGND#11 A0#1 a_264_74# VNB sky130_fd_pr__nfet_01v8_lvt l=0.15 w=0.64 ad=0.384 as=0.1536 pd=2.48 ps=1.76
XM5 a_264_74# a_27_74# a_342_74# VNB sky130_fd_pr__nfet_01v8_lvt l=0.15 w=0.64 ad=0.1536 as=0.2496 pd=1.76 ps=2.06
XM8 a_342_74# S0#8 a_450_74# VNB sky130_fd_pr__nfet_01v8_lvt l=0.15 w=0.64 ad=0.2496 as=0.48 pd=2.06 ps=2.78
XM19 a_450_74# A1#3 VGND#10 VNB sky130_fd_pr__nfet_01v8_lvt l=0.15 w=0.64 ad=0.48 as=0.3456 pd=2.78 ps=2.36
XM16 VGND#10 A2#1 a_768_74# VNB sky130_fd_pr__nfet_01v8_lvt l=0.15 w=0.64 ad=0.3456 as=0.1536 pd=2.36 ps=1.76
XM12 a_768_74# a_27_74##6 a_846_74##6 VNB sky130_fd_pr__nfet_01v8_lvt l=0.15 w=0.64 ad=0.1536 as=0.3296 pd=1.76 ps=2.31
XM1 a_846_74##6 S0#1 a_979_74# VNB sky130_fd_pr__nfet_01v8_lvt l=0.15 w=0.64 ad=0.3296 as=0.1536 pd=2.31 ps=1.76
XM9 a_979_74# A3#3 VGND#9 VNB sky130_fd_pr__nfet_01v8_lvt l=0.15 w=0.64 ad=0.1536 as=0.1824 pd=1.76 ps=1.85
XM6 a_846_74##2 S1#4 a_1338_125##7 VNB sky130_fd_pr__nfet_01v8_lvt l=0.15 w=0.64 ad=0.454475 as=0.1856 pd=3.19 ps=1.86
XM2 a_1338_125##7 a_1396_99##3 a_342_74##6 VNB sky130_fd_pr__nfet_01v8_lvt l=0.15 w=0.64 ad=0.1856 as=0.1824 pd=1.86 ps=1.85
XM3 a_1396_99##5 S1#3 VGND#8 VNB sky130_fd_pr__nfet_01v8_lvt l=0.15 w=0.64 ad=0.1824 as=0.2938 pd=1.85 ps=2.32
XM15 VGND#8 a_1338_125##3 X#3 VNB sky130_fd_pr__nfet_01v8_lvt l=0.15 w=0.74 ad=0.2938 as=0.2109 pd=2.32 ps=2.05
XM10 a_27_74##18 S0#4 VPWR#11 VPB sky130_fd_pr__pfet_01v8 l=0.15 w=1 ad=0.295 as=0.458625 pd=2.59 ps=3.14
XM21 VPWR#11 A0#3 a_255_341# VPB sky130_fd_pr__pfet_01v8 l=0.15 w=1 ad=0.458625 as=0.81 pd=3.14 ps=3.62
XM4 a_255_341# S0#7 a_342_74##2 VPB sky130_fd_pr__pfet_01v8 l=0.15 w=1 ad=0.81 as=0.3 pd=3.62 ps=2.6
XM18 a_342_74##2 a_27_74##3 a_537_341# VPB sky130_fd_pr__pfet_01v8 l=0.15 w=1 ad=0.3 as=0.36 pd=2.6 ps=2.72
XM11 a_537_341# A1#1 VPWR#10 VPB sky130_fd_pr__pfet_01v8 l=0.15 w=1 ad=0.36 as=0.5512 pd=2.72 ps=3.5
XM24 VPWR#10 A2#3 a_763_341# VPB sky130_fd_pr__pfet_01v8 l=0.15 w=1 ad=0.5512 as=0.39525 pd=3.5 ps=3.17
XM20 a_763_341# S0#2 a_846_74##5 VPB sky130_fd_pr__pfet_01v8 l=0.15 w=1 ad=0.39525 as=0.855 pd=3.17 ps=3.71
XM13 a_846_74##5 a_27_74##7 a_1065_387# VPB sky130_fd_pr__pfet_01v8 l=0.15 w=1 ad=0.855 as=0.27 pd=3.71 ps=2.54
XM17 a_1065_387# A3#1 VPWR#9 VPB sky130_fd_pr__pfet_01v8 l=0.15 w=1 ad=0.27 as=0.295 pd=2.54 ps=2.59
XM14 a_342_74##4 S1#5 a_1338_125##5 VPB sky130_fd_pr__pfet_01v8 l=0.15 w=1 ad=0.295 as=0.35 pd=2.59 ps=2.7
XM22 a_1338_125##5 a_1396_99##4 a_846_74# VPB sky130_fd_pr__pfet_01v8 l=0.15 w=1 ad=0.35 as=0.345 pd=2.7 ps=2.69
XM23 a_1396_99##7 S1#1 VPWR#8 VPB sky130_fd_pr__pfet_01v8 l=0.15 w=1 ad=0.345 as=0.67255 pd=2.69 ps=3.52
XM0 VPWR#8 a_1338_125# X#1 VPB sky130_fd_pr__pfet_01v8 l=0.15 w=1.12 ad=0.67255 as=0.3472 pd=3.52 ps=2.86
*
*
*       RESISTOR AND CAP/DIODE CARDS
*
Rg1	A0#1	A0#2	333.761475
Rg2	A0#2	A0#3	400.207520
Rg3	a_27_74#	a_27_74##2	325.153564
Rg4	a_27_74##3	a_27_74##4	442.402008
Rg5	A1#1	A1#2	400.207520
Rg6	A1#2	A1#3	333.761475
Rg7	A2#1	A2#2	346.180084
Rg8	A2#2	A2#3	408.386017
Rg9	a_27_74##5	a_27_74##6	279.244598
Rg10	S0#1	S0#2	1153.602905
Rg11	S0#2	S0#3	1495.479248
Rg12	S0#3	S0#4	1229.330078
Rg13	S0#4	S0#5	462.223328
Rg14	S0#5	S0#6	388.288422
Rg15	S0#3	S0#7	357.447479
Rg16	S0#7	S0#8	798.663513
Rg17	a_27_74##7	a_27_74##8	400.207520
Rg18	A3#1	A3#2	399.859680
Rg19	A3#2	A3#3	506.355560
Rg20	A3#2	A3#4	30.084387
Rg21	a_1396_99#	a_1396_99##2	428.429138
Rg22	a_1396_99##2	a_1396_99##3	363.225281
Rg23	a_1396_99##2	a_1396_99##4	463.390228
Rg24	S1#1	S1#2	460.906128
Rg25	S1#2	S1#3	352.006958
Rg26	S1#3	S1#4	1768.873169
Rg27	S1#4	S1#5	786.969788
Rg28	a_1338_125#	a_1338_125##2	426.276154
Rg29	a_1338_125##2	a_1338_125##3	345.483582
Rf1	S0#5	S0#10	161.465057
Rf2	S0#11	S0	1.232256
Rf3	S0#10	S0#11	10.060016
Rf4	A0	A0#2	171.452469
Rf5	A1	A1#2	171.452469
Rf6	A2	A2#2	170.292816
Rf7	a_27_74##8	a_27_74##10	246.704102
Rf8	a_27_74##10	a_27_74##11	109.546303
Rf9	a_27_74##11	a_27_74##12	145.734238
Rf10	a_27_74##12	a_27_74##13	83.680840
Rf11	a_27_74##13	a_27_74##14	17.998653
Rf12	a_27_74##10	a_27_74##5	169.701645
Rf13	a_27_74##11	a_27_74##4	173.629761
Rf14	a_27_74##12	a_27_74##2	185.454315
Rf15	a_27_74##13	a_27_74##18	94.615120
Rf16	A3#4	A3	162.398010
Rf17	a_342_74#	a_342_74##3	93.819672
Rf18	a_342_74##3	a_342_74##5	335.534119
Rf19	a_342_74##5	a_342_74##6	174.951767
Rf20	a_342_74##2	a_342_74##3	5.000000
Rf21	a_342_74##4	a_342_74##5	5.000000
Rf22	a_846_74#	a_846_74##3	260.444305
Rf23	a_846_74##3	a_846_74##4	62.777157
Rf24	a_846_74##4	a_846_74##5	106.798721
Rf25	a_846_74##4	a_846_74##6	114.846626
Rf26	a_846_74##2	a_846_74##3	7.500000
Rf27	a_1396_99##5	a_1396_99#	47.721985
Rf28	a_1396_99#	a_1396_99##7	42.492680
Rf29	S1#2	S1	166.137894
Rf30	a_1338_125##2	a_1338_125##6	399.426727
Rf31	a_1338_125##6	a_1338_125##8	52.103249
Rf32	a_1338_125##5	a_1338_125##6	5.000000
Rf33	a_1338_125##7	a_1338_125##8	15.000000
Rf34	X	X#2	2.422064
Rf35	X#2	X	16.365480
Rf36	X	X#4	4.370047
Rf37	X#4	X	7.607119
Rf38	X#1	X#2	15.000000
Rf39	X#3	X#4	7.500000
Rf41	VPWR#2	VPWR#3	50.745564
Rf42	VPWR#3	VPWR#4	165.434845
Rf43	VPWR#4	VPWR#5	186.875168
Rf44	VPWR#5	VPWR#6	181.104172
Rf46	VPWR#2	VPWR#8	31.534731
Rf47	VPWR#4	VPWR#9	33.523315
Rf48	VPWR#5	VPWR#10	34.462341
Rf49	VPWR#6	VPWR#11	39.270222
Rf51	VGND#2	VGND#3	42.710007
Rf52	VGND#3	VGND#4	199.768570
Rf53	VGND#4	VGND#5	153.418045
Rf54	VGND#5	VGND#6	181.733612
Rf56	VGND#2	VGND#8	37.242989
Rf57	VGND#4	VGND#9	30.353714
Rf58	VGND#5	VGND#10	26.645115
Rf59	VGND#6	VGND#11	30.624653
Re1	VPWR#3	VPWR	2.920302
Re2	VPWR	VPWR#5	1.251558
Re3	VGND#3	VGND	2.920302
Re4	VGND	VGND#5	1.251558
*
*       CAPACITOR CARDS
*
*
C1	VPWR#9	a_27_74##7	8.98221e-19
C2	VGND#3	a_342_74##6	1.20859e-17
C3	a_846_74##5	A3#1	9.19939e-18
C4	a_342_74##4	S0#2	1.06522e-18
C5	a_27_74##10	a_342_74##2	9.15167e-18
C6	a_27_74##13	VPWR#11	4.06046e-18
C7	a_1338_125##7	a_846_74#	5.75965e-17
C8	A2#1	a_27_74##6	4.36134e-17
C9	A3#2	VPWR#9	1.92507e-18
C10	VPWR#5	S0#3	3.00578e-17
C11	a_1338_125##5	a_342_74##6	2.19214e-20
C12	VGND#3	a_1338_125##7	4.9434e-18
C13	a_27_74##11	a_27_74##10	1.33995e-18
C14	a_846_74##4	S1#4	1.61093e-18
C15	VPWR#9	S0#2	2.50795e-19
C16	a_846_74##5	a_27_74##7	4.40574e-17
C17	VGND#3	a_846_74##2	9.021e-17
C18	a_342_74##4	A2#3	1.70913e-19
C19	a_27_74##12	VPWR#11	3.63623e-20
C20	a_846_74##2	a_846_74#	3.10154e-18
C21	a_27_74##13	a_27_74##18	1.59967e-18
C22	A1#3	A2#1	1.23035e-17
C23	a_846_74##5	S0#2	7.22169e-17
C24	a_342_74##6	a_1396_99##2	2.01301e-18
C25	a_846_74##4	A3#3	8.05038e-18
C26	a_342_74##2	A3#1	9.34065e-20
C27	a_342_74##4	a_1338_125##7	3.19692e-17
C28	a_1338_125##2	VGND#8	3.6475e-17
C29	a_846_74##5	A2#3	4.5494e-18
C30	a_342_74##6	A3#2	2.57245e-18
C31	a_1396_99##5	a_1338_125##2	1.81049e-19
C32	VPWR#10	S0#2	1.11016e-17
C33	S0#8	A1#3	6.49763e-18
C34	a_846_74##4	a_342_74##6	2.04542e-17
C35	a_342_74##2	a_27_74##7	2.79678e-19
C36	a_846_74##4	S0#1	5.96879e-18
C37	a_846_74##2	a_342_74##4	1.73587e-18
C38	VGND#5	VGND#9	7.13483e-19
C39	a_846_74##5	A1#1	7.28769e-19
C40	a_27_74##10	a_27_74##8	1.50834e-17
C41	A2#3	VPWR#10	3.1375e-17
C42	a_1396_99##5	S1#2	5.62945e-18
C43	a_342_74##2	S0#2	4.24294e-17
C44	a_1338_125##7	a_1396_99##2	1.60914e-17
C45	VGND#5	a_846_74##6	2.49513e-17
C46	a_846_74##5	a_27_74##3	4.31221e-19
C47	a_27_74##11	a_27_74##5	7.10641e-20
C48	a_27_74#	S0#8	2.20395e-17
C49	A1#1	VPWR#10	3.34198e-17
C50	a_27_74##10	a_27_74##5	2.52653e-17
C51	a_342_74##2	A2#3	2.75352e-17
C52	a_846_74##5	A3#2	6.56848e-19
C53	VPWR#3	X#1	1.64954e-17
C54	a_1396_99##5	a_1396_99#	5.5421e-18
C55	a_1338_125##7	A3#2	5.59768e-19
C56	VGND#5	VGND#10	3.83554e-18
C57	VPWR#10	a_27_74##3	1.8581e-18
C58	VPWR#3	VPWR#8	2.09e-17
C59	a_27_74##11	A2#2	1.48562e-19
C60	a_342_74##2	A1#1	2.82274e-17
C61	A0#1	a_27_74#	4.32914e-17
C62	a_846_74##4	a_846_74##2	4.6336e-19
C63	a_1338_125##7	a_1396_99#	3.39531e-19
C64	VPWR#3	a_1396_99##7	9.74361e-18
C65	a_27_74##10	A2#2	6.49605e-17
C66	VPWR#10	S0#7	7.34972e-20
C67	a_846_74##2	a_1396_99#	3.45611e-20
C68	a_846_74##2	a_1396_99##2	7.64279e-19
C69	a_1396_99##2	S1#2	1.31952e-19
C70	VPWR#3	a_846_74#	9.4103e-18
C71	a_342_74##2	a_27_74##3	7.26361e-17
C72	S0#11	VPWR#11	2.74085e-17
C73	VPWR#11	A1#1	4.91571e-19
C74	a_1338_125##5	VPWR#3	1.33159e-16
C75	a_27_74##11	A1#2	7.01735e-18
C76	a_27_74##13	S0#10	6.04265e-17
C77	S0#6	A0#1	1.06532e-17
C78	VPWR#10	A0#3	4.59934e-19
C79	VGND#9	a_846_74##4	3.33705e-17
C80	a_27_74##10	A1#2	1.40032e-19
C81	a_342_74##2	S0#7	6.94124e-17
C82	VGND#3	a_846_74#	3.91073e-18
C83	A3#2	a_846_74##2	1.17257e-18
C84	VPWR#11	a_27_74##3	3.8013e-19
C85	a_27_74##18	S0#11	4.32471e-17
C86	VGND#4	A3#2	1.64471e-18
C87	a_27_74##11	a_27_74##4	2.37347e-17
C88	a_342_74##2	A0#3	8.21547e-18
C89	VPWR#11	S0#7	2.97395e-18
C90	a_27_74##10	a_27_74##4	2.86647e-19
C91	a_1396_99##2	a_1396_99#	4.41347e-18
C92	a_27_74##13	a_27_74##2	1.44254e-18
C93	a_27_74##18	S0#7	2.64697e-19
C94	a_342_74##2	S0#4	2.81993e-18
C95	a_27_74##12	a_27_74##2	4.35687e-18
C96	a_342_74##4	VPWR#5	1.67639e-17
C97	A0#3	VPWR#11	3.48951e-17
C98	a_1338_125##2	VPWR#8	1.11915e-16
C99	a_27_74##18	S0#10	1.65965e-18
C100	VPWR#8	X#1	3.16452e-17
C101	a_846_74##6	a_27_74##8	7.4953e-19
C102	a_27_74##18	A0#3	2.95357e-18
C103	a_1396_99##7	a_1338_125##2	6.48964e-17
C104	VGND#9	A3#2	4.86416e-18
C105	A2#3	S0#1	3.12372e-20
C106	S0#4	VPWR#11	4.19622e-17
C107	a_27_74##13	A0#2	2.75979e-19
C108	a_27_74##10	A3#3	1.43861e-18
C109	a_27_74##12	A0#2	3.05983e-17
C110	VPWR#10	S0#3	1.00282e-17
C111	a_27_74##18	S0#4	4.48622e-17
C112	a_1338_125##5	a_1338_125##2	1.26743e-18
C113	a_27_74##5	a_846_74##6	1.78846e-18
C114	S1#1	a_1338_125#	1.41381e-17
C115	a_846_74#	S1#2	5.0553e-19
C116	a_27_74##13	S0#5	1.11229e-17
C117	a_27_74##10	S0#1	1.84886e-17
C118	X#3	a_1338_125##3	2.03948e-17
C119	a_27_74##12	S0#5	3.03902e-21
C120	a_1396_99#	a_1396_99##7	3.93559e-18
C121	a_1396_99##4	a_1338_125#	3.03094e-20
C122	a_27_74##11	a_27_74##6	8.60884e-20
C123	a_846_74#	a_1396_99#	7.1416e-17
C124	a_1338_125##3	VGND#8	2.37958e-17
C125	a_1396_99##4	S1#1	4.99033e-18
C126	a_342_74##2	VPWR#5	5.9256e-17
C127	a_1396_99#	a_1338_125##5	7.02202e-18
C128	A2#2	VGND#10	1.43479e-18
C129	a_27_74##10	a_27_74##6	1.09206e-17
C130	S0#11	A0#2	1.04535e-18
C131	a_1396_99##5	a_1338_125##3	3.84043e-20
C132	VPWR#4	S1#5	5.71267e-18
C133	a_27_74##11	A2#1	2.23404e-19
C134	S0#10	A0#2	2.58759e-17
C135	a_846_74#	a_1396_99##7	5.42619e-17
C136	VGND#3	a_1338_125##3	9.83666e-18
C137	S1#3	VGND#8	2.7391e-17
C138	S1#5	a_1396_99##4	3.73306e-17
C139	a_27_74##12	A1#3	1.37892e-19
C140	a_27_74##8	A3#2	2.21196e-17
C141	S0#11	S0#5	5.05128e-18
C142	a_27_74##10	A2#1	1.91962e-17
C143	VGND#3	S1#3	3.58879e-17
C144	a_1396_99##5	S1#3	6.84375e-17
C145	a_342_74#	A1#2	6.51979e-21
C146	a_1338_125##5	a_1396_99##7	3.99488e-17
C147	VGND#3	a_1396_99##3	1.93424e-18
C148	a_27_74##11	A1#3	2.50063e-17
C149	S0#10	S0#5	1.19769e-17
C150	VGND#8	a_1396_99##3	1.60583e-19
C151	VPWR#4	A3#1	1.17164e-18
C152	A3#1	S1#5	6.0459e-18
C153	a_342_74##4	a_27_74##8	2.801e-19
C154	VGND#4	S0#2	5.93584e-20
C155	VGND#3	S1#4	2.11038e-17
C156	a_27_74##12	S0#8	1.833e-18
C157	a_342_74##6	S1#3	3.31054e-19
C158	a_342_74##2	S0#3	8.64695e-18
C159	a_1338_125##5	a_846_74#	1.22216e-16
C160	a_1396_99##5	a_1396_99##3	1.08669e-18
C161	a_342_74#	a_27_74##4	3.02788e-18
C162	a_846_74##2	a_1338_125##3	8.86901e-19
C163	a_27_74##13	a_27_74#	2.87776e-19
C164	a_27_74##11	S0#8	2.99904e-17
C165	VGND#8	S1#4	2.04269e-19
C166	S1#5	a_1396_99##2	6.0053e-18
C167	a_1338_125##7	S1#3	1.0563e-19
C168	a_27_74##8	a_846_74##5	6.1565e-17
C169	a_27_74##7	A3#1	5.30122e-17
C170	VPWR#4	a_27_74##7	4.11601e-18
C171	a_342_74##6	a_1396_99##3	3.58458e-17
C172	a_1338_125##5	VPWR#4	2.29262e-17
C173	a_27_74##12	a_27_74#	2.03336e-17
C174	A3#2	S1#5	6.69014e-18
C175	a_27_74##10	S0#8	9.4663e-21
C176	a_27_74##2	a_342_74#	3.06685e-17
C177	a_846_74##2	S1#3	8.12992e-18
C178	a_846_74##5	a_27_74##5	1.93152e-18
C179	VGND#5	A3#3	2.22289e-19
C180	a_27_74##13	A0#1	1.6031e-18
C181	a_1338_125##7	a_1396_99##3	1.71965e-17
C182	a_27_74##11	a_27_74#	2.95758e-19
C183	S1#3	S1#2	1.17765e-18
C184	S0#2	a_27_74##7	4.24081e-18
C185	a_342_74##4	a_1338_125##5	1.054e-16
C186	VGND#5	S0#1	5.44788e-19
C187	a_342_74##6	S1#4	3.58867e-17
C188	a_1396_99##3	S1#2	4.94011e-19
C189	a_27_74##12	A0#1	3.54434e-17
C190	VPWR#4	S0#2	3.11104e-19
C191	a_846_74##2	a_1396_99##3	7.75429e-18
C192	VGND#5	a_27_74##6	1.11095e-17
C193	a_342_74##4	VPWR#4	8.61372e-17
C194	S1#3	a_1396_99#	3.62074e-18
C195	S1#4	a_1338_125##7	2.21257e-17
C196	VPWR#4	a_1396_99##2	3.66552e-20
C197	A0#2	VGND#11	3.22463e-18
C198	VPWR#9	a_1338_125##5	2.88974e-18
C199	VGND#5	A2#1	2.38297e-17
C200	a_27_74##13	S0#6	4.2592e-17
C201	A2#3	S0#2	5.34361e-17
C202	A3	A3#2	2.07382e-17
C203	a_1396_99#	a_1396_99##3	8.1187e-21
C204	a_342_74##2	a_27_74##5	1.22956e-18
C205	a_342_74##6	A3#3	2.90357e-19
C206	VPWR#10	A2#2	2.08223e-19
C207	VGND#5	A1#3	2.21062e-17
C208	S1#4	a_1396_99#	1.34527e-19
C209	a_846_74##2	S1#4	5.60285e-17
C210	a_27_74##12	S0#6	1.71343e-18
C211	a_342_74##4	VPWR#9	9.49417e-17
C212	VGND#5	S0#8	5.81272e-18
C213	VGND#11	S0#5	1.18096e-18
C214	a_342_74##2	A2#2	2.48968e-19
C215	VPWR#10	A1#2	2.31544e-19
C216	VPWR#3	a_1338_125#	5.27945e-18
C217	A1#1	A2#3	2.18048e-17
C218	VGND#5	a_27_74#	7.57234e-20
C219	VPWR#4	A3#2	1.59392e-19
C220	VGND#9	S1#4	1.80253e-18
C221	VPWR#11	S0#3	2.60051e-18
C222	VPWR#3	S1#1	4.12001e-18
C223	a_846_74##2	A3#3	3.80024e-18
C224	VGND#5	A0#1	4.41308e-20
C225	a_846_74##4	a_979_74#	8.40037e-19
C226	a_342_74##2	A1#2	6.53981e-19
C227	VPWR#3	a_1396_99##4	7.06047e-18
C228	a_27_74##3	A1#1	3.47299e-17
C229	S1	a_1396_99##2	1.75519e-20
C230	A3#3	a_27_74##8	2.25932e-17
C231	a_27_74##12	S0#3	8.97059e-19
C232	VGND#9	A3#3	4.1992e-17
C233	a_27_74##11	a_846_74##6	1.2203e-18
C234	VPWR#3	S1#5	3.78317e-18
C235	a_342_74##2	a_27_74##4	1.29402e-18
C236	a_342_74##4	a_846_74##5	1.5085e-16
C237	a_27_74##8	S0#1	2.85179e-17
C238	a_846_74##2	S0#1	1.41135e-19
C239	a_846_74##6	S1#4	7.79864e-20
C240	S0#7	a_27_74##3	4.04186e-17
C241	a_27_74##2	a_342_74##2	1.18832e-17
C242	a_27_74##5	S0#1	2.32734e-17
C243	a_27_74##10	a_846_74##6	6.62273e-17
C244	VGND#9	S0#1	2.2275e-18
C245	a_1338_125##2	a_1338_125#	1.32777e-17
C246	a_27_74##18	S0#3	2.57341e-20
C247	a_846_74##6	A3#3	1.06885e-17
C248	VGND#8	X#3	4.31481e-17
C249	a_1338_125##2	S1#1	3.25062e-17
C250	A2#2	S0#1	1.8438e-18
C251	A2#1	a_27_74##5	2.49372e-18
C252	a_342_74##2	A0#2	8.04757e-19
C253	S1#2	a_1338_125#	1.11277e-18
C254	A0#3	S0#7	6.14848e-18
C255	a_1338_125##2	a_1396_99##4	3.77203e-19
C256	VGND#9	a_27_74##6	4.76183e-19
C257	A2	A3#2	1.59935e-19
C258	a_27_74##11	S0#3	8.69388e-19
C259	a_342_74##4	a_1065_387#	1.06558e-17
C260	VPWR#11	A0#2	4.23168e-19
C261	a_1396_99#	a_1338_125#	2.64549e-19
C262	a_846_74##6	S0#1	4.41562e-17
C263	VPWR#5	S0#2	2.5075e-17
C264	a_1396_99##4	S1#2	1.70311e-19
C265	a_27_74##4	S0#3	1.95212e-19
C266	a_1396_99#	S1#1	4.90311e-18
C267	S0#4	A0#3	3.82781e-17
C268	VPWR#5	A2#3	2.1309e-18
C269	S0#3	S0#2	1.73851e-19
C270	a_846_74##5	a_1065_387#	1.86691e-18
C271	VGND#5	S0#2	4.53229e-20
C272	VGND#9	A2#1	1.67995e-19
C273	VPWR#11	S0#5	5.47384e-19
C274	a_1396_99#	a_1396_99##4	1.15727e-19
C275	VPWR#5	A1#1	3.8822e-18
C276	a_846_74##6	a_27_74##6	3.66551e-17
C277	a_27_74##18	S0#5	5.62353e-18
C278	S1#5	a_1396_99#	6.4746e-19
C279	a_1396_99##5	VGND#8	6.10388e-17
C280	a_342_74##2	a_342_74##4	1.0713e-18
C281	S0#8	A1#2	5.90595e-20
C282	a_27_74##12	a_342_74#	7.17142e-17
C283	VPWR#5	a_27_74##3	2.815e-18
C284	a_342_74#	S0#3	1.1433e-18
C285	a_27_74##10	a_768_74#	2.80139e-18
C286	a_846_74##4	A2#3	4.90209e-20
C287	S0#8	a_27_74##4	2.03726e-17
C288	a_846_74##6	A2#1	3.05165e-18
C289	a_27_74##11	a_342_74#	6.29984e-17
C290	a_27_74##2	S0#3	6.12582e-18
C291	a_846_74##6	a_979_74#	8.27748e-18
C292	a_27_74##11	a_450_74#	1.50813e-17
C293	a_342_74##2	a_763_341#	7.80463e-18
C294	a_27_74##2	S0#8	1.78068e-17
C295	a_27_74##13	VGND#11	4.97316e-17
C296	a_846_74##6	A1#3	4.31894e-19
C297	A0#1	a_27_74##2	3.50572e-19
C298	a_342_74##2	a_537_341#	5.02407e-18
C299	a_27_74##8	S0#2	3.07705e-17
C300	A2#1	VGND#10	1.76995e-17
C301	a_342_74##2	a_846_74##5	4.26578e-17
C302	A2#3	a_27_74##8	1.39073e-18
C303	a_27_74##12	VGND#11	2.5712e-17
C304	a_27_74##5	S0#2	1.66249e-17
C305	a_846_74##6	S0#8	1.93049e-19
C306	a_27_74##13	a_27_74##14	3.3189e-18
C307	a_846_74#	S1#3	9.00098e-19
C308	a_342_74##2	a_255_341#	4.10753e-18
C309	A0	S0#3	2.05247e-20
C310	A1#3	VGND#10	1.76995e-17
C311	a_846_74##4	a_342_74##4	8.43339e-18
C312	A2#2	S0#2	1.71735e-19
C313	a_846_74##2	VGND#8	5.00229e-18
C314	a_1338_125##2	VPWR#3	3.09379e-17
C315	a_27_74##12	a_264_74#	1.39124e-18
C316	a_27_74##18	a_255_341#	3.57303e-19
C317	VGND#3	a_1338_125##2	5.05798e-18
C318	VPWR#3	S1#2	1.12549e-20
C319	A1#2	S0#2	1.92339e-19
C320	A1#1	S0#3	2.07614e-17
C321	a_846_74#	a_1396_99##3	4.82708e-18
C322	a_342_74##2	VPWR#10	7.79325e-17
C323	VGND#3	VGND#4	9.77706e-18
C324	VGND#3	S1#2	4.40847e-19
C325	VPWR#3	a_1396_99#	3.53104e-18
C326	a_342_74##6	a_1338_125##7	5.63718e-17
C327	a_846_74##2	a_1396_99##5	8.61289e-18
C328	a_342_74#	A1#3	6.68799e-19
C329	VGND#3	a_1396_99#	9.31481e-18
C330	a_846_74#	S1#4	1.27557e-18
C331	a_27_74##3	A1#2	1.69342e-18
C332	a_846_74##4	A3	6.22418e-17
C333	a_27_74##11	S0#2	2.85047e-19
C334	VPWR#3	VPWR#4	2.037e-17
C335	S1#4	a_1396_99##2	2.08825e-17
C336	a_342_74##4	a_1396_99##3	4.5824e-20
C337	S1#2	a_1338_125##2	3.65122e-17
C338	a_342_74##6	a_846_74##2	1.32738e-16
C339	a_27_74##10	S0#2	8.56996e-18
C340	a_342_74#	S0#8	3.75874e-17
C341	S0#7	a_27_74##4	1.44772e-17
C342	A3#2	S1#4	1.97261e-17
C343	a_1396_99#	a_1338_125##2	4.48469e-18
C344	VGND#11	A1#3	6.8908e-20
C345	S0#3	a_27_74##3	2.46599e-17
C346	a_27_74##2	S0#7	1.75376e-17
C347	a_1396_99#	S1#2	3.30723e-17
C348	a_342_74##4	S1#4	8.25816e-18
C349	VPWR#5	a_27_74##5	2.95721e-19
C350	a_27_74#	a_342_74#	1.1356e-17
C351	A3#1	a_1065_387#	1.86192e-17
C352	A0#2	S0#7	1.05641e-18
C353	VGND#5	a_27_74##5	2.05244e-19
C354	a_27_74##7	a_1065_387#	7.30492e-18
C355	VGND#11	S0#8	2.65432e-19
C356	A3#3	a_979_74#	1.55312e-18
C357	VGND#5	A2#2	9.18995e-19
C358	a_342_74##4	A3#3	3.12772e-19
C359	VGND#5	VGND#4	1.98955e-19
C360	a_846_74##4	a_846_74##5	2.34206e-18
C361	S0#1	a_979_74#	8.75513e-18
C362	A0#2	S0#4	3.2341e-19
C363	VPWR#11	a_342_74##2	1.93243e-17
C364	S0#5	A0#3	2.23079e-18
C365	A2	a_846_74##4	5.21303e-19
C366	VGND#5	A1#2	1.00968e-18
C367	S0#2	a_763_341#	5.71803e-18
C368	VPWR#5	a_27_74##4	1.71447e-19
C369	a_1338_125##7	a_1396_99##4	1.8131e-20
C370	S0#5	S0#4	2.15607e-19
C371	VGND#11	a_27_74#	2.62723e-18
C372	A2#3	a_763_341#	1.88525e-17
C373	VGND#5	a_27_74##4	8.63329e-19
C374	a_342_74##4	S0#1	3.98839e-19
C375	a_27_74##8	a_27_74##5	2.47207e-18
C376	VGND#9	a_846_74##2	3.42487e-17
C377	A1#1	a_537_341#	2.20725e-17
C378	a_1396_99##5	S1	2.794e-17
C379	a_1338_125##7	S1#5	2.90632e-18
C380	A0#1	VGND#11	2.59329e-17
C381	a_27_74##6	a_768_74#	1.42555e-17
C382	A2#2	a_27_74##8	2.4572e-18
C383	a_27_74##3	a_537_341#	1.30144e-17
C384	A2#1	a_768_74#	1.42555e-17
C385	A2#2	a_27_74##5	3.09375e-17
C386	a_846_74##5	A3#3	6.95164e-19
C387	VPWR	S0#3	3.24286e-17
C388	a_27_74##18	VPWR#11	8.19032e-17
C389	a_27_74##10	a_846_74##4	2.57417e-17
C390	S0#7	a_255_341#	3.3884e-17
C391	a_27_74##11	S0#7	1.54038e-18
C392	S0#6	VGND#11	2.86181e-17
C393	a_27_74##11	A1	6.14427e-17
C394	VGND#4	a_846_74##2	5.87062e-17
C395	A1#3	a_450_74#	5.36634e-18
C396	A1#2	A2#2	2.57025e-17
C397	A0#3	a_255_341#	2.5545e-18
C398	VGND#4	S1#4	8.40058e-18
C399	S0#8	a_450_74#	1.20898e-17
C400	A3	a_342_74##4	3.64415e-17
C401	a_846_74##5	S0#1	5.69883e-19
C402	S0#1	A3#2	1.16952e-18
C403	S0#6	a_27_74##14	6.68e-18
C404	A0#3	S0#3	3.63234e-18
C405	a_27_74##4	A1#2	3.59997e-17
C406	a_846_74##6	a_846_74##2	8.52062e-19
C407	S1	a_1338_125##5	1.70047e-18
C408	a_27_74##13	S0#4	2.32317e-19
C409	S0#10	VGND#11	2.37112e-18
C410	VGND#4	A3#3	9.60343e-19
C411	S0#11	A0	2.32981e-17
C412	a_27_74#	a_264_74#	1.14517e-17
C413	a_27_74##12	S0#4	1.76265e-21
C414	A1	VGND#10	1.8969e-18
C415	A0#1	a_264_74#	2.64619e-18
C416	a_846_74##6	VGND#9	5.20447e-17
C417	S0#10	A0	3.53244e-18
C418	VGND	A3#2	5.19479e-18
C419	A0#2	a_27_74##2	6.02677e-17
C420	a_342_74#	A1	7.1904e-19
C421	A3	S1#4	1.36844e-18
C422	a_27_74##2	S0#5	2.43121e-19
C423	A2	a_846_74##5	9.54293e-18
C424	A2	VPWR#10	3.16357e-18
C425	S1	S1#3	3.58635e-19
C426	S0#5	A0#2	2.55156e-17
C427	S1	a_1396_99##3	5.79543e-20
C428	A2	a_342_74##2	3.66298e-17
C429	S0#4	S0#3	5.85643e-19
C430	S1#3	a_1338_125##3	2.46687e-17
C431	a_1338_125#	X#1	1.20593e-17
C432	VGND#4	S0#1	5.70305e-18
C433	A1	VPWR#10	3.57766e-18
C434	a_342_74##2	A1	5.45863e-17
C435	VPWR#8	a_1338_125#	5.08439e-17
C436	VPWR	VPWR#4	1.13691e-16
C437	A2	S0#1	4.9009e-19
C438	A3	S1#5	7.20562e-19
C439	S0#11	A0#3	7.81895e-19
C440	a_846_74#	a_1396_99##2	8.40096e-18
C441	S1	a_1338_125#	1.66556e-19
C442	a_1396_99##2	VNB	2.47772e-17
C443	A3#2	VNB	8.34871e-17
C444	X	X#3	1.13027e-18
C445	S0#3	VNB	1.27797e-16
C446	VGND#8	X	2.54128e-17
C447	a_846_74##6	S0#2	3.45201e-19
C448	a_1396_99##5	X	5.04829e-19
C449	a_1396_99##3	S1#3	2.1275e-18
C450	A0	a_342_74##2	8.86982e-18
C451	VGND#4	a_846_74##6	2.57763e-17
C452	A0	VPWR#11	2.49101e-17
C453	S1#1	VPWR#8	3.99853e-17
C454	VGND#4	a_27_74##8	6.17401e-20
C455	VPWR	a_27_74##11	3.84453e-18
C456	VPWR	a_27_74##10	4.39832e-18
C457	VGND	VGND#4	1.24129e-16
C458	VPWR	S0#11	4.12219e-18
C459	S1#4	S1#3	2.3936e-19
C460	S0#11	S0#4	6.38947e-18
C461	S1#1	a_1396_99##7	3.0225e-17
C462	A2	A3#1	1.13204e-20
C463	X	X#1	1.03842e-17
C464	VPWR#4	A3#3	1.68898e-20
C465	VPWR#8	X	1.63782e-17
C466	A2	a_27_74##7	2.11192e-19
C467	S0#2	VGND#10	1.23609e-18
C468	A2	S0#2	8.57774e-18
C469	VPWR#8	a_1396_99##4	2.3366e-19
C470	A2	A2#3	1.70865e-17
C471	VGND	a_846_74##4	7.75521e-18
C472	A2	A1#1	4.91258e-18
C473	a_27_74##4	a_450_74#	2.22663e-18
C474	a_846_74#	S1#1	1.64561e-18
C475	VPWR#3	S1	3.59183e-18
C476	S1#4	a_1396_99##3	5.09519e-17
C477	VGND	a_27_74##13	2.27411e-17
C478	VGND#3	S1	5.04181e-18
C479	A1	S0#2	2.63614e-19
C480	a_846_74##6	VGND#10	4.83109e-20
C481	VGND	a_27_74##12	2.74057e-17
C482	VGND	a_27_74##11	3.1404e-17
C483	A1	A2#3	3.11139e-18
C484	VGND	a_27_74##10	1.85698e-17
C485	a_1396_99##7	a_1396_99##4	1.19584e-18
C486	A1	A1#1	1.63311e-17
C487	A1	a_27_74##3	5.70168e-18
C488	X	a_1338_125##3	1.81338e-17
C489	S1	a_1338_125##2	6.37535e-17
C490	X	S1#3	7.57557e-19
C491	A1	S0#7	2.93433e-19
C492	a_1338_125##5	a_1396_99##2	8.85424e-20
C493	VGND	S0#10	4.31536e-18
C494	VPWR#3	a_1396_99##2	3.63653e-20
C495	VGND#4	VNB	7.18868e-17
C496	a_1338_125##5	S1#1	1.67019e-17
C497	S1	S1#2	2.30383e-17
C498	VPWR#8	S1#5	4.40276e-20
C499	VPWR	a_342_74##4	5.76825e-17
C500	VPWR	VPWR#9	1.5731e-17
C501	VPWR#4	VNB	7.56035e-17
C502	VGND	a_342_74##6	5.05212e-18
C503	a_1396_99#	S1	4.87444e-17
C504	VPWR	a_846_74##5	2.24401e-17
C505	VPWR#4	a_27_74##8	2.72074e-20
C506	VGND	a_846_74##2	3.18863e-17
C507	VGND	VGND#9	2.32806e-17
C508	a_1396_99##4	a_846_74#	3.83004e-17
C509	VPWR#4	S0#1	6.82927e-20
C510	a_27_74##10	a_846_74##5	5.92933e-18
C511	VPWR	VPWR#10	1.87565e-17
C512	VGND	a_846_74##6	3.17051e-17
C513	VPWR	a_342_74##2	5.82428e-17
C514	A0	S0#7	1.68221e-18
C515	a_846_74##4	VNB	1.02189e-17
C516	VGND	a_342_74#	1.02933e-17
C517	A0	A0#3	9.38959e-18
C518	a_27_74##13	a_27_74##12	1.79786e-18
C519	VPWR	a_27_74##18	2.20675e-17
C520	VGND	VGND#11	2.10468e-17
C521	A0	S0#4	1.73794e-18
C522	A2	a_27_74##8	7.53854e-18
C523	a_27_74##13	VNB	5.81301e-17
C524	a_27_74##12	VNB	7.88622e-18
C525	X	a_1338_125#	1.66155e-17
C526	a_27_74##11	VNB	1.07376e-17
C527	a_1338_125##5	A3#2	1.71737e-20
C528	a_27_74##10	VNB	5.87868e-18
C529	X	S1#1	1.20038e-18
C530	a_1338_125##5	a_1396_99##4	8.54204e-17
C531	A3#3	S1#4	2.51293e-18
C532	A2	A2#2	7.63081e-18
C533	S0#11	VNB	4.97729e-18
C534	A2	A1#2	1.50006e-18
C535	S0#10	VNB	1.62604e-18
C536	X#3	VNB	2.09761e-17
C537	VGND#8	VNB	1.08178e-17
C538	a_1396_99##5	VNB	1.5123e-17
C539	a_846_74#	S1#5	1.25185e-21
C540	VGND	a_342_74##2	3.01077e-18
C541	a_1338_125##7	VNB	1.4159e-18
C542	a_846_74##2	VNB	2.72492e-17
C543	VGND#9	VNB	9.16233e-18
C544	A1	A2#2	2.62003e-17
C545	a_846_74##6	VNB	1.26162e-19
C546	A1	A1#2	1.63281e-17
C547	a_342_74##4	a_1396_99##4	2.16503e-18
C548	a_342_74#	VNB	3.30611e-18
C549	A1	a_27_74##4	3.84788e-18
C550	VGND	S1#4	2.42351e-18
C551	VPWR	S1#5	2.15602e-18
C552	VGND#11	VNB	4.20871e-18
C553	VGND	A3#3	7.30742e-19
C554	VGND	S0#1	4.30089e-19
C555	VPWR	A3#1	3.2615e-18
C556	X#1	VNB	1.72883e-17
C557	VGND	a_27_74##6	1.09725e-18
C558	VPWR#8	VNB	5.38124e-18
C559	a_1396_99##7	VNB	7.88608e-18
C560	VGND	A2#1	4.04258e-19
C561	VPWR	S0#2	1.37759e-17
C562	a_846_74#	VNB	2.7301e-17
C563	VGND	A1#3	4.89151e-19
C564	a_1338_125##5	S1#5	2.24944e-17
C565	a_1338_125##5	VNB	1.34889e-17
C566	VGND#3	X	2.33091e-17
C567	VPWR	A2#3	2.07018e-18
C568	VGND	S0#8	1.79089e-18
C569	a_342_74##4	VNB	3.01597e-17
C570	VPWR#9	VNB	4.16818e-18
C571	VGND	a_27_74#	2.63795e-19
C572	VPWR	A1#1	4.0846e-18
C573	VGND	A0#1	1.00775e-18
C574	VPWR	a_27_74##3	5.00601e-18
C575	a_846_74##5	VNB	1.34352e-19
C576	VGND	S0#6	1.38809e-18
C577	A0	a_27_74##2	1.06063e-17
C578	VGND#5	a_27_74##11	8.47091e-17
C579	VPWR#10	VNB	8.77004e-18
C580	a_1338_125##2	X	7.74512e-17
C581	VPWR	A0#3	3.99348e-18
C582	A0	A0#2	6.61589e-18
C583	a_342_74##2	VNB	1.18056e-17
C584	X	S1#2	2.94344e-19
C585	VPWR#9	a_1396_99##4	4.14688e-19
C586	VPWR	S0#4	1.00821e-17
C587	VPWR#11	VNB	1.01111e-17
C588	a_1396_99#	X	7.35122e-19
C589	A0	S0#5	1.57926e-18
C590	a_27_74##18	VNB	6.87331e-17
C591	a_1338_125##3	VNB	3.86179e-17
C592	a_342_74##4	a_1396_99##2	2.18273e-18
C593	S1#3	VNB	1.14718e-16
C594	VGND#3	a_1396_99##2	3.39735e-19
C595	a_1396_99##3	VNB	2.7613e-17
C596	a_1396_99##5	a_1396_99##7	4.53816e-20
C597	S1#4	VNB	1.12988e-16
C598	VGND	S0#2	5.81877e-21
C599	VPWR	VPWR#5	1.51603e-16
C600	A3#3	VNB	3.56004e-17
C601	S0#1	VNB	5.22204e-17
C602	a_342_74##4	S1#5	7.98624e-17
C603	a_27_74##6	VNB	2.48314e-17
C604	VGND#5	a_27_74##10	2.63515e-17
C605	S0#1	A3#3	5.17735e-17
C606	A2#1	VNB	2.40101e-17
C607	A1#3	VNB	2.74504e-17
C608	S0#8	VNB	4.04253e-17
C609	VGND#4	a_846_74##4	1.94692e-18
C610	a_27_74#	VNB	2.65834e-17
C611	A0#1	VNB	3.18501e-17
C612	A0	a_255_341#	2.17183e-18
C613	S0#6	VNB	3.5808e-17
C614	VPWR	a_27_74##8	5.63224e-18
C615	a_1338_125#	VNB	4.31584e-17
C616	S1#1	VNB	4.25906e-17
C617	VPWR	a_27_74##5	1.70233e-18
C618	a_1338_125##5	A3#1	5.74835e-19
C619	a_1396_99##4	VNB	4.07322e-17
C620	S1#5	VNB	4.51916e-17
C621	A3#1	VNB	4.34549e-17
C622	VGND	VGND#5	1.76155e-16
C623	a_27_74##7	VNB	3.21449e-17
C624	S0#2	VNB	1.07586e-16
C625	A2#3	VNB	2.83823e-17
C626	VPWR	a_27_74##2	1.41241e-17
C627	A1#1	VNB	2.45627e-17
C628	a_27_74##3	VNB	2.49336e-17
C629	VPWR#9	S1#5	2.88425e-18
C630	S0#7	VNB	3.01384e-17
C631	VGND	a_27_74##8	2.32404e-18
C632	a_27_74##12	a_27_74##11	2.09266e-18
C633	A0#3	VNB	3.11005e-17
C634	S0#4	VNB	9.51833e-17
C635	VGND	a_27_74##5	1.39967e-18
C636	VGND	A2#2	5.13443e-18
C637	a_342_74##4	A3#2	1.19568e-17
C638	VPWR#3	VNB	2.09466e-16
C639	VGND#3	VNB	1.90825e-16
C640	VPWR#5	VNB	6.51835e-17
C641	VGND	a_27_74##4	7.7981e-19
C642	VGND#5	VNB	7.83266e-17
C643	VGND	a_27_74##2	3.52353e-18
C644	a_1338_125##2	VNB	5.39128e-17
C645	a_342_74##4	A3#1	3.88096e-17
C646	VGND	A0#2	3.48469e-18
C647	S1#2	VNB	3.05727e-17
C648	a_1396_99#	VNB	5.55455e-17
C649	a_27_74##8	VNB	3.12642e-17
C650	a_846_74#	a_1396_99##5	6.00243e-17
C651	a_27_74##5	VNB	2.08928e-17
C652	A2#2	VNB	2.99875e-17
C653	A1#2	VNB	2.97423e-17
C654	a_27_74##4	VNB	2.59092e-17
C655	A1	A2	5.97669e-17
C656	a_846_74##4	A3#2	5.58451e-17
C657	a_27_74##2	VNB	3.81212e-17
C658	A0#2	VNB	3.15719e-17
C659	S0#5	VNB	5.00209e-17
C660	VPWR#9	A3#1	3.21844e-17
C661	a_27_74##6	S0#1	1.40966e-17
C662	VPWR	A3	3.47773e-18
C663	VPWR	A2	5.14002e-18
C664	VGND	A3	2.10765e-18
C665	VPWR	A1	4.73429e-18
C666	a_342_74#	S0#7	2.99689e-18
C667	VPWR	A0	5.85121e-18
C668	A3	VNB	4.46866e-18
C669	VGND	A1	4.48085e-18
C670	a_846_74##5	S1#5	1.47936e-18
C671	S1	VNB	2.3901e-18
C672	a_342_74##4	a_27_74##7	2.44339e-17
C673	A2	VNB	2.88112e-18
C674	A1	VNB	1.28705e-18
C675	A0	VNB	2.22086e-18
C676	a_846_74#	a_342_74##6	4.30831e-17
C677	X	VNB	7.69144e-17
C678	a_27_74##11	a_342_74##2	2.19055e-17
C679	VPWR	VNB	3.2103e-16
C680	a_846_74##4	a_27_74##8	8.47894e-17
C681	VGND	VNB	2.97269e-16
C682	VGND#3	a_1396_99##5	3.64584e-17
C683	VGND#6	a_27_74##11	9.62435e-19
C684	VGND#6	S0#6	5.44495e-18
C685	VGND#2	S1#3	1.30732e-17
C686	A0	VPWR#6	9.79582e-19
C687	a_27_74##18	VPWR#6	1.92338e-17
C688	VGND#3	VGND#2	1.02317e-16
C689	VGND#6	a_27_74#	4.47811e-18
C690	VGND#2	S1	8.11718e-19
C691	VGND#6	a_27_74##13	2.19243e-17
C692	VGND#6	S0#5	5.45838e-21
C693	VGND#2	X	2.07047e-17
C694	VPWR#2	VNB	4.61951e-17
C695	VGND	VGND#6	1.31301e-16
C696	VPWR#6	S0#4	4.03276e-17
C697	VPWR#6	S0#3	2.48284e-17
C698	VPWR#2	a_1338_125#	5.05243e-18
C699	VPWR#2	S1#2	2.10774e-20
C700	S0#11	VPWR#6	3.03235e-19
C701	VGND#2	a_1338_125##2	7.76792e-19
C702	VGND#6	a_27_74##2	1.08729e-19
C703	VPWR#6	VNB	6.2074e-17
C704	VPWR	VPWR#6	1.55578e-16
C705	X#1	VPWR#2	1.36252e-17
C706	VGND#2	a_1338_125##3	6.87762e-18
C707	VGND#6	a_27_74##12	4.34578e-17
C708	VGND#6	A0#1	8.43497e-18
C709	VGND#2	VNB	4.82534e-17
C710	a_342_74##2	VPWR#6	3.69419e-18
C711	VPWR#6	S0#5	7.93539e-20
C712	VPWR#6	a_27_74##2	3.02887e-18
C713	VGND#6	VNB	7.66791e-17
C714	VPWR#3	VPWR#2	7.5517e-17
C715	VGND#6	S0#8	1.22715e-18
C716	a_846_74##2	VGND#2	2.90914e-18
C717	a_1338_125##2	VPWR#2	5.56409e-18
C718	VPWR#6	A0#3	4.89614e-18
*
*
.ENDS sky130_fd_sc_hs__mux4_1
*
