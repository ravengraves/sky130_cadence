* Extracted by Quantus, converted by sky130cad/quantus.py
*
*
*
*                       LINUX           Wed Nov 18 09:14:47 2026
*
*
*
*  PROGRAM  advgen
*
*  Name           : advgen - Quantus - (64-bit)
*  Version        : 25.1.0-p047
*  Build Date     : Thu Dec 11 23:20:30 PST 2025
*
*  HSPICE LIBRARY
*
*  OPERATING_TEMPERATURE 150
*  QRC_TECH_DIR <path>/tech
*
*
*

*
.SUBCKT sky130_fd_sc_hs__xnor3_4 VNB VPB VGND VPWR X B C A
*
*
*  caps2d version: 10
*
*
*       TRANSISTOR CARDS
*
*
XM11 a_27_373# a_75_227# VGND#14 VNB sky130_fd_pr__nfet_01v8_lvt l=0.15 w=0.64 ad=0.1824 as=0.224 pd=1.85 ps=1.98
XM3 VGND#14 A#1 a_75_227##8 VNB sky130_fd_pr__nfet_01v8_lvt l=0.15 w=0.64 ad=0.224 as=0.2144 pd=1.98 ps=1.95
XM10 a_75_227##8 B#5 a_321_77##4 VNB sky130_fd_pr__nfet_01v8_lvt l=0.15 w=0.64 ad=0.2144 as=0.1915 pd=1.95 ps=1.93
XM0 a_321_77##4 a_386_23##4 a_27_373##6 VNB sky130_fd_pr__nfet_01v8_lvt l=0.15 w=0.42 ad=0.1915 as=0.2811 pd=1.93 ps=2.21
XM16 a_27_373##6 B#9 a_324_373# VNB sky130_fd_pr__nfet_01v8_lvt l=0.15 w=0.64 ad=0.2811 as=0.192 pd=2.21 ps=1.88
XM13 a_324_373# a_386_23##3 a_75_227##10 VNB sky130_fd_pr__nfet_01v8_lvt l=0.15 w=0.64 ad=0.192 as=0.3467 pd=1.88 ps=2.79
XM22 a_386_23##9 B#7 VGND#13 VNB sky130_fd_pr__nfet_01v8_lvt l=0.15 w=0.74 ad=0.2109 as=0.3368 pd=2.05 ps=2.67
XM12 a_321_77##6 a_1024_300##3 a_1057_74##17 VNB sky130_fd_pr__nfet_01v8_lvt l=0.15 w=0.64 ad=0.1824 as=0.2592 pd=1.85 ps=2.09
XM1 a_1057_74##17 C#4 a_324_373##5 VNB sky130_fd_pr__nfet_01v8_lvt l=0.15 w=0.64 ad=0.2592 as=0.192 pd=2.09 ps=1.88
XM25 a_1024_300##7 C#5 VGND#10 VNB sky130_fd_pr__nfet_01v8_lvt l=0.15 w=0.42 ad=0.1197 as=1.37325 pd=1.41 ps=4.85
XM8 X#8 a_1057_74##13 VGND#10 VNB sky130_fd_pr__nfet_01v8_lvt l=0.15 w=0.74 ad=0.2072 as=1.37325 pd=2.04 ps=4.85
XM2 VGND#9 a_1057_74##11 X#8 VNB sky130_fd_pr__nfet_01v8_lvt l=0.15 w=0.74 ad=0.2072 as=0.2072 pd=2.04 ps=2.04
XM5 VGND#9 a_1057_74##9 X#4 VNB sky130_fd_pr__nfet_01v8_lvt l=0.15 w=0.74 ad=0.2072 as=0.2072 pd=2.04 ps=2.04
XM17 X#4 a_1057_74# VGND#1 VNB sky130_fd_pr__nfet_01v8_lvt l=0.15 w=0.74 ad=0.2072 as=0.2109 pd=2.04 ps=2.05
XM6 a_27_373##3 a_75_227##3 VPWR#12 VPB sky130_fd_pr__pfet_01v8 l=0.15 w=1 ad=0.295 as=0.35 pd=2.59 ps=2.7
XM19 VPWR#12 A#3 a_75_227##5 VPB sky130_fd_pr__pfet_01v8 l=0.15 w=1 ad=0.35 as=0.3748 pd=2.7 ps=2.78
XM26 a_75_227##5 B#4 a_324_373##2 VPB sky130_fd_pr__pfet_01v8 l=0.15 w=0.84 ad=0.3748 as=0.405 pd=2.78 ps=2.78
XM4 a_324_373##2 a_386_23##5 a_27_373##4 VPB sky130_fd_pr__pfet_01v8 l=0.15 w=0.64 ad=0.405 as=0.192 pd=2.78 ps=1.88
XM23 a_27_373##4 B#8 a_321_77# VPB sky130_fd_pr__pfet_01v8 l=0.15 w=0.64 ad=0.192 as=0.2834 pd=1.88 ps=2.4
XM20 a_321_77# a_386_23# a_75_227##4 VPB sky130_fd_pr__pfet_01v8 l=0.15 w=0.84 ad=0.2834 as=0.38735 pd=2.4 ps=2.91
XM21 a_386_23##6 B#1 VPWR#11 VPB sky130_fd_pr__pfet_01v8 l=0.15 w=1.12 ad=0.3304 as=0.3304 pd=2.83 ps=2.83
XM15 a_324_373##7 a_1024_300# a_1057_74##18 VPB sky130_fd_pr__pfet_01v8 l=0.15 w=0.84 ad=0.2478 as=0.4557 pd=2.27 ps=3.04
XM7 a_1057_74##18 C#6 a_321_77##5 VPB sky130_fd_pr__pfet_01v8 l=0.15 w=0.84 ad=0.4557 as=0.2478 pd=3.04 ps=2.27
XM24 a_1024_300##4 C#1 VPWR#10 VPB sky130_fd_pr__pfet_01v8 l=0.15 w=0.64 ad=0.1888 as=1.0632 pd=1.87 ps=4.34
XM27 X#3 a_1057_74##14 VPWR#10 VPB sky130_fd_pr__pfet_01v8 l=0.15 w=1.12 ad=0.336 as=1.0632 pd=2.84 ps=4.34
XM14 VPWR#9 a_1057_74##12 X#3 VPB sky130_fd_pr__pfet_01v8 l=0.15 w=1.12 ad=0.336 as=0.336 pd=2.84 ps=2.84
XM18 X#6 a_1057_74##10 VPWR#9 VPB sky130_fd_pr__pfet_01v8 l=0.15 w=1.12 ad=0.336 as=0.336 pd=2.84 ps=2.84
XM9 VPWR#1 a_1057_74##8 X#6 VPB sky130_fd_pr__pfet_01v8 l=0.15 w=1.12 ad=0.3304 as=0.336 pd=2.83 ps=2.84
*
*
*       RESISTOR AND CAP/DIODE CARDS
*
Rg1	a_75_227#	a_75_227##2	291.663208
Rg2	a_75_227##2	a_75_227##3	513.659058
Rg3	A#1	A#2	416.971466
Rg4	A#2	A#3	400.207520
Rg5	a_386_23#	a_386_23##2	354.298584
Rg6	a_386_23##2	a_386_23##3	290.721832
Rg7	a_386_23##3	a_386_23##4	1283.959839
Rg8	a_386_23##4	a_386_23##5	763.111694
Rg9	B#1	B#2	442.268127
Rg10	B#2	B#3	1494.451782
Rg11	B#3	B#4	1030.881104
Rg12	B#4	B#5	889.983887
Rg13	B#2	B#6	12.078511
Rg14	B#6	B#7	335.326721
Rg15	B#3	B#8	447.099945
Rg16	B#8	B#9	775.688049
Rg17	a_1024_300#	a_1024_300##2	354.298584
Rg18	a_1024_300##2	a_1024_300##3	497.312164
Rg19	C#1	C#2	285.875671
Rg20	C#2	C#3	440.711121
Rg21	C#3	C#4	457.920563
Rg22	C#2	C#5	210.821686
Rg23	C#3	C#6	469.684204
Rg24	a_1057_74#	a_1057_74##2	322.244293
Rg25	a_1057_74##2	a_1057_74##3	67.463860
Rg26	a_1057_74##3	a_1057_74##4	74.366837
Rg27	a_1057_74##4	a_1057_74##5	76.646584
Rg28	a_1057_74##5	a_1057_74##6	9.292394
Rg29	a_1057_74##6	a_1057_74##7	67.015266
Rg30	a_1057_74##2	a_1057_74##8	455.608124
Rg31	a_1057_74##3	a_1057_74##9	320.892242
Rg32	a_1057_74##3	a_1057_74##10	453.044830
Rg33	a_1057_74##4	a_1057_74##11	369.857300
Rg34	a_1057_74##4	a_1057_74##12	458.805878
Rg35	a_1057_74##5	a_1057_74##13	344.584381
Rg36	a_1057_74##6	a_1057_74##14	433.532959
Rf1	a_27_373#	a_27_373##2	97.742477
Rf2	a_27_373##2	a_27_373##3	20.178268
Rf3	A#2	A#5	162.175049
Rf4	A#6	A	1.942243
Rf5	A#5	A#6	4.094857
Rf6	a_27_373##4	a_27_373##5	110.569954
Rf7	a_27_373##5	a_27_373##6	102.489174
Rf8	a_324_373#	a_324_373##3	98.288185
Rf9	a_324_373##3	a_324_373##4	1.879877
Rf10	a_324_373##2	a_324_373##3	15.000000
Rf11	a_75_227##4	a_75_227##6	200.186050
Rf12	a_75_227##6	a_75_227##7	97.621147
Rf13	a_75_227##7	a_75_227##9	72.050537
Rf14	a_75_227##9	a_75_227##10	177.875946
Rf15	a_75_227##5	a_75_227##6	5.000000
Rf16	a_75_227##8	a_75_227##9	7.500000
Rf17	B	B#6	166.137894
Rf18	a_386_23##6	a_386_23##7	69.906311
Rf19	a_386_23##7	a_386_23##2	177.575104
Rf20	a_386_23##7	a_386_23##9	64.269272
Rf21	a_324_373##5	a_324_373##6	159.800354
Rf22	a_324_373##6	a_324_373##7	18.569801
Rf23	a_321_77#	a_321_77##2	125.901535
Rf24	a_321_77##2	a_321_77##3	104.592438
Rf25	a_321_77##3	a_321_77##4	208.793228
Rf26	a_321_77##2	a_321_77##5	119.466721
Rf27	a_321_77##3	a_321_77##6	20.991852
Rf28	a_1024_300##4	a_1024_300##5	55.471458
Rf29	a_1024_300##5	a_1024_300##2	240.755920
Rf30	a_1024_300##5	a_1024_300##7	45.565369
Rf31	C	C#2	166.137894
Rf32	a_1057_74##7	a_1057_74##16	66.618652
Rf33	a_1057_74##16	a_1057_74##17	215.328156
Rf34	a_1057_74##16	a_1057_74##18	226.238617
Rf35	X	X#1	8.726183
Rf36	X#1	X#2	35.385235
Rf37	X#2	X#3	51.894478
Rf38	X	X#5	2.558873
Rf39	X#5	X	12.007017
Rf40	X#1	X	5.274139
Rf41	X	X#7	13.403392
Rf42	X#7	X	0.183608
Rf43	X#2	X#8	45.114147
Rf44	X#4	X#5	7.500000
Rf45	X#6	X#7	5.000000
Rf46	VGND#1	VGND#2	111.703896
Rf47	VGND#2	VGND#3	39.545311
Rf48	VGND#3	VGND#4	64.366699
Rf49	VGND#4	VGND#5	227.244766
Rf50	VGND#5	VGND#6	78.504745
Rf51	VGND#6	VGND#7	184.793228
Rf53	VGND#2	VGND#9	65.196548
Rf54	VGND#4	VGND#11	2.562737
Rf55	VGND#11	VGND#12	4.412772
Rf56	VGND#12	VGND#10	9.795873
Rf57	VGND#5	VGND#13	25.846697
Rf58	VGND#7	VGND#14	35.885353
Rf59	VGND#10	VGND#11	5.000000
Rf60	VGND#10	VGND#12	7.500000
Rf61	VPWR#1	VPWR#2	115.707314
Rf62	VPWR#2	VPWR#3	36.258038
Rf63	VPWR#3	VPWR#4	44.002426
Rf64	VPWR#4	VPWR#5	236.831207
Rf65	VPWR#5	VPWR#6	87.270805
Rf66	VPWR#6	VPWR#7	192.098267
Rf68	VPWR#2	VPWR#9	67.810089
Rf69	VPWR#4	VPWR#10	19.820507
Rf70	VPWR#5	VPWR#11	31.948624
Rf71	VPWR#7	VPWR#12	35.077789
Rf73	a_75_227##2	a_75_227##7	160.232803
Re1	a_27_373##5	a_27_373##2	21.829418
Re2	a_324_373##6	a_324_373##4	24.299402
Re3	VPWR#3	VPWR	2.687498
Re4	VPWR	VPWR#6	1.343749
Re5	VGND#3	VGND	2.687498
Re6	VGND	VGND#6	1.343749
*
*       CAPACITOR CARDS
*
*
C1	VPWR#3	VPWR#2	6.10262e-17
C2	a_27_373##3	a_75_227##5	1.67843e-18
C3	a_321_77##6	a_1057_74##17	6.13876e-17
C4	VGND#2	a_1057_74##3	2.68718e-20
C5	a_75_227##8	a_75_227#	2.63065e-19
C6	a_386_23##7	B#8	2.77508e-19
C7	a_27_373#	A#1	1.17855e-18
C8	a_27_373##3	VPWR#12	4.64654e-17
C9	VGND#4	C#3	9.43212e-20
C10	a_75_227#	VGND#14	1.67195e-17
C11	a_1024_300##5	a_1057_74##18	1.8183e-18
C12	VGND#13	a_1057_74##17	3.33102e-18
C13	a_386_23##2	B#3	8.09335e-19
C14	VGND#5	B#2	1.37947e-19
C15	a_386_23##2	B#2	1.14825e-17
C16	a_27_373#	a_75_227#	2.88276e-17
C17	a_321_77##2	a_321_77##5	1.63411e-18
C18	a_386_23##7	a_386_23##5	1.24515e-19
C19	VGND#2	a_1057_74##2	5.04805e-20
C20	VGND#13	a_321_77##6	1.01341e-17
C21	B#3	B#1	1.20682e-17
C22	a_324_373##6	VPWR#5	6.26898e-18
C23	B#2	B#1	3.3026e-17
C24	a_321_77##3	a_321_77##2	5.40327e-19
C25	VGND#3	VGND#4	1.74092e-16
C26	a_1057_74##9	a_1057_74#	3.62357e-17
C27	VPWR#1	a_1057_74##8	3.27795e-17
C28	VGND#3	VGND#2	6.73851e-17
C29	C#5	a_1057_74##6	1.23716e-20
C30	a_321_77##2	a_324_373##7	1.29395e-18
C31	VPWR#3	X#2	1.67037e-18
C32	VGND#1	VPWR#1	1.15998e-17
C33	a_1057_74##3	X#6	2.02512e-19
C34	a_1057_74##8	X#6	2.44129e-17
C35	VPWR#3	X#1	9.00115e-19
C36	B#3	a_386_23#	1.3662e-17
C37	VGND#5	a_324_373##6	2.20513e-19
C38	VPWR#3	a_1057_74##16	1.61179e-17
C39	VPWR#1	a_1057_74##10	1.23306e-18
C40	a_321_77#	a_386_23##3	2.67515e-19
C41	VPWR#9	a_1057_74##8	6.79311e-19
C42	a_386_23#	B#2	2.46806e-17
C43	a_1057_74##2	X#6	1.99812e-19
C44	a_1057_74##11	a_1057_74##9	3.81294e-17
C45	VGND#2	VGND#1	1.8703e-18
C46	a_75_227##10	VGND#13	7.13985e-18
C47	a_321_77##2	VPWR#11	5.2234e-17
C48	a_1057_74##10	X#6	2.37392e-17
C49	VGND#3	X#2	2.0449e-18
C50	a_27_373##4	a_386_23##3	1.03391e-21
C51	VPWR#9	a_1057_74##4	1.69104e-18
C52	X#2	a_1057_74##6	9.47804e-18
C53	VPWR#1	a_1057_74##12	2.59902e-19
C54	VGND#3	X#1	1.80519e-18
C55	a_1057_74##10	VPWR#9	2.35209e-17
C56	a_321_77##3	a_386_23##7	5.56039e-18
C57	a_1057_74##6	X#3	7.16499e-21
C58	VGND#3	a_1057_74##16	1.43882e-17
C59	A#5	B#4	1.70428e-18
C60	X#3	a_1057_74##10	1.80807e-18
C61	a_1057_74##13	a_1057_74##11	3.67282e-17
C62	VPWR#9	a_1057_74##3	2.04618e-18
C63	a_321_77##2	a_386_23##6	6.95992e-17
C64	VGND#4	VGND#9	4.30104e-18
C65	VPWR#6	VPWR#5	1.30504e-16
C66	a_1057_74##12	VPWR#9	2.91372e-17
C67	a_27_373##4	a_386_23##4	1.18437e-18
C68	VPWR#6	VPWR#4	2.85226e-17
C69	a_324_373#	a_386_23##9	7.86506e-18
C70	X#3	a_1057_74##12	6.04329e-17
C71	a_386_23##7	a_321_77##2	4.4564e-18
C72	C#3	C#5	6.16171e-19
C73	VPWR#9	a_1057_74##14	6.30817e-19
C74	a_324_373##2	a_386_23##4	4.177e-18
C75	C#5	a_1057_74##13	1.47466e-18
C76	a_1057_74##4	X#3	1.33269e-19
C77	VGND#2	a_1057_74#	3.29689e-18
C78	VGND#4	X#8	3.54056e-18
C79	X#3	a_1057_74##14	5.11054e-17
C80	a_75_227##5	a_386_23##4	3.63329e-19
C81	X#2	a_1057_74##4	2.08374e-17
C82	VPWR#10	a_1057_74##6	2.94895e-20
C83	a_1057_74##14	VPWR#10	2.84804e-17
C84	VGND#4	a_1057_74##9	3.61677e-19
C85	a_324_373##6	a_1024_300##5	1.21931e-18
C86	a_321_77#	a_321_77##2	1.11723e-18
C87	C#4	C#5	3.41237e-18
C88	a_386_23##5	B#3	5.98887e-18
C89	a_321_77##3	a_324_373##6	5.23018e-17
C90	a_1024_300##4	a_1057_74##14	8.63996e-22
C91	VGND#2	X#8	6.77007e-19
C92	a_1057_74##3	X#4	2.75905e-19
C93	VGND#2	a_1057_74##9	3.51399e-18
C94	a_324_373##6	a_321_77##2	1.39031e-16
C95	VGND#4	VGND#10	2.06863e-17
C96	a_324_373#	B#8	2.13395e-17
C97	C#1	VPWR#10	1.36143e-17
C98	a_321_77##5	a_1057_74##14	4.17969e-19
C99	X#2	a_1057_74##3	1.06914e-18
C100	a_1024_300##4	C#1	1.94119e-17
C101	VGND#4	a_1057_74##11	6.74181e-19
C102	a_27_373##6	a_324_373#	3.64984e-17
C103	a_324_373##6	a_386_23##7	1.55735e-17
C104	a_321_77##4	a_75_227##10	6.52228e-17
C105	a_1057_74##2	X#4	5.2171e-19
C106	a_1057_74##16	a_1057_74##6	8.53018e-19
C107	a_321_77##4	B#8	6.11619e-20
C108	VPWR#10	C#6	2.21347e-19
C109	a_1024_300##3	C#4	2.32163e-17
C110	a_324_373##4	a_321_77##3	2.34076e-18
C111	VGND#9	a_1057_74##4	7.58125e-19
C112	a_321_77##5	C#1	3.03811e-18
C113	a_386_23##7	a_321_77#	2.42835e-17
C114	a_1057_74##6	X#8	1.25756e-20
C115	VGND#2	a_1057_74##11	1.0883e-18
C116	a_1024_300##4	C#6	1.28781e-18
C117	a_1057_74##18	C#1	2.55962e-18
C118	a_321_77##4	a_324_373#	4.66202e-17
C119	VGND#5	a_324_373##5	3.87123e-19
C120	a_321_77##5	C#6	6.04749e-17
C121	a_324_373##4	a_386_23##7	7.59033e-18
C122	B#4	B#3	1.12407e-18
C123	VGND#4	a_1057_74##13	6.47712e-18
C124	a_1057_74##7	VPWR#4	1.23717e-19
C125	a_324_373#	B#4	2.13513e-20
C126	X#1	a_1057_74#	8.12095e-19
C127	VGND#9	a_1057_74##3	3.52157e-18
C128	B#7	a_1024_300##3	4.44677e-18
C129	VGND#6	VGND#5	1.051e-16
C130	a_1057_74##18	C#6	3.44113e-17
C131	a_27_373##6	B#4	6.01848e-19
C132	a_1024_300##3	C#3	1.56219e-18
C133	X#1	a_1057_74##3	1.44917e-17
C134	VGND#6	VGND#4	4.79741e-17
C135	a_321_77##4	a_27_373##6	7.25465e-17
C136	VGND#3	VGND#1	5.11891e-17
C137	X#2	a_1057_74##9	2.5467e-19
C138	a_321_77##5	a_1024_300#	2.26406e-17
C139	X#2	VGND#9	1.34581e-17
C140	a_321_77##4	B#4	1.90739e-19
C141	a_386_23##3	a_1024_300##3	1.31665e-19
C142	VPWR#6	a_1024_300##5	3.12695e-18
C143	VGND#5	a_1057_74##17	3.2675e-17
C144	a_1024_300#	a_1057_74##18	3.11945e-17
C145	a_1057_74##4	X#8	5.86022e-19
C146	VPWR#11	C#6	9.52783e-19
C147	VGND#4	C#5	2.62398e-18
C148	X#1	a_1057_74##9	7.06111e-19
C149	a_386_23##3	B#7	4.65393e-18
C150	VGND#10	a_1057_74##6	2.32985e-18
C151	VPWR#4	C#2	1.17198e-19
C152	a_1057_74##16	a_1057_74##4	1.34953e-19
C153	a_324_373##2	a_386_23##7	1.14438e-18
C154	a_321_77##5	B#1	8.77086e-19
C155	a_75_227##8	a_27_373##6	1.69176e-17
C156	a_1024_300#	a_324_373##7	2.42308e-17
C157	VGND#3	X#8	2.58441e-17
C158	a_321_77##2	VPWR#6	2.25288e-17
C159	VGND#9	X#1	1.05459e-17
C160	X#1	a_1057_74##2	1.39409e-17
C161	VGND#4	a_1057_74##7	2.93426e-20
C162	X#2	a_1057_74##11	2.14287e-18
C163	a_1057_74##18	B#1	3.24902e-18
C164	X#2	X#8	3.98814e-18
C165	VGND#5	C#4	1.99854e-18
C166	VPWR#11	a_1024_300#	4.12897e-18
C167	VGND#4	a_1057_74##17	6.87398e-17
C168	VPWR#6	a_386_23##7	1.56037e-18
C169	VGND#3	a_1024_300##7	9.72545e-19
C170	a_1024_300##7	a_1024_300##4	1.27431e-18
C171	VGND#6	a_1057_74##16	2.82944e-18
C172	a_75_227##8	a_321_77##4	9.36868e-17
C173	VGND#5	a_321_77##6	1.84288e-17
C174	a_386_23##3	B#9	4.46921e-17
C175	X#1	a_1057_74##11	2.1849e-19
C176	VPWR#5	a_1024_300##2	5.57092e-20
C177	VGND#4	C#4	3.88252e-18
C178	VPWR#11	B#1	3.67902e-17
C179	a_75_227##4	a_1024_300#	3.63666e-19
C180	a_1057_74##7	X#2	4.93572e-17
C181	a_386_23##4	a_386_23##3	5.03857e-19
C182	VGND#4	C#2	5.61012e-19
C183	X#2	a_1057_74##13	1.53899e-18
C184	a_1057_74##16	a_1057_74##11	1.06055e-19
C185	a_386_23##6	B#1	2.79966e-17
C186	VGND#5	a_1024_300##3	7.44733e-18
C187	VGND#6	a_1024_300##5	1.91995e-18
C188	A#5	a_27_373##5	8.61355e-18
C189	VPWR#11	a_386_23#	5.16932e-19
C190	a_1024_300##7	a_1057_74##6	2.67393e-21
C191	a_1057_74##16	a_1057_74##7	1.46077e-17
C192	a_75_227##4	B#1	3.66066e-18
C193	a_386_23##4	B#9	3.27927e-17
C194	VGND#6	a_321_77##3	3.42398e-17
C195	VGND#4	a_1024_300##3	8.12297e-20
C196	a_1057_74##16	X#8	3.81515e-19
C197	a_321_77#	B#1	1.72288e-19
C198	VGND#14	a_75_227##8	5.49088e-17
C199	VGND#5	a_1024_300##2	2.97713e-20
C200	a_321_77##6	a_324_373##6	4.08843e-17
C201	X#2	C#2	5.67352e-20
C202	a_386_23#	a_75_227##4	2.03778e-17
C203	X#2	C#5	1.57223e-19
C204	a_1057_74##16	a_1057_74##13	2.08756e-18
C205	a_27_373##4	B#1	4.35531e-19
C206	X#2	VPWR#2	2.29082e-19
C207	VGND#6	a_386_23##7	6.92113e-19
C208	a_324_373##6	VGND#13	2.33849e-18
C209	VGND#5	B#7	4.37316e-18
C210	a_321_77#	a_386_23#	5.70829e-17
C211	B#5	a_386_23##4	3.94986e-17
C212	a_1057_74##16	C#2	5.19628e-17
C213	a_324_373##6	a_386_23##9	3.10506e-18
C214	a_27_373#	a_75_227##8	5.87329e-19
C215	a_75_227##4	B#8	1.21352e-18
C216	a_1057_74##16	C#3	2.53779e-20
C217	a_27_373##4	a_386_23#	2.42674e-18
C218	a_1057_74##16	VGND#10	7.57689e-17
C219	B#8	a_321_77#	1.17554e-17
C220	a_321_77##5	C#3	3.96252e-18
C221	a_324_373##2	a_386_23#	8.49687e-19
C222	a_1057_74##16	C#5	2.40915e-17
C223	VPWR#3	VPWR#1	5.49406e-17
C224	a_75_227##4	a_386_23##5	1.9843e-18
C225	a_1024_300##5	C#2	3.09697e-17
C226	X#1	VPWR#2	1.56462e-19
C227	A#1	B#5	3.03411e-17
C228	a_27_373##4	B#8	4.19063e-17
C229	a_27_373#	VGND#14	4.4708e-17
C230	a_1057_74##16	VPWR#4	4.88731e-17
C231	a_75_227##5	a_386_23#	3.33007e-19
C232	a_324_373##4	a_75_227##10	4.59916e-18
C233	a_321_77#	a_386_23##5	1.86761e-18
C234	a_324_373##2	B#8	2.84823e-18
C235	a_1057_74##16	a_1024_300##7	3.35515e-17
C236	a_324_373##4	a_324_373#	1.40294e-17
C237	VPWR#3	a_1057_74##6	2.72638e-20
C238	a_75_227##4	B#4	4.72948e-19
C239	VGND#3	VPWR#1	3.54257e-18
C240	a_27_373##4	a_386_23##5	3.82548e-17
C241	VGND#6	A#5	3.17413e-18
C242	a_75_227##5	B#8	4.98601e-20
C243	VGND#4	VGND#2	2.37409e-18
C244	a_324_373##4	a_27_373##6	4.05423e-18
C245	X#3	VPWR#3	3.97615e-17
C246	a_1057_74##16	C#4	3.6118e-19
C247	a_75_227#	A#1	2.41442e-17
C248	a_321_77#	B#4	1.97857e-19
C249	a_1024_300##5	a_1024_300##2	3.21304e-19
C250	a_324_373##2	a_386_23##5	4.77048e-17
C251	a_324_373##4	a_321_77##4	5.31234e-18
C252	VPWR#3	a_1057_74##4	1.25741e-20
C253	a_321_77##3	a_1024_300##2	6.5038e-19
C254	VGND#3	VPWR#9	2.45874e-18
C255	a_27_373##4	B#4	1.83539e-18
C256	a_324_373##4	a_75_227##8	1.17249e-18
C257	a_75_227##5	a_386_23##5	9.45606e-19
C258	VPWR#3	a_1024_300##4	5.78535e-18
C259	a_1024_300##2	a_321_77##2	1.38013e-18
C260	a_324_373##5	a_1057_74##16	2.38988e-18
C261	a_27_373##6	a_27_373##5	3.53944e-19
C262	a_1057_74##18	C#3	7.65604e-19
C263	B#4	a_324_373##2	2.90051e-17
C264	a_386_23##7	a_1024_300##2	1.2042e-19
C265	a_27_373##5	a_321_77##4	2.23096e-18
C266	a_75_227##5	B#4	4.26491e-17
C267	VPWR#3	a_1057_74##18	1.00921e-17
C268	VGND#6	a_1024_300##7	4.49814e-18
C269	a_27_373##5	a_75_227##8	6.73343e-18
C270	VPWR#6	a_324_373#	1.91916e-18
C271	a_321_77##3	B#6	2.36743e-17
C272	VPWR#12	B#4	2.59598e-19
C273	VGND#6	a_324_373##5	1.25934e-17
C274	a_1024_300##7	C#3	1.31055e-19
C275	a_27_373##5	VGND#14	9.41826e-19
C276	VGND#3	a_1057_74##6	2.15005e-20
C277	VGND#6	a_1057_74##17	4.48453e-17
C278	a_75_227##5	A#3	6.14556e-17
C279	a_1057_74##7	VGND#10	6.20605e-17
C280	VGND#6	a_321_77##6	1.60297e-17
C281	a_324_373##6	a_1024_300##4	3.31215e-18
C282	a_386_23##7	B#6	1.92593e-17
C283	A#3	VPWR#12	2.1761e-17
C284	VGND#3	a_1057_74##4	8.18321e-20
C285	VGND#6	VGND#13	1.99745e-17
C286	a_324_373##6	a_321_77##5	9.90262e-18
C287	a_75_227##5	a_75_227##3	7.16818e-18
C288	a_27_373##3	A#3	5.14849e-19
C289	a_386_23##4	B#3	2.14786e-19
C290	a_321_77##3	a_386_23##2	9.5193e-18
C291	VGND#6	a_386_23##9	5.4792e-18
C292	VGND#3	a_1057_74##3	1.30884e-20
C293	VPWR#12	a_75_227##3	4.67511e-17
C294	VGND#6	a_75_227##10	1.16952e-16
C295	a_321_77##3	C#4	4.22914e-20
C296	VGND#3	a_1057_74##2	1.12751e-20
C297	C#2	VGND#10	3.26476e-18
C298	a_1057_74##10	a_1057_74##8	4.56491e-17
C299	VGND#6	a_324_373#	6.35024e-18
C300	a_75_227##3	a_27_373##3	1.68875e-17
C301	VPWR#9	VPWR#1	1.94092e-18
C302	a_386_23##7	a_386_23##2	1.87404e-19
C303	a_1024_300##7	C#2	1.04436e-17
C304	a_27_373##2	VGND#14	4.08269e-18
C305	a_324_373##6	VPWR#11	3.26066e-18
C306	VGND#6	a_27_373##6	7.92533e-18
C307	a_27_373#	a_27_373##2	4.89093e-18
C308	VGND#6	a_321_77##4	2.0068e-17
C309	a_324_373##6	a_386_23##6	2.73957e-17
C310	a_324_373##5	C#3	2.74951e-17
C311	a_1057_74##17	C#2	4.34479e-19
C312	VGND#6	a_75_227##8	5.13847e-17
C313	a_324_373##6	a_75_227##4	1.03097e-18
C314	a_1057_74##12	a_1057_74##10	4.77682e-17
C315	a_321_77##3	a_1024_300##3	2.08441e-19
C316	a_386_23##9	a_386_23##6	3.21002e-18
C317	a_386_23##3	B#8	2.86988e-19
C318	VPWR#2	VPWR#1	7.0017e-19
C319	a_324_373##6	a_321_77#	1.99121e-18
C320	VGND#6	a_27_373#	1.95995e-17
C321	VPWR#6	a_1024_300##4	6.07945e-18
C322	a_324_373##5	a_1024_300##2	6.54465e-17
C323	a_324_373##5	a_1024_300##5	2.63036e-17
C324	a_1057_74##17	a_1024_300##2	6.14255e-19
C325	a_324_373##4	a_75_227##4	9.70587e-18
C326	VPWR#6	a_321_77##5	1.48541e-17
C327	a_1057_74##14	a_1057_74##12	4.62375e-17
C328	VGND#1	a_1057_74#	2.46087e-17
C329	a_324_373##4	a_321_77#	4.32085e-17
C330	VPWR#6	a_1057_74##18	3.65835e-17
C331	a_321_77##3	B#7	3.89188e-17
C332	a_324_373##4	a_27_373##4	1.7597e-17
C333	a_321_77##3	a_324_373##5	1.84431e-19
C334	VGND#3	a_1057_74#	6.7457e-18
C335	VPWR#2	a_1057_74##8	2.27534e-18
C336	VPWR#6	VPWR#11	1.44545e-17
C337	a_1057_74#	X#4	1.5442e-17
C338	a_324_373##4	a_324_373##2	3.2529e-17
C339	X#3	VPWR#9	8.68577e-17
C340	a_27_373##5	a_321_77#	1.84131e-18
C341	a_1057_74##17	a_1024_300##5	1.48225e-18
C342	VPWR#11	B#3	2.95301e-18
C343	a_1057_74##17	C#3	1.66244e-18
C344	a_386_23##7	a_1024_300##3	2.42104e-20
C345	C#1	a_1057_74##14	2.88431e-18
C346	VGND#3	a_1057_74##9	6.60561e-18
C347	VPWR#6	a_386_23##6	2.75675e-18
C348	a_324_373##4	a_75_227##5	1.07162e-18
C349	A#5	A#2	9.93461e-18
C350	VGND#1	a_1057_74##9	1.23945e-18
C351	a_27_373##5	a_27_373##4	9.15512e-18
C352	a_321_77##2	VPWR#5	1.19643e-17
C353	B#4	a_386_23##4	3.79625e-18
C354	a_324_373##6	B#2	8.62881e-19
C355	B#6	VGND#13	8.7345e-19
C356	VPWR#4	VPWR#9	2.25526e-18
C357	a_75_227##4	VPWR#6	1.48914e-16
C358	VGND#2	X#2	1.6413e-19
C359	VGND#3	a_1057_74##11	1.01896e-17
C360	VGND#9	a_1057_74#	1.22514e-18
C361	B#6	a_386_23##9	1.4617e-17
C362	a_27_373##5	a_324_373##2	6.53129e-17
C363	a_321_77##3	a_386_23##3	6.68529e-19
C364	a_321_77#	VPWR#6	1.07333e-17
C365	VPWR#4	a_1057_74##10	3.44312e-19
C366	a_324_373#	a_75_227##4	7.71928e-19
C367	VPWR#11	B#2	1.34473e-18
C368	VGND#3	a_1057_74##13	1.28335e-17
C369	a_1057_74##7	VPWR#10	6.98058e-17
C370	a_27_373##5	a_75_227##5	1.23033e-16
C371	a_1057_74##9	X#4	1.4935e-17
C372	a_1024_300##5	C#3	1.67491e-17
C373	VPWR#6	a_27_373##4	1.10423e-17
C374	C#6	C#1	4.78973e-18
C375	VPWR#2	a_1057_74##10	5.16429e-18
C376	a_386_23##7	B#7	2.55019e-18
C377	a_75_227##2	A#5	2.69384e-17
C378	VPWR#6	a_324_373##2	3.34719e-18
C379	VGND#1	a_1057_74##11	2.98582e-19
C380	a_1057_74##9	VGND#9	1.76594e-17
C381	a_75_227##5	VPWR#6	5.0564e-17
C382	VPWR#10	X#3	7.89549e-17
C383	a_324_373#	a_321_77#	5.05698e-18
C384	a_386_23##2	a_75_227##10	2.25539e-18
C385	VGND#2	X#1	3.2453e-19
C386	VPWR#4	X#3	1.30755e-17
C387	VGND#4	a_1057_74##16	3.1045e-17
C388	a_321_77##3	B#9	2.69972e-19
C389	C#2	a_1024_300##4	5.74354e-18
C390	a_1024_300#	C#6	1.9929e-17
C391	a_324_373#	a_386_23##2	3.06849e-17
C392	VPWR#4	a_1057_74##12	1.11562e-18
C393	VPWR#6	a_27_373##3	1.55623e-17
C394	VGND#6	a_321_77#	2.84141e-18
C395	X#8	a_1057_74##9	1.33051e-18
C396	a_27_373##2	a_75_227##5	4.8672e-17
C397	a_321_77##4	a_386_23##2	4.48037e-18
C398	a_324_373##6	a_1024_300##3	4.40169e-18
C399	a_386_23##7	a_386_23##3	1.11091e-18
C400	a_1057_74##18	C#2	8.13876e-19
C401	a_27_373##2	VPWR#12	1.066e-17
C402	a_324_373#	a_27_373##4	4.17295e-18
C403	VPWR#2	a_1057_74##12	4.41775e-18
C404	a_1057_74##11	VGND#9	2.17838e-17
C405	VGND#6	a_324_373##2	2.92181e-18
C406	a_324_373##6	B#7	2.53838e-19
C407	C	a_1057_74##6	1.43596e-19
C408	B#1	a_1024_300#	5.29655e-18
C409	a_27_373##2	a_27_373##3	4.90243e-18
C410	a_386_23##6	B#2	1.76894e-17
C411	a_1024_300##2	a_321_77##5	1.36037e-17
C412	a_27_373##6	A#2	7.40468e-19
C413	a_321_77##6	a_321_77##2	3.72219e-19
C414	C	C#3	4.50241e-21
C415	VPWR#4	VPWR#10	3.43974e-18
C416	X#8	a_1057_74##11	4.15245e-17
C417	a_27_373##6	a_27_373##4	3.77966e-19
C418	a_321_77##3	VGND#13	4.47243e-17
C419	VPWR#4	a_1057_74##14	9.73196e-18
C420	a_75_227##8	A#2	4.09508e-18
C421	a_386_23##7	B#9	1.6699e-19
C422	VGND#9	a_1057_74##13	1.46226e-18
C423	VPWR#5	C#3	4.81421e-20
C424	VPWR#2	a_1057_74##14	5.104e-19
C425	a_75_227##2	a_27_373##6	1.46405e-18
C426	a_27_373##6	a_324_373##2	4.08982e-17
C427	X#8	a_1057_74##13	3.82855e-17
C428	VPWR#3	a_1057_74##8	4.13808e-18
C429	a_75_227##4	B#3	4.50181e-17
C430	B#8	a_386_23#	3.04724e-17
C431	a_321_77##3	a_386_23##9	6.4708e-17
C432	a_75_227##2	VGND#14	4.00319e-17
C433	VPWR#3	a_1057_74##10	4.13753e-18
C434	a_27_373#	a_75_227##2	4.09472e-17
C435	a_321_77##5	a_1024_300##4	5.17905e-17
C436	VPWR#4	C#1	5.63193e-19
C437	a_1057_74##13	VGND#10	1.71849e-17
C438	a_321_77##4	a_324_373##2	1.30195e-18
C439	VPWR#3	a_1057_74##12	3.80582e-18
C440	a_75_227##4	B#2	4.94278e-18
C441	a_27_373##5	B#5	6.05309e-19
C442	VGND#6	C#4	2.50478e-18
C443	a_321_77##5	VPWR#5	1.67594e-18
C444	X#8	C#5	3.51259e-19
C445	VPWR#3	a_1057_74##14	6.13746e-18
C446	VPWR#5	B#3	1.18089e-18
C447	a_386_23##5	B#8	5.04317e-17
C448	VGND#6	a_1024_300##3	2.022e-18
C449	a_321_77##3	B#2	1.0162e-17
C450	B	B#2	1.21918e-17
C451	VPWR#2	a_1057_74##3	2.017e-20
C452	a_1024_300##7	a_1057_74##13	7.03597e-20
C453	a_75_227##4	a_386_23##2	1.20228e-19
C454	a_1024_300##4	a_1057_74##18	2.4556e-17
C455	VPWR#3	C#1	1.10283e-20
C456	VGND#6	B#7	8.37549e-18
C457	a_321_77##3	a_75_227##10	4.11315e-17
C458	B#4	B#8	1.51336e-18
C459	VPWR#5	C#6	3.08992e-18
C460	a_386_23##2	a_321_77#	2.28499e-17
C461	C#5	VGND#10	9.42825e-18
C462	VGND#6	a_386_23##3	2.29535e-17
C463	VPWR#4	C#3	8.11291e-20
C464	B#4	a_386_23##5	1.82076e-17
C465	a_324_373##5	a_1057_74##13	1.87606e-19
C466	a_324_373##2	a_386_23##2	2.96577e-20
C467	VPWR#4	C#6	1.77192e-19
C468	VGND#13	B#2	8.93689e-19
C469	a_321_77##5	a_1057_74##18	7.97829e-17
C470	a_321_77#	B#3	3.41876e-18
C471	VPWR#6	B#3	4.12312e-17
C472	VGND#6	a_386_23##4	1.61191e-17
C473	a_75_227##8	a_75_227##5	2.93008e-18
C474	a_1024_300##7	C#5	2.09745e-17
C475	a_1057_74##18	VPWR#5	4.74577e-17
C476	a_324_373##6	C#1	6.56929e-20
C477	X#2	a_1057_74##10	9.75232e-19
C478	VPWR#5	B#2	7.81799e-20
C479	X#2	X#1	2.79134e-18
C480	VGND#6	B#5	4.04426e-18
C481	a_1057_74##17	a_1057_74##13	4.68378e-19
C482	VPWR#2	a_1057_74##2	1.9901e-20
C483	a_321_77##3	a_324_373#	4.87008e-20
C484	a_324_373##6	C#6	4.73789e-18
C485	A#3	B#4	3.23916e-17
C486	VGND#10	C#4	4.39707e-19
C487	VGND#6	A#1	3.29338e-18
C488	a_324_373##5	C#5	2.25533e-18
C489	a_321_77#	B#2	1.20658e-17
C490	A#2	a_75_227##5	3.33856e-18
C491	VGND#5	a_321_77##3	7.17801e-18
C492	VPWR#5	a_1024_300#	6.36872e-18
C493	a_324_373##6	a_1024_300#	1.79682e-17
C494	VGND#6	a_75_227#	8.99403e-18
C495	X	a_1057_74##4	9.22099e-19
C496	a_1057_74##18	VPWR#4	6.58166e-17
C497	X	a_1057_74##3	4.92822e-18
C498	X	a_1057_74##2	5.16858e-18
C499	B#7	a_1024_300##2	5.22292e-19
C500	VGND#9	VGND#1	3.04187e-18
C501	a_1024_300##7	C#4	4.21356e-19
C502	a_324_373##6	B#1	4.40699e-18
C503	a_321_77##2	B#2	1.68953e-17
C504	a_75_227##3	A#3	3.34623e-17
C505	a_1057_74##4	a_1057_74##10	2.52655e-19
C506	a_75_227##2	a_75_227##5	3.08302e-18
C507	X#2	a_1057_74##12	4.28474e-18
C508	a_1057_74##16	X#2	1.75337e-18
C509	a_75_227##2	VPWR#12	4.61931e-19
C510	a_324_373##5	C#4	3.41566e-17
C511	a_324_373##4	a_386_23#	9.77035e-19
C512	a_386_23##9	B#2	5.15095e-18
C513	VPWR#6	a_1024_300#	8.18056e-18
C514	a_27_373##4	B#3	2.42753e-18
C515	a_324_373##4	B#8	1.64511e-18
C516	VPWR#5	B#1	3.61711e-18
C517	a_386_23##2	B#7	2.42653e-19
C518	a_27_373##5	a_386_23#	1.5634e-19
C519	a_1057_74##17	C#4	5.59716e-17
C520	VPWR#11	a_1057_74##18	8.79601e-18
C521	a_324_373##4	a_386_23##5	1.31372e-18
C522	a_27_373##5	B#8	2.68527e-19
C523	B#9	a_386_23##2	8.28195e-18
C524	a_324_373##5	a_1024_300##3	5.78901e-18
C525	VPWR#6	a_386_23#	1.07628e-18
C526	X#2	a_1057_74##14	4.14895e-18
C527	a_27_373##4	B#2	1.12969e-18
C528	a_27_373##5	a_386_23##5	4.50297e-18
C529	a_1057_74##6	a_1057_74##4	1.63767e-18
C530	a_321_77##6	C#4	1.3203e-18
C531	a_27_373##5	B#4	3.59159e-17
C532	a_324_373#	a_386_23##7	1.78408e-18
C533	a_1057_74##17	a_1024_300##3	1.7347e-17
C534	a_27_373##5	A#3	1.54757e-18
C535	VGND#13	C#4	5.35009e-19
C536	VPWR#6	B#4	7.8198e-19
C537	A#2	B#5	1.3899e-17
C538	C#6	C#2	9.092e-20
C539	a_1057_74##16	a_1057_74##14	2.38579e-18
C540	a_324_373##5	B#7	3.48182e-20
C541	a_27_373##5	a_75_227##3	2.39681e-19
C542	A#5	B#5	1.6988e-18
C543	VPWR#6	A#3	2.64525e-18
C544	a_321_77##6	a_1024_300##3	5.56625e-17
C545	X#2	C#1	2.03731e-19
C546	X#2	VPWR#9	2.34281e-17
C547	a_1024_300##2	C#6	6.06193e-18
C548	X#8	VGND#9	5.87934e-17
C549	C	a_1057_74##16	2.37716e-17
C550	a_75_227##2	B#5	1.14753e-19
C551	VPWR#6	a_75_227##3	2.38039e-18
C552	a_27_373##2	A#3	2.28005e-19
C553	a_1057_74##17	B#7	3.98837e-19
C554	a_386_23##7	B#3	6.52849e-19
C555	a_324_373##2	B#3	2.87102e-19
C556	a_75_227##2	A#1	6.66025e-18
C557	a_1024_300##5	C	2.23802e-17
C558	VGND#13	a_1024_300##3	2.70477e-18
C559	a_27_373##2	a_75_227##3	1.05114e-17
C560	a_75_227##2	a_75_227#	4.36447e-18
C561	B#1	a_1024_300##2	1.9044e-18
C562	VGND#6	B#2	1.24762e-19
C563	a_321_77##6	B#7	2.54588e-18
C564	X#1	VPWR#9	5.90872e-18
C565	a_1057_74##16	C#1	1.96737e-17
C566	a_1057_74##7	a_1057_74##6	1.69096e-17
C567	a_324_373##2	B#2	5.58492e-20
C568	a_386_23##9	a_1024_300##3	3.84365e-19
C569	a_27_373##5	a_324_373##4	2.76885e-17
C570	X#2	X#3	4.82874e-20
C571	a_324_373##6	VPWR#6	4.4826e-17
C572	a_324_373#	B#3	1.54579e-19
C573	a_75_227##4	VPWR#11	9.8383e-18
C574	a_386_23##7	B#2	2.38423e-17
C575	B#7	VGND#13	1.4265e-17
C576	a_1024_300##5	a_1057_74##14	7.61969e-20
C577	a_324_373##4	VPWR#6	3.87879e-17
C578	a_75_227##10	a_1024_300##3	2.89008e-19
C579	B	a_321_77##3	1.32383e-17
C580	X	VPWR#2	1.61864e-17
C581	a_1057_74##7	VPWR#3	4.98677e-18
C582	B	a_321_77##2	1.25805e-17
C583	a_321_77##6	a_386_23##3	4.73698e-19
C584	B#8	a_386_23##2	2.0899e-17
C585	a_27_373##5	VPWR#6	2.60544e-17
C586	VGND#6	a_324_373##6	3.96041e-18
C587	a_386_23##7	B	2.1361e-17
C588	VGND#3	a_1057_74##7	6.77161e-18
C589	a_386_23##9	B#7	3.80466e-17
C590	VGND#10	X#8	5.60498e-17
C591	a_1057_74##16	C#6	1.81945e-18
C592	VGND#2	X	1.21847e-17
C593	VGND#3	C#2	3.61268e-18
C594	VGND#13	a_386_23##3	1.73373e-18
C595	a_75_227##5	B#3	4.29796e-18
C596	X#2	X	5.36826e-18
C597	a_27_373##2	VPWR#6	2.25595e-17
C598	VPWR#10	X#2	9.36418e-18
C599	a_75_227##10	B#7	3.5081e-18
C600	A#2	B#4	2.1857e-17
C601	a_1024_300##5	C#1	1.85386e-18
C602	a_324_373##6	a_1024_300##2	7.18631e-17
C603	C#1	a_1057_74##6	1.88401e-20
C604	a_386_23##9	a_386_23##3	3.77104e-18
C605	VGND#6	a_27_373##2	1.17886e-18
C606	a_75_227##2	B#4	3.58167e-19
C607	a_75_227##3	A#2	4.50296e-18
C608	C#2	a_1057_74##6	3.76802e-19
C609	a_324_373#	B#7	1.71899e-18
C610	a_75_227##2	A#3	1.78739e-18
C611	a_1057_74##16	a_1024_300#	1.01095e-19
C612	a_75_227##2	a_75_227##3	3.61846e-18
C613	a_27_373##6	B#3	1.32471e-19
C614	C	a_1024_300##4	1.65914e-17
C615	a_75_227##10	a_386_23##3	3.75973e-17
C616	VPWR#6	a_1024_300##2	4.32568e-18
C617	a_321_77#	a_75_227##4	5.88496e-17
C618	X	VGND#1	6.60067e-17
C619	A	a_75_227##5	3.59216e-17
C620	C	a_1057_74##18	6.12336e-19
C621	a_324_373##4	a_386_23##2	1.13999e-17
C622	VGND#9	X	6.49549e-17
C623	a_27_373##6	B#7	3.77927e-19
C624	VGND#6	C#2	5.93878e-19
C625	a_1024_300##5	C#6	8.64838e-19
C626	C#2	a_1057_74##7	3.60047e-17
C627	VGND#6	a_1024_300##2	3.52153e-18
C628	a_324_373#	a_386_23##3	2.20086e-17
C629	a_1057_74##16	VPWR#10	1.00234e-16
C630	VPWR#6	a_386_23##2	1.12485e-18
C631	a_27_373##5	A#2	1.77244e-18
C632	VGND#6	B#6	3.49414e-18
C633	C#3	C#2	2.33535e-18
C634	a_27_373##4	a_75_227##4	4.5259e-17
C635	a_75_227##10	B#9	7.13166e-18
C636	a_75_227##2	a_27_373##5	2.09016e-18
C637	VGND#6	a_386_23##2	4.37162e-18
C638	a_27_373##6	a_386_23##3	7.79291e-19
C639	B	a_386_23##6	2.65628e-17
C640	VPWR#6	a_75_227##2	6.76431e-19
C641	X	VPWR#1	1.05099e-16
C642	a_321_77##2	C#6	5.03693e-19
C643	X	X#6	7.26185e-19
C644	a_1024_300##5	a_1057_74##16	2.29688e-18
C645	VPWR#9	X	8.58838e-17
C646	a_27_373##2	a_75_227##2	5.46715e-17
C647	a_324_373#	B#9	2.72248e-17
C648	a_27_373##4	a_321_77#	2.75237e-17
C649	VGND#6	a_75_227##2	5.7811e-18
C650	a_321_77##4	a_386_23##3	2.76382e-17
C651	a_1057_74##16	a_1024_300##4	4.59719e-17
C652	a_75_227##10	a_386_23##4	2.39254e-18
C653	a_1057_74##4	a_1057_74##3	1.28068e-18
C654	B#6	a_386_23##2	2.51479e-19
C655	a_1057_74##6	VNB	2.18809e-17
C656	a_1057_74##4	VNB	2.1454e-17
C657	a_1057_74##3	VNB	2.67149e-17
C658	B#9	a_27_373##6	1.72344e-17
C659	a_1057_74##2	VNB	3.42622e-17
C660	C#3	VNB	4.94754e-17
C661	B#3	VNB	1.52067e-16
C662	B#2	VNB	9.4366e-17
C663	a_324_373##2	a_321_77#	5.99029e-18
C664	a_75_227##8	a_386_23##3	3.96812e-19
C665	a_324_373#	a_386_23##4	2.25737e-18
C666	X	a_1057_74#	2.27923e-17
C667	a_321_77##2	a_1024_300#	2.24947e-17
C668	X	a_1057_74##9	2.17955e-17
C669	X	a_1057_74##11	1.52561e-18
C670	a_324_373##5	a_1024_300##7	2.62656e-17
C671	a_1057_74##17	VGND#10	3.3227e-18
C672	a_321_77##4	B#9	2.00015e-17
C673	C	C#1	5.33474e-18
C674	a_75_227##2	A#2	3.08401e-17
C675	a_1024_300##5	B#1	4.98421e-21
C676	C	C#6	2.13865e-20
C677	A	B#4	2.54973e-18
C678	a_1024_300##2	C#3	2.66452e-17
C679	a_27_373##4	a_324_373##2	1.83138e-17
C680	a_27_373##6	a_386_23##4	4.05041e-17
C681	a_321_77##5	a_1057_74##16	7.12956e-18
C682	A	a_75_227##3	1.51249e-18
C683	a_75_227##8	B#9	1.00687e-18
C684	a_324_373#	B#5	1.29964e-19
C685	X	a_1057_74##8	3.44044e-17
C686	B	B#1	3.14871e-18
C687	B#2	a_1024_300##2	5.18587e-18
C688	X	a_1057_74##10	3.18874e-17
C689	X	a_1057_74##12	2.18967e-18
C690	a_321_77##4	a_386_23##4	3.83073e-17
C691	a_1057_74##17	a_1024_300##7	1.51431e-17
C692	a_321_77##2	B#1	3.20431e-17
C693	VPWR#5	VNB	7.16663e-17
C694	VPWR#4	VNB	7.15637e-17
C695	VPWR#2	VNB	2.54082e-17
C696	VPWR#3	C	4.98312e-18
C697	a_27_373##4	a_75_227##5	2.81914e-17
C698	A	a_27_373##5	2.00778e-17
C699	VGND#5	VNB	5.86663e-17
C700	VGND#4	VNB	8.33308e-17
C701	VGND#2	VNB	3.12479e-17
C702	a_27_373##6	B#5	9.31485e-18
C703	X#2	VNB	1.11761e-18
C704	a_27_373##2	A	2.32084e-18
C705	X#1	VNB	1.08973e-17
C706	a_1057_74##16	VNB	2.12424e-17
C707	a_1024_300##5	VNB	6.58014e-18
C708	a_321_77##3	VNB	1.39006e-17
C709	a_321_77##2	VNB	3.31837e-18
C710	A#5	a_27_373##6	4.87503e-18
C711	a_75_227##8	a_386_23##4	2.37256e-17
C712	a_386_23##7	VNB	3.52388e-18
C713	a_324_373##6	B	9.55764e-18
C714	A#5	VNB	3.6478e-19
C715	a_1057_74##18	a_1057_74##16	1.3787e-18
C716	VGND#1	VNB	7.35773e-17
C717	VGND#9	VNB	7.06031e-18
C718	VPWR#3	X	2.15077e-17
C719	C	a_1057_74##7	3.58974e-18
C720	X#8	VNB	2.4741e-18
C721	a_1024_300##7	VNB	2.63301e-18
C722	VGND#3	X	1.94472e-17
C723	B#5	a_321_77##4	1.32974e-17
C724	a_324_373##5	VNB	8.9614e-18
C725	C	C#2	7.2076e-18
C726	a_1057_74##17	VNB	1.97113e-17
C727	a_386_23##7	B#1	5.79758e-19
C728	a_321_77##6	VNB	8.8806e-18
C729	VGND#13	VNB	6.38855e-18
C730	a_386_23##9	VNB	2.98226e-18
C731	a_75_227##10	VNB	9.58609e-18
C732	a_1057_74##17	a_324_373##5	1.26099e-16
C733	a_324_373#	VNB	1.27627e-18
C734	A	A#2	8.71116e-18
C735	a_27_373##6	VNB	2.79027e-18
C736	a_75_227##8	VNB	9.74165e-18
C737	VGND#14	VNB	1.5441e-18
C738	a_27_373#	VNB	4.74756e-17
C739	a_75_227##2	A	1.42095e-17
C740	VPWR#1	VNB	8.03383e-17
C741	VPWR#9	VNB	5.51656e-18
C742	X#3	VNB	2.37377e-18
C743	a_321_77##2	a_386_23#	5.4355e-19
C744	a_27_373##6	A#1	3.95031e-19
C745	a_1024_300##4	VNB	8.73679e-18
C746	a_321_77##5	VNB	1.34291e-18
C747	a_1057_74##18	VNB	2.5207e-17
C748	VPWR#11	VNB	3.53711e-18
C749	a_75_227##4	VNB	1.78063e-17
C750	a_27_373##4	VNB	5.09213e-18
C751	a_75_227##8	B#5	4.64398e-17
C752	a_324_373##2	VNB	4.37351e-18
C753	a_75_227##5	VNB	1.19622e-17
C754	VPWR#12	VNB	5.31428e-18
C755	a_27_373##3	VNB	3.26405e-17
C756	a_1057_74#	VNB	3.07459e-17
C757	a_1057_74##9	VNB	2.84771e-17
C758	a_1057_74##11	VNB	3.11936e-17
C759	a_1057_74##13	VNB	3.13806e-17
C760	C#5	VNB	3.21401e-17
C761	VPWR#4	VPWR#2	7.64123e-19
C762	C#4	VNB	3.59431e-17
C763	a_1024_300##3	VNB	4.15245e-17
C764	B#7	VNB	5.02959e-17
C765	a_386_23##3	VNB	6.93863e-17
C766	B#9	VNB	2.76918e-17
C767	a_386_23##4	VNB	1.03906e-16
C768	B#5	VNB	3.64853e-17
C769	a_321_77##4	A#1	7.94712e-19
C770	A#1	VNB	2.67866e-17
C771	a_75_227#	VNB	3.64434e-17
C772	a_1057_74##8	VNB	4.0391e-17
C773	a_1057_74##10	VNB	3.29047e-17
C774	a_1057_74##12	VNB	3.44408e-17
C775	a_1057_74##14	VNB	3.3613e-17
C776	C#1	VNB	3.34604e-17
C777	C#6	VNB	3.62069e-17
C778	VGND#14	B#5	9.70149e-19
C779	a_1024_300#	VNB	3.65536e-17
C780	a_321_77##6	a_324_373##5	1.16352e-18
C781	B#1	VNB	3.77917e-17
C782	B#6	B#2	1.19846e-17
C783	a_386_23#	VNB	2.94443e-17
C784	B#8	VNB	3.79086e-17
C785	a_386_23##5	VNB	3.64631e-17
C786	a_386_23##7	a_386_23#	6.03413e-18
C787	B#4	VNB	8.76932e-17
C788	A#3	VNB	3.16912e-17
C789	a_75_227##3	VNB	4.31675e-17
C790	VPWR#3	VNB	1.86643e-16
C791	VGND#3	VNB	1.81946e-16
C792	a_75_227##5	VPWR#12	9.90902e-17
C793	a_324_373##6	VNB	1.91524e-17
C794	a_324_373##4	VNB	6.22262e-19
C795	a_27_373##5	VNB	2.68408e-18
C796	VPWR#6	VNB	3.26861e-16
C797	a_27_373##2	VNB	5.08467e-17
C798	a_75_227##8	A#1	1.82866e-17
C799	VGND#6	VNB	3.54702e-16
C800	a_1057_74##7	VNB	3.02454e-17
C801	C#2	VNB	3.71263e-17
C802	a_1024_300##2	VNB	4.98213e-17
C803	B#6	VNB	6.59238e-20
C804	a_386_23##2	VNB	2.94206e-17
C805	A#2	VNB	3.04476e-17
C806	a_75_227##2	VNB	5.0622e-17
C807	a_27_373#	B#5	4.72152e-20
C808	VPWR#3	VPWR#4	1.25632e-16
C809	a_75_227##8	A#5	3.72483e-17
C810	A	VNB	5.80538e-19
C811	C	VNB	2.28592e-18
C812	a_1024_300##5	a_321_77##5	1.76865e-17
C813	a_1057_74##3	a_1057_74##2	3.77847e-18
C814	B	VNB	1.84423e-18
C815	X	VNB	1.02152e-17
C816	VGND#14	A#1	3.4495e-17
C817	a_324_373##4	VPWR#7	5.19186e-19
C818	VPWR#7	VNB	7.15876e-17
C819	VGND#7	B#5	4.38346e-18
C820	VPWR#7	A#3	1.84581e-18
C821	VGND#7	A#2	2.66614e-20
C822	VGND#7	a_27_373#	2.33464e-17
C823	VGND#7	a_386_23##4	7.16994e-18
C824	VPWR#7	B#3	3.21076e-18
C825	a_27_373##2	VPWR#7	3.14091e-18
C826	a_27_373##5	VPWR#7	2.14283e-18
C827	VGND#7	a_75_227#	6.98067e-18
C828	VGND#7	VNB	7.63744e-17
C829	VPWR#7	a_75_227##3	3.12393e-18
C830	a_27_373##3	VPWR#7	1.39992e-17
C831	a_75_227##5	VPWR#7	7.63097e-17
C832	VPWR#7	B#4	1.49289e-17
C833	VGND#7	A#1	4.60815e-18
C834	VPWR#7	A#2	2.55682e-20
C835	VGND#7	a_75_227##8	7.22361e-17
C836	VPWR#7	a_386_23##4	4.19079e-19
C837	VGND#6	VGND#7	1.5224e-16
C838	VGND#7	a_75_227##2	7.80283e-19
C839	VPWR#6	VPWR#7	1.36683e-16
*
*
.ENDS sky130_fd_sc_hs__xnor3_4
*
