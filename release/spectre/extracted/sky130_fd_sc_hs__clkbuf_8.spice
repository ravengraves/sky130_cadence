* Extracted by Quantus, converted by sky130cad/quantus.py
*
*
*
*                       LINUX           Wed Nov 18 08:22:37 2026
*
*
*
*  PROGRAM  advgen
*
*  Name           : advgen - Quantus - (64-bit)
*  Version        : 25.1.0-p047
*  Build Date     : Thu Dec 11 23:20:30 PST 2025
*
*  HSPICE LIBRARY
*
*  OPERATING_TEMPERATURE 150
*  QRC_TECH_DIR <path>/tech
*
*
*

*
.SUBCKT sky130_fd_sc_hs__clkbuf_8 VPB VNB VGND VPWR X A
*
*
*  caps2d version: 10
*
*
*       TRANSISTOR CARDS
*
*
XM10 VGND#7 A#7 a_125_368##28 VNB sky130_fd_pr__nfet_01v8_lvt l=0.15 w=0.42 ad=0.1491 as=0.1176 pd=1.55 ps=1.4
XM14 a_125_368##28 A#6 VGND#11 VNB sky130_fd_pr__nfet_01v8_lvt l=0.15 w=0.42 ad=0.1176 as=0.1659 pd=1.4 ps=1.63
XM11 VGND#11 a_125_368##11 X#5 VNB sky130_fd_pr__nfet_01v8_lvt l=0.15 w=0.42 ad=0.1659 as=0.1281 pd=1.63 ps=1.45
XM17 X#5 a_125_368##23 VGND#10 VNB sky130_fd_pr__nfet_01v8_lvt l=0.15 w=0.42 ad=0.1281 as=0.1764 pd=1.45 ps=1.68
XM15 VGND#10 a_125_368##21 X#12 VNB sky130_fd_pr__nfet_01v8_lvt l=0.15 w=0.42 ad=0.1764 as=0.1176 pd=1.68 ps=1.4
XM0 X#12 a_125_368##19 VGND#9 VNB sky130_fd_pr__nfet_01v8_lvt l=0.15 w=0.42 ad=0.1176 as=0.1176 pd=1.4 ps=1.4
XM13 VGND#9 a_125_368##17 X#11 VNB sky130_fd_pr__nfet_01v8_lvt l=0.15 w=0.42 ad=0.1176 as=0.1176 pd=1.4 ps=1.4
XM4 VGND#8 a_125_368##15 X#11 VNB sky130_fd_pr__nfet_01v8_lvt l=0.15 w=0.42 ad=0.147 as=0.1176 pd=1.54 ps=1.4
XM8 X#1 a_125_368##13 VGND#8 VNB sky130_fd_pr__nfet_01v8_lvt l=0.15 w=0.42 ad=0.1176 as=0.147 pd=1.4 ps=1.54
XM1 X#1 a_125_368# VGND#1 VNB sky130_fd_pr__nfet_01v8_lvt l=0.15 w=0.42 ad=0.1176 as=0.1197 pd=1.4 ps=1.41
XM7 a_125_368##29 A#5 VPWR#7 VPB sky130_fd_pr__pfet_01v8 l=0.15 w=1.12 ad=0.3416 as=0.3808 pd=2.85 ps=2.92
XM18 VPWR#12 A#1 a_125_368##29 VPB sky130_fd_pr__pfet_01v8 l=0.15 w=1.12 ad=0.448 as=0.3416 pd=3.04 ps=2.85
XM16 X#10 a_125_368##25 VPWR#12 VPB sky130_fd_pr__pfet_01v8 l=0.15 w=1.12 ad=0.336 as=0.448 pd=2.84 ps=3.04
XM2 X#10 a_125_368##24 VPWR#11 VPB sky130_fd_pr__pfet_01v8 l=0.15 w=1.12 ad=0.336 as=0.336 pd=2.84 ps=2.84
XM12 X#15 a_125_368##22 VPWR#11 VPB sky130_fd_pr__pfet_01v8 l=0.15 w=1.12 ad=0.336 as=0.336 pd=2.84 ps=2.84
XM9 VPWR#9 a_125_368##20 X#15 VPB sky130_fd_pr__pfet_01v8 l=0.15 w=1.12 ad=0.336 as=0.336 pd=2.84 ps=2.84
XM19 X#14 a_125_368##18 VPWR#9 VPB sky130_fd_pr__pfet_01v8 l=0.15 w=1.12 ad=0.336 as=0.336 pd=2.84 ps=2.84
XM5 VPWR#8 a_125_368##16 X#14 VPB sky130_fd_pr__pfet_01v8 l=0.15 w=1.12 ad=0.392 as=0.336 pd=2.94 ps=2.84
XM3 VPWR#8 a_125_368##14 X#13 VPB sky130_fd_pr__pfet_01v8 l=0.15 w=1.12 ad=0.392 as=0.3528 pd=2.94 ps=2.87
XM6 VPWR#1 a_125_368##12 X#13 VPB sky130_fd_pr__pfet_01v8 l=0.15 w=1.12 ad=0.3304 as=0.3528 pd=2.83 ps=2.87
*
*
*       RESISTOR AND CAP/DIODE CARDS
*
Rg1	A#1	A#2	449.655212
Rg2	A#2	A#3	30.596949
Rg3	A#3	A#4	23.723120
Rg4	A#4	A#5	449.450317
Rg5	A#2	A#6	489.373627
Rg6	A#4	A#7	486.409576
Rg7	a_125_368#	a_125_368##2	397.555725
Rg8	a_125_368##2	a_125_368##3	69.322823
Rg9	a_125_368##3	a_125_368##4	82.473221
Rg10	a_125_368##4	a_125_368##5	71.211914
Rg11	a_125_368##5	a_125_368##6	62.836910
Rg12	a_125_368##6	a_125_368##7	70.548058
Rg13	a_125_368##7	a_125_368##8	30.191841
Rg14	a_125_368##8	a_125_368##9	69.334579
Rg15	a_125_368##9	a_125_368##10	61.286598
Rg16	a_125_368##10	a_125_368##11	397.555725
Rg17	a_125_368##2	a_125_368##12	520.126282
Rg18	a_125_368##3	a_125_368##13	399.152283
Rg19	a_125_368##3	a_125_368##14	520.573303
Rg20	a_125_368##4	a_125_368##15	468.102905
Rg21	a_125_368##4	a_125_368##16	482.449432
Rg22	a_125_368##5	a_125_368##17	492.724396
Rg23	a_125_368##5	a_125_368##18	507.070892
Rg24	a_125_368##6	a_125_368##19	376.234039
Rg25	a_125_368##6	a_125_368##20	498.804565
Rg26	a_125_368##7	a_125_368##21	391.786499
Rg27	a_125_368##8	a_125_368##22	404.636658
Rg28	a_125_368##9	a_125_368##23	443.447113
Rg29	a_125_368##9	a_125_368##24	457.793640
Rg30	a_125_368##10	a_125_368##25	520.126282
Rf1	A#8	A	1.038028
Rf2	A#9	A	1.038028
Rf3	A#8	A#9	14.668931
Rf4	A#3	A#11	81.154427
Rf5	A#9	A#11	1.222411
Rf6	a_125_368##6	a_125_368##27	78.645760
Rf7	a_125_368##27	a_125_368##28	86.317505
Rf8	a_125_368##27	a_125_368##29	102.642006
Rf9	X#1	X#2	35.806046
Rf10	X#2	X#3	68.133049
Rf11	X#3	X#4	65.876305
Rf12	X#4	X#5	92.595230
Rf13	X#2	X#6	35.673496
Rf14	X#6	X#7	24.748734
Rf15	X#7	X#8	70.721870
Rf16	X#8	X#9	60.860058
Rf17	X#9	X#10	100.438530
Rf18	X#3	X#11	35.806046
Rf19	X#4	X#12	28.841251
Rf20	X#6	X	5.322393
Rf21	X#7	X#13	31.656734
Rf22	X#8	X#14	31.184069
Rf23	X#9	X#15	31.656736
Rf24	VGND#1	VGND#2	93.616676
Rf25	VGND#2	VGND#3	65.299950
Rf26	VGND#3	VGND#4	41.614250
Rf27	VGND#4	VGND#5	26.273645
Rf28	VGND#5	VGND#6	73.001427
Rf29	VGND#6	VGND#7	105.433685
Rf30	VGND#2	VGND#8	29.103382
Rf31	VGND#3	VGND#9	31.948624
Rf32	VGND#5	VGND#10	31.948624
Rf33	VGND#6	VGND#11	34.507496
Rf34	VPWR#1	VPWR#2	102.539932
Rf35	VPWR#2	VPWR#3	65.818954
Rf36	VPWR#3	VPWR#4	35.892784
Rf37	VPWR#4	VPWR#5	29.926170
Rf38	VPWR#5	VPWR#6	69.348907
Rf39	VPWR#6	VPWR#7	106.653351
Rf40	VPWR#2	VPWR#8	35.727165
Rf41	VPWR#3	VPWR#10	32.494125
Rf42	VPWR#10	VPWR#9	60.291309
Rf43	VPWR#5	VPWR#11	35.727165
Rf44	VPWR#6	VPWR#12	31.534731
Rf45	VPWR#9	VPWR#10	15.000000
Re1	VPWR#4	VPWR	0.892922
Re2	VGND	VGND#4	0.892955
*
*       CAPACITOR CARDS
*
*
C1	VGND#2	VGND#1	9.92645e-19
C2	VPWR#2	a_125_368##5	3.33675e-20
C3	VGND#5	a_125_368##10	5.77792e-21
C4	VGND#2	X#1	1.05022e-17
C5	VGND#3	VGND#8	3.55735e-19
C6	VPWR#2	a_125_368##4	2.74601e-20
C7	VGND#5	a_125_368##9	6.35571e-20
C8	VGND#3	X#11	5.24021e-18
C9	VPWR#2	a_125_368##3	4.30128e-20
C10	VGND#2	X#11	5.19089e-18
C11	VGND#1	X#6	9.64957e-18
C12	VPWR#2	a_125_368##2	4.56734e-20
C13	a_125_368##27	A#11	4.81283e-17
C14	VGND#6	VGND#10	3.8184e-19
C15	a_125_368##4	a_125_368##14	2.78484e-18
C16	VGND#6	X#5	9.18578e-18
C17	VGND#5	X#5	8.71516e-18
C18	VGND#1	X#2	1.43156e-17
C19	X#2	X#1	1.26353e-18
C20	VGND#8	X#3	1.89984e-17
C21	VGND#6	A#4	9.74797e-20
C22	VGND#6	a_125_368##28	1.58423e-17
C23	VGND#3	a_125_368##5	4.0001e-20
C24	a_125_368##28	A#4	1.83634e-17
C25	VGND#8	X#2	1.90655e-17
C26	X#3	X#11	7.49965e-19
C27	VGND#9	X#4	1.5729e-17
C28	VGND#7	VGND#6	1.35535e-18
C29	VGND#3	a_125_368##4	3.56783e-20
C30	VPWR#2	VPWR#1	1.04067e-18
C31	VGND#9	X#3	1.57703e-17
C32	X#4	X#12	1.33971e-19
C33	X#9	a_125_368##9	5.74019e-20
C34	X#13	VPWR#2	1.49819e-17
C35	VGND#7	A#4	1.49161e-18
C36	VGND#10	X#4	2.23832e-17
C37	X#9	a_125_368##8	1.56577e-17
C38	VPWR#3	VPWR#8	2.83085e-19
C39	VGND#2	a_125_368##4	8.28996e-20
C40	a_125_368##8	a_125_368##20	3.47913e-18
C41	X#5	X#4	5.94527e-19
C42	X#14	VPWR#3	6.51945e-18
C43	a_125_368##20	a_125_368##5	3.47913e-18
C44	VGND#2	a_125_368##3	4.22232e-20
C45	X#14	VPWR#2	7.93669e-18
C46	X#1	VGND#1	2.91076e-17
C47	VGND#2	a_125_368##2	9.92428e-20
C48	a_125_368##27	X#5	1.48947e-17
C49	VGND#8	VGND#1	2.43873e-18
C50	a_125_368##10	a_125_368##9	1.18208e-17
C51	X#7	VPWR#1	1.75277e-19
C52	X#8	X#13	9.02757e-20
C53	VGND#11	a_125_368##27	3.48819e-17
C54	X#6	VPWR#1	3.53602e-17
C55	VGND#8	X#1	2.93564e-17
C56	X#7	X#13	7.30592e-19
C57	X#8	a_125_368##5	1.41577e-17
C58	X#10	VPWR#6	7.26236e-18
C59	VPWR#11	VPWR#3	5.14699e-20
C60	X#8	VPWR#8	1.54856e-17
C61	VPWR#8	a_125_368##4	4.98518e-19
C62	X#11	X#1	1.48338e-18
C63	X#6	X#13	1.75347e-19
C64	X#10	VPWR#5	7.36e-18
C65	X#7	VPWR#8	1.57149e-17
C66	VPWR#8	a_125_368##3	5.73672e-19
C67	X#8	a_125_368##4	1.42237e-17
C68	X#11	VGND#8	2.9377e-17
C69	X#8	X#14	8.15576e-20
C70	X#9	VPWR#9	8.16603e-18
C71	VGND#9	VGND#8	2.36231e-18
C72	X#8	VPWR#9	6.47799e-18
C73	a_125_368##29	VPWR#6	1.505e-17
C74	a_125_368##28	A#11	2.08253e-17
C75	X#9	X#15	1.01148e-19
C76	VGND#9	X#11	2.90885e-17
C77	X#6	a_125_368##8	1.19829e-19
C78	a_125_368##25	a_125_368##9	3.47913e-18
C79	X#7	a_125_368##4	2.15648e-19
C80	VPWR#7	VPWR#6	9.5684e-19
C81	X#12	X#11	1.72657e-18
C82	X#9	VPWR#11	1.60823e-17
C83	a_125_368##9	a_125_368##8	1.15803e-17
C84	X#12	VGND#9	2.96081e-17
C85	X#7	a_125_368##3	4.07574e-18
C86	X#6	a_125_368##5	2.53001e-19
C87	A#4	a_125_368##25	2.50424e-18
C88	VGND#10	VGND#9	1.89091e-18
C89	X#4	a_125_368##8	1.6293e-17
C90	X#7	a_125_368##2	3.17526e-18
C91	X#6	a_125_368##4	5.03288e-19
C92	VGND#10	X#12	3.11546e-17
C93	VGND#1	VPWR#1	9.99563e-20
C94	X#5	X#12	1.96067e-18
C95	X#6	a_125_368##3	1.03012e-18
C96	X#5	VGND#10	4.41347e-17
C97	VPWR#11	a_125_368##9	3.92811e-19
C98	X#6	a_125_368##2	2.36311e-17
C99	VPWR#11	a_125_368##8	4.25541e-19
C100	VGND#11	VGND#10	2.49997e-18
C101	a_125_368##27	X#10	4.78991e-17
C102	VGND#11	X#5	4.81045e-17
C103	X#10	a_125_368##10	1.6075e-18
C104	VGND#2	a_125_368##13	1.23167e-18
C105	a_125_368##28	X#5	3.17017e-18
C106	X#3	a_125_368##5	1.06594e-17
C107	a_125_368##27	VPWR#12	2.22844e-17
C108	X#10	a_125_368##9	1.37172e-17
C109	a_125_368##28	VGND#11	4.26831e-17
C110	VGND#2	a_125_368##15	1.23167e-18
C111	X#3	a_125_368##4	1.23279e-17
C112	a_125_368##27	a_125_368##29	3.20215e-18
C113	a_125_368##27	a_125_368##10	3.90271e-18
C114	VGND#3	a_125_368##17	1.23167e-18
C115	VGND#7	VGND#11	2.50436e-18
C116	X#3	a_125_368#	5.82482e-20
C117	X#3	a_125_368##3	8.10801e-19
C118	a_125_368##27	a_125_368##9	8.57534e-19
C119	VGND#7	a_125_368##28	4.81286e-17
C120	X#2	a_125_368#	1.03418e-17
C121	VGND#3	a_125_368##19	3.695e-18
C122	VGND#6	a_125_368##21	8.02225e-20
C123	A#11	a_125_368##29	3.12909e-17
C124	X#3	a_125_368##13	8.7536e-20
C125	a_125_368##27	a_125_368##8	4.7109e-19
C126	X#4	a_125_368##15	4.36499e-20
C127	X#2	a_125_368##13	9.14099e-18
C128	VGND#6	a_125_368##23	3.27546e-19
C129	VPWR#4	a_125_368##8	6.19502e-20
C130	X#3	a_125_368##15	9.2086e-18
C131	VGND#5	a_125_368##23	2.71641e-18
C132	X#4	a_125_368##17	9.98825e-20
C133	X#2	a_125_368##15	1.66603e-19
C134	X#2	a_125_368##3	1.05098e-17
C135	X#10	A#4	2.05216e-19
C136	X#3	a_125_368##17	8.69677e-18
C137	VGND#6	a_125_368##11	1.04584e-17
C138	a_125_368##27	a_125_368##5	1.92876e-19
C139	X#13	VPWR#1	7.71332e-17
C140	X#2	a_125_368##17	3.58722e-20
C141	X#4	a_125_368##19	9.14195e-18
C142	X#2	a_125_368##2	7.01128e-18
C143	VPWR#8	VPWR#1	1.95129e-18
C144	X#3	a_125_368##19	1.63871e-19
C145	VGND#6	A#6	4.55597e-18
C146	VGND#1	a_125_368#	2.59872e-17
C147	VGND#4	a_125_368##8	2.4445e-20
C148	X#4	a_125_368##21	1.37159e-17
C149	VPWR#8	X#13	7.53844e-17
C150	a_125_368#	X#1	9.8392e-18
C151	A#4	a_125_368##10	1.89677e-17
C152	X#3	a_125_368##21	3.90164e-20
C153	VGND#1	a_125_368##13	2.08921e-18
C154	X#14	X#13	3.55461e-18
C155	VGND#8	a_125_368#	2.24578e-18
C156	VGND#6	A#7	2.35536e-18
C157	X#4	a_125_368##23	1.22522e-19
C158	VPWR#6	VPWR#5	1.07669e-18
C159	a_125_368##13	X#1	1.10725e-17
C160	X#14	VPWR#8	7.7215e-17
C161	X#11	a_125_368#	1.89616e-19
C162	VGND#8	a_125_368##13	2.79732e-17
C163	X#1	a_125_368##15	5.42346e-19
C164	VPWR#9	VPWR#8	2.28687e-18
C165	a_125_368##6	a_125_368##10	1.4271e-17
C166	X#11	a_125_368##13	2.84958e-19
C167	a_125_368##27	a_125_368##23	1.73466e-19
C168	a_125_368##6	a_125_368##9	1.65962e-17
C169	A#11	a_125_368##10	1.96212e-18
C170	a_125_368##27	A#4	1.4634e-17
C171	a_125_368##6	a_125_368##8	3.04666e-17
C172	VGND#8	a_125_368##15	2.46749e-17
C173	a_125_368##5	a_125_368##4	1.51582e-17
C174	VPWR#9	X#14	6.95297e-17
C175	a_125_368##6	a_125_368##5	2.59851e-17
C176	X#1	a_125_368##17	1.16776e-19
C177	A#4	a_125_368##29	3.01686e-18
C178	a_125_368##6	a_125_368##4	1.68052e-17
C179	a_125_368##15	X#11	8.68568e-18
C180	a_125_368##6	a_125_368##3	2.29329e-17
C181	a_125_368##27	a_125_368##11	1.66199e-18
C182	X#15	X#14	4.39158e-18
C183	VGND#8	a_125_368##17	1.65544e-18
C184	VPWR#5	VPWR#3	9.68748e-19
C185	VGND#9	a_125_368##15	1.59833e-18
C186	a_125_368##17	X#11	1.10157e-17
C187	VPWR#2	a_125_368##14	1.58401e-18
C188	X#15	VPWR#9	6.93737e-17
C189	X#12	a_125_368##15	1.43952e-19
C190	a_125_368##27	A#6	9.20653e-18
C191	VGND#9	a_125_368##17	2.57582e-17
C192	VGND#7	VPWR#7	2.42057e-19
C193	VPWR#11	VPWR#9	2.28687e-18
C194	X#11	a_125_368##19	5.40425e-19
C195	VPWR#3	a_125_368##16	2.78329e-19
C196	X#12	a_125_368##17	3.294e-19
C197	X#8	a_125_368##12	1.02261e-20
C198	VPWR#2	a_125_368##16	1.4229e-18
C199	VGND#9	a_125_368##19	2.25468e-17
C200	VPWR#11	X#15	7.52603e-17
C201	X#11	a_125_368##21	1.28671e-19
C202	a_125_368##19	X#12	7.12801e-18
C203	X#6	a_125_368##12	1.65532e-17
C204	VPWR#3	VPWR#2	9.68748e-19
C205	X#10	X#15	3.51213e-18
C206	VPWR#3	a_125_368##18	5.08735e-18
C207	VGND#9	a_125_368##21	1.63341e-18
C208	X#8	a_125_368##14	1.62895e-20
C209	VGND#10	a_125_368##19	7.30871e-19
C210	X#7	a_125_368##14	2.10046e-17
C211	X#12	a_125_368##21	2.17197e-17
C212	X#10	VPWR#11	9.1716e-17
C213	VGND#9	a_125_368##23	3.31733e-19
C214	a_125_368##21	VGND#10	1.59809e-17
C215	VPWR#3	a_125_368##20	4.30461e-18
C216	VPWR#12	VPWR#11	2.03612e-18
C217	X#8	a_125_368##16	5.66009e-18
C218	X#12	a_125_368##23	4.04062e-19
C219	X#5	a_125_368##21	5.40961e-19
C220	a_125_368##4	a_125_368##3	9.59255e-18
C221	VPWR#12	X#10	6.67836e-17
C222	a_125_368##23	VGND#10	1.81014e-17
C223	VGND#11	a_125_368##21	2.07857e-19
C224	VPWR#5	a_125_368##22	3.48466e-19
C225	X#5	a_125_368##23	3.98612e-17
C226	X#8	a_125_368##18	9.08303e-18
C227	VPWR#3	a_125_368##22	2.78329e-19
C228	a_125_368##29	X#10	2.58191e-18
C229	VGND#10	a_125_368##11	7.29405e-19
C230	VGND#11	a_125_368##23	1.1821e-18
C231	a_125_368##29	VPWR#12	7.87278e-17
C232	X#9	a_125_368##20	2.13501e-17
C233	a_125_368##11	X#5	2.26512e-17
C234	a_125_368##28	a_125_368##23	1.96963e-19
C235	VPWR#5	a_125_368##24	1.42194e-18
C236	VGND#10	A#6	2.74565e-19
C237	a_125_368##11	VGND#11	1.40386e-17
C238	VPWR#7	VPWR#12	1.69485e-18
C239	X#5	A#6	6.78352e-19
C240	a_125_368##28	a_125_368##11	8.30406e-19
C241	A#11	A#4	1.65257e-17
C242	VPWR#7	a_125_368##29	9.19886e-17
C243	X#9	a_125_368##22	5.51839e-18
C244	VPWR#6	a_125_368##25	8.47485e-18
C245	A#6	VGND#11	1.61625e-17
C246	VGND#7	a_125_368##11	2.8936e-19
C247	VGND#6	VGND#5	9.53351e-19
C248	a_125_368##28	A#6	3.26848e-17
C249	X#9	VPWR#5	4.07058e-20
C250	VGND#11	A#7	8.73614e-19
C251	VGND#7	A#6	1.36469e-18
C252	VPWR#6	A#1	2.58372e-18
C253	a_125_368##28	A#7	3.00729e-17
C254	VGND#7	A#7	2.26516e-17
C255	X#9	VPWR#3	3.08686e-19
C256	a_125_368##13	a_125_368#	3.20758e-17
C257	a_125_368##3	a_125_368##2	1.15561e-17
C258	VGND#5	VGND#3	1.13178e-18
C259	X#8	VPWR#3	2.17098e-19
C260	a_125_368##15	a_125_368##13	2.23371e-17
C261	A	A#4	2.455e-17
C262	VPWR#1	a_125_368##12	4.95535e-17
C263	a_125_368##12	X#13	2.77623e-17
C264	X#8	VPWR#2	1.66215e-19
C265	a_125_368##27	a_125_368##25	8.3731e-18
C266	VPWR#1	a_125_368##14	2.99442e-18
C267	VPWR#8	a_125_368##12	2.64988e-18
C268	a_125_368##17	a_125_368##15	3.20842e-17
C269	a_125_368##14	X#13	3.33045e-17
C270	X#14	a_125_368##12	4.02653e-19
C271	A#11	a_125_368##25	5.5875e-19
C272	VPWR#4	VPWR#6	4.4397e-17
C273	VGND#3	VGND#2	9.91745e-19
C274	VPWR#1	a_125_368##16	2.9687e-19
C275	a_125_368##14	VPWR#8	2.49801e-17
C276	a_125_368##27	A#1	1.81882e-18
C277	X#7	VPWR#2	1.83176e-19
C278	VPWR#4	VPWR#5	2.8849e-17
C279	a_125_368##19	a_125_368##17	3.0946e-17
C280	X#13	a_125_368##16	2.65144e-18
C281	X#14	a_125_368##14	6.41399e-19
C282	VPWR#4	VPWR#3	2.6241e-17
C283	VPWR#4	VPWR#2	4.42967e-17
C284	VPWR#8	a_125_368##16	5.6176e-17
C285	A#11	A#1	1.9716e-18
C286	a_125_368##16	X#14	1.84891e-17
C287	a_125_368##27	A#5	4.02524e-19
C288	X#13	a_125_368##18	2.96446e-19
C289	a_125_368##21	a_125_368##19	3.16385e-17
C290	VPWR#8	a_125_368##18	2.49659e-18
C291	VPWR#9	a_125_368##16	3.35849e-19
C292	X#9	VPWR#4	1.39078e-19
C293	X#14	a_125_368##18	5.26368e-17
C294	VGND#4	VGND#6	4.69765e-17
C295	a_125_368##18	VPWR#9	2.38575e-17
C296	VPWR#8	a_125_368##20	3.06214e-19
C297	VGND#4	VGND#5	2.90173e-17
C298	a_125_368##23	a_125_368##21	1.75124e-17
C299	VGND#4	VGND#3	3.04298e-17
C300	X#15	a_125_368##18	2.39043e-18
C301	X#14	a_125_368##20	2.40347e-18
C302	VGND#4	VGND#2	4.33943e-17
C303	a_125_368##20	VPWR#9	2.90542e-17
C304	VPWR#11	a_125_368##18	3.06214e-19
C305	X#15	a_125_368##20	6.12899e-17
C306	VGND#6	a_125_368##6	7.62004e-19
C307	a_125_368##11	a_125_368##23	2.76044e-17
C308	VPWR#11	a_125_368##20	2.52586e-18
C309	VPWR#9	a_125_368##22	3.35849e-19
C310	VGND#4	X#4	3.98289e-19
C311	X#10	a_125_368##20	2.88276e-19
C312	a_125_368##22	X#15	1.82214e-17
C313	a_125_368##6	X#9	7.90463e-17
C314	VPWR#11	a_125_368##22	6.07103e-17
C315	a_125_368##6	X#8	7.82455e-17
C316	A#6	a_125_368##11	1.98454e-17
C317	a_125_368##6	X#7	4.2705e-17
C318	X#10	a_125_368##22	6.61303e-19
C319	X#15	a_125_368##24	6.47481e-19
C320	a_125_368##6	X#6	3.21039e-17
C321	VPWR#6	a_125_368##10	2.80205e-20
C322	X#4	a_125_368##6	9.46706e-17
C323	VPWR#11	a_125_368##24	5.17548e-17
C324	X#3	a_125_368##6	7.50474e-17
C325	VGND#8	a_125_368##4	2.87127e-19
C326	X#2	a_125_368##6	3.57519e-17
C327	X#10	a_125_368##24	2.37079e-17
C328	A#7	A#6	3.37934e-17
C329	X#15	a_125_368##25	2.84514e-19
C330	a_125_368##27	a_125_368##6	2.42677e-19
C331	VGND#4	VGND#1	2.6963e-17
C332	VPWR#12	a_125_368##24	7.45976e-19
C333	VPWR#11	a_125_368##25	2.48766e-18
C334	VGND	a_125_368##10	4.06801e-19
C335	VGND	a_125_368##9	4.1822e-19
C336	X#10	a_125_368##25	5.89409e-17
C337	VGND	a_125_368##8	5.20991e-19
C338	VGND#8	a_125_368##3	8.08142e-19
C339	VGND#3	X#4	5.38838e-19
C340	VGND	a_125_368##5	4.56759e-19
C341	VGND	a_125_368##4	3.39714e-19
C342	a_125_368##25	VPWR#12	2.65206e-17
C343	VGND	a_125_368##3	6.63728e-19
C344	VGND	a_125_368##2	2.01973e-18
C345	VPWR#11	A#1	3.12383e-19
C346	a_125_368##29	a_125_368##25	5.24626e-19
C347	VGND#4	X#12	1.3672e-17
C348	X#10	A#1	7.72432e-19
C349	VPWR#7	a_125_368##25	2.8528e-19
C350	A#1	VPWR#12	3.50283e-17
C351	VPWR#4	VPWR#1	2.90967e-17
C352	a_125_368##29	A#1	7.4893e-17
C353	VGND#9	a_125_368##6	5.90823e-19
C354	VGND#3	X#3	3.80972e-19
C355	VPWR#7	A#1	1.3551e-18
C356	VPWR#12	A#5	1.41805e-18
C357	VGND#4	VGND#7	2.85168e-17
C358	VGND#6	a_125_368##27	2.33038e-19
C359	VPWR#5	a_125_368##10	1.76529e-20
C360	a_125_368##29	A#5	5.39321e-17
C361	a_125_368##14	a_125_368##12	4.71093e-17
C362	X#5	a_125_368##6	5.42665e-17
C363	A#5	VPWR#7	3.62564e-17
C364	X#15	VPWR#4	1.42121e-17
C365	VGND#2	X#3	3.80972e-19
C366	a_125_368##16	a_125_368##14	3.72493e-17
C367	a_125_368##10	VNB	3.64333e-17
C368	a_125_368##9	VNB	4.37389e-17
C369	a_125_368##8	VNB	4.97869e-17
C370	a_125_368##5	VNB	3.59935e-17
C371	a_125_368##4	VNB	4.41104e-17
C372	VPWR#5	a_125_368##9	3.72673e-20
C373	a_125_368##3	VNB	4.45821e-17
C374	a_125_368##2	VNB	5.19495e-17
C375	A#4	VNB	8.21838e-17
C376	VPWR#4	VPWR#7	2.96384e-17
C377	VPWR#9	a_125_368##6	1.36207e-18
C378	a_125_368##18	a_125_368##16	4.7127e-17
C379	VGND#2	X#2	3.80972e-19
C380	VGND#9	a_125_368##5	2.39788e-19
C381	a_125_368##6	X#10	5.39408e-17
C382	a_125_368##20	a_125_368##18	4.76523e-17
C383	A#6	a_125_368##10	2.17028e-18
C384	VPWR	VPWR#6	2.6529e-17
C385	VPWR	VPWR#5	1.74968e-17
C386	VPWR	VPWR#3	2.86762e-17
C387	a_125_368##22	a_125_368##20	4.71404e-17
C388	VPWR	VPWR#2	2.56889e-17
C389	VGND#4	a_125_368##21	3.06456e-18
C390	VPWR	X#9	2.26041e-18
C391	VPWR	X#8	1.92883e-18
C392	a_125_368##24	a_125_368##22	4.67449e-17
C393	VPWR	X#7	1.4827e-18
C394	a_125_368##28	A	1.64846e-17
C395	VPWR	X#6	3.79218e-18
C396	VGND#7	A	1.19681e-17
C397	VPWR	a_125_368##27	1.68213e-18
C398	a_125_368##25	a_125_368##24	4.71271e-17
C399	VPWR	A#11	2.17895e-18
C400	VGND	VGND#6	5.0982e-17
C401	VGND	VGND#5	1.70549e-17
C402	VGND	VGND#3	1.85177e-17
C403	VGND	VGND#2	2.16087e-17
C404	VGND	X#9	3.46797e-18
C405	VGND	X#8	3.45774e-18
C406	VGND	X#7	3.07977e-18
C407	A#1	a_125_368##25	3.04694e-17
C408	VGND	X#6	2.89014e-18
C409	VGND#10	a_125_368##9	4.74384e-19
C410	VGND	X#4	4.68977e-18
C411	VGND	X#3	3.82143e-18
C412	VPWR#4	a_125_368##20	1.60555e-18
C413	A	a_125_368##29	1.82588e-17
C414	VGND	X#2	4.71011e-18
C415	X#2	X#7	4.91613e-18
C416	VGND	a_125_368##27	4.45917e-18
C417	A	VPWR#7	3.29944e-17
C418	VPWR#4	a_125_368##22	1.19059e-18
C419	VGND	A#11	2.24739e-18
C420	A#5	A#1	4.45034e-17
C421	VPWR#6	VNB	3.45206e-17
C422	VPWR#5	VNB	2.22796e-17
C423	VPWR	VPWR#1	4.22552e-17
C424	VPWR#3	VNB	2.0119e-17
C425	VGND	VGND#1	3.61647e-17
C426	VPWR#2	VNB	3.37914e-17
C427	VPWR	X#13	1.44951e-17
C428	VGND	X#1	1.14381e-17
C429	VGND#6	VNB	3.78301e-17
C430	VGND	VGND#8	2.28467e-17
C431	VPWR	VPWR#8	2.11021e-17
C432	VGND#5	VNB	2.28274e-17
C433	VGND#10	a_125_368##8	1.33448e-18
C434	VGND#3	VNB	2.35872e-17
C435	VGND	X#11	1.06296e-17
C436	VPWR	X#14	1.43932e-17
C437	VGND#2	VNB	3.22158e-17
C438	VGND	VGND#9	1.7734e-17
C439	X#9	VNB	1.80093e-18
C440	VGND	X#12	1.2955e-17
C441	X#8	VNB	1.87093e-18
C442	VPWR	X#15	1.42584e-17
C443	X#7	VNB	1.93165e-18
C444	VGND	VGND#10	1.80676e-17
C445	X#6	VNB	3.70004e-17
C446	VGND	X#5	1.67197e-17
C447	VPWR	VPWR#11	2.15324e-17
C448	X#4	VNB	3.16474e-18
C449	X#3	VNB	1.81148e-18
C450	VPWR	X#10	1.53733e-17
C451	X#2	VNB	1.31983e-17
C452	VGND	a_125_368##28	1.29897e-17
C453	X#4	X#3	5.2354e-19
C454	VPWR	VPWR#12	2.08887e-17
C455	a_125_368##27	VNB	1.38316e-17
C456	VGND	VGND#7	4.21588e-17
C457	a_125_368##6	a_125_368##25	5.29035e-18
C458	VPWR	a_125_368##29	1.69161e-17
C459	A#11	VNB	4.25058e-18
C460	VPWR	VPWR#7	4.35018e-17
C461	VGND#1	VNB	4.73398e-17
C462	X#1	VNB	4.72986e-18
C463	VGND#8	VNB	5.57835e-19
C464	X#11	VNB	4.52335e-18
C465	X#12	VNB	2.10258e-18
C466	VGND	X#10	3.05136e-18
C467	VGND#10	VNB	4.17808e-18
C468	X#5	a_125_368##10	7.00594e-18
C469	X#5	VNB	4.73011e-18
C470	VGND#11	VNB	7.9995e-18
C471	a_125_368##28	VNB	1.31199e-17
C472	VPWR#4	a_125_368##6	1.48509e-20
C473	VGND#7	VNB	5.99865e-17
C474	VGND	a_125_368#	8.45562e-20
C475	VPWR#1	VNB	7.29238e-17
C476	VGND	a_125_368##13	5.61872e-19
C477	X#13	VNB	5.51429e-18
C478	VPWR#8	VNB	7.60398e-19
C479	VGND	a_125_368##15	6.25154e-19
C480	VGND#4	a_125_368##6	1.16119e-19
C481	X#14	VNB	2.3971e-18
C482	VGND	a_125_368##17	6.23979e-19
C483	VPWR#9	VNB	2.92383e-18
C484	VGND	a_125_368##19	2.82649e-19
C485	X#15	VNB	2.37032e-18
C486	VPWR#11	VNB	1.27703e-19
C487	VGND	a_125_368##21	3.41678e-19
C488	VPWR	a_125_368##12	6.88075e-19
C489	X#10	VNB	3.47226e-18
C490	VGND	a_125_368##23	2.27922e-19
C491	VPWR	a_125_368##14	8.23392e-19
C492	VPWR#12	VNB	3.74405e-18
C493	VGND	a_125_368##11	3.66446e-19
C494	a_125_368##29	VNB	2.2385e-18
C495	VPWR	a_125_368##16	9.18778e-19
C496	VPWR#7	VNB	7.69309e-17
C497	VGND	A#6	1.55928e-19
C498	a_125_368#	VNB	2.98725e-17
C499	VPWR	a_125_368##18	1.0334e-18
C500	A	A#5	6.00912e-18
C501	VPWR#6	A#4	4.23071e-20
C502	VGND	A#7	5.98306e-19
C503	a_125_368##13	VNB	2.3965e-17
C504	X#5	a_125_368##9	8.51335e-18
C505	VPWR	a_125_368##20	1.69239e-18
C506	a_125_368##15	VNB	2.37103e-17
C507	a_125_368##17	VNB	2.34472e-17
C508	VPWR	a_125_368##22	1.11448e-18
C509	a_125_368##19	VNB	2.54019e-17
C510	VPWR#3	a_125_368##5	1.82478e-20
C511	a_125_368##21	VNB	2.78198e-17
C512	VPWR	a_125_368##24	9.0822e-19
C513	a_125_368##23	VNB	2.76306e-17
C514	VPWR	a_125_368##25	2.56305e-18
C515	a_125_368##11	VNB	3.45644e-17
C516	A#6	VNB	2.99055e-17
C517	VPWR	A#1	1.25733e-19
C518	A#7	VNB	4.45973e-17
C519	VPWR	A#5	2.53411e-18
C520	a_125_368##12	VNB	4.40293e-17
C521	a_125_368##14	VNB	3.25505e-17
C522	a_125_368##16	VNB	2.76138e-17
C523	VPWR	VPWR#4	8.1601e-18
C524	a_125_368##18	VNB	3.16248e-17
C525	VGND#6	a_125_368##10	9.33356e-20
C526	X#3	X#2	4.5568e-19
C527	a_125_368##20	VNB	3.7329e-17
C528	a_125_368##22	VNB	2.79454e-17
C529	VPWR	a_125_368##6	1.32613e-17
C530	a_125_368##24	VNB	2.77313e-17
C531	X#5	a_125_368##8	5.05805e-20
C532	a_125_368##25	VNB	4.14774e-17
C533	A#1	VNB	3.18527e-17
C534	VGND	VGND#4	7.87618e-18
C535	A#5	VNB	4.00411e-17
C536	VGND	a_125_368##6	1.88061e-17
C537	VPWR#4	VNB	2.28466e-16
C538	VGND#4	VNB	2.28463e-16
C539	VPWR	A	4.57568e-18
C540	a_125_368##6	VNB	8.11743e-17
C541	VGND	A	5.99495e-18
C542	A	VNB	2.81312e-17
C543	VPWR	VNB	5.74874e-17
C544	VGND	VNB	5.59828e-17
*
*
.ENDS sky130_fd_sc_hs__clkbuf_8
*
