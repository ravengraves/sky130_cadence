* Extracted by Quantus, converted by sky130cad/quantus.py
*
*
*
*                       LINUX           Wed Nov 18 09:03:15 2026
*
*
*
*  PROGRAM  advgen
*
*  Name           : advgen - Quantus - (64-bit)
*  Version        : 25.1.0-p047
*  Build Date     : Thu Dec 11 23:20:30 PST 2025
*
*  HSPICE LIBRARY
*
*  OPERATING_TEMPERATURE 150
*  QRC_TECH_DIR <path>/tech
*
*
*

*
.SUBCKT sky130_fd_sc_hs__o32a_4 VNB VPB VGND VPWR X A1 A2 A3 B2 B1
*
*
*  caps2d version: 10
*
*
*       TRANSISTOR CARDS
*
*
XM7 VGND#8 a_83_256##12 X#3 VNB sky130_fd_pr__nfet_01v8_lvt l=0.15 w=0.74 ad=0.2543 as=0.2072 pd=2.19 ps=2.04
XM8 X#3 a_83_256##8 VGND#13 VNB sky130_fd_pr__nfet_01v8_lvt l=0.15 w=0.74 ad=0.2072 as=0.3108 pd=2.04 ps=2.32
XM26 X#1 a_83_256##5 VGND#13 VNB sky130_fd_pr__nfet_01v8_lvt l=0.15 w=0.74 ad=0.2997 as=0.3108 pd=2.29 ps=2.32
XM20 VGND#12 a_83_256# X#1 VNB sky130_fd_pr__nfet_01v8_lvt l=0.15 w=0.74 ad=0.2109 as=0.2997 pd=2.05 ps=2.29
XM18 a_83_256##21 B1#4 a_564_74##7 VNB sky130_fd_pr__nfet_01v8_lvt l=0.15 w=0.64 ad=0.1792 as=0.1824 pd=1.84 ps=1.85
XM21 a_564_74##10 B1#1 a_83_256##21 VNB sky130_fd_pr__nfet_01v8_lvt l=0.15 w=0.64 ad=0.224 as=0.1792 pd=1.98 ps=1.84
XM4 a_83_256##22 B2#6 a_564_74##10 VNB sky130_fd_pr__nfet_01v8_lvt l=0.15 w=0.64 ad=0.224 as=0.224 pd=1.98 ps=1.98
XM9 a_564_74##4 B2#1 a_83_256##22 VNB sky130_fd_pr__nfet_01v8_lvt l=0.15 w=0.64 ad=0.2432 as=0.224 pd=2.04 ps=1.98
XM25 a_564_74##4 A3#5 VGND#11 VNB sky130_fd_pr__nfet_01v8_lvt l=0.15 w=0.64 ad=0.2432 as=0.2368 pd=2.04 ps=2.02
XM5 VGND#11 A3#1 a_564_74##9 VNB sky130_fd_pr__nfet_01v8_lvt l=0.15 w=0.64 ad=0.2368 as=0.192 pd=2.02 ps=1.88
XM19 VGND#10 A2#5 a_564_74##9 VNB sky130_fd_pr__nfet_01v8_lvt l=0.15 w=0.64 ad=0.224 as=0.192 pd=1.98 ps=1.88
XM24 a_564_74##8 A2#1 VGND#10 VNB sky130_fd_pr__nfet_01v8_lvt l=0.15 w=0.64 ad=0.1792 as=0.224 pd=1.84 ps=1.98
XM3 VGND#9 A1#5 a_564_74##8 VNB sky130_fd_pr__nfet_01v8_lvt l=0.15 w=0.64 ad=0.304 as=0.1792 pd=2.23 ps=1.84
XM14 a_564_74# A1#1 VGND#9 VNB sky130_fd_pr__nfet_01v8_lvt l=0.15 w=0.64 ad=0.1824 as=0.304 pd=1.85 ps=2.23
XM0 VPWR#7 a_83_256##14 X#5 VPB sky130_fd_pr__pfet_01v8 l=0.15 w=1.12 ad=0.3304 as=0.336 pd=2.83 ps=2.84
XM12 X#5 a_83_256##13 VPWR#11 VPB sky130_fd_pr__pfet_01v8 l=0.15 w=1.12 ad=0.336 as=0.392 pd=2.84 ps=2.94
XM15 X#6 a_83_256##9 VPWR#11 VPB sky130_fd_pr__pfet_01v8 l=0.15 w=1.12 ad=0.4704 as=0.392 pd=3.08 ps=2.94
XM22 VPWR#10 a_83_256##4 X#6 VPB sky130_fd_pr__pfet_01v8 l=0.15 w=1.12 ad=0.4524 as=0.4704 pd=3.08 ps=3.08
XM17 a_534_388##2 B1#5 VPWR#10 VPB sky130_fd_pr__pfet_01v8 l=0.15 w=1 ad=0.44 as=0.4524 pd=2.88 ps=3.08
XM13 a_534_388##2 B2#5 a_83_256##16 VPB sky130_fd_pr__pfet_01v8 l=0.15 w=1 ad=0.44 as=0.3 pd=2.88 ps=2.6
XM1 a_83_256##16 B2#7 a_534_388# VPB sky130_fd_pr__pfet_01v8 l=0.15 w=1 ad=0.3 as=0.3 pd=2.6 ps=2.6
XM16 VPWR#9 B1#6 a_534_388# VPB sky130_fd_pr__pfet_01v8 l=0.15 w=1 ad=0.345 as=0.3 pd=2.69 ps=2.6
XM6 a_961_392##3 A3#7 a_83_256##15 VPB sky130_fd_pr__pfet_01v8 l=0.15 w=1 ad=0.295 as=0.32 pd=2.59 ps=2.64
XM27 a_83_256##15 A3#6 a_961_392# VPB sky130_fd_pr__pfet_01v8 l=0.15 w=1 ad=0.32 as=0.3 pd=2.64 ps=2.6
XM11 a_961_392# A2#4 a_1234_392# VPB sky130_fd_pr__pfet_01v8 l=0.15 w=1 ad=0.3 as=0.49 pd=2.6 ps=2.98
XM23 VPWR#8 A1#4 a_1234_392# VPB sky130_fd_pr__pfet_01v8 l=0.15 w=1 ad=0.32 as=0.49 pd=2.64 ps=2.98
XM2 a_1234_392##2 A1#6 VPWR#8 VPB sky130_fd_pr__pfet_01v8 l=0.15 w=1 ad=0.3 as=0.32 pd=2.6 ps=2.64
XM10 a_1234_392##2 A2#6 a_961_392##4 VPB sky130_fd_pr__pfet_01v8 l=0.15 w=1 ad=0.3 as=0.295 pd=2.6 ps=2.59
*
*
*       RESISTOR AND CAP/DIODE CARDS
*
Rg1	a_83_256#	a_83_256##2	357.400452
Rg2	a_83_256##2	a_83_256##3	48.347958
Rg3	a_83_256##2	a_83_256##4	450.645477
Rg4	a_83_256##3	a_83_256##5	336.856964
Rg5	a_83_256##3	a_83_256##6	49.541122
Rg6	a_83_256##6	a_83_256##7	125.869171
Rg7	a_83_256##7	a_83_256##8	340.601379
Rg8	a_83_256##6	a_83_256##9	450.645477
Rg9	a_83_256##7	a_83_256##10	68.320091
Rg10	a_83_256##10	a_83_256##11	117.274651
Rg11	a_83_256##11	a_83_256##12	327.471069
Rg12	a_83_256##10	a_83_256##13	402.043823
Rg13	a_83_256##11	a_83_256##14	561.555420
Rg14	B1#1	B1#2	447.384430
Rg15	B1#2	B1#3	380.472107
Rg16	B1#2	B1#4	236.878250
Rg17	B1#3	B1#5	417.171356
Rg18	B2#1	B2#2	439.907654
Rg19	B2#2	B2#3	52.533195
Rg20	B2#3	B2#4	286.009979
Rg21	B2#4	B2#5	548.574097
Rg22	B2#2	B2#6	243.687881
Rg23	B2#4	B2#7	358.407074
Rg24	B1#6	B1#7	1389.117920
Rg25	A3#1	A3#2	334.951599
Rg26	A3#2	A3#3	36.503117
Rg27	A3#3	A3#4	26.676205
Rg28	A3#4	A3#5	326.968750
Rg29	A3#2	A3#6	590.181946
Rg30	A3#4	A3#7	541.714233
Rg31	A2#1	A2#2	350.320129
Rg32	A2#2	A2#3	54.657841
Rg33	A2#3	A2#4	443.537354
Rg34	A2#2	A2#5	245.266769
Rg35	A1#1	A1#2	455.809540
Rg36	A1#2	A1#3	97.223221
Rg37	A1#3	A1#4	467.481537
Rg38	A1#2	A1#5	261.420227
Rg39	A1#3	A1#6	356.532349
Rg40	A2#6	A2#7	569.323364
Rf1	X#1	X#2	77.200630
Rf2	X#2	X	46.276421
Rf3	X#2	X#3	18.703703
Rf4	X	X#4	50.678040
Rf5	X#4	X#5	26.045521
Rf6	X#4	X#6	84.589287
Rf7	a_534_388#	a_534_388##2	77.836212
Rf8	B2	B2#3	169.287277
Rf9	a_83_256##15	a_83_256##17	156.712296
Rf10	a_83_256##17	a_83_256##18	36.015171
Rf11	a_83_256##18	a_83_256##3	154.316986
Rf12	a_83_256##18	a_83_256##20	8.258814
Rf13	a_83_256##20	a_83_256##21	25.107595
Rf14	a_83_256##20	a_83_256##22	80.532822
Rf15	a_83_256##16	a_83_256##17	15.000000
Rf16	A3#8	A3#3	80.613510
Rf17	A3	A3#10	0.497105
Rf18	A3#8	A3#10	4.724072
Rf19	B1#7	B1	552.502258
Rf20	B1	B1#3	162.201172
Rf21	A1#2	A1	167.797211
Rf22	a_1234_392#	a_1234_392##2	84.473152
Rf23	A2#7	A2	14.364518
Rf24	A2	A2#3	97.737190
Rf25	A2#7	A2	7.479781
Rf26	a_961_392##2	a_961_392##3	57.315178
Rf27	a_961_392##2	a_961_392##4	150.960403
Rf28	a_961_392#	a_961_392##2	15.000000
Rf29	a_564_74#	a_564_74##2	80.912346
Rf30	a_564_74##2	a_564_74##3	70.710632
Rf31	a_564_74##3	a_564_74##5	73.217155
Rf32	a_564_74##5	a_564_74##6	80.216232
Rf33	a_564_74##6	a_564_74##7	82.452690
Rf34	a_564_74##2	a_564_74##8	12.131965
Rf35	a_564_74##3	a_564_74##9	10.866916
Rf36	a_564_74##6	a_564_74##10	21.713133
Rf37	a_564_74##4	a_564_74##5	7.500000
Rf39	VGND#2	VGND#3	78.358650
Rf40	VGND#3	VGND#4	73.001427
Rf41	VGND#4	VGND#5	148.633224
Rf42	VGND#5	VGND#6	69.738693
Rf43	VGND#6	VGND#7	77.019211
Rf44	VGND#7	VGND#8	103.317566
Rf45	VGND#2	VGND#9	32.627857
Rf46	VGND#3	VGND#10	32.145462
Rf47	VGND#4	VGND#11	32.342297
Rf48	VGND#6	VGND#12	31.141060
Rf49	VGND#7	VGND#13	33.720150
Rf50	VPWR#1	VPWR#2	34.309200
Rf51	VPWR#2	VPWR#3	190.612732
Rf52	VPWR#3	VPWR#4	73.025963
Rf53	VPWR#4	VPWR#5	81.061516
Rf54	VPWR#5	VPWR#6	74.462440
Rf55	VPWR#6	VPWR#7	120.594025
Rf56	VPWR#2	VPWR#8	31.948624
Rf57	VPWR#3	VPWR#9	32.932804
Rf58	VPWR#5	VPWR#10	35.727165
Rf59	VPWR#6	VPWR#11	34.880951
Re1	VPWR#1	VPWR	4.549932
Re2	VPWR	VPWR#4	0.974985
Re3	VGND#2	VGND	4.549932
Re4	VGND	VGND#5	0.974985
*
*       CAPACITOR CARDS
*
*
C1	a_564_74#	VGND#9	4.23861e-17
C2	VGND#12	B1#1	1.9894e-19
C3	a_564_74##7	B1#4	5.65469e-17
C4	a_961_392#	A2#1	1.99659e-19
C5	VPWR#5	a_83_256##4	4.22931e-18
C6	a_961_392##3	VPWR#3	2.88643e-17
C7	X#6	VPWR#10	8.26106e-17
C8	X#1	B1#1	1.3645e-19
C9	VGND#3	a_564_74##2	7.35124e-18
C10	VGND#12	B1#4	2.18106e-18
C11	a_564_74##7	a_83_256#	1.28763e-18
C12	VPWR#11	VPWR#10	1.50992e-18
C13	X#6	a_83_256##6	5.74766e-18
C14	VPWR#6	a_83_256##9	9.89661e-19
C15	X#1	B1#4	4.81208e-19
C16	VGND#12	a_83_256#	4.67994e-17
C17	X#6	VPWR#11	7.91507e-17
C18	VPWR#11	a_83_256##10	6.82823e-19
C19	X#1	a_83_256#	1.37814e-17
C20	B1#2	a_83_256##21	7.52028e-19
C21	X#5	X#6	6.98684e-19
C22	VPWR#6	a_83_256##13	2.57489e-18
C23	VGND#12	a_83_256##5	1.83933e-18
C24	VGND#13	a_83_256#	1.09054e-18
C25	VGND#10	VGND#9	2.63571e-18
C26	a_534_388#	VPWR#3	9.5762e-18
C27	X#1	a_83_256##5	5.68512e-17
C28	X#5	VPWR#11	7.48547e-17
C29	B1#3	B2#4	3.16307e-18
C30	VPWR#11	a_83_256##6	7.00938e-19
C31	B1#3	B2#2	4.26187e-19
C32	VGND#12	a_83_256##8	2.59532e-19
C33	a_83_256##5	VGND#13	2.33905e-17
C34	VPWR#6	a_83_256##14	1.60774e-18
C35	VPWR#7	VPWR#11	1.47906e-18
C36	X#1	a_83_256##8	5.46317e-19
C37	a_83_256##15	B2#1	5.43736e-19
C38	a_564_74##7	a_83_256##18	3.41972e-17
C39	a_83_256##6	B1#3	2.44162e-17
C40	a_83_256##8	VGND#13	2.59605e-17
C41	VPWR#7	X#5	6.58016e-17
C42	a_564_74##7	B1#2	3.27834e-18
C43	VGND#8	a_83_256##5	2.90158e-19
C44	a_564_74##3	a_961_392#	7.30951e-20
C45	a_534_388##2	VPWR#5	8.68271e-18
C46	a_83_256##8	X#3	1.4935e-17
C47	VPWR#9	B2#1	4.59818e-20
C48	VGND#13	a_83_256##12	1.465e-18
C49	a_564_74##3	a_564_74##2	2.49329e-18
C50	VGND#8	a_83_256##8	1.37281e-18
C51	a_83_256##3	B2#2	1.85874e-19
C52	a_83_256##12	X#3	1.5442e-17
C53	a_83_256##3	a_83_256##10	2.19766e-18
C54	A3#8	A3#4	1.89258e-17
C55	a_83_256##16	B2#1	1.44355e-20
C56	a_83_256##12	VGND#8	2.71706e-17
C57	X#1	a_83_256##18	2.57875e-18
C58	a_83_256##3	a_83_256##6	4.3794e-17
C59	VGND#11	VGND#10	1.76001e-18
C60	B2#4	B1#6	7.94665e-18
C61	X#6	VPWR#6	9.84554e-18
C62	a_83_256##18	B2#5	1.72746e-18
C63	B2#2	B1#6	1.25873e-17
C64	A1#5	A1#1	1.49213e-17
C65	X#6	VPWR#5	8.67523e-18
C66	VPWR#1	VPWR#2	3.78292e-17
C67	a_83_256##16	B1#1	5.62753e-19
C68	A2#1	A1#5	3.3041e-17
C69	a_961_392##4	A2#6	5.14294e-17
C70	a_1234_392##2	A2#6	3.17475e-17
C71	a_961_392##4	A1#6	2.17547e-17
C72	VPWR#3	A3#4	1.35644e-19
C73	X#5	VPWR#6	1.66809e-17
C74	VPWR#8	A2#6	4.81056e-18
C75	a_564_74##4	VGND#11	5.07159e-17
C76	A3#8	B2#2	1.14811e-18
C77	a_83_256##22	B1#6	1.44139e-19
C78	A2#5	A2#1	2.37936e-17
C79	a_1234_392##2	A1#6	3.91188e-17
C80	X#2	X#1	2.65318e-18
C81	X#4	a_83_256##4	1.44606e-19
C82	a_961_392##4	A1#4	9.19933e-19
C83	VPWR#8	A1#6	3.54375e-17
C84	a_961_392#	A2#6	2.60306e-19
C85	VPWR#7	VPWR#6	8.82913e-19
C86	A3#1	A2#5	2.87581e-17
C87	X#2	VGND#13	5.72445e-17
C88	a_961_392##4	A2#4	4.83776e-19
C89	X#4	a_83_256##9	3.72238e-19
C90	VPWR#8	A1#4	3.43481e-17
C91	a_961_392#	A1#6	2.05618e-19
C92	a_564_74##4	a_83_256##22	5.15086e-17
C93	VPWR#6	a_83_256##11	5.80369e-20
C94	a_1234_392#	A1#4	3.52317e-17
C95	a_961_392##4	A3#6	3.6879e-19
C96	VPWR#8	A2#4	3.08402e-18
C97	B1#2	B2#5	6.44184e-18
C98	X#2	X#3	4.68449e-19
C99	a_961_392#	A1#4	2.2693e-17
C100	X#4	a_83_256##13	1.54053e-17
C101	A3#5	A3#1	2.37706e-17
C102	X#4	VPWR#6	1.30772e-19
C103	a_1234_392#	A2#4	4.09529e-17
C104	X#1	a_83_256##6	8.73972e-18
C105	a_961_392##4	A1#3	6.16948e-19
C106	VPWR#8	A3#6	4.87164e-19
C107	VGND#13	a_83_256##10	2.63605e-19
C108	a_961_392#	A2#4	4.87815e-17
C109	B2#2	A3#4	1.27006e-18
C110	VPWR#6	a_83_256##10	4.34131e-21
C111	a_83_256##18	A3#4	4.55619e-19
C112	VGND#8	X#2	5.88973e-17
C113	VGND#5	a_564_74##6	6.36187e-17
C114	X#4	a_83_256##14	1.36896e-17
C115	a_1234_392#	A3#6	1.7283e-18
C116	a_83_256##15	A2#4	5.61658e-19
C117	VPWR#3	B2#2	9.64072e-20
C118	B2#1	A3#5	2.31621e-17
C119	VPWR#8	A3#7	2.86016e-19
C120	VGND#6	a_83_256##18	4.36103e-20
C121	a_961_392#	A3#6	3.92843e-17
C122	A3#6	a_83_256##15	2.36126e-17
C123	a_83_256##11	X#3	7.29568e-20
C124	a_83_256##21	a_83_256##22	3.91254e-18
C125	VPWR#9	A2#4	2.94137e-19
C126	VPWR#8	B1#6	3.96375e-19
C127	a_961_392#	A3#7	5.35097e-19
C128	VGND#13	a_83_256##6	1.6466e-18
C129	B2#6	B2#1	2.1495e-17
C130	a_83_256##15	A3#7	3.72105e-17
C131	a_564_74#	a_961_392##4	2.39351e-19
C132	a_1234_392##2	A1#3	3.79908e-18
C133	VPWR#9	A3#6	5.28473e-19
C134	a_83_256##10	X#3	3.91048e-19
C135	a_83_256##18	B2#4	1.00133e-17
C136	a_961_392#	B1#6	1.8208e-19
C137	VPWR#2	A2#3	2.04203e-20
C138	a_961_392##3	A3#7	3.81038e-17
C139	VPWR#6	a_83_256##6	1.07398e-19
C140	a_83_256##15	B1#6	1.43151e-19
C141	VPWR#9	A3#7	1.67439e-18
C142	B1#1	B2#6	2.114e-17
C143	a_83_256##16	A3#6	1.62054e-20
C144	a_961_392##3	B1#6	7.173e-18
C145	a_83_256##18	B2#2	5.66257e-18
C146	a_83_256##11	VGND#8	2.86259e-18
C147	a_564_74##3	A3#8	4.23383e-18
C148	a_564_74##2	A1#2	3.37946e-18
C149	VPWR#9	B1#6	3.418e-17
C150	a_83_256##16	A3#7	1.72973e-20
C151	VPWR#2	A2#1	6.55852e-20
C152	B1#4	B1#1	3.26626e-17
C153	a_534_388#	B1#6	3.3487e-17
C154	a_564_74##7	a_83_256##21	4.21162e-17
C155	VPWR#8	A1#3	6.45668e-19
C156	VPWR#9	B2#7	1.00049e-18
C157	a_83_256##18	B1#2	1.78931e-17
C158	a_83_256##16	B1#6	2.08219e-17
C159	a_564_74##3	A2#3	2.85678e-17
C160	a_564_74##2	A2#3	3.82539e-18
C161	a_534_388#	B2#7	4.01988e-17
C162	B1#7	VPWR#3	2.97735e-19
C163	VGND#7	X#2	1.51504e-17
C164	VPWR#5	a_83_256##6	8.04823e-20
C165	a_564_74##6	a_83_256##18	1.68844e-17
C166	B2#1	A3#4	6.20459e-18
C167	a_83_256#	B1#4	3.65567e-18
C168	VPWR#9	B2#5	7.87351e-19
C169	VGND#3	A1#3	4.96052e-21
C170	a_83_256##16	B2#7	3.67427e-17
C171	VPWR#10	B1#6	1.10971e-18
C172	a_534_388#	B2#5	1.23935e-20
C173	VGND#4	B1#7	3.86559e-20
C174	A2#1	A1#4	1.49043e-18
C175	VGND#12	a_564_74##7	5.10437e-17
C176	VPWR#9	B1#5	4.55042e-19
C177	a_83_256##16	B2#5	3.93091e-17
C178	VPWR#10	B2#7	1.24499e-18
C179	a_83_256##5	a_83_256#	2.22572e-17
C180	VGND#3	A2#1	1.23614e-18
C181	a_534_388##2	B2#5	3.59883e-17
C182	a_83_256##10	a_83_256##9	1.94229e-18
C183	a_1234_392#	A1#3	6.19234e-19
C184	B1#2	B2#4	1.11314e-18
C185	VPWR#9	a_83_256##4	4.79064e-19
C186	a_83_256##16	B1#5	2.04176e-18
C187	VPWR#10	B2#5	3.50889e-18
C188	a_564_74##3	B1#7	5.63689e-18
C189	a_564_74#	A2#7	4.51771e-18
C190	a_534_388##2	B1#5	3.6905e-17
C191	a_564_74##2	A1#1	9.60573e-19
C192	X#6	B2#5	8.46813e-19
C193	VPWR#5	B1#3	2.9745e-20
C194	a_83_256##8	a_83_256##5	2.13896e-17
C195	VGND#7	a_83_256##11	1.52937e-20
C196	B1#5	VPWR#10	2.20972e-17
C197	a_83_256##18	a_83_256##16	4.32605e-18
C198	VGND#3	A2#5	2.74362e-18
C199	a_564_74##3	A1#5	2.02452e-19
C200	X#1	VGND#12	4.21272e-17
C201	a_534_388##2	a_83_256##4	5.79511e-19
C202	X#6	B1#5	7.08311e-19
C203	B1	B2#4	1.36347e-18
C204	VGND#6	B1#3	9.90371e-19
C205	a_564_74#	A1#2	3.22182e-18
C206	B1	B2#2	6.77982e-19
C207	VPWR#10	a_83_256##4	6.32489e-17
C208	a_961_392##4	VPWR#1	5.24149e-17
C209	VGND#4	A3#1	2.38619e-18
C210	B1	B1#2	1.32922e-18
C211	a_564_74##2	A1#5	3.41657e-17
C212	a_83_256##12	a_83_256##8	3.79643e-17
C213	VGND#6	B1#2	3.81044e-20
C214	VGND#9	A1#2	1.62232e-18
C215	VPWR#1	a_1234_392##2	4.69274e-18
C216	B1	a_83_256##10	1.72769e-19
C217	a_83_256##3	VPWR#5	3.33425e-19
C218	a_83_256##4	X#6	2.81152e-17
C219	VGND#13	VGND#12	1.30463e-18
C220	a_83_256##18	a_83_256##6	9.04519e-19
C221	VGND#7	a_83_256##10	1.02456e-19
C222	B1	a_83_256##6	3.80351e-18
C223	VPWR#1	VPWR#8	1.56868e-17
C224	a_961_392#	A1#3	1.08823e-19
C225	a_564_74##3	A2#1	9.97973e-19
C226	VPWR#10	a_83_256##9	2.68802e-18
C227	VPWR#11	a_83_256##4	8.90144e-19
C228	VGND#5	a_564_74##7	3.59623e-17
C229	VPWR#1	a_1234_392#	1.17626e-18
C230	B1#7	A3#8	4.31581e-17
C231	X#6	a_83_256##9	4.38669e-17
C232	a_961_392#	a_564_74##9	2.01131e-21
C233	VGND#4	B2#2	7.90769e-20
C234	X#5	a_83_256##4	5.41041e-20
C235	VGND#6	a_83_256##3	1.32842e-18
C236	X#1	VGND#13	5.23529e-17
C237	VPWR#1	a_961_392#	1.76452e-18
C238	VGND#4	A3#5	9.41709e-19
C239	a_564_74##2	A2#1	2.42293e-17
C240	VPWR#11	a_83_256##9	6.25023e-17
C241	VGND#10	A2#3	1.45807e-18
C242	X#6	a_83_256##13	4.31172e-19
C243	B2#1	B1#6	6.92822e-20
C244	X#5	a_83_256##9	1.36047e-18
C245	B2	A3#4	1.06218e-18
C246	a_564_74##3	A2#5	4.06893e-17
C247	B2	B2#4	4.17878e-18
C248	a_83_256##13	VPWR#11	2.53566e-17
C249	VPWR#6	VPWR#5	9.16231e-19
C250	B2	B2#2	2.32413e-17
C251	VPWR#7	a_83_256##9	2.56585e-19
C252	a_961_392#	A3#4	2.79636e-19
C253	X#5	a_83_256##13	5.69291e-17
C254	B1#1	B2#4	1.7665e-17
C255	a_564_74##2	A2#5	4.04506e-19
C256	a_83_256##14	a_83_256##10	6.027e-18
C257	VGND#4	B2#1	4.4289e-18
C258	a_83_256##22	A2#3	1.62638e-19
C259	VPWR#11	a_83_256##14	1.46384e-18
C260	VPWR#7	a_83_256##13	1.23062e-18
C261	B1#1	B2#2	1.49117e-17
C262	a_564_74##3	A3#1	3.55168e-17
C263	a_564_74##6	A3#5	2.04124e-19
C264	VGND#7	a_83_256##6	6.92227e-20
C265	A1#6	A2#6	4.49102e-17
C266	X#5	a_83_256##14	4.89918e-17
C267	a_961_392##4	A2#7	3.17003e-18
C268	VPWR#7	a_83_256##14	3.29048e-17
C269	X#4	a_83_256##11	9.82103e-18
C270	VGND#8	VGND#13	1.50129e-18
C271	a_83_256##18	B1#3	8.38158e-18
C272	A3	A3#4	1.36542e-17
C273	a_534_388#	VPWR#4	1.79567e-17
C274	A1#4	A1#6	3.90542e-17
C275	a_961_392##4	A1#2	1.90047e-19
C276	a_564_74##3	A3#5	7.88514e-19
C277	a_564_74##4	B1#7	1.8818e-17
C278	a_564_74##6	B2#1	8.98496e-19
C279	a_83_256##22	a_83_256##15	1.11035e-18
C280	a_1234_392##2	A1#2	3.60085e-19
C281	a_83_256##15	A3#4	1.09408e-18
C282	X#4	B1#3	1.16727e-19
C283	a_83_256##22	B1#7	1.07701e-17
C284	X#4	X#6	1.86739e-18
C285	a_534_388##2	VPWR#4	2.13798e-17
C286	X#4	a_83_256##10	1.33872e-17
C287	a_83_256##3	a_83_256##18	2.50295e-18
C288	A2#4	A1#4	2.5881e-17
C289	VGND#6	a_83_256##6	1.72149e-19
C290	a_564_74##3	B2#1	3.01872e-19
C291	X#4	a_83_256##3	2.04657e-17
C292	a_564_74##6	B2#6	2.85869e-17
C293	X#4	VPWR#11	3.01388e-17
C294	X#2	a_83_256##3	1.80266e-17
C295	A2#3	a_1234_392#	3.38135e-17
C296	A3#6	A2#4	4.66375e-17
C297	X#2	a_83_256##11	6.00467e-18
C298	A2#3	a_961_392#	2.33803e-18
C299	a_564_74##2	a_564_74#	2.61829e-18
C300	A2	A1#3	1.79646e-17
C301	a_564_74##6	B2#4	4.03285e-19
C302	X#4	X#5	2.00849e-19
C303	a_961_392##3	A3#4	1.49491e-19
C304	a_564_74##6	B1#1	2.05776e-17
C305	A3#7	A3#6	4.83751e-17
C306	X#4	a_83_256##6	4.33635e-18
C307	X#2	a_83_256##10	8.84544e-18
C308	a_564_74##7	B1#3	2.96758e-18
C309	VGND#6	a_83_256#	2.22634e-18
C310	a_564_74##2	VGND#9	4.27101e-17
C311	VGND#12	B1#3	1.04149e-18
C312	B1#7	a_1234_392#	1.88181e-17
C313	X#1	B1#3	1.03719e-18
C314	VGND#4	a_564_74##4	4.58744e-17
C315	B1#7	a_961_392#	7.91549e-17
C316	a_564_74##6	B2#2	2.36094e-18
C317	B1#6	A3#7	1.7128e-17
C318	X#4	VPWR#7	2.20291e-17
C319	A1#1	A2#7	1.7486e-17
C320	a_83_256##15	B1#7	2.02319e-16
C321	VGND#7	a_83_256##5	2.74182e-18
C322	a_564_74##6	B1#4	7.06197e-19
C323	a_961_392##4	a_1234_392##2	8.29091e-17
C324	B1#7	a_961_392##3	6.08351e-17
C325	a_83_256##22	a_83_256##16	4.0999e-18
C326	VGND#12	a_83_256##3	4.01309e-17
C327	a_564_74##2	A1#3	1.77262e-19
C328	VPWR#9	B1#7	1.49182e-19
C329	a_83_256##3	X#1	6.72325e-17
C330	A1	A1#3	5.64974e-19
C331	a_564_74##3	A3#4	1.54818e-18
C332	a_564_74##2	a_564_74##8	4.28276e-18
C333	B2#7	B1#6	4.95214e-17
C334	a_83_256##3	VGND#13	4.64017e-18
C335	a_564_74##3	VGND#10	4.2573e-17
C336	a_83_256##16	B1#7	4.46483e-18
C337	a_961_392##4	VPWR#8	3.35683e-17
C338	a_564_74##6	B1#2	7.92516e-21
C339	A2#1	A1#2	9.66807e-18
C340	X#2	a_83_256##6	1.75112e-18
C341	VGND#7	a_83_256##8	2.72738e-18
C342	VGND#5	B2#6	4.48392e-18
C343	B2#5	B2#7	4.29188e-17
C344	a_83_256##11	a_83_256##10	7.73171e-18
C345	VGND#5	B1#1	4.42745e-18
C346	B1	VPWR#5	6.58278e-19
C347	a_564_74##2	VGND#10	3.74602e-17
C348	a_83_256##18	A3#8	2.5959e-18
C349	a_1234_392##2	VPWR#8	1.32925e-18
C350	VGND#5	B1#4	4.41725e-18
C351	B1	VPWR#3	1.94738e-18
C352	a_83_256##4	B1#6	9.87285e-20
C353	a_564_74##3	a_564_74##9	7.10313e-18
C354	VPWR#1	A2#6	6.27903e-18
C355	VPWR#4	B2#4	4.02739e-20
C356	a_564_74#	A1#1	4.95763e-17
C357	A3#1	A2#3	2.35418e-18
C358	B1#5	B2#5	2.42919e-17
C359	a_83_256##16	B1#3	1.62139e-18
C360	VPWR#4	B2#2	2.46559e-20
C361	VPWR#1	A1#6	3.75337e-18
C362	a_564_74##6	a_564_74##4	2.5966e-18
C363	B1#3	a_534_388##2	9.60675e-19
C364	a_961_392#	a_961_392##4	1.16777e-18
C365	VPWR#4	B1#2	5.40258e-20
C366	A2#3	B2#1	6.43075e-19
C367	VPWR#1	A1#4	7.03688e-19
C368	A1#1	VGND#9	2.27678e-17
C369	X#6	B1#3	6.44874e-19
C370	a_83_256##4	B1#5	2.95527e-17
C371	a_564_74#	A1#5	1.90971e-18
C372	X	a_83_256##11	1.25618e-17
C373	a_564_74##3	VGND#11	4.26989e-17
C374	VPWR#9	B2#2	1.99405e-19
C375	a_83_256##3	VPWR#10	1.87042e-17
C376	A3#8	B2#1	3.70611e-18
C377	a_83_256##3	X#6	4.80043e-17
C378	a_564_74##6	a_83_256##22	5.36212e-17
C379	a_83_256##9	a_83_256##4	2.96497e-17
C380	A1#5	VGND#9	2.25417e-17
C381	VGND#6	a_564_74##7	1.09829e-17
C382	B2#1	B1#7	1.82079e-17
C383	VGND#10	A1#1	4.06251e-19
C384	a_564_74#	A2#1	3.96386e-19
C385	a_961_392#	VPWR#8	1.79784e-17
C386	VGND#7	VGND#12	2.89943e-19
C387	VGND#5	B2#4	1.4805e-20
C388	a_564_74##4	a_564_74##3	4.04977e-18
C389	A1#5	a_564_74##8	1.29513e-17
C390	a_83_256##18	B1	1.79524e-17
C391	a_83_256##13	a_83_256##9	3.74808e-17
C392	VGND#5	B2#2	1.99966e-19
C393	VGND#7	VGND#6	8.56343e-19
C394	a_534_388#	B2#4	2.26896e-19
C395	VGND#9	A2#1	6.99201e-19
C396	VGND#5	B1#2	1.86842e-19
C397	X#4	B1	1.85179e-18
C398	a_564_74##6	a_564_74##10	3.11766e-18
C399	a_961_392#	a_1234_392#	6.44735e-17
C400	VGND#10	A1#5	1.5138e-18
C401	VPWR#4	B2#7	5.22764e-18
C402	a_564_74#	A2#5	2.54985e-19
C403	a_83_256##14	a_83_256##13	4.60703e-17
C404	B2	A3#8	4.89324e-18
C405	VPWR	B1#2	6.22658e-19
C406	a_564_74##3	A3	1.94326e-17
C407	A1#3	A2#7	1.44225e-17
C408	A2#1	a_564_74##8	4.65312e-18
C409	VPWR#4	B2#5	5.25618e-18
C410	a_534_388#	B2#2	3.48286e-19
C411	A2#3	A1#4	3.49298e-18
C412	VGND#7	X#1	1.00899e-17
C413	a_83_256##18	B2	1.60027e-17
C414	A3#8	B1#1	7.96902e-19
C415	A2#3	A2#4	3.36571e-18
C416	VPWR#2	A1#6	1.16178e-18
C417	a_83_256#	B1#3	4.78391e-18
C418	B1#7	A2#6	7.97542e-19
C419	A3#6	A2#3	2.48827e-18
C420	VGND#10	A2#1	3.16855e-17
C421	a_564_74#	A3#1	2.92209e-19
C422	a_564_74##6	a_83_256##21	2.92026e-17
C423	B1#7	A1#6	4.45509e-19
C424	VGND#11	A3#4	1.15675e-18
C425	VGND#6	X#1	7.78973e-18
C426	a_83_256##3	a_83_256#	2.72669e-18
C427	B1#7	A1#4	1.99106e-18
C428	a_961_392#	a_83_256##15	7.00195e-19
C429	a_564_74##2	A2	1.18323e-17
C430	a_83_256##3	a_83_256##5	2.69356e-21
C431	B1#7	A2#4	1.17757e-17
C432	a_83_256##3	a_83_256##8	1.18127e-19
C433	a_83_256##22	B2	2.86141e-17
C434	B1#7	A3#6	2.83633e-17
C435	a_83_256##16	B2#4	1.16058e-17
C436	A2#5	VGND#10	1.85883e-17
C437	B1#7	A3#7	5.57691e-17
C438	VPWR#2	A1#4	4.27042e-18
C439	VGND	A3#4	1.37797e-19
C440	VGND#11	A2#1	2.86953e-19
C441	B1#7	B1#6	2.53405e-17
C442	a_83_256##18	B1#1	2.1394e-17
C443	VGND	B2#4	1.58904e-18
C444	a_564_74##7	a_564_74##6	2.86787e-18
C445	VGND	B2#2	3.78404e-18
C446	VGND	B1#2	2.08453e-20
C447	VGND	a_83_256##10	5.16176e-19
C448	B1#7	B2#7	3.06304e-19
C449	A3	VGND#11	1.01168e-18
C450	A2#5	a_564_74##9	1.35659e-17
C451	VGND	a_83_256##6	8.56339e-19
C452	a_83_256##16	B2#2	6.97977e-18
C453	a_83_256##15	B1	2.06219e-17
C454	a_564_74##2	A1	5.1776e-17
C455	B1	VPWR#9	4.91628e-17
C456	a_83_256##10	a_83_256##6	1.61942e-17
C457	VGND#10	A3#1	7.39814e-19
C458	B1	a_534_388#	6.07002e-17
C459	A1#3	A2#6	8.57646e-19
C460	a_83_256##15	a_961_392##3	3.63937e-18
C461	a_564_74#	A2	2.6565e-17
C462	B1	a_83_256##16	1.26935e-16
C463	VPWR#1	A2#7	4.92247e-20
C464	VGND#11	A2#5	7.97297e-19
C465	B1	a_534_388##2	7.40361e-17
C466	VPWR#10	B1	3.67838e-17
C467	a_83_256##18	B1#4	3.35255e-18
C468	VPWR#2	A2#4	5.3919e-18
C469	X#6	B1	2.92716e-18
C470	a_564_74##4	A3#4	1.61907e-18
C471	a_83_256##22	A2#1	1.12656e-19
C472	A3#1	a_564_74##9	1.35659e-17
C473	B1#3	B2#5	9.51115e-18
C474	a_83_256##15	VPWR#9	1.5518e-18
C475	a_83_256##16	B2	3.19524e-17
C476	VGND#10	A3#5	2.7892e-19
C477	VGND#3	A1#4	6.06285e-20
C478	a_83_256##4	B1#3	7.61461e-18
C479	A3#1	VGND#11	2.0762e-17
C480	VPWR#3	A3#6	3.02627e-18
C481	VGND#8	VGND#7	1.29588e-18
C482	a_83_256##18	a_83_256#	8.63463e-19
C483	a_83_256##22	A2#5	9.75077e-20
C484	VPWR	VPWR#6	7.00023e-17
C485	A2	a_961_392##4	3.66532e-17
C486	A1#2	A2#7	7.85762e-18
C487	VPWR	VPWR#5	6.80873e-17
C488	VPWR#9	a_961_392##3	1.96711e-17
C489	A2	a_1234_392##2	6.5372e-17
C490	VPWR	VPWR#3	1.13248e-16
C491	VPWR	VPWR#2	5.82225e-17
C492	VGND#4	VGND#3	9.94511e-19
C493	B1	B2#1	4.99521e-20
C494	VPWR#2	A3#6	2.2964e-18
C495	a_961_392##4	VPWR#2	4.20955e-19
C496	A2	a_1234_392#	3.29351e-17
C497	a_564_74##4	A3#1	1.1431e-18
C498	A2#3	A2#7	4.53951e-19
C499	A2#3	A1#3	1.3137e-18
C500	X	X#4	7.55345e-18
C501	A2#3	A1#2	9.8955e-18
C502	A3#5	VGND#11	2.1905e-17
C503	B1#7	A2#7	2.39918e-19
C504	A3#4	A2#3	3.61787e-17
C505	a_83_256##22	A3#1	3.93583e-19
C506	VPWR#4	B1#3	2.49858e-20
C507	a_83_256##18	a_83_256##5	3.62306e-19
C508	a_534_388##2	B1#2	1.91434e-19
C509	VPWR#3	A3#7	5.35378e-18
C510	a_564_74##4	A3#5	3.07844e-17
C511	a_83_256##22	A3#4	1.19917e-18
C512	B1#7	A2#3	2.69888e-17
C513	A2	A1#1	4.08876e-18
C514	VPWR	X#4	3.11251e-18
C515	VGND	VGND#7	7.02587e-17
C516	VGND	VGND#6	6.2039e-17
C517	VGND#11	B2#1	8.09881e-19
C518	a_534_388#	VPWR#9	2.57632e-17
C519	VGND	VGND#4	8.79822e-17
C520	VGND#8	X	4.08599e-17
C521	A2	A2#1	4.4468e-18
C522	VGND	VGND#3	4.71309e-17
C523	VGND	a_564_74##6	2.88894e-17
C524	a_564_74##2	A1#4	2.3576e-18
C525	a_83_256##22	A3#5	1.40257e-18
C526	VGND	a_564_74##3	2.07368e-17
C527	VGND	a_564_74##2	2.25913e-18
C528	VPWR#5	B1#6	3.38928e-19
C529	B1	B1#6	1.18722e-17
C530	X#2	a_83_256#	2.078e-19
C531	B1	B2#7	1.31362e-17
C532	A1#3	VNB	1.99847e-17
C533	a_564_74##4	B2#1	3.6937e-17
C534	A3#4	VNB	6.37115e-17
C535	A1	A2#1	6.00214e-18
C536	B2#4	VNB	3.0251e-17
C537	B2#2	VNB	4.20342e-17
C538	VGND	A3#8	2.86556e-18
C539	B1	B2#5	2.22451e-17
C540	B1#2	VNB	1.98686e-17
C541	a_83_256##11	VNB	2.78567e-17
C542	a_83_256##10	VNB	2.82631e-17
C543	a_83_256##16	VPWR#9	2.8046e-18
C544	a_83_256##6	VNB	7.07647e-17
C545	B1	B1#5	1.40202e-17
C546	VPWR#3	B1#6	2.11376e-17
C547	VGND	a_83_256##18	4.58878e-18
C548	B2	B1#6	7.03428e-18
C549	B1	a_83_256##4	1.07698e-18
C550	VGND#11	B2#6	2.05041e-19
C551	VGND	X#4	5.07842e-18
C552	VGND	X#2	1.98609e-17
C553	B1	a_83_256##9	1.46875e-19
C554	VPWR	a_1234_392#	2.52226e-18
C555	X	VPWR#7	2.68556e-17
C556	X#2	X#4	4.04612e-17
C557	VGND#4	a_564_74##6	8.12686e-18
C558	VPWR	a_961_392#	3.39945e-17
C559	a_83_256##22	B2#1	3.53971e-17
C560	VGND	VGND#10	1.57157e-17
C561	VPWR	a_83_256##15	5.55449e-18
C562	VPWR#2	B1#6	2.16942e-19
C563	VPWR	a_961_392##3	1.94162e-17
C564	VGND	VGND#11	1.59014e-17
C565	a_83_256##3	B1#3	2.13756e-17
C566	VGND	a_564_74##4	2.57873e-17
C567	VPWR	VPWR#9	1.57943e-17
C568	VGND	a_83_256##22	9.95859e-18
C569	A2	A1#4	9.35698e-18
C570	VPWR	a_534_388#	1.92095e-17
C571	VPWR	a_83_256##16	8.56553e-18
C572	VGND	a_83_256##21	8.97785e-18
C573	a_961_392##4	A1#1	1.21481e-19
C574	VPWR	a_534_388##2	2.0989e-17
C575	VGND	a_564_74##7	2.39731e-17
C576	a_534_388#	a_83_256##16	1.80352e-18
C577	a_564_74##4	B2#6	4.24687e-19
C578	VGND	VGND#12	2.22233e-17
C579	VPWR	VPWR#10	2.03454e-17
C580	X#2	a_83_256##5	1.03998e-18
C581	VGND	X#1	1.82582e-17
C582	A3#8	VGND#11	3.08246e-18
C583	VPWR	X#6	1.87127e-17
C584	VGND	VGND#13	1.83403e-17
C585	VPWR	VPWR#11	2.13726e-17
C586	VPWR	X#5	1.70044e-17
C587	VGND	VGND#8	7.29766e-17
C588	VPWR	VPWR#7	5.71631e-17
C589	A1	A1#4	9.41623e-19
C590	VGND#11	B1#1	6.37535e-20
C591	a_83_256##22	B2#6	2.16887e-17
C592	a_1234_392##2	A1#1	2.27348e-19
C593	VGND	X#6	3.23072e-18
C594	a_83_256##21	B2#1	2.9919e-19
C595	VPWR#6	VNB	3.6791e-17
C596	VGND	VPWR#7	2.21711e-18
C597	VPWR#5	VNB	3.41432e-17
C598	VPWR#3	VNB	5.4088e-17
C599	a_83_256##22	B2#2	1.07908e-17
C600	VPWR#2	VNB	5.09175e-17
C601	VGND#7	VNB	3.71907e-17
C602	VPWR#1	A2	5.87921e-18
C603	B1	B1#7	7.67906e-18
C604	VGND#6	VNB	3.41772e-17
C605	VGND#4	VNB	4.92092e-17
C606	VGND	A2#1	5.84781e-19
C607	VGND#3	VNB	2.98229e-17
C608	X#2	a_83_256##8	4.19141e-17
C609	VGND	A2#5	7.2806e-20
C610	a_564_74##6	VNB	5.40088e-18
C611	a_564_74##3	VNB	2.15849e-18
C612	a_564_74##4	A3#8	2.16323e-17
C613	B2#6	a_564_74##10	1.42892e-17
C614	a_564_74##2	VNB	2.08609e-18
C615	VGND	A3#5	3.34798e-19
C616	VGND	B2#1	2.06962e-18
C617	B2	B1#7	2.82636e-17
C618	B1	B1#3	2.35192e-17
C619	VGND	B2#6	1.49254e-18
C620	A3	A2#3	2.46716e-17
C621	VPWR	A2#4	3.49208e-19
C622	VGND	B1#1	1.71984e-18
C623	VGND#11	B1#4	3.58252e-20
C624	VGND	B1#4	1.95518e-18
C625	VPWR	A3#6	6.26639e-19
C626	A2	A2#7	2.64345e-17
C627	A3#8	VNB	2.81447e-18
C628	a_83_256##3	B1	4.22301e-17
C629	VPWR	A3#7	1.16137e-18
C630	a_83_256##18	VNB	7.37642e-18
C631	VGND	a_83_256##5	1.3404e-19
C632	A2	A1#2	1.25513e-17
C633	a_534_388##2	a_83_256##16	1.29562e-19
C634	VPWR	B1#6	9.15219e-18
C635	B2	B1#3	3.38486e-19
C636	A3	B1#7	2.25046e-17
C637	VGND	a_83_256##8	1.12179e-18
C638	X#4	VNB	4.41162e-18
C639	X	a_83_256##14	3.52855e-18
C640	VPWR	B2#7	1.16027e-17
C641	a_83_256##22	B1#1	6.55767e-19
C642	X#2	VNB	6.44578e-18
C643	A2#3	A2	3.95446e-18
C644	a_564_74#	VNB	3.78047e-17
C645	VGND#9	VNB	3.324e-18
C646	VPWR	B2#5	1.39082e-17
C647	a_961_392#	VPWR#3	1.10987e-17
C648	VGND#10	VNB	8.23098e-19
C649	VPWR	B1#5	1.11374e-17
C650	VGND#11	VNB	3.92145e-18
C651	a_564_74##4	VNB	3.7899e-18
C652	VPWR	a_83_256##4	2.96043e-18
C653	a_83_256##22	VNB	7.01917e-19
C654	A1	A1#2	2.53348e-17
C655	VPWR	a_83_256##9	6.05129e-19
C656	a_83_256##21	B2#6	1.12653e-18
C657	a_564_74##7	VNB	1.10013e-17
C658	A2#3	A1	1.58804e-17
C659	VGND#12	VNB	7.29244e-18
C660	VPWR	a_83_256##13	1.67187e-19
C661	X#1	VNB	2.66822e-18
C662	VGND#13	VNB	3.50728e-18
C663	VPWR	a_83_256##14	3.01494e-18
C664	VGND#8	VNB	6.47079e-17
C665	a_961_392##4	VNB	5.04027e-17
C666	a_1234_392##2	VNB	1.77519e-18
C667	VPWR#8	VNB	6.65361e-19
C668	a_961_392#	VNB	4.17042e-18
C669	VGND#12	B2#1	4.73752e-20
C670	a_961_392##3	VNB	3.30172e-18
C671	VPWR#9	VNB	3.69639e-18
C672	VPWR	VPWR#4	5.62645e-17
C673	a_534_388#	VNB	3.53365e-18
C674	B1#1	a_564_74##10	7.06145e-18
C675	X#2	a_83_256##12	3.51542e-17
C676	a_534_388##2	VNB	4.03985e-18
C677	VGND#4	a_564_74##3	8.90493e-18
C678	VPWR#10	VNB	2.98907e-18
C679	X#6	VNB	6.4127e-18
C680	VPWR#11	VNB	8.75872e-19
C681	X#5	VNB	2.1722e-18
C682	B1#7	A3#4	4.29368e-17
C683	VPWR#7	VNB	8.26131e-17
C684	A1#1	VNB	4.98457e-17
C685	A1#5	VNB	2.37959e-17
C686	VPWR	A2#3	3.72849e-18
C687	A2#1	VNB	3.5115e-17
C688	a_564_74##7	B2#6	2.17549e-19
C689	A2#5	VNB	2.24554e-17
C690	A3#1	VNB	2.51491e-17
C691	a_961_392#	VPWR#2	3.13103e-17
C692	A3#5	VNB	2.34274e-17
C693	X	a_83_256##3	6.73907e-19
C694	B2#1	VNB	3.77006e-17
C695	VPWR	B1#7	1.73502e-17
C696	B2#6	VNB	2.51637e-17
C697	VGND	VGND#5	7.46432e-17
C698	B1#1	VNB	3.33206e-17
C699	B1#4	VNB	2.82844e-17
C700	a_83_256#	VNB	2.61774e-17
C701	a_83_256##5	VNB	2.72575e-17
C702	a_83_256##8	VNB	2.72641e-17
C703	a_83_256##12	VNB	3.6062e-17
C704	VGND	A2#3	4.37019e-18
C705	VPWR	a_83_256##3	8.50858e-18
C706	A2#6	VNB	3.53364e-17
C707	A1#6	VNB	2.61437e-17
C708	A1#4	VNB	3.8418e-17
C709	VGND	B1#7	1.02977e-17
C710	a_83_256##21	B1#1	2.54277e-17
C711	A2#4	VNB	3.89679e-17
C712	A3#6	VNB	3.77305e-17
C713	B2#4	B1#7	2.77399e-18
C714	A3#7	VNB	4.0571e-17
C715	B1#6	VNB	1.01995e-16
C716	VGND	B1#3	1.27187e-18
C717	B2#7	VNB	3.08224e-17
C718	B2#5	VNB	4.68427e-17
C719	VGND	a_83_256##3	1.1018e-17
C720	B1#5	VNB	3.94032e-17
C721	a_83_256##4	VNB	3.83369e-17
C722	a_83_256##9	VNB	3.06824e-17
C723	VPWR#5	B1#5	1.14233e-17
C724	a_83_256##13	VNB	2.9661e-17
C725	a_83_256##14	VNB	4.87628e-17
C726	VGND#12	B2#6	7.02863e-20
C727	VPWR#10	a_534_388##2	2.53259e-17
C728	B2#2	B1#7	1.69073e-17
C729	VPWR#1	VNB	1.34377e-16
C730	A1	A2	4.42805e-17
C731	VPWR	B1	2.2273e-17
C732	VPWR#10	a_83_256##6	4.65259e-18
C733	VPWR#4	VNB	3.02637e-17
C734	VGND#5	VNB	4.40128e-17
C735	A2#7	VNB	5.16473e-17
C736	VPWR	B2	3.5979e-18
C737	A1#2	VNB	4.24522e-17
C738	A2#3	VNB	5.01055e-17
C739	VGND	B1	2.43475e-18
C740	B1#7	VNB	7.71196e-17
C741	VGND	B2	2.85397e-18
C742	VPWR	A2	1.23423e-18
C743	B1#3	VNB	4.73573e-17
C744	B2#2	a_564_74##10	6.84216e-19
C745	a_83_256##3	VNB	6.10781e-18
C746	VGND	A3	2.01555e-18
C747	VGND	A2	1.20211e-18
C748	a_564_74##7	B1#1	1.23372e-18
C749	VPWR	X	2.12276e-18
C750	VGND	X	2.21844e-18
C751	B1	VNB	4.05069e-18
C752	B2	VNB	3.24631e-18
C753	VGND#3	a_564_74##3	8.73576e-18
C754	A3	VNB	1.77388e-18
C755	A2	VNB	2.87059e-17
C756	A1	VNB	1.09946e-17
C757	X	VNB	3.14513e-17
C758	VPWR	VNB	3.13491e-16
C759	VGND	VNB	2.99914e-16
C760	a_1234_392#	A2#1	3.83216e-19
C761	B1#4	a_83_256##21	1.05606e-17
C762	VGND#2	a_564_74#	4.06791e-17
C763	VGND#2	A1	3.38153e-18
C764	VGND#2	A1#1	6.11367e-18
C765	VGND#2	A2	7.51464e-18
C766	VGND#2	A1#3	2.42514e-20
C767	VGND#2	VNB	1.51692e-16
C768	VGND#2	VGND#3	1.11927e-17
C769	VGND#10	VGND#2	6.20399e-20
C770	VGND#2	a_564_74##2	2.34424e-17
C771	VGND#2	A2#1	4.94187e-19
C772	VGND#2	A2#7	7.34411e-19
C773	VGND#2	A1#5	4.90133e-18
*
*
.ENDS sky130_fd_sc_hs__o32a_4
*
