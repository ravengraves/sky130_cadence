* Extracted by Quantus, converted by sky130cad/quantus.py
*
*
*
*                       LINUX           Wed Nov 18 08:17:11 2026
*
*
*
*  PROGRAM  advgen
*
*  Name           : advgen - Quantus - (64-bit)
*  Version        : 25.1.0-p047
*  Build Date     : Thu Dec 11 23:20:30 PST 2025
*
*  HSPICE LIBRARY
*
*  OPERATING_TEMPERATURE 150
*  QRC_TECH_DIR <path>/tech
*
*
*

*
.SUBCKT sky130_fd_sc_hs__and3_1 VPB VNB VGND VPWR X A B C
*
*
*  caps2d version: 10
*
*
*       TRANSISTOR CARDS
*
*
XM6 a_27_398##9 A#2 a_121_136# VNB sky130_fd_pr__nfet_01v8_lvt l=0.15 w=0.64 ad=0.1824 as=0.2624 pd=1.85 ps=2.1
XM2 a_121_136# B#1 a_233_136# VNB sky130_fd_pr__nfet_01v8_lvt l=0.15 w=0.64 ad=0.2624 as=0.222 pd=2.1 ps=2.09
XM7 a_233_136# C#1 VGND#4 VNB sky130_fd_pr__nfet_01v8_lvt l=0.15 w=0.64 ad=0.222 as=0.3107 pd=2.09 ps=2.34
XM3 VGND#4 a_27_398##3 X#3 VNB sky130_fd_pr__nfet_01v8_lvt l=0.15 w=0.74 ad=0.3107 as=0.2109 pd=2.34 ps=2.05
XM0 a_27_398##7 A#1 VPWR#8 VPB sky130_fd_pr__pfet_01v8 l=0.15 w=0.84 ad=0.2478 as=0.336 pd=2.27 ps=2.48
XM1 VPWR#8 B#3 a_27_398##8 VPB sky130_fd_pr__pfet_01v8 l=0.15 w=0.84 ad=0.336 as=0.252 pd=2.48 ps=2.28
XM5 a_27_398##8 C#3 VPWR#6 VPB sky130_fd_pr__pfet_01v8 l=0.15 w=0.84 ad=0.252 as=0.72645 pd=2.28 ps=3.68
XM4 VPWR#6 a_27_398# X#1 VPB sky130_fd_pr__pfet_01v8 l=0.15 w=1.12 ad=0.72645 as=0.3304 pd=3.68 ps=2.83
*
*
*       RESISTOR AND CAP/DIODE CARDS
*
Rg1	A#1	A#2	737.873657
Rg2	A#2	A#3	261.256744
Rg3	B#1	B#2	279.244598
Rg4	B#2	B#3	385.389252
Rg5	C#1	C#2	330.020691
Rg6	C#2	C#3	369.896088
Rg7	a_27_398#	a_27_398##2	451.603058
Rg8	a_27_398##2	a_27_398##3	334.791077
Rf1	A#3	A	110.716927
Rf2	B#4	B	2.103310
Rf3	B#2	B#6	162.336121
Rf4	B#4	B#6	8.415057
Rf5	B#7	B	2.103310
Rf6	B#6	B#7	1.963513
Rf7	C#2	C	162.201172
Rf8	a_27_398##2	a_27_398##5	253.466064
Rf9	a_27_398##5	a_27_398##6	61.174358
Rf10	a_27_398##6	a_27_398##7	22.179371
Rf11	a_27_398##5	a_27_398##8	20.641609
Rf12	a_27_398##6	a_27_398##9	53.344700
Rf13	X#2	X	0.452333
Rf14	X	X#3	95.493408
Rf15	X#2	X	16.283972
Rf16	X#1	X#2	5.000000
Rf18	VPWR#2	VPWR#3	36.615833
Rf19	VPWR#3	VPWR#4	48.188797
Rf21	VPWR#2	VPWR#7	12.641079
Rf22	VPWR#7	VPWR#6	10.567735
Rf23	VPWR#4	VPWR#8	46.120842
Rf24	VPWR#6	VPWR#7	7.500000
Rf26	VGND#2	VGND#3	30.656675
Rf27	VGND#2	VGND#4	37.833496
Re1	VPWR#3	VPWR	1.637070
Re2	VGND	VGND#3	1.637131
*
*       CAPACITOR CARDS
*
*
C1	a_27_398##6	B#7	7.88167e-18
C2	B#7	a_27_398##5	5.19217e-17
C3	a_27_398##6	B#6	4.78804e-18
C4	VGND#4	a_27_398##5	1.5544e-18
C5	a_27_398##5	X#1	2.27278e-19
C6	a_27_398##5	VPWR#6	2.6318e-17
C7	a_27_398##5	a_27_398##8	6.72249e-19
C8	a_27_398##6	VPWR#8	1.94416e-17
C9	VGND#4	X#3	6.17043e-17
C10	a_27_398##9	B#6	3.67266e-18
C11	a_27_398##5	VPWR#8	1.40069e-17
C12	a_27_398##6	a_27_398##7	1.01671e-18
C13	a_27_398##7	a_27_398##5	5.48268e-19
C14	a_27_398##9	VGND#4	8.14244e-18
C15	X#3	X#1	2.77099e-18
C16	a_27_398##6	A#2	4.61324e-18
C17	a_27_398##6	a_27_398#	1.27298e-19
C18	B#7	A#2	2.78825e-19
C19	X#3	a_27_398##3	3.33241e-17
C20	a_27_398##5	a_27_398#	1.29811e-19
C21	VPWR#6	X#1	3.37952e-17
C22	a_27_398##3	VGND#4	2.77999e-17
C23	B#6	A#2	2.35139e-18
C24	X#3	C#1	2.45986e-18
C25	a_27_398##8	X#1	1.20741e-18
C26	a_27_398##5	C#3	1.59986e-17
C27	C#1	VGND#4	2.86531e-17
C28	a_27_398##6	B#3	7.45908e-20
C29	a_27_398##8	VPWR#6	5.29398e-17
C30	X#3	B#1	9.96094e-20
C31	a_27_398##5	B#3	1.68428e-17
C32	VGND#4	B#1	3.24395e-18
C33	VPWR#8	VPWR#6	2.42969e-18
C34	a_27_398##9	a_27_398##3	1.51595e-18
C35	a_27_398##6	A#1	2.855e-17
C36	VPWR#8	a_27_398##8	5.07397e-17
C37	VGND#4	A#2	1.52223e-18
C38	a_27_398##5	A#1	1.89314e-19
C39	a_27_398##9	C#1	1.05997e-18
C40	a_27_398##7	a_27_398##8	2.16757e-18
C41	a_27_398##9	B#1	6.10674e-18
C42	a_27_398##7	VPWR#8	5.11773e-17
C43	B#7	A#1	1.20824e-18
C44	a_27_398##9	A#2	3.55494e-17
C45	a_27_398##5	VPWR#3	4.00218e-19
C46	a_27_398##6	a_27_398##2	9.77039e-19
C47	a_27_398#	X#1	2.24596e-17
C48	C#1	a_27_398##3	2.07358e-17
C49	VPWR#6	a_27_398#	5.66056e-17
C50	X#1	C#3	1.36453e-18
C51	a_27_398##6	C#2	4.69879e-19
C52	a_27_398##8	a_27_398#	6.89618e-19
C53	VPWR#6	C#3	5.32061e-17
C54	B#1	C#1	3.0949e-17
C55	a_27_398##5	C#2	3.58762e-18
C56	X#1	B#3	2.02185e-19
C57	C#3	a_27_398##8	1.49543e-17
C58	VPWR#6	B#3	2.34839e-18
C59	a_27_398##6	B#2	2.56024e-18
C60	B#6	a_27_398##2	9.66074e-20
C61	VPWR#8	C#3	6.49274e-19
C62	a_27_398##5	B#2	2.08639e-18
C63	B#7	C#2	1.88663e-18
C64	a_27_398##8	B#3	3.61242e-17
C65	A#2	B#1	2.08018e-17
C66	VPWR#6	A#1	6.16684e-19
C67	B#3	VPWR#8	2.33546e-17
C68	A#3	a_27_398##6	4.47964e-18
C69	B#6	C#2	3.72939e-18
C70	a_27_398##8	A#1	7.48451e-19
C71	a_27_398##2	X#3	5.93822e-17
C72	B#7	B#2	9.30764e-18
C73	a_27_398##7	B#3	8.69725e-19
C74	A#3	a_27_398##5	5.72227e-19
C75	A#1	VPWR#8	2.9002e-17
C76	VGND#4	a_27_398##2	6.91588e-18
C77	B#6	B#2	7.22516e-18
C78	a_27_398##7	A#1	3.26049e-17
C79	X#3	C#2	2.68834e-20
C80	VGND#4	C#2	4.31884e-18
C81	a_27_398##8	VPWR#3	8.68808e-18
C82	a_27_398##2	X#1	3.92532e-17
C83	a_27_398##2	VPWR#6	3.98415e-17
C84	C#3	a_27_398#	8.65306e-18
C85	X#1	C#2	3.05811e-19
C86	VGND#4	A#3	1.07516e-18
C87	VPWR#6	C#2	1.35264e-18
C88	a_27_398##9	B#2	1.45074e-18
C89	B#3	C#3	3.75584e-17
C90	VGND#3	C#1	3.61675e-18
C91	A#3	a_27_398##9	4.83512e-17
C92	VGND#3	B#1	9.51807e-19
C93	C#1	a_27_398##2	1.65278e-18
C94	VPWR#8	B#2	6.63214e-19
C95	A#1	B#3	2.52016e-17
C96	a_27_398##2	B#1	2.40151e-19
C97	VPWR#3	C#3	1.76831e-18
C98	VPWR#8	A#3	3.54281e-19
C99	B#1	C#2	1.0617e-18
C100	C	a_27_398##5	3.58827e-17
C101	a_27_398##2	a_27_398#	7.86612e-18
C102	A#3	a_27_398##3	5.50665e-19
C103	B#7	C	1.29126e-17
C104	A#3	C#1	1.44344e-18
C105	A#2	B#2	1.788e-17
C106	C#2	a_27_398#	2.2488e-18
C107	B#6	C	1.55991e-17
C108	A#3	B#1	9.23932e-18
C109	a_27_398##2	B#3	1.2931e-20
C110	a_27_398##2	A#1	7.29873e-20
C111	B#3	C#2	5.14035e-19
C112	C	VGND#4	1.78992e-17
C113	C#1	a_233_136#	1.41975e-17
C114	B#1	a_233_136#	1.3259e-17
C115	A#1	B#2	1.17124e-17
C116	B	X#3	2.35958e-18
C117	C	VPWR#6	2.76631e-18
C118	B#1	a_121_136#	1.90675e-17
C119	VGND#3	C#2	2.76728e-19
C120	A#2	a_121_136#	1.57852e-17
C121	a_27_398##9	B	1.32239e-17
C122	C#2	a_27_398##2	2.62057e-17
C123	VGND#3	B#2	3.28285e-20
C124	A	VGND#4	2.30371e-17
C125	a_27_398##2	B#2	1.73645e-19
C126	VGND#3	A#3	7.39443e-17
C127	VPWR	a_27_398##6	2.04119e-18
C128	B#2	C#2	3.07886e-17
C129	VPWR	a_27_398##5	3.53148e-18
C130	B	a_27_398##3	1.08298e-18
C131	B	C#1	3.588e-18
C132	VPWR	B#7	3.5415e-18
C133	B	B#1	8.93066e-18
C134	C	a_27_398#	5.13956e-19
C135	A#3	B#2	1.34667e-18
C136	B	A#2	4.69918e-18
C137	X	X#1	4.68977e-18
C138	A	a_27_398##3	2.66417e-18
C139	VPWR#6	X	3.04574e-17
C140	A	C#1	5.38771e-18
C141	A	B#1	1.79449e-17
C142	A	A#2	1.21899e-18
C143	B#2	a_121_136#	8.63061e-19
C144	VGND#3	C	8.33371e-19
C145	VPWR	a_27_398##8	1.29033e-17
C146	VGND	X#3	1.90657e-17
C147	C	a_27_398##2	2.65994e-17
C148	VPWR	a_27_398##7	1.57024e-17
C149	a_27_398##6	VNB	2.86413e-17
C150	X	a_27_398#	9.69672e-18
C151	C	C#2	1.71516e-17
C152	a_27_398##5	VNB	9.25248e-18
C153	VGND	a_27_398##9	8.57199e-18
C154	VGND	X#1	1.1388e-18
C155	B	a_27_398##2	5.0933e-18
C156	C	B#2	2.42337e-18
C157	B	C#2	5.4267e-19
C158	VGND#3	A	3.17305e-17
C159	VPWR	a_27_398#	5.03626e-18
C160	B	B#2	3.97534e-18
C161	X#3	VNB	5.61924e-17
C162	VGND	a_27_398##3	7.40902e-18
C163	VPWR	C#3	3.80211e-18
C164	VGND#4	VNB	9.26399e-18
C165	VGND	C#1	7.04257e-18
C166	A#3	B	2.78388e-18
C167	VPWR	B#3	6.98683e-18
C168	a_27_398##9	VNB	3.45813e-17
C169	VPWR	A#1	7.39777e-18
C170	A	B#2	3.68122e-19
C171	X#1	VNB	4.23164e-17
C172	VPWR#6	VNB	2.49386e-18
C173	a_27_398##8	VNB	3.02106e-18
C174	B	a_233_136#	9.19657e-19
C175	VPWR	VPWR#3	9.25068e-18
C176	VPWR#8	VNB	2.8618e-18
C177	a_27_398##7	VNB	3.16812e-17
C178	B	a_121_136#	2.01591e-18
C179	a_27_398##3	VNB	3.64598e-17
C180	VPWR	a_27_398##2	4.58149e-18
C181	C#1	VNB	3.36196e-17
C182	A	a_233_136#	1.01024e-18
C183	B#1	VNB	2.43512e-17
C184	A#2	VNB	3.57417e-17
C185	a_27_398#	VNB	4.24993e-17
C186	VGND	VGND#3	4.01832e-17
C187	C#3	VNB	3.04077e-17
C188	VGND	a_27_398##2	4.91767e-18
C189	B#3	VNB	3.33012e-17
C190	VGND	C#2	7.32685e-19
C191	A#1	VNB	5.72701e-17
C192	VPWR#3	VNB	1.49228e-16
C193	VGND	A#3	3.44431e-17
C194	A	B	1.05684e-17
C195	VGND#3	VNB	1.96022e-16
C196	a_27_398##2	VNB	3.89923e-17
C197	C#2	VNB	4.00752e-17
C198	B#2	VNB	2.84533e-17
C199	VPWR	C	2.06437e-18
C200	A#3	VNB	1.14931e-16
C201	VGND	C	4.02622e-18
C202	VGND	B	5.49091e-18
C203	VPWR	X	1.57534e-17
C204	VGND	A	1.53657e-17
C205	C	VNB	5.23708e-19
C206	A	VNB	1.0071e-17
C207	X	VNB	1.8852e-17
C208	VPWR	VNB	5.89223e-17
C209	VGND	VNB	7.03553e-17
C210	VPWR	VPWR#2	8.41534e-17
C211	VGND#2	X#3	1.60441e-17
C212	VGND	VGND#2	5.75202e-17
C213	VPWR#4	A#1	5.94505e-18
C214	VPWR	VPWR#4	5.50898e-17
C215	VGND#2	A#3	1.13917e-18
C216	VPWR#2	VNB	5.67871e-17
C217	VPWR#3	VPWR#4	4.97605e-17
C218	VGND#3	VGND#2	5.48705e-17
C219	VPWR#4	VPWR#6	2.17932e-18
C220	VPWR#4	VNB	5.42191e-17
C221	a_27_398##5	VPWR#4	1.71101e-19
C222	VPWR#4	a_27_398#	3.33681e-19
C223	VGND#2	C#1	2.96759e-19
C224	X	VPWR#2	1.93497e-17
C225	VPWR#4	VPWR#2	2.28461e-18
C226	VPWR#4	B#3	4.56832e-18
C227	VGND#2	VNB	5.32875e-17
C228	A	VGND#2	2.66521e-18
C229	VGND#2	C	5.87159e-20
C230	VPWR#3	VPWR#2	5.81802e-17
C231	VGND#2	a_27_398##2	9.91605e-19
C232	VPWR#2	a_27_398#	1.03143e-17
C233	a_27_398##6	VPWR#4	3.37169e-19
C234	a_27_398##8	VPWR#4	1.10843e-18
C235	a_27_398##2	VPWR#2	2.83589e-19
C236	VGND#2	a_27_398##3	6.06393e-18
C237	VPWR#4	C#3	7.98804e-19
C238	a_27_398##7	VPWR#4	1.34382e-17
*
*
.ENDS sky130_fd_sc_hs__and3_1
*
