* Extracted by Quantus, converted by sky130cad/quantus.py
*
*
*
*                       LINUX           Wed Nov 18 08:48:25 2026
*
*
*
*  PROGRAM  advgen
*
*  Name           : advgen - Quantus - (64-bit)
*  Version        : 25.1.0-p047
*  Build Date     : Thu Dec 11 23:20:30 PST 2025
*
*  HSPICE LIBRARY
*
*  OPERATING_TEMPERATURE 150
*  QRC_TECH_DIR <path>/tech
*
*
*

*
.SUBCKT sky130_fd_sc_hs__nand4bb_2 VPB VNB VGND VPWR Y B_N A_N C D
*
*
*  caps2d version: 10
*
*
*       TRANSISTOR CARDS
*
*
XM12 a_27_368##11 A_N#1 VGND#7 VNB sky130_fd_pr__nfet_01v8_lvt l=0.15 w=0.64 ad=0.1824 as=0.2688 pd=1.85 ps=2.12
XM9 VGND#7 B_N#3 a_231_74##10 VNB sky130_fd_pr__nfet_01v8_lvt l=0.15 w=0.64 ad=0.2688 as=0.1824 pd=2.12 ps=1.85
XM4 Y#4 a_27_368##6 a_373_74##4 VNB sky130_fd_pr__nfet_01v8_lvt l=0.15 w=0.74 ad=0.2257 as=0.2442 pd=2.09 ps=2.14
XM6 a_373_74##2 a_27_368##5 Y#4 VNB sky130_fd_pr__nfet_01v8_lvt l=0.15 w=0.74 ad=0.3546 as=0.2257 pd=2.56 ps=2.09
XM5 a_678_74##2 a_231_74##7 a_373_74##2 VNB sky130_fd_pr__nfet_01v8_lvt l=0.15 w=0.74 ad=0.2072 as=0.3546 pd=2.04 ps=2.56
XM16 a_373_74# a_231_74# a_678_74##2 VNB sky130_fd_pr__nfet_01v8_lvt l=0.15 w=0.74 ad=0.2516 as=0.2072 pd=2.16 ps=2.04
XM2 a_678_74# C#6 a_886_74##3 VNB sky130_fd_pr__nfet_01v8_lvt l=0.15 w=0.74 ad=0.259 as=0.2109 pd=2.18 ps=2.05
XM15 a_886_74##4 C#1 a_678_74# VNB sky130_fd_pr__nfet_01v8_lvt l=0.15 w=0.74 ad=0.2072 as=0.259 pd=2.04 ps=2.18
XM14 VGND#6 D#7 a_886_74##4 VNB sky130_fd_pr__nfet_01v8_lvt l=0.15 w=0.74 ad=0.259 as=0.2072 pd=2.18 ps=2.04
XM18 a_886_74# D#1 VGND#6 VNB sky130_fd_pr__nfet_01v8_lvt l=0.15 w=0.74 ad=0.2109 as=0.259 pd=2.05 ps=2.18
XM0 a_27_368##9 A_N#3 VPWR#13 VPB sky130_fd_pr__pfet_01v8 l=0.15 w=1 ad=0.295 as=0.4845 pd=2.59 ps=3.04
XM17 VPWR#13 B_N#1 a_231_74##8 VPB sky130_fd_pr__pfet_01v8 l=0.15 w=1 ad=0.4845 as=0.395 pd=3.04 ps=2.79
XM1 VPWR#12 a_27_368##7 Y#7 VPB sky130_fd_pr__pfet_01v8 l=0.15 w=1.12 ad=0.3864 as=0.336 pd=2.93 ps=2.84
XM8 Y#7 a_27_368# VPWR#11 VPB sky130_fd_pr__pfet_01v8 l=0.15 w=1.12 ad=0.336 as=0.448 pd=2.84 ps=3.04
XM7 VPWR#11 a_231_74##5 Y#8 VPB sky130_fd_pr__pfet_01v8 l=0.15 w=1.12 ad=0.448 as=0.336 pd=3.04 ps=2.84
XM19 Y#8 a_231_74##6 VPWR#10 VPB sky130_fd_pr__pfet_01v8 l=0.15 w=1.12 ad=0.336 as=0.9296 pd=2.84 ps=3.9
XM10 VPWR#10 C#4 Y#5 VPB sky130_fd_pr__pfet_01v8 l=0.15 w=1.12 ad=0.9296 as=0.336 pd=3.9 ps=2.84
XM13 Y#5 C#5 VPWR#9 VPB sky130_fd_pr__pfet_01v8 l=0.15 w=1.12 ad=0.336 as=0.448 pd=2.84 ps=3.04
XM11 VPWR#9 D#5 Y#1 VPB sky130_fd_pr__pfet_01v8 l=0.15 w=1.12 ad=0.448 as=0.3808 pd=3.04 ps=2.92
XM3 Y#1 D#6 VPWR#1 VPB sky130_fd_pr__pfet_01v8 l=0.15 w=1.12 ad=0.3808 as=0.3416 pd=2.92 ps=2.85
*
*
*       RESISTOR AND CAP/DIODE CARDS
*
Rg1	A_N#1	A_N#2	380.329956
Rg2	A_N#2	A_N#3	420.205353
Rg3	B_N#1	B_N#2	475.028809
Rg4	B_N#2	B_N#3	313.676300
Rg5	a_27_368#	a_27_368##2	491.295685
Rg6	a_27_368##2	a_27_368##3	50.133865
Rg7	a_27_368##3	a_27_368##4	54.486244
Rg8	a_27_368##2	a_27_368##5	317.859833
Rg9	a_27_368##3	a_27_368##6	322.990906
Rg10	a_27_368##3	a_27_368##7	469.777618
Rg11	a_231_74#	a_231_74##2	397.555725
Rg12	a_231_74##2	a_231_74##3	36.503117
Rg13	a_231_74##3	a_231_74##4	16.832588
Rg14	a_231_74##4	a_231_74##5	452.177887
Rg15	a_231_74##2	a_231_74##6	449.655212
Rg16	a_231_74##4	a_231_74##7	394.610352
Rg17	C#1	C#2	426.871521
Rg18	C#2	C#3	42.819736
Rg19	C#3	C#4	455.914490
Rg20	C#2	C#5	426.210968
Rg21	C#3	C#6	426.989899
Rg22	D#1	D#2	397.555725
Rg23	D#2	D#3	30.596949
Rg24	D#3	D#4	30.613653
Rg25	D#4	D#5	449.655212
Rg26	D#2	D#6	449.655212
Rg27	D#4	D#7	397.555725
Rf1	A_N#2	A_N#5	161.881958
Rf2	A_N#6	A_N	1.649148
Rf3	A_N#5	A_N#6	6.551771
Rf4	B_N	B_N#2	162.201172
Rf5	a_27_368##4	a_27_368##10	310.649384
Rf6	a_27_368##10	a_27_368##11	109.209625
Rf7	a_27_368##9	a_27_368##10	5.000000
Rf8	a_231_74##8	a_231_74##9	81.272369
Rf9	a_231_74##9	a_231_74##10	29.951342
Rf10	a_231_74##9	a_231_74##3	225.415619
Rf11	a_373_74#	a_373_74##3	105.457756
Rf12	a_373_74##3	a_373_74##4	89.325668
Rf13	a_373_74##2	a_373_74##3	15.000000
Rf14	a_678_74#	a_678_74##2	145.407959
Rf15	C#7	C	1.070568
Rf16	C#2	C#9	81.186966
Rf17	C#9	C	1.070568
Rf18	C#7	C#9	14.668931
Rf19	Y#1	Y#2	85.266777
Rf20	Y#2	Y#3	62.194817
Rf21	Y#3	Y	31.946342
Rf22	Y	Y#4	152.116745
Rf23	Y#2	Y#5	18.602406
Rf24	Y#3	Y#6	28.650801
Rf25	Y#6	Y#7	88.125626
Rf26	Y#6	Y#8	16.634041
Rf27	D#3	D	99.959625
Rf28	a_886_74#	a_886_74##2	87.993027
Rf29	a_886_74##2	a_886_74##3	91.554207
Rf30	a_886_74##2	a_886_74##4	21.341251
Rf31	VPWR#1	VPWR#2	105.096703
Rf32	VPWR#2	VPWR#3	88.844551
Rf33	VPWR#3	VPWR#4	63.301407
Rf34	VPWR#4	VPWR#5	25.543140
Rf35	VPWR#5	VPWR#6	73.001427
Rf36	VPWR#6	VPWR#7	87.246277
Rf38	VPWR#2	VPWR#9	31.534731
Rf39	VPWR#3	VPWR#10	14.483401
Rf40	VPWR#5	VPWR#11	33.503098
Rf41	VPWR#6	VPWR#12	33.326477
Rf42	VPWR#7	VPWR#13	34.704330
Rf44	VGND#2	VGND#3	193.194031
Rf45	VGND#3	VGND#4	187.349976
Rf47	VGND#2	VGND#6	37.263206
Rf48	VGND#4	VGND#7	31.337896
Re1	VPWR#4	VPWR	0.701577
Re2	VGND	VGND#3	0.701602
*
*       CAPACITOR CARDS
*
*
C1	VPWR#3	VPWR#2	9.97773e-19
C2	VGND#3	C#3	1.75163e-20
C3	a_886_74##2	D#1	2.23038e-19
C4	a_373_74##2	Y#4	7.38723e-17
C5	VGND#3	a_231_74##4	8.69001e-20
C6	a_373_74##4	a_373_74##2	1.8946e-18
C7	a_886_74##2	D#7	2.16417e-17
C8	VGND#3	a_27_368##2	6.98979e-20
C9	D#3	D#4	1.30759e-17
C10	a_373_74##4	Y#4	3.81252e-17
C11	D#3	C#3	3.99486e-18
C12	a_886_74##2	C#1	1.96636e-17
C13	a_886_74##2	C#6	1.52195e-19
C14	a_678_74#	C#3	1.26278e-18
C15	Y#6	VPWR#3	3.29628e-19
C16	VGND#7	a_373_74##4	2.63569e-18
C17	VPWR#3	C#3	2.04712e-20
C18	VGND#7	a_231_74##10	5.93491e-17
C19	Y#3	VPWR#3	6.26374e-17
C20	A_N#6	a_231_74##8	7.64181e-18
C21	a_886_74##3	C#3	3.47344e-18
C22	Y#2	VPWR#3	1.33706e-17
C23	VPWR#2	C#3	2.01982e-20
C24	a_27_368##11	VGND#7	5.99561e-17
C25	A_N#5	a_231_74##8	1.37586e-18
C26	VPWR#5	a_27_368##2	4.50848e-20
C27	a_231_74##3	a_231_74##4	2.76881e-17
C28	a_27_368##9	A_N#6	3.83785e-17
C29	Y#2	VPWR#2	1.6661e-19
C30	a_231_74##3	a_27_368##2	1.84302e-17
C31	a_27_368##9	A_N#5	2.58391e-18
C32	a_373_74#	a_231_74##4	8.4268e-19
C33	a_27_368##4	a_231_74##4	4.62783e-19
C34	Y#1	VPWR#1	9.61657e-17
C35	a_886_74##2	Y#2	3.18069e-18
C36	a_27_368##4	a_27_368##2	3.2731e-18
C37	a_886_74#	D#1	3.37567e-17
C38	VPWR#9	VPWR#1	1.76313e-18
C39	VGND#6	D#1	3.36601e-17
C40	a_886_74#	D#7	9.13406e-19
C41	Y#1	VPWR#9	7.4858e-17
C42	a_886_74##2	C#3	1.44902e-18
C43	a_678_74##2	a_231_74##4	5.96336e-19
C44	a_886_74##4	D#1	1.66563e-18
C45	D#7	VGND#6	1.69038e-17
C46	Y#5	Y#1	2.07064e-18
C47	a_678_74#	D#1	8.29979e-19
C48	a_231_74##9	a_27_368##5	2.28643e-18
C49	a_886_74##4	D#7	3.63009e-17
C50	VPWR#3	D#5	3.45466e-19
C51	VGND#6	C#1	4.82425e-19
C52	Y#5	VPWR#9	6.22197e-17
C53	VPWR#2	D#5	2.57874e-18
C54	a_678_74#	D#7	2.1229e-18
C55	a_231_74##9	a_27_368##6	1.74427e-17
C56	C#1	a_886_74##4	1.14491e-17
C57	a_886_74##3	D#7	2.50088e-19
C58	VPWR#3	C#5	7.22618e-19
C59	a_373_74##2	a_231_74##4	7.22223e-19
C60	a_678_74#	C#1	4.17577e-17
C61	a_231_74##10	a_231_74##8	3.15728e-18
C62	Y#3	D#6	7.12122e-20
C63	VPWR#2	C#5	2.57874e-18
C64	a_886_74##4	C#6	6.63828e-19
C65	a_27_368##2	a_231_74##7	3.11808e-18
C66	a_886_74##3	C#1	1.12764e-18
C67	a_678_74#	C#6	3.34921e-17
C68	Y#8	Y#5	1.21375e-18
C69	VPWR#3	C#4	2.16046e-17
C70	Y#3	D#5	1.06065e-19
C71	a_231_74##9	A_N#1	3.1763e-19
C72	a_886_74##3	C#6	5.56855e-17
C73	a_678_74##2	C#1	1.97545e-19
C74	Y#2	D#5	1.58753e-19
C75	a_678_74#	a_231_74#	5.4989e-19
C76	a_373_74#	C#6	4.68008e-19
C77	Y#4	a_231_74##4	4.74259e-18
C78	VPWR#3	a_231_74##6	2.47083e-17
C79	VGND#7	a_27_368##9	3.20504e-18
C80	a_373_74##2	C#1	9.13886e-20
C81	a_886_74##3	a_231_74#	3.10301e-18
C82	a_373_74##2	a_27_368##2	9.98623e-20
C83	Y#3	C#5	1.85757e-19
C84	a_678_74##2	C#6	6.79135e-19
C85	a_678_74#	a_231_74##7	8.76982e-20
C86	a_27_368##11	a_27_368##9	2.61003e-18
C87	Y#2	C#5	1.83414e-17
C88	a_373_74#	a_231_74#	3.21637e-17
C89	VPWR#11	Y#8	6.89352e-17
C90	Y#6	a_231_74##4	6.74593e-18
C91	a_373_74##2	C#6	2.59895e-19
C92	a_886_74##3	a_231_74##7	4.64638e-19
C93	VPWR#3	a_231_74##5	7.22618e-19
C94	a_678_74##2	a_231_74#	3.90394e-17
C95	Y#3	C#4	1.15789e-18
C96	Y#4	C#6	1.32951e-19
C97	Y#7	Y#8	1.29415e-19
C98	Y#2	C#4	2.52089e-17
C99	a_373_74##2	a_231_74#	8.27392e-19
C100	a_886_74##3	a_27_368##5	3.03194e-19
C101	VPWR#5	a_27_368#	2.59242e-18
C102	Y#6	a_231_74##6	2.8092e-17
C103	a_678_74##2	a_231_74##7	2.75973e-17
C104	Y#3	C#3	9.59992e-19
C105	Y#7	VPWR#11	7.82442e-17
C106	Y#4	a_231_74#	2.08517e-19
C107	VPWR#3	a_27_368#	3.45466e-19
C108	Y#4	a_27_368##2	7.51811e-18
C109	Y#3	a_231_74##6	2.06102e-18
C110	C#3	D#4	2.64466e-17
C111	a_373_74##2	a_231_74##7	2.14936e-17
C112	VPWR#6	a_27_368##7	2.71346e-18
C113	Y#2	a_231_74##6	9.9519e-20
C114	a_678_74##2	a_27_368##5	1.68184e-18
C115	VPWR#12	VPWR#11	1.54138e-18
C116	Y#4	a_231_74##7	7.40974e-18
C117	Y#6	a_231_74##5	2.29348e-17
C118	Y#3	a_231_74##4	4.03521e-18
C119	a_373_74##2	a_27_368##5	4.03794e-17
C120	Y#3	a_231_74##5	5.33219e-19
C121	VPWR#12	Y#7	4.30181e-17
C122	a_373_74##4	a_231_74##7	2.09114e-19
C123	a_678_74##2	a_27_368##6	8.25538e-19
C124	Y#4	a_27_368##5	3.32964e-17
C125	a_373_74##2	a_27_368##6	2.72738e-19
C126	Y#6	a_27_368#	6.4842e-19
C127	Y#2	C#3	4.06557e-18
C128	a_373_74##4	a_27_368##5	8.23611e-19
C129	a_373_74##4	a_27_368##2	1.29234e-19
C130	Y#3	a_27_368#	3.97038e-19
C131	a_27_368##6	Y#4	2.45522e-17
C132	a_373_74##2	B_N#3	5.50267e-20
C133	a_373_74##4	a_27_368##6	4.74628e-17
C134	VGND#7	a_27_368##5	1.88548e-19
C135	VPWR#13	VPWR#12	1.05693e-17
C136	Y#4	B_N#3	8.36353e-20
C137	Y#3	a_27_368##7	2.0839e-19
C138	a_373_74##4	B_N#3	1.42958e-18
C139	VGND#7	a_27_368##6	6.89859e-19
C140	a_231_74##10	B_N#3	4.89493e-17
C141	a_27_368##9	a_231_74##8	3.17799e-17
C142	a_27_368##11	a_27_368##6	1.23762e-19
C143	a_373_74##4	A_N#1	3.28618e-19
C144	B_N#3	VGND#7	2.2565e-17
C145	a_27_368##9	VPWR#13	6.83171e-17
C146	VPWR#4	VPWR#6	4.39958e-17
C147	A_N#1	VGND#7	2.76985e-17
C148	VPWR#4	VPWR#5	2.86484e-17
C149	VPWR#4	VPWR#3	5.32921e-17
C150	a_27_368##11	A_N#1	3.71157e-17
C151	VPWR#4	VPWR#2	4.54001e-17
C152	a_886_74##2	a_886_74#	5.57916e-19
C153	a_231_74##4	C#3	3.6157e-18
C154	A_N#6	a_27_368##7	6.88342e-20
C155	D#7	D#1	2.48722e-17
C156	Y#6	VPWR#4	2.16502e-19
C157	a_886_74##2	VGND#6	2.21826e-17
C158	VPWR#1	D#6	5.17348e-17
C159	A_N#6	B_N#1	3.2467e-18
C160	D#6	Y#1	2.61334e-17
C161	VPWR#2	D#3	6.53713e-20
C162	C#1	D#7	3.99039e-17
C163	a_886_74##2	a_886_74##4	5.26243e-19
C164	VPWR#1	D#5	2.86413e-18
C165	VPWR#9	D#6	1.26655e-18
C166	Y#1	D#5	7.27356e-17
C167	a_886_74##2	D#3	5.13367e-17
C168	A_N#6	A_N#3	2.88029e-18
C169	VPWR#1	C#5	2.8528e-19
C170	D#5	VPWR#9	3.19803e-17
C171	C#6	C#1	2.52379e-17
C172	a_886_74##2	a_678_74#	1.44439e-17
C173	Y#1	C#5	1.67945e-18
C174	Y#5	D#5	6.04773e-19
C175	C#5	VPWR#9	3.62278e-17
C176	Y#1	C#4	4.92183e-19
C177	Y#5	C#5	5.30654e-17
C178	a_231_74#	C#6	2.96856e-18
C179	a_886_74##3	a_886_74##2	5.74436e-19
C180	VPWR#9	C#4	1.2717e-18
C181	D	D#4	7.64919e-20
C182	a_27_368##4	VPWR#6	4.10191e-18
C183	Y#1	a_231_74##6	1.46103e-19
C184	D	C#3	1.99122e-20
C185	Y#5	C#4	4.57749e-17
C186	VPWR#9	a_231_74##6	8.34712e-20
C187	C#4	VPWR#10	1.73931e-17
C188	a_231_74##7	a_231_74#	3.97729e-17
C189	a_231_74##3	Y#6	7.55184e-17
C190	Y#5	a_231_74##6	3.3173e-19
C191	a_231_74##3	Y#3	1.11796e-17
C192	Y#8	C#4	4.31249e-19
C193	a_678_74#	Y#3	1.21374e-18
C194	a_231_74##6	VPWR#10	2.65952e-17
C195	VPWR#11	C#4	8.34712e-20
C196	C#3	VPWR#9	1.09027e-18
C197	Y#8	a_231_74##6	5.39702e-17
C198	a_27_368##5	a_231_74##7	1.94426e-17
C199	Y#3	a_27_368##4	2.0318e-19
C200	VPWR#11	a_231_74##6	1.2717e-18
C201	C	D#4	3.95902e-18
C202	a_886_74##3	Y#3	1.34162e-18
C203	Y#8	a_231_74##5	4.57764e-17
C204	C	C#3	3.78139e-17
C205	C	a_231_74##4	1.13603e-18
C206	VGND#3	a_678_74#	2.54374e-17
C207	a_886_74#	D#3	1.78013e-17
C208	a_231_74##9	a_231_74##3	1.7798e-18
C209	a_231_74##5	VPWR#11	3.17736e-17
C210	a_27_368##6	a_27_368##5	3.3595e-17
C211	VGND#6	D#3	1.99227e-18
C212	Y#8	a_27_368#	3.77983e-20
C213	Y#7	a_231_74##5	5.19482e-19
C214	a_27_368#	VPWR#11	3.66551e-17
C215	VPWR#12	a_231_74##5	2.8528e-19
C216	VGND#3	a_678_74##2	7.14688e-17
C217	C#3	Y#5	5.48219e-19
C218	a_231_74##9	a_27_368##4	6.44937e-17
C219	B_N#3	a_27_368##6	3.0462e-18
C220	Y#7	a_27_368#	7.72429e-17
C221	VGND#3	a_373_74##2	3.32107e-17
C222	VPWR#11	a_27_368##7	1.3146e-18
C223	VPWR#12	a_27_368#	1.25159e-18
C224	Y#7	a_27_368##7	5.50536e-17
C225	a_678_74##2	Y#3	3.07342e-19
C226	VGND#3	a_373_74##4	2.0501e-17
C227	a_27_368##2	a_231_74##4	2.3094e-17
C228	A_N#6	a_27_368##4	8.09083e-19
C229	A_N#1	B_N#3	2.00839e-17
C230	B_N#2	a_231_74##9	3.61631e-17
C231	a_27_368##7	VPWR#12	2.6428e-17
C232	VPWR#4	VPWR#1	2.95983e-17
C233	Y#7	B_N#1	1.12446e-18
C234	a_231_74##8	a_27_368##7	6.27116e-19
C235	VPWR#12	B_N#1	4.73198e-18
C236	VPWR#13	a_27_368##7	1.62304e-18
C237	A_N#6	B_N#2	9.92483e-19
C238	a_231_74##9	A_N#2	1.41799e-19
C239	Y#7	A_N#3	3.19688e-19
C240	a_231_74##8	B_N#1	4.42822e-17
C241	a_27_368##9	a_27_368##7	7.02872e-19
C242	VPWR#12	A_N#3	1.44461e-18
C243	A_N#5	B_N#2	2.58449e-17
C244	B_N#1	VPWR#13	3.6643e-17
C245	D#3	VPWR#1	4.79076e-18
C246	a_231_74##8	A_N#3	2.8671e-18
C247	Y#8	VPWR#4	1.50647e-17
C248	a_27_368##9	B_N#1	4.33463e-17
C249	Y#4	a_231_74##3	4.93106e-17
C250	A_N#6	A_N#2	7.00634e-18
C251	D#3	Y#1	5.91187e-17
C252	A_N#3	VPWR#13	3.76248e-17
C253	A_N#5	A_N#2	1.20059e-17
C254	a_27_368##9	A_N#3	5.8242e-17
C255	a_27_368##4	Y#4	1.2071e-18
C256	D#5	D#6	3.79489e-17
C257	a_373_74##4	a_27_368##4	1.52989e-18
C258	C#5	D#5	3.06608e-17
C259	VPWR#2	VPWR#1	9.5684e-19
C260	a_231_74##9	a_27_368##2	3.52963e-19
C261	B_N#2	a_231_74##10	3.29804e-17
C262	Y	D#4	1.27183e-19
C263	a_27_368##11	B_N#2	5.61856e-18
C264	a_231_74##3	Y#8	3.08246e-18
C265	Y	C#3	2.91063e-18
C266	C#4	C#5	4.58357e-17
C267	Y	a_231_74##4	1.83068e-17
C268	a_231_74##3	VPWR#11	1.58075e-19
C269	Y	a_27_368##2	7.38281e-20
C270	Y#1	VPWR#2	1.45444e-17
C271	VGND#7	A_N#2	6.96625e-18
C272	a_231_74##3	Y#7	3.86664e-17
C273	a_27_368##11	A_N#2	7.49533e-18
C274	VPWR#3	VPWR#9	1.96221e-18
C275	a_231_74##6	C#4	5.49693e-18
C276	a_27_368#	a_231_74##4	1.18387e-18
C277	a_27_368##4	Y#7	7.04195e-17
C278	VGND#3	a_231_74#	4.48038e-18
C279	a_27_368##4	VPWR#12	4.21813e-17
C280	VGND#3	a_231_74##7	4.30471e-18
C281	a_27_368##4	a_231_74##8	8.25233e-17
C282	a_231_74##5	a_231_74##6	4.53388e-17
C283	VGND#3	a_27_368##5	5.12723e-18
C284	a_886_74##2	Y#1	3.24774e-18
C285	VPWR#3	Y#5	7.34854e-17
C286	VPWR#11	a_231_74##4	4.4084e-19
C287	VGND#3	a_27_368##6	5.12723e-18
C288	a_27_368##9	a_27_368##4	1.25714e-18
C289	B_N#2	a_231_74##8	1.62637e-17
C290	a_886_74#	VGND#6	4.55113e-17
C291	a_27_368#	a_231_74##5	3.03569e-17
C292	Y#5	VPWR#2	8.43957e-18
C293	B_N#2	a_27_368##9	4.84294e-18
C294	a_231_74##8	A_N#2	8.53784e-19
C295	A_N#2	VPWR#13	8.33243e-19
C296	VPWR#3	VPWR#10	2.85066e-17
C297	a_231_74##9	Y#4	4.20451e-17
C298	a_27_368##7	a_27_368#	4.55976e-17
C299	a_886_74##4	a_886_74#	2.43346e-18
C300	a_27_368##9	A_N#2	4.92723e-18
C301	a_886_74##2	C	2.74575e-17
C302	Y#3	C	2.17592e-17
C303	C	Y#2	8.19866e-17
C304	B_N#1	a_27_368##7	4.8922e-18
C305	Y#3	Y#1	1.63243e-18
C306	VPWR#6	VPWR#11	2.47721e-19
C307	a_231_74##9	a_373_74##4	8.94356e-17
C308	a_886_74##4	VGND#6	4.24187e-17
C309	Y#8	VPWR#3	6.67336e-17
C310	VPWR#4	a_231_74##5	3.07733e-18
C311	a_886_74#	D	2.5858e-17
C312	B_N#2	a_27_368##6	2.06098e-19
C313	A_N#3	B_N#1	2.348e-17
C314	Y#2	Y#1	5.43544e-19
C315	VGND	a_27_368##2	1.47077e-19
C316	A_N#1	B_N#2	2.05583e-18
C317	a_678_74#	VGND#6	2.23955e-18
C318	Y#7	VPWR#6	8.49478e-18
C319	VPWR#11	VPWR#3	1.96221e-18
C320	Y#2	VPWR#9	2.45709e-17
C321	a_886_74##3	C	5.25375e-17
C322	Y#7	VPWR#5	8.58962e-18
C323	a_678_74#	a_886_74##4	4.11237e-17
C324	a_27_368##4	a_231_74##6	2.03736e-19
C325	D	VPWR#1	3.20762e-17
C326	Y#7	a_27_368##2	1.70318e-18
C327	a_27_368##4	a_231_74##5	3.92008e-19
C328	a_27_368##4	a_27_368#	2.49725e-18
C329	D#4	VNB	1.70441e-17
C330	a_27_368##4	a_27_368##7	1.36359e-17
C331	C#3	VNB	6.55025e-17
C332	a_231_74##4	VNB	6.1485e-17
C333	a_886_74##3	a_886_74##4	2.50552e-18
C334	Y#2	Y#5	1.2455e-18
C335	a_27_368##2	VNB	2.75197e-17
C336	Y	Y#6	6.04382e-19
C337	B_N#1	a_27_368##4	2.55386e-18
C338	Y	Y#3	2.33413e-18
C339	a_27_368##11	a_231_74##9	1.2077e-18
C340	a_27_368##4	A_N#3	3.79383e-19
C341	Y#3	VPWR#10	1.31129e-17
C342	VPWR	VPWR#6	2.9183e-17
C343	VPWR	VPWR#5	1.73939e-17
C344	Y#6	Y#8	8.85154e-19
C345	A_N#2	B_N#1	1.36146e-18
C346	a_678_74#	a_886_74##3	6.6234e-17
C347	VPWR	VPWR#3	7.90781e-17
C348	VPWR	VPWR#2	2.59883e-17
C349	VGND#3	a_27_368##4	9.95724e-20
C350	VPWR	Y#6	2.73463e-18
C351	VPWR	Y#3	4.28396e-18
C352	VPWR	Y#2	2.50943e-18
C353	Y	a_886_74##3	1.2628e-17
C354	Y	a_373_74#	6.22479e-17
C355	Y	a_678_74##2	1.39873e-18
C356	a_373_74##2	Y	1.22627e-17
C357	a_231_74##3	a_27_368##4	4.20852e-17
C358	Y#6	VPWR#11	2.89756e-17
C359	VPWR	A_N#6	3.68154e-18
C360	a_231_74##3	B_N#2	9.12363e-20
C361	VPWR#6	VPWR#5	9.53351e-19
C362	Y#8	Y#2	3.64124e-19
C363	VGND	a_886_74##2	4.14932e-18
C364	D	D#6	2.46755e-18
C365	VGND	Y#6	8.53072e-19
C366	B_N#2	a_27_368##4	1.05892e-17
C367	VGND	Y#3	5.08731e-19
C368	D	D#5	5.56305e-19
C369	D	C#5	1.44816e-19
C370	a_373_74#	a_886_74##3	1.59152e-17
C371	a_678_74##2	a_678_74#	2.26657e-18
C372	C	D#6	2.85239e-19
C373	VGND	a_231_74##9	1.5644e-17
C374	C	D#5	1.22334e-18
C375	A_N#2	B_N#2	3.42326e-17
C376	C	C#5	2.05511e-18
C377	VPWR	VPWR#1	4.15424e-17
C378	VGND	A_N#5	4.22445e-18
C379	C	C#4	2.05173e-18
C380	Y#7	Y#6	2.78109e-18
C381	VPWR	Y#1	1.49184e-17
C382	VGND	a_886_74#	1.43009e-17
C383	VPWR	VPWR#9	2.08915e-17
C384	VPWR#6	VNB	3.72746e-17
C385	C	a_231_74##6	1.49195e-19
C386	VPWR#5	VNB	2.23502e-17
C387	VGND	a_886_74##4	1.40942e-17
C388	Y	D#1	1.41234e-19
C389	VPWR	Y#5	1.5943e-17
C390	VPWR#3	VNB	4.45166e-17
C391	VGND	a_678_74#	2.98311e-17
C392	a_27_368##9	VPWR#6	1.32896e-19
C393	VPWR#2	VNB	3.47501e-17
C394	Y	D#7	1.1386e-19
C395	VGND	a_886_74##3	8.5931e-18
C396	VPWR	Y#8	1.61996e-17
C397	a_886_74##2	VNB	5.31926e-18
C398	VGND	a_373_74#	8.47814e-18
C399	Y	C#1	2.26338e-19
C400	VGND	a_678_74##2	2.80211e-17
C401	VPWR	VPWR#11	2.13302e-17
C402	Y	C#6	1.06988e-18
C403	VGND	a_373_74##2	2.13494e-17
C404	Y#3	VNB	2.9357e-18
C405	VPWR	Y#7	1.67105e-17
C406	a_373_74##2	a_678_74#	6.47763e-22
C407	VGND	Y#4	9.65674e-18
C408	Y	a_231_74#	1.02618e-17
C409	VPWR	VPWR#12	1.82229e-17
C410	VGND	a_373_74##4	2.17934e-17
C411	Y	a_231_74##7	5.22522e-18
C412	VPWR	a_231_74##8	3.81577e-18
C413	VGND	a_231_74##10	1.33177e-17
C414	VGND	VGND#7	2.0524e-17
C415	VGND	a_27_368##11	1.95581e-17
C416	VPWR	a_27_368##9	2.58175e-17
C417	a_231_74##9	VNB	1.95079e-17
C418	A_N#6	VNB	3.60454e-18
C419	VGND#7	A_N#5	1.59728e-17
C420	D	D#3	3.39288e-19
C421	A_N#5	VNB	3.36711e-18
C422	a_886_74#	VNB	4.41303e-17
C423	VGND#6	VNB	2.02178e-18
C424	a_886_74##4	VNB	2.1281e-18
C425	a_678_74#	VNB	8.90091e-18
C426	VGND	Y#7	3.41652e-18
C427	a_886_74##3	VNB	5.19288e-18
C428	a_373_74#	VNB	1.63047e-18
C429	C	D#3	2.55229e-17
C430	VGND	a_231_74##8	2.002e-18
C431	a_678_74##2	VNB	7.03381e-18
C432	a_373_74##2	VNB	1.32734e-18
C433	a_373_74#	a_678_74##2	5.34576e-17
C434	Y#4	VNB	2.67336e-18
C435	a_373_74##2	a_886_74##3	1.90958e-18
C436	a_373_74##4	VNB	8.49645e-18
C437	VGND	D#1	1.49327e-18
C438	a_231_74##10	VNB	3.35819e-18
C439	VGND#7	VNB	4.77684e-18
C440	VGND	D#7	2.43438e-20
C441	a_27_368##11	VNB	5.74389e-17
C442	VGND	C#1	2.07506e-18
C443	VPWR	D#6	2.99493e-18
C444	VPWR#1	VNB	7.93086e-17
C445	VPWR#5	VPWR#3	9.97773e-19
C446	VGND	C#6	1.60934e-18
C447	Y#1	VNB	3.214e-18
C448	VPWR	D#5	1.16637e-19
C449	VPWR#9	VNB	3.74405e-18
C450	VGND	a_231_74#	1.6372e-18
C451	Y#5	VNB	2.1429e-18
C452	VPWR	C#5	2.31358e-19
C453	VGND	a_231_74##7	1.71576e-18
C454	VGND	a_27_368##5	1.33423e-18
C455	Y#8	VNB	2.16127e-18
C456	VPWR#11	VNB	3.8961e-18
C457	VGND	a_27_368##6	1.27909e-18
C458	Y#7	VNB	2.2715e-18
C459	VGND	B_N#3	1.18986e-18
C460	VPWR#12	VNB	6.65901e-18
C461	VPWR	a_231_74##5	6.21293e-19
C462	a_27_368##11	A_N#5	2.91601e-17
C463	VGND	A_N#1	2.17351e-18
C464	a_231_74##8	VNB	8.8062e-18
C465	VPWR	a_27_368#	1.69532e-19
C466	VPWR#13	VNB	1.05862e-17
C467	a_27_368##9	VNB	6.1362e-17
C468	VPWR	a_27_368##7	5.57274e-18
C469	D#1	VNB	3.03792e-17
C470	D#7	VNB	2.68537e-17
C471	VPWR	B_N#1	7.58057e-18
C472	C#1	VNB	2.73388e-17
C473	Y	D#3	1.68754e-19
C474	VPWR	A_N#3	7.29918e-18
C475	C#6	VNB	3.13686e-17
C476	a_231_74#	VNB	3.49995e-17
C477	a_231_74##7	VNB	2.74214e-17
C478	Y#4	a_886_74##3	1.09069e-18
C479	a_27_368##5	VNB	2.66155e-17
C480	VPWR	VPWR#4	9.124e-18
C481	Y	a_231_74##3	6.08581e-17
C482	a_27_368##6	VNB	2.93023e-17
C483	B_N#3	VNB	3.21539e-17
C484	A_N#1	VNB	3.71874e-17
C485	VPWR	D#3	3.77343e-18
C486	D#6	VNB	3.6246e-17
C487	D#5	VNB	3.25562e-17
C488	VPWR#4	a_231_74##4	5.3225e-20
C489	VPWR	a_231_74##3	5.48228e-18
C490	C#5	VNB	3.13582e-17
C491	C#4	VNB	3.14875e-17
C492	VPWR	a_27_368##4	9.6853e-18
C493	a_231_74##6	VNB	3.61335e-17
C494	VGND	VGND#3	4.98103e-17
C495	a_231_74##5	VNB	3.17456e-17
C496	VPWR	B_N#2	2.90177e-18
C497	C	D	6.03279e-19
C498	VGND	D#3	3.90418e-18
C499	a_27_368#	VNB	3.26688e-17
C500	a_27_368##7	VNB	3.32302e-17
C501	B_N#1	VNB	5.60291e-17
C502	VGND	a_231_74##3	5.47757e-18
C503	A_N#3	VNB	4.32607e-17
C504	VGND	a_27_368##4	4.0917e-18
C505	VPWR#4	VNB	2.76725e-16
C506	VGND	B_N#2	4.92547e-18
C507	VGND#3	VNB	3.46515e-16
C508	VGND	A_N#2	2.32693e-19
C509	D#3	VNB	5.08154e-17
C510	a_373_74##2	a_678_74##2	3.08381e-17
C511	a_231_74##3	VNB	3.45354e-18
C512	a_27_368##4	VNB	7.11489e-17
C513	B_N#2	VNB	3.43686e-17
C514	Y	C	1.76627e-17
C515	A_N#2	VNB	4.32541e-17
C516	VPWR	D	2.1972e-18
C517	VPWR	C	5.41552e-18
C518	VGND	D	2.00818e-18
C519	VGND	C	6.0637e-18
C520	D	VNB	2.90351e-17
C521	C	VNB	1.19493e-17
C522	VGND	Y	7.34182e-18
C523	a_886_74#	VPWR#1	1.63553e-19
C524	Y	VNB	6.32677e-18
C525	VPWR	VNB	7.0964e-17
C526	VGND	VNB	1.00127e-16
C527	VGND#4	A_N#1	4.75802e-18
C528	VPWR#7	VPWR#12	1.04765e-19
C529	VPWR#7	A_N#3	4.54416e-18
C530	VGND#2	a_231_74#	9.25301e-20
C531	VPWR#7	a_27_368##7	1.70756e-19
C532	VGND#2	a_886_74#	1.7841e-17
C533	VGND#4	a_373_74##4	1.88311e-17
C534	VPWR#7	VPWR#6	8.48594e-19
C535	VGND#4	a_27_368##11	2.25734e-17
C536	VGND#2	a_678_74#	4.53705e-17
C537	VGND#3	VGND#2	8.74594e-17
C538	VGND#4	a_27_368##4	1.28675e-19
C539	VGND#2	C#1	5.39916e-18
C540	a_27_368##9	VPWR#7	1.82706e-17
C541	VGND#2	C#3	4.79554e-20
C542	VGND	VGND#2	6.83493e-17
C543	VGND#4	a_231_74##10	1.68465e-17
C544	VGND#2	D#1	5.0217e-18
C545	VGND	VGND#4	5.65805e-17
C546	VPWR#7	B_N#1	6.67864e-18
C547	VGND#4	a_231_74##9	1.22304e-17
C548	VPWR#7	VNB	5.57083e-17
C549	VGND#4	B_N#3	7.46402e-18
C550	VGND#4	B_N#2	1.25789e-18
C551	VGND#2	a_886_74##2	9.68101e-19
C552	VPWR	VPWR#7	6.08625e-17
C553	VGND#4	A_N#5	4.42852e-19
C554	VGND#2	C#6	4.73203e-18
C555	VPWR#7	B_N#2	1.03517e-19
C556	VGND#2	VNB	7.27593e-17
C557	VGND#2	a_886_74##4	1.37184e-17
C558	VGND#3	VGND#4	8.91141e-17
C559	VGND#4	VNB	7.81197e-17
C560	VGND#2	D#7	5.24458e-18
C561	VPWR#4	VPWR#7	6.0293e-17
*
*
.ENDS sky130_fd_sc_hs__nand4bb_2
*
