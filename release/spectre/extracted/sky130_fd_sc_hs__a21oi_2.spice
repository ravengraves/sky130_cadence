* Extracted by Quantus, converted by sky130cad/quantus.py
*
*
*
*                       LINUX           Wed Nov 18 08:05:58 2026
*
*
*
*  PROGRAM  advgen
*
*  Name           : advgen - Quantus - (64-bit)
*  Version        : 25.1.0-p047
*  Build Date     : Thu Dec 11 23:20:30 PST 2025
*
*  HSPICE LIBRARY
*
*  OPERATING_TEMPERATURE 150
*  QRC_TECH_DIR <path>/tech
*
*
*

*
.SUBCKT sky130_fd_sc_hs__a21oi_2 VPB VNB VGND VPWR Y A2 A1 B1
*
*
*  caps2d version: 10
*
*
*       TRANSISTOR CARDS
*
*
XM5 VGND#3 B1#6 Y#2 VNB sky130_fd_pr__nfet_01v8_lvt l=0.15 w=0.74 ad=0.1961 as=0.1961 pd=2.01 ps=2.01
XM7 a_280_107##4 A2#4 VGND#4 VNB sky130_fd_pr__nfet_01v8_lvt l=0.15 w=0.74 ad=0.25175 as=0.387325 pd=2.22 ps=2.81
XM10 VGND#4 A2#1 a_280_107# VNB sky130_fd_pr__nfet_01v8_lvt l=0.15 w=0.74 ad=0.387325 as=0.2072 pd=2.81 ps=2.04
XM1 a_280_107# A1#5 Y#1 VNB sky130_fd_pr__nfet_01v8_lvt l=0.15 w=0.74 ad=0.2072 as=0.2072 pd=2.04 ps=2.04
XM0 Y#1 A1#3 a_280_107##2 VNB sky130_fd_pr__nfet_01v8_lvt l=0.15 w=0.74 ad=0.2072 as=0.1961 pd=2.04 ps=2.01
XM4 a_131_368##5 B1#5 Y#4 VPB sky130_fd_pr__pfet_01v8 l=0.15 w=1.12 ad=0.308 as=0.336 pd=2.79 ps=2.84
XM9 Y#4 B1#1 a_131_368##3 VPB sky130_fd_pr__pfet_01v8 l=0.15 w=1.12 ad=0.336 as=0.336 pd=2.84 ps=2.84
XM2 VPWR#6 A2#6 a_131_368##3 VPB sky130_fd_pr__pfet_01v8 l=0.15 w=1.12 ad=0.4032 as=0.336 pd=2.96 ps=2.84
XM6 a_131_368##6 A2#5 VPWR#6 VPB sky130_fd_pr__pfet_01v8 l=0.15 w=1.12 ad=0.336 as=0.4032 pd=2.84 ps=2.96
XM8 a_131_368##6 A1#6 VPWR#5 VPB sky130_fd_pr__pfet_01v8 l=0.15 w=1.12 ad=0.336 as=0.336 pd=2.84 ps=2.84
XM3 VPWR#5 A1#1 a_131_368# VPB sky130_fd_pr__pfet_01v8 l=0.15 w=1.12 ad=0.336 as=0.308 pd=2.84 ps=2.79
*
*
*       RESISTOR AND CAP/DIODE CARDS
*
Rg1	B1#1	B1#2	593.719238
Rg2	B1#2	B1#3	279.085266
Rg3	B1#3	B1#4	40.720856
Rg4	B1#2	B1#5	371.735809
Rg5	B1#3	B1#6	416.264008
Rg6	A2#1	A2#2	377.027313
Rg7	A2#2	A2#3	91.077492
Rg8	A2#3	A2#4	369.585205
Rg9	A2#2	A2#5	429.126801
Rg10	A2#3	A2#6	416.207306
Rg11	A1#1	A1#2	451.603058
Rg12	A1#2	A1#3	401.146606
Rg13	A1#2	A1#4	45.379078
Rg14	A1#4	A1#5	397.555725
Rg15	A1#4	A1#6	449.655212
Rf1	B1#4	B1	162.791672
Rf2	A2	A2#7	3.476179
Rf3	A2#7	A2	3.476179
Rf4	A2#8	A2#2	160.890457
Rf5	A2#7	A2#8	5.313624
Rf6	A2	A2#10	3.476179
Rf7	A2#10	A2	3.476179
Rf8	A2#8	A2#10	5.313624
Rf9	Y#1	Y#3	182.732315
Rf10	Y#3	Y	47.443253
Rf11	Y	Y#4	30.625111
Rf12	Y#2	Y#3	7.500000
Rf13	A1#7	A1#2	161.226013
Rf14	A1	A1#9	0.993209
Rf15	A1#7	A1#9	5.660404
Rf16	a_280_107#	a_280_107##3	64.754349
Rf17	a_280_107##3	a_280_107##4	280.317993
Rf18	a_280_107##2	a_280_107##3	7.500000
Rf19	a_131_368#	a_131_368##2	76.474457
Rf20	a_131_368##2	a_131_368##4	74.490265
Rf21	a_131_368##4	a_131_368##5	103.023567
Rf22	a_131_368##2	a_131_368##6	14.409969
Rf23	a_131_368##3	a_131_368##4	7.500000
Rf25	VPWR#2	VPWR#3	66.963989
Rf26	VPWR#3	VPWR#4	18.652620
Rf27	VPWR#2	VPWR#5	48.224632
Rf28	VPWR#3	VPWR#6	36.725166
Rf30	VGND#2	VGND#3	151.960632
Rf31	VGND#2	VGND#4	34.659180
Re1	VPWR#4	VPWR	1.227783
Re2	VGND	VGND#2	1.227829
*
*       CAPACITOR CARDS
*
*
C1	a_131_368##2	A1#4	2.57244e-19
C2	A1#7	A1#4	1.6584e-17
C3	a_131_368##2	VPWR#3	9.49864e-18
C4	B1#1	A2#3	1.03961e-17
C5	VPWR#4	A2#3	2.69469e-20
C6	VPWR#4	B1#2	3.83564e-20
C7	a_280_107##2	a_131_368##2	2.12761e-17
C8	a_280_107##2	A1#4	1.3793e-17
C9	Y#1	A1#4	3.83724e-18
C10	a_280_107##2	A1#7	2.51473e-17
C11	Y#1	A2#3	2.84269e-18
C12	a_280_107##4	a_131_368##2	5.63034e-17
C13	Y#1	A1#7	1.97691e-17
C14	a_280_107#	A1#4	1.12719e-19
C15	A2#2	A1#4	2.98449e-17
C16	A2#3	A2#2	6.76762e-19
C17	a_131_368##2	a_131_368#	3.01982e-18
C18	a_131_368##2	VPWR#5	3.8794e-17
C19	a_131_368##3	VPWR#3	1.97425e-18
C20	A2#3	VGND#4	1.15756e-18
C21	a_131_368##2	a_131_368##6	1.3641e-18
C22	B1#4	A2#3	1.10792e-18
C23	a_280_107##2	Y#1	5.22277e-17
C24	a_131_368##2	VPWR#6	5.1966e-17
C25	a_131_368##3	a_131_368##2	2.73185e-18
C26	Y#1	a_280_107#	5.2694e-17
C27	a_280_107##4	A2#3	1.05928e-17
C28	Y#1	VGND#4	5.01741e-17
C29	VGND#4	a_280_107#	2.46338e-17
C30	Y#1	a_280_107##4	6.09051e-18
C31	Y#2	a_280_107#	1.13022e-20
C32	a_280_107##2	a_131_368#	5.37405e-17
C33	Y#2	VGND#4	5.32653e-18
C34	a_280_107##2	VPWR#5	1.09322e-18
C35	Y#2	a_280_107##4	5.67896e-17
C36	VGND#3	VGND#4	4.66572e-19
C37	Y#2	B1#2	5.23354e-18
C38	VGND#3	Y#2	8.83747e-17
C39	a_280_107##4	a_131_368#	2.73311e-21
C40	a_280_107##2	a_131_368##3	1.31797e-22
C41	VPWR#3	A1#1	2.68885e-19
C42	VGND#3	B1#2	6.33575e-20
C43	a_280_107##4	a_131_368##6	1.37609e-18
C44	a_131_368#	A1#4	2.21873e-19
C45	a_280_107##4	VPWR#6	1.70676e-18
C46	VPWR#3	A1#6	6.36351e-19
C47	a_131_368#	VPWR#5	3.77123e-17
C48	B1	A2#3	4.4222e-19
C49	a_131_368##2	A1#1	1.64797e-18
C50	a_280_107##2	A1#3	5.14505e-17
C51	a_280_107##4	a_131_368##3	5.35507e-17
C52	VPWR#3	A2#5	4.73977e-18
C53	A1#3	Y#1	1.74547e-17
C54	Y#4	a_280_107##4	3.71059e-17
C55	a_280_107##2	A1#5	1.60132e-18
C56	a_131_368##2	A1#6	3.50122e-17
C57	Y#1	A1#5	4.39343e-17
C58	VPWR#3	A2#6	2.00332e-18
C59	a_280_107##2	A2#1	3.62889e-19
C60	VGND#4	A1#3	7.3607e-19
C61	A1#4	VPWR#5	1.01045e-18
C62	VPWR#6	VPWR#5	1.92497e-18
C63	a_280_107#	A1#5	3.35824e-17
C64	a_131_368##2	A2#5	3.15575e-17
C65	Y#1	A2#1	2.19971e-17
C66	VGND#4	A1#5	1.09678e-18
C67	a_280_107##2	A2#4	1.47517e-19
C68	A1	A1#4	6.74339e-18
C69	VPWR#3	B1#1	4.60754e-19
C70	a_280_107#	A2#1	2.54178e-17
C71	Y#1	A2#4	8.83758e-19
C72	a_280_107##4	A1#5	2.45906e-19
C73	a_131_368##2	A2#6	1.06181e-18
C74	A2#1	VGND#4	2.59528e-17
C75	a_280_107#	A2#4	5.9177e-19
C76	Y#2	A1#5	2.21587e-19
C77	a_131_368##3	VPWR#6	4.48701e-17
C78	VPWR#3	B1#5	2.2308e-19
C79	a_280_107##4	A2#1	8.63288e-19
C80	A2#4	VGND#4	2.5383e-17
C81	a_280_107#	B1#6	2.01633e-19
C82	Y#2	A2#1	9.14398e-19
C83	a_280_107##4	A2#4	1.76316e-17
C84	VGND#4	B1#6	2.14534e-18
C85	VGND#3	A2#1	4.84532e-19
C86	a_280_107##2	A1#1	1.80152e-17
C87	a_131_368##3	Y#4	5.77116e-17
C88	Y#2	A2#4	3.3929e-17
C89	a_280_107##4	B1#6	2.94615e-18
C90	A2	A1#4	1.18497e-17
C91	A2	A2#3	7.19676e-18
C92	VGND#3	A2#4	7.27151e-19
C93	a_131_368##5	a_131_368##3	2.4622e-18
C94	B1#6	Y#2	3.54391e-17
C95	a_280_107##2	A1#6	1.09283e-17
C96	VPWR#4	VPWR#3	2.52379e-17
C97	a_131_368##5	Y#4	9.03335e-17
C98	VGND#3	B1#6	4.63597e-17
C99	a_280_107##2	A2#5	1.97216e-19
C100	a_280_107##4	A1#1	1.76683e-19
C101	a_280_107##2	A2#6	1.22237e-19
C102	a_280_107##4	A1#6	7.93777e-18
C103	A2#3	VPWR#6	4.14127e-19
C104	a_131_368#	A1#1	4.49184e-17
C105	Y	A2#3	1.57205e-18
C106	a_280_107##2	B1#1	1.42522e-19
C107	a_280_107##4	A2#5	1.31198e-17
C108	Y	B1#2	2.16231e-17
C109	A1#5	A1#3	4.1052e-17
C110	A1#1	VPWR#5	2.73393e-17
C111	a_131_368#	A1#6	1.58151e-18
C112	a_280_107##4	A2#6	1.92155e-17
C113	A1#6	VPWR#5	2.7727e-17
C114	VPWR#6	A1#1	1.70882e-19
C115	A2#1	A1#5	4.10501e-17
C116	A1#6	a_131_368##6	2.32435e-17
C117	a_280_107##4	B1#1	1.67349e-17
C118	VPWR#5	A2#5	6.13345e-19
C119	VPWR#6	A1#6	3.90617e-19
C120	Y#2	B1#1	1.64186e-18
C121	a_131_368##2	A2#2	4.30884e-19
C122	A2#5	a_131_368##6	2.32435e-17
C123	Y#4	A1#1	4.17966e-19
C124	VPWR#5	A2#6	1.45546e-19
C125	A2#4	A2#1	1.67105e-17
C126	a_131_368##3	A2#3	4.84504e-19
C127	A2#5	VPWR#6	2.85593e-17
C128	Y#4	A1#6	4.56812e-19
C129	B1#6	A2#1	1.84641e-19
C130	a_131_368##3	A2#5	1.31301e-18
C131	A1#7	A2#2	1.34671e-18
C132	A2#6	VPWR#6	2.98918e-17
C133	Y#4	A2#5	8.89554e-19
C134	B1#6	A2#4	3.18268e-18
C135	a_131_368##3	A2#6	5.6678e-17
C136	Y#4	A2#6	2.85046e-18
C137	a_131_368##3	B1#1	3.53341e-17
C138	a_131_368##5	A2#6	1.95706e-19
C139	Y#4	B1#1	4.84065e-17
C140	a_131_368##3	B1#5	8.78501e-19
C141	a_131_368##5	B1#1	9.24104e-19
C142	a_280_107##2	A2#2	9.25707e-20
C143	Y#4	B1#5	4.77186e-17
C144	Y#1	A2#2	1.48428e-17
C145	a_131_368##5	B1#5	4.04417e-17
C146	A2#2	VGND#4	8.23031e-19
C147	a_131_368##3	VPWR#4	3.99703e-17
C148	A2#2	a_280_107##4	1.95656e-17
C149	A1#6	A1#1	4.6994e-17
C150	Y#4	B1#2	9.40333e-19
C151	a_131_368##5	VPWR#4	5.63325e-17
C152	a_280_107##4	B1#4	9.45968e-19
C153	A2#5	A1#6	4.57488e-17
C154	VGND#3	B1#4	7.39836e-18
C155	A2#2	VPWR#6	9.83174e-19
C156	a_131_368##3	A2#2	4.50178e-20
C157	A2#6	A2#5	3.60858e-17
C158	A1#4	VNB	5.91246e-17
C159	A2#3	VNB	2.61101e-17
C160	B1#2	VNB	2.50149e-17
C161	B1#1	A2#6	4.55917e-17
C162	B1#4	a_131_368##5	4.27448e-18
C163	B1#2	a_131_368##5	3.18102e-18
C164	A2#2	A2#1	3.62457e-18
C165	B1#5	B1#1	4.63504e-17
C166	A2#4	A2#2	1.5603e-18
C167	A2	A1#7	1.67087e-17
C168	VPWR#4	A2#6	5.33919e-18
C169	A1	a_280_107##2	5.60938e-17
C170	B1#4	A2#4	1.632e-19
C171	VGND#3	B1	2.10364e-17
C172	VPWR#4	B1#1	4.50109e-18
C173	VPWR#4	B1#5	4.47622e-18
C174	A2	a_280_107##2	5.80317e-18
C175	A2#2	A2#5	2.11255e-18
C176	Y#1	A2	3.48242e-17
C177	VPWR	VPWR#3	2.93642e-17
C178	a_280_107##4	A2	8.79922e-17
C179	VPWR	a_131_368##2	1.84543e-17
C180	Y	a_280_107##4	3.32794e-17
C181	Y#2	Y	1.53112e-17
C182	VPWR#4	B1#4	1.21032e-18
C183	VPWR	a_280_107##2	5.7139e-18
C184	A2	A1#3	1.30025e-18
C185	VGND	A1#7	3.54453e-18
C186	A2	A1#5	3.13584e-18
C187	VPWR	a_280_107##4	7.35567e-18
C188	A2	A2#1	5.96915e-19
C189	A1	A1#1	1.85021e-18
C190	A2	A2#4	3.65082e-18
C191	Y	a_131_368##5	2.82965e-17
C192	VPWR	a_131_368#	1.68789e-17
C193	A1	A1#6	1.29169e-18
C194	VPWR#3	VNB	2.04363e-17
C195	VGND	a_280_107##2	2.22146e-17
C196	A1	A2#5	1.33101e-19
C197	VGND	Y#1	1.3879e-17
C198	VGND	a_280_107#	1.70561e-17
C199	A2	A1#1	4.43455e-19
C200	a_131_368##2	VNB	2.08637e-18
C201	VPWR	a_131_368##3	2.1978e-17
C202	VGND	VGND#4	1.68647e-17
C203	Y	A2#4	1.77826e-19
C204	A2	A1#6	1.56316e-18
C205	VGND	a_280_107##4	4.81163e-18
C206	VPWR	Y#4	8.41756e-18
C207	VGND	Y#2	3.06946e-17
C208	Y	B1#6	1.25062e-18
C209	VPWR	a_131_368##5	2.38448e-17
C210	A1#7	VNB	4.18022e-18
C211	B1	VPWR#4	2.58721e-18
C212	VGND	VGND#3	4.90904e-17
C213	A2	A2#6	1.53009e-18
C214	A2	B1#1	2.51803e-18
C215	a_280_107##2	VNB	8.79713e-17
C216	Y#1	VNB	5.9267e-19
C217	a_280_107#	VNB	2.64069e-18
C218	Y	A2#6	1.70539e-19
C219	VGND#4	VNB	9.433e-18
C220	a_280_107##4	VNB	8.45248e-18
C221	VGND	A1#3	1.66469e-18
C222	VPWR	A1#1	1.43604e-18
C223	Y	B1#1	8.64795e-18
C224	Y#2	VNB	2.58904e-17
C225	B1	B1#4	2.07571e-17
C226	VGND	A1#5	9.65727e-19
C227	VPWR	A1#6	5.96973e-19
C228	VGND#3	VNB	8.24512e-17
C229	VGND	A2#1	1.51579e-18
C230	A1	A2#2	8.69388e-19
C231	a_131_368#	VNB	4.08423e-17
C232	VPWR	A2#5	8.73155e-20
C233	VPWR#5	VNB	2.70024e-18
C234	VGND	A2#4	1.04541e-17
C235	VPWR	A2#6	4.18865e-19
C236	VGND	B1#6	5.18989e-18
C237	VPWR#6	VNB	2.93817e-18
C238	Y	VPWR#4	5.05018e-19
C239	VPWR	B1#1	1.52008e-18
C240	a_131_368##3	VNB	2.39859e-18
C241	A2	A2#2	1.35173e-17
C242	Y#4	VNB	3.77459e-18
C243	VPWR	B1#5	2.51957e-18
C244	a_131_368##5	VNB	5.42319e-17
C245	A1#3	VNB	3.32321e-17
C246	A1#5	VNB	3.0323e-17
C247	VPWR	VPWR#4	4.63387e-17
C248	A2#1	VNB	2.97538e-17
C249	A2#4	VNB	4.19698e-17
C250	B1#6	VNB	5.12624e-17
C251	Y	B1#4	1.57174e-17
C252	A1#1	VNB	4.22563e-17
C253	VPWR	A2#2	1.18544e-18
C254	A1#6	VNB	3.37359e-17
C255	A2#5	VNB	3.05875e-17
C256	VPWR	B1#4	1.54021e-18
C257	A2#6	VNB	3.64871e-17
C258	B1#1	VNB	4.73658e-17
C259	B1#5	VNB	4.02761e-17
C260	VGND	A2#2	1.62088e-18
C261	A2	A1	1.21075e-17
C262	B1	Y	3.61123e-17
C263	VPWR#4	VNB	2.44002e-16
C264	VPWR	B1	7.13965e-18
C265	A2#2	VNB	2.76642e-17
C266	VPWR	A1	2.527e-18
C267	B1#4	VNB	7.63426e-17
C268	VGND	B1	2.90806e-18
C269	VPWR	A2	3.81208e-18
C270	VPWR	Y	3.63931e-18
C271	VGND	A2	4.77381e-18
C272	B1	VNB	2.61862e-17
C273	A1	VNB	2.30685e-18
C274	VGND	Y	5.23249e-18
C275	A2	VNB	8.84911e-18
C276	Y	VNB	1.40412e-17
C277	VPWR	VNB	7.3165e-17
C278	VGND	VNB	6.68423e-17
C279	VPWR#2	VNB	4.63681e-17
C280	VPWR	VPWR#2	4.12242e-17
C281	VGND#2	A1#5	5.18001e-18
C282	VPWR#4	VPWR#2	5.11247e-17
C283	VPWR#2	A2#6	8.26432e-20
C284	VPWR#2	A2#5	5.44568e-19
C285	VPWR#2	A1#6	5.26359e-18
C286	VPWR#2	A1#1	5.53474e-18
C287	a_131_368#	VPWR#2	2.12999e-17
C288	VGND#2	B1#2	1.64918e-19
C289	a_131_368##2	VPWR#2	8.21926e-18
C290	VPWR#3	VPWR#2	7.36828e-19
C291	VGND#2	B1#1	1.29732e-19
C292	VGND#2	B1#4	3.75819e-20
C293	VGND#2	a_280_107#	2.68166e-17
C294	VGND	VGND#2	7.4772e-17
C295	VGND#2	a_280_107##2	3.58415e-17
C296	VGND#2	A2#1	4.53792e-18
C297	VGND#2	Y#2	1.2184e-17
C298	VGND#2	A1#3	5.12723e-18
C299	VGND#2	VNB	2.72439e-16
C300	VGND#2	A1#4	7.70196e-20
C301	VGND#2	Y#1	1.63142e-18
C302	VGND#2	A2#4	5.77866e-18
C303	VGND#2	VGND#3	4.42399e-17
*
*
.ENDS sky130_fd_sc_hs__a21oi_2
*
