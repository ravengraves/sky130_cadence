* Extracted by Quantus, converted by sky130cad/quantus.py
*
*
*
*                       LINUX           Wed Nov 18 08:16:48 2026
*
*
*
*  PROGRAM  advgen
*
*  Name           : advgen - Quantus - (64-bit)
*  Version        : 25.1.0-p047
*  Build Date     : Thu Dec 11 23:20:30 PST 2025
*
*  HSPICE LIBRARY
*
*  OPERATING_TEMPERATURE 150
*  QRC_TECH_DIR <path>/tech
*
*
*

*
.SUBCKT sky130_fd_sc_hs__and2b_2 VPB VNB VGND VPWR X B A_N
*
*
*  caps2d version: 10
*
*
*       TRANSISTOR CARDS
*
*
XM9 a_27_74##6 A_N#3 VGND#6 VNB sky130_fd_pr__nfet_01v8_lvt l=0.15 w=0.55 ad=0.15675 as=0.2785 pd=1.67 ps=2.32
XM1 VGND#6 a_198_48##4 X#1 VNB sky130_fd_pr__nfet_01v8_lvt l=0.15 w=0.74 ad=0.2785 as=0.2072 pd=2.32 ps=2.04
XM4 X#1 a_198_48##5 VGND#5 VNB sky130_fd_pr__nfet_01v8_lvt l=0.15 w=0.74 ad=0.2072 as=0.5957 pd=2.04 ps=3.09
XM7 VGND#5 B#1 a_505_74# VNB sky130_fd_pr__nfet_01v8_lvt l=0.15 w=0.74 ad=0.5957 as=0.1776 pd=3.09 ps=1.96
XM5 a_505_74# a_27_74##3 a_198_48##7 VNB sky130_fd_pr__nfet_01v8_lvt l=0.15 w=0.74 ad=0.1776 as=0.2109 pd=1.96 ps=2.05
XM0 a_27_74##7 A_N#1 VPWR#5 VPB sky130_fd_pr__pfet_01v8 l=0.15 w=0.84 ad=0.2478 as=0.5041 pd=2.27 ps=3.2
XM3 X#2 a_198_48##6 VPWR#5 VPB sky130_fd_pr__pfet_01v8 l=0.15 w=1.12 ad=0.336 as=0.5041 pd=2.84 ps=3.2
XM8 VPWR#3 a_198_48# X#2 VPB sky130_fd_pr__pfet_01v8 l=0.15 w=1.12 ad=0.73455 as=0.336 pd=3.6 ps=2.84
XM2 VPWR#3 B#3 a_198_48##9 VPB sky130_fd_pr__pfet_01v8 l=0.15 w=1 ad=0.73455 as=0.3 pd=3.6 ps=2.6
XM6 a_198_48##9 a_27_74# VPWR#1 VPB sky130_fd_pr__pfet_01v8 l=0.15 w=1 ad=0.3 as=0.295 pd=2.6 ps=2.59
*
*
*       RESISTOR AND CAP/DIODE CARDS
*
Rg1	A_N#1	A_N#2	349.716187
Rg2	A_N#2	A_N#3	432.474274
Rg3	a_198_48#	a_198_48##2	454.031555
Rg4	a_198_48##2	a_198_48##3	91.059822
Rg5	a_198_48##3	a_198_48##4	374.534637
Rg6	a_198_48##2	a_198_48##5	373.967499
Rg7	a_198_48##3	a_198_48##6	473.258270
Rg8	B#1	B#2	307.937683
Rg9	B#2	B#3	479.379059
Rg10	a_27_74#	a_27_74##2	444.577118
Rg11	a_27_74##2	a_27_74##3	353.846649
Rf1	A_N#4	A_N#2	162.448425
Rf2	A_N	A_N#6	2.215620
Rf3	A_N#4	A_N#6	4.635897
Rf4	X#1	X#3	83.003326
Rf5	X#3	X	1.528014
Rf6	X#2	X#3	15.000000
Rf7	B	B#4	1.236861
Rf8	B#5	B#2	161.469666
Rf9	B#4	B#5	7.059660
Rf10	a_27_74##2	a_27_74##5	384.819763
Rf11	a_27_74##5	a_27_74##6	127.327293
Rf12	a_27_74##5	a_27_74##7	19.843185
Rf13	a_198_48##7	a_198_48##8	128.934296
Rf14	a_198_48##8	a_198_48##9	81.973831
Rf15	VPWR#1	VPWR#2	137.555527
Rf16	VPWR#2	VPWR#3	27.496794
Rf17	VPWR#2	VPWR#4	63.164146
Rf18	VPWR#4	VPWR#5	31.554951
Rf21	VGND#2	VGND#3	65.720917
Rf23	VGND#2	VGND#5	16.303333
Rf24	VGND#3	VGND#6	36.672695
Rf28	a_198_48##2	a_198_48##8	160.232803
Re1	VPWR#2	VPWR	1.403190
Re2	VGND	VGND#2	1.403242
*
*       CAPACITOR CARDS
*
*
C1	VPWR#2	a_198_48##3	4.85137e-20
C2	A_N#4	a_198_48##3	9.31329e-19
C3	a_198_48##7	B#5	2.76524e-17
C4	a_198_48##3	a_198_48##2	3.8062e-18
C5	a_198_48##7	B#4	2.7346e-18
C6	A_N#2	a_198_48##3	1.51552e-17
C7	B#5	a_198_48##9	1.41307e-17
C8	B#4	a_198_48##9	9.81014e-18
C9	X#1	a_198_48##7	1.89347e-18
C10	a_27_74##6	A_N#4	3.92914e-17
C11	a_198_48##7	VPWR#1	1.31846e-18
C12	VGND#6	X#1	5.06785e-17
C13	X#1	a_198_48##3	6.20879e-18
C14	a_198_48##7	a_198_48##9	5.30121e-18
C15	a_27_74##6	X#1	2.49957e-17
C16	B#5	a_27_74##3	2.37417e-18
C17	a_27_74##6	VGND#6	7.72209e-17
C18	A_N#4	a_27_74##7	2.00381e-17
C19	B#4	a_198_48##5	2.03122e-19
C20	a_198_48##7	a_27_74##3	4.60444e-17
C21	a_198_48##7	B#1	3.11935e-17
C22	a_27_74##7	X#1	2.03935e-18
C23	a_27_74##6	a_198_48##3	1.44718e-18
C24	a_198_48##7	a_198_48##5	1.07323e-18
C25	X#1	a_27_74##3	4.65148e-19
C26	B#1	VGND#5	2.36699e-17
C27	a_27_74##6	a_27_74##7	2.79557e-18
C28	A_N	a_198_48##3	2.68511e-19
C29	X#1	B#1	1.37751e-18
C30	a_198_48##5	VGND#5	9.83601e-18
C31	VGND#6	B#1	8.69306e-20
C32	X#1	a_198_48##5	4.29325e-17
C33	a_198_48##9	a_27_74##7	1.74627e-17
C34	VGND#6	a_198_48##5	6.13422e-19
C35	a_27_74##7	VPWR#3	5.18308e-18
C36	X#1	a_198_48##4	3.75817e-17
C37	a_198_48##4	VGND#6	1.85948e-17
C38	a_27_74##7	X#2	4.16574e-18
C39	X#1	A_N#3	1.10097e-18
C40	a_27_74##6	a_198_48##4	5.24542e-18
C41	a_27_74##7	VPWR#5	5.67091e-17
C42	A_N#3	VGND#6	2.13987e-17
C43	a_27_74##6	A_N#3	4.33326e-17
C44	B#1	a_27_74##3	4.96648e-17
C45	VPWR#1	a_27_74#	2.73472e-17
C46	X	a_198_48##3	1.32452e-17
C47	a_198_48##9	a_27_74#	3.18187e-17
C48	VPWR#1	B#3	5.06774e-18
C49	a_198_48##5	B#1	5.20049e-18
C50	a_198_48##9	B#3	4.32394e-17
C51	VPWR#1	a_198_48#	1.29745e-18
C52	B#3	VPWR#3	2.37006e-17
C53	B#5	a_27_74##2	2.49035e-17
C54	a_198_48##4	a_198_48##5	3.8532e-17
C55	a_198_48#	VPWR#3	2.38399e-17
C56	a_27_74##7	a_27_74#	4.01768e-19
C57	a_198_48#	X#2	2.59374e-17
C58	B#5	B#2	1.61641e-17
C59	a_27_74##7	B#3	6.22298e-19
C60	B#4	B#2	7.1279e-18
C61	VPWR#5	a_198_48#	4.28224e-18
C62	A_N#3	a_198_48##4	2.11389e-17
C63	a_198_48##6	X#2	2.59374e-17
C64	a_27_74##7	a_198_48#	2.61134e-17
C65	a_27_74##2	a_198_48##7	4.82827e-17
C66	a_198_48##6	VPWR#5	2.65682e-17
C67	a_198_48##2	B#4	5.98922e-17
C68	a_27_74##7	a_198_48##6	3.33099e-17
C69	VPWR#2	VPWR#1	3.72557e-17
C70	A_N#1	VPWR#5	2.93101e-17
C71	a_198_48##7	B#2	1.13478e-18
C72	a_27_74##7	A_N#1	5.68787e-17
C73	a_198_48##3	X#2	1.62281e-20
C74	VPWR#2	VPWR#3	9.01738e-18
C75	B#2	VGND#5	6.72187e-19
C76	a_198_48##2	a_198_48##7	2.19892e-18
C77	X#1	B#2	1.19642e-19
C78	a_27_74##2	VPWR#1	4.82098e-17
C79	VPWR#5	VPWR#2	9.64914e-18
C80	VGND	a_198_48##3	8.21682e-19
C81	a_198_48##2	VGND#5	8.40089e-18
C82	a_27_74##2	a_198_48##9	8.42379e-17
C83	A_N#4	A_N#2	1.45379e-17
C84	a_27_74##7	VPWR#2	6.58075e-17
C85	B#3	a_27_74#	4.77219e-17
C86	X#1	a_198_48##2	3.55038e-17
C87	a_27_74##2	X#2	3.45767e-20
C88	a_198_48##9	B#2	1.72611e-18
C89	X#1	A_N#2	5.05867e-19
C90	a_198_48#	B#3	1.2285e-17
C91	a_27_74##6	A_N#2	1.1299e-17
C92	a_198_48##2	VPWR#3	3.4379e-18
C93	a_27_74##7	B#2	3.64322e-19
C94	a_198_48##7	a_505_74#	6.93793e-18
C95	a_198_48##6	a_198_48#	5.06968e-17
C96	B#2	a_27_74##3	1.85284e-18
C97	a_198_48##2	a_27_74##7	4.40293e-17
C98	VPWR#2	a_27_74#	4.36845e-18
C99	a_198_48##3	VNB	2.73461e-17
C100	a_198_48##2	a_27_74##3	3.95072e-19
C101	a_198_48##5	B#2	3.20531e-19
C102	A_N#1	a_198_48##6	2.04067e-17
C103	VPWR#2	B#3	2.17028e-17
C104	a_198_48##2	B#1	9.85311e-19
C105	A_N#2	a_27_74##7	1.00139e-17
C106	VPWR#2	a_198_48#	2.50794e-17
C107	a_198_48##2	a_198_48##5	5.65315e-18
C108	a_27_74##2	a_27_74#	2.08722e-17
C109	a_198_48##2	a_198_48##4	1.84815e-20
C110	VPWR#2	a_198_48##6	5.27008e-18
C111	a_27_74##2	B#3	2.868e-17
C112	VPWR#2	A_N#1	9.96564e-19
C113	a_27_74##2	a_198_48#	5.53386e-19
C114	A_N#2	a_198_48##4	1.74746e-18
C115	a_198_48##2	a_27_74#	1.42635e-19
C116	a_27_74##2	a_198_48##6	2.56253e-19
C117	a_27_74##7	a_198_48##3	6.09431e-18
C118	a_27_74##3	a_505_74#	1.65047e-17
C119	a_198_48##2	B#3	7.10688e-19
C120	B#1	a_505_74#	1.58072e-17
C121	a_198_48##2	a_198_48#	5.63355e-18
C122	a_198_48##2	a_198_48##6	7.3963e-20
C123	a_27_74##2	VPWR#2	4.7791e-18
C124	A_N#2	a_198_48##6	6.04212e-19
C125	VPWR#2	B#2	3.81228e-19
C126	VPWR#2	a_198_48##2	4.63223e-19
C127	A_N	a_27_74##7	5.84266e-17
C128	VPWR	B#5	1.84998e-18
C129	B#2	a_27_74##2	3.54741e-17
C130	VPWR	B#4	1.8589e-18
C131	X#1	X	3.0575e-18
C132	a_198_48##2	a_27_74##2	5.29212e-18
C133	a_198_48##2	B#2	1.87959e-17
C134	X	X#2	3.02716e-19
C135	VGND	B#5	1.75505e-18
C136	VGND	B#4	1.73994e-18
C137	a_27_74##7	X	1.03393e-16
C138	VPWR	VPWR#1	3.59011e-17
C139	VPWR	a_198_48##9	4.37122e-18
C140	VGND	A_N#4	3.08761e-18
C141	VGND	a_198_48##7	2.38816e-17
C142	A_N	a_198_48##6	1.68034e-19
C143	VPWR	VPWR#5	1.78734e-17
C144	A_N	A_N#1	3.0913e-18
C145	VGND	X#1	1.65265e-17
C146	VPWR	a_27_74##7	3.06064e-17
C147	VGND	a_27_74##6	1.99558e-17
C148	B#5	VNB	1.72705e-18
C149	B#4	VNB	5.43857e-18
C150	VGND	a_198_48##9	4.29326e-18
C151	X	B#3	2.83699e-20
C152	X	a_198_48#	1.04276e-17
C153	A_N#4	VNB	1.35397e-17
C154	a_198_48##7	VNB	4.14599e-17
C155	X	a_198_48##6	1.17498e-17
C156	VGND	a_27_74##3	1.79747e-18
C157	VPWR	a_27_74#	3.52212e-18
C158	X	A_N#1	1.09876e-18
C159	X#1	VNB	2.4923e-18
C160	VGND	B#1	3.86382e-19
C161	VPWR	B#3	7.5838e-18
C162	VGND#6	VNB	2.59754e-18
C163	VGND	a_198_48##5	1.73906e-18
C164	a_27_74##6	VNB	4.67628e-17
C165	VPWR#1	VNB	5.28732e-17
C166	VGND	a_198_48##4	4.85179e-18
C167	a_198_48##9	VNB	5.40877e-18
C168	VPWR	a_198_48##6	7.6042e-19
C169	VGND	A_N#3	1.14572e-18
C170	A_N	A_N#2	8.82255e-18
C171	VPWR	A_N#1	6.62551e-18
C172	VPWR#5	VNB	1.40858e-17
C173	a_27_74##7	VNB	4.91471e-17
C174	a_27_74##3	VNB	3.10342e-17
C175	VPWR	VPWR#2	7.24858e-17
C176	X	B#2	1.92183e-20
C177	B#1	VNB	2.35536e-17
C178	a_198_48##5	VNB	2.78399e-17
C179	X	a_198_48##2	6.72844e-17
C180	a_198_48##4	VNB	2.90142e-17
C181	VPWR	a_27_74##2	1.30856e-17
C182	A_N#3	VNB	4.02335e-17
C183	X	A_N#2	5.00168e-19
C184	a_27_74#	VNB	3.46677e-17
C185	VPWR	a_198_48##2	4.0047e-18
C186	B#3	VNB	3.50945e-17
C187	a_198_48#	VNB	3.34365e-17
C188	VGND	a_27_74##2	3.32879e-18
C189	a_198_48##6	VNB	3.6074e-17
C190	A_N#1	VNB	4.52121e-17
C191	VGND	B#2	6.64159e-20
C192	VGND	a_198_48##2	1.0848e-17
C193	VPWR#2	VNB	2.05609e-16
C194	a_27_74##2	VNB	9.66689e-17
C195	B#2	VNB	3.79662e-17
C196	a_198_48##2	VNB	4.06695e-17
C197	VPWR	A_N	2.95296e-18
C198	A_N#2	VNB	6.33014e-17
C199	VPWR	X	4.2148e-18
C200	A_N	VNB	1.09545e-17
C201	VGND	X	1.22524e-18
C202	X	VNB	4.91815e-19
C203	VPWR	VNB	5.46346e-17
C204	VGND	VNB	6.03322e-17
C205	VGND#3	a_27_74##6	2.10084e-17
C206	VGND#3	A_N#2	1.21963e-19
C207	VGND#3	A_N#3	5.86577e-18
C208	VGND#3	X#1	7.64503e-18
C209	VGND#3	a_198_48##5	7.97468e-19
C210	VGND	VGND#3	5.45085e-17
C211	VGND#2	VGND#3	5.63258e-17
C212	VPWR#4	A_N#1	3.27679e-18
C213	a_27_74##7	VPWR#4	1.13258e-17
C214	VPWR#2	VPWR#4	5.62215e-17
C215	VPWR	VPWR#4	3.83603e-17
C216	VGND#2	a_198_48##7	4.7049e-17
C217	VGND#3	a_198_48##3	4.05638e-20
C218	VGND#2	B#1	2.43657e-17
C219	VGND#2	a_27_74##2	1.14951e-19
C220	VPWR#4	VNB	5.07129e-17
C221	VGND#2	VNB	2.3262e-16
C222	VGND#2	VGND#5	1.07326e-17
C223	VGND#2	a_198_48##4	1.19658e-18
C224	VGND#2	a_198_48##2	4.2466e-17
C225	VGND#6	VGND#2	1.99943e-18
C226	VGND#3	a_198_48##4	6.72301e-18
C227	VGND#3	VNB	5.10638e-17
C228	VPWR#4	a_198_48##6	8.42012e-18
C229	VGND#3	B#1	5.58491e-20
C230	VGND#2	a_198_48##3	4.58266e-20
C231	VPWR#4	a_198_48##3	9.86051e-21
C232	VGND#2	a_27_74##3	1.21255e-17
C233	VGND	VGND#2	9.16377e-17
C234	VGND#2	a_198_48##5	1.59166e-17
C235	VGND#2	B#2	1.08654e-18
C236	VGND#2	X#1	3.49032e-17
C237	VGND#2	A_N#3	6.62637e-19
C238	VPWR#4	A_N#2	8.74503e-20
*
*
.ENDS sky130_fd_sc_hs__and2b_2
*
