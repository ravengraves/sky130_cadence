* Extracted by Quantus, converted by sky130cad/quantus.py
*
*
*
*                       LINUX           Wed Nov 18 08:12:01 2026
*
*
*
*  PROGRAM  advgen
*
*  Name           : advgen - Quantus - (64-bit)
*  Version        : 25.1.0-p047
*  Build Date     : Thu Dec 11 23:20:30 PST 2025
*
*  HSPICE LIBRARY
*
*  OPERATING_TEMPERATURE 150
*  QRC_TECH_DIR <path>/tech
*
*
*

*
.SUBCKT sky130_fd_sc_hs__a311oi_2 VPB VNB VGND VPWR Y A3 A2 A1 B1 C1
*
*
*  caps2d version: 10
*
*
*       TRANSISTOR CARDS
*
*
XM7 a_45_74##3 A3#5 VGND#7 VNB sky130_fd_pr__nfet_01v8_lvt l=0.15 w=0.74 ad=0.1961 as=0.2072 pd=2.01 ps=2.04
XM13 VGND#7 A3#4 a_45_74# VNB sky130_fd_pr__nfet_01v8_lvt l=0.15 w=0.74 ad=0.2072 as=0.2072 pd=2.04 ps=2.04
XM16 a_300_74# A2#5 a_45_74# VNB sky130_fd_pr__nfet_01v8_lvt l=0.15 w=0.74 ad=0.2072 as=0.2072 pd=2.04 ps=2.04
XM0 a_45_74##4 A2#6 a_300_74# VNB sky130_fd_pr__nfet_01v8_lvt l=0.15 w=0.74 ad=0.1961 as=0.2072 pd=2.01 ps=2.04
XM1 Y#4 A1#6 a_300_74##2 VNB sky130_fd_pr__nfet_01v8_lvt l=0.15 w=0.74 ad=0.1961 as=0.2072 pd=2.01 ps=2.04
XM17 a_300_74##2 A1#1 Y#7 VNB sky130_fd_pr__nfet_01v8_lvt l=0.15 w=0.74 ad=0.2072 as=0.2072 pd=2.04 ps=2.04
XM6 Y#7 B1#4 VGND#6 VNB sky130_fd_pr__nfet_01v8_lvt l=0.15 w=0.74 ad=0.2072 as=0.5106 pd=2.04 ps=2.86
XM15 VGND#6 C1#4 Y#5 VNB sky130_fd_pr__nfet_01v8_lvt l=0.15 w=0.74 ad=0.5106 as=0.1961 pd=2.86 ps=2.01
XM2 a_127_368##4 A3#6 VPWR#8 VPB sky130_fd_pr__pfet_01v8 l=0.15 w=1.12 ad=0.336 as=0.308 pd=2.84 ps=2.79
XM8 VPWR#7 A3#1 a_127_368##4 VPB sky130_fd_pr__pfet_01v8 l=0.15 w=1.12 ad=0.336 as=0.336 pd=2.84 ps=2.84
XM4 a_127_368##6 A2#7 VPWR#7 VPB sky130_fd_pr__pfet_01v8 l=0.15 w=1.12 ad=0.336 as=0.336 pd=2.84 ps=2.84
XM9 VPWR#5 A2#1 a_127_368##6 VPB sky130_fd_pr__pfet_01v8 l=0.15 w=1.12 ad=0.3696 as=0.336 pd=2.9 ps=2.84
XM10 a_127_368##5 A1#5 VPWR#5 VPB sky130_fd_pr__pfet_01v8 l=0.15 w=1.12 ad=0.336 as=0.3696 pd=2.84 ps=2.9
XM3 VPWR#3 A1#7 a_127_368##5 VPB sky130_fd_pr__pfet_01v8 l=0.15 w=1.12 ad=0.308 as=0.336 pd=2.79 ps=2.84
XM5 a_127_368# B1#5 a_692_368##3 VPB sky130_fd_pr__pfet_01v8 l=0.15 w=1.12 ad=0.336 as=0.308 pd=2.84 ps=2.79
XM11 a_692_368##4 B1#1 a_127_368# VPB sky130_fd_pr__pfet_01v8 l=0.15 w=1.12 ad=0.336 as=0.336 pd=2.84 ps=2.84
XM14 Y#1 C1#5 a_692_368##4 VPB sky130_fd_pr__pfet_01v8 l=0.15 w=1.12 ad=0.336 as=0.336 pd=2.84 ps=2.84
XM12 a_692_368# C1#1 Y#1 VPB sky130_fd_pr__pfet_01v8 l=0.15 w=1.12 ad=0.308 as=0.336 pd=2.79 ps=2.84
*
*
*       RESISTOR AND CAP/DIODE CARDS
*
Rg1	A3#1	A3#2	516.620850
Rg2	A3#2	A3#3	56.190357
Rg3	A3#2	A3#4	329.212952
Rg4	A3#3	A3#5	326.544525
Rg5	A3#3	A3#6	509.023376
Rg6	A2#1	A2#2	512.399292
Rg7	A2#2	A2#3	17.800245
Rg8	A2#3	A2#4	51.273705
Rg9	A2#4	A2#5	320.892242
Rg10	A2#2	A2#6	328.502533
Rg11	A2#4	A2#7	506.023621
Rg12	A1#1	A1#2	492.875366
Rg13	A1#2	A1#3	17.902014
Rg14	A1#3	A1#4	59.210228
Rg15	A1#4	A1#5	466.587219
Rg16	A1#2	A1#6	380.397400
Rg17	A1#3	A1#7	421.875183
Rg18	B1#1	B1#2	466.290192
Rg19	B1#2	B1#3	22.738758
Rg20	B1#3	B1#4	394.232941
Rg21	B1#3	B1#5	449.668243
Rg22	C1#1	C1#2	451.603058
Rg23	C1#2	C1#3	41.441631
Rg24	C1#3	C1#4	392.634735
Rg25	C1#3	C1#5	450.494476
Rf1	A3#3	A3	163.451233
Rf2	A2#3	A2	100.622910
Rf3	a_45_74#	a_45_74##2	16.988226
Rf4	a_45_74##2	a_45_74##3	79.234406
Rf5	a_45_74##2	a_45_74##4	60.009628
Rf6	A1	A1#4	118.016724
Rf7	a_300_74#	a_300_74##2	105.309441
Rf8	a_127_368#	a_127_368##2	120.043129
Rf9	a_127_368##2	a_127_368##3	80.048515
Rf10	a_127_368##3	a_127_368##4	87.602989
Rf11	a_127_368##2	a_127_368##5	31.761475
Rf12	a_127_368##3	a_127_368##6	25.098005
Rf13	B1	B1#6	1.986418
Rf14	B1#6	B1	12.682514
Rf15	C1#2	C1	166.137894
Rf16	a_692_368#	a_692_368##2	80.804855
Rf17	a_692_368##2	a_692_368##3	81.642052
Rf18	a_692_368##2	a_692_368##4	23.228060
Rf19	Y#1	Y	83.271149
Rf20	Y	Y#2	16.645428
Rf21	Y#2	Y#3	84.744591
Rf22	Y#3	Y#4	51.233261
Rf23	Y#2	Y	2.786005
Rf24	Y#6	Y	10.805780
Rf25	Y#6	Y	10.805780
Rf26	Y#3	Y#7	14.723639
Rf27	Y#5	Y#6	7.500000
Rf29	VGND#2	VGND#3	97.496353
Rf30	VGND#3	VGND#4	153.381516
Rf32	VGND#2	VGND#6	20.574043
Rf33	VGND#4	VGND#7	33.326477
Rf35	VPWR#2	VPWR#3	36.016815
Rf36	VPWR#2	VPWR#4	50.414055
Rf37	VPWR#4	VPWR#5	40.870590
Rf38	VPWR#4	VPWR#6	69.870483
Rf39	VPWR#6	VPWR#7	61.544025
Rf40	VPWR#6	VPWR#8	117.599754
Rf44	B1#2	B1#6	80.116402
Re1	VPWR#2	VPWR	0.818510
Re2	VGND	VGND#3	0.818540
*
*       CAPACITOR CARDS
*
*
C1	VPWR#4	A2#7	2.75019e-19
C2	VGND	VNB	8.89283e-17
C3	VPWR	VNB	7.97941e-17
C4	Y	VNB	1.07068e-16
C5	a_127_368##2	B1#1	2.00438e-19
C6	A2	VNB	6.03956e-18
C7	VGND	Y	1.77083e-17
C8	A1	VNB	6.43742e-18
C9	a_300_74#	A2#5	2.5497e-17
C10	B1	VNB	1.57336e-17
C11	C1	VNB	9.72318e-18
C12	VPWR	Y	5.8637e-18
C13	VGND	A2	2.32768e-18
C14	VGND	A1	2.93776e-18
C15	VGND	B1	7.26879e-18
C16	VPWR	A2	1.34851e-18
C17	VPWR#6	A2#7	7.11581e-18
C18	VGND	C1	2.76529e-18
C19	Y#4	A3#4	3.15158e-19
C20	A3#3	VNB	6.00236e-17
C21	VPWR	A1	3.08616e-18
C22	a_127_368##6	VPWR#5	7.00438e-17
C23	A2#3	VNB	4.53811e-17
C24	A1#4	VNB	4.0219e-17
C25	VPWR	B1	8.49419e-18
C26	a_45_74#	A2#6	1.60982e-18
C27	VPWR	C1	3.04301e-18
C28	VGND#3	VNB	2.84657e-16
C29	A3#6	VNB	4.7587e-17
C30	VGND	A3#3	3.30738e-18
C31	A3#1	VNB	3.53655e-17
C32	C1	Y	3.01966e-17
C33	VGND	A2#3	5.40968e-18
C34	A2#7	VNB	3.70682e-17
C35	A2#1	VNB	3.56101e-17
C36	VGND	A1#4	3.48133e-18
C37	VGND#7	A1#6	3.04991e-19
C38	A1#5	VNB	2.86727e-17
C39	A1#7	VNB	3.09073e-17
C40	B1#5	VNB	3.51136e-17
C41	B1#1	VNB	3.21999e-17
C42	VGND	VGND#3	3.70664e-17
C43	C1#5	VNB	3.30642e-17
C44	VPWR	A3#3	3.56223e-18
C45	VGND#6	B1#3	2.89442e-18
C46	C1#1	VNB	3.93942e-17
C47	a_300_74##2	A3#4	8.07819e-20
C48	VPWR	A2#3	3.15512e-18
C49	A3#5	VNB	3.09742e-17
C50	A3#4	VNB	2.30795e-17
C51	A1	B1	3.10982e-17
C52	VPWR	A1#4	1.63959e-18
C53	A2#5	VNB	2.52104e-17
C54	a_300_74#	A2#6	3.82944e-17
C55	A2#6	VNB	3.05215e-17
C56	A1#6	VNB	3.25593e-17
C57	a_127_368##2	C1#5	1.21888e-19
C58	A1#1	VNB	4.81855e-17
C59	B1#4	VNB	3.00505e-17
C60	C1#4	VNB	3.15925e-17
C61	VPWR#4	A2#1	7.22942e-18
C62	VPWR#8	VNB	8.79531e-17
C63	a_127_368##4	VNB	8.95054e-18
C64	VPWR#7	VNB	2.92383e-18
C65	B1	C1	3.73975e-17
C66	Y#4	A2#5	5.03668e-19
C67	a_127_368##6	VNB	2.18579e-18
C68	VPWR#5	VNB	4.85317e-19
C69	a_45_74#	A1#6	5.83841e-19
C70	VPWR	A3#6	2.14877e-18
C71	a_127_368##5	VNB	4.59655e-18
C72	VPWR#3	VNB	8.58406e-18
C73	VPWR	A3#1	1.01001e-18
C74	a_692_368##3	VNB	1.19446e-17
C75	a_127_368#	VNB	1.6204e-18
C76	VPWR	A2#7	2.5924e-18
C77	VGND	A3#5	1.58908e-18
C78	Y#1	VNB	2.76223e-19
C79	VGND	A3#4	7.91493e-19
C80	VPWR	A2#1	2.5345e-18
C81	a_692_368#	VNB	4.26793e-17
C82	a_45_74##3	VNB	3.7591e-17
C83	VGND	A2#5	1.63292e-18
C84	VGND#7	VNB	1.79708e-18
C85	VPWR	A1#5	1.25013e-18
C86	A3#3	A2	2.39102e-17
C87	VPWR#6	A2#1	2.81463e-19
C88	a_45_74##4	A2#6	4.30293e-17
C89	a_45_74#	VNB	4.85794e-18
C90	VGND	A2#6	9.95843e-19
C91	a_300_74#	VNB	8.33418e-18
C92	VPWR	A1#7	1.09517e-18
C93	VGND	A1#6	9.15215e-19
C94	a_45_74##4	VNB	3.03686e-18
C95	Y#4	VNB	6.34607e-18
C96	VGND	A1#1	2.966e-18
C97	VPWR	B1#5	1.94755e-18
C98	a_300_74##2	VNB	8.69788e-18
C99	VGND	B1#4	2.38589e-19
C100	VPWR	B1#1	1.51183e-18
C101	VGND#6	VNB	1.24828e-18
C102	VGND	C1#4	1.05117e-18
C103	VPWR#5	a_127_368##5	5.5082e-17
C104	VPWR	C1#5	1.67354e-18
C105	Y#5	VNB	9.36707e-18
C106	a_300_74##2	A2#5	1.15099e-19
C107	VGND	VPWR#8	5.29227e-18
C108	VPWR	C1#1	2.27045e-18
C109	VGND	a_127_368##4	3.79055e-18
C110	a_692_368##2	B1#1	2.21445e-17
C111	A1	A2#3	4.17005e-19
C112	a_127_368##2	VNB	5.95849e-18
C113	a_127_368##3	VNB	4.64703e-18
C114	A1	A1#4	3.37685e-20
C115	a_692_368##2	VNB	4.64529e-18
C116	Y#2	VNB	4.37326e-18
C117	Y#3	VNB	5.21373e-18
C118	Y	B1#5	1.93662e-19
C119	Y#4	A2#6	2.71546e-18
C120	a_45_74#	A1#1	3.28102e-19
C121	B1#3	a_127_368#	2.83019e-18
C122	Y	B1#1	2.28175e-19
C123	VPWR	A1#1	4.27748e-21
C124	Y	C1#5	4.05095e-19
C125	VPWR#4	VNB	2.57683e-17
C126	VGND	a_45_74##3	1.5469e-17
C127	Y	C1#1	3.1906e-18
C128	VPWR#6	VNB	3.14733e-17
C129	VPWR#4	A1#5	4.7483e-18
C130	a_45_74##4	Y#3	2.4073e-18
C131	VGND	VGND#7	1.62591e-17
C132	VGND	a_45_74#	1.08968e-17
C133	VPWR	VPWR#8	3.58328e-17
C134	a_45_74##4	A1#6	3.19047e-18
C135	VGND	a_300_74#	2.60095e-17
C136	VPWR#5	VPWR#3	2.91438e-18
C137	VPWR	a_127_368##4	1.72913e-17
C138	VGND	a_45_74##4	6.81721e-18
C139	VGND	Y#4	6.16618e-18
C140	VGND	a_300_74##2	2.81812e-17
C141	VPWR	a_127_368##6	1.62885e-17
C142	a_300_74##2	A2#6	3.87032e-19
C143	VPWR	a_127_368##5	1.10523e-17
C144	VGND	Y#5	2.01794e-17
C145	VPWR#6	A1#5	7.74347e-20
C146	VPWR	VPWR#3	2.21654e-17
C147	VPWR	a_692_368##3	2.18228e-17
C148	A1	A3#1	4.69815e-20
C149	Y	A1#1	1.62536e-19
C150	VGND	a_45_74##2	5.08388e-18
C151	VPWR	a_127_368#	8.30394e-18
C152	Y	B1#4	2.65342e-20
C153	VGND	a_127_368##2	2.12887e-18
C154	a_692_368##2	C1#5	2.63428e-17
C155	A1	A2#7	6.75846e-20
C156	VGND	a_127_368##3	4.22808e-18
C157	Y	C1#4	1.90053e-19
C158	Y#4	A1#6	4.55105e-17
C159	VPWR	Y#1	6.31135e-18
C160	VPWR	a_692_368#	2.16931e-17
C161	A1	A2#1	1.29976e-19
C162	a_45_74##2	A3#5	8.16844e-20
C163	VGND	Y#2	2.15591e-18
C164	a_127_368##5	VPWR#3	5.21059e-17
C165	A1	A1#5	1.42183e-19
C166	VGND	Y#3	1.88674e-17
C167	a_45_74##4	A1#1	2.68192e-19
C168	A1	A1#7	1.03822e-18
C169	a_45_74##3	VPWR#8	7.68699e-18
C170	A1	B1#5	6.01849e-19
C171	VPWR#4	A1#7	5.29028e-19
C172	Y	a_692_368##3	2.77017e-22
C173	a_300_74##2	A1#6	4.1434e-17
C174	B1	A1#7	1.22791e-19
C175	Y	Y#1	1.47869e-18
C176	VGND#6	A2#6	8.22771e-20
C177	B1	B1#5	2.10112e-18
C178	Y	a_692_368#	3.7946e-17
C179	VPWR	a_127_368##2	4.7077e-18
C180	B1	B1#1	5.47561e-18
C181	VPWR	a_127_368##3	5.29693e-18
C182	a_45_74##2	A3#4	2.14925e-17
C183	B1	C1#5	5.33753e-18
C184	a_45_74##4	B1#4	1.9132e-19
C185	VPWR	a_692_368##2	2.59323e-17
C186	B1	C1#1	1.40877e-19
C187	A2#3	A1#4	5.86995e-17
C188	A2	a_127_368##4	1.94485e-17
C189	a_300_74##2	A1#1	3.03899e-17
C190	Y#3	a_300_74##2	4.42621e-17
C191	a_127_368##5	a_127_368#	8.11945e-19
C192	C1	C1#5	1.16954e-18
C193	VPWR#3	a_692_368##3	6.70917e-17
C194	VPWR	VPWR#4	3.93964e-17
C195	VGND#6	A1#6	1.17085e-19
C196	A3#2	VNB	2.10624e-17
C197	C1	C1#1	1.64682e-18
C198	VPWR	VPWR#6	3.49871e-17
C199	A2#4	VNB	1.88165e-17
C200	A1#3	VNB	4.96583e-17
C201	B1#3	VNB	5.8474e-17
C202	C1#3	VNB	7.03034e-17
C203	a_45_74##2	A2#5	1.88372e-17
C204	A1#1	Y#7	5.2455e-18
C205	VGND#3	A2#3	1.38921e-19
C206	B1	A1#1	7.69217e-18
C207	a_300_74##2	B1#4	8.94426e-19
C208	A1#3	A1#1	5.09898e-18
C209	VGND#3	A1#4	2.24388e-19
C210	VGND#6	A1#1	1.5613e-19
C211	Y#3	Y#7	2.99581e-18
C212	Y#2	VGND#6	2.80204e-17
C213	a_45_74##2	A3#2	3.74818e-19
C214	B1#4	Y#7	1.49604e-17
C215	A1#1	B1#3	1.97973e-17
C216	VPWR#6	VPWR#4	7.02003e-19
C217	a_127_368#	a_692_368##3	8.34202e-17
C218	B1#4	VGND#6	2.81139e-17
C219	B1	a_127_368#	6.14711e-17
C220	Y#3	VGND#6	7.0081e-17
C221	B1	a_692_368##4	3.88637e-17
C222	a_45_74##2	A2	3.70546e-17
C223	a_692_368##3	a_692_368##4	5.06873e-18
C224	Y#2	Y#5	2.20291e-19
C225	Y#4	A1	3.66358e-17
C226	A2#1	A1#4	1.87663e-18
C227	A2	a_127_368##3	9.30107e-18
C228	Y#5	B1#4	6.51875e-19
C229	VGND	A2#4	1.6604e-20
C230	VGND	A1#3	3.66633e-19
C231	A3#3	A3#2	4.74226e-18
C232	VGND	C1#3	5.71353e-21
C233	C1#4	VGND#6	2.61447e-17
C234	a_127_368#	a_692_368##4	5.92914e-17
C235	C1	Y#1	3.02272e-17
C236	Y#3	Y#5	3.03551e-18
C237	A3#3	A2#4	9.03839e-19
C238	C1#3	Y#1	2.83019e-18
C239	A1	a_127_368##2	5.14191e-17
C240	Y#5	C1#4	3.14907e-17
C241	A3#6	A3#1	4.77504e-17
C242	Y#3	A1	1.40229e-17
C243	a_692_368##4	Y#1	5.83403e-17
C244	a_127_368##2	A1#1	2.18312e-18
C245	Y#3	A2#5	1.5467e-19
C246	A3#1	A2#7	4.92096e-17
C247	B1	a_692_368##2	4.97027e-18
C248	A2#3	A1#6	7.46604e-20
C249	Y#2	B1	3.791e-17
C250	Y#3	B1	7.11804e-17
C251	a_692_368##4	a_692_368#	5.01824e-18
C252	A2#3	A1#1	5.19801e-19
C253	A3#3	VPWR#8	5.64758e-19
C254	A2#3	B1#4	2.35361e-19
C255	A2#7	A2#1	4.78207e-17
C256	A3#3	a_127_368##4	3.04357e-17
C257	A2#3	A2#4	1.81672e-17
C258	a_692_368#	C1#3	8.46999e-20
C259	Y#3	A2#6	3.94235e-19
C260	VGND#7	A3#2	5.89042e-20
C261	C1	a_692_368##2	1.41524e-18
C262	a_692_368#	Y#1	5.09749e-17
C263	Y#2	C1	4.03455e-17
C264	A2#3	A1#3	2.5127e-18
C265	A2#1	A1#5	4.01782e-17
C266	A2#3	B1#3	1.46171e-19
C267	Y#3	A1#6	1.27686e-18
C268	VGND#3	A2#6	2.3727e-18
C269	VPWR#5	A2#3	5.96086e-19
C270	A1#5	A1#7	4.75328e-17
C271	VGND#3	A1#6	5.35671e-18
C272	a_45_74##2	a_127_368##4	5.87092e-18
C273	VGND#3	A1#1	7.40949e-18
C274	Y	B1#3	1.56552e-19
C275	Y	C1#3	1.47146e-17
C276	A1#7	B1#5	5.20802e-18
C277	Y#3	A1#1	3.62148e-17
C278	a_127_368##4	A3#2	5.15802e-19
C279	a_45_74##3	A3#3	2.41967e-17
C280	A3#3	VGND#7	1.92072e-18
C281	A1#4	A1#3	3.7142e-18
C282	Y#3	a_127_368##2	3.17303e-18
C283	VPWR#6	A3#2	7.74711e-21
C284	B1#5	B1#1	4.71969e-17
C285	Y#3	B1#4	4.6631e-17
C286	a_45_74##3	VGND#7	3.96718e-17
C287	Y#2	C1#4	2.41934e-17
C288	A2#3	a_300_74#	3.60862e-18
C289	B1#1	C1#5	4.65073e-17
C290	A2#3	a_45_74##4	5.23897e-17
C291	a_45_74##3	a_45_74#	2.03847e-18
C292	a_127_368##2	A1#3	6.35748e-18
C293	Y#4	A2#3	1.62781e-18
C294	a_127_368##3	VPWR#7	1.01967e-17
C295	Y#3	C1#4	1.1459e-18
C296	VPWR#8	A3#6	3.57188e-17
C297	a_300_74#	A1#4	3.31653e-18
C298	a_127_368##6	a_127_368##2	4.48083e-18
C299	A1#3	B1#3	2.73517e-18
C300	a_127_368##4	A3#6	6.29213e-17
C301	C1#5	C1#1	4.65387e-17
C302	VGND#7	a_45_74#	2.98694e-17
C303	a_45_74##2	A3#3	1.58106e-17
C304	VPWR#8	A3#1	1.23306e-18
C305	Y#4	A1#4	2.41725e-17
C306	VPWR#7	A3#6	6.79311e-19
C307	a_127_368##3	a_127_368##6	3.95309e-20
C308	a_300_74##2	A1#4	7.34055e-18
C309	a_127_368##4	A3#1	8.21367e-17
C310	a_127_368##2	VPWR#5	2.40652e-17
C311	VPWR#8	A2#7	2.59902e-19
C312	A3#1	VPWR#7	2.90094e-17
C313	a_45_74##2	A2#3	1.77615e-17
C314	a_127_368##4	A2#7	2.49225e-18
C315	a_127_368##6	A3#1	2.49225e-18
C316	A2	A3#2	8.40965e-18
C317	a_127_368##3	VPWR#5	1.69265e-17
C318	A2#7	VPWR#7	2.39749e-17
C319	VPWR#5	A3#1	1.9205e-19
C320	a_45_74#	a_300_74#	2.34949e-17
C321	a_127_368##2	a_127_368##5	5.02997e-18
C322	A2#3	a_127_368##3	7.95549e-17
C323	a_127_368##6	A2#7	5.37203e-17
C324	VPWR#7	A2#1	3.44144e-19
C325	VGND#3	a_300_74#	2.17766e-17
C326	VPWR#5	A2#7	4.08569e-19
C327	Y#4	VGND#7	2.11403e-21
C328	a_127_368##6	A2#1	6.24967e-17
C329	a_127_368##2	A1#4	4.49546e-17
C330	a_127_368##2	VPWR#3	3.67002e-17
C331	A3#5	A3#4	3.77799e-17
C332	VPWR#7	A1#5	1.53459e-19
C333	A2#1	VPWR#5	2.19454e-17
C334	VGND#3	a_300_74##2	4.63565e-17
C335	a_127_368##6	A1#5	2.37358e-18
C336	a_45_74##4	a_300_74#	6.1236e-17
C337	VPWR#5	A1#5	5.76841e-17
C338	A1	A3#2	1.48775e-19
C339	A3#3	VPWR#6	9.2075e-20
C340	A3#4	A2#5	3.93713e-17
C341	a_127_368##6	A1#7	3.40371e-19
C342	A1	A2#4	2.14018e-19
C343	A1#5	a_127_368##5	2.36043e-17
C344	a_45_74#	a_300_74##2	7.91078e-19
C345	A1	A1#3	2.49281e-17
C346	A1	B1#3	2.84671e-18
C347	VPWR#5	A1#7	2.35939e-18
C348	VPWR#3	A1#5	2.33211e-18
C349	Y#4	A3#2	2.64412e-19
C350	a_127_368##2	a_127_368#	3.19178e-19
C351	A1#7	a_127_368##5	1.75398e-17
C352	B1#3	C1#3	3.33264e-17
C353	VPWR#4	A2#3	5.39428e-20
C354	a_127_368##2	VPWR#4	2.26359e-19
C355	A2#5	A2#6	3.83623e-17
C356	VPWR#6	A2#3	7.25933e-20
C357	a_45_74##4	Y#4	1.73414e-17
C358	VGND#3	A1#3	1.96897e-19
C359	VPWR#3	A1#7	6.25097e-17
C360	a_127_368#	A1#5	9.77772e-20
C361	a_127_368##5	B1#5	2.32747e-19
C362	VPWR#8	VPWR#6	7.0017e-19
C363	a_692_368##3	A1#7	1.42031e-18
C364	a_127_368##2	a_692_368##4	1.80753e-20
C365	VPWR#3	B1#5	2.36082e-18
C366	VPWR#4	A1#4	6.12893e-21
C367	a_127_368#	A1#7	3.51348e-19
C368	A2#6	A1#6	2.65089e-18
C369	a_127_368##3	VPWR#4	7.675e-19
C370	a_127_368##5	B1#1	6.56193e-20
C371	a_692_368##3	B1#5	7.693e-17
C372	VPWR#3	B1#1	2.03279e-19
C373	B1	A1#3	2.47217e-18
C374	a_127_368##4	VPWR#6	1.69403e-17
C375	a_127_368#	B1#5	4.22566e-17
C376	B1	B1#3	3.34939e-17
C377	a_300_74##2	Y#4	4.63219e-17
C378	B1	C1#3	1.63617e-17
C379	a_692_368##3	B1#1	1.66229e-18
C380	a_127_368##3	VPWR#6	7.675e-19
C381	a_45_74##3	a_45_74##2	1.67087e-19
C382	A1#6	A1#1	3.8798e-17
C383	a_692_368##4	B1#5	2.68016e-18
C384	VPWR#3	C1#5	6.99797e-20
C385	VGND#3	Y#3	1.09097e-18
C386	B1#1	a_127_368#	2.41766e-17
C387	a_692_368##2	a_127_368#	1.04113e-17
C388	a_692_368##4	B1#1	4.75874e-17
C389	VPWR#3	C1#1	4.99852e-20
C390	a_45_74##2	VGND#7	1.74475e-17
C391	Y#4	A1#3	5.18321e-18
C392	A1#1	B1#4	3.94431e-17
C393	a_127_368##6	VPWR#4	8.44968e-18
C394	a_692_368##4	C1#5	5.28098e-17
C395	a_692_368##2	a_692_368##4	4.35239e-20
C396	a_127_368##6	VPWR#6	8.4992e-18
C397	a_45_74##2	a_45_74#	2.36944e-18
C398	C1#5	Y#1	2.08407e-17
C399	Y#3	a_127_368#	1.90926e-18
C400	C1	C1#3	1.67475e-17
C401	a_692_368##4	C1#1	3.26069e-18
C402	B1#4	C1#4	7.578e-18
C403	a_692_368#	C1#5	2.31105e-18
C404	a_692_368##2	Y#1	9.67079e-18
C405	Y#1	C1#1	5.87295e-17
C406	a_45_74##2	a_300_74#	1.00938e-17
C407	a_692_368##2	B1#3	8.18384e-20
C408	VPWR#6	VPWR#5	1.3803e-19
C409	a_692_368#	C1#1	4.63857e-17
C410	Y#2	Y#1	1.78387e-18
C411	a_300_74##2	A1#3	1.30801e-18
C412	a_127_368##5	VPWR#4	2.66163e-18
C413	a_127_368##3	A2#7	2.21084e-17
C414	a_692_368##2	C1#3	8.58444e-20
C415	a_127_368##2	A2#1	1.16384e-18
C416	a_300_74#	a_127_368##2	9.70813e-19
C417	VPWR#4	VPWR#3	6.63613e-20
C418	a_127_368##3	A2#1	2.50338e-17
C419	VPWR#8	a_127_368##4	8.78419e-17
C420	A1#3	VPWR#3	2.11049e-18
C421	VGND#6	Y#5	4.71955e-17
C422	a_45_74##3	A3#5	2.56349e-17
C423	a_127_368##2	A1#5	1.3345e-17
C424	VPWR#8	VPWR#7	1.94092e-18
C425	Y#2	B1#3	3.05872e-18
C426	a_45_74##4	a_127_368##2	9.01636e-19
C427	VGND#7	A3#5	2.94606e-17
C428	a_127_368##4	VPWR#7	7.86536e-17
C429	a_45_74##3	A3#4	8.48022e-19
C430	VPWR#6	A3#6	2.3418e-18
C431	a_45_74#	A3#5	8.12074e-19
C432	a_692_368##3	A1#1	7.067e-19
C433	a_127_368##2	A1#7	1.68041e-17
C434	a_45_74##4	a_127_368##3	3.32518e-18
C435	A3#2	A2#4	2.77746e-17
C436	Y#2	C1#3	1.37062e-17
C437	VGND#7	A3#4	3.1558e-17
C438	a_127_368##4	a_127_368##6	5.01824e-18
C439	Y#3	A1#3	2.28008e-18
C440	a_45_74##3	A2#5	1.87602e-19
C441	a_127_368#	A1#1	2.50715e-18
C442	VPWR#4	A3#1	7.49838e-20
C443	A3#4	a_45_74#	1.77265e-17
C444	VPWR#7	a_127_368##6	6.84668e-17
C445	a_127_368##2	B1#5	5.24265e-19
C446	VGND#7	A2#5	2.00383e-18
C447	VPWR#6	A3#1	5.14273e-18
C448	a_300_74#	A3#4	6.84337e-19
C449	Y#4	A3#5	3.7327e-19
C450	Y#3	B1#3	4.24981e-18
C451	A2#5	a_45_74#	1.47005e-17
C452	a_692_368##3	B1#3	8.87059e-20
C453	VPWR#7	VPWR#5	1.96427e-18
C454	VGND#7	A2#6	8.49796e-19
C455	a_692_368##2	VPWR#2	6.26258e-17
C456	VGND#4	A3#4	1.22302e-18
C457	VPWR	VPWR#2	7.09341e-17
C458	VPWR#2	C1#1	4.45244e-18
C459	VGND#3	VGND#4	7.91255e-17
C460	VGND#2	Y#2	2.25448e-19
C461	VGND#4	a_300_74#	1.78912e-17
C462	VGND#4	A2#5	4.86836e-18
C463	a_692_368#	VPWR#2	5.0507e-17
C464	VPWR#2	VPWR#6	4.29927e-17
C465	VPWR#2	B1#5	4.46413e-18
C466	VPWR#2	B1#3	2.25602e-20
C467	VGND#2	Y#3	1.70676e-17
C468	a_127_368#	VPWR#2	2.88521e-19
C469	VGND#2	A2#6	4.65139e-19
C470	VPWR#2	VPWR#8	2.82341e-17
C471	VGND#4	A2#6	2.92161e-18
C472	VGND#4	A2#3	1.30371e-19
C473	a_127_368##5	VPWR#2	7.78984e-18
C474	VGND#2	A1#6	7.73987e-19
C475	VPWR#2	A1#1	2.83015e-19
C476	VGND#2	VNB	8.92789e-17
C477	a_127_368##2	VPWR#2	9.56059e-19
C478	VPWR#2	C1#5	4.47374e-18
C479	VGND#2	Y#5	2.67421e-17
C480	VGND#3	VGND#2	9.81896e-17
C481	VGND#4	VNB	6.87436e-17
C482	VPWR#2	VPWR#4	3.63797e-17
C483	VGND#4	a_45_74##3	1.79242e-17
C484	VGND#2	A1#1	1.2275e-18
C485	VPWR#2	A1#7	1.83922e-18
C486	VGND	VGND#2	9.64366e-17
C487	VPWR#2	A1#3	2.01574e-20
C488	a_692_368##3	VPWR#2	4.58975e-17
C489	Y	VPWR#2	1.39962e-18
C490	VGND	VGND#4	4.84827e-17
C491	VGND#2	B1#4	7.6417e-18
C492	VGND#4	A3#5	1.23778e-18
C493	VPWR#2	A1#4	1.40284e-20
C494	VGND#4	a_45_74##2	1.51446e-18
C495	VPWR#2	VNB	3.42567e-16
C496	VPWR#2	B1#1	4.45244e-18
C497	VGND#2	C1#3	2.45531e-19
C498	VPWR#2	C1#3	2.25602e-20
C499	VGND#2	C1#4	8.82742e-18
C500	VGND#2	Y	2.44243e-17
C501	VGND#4	a_45_74#	1.47251e-17
*
*
.ENDS sky130_fd_sc_hs__a311oi_2
*
