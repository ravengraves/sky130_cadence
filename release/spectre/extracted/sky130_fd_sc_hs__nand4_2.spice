* Extracted by Quantus, converted by sky130cad/quantus.py
*
*
*
*                       LINUX           Wed Nov 18 08:47:14 2026
*
*
*
*  PROGRAM  advgen
*
*  Name           : advgen - Quantus - (64-bit)
*  Version        : 25.1.0-p047
*  Build Date     : Thu Dec 11 23:20:30 PST 2025
*
*  HSPICE LIBRARY
*
*  OPERATING_TEMPERATURE 150
*  QRC_TECH_DIR <path>/tech
*
*
*

*
.SUBCKT sky130_fd_sc_hs__nand4_2 VPB VNB VGND VPWR Y D C B A
*
*
*  caps2d version: 10
*
*
*       TRANSISTOR CARDS
*
*
XM4 VGND#4 D#5 a_27_74##4 VNB sky130_fd_pr__nfet_01v8_lvt l=0.15 w=0.74 ad=0.2738 as=0.2109 pd=2.22 ps=2.05
XM13 a_27_74##2 D#1 VGND#4 VNB sky130_fd_pr__nfet_01v8_lvt l=0.15 w=0.74 ad=0.2072 as=0.2738 pd=2.04 ps=2.22
XM7 a_27_74##2 C#4 a_304_74##2 VNB sky130_fd_pr__nfet_01v8_lvt l=0.15 w=0.74 ad=0.2072 as=0.2072 pd=2.04 ps=2.04
XM9 a_304_74##2 C#5 a_27_74# VNB sky130_fd_pr__nfet_01v8_lvt l=0.15 w=0.74 ad=0.2072 as=0.23225 pd=2.04 ps=2.19
XM0 a_515_74##3 B#4 a_304_74# VNB sky130_fd_pr__nfet_01v8_lvt l=0.15 w=0.74 ad=0.1983 as=0.2072 pd=2.05 ps=2.04
XM15 a_304_74# B#1 a_515_74##4 VNB sky130_fd_pr__nfet_01v8_lvt l=0.15 w=0.74 ad=0.2072 as=0.2072 pd=2.04 ps=2.04
XM3 a_515_74##4 A#7 Y#1 VNB sky130_fd_pr__nfet_01v8_lvt l=0.15 w=0.74 ad=0.2072 as=0.222 pd=2.04 ps=2.08
XM14 Y#1 A#1 a_515_74# VNB sky130_fd_pr__nfet_01v8_lvt l=0.15 w=0.74 ad=0.222 as=0.22325 pd=2.08 ps=2.15
XM6 Y#5 D#7 VPWR#5 VPB sky130_fd_pr__pfet_01v8 l=0.15 w=1.12 ad=0.3808 as=0.336 pd=2.92 ps=2.84
XM10 VPWR#8 D#6 Y#5 VPB sky130_fd_pr__pfet_01v8 l=0.15 w=1.12 ad=0.3808 as=0.3808 pd=2.92 ps=2.92
XM1 VPWR#8 C#6 Y#8 VPB sky130_fd_pr__pfet_01v8 l=0.15 w=1.12 ad=0.3808 as=0.3584 pd=2.92 ps=2.88
XM12 Y#8 C#1 VPWR#7 VPB sky130_fd_pr__pfet_01v8 l=0.15 w=1.12 ad=0.3584 as=0.7392 pd=2.88 ps=3.56
XM2 VPWR#7 B#5 Y#7 VPB sky130_fd_pr__pfet_01v8 l=0.15 w=1.12 ad=0.7392 as=0.336 pd=3.56 ps=2.84
XM8 Y#7 B#3 VPWR#6 VPB sky130_fd_pr__pfet_01v8 l=0.15 w=1.12 ad=0.336 as=0.4592 pd=2.84 ps=3.06
XM5 Y#6 A#5 VPWR#6 VPB sky130_fd_pr__pfet_01v8 l=0.15 w=1.12 ad=0.336 as=0.4592 pd=2.84 ps=3.06
XM11 VPWR#1 A#6 Y#6 VPB sky130_fd_pr__pfet_01v8 l=0.15 w=1.12 ad=0.3528 as=0.336 pd=2.87 ps=2.84
*
*
*       RESISTOR AND CAP/DIODE CARDS
*
Rg1	D#1	D#2	397.555725
Rg2	D#2	D#3	30.596949
Rg3	D#3	D#4	30.613653
Rg4	D#4	D#5	397.555725
Rg5	D#2	D#6	449.655212
Rg6	D#4	D#7	449.655212
Rg7	C#1	C#2	416.062469
Rg8	C#2	C#3	81.216202
Rg9	C#3	C#4	397.590515
Rg10	C#2	C#5	363.962982
Rg11	C#3	C#6	449.490784
Rg12	B#1	B#2	427.132996
Rg13	B#2	B#3	429.126801
Rg14	B#2	B#4	377.027313
Rg15	B#2	B#5	473.870972
Rg16	A#1	A#2	397.555725
Rg17	A#2	A#3	17.800245
Rg18	A#3	A#4	35.535461
Rg19	A#4	A#5	462.000427
Rg20	A#2	A#6	449.655212
Rg21	A#4	A#7	403.815002
Rf1	D#8	D	1.043313
Rf2	D#9	D	1.043313
Rf3	D#8	D#9	14.668931
Rf4	D#3	D#11	81.159714
Rf5	D#9	D#11	1.069610
Rf6	a_27_74#	a_27_74##3	110.450302
Rf7	a_27_74##3	a_27_74##4	105.501266
Rf8	a_27_74##2	a_27_74##3	7.500000
Rf9	C#7	C	0.997598
Rf10	C#2	C#9	54.408531
Rf11	C#7	C#9	7.792870
Rf12	C#10	C	0.997598
Rf13	C#9	C#10	6.876061
Rf14	a_304_74#	a_304_74##2	145.792816
Rf15	B#2	B#7	81.090294
Rf16	B#8	B	0.973891
Rf17	B#7	B#8	1.833616
Rf18	B#9	B	0.973891
Rf19	B#8	B#9	14.668931
Rf20	A#3	A	166.137894
Rf21	Y#1	Y	65.350723
Rf22	Y	Y#2	37.341881
Rf23	Y#2	Y#3	71.344681
Rf24	Y#3	Y#4	91.994553
Rf25	Y#4	Y#5	90.943207
Rf26	Y#2	Y#6	17.463110
Rf27	Y#3	Y#7	17.027714
Rf28	Y#4	Y#8	17.027714
Rf29	a_515_74#	a_515_74##2	86.076210
Rf30	a_515_74##2	a_515_74##3	89.044800
Rf31	a_515_74##2	a_515_74##4	28.870636
Rf32	VPWR#1	VPWR#2	99.233261
Rf33	VPWR#2	VPWR#3	81.792023
Rf34	VPWR#3	VPWR#4	87.416908
Rf35	VPWR#4	VPWR#5	104.164925
Rf36	VPWR#2	VPWR#6	32.420494
Rf37	VPWR#3	VPWR#7	19.982773
Rf38	VPWR#4	VPWR#8	32.420494
Rf39	VGND#1	VGND#2	118.317268
Rf41	VGND#2	VGND#4	36.672695
Re1	VPWR#3	VPWR	0.982218
Re2	VGND	VGND#1	0.982254
*
*       CAPACITOR CARDS
*
*
C1	Y#6	VPWR#1	6.08975e-17
C2	a_515_74#	A#1	3.148e-17
C3	VGND	VNB	8.41744e-17
C4	VPWR	VNB	5.80763e-17
C5	Y	VNB	5.85635e-17
C6	D	VNB	2.75405e-17
C7	C	VNB	1.55493e-17
C8	VGND	Y	4.1606e-18
C9	B	VNB	7.95724e-18
C10	A	VNB	7.2515e-18
C11	VGND	D	3.98823e-18
C12	VPWR	Y	2.45497e-18
C13	VGND	C	5.91735e-18
C14	VPWR	D	4.88924e-18
C15	VGND	B	5.21242e-18
C16	VGND	A	2.80832e-18
C17	D#3	VNB	3.93073e-17
C18	VPWR	C	4.80978e-18
C19	C#2	VNB	5.80491e-17
C20	B#2	VNB	6.44088e-17
C21	VPWR	B	3.5039e-18
C22	A#3	VNB	4.46044e-17
C23	VGND#1	VNB	3.13359e-16
C24	VPWR	A	2.52134e-18
C25	VPWR#3	VNB	2.39662e-16
C26	D#7	VNB	4.17897e-17
C27	D#6	VNB	2.78859e-17
C28	A	Y	2.8753e-17
C29	VGND	C#2	1.16552e-18
C30	C#6	VNB	2.93339e-17
C31	C#1	VNB	3.27163e-17
C32	VGND	B#2	2.5651e-18
C33	B#5	VNB	3.18213e-17
C34	B#3	VNB	3.28706e-17
C35	A#5	VNB	3.19103e-17
C36	VGND	VGND#1	6.47404e-17
C37	A#6	VNB	3.74101e-17
C38	D#5	VNB	3.57935e-17
C39	VPWR	C#2	1.08151e-18
C40	D#1	VNB	2.54115e-17
C41	C#4	VNB	2.95211e-17
C42	VPWR	B#2	2.48624e-18
C43	C#5	VNB	3.15663e-17
C44	B#4	VNB	3.10847e-17
C45	B#1	VNB	2.96348e-17
C46	A#7	VNB	2.94085e-17
C47	B	A	3.86129e-17
C48	A#1	VNB	3.39041e-17
C49	VPWR#5	VNB	7.34774e-17
C50	VPWR	VPWR#3	6.51438e-17
C51	Y#5	VNB	4.98432e-18
C52	VPWR#8	VNB	1.0581e-18
C53	Y	B#2	4.96449e-19
C54	Y#8	VNB	2.77428e-18
C55	VPWR	D#7	1.70103e-18
C56	D	D#3	4.98689e-18
C57	VPWR#7	VNB	4.25567e-18
C58	Y	A#3	1.20141e-17
C59	Y#7	VNB	2.1429e-18
C60	VPWR	D#6	4.99842e-19
C61	VPWR#6	VNB	3.75478e-18
C62	VGND	D#5	8.18924e-19
C63	Y#6	VNB	2.70021e-18
C64	VPWR	C#6	3.55248e-19
C65	VPWR#1	VNB	6.43861e-17
C66	VGND	D#1	1.18963e-18
C67	a_27_74##4	VNB	4.30109e-17
C68	VGND#4	VNB	1.43647e-18
C69	VGND	C#4	2.32639e-18
C70	VPWR	C#1	2.12934e-19
C71	a_27_74##2	VNB	7.47425e-18
C72	C	D#3	4.76052e-18
C73	VGND	C#5	1.61666e-18
C74	a_304_74##2	VNB	3.88337e-18
C75	VPWR	B#5	2.14849e-19
C76	a_27_74#	VNB	1.18949e-17
C77	VGND	B#4	1.67706e-18
C78	a_515_74##3	VNB	1.05345e-17
C79	VPWR	B#3	2.12031e-19
C80	C	C#2	2.04378e-17
C81	VGND	B#1	1.6705e-18
C82	a_304_74#	VNB	7.5933e-18
C83	a_515_74##4	VNB	3.81413e-18
C84	VPWR	A#5	3.00765e-19
C85	VGND	A#7	1.67353e-18
C86	Y#1	VNB	2.58318e-18
C87	VGND	A#1	2.32146e-18
C88	a_515_74#	VNB	3.48346e-17
C89	VPWR	A#6	1.51977e-18
C90	C	B#2	3.50463e-17
C91	D#11	VNB	4.17188e-18
C92	Y	B#5	1.64378e-19
C93	D	D#7	5.04806e-18
C94	B	B#2	2.19048e-17
C95	Y	B#3	2.18731e-19
C96	Y	A#5	3.66154e-19
C97	B	A#3	4.36377e-20
C98	Y	A#6	1.06055e-17
C99	VGND	a_27_74##4	1.75142e-17
C100	Y#2	VNB	2.07268e-20
C101	D#4	D#3	3.13883e-18
C102	A	B#2	9.97585e-19
C103	VGND	a_27_74##2	1.69123e-17
C104	a_515_74##2	VNB	4.72906e-18
C105	VPWR#2	VNB	3.42721e-17
C106	VGND	a_304_74##2	1.07387e-17
C107	VPWR	VPWR#5	4.25272e-17
C108	VPWR#4	VNB	3.53074e-17
C109	A	A#3	1.9961e-17
C110	VGND	a_27_74#	2.48802e-17
C111	C	D#6	6.73752e-19
C112	VPWR	Y#5	1.47811e-17
C113	VGND	a_515_74##3	1.88311e-17
C114	D#3	C#3	2.53056e-17
C115	VGND	a_304_74#	1.08994e-17
C116	VPWR	VPWR#8	2.13431e-17
C117	C	C#6	2.89536e-18
C118	VPWR	Y#8	1.60524e-17
C119	VGND	Y#1	7.49635e-18
C120	C	C#1	6.33529e-20
C121	VGND	a_515_74#	2.24725e-17
C122	VPWR	Y#7	1.5835e-17
C123	C	B#5	9.43567e-19
C124	VPWR	VPWR#6	2.09044e-17
C125	VGND	D#11	2.13826e-18
C126	VPWR	Y#6	1.47467e-17
C127	VPWR	VPWR#1	4.50577e-17
C128	a_27_74##4	VGND#4	6.46208e-17
C129	B	B#3	3.1859e-18
C130	B	A#5	2.52964e-18
C131	VGND	a_515_74##2	2.59059e-17
C132	B	A#6	1.83738e-19
C133	D	VPWR#5	3.16548e-17
C134	Y	VPWR#1	4.46864e-17
C135	D#11	Y#5	2.89563e-17
C136	D	Y#5	1.81066e-17
C137	a_27_74##4	a_27_74##2	2.34568e-18
C138	VPWR	D#11	2.16524e-18
C139	C#2	B#2	2.88617e-17
C140	A	A#5	1.26011e-18
C141	A	A#6	1.23024e-18
C142	VGND#1	C#2	3.59817e-19
C143	Y#1	Y	8.3995e-19
C144	Y	a_515_74#	3.2766e-17
C145	a_27_74##4	D	5.36265e-17
C146	a_27_74##2	VGND#4	5.21368e-17
C147	VPWR	Y#2	2.43702e-18
C148	VPWR#3	C#2	1.85248e-20
C149	VPWR	Y#3	3.13811e-18
C150	VGND#1	B#2	6.79099e-20
C151	VPWR	Y#4	3.86374e-18
C152	VPWR	VPWR#2	2.58169e-17
C153	VPWR	VPWR#4	2.65653e-17
C154	VPWR#3	B#2	1.84801e-20
C155	VGND#1	A#3	5.31916e-20
C156	C#3	Y#8	1.8274e-19
C157	D#4	VNB	3.13902e-17
C158	C#3	C#2	4.00417e-18
C159	C#3	VNB	2.76526e-17
C160	A#4	VNB	1.66699e-17
C161	a_27_74##2	C	1.99353e-18
C162	a_304_74##2	C	6.67196e-17
C163	C#2	C#1	1.96149e-18
C164	a_304_74#	C	8.5056e-18
C165	a_27_74##2	a_304_74##2	5.47033e-17
C166	B#2	C#1	1.51061e-19
C167	B#2	B#5	2.04186e-18
C168	D#11	C	2.41488e-17
C169	VPWR#3	D#6	6.75511e-20
C170	a_304_74#	B	2.73902e-17
C171	a_27_74##2	a_27_74#	2.37845e-18
C172	a_515_74##4	B	1.7331e-17
C173	VPWR#3	C#6	2.84826e-19
C174	D	VPWR#4	2.22864e-19
C175	VPWR#3	C#1	5.04879e-18
C176	D#7	D#6	3.97115e-17
C177	VPWR#3	B#5	5.03876e-18
C178	a_27_74#	a_304_74##2	8.50009e-17
C179	VPWR#3	B#3	2.96652e-19
C180	Y#1	A	3.07549e-17
C181	C	Y#3	1.38254e-17
C182	D#6	C#6	3.89493e-17
C183	B#2	A#4	2.47538e-17
C184	C	Y#4	6.88384e-17
C185	VPWR#3	A#5	7.20614e-20
C186	a_515_74##2	B#1	1.72643e-17
C187	D#3	Y#5	5.63166e-18
C188	C#6	C#1	4.24381e-17
C189	B	Y#2	2.42846e-17
C190	B	Y#3	3.28404e-17
C191	a_304_74##2	a_304_74#	1.45922e-18
C192	a_27_74#	a_515_74##3	4.41862e-17
C193	a_515_74##2	B	6.66333e-18
C194	VGND#1	C#5	4.43427e-18
C195	a_515_74##2	A#7	1.85785e-17
C196	C#1	B#5	1.19902e-17
C197	VGND#1	B#4	4.47052e-18
C198	C#2	Y#8	4.31265e-19
C199	C#2	VPWR#7	3.36836e-18
C200	VGND#1	B#1	4.47052e-18
C201	A	Y#2	4.05409e-17
C202	VGND#1	A#7	4.48038e-18
C203	B#5	B#3	4.58582e-17
C204	a_27_74##4	D#3	3.11949e-18
C205	VGND#1	A#1	4.48038e-18
C206	A#4	A#3	3.83185e-18
C207	VGND#4	D#3	1.93556e-18
C208	a_27_74##2	D#3	1.12929e-18
C209	a_304_74#	a_515_74##3	5.89494e-17
C210	B#2	Y#7	5.48219e-19
C211	B#3	A#5	3.12978e-17
C212	B#2	VPWR#6	1.40693e-18
C213	a_27_74##4	D#11	8.0866e-18
C214	VPWR#3	VPWR#5	2.7231e-17
C215	a_515_74##3	a_515_74##4	5.09013e-18
C216	a_304_74##2	C#2	2.64401e-17
C217	A#5	A#6	4.65934e-17
C218	VPWR#8	VPWR#3	2.38238e-19
C219	A#3	Y#6	7.12684e-19
C220	a_27_74#	C#2	1.90455e-18
C221	Y#5	Y#4	2.4374e-20
C222	Y#8	VPWR#3	8.19229e-18
C223	a_304_74#	a_515_74##4	4.47613e-17
C224	VGND#1	C#3	1.17797e-20
C225	a_304_74#	C#2	1.39635e-18
C226	VPWR#5	D#7	5.48297e-17
C227	Y	A#4	2.63299e-19
C228	Y#7	VPWR#3	8.24175e-18
C229	D#7	Y#5	2.40893e-17
C230	VPWR#5	VPWR#4	1.08063e-18
C231	a_27_74##2	D#11	2.75754e-17
C232	D#11	D#3	1.73384e-17
C233	a_515_74##3	B#2	8.54842e-19
C234	VPWR#3	VPWR#6	2.39577e-19
C235	VPWR#5	D#6	2.90371e-18
C236	VPWR#8	D#7	2.38164e-18
C237	a_304_74#	Y#1	2.04699e-18
C238	a_304_74#	B#2	4.70113e-17
C239	Y#4	VPWR#8	3.29049e-17
C240	Y#5	D#6	6.40771e-17
C241	Y#8	D#7	4.08467e-19
C242	VPWR#3	VPWR#1	3.13035e-17
C243	VPWR#8	D#6	4.89638e-17
C244	Y#5	VPWR#4	1.5374e-17
C245	Y#5	C#6	4.3477e-19
C246	VGND#1	a_304_74##2	9.85745e-19
C247	a_515_74##4	Y#1	4.41513e-17
C248	Y#8	D#6	1.70529e-18
C249	VGND#1	a_27_74#	5.64919e-17
C250	C#6	VPWR#8	2.70683e-17
C251	VPWR#7	D#6	2.43383e-19
C252	Y#4	Y#8	3.33406e-18
C253	D#5	D#1	2.22036e-17
C254	Y#1	A#3	4.84406e-18
C255	VGND#1	a_515_74##3	4.52224e-17
C256	Y#5	C#1	1.82336e-19
C257	C#6	Y#8	3.98866e-17
C258	D	D#4	1.81099e-17
C259	a_515_74#	A#3	3.08181e-19
C260	VGND#1	a_304_74#	1.32949e-18
C261	Y#3	VPWR#7	3.20922e-17
C262	a_515_74##4	a_515_74#	5.21737e-18
C263	VPWR#8	C#1	2.28302e-18
C264	VPWR#7	C#6	4.92888e-19
C265	Y#3	Y#2	9.8256e-19
C266	Y#8	C#1	5.54279e-17
C267	Y#7	Y#2	9.19576e-19
C268	D#1	C#4	4.02524e-17
C269	Y#4	VPWR#7	2.79645e-17
C270	VPWR#8	B#5	1.78089e-19
C271	C#1	VPWR#7	4.27087e-17
C272	VGND#1	a_515_74#	5.41231e-17
C273	a_515_74#	Y#1	3.47629e-17
C274	Y#8	B#5	5.19827e-19
C275	Y#3	Y#7	1.63657e-18
C276	Y#7	C#1	5.19827e-19
C277	Y#8	VPWR#4	9.45826e-18
C278	B#5	VPWR#7	3.72753e-17
C279	Y#2	VPWR#6	1.78428e-17
C280	C#4	C#5	3.84613e-17
C281	VPWR#6	C#1	1.78089e-19
C282	VPWR#4	D#3	8.87704e-20
C283	Y#7	B#5	4.64739e-17
C284	Y#3	C#2	1.72216e-18
C285	VPWR#7	B#3	5.08644e-19
C286	C#2	Y#4	2.32208e-17
C287	Y#3	VPWR#6	1.76011e-17
C288	VPWR#6	B#5	1.28126e-18
C289	D#11	C#3	7.29613e-18
C290	C	C#3	1.7196e-17
C291	a_515_74##2	Y#2	9.20831e-19
C292	Y#7	B#3	5.36794e-17
C293	Y#4	Y#3	1.83892e-20
C294	C#5	B#4	3.49242e-18
C295	Y#2	Y#6	3.38016e-18
C296	VPWR#7	A#5	2.51298e-19
C297	VPWR#4	C#2	1.31553e-20
C298	B#3	VPWR#6	3.65088e-17
C299	B#2	Y#3	4.8838e-17
C300	Y#7	VPWR#2	8.68684e-18
C301	Y#7	A#5	7.51867e-19
C302	Y#6	B#3	5.21554e-19
C303	a_515_74##2	B#2	2.82079e-19
C304	Y#2	VPWR#2	2.15613e-19
C305	A#5	VPWR#6	3.19919e-17
C306	B#4	B#1	3.83019e-17
C307	VPWR#1	B#3	3.10769e-19
C308	Y#2	VPWR#1	4.7161e-19
C309	VPWR#2	B#2	2.08561e-20
C310	Y#2	A#3	3.47085e-18
C311	Y#6	A#5	4.50116e-17
C312	VPWR#6	A#6	1.32459e-18
C313	VPWR#1	A#5	2.55755e-18
C314	a_515_74##2	A#3	3.26453e-19
C315	B#1	A#7	4.06992e-17
C316	A#6	Y#6	2.17863e-17
C317	Y#3	VPWR#2	1.6661e-19
C318	Y#4	C#3	8.37584e-19
C319	VPWR#2	A#3	5.49992e-20
C320	B	A#4	1.17374e-17
C321	VPWR#1	A#6	3.9604e-17
C322	D#11	D#6	2.07703e-18
C323	Y#6	VPWR#2	1.36359e-17
C324	A#7	A#1	3.4247e-17
C325	VGND#1	a_515_74##2	6.4031e-17
C326	D#11	C#6	8.33825e-19
C327	Y#3	VPWR#3	2.15613e-19
C328	VPWR#2	VPWR#1	1.04067e-18
C329	Y#4	VPWR#3	2.15613e-19
C330	a_27_74##4	D#5	5.16026e-17
C331	Y#4	VPWR#4	1.6661e-19
C332	VPWR#3	VPWR#2	4.58568e-17
C333	D#5	VGND#4	1.88419e-17
C334	VPWR#3	VPWR#4	4.71608e-17
C335	A	A#4	2.99276e-19
C336	a_27_74##4	D#1	1.65988e-18
C337	a_27_74##2	D#5	7.11918e-19
C338	VPWR#5	Y#5	8.41108e-17
C339	VGND#4	D#1	3.71133e-17
C340	a_27_74##4	C#4	1.9796e-19
C341	a_27_74##2	Y#4	8.20414e-18
C342	a_27_74##2	D#1	2.96585e-17
C343	VPWR#5	VPWR#8	1.80849e-18
C344	Y#4	D#7	4.08467e-21
C345	VGND#4	C#4	1.07229e-18
C346	a_304_74##2	D#1	1.2334e-18
C347	Y#5	VPWR#8	6.57682e-17
C348	a_27_74##2	C#4	4.61915e-17
C349	a_27_74#	D#1	2.02452e-19
C350	Y#5	Y#8	2.4374e-18
C351	a_304_74##2	C#4	3.30272e-17
C352	Y#4	D#6	7.39238e-21
C353	a_27_74##2	C#5	4.01042e-19
C354	a_27_74#	C#4	4.62933e-19
C355	VPWR#8	Y#8	6.22366e-17
C356	a_304_74##2	C#5	4.8791e-17
C357	a_27_74##2	B#4	5.46199e-20
C358	VPWR#4	D#6	9.77087e-19
C359	Y#4	C#6	1.9178e-17
C360	VPWR#8	VPWR#7	2.68107e-18
C361	a_27_74#	C#5	4.20834e-17
C362	a_304_74##2	B#4	3.93428e-19
C363	a_515_74##3	C#5	9.85713e-19
C364	Y#8	VPWR#7	6.08073e-17
C365	Y#3	C#1	5.19827e-21
C366	a_27_74#	B#4	1.13568e-18
C367	VPWR#4	C#3	1.36474e-20
C368	a_304_74##2	C#3	1.95841e-18
C369	a_304_74#	Y#3	6.3462e-18
C370	VPWR#4	C#6	9.78637e-19
C371	a_304_74#	C#5	3.93428e-19
C372	Y#4	C#1	2.07251e-17
C373	Y#8	Y#7	1.83892e-18
C374	a_515_74##3	B#4	3.98482e-17
C375	a_515_74##4	C#5	1.21695e-19
C376	a_27_74##4	VPWR#5	3.27106e-19
C377	Y#3	B#5	2.10205e-17
C378	a_304_74#	B#4	4.55401e-17
C379	VPWR#7	Y#7	6.08612e-17
C380	a_515_74##3	B#1	9.66485e-19
C381	Y#4	B#5	5.19827e-21
C382	a_515_74##4	B#4	1.56877e-18
C383	Y#1	Y#2	2.32804e-18
C384	Y#2	B#3	6.30037e-19
C385	VPWR#7	VPWR#6	2.68473e-18
C386	a_515_74##2	a_304_74#	1.61216e-17
C387	a_304_74#	B#1	3.73084e-17
C388	Y#3	B#3	1.85392e-17
C389	a_515_74##3	A#7	4.16491e-19
C390	B#1	a_515_74##4	1.9687e-17
C391	Y#7	VPWR#6	6.22197e-17
C392	a_27_74#	C#3	2.12717e-19
C393	a_304_74#	A#7	1.53646e-18
C394	a_27_74##2	Y#5	5.35461e-19
C395	Y#2	A#5	2.62366e-17
C396	Y#1	B#1	1.73313e-18
C397	a_515_74##2	a_515_74##4	3.45296e-18
C398	Y#7	Y#6	1.57462e-18
C399	A#7	a_515_74##4	1.60695e-17
C400	Y#3	A#5	2.9619e-19
C401	VPWR#2	B#3	2.57874e-18
C402	a_515_74#	B#1	4.34196e-19
C403	Y#1	A#7	3.29477e-17
C404	VPWR#6	Y#6	5.86313e-17
C405	Y#2	A#6	1.16756e-17
C406	a_515_74##4	A#1	1.7836e-18
C407	a_515_74##2	Y#1	1.23967e-17
C408	a_515_74#	A#7	1.90041e-18
C409	VPWR#6	VPWR#1	1.95163e-18
C410	VPWR#2	A#5	2.86612e-18
C411	Y#1	A#1	4.74938e-17
C412	VGND#2	a_27_74#	6.30469e-18
C413	VGND#2	VNB	5.95086e-17
C414	VGND#2	C#3	9.98279e-21
C415	VGND	VGND#2	5.92467e-17
C416	VGND#2	D#5	5.66141e-18
C417	VGND#1	VGND#2	6.94396e-17
C418	VGND#2	D#1	5.07279e-18
C419	VGND#2	C#4	5.06581e-18
C420	VGND#2	C#5	2.58485e-19
C421	VGND#2	a_27_74##4	2.10084e-17
C422	VGND#2	B#4	8.42461e-20
C423	VGND#2	a_27_74##2	3.33788e-17
*
*
.ENDS sky130_fd_sc_hs__nand4_2
*
