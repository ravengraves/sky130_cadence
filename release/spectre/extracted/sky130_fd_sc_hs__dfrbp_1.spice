* Extracted by Quantus, converted by sky130cad/quantus.py
*
*
*
*                       LINUX           Wed Nov 18 08:26:33 2026
*
*
*
*  PROGRAM  advgen
*
*  Name           : advgen - Quantus - (64-bit)
*  Version        : 25.1.0-p047
*  Build Date     : Thu Dec 11 23:20:30 PST 2025
*
*  HSPICE LIBRARY
*
*  OPERATING_TEMPERATURE 150
*  QRC_TECH_DIR <path>/tech
*
*
*

*
.SUBCKT sky130_fd_sc_hs__dfrbp_1 VPB VNB VGND RESET_B VPWR Q_N Q D CLK
*
*
*  caps2d version: 10
*
*
*       TRANSISTOR CARDS
*
*
XM3 a_38_78##5 D#1 a_125_78# VNB sky130_fd_pr__nfet_01v8_lvt l=0.15 w=0.42 ad=0.1197 as=0.1008 pd=1.41 ps=1.32
XM1 a_125_78# RESET_B#3 VGND#15 VNB sky130_fd_pr__nfet_01v8_lvt l=0.15 w=0.42 ad=0.1008 as=0.1365 pd=1.32 ps=1.49
XM19 a_319_360##13 CLK#1 VGND#14 VNB sky130_fd_pr__nfet_01v8_lvt l=0.15 w=0.74 ad=0.2109 as=0.3108 pd=2.05 ps=2.32
XM4 VGND#14 a_319_360##8 a_498_360##11 VNB sky130_fd_pr__nfet_01v8_lvt l=0.15 w=0.74 ad=0.3108 as=0.2109 pd=2.32 ps=2.05
XM21 a_38_78# a_319_360##7 a_706_463##9 VNB sky130_fd_pr__nfet_01v8_lvt l=0.15 w=0.42 ad=0.1197 as=0.147 pd=1.41 ps=1.54
XM27 a_706_463##9 a_498_360##3 a_832_118# VNB sky130_fd_pr__nfet_01v8_lvt l=0.15 w=0.42 ad=0.147 as=0.1008 pd=1.54 ps=1.32
XM33 a_832_118# a_841_401# a_910_118# VNB sky130_fd_pr__nfet_01v8_lvt l=0.15 w=0.42 ad=0.1008 as=0.1008 pd=1.32 ps=1.32
XM5 a_910_118# RESET_B#7 VGND#13 VNB sky130_fd_pr__nfet_01v8_lvt l=0.15 w=0.42 ad=0.1008 as=0.3202 pd=1.32 ps=2.54
XM23 VGND#13 a_706_463##3 a_841_401##5 VNB sky130_fd_pr__nfet_01v8_lvt l=0.15 w=0.64 ad=0.3202 as=0.3222 pd=2.54 ps=2.44
XM28 a_841_401##5 a_498_360##5 a_1224_74##13 VNB sky130_fd_pr__nfet_01v8_lvt l=0.15 w=0.64 ad=0.3222 as=0.433 pd=2.44 ps=3.08
XM25 a_1224_74##13 a_319_360# a_1434_74# VNB sky130_fd_pr__nfet_01v8_lvt l=0.15 w=0.42 ad=0.433 as=0.1008 pd=3.08 ps=1.32
XM10 a_1434_74# a_1482_48##3 VGND#12 VNB sky130_fd_pr__nfet_01v8_lvt l=0.15 w=0.42 ad=0.1008 as=0.1722 pd=1.32 ps=1.66
XM0 VGND#12 RESET_B#9 a_1624_74# VNB sky130_fd_pr__nfet_01v8_lvt l=0.15 w=0.42 ad=0.1722 as=0.1008 pd=1.66 ps=1.32
XM29 a_1624_74# a_1224_74##10 a_1482_48##7 VNB sky130_fd_pr__nfet_01v8_lvt l=0.15 w=0.42 ad=0.1008 as=0.1197 pd=1.32 ps=1.41
XM7 VGND#11 a_1224_74##7 Q_N#1 VNB sky130_fd_pr__nfet_01v8_lvt l=0.15 w=0.74 ad=0.2109 as=0.2627 pd=2.05 ps=2.19
XM26 a_2026_424##7 a_1224_74# VGND#4 VNB sky130_fd_pr__nfet_01v8_lvt l=0.15 w=0.55 ad=0.15675 as=0.24475 pd=1.67 ps=2.18
XM18 VGND#4 a_2026_424##3 Q#2 VNB sky130_fd_pr__nfet_01v8_lvt l=0.15 w=0.74 ad=0.24475 as=0.2109 pd=2.18 ps=2.05
XM30 VPWR#11 D#3 a_38_78##6 VPB sky130_fd_pr__pfet_01v8 l=0.15 w=0.42 ad=0.1239 as=0.126 pd=1.43 ps=1.44
XM16 a_38_78##6 RESET_B#4 VPWR#18 VPB sky130_fd_pr__pfet_01v8 l=0.15 w=0.42 ad=0.126 as=0.1239 pd=1.44 ps=1.43
XM24 a_319_360##12 CLK#3 VPWR#17 VPB sky130_fd_pr__pfet_01v8 l=0.15 w=1.12 ad=0.3304 as=0.336 pd=2.83 ps=2.84
XM6 VPWR#17 a_319_360##9 a_498_360##13 VPB sky130_fd_pr__pfet_01v8 l=0.15 w=1.12 ad=0.336 as=0.3304 pd=2.84 ps=2.83
XM31 a_38_78##2 a_498_360# a_706_463##7 VPB sky130_fd_pr__pfet_01v8 l=0.15 w=0.42 ad=0.1239 as=0.126 pd=1.43 ps=1.44
XM13 a_706_463##7 a_319_360##6 a_796_463# VPB sky130_fd_pr__pfet_01v8 l=0.15 w=0.42 ad=0.126 as=0.1008 pd=1.44 ps=1.32
XM22 a_796_463# a_841_401##3 VPWR#16 VPB sky130_fd_pr__pfet_01v8 l=0.15 w=0.42 ad=0.1008 as=0.27995 pd=1.32 ps=2.31
XM14 VPWR#16 RESET_B#8 a_706_463##8 VPB sky130_fd_pr__pfet_01v8 l=0.15 w=0.42 ad=0.27995 as=0.1176 pd=2.31 ps=1.4
XM8 VPWR#15 a_706_463# a_841_401##4 VPB sky130_fd_pr__pfet_01v8 l=0.15 w=1 ad=0.295 as=0.3 pd=2.59 ps=2.6
XM9 a_841_401##4 a_319_360##2 a_1224_74##14 VPB sky130_fd_pr__pfet_01v8 l=0.15 w=1 ad=0.3 as=0.3877 pd=2.6 ps=3.2
XM11 a_1224_74##14 a_498_360##6 a_1465_471# VPB sky130_fd_pr__pfet_01v8 l=0.15 w=0.42 ad=0.3877 as=0.1134 pd=3.2 ps=1.38
XM17 a_1465_471# a_1482_48# VPWR#14 VPB sky130_fd_pr__pfet_01v8 l=0.15 w=0.42 ad=0.1134 as=0.1512 pd=1.38 ps=1.56
XM32 VPWR#14 RESET_B#11 a_1482_48##4 VPB sky130_fd_pr__pfet_01v8 l=0.15 w=0.42 ad=0.1512 as=0.126 pd=1.56 ps=1.44
XM15 a_1482_48##4 a_1224_74##9 VPWR#13 VPB sky130_fd_pr__pfet_01v8 l=0.15 w=0.42 ad=0.126 as=0.3458 pd=1.44 ps=2.97
XM2 VPWR#13 a_1224_74##8 Q_N#2 VPB sky130_fd_pr__pfet_01v8 l=0.15 w=1.12 ad=0.3458 as=0.6888 pd=2.97 ps=3.47
XM20 a_2026_424##6 a_1224_74##6 VPWR#12 VPB sky130_fd_pr__pfet_01v8 l=0.15 w=0.84 ad=0.2478 as=0.3836 pd=2.27 ps=2.97
XM12 VPWR#12 a_2026_424# Q#1 VPB sky130_fd_pr__pfet_01v8 l=0.15 w=1.12 ad=0.3836 as=0.3304 pd=2.97 ps=2.83
*
*
*       RESISTOR AND CAP/DIODE CARDS
*
Rg1	D#1	D#2	340.218658
Rg2	D#2	D#3	357.102295
Rg3	RESET_B#1	RESET_B#2	6.813559
Rg4	RESET_B#2	RESET_B#3	451.728088
Rg5	RESET_B#2	RESET_B#4	454.157837
Rg6	CLK#1	CLK#2	372.003876
Rg7	CLK#2	CLK#3	442.817719
Rg8	a_498_360#	a_498_360##2	337.898376
Rg9	a_498_360##2	a_498_360##3	676.665771
Rg10	a_841_401#	a_841_401##2	471.466309
Rg11	a_841_401##2	a_841_401##3	269.952026
Rg12	RESET_B#5	RESET_B#6	73.925568
Rg13	RESET_B#6	RESET_B#7	615.566956
Rg14	RESET_B#6	RESET_B#8	248.803528
Rg15	a_706_463#	a_706_463##2	671.281128
Rg16	a_706_463##2	a_706_463##3	380.705597
Rg17	a_498_360##4	a_498_360##5	657.651978
Rg18	a_319_360#	a_319_360##2	1145.673950
Rg19	a_319_360##2	a_319_360##3	1917.682007
Rg20	a_319_360##3	a_319_360##4	1417.819702
Rg21	a_319_360##4	a_319_360##5	56.714977
Rg22	a_319_360##3	a_319_360##6	283.919525
Rg23	a_319_360##4	a_319_360##7	581.862427
Rg24	a_319_360##5	a_319_360##8	294.612335
Rg25	a_319_360##5	a_319_360##9	498.475800
Rg26	a_498_360##6	a_498_360##7	233.787552
Rg27	a_1482_48#	a_1482_48##2	676.838989
Rg28	a_1482_48##2	a_1482_48##3	237.812225
Rg29	RESET_B#9	RESET_B#10	752.680725
Rg30	RESET_B#10	RESET_B#11	247.112122
Rg31	a_1224_74#	a_1224_74##2	403.294342
Rg32	a_1224_74##2	a_1224_74##3	187.937668
Rg33	a_1224_74##3	a_1224_74##4	51.143871
Rg34	a_1224_74##4	a_1224_74##5	116.626869
Rg35	a_1224_74##2	a_1224_74##6	528.965637
Rg36	a_1224_74##3	a_1224_74##7	321.973785
Rg37	a_1224_74##4	a_1224_74##8	457.307739
Rg38	a_1224_74##5	a_1224_74##9	490.156952
Rg39	a_1224_74##5	a_1224_74##10	445.829285
Rg40	a_2026_424#	a_2026_424##2	465.025360
Rg41	a_2026_424##2	a_2026_424##3	366.265259
Rf1	D	D#4	5.305026
Rf2	D#4	D	6.962847
Rf3	RESET_B	RESET_B#1	82.227661
Rf4	CLK	CLK#2	173.403214
Rf5	a_319_360##5	a_319_360##11	221.062912
Rf6	a_319_360##11	a_319_360##12	84.902321
Rf7	a_319_360##11	a_319_360##13	17.319063
Rf8	a_38_78#	a_38_78##3	159.872375
Rf9	a_38_78##3	a_38_78##4	165.247147
Rf10	a_38_78##4	a_38_78##5	154.955963
Rf11	a_38_78##4	a_38_78##6	33.863968
Rf12	a_38_78##2	a_38_78##3	15.000000
Rf13	a_706_463##2	a_706_463##5	242.520630
Rf14	a_706_463##5	a_706_463##6	66.076469
Rf15	a_706_463##6	a_706_463##7	39.674316
Rf16	a_706_463##5	a_706_463##8	25.397230
Rf17	a_706_463##6	a_706_463##9	131.366516
Rf18	RESET_B#5	RESET_B#15	161.007004
Rf19	RESET_B#16	RESET_B#17	10.551989
Rf20	RESET_B#15	RESET_B#16	4.920908
Rf21	a_841_401##4	a_841_401##6	107.005623
Rf22	a_841_401##6	a_841_401##2	203.899689
Rf23	a_841_401##5	a_841_401##6	15.000000
Rf24	a_498_360##7	a_498_360##4	243.452530
Rf25	a_498_360##4	a_498_360##10	282.731140
Rf26	a_498_360##10	a_498_360##11	22.256985
Rf27	a_498_360##10	a_498_360##12	65.041000
Rf28	a_498_360##12	a_498_360##13	37.402596
Rf29	a_498_360##12	a_498_360##2	174.810776
Rf30	RESET_B#10	RESET_B#19	168.696762
Rf31	a_1224_74##5	a_1224_74##12	221.614319
Rf32	a_1224_74##12	a_1224_74##13	124.675819
Rf33	a_1224_74##12	a_1224_74##14	105.006599
Rf34	a_1482_48##4	a_1482_48##5	142.291443
Rf35	a_1482_48##5	a_1482_48##2	224.389938
Rf36	a_1482_48##5	a_1482_48##7	26.614391
Rf37	Q_N#1	Q_N	50.199562
Rf38	Q_N	Q_N#3	7.052421
Rf39	Q_N#3	Q_N	0.096609
Rf40	Q_N#2	Q_N#3	2.500000
Rf41	a_2026_424##2	a_2026_424##5	180.920303
Rf42	a_2026_424##5	a_2026_424##6	62.308384
Rf43	a_2026_424##5	a_2026_424##7	57.017704
Rf44	Q#1	Q	18.225628
Rf45	Q	Q#3	6.530186
Rf46	Q#3	Q	6.530186
Rf47	Q#2	Q#3	7.500000
Rf49	VPWR#2	VPWR#3	119.618431
Rf50	VPWR#3	VPWR#4	14.854656
Rf51	VPWR#4	VPWR#5	70.974457
Rf52	VPWR#5	VPWR#6	149.292007
Rf53	VPWR#6	VPWR#7	94.417664
Rf54	VPWR#7	VPWR#8	91.462822
Rf55	VPWR#8	VPWR#9	85.444542
Rf56	VPWR#9	VPWR#10	70.867264
Rf57	VPWR#10	VPWR#11	112.013924
Rf58	VPWR#2	VPWR#12	42.020184
Rf59	VPWR#4	VPWR#13	50.789909
Rf60	VPWR#5	VPWR#14	53.415070
Rf61	VPWR#6	VPWR#15	56.062122
Rf62	VPWR#7	VPWR#16	30.302891
Rf63	VPWR#9	VPWR#17	34.310661
Rf64	VPWR#10	VPWR#18	37.027283
Rf66	VGND#2	VGND#3	122.538498
Rf67	VGND#2	VGND#4	41.038895
Rf68	VGND#3	VGND#5	98.918076
Rf69	VGND#5	VGND#6	190.206665
Rf70	VGND#6	VGND#7	131.466354
Rf71	VGND#7	VGND#8	80.696266
Rf72	VGND#8	VGND#9	80.363823
Rf74	VGND#3	VGND#11	45.656124
Rf75	VGND#5	VGND#12	28.474823
Rf76	VGND#6	VGND#13	24.468842
Rf77	VGND#8	VGND#14	34.310661
Rf78	VGND#9	VGND#15	41.376114
Rf79	D#2	D#4	53.410934
Re1	RESET_B#19	RESET_B#17	13.698293
Re2	RESET_B#17	RESET_B	7.213822
Re4	VPWR#3	VPWR	2.268450
Re5	VPWR	VPWR#8	1.620321
Re6	VGND#3	VGND	2.268450
Re7	VGND	VGND#7	1.620321
*
*       CAPACITOR CARDS
*
*
C1	a_498_360##4	a_841_401##5	1.1864e-16
C2	RESET_B#17	VPWR#16	3.79074e-18
C3	a_38_78##2	a_706_463##7	5.26016e-17
C4	a_498_360##4	VGND#13	2.28778e-18
C5	a_498_360##12	a_38_78#	1.78619e-17
C6	VPWR#9	RESET_B#4	3.7965e-19
C7	VPWR#6	a_498_360##5	3.697e-20
C8	a_706_463##9	a_498_360##3	4.52593e-17
C9	a_1482_48##5	a_1224_74##7	2.61209e-18
C10	VPWR#8	a_841_401##4	1.14259e-17
C11	a_1224_74##8	a_1224_74##6	4.30562e-18
C12	a_38_78##4	a_319_360##5	2.21863e-19
C13	VGND#14	a_498_360##11	4.85512e-17
C14	RESET_B#17	a_706_463##7	6.58912e-18
C15	a_498_360##11	a_841_401#	1.5357e-17
C16	a_319_360##3	a_498_360#	1.90902e-17
C17	a_841_401##5	RESET_B#5	1.29867e-19
C18	Q_N#2	a_1224_74##5	6.95994e-19
C19	a_38_78#	a_498_360##3	5.23468e-18
C20	a_319_360##11	a_319_360##5	2.37389e-18
C21	RESET_B#17	a_38_78##2	3.44553e-17
C22	VPWR#13	a_1224_74##5	9.14043e-19
C23	VPWR#10	D#3	3.39113e-18
C24	VGND#7	a_841_401##4	4.2192e-18
C25	a_319_360##7	a_706_463##9	1.1561e-17
C26	a_498_360##4	RESET_B#6	1.15835e-19
C27	a_38_78##2	a_498_360##13	4.23569e-17
C28	a_498_360##11	a_498_360##12	1.74976e-20
C29	a_1224_74##9	a_1224_74##8	3.0976e-17
C30	RESET_B#15	a_319_360##2	5.65632e-19
C31	a_1482_48##4	a_1224_74##5	3.59215e-17
C32	a_498_360##13	RESET_B#2	7.37786e-19
C33	VGND#7	VPWR#15	3.04123e-18
C34	a_498_360##11	a_498_360##3	1.08286e-17
C35	CLK#2	a_38_78##4	2.02881e-18
C36	a_1482_48##5	a_1224_74##10	3.14918e-17
C37	VPWR#5	VPWR#13	2.77929e-18
C38	a_841_401##5	a_706_463##2	8.14086e-17
C39	a_38_78#	a_319_360##7	4.91919e-17
C40	VPWR#17	a_319_360##3	4.10861e-18
C41	a_319_360##11	CLK#2	6.13128e-17
C42	a_2026_424##5	VPWR#12	1.17666e-17
C43	a_706_463##7	VPWR#8	1.77773e-17
C44	a_38_78##2	VPWR#17	4.61097e-17
C45	RESET_B#10	a_1482_48##4	5.10976e-17
C46	RESET_B#11	a_1224_74##9	2.27621e-17
C47	a_498_360##11	a_319_360##7	1.23501e-17
C48	a_38_78##2	VPWR#8	3.70881e-17
C49	RESET_B#10	VPWR#14	1.25562e-17
C50	a_319_360##9	a_319_360##3	1.61828e-17
C51	a_841_401##2	a_841_401##5	1.72347e-18
C52	a_38_78#	a_319_360##8	6.50302e-19
C53	VPWR#8	a_498_360##13	2.90621e-18
C54	VGND#3	a_2026_424##3	2.19441e-18
C55	a_1482_48##5	RESET_B#9	3.45597e-18
C56	a_38_78##4	a_498_360##13	1.74605e-20
C57	RESET_B#5	a_319_360##3	1.57948e-18
C58	VGND#4	Q#2	4.61646e-17
C59	a_1482_48##4	VPWR#5	4.3697e-18
C60	VGND#8	a_319_360##8	9.31646e-18
C61	a_1482_48##4	a_1482_48##2	3.071e-19
C62	VGND#3	a_1224_74#	7.00674e-19
C63	a_1224_74##14	RESET_B#10	3.05301e-19
C64	VGND#15	VGND#14	1.10769e-18
C65	a_38_78##5	RESET_B#2	8.58168e-18
C66	a_498_360##11	a_319_360##8	4.05441e-17
C67	a_1482_48#	RESET_B#11	1.72064e-17
C68	VPWR#8	a_319_360##12	4.15068e-18
C69	a_706_463##5	a_706_463#	2.56678e-18
C70	a_1224_74##12	RESET_B#9	1.45418e-19
C71	VGND#7	a_498_360##13	2.67259e-18
C72	VGND#3	a_1224_74##7	9.54787e-18
C73	a_319_360##12	a_498_360##13	5.34961e-18
C74	VPWR#12	a_1224_74##2	5.79961e-19
C75	a_38_78##4	D#2	8.56874e-18
C76	a_706_463##9	a_841_401##2	8.21562e-17
C77	a_1482_48##4	VPWR#4	4.16747e-18
C78	a_319_360##8	VGND#14	2.19148e-17
C79	VGND#3	a_1224_74##10	9.3544e-19
C80	a_1224_74##14	a_1482_48##2	2.77991e-19
C81	a_1482_48##5	a_1482_48##3	4.37731e-19
C82	a_706_463##6	RESET_B#8	7.89629e-19
C83	VPWR#8	a_38_78##6	1.64859e-17
C84	VGND#7	a_319_360##12	1.32887e-18
C85	a_319_360##11	D#2	2.40933e-19
C86	a_498_360##11	CLK#1	3.78359e-19
C87	VGND#3	RESET_B#9	5.90119e-19
C88	a_498_360##11	a_841_401##2	3.73194e-17
C89	a_841_401##4	a_1482_48##2	4.46266e-20
C90	VGND#6	a_1224_74##13	6.61172e-18
C91	a_498_360##6	a_1482_48#	2.57233e-17
C92	VGND#8	CLK#1	4.74562e-18
C93	VPWR#8	VPWR#11	5.39752e-17
C94	a_706_463##5	RESET_B#8	2.96642e-17
C95	Q_N#2	a_2026_424##5	2.26981e-17
C96	VGND#3	a_1482_48##3	5.25167e-19
C97	a_1224_74##12	VPWR#5	6.48123e-20
C98	a_706_463##9	a_498_360##2	5.59363e-18
C99	a_498_360##7	a_1224_74##14	6.61486e-17
C100	a_706_463##2	a_319_360##3	2.17688e-19
C101	CLK#1	VGND#14	2.47727e-17
C102	RESET_B#6	a_319_360##3	2.74274e-19
C103	a_319_360##2	a_1482_48#	4.25248e-19
C104	a_2026_424##5	a_1224_74##4	7.60816e-20
C105	a_38_78#	a_498_360##2	4.29371e-17
C106	VPWR#18	VPWR#17	1.04932e-17
C107	RESET_B#19	VPWR#6	1.16144e-18
C108	VPWR#7	a_498_360##3	2.0574e-19
C109	VGND#3	a_319_360#	2.77338e-19
C110	VGND#3	VGND#5	1.1314e-16
C111	VGND#15	a_319_360##8	1.42592e-19
C112	a_38_78##4	a_319_360##12	5.08413e-17
C113	a_706_463##2	RESET_B#6	3.10239e-17
C114	a_841_401##4	a_498_360##7	4.86998e-17
C115	a_2026_424##7	VGND#4	4.8408e-17
C116	a_498_360##11	a_498_360##2	2.61191e-18
C117	a_319_360##12	RESET_B#2	8.32493e-18
C118	a_706_463##6	a_841_401##3	2.58461e-17
C119	RESET_B#2	CLK#1	2.90994e-18
C120	RESET_B#2	CLK#3	9.22632e-18
C121	a_1482_48##5	a_319_360#	2.35605e-19
C122	VGND#5	a_1224_74##13	2.88536e-17
C123	a_319_360##2	a_498_360##6	1.43189e-17
C124	CLK#1	a_319_360##13	1.05321e-17
C125	RESET_B#19	VPWR#5	3.50134e-18
C126	a_706_463##9	a_319_360##5	1.57276e-19
C127	VPWR#18	a_319_360##3	1.73713e-20
C128	a_706_463##5	a_841_401##3	4.09515e-18
C129	VGND#14	RESET_B#3	5.14646e-19
C130	Q_N#2	a_1224_74##4	2.34175e-17
C131	a_38_78#	a_319_360##5	8.69362e-18
C132	a_498_360##4	a_841_401##4	6.43028e-17
C133	VGND#15	CLK#1	1.19468e-18
C134	a_1224_74##12	a_319_360#	4.84953e-18
C135	RESET_B#17	a_498_360##5	5.93952e-21
C136	RESET_B#17	VGND#6	1.49208e-18
C137	a_319_360##5	a_498_360##11	6.12642e-17
C138	a_38_78##4	VPWR#18	3.23743e-17
C139	a_1224_74##14	VPWR#6	5.15538e-18
C140	VPWR#3	VPWR#6	1.65143e-17
C141	a_706_463#	a_319_360##2	7.16304e-17
C142	RESET_B#4	a_319_360##3	1.06725e-19
C143	a_319_360##5	VGND#14	1.78833e-17
C144	a_706_463##6	a_319_360##6	9.57239e-18
C145	a_2026_424##5	Q#2	6.2698e-19
C146	a_706_463##6	a_796_463#	1.66991e-18
C147	a_319_360##11	a_319_360##12	3.24624e-18
C148	a_841_401##2	a_319_360##3	5.58136e-19
C149	VPWR#3	VPWR#5	9.87116e-17
C150	a_38_78##5	VGND#15	3.14816e-17
C151	a_706_463##5	a_319_360##6	2.59233e-19
C152	RESET_B#3	VGND#15	1.90111e-17
C153	VPWR#15	RESET_B#5	3.6868e-18
C154	a_841_401##2	RESET_B#6	5.5513e-17
C155	a_1224_74##14	VPWR#5	1.29836e-17
C156	VPWR#3	VPWR#4	4.94524e-17
C157	a_38_78##5	CLK#1	1.14468e-18
C158	VPWR#18	RESET_B#2	1.7767e-18
C159	a_38_78##6	VPWR#18	2.69337e-17
C160	VGND#6	VGND#13	7.18426e-18
C161	Q_N#1	a_2026_424##7	4.62254e-17
C162	VGND#11	VGND#4	1.09749e-18
C163	a_841_401##4	a_498_360##5	2.3483e-18
C164	VPWR#8	a_498_360##5	1.09122e-19
C165	RESET_B#8	a_706_463#	2.61369e-18
C166	CLK#2	VGND#14	5.94341e-19
C167	a_706_463##9	a_706_463##6	5.50697e-20
C168	Q_N#2	a_1224_74##2	6.37197e-19
C169	a_706_463##2	a_841_401##4	8.78892e-19
C170	RESET_B#17	a_498_360##3	4.95957e-20
C171	a_2026_424##5	a_1224_74##2	5.25638e-17
C172	a_706_463##6	a_498_360#	2.50851e-19
C173	CLK#2	a_319_360##13	3.98552e-19
C174	a_1224_74##5	a_1224_74##7	9.92547e-19
C175	a_841_401##4	VPWR#6	6.98789e-18
C176	VPWR#13	a_1224_74##4	1.17874e-18
C177	VGND#15	D#1	3.12309e-18
C178	a_706_463##2	VPWR#15	4.72509e-18
C179	a_2026_424##5	VGND#4	8.72363e-18
C180	VPWR#11	VPWR#18	2.00319e-18
C181	VGND#7	a_498_360##5	7.19888e-19
C182	a_706_463##5	a_498_360#	3.74307e-20
C183	a_38_78##5	RESET_B#3	1.05316e-17
C184	a_1482_48##5	Q_N#2	4.91985e-18
C185	RESET_B#9	a_1224_74##5	1.94446e-17
C186	a_841_401##3	RESET_B#8	1.03274e-17
C187	VGND#7	a_706_463##3	8.8526e-19
C188	VPWR#11	a_38_78##4	8.32703e-19
C189	RESET_B#15	a_319_360##3	8.84856e-19
C190	VPWR#11	a_38_78##6	3.39417e-17
C191	VGND#7	RESET_B#7	8.04328e-18
C192	a_498_360##2	a_319_360##3	1.16834e-18
C193	VPWR#3	a_2026_424##5	4.80188e-19
C194	RESET_B#17	VPWR#7	4.43709e-18
C195	a_1224_74##5	a_319_360#	1.29253e-19
C196	a_38_78##5	D#1	4.5347e-17
C197	a_1482_48##2	a_1224_74##7	1.1116e-19
C198	VGND#7	a_841_401#	1.58296e-18
C199	VPWR#3	a_2026_424#	3.95772e-18
C200	RESET_B#17	VPWR#6	9.66597e-18
C201	D#1	RESET_B#2	6.37409e-18
C202	D#3	RESET_B#2	1.36103e-17
C203	a_319_360##6	a_841_401##3	4.16399e-17
C204	RESET_B#19	a_1224_74##8	6.97657e-19
C205	VGND#11	Q_N#1	6.92746e-17
C206	VGND#7	a_498_360##3	1.26807e-18
C207	RESET_B#19	a_1224_74##12	7.70552e-17
C208	VPWR#3	a_1224_74##6	4.97122e-18
C209	a_1482_48##2	RESET_B#9	5.16817e-17
C210	a_841_401##5	VPWR#15	2.25521e-17
C211	a_498_360#	a_841_401##3	4.18663e-19
C212	VGND#7	a_319_360##7	1.23207e-18
C213	VPWR#3	a_1224_74##8	1.3321e-17
C214	a_38_78##2	a_841_401##2	6.61891e-19
C215	VGND#3	a_2026_424##5	1.99773e-18
C216	VGND#7	VGND#8	9.19804e-17
C217	VGND#7	a_319_360##8	2.32935e-18
C218	a_38_78##4	a_319_360##9	2.89004e-19
C219	a_38_78##5	D#2	5.39306e-18
C220	a_498_360#	a_319_360##6	3.14338e-17
C221	a_1224_74##2	a_2026_424##3	4.44155e-18
C222	VPWR#3	a_1224_74##9	9.62497e-18
C223	a_319_360#	a_1482_48##2	3.2848e-17
C224	a_498_360##13	a_841_401##2	2.4504e-20
C225	VGND#7	VGND#6	1.44047e-16
C226	VGND#7	CLK#1	2.58524e-19
C227	Q_N#1	a_2026_424##5	3.57209e-17
C228	a_706_463##7	a_498_360##2	7.53667e-19
C229	RESET_B#19	a_1482_48#	7.17923e-18
C230	a_706_463##6	a_319_360##3	2.74539e-18
C231	VPWR#3	RESET_B#11	7.62539e-18
C232	a_1482_48##5	a_1482_48##4	2.54442e-18
C233	a_319_360##5	a_319_360##3	1.89745e-19
C234	VPWR#3	a_1224_74##12	6.12247e-19
C235	a_38_78##2	a_498_360##2	6.22858e-17
C236	VGND#7	VGND#5	1.36004e-17
C237	VPWR#8	VPWR#10	7.01991e-17
C238	VGND#7	RESET_B#3	7.58056e-18
C239	a_1224_74##2	a_2026_424#	5.75371e-18
C240	VPWR#3	a_1482_48#	5.5529e-18
C241	a_498_360##13	a_498_360##2	2.21239e-19
C242	VPWR#8	VPWR#9	7.49394e-17
C243	VGND#7	D#1	1.24914e-17
C244	a_1224_74##13	a_319_360##2	5.43674e-19
C245	a_319_360##5	RESET_B#2	1.24388e-19
C246	a_38_78##4	CLK#3	2.55652e-17
C247	Q#1	a_2026_424#	3.7281e-17
C248	VPWR#12	Q#1	5.70749e-17
C249	VPWR#3	a_498_360##6	7.44772e-18
C250	a_1224_74#	a_2026_424##3	2.5852e-17
C251	VPWR#8	VPWR#7	8.86662e-17
C252	a_1482_48##4	a_1224_74##2	3.7758e-20
C253	a_1224_74##12	a_1482_48##4	2.63826e-18
C254	a_38_78##2	a_319_360##5	3.41565e-17
C255	VGND#3	a_1482_48##5	5.11509e-17
C256	a_498_360##4	a_319_360#	3.20911e-17
C257	a_841_401##5	a_319_360##2	1.04664e-19
C258	a_706_463##6	RESET_B#6	1.14558e-19
C259	VPWR#16	VPWR#6	1.03118e-18
C260	a_498_360##13	a_319_360##5	3.95625e-17
C261	VPWR#8	VPWR#6	9.93005e-17
C262	a_2026_424#	VPWR#12	2.28767e-17
C263	a_498_360##4	a_498_360##5	2.79448e-17
C264	CLK#3	a_319_360##9	4.90566e-17
C265	VGND#3	a_1224_74##12	6.53591e-18
C266	VPWR#17	a_319_360##5	7.4736e-19
C267	a_498_360##4	a_706_463##3	2.43948e-17
C268	Q#1	a_1224_74##6	1.87648e-18
C269	VGND#3	a_319_360##2	4.02629e-18
C270	a_38_78##4	RESET_B#4	1.69391e-17
C271	a_2026_424##6	a_2026_424#	1.29795e-18
C272	a_498_360##4	RESET_B#7	1.19655e-17
C273	a_706_463##5	a_319_360##3	7.15438e-18
C274	a_841_401##5	a_706_463#	4.45695e-18
C275	VPWR#3	a_1224_74##4	5.25995e-19
C276	a_1224_74##6	VPWR#12	2.75466e-17
C277	a_498_360##4	a_841_401#	2.25443e-19
C278	RESET_B#17	a_319_360##2	6.75384e-18
C279	a_38_78##6	a_319_360##5	2.46968e-19
C280	RESET_B#4	CLK#3	5.29125e-18
C281	a_1224_74##7	a_1224_74#	4.11684e-18
C282	a_1482_48##5	a_1224_74##4	2.04297e-17
C283	a_706_463##2	a_319_360#	5.81906e-19
C284	Q_N#2	a_2026_424#	4.76853e-19
C285	CLK#2	a_319_360##12	2.75402e-17
C286	a_498_360##4	a_498_360##3	1.56257e-19
C287	a_2026_424##6	VPWR#12	7.61014e-17
C288	RESET_B#2	CLK#2	1.34426e-17
C289	a_706_463##2	a_498_360##5	5.67631e-19
C290	RESET_B#17	a_706_463#	5.20602e-18
C291	a_2026_424##6	a_1224_74##6	6.83974e-17
C292	VPWR#3	a_1224_74##2	2.40574e-18
C293	VGND#8	a_498_360##11	2.04311e-17
C294	a_38_78##4	D#3	1.64005e-17
C295	VPWR#13	a_2026_424#	1.64683e-19
C296	VGND#12	VGND#11	1.44988e-18
C297	a_1224_74##5	a_1224_74##8	9.20383e-18
C298	a_706_463##5	RESET_B#6	1.21052e-17
C299	D#3	RESET_B#4	2.80807e-17
C300	RESET_B#7	a_706_463##2	1.39166e-17
C301	VPWR#8	a_319_360##2	1.09615e-17
C302	a_841_401##2	a_498_360##5	4.08124e-19
C303	Q_N#2	a_1224_74##6	6.65945e-18
C304	a_1224_74##14	a_1465_471#	2.43476e-18
C305	a_706_463##2	a_841_401#	1.01671e-19
C306	a_841_401##2	a_706_463##3	2.42538e-19
C307	a_1224_74##7	a_1224_74##2	4.7728e-19
C308	VPWR#8	a_706_463#	2.02246e-18
C309	a_2026_424##6	a_1224_74##8	9.12062e-19
C310	a_1224_74##10	a_1224_74##7	3.97907e-18
C311	VGND#7	a_319_360##2	4.25711e-19
C312	RESET_B#17	a_319_360##6	1.70358e-18
C313	a_38_78##2	VPWR#9	4.25851e-18
C314	a_706_463##5	RESET_B#15	2.87612e-17
C315	a_841_401##2	RESET_B#7	1.6922e-17
C316	VPWR#13	a_1224_74##6	7.67914e-19
C317	VGND#6	a_498_360##11	3.6714e-17
C318	RESET_B#10	a_1224_74##9	1.7784e-17
C319	a_319_360##11	a_498_360##11	5.53983e-19
C320	VPWR#8	RESET_B#8	3.37546e-18
C321	Q#2	a_2026_424##3	2.41987e-17
C322	VGND#7	a_706_463#	3.06025e-19
C323	a_841_401##2	a_841_401#	1.13368e-17
C324	VGND#3	a_1224_74##4	5.38146e-18
C325	a_1482_48##5	Q_N#1	1.14392e-17
C326	Q_N#2	a_1224_74##8	2.78135e-17
C327	a_1224_74##8	a_1224_74##2	5.94303e-19
C328	a_498_360##12	a_498_360##3	1.19576e-19
C329	VPWR#8	a_841_401##3	3.31926e-18
C330	Q_N#2	a_2026_424##6	7.24369e-17
C331	a_1224_74##12	a_1224_74##4	5.9633e-20
C332	a_498_360##3	a_841_401##2	8.89285e-18
C333	a_1482_48##4	a_1224_74##6	1.86142e-19
C334	a_38_78##2	a_319_360##7	7.74011e-19
C335	VGND#5	RESET_B#10	1.5629e-19
C336	CLK	RESET_B#2	9.53449e-20
C337	a_1482_48#	RESET_B#10	3.04441e-17
C338	a_1224_74##8	VPWR#13	2.49542e-17
C339	a_2026_424##3	VGND#4	2.14948e-17
C340	a_1224_74##12	a_1224_74##14	1.2103e-18
C341	VGND#3	a_1224_74##2	3.60104e-18
C342	a_1482_48##5	a_1224_74##2	9.97058e-20
C343	a_706_463##6	a_706_463##5	4.17712e-18
C344	VPWR#8	a_498_360#	6.59343e-18
C345	Q_N#2	a_1224_74##9	2.01403e-18
C346	a_319_360##11	VGND#14	5.57795e-17
C347	RESET_B#9	a_1224_74##10	4.38211e-17
C348	Q#2	a_1224_74#	1.08082e-18
C349	VGND#7	a_319_360##6	5.73068e-19
C350	a_1482_48##4	a_1224_74##8	7.23312e-18
C351	a_319_360##7	a_498_360##2	2.02497e-17
C352	a_841_401##5	RESET_B#6	2.56095e-19
C353	VPWR#8	a_319_360##9	4.68401e-18
C354	a_2026_424##7	a_2026_424##3	9.95868e-19
C355	a_1482_48##5	VGND#11	7.96115e-17
C356	a_1224_74##9	VPWR#13	1.91458e-17
C357	RESET_B#19	VPWR#3	3.49143e-17
C358	a_319_360##5	a_498_360##3	4.86936e-19
C359	a_498_360##7	a_1482_48#	3.48473e-17
C360	a_1224_74##12	a_1482_48##5	1.30981e-18
C361	a_319_360##2	a_1482_48##2	6.8351e-18
C362	VPWR#8	CLK#3	4.63808e-18
C363	VPWR#5	a_1224_74##5	1.20836e-19
C364	VPWR#14	a_1224_74##8	8.58035e-19
C365	VPWR#10	VPWR#9	1.33038e-18
C366	VPWR#4	a_2026_424#	1.16455e-19
C367	VPWR#10	VPWR#17	2.8643e-19
C368	a_1224_74#	VGND#4	2.15684e-17
C369	a_319_360##5	a_319_360##7	2.42496e-19
C370	VGND#5	a_1482_48##2	1.42884e-18
C371	VGND#3	RESET_B#19	1.6076e-18
C372	VPWR#13	Q_N#2	6.46202e-17
C373	a_841_401##4	a_1224_74##12	5.97148e-20
C374	VPWR#4	a_1224_74##5	2.95376e-20
C375	a_2026_424##5	a_2026_424##2	5.45026e-19
C376	a_1482_48##4	a_1224_74##9	3.39155e-17
C377	a_319_360##5	a_319_360##8	1.05367e-17
C378	VPWR#8	RESET_B#4	5.13749e-19
C379	a_319_360##11	a_319_360##13	8.0098e-18
C380	a_319_360##2	a_498_360##7	3.44727e-17
C381	a_706_463##9	a_706_463##7	3.37012e-19
C382	CLK#1	a_319_360##5	6.21119e-18
C383	a_1482_48##3	RESET_B#9	1.49239e-17
C384	VPWR#13	RESET_B#11	8.71046e-19
C385	VPWR#8	D#3	2.97486e-18
C386	D#2	RESET_B#2	5.53312e-17
C387	D	RESET_B#2	3.56692e-18
C388	a_1224_74#	a_2026_424##7	2.22853e-17
C389	VPWR#14	a_1224_74##9	2.46407e-18
C390	VPWR#8	a_498_360##12	8.8189e-19
C391	a_498_360##4	a_319_360##2	4.12121e-17
C392	RESET_B#17	VPWR#3	1.28778e-18
C393	VGND#11	a_2026_424##3	2.68459e-19
C394	VGND#4	a_1224_74##7	6.0463e-19
C395	a_706_463##9	a_319_360##6	1.47019e-19
C396	a_1482_48##4	Q_N#2	1.31872e-17
C397	RESET_B#11	a_1482_48##4	1.72271e-17
C398	a_498_360##11	a_910_118#	2.96847e-19
C399	a_498_360##4	a_706_463#	2.06936e-18
C400	RESET_B#10	VPWR#5	7.25649e-19
C401	VPWR#4	a_1224_74##6	2.33027e-19
C402	RESET_B#17	RESET_B#15	1.48102e-17
C403	RESET_B#5	a_319_360##2	1.69441e-18
C404	a_38_78##2	a_706_463##9	3.81648e-18
C405	Q_N#1	a_1224_74#	1.54168e-18
C406	VPWR#13	a_1482_48#	4.20631e-19
C407	VGND#15	a_319_360##11	4.30418e-17
C408	VGND#5	a_498_360##7	5.24087e-19
C409	VGND#8	a_319_360##11	1.21289e-17
C410	RESET_B#11	VPWR#14	1.42333e-17
C411	RESET_B#5	a_706_463#	9.71784e-18
C412	RESET_B#17	a_706_463##6	3.36943e-17
C413	a_2026_424##7	a_1224_74##7	8.94263e-19
C414	RESET_B#17	a_319_360##3	7.4121e-19
C415	a_1224_74##14	a_1224_74##9	7.8822e-20
C416	a_706_463##2	a_319_360##2	8.74022e-19
C417	a_319_360#	a_1482_48##3	3.32833e-17
C418	a_38_78##5	a_38_78##4	9.95581e-19
C419	a_1482_48##4	VPWR#13	7.32913e-17
C420	a_1482_48##4	a_1482_48#	8.71897e-19
C421	VGND#11	a_1224_74#	4.60861e-19
C422	VGND#7	a_498_360##12	5.89259e-21
C423	RESET_B#17	a_706_463##5	3.84124e-17
C424	VPWR#5	a_1224_74##8	1.44343e-18
C425	a_38_78#	a_38_78##2	1.09529e-18
C426	a_706_463##2	a_706_463#	1.74132e-19
C427	RESET_B#17	RESET_B#6	1.12734e-20
C428	a_2026_424##5	a_2026_424#	2.37599e-19
C429	a_1224_74##13	VGND#12	1.53428e-17
C430	a_38_78##4	RESET_B#2	2.7521e-17
C431	Q	a_1224_74##2	4.17773e-19
C432	RESET_B#17	VPWR#8	8.12885e-17
C433	a_1224_74##7	Q_N#1	3.01775e-17
C434	a_1482_48#	VPWR#14	1.61927e-17
C435	VPWR#3	a_2026_424##2	3.3825e-18
C436	a_1224_74##5	RESET_B#19	3.36203e-18
C437	VPWR#5	a_1482_48##2	8.86311e-20
C438	VPWR#4	a_1224_74##8	3.50672e-18
C439	a_1224_74##14	RESET_B#11	6.76436e-19
C440	VGND#6	a_498_360##4	6.01143e-17
C441	VGND#6	RESET_B#6	1.1224e-19
C442	a_706_463##9	a_832_118#	1.77514e-18
C443	VGND#7	RESET_B#17	1.44554e-18
C444	VPWR#14	VPWR#13	4.64811e-18
C445	VGND#3	a_2026_424##2	4.12695e-18
C446	VPWR#3	a_1224_74##5	2.79896e-18
C447	a_1482_48##5	a_1224_74##5	9.58614e-17
C448	RESET_B#19	RESET_B#10	2.44128e-17
C449	VGND#5	a_498_360##4	9.21689e-19
C450	a_498_360##11	a_832_118#	1.0959e-18
C451	VGND#11	a_1224_74##7	5.28661e-17
C452	a_1224_74##10	a_1624_74#	9.87534e-18
C453	a_841_401##2	a_841_401##3	3.15965e-18
C454	a_841_401##4	RESET_B#11	1.45671e-19
C455	VGND#3	a_1224_74##5	5.5741e-18
C456	a_498_360##5	a_319_360#	4.1685e-18
C457	a_1224_74##12	a_1224_74##5	4.07846e-18
C458	VPWR#3	RESET_B#10	2.74399e-18
C459	VPWR#14	a_498_360##6	1.93523e-18
C460	RESET_B#19	a_1482_48##2	4.82589e-18
C461	RESET_B#9	a_1624_74#	9.87534e-18
C462	VGND#12	a_1482_48##5	1.33698e-17
C463	RESET_B#15	VPWR#6	8.1843e-19
C464	a_2026_424##5	a_1224_74##6	4.34222e-18
C465	a_1224_74##14	a_1482_48#	1.72864e-17
C466	VGND#3	RESET_B#10	2.19495e-18
C467	VPWR#14	a_1482_48##4	3.01747e-17
C468	a_706_463##6	VPWR#7	4.99602e-18
C469	a_498_360##7	VPWR#6	1.21152e-18
C470	VPWR#8	RESET_B#15	1.58044e-18
C471	VPWR#15	RESET_B#11	5.61552e-19
C472	a_498_360#	a_841_401##2	4.59176e-19
C473	a_38_78##5	a_319_360##11	9.02468e-18
C474	RESET_B#19	a_498_360##7	4.16736e-17
C475	a_498_360##11	a_498_360##13	1.89081e-18
C476	a_498_360##2	a_319_360##6	4.77686e-18
C477	VGND#3	a_1482_48##2	6.05022e-18
C478	VPWR#5	a_498_360##7	4.49465e-19
C479	a_841_401##4	a_1482_48#	3.93726e-19
C480	VPWR#4	a_1224_74##9	2.4199e-18
C481	VPWR#3	a_498_360##7	4.38772e-18
C482	a_706_463##6	VPWR#8	1.00087e-17
C483	VGND#6	RESET_B#5	1.65585e-19
C484	VPWR#14	a_319_360##2	1.3801e-18
C485	a_38_78##6	VPWR#10	1.65854e-17
C486	VGND#11	a_1224_74##10	1.77593e-18
C487	a_1482_48##5	RESET_B#10	6.14746e-19
C488	a_1224_74##14	a_498_360##6	3.83681e-17
C489	VGND#3	a_498_360##7	3.07265e-18
C490	VPWR#8	a_706_463##5	1.2349e-17
C491	a_1224_74##12	RESET_B#10	7.10424e-18
C492	VPWR#15	a_1482_48#	5.40826e-19
C493	a_706_463##3	a_498_360##5	2.40592e-17
C494	a_319_360##5	a_498_360#	1.91092e-17
C495	RESET_B#17	a_498_360##7	1.40546e-17
C496	VGND#3	a_498_360##4	3.40976e-18
C497	VGND#3	VGND#4	1.06783e-19
C498	a_2026_424##5	a_1224_74##8	1.81381e-19
C499	a_841_401##4	a_498_360##6	7.43657e-19
C500	VPWR#5	RESET_B#11	4.14636e-18
C501	a_1224_74##10	a_1482_48##7	1.42501e-17
C502	a_1482_48##3	a_1434_74#	9.87534e-18
C503	a_319_360##9	a_319_360##5	3.18139e-17
C504	VGND#7	RESET_B#15	1.32185e-18
C505	VGND#5	a_319_360##2	5.54891e-20
C506	VPWR#14	a_706_463#	3.44047e-19
C507	RESET_B#19	VGND#12	4.37938e-18
C508	a_319_360#	a_1434_74#	9.87534e-18
C509	RESET_B#17	a_498_360##4	1.08238e-17
C510	a_706_463##5	VPWR#7	6.53452e-18
C511	VPWR#6	a_498_360##4	4.11951e-19
C512	VPWR#8	a_38_78##4	1.12515e-17
C513	a_319_360##2	a_1224_74##14	1.17489e-17
C514	VGND#3	a_2026_424##7	1.79839e-17
C515	VGND#12	a_1224_74##7	5.0301e-19
C516	VGND#11	RESET_B#9	2.77462e-19
C517	VPWR#8	a_498_360##7	1.65243e-18
C518	CLK#2	a_319_360##9	2.04662e-18
C519	VPWR#15	a_498_360##6	8.19956e-19
C520	a_1224_74##14	a_1482_48##4	1.27616e-18
C521	a_1482_48#	a_1465_471#	8.26117e-18
C522	RESET_B#17	RESET_B#5	9.32772e-18
C523	a_841_401##4	RESET_B#6	5.55948e-20
C524	a_1482_48##2	a_1482_48##5	3.06592e-18
C525	VPWR#7	VPWR#6	4.28617e-19
C526	a_1224_74##5	RESET_B#10	7.30651e-17
C527	VGND#3	Q_N#1	4.87387e-17
C528	a_38_78##4	VPWR#10	4.0637e-18
C529	VPWR#11	VPWR#10	7.06672e-19
C530	VGND#6	a_706_463##2	5.3206e-19
C531	a_498_360##6	a_1465_471#	8.06292e-18
C532	a_841_401##4	a_319_360##2	6.48846e-17
C533	VPWR#8	a_319_360##3	3.53384e-17
C534	CLK	a_498_360##12	3.65601e-19
C535	a_706_463##2	RESET_B#17	2.53566e-17
C536	a_1224_74##12	a_1482_48##2	7.19174e-17
C537	RESET_B#7	a_706_463##3	2.13331e-17
C538	RESET_B#19	a_1224_74##13	7.07691e-19
C539	a_1482_48##2	a_1224_74##5	5.73511e-18
C540	VGND#7	a_498_360##4	3.09759e-17
C541	VGND#6	a_706_463#	5.00886e-20
C542	VPWR#8	RESET_B#5	3.58735e-21
C543	a_1224_74##13	a_1482_48##5	1.97558e-18
C544	VPWR#15	a_319_360##2	5.25088e-18
C545	VPWR#7	RESET_B#5	8.18124e-19
C546	RESET_B#17	a_841_401##2	4.27469e-17
C547	a_1482_48##2	RESET_B#10	3.124e-17
C548	a_1224_74##14	VPWR#14	4.02148e-17
C549	a_319_360##11	RESET_B#2	6.79791e-18
C550	VPWR#5	a_1482_48#	4.11292e-18
C551	VGND#12	a_1224_74##10	5.36387e-18
C552	a_706_463##5	VPWR#6	1.91645e-18
C553	VPWR#8	a_706_463##2	8.72053e-19
C554	VPWR#6	RESET_B#5	2.27428e-18
C555	a_841_401##4	a_706_463#	2.22689e-17
C556	RESET_B#17	a_498_360##2	1.12872e-17
C557	VPWR#15	a_319_360##3	2.133e-19
C558	VGND#7	a_706_463##2	6.71361e-18
C559	a_38_78##4	VPWR#9	3.02566e-18
C560	VPWR#8	a_841_401##2	2.31435e-18
C561	RESET_B#7	a_910_118#	7.05199e-18
C562	a_498_360##7	a_1482_48##2	3.80946e-19
C563	a_841_401##3	a_796_463#	6.1844e-18
C564	VPWR#15	a_706_463#	5.88085e-17
C565	a_1482_48##5	a_1224_74##8	5.80639e-19
C566	a_841_401#	a_910_118#	6.61119e-18
C567	VGND#7	a_319_360##11	2.37691e-17
C568	VGND#7	a_841_401##2	7.2077e-18
C569	VGND#6	a_841_401##2	6.82754e-20
C570	a_841_401##4	VPWR#14	1.5538e-18
C571	a_841_401#	RESET_B#7	4.54016e-17
C572	VPWR#8	a_498_360##2	4.89908e-19
C573	a_1224_74##12	a_498_360##7	6.5784e-17
C574	VGND#3	VGND#12	2.30691e-17
C575	a_319_360##6	a_796_463#	6.64262e-18
C576	VPWR#16	a_319_360##2	7.30052e-19
C577	VGND#12	RESET_B#9	3.00222e-17
C578	a_841_401##5	VGND#13	8.84138e-19
C579	a_38_78##5	a_125_78#	2.79278e-18
C580	VGND#7	a_498_360##2	3.00757e-18
C581	VPWR#15	RESET_B#6	6.78425e-19
C582	VPWR#8	a_319_360##5	8.27775e-19
C583	a_1224_74##12	a_1224_74##8	3.00951e-20
C584	VPWR#5	a_498_360##6	5.5341e-18
C585	a_1224_74##13	a_1224_74##10	2.18315e-19
C586	a_2026_424##5	Q	1.02266e-18
C587	VGND#7	a_319_360##5	9.37913e-18
C588	VPWR#15	RESET_B#8	4.18112e-18
C589	VPWR#8	CLK#2	9.03047e-19
C590	VPWR#6	a_706_463##2	3.23612e-19
C591	VGND#3	a_1224_74##13	1.79443e-17
C592	D	a_38_78##4	6.64968e-17
C593	VPWR#16	a_706_463#	1.1252e-18
C594	a_498_360##4	RESET_B#5	1.73784e-19
C595	VGND#7	CLK#2	4.77029e-18
C596	a_319_360##11	a_319_360##7	6.12027e-20
C597	a_841_401#	a_832_118#	4.48478e-18
C598	RESET_B#8	a_706_463##8	1.29562e-17
C599	VGND#12	a_1482_48##3	2.99478e-17
C600	a_498_360##3	a_841_401#	4.55624e-17
C601	a_498_360##4	a_706_463##2	1.07872e-18
C602	a_498_360##3	a_832_118#	7.46425e-18
C603	a_498_360##4	a_1224_74##12	3.88509e-17
C604	VGND#7	RESET_B#2	1.1976e-18
C605	VGND#5	a_1224_74##10	5.49619e-18
C606	VPWR#6	a_319_360##2	5.36002e-17
C607	VPWR#15	a_841_401##3	6.79219e-19
C608	a_1224_74##13	RESET_B#9	4.73245e-19
C609	a_706_463##2	RESET_B#5	2.97572e-17
C610	a_498_360##4	a_841_401##2	9.10389e-18
C611	a_841_401##4	a_1224_74##14	2.78552e-17
C612	RESET_B#8	VPWR#16	1.92745e-17
C613	RESET_B#17	a_1224_74##13	1.54908e-18
C614	a_1224_74##2	a_2026_424##2	3.5408e-17
C615	VPWR#5	a_319_360##2	2.24563e-18
C616	a_841_401##2	a_706_463##2	3.78657e-17
C617	a_841_401##5	RESET_B#17	1.02333e-17
C618	a_319_360##11	a_319_360##8	3.21035e-19
C619	VGND#12	a_319_360#	4.8307e-18
C620	VPWR#15	a_319_360##6	2.60878e-19
C621	Q#2	a_1224_74##4	5.61944e-21
C622	Q	Q#2	4.38549e-18
C623	a_841_401##3	VPWR#16	1.9396e-17
C624	a_319_360##7	a_498_360##3	3.784e-17
C625	VGND#4	Q	2.11272e-17
C626	a_1224_74##13	a_1482_48##3	4.93293e-18
C627	RESET_B#17	VGND#13	6.31564e-21
C628	a_1224_74##4	a_1224_74##2	3.17637e-19
C629	VGND#8	a_319_360##5	1.01283e-18
C630	a_706_463##7	RESET_B#8	1.04076e-18
C631	a_498_360##2	a_841_401##2	2.6147e-17
C632	Q#2	a_2026_424##2	3.44411e-17
C633	VPWR#6	a_706_463#	2.07175e-18
C634	VGND#5	RESET_B#9	3.68469e-18
C635	D	a_38_78##5	8.54015e-17
C636	a_2026_424##2	VGND#4	3.56678e-17
C637	RESET_B#19	a_1434_74#	7.05134e-19
C638	a_319_360##5	a_498_360##2	4.35754e-17
C639	a_1224_74##5	a_1224_74##4	2.28903e-18
C640	a_706_463##9	a_841_401##5	1.23381e-19
C641	VPWR#16	a_319_360##6	2.20288e-18
C642	VGND#12	a_498_360##5	8.36681e-19
C643	VPWR#15	a_841_401##4	7.03567e-17
C644	a_319_360##11	CLK#1	3.85156e-17
C645	a_706_463##7	a_841_401##3	7.73772e-19
C646	CLK	a_38_78##2	6.15065e-18
C647	VPWR#16	a_319_360##3	2.12227e-17
C648	CLK	a_498_360##13	6.72746e-18
C649	a_1224_74##13	a_319_360#	4.28647e-17
C650	VGND#6	a_1482_48##3	3.23465e-19
C651	VPWR#7	RESET_B#8	2.40242e-18
C652	RESET_B#17	a_706_463##9	2.87057e-18
C653	a_319_360##8	a_319_360##7	3.60501e-18
C654	a_319_360##12	CLK	5.5525e-18
C655	CLK#2	a_319_360##5	7.4566e-17
C656	a_1224_74##12	a_706_463##2	1.46841e-19
C657	a_38_78##2	a_841_401##3	4.92957e-19
C658	VPWR#5	VPWR#4	1.1272e-18
C659	a_498_360##12	a_38_78##2	1.23523e-17
C660	Q	Q#1	1.59587e-18
C661	VPWR#12	Q	2.79655e-17
C662	VGND#8	CLK#2	6.94161e-20
C663	VPWR#16	a_498_360#	6.37653e-19
C664	RESET_B#17	a_38_78#	3.49667e-18
C665	VPWR#10	a_319_360##3	7.49293e-20
C666	RESET_B#3	a_125_78#	6.24915e-18
C667	a_706_463##7	a_319_360##6	2.28286e-17
C668	a_841_401##5	a_319_360#	8.80165e-20
C669	VGND#5	a_1482_48##3	3.76878e-18
C670	D#1	a_125_78#	8.20925e-18
C671	a_1224_74##12	a_1482_48#	7.24222e-18
C672	VGND#12	a_706_463##3	5.19951e-19
C673	a_498_360##11	a_1224_74##13	9.06494e-21
C674	VPWR#9	a_319_360##5	1.77439e-19
C675	a_498_360##12	a_319_360##3	5.06746e-20
C676	RESET_B#17	a_498_360##11	5.56653e-18
C677	a_319_360##11	RESET_B#3	2.86341e-18
C678	VGND#5	a_1482_48##5	4.76683e-18
C679	Q#2	a_1224_74##2	4.87773e-19
C680	a_498_360##5	a_1224_74##13	1.92692e-17
C681	a_38_78##2	a_319_360##6	7.40373e-18
C682	D	VPWR#11	1.99581e-17
C683	RESET_B#6	a_706_463#	3.36664e-19
C684	VPWR#17	a_841_401##3	2.07418e-19
C685	VGND#7	a_1224_74##13	9.53372e-18
C686	Q_N#1	a_1224_74##5	2.03104e-19
C687	VPWR#16	a_319_360##9	1.19916e-18
C688	VPWR#3	Q#1	2.1053e-17
C689	CLK#1	a_319_360##8	2.09585e-17
C690	a_498_360#	a_706_463##7	8.70326e-18
C691	VGND#6	a_319_360#	6.99535e-19
C692	VPWR#7	a_841_401##3	3.14087e-18
C693	a_1224_74##4	VNB	6.86261e-17
C694	VGND#11	a_1224_74##5	2.03474e-19
C695	VGND#7	a_841_401##5	9.06886e-18
C696	a_1224_74##2	VNB	6.21607e-17
C697	RESET_B#19	Q_N#2	2.07044e-18
C698	a_498_360##5	a_841_401##5	2.13496e-17
C699	a_319_360##3	VNB	1.59655e-16
C700	RESET_B#6	VNB	3.13387e-17
C701	RESET_B#2	VNB	1.28226e-16
C702	a_38_78##2	a_498_360#	3.47329e-17
C703	Q	a_2026_424##3	1.08002e-17
C704	Q	a_1224_74#	6.77878e-19
C705	VPWR#17	a_319_360##6	5.17662e-19
C706	a_1224_74##13	a_706_463##3	1.15357e-18
C707	RESET_B#19	VPWR#13	9.3342e-19
C708	a_319_360##11	D#1	1.34403e-18
C709	VPWR#3	a_2026_424##6	1.5063e-17
C710	VGND#5	a_319_360#	4.18487e-18
C711	VPWR#16	VPWR#15	5.563e-18
C712	VPWR#9	CLK#2	8.41777e-20
C713	a_706_463##5	VPWR#15	2.2438e-17
C714	a_498_360##13	a_498_360#	1.6829e-19
C715	VGND#5	a_1224_74##12	1.14447e-18
C716	D	D#1	6.36323e-18
C717	RESET_B#19	a_1482_48##4	4.95997e-18
C718	VPWR#9	a_319_360##3	1.60947e-18
C719	RESET_B#15	RESET_B#5	1.16392e-17
C720	Q_N#2	VPWR#3	6.89359e-17
C721	RESET_B#3	CLK#1	4.23173e-18
C722	RESET_B#8	a_319_360##3	2.19972e-17
C723	VGND#3	VPWR#12	3.58776e-18
C724	a_38_78##2	a_319_360##9	2.45709e-17
C725	a_841_401##5	a_706_463##3	3.53112e-17
C726	a_2026_424##5	a_2026_424##3	1.9614e-19
C727	VPWR#17	a_498_360#	1.27487e-18
C728	RESET_B#19	VPWR#14	2.50716e-17
C729	VGND#6	a_498_360##5	9.59319e-18
C730	VGND#4	a_1224_74##2	2.01087e-18
C731	a_1224_74##13	RESET_B#7	3.84803e-19
C732	VGND#7	a_706_463##9	1.22867e-17
C733	a_498_360##13	a_319_360##9	3.1144e-17
C734	a_706_463##5	RESET_B#5	5.65414e-18
C735	Q	a_2026_424#	1.02782e-17
C736	Q	a_1224_74##6	6.59058e-19
C737	a_841_401##2	a_832_118#	2.31571e-19
C738	VGND#8	VNB	3.72262e-17
C739	CLK	CLK#3	1.19185e-19
C740	VGND#6	VNB	7.32e-17
C741	VGND#5	VNB	6.79373e-17
C742	a_1224_74##12	a_319_360##2	1.90241e-17
C743	a_706_463##3	VGND#13	1.27446e-17
C744	VPWR#3	a_1482_48##4	1.82184e-17
C745	VGND#7	a_38_78#	1.13125e-17
C746	VPWR#10	VNB	3.77156e-17
C747	VGND#3	Q_N#2	2.28103e-18
C748	a_38_78##2	CLK#3	9.93502e-18
C749	VPWR#9	VNB	3.82966e-17
C750	a_706_463##5	a_706_463##8	2.30465e-18
C751	VPWR#7	VNB	3.25578e-17
C752	VPWR#6	VNB	4.70758e-17
C753	VPWR#5	VNB	5.52543e-17
C754	VPWR#4	VNB	2.02018e-17
C755	VPWR#17	a_319_360##9	4.02484e-17
C756	a_2026_424##5	VNB	4.04188e-18
C757	a_1482_48##2	a_1224_74##4	3.70533e-20
C758	a_841_401##5	RESET_B#7	7.64181e-18
C759	RESET_B#19	a_1224_74##14	1.17483e-17
C760	D#1	RESET_B#3	3.89333e-17
C761	a_706_463##2	RESET_B#15	2.60934e-17
C762	a_1482_48##5	VNB	2.4314e-17
C763	VGND#7	a_498_360##11	1.7518e-16
C764	a_1224_74##12	VNB	8.88297e-18
C765	a_706_463##6	VPWR#16	1.64388e-17
C766	D	D#3	1.26582e-17
C767	a_498_360##13	CLK#3	2.92556e-18
C768	a_498_360##12	VNB	2.33661e-18
C769	a_706_463##7	a_319_360##3	2.68632e-18
C770	a_498_360##12	a_498_360##2	1.56056e-19
C771	a_319_360##12	a_319_360##9	1.92483e-18
C772	VPWR#8	CLK	1.24805e-18
C773	a_1224_74##13	a_841_401#	2.60404e-19
C774	RESET_B#15	VNB	8.59509e-19
C775	a_2026_424##5	a_1224_74#	1.27498e-18
C776	a_706_463##6	VNB	5.94524e-18
C777	a_706_463##5	VNB	8.72721e-18
C778	a_38_78##4	VNB	1.91766e-17
C779	VGND#3	a_1482_48##4	2.29675e-18
C780	a_38_78##2	RESET_B#4	4.03331e-19
C781	a_319_360##11	VNB	1.6866e-17
C782	a_706_463##9	a_498_360##5	2.85148e-19
C783	a_706_463##2	a_706_463##5	1.00321e-18
C784	VPWR#17	CLK#3	3.73535e-17
C785	RESET_B#7	VGND#13	1.02506e-17
C786	Q#2	VNB	3.84699e-17
C787	VGND#4	VNB	9.00293e-18
C788	VPWR#8	D	7.45576e-18
C789	VGND#6	a_706_463##3	1.43598e-17
C790	a_2026_424##7	VNB	5.66657e-18
C791	Q_N#1	VNB	1.69072e-17
C792	VGND#11	VNB	1.78798e-18
C793	VGND#7	D	8.14705e-18
C794	VPWR#7	a_319_360##3	3.67819e-17
C795	VPWR#3	a_1224_74##14	2.46351e-17
C796	VGND#12	VNB	6.47561e-19
C797	VGND#3	Q	2.30071e-17
C798	a_38_78#	a_706_463##9	9.52195e-17
C799	a_1224_74##13	VNB	1.59324e-18
C800	a_841_401##3	a_319_360##3	1.8951e-17
C801	a_841_401##5	VNB	4.62403e-18
C802	a_706_463##5	VPWR#16	3.25011e-17
C803	a_841_401##5	a_841_401#	8.51856e-20
C804	a_1482_48##2	VGND#12	4.70369e-17
C805	a_706_463##9	VNB	2.57652e-18
C806	CLK#3	a_319_360##12	2.85114e-17
C807	a_38_78#	VNB	3.43841e-18
C808	a_498_360##11	VNB	3.8169e-17
C809	VGND#14	VNB	3.60125e-18
C810	VGND#15	VNB	4.14918e-18
C811	Q_N#1	a_1224_74##4	3.39585e-17
C812	a_38_78##6	a_319_360##9	3.07971e-19
C813	a_2026_424##2	Q	2.97153e-17
C814	a_38_78##5	VNB	3.58628e-17
C815	Q#1	VNB	3.86865e-17
C816	VPWR#12	VNB	3.22952e-18
C817	a_2026_424##6	VNB	5.35462e-18
C818	a_498_360##5	a_319_360##2	1.01048e-19
C819	Q_N#2	VNB	2.88529e-17
C820	VPWR#13	VNB	4.54953e-18
C821	VPWR#17	RESET_B#4	3.10168e-18
C822	a_1482_48##4	VNB	2.35424e-18
C823	CLK	a_319_360##5	5.19907e-20
C824	a_841_401##3	RESET_B#6	5.82904e-18
C825	VPWR#14	VNB	6.58305e-18
C826	a_1224_74##14	VNB	3.5248e-19
C827	CLK	CLK#2	1.35016e-18
C828	a_841_401##4	VNB	6.15735e-18
C829	VPWR#18	CLK#3	5.60282e-18
C830	VPWR#15	VNB	4.90761e-18
C831	a_706_463##6	a_841_401##2	4.94685e-17
C832	a_498_360##12	a_319_360##5	6.03371e-17
C833	VPWR#16	VNB	1.16539e-17
C834	VPWR#9	a_319_360##9	3.69838e-18
C835	a_706_463##9	a_706_463##3	4.30674e-19
C836	a_706_463##7	VNB	6.7814e-19
C837	a_38_78##2	VNB	9.61247e-18
C838	a_498_360##13	VNB	2.38784e-19
C839	a_1224_74##13	a_1482_48##2	2.39976e-17
C840	VPWR#17	VNB	7.22128e-19
C841	a_319_360##12	VNB	2.8688e-18
C842	VPWR#18	VNB	4.30338e-18
C843	a_2026_424##5	a_1224_74##7	1.93641e-19
C844	a_38_78##6	VNB	2.15803e-18
C845	a_841_401##2	a_706_463##5	1.92413e-17
C846	VPWR#11	VNB	5.55091e-17
C847	a_2026_424##3	VNB	3.30168e-17
C848	VGND#11	Q_N#2	6.29629e-18
C849	VGND#7	a_38_78##5	2.83039e-17
C850	a_1224_74#	VNB	3.53987e-17
C851	a_498_360##11	a_706_463##9	7.77457e-17
C852	a_1224_74##7	VNB	3.0658e-17
C853	D	D#2	5.36846e-17
C854	a_1224_74##10	VNB	2.91802e-17
C855	a_498_360##11	a_498_360##5	3.43924e-19
C856	RESET_B#9	VNB	3.48785e-17
C857	a_38_78##6	CLK#3	1.19273e-18
C858	a_1482_48##3	VNB	1.78111e-17
C859	a_498_360##5	a_706_463#	1.72732e-17
C860	a_319_360#	VNB	4.05814e-17
C861	a_498_360##5	VNB	3.88668e-17
C862	a_706_463##3	VNB	3.64377e-17
C863	RESET_B#7	VNB	3.88792e-17
C864	a_841_401#	VNB	2.95719e-17
C865	a_498_360##3	VNB	5.02943e-17
C866	a_319_360##7	VNB	3.80161e-17
C867	a_319_360##8	VNB	2.94438e-17
C868	VGND#6	RESET_B#7	2.92506e-18
C869	CLK#1	VNB	3.27176e-17
C870	VPWR#7	RESET_B#6	2.58564e-19
C871	a_38_78##2	a_319_360##3	8.87091e-18
C872	RESET_B#3	VNB	3.08517e-17
C873	D#1	VNB	5.79959e-17
C874	RESET_B#4	VPWR#18	1.92692e-17
C875	a_2026_424#	VNB	3.97133e-17
C876	a_1224_74##6	VNB	4.88538e-17
C877	a_1224_74##8	VNB	4.56077e-17
C878	a_1224_74##9	VNB	3.56646e-17
C879	VPWR#11	CLK#3	1.46658e-19
C880	RESET_B#11	VNB	2.58327e-17
C881	a_1482_48#	VNB	4.11381e-17
C882	a_498_360##6	VNB	2.87808e-17
C883	a_319_360##2	VNB	1.45035e-16
C884	a_706_463#	VNB	3.71173e-17
C885	RESET_B#17	a_1224_74##14	1.87996e-18
C886	RESET_B#8	VNB	2.51889e-17
C887	a_841_401##3	VNB	2.31198e-17
C888	a_706_463##9	RESET_B#7	7.18613e-19
C889	a_498_360##3	a_319_360##3	8.43945e-20
C890	a_319_360##6	VNB	2.50511e-17
C891	a_498_360#	VNB	2.28266e-17
C892	a_319_360##9	VNB	3.43979e-17
C893	CLK#3	VNB	4.23897e-17
C894	a_38_78##6	RESET_B#4	2.69874e-17
C895	RESET_B#4	VNB	3.188e-17
C896	a_1224_74##13	a_498_360##7	5.63539e-19
C897	a_706_463##6	a_498_360##2	5.0484e-18
C898	D#3	VNB	7.47013e-17
C899	RESET_B#19	VNB	5.15169e-19
C900	VPWR#6	a_319_360##3	3.34082e-18
C901	VPWR#3	VNB	2.59467e-16
C902	VGND#3	VNB	2.83173e-16
C903	CLK#2	a_498_360##12	2.75008e-18
C904	a_498_360##11	a_38_78#	8.55202e-17
C905	RESET_B#17	VNB	1.11773e-17
C906	a_498_360##11	a_706_463##3	3.48046e-18
C907	VPWR#8	VNB	2.98722e-16
C908	RESET_B#17	a_841_401##4	4.03368e-17
C909	VGND#7	VNB	3.50525e-16
C910	a_319_360##3	a_319_360##6	7.07219e-19
C911	a_2026_424##2	VNB	5.012e-17
C912	a_1224_74##5	VNB	6.98243e-17
C913	VPWR#9	CLK#3	4.29287e-18
C914	VPWR#18	D#3	7.14071e-19
C915	RESET_B#10	VNB	4.83817e-17
C916	a_1482_48##2	VNB	5.52413e-17
C917	a_498_360##7	VNB	4.2964e-17
C918	a_498_360##4	VNB	3.89851e-17
C919	RESET_B#5	VNB	3.87162e-17
C920	VPWR#11	RESET_B#4	1.26838e-18
C921	a_706_463##2	VNB	4.21017e-17
C922	a_841_401##2	VNB	5.39977e-17
C923	a_498_360##2	VNB	5.79066e-17
C924	a_319_360##5	VNB	1.27457e-16
C925	VGND#11	a_1224_74##4	1.14864e-17
C926	CLK#2	VNB	3.80931e-17
C927	D#2	VNB	1.00129e-16
C928	RESET_B#17	VPWR#15	6.93729e-17
C929	VPWR#16	a_498_360##13	2.19346e-20
C930	a_706_463##7	a_706_463##5	1.57322e-18
C931	Q_N#1	a_1224_74##2	2.12073e-19
C932	a_38_78##6	D#3	2.35212e-17
C933	a_2026_424##2	VPWR#12	3.61596e-17
C934	a_1224_74##6	a_2026_424#	3.58371e-17
C935	a_706_463##9	a_841_401#	4.91657e-18
C936	a_319_360##3	a_910_118#	8.05764e-19
C937	VGND#6	a_841_401#	7.78968e-19
C938	a_38_78##2	a_706_463##6	4.31858e-17
C939	a_498_360##4	a_1224_74##13	1.07663e-16
C940	CLK	VNB	2.26496e-18
C941	VGND#15	RESET_B#2	6.06597e-18
C942	D	VNB	4.57389e-17
C943	a_38_78##2	RESET_B#2	1.77684e-19
C944	Q	VNB	4.42289e-17
C945	VPWR#11	D#3	2.23526e-17
C946	a_498_360##11	RESET_B#7	6.69562e-18
C947	VPWR#10	RESET_B#4	5.69966e-18
C948	a_38_78##5	RESET_B	3.49194e-17
C949	VPWR#4	VPWR#2	1.68824e-19
C950	VGND#9	a_38_78##5	2.50593e-17
C951	VPWR#2	Q#1	3.72518e-17
C952	VGND#2	a_1224_74##2	1.00718e-18
C953	VPWR#2	VPWR#12	4.16873e-18
C954	VGND#9	D	1.42303e-18
C955	VGND#2	a_2026_424##2	4.41816e-19
C956	a_2026_424##6	VPWR#2	2.7609e-17
C957	Q_N#2	VPWR#2	4.08087e-18
C958	a_2026_424##5	VPWR#2	8.39574e-20
C959	VPWR#13	VPWR#2	5.63156e-19
C960	RESET_B	VPWR#18	2.96231e-18
C961	VPWR#3	VPWR#2	1.21649e-16
C962	VGND#9	D#1	7.86945e-18
C963	VGND#15	RESET_B	1.85932e-17
C964	VGND#2	Q	2.28418e-17
C965	RESET_B	a_319_360##12	8.94815e-17
C966	VGND#2	a_1224_74##7	2.33762e-19
C967	a_2026_424##2	VPWR#2	2.51872e-19
C968	RESET_B	VNB	2.13965e-17
C969	VGND#7	VGND#9	1.26124e-16
C970	RESET_B	VPWR#17	1.03032e-17
C971	RESET_B	VGND#14	4.81682e-18
C972	RESET_B	VPWR#9	4.89721e-18
C973	VGND#2	a_1224_74#	6.55799e-18
C974	RESET_B	a_498_360##13	3.16099e-17
C975	VGND#2	a_2026_424##5	3.55186e-19
C976	VGND#9	RESET_B#3	5.4722e-18
C977	VGND#2	VNB	5.89084e-17
C978	RESET_B	a_319_360##11	4.0143e-17
C979	RESET_B	a_498_360##11	3.5789e-18
C980	RESET_B	VPWR#10	2.09733e-18
C981	VGND#9	VGND#8	1.02139e-18
C982	RESET_B	a_38_78##2	3.49537e-17
C983	RESET_B	RESET_B#2	4.04748e-17
C984	RESET_B	CLK#1	7.69983e-20
C985	VGND#2	a_2026_424##3	6.91083e-18
C986	RESET_B	D#2	2.06911e-18
C987	RESET_B	a_38_78#	2.13071e-18
C988	VPWR#2	a_1224_74##4	1.30783e-19
C989	VGND#9	RESET_B#2	7.79673e-19
C990	RESET_B	D#3	2.66694e-19
C991	VGND#9	CLK#1	1.36032e-18
C992	VPWR#2	a_1224_74##2	2.00989e-18
C993	a_38_78##4	RESET_B	1.13286e-16
C994	VGND#9	VNB	6.80463e-17
C995	RESET_B	CLK#2	6.37737e-18
C996	RESET_B	a_498_360##12	8.24864e-18
C997	VPWR#2	a_2026_424#	1.30538e-17
C998	VPWR#2	a_1224_74##6	1.07023e-17
C999	VGND#3	VGND#2	1.16623e-16
C1000	VPWR#2	a_1224_74##8	6.34911e-19
C1001	RESET_B	CLK#3	2.2596e-18
C1002	RESET_B	a_319_360##5	1.68963e-17
C1003	RESET_B	D	4.2955e-18
C1004	VGND#9	a_319_360##8	2.08335e-19
C1005	VGND#2	a_2026_424##7	1.76955e-17
C1006	VGND#7	RESET_B	4.29528e-18
C1007	VGND#9	a_319_360##11	1.17168e-17
C1008	RESET_B	a_319_360##9	1.70611e-18
C1009	VGND#9	VGND#14	1.14092e-18
C1010	RESET_B	a_498_360##2	6.00618e-18
C1011	RESET_B	CLK	1.39684e-17
C1012	VPWR#2	VNB	6.46835e-17
C1013	VPWR#8	RESET_B	6.20913e-17
*
*
.ENDS sky130_fd_sc_hs__dfrbp_1
*
