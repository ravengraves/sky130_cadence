* Extracted by Quantus, converted by sky130cad/quantus.py
*
*
*
*                       LINUX           Wed Nov 18 08:13:03 2026
*
*
*
*  PROGRAM  advgen
*
*  Name           : advgen - Quantus - (64-bit)
*  Version        : 25.1.0-p047
*  Build Date     : Thu Dec 11 23:20:30 PST 2025
*
*  HSPICE LIBRARY
*
*  OPERATING_TEMPERATURE 150
*  QRC_TECH_DIR <path>/tech
*
*
*

*
.SUBCKT sky130_fd_sc_hs__a31oi_1 VPB VNB VGND VPWR Y A2 A3 A1 B1
*
*
*  caps2d version: 10
*
*
*       TRANSISTOR CARDS
*
*
XM3 VGND#4 A3#1 a_145_74# VNB sky130_fd_pr__nfet_01v8_lvt l=0.15 w=0.74 ad=0.3182 as=0.1776 pd=2.34 ps=1.96
XM6 a_145_74# A2#3 a_223_74# VNB sky130_fd_pr__nfet_01v8_lvt l=0.15 w=0.74 ad=0.1776 as=0.3108 pd=1.96 ps=2.32
XM4 a_223_74# A1#3 Y#3 VNB sky130_fd_pr__nfet_01v8_lvt l=0.15 w=0.74 ad=0.3108 as=0.3108 pd=2.32 ps=2.32
XM1 Y#3 B1#3 VGND#5 VNB sky130_fd_pr__nfet_01v8_lvt l=0.15 w=0.74 ad=0.3108 as=0.2109 pd=2.32 ps=2.05
XM5 VPWR#3 A3#4 a_136_368##2 VPB sky130_fd_pr__pfet_01v8 l=0.15 w=1.12 ad=0.4312 as=0.336 pd=3.01 ps=2.84
XM7 a_136_368##2 A2#1 VPWR#4 VPB sky130_fd_pr__pfet_01v8 l=0.15 w=1.12 ad=0.336 as=0.5488 pd=2.84 ps=3.22
XM0 VPWR#4 A1#1 a_136_368# VPB sky130_fd_pr__pfet_01v8 l=0.15 w=1.12 ad=0.5488 as=0.392 pd=3.22 ps=2.94
XM2 a_136_368# B1#4 Y#1 VPB sky130_fd_pr__pfet_01v8 l=0.15 w=1.12 ad=0.392 as=0.3304 pd=2.94 ps=2.83
*
*
*       RESISTOR AND CAP/DIODE CARDS
*
Rg1	A3#1	A3#2	320.354431
Rg2	A3#2	A3#3	44.378014
Rg3	A3#2	A3#4	506.680298
Rg4	A2#1	A2#2	492.059540
Rg5	A2#2	A2#3	307.937683
Rg6	A1#1	A1#2	493.808685
Rg7	A1#2	A1#3	440.886749
Rg8	B1#1	B1#2	110.730057
Rg9	B1#2	B1#3	322.953644
Rg10	B1#2	B1#4	507.075531
Rf1	A3	A3#5	0.882458
Rf2	A3#6	A3#3	161.115265
Rf3	A3#5	A3#6	3.543054
Rf4	A2#2	A2	163.582779
Rf5	A1	A1#2	163.775864
Rf6	a_136_368#	a_136_368##2	102.871391
Rf7	Y	Y#2	0.132113
Rf8	Y#2	Y	9.644220
Rf9	Y	Y#3	315.104614
Rf10	Y#1	Y#2	5.000000
Rf11	B1	B1#1	7.059660
Rf12	B1#1	B1	9.883524
Rf14	VGND#2	VGND#3	69.738693
Rf15	VGND#3	VGND#4	113.735641
Rf16	VGND#2	VGND#5	31.731567
Rf18	VPWR#2	VPWR#3	122.006790
Rf19	VPWR#2	VPWR#4	34.245285
Re1	VPWR#2	VPWR	1.637070
Re2	VGND	VGND#3	1.637131
*
*       CAPACITOR CARDS
*
*
C1	VGND	VNB	6.7446e-17
C2	VPWR	VNB	5.86593e-17
C3	Y	VNB	9.18617e-17
C4	A2	VNB	2.43957e-18
C5	VGND	Y	9.22365e-18
C6	A1	VNB	1.36248e-18
C7	B1	VNB	2.95578e-17
C8	VGND	A2	6.66317e-18
C9	VPWR	Y	3.10581e-17
C10	VGND	A1	2.96889e-18
C11	VGND	B1	7.94859e-18
C12	A3#3	VNB	6.56915e-17
C13	A2#2	VNB	2.99991e-17
C14	Y	A2	5.38872e-19
C15	A1#2	VNB	2.46027e-17
C16	VPWR	A1	1.96447e-18
C17	VGND#3	VNB	1.72774e-16
C18	VPWR	B1	4.66675e-18
C19	A1	Y	4.10266e-17
C20	A3#4	VNB	4.7056e-17
C21	VGND	A3#3	3.79995e-19
C22	A2#1	VNB	3.75906e-17
C23	B1	Y	6.95542e-17
C24	VGND	A2#2	3.32079e-19
C25	A1#1	VNB	3.76914e-17
C26	B1#4	VNB	4.16538e-17
C27	A2	A1	1.54369e-17
C28	VGND	A1#2	3.32079e-19
C29	A3#1	VNB	3.42854e-17
C30	A2#3	VNB	2.66148e-17
C31	VGND	VGND#3	2.53766e-17
C32	A1#3	VNB	2.87005e-17
C33	B1#3	VNB	2.99972e-17
C34	VPWR#3	VNB	8.59775e-17
C35	A2	a_145_74#	8.61107e-21
C36	VPWR	A2#2	2.44356e-18
C37	a_136_368##2	VNB	2.16403e-18
C38	VPWR#4	VNB	5.31481e-18
C39	A2	a_223_74#	2.00195e-18
C40	a_136_368#	VNB	2.75115e-18
C41	VGND#4	VNB	6.84316e-17
C42	Y	A3#3	8.20608e-18
C43	A1	B1	3.12998e-17
C44	Y	A2#2	5.95494e-17
C45	Y#3	VNB	1.16534e-17
C46	VGND	A3#1	1.57993e-18
C47	VGND#5	VNB	3.24788e-17
C48	A3#5	VNB	7.75323e-18
C49	Y	A1#2	2.67386e-18
C50	VGND	A2#3	1.02137e-18
C51	A3#6	VNB	1.20455e-17
C52	VPWR	A3#4	3.96472e-18
C53	VGND	A1#3	9.64916e-19
C54	A2	A3#3	2.11307e-18
C55	VGND	B1#3	4.68416e-19
C56	VPWR	A2#1	1.82674e-19
C57	A2	A2#2	9.14694e-18
C58	VGND	VPWR#3	3.44359e-18
C59	VPWR	A1#1	3.72933e-19
C60	VPWR	B1#4	1.84927e-18
C61	A2	A1#2	1.44932e-18
C62	Y	A3#4	1.08506e-17
C63	VGND	VGND#4	4.4913e-17
C64	Y	A2#1	1.43205e-17
C65	VGND	Y#3	4.51697e-17
C66	Y	A1#1	1.98823e-17
C67	VGND	VGND#5	2.21966e-17
C68	VPWR	VPWR#3	4.20859e-17
C69	Y	B1#4	5.07241e-17
C70	A2#2	A1	1.46877e-17
C71	VGND	A3#5	3.17281e-18
C72	VPWR	a_136_368##2	1.75938e-17
C73	VPWR	VPWR#4	2.20827e-17
C74	A1	A1#2	1.9423e-17
C75	VPWR	a_136_368#	1.79325e-17
C76	B1	A1#2	4.47004e-18
C77	VPWR#3	Y	2.31259e-17
C78	Y	a_136_368##2	5.91476e-17
C79	A2	A3#1	3.53677e-18
C80	Y	VPWR#4	1.11971e-18
C81	A2	A2#3	1.34533e-17
C82	VPWR	A3#6	2.69834e-18
C83	Y	a_136_368#	1.41824e-16
C84	A2#2	a_223_74#	9.03745e-19
C85	A2	A1#3	6.3208e-18
C86	Y	Y#1	4.92321e-18
C87	A2	B1#3	2.54137e-18
C88	Y#3	Y	9.08969e-18
C89	A3#6	Y	2.11257e-17
C90	A3#3	A2#2	3.10541e-17
C91	Y#3	A2	7.85508e-17
C92	A2#2	A1#2	2.69193e-17
C93	A3#1	a_145_74#	1.35023e-17
C94	A2#3	a_145_74#	2.64737e-18
C95	VGND#3	A2#2	1.57414e-19
C96	B1#2	VNB	7.88858e-17
C97	VGND#3	A1#2	1.54797e-19
C98	A2#3	a_223_74#	1.75511e-17
C99	Y#3	A1	2.65654e-17
C100	A1#3	a_223_74#	1.10104e-17
C101	A1#2	B1#2	3.07412e-17
C102	Y#3	B1	1.79319e-17
C103	VGND#5	B1	4.57027e-17
C104	Y#3	a_145_74#	2.00943e-18
C105	Y#3	a_223_74#	5.59558e-18
C106	VPWR#3	A3#3	1.00511e-17
C107	VGND	B1#2	4.90778e-19
C108	A3#4	A2#1	4.8238e-17
C109	a_136_368##2	A2#2	5.85451e-19
C110	VPWR#4	A2#2	1.03382e-18
C111	VGND#3	A2#3	5.31202e-18
C112	A3#3	VGND#4	9.5682e-18
C113	VGND#3	A1#3	5.31202e-18
C114	A2#1	A1#1	2.26282e-17
C115	a_136_368#	A1#2	7.16307e-19
C116	Y#3	A3#3	4.69912e-18
C117	A1#1	B1#4	3.91929e-17
C118	A3#5	A3#3	9.52678e-18
C119	VPWR	B1#2	6.87871e-19
C120	Y#3	A2#2	2.57553e-18
C121	A3#6	A3#3	1.4782e-17
C122	VGND#3	B1#2	1.71863e-21
C123	A1#2	Y#3	4.16201e-18
C124	VGND#3	VGND#4	3.48732e-17
C125	VPWR#3	A3#4	3.72118e-17
C126	a_136_368##2	A3#4	5.05966e-17
C127	VPWR#3	A2#1	1.95557e-18
C128	VPWR#4	A3#4	1.32467e-18
C129	a_136_368##2	A2#1	6.91177e-17
C130	VGND#3	Y#3	4.77568e-17
C131	VPWR#3	A1#1	6.75218e-19
C132	A3#1	A2#3	4.56221e-17
C133	A2#1	VPWR#4	3.81643e-17
C134	Y	B1#2	9.78143e-18
C135	a_136_368##2	A1#1	1.36014e-18
C136	VPWR#3	B1#4	4.03989e-19
C137	a_136_368#	A2#1	1.37598e-18
C138	A1#1	VPWR#4	3.41652e-17
C139	A2#3	A1#3	2.10312e-17
C140	a_136_368#	A1#1	6.8693e-17
C141	VPWR#4	B1#4	1.3743e-18
C142	B1#4	a_136_368#	2.45011e-17
C143	A1#3	B1#3	2.22676e-17
C144	B1#4	Y#1	1.17607e-17
C145	A3#1	VGND#4	2.52478e-17
C146	VPWR#3	a_136_368##2	7.11524e-17
C147	VGND#4	A2#3	1.08034e-18
C148	VPWR#3	VPWR#4	1.37226e-18
C149	VGND#4	A1#3	6.31635e-19
C150	Y#3	A3#1	2.14617e-17
C151	a_136_368##2	VPWR#4	6.30385e-17
C152	VGND#5	A3#1	4.00762e-19
C153	VGND#4	B1#3	4.42832e-19
C154	a_136_368##2	a_136_368#	2.33146e-18
C155	Y#3	A2#3	2.66023e-17
C156	VGND#5	A2#3	5.87316e-19
C157	a_136_368#	VPWR#4	6.06679e-17
C158	Y#3	A1#3	4.4404e-17
C159	VGND#5	A1#3	2.48114e-18
C160	B1#3	Y#3	2.15411e-17
C161	A1	B1#2	4.12808e-18
C162	VGND#5	B1#3	3.40827e-17
C163	A3#6	VPWR#3	2.43344e-17
C164	B1	B1#2	3.26405e-17
C165	VGND#4	Y#3	7.21762e-17
C166	VGND#4	A3#5	3.24887e-17
C167	Y#3	VGND#5	5.92407e-17
C168	A3#5	Y#3	2.00944e-17
C169	A3#6	Y#3	2.77325e-18
C170	B1#2	VGND#5	8.08473e-18
C171	a_136_368##2	VPWR#2	1.52611e-17
C172	VGND#2	VNB	4.3163e-17
C173	VPWR#2	VNB	2.13896e-16
C174	VGND#3	VGND#2	4.40748e-17
C175	Y	VPWR#2	3.10709e-17
C176	VPWR#2	B1#4	6.3678e-18
C177	VPWR#2	VPWR#3	3.23943e-17
C178	a_136_368#	VPWR#2	2.10549e-17
C179	VPWR	VPWR#2	5.59042e-17
C180	VPWR#2	A1#1	5.67699e-18
C181	VGND#2	B1#3	3.75761e-18
C182	VPWR#2	A1#2	5.45167e-20
C183	VGND	VGND#2	3.10691e-17
C184	VPWR#2	A2#1	5.6704e-18
C185	VGND#2	Y#3	9.99174e-18
C186	B1	VPWR#2	3.09124e-19
C187	VGND#2	B1	2.19598e-18
C188	VPWR#2	B1#2	6.7658e-19
C189	VGND#2	B1#2	7.75846e-19
*
*
.ENDS sky130_fd_sc_hs__a31oi_1
*
