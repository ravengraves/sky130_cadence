* Extracted by Quantus, converted by sky130cad/quantus.py
*
*
*
*                       LINUX           Wed Nov 18 09:04:47 2026
*
*
*
*  PROGRAM  advgen
*
*  Name           : advgen - Quantus - (64-bit)
*  Version        : 25.1.0-p047
*  Build Date     : Thu Dec 11 23:20:30 PST 2025
*
*  HSPICE LIBRARY
*
*  OPERATING_TEMPERATURE 150
*  QRC_TECH_DIR <path>/tech
*
*
*

*
.SUBCKT sky130_fd_sc_hs__o41ai_4 VNB VPB VGND VPWR Y B1 A4 A3 A2 A1
*
*
*  caps2d version: 10
*
*
*       TRANSISTOR CARDS
*
*
XM6 a_27_74##12 B1#5 Y#8 VNB sky130_fd_pr__nfet_01v8_lvt l=0.15 w=0.74 ad=0.2109 as=0.2072 pd=2.05 ps=2.04
XM11 Y#8 B1#7 a_27_74##20 VNB sky130_fd_pr__nfet_01v8_lvt l=0.15 w=0.74 ad=0.2072 as=0.2072 pd=2.04 ps=2.04
XM35 a_27_74##20 B1#6 Y#6 VNB sky130_fd_pr__nfet_01v8_lvt l=0.15 w=0.74 ad=0.2072 as=0.259 pd=2.04 ps=2.18
XM32 Y#6 B1#1 a_27_74##9 VNB sky130_fd_pr__nfet_01v8_lvt l=0.15 w=0.74 ad=0.259 as=0.259 pd=2.18 ps=2.18
XM30 a_27_74##9 A4#14 VGND#19 VNB sky130_fd_pr__nfet_01v8_lvt l=0.15 w=0.74 ad=0.259 as=0.4292 pd=2.18 ps=2.64
XM18 VGND#19 A4#11 a_27_74##19 VNB sky130_fd_pr__nfet_01v8_lvt l=0.15 w=0.74 ad=0.4292 as=0.2257 pd=2.64 ps=2.09
XM26 VGND#18 A4#9 a_27_74##19 VNB sky130_fd_pr__nfet_01v8_lvt l=0.15 w=0.74 ad=0.2072 as=0.2257 pd=2.04 ps=2.09
XM25 a_27_74##18 A4#1 VGND#18 VNB sky130_fd_pr__nfet_01v8_lvt l=0.15 w=0.74 ad=0.2072 as=0.2072 pd=2.04 ps=2.04
XM36 a_27_74##18 A3#11 VGND#17 VNB sky130_fd_pr__nfet_01v8_lvt l=0.15 w=0.74 ad=0.2072 as=0.259 pd=2.04 ps=2.18
XM13 a_27_74##17 A3#9 VGND#17 VNB sky130_fd_pr__nfet_01v8_lvt l=0.15 w=0.74 ad=0.2072 as=0.259 pd=2.04 ps=2.18
XM7 VGND#16 A3#7 a_27_74##17 VNB sky130_fd_pr__nfet_01v8_lvt l=0.15 w=0.74 ad=0.259 as=0.2072 pd=2.18 ps=2.04
XM27 VGND#16 A3#1 a_27_74##16 VNB sky130_fd_pr__nfet_01v8_lvt l=0.15 w=0.74 ad=0.259 as=0.2072 pd=2.18 ps=2.04
XM15 VGND#15 A2#7 a_27_74##16 VNB sky130_fd_pr__nfet_01v8_lvt l=0.15 w=0.74 ad=0.259 as=0.2072 pd=2.18 ps=2.04
XM2 a_27_74##15 A2#11 VGND#15 VNB sky130_fd_pr__nfet_01v8_lvt l=0.15 w=0.74 ad=0.2072 as=0.259 pd=2.04 ps=2.18
XM3 a_27_74##15 A2#9 VGND#14 VNB sky130_fd_pr__nfet_01v8_lvt l=0.15 w=0.74 ad=0.2072 as=0.2331 pd=2.04 ps=2.11
XM28 VGND#14 A2#8 a_27_74##14 VNB sky130_fd_pr__nfet_01v8_lvt l=0.15 w=0.74 ad=0.2331 as=0.2479 pd=2.11 ps=2.15
XM34 VGND#13 A1#12 a_27_74##14 VNB sky130_fd_pr__nfet_01v8_lvt l=0.15 w=0.74 ad=0.2701 as=0.2479 pd=2.21 ps=2.15
XM33 VGND#13 A1#10 a_27_74##13 VNB sky130_fd_pr__nfet_01v8_lvt l=0.15 w=0.74 ad=0.2701 as=0.2072 pd=2.21 ps=2.04
XM19 a_27_74##13 A1#8 VGND#12 VNB sky130_fd_pr__nfet_01v8_lvt l=0.15 w=0.74 ad=0.2072 as=0.259 pd=2.04 ps=2.18
XM8 a_27_74# A1#1 VGND#12 VNB sky130_fd_pr__nfet_01v8_lvt l=0.15 w=0.74 ad=0.2109 as=0.259 pd=2.05 ps=2.18
XM37 Y#9 B1#9 VPWR#6 VPB sky130_fd_pr__pfet_01v8 l=0.15 w=1.12 ad=0.448 as=0.3304 pd=3.04 ps=2.83
XM0 VPWR#9 B1#8 Y#9 VPB sky130_fd_pr__pfet_01v8 l=0.15 w=1.12 ad=0.3304 as=0.448 pd=2.83 ps=3.04
XM1 a_339_368##9 A4#8 Y#3 VPB sky130_fd_pr__pfet_01v8 l=0.15 w=1.12 ad=0.3304 as=0.336 pd=2.83 ps=2.84
XM20 Y#3 A4#13 a_339_368##8 VPB sky130_fd_pr__pfet_01v8 l=0.15 w=1.12 ad=0.336 as=0.336 pd=2.84 ps=2.84
XM5 a_339_368##8 A4#12 Y#1 VPB sky130_fd_pr__pfet_01v8 l=0.15 w=1.12 ad=0.336 as=0.336 pd=2.84 ps=2.84
XM22 Y#1 A4#10 a_339_368##6 VPB sky130_fd_pr__pfet_01v8 l=0.15 w=1.12 ad=0.336 as=0.336 pd=2.84 ps=2.84
XM24 a_788_368##6 A3#6 a_339_368##6 VPB sky130_fd_pr__pfet_01v8 l=0.15 w=1.12 ad=0.448 as=0.336 pd=3.04 ps=2.84
XM9 a_339_368##3 A3#12 a_788_368##6 VPB sky130_fd_pr__pfet_01v8 l=0.15 w=1.12 ad=0.336 as=0.448 pd=2.84 ps=3.04
XM4 a_788_368##3 A3#10 a_339_368##3 VPB sky130_fd_pr__pfet_01v8 l=0.15 w=1.12 ad=0.336 as=0.336 pd=2.84 ps=2.84
XM21 a_339_368# A3#8 a_788_368##3 VPB sky130_fd_pr__pfet_01v8 l=0.15 w=1.12 ad=0.3304 as=0.336 pd=2.83 ps=2.84
XM29 a_788_368##5 A2#13 a_1191_368##8 VPB sky130_fd_pr__pfet_01v8 l=0.15 w=1.12 ad=0.336 as=0.3304 pd=2.84 ps=2.83
XM14 a_1191_368##5 A2#12 a_788_368##5 VPB sky130_fd_pr__pfet_01v8 l=0.15 w=1.12 ad=0.336 as=0.336 pd=2.84 ps=2.84
XM31 a_788_368# A2#10 a_1191_368##5 VPB sky130_fd_pr__pfet_01v8 l=0.15 w=1.12 ad=0.336 as=0.336 pd=2.84 ps=2.84
XM12 a_1191_368##3 A2#1 a_788_368# VPB sky130_fd_pr__pfet_01v8 l=0.15 w=1.12 ad=0.336 as=0.336 pd=2.84 ps=2.84
XM17 a_1191_368##3 A1#6 VPWR#8 VPB sky130_fd_pr__pfet_01v8 l=0.15 w=1.12 ad=0.336 as=0.392 pd=2.84 ps=2.94
XM16 VPWR#8 A1#11 a_1191_368##7 VPB sky130_fd_pr__pfet_01v8 l=0.15 w=1.12 ad=0.392 as=0.336 pd=2.94 ps=2.84
XM23 VPWR#7 A1#9 a_1191_368##7 VPB sky130_fd_pr__pfet_01v8 l=0.15 w=1.12 ad=0.392 as=0.336 pd=2.94 ps=2.84
XM10 a_1191_368# A1#7 VPWR#7 VPB sky130_fd_pr__pfet_01v8 l=0.15 w=1.12 ad=0.3304 as=0.392 pd=2.83 ps=2.94
*
*
*       RESISTOR AND CAP/DIODE CARDS
*
Rg1	B1#1	B1#2	513.378540
Rg2	B1#2	B1#3	154.404327
Rg3	B1#3	B1#4	56.372738
Rg4	B1#4	B1#5	297.108032
Rg5	B1#2	B1#6	262.702026
Rg6	B1#3	B1#7	295.564484
Rg7	B1#3	B1#8	512.211304
Rg8	B1#4	B1#9	493.723785
Rg9	A4#1	A4#2	466.777130
Rg10	A4#2	A4#3	73.191986
Rg11	A4#3	A4#4	34.769192
Rg12	A4#4	A4#5	15.573307
Rg13	A4#5	A4#6	29.930607
Rg14	A4#6	A4#7	29.974819
Rg15	A4#7	A4#8	452.145508
Rg16	A4#2	A4#9	275.603516
Rg17	A4#3	A4#10	403.131470
Rg18	A4#4	A4#11	297.384308
Rg19	A4#5	A4#12	400.390808
Rg20	A4#6	A4#13	436.195557
Rg21	A4#7	A4#14	284.340485
Rg22	A3#1	A3#2	419.793488
Rg23	A3#2	A3#3	24.367487
Rg24	A3#3	A3#4	33.086029
Rg25	A3#4	A3#5	37.663319
Rg26	A3#5	A3#6	677.262695
Rg27	A3#2	A3#7	336.932312
Rg28	A3#2	A3#8	449.407257
Rg29	A3#4	A3#9	318.885620
Rg30	A3#4	A3#10	440.186218
Rg31	A3#5	A3#11	344.508087
Rg32	A3#5	A3#12	451.222778
Rg33	A2#1	A2#2	507.633148
Rg34	A2#2	A2#3	66.369736
Rg35	A2#3	A2#4	31.835342
Rg36	A2#4	A2#5	47.585129
Rg37	A2#5	A2#6	66.386436
Rg38	A2#6	A2#7	318.816589
Rg39	A2#2	A2#8	323.721649
Rg40	A2#3	A2#9	320.892242
Rg41	A2#3	A2#10	506.023621
Rg42	A2#5	A2#11	319.959229
Rg43	A2#5	A2#12	504.081116
Rg44	A2#6	A2#13	507.470581
Rg45	A1#1	A1#2	322.953644
Rg46	A1#2	A1#3	96.590942
Rg47	A1#3	A1#4	55.853767
Rg48	A1#4	A1#5	76.230057
Rg49	A1#5	A1#6	516.620850
Rg50	A1#2	A1#7	507.075531
Rg51	A1#3	A1#8	299.509430
Rg52	A1#3	A1#9	483.631287
Rg53	A1#4	A1#10	320.203186
Rg54	A1#4	A1#11	505.450867
Rg55	A1#5	A1#12	329.212952
Rf1	B1	B1#10	2.823864
Rf2	B1#10	B1	14.119321
Rf3	A4#6	A4	53.940411
Rf4	Y#1	Y	39.928337
Rf5	Y	Y#2	3.415111
Rf6	Y	Y#4	10.865244
Rf7	Y#4	Y#5	46.414654
Rf8	Y#5	Y#7	34.180752
Rf9	Y#7	Y#8	72.793419
Rf10	Y#4	Y#3	40.194965
Rf11	Y#5	Y#9	84.680977
Rf12	Y#1	Y#2	15.000000
Rf13	Y#3	Y#4	15.000000
Rf14	Y#6	Y#7	15.000000
Rf15	a_339_368##2	a_339_368#	42.163414
Rf16	a_339_368##2	a_339_368##4	68.156113
Rf17	a_339_368##4	a_339_368##3	42.163414
Rf18	a_339_368##4	a_339_368##5	73.334007
Rf19	a_339_368##5	a_339_368##6	26.446381
Rf20	a_339_368##5	a_339_368##7	66.659103
Rf21	a_339_368##7	a_339_368##8	18.793110
Rf22	a_339_368##7	a_339_368##10	66.777367
Rf23	a_339_368##10	a_339_368##9	40.878479
Rf24	a_339_368#	a_339_368##2	15.000000
Rf25	a_339_368##3	a_339_368##4	15.000000
Rf26	a_339_368##9	a_339_368##10	15.000000
Rf27	A3	A3#13	1.058949
Rf28	A3#13	A3	15.884235
Rf29	a_788_368#	a_788_368##2	95.722542
Rf30	a_788_368##2	a_788_368##4	107.543167
Rf31	a_788_368##2	a_788_368##5	27.992708
Rf32	a_788_368##4	a_788_368##6	90.978661
Rf33	a_788_368##4	a_788_368##3	48.459789
Rf34	a_788_368##3	a_788_368##4	15.000000
Rf35	A2	A2#14	2.823864
Rf36	A2#14	A2	14.119321
Rf37	A1	A1#13	2.823864
Rf38	A1#13	A1	14.119321
Rf39	a_27_74#	a_27_74##2	83.183289
Rf40	a_27_74##2	a_27_74##3	70.136757
Rf41	a_27_74##3	a_27_74##4	68.433075
Rf42	a_27_74##4	a_27_74##5	65.145798
Rf43	a_27_74##5	a_27_74##6	68.002594
Rf44	a_27_74##6	a_27_74##7	62.120838
Rf45	a_27_74##7	a_27_74##8	109.444519
Rf46	a_27_74##8	a_27_74##10	79.426659
Rf47	a_27_74##10	a_27_74##11	81.003578
Rf48	a_27_74##11	a_27_74##12	78.717010
Rf49	a_27_74##2	a_27_74##13	12.244770
Rf50	a_27_74##3	a_27_74##14	13.666845
Rf51	a_27_74##4	a_27_74##15	17.348473
Rf52	a_27_74##5	a_27_74##16	13.666845
Rf53	a_27_74##6	a_27_74##17	13.666845
Rf54	a_27_74##7	a_27_74##18	16.172878
Rf55	a_27_74##8	a_27_74##19	15.953205
Rf56	a_27_74##11	a_27_74##20	19.941607
Rf57	a_27_74##9	a_27_74##10	7.500000
Rf58	a_1191_368#	a_1191_368##2	97.462845
Rf59	a_1191_368##2	a_1191_368##4	92.820534
Rf60	a_1191_368##4	a_1191_368##6	85.179916
Rf61	a_1191_368##2	a_1191_368##7	25.098005
Rf62	a_1191_368##6	a_1191_368##5	42.163414
Rf63	a_1191_368##6	a_1191_368##9	62.914070
Rf64	a_1191_368##9	a_1191_368##8	42.163414
Rf65	a_1191_368##3	a_1191_368##4	5.000000
Rf66	a_1191_368##5	a_1191_368##6	15.000000
Rf67	a_1191_368##8	a_1191_368##9	15.000000
Rf69	VGND#2	VGND#3	71.820625
Rf70	VGND#3	VGND#4	74.085197
Rf71	VGND#4	VGND#5	62.774361
Rf72	VGND#5	VGND#6	67.887894
Rf73	VGND#6	VGND#7	67.887894
Rf74	VGND#7	VGND#8	68.010475
Rf75	VGND#8	VGND#9	28.952990
Rf76	VGND#9	VGND#10	45.779209
Rf78	VGND#2	VGND#12	33.326477
Rf79	VGND#3	VGND#13	36.824379
Rf80	VGND#4	VGND#14	33.326477
Rf81	VGND#5	VGND#15	33.326477
Rf82	VGND#6	VGND#16	33.326477
Rf83	VGND#7	VGND#17	33.326477
Rf84	VGND#8	VGND#18	56.430489
Rf85	VGND#10	VGND#19	26.054598
Rf87	VPWR#2	VPWR#3	70.213516
Rf88	VPWR#3	VPWR#4	369.745087
Rf89	VPWR#4	VPWR#5	151.920502
Rf90	VPWR#5	VPWR#6	109.212227
Rf91	VPWR#2	VPWR#7	36.160385
Rf92	VPWR#3	VPWR#8	39.658287
Rf93	VPWR#5	VPWR#9	36.061966
Rf96	A3#3	A3#13	40.058201
Rf97	A2#4	A2#14	40.058201
Rf98	A1#3	A1#13	40.058201
Rf94	B1#4	B1#10	53.410934
Re1	VPWR#3	VPWR	2.687498
Re2	VPWR	VPWR#4	1.343749
Re3	VGND#3	VGND	2.687498
Re4	VGND	VGND#9	1.343749
*
*       CAPACITOR CARDS
*
*
C1	a_339_368##7	Y#3	1.61552e-17
C2	a_27_74##9	Y#6	5.04991e-17
C3	a_27_74##6	VGND#17	4.31149e-17
C4	a_27_74##12	B1#7	1.80551e-18
C5	VGND#5	A2#7	2.71574e-18
C6	a_27_74##7	a_27_74##18	1.01693e-18
C7	B1#5	Y#8	2.05514e-17
C8	A1#10	A1#8	3.73535e-17
C9	a_27_74##8	VGND#18	7.84065e-17
C10	a_27_74##12	B1#5	4.39067e-17
C11	VGND#6	A3#1	1.23408e-18
C12	a_339_368##2	A3#10	8.5306e-19
C13	a_339_368##5	A4#3	3.56983e-20
C14	A3#5	a_339_368##3	3.43761e-18
C15	a_27_74##2	A1#1	1.53927e-18
C16	a_27_74##6	a_27_74##5	2.42159e-18
C17	a_339_368##5	A3#12	5.19066e-19
C18	A3#5	A2#13	2.73301e-19
C19	VGND#18	a_27_74##7	7.4782e-17
C20	a_788_368##6	A4#1	1.39605e-18
C21	VGND#7	VGND#6	1.44368e-18
C22	A1#12	A1#10	2.61088e-17
C23	a_27_74##8	a_27_74##19	4.25666e-18
C24	a_339_368##6	A4#1	5.15082e-19
C25	VGND#6	A3#7	2.74533e-18
C26	a_27_74##2	A1#8	3.35825e-17
C27	a_339_368##5	A3#6	2.62366e-17
C28	VGND#8	A3#9	8.52808e-20
C29	Y#8	Y#6	2.37845e-18
C30	a_27_74##11	a_27_74##9	2.5966e-18
C31	a_1191_368#	A1#7	3.74595e-17
C32	A2#8	A1#12	3.02006e-17
C33	a_27_74##3	A1#10	4.36872e-19
C34	VGND#7	A3#9	1.23726e-18
C35	a_27_74##8	VGND#19	4.63454e-17
C36	a_788_368##6	A3#5	1.18168e-17
C37	A2#2	A1#5	2.68105e-17
C38	VPWR#7	A1#7	5.65872e-17
C39	Y#8	a_27_74##20	2.51281e-19
C40	a_27_74##2	A1#10	3.04938e-17
C41	a_339_368##5	A4#10	2.39746e-17
C42	a_1191_368#	A1#9	7.64554e-19
C43	Y#5	A3#6	6.77144e-19
C44	a_1191_368##7	A1#7	1.32172e-18
C45	a_27_74##11	Y#6	5.04322e-17
C46	VGND#8	A3#11	3.05617e-19
C47	A2#9	A2#8	3.2485e-17
C48	A1#9	VPWR#7	2.50746e-17
C49	VPWR#8	A1#7	3.63184e-19
C50	a_27_74##3	A1#12	3.06899e-17
C51	a_27_74##9	a_27_74##8	3.38445e-18
C52	Y#5	a_339_368##9	3.8693e-17
C53	a_339_368##7	A4#12	1.5474e-17
C54	VGND#6	VGND#5	1.44368e-18
C55	VGND#7	A3#11	2.71574e-18
C56	a_1191_368##7	A1#9	5.83968e-17
C57	a_339_368##5	A4#12	5.75915e-19
C58	a_27_74##2	A1#12	1.06161e-18
C59	VPWR#7	A1#11	1.18964e-18
C60	VPWR#8	A1#9	6.77197e-19
C61	a_27_74##12	Y#8	4.55192e-17
C62	a_27_74##11	a_27_74##20	1.01425e-18
C63	A2#11	A2#9	3.91135e-17
C64	VGND#8	A4#1	4.679e-18
C65	A2#6	A2#5	4.80129e-18
C66	a_1191_368##7	A1#11	4.8783e-17
C67	a_27_74##3	A2#8	2.63197e-17
C68	a_27_74##5	A2#9	2.86607e-19
C69	Y#5	VPWR#9	2.29836e-17
C70	a_339_368##7	A4#13	1.54829e-17
C71	Y#6	a_27_74##8	9.60018e-19
C72	A1#11	VPWR#8	2.47173e-17
C73	VPWR#7	A1#6	2.41252e-19
C74	a_339_368##5	A4#13	2.27448e-19
C75	a_27_74##5	A2#6	1.95034e-18
C76	a_788_368##6	A4#5	4.18448e-20
C77	a_27_74##2	A2#8	1.96619e-19
C78	a_27_74##4	A2#9	1.23689e-17
C79	a_1191_368##7	A1#6	1.32172e-18
C80	a_1191_368##3	A1#11	4.32368e-19
C81	VGND#18	A4#3	2.80278e-18
C82	A2#7	A2#11	2.37356e-17
C83	a_27_74##11	Y#8	3.39394e-17
C84	a_27_74##3	A1#5	1.38815e-18
C85	VPWR#8	A1#6	5.39163e-17
C86	a_27_74##3	A2#9	1.12043e-18
C87	a_27_74##7	A3#5	1.44322e-17
C88	a_27_74##5	A2#11	1.29159e-18
C89	VGND#8	A4#9	2.89776e-18
C90	VGND#3	VGND#5	1.81448e-17
C91	a_339_368##9	B1#1	1.77546e-18
C92	a_1191_368##3	A1#6	2.89079e-17
C93	VGND#3	VGND#4	5.69027e-17
C94	VGND#5	VGND#4	1.7314e-18
C95	a_27_74##4	A2#11	1.2564e-17
C96	a_1191_368##2	VPWR#3	3.02737e-18
C97	a_27_74##6	A2#7	1.91698e-19
C98	VPWR#8	A2#1	2.20397e-18
C99	a_788_368##6	A4#3	1.63118e-18
C100	A3#1	A2#7	3.82503e-17
C101	A4#1	A3#5	8.5195e-18
C102	A4#7	VGND#19	3.65196e-18
C103	a_27_74##12	a_27_74##11	3.22697e-18
C104	a_1191_368##3	A2#1	5.86399e-17
C105	a_27_74##3	A2#11	2.72166e-19
C106	a_27_74##5	A2#7	4.26209e-17
C107	a_27_74#	A1#2	1.24751e-18
C108	a_27_74##7	A3#1	1.80534e-19
C109	a_339_368##6	A4#5	1.16352e-19
C110	Y#5	A4#8	1.06911e-17
C111	VGND#8	A4#11	5.08348e-19
C112	A2#1	a_788_368#	2.65265e-17
C113	a_1191_368##2	a_1191_368#	2.54741e-18
C114	VPWR#8	A2#10	2.65252e-19
C115	A4#3	a_27_74##19	4.55311e-19
C116	a_27_74##8	A4#7	1.57462e-18
C117	VPWR#7	a_1191_368#	8.26212e-17
C118	a_27_74##3	a_27_74##2	2.52066e-18
C119	a_1191_368##5	A2#1	1.48877e-17
C120	A4#5	VGND#19	1.24553e-18
C121	a_1191_368##3	A2#10	2.43214e-18
C122	a_27_74##6	A3#1	1.0331e-18
C123	VGND#3	a_1191_368##2	6.41033e-18
C124	A3#7	A3#1	2.78636e-17
C125	a_27_74##2	A1#5	5.45358e-20
C126	a_27_74##6	A3#5	6.6699e-18
C127	a_788_368##5	A2#1	7.64064e-20
C128	a_788_368#	A2#10	3.99454e-17
C129	VPWR#8	A2#12	7.33399e-20
C130	VPWR#5	B1#1	1.53462e-19
C131	a_27_74#	VGND#12	4.11698e-17
C132	a_27_74##5	A3#1	2.0746e-17
C133	a_27_74##4	A2#5	1.00891e-18
C134	a_27_74##7	A3#7	4.81289e-19
C135	a_1191_368##5	A2#10	6.75482e-17
C136	a_1191_368##2	VPWR#7	3.08704e-17
C137	a_339_368##6	A4#3	3.05535e-18
C138	VGND#8	A4#14	4.72562e-20
C139	a_27_74##8	A4#5	4.26131e-18
C140	a_788_368##5	A2#10	3.52294e-19
C141	A3#9	A3#7	3.82503e-17
C142	a_788_368#	A2#12	4.35577e-19
C143	A4#7	a_27_74##9	5.00255e-18
C144	VPWR#8	A2#13	4.59545e-20
C145	a_27_74##6	A3#7	3.2884e-17
C146	a_27_74##2	A1#4	2.1678e-18
C147	a_1191_368##7	VPWR#7	8.14377e-17
C148	a_1191_368##5	A2#12	5.96199e-17
C149	Y#1	A4#5	1.0362e-17
C150	A1#2	VGND#12	1.60259e-18
C151	VGND#3	a_27_74##4	2.9265e-18
C152	a_27_74##5	A3#7	4.04506e-19
C153	A2#12	a_788_368##5	2.20089e-17
C154	VGND#3	a_27_74##3	2.72072e-17
C155	a_788_368##2	VPWR#3	1.54243e-18
C156	a_788_368#	A2#13	1.81578e-19
C157	a_27_74##7	A3#9	1.60202e-18
C158	VPWR#5	A4#7	2.9622e-20
C159	VGND#3	a_27_74##2	2.87646e-17
C160	a_1191_368##2	a_1191_368##7	1.76891e-19
C161	A3#11	A3#9	2.78682e-17
C162	a_27_74##5	A3#5	1.90875e-19
C163	a_1191_368##8	A2#12	1.59617e-18
C164	a_1191_368##5	A2#13	1.84786e-18
C165	VPWR#8	VPWR#7	1.17384e-18
C166	a_27_74##5	a_788_368##2	5.06343e-18
C167	a_27_74##6	A3#9	2.00297e-17
C168	a_27_74##2	A1#2	9.06658e-19
C169	A2#13	a_788_368##5	2.70489e-17
C170	A4#7	a_339_368##8	1.70668e-18
C171	Y#1	A4#3	1.90698e-18
C172	a_788_368##3	A2#12	1.0169e-19
C173	a_1191_368##8	A2#13	8.45002e-17
C174	VGND#3	a_788_368##2	1.21926e-18
C175	VPWR#8	a_1191_368##7	8.14689e-17
C176	A3#5	A2#6	2.60325e-18
C177	a_27_74##7	A3#11	3.74482e-17
C178	A4#3	A3#6	1.60604e-17
C179	A4#1	A3#11	3.67552e-17
C180	a_27_74##11	B1#2	3.72909e-19
C181	VGND#9	a_27_74##8	1.79196e-17
C182	a_27_74#	A1#1	2.88494e-17
C183	a_339_368#	A2#13	8.10231e-19
C184	a_788_368##5	A3#8	1.4688e-19
C185	a_1191_368##2	VPWR#8	3.08711e-17
C186	a_27_74##8	A4#3	2.90514e-17
C187	VGND#13	VGND#12	1.57663e-18
C188	VGND#5	A2#4	6.86163e-20
C189	a_27_74##6	A3#11	4.04506e-19
C190	a_788_368##3	A2#13	3.49055e-19
C191	a_1191_368##8	A3#8	1.76484e-18
C192	A1#5	VGND#13	9.7055e-19
C193	Y#5	B1#2	5.3674e-18
C194	VGND#4	A2#4	6.37728e-20
C195	A1#3	a_1191_368##2	1.21087e-16
C196	a_27_74##8	A4#1	1.46134e-18
C197	VGND#12	A1#1	3.37563e-17
C198	a_27_74##8	a_339_368##5	2.12608e-18
C199	a_339_368#	A3#8	5.1086e-17
C200	a_788_368##5	A3#10	4.27903e-20
C201	A4#9	A4#1	3.72542e-17
C202	a_27_74#	A1#8	7.39424e-19
C203	a_788_368##2	A3#1	1.56054e-18
C204	a_27_74##7	A4#1	2.91657e-17
C205	a_788_368##3	A3#8	3.17399e-17
C206	A4#5	A4#10	7.64696e-19
C207	a_1191_368##3	a_1191_368##2	2.54741e-18
C208	a_1191_368##3	VPWR#8	8.88952e-17
C209	a_339_368##3	A3#8	1.86808e-18
C210	A1#4	VGND#13	1.95275e-18
C211	a_339_368#	A3#10	7.63331e-19
C212	a_339_368##7	VPWR#4	5.81466e-17
C213	A1#8	VGND#12	2.09216e-17
C214	Y#3	A4#7	1.70363e-17
C215	a_339_368##5	VPWR#4	6.68158e-17
C216	a_27_74##7	a_339_368##5	9.57019e-19
C217	a_788_368##6	A3#8	1.98864e-19
C218	a_27_74##8	A4#9	2.91046e-17
C219	VGND#13	A1#1	4.32047e-19
C220	a_788_368##3	A3#10	3.44273e-17
C221	a_27_74##3	A2#2	9.40743e-19
C222	A4#11	A4#9	3.26159e-17
C223	A4#8	a_27_74##9	3.16894e-18
C224	a_339_368##3	A3#10	6.66104e-17
C225	a_27_74##7	A4#3	4.8262e-19
C226	a_27_74##3	A1#3	1.47582e-17
C227	a_339_368##2	VPWR#4	5.05373e-17
C228	A1#8	a_27_74##13	1.4951e-17
C229	Y#3	A4#5	4.69142e-20
C230	Y#6	A4#8	2.85577e-18
C231	a_27_74##7	A4#9	1.51167e-18
C232	a_27_74##2	A1#3	9.22145e-17
C233	a_788_368##6	A3#10	4.62904e-19
C234	a_788_368##3	A3#12	8.45505e-19
C235	VGND#12	A1#10	1.37281e-18
C236	VGND#3	a_27_74#	1.59504e-17
C237	VGND#13	A1#8	7.6211e-19
C238	VGND#8	A3#5	2.6829e-20
C239	a_339_368##3	A3#12	6.11162e-17
C240	A4#14	A4#11	1.2072e-17
C241	VGND#3	VGND#12	1.62376e-17
C242	a_788_368#	a_1191_368##3	8.96539e-17
C243	a_27_74##8	A4#11	3.41487e-17
C244	a_27_74##4	A2#4	4.31549e-18
C245	A1#10	a_27_74##13	1.4951e-17
C246	VPWR#5	B1#4	1.39674e-19
C247	a_788_368##6	A3#12	6.0767e-17
C248	a_788_368##3	A3#6	1.86506e-19
C249	a_27_74##11	A4#14	2.01668e-19
C250	a_27_74##3	A2#4	3.48528e-19
C251	VGND#3	VGND#13	1.61339e-17
C252	a_339_368##3	A3#6	5.24626e-19
C253	VPWR#7	A1#2	5.29555e-19
C254	VGND#12	A1#12	2.89475e-19
C255	a_339_368##9	A4#7	1.91218e-19
C256	a_1191_368##5	a_1191_368##3	4.51729e-18
C257	A1#10	VGND#13	2.07187e-17
C258	B1#1	A4#14	2.7441e-17
C259	VGND#3	VGND#14	1.61687e-17
C260	Y#1	A3#12	4.50862e-20
C261	a_788_368##6	A3#6	2.59864e-17
C262	VGND#3	a_27_74##15	1.15458e-17
C263	VGND#14	VGND#13	1.69529e-18
C264	a_339_368##6	A3#6	5.23843e-17
C265	a_27_74##8	A4#14	1.1499e-18
C266	a_788_368##2	A2#4	2.13822e-18
C267	VGND#3	VGND#15	2.28189e-18
C268	a_788_368#	a_1191_368##5	9.64191e-17
C269	Y#1	A3#6	3.87424e-18
C270	a_27_74##11	B1#1	8.88198e-19
C271	a_788_368##6	A4#10	7.5774e-20
C272	B1#6	B1#1	2.46344e-17
C273	VGND#13	A1#12	3.28466e-17
C274	a_339_368##8	A3#6	2.29233e-19
C275	VGND#7	A3#5	1.17131e-19
C276	A4#10	a_339_368##6	3.96264e-17
C277	Y#6	B1#2	1.27132e-17
C278	VGND#8	a_27_74##8	1.87304e-19
C279	A4#10	Y#1	2.37811e-17
C280	a_788_368##5	a_788_368#	9.8793e-19
C281	A4#13	A4#5	7.64197e-19
C282	A1#12	a_27_74##14	8.85644e-18
C283	a_339_368##8	A4#10	1.22447e-18
C284	a_27_74##8	B1#1	8.24051e-20
C285	a_27_74##9	Y#3	1.75519e-18
C286	a_339_368##6	A4#12	1.20605e-18
C287	B1#7	B1#6	3.6611e-17
C288	a_27_74#	A1#3	4.80169e-17
C289	VGND#13	A2#8	1.37449e-18
C290	a_27_74##11	B1#4	6.62314e-19
C291	A2	A1#5	8.06657e-18
C292	Y#3	A4#10	1.95092e-19
C293	a_27_74##11	B1#6	2.29242e-17
C294	Y#1	A4#12	4.4701e-17
C295	A1#3	VGND#12	1.86586e-18
C296	VGND#14	A1#12	1.35416e-18
C297	a_1191_368##5	a_788_368##5	7.16132e-17
C298	A2	A2#6	1.22093e-17
C299	A1#3	a_27_74##13	1.2791e-18
C300	A4#12	a_339_368##8	2.49647e-17
C301	A2	A2#5	1.44214e-17
C302	VPWR#8	A1#5	5.34904e-19
C303	A2#8	a_27_74##14	1.16707e-17
C304	VGND#8	a_27_74##7	8.43676e-18
C305	A2	A2#2	1.93669e-17
C306	VPWR#9	A4#10	3.81831e-20
C307	Y#3	A4#12	1.14082e-18
C308	a_27_74##15	A1#12	2.42419e-19
C309	B1#5	B1#7	3.7764e-17
C310	Y#1	A4#13	1.14082e-18
C311	VPWR#3	a_1191_368#	1.77335e-17
C312	VGND#13	A2#9	2.84093e-19
C313	a_1191_368##8	a_1191_368##5	3.01982e-18
C314	a_339_368##9	A4#12	2.27448e-19
C315	A4#13	a_339_368##8	2.8123e-17
C316	VPWR#3	VPWR#7	2.13676e-17
C317	A2#8	VGND#14	2.055e-17
C318	VGND#6	A3#5	6.03435e-20
C319	VPWR#8	A1#4	5.29555e-19
C320	VPWR#9	A4#12	6.80595e-20
C321	a_27_74##11	B1#7	2.10037e-17
C322	a_27_74##15	VGND#14	2.83262e-17
C323	a_1191_368##7	VPWR#3	2.75036e-17
C324	Y#3	A4#13	4.61791e-17
C325	VPWR#5	B1#2	3.47409e-19
C326	Y#1	A4#8	1.95092e-19
C327	VPWR#3	VPWR#8	2.12095e-17
C328	a_339_368##9	A4#13	1.55414e-18
C329	VGND#3	a_1191_368#	3.71508e-18
C330	a_1191_368##8	a_788_368##5	7.07473e-17
C331	a_27_74##15	A2#8	5.73187e-19
C332	a_339_368##8	A4#8	1.54626e-18
C333	a_27_74##3	a_1191_368##3	2.46169e-18
C334	VGND#7	a_27_74##7	8.96084e-18
C335	a_1191_368##3	VPWR#3	4.69709e-17
C336	a_339_368##5	A4#1	1.67696e-19
C337	A2#4	VGND#14	1.25013e-18
C338	VPWR#9	A4#13	1.87397e-19
C339	Y#3	A4#8	4.83301e-17
C340	VPWR#3	a_788_368#	8.34396e-18
C341	VGND#14	A2#9	3.1372e-17
C342	A2#4	a_27_74##15	1.02775e-18
C343	a_339_368##9	VPWR#5	4.59228e-17
C344	Y#9	A4#13	1.14528e-19
C345	VGND#15	VGND#14	2.30962e-18
C346	a_339_368##9	A4#8	3.92075e-17
C347	a_1191_368##5	VPWR#3	1.07846e-16
C348	a_27_74##9	Y#5	9.54448e-19
C349	A3	A2#6	9.47182e-18
C350	a_339_368##8	B1#8	7.55922e-20
C351	a_27_74##11	B1#5	1.21193e-18
C352	VPWR#9	A4#8	2.61045e-18
C353	VGND#3	a_1191_368##3	3.5493e-18
C354	A2#9	a_27_74##15	1.57038e-17
C355	Y#3	B1#8	3.86081e-19
C356	A3	A3#5	6.22309e-17
C357	a_1191_368##8	VPWR#3	5.06622e-17
C358	VGND#5	a_27_74##15	5.23612e-18
C359	VGND#3	a_788_368#	3.1998e-18
C360	Y#9	A4#8	3.71688e-19
C361	a_339_368##9	B1#8	1.73027e-18
C362	Y#6	Y#9	1.46519e-18
C363	a_788_368##2	A2#6	1.4689e-18
C364	VGND#14	A2#11	1.58203e-18
C365	VGND#7	a_27_74##6	7.34874e-18
C366	a_339_368#	a_1191_368##8	3.17779e-17
C367	a_788_368##3	a_788_368##5	4.93127e-19
C368	Y#5	B1#4	4.62276e-18
C369	VPWR#9	B1#8	6.79621e-17
C370	VGND#15	a_27_74##15	2.83076e-17
C371	VGND#15	A2#9	1.58203e-18
C372	a_788_368##3	VPWR#3	2.30785e-20
C373	A3	A4#3	2.08114e-18
C374	A1#9	A1#7	3.8557e-17
C375	Y#3	B1#9	2.10319e-19
C376	Y#6	Y#5	4.28463e-18
C377	Y#9	B1#8	7.79743e-17
C378	A2#11	a_27_74##15	1.81947e-17
C379	VPWR#6	B1#8	1.34415e-18
C380	VPWR#9	B1#2	1.71372e-18
C381	VGND#4	a_27_74##15	5.18684e-18
C382	VPWR#9	B1#9	1.33219e-18
C383	Y#9	B1#9	3.03558e-17
C384	a_788_368##2	A2#5	1.44932e-18
C385	A1#3	a_1191_368#	3.57991e-17
C386	A1#11	A1#9	4.76598e-17
C387	VGND#15	A2#11	3.56549e-17
C388	VPWR#7	A1#3	5.34904e-19
C389	VPWR#6	B1#9	5.62999e-17
C390	VGND#6	a_27_74##6	6.9896e-18
C391	a_27_74##15	A2#7	5.62851e-19
C392	a_1191_368##2	A1#7	7.95345e-18
C393	a_788_368##3	a_339_368#	7.11751e-17
C394	A4#1	A3#6	1.45134e-17
C395	a_788_368##3	VPWR#4	6.34659e-19
C396	A2#2	VGND#14	6.86471e-19
C397	A4	A3#5	1.21061e-18
C398	a_339_368##3	VPWR#4	6.6597e-17
C399	A1#6	A1#11	3.8674e-17
C400	Y#9	VPWR#5	1.58548e-17
C401	A4	A4#7	3.33828e-17
C402	A4	A4#5	2.22761e-17
C403	A2#7	VGND#15	2.02914e-17
C404	VGND#16	A2#11	3.18276e-19
C405	A2#7	a_27_74##16	1.49812e-17
C406	a_27_74##12	VPWR#6	3.13202e-19
C407	A2#1	A1#6	4.86408e-17
C408	VGND#6	a_27_74##5	7.34874e-18
C409	a_1191_368##2	A1#9	2.40511e-17
C410	a_788_368#	A2#4	2.78845e-18
C411	A2#6	VGND#15	1.56839e-18
C412	VGND#16	VGND#15	1.88328e-18
C413	VGND#15	A3#1	7.30871e-19
C414	a_788_368##3	a_339_368##3	8.61171e-17
C415	a_1191_368##5	A2#4	1.33356e-18
C416	VGND#16	A2#7	1.61711e-18
C417	VPWR#6	VPWR#5	9.53351e-19
C418	VGND#3	A1#1	1.38292e-18
C419	A2#10	A2#1	4.9179e-17
C420	A3#1	a_27_74##16	5.46871e-18
C421	VGND#3	A1#8	9.99101e-20
C422	Y#6	B1#4	1.58299e-18
C423	VGND#8	VGND#17	1.12981e-19
C424	a_788_368##6	a_788_368##3	2.46094e-18
C425	a_788_368##2	a_788_368#	1.35986e-18
C426	B1#4	a_27_74##20	5.88922e-19
C427	VGND#3	A1#10	2.73545e-18
C428	VGND#5	a_27_74##5	6.9896e-18
C429	A2#5	VGND#15	7.36215e-19
C430	B1#4	Y#8	6.3126e-18
C431	VGND#3	A1#12	1.41497e-18
C432	a_1191_368##2	A1#11	2.37819e-17
C433	VGND#16	A3#1	3.6225e-17
C434	A2#12	A2#10	4.8121e-17
C435	B1#4	a_27_74##12	9.34731e-18
C436	VGND#3	A2#8	9.4797e-19
C437	a_339_368##3	a_788_368##6	9.19995e-17
C438	VGND#3	A2#9	6.51938e-19
C439	VPWR#3	A2#6	2.63675e-20
C440	VPWR#3	A3#1	3.57526e-19
C441	B1#1	A4#8	1.84332e-17
C442	VGND#3	A2#11	6.51938e-19
C443	A2#13	A2#12	4.90875e-17
C444	a_788_368##2	a_1191_368##5	1.52121e-17
C445	VPWR#3	A2#5	2.60159e-20
C446	Y#5	B1#1	7.10587e-19
C447	A3#7	VGND#16	2.02914e-17
C448	VGND#17	A3#1	3.18276e-19
C449	VGND#5	a_27_74##4	3.87788e-19
C450	a_1191_368##2	A1#6	8.52115e-18
C451	VPWR#3	A2#2	2.60159e-20
C452	a_27_74##7	a_788_368##6	2.49924e-17
C453	A3#7	a_27_74##17	1.49812e-17
C454	A3#8	A2#13	4.74521e-18
C455	VPWR#4	A3#1	3.55832e-19
C456	a_339_368##6	a_788_368##6	8.10141e-17
C457	a_27_74##8	a_339_368##6	1.08248e-17
C458	VGND#16	A3#9	7.30871e-19
C459	a_788_368##2	a_788_368##5	2.45315e-18
C460	VGND#17	A3#7	1.61711e-18
C461	a_27_74##5	A2	2.34395e-17
C462	a_788_368#	A2#2	1.42031e-18
C463	a_27_74##4	A2	7.11787e-17
C464	A3#10	A3#8	4.82056e-17
C465	VGND#3	A1#4	8.85545e-20
C466	a_27_74##3	A2	5.24587e-17
C467	VGND#4	a_27_74##4	3.87788e-19
C468	A3#9	a_27_74##17	5.46871e-18
C469	Y#1	a_788_368##6	3.61533e-18
C470	a_1191_368##2	A2#1	1.98864e-19
C471	a_27_74##7	a_339_368##6	3.20587e-18
C472	VGND#17	VGND#16	1.88328e-18
C473	a_1191_368##5	A2#5	7.96343e-20
C474	A2	a_788_368##2	6.29555e-17
C475	A3#12	A3#10	4.72397e-17
C476	VGND#3	A2#5	1.10693e-20
C477	VGND#17	A3#9	3.56687e-17
C478	a_27_74##8	Y#1	2.88362e-18
C479	a_788_368##2	a_1191_368##8	3.69067e-17
C480	a_27_74##7	A3	5.2795e-17
C481	Y#1	a_339_368##6	8.1955e-17
C482	VPWR#9	B1#4	3.07051e-20
C483	a_27_74##6	A3	7.65871e-17
C484	VGND#9	A4#9	1.94359e-18
C485	a_27_74##5	A3	4.95361e-17
C486	Y#9	B1#4	5.02763e-18
C487	VGND#3	A2#2	3.32079e-20
C488	VPWR#6	B1#4	7.31411e-18
C489	A3#6	A3#12	3.04529e-17
C490	VGND#4	a_27_74##3	6.79479e-18
C491	VPWR#3	A1#7	2.26653e-18
C492	a_1191_368##2	A1#5	1.59846e-18
C493	A3#11	VGND#17	2.04206e-17
C494	A3	a_788_368##2	3.26736e-17
C495	VPWR#3	A1#9	2.91721e-19
C496	VGND#18	A3#9	1.59372e-19
C497	A4#10	A3#6	4.69428e-17
C498	VPWR#3	A1#11	2.75073e-18
C499	a_1191_368##5	A2#2	7.78339e-20
C500	a_27_74##8	A4	7.04779e-17
C501	A3#11	a_27_74##18	1.2912e-17
C502	VPWR#3	A1#6	3.69379e-18
C503	Y#1	a_339_368##8	4.04457e-17
C504	a_27_74#	a_1191_368#	3.48608e-19
C505	VPWR#3	A2#1	5.85379e-18
C506	A4#12	A4#10	4.73067e-17
C507	VGND#17	A4#1	7.62034e-19
C508	VGND#18	A3#11	3.6369e-19
C509	VPWR#3	A2#10	5.93268e-18
C510	a_27_74##2	a_27_74#	2.49329e-18
C511	a_1191_368##2	A1#4	1.4207e-18
C512	VPWR#3	A2#12	6.01414e-18
C513	Y#3	Y#1	2.58456e-18
C514	A4#1	a_27_74##18	1.49453e-17
C515	A4#13	A4#12	4.73644e-17
C516	VPWR#3	A2#13	4.48052e-18
C517	a_788_368##3	a_788_368##2	6.78775e-19
C518	a_339_368##7	VPWR#5	5.02918e-18
C519	Y#5	A4	1.48915e-17
C520	VGND#17	A4#9	2.90636e-19
C521	VPWR#4	A3#5	1.40118e-19
C522	A4#1	VGND#18	1.69492e-17
C523	Y#3	a_339_368##8	6.26184e-17
C524	A4#8	A4#13	4.81451e-17
C525	VGND	A3#5	9.96238e-20
C526	a_27_74##2	VGND#12	4.85086e-17
C527	VGND	A4#3	1.0282e-20
C528	a_1191_368##8	A2#6	8.07105e-20
C529	a_1191_368##2	A1#2	1.4207e-18
C530	VGND	B1#2	1.41358e-18
C531	VPWR#4	A3#8	4.43427e-18
C532	VGND#18	VGND#17	2.15693e-18
C533	VPWR#4	A4#7	2.84787e-20
C534	A2	a_1191_368##3	4.1909e-17
C535	B1#8	A4#8	6.22293e-18
C536	A2	a_788_368#	5.42359e-17
C537	VPWR#4	A3#10	4.43427e-18
C538	A2	a_1191_368##5	9.52825e-19
C539	VPWR#4	A4#5	1.89252e-20
C540	a_339_368##9	a_339_368##8	3.06366e-18
C541	A4#9	VGND#18	1.99112e-17
C542	B1	Y#5	1.07406e-17
C543	VPWR#4	A3#12	4.42933e-18
C544	VGND#19	A4#1	2.22908e-19
C545	A3#5	VGND#16	1.74557e-18
C546	A1#5	A1#4	4.07881e-18
C547	VPWR#4	A3#6	4.48955e-18
C548	B1#9	B1#8	3.20691e-17
C549	VPWR#4	A4#3	7.82133e-20
C550	VPWR	VPWR#5	9.9209e-17
C551	A4#9	a_27_74##19	1.58688e-17
C552	VPWR#4	A4#10	4.43427e-18
C553	Y#3	a_339_368##9	7.69298e-17
C554	a_27_74##9	A4	5.99063e-17
C555	a_27_74##2	a_27_74##13	1.14742e-18
C556	Y#6	A4	1.35798e-17
C557	VPWR#4	A4#12	4.43427e-18
C558	a_27_74##3	VGND#13	4.50882e-17
C559	a_788_368##2	A2#1	1.05171e-19
C560	VGND#18	A4#11	6.13383e-19
C561	a_339_368##2	a_1191_368##8	4.50261e-17
C562	VPWR#4	A4#13	4.42515e-18
C563	VGND#19	A4#9	9.88691e-19
C564	A3	a_788_368##3	9.75549e-17
C565	A3	a_788_368##6	2.64474e-17
C566	VGND#8	A3#6	1.04258e-20
C567	VPWR	a_27_74##8	3.76686e-18
C568	VPWR	a_27_74##7	3.19354e-18
C569	A4#11	a_27_74##19	1.38522e-17
C570	a_27_74##9	A4#9	2.67945e-19
C571	Y#6	B1	1.33221e-17
C572	Y#8	B1	5.04968e-17
C573	a_27_74##12	B1	3.70125e-17
C574	A1#3	A1#5	7.97964e-18
C575	VGND#18	A4#14	1.23741e-19
C576	VPWR	a_788_368##2	3.45039e-18
C577	a_27_74##2	VGND#13	4.61447e-17
C578	A4#11	VGND#19	2.58189e-17
C579	VPWR#9	a_339_368##9	7.54155e-17
C580	Y#9	Y#3	1.58888e-18
C581	VGND#9	A4#5	2.04803e-20
C582	VPWR	a_339_368##7	2.6743e-17
C583	A1#3	A1#4	2.14157e-17
C584	a_788_368##2	A2#10	4.84922e-19
C585	Y#6	A4#9	1.31168e-19
C586	VPWR	a_339_368##5	3.11658e-17
C587	a_339_368##2	a_339_368#	1.93994e-18
C588	a_27_74##3	a_27_74##14	1.54732e-17
C589	a_339_368##5	A3#5	7.38973e-20
C590	VGND	VGND#8	5.06237e-17
C591	A4	Y#1	3.4478e-17
C592	VGND	VGND#7	5.8769e-17
C593	VPWR	a_339_368##2	2.4736e-17
C594	A2	A3#1	3.60484e-18
C595	VGND	VGND#6	5.65415e-17
C596	VGND	VGND#5	3.60156e-17
C597	A1#3	A1#2	2.82412e-17
C598	VPWR	Y#5	7.80107e-18
C599	A4	Y#3	7.12323e-17
C600	a_27_74##4	VGND#14	1.53493e-17
C601	A3#5	a_27_74##17	7.3193e-19
C602	VGND#9	A4#3	1.72026e-19
C603	a_27_74##9	A4#11	1.31725e-18
C604	a_27_74##5	a_27_74##15	3.50911e-18
C605	VGND	a_27_74##11	2.68652e-17
C606	VPWR#3	A1#3	9.21907e-18
C607	VGND	a_27_74##8	2.19612e-17
C608	VGND	a_27_74##7	1.97609e-17
C609	A3	A3#1	1.33895e-17
C610	VGND	a_27_74##6	1.75425e-17
C611	VGND	a_27_74##5	1.77336e-17
C612	VGND	a_27_74##4	8.7036e-19
C613	VGND#3	A1#3	1.16201e-17
C614	a_339_368##5	a_339_368##3	2.61957e-18
C615	A4#14	VGND#19	2.64578e-17
C616	VPWR#3	A2#4	1.1215e-19
C617	B1#4	A4#8	2.26244e-18
C618	Y#6	A4#11	1.45959e-19
C619	VGND	a_788_368##2	4.57275e-18
C620	VGND#3	A2#4	5.8446e-19
C621	A1#3	A2#2	1.77954e-18
C622	A3	A4#1	3.39248e-18
C623	B1	Y#9	5.62062e-17
C624	a_339_368##2	a_788_368##3	3.43883e-17
C625	B1	VPWR#6	2.42918e-17
C626	a_788_368##2	A2#12	1.68714e-17
C627	Y#9	VPWR#9	9.11499e-17
C628	a_27_74##3	VGND#14	3.96712e-17
C629	a_27_74##9	A4#14	5.66435e-17
C630	VGND#19	VGND#18	2.26031e-18
C631	A1#5	VNB	2.62815e-17
C632	VGND	Y#5	1.2432e-18
C633	A1#4	VNB	2.33237e-17
C634	A1#2	VNB	4.08723e-17
C635	a_339_368##7	A4#7	1.09691e-19
C636	A2#6	VNB	2.66926e-17
C637	A2#5	VNB	2.02023e-17
C638	A2#2	VNB	2.61808e-17
C639	A3#5	VNB	9.54323e-17
C640	a_27_74##4	a_27_74##15	1.64624e-18
C641	A4#7	VNB	4.04623e-17
C642	A4#5	VNB	2.54121e-17
C643	A4#3	VNB	3.32649e-17
C644	B1#2	VNB	1.86532e-17
C645	a_27_74##5	VGND#15	4.77839e-17
C646	Y#6	A4#14	1.5846e-18
C647	VGND	VGND#15	1.38368e-17
C648	VPWR	a_1191_368##5	3.65389e-18
C649	VPWR	a_788_368##5	7.53739e-18
C650	VGND	VGND#16	1.61196e-17
C651	A4	B1#1	5.00505e-18
C652	VPWR	a_1191_368##8	2.44138e-17
C653	VPWR#6	VPWR#9	1.59316e-18
C654	a_339_368##5	a_788_368##6	1.97253e-17
C655	VGND	VGND#17	1.61306e-17
C656	VPWR	a_788_368##3	1.14354e-17
C657	VPWR	a_339_368##3	3.04879e-17
C658	a_27_74##8	a_27_74##7	2.91608e-18
C659	VPWR	a_788_368##6	1.04399e-17
C660	VGND	a_27_74##9	2.62403e-17
C661	VGND	Y#6	1.19718e-17
C662	VPWR	Y#1	9.34115e-18
C663	a_27_74##9	B1#1	2.87514e-17
C664	VGND	Y#8	6.44293e-18
C665	a_339_368##3	a_339_368##2	3.01982e-18
C666	VPWR	Y#3	1.08708e-17
C667	VGND	a_27_74##12	2.31467e-17
C668	VPWR	a_339_368##9	2.40634e-17
C669	VGND#4	A2#8	2.19588e-18
C670	a_788_368##2	A2#13	2.19503e-17
C671	VPWR	VPWR#9	2.21978e-17
C672	A3#5	VGND#17	2.78421e-18
C673	VPWR	Y#9	1.91715e-17
C674	VPWR	VPWR#6	6.77651e-17
C675	a_27_74##15	a_27_74##3	3.21832e-18
C676	a_339_368##7	A4#5	1.11173e-19
C677	VPWR#6	Y#9	1.05969e-16
C678	a_339_368#	A3#5	8.77755e-19
C679	Y#6	B1#1	4.77437e-17
C680	VGND	a_788_368##3	4.43109e-18
C681	a_27_74##4	VGND#15	1.43577e-17
C682	A2#5	A2#4	4.80129e-18
C683	A3#1	A2#6	1.54896e-17
C684	VPWR#5	VNB	5.52362e-17
C685	VGND	a_788_368##6	4.12371e-18
C686	VGND	a_339_368##6	4.00559e-18
C687	a_339_368#	A3#1	8.3299e-19
C688	VGND#8	VNB	2.00304e-17
C689	VGND	Y#1	3.05939e-18
C690	VGND#7	VNB	3.09106e-17
C691	VGND#6	VNB	2.93408e-17
C692	VGND#5	VNB	2.83243e-17
C693	VGND#4	VNB	2.88043e-17
C694	VGND	Y#3	4.23642e-18
C695	a_27_74##5	a_27_74##16	3.82815e-18
C696	a_339_368##5	a_339_368##6	1.21624e-18
C697	a_27_74##9	B1#6	4.24687e-19
C698	VGND	Y#9	3.96502e-18
C699	a_1191_368##2	VNB	3.63303e-18
C700	a_27_74##11	VNB	5.41117e-18
C701	VGND	VPWR#6	4.27894e-18
C702	A2#4	A2#2	4.80129e-18
C703	a_27_74##8	VNB	4.08956e-18
C704	a_27_74##7	VNB	1.19379e-18
C705	a_27_74##6	VNB	2.0942e-18
C706	a_27_74##5	VNB	2.0942e-18
C707	a_27_74##3	VNB	4.9095e-18
C708	VPWR#3	A2	7.40791e-18
C709	a_27_74##2	VNB	1.94134e-18
C710	a_27_74##6	VGND#16	4.74323e-17
C711	a_788_368##2	VNB	6.02297e-18
C712	VGND#3	A2	8.4862e-18
C713	a_339_368##7	VNB	4.45723e-18
C714	a_788_368##3	A3#1	2.78771e-18
C715	a_339_368##5	VNB	4.8619e-18
C716	VGND	A2#7	8.67282e-19
C717	A4	A4#8	6.50427e-18
C718	a_27_74##3	a_1191_368##2	2.76252e-18
C719	a_339_368##2	VNB	9.50574e-18
C720	VGND	A3#1	6.44735e-19
C721	a_339_368##7	Y#1	1.62075e-17
C722	Y#5	VNB	1.24557e-17
C723	VGND	A3#7	6.63371e-20
C724	a_788_368##2	A3#8	2.02176e-19
C725	Y#6	B1#6	3.14079e-17
C726	VGND	A3#9	6.39709e-19
C727	VGND	A3#11	1.7225e-19
C728	a_27_74#	VNB	3.59485e-17
C729	Y#8	B1#1	1.7013e-19
C730	VGND#12	VNB	2.72732e-18
C731	VGND	A4#1	5.54772e-19
C732	A2	A1#3	2.78995e-17
C733	VGND#13	VNB	9.83225e-19
C734	VGND	A4#9	3.79673e-19
C735	VGND#14	VNB	4.87509e-19
C736	VGND	A4#11	7.07273e-19
C737	B1	A4#8	7.39153e-19
C738	a_27_74##15	VNB	4.52177e-18
C739	VGND#4	A2#9	1.22302e-18
C740	VGND#15	VNB	4.39767e-19
C741	VGND	A4#14	3.89792e-19
C742	A2	A2#4	2.38223e-17
C743	VGND#16	VNB	4.46333e-19
C744	VGND	B1#1	4.52932e-18
C745	VPWR#5	A4#8	4.49547e-18
C746	VGND#17	VNB	4.53626e-19
C747	VGND	B1#6	3.40034e-18
C748	VGND#18	VNB	5.43425e-18
C749	VGND	B1#7	1.59449e-18
C750	VPWR	A2#13	1.57259e-18
C751	VGND#19	VNB	3.6924e-18
C752	VGND	B1#5	2.33633e-18
C753	a_27_74##9	VNB	2.68062e-18
C754	Y#6	VNB	1.77516e-18
C755	VPWR	A3#8	1.6127e-18
C756	Y#5	VPWR#5	1.21512e-18
C757	VPWR	A3#10	1.5816e-18
C758	a_27_74##12	VNB	4.00687e-17
C759	a_27_74##9	VGND#19	5.42656e-17
C760	B1#6	a_27_74##20	1.44923e-17
C761	a_1191_368#	VNB	6.08473e-17
C762	VPWR#7	VNB	2.76253e-18
C763	VPWR	A3#12	1.58226e-18
C764	a_1191_368##7	VNB	2.139e-18
C765	VPWR#8	VNB	8.43899e-19
C766	VPWR	A3#6	1.5607e-18
C767	a_1191_368##3	VNB	3.25717e-18
C768	a_788_368#	VNB	1.27712e-18
C769	a_1191_368##5	VNB	5.53775e-18
C770	VPWR	A4#10	1.65796e-18
C771	a_27_74##7	A3#6	5.9753e-18
C772	a_1191_368##8	VNB	1.46892e-17
C773	VPWR	A4#12	1.65796e-18
C774	a_339_368#	VNB	5.01255e-18
C775	a_339_368##5	Y#1	1.84886e-17
C776	a_788_368##3	VNB	4.65716e-18
C777	a_339_368##3	VNB	4.82352e-18
C778	VPWR	A4#13	1.58019e-18
C779	a_27_74##5	VGND#16	4.30712e-17
C780	a_788_368##6	VNB	1.56103e-18
C781	a_339_368##6	VNB	2.26675e-19
C782	VPWR	A4#8	2.07611e-18
C783	Y#1	VNB	7.38421e-19
C784	a_339_368##2	A3#5	1.24774e-19
C785	Y#3	VNB	1.39864e-18
C786	VPWR	B1#8	6.19712e-19
C787	a_339_368##9	VNB	1.469e-17
C788	VPWR#9	VNB	9.58005e-18
C789	A4	B1#4	9.2817e-19
C790	VPWR	B1#9	2.88881e-18
C791	Y#9	VNB	8.176e-18
C792	VPWR#6	VNB	8.05056e-17
C793	Y#6	B1#7	1.01981e-18
C794	A1#1	VNB	3.04691e-17
C795	A1#8	VNB	2.47219e-17
C796	A1#10	VNB	2.45691e-17
C797	VPWR	VPWR#3	4.54822e-17
C798	Y#8	B1#6	4.01042e-19
C799	A1#12	VNB	2.26655e-17
C800	A2#8	VNB	2.3858e-17
C801	VGND#5	A2#11	1.22302e-18
C802	A2#9	VNB	2.28629e-17
C803	B1	B1#4	5.59467e-17
C804	a_339_368##2	A2#13	9.4762e-19
C805	a_27_74##6	a_27_74##17	2.96381e-18
C806	A2#11	VNB	2.29898e-17
C807	A2#7	VNB	2.45349e-17
C808	a_27_74##7	a_27_74##6	2.49329e-18
C809	VPWR	VPWR#4	1.83171e-16
C810	A3#1	VNB	4.79914e-17
C811	a_339_368##5	A4#5	7.6339e-20
C812	A3#7	VNB	2.44684e-17
C813	A3#9	VNB	2.26711e-17
C814	a_339_368##7	a_339_368##8	6.54033e-19
C815	A3#11	VNB	2.53236e-17
C816	A4#1	VNB	3.76887e-17
C817	A4#9	VNB	2.66282e-17
C818	A4#11	VNB	2.47027e-17
C819	a_788_368##2	A3#10	5.88996e-20
C820	A4#14	VNB	2.52536e-17
C821	B1#1	VNB	3.87474e-17
C822	VGND#8	VGND#7	1.14931e-18
C823	B1#6	VNB	2.6515e-17
C824	a_788_368##3	A3#5	2.20528e-17
C825	B1#7	VNB	2.55849e-17
C826	B1#5	VNB	3.3319e-17
C827	A3	A2	2.79957e-17
C828	A1#7	VNB	3.85641e-17
C829	VGND	VGND#9	2.28574e-17
C830	a_27_74##7	VGND#17	4.70871e-17
C831	A1#9	VNB	3.29162e-17
C832	A1#11	VNB	3.27974e-17
C833	B1#7	a_27_74##20	1.44923e-17
C834	A1#6	VNB	3.18584e-17
C835	A2#1	VNB	3.63804e-17
C836	A2#10	VNB	3.49987e-17
C837	A2#12	VNB	3.5442e-17
C838	A2#13	VNB	3.8115e-17
C839	A3#8	VNB	3.41346e-17
C840	A4	A3	1.5007e-18
C841	A3#10	VNB	3.27473e-17
C842	A3#12	VNB	3.28957e-17
C843	VGND	B1#4	2.29477e-18
C844	A3#6	VNB	4.68834e-17
C845	A4#10	VNB	3.38312e-17
C846	A4#12	VNB	3.19783e-17
C847	A1#8	A1#1	2.76313e-17
C848	A4#13	VNB	3.27044e-17
C849	A4#8	VNB	5.14968e-17
C850	B1#8	VNB	3.32715e-17
C851	B1#9	VNB	4.81913e-17
C852	VPWR#3	VNB	2.6481e-16
C853	VPWR	A2	1.90914e-18
C854	VGND#3	VNB	2.00441e-16
C855	VPWR#4	VNB	1.05263e-16
C856	VPWR	A3	9.07929e-18
C857	VPWR#5	B1#8	9.94764e-19
C858	VGND#9	VNB	1.34319e-17
C859	A1#3	VNB	7.2156e-17
C860	Y#6	B1#5	6.53843e-19
C861	A2#4	VNB	3.7571e-17
C862	VGND	A2	2.23748e-18
C863	VPWR	A4	5.86259e-18
C864	a_339_368##8	a_339_368##5	3.06366e-18
C865	Y#8	B1#7	2.4289e-17
C866	VGND	A3	1.02647e-17
C867	VPWR	B1	6.89202e-18
C868	B1#4	VNB	9.32149e-17
C869	VGND	A4	7.81703e-18
C870	VGND	B1	7.1961e-18
C871	A2	VNB	1.5056e-17
C872	A3	VNB	1.19326e-17
C873	A4	VNB	4.97664e-18
C874	B1	VNB	2.82951e-17
C875	VPWR	VNB	3.1388e-16
C876	VGND	VNB	2.97671e-16
C877	a_339_368##2	A3#8	2.57983e-17
C878	VGND#10	B1#1	4.98099e-18
C879	VGND#10	B1#6	4.6291e-18
C880	VGND#10	B1#2	1.02849e-19
C881	VGND#3	VGND#2	8.12731e-17
C882	VGND#2	A1#1	1.23778e-18
C883	VGND#10	B1#7	4.49279e-18
C884	VGND#10	B1#5	4.48766e-18
C885	VGND#10	a_27_74##11	6.98265e-17
C886	VGND#10	VGND#8	1.30554e-18
C887	VPWR#3	VPWR#2	8.14203e-17
C888	a_1191_368##2	VPWR#2	1.20253e-19
C889	VGND#2	A1#8	2.74533e-18
C890	VPWR#2	A1#3	4.24017e-20
C891	VGND#10	a_27_74##8	6.56595e-19
C892	VGND#2	VNB	4.86804e-17
C893	VGND#10	a_27_74##9	4.64246e-17
C894	VGND#10	B1#4	4.67104e-19
C895	VGND#10	A4#8	8.79847e-20
C896	VGND#10	A4#7	4.09164e-20
C897	a_1191_368#	VPWR#2	2.08429e-17
C898	VGND	VGND#10	2.03016e-16
C899	VGND#10	A4#1	1.06011e-19
C900	a_1191_368##7	VPWR#2	9.18163e-18
C901	VGND#10	A4#9	6.49403e-19
C902	VPWR#2	A1#7	2.00416e-18
C903	VGND#10	VNB	1.07397e-16
C904	VGND#2	a_27_74##2	8.71444e-18
C905	VPWR#2	A1#9	2.54361e-18
C906	VGND#10	A4#11	4.56217e-18
C907	VGND#2	A1#3	9.20266e-20
C908	VPWR#2	VNB	4.75953e-17
C909	VGND#10	A4#14	4.86279e-18
C910	VGND#10	a_27_74##12	4.92041e-17
C911	VGND#2	a_27_74#	1.78949e-17
*
*
.ENDS sky130_fd_sc_hs__o41ai_4
*
