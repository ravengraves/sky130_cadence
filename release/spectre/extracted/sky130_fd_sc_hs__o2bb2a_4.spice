* Extracted by Quantus, converted by sky130cad/quantus.py
*
*
*
*                       LINUX           Wed Nov 18 08:59:45 2026
*
*
*
*  PROGRAM  advgen
*
*  Name           : advgen - Quantus - (64-bit)
*  Version        : 25.1.0-p047
*  Build Date     : Thu Dec 11 23:20:30 PST 2025
*
*  HSPICE LIBRARY
*
*  OPERATING_TEMPERATURE 150
*  QRC_TECH_DIR <path>/tech
*
*
*

*
.SUBCKT sky130_fd_sc_hs__o2bb2a_4 VNB VPB VGND VPWR X B1 A2_N A1_N B2
*
*
*  caps2d version: 10
*
*
*       TRANSISTOR CARDS
*
*
XM6 VGND#12 B1#4 a_27_74##5 VNB sky130_fd_pr__nfet_01v8_lvt l=0.15 w=0.64 ad=0.2688 as=0.1824 pd=2.12 ps=1.85
XM22 a_27_74##6 B1#1 VGND#12 VNB sky130_fd_pr__nfet_01v8_lvt l=0.15 w=0.64 ad=0.1792 as=0.2688 pd=1.84 ps=2.12
XM7 VGND#11 B2#6 a_27_74##6 VNB sky130_fd_pr__nfet_01v8_lvt l=0.15 w=0.64 ad=0.224 as=0.1792 pd=1.98 ps=1.84
XM16 a_27_74##2 B2#1 VGND#11 VNB sky130_fd_pr__nfet_01v8_lvt l=0.15 w=0.64 ad=0.1984 as=0.224 pd=1.9 ps=1.98
XM2 a_310_392##18 a_476_48##4 a_27_74##2 VNB sky130_fd_pr__nfet_01v8_lvt l=0.15 w=0.64 ad=0.2016 as=0.1984 pd=1.91 ps=1.9
XM20 a_27_74# a_476_48##3 a_310_392##18 VNB sky130_fd_pr__nfet_01v8_lvt l=0.15 w=0.64 ad=0.2048 as=0.2016 pd=1.92 ps=1.91
XM0 a_476_48##9 A2_N#1 a_835_94# VNB sky130_fd_pr__nfet_01v8_lvt l=0.15 w=0.64 ad=0.1952 as=0.1536 pd=1.89 ps=1.76
XM18 a_835_94# A1_N#3 VGND#10 VNB sky130_fd_pr__nfet_01v8_lvt l=0.15 w=0.64 ad=0.1536 as=0.3386 pd=1.76 ps=2.46
XM9 X#5 a_310_392##10 VGND#10 VNB sky130_fd_pr__nfet_01v8_lvt l=0.15 w=0.74 ad=0.3145 as=0.3386 pd=2.33 ps=2.46
XM3 VGND#9 a_310_392##8 X#5 VNB sky130_fd_pr__nfet_01v8_lvt l=0.15 w=0.74 ad=0.259 as=0.3145 pd=2.18 ps=2.33
XM1 VGND#9 a_310_392##6 X#3 VNB sky130_fd_pr__nfet_01v8_lvt l=0.15 w=0.74 ad=0.259 as=0.2072 pd=2.18 ps=2.04
XM8 X#3 a_310_392##5 VGND#1 VNB sky130_fd_pr__nfet_01v8_lvt l=0.15 w=0.74 ad=0.2072 as=0.2627 pd=2.04 ps=2.19
XM10 a_41_392##4 B1#6 VPWR#14 VPB sky130_fd_pr__pfet_01v8 l=0.15 w=1 ad=0.295 as=0.3 pd=2.59 ps=2.6
XM12 VPWR#14 B1#5 a_41_392##2 VPB sky130_fd_pr__pfet_01v8 l=0.15 w=1 ad=0.3 as=0.3 pd=2.6 ps=2.6
XM23 a_41_392##2 B2#4 a_310_392##17 VPB sky130_fd_pr__pfet_01v8 l=0.15 w=1 ad=0.3 as=0.3 pd=2.6 ps=2.6
XM13 a_310_392##17 B2#5 a_41_392# VPB sky130_fd_pr__pfet_01v8 l=0.15 w=1 ad=0.3 as=0.295 pd=2.6 ps=2.59
XM4 VPWR#13 a_476_48##5 a_310_392##15 VPB sky130_fd_pr__pfet_01v8 l=0.15 w=0.84 ad=0.2478 as=0.3108 pd=2.27 ps=2.42
XM19 a_310_392##15 a_476_48# VPWR#12 VPB sky130_fd_pr__pfet_01v8 l=0.15 w=0.84 ad=0.3108 as=0.5166 pd=2.42 ps=3.46
XM15 VPWR#12 A2_N#3 a_476_48##6 VPB sky130_fd_pr__pfet_01v8 l=0.15 w=0.84 ad=0.5166 as=0.252 pd=3.46 ps=2.28
XM17 a_476_48##6 A1_N#1 VPWR#11 VPB sky130_fd_pr__pfet_01v8 l=0.15 w=0.84 ad=0.252 as=0.5418 pd=2.28 ps=3.46
XM21 X#6 a_310_392##12 VPWR#11 VPB sky130_fd_pr__pfet_01v8 l=0.15 w=1.12 ad=0.448 as=0.5418 pd=3.04 ps=3.46
XM14 VPWR#10 a_310_392##11 X#6 VPB sky130_fd_pr__pfet_01v8 l=0.15 w=1.12 ad=0.392 as=0.448 pd=2.94 ps=3.04
XM5 X#1 a_310_392##7 VPWR#10 VPB sky130_fd_pr__pfet_01v8 l=0.15 w=1.12 ad=0.3416 as=0.392 pd=2.85 ps=2.94
XM11 VPWR#1 a_310_392# X#1 VPB sky130_fd_pr__pfet_01v8 l=0.15 w=1.12 ad=0.3808 as=0.3416 pd=2.92 ps=2.85
*
*
*       RESISTOR AND CAP/DIODE CARDS
*
Rg1	B1#1	B1#2	373.503235
Rg2	B1#2	B1#3	74.307770
Rg3	B1#3	B1#4	340.385803
Rg4	B1#2	B1#5	506.833282
Rg5	B1#3	B1#6	473.230347
Rg6	B2#1	B2#2	453.936310
Rg7	B2#2	B2#3	41.835377
Rg8	B2#3	B2#4	424.664154
Rg9	B2#2	B2#5	394.407837
Rg10	B2#3	B2#6	484.403015
Rg11	a_476_48#	a_476_48##2	457.985657
Rg12	a_476_48##2	a_476_48##3	380.313354
Rg13	a_476_48##2	a_476_48##4	537.631042
Rg14	a_476_48##2	a_476_48##5	370.993774
Rg15	A2_N#1	A2_N#2	353.846649
Rg16	A2_N#2	A2_N#3	354.298584
Rg17	A1_N#1	A1_N#2	354.298584
Rg18	A1_N#2	A1_N#3	353.846649
Rg19	a_310_392#	a_310_392##2	559.956482
Rg20	a_310_392##2	a_310_392##3	176.750473
Rg21	a_310_392##3	a_310_392##4	109.493378
Rg22	a_310_392##2	a_310_392##5	297.530212
Rg23	a_310_392##3	a_310_392##6	363.728485
Rg24	a_310_392##3	a_310_392##7	452.677094
Rg25	a_310_392##4	a_310_392##8	304.068268
Rg26	a_310_392##4	a_310_392##9	64.081955
Rg27	a_310_392##9	a_310_392##10	322.953644
Rg28	a_310_392##4	a_310_392##11	486.547119
Rg29	a_310_392##9	a_310_392##12	507.075531
Rf1	B1#7	B1	1.596157
Rf2	B1#3	B1#9	55.007092
Rf3	B1#7	B1#9	9.590823
Rf4	B1#10	B1	1.596157
Rf5	B1#9	B1#10	2.851326
Rf6	B2	B2#7	13.975380
Rf7	B2#7	B2	4.920908
Rf8	a_41_392#	a_41_392##3	94.365250
Rf9	a_41_392##3	a_41_392##4	90.881065
Rf10	a_41_392##2	a_41_392##3	5.000000
Rf11	a_27_74#	a_27_74##3	51.986832
Rf12	a_27_74##3	a_27_74##4	40.439014
Rf13	a_27_74##4	a_27_74##5	84.693901
Rf14	a_27_74##4	a_27_74##6	11.128067
Rf15	a_27_74##2	a_27_74##3	15.000000
Rf16	A2_N#2	A2_N#5	161.302414
Rf17	A2_N#6	A2_N	1.069610
Rf18	A2_N#5	A2_N#6	5.583287
Rf19	a_476_48##6	a_476_48##7	83.427101
Rf20	a_476_48##7	a_476_48##2	73.213684
Rf21	a_476_48##7	a_476_48##9	64.085526
Rf22	A1_N	A1_N#2	166.137894
Rf23	a_310_392##4	a_310_392##14	72.130074
Rf24	a_310_392##14	a_310_392##16	237.263184
Rf25	a_310_392##16	a_310_392##17	127.540771
Rf26	a_310_392##14	a_310_392##18	247.774857
Rf27	a_310_392##15	a_310_392##16	15.000000
Rf28	X#1	X#2	28.407557
Rf29	X#2	X#4	42.538857
Rf30	X#4	X	16.774097
Rf31	X	X#5	16.590858
Rf32	X#2	X#6	86.951324
Rf33	X#3	X#4	7.500000
Rf34	VPWR#1	VPWR#2	41.751957
Rf35	VPWR#2	VPWR#3	77.445518
Rf36	VPWR#3	VPWR#4	79.210724
Rf37	VPWR#4	VPWR#5	78.114967
Rf38	VPWR#5	VPWR#6	29.560919
Rf39	VPWR#6	VPWR#7	47.458290
Rf40	VPWR#7	VPWR#8	139.599960
Rf42	VPWR#3	VPWR#10	34.939823
Rf43	VPWR#4	VPWR#11	26.437206
Rf44	VPWR#5	VPWR#12	26.437206
Rf45	VPWR#7	VPWR#13	43.955643
Rf46	VPWR#8	VPWR#14	53.143215
Rf47	VGND#1	VGND#2	36.772179
Rf48	VGND#2	VGND#3	77.445518
Rf49	VGND#3	VGND#4	81.008369
Rf50	VGND#4	VGND#5	105.870071
Rf51	VGND#5	VGND#6	115.395248
Rf52	VGND#6	VGND#7	73.001427
Rf54	VGND#3	VGND#9	32.735970
Rf55	VGND#4	VGND#10	28.624043
Rf56	VGND#6	VGND#11	32.145462
Rf57	VGND#7	VGND#12	33.326477
Rf59	B2#2	B2#7	80.116402
Re1	VPWR#2	VPWR	11.068454
Re2	VPWR	VPWR#6	0.790604
Re3	VGND#2	VGND	11.068454
Re4	VGND	VGND#5	0.790604
*
*       CAPACITOR CARDS
*
*
C1	B2#3	a_476_48##4	2.23741e-17
C2	a_476_48##7	A2_N#5	2.40238e-17
C3	VGND#1	a_310_392##6	1.37281e-18
C4	a_310_392##9	a_310_392##4	3.49927e-18
C5	VGND#9	a_310_392##5	1.465e-18
C6	a_310_392##4	a_310_392##3	4.03516e-18
C7	a_476_48##7	B2#1	8.07369e-20
C8	a_27_74##4	a_476_48##3	1.32151e-19
C9	X#6	VPWR#10	9.70509e-17
C10	X#3	a_310_392##6	5.1946e-17
C11	VGND#1	a_310_392##8	2.86953e-19
C12	a_310_392##6	VGND#9	2.06693e-17
C13	a_27_74##2	a_310_392##17	1.03819e-18
C14	VPWR#11	VPWR#10	1.41189e-18
C15	a_27_74##4	a_476_48##4	2.21179e-19
C16	a_476_48##7	B2#6	5.35836e-20
C17	X#3	a_310_392##8	1.3443e-18
C18	VPWR#11	X#6	1.40265e-17
C19	VGND#9	a_310_392##8	3.16337e-17
C20	A1_N#2	a_310_392##9	2.28521e-17
C21	a_27_74##4	B2#1	9.85909e-19
C22	X#3	a_310_392##10	3.24649e-19
C23	a_310_392##8	X#5	5.9552e-18
C24	VPWR#3	a_310_392##7	2.57891e-18
C25	X#2	a_310_392#	3.84547e-17
C26	VGND#9	a_310_392##10	1.25382e-18
C27	VGND#10	a_310_392##8	9.68224e-19
C28	a_27_74##4	B2#6	4.57816e-17
C29	a_310_392##10	X#5	1.07217e-17
C30	VGND#6	a_310_392##18	8.83178e-18
C31	VPWR#3	a_310_392##11	9.94764e-19
C32	X#2	a_310_392##7	3.87409e-17
C33	VGND#10	a_310_392##10	4.13433e-17
C34	VPWR#12	VPWR#11	6.94395e-18
C35	a_27_74##4	B2#3	2.32556e-18
C36	a_27_74##4	B1#1	3.79027e-17
C37	B1#2	B2#6	5.15323e-18
C38	VGND#4	a_310_392##18	7.94464e-18
C39	VPWR#4	a_310_392##12	6.6582e-18
C40	a_476_48##6	VPWR#12	2.75382e-18
C41	VGND#10	A1_N#3	3.52521e-17
C42	X#3	X#2	1.29503e-18
C43	VGND#6	a_27_74##2	5.28182e-18
C44	a_27_74##4	B1#2	1.18483e-18
C45	X#2	a_310_392##11	1.8151e-18
C46	a_27_74##4	B1#4	8.41001e-19
C47	a_310_392##15	a_476_48##6	5.87316e-17
C48	VGND#4	a_310_392##9	5.20677e-20
C49	VPWR#10	a_310_392##3	4.62692e-19
C50	VGND#10	A2_N#1	1.50752e-18
C51	VPWR#4	A1_N#1	4.19053e-18
C52	a_476_48##9	A1_N#3	9.64988e-19
C53	a_310_392##15	VPWR#12	4.23864e-17
C54	X#2	a_310_392##12	2.01349e-19
C55	a_27_74#	A1_N#3	2.8828e-19
C56	VPWR#5	A2_N#3	4.17863e-18
C57	VGND#10	a_476_48##3	2.82607e-19
C58	a_310_392##14	X#3	1.56375e-17
C59	VPWR#13	VPWR#12	4.26163e-18
C60	a_476_48##9	A2_N#1	4.10425e-17
C61	a_476_48##2	B2#3	3.89134e-18
C62	X#6	a_310_392##9	6.713e-19
C63	a_310_392##14	a_310_392##12	3.02091e-17
C64	a_310_392##18	A1_N#3	9.98813e-20
C65	VGND#6	B2#3	7.11959e-20
C66	a_476_48##2	B1#2	1.29779e-18
C67	a_27_74#	A2_N#1	2.79086e-18
C68	a_310_392##15	VPWR#13	4.69139e-17
C69	VGND#10	a_476_48##4	4.69352e-20
C70	a_476_48##9	a_476_48##3	2.60383e-18
C71	VPWR#5	a_476_48#	1.14497e-18
C72	a_310_392##14	VGND#9	4.61495e-18
C73	a_310_392##18	A2_N#1	8.93187e-18
C74	a_41_392#	a_310_392##15	2.36406e-18
C75	a_310_392##14	A1_N#1	3.01652e-17
C76	VGND#4	VGND#3	1.1207e-18
C77	a_27_74#	a_476_48##3	4.79165e-17
C78	a_476_48##9	a_476_48##4	8.97639e-19
C79	VPWR#7	a_476_48##5	1.43411e-18
C80	a_476_48##7	a_310_392##12	6.87613e-20
C81	a_310_392##18	a_476_48##3	3.30052e-17
C82	a_41_392#	VPWR#13	4.59455e-17
C83	a_310_392##17	a_310_392##15	6.96225e-19
C84	a_310_392##14	X#5	5.35874e-18
C85	VGND#3	a_310_392##3	5.74982e-20
C86	a_27_74#	a_476_48##4	8.98574e-18
C87	a_310_392##14	A2_N#3	3.56001e-19
C88	a_476_48##9	B2#1	2.47633e-19
C89	a_310_392##18	a_476_48##4	3.16092e-17
C90	VPWR#7	B2#5	5.95384e-18
C91	a_476_48##7	A1_N#1	1.23006e-19
C92	VGND#11	a_476_48##3	2.88293e-19
C93	a_27_74#	B2#1	2.21179e-19
C94	a_310_392##14	VGND#10	9.56909e-17
C95	a_27_74##2	a_476_48##4	4.64434e-17
C96	a_41_392#	a_310_392##17	8.28425e-17
C97	A2_N#6	A1_N#1	5.72344e-19
C98	VGND#3	a_310_392##2	3.06657e-21
C99	a_476_48##9	B2#6	1.66901e-19
C100	a_310_392##14	a_476_48#	1.96585e-19
C101	a_310_392##18	B2#1	3.50584e-18
C102	VGND#11	a_476_48##4	2.91096e-18
C103	a_27_74#	B2#6	1.32013e-19
C104	a_41_392##2	a_41_392#	3.01982e-18
C105	a_476_48##7	A2_N#3	1.4608e-18
C106	a_27_74##2	B2#1	4.47836e-17
C107	VPWR#7	B2#4	8.27164e-20
C108	A2_N#6	A2_N#3	2.77153e-18
C109	VGND#11	B2#1	3.17684e-17
C110	a_41_392##2	a_310_392##17	5.96148e-17
C111	a_310_392##3	a_310_392#	7.20051e-18
C112	B1#3	B1#2	7.86636e-18
C113	a_310_392##14	a_476_48##5	7.56635e-20
C114	a_476_48##7	a_476_48#	2.25128e-17
C115	VPWR#7	B1#5	2.49606e-20
C116	B2#6	VGND#11	1.86936e-17
C117	a_476_48##9	a_310_392##14	4.3134e-17
C118	A2_N#6	a_476_48#	6.77553e-19
C119	VGND#12	B2#1	2.86953e-19
C120	a_41_392##2	VPWR#14	6.79719e-17
C121	B2#6	a_27_74##6	1.2912e-17
C122	a_476_48##7	a_476_48##5	1.23761e-18
C123	VGND#11	B1#1	7.6211e-19
C124	A2_N#5	a_476_48#	2.12944e-18
C125	VGND#12	B2#6	1.37281e-18
C126	a_41_392##4	a_41_392##2	3.01982e-18
C127	VPWR#7	B1#6	2.46957e-20
C128	a_27_74#	a_310_392##14	2.52589e-18
C129	B1#1	a_27_74##6	1.2912e-17
C130	VGND#11	B1#4	3.96119e-19
C131	a_41_392##4	VPWR#14	6.24689e-17
C132	B1#1	VGND#12	2.13213e-17
C133	a_27_74##5	B1#1	8.45626e-19
C134	a_310_392##18	a_310_392##14	1.05532e-18
C135	B1#4	VGND#12	2.60057e-17
C136	a_27_74##5	B1#4	4.59179e-17
C137	a_310_392##11	a_310_392##3	1.93134e-18
C138	a_476_48##9	a_476_48##7	1.04658e-18
C139	VGND#3	VGND#2	9.71908e-19
C140	a_310_392##15	a_476_48##4	1.29778e-17
C141	a_310_392##6	a_310_392##5	3.66447e-17
C142	VPWR#3	VPWR#2	8.81498e-19
C143	VPWR#13	a_476_48##4	1.46977e-18
C144	VPWR#1	a_310_392#	3.03929e-17
C145	a_310_392##8	a_310_392##6	2.73512e-17
C146	X#2	VPWR#2	8.51506e-18
C147	a_310_392##15	B2#3	2.89242e-19
C148	a_310_392#	X#1	2.46519e-17
C149	VPWR#7	B2#3	3.24765e-20
C150	VPWR#1	a_310_392##7	1.3551e-18
C151	VPWR#10	a_310_392#	1.44108e-18
C152	a_476_48##9	A2_N#5	2.06768e-17
C153	VPWR#4	a_310_392##9	1.97982e-20
C154	a_310_392##7	X#1	2.39997e-17
C155	a_310_392##10	a_310_392##8	2.13609e-17
C156	VPWR#1	a_310_392##11	2.81672e-19
C157	a_310_392##7	VPWR#10	2.49647e-17
C158	X#6	a_310_392##7	4.35441e-19
C159	a_310_392##18	a_476_48#	1.10194e-18
C160	VGND#4	a_310_392##4	7.02308e-20
C161	X#2	VPWR#1	1.0856e-16
C162	VPWR#10	a_310_392##11	5.51282e-17
C163	VGND#3	a_310_392##4	1.34407e-19
C164	A1_N#3	a_310_392##10	1.51807e-17
C165	X#6	a_310_392##11	7.58383e-17
C166	X#6	VPWR#4	7.1183e-18
C167	a_27_74##4	a_27_74#	9.88518e-19
C168	a_310_392##18	A2_N#5	1.0706e-18
C169	VPWR#10	a_310_392##12	2.47764e-18
C170	VPWR#11	a_310_392##11	1.40198e-18
C171	X#2	X#1	9.40796e-19
C172	X#6	a_310_392##12	2.57089e-17
C173	X#6	VPWR#3	1.13981e-17
C174	A2_N#1	A1_N#3	4.55279e-17
C175	a_476_48##3	a_310_392##10	3.44428e-20
C176	VPWR#4	a_310_392##4	2.69714e-20
C177	X#3	a_310_392##3	7.2608e-18
C178	a_310_392##12	VPWR#11	3.60935e-17
C179	VPWR#3	a_310_392##4	9.55477e-20
C180	X#3	VGND#1	7.68323e-17
C181	X#6	A1_N#1	1.40152e-18
C182	a_476_48##6	a_310_392##12	2.30959e-18
C183	VPWR#3	a_310_392##3	1.95856e-20
C184	a_41_392#	B2#3	1.04228e-18
C185	X#2	VPWR#10	9.7759e-17
C186	VGND#4	a_310_392##14	2.17718e-17
C187	A1_N#1	VPWR#11	1.03867e-17
C188	VPWR#11	VPWR#3	8.12643e-19
C189	a_476_48##3	A2_N#1	3.5482e-18
C190	X#3	a_310_392##2	1.04538e-17
C191	VPWR#12	a_310_392##12	1.83967e-18
C192	X#2	a_310_392##4	8.2145e-19
C193	X#6	A2_N#3	6.02578e-19
C194	VPWR#7	VPWR#12	3.34222e-18
C195	VGND#9	VGND#1	1.68964e-18
C196	a_476_48##6	A1_N#1	3.04157e-17
C197	a_310_392##15	a_310_392##12	9.45524e-20
C198	a_476_48##4	A2_N#1	3.90543e-19
C199	a_310_392##14	a_310_392##4	2.23836e-17
C200	VPWR#11	A2_N#3	7.37412e-19
C201	VPWR#12	A1_N#1	7.37412e-19
C202	VPWR#3	a_310_392##2	1.11918e-21
C203	X#6	a_476_48#	3.96298e-19
C204	X#6	X#2	2.59148e-18
C205	a_476_48##6	A2_N#3	4.04442e-17
C206	a_476_48##4	a_476_48##3	2.94373e-17
C207	a_310_392##15	A1_N#1	1.52354e-19
C208	X#3	VGND#9	2.66502e-17
C209	a_27_74##4	VGND#11	4.54419e-17
C210	VGND#9	a_310_392##3	6.79508e-19
C211	VPWR#11	a_476_48#	3.40885e-19
C212	A2_N#3	VPWR#12	2.32089e-17
C213	a_310_392##15	VPWR#7	1.88845e-18
C214	VPWR#13	A1_N#1	3.54338e-19
C215	a_310_392##14	A1_N#2	5.91259e-17
C216	a_310_392##15	A2_N#3	1.92374e-17
C217	VGND#2	VGND#1	1.82122e-17
C218	a_310_392##17	B2#3	6.67554e-18
C219	a_476_48#	VPWR#12	2.63288e-17
C220	B2#1	a_476_48##4	3.60821e-17
C221	a_310_392##15	VPWR#5	4.09285e-18
C222	VGND#2	X#3	8.47929e-18
C223	a_27_74##4	a_27_74##6	4.05145e-19
C224	VPWR#13	A2_N#3	9.49994e-19
C225	a_310_392##14	X#6	1.40724e-16
C226	a_310_392##15	a_476_48#	3.02881e-17
C227	a_476_48##7	A1_N#2	8.21713e-19
C228	a_310_392##14	A2_N#2	2.57088e-19
C229	VPWR#12	a_476_48##5	1.2118e-18
C230	a_310_392##15	VPWR#4	1.81739e-18
C231	VPWR#13	a_476_48#	3.20545e-18
C232	A2_N#6	A1_N#2	1.60035e-18
C233	B2#6	B2#1	3.07271e-17
C234	a_310_392##15	a_476_48##5	4.83202e-17
C235	a_27_74##4	VGND#12	5.61281e-17
C236	a_41_392#	a_476_48#	2.15112e-19
C237	A2_N#5	A1_N#2	1.65501e-17
C238	VPWR#12	B2#5	4.72131e-19
C239	VPWR#13	a_476_48##5	4.68805e-17
C240	a_310_392##14	VPWR#11	4.57058e-17
C241	a_310_392##17	a_476_48#	6.43809e-20
C242	a_476_48##7	A2_N#2	7.09861e-18
C243	a_41_392#	VPWR#7	5.46802e-17
C244	VGND#10	VGND#9	1.72754e-18
C245	a_310_392##15	B2#5	9.85885e-19
C246	a_41_392#	a_476_48##5	2.07921e-18
C247	B2	B2#3	4.05602e-17
C248	A2_N#6	A2_N#2	6.14434e-18
C249	B2	B1#2	3.90514e-18
C250	B1#1	B2#6	3.43483e-17
C251	VPWR#13	B2#5	1.38831e-18
C252	a_27_74##5	a_27_74##4	3.15092e-18
C253	a_310_392##17	a_476_48##5	2.23481e-19
C254	A2_N#5	A2_N#2	1.40398e-17
C255	a_310_392##15	B2#4	2.7398e-19
C256	a_41_392#	B2#5	6.37538e-17
C257	a_41_392##2	B1#2	1.07732e-19
C258	a_310_392##14	a_476_48##6	2.53733e-17
C259	a_310_392##17	B2#5	5.08581e-17
C260	X#2	a_310_392##9	7.56996e-20
C261	B2#3	a_476_48##5	1.55796e-18
C262	a_310_392##17	VPWR#7	5.00104e-20
C263	B1#4	B1#1	1.96437e-17
C264	VGND#9	a_310_392##4	7.30425e-19
C265	VPWR#2	VPWR#1	2.04499e-17
C266	a_310_392##15	B1#5	4.35747e-19
C267	a_41_392#	B2#4	1.37698e-18
C268	a_41_392##2	B2#5	2.34565e-18
C269	X#2	VPWR#3	8.64783e-18
C270	B2#4	a_310_392##17	1.75495e-17
C271	A1_N	a_310_392##9	6.10808e-19
C272	VPWR#10	VPWR#2	7.53417e-20
C273	VGND#5	a_310_392##18	9.89218e-17
C274	VGND#2	VPWR#1	5.87963e-18
C275	a_41_392##2	B2#4	7.16523e-17
C276	X#2	a_310_392##3	1.53175e-17
C277	VGND#10	A1_N#2	8.97209e-19
C278	a_41_392##2	B1#5	6.3197e-17
C279	a_310_392##14	VPWR#4	2.85617e-18
C280	VPWR#14	B1#2	8.31232e-20
C281	B1#5	VPWR#14	2.19824e-17
C282	a_310_392##15	a_310_392##14	8.44471e-19
C283	a_41_392##2	B1#6	2.56891e-18
C284	X#2	a_310_392##2	6.61533e-18
C285	a_41_392##4	B1#5	2.13026e-18
C286	B1#6	VPWR#14	2.79671e-17
C287	a_27_74##4	B1#3	1.62526e-18
C288	a_476_48##4	a_476_48#	1.94238e-18
C289	a_41_392##4	B1#6	5.56281e-17
C290	a_310_392##7	a_310_392#	4.49314e-17
C291	a_476_48##9	A2_N#2	3.41936e-18
C292	A2_N#6	a_476_48##6	3.96363e-17
C293	a_310_392##18	A2_N#2	4.42481e-19
C294	a_476_48##7	VPWR#12	7.38567e-19
C295	a_310_392##15	VPWR#6	5.73744e-18
C296	VPWR#10	a_310_392##4	6.21016e-19
C297	a_310_392##11	a_310_392##7	3.74796e-17
C298	VGND#6	a_27_74##4	8.76612e-18
C299	a_27_74#	a_476_48##2	5.02483e-17
C300	X#6	a_310_392##4	5.25002e-18
C301	a_310_392##18	a_476_48##2	2.7206e-18
C302	a_310_392##14	a_310_392##9	1.64524e-17
C303	VGND#3	a_310_392##6	5.49405e-18
C304	a_27_74##2	a_476_48##2	1.78584e-17
C305	a_310_392##14	a_835_94#	1.38418e-17
C306	a_310_392##12	a_310_392##11	3.24144e-17
C307	a_310_392##15	a_476_48##7	6.52944e-17
C308	a_27_74#	a_476_48##9	3.36659e-17
C309	A1_N#2	VPWR#11	8.52968e-19
C310	VGND#2	a_310_392##5	6.79752e-18
C311	B1	B2#3	1.09719e-17
C312	a_310_392##14	a_310_392##3	8.4531e-18
C313	B1	B1#2	2.00351e-17
C314	A1_N#1	a_310_392##12	2.06244e-17
C315	VGND#3	a_310_392##8	9.54366e-19
C316	a_310_392##18	a_476_48##9	3.05326e-17
C317	a_476_48##6	A2_N#2	2.02374e-18
C318	a_310_392##14	X#2	2.91586e-17
C319	A2_N#2	VPWR#12	8.70867e-19
C320	VGND#4	a_310_392##10	3.62529e-18
C321	A2_N#3	A1_N#1	3.72519e-17
C322	VGND#1	VPWR#1	1.41898e-17
C323	a_310_392##15	A2_N#2	4.42658e-19
C324	B1#5	B2#3	5.37819e-18
C325	a_27_74#	a_310_392##18	6.4642e-17
C326	VGND#12	B1#3	1.10678e-18
C327	a_27_74##5	B1#3	2.7597e-17
C328	a_476_48#	A2_N#3	2.04817e-17
C329	a_476_48##2	a_310_392##15	6.16973e-17
C330	X	a_310_392##9	1.15603e-18
C331	X	a_310_392##3	1.63014e-18
C332	a_476_48##2	VPWR#13	3.47765e-18
C333	VGND#4	A1_N#3	7.86699e-19
C334	VPWR#6	a_476_48##4	1.9266e-19
C335	VGND#5	a_476_48##3	4.43427e-18
C336	a_476_48##5	a_476_48#	2.89298e-17
C337	VGND#5	a_476_48##4	1.32727e-19
C338	VPWR#2	a_310_392#	7.26291e-18
C339	a_27_74##2	a_310_392##18	1.9749e-17
C340	B2#5	a_476_48##5	5.34116e-18
C341	VGND#4	A2_N#1	3.38657e-18
C342	VGND#11	a_310_392##18	1.18059e-17
C343	a_41_392##2	B1#3	2.92009e-19
C344	B2#4	B2#5	4.23368e-17
C345	B2	a_476_48##7	4.51696e-18
C346	VPWR#14	B1#3	5.89938e-19
C347	B1#3	a_41_392##4	2.45589e-17
C348	a_476_48##4	A2_N#2	5.27394e-20
C349	a_27_74##4	B2	1.47088e-17
C350	a_310_392##3	a_310_392##2	7.98973e-18
C351	a_27_74##2	VGND#11	2.00479e-17
C352	B1#5	B2#4	4.23068e-17
C353	A1_N	a_310_392##14	2.76754e-17
C354	a_476_48##2	a_476_48##4	3.72198e-17
C355	A2_N#6	A1_N	1.32451e-17
C356	B1#6	B1#5	4.85575e-17
C357	VGND#6	a_476_48##4	7.0834e-18
C358	A2_N#5	A1_N	2.82866e-18
C359	a_310_392##14	a_310_392##6	5.74788e-20
C360	VPWR#6	a_476_48#	3.05561e-18
C361	VGND#5	a_476_48#	6.08549e-20
C362	A1_N#2	a_310_392##12	1.55394e-18
C363	a_27_74##4	a_41_392##2	7.40474e-18
C364	VGND	a_310_392##9	2.0921e-19
C365	a_27_74##2	B2	2.34014e-17
C366	a_310_392##14	a_310_392##8	4.15821e-19
C367	VGND#6	B2#1	3.69712e-18
C368	A1_N#3	a_310_392##9	1.2791e-18
C369	A1_N#3	a_835_94#	2.99492e-18
C370	VGND#12	VGND#11	1.57663e-18
C371	a_476_48#	A2_N#2	1.90958e-17
C372	VPWR#2	a_310_392##2	2.21038e-20
C373	A2_N#1	a_835_94#	5.89018e-18
C374	VGND#4	X	9.07057e-18
C375	VGND#3	X	9.58548e-18
C376	a_476_48##7	a_310_392##14	5.48025e-18
C377	a_476_48##2	a_476_48#	6.07059e-18
C378	a_27_74##2	B2#3	2.11724e-18
C379	a_476_48##7	a_310_392##9	4.66683e-19
C380	a_27_74##4	B1	3.042e-17
C381	a_310_392##14	a_310_392##10	6.76388e-18
C382	VGND#6	B2#6	2.74118e-18
C383	X	X#2	1.45572e-18
C384	VPWR#7	a_476_48##4	2.78848e-19
C385	a_310_392##14	X	9.49047e-17
C386	B2	a_41_392#	2.18715e-18
C387	B2	a_310_392##17	7.36804e-17
C388	B2	a_41_392##2	1.85688e-18
C389	A1_N	a_476_48##6	1.33237e-17
C390	VPWR	VPWR#7	9.88303e-17
C391	VPWR	VPWR#5	4.28151e-17
C392	VPWR	VPWR#4	5.92636e-17
C393	a_310_392##14	A1_N#3	2.36595e-17
C394	VPWR	VPWR#3	6.12442e-17
C395	VPWR	X#2	2.1532e-17
C396	VPWR	a_310_392##14	1.73241e-17
C397	VGND#2	a_310_392##2	6.05647e-20
C398	X	X#3	2.5966e-18
C399	a_27_74##5	B1	3.52495e-17
C400	X	VGND#9	6.14808e-17
C401	X	X#5	1.64034e-17
C402	VPWR	a_476_48##7	2.7422e-18
C403	VGND#5	A2_N#2	3.87647e-20
C404	a_27_74##5	VGND#12	5.06223e-17
C405	VGND#10	X	4.00704e-17
C406	VPWR	A2_N#6	3.17187e-18
C407	B2	a_476_48##4	3.35387e-18
C408	VGND#11	B2#3	8.50616e-19
C409	VGND	VGND#6	8.23376e-17
C410	VGND	VGND#4	8.48044e-17
C411	VGND	VGND#3	6.05039e-17
C412	A2_N#2	A1_N#2	2.8991e-17
C413	a_476_48##9	a_476_48##6	2.30248e-18
C414	a_310_392##14	A2_N#1	1.59494e-17
C415	VGND	X#2	1.16807e-18
C416	B1	a_41_392##2	2.63632e-17
C417	VGND	a_310_392##14	2.35484e-17
C418	B1	a_41_392##4	3.84229e-17
C419	a_310_392##9	VNB	2.3622e-17
C420	a_310_392##3	VNB	3.00452e-17
C421	a_310_392##2	VNB	3.52444e-17
C422	B2#3	VNB	8.0101e-17
C423	B1#2	VNB	3.12631e-17
C424	VGND#3	VGND#1	1.20547e-19
C425	VGND	A2_N#5	4.29318e-18
C426	VGND	a_27_74##4	2.12724e-17
C427	a_476_48##7	B2#3	7.11124e-19
C428	a_310_392##14	A2_N#5	1.05583e-18
C429	B2	a_476_48#	4.03288e-19
C430	A1_N	a_310_392##12	7.37783e-19
C431	VPWR	VPWR#10	2.15133e-17
C432	B2	a_476_48##5	1.24605e-18
C433	a_310_392##14	a_476_48##3	3.73517e-19
C434	a_476_48##7	A1_N#3	2.13826e-19
C435	VGND	X#3	2.14941e-17
C436	VPWR	X#6	1.92814e-17
C437	B1	a_476_48##4	1.18048e-18
C438	A1_N	A1_N#1	4.26169e-18
C439	VGND	VGND#9	1.60414e-17
C440	VPWR	VPWR#11	2.01006e-17
C441	X	a_310_392##6	4.24687e-19
C442	A1_N	A2_N#3	5.45277e-19
C443	VPWR	a_476_48##6	6.6073e-18
C444	VGND	VGND#10	3.16107e-17
C445	VPWR	VPWR#12	2.08598e-17
C446	X	a_310_392##8	2.23498e-17
C447	VGND	a_476_48##9	1.11324e-17
C448	VPWR	a_310_392##15	2.93579e-17
C449	X	a_310_392##10	1.34844e-17
C450	VGND	a_27_74#	1.05248e-17
C451	B2	B1#5	1.07238e-18
C452	VGND	a_310_392##18	4.49335e-17
C453	X	A1_N#3	4.70124e-19
C454	VPWR	a_41_392#	2.78296e-17
C455	VGND	a_27_74##2	1.34201e-17
C456	X	A2_N#1	1.56786e-19
C457	VGND	VGND#11	1.59099e-17
C458	VPWR	a_310_392##17	8.3533e-18
C459	B2	B1#6	7.46975e-19
C460	VPWR	a_41_392##2	2.20853e-17
C461	VGND	VGND#12	1.82544e-17
C462	VGND	a_27_74##5	1.81935e-17
C463	VPWR	a_41_392##4	1.87656e-17
C464	VGND#3	X#3	9.09261e-18
C465	VGND	X#6	4.12228e-18
C466	VGND	a_310_392##15	2.6325e-18
C467	a_476_48##7	A2_N#1	6.99726e-19
C468	a_310_392##14	a_476_48##4	1.85705e-19
C469	VGND#6	VNB	4.30236e-17
C470	VGND#4	VNB	4.52576e-17
C471	VGND#3	VNB	3.15441e-17
C472	VPWR#7	VNB	4.70712e-17
C473	VGND	a_310_392##5	3.00822e-18
C474	VPWR#5	VNB	2.32415e-17
C475	VPWR#4	VNB	3.16832e-17
C476	VPWR#3	VNB	3.19271e-17
C477	VGND	a_310_392##8	4.28208e-19
C478	X#2	VNB	1.44791e-17
C479	VGND	a_310_392##10	1.54495e-19
C480	VPWR	a_310_392#	2.9307e-18
C481	a_310_392##14	VNB	1.79386e-17
C482	VGND	A1_N#3	3.33729e-18
C483	VPWR	a_310_392##7	1.01148e-19
C484	B2	a_476_48##2	1.76641e-17
C485	A1_N	A1_N#2	8.56915e-18
C486	VGND	A2_N#1	1.52901e-20
C487	VPWR	a_310_392##11	5.48349e-19
C488	a_476_48##7	VNB	2.79852e-18
C489	VGND	a_476_48##3	2.74227e-18
C490	A2_N#6	VNB	2.61343e-18
C491	VGND	a_476_48##4	2.86804e-18
C492	VPWR	a_310_392##12	3.52373e-18
C493	A1_N	A2_N#2	1.75518e-18
C494	A2_N#5	VNB	1.58521e-18
C495	a_27_74##4	VNB	5.71601e-18
C496	VGND	B2#1	3.11487e-19
C497	VPWR	A1_N#1	7.71706e-18
C498	a_476_48##7	A2_N#6	1.77129e-17
C499	VPWR	A2_N#3	7.52672e-18
C500	B2	B1#3	3.31989e-20
C501	VGND	B1#1	4.19571e-19
C502	VPWR	a_476_48#	8.16401e-18
C503	VGND	B1#4	1.07785e-18
C504	VGND#1	VNB	4.35897e-17
C505	VPWR	a_476_48##5	4.13684e-18
C506	X#3	VNB	8.8344e-18
C507	VGND#9	VNB	6.48186e-19
C508	VPWR	B2#5	1.63358e-18
C509	VGND#10	VNB	1.80359e-18
C510	VPWR	B2#4	1.32998e-18
C511	B1#2	B2#3	3.40736e-17
C512	a_476_48##9	VNB	8.17028e-18
C513	a_27_74#	VNB	6.1708e-18
C514	VPWR	B1#5	1.23838e-18
C515	a_310_392##18	VNB	1.51394e-17
C516	a_27_74##2	VNB	3.02633e-18
C517	VGND#11	VNB	8.87614e-19
C518	VPWR	B1#6	1.77008e-18
C519	VGND#12	VNB	3.32409e-18
C520	a_27_74##5	VNB	3.90247e-17
C521	B1	a_476_48##2	2.49412e-18
C522	VPWR#1	VNB	5.49503e-17
C523	VGND	a_476_48#	1.65266e-20
C524	X	a_310_392##4	7.36676e-18
C525	VPWR	VPWR#2	1.38138e-17
C526	VPWR#10	VNB	9.05106e-19
C527	X#6	VNB	7.52638e-18
C528	VPWR#10	VPWR#1	1.68603e-18
C529	VPWR#11	VNB	8.54989e-18
C530	VPWR#12	VNB	1.17313e-17
C531	VPWR	VPWR#6	2.6011e-17
C532	B1	B1#3	2.54767e-17
C533	a_310_392##15	VNB	7.01719e-18
C534	VPWR#13	VNB	9.51169e-18
C535	a_41_392#	VNB	1.43352e-17
C536	a_310_392##17	VNB	2.12934e-18
C537	a_41_392##2	VNB	7.11072e-18
C538	VPWR#14	VNB	2.82484e-18
C539	a_41_392##4	VNB	5.10961e-17
C540	a_310_392##5	VNB	3.02497e-17
C541	a_310_392##6	VNB	2.72985e-17
C542	a_310_392##8	VNB	2.30781e-17
C543	VGND	VGND#2	1.38542e-17
C544	a_310_392##10	VNB	2.83764e-17
C545	A1_N#3	VNB	2.75736e-17
C546	VPWR	a_476_48##2	6.05195e-18
C547	A2_N#1	VNB	3.41979e-17
C548	a_476_48##3	VNB	3.49887e-17
C549	VGND	VGND#5	7.10461e-17
C550	a_476_48##4	VNB	1.15841e-16
C551	a_27_74##2	a_310_392##15	2.69085e-18
C552	B2#1	VNB	2.91846e-17
C553	VGND	a_310_392##4	5.12399e-19
C554	B2#6	VNB	3.05433e-17
C555	VPWR	B1#3	9.52752e-19
C556	B1#1	VNB	2.74044e-17
C557	VGND	A1_N#2	3.84826e-18
C558	B1#4	VNB	3.54535e-17
C559	a_310_392#	VNB	5.16234e-17
C560	a_310_392##7	VNB	2.95935e-17
C561	VGND	a_476_48##2	6.09972e-18
C562	a_310_392##11	VNB	3.20936e-17
C563	a_310_392##12	VNB	4.10085e-17
C564	A1_N#1	VNB	3.14789e-17
C565	B1	B2	1.82304e-17
C566	A2_N#3	VNB	3.13222e-17
C567	VGND	B1#3	2.50073e-18
C568	a_476_48#	VNB	5.03339e-17
C569	a_476_48##5	VNB	3.23663e-17
C570	B2#5	VNB	3.83623e-17
C571	VGND#1	a_310_392##5	2.35502e-17
C572	B2#4	VNB	3.09918e-17
C573	B1#5	VNB	3.45683e-17
C574	B1#6	VNB	4.90352e-17
C575	VPWR#2	VNB	9.43045e-17
C576	VGND#2	VNB	9.63811e-17
C577	VPWR	B2	4.90152e-18
C578	VPWR#6	VNB	1.46232e-17
C579	VGND#5	VNB	4.45758e-17
C580	VPWR	A1_N	4.60094e-18
C581	a_310_392##4	VNB	3.97468e-17
C582	A1_N#2	VNB	2.74454e-17
C583	a_476_48##7	a_476_48##4	1.0537e-18
C584	A2_N#2	VNB	2.81021e-17
C585	VGND	B2	5.9658e-18
C586	a_476_48##2	VNB	1.29061e-17
C587	VPWR	B1	8.11548e-18
C588	B1#3	VNB	8.2826e-17
C589	VGND	B1	8.16454e-18
C590	VGND	X	2.04193e-17
C591	B2	VNB	6.44581e-18
C592	A1_N	VNB	2.49578e-18
C593	B1	VNB	3.77267e-17
C594	X	VNB	5.39422e-18
C595	VGND#12	B1#2	3.86587e-19
C596	VPWR	VNB	2.98666e-16
C597	X#3	a_310_392##5	3.91426e-17
C598	VGND	VNB	3.00993e-16
C599	VPWR#8	B1#5	5.10817e-18
C600	VPWR	VPWR#8	1.14505e-16
C601	a_41_392##2	VPWR#8	3.69317e-17
C602	VGND#7	a_27_74##5	2.1034e-17
C603	VGND	VGND#7	8.40468e-17
C604	VPWR#8	VNB	6.18465e-17
C605	VPWR#8	B2#5	1.94895e-19
C606	VGND#7	B1#1	2.7245e-18
C607	B1	VPWR#8	8.50277e-19
C608	a_41_392#	VPWR#8	1.10423e-17
C609	VPWR#8	B1#6	5.68173e-18
C610	VGND#7	VGND#6	9.90885e-19
C611	VGND#7	B1#3	3.73459e-19
C612	VGND#7	B1#4	2.7211e-18
C613	VGND#7	VGND#11	2.10188e-19
C614	VGND#7	B1	5.27688e-19
C615	VPWR#8	B1#3	6.0253e-19
C616	VPWR#8	VPWR#7	1.60286e-19
C617	VGND#7	VNB	5.06366e-17
C618	VPWR#8	B2#4	5.01102e-18
C619	VGND#7	a_27_74##4	7.60389e-18
C620	a_41_392##4	VPWR#8	2.11181e-17
C621	VPWR#8	B2#3	2.40124e-20
*
*
.ENDS sky130_fd_sc_hs__o2bb2a_4
*
