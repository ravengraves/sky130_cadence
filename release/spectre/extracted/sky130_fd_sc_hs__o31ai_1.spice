* Extracted by Quantus, converted by sky130cad/quantus.py
*
*
*
*                       LINUX           Wed Nov 18 09:02:09 2026
*
*
*
*  PROGRAM  advgen
*
*  Name           : advgen - Quantus - (64-bit)
*  Version        : 25.1.0-p047
*  Build Date     : Thu Dec 11 23:20:30 PST 2025
*
*  HSPICE LIBRARY
*
*  OPERATING_TEMPERATURE 150
*  QRC_TECH_DIR <path>/tech
*
*
*

*
.SUBCKT sky130_fd_sc_hs__o31ai_1 VNB VPB VGND VPWR Y A1 A2 B1 A3
*
*
*  caps2d version: 10
*
*
*       TRANSISTOR CARDS
*
*
XM7 VGND#3 A1#4 a_114_74##2 VNB sky130_fd_pr__nfet_01v8_lvt l=0.15 w=0.74 ad=0.2109 as=0.2072 pd=2.05 ps=2.04
XM3 a_114_74##2 A2#3 VGND#4 VNB sky130_fd_pr__nfet_01v8_lvt l=0.15 w=0.74 ad=0.2072 as=0.6984 pd=2.04 ps=3.4
XM6 VGND#4 A3#1 a_114_74# VNB sky130_fd_pr__nfet_01v8_lvt l=0.15 w=0.74 ad=0.6984 as=0.222 pd=3.4 ps=2.08
XM2 a_114_74# B1#3 Y#1 VNB sky130_fd_pr__nfet_01v8_lvt l=0.15 w=0.74 ad=0.222 as=0.2479 pd=2.08 ps=2.15
XM5 VPWR#3 A1#1 a_119_368# VPB sky130_fd_pr__pfet_01v8 l=0.15 w=1.12 ad=0.3304 as=0.3024 pd=2.83 ps=2.78
XM1 a_119_368# A2#1 a_203_368# VPB sky130_fd_pr__pfet_01v8 l=0.15 w=1.12 ad=0.3024 as=0.4704 pd=2.78 ps=3.08
XM4 a_203_368# A3#3 Y#2 VPB sky130_fd_pr__pfet_01v8 l=0.15 w=1.12 ad=0.4704 as=0.7728 pd=3.08 ps=3.62
XM0 Y#2 B1#4 VPWR#1 VPB sky130_fd_pr__pfet_01v8 l=0.15 w=1.12 ad=0.7728 as=0.3304 pd=3.62 ps=2.83
*
*
*       RESISTOR AND CAP/DIODE CARDS
*
Rg1	A1#1	A1#2	563.875305
Rg2	A1#2	A1#3	31.581308
Rg3	A1#2	A1#4	380.488098
Rg4	A2#1	A2#2	456.846832
Rg5	A2#2	A2#3	353.846649
Rg6	A3#1	A3#2	389.313507
Rg7	A3#2	A3#3	531.553772
Rg8	B1#1	B1#2	33.566738
Rg9	B1#2	B1#3	368.862610
Rg10	B1#2	B1#4	471.862823
Rf1	A1	A1#3	163.775864
Rf2	A2#4	A2#2	161.486633
Rf3	A2	A2#6	1.253837
Rf4	A2#4	A2#6	4.615015
Rf5	A2	A2#7	1.253837
Rf6	A2#6	A2#7	8.537777
Rf7	A2	A2#8	1.253837
Rf8	A2#7	A2#8	8.537777
Rf9	A2	A2#9	1.253837
Rf10	A2#8	A2#9	8.537777
Rf11	a_114_74#	a_114_74##2	107.693710
Rf12	A3#2	A3#5	161.934692
Rf13	A3#6	A3	1.701882
Rf14	A3#5	A3#6	9.320884
Rf15	Y#1	Y	175.655228
Rf16	Y	Y#2	5.761806
Rf17	B1	B1#1	168.106262
Rf18	VPWR#1	VPWR#2	114.983047
Rf19	VPWR#2	VPWR#3	135.009720
Rf21	VGND#2	VGND#3	117.970161
Rf22	VGND#2	VGND#4	14.493389
Re1	VPWR#2	VPWR	1.637070
Re2	VGND	VGND#2	1.637131
*
*       CAPACITOR CARDS
*
*
C1	A3#3	B1#2	2.89058e-19
C2	B1#1	B1#2	1.45902e-17
C3	A3#2	B1#2	2.64054e-17
C4	Y#1	A3#5	2.22135e-17
C5	A2#4	VGND#4	1.94431e-18
C6	Y#1	B1#2	7.80986e-18
C7	Y#1	a_114_74#	1.00725e-16
C8	a_114_74##2	A2#4	3.5686e-17
C9	Y#1	VGND#4	3.54183e-19
C10	VGND#3	A2#4	7.11161e-19
C11	a_114_74#	VGND#4	6.853e-17
C12	a_114_74##2	Y#1	3.18399e-19
C13	a_114_74##2	a_114_74#	1.56996e-18
C14	A3	B1#2	1.26537e-17
C15	a_114_74##2	VGND#4	6.74292e-17
C16	Y#1	VPWR#1	2.79779e-18
C17	VGND#3	VGND#4	3.25907e-18
C18	VGND#3	a_114_74##2	6.23992e-17
C19	B1	B1#2	9.84727e-18
C20	A2#4	A3#1	1.34969e-19
C21	Y#1	B1#3	2.92896e-17
C22	a_114_74#	B1#3	3.13398e-17
C23	Y#1	A3#1	2.04904e-17
C24	A3#5	A3#3	2.36704e-18
C25	VGND#4	B1#3	4.48283e-18
C26	a_114_74#	A3#1	4.48414e-17
C27	Y#1	A2#3	1.30084e-19
C28	VGND#3	VPWR#3	1.212e-18
C29	a_114_74##2	B1#3	8.5724e-20
C30	A3#1	VGND#4	3.41586e-17
C31	a_114_74#	A2#3	4.42017e-19
C32	a_114_74##2	A3#1	1.53321e-18
C33	A2#3	VGND#4	3.01789e-17
C34	VGND#3	A3#1	1.48099e-19
C35	a_114_74##2	A2#3	5.60884e-17
C36	VGND#4	A1#4	1.45235e-18
C37	VGND#3	A2#3	3.31951e-18
C38	a_114_74##2	A1#4	1.66494e-17
C39	VGND#3	A1#4	4.34397e-17
C40	VPWR#1	B1#4	5.36473e-17
C41	B1#2	VPWR#1	5.77195e-18
C42	A3#1	B1#3	3.54503e-17
C43	Y	B1#2	7.22914e-19
C44	B1#4	Y#2	4.4277e-18
C45	VPWR#1	A3#3	1.3976e-18
C46	A3#5	A3#2	1.7001e-17
C47	A3#3	Y#2	3.55075e-17
C48	A2#3	A3#1	4.12531e-18
C49	VPWR#1	A2#1	3.18931e-19
C50	VPWR#3	B1#4	4.37686e-19
C51	VPWR#1	A1#1	3.53015e-19
C52	A3#5	A2#2	4.50208e-19
C53	A1#4	A2#3	3.70636e-17
C54	VPWR#3	A3#3	1.06571e-18
C55	B1#1	Y#1	3.41661e-17
C56	A2#4	A3#2	1.34755e-18
C57	VPWR#3	A2#1	3.40917e-18
C58	VPWR#2	VPWR#1	3.49147e-17
C59	VPWR#3	A1#1	3.64387e-17
C60	Y#1	A3#2	3.30745e-18
C61	A2#4	A2#2	1.36825e-17
C62	a_114_74#	A3#2	1.02035e-18
C63	VGND#4	A3#2	1.01784e-18
C64	A2#4	A1#3	7.42122e-18
C65	VPWR#2	VPWR#3	3.15443e-17
C66	VGND#4	A2#2	7.20663e-19
C67	A3#3	B1#4	1.12995e-17
C68	a_114_74##2	A2#2	1.76181e-18
C69	A3#2	Y#2	1.40344e-18
C70	VGND	B1#2	8.92036e-19
C71	A2#1	A3#3	2.90038e-17
C72	A1#3	VGND#3	7.56731e-18
C73	B1#1	A3#1	8.20054e-19
C74	A1#1	A2#1	5.64306e-17
C75	VPWR#2	A3#3	5.34729e-18
C76	VPWR#3	A1#3	1.01722e-17
C77	A2#2	A3#1	1.40746e-18
C78	VPWR#2	A2#1	6.15585e-18
C79	A1#3	A2#3	2.0325e-18
C80	Y#1	A3	1.91992e-17
C81	A2#2	A3#3	7.72314e-19
C82	A1#1	A2#2	2.09643e-18
C83	A3	VPWR#1	6.23061e-19
C84	VPWR#2	A3#2	1.09441e-19
C85	VPWR#2	A2#2	1.21662e-19
C86	B1	VPWR#1	2.84314e-17
C87	A3#3	a_203_368#	2.8471e-17
C88	A2#1	a_203_368#	2.65751e-17
C89	A1	A2#4	2.91562e-17
C90	Y	A3#5	7.28486e-17
C91	B1#1	A2#2	2.32316e-20
C92	B1#2	VNB	6.36e-17
C93	A2#1	a_119_368#	2.20836e-17
C94	A2#2	A3#2	1.86158e-17
C95	A1#1	a_119_368#	2.2795e-17
C96	A2#4	Y	2.44521e-17
C97	VGND#3	A1	2.86524e-17
C98	A3	B1#4	1.031e-17
C99	VPWR#3	A2	7.9051e-17
C100	VPWR	A3#5	2.20861e-18
C101	Y#1	Y	3.53152e-18
C102	A1#3	A2#2	2.72774e-17
C103	a_114_74#	Y	1.14251e-17
C104	Y	VGND#4	8.78186e-19
C105	B1	B1#4	2.78672e-18
C106	a_114_74##2	Y	1.52715e-17
C107	A1	VPWR#3	2.00021e-17
C108	Y	VPWR#1	9.68196e-17
C109	A2#2	a_203_368#	2.22589e-19
C110	Y	Y#2	1.98654e-17
C111	A1	A3#1	4.03082e-19
C112	A1	A2#3	1.10846e-18
C113	VGND	A3#5	2.0481e-18
C114	A2	A3#3	8.79908e-18
C115	VPWR#3	Y	3.30206e-18
C116	A2	A2#1	4.12445e-17
C117	Y	B1#3	4.97807e-20
C118	A3	B1#1	1.68543e-17
C119	A2	A1#1	2.49102e-17
C120	VPWR	VPWR#1	4.55906e-17
C121	Y	A3#1	1.04332e-18
C122	A3	A3#2	6.01841e-18
C123	VGND	A2#4	8.18288e-18
C124	Y	A2#3	4.29177e-18
C125	Y	A1#4	2.52348e-19
C126	VGND	Y#1	2.21803e-17
C127	A2	VPWR#2	1.66316e-17
C128	VGND	a_114_74#	1.91411e-17
C129	VPWR	VPWR#3	3.85411e-17
C130	VGND	VGND#4	6.25386e-17
C131	Y	B1#4	2.50918e-17
C132	VGND	a_114_74##2	1.86877e-17
C133	VGND	VGND#3	4.14303e-17
C134	Y	A3#3	5.90525e-17
C135	Y	A2#1	8.11829e-18
C136	A2	A3#2	1.01241e-18
C137	Y	A1#1	5.47463e-19
C138	A2	A2#2	9.14899e-18
C139	VPWR	B1#4	4.5054e-18
C140	VGND	VPWR#3	2.89261e-18
C141	VGND	B1#3	2.09908e-18
C142	VPWR	A3#3	2.38159e-20
C143	Y	VPWR#2	3.89018e-17
C144	A2	A1#3	3.93391e-18
C145	VGND	A3#1	2.40174e-19
C146	VPWR	A2#1	2.84689e-19
C147	A1	A2#2	1.04712e-18
C148	VPWR	A1#1	5.7817e-18
C149	VGND	A1#4	3.87545e-18
C150	Y	B1#1	2.35067e-18
C151	A1	A1#3	2.43589e-17
C152	A2	a_203_368#	6.66653e-18
C153	Y	A3#2	1.75029e-17
C154	VPWR	VPWR#2	3.53977e-17
C155	A3#5	VNB	3.50486e-18
C156	Y	A2#2	5.30124e-18
C157	A2	a_119_368#	4.17142e-18
C158	Y	A1#3	8.22612e-19
C159	A3	B1	2.2223e-17
C160	A2#4	VNB	1.53627e-18
C161	Y#1	VNB	4.18431e-17
C162	a_114_74#	VNB	2.1507e-18
C163	Y	a_203_368#	5.65753e-18
C164	VGND#4	VNB	5.7133e-17
C165	VPWR	A1#3	9.83849e-19
C166	a_114_74##2	VNB	3.69874e-18
C167	VGND#3	VNB	6.10862e-17
C168	VGND	B1#1	4.46441e-18
C169	VPWR#1	VNB	8.05528e-17
C170	VPWR#3	VNB	8.70565e-17
C171	B1#3	VNB	3.26622e-17
C172	VGND	A1#3	2.21386e-20
C173	A3	Y	2.95982e-17
C174	A3#1	VNB	3.23629e-17
C175	A2#3	VNB	2.74989e-17
C176	A1#4	VNB	3.38474e-17
C177	B1#4	VNB	3.97404e-17
C178	VPWR	A3	3.32056e-18
C179	A3#3	VNB	3.85593e-17
C180	A2	Y	1.29079e-16
C181	A2#1	VNB	3.47232e-17
C182	VPWR	B1	2.14313e-18
C183	A1#1	VNB	4.27609e-17
C184	A1	Y	3.67904e-18
C185	VPWR#2	VNB	1.80964e-16
C186	VGND	A3	1.88321e-18
C187	VPWR	A2	2.39772e-17
C188	B1#1	VNB	9.14048e-18
C189	VPWR	A1	1.34917e-18
C190	A3#2	VNB	3.87797e-17
C191	A2#2	VNB	2.53988e-17
C192	A1#3	VNB	6.17387e-17
C193	VPWR	Y	3.49648e-17
C194	VGND	A1	2.41723e-18
C195	VGND	Y	2.54166e-18
C196	A3	VNB	1.3722e-18
C197	A3#1	B1#2	5.23221e-18
C198	B1	VNB	1.31361e-17
C199	A2	VNB	8.21298e-18
C200	A1	VNB	1.94338e-17
C201	Y	VNB	1.43311e-17
C202	VPWR	VNB	5.72853e-17
C203	VGND	VNB	5.46691e-17
C204	VGND#2	B1#1	5.01029e-19
C205	VGND#2	Y#1	2.50414e-17
C206	VGND#2	VGND#4	6.93275e-17
C207	VGND#2	B1#2	3.55899e-19
C208	VGND#2	VGND#3	2.86177e-17
C209	VGND	VGND#2	1.63493e-17
C210	VGND#2	B1#3	1.35959e-18
C211	VGND#2	VNB	1.64625e-16
*
*
.ENDS sky130_fd_sc_hs__o31ai_1
*
