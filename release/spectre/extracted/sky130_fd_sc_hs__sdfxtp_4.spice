* Extracted by Quantus, converted by sky130cad/quantus.py
*
*
*
*                       LINUX           Wed Nov 18 09:11:41 2026
*
*
*
*  PROGRAM  advgen
*
*  Name           : advgen - Quantus - (64-bit)
*  Version        : 25.1.0-p047
*  Build Date     : Thu Dec 11 23:20:30 PST 2025
*
*  HSPICE LIBRARY
*
*  OPERATING_TEMPERATURE 150
*  QRC_TECH_DIR <path>/tech
*
*
*

*
.SUBCKT sky130_fd_sc_hs__sdfxtp_4 VNB VPB VGND VPWR Q SCE CLK D SCD
*
*
*  caps2d version: 10
*
*
*       TRANSISTOR CARDS
*
*
XM6 a_36_74##8 SCE#4 VGND#17 VNB sky130_fd_pr__nfet_01v8_lvt l=0.15 w=0.42 ad=0.1197 as=0.147 pd=1.41 ps=1.54
XM36 VGND#17 a_36_74# a_223_74# VNB sky130_fd_pr__nfet_01v8_lvt l=0.15 w=0.42 ad=0.147 as=0.1008 pd=1.54 ps=1.32
XM34 a_223_74# D#3 a_301_74##6 VNB sky130_fd_pr__nfet_01v8_lvt l=0.15 w=0.42 ad=0.1008 as=0.2541 pd=1.32 ps=2.05
XM3 a_301_74##6 SCE#6 a_452_74# VNB sky130_fd_pr__nfet_01v8_lvt l=0.15 w=0.42 ad=0.2541 as=0.1008 pd=2.05 ps=1.32
XM0 a_452_74# SCD#1 VGND#16 VNB sky130_fd_pr__nfet_01v8_lvt l=0.15 w=0.42 ad=0.1008 as=0.227 pd=1.32 ps=2.18
XM29 VGND#16 CLK#3 a_630_74##15 VNB sky130_fd_pr__nfet_01v8_lvt l=0.15 w=0.74 ad=0.227 as=0.2109 pd=2.18 ps=2.05
XM37 VGND#15 a_630_74##6 a_828_74##13 VNB sky130_fd_pr__nfet_01v8_lvt l=0.15 w=0.74 ad=0.2109 as=0.2109 pd=2.05 ps=2.05
XM4 a_301_74# a_630_74##7 a_1026_100##6 VNB sky130_fd_pr__nfet_01v8_lvt l=0.15 w=0.42 ad=0.1197 as=0.2226 pd=1.41 ps=1.9
XM18 a_1026_100##6 a_828_74##4 a_1162_100# VNB sky130_fd_pr__nfet_01v8_lvt l=0.15 w=0.42 ad=0.2226 as=0.1995 pd=1.9 ps=1.79
XM19 a_1162_100# a_1257_74##3 VGND#14 VNB sky130_fd_pr__nfet_01v8_lvt l=0.15 w=0.42 ad=0.1995 as=0.41375 pd=1.79 ps=2.64
XM17 VGND#14 a_1026_100# a_1257_74##4 VNB sky130_fd_pr__nfet_01v8_lvt l=0.15 w=0.55 ad=0.41375 as=0.2365 pd=2.64 ps=1.96
XM20 a_1257_74##4 a_828_74##5 a_1587_74##9 VNB sky130_fd_pr__nfet_01v8_lvt l=0.15 w=0.55 ad=0.2365 as=0.4 pd=1.96 ps=2.59
XM2 a_1587_74##9 a_630_74##9 a_1766_74# VNB sky130_fd_pr__nfet_01v8_lvt l=0.15 w=0.42 ad=0.4 as=0.1008 pd=2.59 ps=1.32
XM38 a_1766_74# a_1814_48##3 VGND#13 VNB sky130_fd_pr__nfet_01v8_lvt l=0.15 w=0.42 ad=0.1008 as=0.1197 pd=1.32 ps=1.41
XM11 a_1814_48##22 a_1587_74# VGND#6 VNB sky130_fd_pr__nfet_01v8_lvt l=0.15 w=0.74 ad=0.2109 as=0.2405 pd=2.05 ps=2.13
XM35 Q#6 a_1814_48##14 VGND#6 VNB sky130_fd_pr__nfet_01v8_lvt l=0.15 w=0.74 ad=0.2701 as=0.2405 pd=2.21 ps=2.13
XM14 VGND#5 a_1814_48##12 Q#6 VNB sky130_fd_pr__nfet_01v8_lvt l=0.15 w=0.74 ad=0.2072 as=0.2701 pd=2.04 ps=2.21
XM25 VGND#5 a_1814_48##10 Q#5 VNB sky130_fd_pr__nfet_01v8_lvt l=0.15 w=0.74 ad=0.2072 as=0.2072 pd=2.04 ps=2.04
XM5 Q#5 a_1814_48##5 VGND#1 VNB sky130_fd_pr__nfet_01v8_lvt l=0.15 w=0.74 ad=0.2072 as=0.2109 pd=2.04 ps=2.05
XM12 a_36_74##9 SCE#5 VPWR#16 VPB sky130_fd_pr__pfet_01v8 l=0.15 w=0.64 ad=0.1888 as=0.224 pd=1.87 ps=1.98
XM22 VPWR#16 SCE#1 a_238_464# VPB sky130_fd_pr__pfet_01v8 l=0.15 w=0.64 ad=0.224 as=0.1728 pd=1.98 ps=1.82
XM27 a_238_464# D#1 a_301_74##4 VPB sky130_fd_pr__pfet_01v8 l=0.15 w=0.64 ad=0.1728 as=0.192 pd=1.82 ps=1.88
XM9 a_301_74##4 a_36_74##3 a_412_464# VPB sky130_fd_pr__pfet_01v8 l=0.15 w=0.64 ad=0.192 as=0.2496 pd=1.88 ps=2.06
XM21 a_412_464# SCD#3 VPWR#14 VPB sky130_fd_pr__pfet_01v8 l=0.15 w=0.64 ad=0.2496 as=0.5048 pd=2.06 ps=3.42
XM24 VPWR#14 CLK#1 a_630_74##13 VPB sky130_fd_pr__pfet_01v8 l=0.15 w=1.12 ad=0.5048 as=0.3304 pd=3.42 ps=2.83
XM7 VPWR#11 a_630_74##8 a_828_74##17 VPB sky130_fd_pr__pfet_01v8 l=0.15 w=1.12 ad=0.6216 as=0.3304 pd=3.35 ps=2.83
XM31 a_301_74##5 a_828_74# a_1026_100##7 VPB sky130_fd_pr__pfet_01v8 l=0.15 w=0.42 ad=0.1239 as=0.126 pd=1.43 ps=1.44
XM15 a_1026_100##7 a_630_74# a_1214_506# VPB sky130_fd_pr__pfet_01v8 l=0.15 w=0.42 ad=0.126 as=0.1638 pd=1.44 ps=1.62
XM23 a_1214_506# a_1257_74# VPWR#9 VPB sky130_fd_pr__pfet_01v8 l=0.15 w=0.42 ad=0.1638 as=0.370175 pd=1.62 ps=3.04
XM8 VPWR#9 a_1026_100##3 a_1257_74##7 VPB sky130_fd_pr__pfet_01v8 l=0.15 w=0.84 ad=0.370175 as=0.756 pd=3.04 ps=3.48
XM13 a_1257_74##7 a_630_74##12 a_1587_74##8 VPB sky130_fd_pr__pfet_01v8 l=0.15 w=0.84 ad=0.756 as=0.2898 pd=3.48 ps=2.46
XM28 a_1587_74##8 a_828_74##7 a_1764_476# VPB sky130_fd_pr__pfet_01v8 l=0.15 w=0.42 ad=0.2898 as=0.1134 pd=2.46 ps=1.38
XM32 a_1764_476# a_1814_48# VPWR#7 VPB sky130_fd_pr__pfet_01v8 l=0.15 w=0.42 ad=0.1134 as=0.2604 pd=1.38 ps=2.39
XM1 a_1814_48##21 a_1587_74##5 VPWR#7 VPB sky130_fd_pr__pfet_01v8 l=0.15 w=0.84 ad=0.252 as=0.2604 pd=2.28 ps=2.39
XM26 VPWR#6 a_1587_74##4 a_1814_48##21 VPB sky130_fd_pr__pfet_01v8 l=0.15 w=0.84 ad=0.3724 as=0.252 pd=2.95 ps=2.28
XM16 Q#3 a_1814_48##16 VPWR#6 VPB sky130_fd_pr__pfet_01v8 l=0.15 w=1.12 ad=0.336 as=0.3724 pd=2.84 ps=2.95
XM10 VPWR#5 a_1814_48##15 Q#3 VPB sky130_fd_pr__pfet_01v8 l=0.15 w=1.12 ad=0.336 as=0.336 pd=2.84 ps=2.84
XM30 Q#1 a_1814_48##11 VPWR#5 VPB sky130_fd_pr__pfet_01v8 l=0.15 w=1.12 ad=0.336 as=0.336 pd=2.84 ps=2.84
XM33 VPWR#1 a_1814_48##9 Q#1 VPB sky130_fd_pr__pfet_01v8 l=0.15 w=1.12 ad=0.3304 as=0.336 pd=2.83 ps=2.84
*
*
*       RESISTOR AND CAP/DIODE CARDS
*
Rg1	a_36_74#	a_36_74##2	778.479614
Rg2	SCE#1	SCE#2	484.685455
Rg3	SCE#2	SCE#3	739.021606
Rg4	SCE#3	SCE#4	242.169754
Rg5	SCE#2	SCE#5	234.008942
Rg6	D#1	D#2	473.017548
Rg7	D#2	D#3	585.753723
Rg8	a_36_74##3	a_36_74##4	339.263733
Rg9	SCE#6	SCE#7	370.124084
Rg10	SCD#1	SCD#2	623.561768
Rg11	SCD#2	SCD#3	393.484894
Rg12	CLK#1	CLK#2	473.627625
Rg13	CLK#2	CLK#3	363.745697
Rg14	CLK#2	CLK#4	33.590763
Rg15	a_828_74#	a_828_74##2	454.965027
Rg16	a_828_74##3	a_828_74##4	247.627029
Rg17	a_630_74#	a_630_74##2	273.761261
Rg18	a_630_74##2	a_630_74##3	631.007019
Rg19	a_630_74##3	a_630_74##4	240.758698
Rg20	a_630_74##4	a_630_74##5	221.219742
Rg21	a_630_74##5	a_630_74##6	360.620422
Rg22	a_630_74##3	a_630_74##7	466.780426
Rg23	a_630_74##4	a_630_74##8	427.807281
Rg24	a_1257_74#	a_1257_74##2	661.613159
Rg25	a_1257_74##2	a_1257_74##3	285.785645
Rg26	a_1026_100#	a_1026_100##2	637.131042
Rg27	a_1026_100##2	a_1026_100##3	350.185699
Rg28	a_828_74##5	a_828_74##6	267.767334
Rg29	a_630_74##9	a_630_74##10	876.993530
Rg30	a_630_74##10	a_630_74##11	35.518757
Rg31	a_630_74##10	a_630_74##12	419.181519
Rg32	a_828_74##7	a_828_74##8	454.342010
Rg33	a_1814_48#	a_1814_48##2	769.814880
Rg34	a_1814_48##2	a_1814_48##3	291.731201
Rg35	a_1814_48##2	a_1814_48##4	48.315460
Rg36	a_1587_74#	a_1587_74##2	440.995697
Rg37	a_1587_74##2	a_1587_74##3	171.425034
Rg38	a_1587_74##2	a_1587_74##4	423.062653
Rg39	a_1587_74##3	a_1587_74##5	348.786133
Rg40	a_1814_48##5	a_1814_48##6	368.862610
Rg41	a_1814_48##6	a_1814_48##7	66.369736
Rg42	a_1814_48##7	a_1814_48##8	86.720970
Rg43	a_1814_48##6	a_1814_48##9	471.862823
Rg44	a_1814_48##7	a_1814_48##10	366.112152
Rg45	a_1814_48##7	a_1814_48##11	470.238159
Rg46	a_1814_48##8	a_1814_48##12	370.669800
Rg47	a_1814_48##8	a_1814_48##13	64.081955
Rg48	a_1814_48##13	a_1814_48##14	368.862610
Rg49	a_1814_48##8	a_1814_48##15	451.334412
Rg50	a_1814_48##13	a_1814_48##16	471.862823
Rf1	D#2	D	171.649307
Rf2	a_36_74##4	a_36_74##6	171.109039
Rf3	a_36_74##6	a_36_74##2	5.859171
Rf4	a_36_74##2	a_36_74##8	88.278786
Rf5	a_36_74##6	a_36_74##9	25.978146
Rf6	SCE	SCE#7	3.018562
Rf7	SCE#7	SCE#3	217.864700
Rf8	SCD	SCD#4	10.235491
Rf9	SCD#4	SCD	4.330400
Rf10	CLK#5	CLK#4	161.672424
Rf11	CLK	CLK#7	1.439625
Rf12	CLK#5	CLK#7	5.647728
Rf13	a_630_74##13	a_630_74##14	58.512951
Rf14	a_630_74##14	a_630_74##15	88.517952
Rf15	a_301_74#	a_301_74##2	134.635345
Rf16	a_301_74##2	a_301_74##3	102.466774
Rf17	a_301_74##3	a_301_74##4	99.792664
Rf18	a_301_74##2	a_301_74##5	71.158340
Rf19	a_301_74##3	a_301_74##6	212.815552
Rf20	a_1026_100##2	a_1026_100##5	248.536621
Rf21	a_1026_100##5	a_1026_100##6	81.724548
Rf22	a_1026_100##5	a_1026_100##7	87.610901
Rf23	a_1257_74##4	a_1257_74##5	51.072903
Rf24	a_1257_74##5	a_1257_74##2	194.503021
Rf25	a_1257_74##5	a_1257_74##7	82.786995
Rf26	a_630_74##11	a_630_74##2	527.223633
Rf27	a_828_74##8	a_828_74##10	211.397705
Rf28	a_828_74##10	a_828_74##11	219.749146
Rf29	a_828_74##11	a_828_74##12	80.665237
Rf30	a_828_74##12	a_828_74##13	85.538429
Rf31	a_828_74##10	a_828_74##6	169.659149
Rf32	a_828_74##11	a_828_74##3	175.466202
Rf33	a_828_74##12	a_828_74##2	126.329849
Rf34	a_828_74##2	a_828_74##17	37.749649
Rf35	a_1587_74##3	a_1587_74##7	177.770920
Rf36	a_1587_74##7	a_1587_74##8	92.959732
Rf37	a_1587_74##7	a_1587_74##9	112.471481
Rf38	a_1814_48##8	a_1814_48##18	89.057999
Rf39	a_1814_48##18	a_1814_48##19	19.383188
Rf40	a_1814_48##19	a_1814_48##4	183.429199
Rf41	a_1814_48##18	a_1814_48##21	62.423256
Rf42	a_1814_48##19	a_1814_48##22	41.065563
Rf43	Q#1	Q#2	34.599602
Rf44	Q#2	Q#3	84.825569
Rf45	Q#2	Q	27.458553
Rf46	Q	Q#4	7.233542
Rf47	Q#4	Q#5	20.051395
Rf48	Q#4	Q#6	61.240173
Rf49	VPWR#1	VPWR#2	94.376015
Rf50	VPWR#2	VPWR#3	69.528831
Rf51	VPWR#3	VPWR#4	57.807934
Rf52	VPWR#2	VPWR#5	42.573776
Rf53	VPWR#3	VPWR#6	71.771095
Rf54	VPWR#4	VPWR#7	44.304161
Rf55	VPWR#4	VPWR#8	203.968979
Rf56	VPWR#8	VPWR#9	23.878334
Rf57	VPWR#8	VPWR#10	194.623444
Rf58	VPWR#10	VPWR#11	24.688660
Rf59	VPWR#10	VPWR#12	59.869816
Rf60	VPWR#12	VPWR#13	33.954678
Rf61	VPWR#13	VPWR#14	24.232351
Rf62	VPWR#13	VPWR#15	146.427902
Rf63	VPWR#15	VPWR#16	31.337896
Rf65	VGND#1	VGND#2	93.256287
Rf66	VGND#2	VGND#3	72.270927
Rf67	VGND#3	VGND#4	54.763336
Rf68	VGND#2	VGND#5	32.539131
Rf69	VGND#3	VGND#6	31.141060
Rf70	VGND#4	VGND#7	218.067719
Rf71	VGND#7	VGND#8	204.857574
Rf72	VGND#8	VGND#9	35.770210
Rf73	VGND#9	VGND#10	38.749577
Rf74	VGND#10	VGND#11	146.474518
Rf76	VGND#4	VGND#13	36.430706
Rf77	VGND#7	VGND#14	31.948624
Rf78	VGND#8	VGND#15	33.326477
Rf79	VGND#10	VGND#16	40.352859
Rf80	VGND#11	VGND#17	33.916985
Rf86	SCD#2	SCD#4	160.232803
Rf88	a_630_74##5	a_630_74##14	160.232803
Re1	VPWR#4	VPWR	2.105487
Re2	VPWR	VPWR#12	1.804703
Re3	VGND#4	VGND	2.105487
Re4	VGND	VGND#9	1.804703
*
*       CAPACITOR CARDS
*
*
C1	a_1814_48##10	a_1814_48##5	4.02157e-17
C2	VGND#5	a_1814_48##5	2.20597e-18
C3	VPWR#2	a_1814_48##9	6.61944e-19
C4	VGND#4	a_1026_100#	1.46377e-18
C5	a_36_74##6	a_36_74##2	2.81655e-17
C6	a_1814_48##10	Q#5	1.87439e-17
C7	a_630_74##12	a_828_74##7	2.72695e-17
C8	VPWR#6	Q#3	7.27118e-17
C9	VPWR#4	a_1587_74##2	3.83788e-20
C10	a_301_74##3	D#1	3.62779e-19
C11	Q#6	a_1814_48##5	2.73446e-19
C12	VPWR#1	a_1814_48##9	4.53051e-17
C13	a_630_74##2	a_1257_74##7	2.00253e-17
C14	VGND#4	a_1587_74##7	8.84675e-18
C15	VGND#2	Q#5	1.15122e-17
C16	VPWR#3	a_1814_48##11	2.0961e-19
C17	a_1814_48##19	Q#2	3.28949e-19
C18	VGND#16	SCD#2	6.56004e-19
C19	a_828_74##11	a_1257_74##4	3.05339e-17
C20	VGND#5	a_1814_48##10	3.27665e-17
C21	a_630_74##2	VPWR#9	1.03491e-18
C22	a_1814_48##19	a_1814_48##2	1.35354e-18
C23	a_1814_48##9	Q#1	2.49885e-17
C24	a_36_74##6	SCE#3	8.97904e-17
C25	VPWR#2	a_1814_48##11	4.93009e-18
C26	a_1814_48##12	a_1814_48##10	3.88267e-17
C27	Q#5	a_1814_48##12	1.22871e-18
C28	a_1026_100##3	a_630_74##12	7.27881e-18
C29	VGND#4	a_1814_48##13	3.47941e-20
C30	a_1814_48##8	VPWR#3	3.76544e-19
C31	VGND#2	a_1814_48##10	9.56478e-19
C32	a_301_74##6	SCD#2	1.46253e-17
C33	VGND#3	VGND#2	8.2274e-19
C34	VPWR#1	a_1814_48##11	2.7086e-18
C35	a_1026_100##7	a_630_74##2	3.89734e-17
C36	Q#2	a_1814_48##9	1.9631e-17
C37	Q#6	a_1814_48##2	9.41936e-19
C38	Q#6	a_1814_48##10	6.26252e-19
C39	VPWR#2	a_1814_48##8	4.81494e-20
C40	VGND#4	a_1814_48##7	1.51695e-18
C41	VPWR#5	a_1814_48##9	2.31041e-18
C42	a_301_74##3	SCE#1	9.30378e-19
C43	a_828_74##11	a_1257_74##5	1.82945e-17
C44	a_1814_48##4	a_1587_74#	4.22867e-19
C45	a_828_74##12	a_1026_100##5	2.8725e-19
C46	VGND#5	a_1814_48##12	2.92284e-17
C47	a_1814_48##11	Q#1	2.31468e-17
C48	VPWR#3	a_1814_48##15	1.00055e-18
C49	VGND#4	a_1814_48##6	1.18046e-19
C50	a_36_74##8	a_36_74##6	3.02223e-18
C51	a_828_74##17	a_630_74##2	8.31249e-20
C52	a_828_74##11	VGND#14	8.38917e-17
C53	a_1814_48##21	VPWR#6	7.45361e-17
C54	SCD#2	CLK#2	1.48037e-17
C55	a_1257_74#	a_1026_100##3	2.96379e-17
C56	Q#3	a_1814_48##9	2.58695e-19
C57	Q#5	a_1814_48##14	2.58931e-19
C58	a_1257_74##5	a_1257_74##7	2.55338e-18
C59	Q#4	a_1814_48##8	4.28496e-17
C60	VGND#3	Q#6	5.98803e-18
C61	VGND#4	a_1587_74##2	4.57126e-19
C62	a_301_74##5	a_630_74##3	1.23024e-18
C63	a_36_74##6	SCD#3	7.39407e-20
C64	VPWR#5	a_1814_48##11	5.31912e-17
C65	VPWR#2	a_1814_48##15	7.53978e-18
C66	a_1814_48##14	a_1814_48##12	2.76743e-17
C67	Q#6	a_1814_48##12	2.81883e-17
C68	VGND#2	a_1814_48##12	1.23779e-18
C69	a_1814_48##8	Q#2	3.85755e-17
C70	VGND#3	a_1814_48##13	3.80223e-20
C71	VGND#4	a_1814_48##2	3.01178e-18
C72	a_828_74##12	a_828_74##17	1.20214e-19
C73	Q#2	a_1814_48##11	1.60124e-17
C74	VGND#4	a_828_74##11	1.03188e-17
C75	a_1026_100##5	a_630_74##3	1.59395e-17
C76	VGND#5	a_1814_48##14	1.48848e-18
C77	VPWR#7	VPWR#6	3.88974e-18
C78	a_828_74##11	a_1026_100##5	4.19154e-18
C79	a_1026_100##7	a_828_74##2	2.72398e-17
C80	Q#3	a_1814_48##11	2.16259e-18
C81	VGND#9	CLK#3	2.05817e-18
C82	a_1026_100##5	a_1257_74##7	8.10811e-20
C83	a_630_74##15	a_630_74##13	2.7095e-18
C84	a_630_74#	a_1257_74#	1.84685e-17
C85	SCE#7	a_301_74##6	1.03273e-17
C86	a_630_74##9	a_828_74##8	2.71399e-17
C87	VGND#6	a_1814_48##12	1.68189e-18
C88	a_828_74##2	a_301_74##5	4.19512e-17
C89	VPWR#3	a_1814_48##16	1.21274e-17
C90	VGND#3	a_1814_48##14	5.08051e-18
C91	a_1814_48##19	a_1814_48##8	1.44259e-19
C92	a_1814_48##15	VPWR#5	2.09523e-17
C93	VGND#6	a_1814_48##2	4.40735e-19
C94	VGND#2	Q#6	8.77089e-18
C95	a_630_74##4	a_828_74##17	1.92486e-18
C96	a_828_74##12	a_1026_100##6	7.66359e-17
C97	VPWR#6	a_1814_48##11	2.05682e-20
C98	a_828_74##17	a_828_74##2	1.956e-17
C99	a_1814_48##14	Q#6	2.3171e-17
C100	VPWR#7	a_1814_48##21	4.20044e-17
C101	VPWR#2	a_1814_48##16	3.00558e-19
C102	Q#3	a_1814_48##15	7.46274e-17
C103	a_1587_74#	a_1814_48##14	3.31583e-17
C104	VPWR#4	a_1257_74##5	7.08379e-19
C105	a_1814_48##22	a_1814_48##12	2.77707e-20
C106	VPWR#4	a_1814_48##9	5.26304e-19
C107	a_36_74##4	CLK#2	5.88862e-19
C108	VGND#5	a_1587_74#	2.78156e-19
C109	VGND#7	a_630_74##11	6.50591e-21
C110	a_301_74##6	D#2	2.09891e-18
C111	a_828_74#	a_630_74#	2.16685e-17
C112	Q#2	a_1814_48##15	8.89675e-19
C113	a_828_74##6	a_1814_48##3	2.50818e-19
C114	a_36_74##4	SCE#2	9.98086e-20
C115	VPWR#5	a_1814_48##16	3.67904e-19
C116	a_1814_48##14	VGND#6	1.98935e-17
C117	a_630_74##3	a_828_74##17	4.41626e-18
C118	VPWR#4	a_1814_48##11	1.18538e-18
C119	VPWR#6	a_1814_48##15	8.09827e-20
C120	a_828_74##6	a_630_74##9	2.09971e-18
C121	a_1026_100##6	a_828_74##11	3.54867e-17
C122	a_630_74##5	VPWR#11	4.40021e-18
C123	a_1814_48##19	a_1587_74##3	4.32786e-17
C124	a_36_74##6	D#1	4.16238e-19
C125	VPWR#3	a_1587_74##4	2.38593e-18
C126	Q#6	a_1587_74#	1.50188e-18
C127	VPWR#4	a_1814_48##15	2.58043e-19
C128	VGND#3	a_1587_74#	1.7814e-18
C129	Q#3	a_1814_48##16	5.66435e-17
C130	VGND#6	VGND#2	2.53742e-19
C131	a_828_74##12	a_301_74#	6.35999e-17
C132	a_828_74##6	a_828_74##5	1.79782e-17
C133	a_301_74##6	a_36_74##2	4.86102e-19
C134	a_630_74##8	a_828_74#	4.46195e-18
C135	a_1814_48##22	a_1814_48##14	6.47762e-20
C136	a_828_74##6	a_1026_100#	2.51106e-17
C137	VPWR#4	a_1814_48##16	3.14426e-18
C138	VGND#4	a_1257_74##5	1.44709e-18
C139	VGND#3	a_1814_48##22	3.21451e-18
C140	a_1814_48##22	a_1814_48##2	1.86682e-18
C141	a_1814_48##3	a_1587_74#	3.04762e-18
C142	a_1814_48##16	VPWR#6	2.04549e-17
C143	VGND#6	a_1587_74#	3.96007e-17
C144	a_1587_74##7	a_1587_74##2	1.45894e-19
C145	VGND#17	a_36_74##2	5.38332e-19
C146	a_630_74##4	VPWR#11	7.79993e-20
C147	VGND#7	a_828_74##6	4.18379e-17
C148	a_828_74##6	a_1257_74##3	1.22835e-19
C149	a_301_74##3	a_630_74##4	6.72433e-20
C150	a_1587_74##8	a_1814_48##21	1.49902e-18
C151	VPWR#4	a_1587_74##4	1.02023e-17
C152	Q#3	a_1587_74##4	2.66654e-18
C153	VPWR#2	VPWR#1	9.28413e-19
C154	a_1587_74##7	a_1587_74##3	1.07081e-19
C155	VGND#1	VPWR#1	1.8017e-19
C156	a_36_74##6	SCE#1	1.00234e-17
C157	a_1814_48##21	a_1814_48##16	1.60354e-18
C158	CLK#1	a_630_74##8	3.51612e-18
C159	a_301_74##6	SCE#3	2.95957e-19
C160	VPWR#4	a_1587_74##5	1.16528e-17
C161	a_1814_48##4	a_1814_48##19	6.88504e-18
C162	VGND#2	a_1814_48##7	3.53696e-20
C163	a_1587_74#	a_1814_48##22	1.11586e-17
C164	a_828_74##13	a_828_74##12	2.59386e-18
C165	VPWR#12	CLK#2	1.84526e-19
C166	a_1587_74##4	VPWR#6	2.37257e-17
C167	Q#4	a_1814_48##5	1.72562e-17
C168	a_630_74##11	VPWR#8	1.68926e-17
C169	a_1587_74##8	VPWR#7	1.70975e-17
C170	VPWR#4	a_1814_48#	8.09187e-18
C171	SCE#3	VGND#17	4.96266e-17
C172	VPWR#7	a_1814_48##16	7.37574e-19
C173	VGND#6	a_1814_48##3	9.2552e-19
C174	a_1257_74##2	a_1026_100#	3.86301e-18
C175	a_630_74##13	SCD#2	5.73956e-19
C176	a_1814_48##19	a_1814_48##16	6.304e-19
C177	a_36_74##8	SCE#3	3.53439e-17
C178	a_630_74##9	a_1814_48##3	3.48776e-17
C179	a_1026_100##5	a_1026_100##7	2.48758e-18
C180	a_1587_74##7	a_1814_48##2	4.07548e-17
C181	a_1814_48##21	a_1587_74##4	4.70379e-17
C182	VPWR#4	a_828_74##7	1.57764e-17
C183	VGND#13	a_1587_74#	3.7028e-18
C184	SCD#3	CLK#1	1.21978e-17
C185	VGND#7	a_1026_100##2	3.56375e-20
C186	VPWR#8	a_1814_48#	5.11625e-19
C187	VGND#3	a_1587_74##2	1.21158e-20
C188	a_1814_48##8	a_1814_48##13	2.16084e-17
C189	a_1587_74##7	a_1814_48##4	3.58489e-17
C190	VPWR#6	a_1587_74##5	6.09381e-19
C191	a_1814_48##22	a_1814_48##3	2.27358e-18
C192	Q#1	VPWR#2	1.15472e-17
C193	VPWR#4	a_630_74##12	2.17194e-17
C194	VPWR#7	a_1257_74##7	6.41828e-20
C195	VGND#13	a_1814_48##2	8.08986e-18
C196	VPWR#7	a_1587_74##4	1.50114e-18
C197	a_1587_74##7	a_1814_48##19	2.42701e-18
C198	a_1814_48##8	a_1814_48##7	2.00284e-17
C199	a_301_74##2	a_630_74##4	1.17526e-17
C200	VGND#8	a_630_74##4	8.06706e-20
C201	VGND#2	a_1814_48##6	5.87174e-20
C202	a_301_74##3	VPWR#12	5.27595e-18
C203	VPWR#4	a_1026_100##3	9.33452e-18
C204	a_1814_48##21	a_1587_74##5	4.31007e-17
C205	Q#4	a_1814_48##10	1.94614e-17
C206	VPWR#3	VPWR#5	1.63469e-18
C207	a_1814_48##6	Q#1	9.94324e-20
C208	a_36_74##3	SCD#3	2.11772e-17
C209	VPWR#8	a_828_74##6	1.08996e-19
C210	a_828_74##3	a_1026_100#	1.16118e-19
C211	D#2	CLK#2	2.51028e-19
C212	VGND#13	a_1814_48##3	3.40052e-17
C213	a_1814_48##19	a_1587_74##4	3.40346e-18
C214	a_301_74##3	CLK#2	2.4476e-17
C215	VPWR#6	a_1814_48#	2.90719e-19
C216	SCE#2	D#2	7.00541e-19
C217	a_828_74##5	a_630_74##9	5.09057e-18
C218	a_36_74##4	a_301_74##4	5.4002e-17
C219	VGND#9	CLK#2	3.5117e-19
C220	a_828_74##3	a_1257_74##3	1.07613e-18
C221	a_1587_74##5	VPWR#7	1.66167e-17
C222	a_1587_74##9	a_1587_74#	1.80373e-19
C223	a_1814_48##22	a_630_74##9	1.33288e-19
C224	a_1587_74##3	a_1587_74##4	6.33132e-18
C225	a_301_74##6	a_301_74##4	3.11721e-18
C226	VGND#10	a_301_74##3	8.72274e-19
C227	VPWR#8	a_828_74##7	5.62814e-19
C228	a_828_74##8	a_1587_74##7	5.34937e-17
C229	VGND#7	a_828_74##5	4.81015e-18
C230	a_1814_48##19	a_1814_48##5	1.38884e-19
C231	a_1814_48##21	a_1814_48#	2.87332e-18
C232	Q#2	VPWR#1	3.49608e-17
C233	D#1	a_36_74##3	2.8832e-17
C234	a_301_74##2	a_630_74##3	9.77623e-19
C235	a_630_74##7	a_828_74##3	4.06745e-18
C236	VPWR#5	a_1814_48##7	3.8842e-19
C237	a_828_74##13	a_301_74#	5.11914e-17
C238	a_301_74##4	SCE#7	2.63891e-18
C239	a_36_74##9	a_36_74##4	9.07022e-21
C240	VGND#13	a_630_74##9	4.27781e-18
C241	Q#4	VGND#1	3.3863e-17
C242	VGND#8	a_630_74##3	2.65149e-20
C243	a_630_74##13	CLK#2	3.8255e-18
C244	a_1814_48#	a_1587_74##3	3.41192e-18
C245	Q#4	a_1814_48##12	6.23949e-20
C246	VPWR#7	a_1814_48#	3.10702e-17
C247	Q#3	VPWR#3	8.24818e-18
C248	a_301_74##2	a_1026_100##7	4.37579e-18
C249	VPWR#8	a_1026_100##2	8.31788e-19
C250	a_1587_74##8	a_1587_74##5	9.01471e-20
C251	a_1587_74##9	a_1814_48##3	2.43036e-18
C252	a_1814_48##19	a_1587_74##5	1.16785e-18
C253	a_1814_48##22	a_828_74##5	1.04068e-19
C254	a_1814_48##7	a_1814_48##6	3.56368e-18
C255	a_1587_74##2	a_1814_48##13	1.74395e-17
C256	a_1814_48##21	a_828_74##7	2.702e-19
C257	a_1026_100#	a_828_74##5	1.57283e-17
C258	SCE#1	D#1	5.101e-17
C259	a_828_74##11	a_1162_100#	2.02757e-18
C260	a_1587_74##7	a_1587_74##4	1.81659e-19
C261	a_828_74##2	a_630_74##6	3.55636e-20
C262	a_301_74##6	a_412_464#	9.51003e-19
C263	a_630_74##11	a_1587_74##7	5.19215e-18
C264	VPWR#6	a_630_74##12	7.98434e-20
C265	VPWR#8	a_630_74##12	2.59538e-18
C266	a_1814_48##19	a_1814_48##10	1.82721e-19
C267	Q#3	a_1814_48##13	6.68645e-19
C268	a_301_74##2	CLK#2	3.50323e-21
C269	VGND#7	a_630_74##2	9.52371e-20
C270	Q#2	Q#1	5.18066e-18
C271	VPWR#7	a_828_74##7	4.27516e-18
C272	VGND#7	a_1026_100#	4.8381e-18
C273	Q#3	VPWR#2	8.99117e-18
C274	VGND#13	a_828_74##5	7.26722e-19
C275	SCE#2	a_36_74##2	2.51631e-17
C276	a_630_74##5	a_630_74##7	2.20942e-19
C277	a_828_74##8	a_1814_48#	1.30779e-17
C278	a_1587_74##8	a_1814_48#	2.72248e-18
C279	a_1587_74##3	a_1587_74##2	6.88756e-18
C280	a_36_74##8	SCE#2	5.42586e-20
C281	a_1814_48##21	a_630_74##12	6.82866e-20
C282	a_1587_74##9	a_630_74##9	4.22915e-17
C283	a_630_74##5	a_630_74##6	1.33689e-17
C284	VPWR#3	a_630_74##12	2.4797e-19
C285	Q#4	Q#5	4.84794e-20
C286	SCE#5	SCE#1	2.33254e-17
C287	Q#4	a_1814_48##14	1.76314e-20
C288	VGND#8	CLK#2	3.46964e-19
C289	a_1814_48##2	a_1587_74##3	4.57311e-17
C290	VPWR#12	CLK#1	4.85708e-18
C291	a_630_74##5	CLK#3	2.38143e-19
C292	a_630_74##11	a_1814_48#	2.66106e-19
C293	VPWR#8	a_1257_74##2	9.03417e-20
C294	a_1814_48##19	a_1814_48#	4.28489e-20
C295	VGND#15	a_828_74##13	3.62656e-17
C296	a_630_74##12	a_828_74##8	2.52615e-18
C297	a_1257_74##3	a_1026_100#	5.08254e-18
C298	VPWR#7	a_630_74##12	2.66386e-18
C299	a_630_74##5	SCD#1	4.6768e-20
C300	a_1587_74##7	a_1587_74##5	2.54047e-18
C301	VGND#7	a_630_74##3	3.67486e-20
C302	a_1587_74##8	a_828_74##7	2.71393e-17
C303	a_1257_74##4	a_630_74##9	2.43898e-20
C304	VGND#13	a_1026_100#	1.55445e-19
C305	a_828_74##6	a_1587_74##7	6.6384e-19
C306	a_1814_48##19	a_1814_48##12	3.99384e-19
C307	VPWR#8	a_1026_100##3	1.86174e-17
C308	a_630_74##11	a_630_74##12	1.19114e-17
C309	Q#2	VPWR#5	2.58432e-17
C310	a_828_74##5	a_1587_74##9	1.11772e-17
C311	VGND#7	a_828_74##3	7.32858e-19
C312	VGND#7	a_1257_74##3	4.51749e-18
C313	VGND#4	VGND#1	5.95388e-17
C314	a_1026_100##3	a_630_74##11	1.32256e-18
C315	a_301_74##2	a_828_74##17	5.93851e-17
C316	VPWR#7	a_1026_100##3	7.33507e-19
C317	VGND#14	a_630_74##9	1.93575e-19
C318	Q#4	VGND#5	1.80369e-17
C319	a_630_74##15	a_828_74##13	2.43825e-18
C320	Q#4	a_1587_74#	9.21609e-20
C321	a_1587_74##8	a_630_74##12	4.22418e-17
C322	a_1814_48##21	VPWR#3	2.82023e-18
C323	SCE#3	SCE#2	1.96148e-18
C324	VGND#4	Q#5	1.35598e-17
C325	a_630_74##6	a_630_74##3	6.05999e-19
C326	a_630_74##11	a_1257_74#	1.43564e-19
C327	a_828_74##5	a_1257_74##4	1.80734e-17
C328	a_630_74##2	VPWR#8	5.26237e-17
C329	a_828_74##4	a_1257_74##3	1.1204e-17
C330	VPWR#10	a_1257_74#	5.41844e-19
C331	a_1587_74##7	a_1814_48#	1.83504e-17
C332	a_630_74##11	a_630_74#	3.5181e-20
C333	VGND#4	VGND#5	1.79469e-17
C334	a_630_74##12	a_1257_74##7	1.48907e-17
C335	a_1814_48##4	a_1814_48##2	1.84401e-17
C336	a_1814_48##19	a_1814_48##14	9.04413e-19
C337	CLK#2	a_630_74##6	4.18423e-18
C338	a_1257_74##5	a_828_74##8	3.6734e-18
C339	VPWR#8	a_1257_74#	1.6625e-17
C340	Q#3	Q#2	3.11364e-18
C341	a_1587_74##8	a_1026_100##3	1.89813e-18
C342	VGND#14	a_828_74##5	5.58546e-19
C343	VGND#4	Q#6	1.62088e-17
C344	a_630_74##15	VGND#15	4.2238e-17
C345	VPWR#13	VPWR#10	9.78064e-18
C346	a_301_74##2	VPWR#11	8.10219e-18
C347	VGND#7	a_828_74##4	3.06992e-18
C348	a_1257_74#	a_1026_100##2	1.39363e-18
C349	a_1257_74##4	a_1026_100#	2.25242e-17
C350	a_828_74##11	a_828_74##6	1.87344e-18
C351	VGND#4	VGND#6	2.32009e-17
C352	a_1257_74##7	a_1026_100##3	4.30479e-17
C353	a_301_74##3	a_630_74##13	6.43054e-17
C354	VPWR#7	VPWR#3	1.81866e-19
C355	a_630_74##2	a_630_74##12	2.62853e-19
C356	SCD	CLK#2	2.40645e-19
C357	SCE#7	SCD#1	1.92682e-17
C358	a_630_74##7	a_828_74##4	9.33217e-18
C359	VGND#4	a_1814_48##22	2.00764e-17
C360	a_1587_74##8	a_1257_74#	5.77043e-19
C361	VPWR#10	a_630_74#	6.03812e-19
C362	a_630_74##2	a_1026_100##3	3.74944e-17
C363	a_1026_100##3	VPWR#9	1.53439e-17
C364	VGND#8	a_630_74##7	3.12728e-18
C365	VGND#16	VGND#15	1.45106e-18
C366	a_1026_100#	VGND#14	1.13974e-17
C367	a_1257_74##5	a_630_74##11	1.55412e-17
C368	D#3	SCE#7	9.50707e-18
C369	VGND#4	VGND#13	1.82078e-17
C370	a_1814_48##19	a_1587_74#	1.14485e-17
C371	a_630_74##2	a_1257_74#	5.89398e-17
C372	VGND#8	a_630_74##5	7.97078e-19
C373	a_1257_74##7	a_1257_74#	2.3132e-18
C374	a_630_74##13	a_301_74##2	1.06425e-17
C375	VPWR#8	a_630_74#	7.40738e-18
C376	VPWR#4	a_1814_48##8	8.14078e-18
C377	a_1257_74##4	a_1257_74##3	2.05107e-19
C378	a_301_74##4	a_412_464#	7.73119e-18
C379	a_630_74##2	a_630_74#	5.01065e-18
C380	a_828_74##11	a_1026_100##2	1.4792e-18
C381	VGND#4	a_1814_48##8	8.72154e-18
C382	a_301_74##3	VPWR#14	1.32404e-17
C383	a_1814_48##19	Q#3	5.69425e-18
C384	a_828_74##8	a_1814_48##2	3.18441e-17
C385	a_1587_74##3	VPWR#4	3.76877e-18
C386	a_1257_74#	VPWR#9	1.00971e-17
C387	a_630_74##2	a_828_74#	8.0767e-20
C388	VGND#10	a_630_74##6	5.36719e-19
C389	VPWR#10	a_828_74##2	8.04625e-19
C390	Q#5	VGND#1	3.32474e-17
C391	a_1026_100##7	a_1026_100##3	1.20056e-18
C392	VGND#16	a_630_74##15	4.20273e-17
C393	VGND#4	a_1587_74##9	4.2194e-17
C394	a_630_74##6	a_630_74##7	5.10516e-18
C395	a_36_74#	D#2	3.10144e-18
C396	a_1257_74##3	VGND#14	1.75082e-17
C397	VGND#4	a_1587_74##3	4.20154e-18
C398	a_630_74##8	a_630_74##2	4.06578e-19
C399	VPWR#10	a_828_74#	6.00287e-18
C400	a_828_74##6	a_1257_74##5	4.42129e-17
C401	VGND#4	a_1257_74##4	1.08831e-17
C402	VGND#8	a_630_74##6	3.53463e-18
C403	a_828_74##2	a_630_74#	8.89021e-19
C404	a_1026_100##5	VPWR#10	5.20349e-19
C405	a_301_74##2	VPWR#14	6.85087e-20
C406	VGND#4	a_1814_48##4	6.24597e-18
C407	VPWR#4	a_828_74##8	4.5395e-18
C408	VPWR#8	a_828_74#	2.97258e-18
C409	VGND#4	VGND#14	7.64786e-18
C410	a_1026_100##7	a_1257_74#	2.74168e-18
C411	a_1814_48##8	VGND#5	2.72567e-18
C412	VGND#4	a_828_74##8	3.74414e-18
C413	a_301_74##5	a_1026_100##7	4.55251e-17
C414	a_828_74##11	a_1257_74##2	6.59034e-17
C415	VPWR#4	a_630_74##11	2.4004e-17
C416	VGND#5	VGND#1	2.30966e-18
C417	VGND#14	a_828_74##4	1.69568e-18
C418	a_630_74##8	a_828_74##2	1.24403e-17
C419	VGND#2	Q#4	2.80471e-19
C420	a_1814_48##19	VPWR#6	5.33416e-18
C421	a_301_74#	a_301_74##2	2.58761e-18
C422	SCE#3	a_36_74#	3.53063e-17
C423	VPWR#13	a_630_74##8	1.82436e-18
C424	a_1814_48##8	Q#6	5.82228e-17
C425	CLK#3	a_630_74##6	4.47652e-18
C426	VPWR#10	a_630_74##5	1.163e-18
C427	VGND#4	a_630_74##11	6.08313e-18
C428	VGND#10	CLK#3	5.29713e-18
C429	VPWR#4	a_828_74##6	3.9915e-18
C430	a_630_74##5	a_630_74##8	2.60231e-18
C431	a_1257_74##5	a_1026_100##2	5.66959e-17
C432	a_1026_100##7	a_630_74#	2.77583e-17
C433	VGND#6	a_1814_48##8	1.21787e-17
C434	a_1814_48##19	Q#6	2.77127e-18
C435	VGND#8	a_828_74##13	4.4247e-17
C436	VPWR#10	a_630_74##8	1.76022e-17
C437	VGND#4	a_828_74##6	4.55544e-17
C438	a_630_74##11	a_1814_48##2	1.00413e-18
C439	SCD#1	CLK#2	6.20316e-19
C440	VPWR#4	a_1026_100##2	4.42575e-18
C441	a_630_74##5	CLK#1	6.76493e-19
C442	VPWR#3	a_1814_48##13	2.10273e-20
C443	a_301_74##6	a_630_74##15	8.58942e-18
C444	a_828_74##12	a_630_74##2	6.24617e-20
C445	a_1026_100##5	a_1026_100##2	2.95146e-18
C446	a_1814_48##4	a_1587_74##3	3.81204e-17
C447	VGND#10	SCD#2	2.27975e-20
C448	VGND#5	Q#5	3.32325e-17
C449	VGND#4	a_1026_100##2	2.84862e-18
C450	a_301_74##3	VPWR#13	6.60214e-17
C451	VGND#10	VGND#15	1.09026e-19
C452	a_301_74##4	a_301_74##3	1.54856e-18
C453	VPWR#8	a_630_74##8	5.67997e-19
C454	a_828_74##11	a_630_74##2	1.98519e-18
C455	a_301_74##2	a_828_74##13	1.15588e-17
C456	a_1026_100##6	a_828_74##4	6.32303e-18
C457	a_1026_100##7	a_828_74#	2.5168e-17
C458	a_1814_48##19	a_1814_48##21	2.85581e-18
C459	CLK#5	a_630_74##13	1.27226e-17
C460	CLK	CLK#2	5.43237e-18
C461	VGND#4	a_1257_74##2	1.90214e-18
C462	SCD#1	CLK#3	3.09631e-17
C463	a_1814_48##2	a_1587_74##2	9.27914e-19
C464	a_301_74##5	a_828_74##17	1.11798e-17
C465	VPWR#4	a_630_74##2	8.39933e-18
C466	VPWR#13	CLK#1	1.40701e-17
C467	SCD#2	CLK#1	1.10686e-17
C468	VGND#10	SCD#1	5.78541e-18
C469	a_1257_74##5	a_1257_74##2	4.49522e-19
C470	a_301_74##6	VGND#16	4.2662e-17
C471	CLK#5	CLK#2	1.45044e-17
C472	a_828_74#	a_301_74##5	1.31891e-17
C473	a_301_74##3	a_301_74##2	1.35574e-18
C474	VGND#6	a_1814_48##19	8.54594e-18
C475	VPWR#10	CLK#1	6.26561e-18
C476	a_1026_100##5	a_1257_74##2	7.01321e-18
C477	Q#6	Q#5	3.36263e-18
C478	a_828_74##12	a_828_74##3	4.71287e-19
C479	a_1026_100##7	a_630_74##8	9.14739e-19
C480	a_301_74##3	VPWR#10	7.96934e-19
C481	a_1814_48##3	a_1766_74#	9.87534e-18
C482	a_630_74##11	a_828_74##8	4.64501e-17
C483	VPWR#8	VPWR#9	1.18968e-17
C484	a_630_74##7	a_1026_100##6	1.49019e-17
C485	VGND#13	a_1587_74##3	7.49628e-19
C486	a_36_74##4	SCD#3	6.93369e-18
C487	a_630_74##9	a_1766_74#	9.87534e-18
C488	a_828_74##11	a_828_74##3	6.27137e-19
C489	a_828_74##6	a_1814_48##2	2.23884e-20
C490	a_301_74##5	a_630_74##8	3.44757e-18
C491	a_630_74##15	a_301_74##3	1.95554e-18
C492	SCE#6	SCD#1	3.10761e-17
C493	VPWR#13	SCD#2	6.24696e-19
C494	a_1587_74##7	a_630_74##9	1.53828e-18
C495	a_36_74##4	D#1	2.18472e-17
C496	a_630_74##7	a_301_74#	2.54948e-17
C497	a_828_74##6	a_630_74##11	9.78324e-17
C498	a_828_74##8	a_1026_100##2	4.29638e-19
C499	VGND#3	a_1814_48##19	8.22284e-19
C500	a_1257_74##5	a_630_74##2	7.29973e-19
C501	VPWR#13	SCD#3	2.01967e-17
C502	a_1814_48##4	a_1814_48##22	8.14249e-18
C503	a_630_74##8	a_828_74##17	1.97082e-17
C504	Q#6	VGND#5	4.28518e-17
C505	a_1814_48#	a_1764_476#	1.06762e-17
C506	VGND#10	SCE#6	6.4875e-18
C507	a_1814_48##19	a_1814_48##22	1.97588e-18
C508	a_1026_100##2	a_630_74##11	1.73037e-17
C509	a_1026_100##5	a_630_74##2	8.42776e-17
C510	a_828_74##12	a_630_74##4	5.63793e-20
C511	a_1814_48##4	VGND#13	2.74045e-17
C512	a_828_74##7	a_1764_476#	1.06762e-17
C513	a_828_74##12	a_828_74##2	2.14142e-18
C514	a_301_74##6	a_452_74#	1.50561e-18
C515	VPWR#7	a_1814_48##2	5.69457e-19
C516	VGND#8	a_630_74##15	6.68844e-19
C517	a_630_74##8	VPWR#11	3.92626e-17
C518	a_828_74##13	a_630_74##7	1.93525e-18
C519	a_1026_100##2	a_828_74##6	9.71561e-18
C520	VPWR#16	SCE#2	3.16485e-18
C521	a_301_74##2	VPWR#10	6.94378e-17
C522	a_630_74##8	a_630_74##3	7.19446e-18
C523	VGND#10	SCE#7	4.93391e-19
C524	VGND#16	a_301_74##3	1.24769e-17
C525	VPWR#4	VPWR#1	6.583e-17
C526	D#3	SCE#6	8.39552e-18
C527	a_301_74#	a_630_74##6	1.94628e-18
C528	a_630_74##2	a_630_74##11	9.44637e-19
C529	a_1587_74##7	a_1814_48##21	1.10532e-17
C530	VGND#9	a_630_74##15	1.80502e-17
C531	a_630_74##13	a_630_74##8	1.25074e-18
C532	VPWR#2	a_1814_48##7	4.57114e-20
C533	VPWR#13	a_36_74##4	4.00659e-19
C534	a_828_74##3	a_1257_74##5	6.556e-19
C535	VGND#15	a_630_74##7	2.56092e-19
C536	a_1026_100##2	a_1257_74##2	1.25117e-16
C537	VGND#6	VGND#5	1.58715e-18
C538	a_1026_100##7	VPWR#10	3.53827e-18
C539	VPWR#4	Q#1	1.40898e-17
C540	VPWR#13	a_36_74##3	8.35324e-18
C541	a_36_74##2	SCE#1	1.25412e-17
C542	a_1257_74#	a_1214_506#	1.02087e-17
C543	a_1026_100##5	a_828_74##3	4.14781e-17
C544	a_1026_100##2	a_630_74##2	2.45571e-17
C545	a_828_74##13	a_630_74##6	1.88742e-17
C546	a_828_74##12	a_630_74##3	1.56957e-18
C547	VGND#10	D#3	3.04126e-19
C548	a_301_74##3	SCD	7.01205e-17
C549	a_630_74#	a_1214_506#	7.70034e-18
C550	a_630_74##13	CLK#1	4.0667e-17
C551	SCE#3	SCE#1	6.51726e-19
C552	a_630_74##15	a_630_74##7	7.09821e-20
C553	a_630_74##2	a_1257_74##2	2.76629e-17
C554	a_1257_74##3	a_1162_100#	4.06479e-18
C555	a_828_74##4	a_1162_100#	1.14172e-17
C556	a_1026_100##7	VPWR#8	2.40976e-17
C557	VPWR#4	Q#3	1.9085e-17
C558	a_36_74#	D#3	4.94799e-17
C559	a_1587_74##9	a_828_74##8	5.09832e-17
C560	a_828_74##3	a_1257_74##2	5.70449e-17
C561	VGND#15	a_630_74##6	3.72386e-17
C562	CLK#1	a_630_74##4	1.62136e-19
C563	CLK#1	VPWR#14	1.75809e-17
C564	VPWR#10	a_630_74##4	2.64014e-19
C565	VGND#6	Q#6	4.26767e-17
C566	a_1587_74##7	VPWR#7	3.26723e-18
C567	VPWR#3	VPWR#2	6.87985e-19
C568	a_828_74##3	a_630_74##2	2.1509e-17
C569	a_828_74##2	a_1257_74##2	2.14515e-19
C570	a_36_74##9	SCE#2	1.01815e-17
C571	a_828_74##13	CLK#3	3.06189e-19
C572	VPWR#2	a_1814_48##6	4.5102e-20
C573	VGND#17	a_301_74##6	1.27587e-17
C574	a_630_74##13	SCD#3	2.14961e-19
C575	VPWR#13	SCE#7	6.83318e-20
C576	a_301_74##5	VPWR#10	2.96381e-17
C577	a_1587_74##9	a_1587_74##8	3.55269e-19
C578	a_828_74##2	a_1026_100##5	8.45852e-17
C579	a_630_74##2	a_828_74##2	1.79238e-17
C580	a_630_74##15	a_630_74##6	1.78353e-18
C581	VPWR#13	D#1	3.4147e-19
C582	a_1814_48##21	VPWR#4	2.54049e-17
C583	SCD#3	a_412_464#	1.59617e-17
C584	VGND#4	Q#3	3.18638e-18
C585	SCD#3	VPWR#14	1.75762e-17
C586	a_828_74##2	a_828_74##3	3.94836e-19
C587	a_36_74##3	a_412_464#	1.59617e-17
C588	VGND#10	a_36_74#	1.19619e-19
C589	a_1587_74##9	a_630_74##11	7.66441e-18
C590	VGND#15	CLK#3	2.44459e-18
C591	a_301_74##4	CLK#1	5.11813e-19
C592	VPWR#13	CLK#2	2.37965e-19
C593	a_1026_100##6	a_630_74##3	1.1933e-19
C594	a_301_74##6	a_301_74##3	8.31256e-20
C595	SCE#4	a_36_74#	1.96567e-17
C596	a_1814_48##22	Q#6	4.6298e-19
C597	VGND#4	VPWR#6	2.81149e-18
C598	VGND#16	a_630_74##6	3.59256e-19
C599	a_828_74##6	VGND#13	2.73273e-18
C600	a_301_74##2	a_828_74##2	6.91923e-18
C601	a_36_74##6	D	5.30491e-17
C602	a_828_74##2	a_630_74##5	1.75171e-19
C603	a_301_74##3	CLK#5	3.47642e-17
C604	VPWR#10	a_630_74##3	3.26357e-19
C605	Q#4	a_1814_48##13	6.54879e-20
C606	D#1	a_238_464#	1.62684e-17
C607	a_630_74##15	CLK#3	4.95862e-17
C608	a_301_74##4	SCD#3	4.05127e-18
C609	SCE#1	a_238_464#	1.62684e-17
C610	a_828_74##11	a_630_74##9	1.18793e-19
C611	VGND#10	a_301_74##6	2.70068e-17
C612	a_1587_74##8	VPWR#4	3.20584e-17
C613	VPWR	a_630_74##3	2.41225e-19
C614	VGND#15	SCD#1	2.5852e-19
C615	a_301_74#	a_630_74##4	1.30271e-17
C616	VPWR	SCE#2	1.51767e-22
C617	a_828_74##6	a_1587_74##9	8.08441e-17
C618	VPWR#13	SCE#1	1.93825e-19
C619	a_301_74##6	SCD	2.30239e-17
C620	a_630_74##3	a_1257_74##2	1.55066e-18
C621	CLK#3	VGND#16	1.65537e-17
C622	a_1814_48##22	VGND#6	4.93267e-17
C623	a_630_74##5	SCD#2	5.20971e-19
C624	a_301_74##3	a_630_74##5	5.20667e-18
C625	VPWR#4	a_1257_74##7	7.11308e-18
C626	a_630_74##15	CLK#5	3.10852e-17
C627	a_828_74##6	a_1257_74##4	8.71816e-17
C628	a_1257_74##4	a_1257_74##7	1.24311e-18
C629	a_301_74##4	a_36_74##3	5.12831e-17
C630	a_301_74##6	a_630_74##6	7.48854e-20
C631	VGND#13	a_1587_74##7	3.26968e-18
C632	a_630_74##15	SCD#1	2.09824e-18
C633	a_630_74##5	a_301_74##2	6.55058e-17
C634	VPWR#16	SCD#3	3.52696e-19
C635	SCD#1	a_452_74#	7.44377e-18
C636	Q#4	a_1814_48##7	2.53925e-18
C637	a_301_74#	a_630_74##3	1.01087e-17
C638	SCE#6	a_452_74#	4.7729e-18
C639	a_828_74##11	a_828_74##5	4.34594e-19
C640	a_36_74##4	SCD#2	5.25331e-17
C641	a_1814_48##8	VPWR#5	2.73296e-18
C642	a_36_74##9	SCD#3	2.61636e-19
C643	a_36_74##8	VGND#17	3.91114e-17
C644	SCD#1	VGND#16	1.46129e-17
C645	a_301_74##4	D#1	3.74926e-17
C646	VPWR#10	VPWR#11	9.43441e-18
C647	VGND#13	VGND#6	1.74944e-18
C648	SCE#7	SCD#2	5.72919e-18
C649	VPWR#16	a_36_74##3	3.62832e-19
C650	a_1814_48##8	Q#3	5.21513e-17
C651	a_301_74##6	CLK#3	1.84456e-18
C652	Q#2	a_1814_48##13	8.42524e-20
C653	a_1587_74#	a_1814_48##13	3.76301e-18
C654	SCE#7	a_36_74##4	2.40971e-17
C655	D#2	SCD#2	2.15931e-18
C656	a_630_74##15	CLK	1.60821e-17
C657	VGND	a_630_74##4	3.91879e-19
C658	a_1814_48##8	VPWR#6	1.06489e-17
C659	a_36_74##9	a_36_74##3	2.69083e-19
C660	VGND	a_630_74##3	1.73107e-18
C661	a_36_74##4	D#2	1.09719e-16
C662	VGND	CLK#2	8.91624e-19
C663	a_630_74##2	a_1214_506#	4.31859e-18
C664	a_828_74##13	a_630_74##4	2.827e-18
C665	a_301_74##4	SCE#1	6.19781e-18
C666	D#2	SCE#7	5.78749e-18
C667	a_36_74##4	a_36_74##2	3.39804e-19
C668	VPWR#16	D#1	5.36184e-18
C669	VGND#16	SCE#6	8.72046e-19
C670	Q#4	a_1814_48##6	2.13214e-17
C671	D#3	a_223_74#	9.87534e-18
C672	a_828_74##11	a_1026_100#	1.867e-17
C673	VGND#13	a_1814_48##22	2.382e-17
C674	a_301_74##6	SCD#1	3.07277e-17
C675	a_36_74#	a_223_74#	9.87534e-18
C676	VPWR	VPWR#13	1.18819e-16
C677	VGND#10	VGND#8	1.06064e-18
C678	VPWR	VPWR#10	1.41415e-16
C679	VPWR	VPWR#8	6.50438e-17
C680	a_1814_48##11	a_1814_48##9	4.85536e-17
C681	a_36_74##2	D#2	4.28958e-17
C682	a_36_74##9	D#1	4.50118e-19
C683	a_1257_74##2	VGND#14	4.78784e-18
C684	SCD#2	a_301_74##3	1.87529e-17
C685	VGND#17	CLK#3	4.00776e-19
C686	a_828_74##12	a_828_74##11	3.09956e-18
C687	Q#2	a_1814_48##7	2.53363e-18
C688	VPWR#16	SCE#1	4.55694e-17
C689	a_301_74##6	SCE	1.18948e-16
C690	a_1587_74##8	a_630_74##9	1.01706e-18
C691	SCE#3	a_36_74##2	5.04725e-17
C692	a_1587_74##3	a_1814_48##21	1.04518e-17
C693	a_36_74##8	SCE	2.00486e-18
C694	VGND#16	D#3	4.12824e-19
C695	a_1587_74##9	a_1587_74##7	1.96518e-18
C696	CLK	a_630_74##13	1.08206e-17
C697	a_36_74##9	SCE#1	1.67211e-18
C698	VPWR#13	VPWR#14	5.01464e-18
C699	a_301_74##6	SCE#6	3.92135e-17
C700	a_36_74##4	a_412_464#	9.7907e-19
C701	a_1587_74##3	VPWR#7	1.18377e-17
C702	VPWR	a_1026_100##5	4.3394e-18
C703	VPWR	a_301_74##3	1.76161e-17
C704	VPWR	a_301_74##2	1.47507e-17
C705	a_828_74##11	a_1257_74##3	3.27634e-17
C706	VPWR#16	SCE#5	1.89692e-17
C707	VGND	VGND#10	9.24085e-17
C708	VGND#17	SCD#1	5.05916e-19
C709	VGND	VGND#8	9.51839e-17
C710	a_1814_48##15	a_1814_48##11	4.80806e-17
C711	VGND	VGND#7	7.91274e-17
C712	VPWR	CLK#5	2.28561e-18
C713	a_36_74##6	VPWR#16	3.83199e-17
C714	VGND#4	VGND#7	7.60357e-17
C715	Q#2	VPWR#2	2.5317e-19
C716	a_36_74##4	a_301_74##3	4.35459e-18
C717	VPWR	a_36_74##6	6.28256e-18
C718	CLK#5	SCD#2	2.40547e-19
C719	a_36_74##9	SCE#5	3.21632e-17
C720	a_630_74##3	a_828_74##3	3.2392e-18
C721	VGND#16	a_36_74#	2.12041e-19
C722	VGND#4	VGND#3	5.3865e-17
C723	a_828_74##3	a_1162_100#	7.91794e-19
C724	a_828_74##12	a_828_74##4	3.35361e-18
C725	Q#2	a_1814_48##6	1.12077e-17
C726	a_301_74##6	D#3	2.99085e-17
C727	a_1814_48##2	a_1587_74#	1.21144e-17
C728	VGND	a_828_74##12	3.10116e-17
C729	VPWR#16	a_301_74##4	2.31043e-17
C730	VGND	a_828_74##11	1.97297e-17
C731	a_1587_74##9	a_1814_48##22	1.33953e-18
C732	CLK	a_630_74##6	3.28789e-19
C733	VGND#4	VGND#2	6.32803e-17
C734	VPWR	a_301_74#	3.53872e-18
C735	a_1026_100##5	a_630_74##8	1.41591e-19
C736	VGND#17	SCE#6	1.15395e-18
C737	VGND	a_1026_100##5	3.41272e-18
C738	VGND	a_301_74##3	5.35769e-18
C739	VGND	a_301_74##2	2.21366e-18
C740	a_301_74##2	a_828_74#	8.29751e-19
C741	a_1814_48##16	a_1814_48##15	4.70431e-17
C742	VGND#8	a_828_74##12	3.58846e-17
C743	Q#1	VPWR#1	6.40413e-17
C744	a_828_74##11	a_828_74##4	1.6462e-17
C745	VGND	CLK#5	1.94178e-18
C746	SCD	CLK#1	6.95098e-19
C747	VGND	a_36_74##6	5.81369e-18
C748	SCD	SCD#3	3.25068e-18
C749	VPWR#4	VPWR#8	1.06538e-16
C750	a_36_74##8	SCE#6	3.39974e-20
C751	SCE	SCD#1	2.6007e-18
C752	a_1814_48##19	VPWR#3	2.1715e-20
C753	a_301_74##6	a_36_74#	2.09788e-18
C754	SCE	SCE#6	2.56485e-18
C755	SCD	SCE#1	4.87213e-19
C756	a_1814_48##6	Q#5	2.05466e-19
C757	a_36_74##6	SCE#2	3.61902e-17
C758	a_1026_100##6	a_828_74##3	2.28691e-17
C759	SCE	D#3	1.83173e-17
C760	SCE	a_36_74#	8.08318e-19
C761	SCE	SCE#4	4.07444e-19
C762	VPWR	a_1026_100##7	1.7719e-17
C763	VGND	VGND#14	8.64289e-18
C764	a_1814_48##19	a_1814_48##13	3.66849e-19
C765	VPWR	a_301_74##5	1.75903e-17
C766	a_1587_74##9	VGND#13	1.43372e-17
C767	a_828_74##12	a_630_74##7	3.95992e-17
C768	VPWR#4	VPWR#3	6.09699e-17
C769	a_301_74##3	a_630_74##8	3.98161e-19
C770	VGND#17	D#3	3.67802e-18
C771	VGND	a_1026_100##6	7.4702e-18
C772	VPWR	a_828_74##17	3.09079e-18
C773	VGND	a_301_74#	8.99307e-18
C774	a_1814_48##13	VNB	2.66427e-17
C775	a_1814_48##7	VNB	2.87105e-17
C776	VGND	a_828_74##13	2.35557e-17
C777	Q#2	a_1587_74##2	5.56759e-20
C778	a_1814_48##6	VNB	3.36405e-17
C779	VPWR	a_630_74##13	4.18e-18
C780	a_1587_74##2	VNB	2.3474e-17
C781	VGND	VGND#15	1.62436e-17
C782	a_1814_48##2	VNB	6.04926e-17
C783	VGND	a_630_74##15	1.98496e-17
C784	a_630_74##4	VNB	2.02097e-17
C785	a_630_74##3	VNB	5.25239e-17
C786	a_828_74##2	a_630_74##4	1.12499e-19
C787	CLK#2	VNB	5.61733e-17
C788	D	SCE#1	2.53771e-18
C789	SCE#2	VNB	5.789e-17
C790	VPWR	a_301_74##4	2.5226e-17
C791	VGND	a_301_74##6	3.5546e-17
C792	VPWR#5	VPWR#1	2.66815e-18
C793	VPWR	VPWR#16	2.22675e-17
C794	VGND	VGND#17	1.84879e-17
C795	VGND	a_36_74##8	2.11852e-17
C796	VPWR	a_36_74##9	2.40626e-17
C797	a_1587_74##8	a_828_74##8	3.24364e-17
C798	a_1587_74##4	a_1814_48##16	3.61743e-17
C799	a_630_74##4	a_630_74##3	2.57095e-18
C800	VPWR#4	VPWR#2	7.66051e-17
C801	a_301_74##2	a_630_74##8	3.8474e-17
C802	a_828_74##2	a_630_74##3	5.54651e-17
C803	a_36_74##8	D#3	9.2863e-20
C804	VGND#7	a_828_74##12	3.20416e-17
C805	a_828_74##11	a_630_74##7	5.16868e-19
C806	a_301_74##4	VPWR#13	1.92184e-17
C807	VGND#5	a_1814_48##7	5.31367e-19
C808	a_1257_74##5	a_1026_100#	1.45415e-17
C809	D#2	a_301_74##3	1.53538e-18
C810	VGND	a_630_74##13	3.66379e-18
C811	VGND#17	a_36_74#	3.01565e-17
C812	a_36_74##6	a_36_74##4	2.39431e-18
C813	Q#4	Q#2	3.51146e-18
C814	SCE	SCE#1	3.69642e-19
C815	VGND#10	VNB	4.06e-17
C816	VGND#8	VNB	5.43453e-17
C817	a_301_74#	a_828_74##2	4.1018e-17
C818	VGND#7	VNB	8.78889e-17
C819	VGND#3	VNB	2.68248e-17
C820	VGND#2	VNB	3.41559e-17
C821	VGND#4	a_1814_48##5	3.96467e-19
C822	VPWR#5	Q#1	5.85713e-17
C823	a_36_74##9	VPWR#16	6.23779e-17
C824	VPWR#13	VNB	4.70604e-17
C825	a_1587_74##8	a_630_74##11	6.69331e-17
C826	a_301_74##3	CLK#1	3.45629e-17
C827	VPWR#10	VNB	6.54251e-17
C828	VPWR#8	VNB	8.58323e-17
C829	VPWR#3	VNB	2.69334e-17
C830	VPWR#2	VNB	3.12496e-17
C831	a_828_74##12	a_630_74##6	3.90791e-19
C832	Q#4	VNB	3.24615e-17
C833	Q#2	VNB	2.4196e-17
C834	a_1814_48##19	a_1814_48##7	9.056e-20
C835	a_1814_48##19	VNB	2.98099e-18
C836	a_1587_74##7	VNB	6.89768e-18
C837	SCD	SCD#2	1.9733e-17
C838	VGND	a_1257_74##3	8.23519e-18
C839	VGND	a_828_74##4	1.42411e-20
C840	a_1587_74##5	a_1587_74##4	3.53384e-17
C841	a_828_74##12	VNB	1.00468e-17
C842	a_36_74##4	SCD	3.83202e-17
C843	a_828_74##11	VNB	1.03025e-17
C844	VGND	a_630_74##6	1.36741e-18
C845	a_36_74##8	a_36_74#	1.84186e-18
C846	VGND	CLK#3	2.24184e-18
C847	a_630_74##11	a_1257_74##7	9.88716e-17
C848	VGND#4	a_1814_48##10	6.14474e-19
C849	VGND	SCD#1	4.01205e-19
C850	a_1257_74##5	VNB	3.68182e-19
C851	Q#6	a_1814_48##13	2.81506e-18
C852	VPWR	a_1257_74#	8.76919e-18
C853	a_1026_100##5	VNB	1.15833e-17
C854	VGND	SCE#6	1.6167e-18
C855	VPWR#4	Q#2	7.45749e-18
C856	a_301_74##3	VNB	1.34474e-17
C857	VGND	D#3	1.26e-18
C858	VPWR	a_630_74#	9.63817e-18
C859	a_301_74##2	VNB	9.58229e-18
C860	VGND	a_36_74#	4.61021e-19
C861	a_301_74##2	CLK#1	2.04656e-18
C862	VPWR	a_828_74#	9.57207e-18
C863	VGND	SCE#4	1.61011e-18
C864	CLK#5	VNB	3.27007e-18
C865	VPWR	a_630_74##8	1.8121e-18
C866	VPWR	CLK#1	9.07931e-19
C867	a_36_74##6	VNB	4.53169e-17
C868	VPWR	SCD#3	4.99444e-19
C869	CLK	a_630_74##5	4.06941e-17
C870	VPWR	a_36_74##3	1.34058e-19
C871	VGND#1	VNB	4.78259e-17
C872	Q#5	VNB	5.10544e-18
C873	SCE#4	VGND#17	1.25756e-17
C874	VPWR	D#1	1.7808e-18
C875	D	D#2	6.4873e-18
C876	Q#6	VNB	5.77287e-18
C877	VGND#6	VNB	1.28669e-18
C878	VPWR	SCE#1	8.96479e-19
C879	a_1814_48##22	VNB	3.0646e-18
C880	VGND#13	VNB	4.73371e-18
C881	VGND#4	a_1814_48##12	6.61617e-19
C882	D	a_36_74##2	1.20412e-17
C883	VPWR	SCE#5	6.1051e-19
C884	a_1587_74##9	VNB	9.90008e-18
C885	VGND#14	VNB	4.33585e-18
C886	SCE#3	D	7.16597e-18
C887	a_1026_100##6	VNB	6.1376e-18
C888	a_1257_74##5	a_1257_74##3	6.35928e-20
C889	a_301_74#	VNB	1.57978e-17
C890	a_828_74##6	a_1587_74##8	1.99023e-18
C891	a_828_74##13	VNB	1.49218e-17
C892	VGND#7	a_828_74##11	4.09786e-17
C893	VGND#15	VNB	3.72946e-18
C894	a_630_74##15	VNB	9.37768e-18
C895	a_630_74##5	a_301_74#	1.11577e-17
C896	VGND#16	VNB	3.81493e-18
C897	VPWR	VPWR#12	2.67703e-17
C898	a_630_74##5	a_630_74##4	5.11891e-19
C899	a_301_74##6	VNB	6.16356e-18
C900	VGND#17	VNB	1.29935e-18
C901	SCE	SCD#2	7.12099e-19
C902	a_36_74##8	VNB	3.94598e-17
C903	VPWR#1	VNB	6.54436e-17
C904	Q#1	VNB	4.96098e-18
C905	CLK#2	a_630_74##15	1.06712e-17
C906	VPWR#5	VNB	4.10514e-19
C907	SCE	a_36_74##4	3.85002e-17
C908	Q#3	VNB	2.71051e-18
C909	a_1814_48##21	VNB	2.74595e-18
C910	SCE	SCE#7	2.35559e-17
C911	VPWR#7	VNB	5.33268e-18
C912	VGND#4	a_1814_48##14	7.93895e-19
C913	CLK#2	a_630_74##4	2.13337e-20
C914	a_1587_74##8	VNB	2.26966e-18
C915	a_1257_74##7	VNB	2.07746e-18
C916	SCE	D#2	4.42328e-17
C917	a_630_74##5	a_828_74##13	3.4221e-17
C918	a_828_74##6	a_1257_74##7	6.53198e-18
C919	a_1026_100##7	VNB	2.00863e-18
C920	a_301_74##3	SCD#3	2.51795e-17
C921	a_301_74##5	VNB	8.9792e-18
C922	a_630_74##5	a_630_74##3	2.62296e-18
C923	VPWR#4	a_1814_48##19	7.86486e-19
C924	a_828_74##17	VNB	2.82278e-18
C925	VPWR	a_1026_100##2	2.63532e-18
C926	a_36_74##8	SCE#4	2.61776e-17
C927	a_630_74##13	VNB	7.86475e-18
C928	SCE	SCE#3	3.72915e-20
C929	a_1587_74##2	a_1814_48##16	1.43528e-18
C930	a_1814_48#	a_1587_74##5	3.18395e-17
C931	a_301_74##4	VNB	3.28603e-18
C932	VPWR	a_630_74##2	1.64768e-17
C933	VGND	VGND#9	2.47091e-17
C934	VPWR#16	VNB	2.33403e-18
C935	a_36_74##9	VNB	4.06409e-17
C936	a_1814_48##5	VNB	2.94053e-17
C937	VGND#4	Q#4	8.52438e-18
C938	a_1814_48##10	VNB	2.32158e-17
C939	VPWR	a_828_74##2	5.72936e-18
C940	a_1814_48##12	VNB	2.46286e-17
C941	a_1814_48##14	VNB	2.87674e-17
C942	VPWR	a_630_74##5	4.50538e-18
C943	a_1587_74#	VNB	3.14538e-17
C944	a_1814_48##3	VNB	2.10927e-17
C945	Q#6	a_1814_48##7	1.07713e-19
C946	a_630_74##5	VGND#15	1.60011e-17
C947	a_630_74##9	VNB	4.43531e-17
C948	VGND#1	a_1814_48##5	2.71177e-17
C949	a_1814_48##19	a_1814_48##6	6.69495e-20
C950	a_828_74##5	VNB	2.6305e-17
C951	CLK#2	a_630_74##5	2.87697e-17
C952	a_1026_100#	VNB	4.38517e-17
C953	a_1257_74##3	VNB	2.9544e-17
C954	VGND#4	a_1587_74#	1.12265e-18
C955	a_828_74##4	VNB	2.33777e-17
C956	a_630_74##7	VNB	4.45131e-17
C957	VGND	a_1026_100##2	1.41441e-18
C958	VPWR	a_36_74##4	7.58473e-18
C959	a_630_74##9	a_1814_48##2	1.82905e-17
C960	a_630_74##6	VNB	4.11362e-17
C961	CLK#3	VNB	3.06035e-17
C962	VGND	a_1257_74##2	2.41828e-18
C963	SCD#1	VNB	3.75126e-17
C964	SCE#6	VNB	2.19329e-17
C965	VGND	a_630_74##2	2.58536e-20
C966	VPWR#4	a_630_74##9	7.35144e-20
C967	D#3	VNB	3.10587e-17
C968	VPWR	D#2	1.18846e-18
C969	a_36_74#	VNB	3.03366e-17
C970	VGND	a_828_74##3	3.05887e-20
C971	SCE#4	VNB	3.01685e-17
C972	a_301_74##2	SCD#3	6.91332e-19
C973	a_1814_48##9	VNB	4.00803e-17
C974	a_1814_48##11	VNB	2.95708e-17
C975	VGND	a_630_74##5	6.67539e-18
C976	a_1814_48##15	VNB	3.40889e-17
C977	a_1814_48##16	VNB	3.95639e-17
C978	Q#3	VPWR#5	6.42748e-17
C979	a_1587_74##4	VNB	3.44937e-17
C980	a_1587_74##5	VNB	3.28305e-17
C981	VGND#4	Q#2	2.23562e-18
C982	a_1814_48#	VNB	4.47032e-17
C983	a_828_74##7	VNB	3.67434e-17
C984	VGND	a_36_74##4	4.12514e-18
C985	VGND#3	a_1814_48##8	7.78033e-19
C986	a_630_74##12	VNB	3.95443e-17
C987	a_1026_100##3	VNB	3.42786e-17
C988	a_1257_74#	VNB	5.02987e-17
C989	a_630_74#	VNB	2.45433e-17
C990	VGND	D#2	1.31512e-18
C991	a_828_74#	VNB	2.54246e-17
C992	a_630_74##8	VNB	4.3131e-17
C993	VGND#4	a_1814_48##3	6.37972e-18
C994	CLK#1	VNB	4.53776e-17
C995	SCD#3	VNB	2.71334e-17
C996	VGND	SCE#3	6.67113e-18
C997	a_36_74##3	VNB	2.30373e-17
C998	D#1	VNB	2.88961e-17
C999	SCE#1	VNB	3.61297e-17
C1000	SCE#5	VNB	2.85333e-17
C1001	a_301_74#	a_828_74##17	2.17599e-17
C1002	D#2	a_36_74##6	2.95508e-18
C1003	a_1257_74##7	a_1026_100##2	1.84073e-17
C1004	VPWR#4	VNB	3.29469e-16
C1005	VGND#4	VNB	3.28085e-16
C1006	VPWR#12	VNB	1.43856e-17
C1007	VGND#9	VNB	1.44919e-17
C1008	a_1814_48##8	VNB	3.97218e-17
C1009	a_1587_74##3	VNB	3.1359e-17
C1010	a_1814_48##4	VNB	3.08927e-18
C1011	a_828_74##8	VNB	4.89377e-17
C1012	a_630_74##11	VNB	6.24757e-17
C1013	a_828_74##6	VNB	3.50027e-17
C1014	VGND#2	a_1814_48##8	8.47951e-20
C1015	a_1026_100##2	VNB	7.32469e-17
C1016	a_1814_48##5	Q#5	1.73595e-17
C1017	a_1257_74##2	VNB	6.87739e-17
C1018	a_630_74##2	VNB	7.25711e-17
C1019	a_828_74##3	VNB	3.04348e-17
C1020	a_828_74##2	VNB	4.502e-17
C1021	a_630_74##5	VNB	3.39255e-17
C1022	SCD#2	VNB	5.01244e-17
C1023	VGND#4	a_630_74##9	7.84111e-18
C1024	VGND#2	VGND#1	1.51905e-18
C1025	VPWR#16	VPWR#13	4.49761e-19
C1026	a_36_74##4	VNB	4.58389e-17
C1027	SCE	D	2.00606e-17
C1028	SCE#7	VNB	3.14048e-17
C1029	a_1026_100##2	VPWR#9	2.68727e-18
C1030	a_828_74##7	a_1814_48#	4.21957e-17
C1031	D#2	VNB	5.99854e-17
C1032	a_36_74##2	VNB	5.28897e-17
C1033	SCE#3	VNB	7.16461e-17
C1034	a_1587_74##7	VPWR#4	1.05486e-17
C1035	a_301_74##3	a_36_74##3	6.17375e-19
C1036	VPWR	SCD	4.12984e-18
C1037	VPWR	D	1.5135e-18
C1038	VGND	SCD	3.72963e-18
C1039	VPWR	CLK	1.62658e-18
C1040	VGND	D	1.47088e-18
C1041	a_1814_48##19	Q#4	1.39846e-18
C1042	VGND#4	a_1814_48##19	4.38963e-18
C1043	VGND#1	a_1814_48##10	2.10831e-18
C1044	VGND	CLK	1.51179e-18
C1045	a_301_74##6	a_630_74##5	3.91406e-19
C1046	VGND	SCE	1.27611e-17
C1047	VPWR#6	VPWR#5	2.58654e-19
C1048	SCD	VNB	2.40705e-18
C1049	D	VNB	9.45174e-19
C1050	VGND#4	a_828_74##5	1.17858e-18
C1051	CLK	VNB	2.19727e-18
C1052	SCE	VNB	1.30775e-17
C1053	VPWR	VNB	2.97972e-16
C1054	VGND	VNB	3.02246e-16
C1055	a_1814_48##19	a_1587_74##2	2.57561e-17
C1056	VGND#11	a_36_74#	6.45886e-18
C1057	a_301_74##4	VPWR#15	1.15022e-17
C1058	VGND#11	SCE#1	1.10162e-19
C1059	VPWR#15	D#2	1.81744e-19
C1060	VPWR#15	SCE#5	2.55179e-18
C1061	VGND#11	SCD#1	2.81721e-20
C1062	VPWR#15	VNB	6.62509e-17
C1063	a_36_74##6	VPWR#15	1.64754e-18
C1064	VPWR#15	SCE#1	4.05997e-18
C1065	VGND#11	D#2	6.28403e-20
C1066	a_36_74##4	VPWR#15	7.99057e-19
C1067	VPWR#15	VPWR#13	2.42816e-19
C1068	VPWR#15	D#1	7.55692e-18
C1069	VGND#11	D#3	8.02087e-18
C1070	VGND	VGND#11	1.2164e-16
C1071	VGND#11	CLK#3	1.92482e-20
C1072	VGND#11	a_36_74##8	2.43353e-17
C1073	VGND#11	SCE#3	1.4648e-18
C1074	VGND#11	SCE	2.66204e-18
C1075	VPWR	VPWR#15	1.17284e-16
C1076	VGND#11	SCE#4	6.55938e-18
C1077	a_36_74##9	VPWR#15	2.77916e-17
C1078	VGND#11	VNB	6.87447e-17
C1079	VGND#11	a_301_74##6	1.5053e-17
C1080	VGND#11	SCE#6	1.8272e-19
C1081	VPWR#15	SCE#2	4.51892e-19
*
*
.ENDS sky130_fd_sc_hs__sdfxtp_4
*
