* Extracted by Quantus, converted by sky130cad/quantus.py
*
*
*
*                       LINUX           Wed Nov 18 09:09:22 2026
*
*
*
*  PROGRAM  advgen
*
*  Name           : advgen - Quantus - (64-bit)
*  Version        : 25.1.0-p047
*  Build Date     : Thu Dec 11 23:20:30 PST 2025
*
*  HSPICE LIBRARY
*
*  OPERATING_TEMPERATURE 150
*  QRC_TECH_DIR <path>/tech
*
*
*

*
.SUBCKT sky130_fd_sc_hs__sdfrbp_2 VNB VPB VGND RESET_B VPWR Q_N Q D CLK SCE SCD
*
*
*  caps2d version: 10
*
*
*       TRANSISTOR CARDS
*
*
XM0 a_27_79##8 SCE#4 VGND#21 VNB sky130_fd_pr__nfet_01v8_lvt l=0.15 w=0.42 ad=0.1197 as=0.1155 pd=1.41 ps=1.39
XM5 a_223_79##2 a_27_79# a_310_79# VNB sky130_fd_pr__nfet_01v8_lvt l=0.15 w=0.42 ad=0.1197 as=0.1008 pd=1.41 ps=1.32
XM28 a_310_79# D#3 a_388_79##8 VNB sky130_fd_pr__nfet_01v8_lvt l=0.15 w=0.42 ad=0.1008 as=0.2709 pd=1.32 ps=2.13
XM7 a_388_79##8 SCE#6 a_547_79# VNB sky130_fd_pr__nfet_01v8_lvt l=0.15 w=0.42 ad=0.2709 as=0.1008 pd=2.13 ps=1.32
XM37 a_547_79# SCD#1 a_223_79# VNB sky130_fd_pr__nfet_01v8_lvt l=0.15 w=0.42 ad=0.1008 as=0.1638 pd=1.32 ps=1.62
XM9 a_223_79# RESET_B#3 VGND#20 VNB sky130_fd_pr__nfet_01v8_lvt l=0.15 w=0.42 ad=0.1638 as=0.1197 pd=1.62 ps=1.41
XM41 a_852_74##12 CLK#4 VGND#19 VNB sky130_fd_pr__nfet_01v8_lvt l=0.15 w=0.74 ad=0.2109 as=0.2072 pd=2.05 ps=2.04
XM39 VGND#19 a_852_74##6 a_1025_74##10 VNB sky130_fd_pr__nfet_01v8_lvt l=0.15 w=0.74 ad=0.2072 as=0.2109 pd=2.04 ps=2.05
XM11 a_388_79# a_852_74##8 a_1223_118##7 VNB sky130_fd_pr__nfet_01v8_lvt l=0.15 w=0.42 ad=0.1197 as=0.147 pd=1.41 ps=1.54
XM23 a_1223_118##7 a_1025_74# a_1323_118# VNB sky130_fd_pr__nfet_01v8_lvt l=0.15 w=0.42 ad=0.147 as=0.1008 pd=1.54 ps=1.32
XM3 a_1323_118# a_1370_289# a_1401_118# VNB sky130_fd_pr__nfet_01v8_lvt l=0.15 w=0.42 ad=0.1008 as=0.1008 pd=1.32 ps=1.32
XM18 a_1401_118# RESET_B#7 VGND#18 VNB sky130_fd_pr__nfet_01v8_lvt l=0.15 w=0.42 ad=0.1008 as=0.70155 pd=1.32 ps=3.61
XM27 VGND#18 a_1223_118##3 a_1370_289##7 VNB sky130_fd_pr__nfet_01v8_lvt l=0.15 w=0.64 ad=0.70155 as=0.1792 pd=3.61 ps=1.84
XM44 a_1370_289##7 a_1025_74##5 a_1790_74##17 VNB sky130_fd_pr__nfet_01v8_lvt l=0.15 w=0.64 ad=0.1792 as=0.433 pd=1.84 ps=3.08
XM25 a_1790_74##17 a_852_74# a_2000_74# VNB sky130_fd_pr__nfet_01v8_lvt l=0.15 w=0.42 ad=0.433 as=0.0882 pd=3.08 ps=1.26
XM19 a_2000_74# a_2006_373# VGND#17 VNB sky130_fd_pr__nfet_01v8_lvt l=0.15 w=0.42 ad=0.0882 as=0.1176 pd=1.26 ps=1.4
XM12 VGND#17 RESET_B#10 a_2158_74# VNB sky130_fd_pr__nfet_01v8_lvt l=0.15 w=0.42 ad=0.1176 as=0.0882 pd=1.4 ps=1.26
XM1 a_2158_74# a_1790_74##7 a_2006_373##4 VNB sky130_fd_pr__nfet_01v8_lvt l=0.15 w=0.42 ad=0.0882 as=0.1113 pd=1.26 ps=1.37
XM43 Q_N#2 a_1790_74##11 VGND#16 VNB sky130_fd_pr__nfet_01v8_lvt l=0.15 w=0.74 ad=0.2072 as=0.27675 pd=2.04 ps=2.42
XM13 VGND#15 a_1790_74##9 Q_N#2 VNB sky130_fd_pr__nfet_01v8_lvt l=0.15 w=0.74 ad=0.233 as=0.2072 pd=2.13 ps=2.04
XM15 VGND#15 a_1790_74# a_2604_392##11 VNB sky130_fd_pr__nfet_01v8_lvt l=0.15 w=0.64 ad=0.233 as=0.1696 pd=2.13 ps=1.81
XM2 VGND#14 a_2604_392##6 Q#3 VNB sky130_fd_pr__nfet_01v8_lvt l=0.15 w=0.74 ad=0.2183 as=0.2072 pd=2.07 ps=2.04
XM14 Q#3 a_2604_392# VGND#1 VNB sky130_fd_pr__nfet_01v8_lvt l=0.15 w=0.74 ad=0.2072 as=0.1998 pd=2.04 ps=2.02
XM34 a_27_79##9 SCE#5 VPWR#22 VPB sky130_fd_pr__pfet_01v8 l=0.15 w=0.64 ad=0.1888 as=0.5152 pd=1.87 ps=2.89
XM20 VPWR#22 SCE#1 a_307_464# VPB sky130_fd_pr__pfet_01v8 l=0.15 w=0.64 ad=0.5152 as=0.1728 pd=2.89 ps=1.82
XM4 a_307_464# D#1 a_388_79##6 VPB sky130_fd_pr__pfet_01v8 l=0.15 w=0.64 ad=0.1728 as=0.3744 pd=1.82 ps=2.45
XM6 a_388_79##6 a_27_79##3 a_538_464# VPB sky130_fd_pr__pfet_01v8 l=0.15 w=0.64 ad=0.3744 as=0.1728 pd=2.45 ps=1.82
XM16 a_538_464# SCD#3 VPWR#21 VPB sky130_fd_pr__pfet_01v8 l=0.15 w=0.64 ad=0.1728 as=0.2688 pd=1.82 ps=2.12
XM45 VPWR#21 RESET_B#4 a_388_79##7 VPB sky130_fd_pr__pfet_01v8 l=0.15 w=0.64 ad=0.2688 as=0.1888 pd=2.12 ps=1.87
XM26 a_852_74##10 CLK#1 VPWR#20 VPB sky130_fd_pr__pfet_01v8 l=0.15 w=1.12 ad=0.3304 as=0.336 pd=2.83 ps=2.84
XM31 VPWR#20 a_852_74##9 a_1025_74##13 VPB sky130_fd_pr__pfet_01v8 l=0.15 w=1.12 ad=0.336 as=0.308 pd=2.84 ps=2.79
XM22 a_388_79##2 a_1025_74##3 a_1223_118##9 VPB sky130_fd_pr__pfet_01v8 l=0.15 w=0.42 ad=0.1176 as=0.126 pd=1.4 ps=1.44
XM24 a_1223_118##9 a_852_74##7 a_1325_457# VPB sky130_fd_pr__pfet_01v8 l=0.15 w=0.42 ad=0.126 as=0.1008 pd=1.44 ps=1.32
XM32 a_1325_457# a_1370_289##3 VPWR#19 VPB sky130_fd_pr__pfet_01v8 l=0.15 w=0.42 ad=0.1008 as=0.255375 pd=1.32 ps=2.28
XM38 VPWR#19 RESET_B#5 a_1223_118##8 VPB sky130_fd_pr__pfet_01v8 l=0.15 w=0.42 ad=0.255375 as=0.1176 pd=2.28 ps=1.4
XM10 VPWR#18 a_1223_118# a_1370_289##4 VPB sky130_fd_pr__pfet_01v8 l=0.15 w=1 ad=0.275 as=0.3 pd=2.55 ps=2.6
XM35 a_1370_289##4 a_852_74##2 a_1790_74##16 VPB sky130_fd_pr__pfet_01v8 l=0.15 w=1 ad=0.3 as=0.4029 pd=2.6 ps=3.28
XM40 a_1790_74##16 a_1025_74##6 a_1955_471# VPB sky130_fd_pr__pfet_01v8 l=0.15 w=0.42 ad=0.4029 as=0.1134 pd=3.28 ps=1.38
XM33 a_1955_471# a_2006_373##3 VPWR#17 VPB sky130_fd_pr__pfet_01v8 l=0.15 w=0.42 ad=0.1134 as=0.416925 pd=1.38 ps=2.7
XM42 VPWR#17 RESET_B#8 a_2006_373##6 VPB sky130_fd_pr__pfet_01v8 l=0.15 w=0.42 ad=0.416925 as=0.126 pd=2.7 ps=1.44
XM21 a_2006_373##6 a_1790_74##13 VPWR#16 VPB sky130_fd_pr__pfet_01v8 l=0.15 w=0.42 ad=0.126 as=0.3542 pd=1.44 ps=3.01
XM17 Q_N#1 a_1790_74##12 VPWR#16 VPB sky130_fd_pr__pfet_01v8 l=0.15 w=1.12 ad=0.336 as=0.3542 pd=2.84 ps=3.01
XM36 VPWR#15 a_1790_74##10 Q_N#1 VPB sky130_fd_pr__pfet_01v8 l=0.15 w=1.12 ad=0.3868 as=0.336 pd=2.95 ps=2.84
XM29 VPWR#15 a_1790_74##8 a_2604_392##10 VPB sky130_fd_pr__pfet_01v8 l=0.15 w=1 ad=0.3868 as=0.275 pd=2.95 ps=2.55
XM30 Q#1 a_2604_392##7 VPWR#14 VPB sky130_fd_pr__pfet_01v8 l=0.15 w=1.12 ad=0.336 as=0.3304 pd=2.84 ps=2.83
XM8 VPWR#1 a_2604_392##5 Q#1 VPB sky130_fd_pr__pfet_01v8 l=0.15 w=1.12 ad=0.3192 as=0.336 pd=2.81 ps=2.84
*
*
*       RESISTOR AND CAP/DIODE CARDS
*
Rg1	SCE#1	SCE#2	366.473175
Rg2	SCE#2	SCE#3	96.769547
Rg3	SCE#3	SCE#4	886.246582
Rg4	SCE#3	SCE#5	272.043243
Rg5	a_27_79#	a_27_79##2	470.697266
Rg6	D#1	D#2	691.476562
Rg7	D#2	D#3	216.119781
Rg8	a_27_79##3	a_27_79##4	314.782288
Rg9	SCE#6	SCE#7	425.579407
Rg10	SCD#1	SCD#2	557.545593
Rg11	SCD#2	SCD#3	368.945282
Rg12	RESET_B#1	RESET_B#2	50.300888
Rg13	RESET_B#2	RESET_B#3	744.742188
Rg14	RESET_B#2	RESET_B#4	316.369873
Rg15	CLK#1	CLK#2	508.060303
Rg16	CLK#2	CLK#3	95.564819
Rg17	CLK#2	CLK#4	324.673096
Rg18	a_1025_74#	a_1025_74##2	607.261292
Rg19	a_1025_74##2	a_1025_74##3	357.474457
Rg20	a_1370_289#	a_1370_289##2	394.593201
Rg21	a_1370_289##2	a_1370_289##3	378.881500
Rg22	RESET_B#5	RESET_B#6	265.668549
Rg23	RESET_B#6	RESET_B#7	728.461426
Rg24	a_1223_118#	a_1223_118##2	400.207520
Rg25	a_1223_118##2	a_1223_118##3	350.977356
Rg26	a_1025_74##4	a_1025_74##5	658.234131
Rg27	a_1025_74##6	a_1025_74##7	232.643753
Rg28	a_852_74#	a_852_74##2	1386.696167
Rg29	a_852_74##2	a_852_74##3	1782.824463
Rg30	a_852_74##3	a_852_74##4	1455.979126
Rg31	a_852_74##4	a_852_74##5	142.731934
Rg32	a_852_74##5	a_852_74##6	365.550079
Rg33	a_852_74##3	a_852_74##7	296.970245
Rg34	a_852_74##4	a_852_74##8	466.138245
Rg35	a_852_74##5	a_852_74##9	438.009857
Rg36	a_2006_373#	a_2006_373##2	762.136536
Rg37	a_2006_373##2	a_2006_373##3	272.201965
Rg38	RESET_B#8	RESET_B#9	253.774399
Rg39	RESET_B#9	RESET_B#10	724.347534
Rg40	a_1790_74#	a_1790_74##2	369.132690
Rg41	a_1790_74##2	a_1790_74##3	89.954697
Rg42	a_1790_74##3	a_1790_74##4	36.576778
Rg43	a_1790_74##4	a_1790_74##5	45.815563
Rg44	a_1790_74##5	a_1790_74##6	68.845757
Rg45	a_1790_74##6	a_1790_74##7	363.421265
Rg46	a_1790_74##2	a_1790_74##8	509.225677
Rg47	a_1790_74##3	a_1790_74##9	348.686707
Rg48	a_1790_74##3	a_1790_74##10	500.303192
Rg49	a_1790_74##4	a_1790_74##11	353.264130
Rg50	a_1790_74##5	a_1790_74##12	480.756073
Rg51	a_1790_74##6	a_1790_74##13	495.165833
Rg52	a_2604_392#	a_2604_392##2	368.862610
Rg53	a_2604_392##2	a_2604_392##3	66.369736
Rg54	a_2604_392##3	a_2604_392##4	55.460026
Rg55	a_2604_392##2	a_2604_392##5	471.862823
Rg56	a_2604_392##3	a_2604_392##6	366.801178
Rg57	a_2604_392##3	a_2604_392##7	470.810913
Rf1	D	D#4	2.079311
Rf2	D#5	D#2	162.312119
Rf3	D#4	D#5	8.430248
Rf4	a_27_79##4	a_27_79##6	318.409546
Rf5	a_27_79##6	a_27_79##7	68.468300
Rf6	a_27_79##7	a_27_79##8	57.220123
Rf7	a_27_79##6	a_27_79##9	25.247570
Rf8	a_27_79##7	a_27_79##2	107.497353
Rf9	SCE#7	SCE	238.239258
Rf10	SCE	SCE#9	6.101927
Rf11	SCE#9	SCE	12.794363
Rf12	SCD	SCD#4	10.235490
Rf13	SCD#4	SCD	4.330400
Rf14	a_223_79#	a_223_79##2	191.048630
Rf15	RESET_B#1	RESET_B#12	161.093033
Rf16	RESET_B#13	RESET_B#14	0.860229
Rf17	RESET_B#12	RESET_B#13	5.117745
Rf18	CLK#3	CLK	163.775864
Rf19	a_852_74##10	a_852_74##11	60.405788
Rf20	a_852_74##11	a_852_74##12	77.136658
Rf21	a_852_74##11	a_852_74##5	170.283539
Rf22	a_388_79#	a_388_79##3	194.461182
Rf23	a_388_79##3	a_388_79##4	146.807083
Rf24	a_388_79##4	a_388_79##5	19.375956
Rf25	a_388_79##5	a_388_79##6	113.154434
Rf26	a_388_79##4	a_388_79##7	20.523441
Rf27	a_388_79##5	a_388_79##8	189.525955
Rf28	a_388_79##2	a_388_79##3	15.000000
Rf29	RESET_B#6	RESET_B#16	161.848785
Rf30	RESET_B#17	RESET_B#18	11.393765
Rf31	RESET_B#16	RESET_B#17	3.488554
Rf32	a_1223_118##2	a_1223_118##5	260.374329
Rf33	a_1223_118##5	a_1223_118##6	52.516293
Rf34	a_1223_118##6	a_1223_118##7	140.632446
Rf35	a_1223_118##5	a_1223_118##8	30.899517
Rf36	a_1223_118##6	a_1223_118##9	36.629208
Rf37	a_1370_289##4	a_1370_289##5	85.389351
Rf38	a_1370_289##5	a_1370_289##2	297.523651
Rf39	a_1370_289##5	a_1370_289##7	21.501669
Rf40	a_1025_74##7	a_1025_74##4	196.743134
Rf41	a_1025_74##4	a_1025_74##11	371.141449
Rf42	a_1025_74##11	a_1025_74##12	66.067673
Rf43	a_1025_74##12	a_1025_74##13	41.988831
Rf44	a_1025_74##12	a_1025_74##2	176.000412
Rf45	a_1025_74##10	a_1025_74##11	7.500000
Rf46	RESET_B#19	RESET_B	10.267756
Rf47	RESET_B#9	RESET_B#22	160.722778
Rf48	RESET_B#19	RESET_B#22	5.708254
Rf49	a_1790_74##6	a_1790_74##15	221.293030
Rf50	a_1790_74##15	a_1790_74##16	132.475189
Rf51	a_1790_74##15	a_1790_74##17	66.832886
Rf52	a_2006_373##4	a_2006_373##5	214.522339
Rf53	a_2006_373##5	a_2006_373##6	78.938873
Rf54	Q_N	Q_N#1	33.934944
Rf55	Q_N	Q_N#2	16.961475
Rf56	a_2604_392##4	a_2604_392##9	92.152763
Rf57	a_2604_392##9	a_2604_392##10	53.874325
Rf58	a_2604_392##9	a_2604_392##11	45.771454
Rf59	Q#2	Q	17.373037
Rf60	Q	Q#3	69.138580
Rf61	Q#1	Q#2	5.000000
Rf62	VGND#1	VGND#2	69.668083
Rf63	VGND#2	VGND#3	29.683495
Rf64	VGND#3	VGND#4	72.442772
Rf65	VGND#4	VGND#5	72.742805
Rf66	VGND#5	VGND#6	92.782410
Rf67	VGND#6	VGND#7	30.656675
Rf68	VGND#7	VGND#8	172.527069
Rf69	VGND#8	VGND#9	210.611359
Rf70	VGND#9	VGND#10	75.315521
Rf71	VGND#10	VGND#11	32.482937
Rf72	VGND#11	VGND#12	193.559280
Rf74	VGND#3	VGND#14	56.430489
Rf75	VGND#4	VGND#15	38.595146
Rf76	VGND#5	VGND#16	29.608692
Rf77	VGND#6	VGND#17	34.507496
Rf78	VGND#8	VGND#18	20.952089
Rf79	VGND#9	VGND#19	56.430489
Rf80	VGND#10	VGND#20	35.491676
Rf81	VGND#12	VGND#21	35.491676
Rf82	VPWR#1	VPWR#2	76.370377
Rf83	VPWR#2	VPWR#3	32.848190
Rf84	VPWR#3	VPWR#4	74.854057
Rf85	VPWR#4	VPWR#5	70.163124
Rf86	VPWR#5	VPWR#6	84.925140
Rf87	VPWR#6	VPWR#7	35.217987
Rf88	VPWR#7	VPWR#8	128.966934
Rf89	VPWR#8	VPWR#9	81.882187
Rf90	VPWR#9	VPWR#10	169.850677
Rf91	VPWR#10	VPWR#11	110.902649
Rf92	VPWR#11	VPWR#12	173.783173
Rf94	VPWR#3	VPWR#14	38.286041
Rf95	VPWR#4	VPWR#15	40.398312
Rf96	VPWR#5	VPWR#16	48.259808
Rf97	VPWR#6	VPWR#17	24.386293
Rf98	VPWR#8	VPWR#18	55.934216
Rf99	VPWR#9	VPWR#19	35.492405
Rf100	VPWR#10	VPWR#20	32.735970
Rf101	VPWR#11	VPWR#21	36.824379
Rf102	VPWR#12	VPWR#22	14.832878
Rf107	SCE#2	SCE#9	53.410934
Rf108	SCD#2	SCD#4	80.116402
Rf120	a_2006_373##2	a_2006_373##5	160.232803
Re2	RESET_B	RESET_B#18	4.743838
Re3	RESET_B#18	RESET_B#14	16.168276
Re4	VPWR#2	VPWR#24	4.826505
Re5	VPWR#24	VPWR	1.014099
Re6	VPWR	VPWR#11	2.265657
Re7	VGND#2	VGND#23	4.826505
Re8	VGND#23	VGND	1.014099
Re9	VGND	VGND#11	2.265657
Re14	VPWR#7	VPWR#24	0.698413
Re17	VGND#7	VGND#23	0.698413
*
*       CAPACITOR CARDS
*
*
C1	a_1223_118##9	a_852_74##4	5.7249e-19
C2	RESET_B#14	a_388_79#	3.60875e-18
C3	a_852_74##10	a_852_74##9	9.93219e-19
C4	SCE#6	SCD#1	4.0509e-17
C5	a_852_74##8	a_1025_74##2	1.82523e-17
C6	RESET_B#16	a_1370_289##2	2.67633e-19
C7	a_27_79##8	D#3	8.1933e-20
C8	a_2006_373##4	RESET_B#10	4.02228e-18
C9	a_1223_118##5	a_1025_74##2	2.14909e-19
C10	a_388_79##6	D#2	1.51199e-19
C11	a_1790_74##16	a_1955_471#	1.66969e-18
C12	a_1790_74##6	VGND#16	4.57073e-18
C13	a_388_79##2	RESET_B#4	3.03751e-19
C14	a_1223_118##7	a_1223_118##6	1.11598e-19
C15	VGND#8	a_1025_74#	2.63826e-18
C16	a_223_79#	a_388_79##8	8.6135e-17
C17	a_388_79##5	RESET_B#12	6.18253e-17
C18	RESET_B#9	a_1790_74##12	7.16528e-19
C19	VPWR#20	CLK#1	3.57583e-17
C20	RESET_B#14	a_1025_74##10	6.04739e-18
C21	VGND#21	a_27_79#	1.14501e-18
C22	SCE#5	SCE#1	3.90844e-18
C23	VGND#17	a_1790_74##7	4.00978e-18
C24	a_388_79##5	a_27_79##3	3.57164e-18
C25	a_2006_373##4	a_1790_74##6	1.24109e-16
C26	a_2006_373##6	VPWR#5	4.35123e-18
C27	VGND#2	VPWR#14	3.64261e-18
C28	RESET_B#9	a_1790_74##13	2.61109e-17
C29	RESET_B#14	VGND#19	5.57539e-18
C30	VPWR#9	a_1370_289##3	2.26069e-18
C31	a_223_79##2	SCE#4	2.39628e-18
C32	a_1223_118##9	a_852_74##3	3.54677e-18
C33	a_852_74##10	CLK#1	3.21023e-17
C34	a_2006_373##2	a_1790_74##12	3.32902e-19
C35	a_852_74##11	a_852_74##4	1.87218e-18
C36	RESET_B#6	a_852_74##3	1.50411e-18
C37	a_27_79##8	a_27_79#	8.61097e-19
C38	VGND#9	a_852_74##8	2.61765e-18
C39	RESET_B#14	a_852_74##12	8.07703e-19
C40	VPWR#20	RESET_B#4	3.17436e-18
C41	a_2006_373##4	a_2006_373#	5.1523e-19
C42	a_2006_373##2	a_1790_74##13	9.5431e-20
C43	a_2604_392##9	VPWR#3	2.71828e-19
C44	VPWR#6	VPWR#17	7.91886e-18
C45	D#3	SCE#6	4.4778e-18
C46	VGND#17	a_1790_74##6	1.69193e-18
C47	VPWR#11	VPWR#10	1.25226e-16
C48	VGND#8	VGND#18	8.70122e-18
C49	VGND#21	SCE#4	3.59563e-17
C50	Q#3	a_1790_74##2	5.85742e-19
C51	RESET_B#14	VGND#20	1.65515e-18
C52	VGND#17	RESET_B#10	2.74012e-17
C53	a_2006_373##2	RESET_B#8	2.16041e-19
C54	a_388_79#	a_1223_118##6	1.82873e-18
C55	VPWR#19	RESET_B#7	2.52915e-19
C56	a_2006_373##4	RESET_B#9	4.20673e-20
C57	VGND#11	a_1223_118##7	1.08699e-17
C58	RESET_B#14	a_852_74##9	2.16359e-18
C59	VPWR#11	VPWR#9	4.53946e-17
C60	a_1790_74##17	VGND#17	2.77009e-17
C61	VPWR#21	CLK#1	8.14072e-19
C62	VPWR#11	a_1025_74##3	4.08153e-18
C63	a_388_79##2	a_852_74##4	2.27393e-17
C64	a_1790_74##17	a_1790_74##7	3.70665e-20
C65	a_2006_373##2	a_2006_373##3	4.66669e-18
C66	VGND#11	a_852_74##7	4.09941e-19
C67	VGND#10	a_852_74##6	1.49747e-19
C68	a_27_79##8	SCE#4	1.85082e-17
C69	VPWR#20	SCD#3	2.47642e-19
C70	VGND#11	a_388_79#	1.09352e-17
C71	RESET_B#14	CLK#1	1.43598e-18
C72	RESET_B#4	a_388_79##7	2.15768e-17
C73	RESET_B#3	CLK#3	9.62132e-18
C74	VGND#11	a_1025_74##10	5.7094e-17
C75	VGND#6	VGND#5	2.63443e-19
C76	a_27_79#	D#3	3.08467e-17
C77	a_852_74##2	a_2006_373##2	2.96988e-19
C78	RESET_B#4	VPWR#21	2.13204e-17
C79	VGND#9	a_852_74##6	6.98122e-18
C80	VGND#17	a_2006_373#	2.40266e-17
C81	a_388_79##2	a_852_74##3	7.33261e-18
C82	a_1370_289##4	a_1790_74##16	4.04788e-17
C83	a_1370_289##5	a_1370_289##4	4.83368e-18
C84	a_2006_373##4	a_2006_373##2	3.61539e-20
C85	a_1223_118##5	a_1370_289##5	5.6867e-19
C86	a_1370_289##2	a_852_74##3	8.54483e-19
C87	VPWR#11	RESET_B#4	4.76e-18
C88	a_388_79##5	a_852_74##5	3.04224e-19
C89	a_1790_74##17	RESET_B#10	8.24904e-20
C90	a_1025_74##7	a_852_74##2	5.07548e-17
C91	VGND#11	a_852_74##12	1.34681e-17
C92	VPWR#11	SCD#3	1.25118e-18
C93	SCD#3	VPWR#21	2.48164e-17
C94	a_852_74##11	CLK#2	2.80473e-17
C95	a_1790_74##16	VPWR#8	2.81895e-18
C96	VGND#10	CLK#4	9.90867e-19
C97	VGND#17	a_2006_373##2	8.50976e-19
C98	SCD#2	RESET_B#3	2.961e-18
C99	a_388_79##6	RESET_B#4	8.78532e-19
C100	RESET_B#5	a_852_74##3	1.86953e-17
C101	a_1790_74##15	a_2006_373##4	2.60831e-18
C102	a_1790_74##17	a_852_74##2	3.11294e-19
C103	a_2604_392##6	a_2604_392#	4.02598e-17
C104	a_1025_74##4	a_852_74##2	4.99711e-17
C105	a_2604_392##9	a_2604_392##2	2.57528e-19
C106	VPWR#11	a_27_79##3	7.53914e-18
C107	VGND#17	a_852_74#	4.36635e-18
C108	SCE#4	a_27_79#	5.14311e-18
C109	a_1025_74##13	a_852_74##4	3.76263e-17
C110	VPWR#9	a_1025_74##3	2.00871e-18
C111	VGND#11	a_223_79#	1.35893e-16
C112	VPWR#6	VPWR#5	1.18075e-18
C113	a_1790_74##17	a_2006_373#	6.48177e-18
C114	VPWR#11	D#1	1.17977e-18
C115	VGND#9	CLK#4	4.87609e-18
C116	a_852_74##11	a_852_74##5	2.20892e-17
C117	a_1025_74##5	a_852_74##2	1.4173e-17
C118	a_1223_118##6	a_1223_118##5	1.30053e-17
C119	a_1223_118##2	a_852_74##2	1.33158e-17
C120	VPWR#21	a_27_79##3	2.78624e-18
C121	a_388_79#	a_852_74##4	1.18476e-17
C122	a_852_74##4	a_852_74##3	1.08733e-19
C123	a_388_79##5	CLK#3	1.57441e-17
C124	a_223_79##2	a_388_79##8	7.2946e-18
C125	a_1790_74##16	VPWR#6	1.30498e-17
C126	a_388_79##6	SCD#3	6.85542e-18
C127	SCE#7	SCD#1	7.94604e-18
C128	VPWR#11	SCE#1	1.41513e-18
C129	a_852_74##4	a_1025_74##2	3.41987e-17
C130	VPWR#18	a_1370_289##4	6.9089e-17
C131	VPWR#1	a_2604_392##5	3.11553e-17
C132	a_1223_118##5	a_1370_289##4	5.57182e-19
C133	a_1025_74##13	a_852_74##3	1.95338e-20
C134	VGND#11	a_388_79##8	2.09805e-17
C135	RESET_B#6	a_852_74##2	1.71488e-18
C136	a_852_74##11	RESET_B#2	4.09325e-19
C137	a_1025_74##2	a_852_74##3	8.94046e-19
C138	a_1025_74##10	a_1401_118#	2.73433e-19
C139	VGND#17	a_1025_74##5	4.55671e-19
C140	VPWR#11	SCE#5	6.5304e-19
C141	a_388_79##6	a_538_464#	4.74873e-18
C142	VGND#10	RESET_B#3	1.92147e-18
C143	VPWR#15	a_1790_74##2	3.00603e-18
C144	VPWR#10	a_852_74##9	3.97585e-18
C145	a_1370_289##4	VPWR#8	7.46124e-18
C146	VPWR#21	D#1	1.01034e-18
C147	RESET_B#6	a_1223_118#	1.50269e-17
C148	RESET_B#18	a_852_74##3	9.37666e-19
C149	a_2604_392##5	Q#1	2.43624e-17
C150	a_388_79##6	a_27_79##3	4.38766e-17
C151	a_1790_74##17	a_852_74#	4.46797e-17
C152	a_1790_74#	a_2604_392##6	4.43946e-18
C153	a_1790_74##17	a_1025_74##7	2.58047e-18
C154	a_388_79#	a_852_74##3	9.21235e-20
C155	CLK#3	a_852_74##11	1.18225e-17
C156	VGND#11	a_223_79##2	4.5017e-17
C157	VGND#5	VGND#4	3.92705e-19
C158	VPWR#10	a_852_74##4	1.58258e-19
C159	a_1370_289##3	a_852_74##3	1.54581e-17
C160	VPWR#9	a_852_74##9	1.87337e-20
C161	VPWR#1	a_2604_392##7	1.31804e-18
C162	RESET_B#18	VPWR#7	8.25856e-19
C163	a_388_79##5	RESET_B#1	9.20144e-18
C164	a_1790_74##17	a_1790_74##16	2.79433e-19
C165	a_1370_289##3	RESET_B#6	4.74775e-18
C166	a_1025_74##4	VGND#17	2.94703e-18
C167	VPWR#14	a_2604_392##5	3.32583e-18
C168	RESET_B#18	a_1790_74##16	1.21146e-17
C169	VPWR#21	SCE#1	5.03268e-19
C170	a_1223_118##5	VPWR#18	3.28265e-17
C171	a_1370_289##4	VPWR#6	1.84293e-18
C172	VGND#17	a_1223_118##3	1.3048e-20
C173	a_388_79##6	D#1	3.64629e-17
C174	D#2	SCE#6	4.85747e-18
C175	a_1025_74##13	a_1025_74#	1.06782e-19
C176	a_1025_74##10	a_852_74##4	1.36609e-17
C177	CLK#2	a_852_74##4	7.37376e-19
C178	a_2604_392##9	VPWR#14	3.34765e-17
C179	SCD	RESET_B#2	6.13643e-18
C180	VGND#11	a_27_79##8	1.65541e-17
C181	RESET_B#18	a_1370_289##4	4.31307e-17
C182	D#2	D#3	4.07019e-18
C183	a_1025_74##5	a_1790_74##17	2.91419e-18
C184	a_388_79##2	a_852_74##8	6.49156e-20
C185	VGND#11	VGND#10	7.03491e-17
C186	a_1025_74##4	a_1790_74##17	7.35709e-17
C187	a_852_74##5	a_852_74##4	1.47417e-17
C188	VGND#17	a_1790_74##15	2.38672e-17
C189	VPWR#2	a_2604_392##4	1.44258e-18
C190	VGND#7	a_1790_74##15	2.98683e-19
C191	a_27_79#	D#2	1.17618e-17
C192	VPWR#20	a_852_74##3	5.28466e-18
C193	VPWR#10	CLK#1	2.98221e-18
C194	CLK#3	RESET_B#12	9.55859e-18
C195	RESET_B#18	VPWR#18	6.96666e-17
C196	a_1223_118##7	a_1323_118#	3.01001e-18
C197	VGND#11	VGND#9	1.17938e-16
C198	a_1790_74##9	a_1790_74#	2.97814e-17
C199	VPWR#14	a_2604_392##7	7.89549e-17
C200	a_1790_74##16	VPWR#7	1.60018e-17
C201	a_1025_74##2	a_1370_289##3	3.1645e-19
C202	a_1025_74##4	a_1370_289##7	2.39546e-19
C203	VPWR#3	a_2604_392##4	4.5741e-19
C204	a_388_79##6	SCE#1	2.08037e-18
C205	RESET_B#18	VPWR#11	1.81412e-17
C206	a_1790_74##15	a_852_74##2	6.81398e-20
C207	VGND#2	a_2604_392##4	3.09113e-18
C208	a_388_79##5	SCD#2	1.17463e-17
C209	a_1025_74##5	a_1370_289##7	1.24533e-17
C210	CLK#2	a_852_74##5	2.92291e-17
C211	a_1025_74##2	a_852_74##7	4.2374e-18
C212	VPWR#10	a_852_74##3	1.6449e-17
C213	a_1025_74##4	VGND#18	1.01599e-17
C214	VGND#11	VGND#8	3.19982e-17
C215	VPWR#5	VPWR#4	1.17131e-18
C216	a_27_79##6	a_27_79##3	1.40901e-19
C217	VPWR#19	VPWR#18	5.13279e-18
C218	VGND#15	a_1790_74##2	4.88273e-18
C219	VPWR#6	a_1790_74##6	7.45453e-20
C220	a_1223_118##5	a_1223_118##8	7.40655e-19
C221	VGND#21	a_223_79##2	4.34978e-17
C222	a_2604_392##10	a_2604_392##7	1.79995e-18
C223	SCE#4	a_27_79##2	1.78621e-17
C224	a_852_74##3	a_852_74##7	7.11323e-19
C225	a_2604_392##7	a_2604_392##5	4.75983e-17
C226	VGND#8	a_852_74##7	1.93438e-20
C227	RESET_B#18	VPWR#19	3.83869e-18
C228	VPWR#5	a_1790_74##6	8.01347e-20
C229	a_388_79##6	SCE#5	6.05222e-19
C230	a_852_74##10	a_852_74##4	2.1212e-19
C231	VPWR#14	a_1790_74##8	3.8907e-18
C232	SCE#1	VPWR#22	2.03656e-17
C233	a_1223_118##6	VPWR#19	7.30219e-18
C234	a_1370_289##5	a_852_74#	4.7518e-19
C235	RESET_B#12	RESET_B#1	1.33809e-17
C236	VGND#9	a_1025_74##10	6.09025e-17
C237	VPWR#15	a_2604_392##7	1.28929e-18
C238	a_2604_392##4	Q#1	1.1473e-19
C239	VPWR#4	a_1790_74##6	5.54121e-20
C240	RESET_B#14	VPWR#11	5.42584e-17
C241	a_1223_118##3	a_1370_289##7	1.24533e-17
C242	RESET_B#18	a_1370_289##5	6.95321e-18
C243	SCE	SCE#3	1.20976e-17
C244	a_1790_74##11	a_1790_74##9	3.75699e-17
C245	SCE#7	a_388_79##5	3.43062e-18
C246	a_27_79##6	a_388_79##6	1.94065e-18
C247	a_2604_392##10	a_1790_74##8	2.43016e-17
C248	a_1025_74##10	CLK#2	6.6744e-19
C249	VPWR#14	a_2604_392##4	6.11996e-18
C250	RESET_B#18	a_1223_118##9	8.8186e-18
C251	a_27_79##6	D#1	7.77918e-19
C252	VGND#11	RESET_B#14	1.38411e-18
C253	VGND#10	VGND#19	8.85354e-20
C254	VGND#4	VGND#3	1.05565e-18
C255	CLK#1	a_852_74##5	2.47191e-18
C256	SCE#5	VPWR#22	2.18574e-17
C257	RESET_B#18	a_1223_118##6	3.96699e-17
C258	a_1223_118##5	VPWR#19	2.81529e-17
C259	a_1790_74##8	a_2604_392##7	7.16383e-18
C260	VPWR#14	a_1790_74##10	2.64886e-19
C261	VPWR#10	CLK#2	7.14778e-20
C262	RESET_B#18	a_388_79##2	3.81804e-17
C263	a_1025_74##10	a_1025_74##4	2.37764e-18
C264	VPWR#6	RESET_B#9	1.31238e-18
C265	a_1223_118##3	VGND#18	1.16095e-17
C266	a_852_74##4	a_1025_74##3	2.08111e-17
C267	a_1790_74##8	VPWR#15	2.86663e-17
C268	a_27_79##7	a_27_79#	4.01845e-19
C269	SCE#5	a_27_79##9	6.89143e-18
C270	VGND#8	a_1025_74##10	7.44147e-17
C271	VPWR#9	a_852_74##3	4.76841e-17
C272	RESET_B#18	a_1223_118##5	4.94443e-17
C273	a_1790_74##7	a_2158_74#	8.8457e-18
C274	a_1370_289##5	a_1025_74##5	2.16164e-17
C275	Q#3	VGND#1	7.37014e-17
C276	RESET_B#2	CLK#3	1.58853e-17
C277	a_2604_392##10	a_1790_74##10	1.66063e-18
C278	a_27_79##8	VGND#21	3.99411e-17
C279	RESET_B#18	a_1025_74##7	1.37171e-17
C280	RESET_B#10	a_2158_74#	8.8457e-18
C281	a_852_74##10	CLK#2	1.64807e-18
C282	a_852_74##3	a_1025_74##3	1.84695e-17
C283	RESET_B#1	CLK#1	9.72166e-18
C284	Q_N#1	a_1790_74##8	1.3736e-18
C285	a_27_79##4	a_388_79##5	3.14144e-17
C286	a_27_79##6	SCE#1	1.09661e-17
C287	a_2604_392##9	a_1790_74##2	1.91018e-17
C288	VGND#7	a_2006_373##2	7.30605e-20
C289	VPWR#7	a_1025_74##7	5.8264e-19
C290	SCE#4	SCE#3	8.72778e-19
C291	RESET_B#18	a_1025_74##4	1.09366e-17
C292	a_1790_74##7	a_1790_74##11	3.53194e-18
C293	VPWR#19	VPWR#8	1.12012e-18
C294	a_1790_74##10	VPWR#15	3.39378e-17
C295	a_1790_74##10	a_1790_74##8	4.02766e-17
C296	VGND#10	a_852_74##12	6.96096e-18
C297	RESET_B#7	VGND#18	1.6471e-17
C298	VPWR#15	a_1790_74##6	1.64641e-18
C299	CLK	RESET_B#2	5.04673e-19
C300	VPWR#16	a_1790_74##8	1.713e-19
C301	VGND#3	a_2604_392##4	4.65916e-19
C302	a_1223_118##2	RESET_B#18	2.99418e-17
C303	a_27_79##7	SCE#4	2.31904e-17
C304	a_2604_392##10	a_1790_74##12	1.65437e-19
C305	VPWR#4	VPWR#3	8.62531e-19
C306	a_1370_289##2	VGND#18	3.17307e-19
C307	Q_N#1	a_1790_74##6	9.53956e-21
C308	VGND#7	a_1025_74##4	3.0832e-17
C309	a_2006_373##2	VPWR#6	4.32442e-17
C310	VGND#14	VGND#1	2.19302e-18
C311	a_1790_74##10	Q_N#1	1.76293e-17
C312	VGND#6	a_1790_74##6	2.37313e-18
C313	a_1370_289##5	a_1223_118##3	2.652e-17
C314	RESET_B#18	RESET_B#6	8.71518e-18
C315	RESET_B#14	a_852_74##4	5.5738e-19
C316	a_1223_118##7	a_852_74##7	6.96387e-20
C317	RESET_B#18	RESET_B#16	1.03212e-17
C318	a_27_79##6	VPWR#22	3.25498e-18
C319	VPWR#16	a_1790_74##6	6.99931e-18
C320	a_2006_373##2	VPWR#5	5.91815e-20
C321	a_27_79##6	SCE#5	3.78855e-17
C322	VPWR#15	a_1790_74##12	2.32675e-18
C323	a_852_74##9	a_852_74##4	3.1427e-17
C324	a_1223_118##6	a_852_74##4	1.01082e-19
C325	VGND#5	a_1790_74##6	9.32591e-19
C326	a_388_79##5	D#2	1.57503e-19
C327	VPWR#8	a_852_74##3	5.11879e-18
C328	a_1223_118##7	a_1223_118##3	2.77994e-19
C329	RESET_B#18	a_1370_289##2	2.43396e-17
C330	VGND#9	a_852_74##12	1.08839e-17
C331	a_2006_373#	a_2000_74#	6.66487e-19
C332	a_1790_74##6	RESET_B#9	4.95919e-17
C333	a_1223_118##5	RESET_B#16	4.24116e-17
C334	VPWR#16	a_1790_74##10	6.37707e-19
C335	a_1790_74##12	a_1790_74##10	4.85115e-17
C336	D#1	SCD#2	3.16195e-19
C337	a_2006_373##6	a_1790_74##6	5.47647e-19
C338	a_852_74#	a_2000_74#	6.4614e-18
C339	a_27_79##4	RESET_B#4	3.36423e-19
C340	a_2604_392##9	a_2604_392##4	3.22722e-17
C341	RESET_B#10	a_1790_74##7	4.41327e-17
C342	VGND#4	a_1790_74##6	8.06846e-20
C343	a_852_74##9	a_852_74##3	1.99567e-17
C344	a_1223_118##7	a_1370_289##2	6.56479e-17
C345	RESET_B#14	a_388_79##2	3.03814e-17
C346	a_2006_373##2	a_1790_74##6	7.62482e-17
C347	a_2006_373##3	a_1955_471#	8.26092e-18
C348	Q_N#1	a_1790_74##12	5.18777e-17
C349	RESET_B#18	a_1025_74##2	1.1141e-17
C350	a_27_79##4	SCD#3	8.91292e-18
C351	VGND#14	Q#3	5.42542e-17
C352	a_1025_74##6	a_1955_471#	8.06292e-18
C353	a_1025_74##10	a_852_74##7	8.80175e-20
C354	a_388_79#	a_1370_289##2	6.80374e-19
C355	RESET_B#9	VPWR#16	3.07583e-17
C356	a_2006_373##2	RESET_B#9	1.2305e-16
C357	a_223_79#	a_547_79#	1.3373e-18
C358	RESET_B#14	a_1025_74##13	4.36718e-17
C359	a_27_79##4	a_27_79##3	7.38847e-18
C360	VGND#2	a_2604_392#	1.15497e-17
C361	VPWR#11	a_1223_118##9	1.07456e-17
C362	a_388_79##2	a_1223_118##6	4.8866e-17
C363	a_1370_289##5	RESET_B#7	7.4657e-18
C364	a_852_74##12	a_388_79##5	7.72396e-19
C365	a_27_79##6	a_27_79##9	3.39818e-18
C366	a_1025_74##10	a_1370_289##2	4.17884e-17
C367	a_1790_74##12	VPWR#16	2.42282e-17
C368	RESET_B#2	CLK#2	6.69182e-19
C369	a_27_79##4	D#1	4.72318e-17
C370	a_1223_118##7	RESET_B#7	1.18219e-18
C371	VGND#6	RESET_B#9	2.21003e-19
C372	RESET_B#9	a_2006_373##6	4.60314e-17
C373	RESET_B#14	VPWR#20	2.04779e-18
C374	a_1223_118##9	VPWR#9	8.26445e-18
C375	a_852_74##12	CLK#2	5.33365e-19
C376	a_1223_118##6	a_852_74##3	2.88899e-18
C377	VPWR#11	a_388_79##2	2.18316e-17
C378	VGND#2	a_2604_392##6	1.04844e-17
C379	a_1790_74##13	a_1790_74##12	2.85568e-17
C380	a_388_79##5	a_27_79##2	9.82849e-20
C381	a_27_79##4	SCE#1	1.28077e-17
C382	RESET_B#14	a_1025_74##2	5.08786e-18
C383	Q_N#1	a_1790_74##13	1.4032e-18
C384	VPWR#21	a_852_74##3	3.80619e-21
C385	a_1025_74##10	a_1223_118##3	1.17502e-18
C386	a_1790_74##2	a_2604_392##7	8.12784e-19
C387	a_1025_74##7	a_2006_373##2	2.52701e-17
C388	a_1223_118##7	a_1025_74##2	2.51457e-18
C389	VPWR#19	a_1025_74##13	3.29465e-20
C390	RESET_B#14	a_852_74##10	5.68088e-17
C391	a_2006_373##6	a_1790_74##12	7.18666e-19
C392	VPWR#11	a_1025_74##13	3.8148e-18
C393	VPWR#11	a_1025_74##2	2.76774e-19
C394	a_2006_373##2	VPWR#16	1.53364e-18
C395	RESET_B#14	a_852_74##5	1.37577e-19
C396	a_388_79#	a_1025_74##2	5.18415e-17
C397	a_2604_392##9	a_1790_74##6	3.40539e-19
C398	a_2006_373#	RESET_B#10	4.20809e-17
C399	a_2604_392##11	Q#3	1.78358e-19
C400	a_1370_289##5	a_852_74##2	7.30266e-18
C401	VGND#3	a_2604_392#	5.85999e-19
C402	a_388_79##2	VPWR#10	1.22763e-17
C403	VPWR#11	a_852_74##3	3.047e-18
C404	a_1790_74##13	VPWR#16	2.10429e-17
C405	VGND#11	a_1025_74##2	1.96519e-18
C406	VPWR#11	VPWR#20	1.57817e-18
C407	a_223_79#	VGND#10	2.24817e-18
C408	a_1025_74##10	a_1025_74##2	7.30603e-19
C409	a_1370_289##3	a_1325_457#	3.25425e-18
C410	CLK#3	RESET_B#14	2.70403e-17
C411	SCD#2	RESET_B#2	4.69498e-17
C412	RESET_B#7	a_1401_118#	7.05199e-18
C413	a_1223_118##7	a_1370_289#	9.35464e-18
C414	VGND#1	VPWR#1	1.1827e-17
C415	a_852_74##7	a_1325_457#	6.96023e-18
C416	a_1370_289#	a_1401_118#	6.69093e-18
C417	VGND#20	a_388_79##5	2.07494e-18
C418	a_27_79##6	a_27_79##4	2.54618e-19
C419	a_1370_289##5	a_1370_289#	1.77406e-19
C420	VGND#11	a_852_74##5	9.96701e-19
C421	a_1223_118##5	RESET_B#7	1.28101e-19
C422	a_388_79##2	a_1223_118##9	6.5732e-17
C423	a_2006_373##2	VPWR#17	2.57482e-18
C424	RESET_B#8	a_1790_74##13	2.14405e-17
C425	SCD	a_388_79##5	8.99023e-17
C426	VPWR#11	a_852_74##10	2.57129e-18
C427	VPWR#11	CLK#3	1.14223e-18
C428	SCE#2	D#1	2.23567e-17
C429	VGND#11	a_1025_74##13	2.52586e-18
C430	Q	a_2604_392##2	8.87478e-18
C431	a_1025_74##10	RESET_B#7	2.1453e-17
C432	a_2006_373##6	a_1790_74##13	3.00206e-17
C433	RESET_B#14	RESET_B#1	6.69171e-18
C434	a_1025_74##10	a_852_74##11	2.29353e-17
C435	a_2006_373##4	VPWR#5	2.99212e-19
C436	VGND#4	a_2604_392##6	2.68162e-19
C437	Q	a_1790_74##2	3.77034e-19
C438	VPWR#11	RESET_B#2	8.6421e-19
C439	VGND#11	CLK#3	2.2515e-18
C440	a_388_79##2	VPWR#9	5.8926e-19
C441	a_1025_74##4	a_1223_118##2	1.2402e-18
C442	VPWR#11	RESET_B#1	1.35959e-18
C443	a_388_79#	a_1370_289#	4.77656e-19
C444	a_1790_74##15	a_1790_74##6	1.27204e-19
C445	VPWR#16	RESET_B#8	7.31711e-19
C446	VGND#10	CLK	2.32223e-18
C447	a_1025_74##10	VGND#18	2.19107e-19
C448	a_1223_118##5	a_852_74##2	3.30699e-19
C449	a_2604_392##11	VGND#14	3.95767e-17
C450	a_1790_74##16	a_2006_373##2	5.06814e-17
C451	VPWR#11	SCE#3	8.99368e-19
C452	a_1025_74##10	a_852_74##5	4.79971e-18
C453	VPWR#11	a_1223_118##6	5.35829e-18
C454	a_1025_74##4	RESET_B#6	3.24947e-19
C455	a_1223_118##5	a_852_74##3	8.1512e-18
C456	VPWR#11	VPWR#21	1.61681e-17
C457	a_852_74#	a_2006_373#	6.75121e-17
C458	a_1223_118##7	a_1025_74#	3.71428e-17
C459	VGND#11	a_852_74##10	2.72893e-18
C460	a_223_79##2	a_310_79#	1.4224e-18
C461	VPWR#14	VPWR#1	1.7285e-18
C462	RESET_B#2	CLK#1	1.95658e-18
C463	a_27_79##7	D#2	1.07635e-18
C464	VGND#3	a_2604_392##6	6.56821e-18
C465	a_1370_289##4	a_2006_373##2	1.79739e-19
C466	a_2006_373##6	RESET_B#8	3.70517e-17
C467	a_1223_118##2	RESET_B#6	2.9055e-17
C468	a_1025_74##4	a_1370_289##2	1.14023e-17
C469	VGND#11	SCD#2	2.98889e-20
C470	VGND#11	a_852_74##4	8.39809e-19
C471	VGND#3	a_2604_392##9	1.10031e-18
C472	a_2006_373##3	RESET_B#8	3.9443e-18
C473	a_1025_74##10	a_1370_289#	1.45357e-17
C474	a_2604_392##4	a_2604_392##2	3.5398e-18
C475	VPWR#11	SCE#7	6.37339e-18
C476	VGND#6	a_1790_74##15	1.00848e-19
C477	a_1370_289#	a_1323_118#	1.5814e-18
C478	a_1370_289##5	a_1025_74#	9.58682e-20
C479	RESET_B#14	a_27_79##4	2.40243e-18
C480	a_1370_289##2	a_1223_118##2	5.8724e-17
C481	VPWR#16	a_2006_373##3	2.69227e-19
C482	a_1025_74#	a_1323_118#	6.95343e-18
C483	a_1223_118##2	VPWR#8	1.02863e-18
C484	VGND#11	SCE#7	5.67377e-18
C485	VGND#19	a_852_74##11	1.89186e-17
C486	SCD#3	a_538_464#	6.25055e-18
C487	a_388_79#	a_1025_74#	1.03565e-17
C488	a_388_79##6	VPWR#11	5.77652e-17
C489	VPWR#11	a_27_79##4	1.85637e-17
C490	a_1025_74##7	a_1790_74##16	6.42961e-17
C491	RESET_B#8	VPWR#17	1.09637e-17
C492	SCE#7	RESET_B#2	3.03188e-19
C493	a_388_79##2	a_1025_74##13	5.90836e-17
C494	a_27_79##3	a_538_464#	7.11744e-18
C495	a_1370_289##2	RESET_B#6	1.81042e-17
C496	RESET_B#14	a_388_79##5	3.44902e-17
C497	VGND#4	a_1790_74#	8.13706e-18
C498	VGND#15	VGND#14	1.78884e-18
C499	VGND#20	RESET_B#2	2.18069e-19
C500	VGND#11	a_27_79##4	3.16068e-18
C501	VGND#11	CLK#2	6.4893e-19
C502	a_2604_392##9	a_2604_392#	2.61365e-19
C503	a_1223_118##5	a_1223_118#	3.55625e-18
C504	a_852_74##8	a_1223_118##7	1.1818e-17
C505	a_1790_74##15	RESET_B#9	2.09641e-18
C506	a_1370_289##4	a_1025_74##7	2.33811e-17
C507	a_2006_373##6	a_2006_373##3	6.7541e-19
C508	a_27_79##7	a_27_79##2	6.32149e-19
C509	VPWR#3	a_2604_392##7	2.89356e-18
C510	a_1025_74##10	a_1025_74#	4.19554e-18
C511	VGND#11	D#2	4.91086e-18
C512	a_1025_74##6	a_2006_373##3	2.5726e-17
C513	Q_N	a_1790_74##2	1.25292e-18
C514	a_1025_74##5	a_852_74#	3.04997e-18
C515	VGND#3	VGND#1	1.89719e-18
C516	a_27_79##7	SCE	1.27498e-17
C517	a_1025_74##2	a_1370_289##2	2.16196e-17
C518	VPWR#11	a_27_79##2	5.77641e-18
C519	a_852_74##12	CLK#3	6.39277e-18
C520	D#1	a_307_464#	1.52812e-17
C521	a_27_79##6	SCE	8.98737e-17
C522	a_1025_74##4	a_1790_74##16	1.58105e-18
C523	VGND#3	a_1790_74#	6.55357e-19
C524	RESET_B#7	a_852_74##3	1.40783e-19
C525	a_2006_373##3	VPWR#17	8.71524e-18
C526	VPWR#5	a_1790_74##8	8.34645e-20
C527	a_388_79##2	VPWR#20	2.20156e-17
C528	a_388_79#	a_852_74##8	4.05307e-17
C529	SCE#1	a_307_464#	1.52812e-17
C530	a_388_79#	a_1223_118##7	9.82028e-17
C531	VGND#11	a_27_79##2	9.52387e-18
C532	a_388_79##5	CLK	6.60645e-18
C533	a_1790_74##2	a_2604_392##4	2.58978e-17
C534	VGND#20	CLK#3	3.43586e-18
C535	VGND#9	a_852_74##11	6.38265e-19
C536	VGND#10	a_388_79##8	1.07883e-18
C537	VPWR#9	RESET_B#6	2.98512e-19
C538	a_1223_118##6	RESET_B#5	1.32534e-18
C539	a_1790_74##16	RESET_B#8	5.91929e-19
C540	a_1223_118##6	a_1325_457#	1.12585e-18
C541	VGND#8	a_1025_74##4	1.19862e-16
C542	VGND#15	a_2604_392##11	6.65778e-17
C543	CLK	a_852_74##11	1.34909e-17
C544	a_1790_74##10	a_1790_74##2	2.13586e-18
C545	VGND#11	SCE#2	4.9375e-19
C546	VPWR#8	RESET_B#6	1.45817e-18
C547	a_388_79##5	VPWR#11	5.26017e-17
C548	VPWR#4	a_1790_74##8	4.28028e-18
C549	VGND#6	a_1790_74##11	7.2396e-20
C550	VGND#4	a_1790_74##9	5.10483e-18
C551	a_1223_118##5	RESET_B#5	2.56321e-17
C552	a_1025_74##10	a_852_74##8	1.46346e-17
C553	VGND#2	VGND#1	2.41303e-17
C554	RESET_B#14	a_852_74##11	3.0341e-17
C555	a_1370_289##4	RESET_B#8	1.62706e-19
C556	a_1223_118##7	a_1223_118##9	2.57955e-19
C557	a_2604_392##9	a_2604_392##6	6.46874e-19
C558	a_852_74##2	a_1025_74##6	1.28728e-17
C559	RESET_B#19	RESET_B#9	6.19878e-18
C560	a_1790_74##15	a_2006_373##2	9.18391e-17
C561	a_852_74##10	a_388_79##2	1.26677e-18
C562	a_388_79##8	CLK#3	1.02295e-18
C563	a_27_79##4	RESET_B#2	3.32465e-19
C564	a_27_79##6	SCE#2	7.44481e-18
C565	a_388_79#	a_852_74##6	6.90638e-19
C566	a_1790_74##16	a_2006_373##3	1.45467e-17
C567	VPWR#8	a_1025_74##5	2.24827e-19
C568	a_1025_74##10	a_1223_118##7	8.45408e-17
C569	a_388_79##8	SCD	2.14284e-17
C570	VGND#2	Q#3	3.43626e-17
C571	a_1223_118##3	a_1025_74##5	3.58334e-17
C572	VGND#20	RESET_B#1	2.09789e-18
C573	RESET_B#18	a_1025_74##5	6.17334e-19
C574	VGND#1	a_2604_392#	2.54464e-17
C575	a_1370_289##4	a_1223_118##2	4.77318e-19
C576	a_2604_392##10	VPWR#14	8.54559e-17
C577	a_27_79##4	SCE#3	7.34824e-19
C578	a_388_79##8	a_388_79##5	6.01417e-18
C579	VGND#5	a_1790_74##11	5.90975e-18
C580	VGND#3	a_1790_74##9	6.10371e-20
C581	VPWR#7	a_852_74#	2.29114e-19
C582	a_1223_118##2	VPWR#18	3.66292e-17
C583	VGND#4	VGND#14	1.95147e-19
C584	a_2604_392##9	Q	2.25158e-17
C585	a_1223_118##6	a_1370_289##3	2.7459e-17
C586	VPWR#5	a_1790_74##10	5.15483e-19
C587	CLK#3	RESET_B#1	1.61799e-17
C588	a_1370_289##4	a_2006_373##3	3.41613e-19
C589	a_852_74##10	a_1025_74##13	1.16405e-18
C590	VPWR	a_852_74##3	2.02549e-18
C591	a_1025_74##10	a_852_74##6	5.01927e-17
C592	VGND#7	a_2006_373#	3.24323e-18
C593	a_1223_118##6	VPWR#9	4.72274e-18
C594	a_1223_118#	a_852_74##2	6.20469e-17
C595	VGND#8	a_1223_118##2	1.18644e-19
C596	a_2604_392#	Q#3	2.38359e-17
C597	RESET_B#18	RESET_B#7	1.8079e-18
C598	a_1790_74##16	a_1025_74##6	4.1495e-17
C599	VPWR#11	a_852_74##11	1.81763e-18
C600	a_1790_74##6	a_1790_74##2	3.40952e-18
C601	a_1223_118##5	a_1370_289##3	3.831e-18
C602	a_1370_289##4	RESET_B#6	7.47969e-20
C603	VPWR#4	a_1790_74##10	1.43095e-18
C604	SCD#3	RESET_B#2	2.98592e-18
C605	VPWR#15	VPWR#14	1.4926e-18
C606	a_1025_74##10	a_388_79#	7.72472e-17
C607	VGND#7	a_852_74#	5.90623e-18
C608	VGND#4	a_1790_74##11	6.741e-19
C609	a_2006_373##2	RESET_B#19	4.9128e-17
C610	VGND#6	a_1790_74##7	8.16804e-18
C611	VPWR#18	a_2006_373##3	5.79959e-19
C612	a_27_79##7	D	4.15763e-18
C613	SCD#1	a_547_79#	8.28512e-18
C614	a_1025_74##7	a_1790_74##15	3.47363e-17
C615	a_223_79##2	SCE	1.20222e-18
C616	RESET_B#14	RESET_B#12	1.78137e-17
C617	VGND#1	a_2604_392##6	3.08238e-18
C618	SCE#6	a_547_79#	8.28512e-18
C619	VPWR#18	RESET_B#6	5.08159e-18
C620	a_852_74##6	VGND#19	1.71553e-17
C621	a_388_79##5	a_1025_74##13	4.3423e-22
C622	a_223_79#	SCD#2	8.14615e-19
C623	a_852_74##10	VPWR#20	9.5802e-22
C624	VPWR#6	a_1790_74##12	1.90973e-18
C625	a_1370_289##4	a_1025_74##6	1.14681e-18
C626	RESET_B#7	a_1223_118##3	3.17683e-18
C627	VGND#7	a_1025_74##5	6.11736e-20
C628	a_388_79#	a_388_79##2	1.20872e-18
C629	SCE#7	SCD#2	3.65158e-17
C630	VGND#14	a_2604_392#	1.79344e-18
C631	VGND#5	Q_N	7.25571e-18
C632	VGND#4	Q_N	1.01933e-17
C633	a_1025_74##10	CLK#4	2.18444e-18
C634	CLK	a_852_74##12	1.04821e-17
C635	a_1223_118##6	a_852_74##7	1.02557e-17
C636	a_852_74##2	a_1790_74##16	1.25338e-17
C637	a_388_79##5	a_538_464#	6.52551e-18
C638	RESET_B#5	a_1223_118#	4.08719e-18
C639	VGND#20	CLK	3.82366e-18
C640	a_1370_289##4	a_1370_289##2	7.28953e-20
C641	a_27_79##4	SCD#2	2.04093e-17
C642	Q_N	a_2604_392##9	1.50473e-17
C643	a_388_79##8	SCD#2	1.93591e-18
C644	VGND#4	a_2604_392##11	1.18591e-17
C645	VPWR#10	a_1025_74##2	1.18616e-19
C646	VPWR#18	a_1025_74##6	7.67897e-19
C647	a_852_74##12	a_852_74##6	1.67464e-18
C648	VPWR#15	a_2604_392##10	7.28994e-17
C649	VPWR#5	a_1790_74##12	6.53237e-18
C650	a_2604_392##6	Q#3	2.38881e-17
C651	a_852_74##4	a_1025_74#	4.88612e-19
C652	a_388_79##8	CLK	5.02639e-18
C653	SCE#3	D#2	6.71454e-19
C654	SCE#7	a_27_79##4	6.6014e-17
C655	D#2	SCD#2	1.27621e-18
C656	VPWR#18	a_1370_289##2	5.61554e-19
C657	VGND#11	a_852_74##11	4.93348e-18
C658	VPWR#9	a_1025_74##2	2.24602e-19
C659	VGND#8	RESET_B#6	3.31841e-19
C660	a_1223_118##5	a_852_74##7	2.81039e-19
C661	a_1223_118##5	VPWR#9	4.9481e-18
C662	a_1370_289##4	a_852_74##2	6.15884e-17
C663	CLK#4	VGND#19	2.06703e-17
C664	a_223_79#	SCE#7	1.88117e-18
C665	a_2604_392##11	a_2604_392#	2.99273e-20
C666	D#2	SCE#7	3.26046e-17
C667	VGND#1	a_1790_74#	1.49963e-19
C668	a_27_79##2	SCD#2	4.13846e-19
C669	VPWR#11	RESET_B#12	1.44794e-18
C670	VPWR#9	RESET_B#7	7.11034e-20
C671	VGND#4	a_1790_74##7	3.47111e-20
C672	a_1025_74##4	a_1790_74##15	4.29651e-17
C673	VGND#6	RESET_B#10	6.67579e-18
C674	a_2604_392##9	a_1790_74##9	2.13223e-19
C675	VPWR	VPWR#9	6.50353e-17
C676	a_388_79##5	VPWR#20	2.34418e-17
C677	D#3	a_310_79#	6.53145e-18
C678	a_388_79#	a_1025_74##13	8.17905e-18
C679	VGND#20	a_852_74##6	1.62438e-19
C680	VPWR	VPWR#8	1.04911e-16
C681	a_27_79##4	D#2	9.37007e-19
C682	a_27_79##2	SCE#7	1.54351e-18
C683	VPWR	VPWR#6	8.65011e-17
C684	VGND#16	VGND#15	1.77242e-18
C685	VPWR	VPWR#5	7.4616e-17
C686	a_27_79#	a_310_79#	8.18569e-18
C687	a_2604_392##6	VGND#14	2.17263e-17
C688	VPWR	VPWR#4	5.85416e-17
C689	VPWR#19	a_1370_289##2	8.54329e-19
C690	a_1370_289#	RESET_B#7	3.91585e-17
C691	VPWR	VPWR#3	1.02483e-17
C692	a_1370_289##3	RESET_B#5	1.28e-17
C693	VPWR#18	a_852_74##2	5.42062e-18
C694	a_852_74##7	a_1223_118#	1.41757e-19
C695	a_388_79##8	SCE#7	5.26165e-17
C696	VPWR#6	a_1790_74##13	1.47524e-18
C697	a_852_74##12	CLK#4	5.32612e-17
C698	RESET_B#19	a_2006_373##6	1.02441e-17
C699	VGND#3	a_2604_392##11	3.11688e-18
C700	VPWR#21	VPWR#20	4.91824e-19
C701	a_1223_118##6	a_1025_74##3	3.61158e-19
C702	VGND#19	a_1025_74##10	6.77668e-17
C703	a_223_79##2	D	1.52042e-17
C704	a_27_79##2	D#2	4.2925e-17
C705	Q#3	a_1790_74#	9.01142e-21
C706	a_27_79##4	SCE#2	3.19939e-20
C707	a_1790_74##6	a_1790_74##11	6.04882e-18
C708	a_1370_289##4	a_1223_118#	1.79864e-17
C709	a_27_79##8	D	1.82084e-18
C710	a_223_79#	a_27_79##4	2.10964e-19
C711	VGND#19	RESET_B#3	5.53492e-19
C712	a_852_74##11	a_388_79##2	6.02825e-18
C713	SCE	VPWR#22	1.03381e-17
C714	a_223_79##2	SCE#7	1.86003e-18
C715	a_1025_74##10	a_1025_74##13	3.69208e-18
C716	VPWR#10	a_852_74##5	6.85323e-20
C717	a_2604_392##11	a_2604_392##6	3.32407e-18
C718	VPWR#5	a_1790_74##13	5.53317e-18
C719	a_2604_392##9	Q#3	2.60117e-17
C720	VPWR	RESET_B#19	5.81494e-19
C721	a_1223_118##5	a_1025_74##3	5.2973e-20
C722	a_27_79##2	SCE#2	5.44232e-17
C723	a_1223_118##5	VPWR#8	3.10544e-18
C724	VGND#20	CLK#4	1.74793e-18
C725	VGND#11	RESET_B#12	2.94313e-18
C726	a_388_79##2	a_1370_289##2	6.43873e-19
C727	VPWR#18	a_1223_118#	5.85198e-17
C728	VGND#8	a_1370_289##2	4.83117e-20
C729	VPWR#3	VPWR#1	1.64849e-18
C730	Q_N#1	VPWR#15	8.29713e-17
C731	a_852_74##7	a_1370_289##3	4.42849e-17
C732	a_388_79##8	a_27_79##4	8.55946e-19
C733	a_1790_74##6	RESET_B#10	2.54815e-17
C734	VGND#14	a_1790_74#	3.57084e-18
C735	VPWR#19	a_852_74##2	6.97575e-19
C736	a_388_79##5	a_852_74##10	3.42037e-17
C737	SCE#3	a_27_79##2	1.36576e-17
C738	VPWR	a_1223_118##6	4.20975e-18
C739	Q_N	a_2604_392##11	3.36633e-18
C740	a_1790_74##15	a_1223_118##2	3.48655e-19
C741	VPWR	a_1223_118##5	1.41278e-17
C742	a_1025_74##13	a_1370_289##2	7.46899e-20
C743	a_2604_392##9	a_1790_74##11	8.73153e-20
C744	a_852_74##12	RESET_B#3	3.39796e-18
C745	Q_N	VGND#15	6.77604e-17
C746	VGND#6	a_2006_373#	3.11158e-18
C747	VGND#6	VGND#16	8.53885e-20
C748	Q_N	Q_N#2	9.78003e-20
C749	VGND#16	Q_N	1.80365e-17
C750	VPWR	RESET_B#16	3.61912e-19
C751	a_1025_74#	a_1370_289#	3.81642e-17
C752	a_2604_392##9	a_2604_392##5	4.48525e-19
C753	a_852_74##12	a_1025_74##10	1.62932e-18
C754	a_2006_373##4	Q_N	8.52298e-17
C755	RESET_B	VPWR#6	9.02094e-18
C756	a_1223_118##9	a_1025_74##2	6.41993e-19
C757	VGND#15	a_2604_392##6	3.4824e-19
C758	Q	VPWR#1	1.05193e-16
C759	a_223_79#	CLK#4	2.0542e-19
C760	VPWR#11	a_27_79##7	1.42716e-18
C761	VGND	a_1790_74##2	2.74313e-18
C762	Q	Q#1	5.30807e-18
C763	VPWR#2	a_2604_392##5	1.00649e-17
C764	a_1025_74##3	a_1370_289##3	1.1643e-18
C765	VPWR#14	Q	9.58821e-17
C766	RESET_B#19	VPWR#17	1.22428e-18
C767	a_27_79##4	a_307_464#	4.31424e-18
C768	a_2604_392##10	Q	1.18905e-19
C769	VGND#20	RESET_B#12	5.8335e-18
C770	VPWR#6	RESET_B#8	1.37626e-17
C771	a_388_79##2	a_1025_74##2	6.99364e-17
C772	a_852_74##8	a_852_74##3	6.65916e-20
C773	VPWR#18	RESET_B#5	3.41046e-18
C774	VGND#15	VPWR#15	1.01601e-17
C775	a_1790_74#	a_2604_392##11	2.94039e-17
C776	a_852_74##11	a_1025_74##13	6.91303e-17
C777	VGND#20	RESET_B#3	4.14843e-17
C778	VPWR#11	a_27_79##6	2.51423e-17
C779	RESET_B#16	a_852_74##3	3.71132e-19
C780	VPWR#19	a_1223_118#	1.244e-18
C781	VPWR#16	VPWR#15	2.1551e-18
C782	VPWR#2	a_2604_392##7	7.52093e-18
C783	VGND#8	a_852_74#	9.01161e-20
C784	a_1025_74##13	a_1025_74##2	5.93881e-19
C785	a_1370_289##5	a_1025_74##7	3.06212e-18
C786	RESET_B	a_1790_74##15	2.30743e-17
C787	D#2	a_388_79##8	4.3535e-17
C788	a_1025_74##3	a_852_74##7	3.06977e-17
C789	VGND#9	a_1025_74##2	2.19528e-20
C790	VPWR#2	VPWR#3	3.90676e-17
C791	a_2006_373#	RESET_B#9	3.47657e-18
C792	RESET_B	RESET_B#19	9.87116e-18
C793	a_2604_392##9	VGND#14	2.33988e-17
C794	a_852_74##12	SCD#1	2.03397e-19
C795	VGND#14	a_1790_74##9	1.35885e-19
C796	VPWR#10	CLK#3	2.23317e-19
C797	RESET_B#5	a_1223_118##8	1.30294e-17
C798	a_852_74##12	VGND#19	6.55605e-17
C799	a_388_79##5	a_388_79##7	2.45045e-18
C800	VGND#8	a_1025_74##2	6.50971e-20
C801	VPWR#18	a_852_74##3	2.91624e-19
C802	SCE	SCE#4	3.32171e-19
C803	VPWR	a_2006_373##4	2.58958e-18
C804	a_223_79#	RESET_B#3	1.13552e-17
C805	a_388_79##5	a_852_74##4	3.28549e-19
C806	a_223_79##2	D#2	1.33348e-17
C807	a_388_79##2	a_852_74##5	4.89029e-19
C808	Q_N	a_2604_392##10	2.42364e-18
C809	a_1790_74#	VGND#15	1.83212e-17
C810	Q_N	VPWR#15	1.03319e-17
C811	VPWR#18	a_1370_289##3	4.24e-19
C812	Q_N	Q_N#1	6.69367e-19
C813	a_852_74##8	a_1025_74#	2.63288e-17
C814	VGND#10	VGND#9	1.06097e-18
C815	CLK	RESET_B#3	7.60952e-19
C816	VGND#11	a_27_79##7	1.73478e-18
C817	VGND#6	a_852_74#	6.55422e-19
C818	VPWR#16	Q_N	1.314e-17
C819	VGND#6	a_2006_373##4	1.93471e-18
C820	a_388_79##8	CLK#4	8.42586e-19
C821	a_2604_392##9	a_2604_392##7	1.60703e-18
C822	RESET_B#5	VPWR#19	1.64046e-17
C823	a_1025_74##13	a_852_74##5	5.24766e-18
C824	VGND#20	SCD#1	1.01252e-18
C825	VPWR#16	Q_N#1	8.23982e-17
C826	VGND#11	a_852_74##6	2.79667e-18
C827	a_2604_392##11	a_1790_74##9	1.14451e-18
C828	a_852_74##6	a_852_74##4	5.83717e-18
C829	VPWR#4	VPWR#14	2.5808e-19
C830	a_388_79##8	a_27_79##2	9.47719e-21
C831	a_27_79##8	D#2	2.38456e-19
C832	a_852_74##11	VPWR#20	1.58731e-18
C833	VGND	VGND#8	1.42005e-16
C834	a_852_74#	a_2006_373##2	2.7416e-17
C835	VGND	VGND#6	7.60986e-17
C836	a_2006_373##4	VGND#16	4.49555e-17
C837	VGND	VGND#5	6.14149e-17
C838	a_852_74##12	SCE#6	1.11113e-19
C839	VPWR#6	a_2006_373##3	1.07622e-17
C840	VGND	VGND#4	7.29308e-17
C841	a_388_79##5	a_1025_74##3	2.65592e-19
C842	VGND	VGND#3	4.88013e-18
C843	a_27_79##7	SCE#3	2.32848e-17
C844	VGND#11	CLK#4	3.65088e-19
C845	a_1025_74##4	a_1370_289##5	1.89623e-16
C846	a_1790_74##15	a_1790_74##11	7.80625e-21
C847	VGND#20	VGND#19	1.93671e-18
C848	VGND	a_1790_74##15	3.58554e-18
C849	VGND#16	VGND#4	7.34715e-19
C850	a_223_79#	SCD#1	3.33724e-17
C851	VGND#8	a_1025_74##5	4.73792e-18
C852	VPWR	a_2604_392##10	1.70568e-17
C853	SCD	SCD#3	2.67154e-18
C854	VPWR#18	a_852_74##7	2.3215e-19
C855	D	D#3	8.06448e-19
C856	a_223_79##2	a_27_79##2	2.02823e-17
C857	VPWR	VPWR#15	1.63463e-17
C858	VGND	RESET_B#19	1.00353e-18
C859	VPWR	Q_N#1	2.08704e-17
C860	D	a_27_79#	5.57174e-18
C861	RESET_B#18	a_1790_74##17	2.93857e-19
C862	VGND#9	a_852_74##5	8.30888e-20
C863	RESET_B	VGND#17	4.54742e-18
C864	VPWR#10	a_852_74##8	5.50168e-20
C865	D	SCE#4	3.32737e-18
C866	a_1370_289##3	VPWR#19	1.62546e-17
C867	VPWR	a_2006_373##6	1.45261e-17
C868	SCD	D#1	2.33384e-19
C869	a_388_79##5	VPWR#21	6.51984e-17
C870	VGND#11	RESET_B#3	6.63569e-18
C871	a_1790_74##9	VGND#15	2.17834e-17
C872	RESET_B	a_1790_74##17	2.78366e-18
C873	VGND	a_1370_289##5	1.48353e-17
C874	a_388_79##8	RESET_B#3	1.91607e-17
C875	VGND#21	a_27_79##2	2.19479e-17
C876	VPWR	a_1790_74##16	2.77182e-17
C877	a_388_79##5	a_852_74##3	4.50607e-20
C878	VPWR#10	RESET_B#1	3.94186e-19
C879	VGND#5	a_2006_373##4	1.65258e-17
C880	VPWR	a_1370_289##4	1.22881e-17
C881	Q_N	a_2604_392##6	1.39372e-19
C882	Q_N	a_1790_74#	1.75723e-18
C883	a_852_74#	a_1025_74##7	9.22831e-18
C884	VGND	RESET_B#16	4.68508e-19
C885	Q_N	a_1790_74##9	3.54775e-17
C886	VPWR	VPWR#19	7.77459e-18
C887	Q_N	a_1790_74##11	2.54642e-17
C888	RESET_B#18	a_1370_289##7	1.63239e-20
C889	a_852_74##6	a_852_74##8	3.41383e-18
C890	CLK#1	a_852_74##9	4.81749e-17
C891	Q_N	a_1790_74##7	8.03073e-19
C892	VGND#11	SCD#1	4.11952e-18
C893	VGND#16	a_1790_74#	2.43904e-19
C894	a_27_79##7	a_27_79##6	4.19526e-18
C895	SCE	D#1	1.32586e-17
C896	VGND#6	a_1025_74##5	1.15722e-19
C897	a_2604_392##9	a_1790_74##8	1.13921e-18
C898	a_388_79##6	VPWR#21	2.62888e-17
C899	a_852_74##10	CLK#3	2.56433e-18
C900	a_1025_74##4	a_2006_373#	4.04083e-19
C901	a_388_79##5	a_852_74##11	4.94896e-18
C902	SCE#3	SCE#1	1.50064e-18
C903	a_1790_74##2	a_2604_392##6	5.33819e-19
C904	a_1370_289##5	VGND#18	5.45454e-18
C905	a_852_74##11	a_852_74##10	1.96387e-17
C906	Q	a_2604_392##5	3.24254e-17
C907	RESET_B#18	VGND#18	1.26785e-20
C908	VGND#20	a_852_74##12	3.35821e-17
C909	Q	a_2604_392##7	2.12285e-17
C910	VGND#11	SCE#6	4.13762e-18
C911	a_1790_74##9	Q_N#2	1.44251e-17
C912	Q	a_1790_74##8	2.67865e-19
C913	a_223_79#	SCE#6	1.35592e-17
C914	a_223_79##2	SCE#2	3.30404e-19
C915	RESET_B	Q_N#1	1.12054e-18
C916	RESET_B#14	SCD	2.94195e-18
C917	VPWR#19	a_852_74##7	2.88803e-18
C918	RESET_B	VPWR#16	2.15189e-18
C919	a_388_79##5	a_852_74##9	6.59815e-19
C920	a_2604_392##10	VPWR#4	7.14027e-18
C921	VGND	a_2604_392##11	1.83693e-17
C922	RESET_B	a_2006_373##6	5.14496e-18
C923	VPWR#11	SCD	3.78295e-18
C924	a_1025_74##4	a_852_74#	3.69165e-17
C925	a_2604_392##2	Q#1	1.132e-19
C926	VGND	VGND#16	1.39025e-17
C927	RESET_B#18	VPWR#9	6.4308e-18
C928	VGND	a_2006_373##4	2.34141e-17
C929	VGND#11	SCD	4.40013e-18
C930	RESET_B	a_1790_74##16	2.24044e-17
C931	a_2006_373##6	VPWR#16	4.24556e-17
C932	a_1370_289##5	a_1223_118##2	1.28683e-16
C933	a_388_79##8	SCD#1	2.15402e-17
C934	a_388_79##5	RESET_B#3	1.41025e-18
C935	VPWR#6	a_1025_74##6	2.41113e-18
C936	VGND	a_1790_74##17	2.66553e-17
C937	VGND#10	CLK#3	8.06971e-19
C938	a_1790_74##15	a_1790_74##7	4.91973e-20
C939	VGND#15	a_1790_74##11	6.58279e-19
C940	VGND#9	a_852_74##4	4.97056e-19
C941	a_1025_74##4	a_1025_74##5	2.43551e-17
C942	VGND	a_1223_118##7	3.02596e-18
C943	VPWR#11	SCE	9.33954e-18
C944	RESET_B#4	CLK#1	4.48862e-18
C945	VGND	a_1025_74##10	1.8024e-17
C946	VGND#8	a_1223_118##3	7.23286e-18
C947	Q_N	a_2604_392##7	2.06368e-19
C948	VGND#11	SCE	1.10503e-17
C949	Q_N	a_1790_74##8	1.09953e-18
C950	a_852_74##10	RESET_B#1	3.1529e-18
C951	RESET_B#18	VPWR#8	8.82094e-18
C952	a_388_79##5	CLK#2	6.38847e-19
C953	VGND#9	CLK#3	2.69903e-20
C954	Q_N	a_1790_74##10	4.48669e-18
C955	a_27_79##6	SCE#3	1.37753e-17
C956	Q_N	a_1790_74##12	7.79777e-18
C957	VPWR#5	VPWR#15	6.1899e-20
C958	VGND#11	a_27_79#	4.34985e-18
C959	VGND#16	a_1790_74##9	1.06396e-18
C960	a_388_79##2	a_1370_289##3	5.93461e-19
C961	a_1025_74##4	a_1223_118##3	2.11991e-17
C962	a_2604_392##2	VNB	3.90476e-17
C963	a_1223_118##2	a_852_74#	1.16408e-18
C964	a_1790_74##2	VNB	3.91245e-17
C965	CLK#4	a_852_74##6	3.80587e-17
C966	a_852_74##4	VNB	7.80183e-17
C967	a_1223_118##2	a_1223_118##5	1.05583e-18
C968	a_852_74##3	VNB	1.66189e-16
C969	CLK#2	VNB	2.89409e-17
C970	RESET_B#2	VNB	3.79145e-17
C971	VPWR#19	a_1025_74##3	6.35891e-19
C972	SCE#3	VNB	6.00082e-17
C973	VGND	VPWR#15	4.07962e-18
C974	VGND#11	CLK	5.56578e-18
C975	a_1790_74##16	a_852_74#	9.09492e-19
C976	VGND#17	VGND#16	1.76226e-18
C977	a_223_79#	D#3	4.77309e-19
C978	a_2604_392##10	VPWR#3	7.80742e-18
C979	a_1223_118##9	a_852_74##7	2.43054e-17
C980	VGND#11	SCE#4	4.23168e-18
C981	a_1790_74##11	Q_N#2	1.49318e-17
C982	a_1025_74##4	RESET_B#7	6.8594e-18
C983	RESET_B	a_852_74#	1.33553e-18
C984	VGND	a_1370_289##4	1.51818e-18
C985	RESET_B#18	a_1223_118##7	3.62396e-18
C986	a_1223_118##2	a_1025_74##5	8.23862e-18
C987	VGND	VPWR#18	3.08296e-18
C988	VPWR	a_1790_74##8	6.08942e-18
C989	a_2604_392##9	a_1790_74##10	6.76753e-19
C990	VGND#6	a_1223_118##3	3.44649e-20
C991	VPWR	a_1790_74##10	6.40911e-18
C992	Q	VPWR#2	3.31794e-17
C993	VPWR	a_1790_74##12	4.58837e-18
C994	a_388_79##8	SCE#6	3.32247e-17
C995	VGND#7	a_1790_74##17	2.58895e-17
C996	VPWR	a_1790_74##13	7.75688e-18
C997	VGND#11	D	4.31551e-18
C998	VPWR#8	a_852_74##2	5.1042e-17
C999	VPWR	RESET_B#8	7.5889e-18
C1000	VPWR	a_2006_373##3	6.00127e-18
C1001	SCD	SCD#2	2.90534e-17
C1002	a_388_79##5	CLK#1	2.9126e-17
C1003	VGND#16	VPWR#16	4.83919e-19
C1004	VPWR	a_1025_74##6	7.44772e-18
C1005	a_1025_74##4	a_1370_289#	2.73107e-19
C1006	SCD#3	RESET_B#4	1.75261e-17
C1007	VPWR	a_852_74##2	8.71927e-18
C1008	SCE#7	SCD	2.48812e-17
C1009	VGND#15	a_1790_74##7	8.00047e-20
C1010	Q#3	a_2604_392##2	9.396e-18
C1011	VPWR	a_1223_118#	1.98972e-18
C1012	a_388_79##5	VPWR#10	6.91514e-18
C1013	VPWR#10	VNB	6.33523e-17
C1014	VPWR#9	VNB	4.26787e-17
C1015	VPWR#8	VNB	4.12677e-17
C1016	VPWR	RESET_B#5	3.93142e-18
C1017	a_27_79##4	SCD	2.22513e-17
C1018	RESET_B#18	a_388_79#	2.24541e-18
C1019	a_223_79##2	SCD#1	1.95586e-19
C1020	VPWR#6	VNB	4.4731e-17
C1021	a_1370_289##5	RESET_B#6	5.45492e-19
C1022	a_388_79##2	a_852_74##7	6.95788e-18
C1023	VPWR#5	VNB	3.10298e-17
C1024	VPWR#2	a_2604_392##2	4.5102e-20
C1025	VPWR#4	VNB	3.11832e-17
C1026	VPWR	a_1370_289##3	3.42319e-18
C1027	VPWR#3	VNB	2.56648e-17
C1028	SCD	D#2	5.5956e-19
C1029	VGND#10	VNB	2.8791e-17
C1030	SCE	SCD#2	8.23113e-19
C1031	VGND#9	VNB	5.94206e-17
C1032	VGND	a_1790_74#	5.97576e-18
C1033	VGND#8	VNB	9.11702e-17
C1034	VGND#6	VNB	2.83871e-17
C1035	VGND	a_1790_74##9	5.68073e-18
C1036	VGND#5	VNB	3.38607e-17
C1037	VGND#4	VNB	3.37085e-17
C1038	VGND	a_1790_74##11	4.76731e-19
C1039	VGND#3	VNB	2.31765e-17
C1040	VPWR#19	a_852_74##3	2.07645e-17
C1041	VGND	a_1790_74##7	9.86696e-19
C1042	Q	a_2604_392##4	5.11559e-18
C1043	VPWR#20	a_1370_289##3	2.32943e-19
C1044	a_1790_74##15	RESET_B#10	3.94962e-18
C1045	a_2604_392##9	VNB	1.35533e-17
C1046	VGND	RESET_B#10	5.16823e-19
C1047	VPWR#19	a_852_74##9	7.02041e-19
C1048	RESET_B	a_1790_74##10	2.63365e-21
C1049	CLK	CLK#3	8.42514e-18
C1050	a_388_79##6	a_388_79##5	2.74196e-18
C1051	a_1223_118##2	RESET_B#7	2.11027e-17
C1052	VGND	a_2006_373#	4.69675e-19
C1053	SCE	a_27_79##4	5.18511e-17
C1054	a_1790_74##15	VNB	3.04648e-19
C1055	VGND	a_852_74#	4.21726e-18
C1056	a_1790_74##11	VGND#16	9.56889e-18
C1057	VGND	a_1025_74##5	1.49015e-18
C1058	VPWR#6	a_852_74##2	3.82521e-18
C1059	a_1223_118##6	RESET_B#6	1.61831e-18
C1060	VGND	a_1223_118##3	1.7865e-18
C1061	SCE	D#2	4.743e-17
C1062	a_1223_118##9	a_1025_74##3	2.3811e-17
C1063	VGND	RESET_B#7	8.9162e-18
C1064	a_388_79##5	RESET_B#2	2.13887e-17
C1065	SCD#2	VPWR#21	1.01542e-18
C1066	RESET_B#18	a_1025_74##10	4.90181e-18
C1067	a_27_79##2	SCE	9.55123e-17
C1068	a_223_79#	VGND#20	4.18322e-17
C1069	a_1370_289##5	VNB	5.63124e-18
C1070	a_1223_118##6	VNB	8.39502e-18
C1071	Q#3	a_2604_392##4	5.32715e-18
C1072	a_1223_118##5	VNB	1.03648e-17
C1073	VGND#8	RESET_B#7	4.7381e-18
C1074	a_223_79#	a_27_79#	2.44951e-19
C1075	SCE	SCE#2	3.83109e-17
C1076	a_852_74##11	a_852_74##9	5.72971e-18
C1077	RESET_B#16	VNB	4.36203e-20
C1078	a_388_79##5	VNB	9.98239e-18
C1079	VGND#17	a_2006_373##4	1.8326e-17
C1080	Q_N	a_2604_392##4	8.2347e-20
C1081	a_852_74##11	VNB	4.66547e-18
C1082	a_1223_118##2	RESET_B#16	1.18307e-17
C1083	RESET_B#3	CLK#4	5.17998e-18
C1084	Q_N	a_1790_74##6	3.64668e-17
C1085	RESET_B#12	VNB	2.56257e-18
C1086	a_1223_118##5	RESET_B#6	2.31333e-17
C1087	Q_N	RESET_B#9	8.79675e-20
C1088	RESET_B#18	VPWR	6.15092e-17
C1089	VPWR#7	a_2006_373##3	4.73779e-18
C1090	Q_N#1	VPWR#5	8.37892e-18
C1091	a_27_79##7	VNB	4.14292e-17
C1092	a_2006_373##2	Q_N	1.06066e-18
C1093	a_27_79##6	VNB	4.92151e-17
C1094	VPWR	VPWR#7	5.95691e-17
C1095	D#3	a_388_79##8	1.21059e-17
C1096	a_2006_373##4	VPWR#16	2.98163e-17
C1097	VGND#1	VNB	4.67906e-17
C1098	Q#3	VNB	1.3537e-17
C1099	VGND#14	a_2604_392##4	6.60133e-18
C1100	VGND#14	VNB	2.51183e-18
C1101	a_2604_392##11	VNB	6.47772e-18
C1102	VGND#15	VNB	3.8261e-18
C1103	D	D#2	4.2957e-18
C1104	a_27_79##3	SCD#3	3.48102e-17
C1105	a_388_79##2	a_1025_74##3	2.0096e-17
C1106	VGND#16	VNB	4.35194e-18
C1107	a_2006_373##4	VNB	1.07849e-17
C1108	VPWR#9	VPWR#8	5.08211e-19
C1109	D	a_27_79##2	6.55347e-18
C1110	VPWR	a_2604_392##4	5.33191e-19
C1111	RESET_B#7	RESET_B#6	1.92944e-18
C1112	RESET_B#18	a_852_74##2	9.97523e-18
C1113	VPWR	a_1790_74##6	1.34169e-22
C1114	VGND	a_852_74##2	2.62068e-18
C1115	a_223_79##2	SCE#6	7.02238e-19
C1116	a_1370_289##2	a_1025_74##5	2.65663e-19
C1117	a_1223_118##7	VNB	1.04741e-17
C1118	VPWR	RESET_B#9	3.19833e-18
C1119	a_2006_373##4	a_1790_74##11	8.59819e-18
C1120	a_388_79#	VNB	4.58686e-18
C1121	VPWR#20	a_852_74##7	6.60105e-19
C1122	a_1025_74##10	VNB	3.17189e-17
C1123	VGND#19	VNB	5.46018e-18
C1124	VPWR	a_2006_373##2	5.64764e-18
C1125	a_852_74##12	VNB	8.40505e-18
C1126	VGND#20	VNB	6.59312e-18
C1127	VPWR#7	a_1025_74##6	5.5341e-18
C1128	a_223_79#	VNB	1.06466e-17
C1129	VPWR	a_1025_74##7	3.82699e-18
C1130	RESET_B	VPWR#7	4.43555e-18
C1131	a_388_79##8	VNB	1.07234e-17
C1132	a_388_79##5	RESET_B#4	3.74413e-17
C1133	a_223_79##2	VNB	1.46888e-17
C1134	VGND#21	VNB	7.80688e-18
C1135	a_27_79##8	VNB	2.91986e-17
C1136	VPWR	a_1223_118##2	2.2168e-18
C1137	VPWR#1	VNB	5.86348e-17
C1138	VPWR#14	VNB	1.33933e-17
C1139	VPWR	RESET_B#6	8.67699e-19
C1140	VPWR#2	a_2604_392##9	3.37271e-18
C1141	a_2604_392##10	VNB	1.69005e-17
C1142	VPWR#15	VNB	3.56938e-18
C1143	Q_N#1	VNB	2.85639e-18
C1144	VPWR	a_1370_289##2	1.74461e-18
C1145	VPWR#16	VNB	1.20417e-17
C1146	a_2006_373##6	VNB	4.9163e-18
C1147	VPWR#6	VPWR#16	7.18089e-18
C1148	RESET_B	a_1790_74##6	2.91829e-18
C1149	VPWR#8	a_1223_118#	2.16837e-18
C1150	a_1370_289##4	VNB	7.87264e-19
C1151	RESET_B#18	a_1223_118#	4.37453e-18
C1152	a_1025_74##13	a_1025_74##3	3.76484e-19
C1153	VPWR#18	VNB	4.91401e-18
C1154	RESET_B	RESET_B#9	3.02514e-17
C1155	a_1370_289##2	a_1370_289##5	9.68115e-19
C1156	VPWR#19	VNB	4.61865e-18
C1157	a_388_79##6	VPWR#22	2.66241e-20
C1158	RESET_B	a_2006_373##2	5.09565e-17
C1159	VGND#16	a_1790_74##7	2.55575e-18
C1160	VGND#2	VGND#3	4.83497e-17
C1161	a_1223_118##9	VNB	5.9658e-19
C1162	a_388_79##2	VNB	1.31541e-17
C1163	RESET_B	a_1025_74##7	3.78157e-17
C1164	a_1025_74##13	VNB	3.84901e-19
C1165	a_388_79##8	a_852_74##12	9.6028e-18
C1166	VPWR#20	VNB	1.15793e-20
C1167	RESET_B	a_1025_74##4	4.3257e-19
C1168	a_852_74##10	VNB	7.26904e-19
C1169	VPWR#7	a_852_74##2	1.60401e-19
C1170	VGND	RESET_B#18	1.2664e-18
C1171	VPWR#21	VNB	3.72866e-18
C1172	a_388_79##6	VNB	1.18995e-19
C1173	VGND	VGND#7	7.07349e-17
C1174	VGND#21	SCE#3	1.01893e-18
C1175	a_2604_392#	VNB	3.36966e-17
C1176	a_2604_392##6	VNB	3.56834e-17
C1177	Q_N#1	VPWR#4	9.20164e-18
C1178	a_1790_74#	VNB	3.39419e-17
C1179	a_1370_289##2	RESET_B#7	2.94617e-17
C1180	a_1790_74##9	VNB	2.75146e-17
C1181	a_1790_74##15	a_2006_373#	1.84341e-17
C1182	a_1790_74##11	VNB	2.81847e-17
C1183	a_1790_74##7	VNB	2.76358e-17
C1184	VGND	a_2604_392##4	7.0466e-19
C1185	RESET_B#10	VNB	3.10458e-17
C1186	a_1223_118##6	a_1370_289##2	2.86263e-17
C1187	a_2006_373#	VNB	3.63738e-17
C1188	VGND	a_1790_74##6	1.08136e-17
C1189	a_852_74#	VNB	6.01013e-17
C1190	a_388_79##2	a_852_74##9	2.54309e-17
C1191	a_1025_74##5	VNB	3.66793e-17
C1192	VGND	RESET_B#9	2.48597e-19
C1193	a_388_79##8	a_27_79#	7.36456e-19
C1194	a_1223_118##3	VNB	2.95182e-17
C1195	RESET_B#7	VNB	5.51588e-17
C1196	VGND	a_2006_373##2	5.22308e-18
C1197	SCE#7	a_388_79##6	4.37507e-18
C1198	a_1370_289#	VNB	2.9815e-17
C1199	a_1025_74#	VNB	3.79637e-17
C1200	VGND	a_1025_74##7	1.6568e-18
C1201	a_852_74##11	CLK#1	1.16839e-18
C1202	D#1	a_27_79##3	1.03856e-17
C1203	a_852_74##8	VNB	3.93753e-17
C1204	a_852_74##6	VNB	3.10406e-17
C1205	VGND	a_1025_74##4	5.38605e-17
C1206	CLK#4	VNB	3.1234e-17
C1207	RESET_B#3	VNB	4.32155e-17
C1208	VGND	a_1223_118##2	9.22633e-18
C1209	SCD#1	VNB	3.09489e-17
C1210	SCE#6	VNB	2.56543e-17
C1211	VGND#9	CLK#2	7.18453e-20
C1212	VPWR#20	a_1025_74##3	1.21463e-18
C1213	VPWR#6	a_1223_118#	4.02474e-19
C1214	D#3	VNB	1.92045e-17
C1215	a_27_79#	VNB	3.07959e-17
C1216	VGND	a_1370_289##2	6.98865e-18
C1217	SCE#4	VNB	7.46126e-17
C1218	SCD#1	RESET_B#3	2.5286e-17
C1219	RESET_B#16	RESET_B#6	8.51695e-18
C1220	a_2604_392##5	VNB	4.08681e-17
C1221	a_1370_289##2	a_1370_289#	6.26578e-18
C1222	a_2604_392##7	VNB	4.11928e-17
C1223	a_1790_74##8	VNB	4.5943e-17
C1224	VGND#8	a_1370_289#	2.6396e-18
C1225	a_1790_74##10	VNB	3.28206e-17
C1226	VGND#2	a_2604_392##2	6.09207e-20
C1227	a_223_79##2	D#3	1.47738e-17
C1228	a_1790_74##12	VNB	3.81545e-17
C1229	a_1370_289##2	a_1223_118##5	2.70856e-17
C1230	a_1790_74##13	VNB	4.42856e-17
C1231	VPWR#2	VPWR#1	2.58892e-17
C1232	RESET_B#8	VNB	2.57594e-17
C1233	VGND#7	a_852_74##2	3.08782e-20
C1234	a_2006_373##3	VNB	2.41366e-17
C1235	a_1025_74##6	VNB	2.88102e-17
C1236	a_852_74##2	VNB	1.37726e-16
C1237	a_1223_118#	VNB	3.05455e-17
C1238	RESET_B#5	VNB	1.76716e-17
C1239	a_1370_289##3	VNB	3.12147e-17
C1240	a_852_74##7	VNB	2.7962e-17
C1241	a_1025_74##3	VNB	2.53184e-17
C1242	a_852_74##9	VNB	3.48871e-17
C1243	a_2006_373##4	a_1790_74##7	3.93727e-17
C1244	a_1790_74##9	a_1790_74##2	2.17435e-18
C1245	CLK#1	VNB	4.9412e-17
C1246	RESET_B#4	VNB	3.16213e-17
C1247	RESET_B	a_2158_74#	2.90757e-21
C1248	RESET_B#18	a_1370_289##3	9.57454e-19
C1249	SCD#3	VNB	2.63221e-17
C1250	a_27_79##3	VNB	2.47281e-17
C1251	SCE	SCD	1.9898e-18
C1252	a_1025_74##13	a_852_74##9	2.56733e-17
C1253	D#1	VNB	4.67689e-17
C1254	SCE#1	VNB	2.82847e-17
C1255	SCE#5	VNB	3.0924e-17
C1256	RESET_B	a_2000_74#	2.68041e-19
C1257	a_1025_74#	a_1370_289##2	9.1115e-18
C1258	a_1223_118##2	a_852_74##3	4.29272e-20
C1259	VPWR#2	VNB	1.28827e-16
C1260	VGND#2	VNB	1.35194e-16
C1261	RESET_B#18	VNB	1.18796e-17
C1262	VPWR#7	VNB	3.23186e-17
C1263	a_1790_74##16	a_2006_373##6	2.06442e-18
C1264	VGND#7	VNB	3.98607e-17
C1265	RESET_B#14	VNB	8.2854e-18
C1266	a_852_74##10	a_1025_74##3	1.32041e-19
C1267	VPWR#11	VNB	3.37598e-16
C1268	a_1223_118##7	a_1370_289##5	1.06064e-18
C1269	VGND#11	VNB	3.79099e-16
C1270	VPWR#9	RESET_B#5	2.21108e-18
C1271	a_2604_392##4	VNB	7.14573e-17
C1272	a_1790_74##6	VNB	1.41445e-16
C1273	RESET_B#9	VNB	6.61686e-17
C1274	D	SCE	2.10365e-17
C1275	a_2006_373##2	VNB	6.04087e-17
C1276	a_388_79##5	SCD#3	2.00902e-17
C1277	a_1025_74##7	VNB	3.52871e-17
C1278	a_1025_74##4	VNB	4.35387e-17
C1279	a_1223_118##2	VNB	4.51791e-17
C1280	RESET_B#6	VNB	7.36493e-17
C1281	VGND#17	a_1790_74##11	2.83115e-19
C1282	a_1370_289##2	VNB	6.28309e-17
C1283	a_1025_74##2	VNB	6.39761e-17
C1284	a_852_74##5	VNB	3.60915e-17
C1285	VGND#16	RESET_B#10	2.21637e-19
C1286	CLK#3	VNB	4.19647e-17
C1287	a_27_79##4	a_388_79##6	6.86266e-17
C1288	a_388_79##2	CLK#1	7.72707e-19
C1289	RESET_B#1	VNB	3.66871e-17
C1290	SCD#2	VNB	5.06061e-17
C1291	RESET_B#18	a_852_74##7	2.14623e-18
C1292	SCE#7	VNB	5.11673e-17
C1293	a_27_79##4	VNB	4.68995e-17
C1294	D#2	VNB	5.26453e-17
C1295	a_27_79##2	VNB	9.1989e-17
C1296	SCE#2	VNB	4.38116e-17
C1297	VGND#15	a_1790_74##6	1.52026e-18
C1298	VGND#2	a_2604_392##9	5.11728e-18
C1299	VPWR#20	a_852_74##9	3.51553e-17
C1300	SCE#1	D#1	4.12081e-17
C1301	RESET_B#18	VGND#8	2.94531e-18
C1302	a_388_79##8	SCE#4	5.46264e-19
C1303	a_1790_74##17	a_2006_373##4	4.63341e-19
C1304	a_2006_373##6	VPWR#6	3.05558e-17
C1305	VPWR#2	VPWR#14	2.09579e-17
C1306	RESET_B#12	a_388_79##7	3.00342e-18
C1307	RESET_B	Q_N	5.33272e-19
C1308	a_1790_74##6	a_1790_74##12	9.89675e-18
C1309	RESET_B	VPWR	3.71108e-17
C1310	VGND	Q_N	2.17978e-17
C1311	SCD	VNB	2.94734e-18
C1312	RESET_B#14	VPWR#10	9.13193e-18
C1313	a_223_79##2	a_27_79#	4.39932e-17
C1314	SCE	VNB	3.04406e-18
C1315	VGND#2	VPWR#1	5.29167e-18
C1316	CLK	VNB	4.15597e-18
C1317	D	VNB	2.45356e-18
C1318	Q	VNB	1.15801e-17
C1319	a_1223_118##6	a_1025_74##2	3.07334e-18
C1320	Q_N	VNB	3.58257e-18
C1321	a_1790_74##6	Q_N#2	5.37137e-19
C1322	a_1025_74##13	CLK#1	1.71123e-18
C1323	VPWR	VNB	2.40839e-16
C1324	RESET_B	VNB	4.37002e-19
C1325	VGND	VNB	2.49228e-16
C1326	a_1790_74##15	a_852_74#	2.37241e-17
C1327	VGND#12	SCE#4	3.28906e-18
C1328	a_27_79##4	VPWR#12	4.55242e-18
C1329	VPWR#12	a_27_79##3	1.26489e-18
C1330	VGND#12	a_27_79##7	5.30969e-19
C1331	VGND#12	D#2	1.07453e-19
C1332	VPWR#12	VPWR#22	1.08931e-17
C1333	VPWR#12	D#1	1.1914e-17
C1334	VPWR#12	D#2	6.05298e-20
C1335	VGND#12	a_27_79#	4.14099e-18
C1336	VPWR#12	VNB	8.64208e-17
C1337	VPWR#12	SCE#1	2.46831e-17
C1338	VPWR#12	SCE#3	4.31145e-19
C1339	VGND#12	a_27_79##2	1.35515e-18
C1340	VPWR#12	a_388_79##6	2.01429e-17
C1341	a_27_79##6	VPWR#12	9.97356e-17
C1342	VGND#12	a_223_79##2	7.62328e-17
C1343	VGND#11	VGND#12	1.48113e-16
C1344	VPWR#12	SCE#5	1.62652e-17
C1345	VPWR#12	SCE#2	2.64746e-18
C1346	VPWR#12	SCD#3	6.13992e-19
C1347	VGND#12	a_27_79##8	1.61451e-17
C1348	VGND#12	VNB	7.66919e-17
C1349	VGND#12	D#3	4.11832e-18
C1350	VPWR#11	VPWR#12	1.84649e-16
*
*
.ENDS sky130_fd_sc_hs__sdfrbp_2
*
