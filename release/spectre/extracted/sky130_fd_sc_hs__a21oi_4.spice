* Extracted by Quantus, converted by sky130cad/quantus.py
*
*
*
*                       LINUX           Wed Nov 18 08:06:04 2026
*
*
*
*  PROGRAM  advgen
*
*  Name           : advgen - Quantus - (64-bit)
*  Version        : 25.1.0-p047
*  Build Date     : Thu Dec 11 23:20:30 PST 2025
*
*  HSPICE LIBRARY
*
*  OPERATING_TEMPERATURE 150
*  QRC_TECH_DIR <path>/tech
*
*
*

*
.SUBCKT sky130_fd_sc_hs__a21oi_4 VPB VNB VGND VPWR Y A2 A1 B1
*
*
*  caps2d version: 10
*
*
*       TRANSISTOR CARDS
*
*
XM2 a_84_74##6 A2#12 VGND#9 VNB sky130_fd_pr__nfet_01v8_lvt l=0.15 w=0.74 ad=0.1961 as=0.2072 pd=2.01 ps=2.04
XM9 VGND#9 A2#10 a_84_74##8 VNB sky130_fd_pr__nfet_01v8_lvt l=0.15 w=0.74 ad=0.2072 as=0.2072 pd=2.04 ps=2.04
XM5 VGND#8 A2#8 a_84_74##8 VNB sky130_fd_pr__nfet_01v8_lvt l=0.15 w=0.74 ad=0.2072 as=0.2072 pd=2.04 ps=2.04
XM6 a_84_74##3 A2#1 VGND#8 VNB sky130_fd_pr__nfet_01v8_lvt l=0.15 w=0.74 ad=0.2072 as=0.2072 pd=2.04 ps=2.04
XM10 Y#6 A1#6 a_84_74##3 VNB sky130_fd_pr__nfet_01v8_lvt l=0.15 w=0.74 ad=0.2072 as=0.2072 pd=2.04 ps=2.04
XM14 Y#6 A1#10 a_84_74##7 VNB sky130_fd_pr__nfet_01v8_lvt l=0.15 w=0.74 ad=0.2072 as=0.2072 pd=2.04 ps=2.04
XM16 a_84_74##7 A1#8 Y#3 VNB sky130_fd_pr__nfet_01v8_lvt l=0.15 w=0.74 ad=0.2072 as=0.2072 pd=2.04 ps=2.04
XM13 a_84_74# A1#7 Y#3 VNB sky130_fd_pr__nfet_01v8_lvt l=0.15 w=0.74 ad=0.2109 as=0.2072 pd=2.05 ps=2.04
XM3 Y#7 B1#7 VGND#7 VNB sky130_fd_pr__nfet_01v8_lvt l=0.15 w=0.74 ad=0.1961 as=0.2072 pd=2.01 ps=2.04
XM11 VGND#7 B1#5 Y#1 VNB sky130_fd_pr__nfet_01v8_lvt l=0.15 w=0.74 ad=0.2072 as=0.1961 pd=2.04 ps=2.01
XM4 VPWR#11 A2#6 a_69_368##11 VPB sky130_fd_pr__pfet_01v8 l=0.15 w=1.12 ad=0.336 as=0.308 pd=2.84 ps=2.79
XM18 a_69_368##12 A2#11 VPWR#11 VPB sky130_fd_pr__pfet_01v8 l=0.15 w=1.12 ad=0.336 as=0.336 pd=2.84 ps=2.84
XM17 a_69_368##12 A2#9 VPWR#10 VPB sky130_fd_pr__pfet_01v8 l=0.15 w=1.12 ad=0.336 as=0.336 pd=2.84 ps=2.84
XM19 VPWR#10 A2#7 a_69_368##6 VPB sky130_fd_pr__pfet_01v8 l=0.15 w=1.12 ad=0.336 as=0.336 pd=2.84 ps=2.84
XM7 a_69_368##6 A1#12 VPWR#9 VPB sky130_fd_pr__pfet_01v8 l=0.15 w=1.12 ad=0.336 as=0.336 pd=2.84 ps=2.84
XM20 VPWR#9 A1#11 a_69_368##9 VPB sky130_fd_pr__pfet_01v8 l=0.15 w=1.12 ad=0.336 as=0.336 pd=2.84 ps=2.84
XM21 VPWR#8 A1#9 a_69_368##9 VPB sky130_fd_pr__pfet_01v8 l=0.15 w=1.12 ad=0.336 as=0.336 pd=2.84 ps=2.84
XM8 a_69_368##3 A1#1 VPWR#8 VPB sky130_fd_pr__pfet_01v8 l=0.15 w=1.12 ad=0.336 as=0.336 pd=2.84 ps=2.84
XM12 a_69_368##3 B1#4 Y#9 VPB sky130_fd_pr__pfet_01v8 l=0.15 w=1.12 ad=0.336 as=0.336 pd=2.84 ps=2.84
XM15 Y#9 B1#8 a_69_368##8 VPB sky130_fd_pr__pfet_01v8 l=0.15 w=1.12 ad=0.336 as=0.336 pd=2.84 ps=2.84
XM1 a_69_368##8 B1#6 Y#10 VPB sky130_fd_pr__pfet_01v8 l=0.15 w=1.12 ad=0.336 as=0.336 pd=2.84 ps=2.84
XM0 Y#10 B1#1 a_69_368# VPB sky130_fd_pr__pfet_01v8 l=0.15 w=1.12 ad=0.336 as=0.308 pd=2.84 ps=2.79
*
*
*       RESISTOR AND CAP/DIODE CARDS
*
Rg1	A2#1	A2#2	397.555725
Rg2	A2#2	A2#3	90.016602
Rg3	A2#3	A2#4	51.916321
Rg4	A2#4	A2#5	66.386436
Rg5	A2#5	A2#6	454.869080
Rg6	A2#2	A2#7	449.655212
Rg7	A2#3	A2#8	373.041962
Rg8	A2#3	A2#9	424.977325
Rg9	A2#4	A2#10	397.590515
Rg10	A2#4	A2#11	449.490784
Rg11	A2#5	A2#12	418.139221
Rg12	A1#1	A1#2	455.914490
Rg13	A1#2	A1#3	58.552822
Rg14	A1#3	A1#4	86.720970
Rg15	A1#4	A1#5	66.386436
Rg16	A1#5	A1#6	397.555725
Rg17	A1#2	A1#7	426.989899
Rg18	A1#3	A1#8	386.713257
Rg19	A1#3	A1#9	432.847015
Rg20	A1#4	A1#10	395.494293
Rg21	A1#4	A1#11	448.603302
Rg22	A1#5	A1#12	449.655212
Rg23	B1#1	B1#2	630.023499
Rg24	B1#2	B1#3	84.521271
Rg25	B1#3	B1#4	519.595093
Rg26	B1#2	B1#5	394.561310
Rg27	B1#2	B1#6	446.660797
Rg28	B1#3	B1#7	397.150360
Rg29	B1#3	B1#8	451.603058
Rf1	A2	A2#13	6.723260
Rf2	A2#13	A2	7.945672
Rf3	A1#13	A1	0.997598
Rf4	A1#3	A1#15	54.408531
Rf5	A1#13	A1#15	9.473685
Rf6	A1#16	A1	0.997598
Rf7	A1#15	A1#16	5.195247
Rf8	a_84_74#	a_84_74##2	78.296722
Rf9	a_84_74##2	a_84_74##4	87.255524
Rf10	a_84_74##4	a_84_74##5	84.090828
Rf11	a_84_74##5	a_84_74##6	86.158134
Rf12	a_84_74##2	a_84_74##7	19.154261
Rf13	a_84_74##5	a_84_74##8	28.306047
Rf14	a_84_74##3	a_84_74##4	7.500000
Rf15	B1#9	B1	0.997598
Rf16	B1#3	B1#11	54.408531
Rf17	B1#9	B1#11	5.500849
Rf18	B1#12	B1	0.997598
Rf19	B1#11	B1#12	9.168082
Rf20	Y#1	Y#2	87.991043
Rf21	Y#2	Y#4	42.566612
Rf22	Y#4	Y#5	35.900864
Rf23	Y#5	Y	11.894531
Rf24	Y	Y#6	18.264444
Rf25	Y#2	Y#7	15.913929
Rf26	Y#5	Y	14.128658
Rf27	Y	Y#8	152.410156
Rf28	Y#8	Y#9	16.279915
Rf29	Y#8	Y#10	78.784904
Rf30	Y#3	Y#4	15.000000
Rf31	a_69_368#	a_69_368##2	98.311989
Rf32	a_69_368##2	a_69_368##4	81.580147
Rf33	a_69_368##4	a_69_368##5	70.461685
Rf34	a_69_368##5	a_69_368##7	64.156174
Rf35	a_69_368##2	a_69_368##8	28.306047
Rf36	a_69_368##5	a_69_368##9	14.409969
Rf37	a_69_368##7	a_69_368##10	79.768181
Rf38	a_69_368##10	a_69_368##11	86.969200
Rf39	a_69_368##10	a_69_368##12	18.602406
Rf40	a_69_368##3	a_69_368##4	7.500000
Rf41	a_69_368##6	a_69_368##7	5.000000
Rf43	VGND#2	VGND#3	136.945145
Rf44	VGND#3	VGND#4	93.845360
Rf45	VGND#4	VGND#5	62.774361
Rf47	VGND#2	VGND#7	35.098007
Rf48	VGND#4	VGND#8	35.098007
Rf49	VGND#5	VGND#9	35.098007
Rf51	VPWR#2	VPWR#3	36.623291
Rf52	VPWR#3	VPWR#4	32.175034
Rf53	VPWR#4	VPWR#5	62.954285
Rf54	VPWR#5	VPWR#6	68.798325
Rf56	VPWR#2	VPWR#8	48.224632
Rf57	VPWR#4	VPWR#9	37.538910
Rf58	VPWR#5	VPWR#10	53.143215
Rf59	VPWR#6	VPWR#11	38.736572
Rf60	A2#3	A2#13	40.058201
Re1	VPWR#3	VPWR	0.755546
Re2	VGND	VGND#3	0.755573
*
*       CAPACITOR CARDS
*
*
C1	a_84_74#	VGND#7	3.04167e-18
C2	a_69_368##5	a_69_368##9	1.07106e-18
C3	a_84_74##6	a_84_74##5	5.2354e-19
C4	a_69_368##5	VPWR#4	3.92936e-19
C5	a_84_74#	Y#7	2.72882e-17
C6	Y#8	VPWR#8	1.29624e-18
C7	a_69_368##10	a_69_368##6	6.05742e-19
C8	VPWR#5	A2#4	2.01982e-20
C9	a_69_368##5	VPWR#9	4.26964e-17
C10	A1#5	VPWR#9	4.84954e-19
C11	A1#4	VPWR#9	3.33578e-19
C12	a_69_368##10	VPWR#10	1.74151e-17
C13	a_69_368##6	a_69_368##5	2.59773e-18
C14	a_84_74#	Y#3	2.94395e-17
C15	a_69_368##10	a_69_368##12	1.73229e-18
C16	a_69_368##6	A1#5	1.0656e-19
C17	A2#5	A2#4	4.03955e-18
C18	a_69_368##10	VPWR#11	2.28266e-17
C19	a_69_368##11	a_69_368##10	5.34827e-19
C20	VGND#4	A1#7	4.94437e-20
C21	Y#1	Y#10	9.15809e-18
C22	A2#4	A2#2	4.0818e-18
C23	A2#4	VPWR#10	6.2216e-19
C24	VGND#4	A1#8	7.99039e-20
C25	a_84_74##3	VGND#8	5.58184e-17
C26	A2#2	VPWR#10	6.13865e-19
C27	VGND#4	A1#10	2.80855e-19
C28	a_84_74##8	a_84_74##3	1.67195e-18
C29	a_84_74##8	VGND#8	4.16102e-17
C30	A2#4	a_69_368##12	6.57862e-19
C31	VGND#4	A1#6	3.41516e-18
C32	VGND#9	VGND#8	2.92642e-18
C33	Y#2	B1#5	7.19392e-19
C34	Y#1	B1#2	3.56114e-18
C35	VGND#9	a_84_74##8	4.15829e-17
C36	VGND#4	A2#1	4.10953e-18
C37	A2#5	VPWR#11	6.06874e-19
C38	Y#2	B1#7	2.04705e-17
C39	a_84_74##6	a_84_74##8	1.72657e-18
C40	A2#4	VPWR#11	6.13865e-19
C41	VGND#4	A2#8	4.33514e-18
C42	a_84_74##6	VGND#9	4.91213e-17
C43	VGND#7	B1#2	5.3914e-19
C44	VGND#4	A2#10	6.4128e-19
C45	VGND#4	A2#4	3.80851e-20
C46	VPWR#3	A1#4	2.04712e-20
C47	Y#8	a_69_368##5	2.01545e-17
C48	a_69_368#	Y#10	7.69493e-17
C49	a_84_74##2	A1#7	2.32869e-18
C50	a_69_368##8	a_69_368#	3.51463e-18
C51	Y#10	a_69_368##8	4.1152e-17
C52	VGND#3	A1#5	4.68318e-20
C53	VGND#3	A1#4	4.42054e-20
C54	a_84_74##2	A1#8	2.41151e-17
C55	VGND#3	A1#2	1.98833e-20
C56	a_84_74##3	a_69_368##6	2.69462e-18
C57	Y#8	a_69_368##2	2.35325e-17
C58	Y#1	B1#5	3.51737e-17
C59	a_69_368#	a_69_368##3	4.75919e-21
C60	VGND#7	B1#5	3.07486e-17
C61	a_84_74##5	A1#6	3.90164e-20
C62	a_84_74##2	A1#10	2.2026e-17
C63	Y#1	B1#7	8.77516e-19
C64	VGND#4	a_84_74##5	2.91756e-19
C65	Y#7	B1#5	1.15904e-19
C66	VGND#7	B1#7	2.8354e-17
C67	a_69_368##3	a_69_368##8	3.51463e-18
C68	B1#3	B1#2	4.04006e-18
C69	a_84_74##2	A1#6	5.73603e-18
C70	a_84_74##5	A2#1	9.24914e-20
C71	Y#1	A1#7	8.46029e-20
C72	B1#7	Y#7	1.50916e-17
C73	A1#2	B1#3	7.98879e-19
C74	VGND#7	A1#7	9.95348e-19
C75	a_84_74##2	A2#1	2.16679e-19
C76	a_84_74#	B1#7	2.415e-18
C77	a_84_74##5	A2#8	1.70261e-17
C78	a_84_74#	A1#2	3.4798e-19
C79	VPWR#4	A1#1	9.67286e-20
C80	Y#7	A1#7	2.32663e-18
C81	a_84_74#	A1#7	5.05465e-17
C82	a_69_368##3	VPWR#8	3.94243e-17
C83	a_84_74##5	A2#10	1.69139e-17
C84	Y#7	A1#8	2.69462e-19
C85	Y#3	A1#7	4.26185e-17
C86	a_69_368##2	B1#6	1.58468e-17
C87	a_69_368##10	A2#5	8.71697e-19
C88	Y#3	A1#4	6.90849e-19
C89	VPWR#4	A1#9	3.20383e-19
C90	A1#4	A1#3	4.0818e-18
C91	a_84_74#	A1#8	1.60728e-18
C92	A1#3	A1#2	4.0818e-18
C93	Y#2	Y#8	5.22236e-18
C94	Y#8	B1#6	1.73137e-18
C95	a_84_74##5	A2#12	1.95034e-19
C96	Y#7	A1#10	1.64789e-19
C97	Y#3	A1#8	3.70343e-17
C98	Y#3	A1#2	1.592e-18
C99	a_69_368##2	B1#8	1.57323e-17
C100	a_69_368##5	A1#5	1.18738e-19
C101	a_69_368##10	A2#4	4.81513e-18
C102	A1#8	a_84_74##7	1.44708e-17
C103	a_84_74##6	a_69_368##11	1.7466e-17
C104	VPWR#4	A1#11	3.23494e-18
C105	Y#7	A1#6	1.13969e-19
C106	VPWR#9	VPWR#8	1.836e-18
C107	a_69_368##6	a_69_368##3	1.04806e-20
C108	Y#8	B1#8	3.35394e-17
C109	A1#10	a_84_74##7	1.44708e-17
C110	a_69_368##5	A1#4	5.41049e-19
C111	a_69_368##10	A2#2	8.93875e-19
C112	VPWR#5	A1#12	2.78329e-19
C113	A1#10	Y#6	9.2161e-18
C114	Y#8	B1#4	3.11106e-17
C115	a_69_368##5	A1#1	1.22713e-18
C116	VPWR#4	A1#12	5.69713e-18
C117	a_84_74##3	A1#10	3.8405e-19
C118	a_69_368##6	VPWR#9	3.89188e-17
C119	A1#6	Y#6	1.44891e-17
C120	VPWR#5	A2#7	7.31769e-18
C121	B1#11	Y#8	1.78656e-17
C122	Y#2	B1#4	4.94201e-18
C123	Y#8	A1#1	1.34569e-17
C124	B1#11	B1#8	2.06454e-18
C125	a_69_368##5	A1#9	3.58109e-17
C126	a_84_74##3	A1#6	4.25952e-17
C127	VPWR#10	VPWR#9	2.10055e-18
C128	VPWR#4	A2#7	4.33586e-19
C129	VGND#8	A1#6	1.09159e-18
C130	a_69_368##6	VPWR#10	5.36763e-17
C131	a_84_74##3	A2#1	2.55624e-17
C132	a_69_368##2	B1#2	6.88978e-20
C133	a_84_74##8	A1#6	1.28671e-19
C134	Y#8	A1#9	5.73707e-18
C135	a_69_368##5	A1#11	3.15107e-17
C136	VPWR#5	A2#9	5.10124e-18
C137	VGND#8	A2#1	3.16094e-17
C138	a_69_368##12	a_69_368##6	2.30759e-18
C139	VPWR#4	A2#9	1.13665e-19
C140	a_84_74##3	A2#8	3.97516e-19
C141	a_84_74##8	A2#1	3.05025e-19
C142	Y#1	B1#1	4.7609e-18
C143	a_69_368##12	VPWR#10	5.20507e-17
C144	VGND#8	A2#8	2.91738e-17
C145	Y#8	A1#11	1.02044e-19
C146	a_69_368##5	A1#12	1.24917e-18
C147	a_84_74##3	A2#10	1.67688e-19
C148	VPWR#5	A2#11	2.85183e-19
C149	A2#8	a_84_74##8	1.38198e-17
C150	VPWR#11	VPWR#10	1.94092e-18
C151	a_69_368##11	a_69_368##6	1.22373e-20
C152	a_69_368##10	A2#7	1.07385e-19
C153	VGND#8	A2#10	1.43011e-18
C154	Y#2	B1#11	1.94966e-17
C155	VGND#9	A2#8	1.70046e-18
C156	VPWR#11	a_69_368##12	5.30395e-17
C157	Y#8	B1#2	3.3668e-19
C158	Y#8	A1#12	7.13992e-20
C159	A2#10	a_84_74##8	1.72195e-17
C160	a_69_368##5	A2#7	2.11095e-19
C161	a_84_74##6	A2#8	1.87602e-19
C162	VGND#9	A2#10	3.4037e-17
C163	a_69_368##11	a_69_368##12	2.03743e-18
C164	VPWR#5	A2#6	1.40614e-19
C165	a_69_368##10	A2#9	1.74917e-17
C166	a_84_74##8	A2#12	6.43198e-19
C167	a_84_74##6	A2#10	8.48022e-19
C168	a_69_368##11	VPWR#11	5.43456e-17
C169	VGND#9	A2#12	3.02801e-17
C170	a_84_74##6	A2#12	3.29144e-17
C171	a_69_368##10	A2#11	1.75541e-17
C172	A1#15	A1#9	2.08017e-18
C173	a_69_368##10	A2#6	2.14322e-19
C174	VPWR#3	VPWR#5	3.44664e-17
C175	Y#8	A1#2	2.02248e-19
C176	B1#7	B1#5	3.96175e-17
C177	VPWR#3	VPWR#4	2.76453e-17
C178	a_69_368#	B1#1	4.3734e-17
C179	Y#10	B1#1	4.82655e-17
C180	a_69_368#	B1#6	1.72079e-18
C181	a_69_368##8	B1#1	1.29161e-18
C182	A1#7	B1#7	4.25016e-18
C183	A1#15	Y#8	7.40944e-18
C184	B1	B1#2	2.148e-17
C185	VGND#8	A2#4	3.36627e-19
C186	Y#10	B1#6	5.5736e-17
C187	B1	A1#2	4.39242e-18
C188	a_69_368#	B1#8	5.34371e-19
C189	B1#6	a_69_368##8	2.39036e-17
C190	VGND#8	A2#2	5.06958e-19
C191	Y#10	B1#8	1.37698e-18
C192	A1#8	A1#7	3.76117e-17
C193	a_69_368#	B1#4	1.42355e-19
C194	VGND#3	VGND#4	4.48577e-17
C195	B1#8	a_69_368##8	2.73382e-17
C196	a_69_368##3	B1#6	3.00902e-19
C197	a_69_368##5	VPWR#3	1.67972e-17
C198	B1#8	Y#9	2.32435e-17
C199	A1#10	A1#8	3.95484e-17
C200	a_69_368#	A1#1	9.69326e-20
C201	a_69_368##8	B1#4	6.2318e-19
C202	a_69_368##3	B1#8	6.72697e-19
C203	B1#4	Y#9	2.32435e-17
C204	A1	A1#5	5.15796e-20
C205	Y#2	B1#2	1.44106e-18
C206	A1	A1#4	1.41236e-17
C207	A1	A1#2	1.27788e-17
C208	a_69_368##8	A1#1	2.68812e-19
C209	a_69_368##3	B1#4	3.73884e-17
C210	A1#6	A1#10	3.872e-17
C211	a_69_368##3	A1#1	5.62032e-17
C212	A1#1	VPWR#8	2.47176e-17
C213	VGND#4	a_84_74##3	2.81615e-17
C214	VGND#9	A2#5	1.20272e-19
C215	A2#1	A1#6	4.02524e-17
C216	a_69_368##3	A1#9	1.34652e-18
C217	a_69_368##2	B1#3	1.76267e-19
C218	a_69_368##6	B1#4	6.60276e-20
C219	Y#8	B1#3	3.29569e-18
C220	A1#9	VPWR#8	2.6948e-17
C221	VPWR#9	A1#1	1.63173e-19
C222	VGND#9	A2#4	6.45351e-19
C223	A2	A1#5	1.08223e-17
C224	A1#9	a_69_368##9	2.32435e-17
C225	a_69_368##6	A1#1	9.5533e-20
C226	a_69_368##5	A1#3	6.75577e-19
C227	A2#8	A2#1	3.96767e-17
C228	Y#2	B1#3	4.75443e-18
C229	A2	A2#5	1.53144e-17
C230	A2	A2#4	3.67226e-17
C231	VPWR#8	A1#11	3.25542e-19
C232	VPWR#9	A1#9	3.51409e-19
C233	A2	A2#2	1.69515e-17
C234	VGND#3	a_84_74##2	7.06872e-17
C235	A1#11	a_69_368##9	2.32435e-17
C236	a_69_368##6	A1#9	1.52758e-19
C237	Y#8	A1#3	1.50256e-18
C238	a_69_368#	B1#2	6.80088e-20
C239	B1#11	B1#3	1.0675e-17
C240	A1#11	VPWR#9	2.17029e-17
C241	VPWR#8	A1#12	1.45657e-19
C242	A2#10	A2#8	4.09582e-17
C243	Y#2	Y#1	2.49051e-18
C244	VPWR#5	VPWR#4	9.40188e-19
C245	a_69_368##6	A1#11	6.65687e-19
C246	a_84_74##6	A2#5	7.09132e-20
C247	B1#2	B1#1	1.07265e-18
C248	VGND#4	a_84_74##8	5.19931e-18
C249	VPWR#9	A1#12	3.50574e-17
C250	a_69_368##6	A1#12	3.37767e-17
C251	A2#12	A2#10	3.9603e-17
C252	Y#2	VGND#7	2.26443e-17
C253	VPWR#10	A1#12	3.32219e-19
C254	VPWR#9	A2#7	1.1231e-18
C255	Y	A1#5	1.3657e-17
C256	Y	A1#4	9.38041e-18
C257	Y	A1#2	2.77709e-19
C258	Y	A2#5	1.81462e-19
C259	a_69_368##6	A2#7	6.34359e-17
C260	Y	A2#4	4.35457e-19
C261	a_84_74##2	A1#3	3.81727e-19
C262	VGND#3	a_84_74#	3.25391e-17
C263	Y	A2#2	5.99272e-18
C264	A2#7	VPWR#10	2.46613e-17
C265	VPWR#9	A2#9	1.77882e-19
C266	Y#3	Y#8	1.9073e-18
C267	VGND#7	B1#3	2.84838e-19
C268	Y#10	B1#2	4.47563e-18
C269	a_69_368##12	A2#7	1.66337e-18
C270	A1#15	A1#3	1.05697e-17
C271	a_69_368##6	A2#9	2.07727e-18
C272	a_69_368##11	A1#12	9.69326e-20
C273	Y#2	Y#7	1.0002e-18
C274	VPWR#11	A2#7	1.72497e-19
C275	A2#9	VPWR#10	2.84583e-17
C276	VGND#3	a_84_74##3	1.44144e-18
C277	a_69_368##12	A2#9	5.23881e-17
C278	a_69_368##11	A2#7	1.42355e-19
C279	VPWR#11	A2#9	6.87375e-19
C280	VPWR#10	A2#11	3.44144e-19
C281	a_84_74#	A1#3	3.89663e-19
C282	a_69_368##11	A2#9	2.33468e-19
C283	a_69_368##12	A2#11	4.59893e-17
C284	Y#2	a_84_74#	1.51454e-17
C285	B1#6	B1#1	4.5933e-17
C286	Y#3	A1#3	3.76208e-18
C287	A2#11	VPWR#11	2.25963e-17
C288	VPWR#10	A2#6	2.5029e-19
C289	a_69_368##11	A2#11	1.1603e-18
C290	a_69_368##12	A2#6	2.07075e-18
C291	VPWR#11	A2#6	4.41308e-17
C292	B1#8	B1#6	4.70881e-17
C293	B1#2	a_69_368##8	5.8589e-19
C294	a_69_368##11	A2#6	4.15694e-17
C295	B1#3	a_69_368##8	6.10011e-19
C296	B1#3	Y#9	5.62838e-19
C297	B1#4	B1#8	4.60496e-17
C298	B1	Y#8	5.31407e-17
C299	A1#5	A1#4	3.45039e-18
C300	Y#2	B1	6.06728e-17
C301	A1#1	B1#4	4.79902e-17
C302	a_69_368##3	A1#3	2.894e-20
C303	a_84_74##6	a_69_368##10	2.78833e-20
C304	A1#3	VPWR#8	8.91208e-19
C305	A1#3	a_69_368##9	2.70455e-19
C306	A1	Y#8	4.05591e-17
C307	A1#9	A1#1	4.72479e-17
C308	VGND#3	A1#7	4.43427e-18
C309	A2	a_69_368##10	9.4781e-17
C310	VGND#3	A1#8	4.43427e-18
C311	A1#11	A1#9	4.57822e-17
C312	Y#1	B1	1.95467e-17
C313	VGND#3	A1#10	4.43427e-18
C314	VGND#3	A1#6	1.63329e-18
C315	A1#12	A1#11	4.65479e-17
C316	B1#2	VNB	3.75558e-17
C317	a_84_74##5	A2	8.74016e-17
C318	A1#5	VNB	2.21394e-17
C319	A1#4	VNB	2.58155e-17
C320	A1#2	VNB	2.40793e-17
C321	Y	a_69_368##5	5.76364e-17
C322	A2#5	VNB	4.20406e-17
C323	A2#7	A1#12	4.73033e-17
C324	A2#4	VNB	5.58828e-17
C325	A2#2	VNB	2.63563e-17
C326	Y#3	A1	5.60912e-17
C327	A1#2	B1#4	1.83899e-17
C328	VPWR	VPWR#5	2.95163e-17
C329	VPWR	VPWR#4	2.82978e-17
C330	B1	Y#10	1.95187e-17
C331	A2#9	A2#7	4.75217e-17
C332	a_84_74##2	a_84_74#	6.86522e-18
C333	VPWR	a_69_368##10	3.25822e-18
C334	a_84_74##2	Y	5.08458e-17
C335	VPWR	a_69_368##5	1.92651e-17
C336	VPWR#3	A1#9	1.60515e-18
C337	A2#11	A2#9	4.58636e-17
C338	VPWR	a_69_368##2	2.76067e-17
C339	A1#15	Y	1.01315e-17
C340	a_84_74##3	A2	2.97435e-17
C341	VPWR	Y#8	1.25671e-17
C342	VPWR#3	A1#11	2.05493e-18
C343	B1#4	B1#3	8.80061e-19
C344	a_84_74##6	A2	1.48151e-17
C345	Y	Y#7	1.29624e-18
C346	VPWR	B1#11	1.08151e-18
C347	A2#6	A2#11	4.68327e-17
C348	a_84_74##2	Y#3	2.66469e-17
C349	VGND	VGND#4	4.49752e-17
C350	a_69_368##6	VPWR#5	6.50598e-18
C351	Y	Y#6	1.24377e-19
C352	a_84_74##3	Y	5.87023e-17
C353	VPWR	A1#15	1.07755e-18
C354	A2	a_69_368##6	3.24726e-17
C355	a_69_368##6	VPWR#4	7.71837e-18
C356	VGND	Y#2	6.28258e-18
C357	Y	Y#9	1.72428e-20
C358	VGND	B1#11	1.14927e-18
C359	a_69_368##3	A1#2	5.46413e-20
C360	a_69_368##2	Y#10	1.6243e-17
C361	VGND	a_84_74##5	3.93663e-18
C362	a_84_74##2	a_84_74##7	9.78911e-19
C363	VPWR#5	VNB	2.5743e-17
C364	VPWR#4	VNB	2.01848e-17
C365	VGND	a_84_74##2	2.71407e-17
C366	Y	a_69_368##9	6.62017e-19
C367	Y	VPWR#9	7.26647e-19
C368	VGND	A1#15	1.16192e-18
C369	a_69_368##6	Y	4.33388e-17
C370	VGND#4	VNB	3.34588e-17
C371	VPWR	a_69_368#	2.27155e-17
C372	B1	B1#1	1.56479e-18
C373	a_84_74##5	a_84_74##3	5.06977e-19
C374	VPWR	Y#10	8.92697e-18
C375	VGND	Y#1	1.4983e-17
C376	B1	B1#6	2.42002e-18
C377	VGND	Y#7	1.38229e-17
C378	a_69_368##5	VNB	2.09331e-18
C379	VGND	a_84_74#	1.95134e-17
C380	VPWR	a_69_368##3	1.95273e-17
C381	a_69_368##2	VNB	5.40563e-18
C382	VGND	Y#3	7.56743e-18
C383	Y#8	Y#10	3.01982e-18
C384	B1	B1#4	1.14608e-17
C385	a_69_368##10	VPWR#5	3.13618e-19
C386	Y	B1#7	1.94798e-19
C387	VPWR#3	A1#3	1.98672e-20
C388	Y#2	VNB	1.09795e-17
C389	VGND	a_84_74##3	1.54343e-17
C390	Y	A1#7	2.92337e-19
C391	B1	A1#1	6.85351e-19
C392	VPWR	a_69_368##6	1.70066e-17
C393	B1#11	VNB	3.68863e-19
C394	VGND	a_84_74##8	1.09176e-17
C395	Y	A1#8	5.87621e-19
C396	VGND#3	A1#3	4.74281e-20
C397	a_84_74##5	VNB	1.69656e-18
C398	Y	A1#10	2.63774e-17
C399	VPWR#10	VPWR#4	9.60252e-20
C400	a_84_74##2	Y#6	3.88319e-19
C401	VGND	a_84_74##6	1.46596e-17
C402	VPWR	a_69_368##12	1.5835e-17
C403	a_69_368##2	a_69_368##8	5.47123e-20
C404	a_84_74##2	VNB	5.07037e-18
C405	VGND	a_69_368#	8.29342e-18
C406	Y	A1#6	1.6488e-17
C407	A1	B1#4	5.17905e-18
C408	VPWR	a_69_368##11	1.51902e-17
C409	Y	A2#1	1.52876e-18
C410	a_84_74##5	A2#5	3.81517e-19
C411	A1	A1#1	2.37767e-18
C412	A1#15	VNB	9.75442e-19
C413	Y	A2#8	2.42556e-19
C414	Y#1	VNB	4.25083e-17
C415	Y	A2#10	1.27887e-19
C416	VGND#7	VNB	2.25711e-18
C417	a_84_74##5	VGND#8	2.26406e-17
C418	Y#7	VNB	6.90539e-18
C419	Y	A2#12	1.56433e-19
C420	A1	A1#11	1.65779e-18
C421	Y#1	VGND#7	4.90368e-17
C422	a_84_74#	VNB	7.52577e-18
C423	Y#3	VNB	1.76977e-18
C424	A1	A1#12	2.17178e-19
C425	Y#3	A1#15	2.04844e-17
C426	a_84_74##3	VNB	4.39373e-18
C427	VGND#8	VNB	4.67461e-20
C428	a_84_74##8	VNB	4.55126e-18
C429	a_69_368##12	VPWR#5	8.43957e-18
C430	VGND#9	VNB	2.25711e-18
C431	VGND	a_69_368##11	5.40091e-18
C432	Y	B1#8	9.12678e-20
C433	a_84_74##6	VNB	4.57504e-17
C434	Y#8	a_69_368##8	4.70952e-17
C435	VGND	B1#5	1.65497e-18
C436	a_69_368#	VNB	7.02735e-17
C437	Y	B1#4	1.3528e-19
C438	A2	A1#12	1.0205e-18
C439	VGND	B1#7	9.02816e-19
C440	VGND	A1#7	1.45944e-18
C441	Y	A1#1	2.15511e-19
C442	A2	A2#7	2.02596e-18
C443	VGND	A1#8	1.61491e-18
C444	a_69_368##5	a_69_368##3	2.94218e-18
C445	a_69_368##3	VNB	2.25696e-18
C446	VPWR	B1#1	2.33608e-18
C447	Y	A1#9	7.07475e-18
C448	a_84_74##3	a_84_74##2	2.67476e-18
C449	VGND	A1#10	1.50215e-18
C450	VPWR#8	VNB	2.79388e-18
C451	A2	A2#9	2.04629e-18
C452	VPWR	B1#6	1.67345e-18
C453	VGND	A1#6	1.4866e-18
C454	Y	A1#11	1.55315e-17
C455	VPWR#9	VNB	3.91088e-19
C456	VGND	A2#1	8.64956e-19
C457	VPWR	B1#8	1.59974e-18
C458	A2	A2#11	2.05823e-18
C459	a_69_368##6	VNB	2.28035e-18
C460	Y	A1#12	8.77297e-18
C461	VGND	A2#8	6.66852e-19
C462	VPWR#10	VNB	2.91397e-18
C463	VPWR	B1#4	1.52729e-18
C464	B1	B1#3	1.05755e-17
C465	a_84_74##5	A2#4	6.36192e-18
C466	a_69_368##2	Y#9	7.14964e-19
C467	A2	A2#6	2.48398e-18
C468	a_69_368##12	VNB	2.1429e-18
C469	VGND	A2#10	6.66852e-19
C470	Y	A2#7	1.33402e-18
C471	A1#2	VPWR#8	1.19043e-19
C472	VPWR	A1#1	1.00199e-18
C473	VPWR#11	VNB	2.60465e-18
C474	VGND	A2#12	1.80169e-18
C475	a_69_368##11	VNB	6.14465e-17
C476	Y	A2#9	2.89391e-19
C477	VPWR	A1#9	1.21033e-18
C478	Y#7	Y#1	2.87289e-19
C479	B1#5	VNB	3.01272e-17
C480	B1#7	VNB	2.75503e-17
C481	VGND	B1#1	2.76479e-18
C482	VPWR	A1#11	5.71781e-19
C483	Y	A2#11	1.46454e-19
C484	a_84_74##5	a_84_74##8	1.24483e-18
C485	A1#7	VNB	3.41046e-17
C486	VPWR	A1#12	5.96526e-19
C487	A1#8	VNB	2.84284e-17
C488	Y	A2#6	1.80957e-19
C489	A1	A1#3	9.73315e-18
C490	A1#10	VNB	2.85452e-17
C491	VPWR	A2#7	2.91982e-19
C492	A1#6	VNB	2.93717e-17
C493	A2#1	VNB	2.4852e-17
C494	VPWR	A2#9	8.15937e-19
C495	A2#8	VNB	2.50231e-17
C496	VPWR	A2#11	8.56064e-19
C497	A2#10	VNB	2.51149e-17
C498	A2#12	VNB	3.35334e-17
C499	VPWR	A2#6	2.21152e-18
C500	B1#1	VNB	6.9279e-17
C501	Y	B1#3	2.08471e-19
C502	B1#6	VNB	3.17125e-17
C503	a_84_74##2	A1#5	2.17365e-19
C504	VPWR	VPWR#3	8.85114e-18
C505	B1#8	VNB	3.21374e-17
C506	Y	A1#3	1.18316e-18
C507	Y#8	Y#9	1.07849e-18
C508	B1#4	VNB	5.74239e-17
C509	A1#1	VNB	3.24646e-17
C510	A1#9	VNB	3.33799e-17
C511	A1#11	VNB	3.15538e-17
C512	A1	B1	2.66366e-17
C513	A1#12	VNB	2.96429e-17
C514	A2#7	VNB	3.41164e-17
C515	a_69_368##5	VPWR#8	4.28947e-17
C516	VGND	VGND#3	2.7578e-17
C517	A2#9	VNB	3.20597e-17
C518	a_84_74##5	A2#2	1.34991e-18
C519	Y#7	VGND#7	4.06366e-17
C520	A2#11	VNB	3.05852e-17
C521	A2#6	VNB	4.01874e-17
C522	VPWR#3	VNB	2.63705e-16
C523	VGND#3	VNB	2.9697e-16
C524	Y	A1	9.08798e-17
C525	B1#3	VNB	3.44533e-17
C526	VPWR	B1	4.48786e-18
C527	a_84_74##5	VGND#9	2.2577e-17
C528	A1#3	VNB	3.13484e-17
C529	A2	Y	3.11391e-17
C530	VPWR	A1	4.64664e-18
C531	VGND	B1	4.96387e-18
C532	VPWR	A2	8.40801e-18
C533	VGND	A1	4.83734e-18
C534	A2#2	A1#5	2.62515e-17
C535	VPWR	Y	5.68066e-18
C536	VGND	A2	8.70782e-18
C537	B1	VNB	2.33481e-17
C538	A1	VNB	9.41544e-18
C539	VGND	Y	9.48202e-18
C540	A2	VNB	2.83173e-17
C541	Y	VNB	1.89251e-18
C542	VPWR	VNB	8.93509e-17
C543	a_84_74##2	A1#4	5.42464e-19
C544	VGND	VNB	9.49496e-17
C545	A1#4	a_69_368##9	2.74109e-19
C546	Y#8	a_69_368##3	8.91601e-17
C547	VPWR#2	A1#11	5.65677e-19
C548	VGND#5	A2#8	6.41281e-19
C549	VPWR#4	VPWR#2	7.0017e-19
C550	VGND#2	Y#1	1.78904e-17
C551	VGND#2	VNB	8.56898e-17
C552	VPWR#2	B1#2	3.26683e-20
C553	VPWR#6	A2#6	4.63829e-18
C554	VGND#2	Y#2	2.58223e-18
C555	VGND#3	VGND#2	9.33113e-17
C556	VPWR#2	B1#8	4.63908e-18
C557	VGND#5	VNB	5.7218e-17
C558	VPWR#2	A1#12	9.00513e-20
C559	VGND#2	A1#7	4.62732e-19
C560	VPWR	VPWR#6	5.40674e-17
C561	VGND#5	A2#10	4.37213e-18
C562	a_69_368##12	VPWR#6	8.03471e-18
C563	VPWR#6	VPWR#5	7.0017e-19
C564	VGND#5	A2#5	4.13281e-20
C565	a_69_368##5	VPWR#2	8.02592e-19
C566	VPWR#2	VNB	9.83232e-17
C567	VPWR#2	B1#4	4.92326e-18
C568	VPWR#3	VPWR#6	5.85877e-17
C569	VGND#5	a_84_74##5	2.91756e-19
C570	VGND#5	a_84_74##6	1.7841e-17
C571	VGND#2	B1#3	9.47593e-20
C572	VPWR#3	VPWR#2	1.18733e-16
C573	VGND#2	A1#8	5.38534e-20
C574	VPWR#6	VNB	5.37769e-17
C575	VGND#5	A2#12	4.10694e-18
C576	VPWR#2	A1#1	4.90594e-18
C577	a_69_368##3	VPWR#2	4.09379e-17
C578	VGND#5	A2#4	3.62715e-20
C579	VGND#2	B1#5	4.1074e-18
C580	VPWR#6	A2#4	2.86596e-20
C581	a_69_368##11	VPWR#6	1.7913e-17
C582	VGND#2	Y#7	1.44494e-17
C583	VPWR#6	A2#7	8.74044e-20
C584	VGND#3	VGND#5	6.03591e-17
C585	VPWR#2	B1#1	4.53948e-18
C586	VGND#2	B1#2	4.47514e-20
C587	a_69_368##2	VPWR#2	6.96699e-17
C588	VGND	VGND#2	8.00318e-17
C589	a_69_368#	VPWR#2	5.05771e-17
C590	VPWR#2	A1#9	4.61854e-18
C591	VPWR#6	A2#9	5.45681e-19
C592	VGND#2	A1#10	3.80068e-20
C593	VGND#2	B1#4	2.52621e-19
C594	a_69_368##10	VPWR#6	3.13618e-19
C595	VPWR#2	B1#3	3.46731e-20
C596	VGND#2	B1#7	4.10822e-18
C597	VGND	VGND#5	6.15685e-17
C598	VGND#5	a_84_74##8	5.24871e-18
C599	VGND#2	B1#1	3.84452e-19
C600	VGND#5	VGND#4	1.14921e-18
C601	VPWR	VPWR#2	7.28464e-17
C602	VGND#2	a_84_74#	1.2321e-17
C603	VPWR#6	A2#11	5.36773e-18
C604	VPWR#2	B1#6	4.51664e-18
*
*
.ENDS sky130_fd_sc_hs__a21oi_4
*
