* Extracted by Quantus, converted by sky130cad/quantus.py
*
*
*
*                       LINUX           Wed Nov 18 08:26:44 2026
*
*
*
*  PROGRAM  advgen
*
*  Name           : advgen - Quantus - (64-bit)
*  Version        : 25.1.0-p047
*  Build Date     : Thu Dec 11 23:20:30 PST 2025
*
*  HSPICE LIBRARY
*
*  OPERATING_TEMPERATURE 150
*  QRC_TECH_DIR <path>/tech
*
*
*

*
.SUBCKT sky130_fd_sc_hs__dfrbp_2 VPB VNB VGND RESET_B VPWR Q_N Q D CLK
*
*
*  caps2d version: 10
*
*
*       TRANSISTOR CARDS
*
*
XM10 a_70_74##5 D#1 a_156_74# VNB sky130_fd_pr__nfet_01v8_lvt l=0.15 w=0.42 ad=0.1176 as=0.1008 pd=1.4 ps=1.32
XM6 a_156_74# RESET_B#1 VGND#19 VNB sky130_fd_pr__nfet_01v8_lvt l=0.15 w=0.42 ad=0.1008 as=0.227 pd=1.32 ps=2.18
XM36 VGND#19 a_298_294##4 a_331_392##11 VNB sky130_fd_pr__nfet_01v8_lvt l=0.15 w=0.74 ad=0.227 as=0.2109 pd=2.18 ps=2.05
XM16 VGND#18 RESET_B#4 a_536_81# VNB sky130_fd_pr__nfet_01v8_lvt l=0.15 w=0.42 ad=0.1281 as=0.1008 pd=1.45 ps=1.32
XM5 a_536_81# a_331_392##3 a_614_81##2 VNB sky130_fd_pr__nfet_01v8_lvt l=0.15 w=0.42 ad=0.1008 as=0.1281 pd=1.32 ps=1.45
XM8 a_70_74##6 a_728_331##4 a_298_294##5 VNB sky130_fd_pr__nfet_01v8_lvt l=0.15 w=0.42 ad=0.1456 as=0.1176 pd=1.63 ps=1.4
XM7 a_298_294##5 a_818_418##4 a_614_81# VNB sky130_fd_pr__nfet_01v8_lvt l=0.15 w=0.42 ad=0.1176 as=0.2184 pd=1.4 ps=1.88
XM11 a_818_418##12 a_728_331##3 VGND#17 VNB sky130_fd_pr__nfet_01v8_lvt l=0.15 w=0.74 ad=0.1998 as=0.7966 pd=2.02 ps=4.01
XM1 VGND#17 CLK#3 a_728_331##15 VNB sky130_fd_pr__nfet_01v8_lvt l=0.15 w=0.74 ad=0.7966 as=0.2109 pd=4.01 ps=2.05
XM4 a_1499_149##2 a_728_331##9 a_1586_149##17 VNB sky130_fd_pr__nfet_01v8_lvt l=0.15 w=0.42 ad=0.1197 as=0.2165 pd=1.41 ps=2.13
XM18 a_1586_149##17 a_818_418##7 a_331_392##4 VNB sky130_fd_pr__nfet_01v8_lvt l=0.15 w=0.74 ad=0.2165 as=0.31255 pd=2.13 ps=2.62
XM24 a_1499_149# a_1800_291# VGND#16 VNB sky130_fd_pr__nfet_01v8_lvt l=0.15 w=0.42 ad=0.1155 as=0.1176 pd=1.39 ps=1.4
XM34 VGND#16 RESET_B#7 a_1974_74# VNB sky130_fd_pr__nfet_01v8_lvt l=0.15 w=0.42 ad=0.1176 as=0.0882 pd=1.4 ps=1.26
XM28 a_1974_74# a_1586_149##8 a_1800_291##4 VNB sky130_fd_pr__nfet_01v8_lvt l=0.15 w=0.42 ad=0.0882 as=0.1197 pd=1.26 ps=1.41
XM30 Q_N#1 a_1586_149##11 VGND#15 VNB sky130_fd_pr__nfet_01v8_lvt l=0.15 w=0.74 ad=0.2072 as=0.2109 pd=2.04 ps=2.05
XM20 VGND#14 a_1586_149##10 Q_N#1 VNB sky130_fd_pr__nfet_01v8_lvt l=0.15 w=0.74 ad=0.233 as=0.2072 pd=2.13 ps=2.04
XM21 VGND#14 a_1586_149# a_2363_352##11 VNB sky130_fd_pr__nfet_01v8_lvt l=0.15 w=0.64 ad=0.233 as=0.1728 pd=2.13 ps=1.82
XM2 Q#2 a_2363_352##6 VGND#13 VNB sky130_fd_pr__nfet_01v8_lvt l=0.15 w=0.74 ad=0.2072 as=0.1998 pd=2.04 ps=2.02
XM32 VGND#1 a_2363_352# Q#2 VNB sky130_fd_pr__nfet_01v8_lvt l=0.15 w=0.74 ad=0.1998 as=0.2072 pd=2.02 ps=2.04
XM26 VPWR#13 D#4 a_70_74##3 VPB sky130_fd_pr__pfet_01v8 l=0.15 w=0.42 ad=0.1449 as=0.126 pd=1.53 ps=1.44
XM29 a_70_74##3 RESET_B#3 VPWR#11 VPB sky130_fd_pr__pfet_01v8 l=0.15 w=0.42 ad=0.126 as=0.77145 pd=1.44 ps=5.4
XM22 VPWR#11 a_298_294##3 a_331_392##8 VPB sky130_fd_pr__pfet_01v8 l=0.15 w=1 ad=0.77145 as=0.295 pd=5.4 ps=2.59
XM23 a_298_294##10 RESET_B#6 VPWR#19 VPB sky130_fd_pr__pfet_01v8 l=0.15 w=0.42 ad=0.1176 as=0.28295 pd=1.4 ps=2.24
XM25 VPWR#19 a_331_392# a_683_485# VPB sky130_fd_pr__pfet_01v8 l=0.15 w=0.42 ad=0.28295 as=0.1008 pd=2.24 ps=1.32
XM35 a_683_485# a_728_331##5 a_298_294##9 VPB sky130_fd_pr__pfet_01v8 l=0.15 w=0.42 ad=0.1008 as=0.126 pd=1.32 ps=1.44
XM15 a_298_294##9 a_818_418##3 a_70_74# VPB sky130_fd_pr__pfet_01v8 l=0.15 w=0.42 ad=0.126 as=0.2793 pd=1.44 ps=2.17
XM12 a_818_418##9 a_728_331# VPWR#18 VPB sky130_fd_pr__pfet_01v8 l=0.15 w=1.12 ad=0.3304 as=0.74445 pd=2.83 ps=3.61
XM3 VPWR#18 CLK#1 a_728_331##11 VPB sky130_fd_pr__pfet_01v8 l=0.15 w=1.12 ad=0.74445 as=0.3304 pd=3.61 ps=2.83
XM9 a_331_392##9 a_728_331##6 a_1586_149##15 VPB sky130_fd_pr__pfet_01v8 l=0.15 w=1 ad=0.28 as=0.3763 pd=2.56 ps=3.06
XM13 a_1586_149##15 a_818_418##5 a_1755_389# VPB sky130_fd_pr__pfet_01v8 l=0.15 w=0.42 ad=0.3763 as=0.1134 pd=3.06 ps=1.38
XM17 a_1755_389# a_1800_291##3 VPWR#17 VPB sky130_fd_pr__pfet_01v8 l=0.15 w=0.42 ad=0.1134 as=0.2852 pd=1.38 ps=2.31
XM27 VPWR#17 RESET_B#9 a_1800_291##5 VPB sky130_fd_pr__pfet_01v8 l=0.15 w=0.42 ad=0.2852 as=0.126 pd=2.31 ps=1.44
XM0 a_1800_291##5 a_1586_149##14 VPWR#16 VPB sky130_fd_pr__pfet_01v8 l=0.15 w=0.42 ad=0.126 as=0.36265 pd=1.44 ps=3.01
XM33 VPWR#16 a_1586_149##13 Q_N#3 VPB sky130_fd_pr__pfet_01v8 l=0.15 w=1.12 ad=0.36265 as=0.336 pd=3.01 ps=2.84
XM14 Q_N#3 a_1586_149##12 VPWR#15 VPB sky130_fd_pr__pfet_01v8 l=0.15 w=1.12 ad=0.336 as=0.4204 pd=2.84 ps=3.01
XM31 VPWR#15 a_1586_149##9 a_2363_352##10 VPB sky130_fd_pr__pfet_01v8 l=0.15 w=1 ad=0.4204 as=0.39 pd=3.01 ps=2.78
XM19 Q#1 a_2363_352##7 VPWR#14 VPB sky130_fd_pr__pfet_01v8 l=0.15 w=1.12 ad=0.336 as=0.3864 pd=2.84 ps=2.93
XM37 VPWR#1 a_2363_352##5 Q#1 VPB sky130_fd_pr__pfet_01v8 l=0.15 w=1.12 ad=0.3864 as=0.336 pd=2.93 ps=2.84
*
*
*       RESISTOR AND CAP/DIODE CARDS
*
Rg1	D#1	D#2	382.823700
Rg2	D#2	D#3	12.779243
Rg3	D#2	D#4	508.413574
Rg4	RESET_B#1	RESET_B#2	531.743835
Rg5	RESET_B#2	RESET_B#3	242.670593
Rg6	a_298_294#	a_298_294##2	63.097591
Rg7	a_298_294##2	a_298_294##3	415.223511
Rg8	a_298_294##2	a_298_294##4	466.419159
Rg9	RESET_B#4	RESET_B#5	521.208008
Rg10	RESET_B#5	RESET_B#6	455.995178
Rg11	a_331_392#	a_331_392##2	450.000275
Rg12	a_331_392##2	a_331_392##3	552.452698
Rg13	a_818_418#	a_818_418##2	277.772339
Rg14	a_818_418##2	a_818_418##3	254.856247
Rg15	a_818_418##2	a_818_418##4	479.372437
Rg16	a_728_331#	a_728_331##2	424.048981
Rg17	a_728_331##2	a_728_331##3	388.722687
Rg18	a_728_331##3	a_728_331##4	1722.964233
Rg19	a_728_331##4	a_728_331##5	651.752991
Rg20	CLK#1	CLK#2	428.305603
Rg21	CLK#2	CLK#3	310.172485
Rg22	a_728_331##6	a_728_331##7	395.736847
Rg23	a_728_331##7	a_728_331##8	242.916214
Rg24	a_728_331##7	a_728_331##9	446.337891
Rg25	a_818_418##5	a_818_418##6	344.610077
Rg26	a_818_418##6	a_818_418##7	309.865570
Rg27	a_1800_291#	a_1800_291##2	516.151428
Rg28	a_1800_291##2	a_1800_291##3	241.966049
Rg29	RESET_B#7	RESET_B#8	531.743835
Rg30	RESET_B#8	RESET_B#9	236.008316
Rg31	a_1586_149#	a_1586_149##2	354.265839
Rg32	a_1586_149##2	a_1586_149##3	20.478601
Rg33	a_1586_149##3	a_1586_149##4	54.194763
Rg34	a_1586_149##4	a_1586_149##5	58.216370
Rg35	a_1586_149##5	a_1586_149##6	49.530773
Rg36	a_1586_149##6	a_1586_149##7	90.697044
Rg37	a_1586_149##7	a_1586_149##8	236.204941
Rg38	a_1586_149##2	a_1586_149##9	388.884644
Rg39	a_1586_149##3	a_1586_149##10	279.764954
Rg40	a_1586_149##4	a_1586_149##11	369.229248
Rg41	a_1586_149##4	a_1586_149##12	478.263000
Rg42	a_1586_149##5	a_1586_149##13	423.316345
Rg43	a_1586_149##6	a_1586_149##14	364.791687
Rg44	a_2363_352#	a_2363_352##2	384.320526
Rg45	a_2363_352##2	a_2363_352##3	59.578423
Rg46	a_2363_352##3	a_2363_352##4	39.846054
Rg47	a_2363_352##2	a_2363_352##5	474.928162
Rg48	a_2363_352##3	a_2363_352##6	379.087921
Rg49	a_2363_352##4	a_2363_352##7	448.418579
Rf1	D	D#5	1.274623
Rf2	D#6	D#3	81.391022
Rf3	D#5	D#6	10.404759
Rf4	D	D#8	1.274623
Rf5	D#6	D#8	2.013824
Rf6	RESET_B#2	RESET_B#11	161.345215
Rf7	RESET_B#12	RESET_B#13	1.112414
Rf8	RESET_B#11	RESET_B#12	3.346218
Rf9	RESET_B#5	RESET_B#15	161.203506
Rf10	RESET_B#16	RESET_B	10.748486
Rf11	RESET_B#15	RESET_B#16	3.543054
Rf12	a_298_294##5	a_298_294##6	45.590305
Rf13	a_298_294##6	a_298_294##7	111.764641
Rf14	a_298_294##7	a_298_294#	192.650406
Rf15	a_298_294##6	a_298_294##9	36.586239
Rf16	a_298_294##7	a_298_294##10	38.306351
Rf17	a_614_81#	a_614_81##2	173.621521
Rf18	a_70_74#	a_70_74##2	13.424774
Rf19	a_70_74##2	a_70_74##4	374.331726
Rf20	a_70_74##4	a_70_74##5	139.105316
Rf21	a_70_74##2	a_70_74##6	193.696976
Rf22	a_70_74##3	a_70_74##4	15.000000
Rf23	CLK#4	CLK	2.155494
Rf24	CLK#2	CLK#6	162.388290
Rf25	CLK#4	CLK#6	8.035555
Rf26	a_728_331##8	a_728_331##12	177.457352
Rf27	a_728_331##12	a_728_331##13	47.447388
Rf28	a_728_331##13	a_728_331##2	89.942253
Rf29	a_728_331##13	a_728_331##15	77.172104
Rf30	a_728_331##11	a_728_331##12	15.000000
Rf31	a_818_418##6	a_818_418##10	478.681335
Rf32	a_818_418##10	a_818_418##11	12.783381
Rf33	a_818_418##11	a_818_418##12	50.099384
Rf34	a_818_418##11	a_818_418#	88.346596
Rf35	a_818_418##9	a_818_418##10	5.000000
Rf36	a_331_392##4	a_331_392##5	111.159439
Rf37	a_331_392##5	a_331_392##6	415.300354
Rf38	a_331_392##6	a_331_392##7	63.706272
Rf39	a_331_392##7	a_331_392##8	123.012840
Rf40	a_331_392##5	a_331_392##9	174.376465
Rf41	a_331_392##6	a_331_392##2	209.797272
Rf42	a_331_392##7	a_331_392##11	21.656248
Rf43	a_1499_149#	a_1499_149##2	151.492310
Rf44	RESET_B#8	RESET_B#19	161.023331
Rf45	RESET_B#20	RESET_B#21	0.790535
Rf46	RESET_B#19	RESET_B#20	5.314581
Rf47	a_1586_149##15	a_1586_149##16	85.085312
Rf48	a_1586_149##16	a_1586_149##17	68.221420
Rf49	a_1586_149##16	a_1586_149##7	217.327423
Rf50	a_1800_291##4	a_1800_291##6	152.829178
Rf51	a_1800_291##6	a_1800_291##2	225.988678
Rf52	a_1800_291##5	a_1800_291##6	15.000000
Rf53	Q_N#2	Q_N#3	82.517097
Rf54	Q_N#2	Q_N	6.995293
Rf55	Q_N#1	Q_N#2	7.500000
Rf56	a_2363_352##4	a_2363_352##9	174.818375
Rf57	a_2363_352##9	a_2363_352##10	44.390526
Rf58	a_2363_352##9	a_2363_352##11	42.363277
Rf59	Q#1	Q	90.636475
Rf60	Q	Q#2	15.471872
Rf61	VGND#1	VGND#2	44.014832
Rf62	VGND#2	VGND#3	68.481133
Rf63	VGND#3	VGND#4	70.131073
Rf64	VGND#4	VGND#5	63.256500
Rf65	VGND#5	VGND#6	62.190964
Rf66	VGND#6	VGND#7	36.500717
Rf67	VGND#7	VGND#8	281.252686
Rf68	VGND#8	VGND#9	173.162491
Rf69	VGND#9	VGND#10	72.295456
Rf70	VGND#10	VGND#11	77.384460
Rf72	VGND#3	VGND#13	41.038895
Rf73	VGND#4	VGND#14	31.473843
Rf74	VGND#5	VGND#15	55.334732
Rf75	VGND#7	VGND#16	33.523315
Rf76	VGND#8	VGND#17	27.306370
Rf77	VGND#10	VGND#18	35.885353
Rf78	VGND#11	VGND#19	37.066368
Rf79	VPWR#1	VPWR#2	41.751957
Rf80	VPWR#2	VPWR#3	77.445518
Rf81	VPWR#3	VPWR#4	88.342033
Rf82	VPWR#4	VPWR#5	65.696381
Rf83	VPWR#5	VPWR#6	32.848190
Rf84	VPWR#6	VPWR#7	46.346661
Rf85	VPWR#7	VPWR#8	233.660172
Rf86	VPWR#8	VPWR#9	210.689667
Rf87	VPWR#9	VPWR#10	21.217461
Rf88	VPWR#10	VPWR#12	143.848801
Rf89	VPWR#12	VPWR#13	56.762787
Rf90	VPWR#3	VPWR#14	38.286041
Rf91	VPWR#4	VPWR#15	41.435421
Rf92	VPWR#5	VPWR#16	35.077789
Rf93	VPWR#7	VPWR#17	43.644302
Rf94	VPWR#8	VPWR#18	25.252243
Rf95	VPWR#10	VPWR#19	38.306351
Rf96	VPWR#11	VPWR#12	5.000000
Re1	RESET_B#21	RESET_B	21.931572
Re3	RESET_B	RESET_B#13	12.051637
Re4	VPWR#2	VPWR#21	11.160645
Re5	VPWR#21	VPWR	1.198481
Re6	VPWR	VPWR#9	2.081275
Re7	VGND#2	VGND#21	11.160645
Re8	VGND#21	VGND	1.198481
Re9	VGND	VGND#9	2.081275
Re17	VGND#6	VGND#21	0.698413
Re14	VPWR#6	VPWR#21	0.698413
*
*       CAPACITOR CARDS
*
*
C1	a_818_418##12	a_728_331##2	2.45559e-17
C2	a_331_392##4	a_1499_149##2	2.78071e-17
C3	VGND#13	a_2363_352#	6.00981e-19
C4	RESET_B#21	a_1586_149##16	2.4434e-17
C5	VPWR#9	a_298_294##9	8.61111e-18
C6	VGND#3	a_2363_352##9	2.42297e-19
C7	a_331_392##6	a_298_294##4	1.24105e-18
C8	a_70_74##2	a_298_294##3	7.51107e-19
C9	a_331_392##9	a_728_331##9	1.0022e-17
C10	a_298_294##6	RESET_B#6	1.9697e-19
C11	VPWR#9	VPWR#10	7.38033e-17
C12	a_2363_352##9	a_2363_352##7	2.79636e-19
C13	a_818_418##11	a_818_418##9	8.14085e-18
C14	Q#2	a_2363_352##6	2.91421e-17
C15	RESET_B#9	a_1586_149##14	2.12063e-17
C16	a_1800_291##5	RESET_B#8	3.03586e-18
C17	VGND#4	a_1586_149##3	7.13227e-20
C18	VPWR#5	a_1586_149##14	1.06078e-18
C19	a_2363_352##10	VPWR#14	8.42045e-17
C20	a_331_392##7	a_298_294##2	1.25178e-17
C21	VPWR#9	VPWR#8	1.46104e-16
C22	RESET_B#13	a_331_392##8	4.8027e-18
C23	a_70_74##5	D#1	3.03082e-17
C24	VPWR#17	RESET_B#8	7.84485e-19
C25	VGND#14	a_2363_352##9	4.63043e-18
C26	VGND#1	a_1586_149#	7.54724e-20
C27	VGND#5	a_1800_291##4	9.44457e-18
C28	a_331_392##7	RESET_B#1	1.84025e-18
C29	a_1499_149##2	a_1586_149##17	6.01409e-17
C30	a_298_294##7	a_298_294##3	3.05318e-18
C31	a_1800_291##5	VPWR#7	6.33058e-19
C32	a_70_74##3	RESET_B#13	5.34482e-17
C33	VPWR#9	a_298_294##10	3.39044e-18
C34	a_2363_352##6	VGND#13	2.2551e-17
C35	RESET_B#13	VGND#10	3.30853e-19
C36	RESET_B#21	RESET_B#19	1.88221e-17
C37	a_614_81#	a_818_418#	1.44545e-17
C38	a_331_392##6	a_818_418##2	1.38677e-19
C39	a_331_392##6	a_70_74##6	2.44505e-17
C40	a_1800_291##2	a_1800_291##5	1.34494e-18
C41	VPWR#9	a_331_392##8	6.40654e-18
C42	a_1800_291##3	RESET_B#9	1.02665e-17
C43	a_298_294##6	a_818_418##2	1.18296e-17
C44	VPWR#15	VPWR#14	6.51584e-18
C45	VGND#3	a_2363_352#	6.10894e-19
C46	a_614_81#	a_818_418##11	1.74188e-18
C47	VPWR#7	RESET_B#9	1.92628e-18
C48	D#8	D#3	2.06025e-17
C49	a_1800_291##2	VPWR#17	2.18432e-17
C50	VPWR#7	VPWR#5	1.21126e-18
C51	RESET_B#13	VPWR#11	3.76968e-18
C52	a_1586_149##5	a_1586_149##4	8.86155e-19
C53	VPWR#9	a_70_74##3	6.28398e-17
C54	a_2363_352##9	a_1586_149##9	3.28095e-18
C55	a_2363_352##11	a_2363_352##6	1.26035e-18
C56	a_331_392##5	a_728_331##7	7.09831e-20
C57	a_1800_291##5	VPWR#5	1.59641e-19
C58	a_70_74##2	a_728_331##3	5.59863e-19
C59	a_1586_149##15	a_1800_291##2	3.97873e-17
C60	VGND#13	a_1586_149#	2.31138e-18
C61	D#5	D#3	1.30958e-17
C62	Q_N#1	a_2363_352##9	3.46409e-17
C63	a_331_392##7	a_331_392##6	1.03335e-18
C64	VPWR#15	a_2363_352##10	4.90254e-17
C65	a_331_392##2	a_298_294##5	6.59464e-18
C66	a_818_418##5	a_1800_291##3	2.75241e-17
C67	a_818_418##6	VPWR#17	1.00676e-17
C68	VPWR#9	VPWR#11	1.67311e-16
C69	VGND#6	a_1586_149##8	7.35485e-18
C70	a_70_74##5	D#5	5.05125e-17
C71	VGND#14	a_2363_352##6	5.33845e-19
C72	a_331_392##6	a_298_294##2	1.07788e-19
C73	a_2363_352##9	Q#1	1.35685e-18
C74	a_331_392##6	a_614_81##2	1.18811e-16
C75	a_1586_149##13	a_1586_149##4	2.33199e-19
C76	a_331_392##2	a_70_74##6	1.62237e-17
C77	RESET_B#21	a_331_392##5	5.45929e-18
C78	a_2363_352##6	a_2363_352#	3.82045e-17
C79	VGND#9	VPWR#13	5.99992e-18
C80	a_2363_352##9	a_2363_352#	1.87325e-20
C81	a_1586_149#	a_2363_352##11	2.63229e-17
C82	a_614_81##2	a_331_392##2	5.46109e-18
C83	VGND#3	a_2363_352##6	7.48633e-18
C84	a_818_418##6	a_1586_149##15	8.04101e-17
C85	VPWR#7	a_1800_291##3	3.2279e-18
C86	VPWR#1	a_2363_352##5	3.01973e-17
C87	a_2363_352##9	a_1586_149##12	3.20469e-19
C88	Q_N#1	a_2363_352##6	6.37938e-19
C89	a_818_418##2	a_818_418#	9.12871e-18
C90	a_818_418##6	a_331_392##9	1.32614e-16
C91	VGND#13	a_1586_149##10	1.71563e-19
C92	a_70_74##2	a_818_418##4	4.80986e-18
C93	a_728_331##6	a_818_418##5	1.04703e-17
C94	RESET_B#21	a_818_418##11	6.89184e-18
C95	a_2363_352##9	a_1586_149##5	1.34983e-20
C96	a_331_392##5	a_614_81##2	1.00778e-19
C97	a_1586_149#	VGND#14	1.46775e-17
C98	Q#1	a_2363_352##5	5.80726e-17
C99	VGND#4	a_1586_149#	1.0138e-18
C100	CLK#4	a_331_392##9	9.90816e-18
C101	VGND#16	VGND#5	2.09836e-20
C102	VPWR#1	a_2363_352##7	1.43952e-18
C103	a_2363_352##9	VPWR#14	1.45823e-17
C104	a_2363_352##11	a_1586_149##10	1.88155e-18
C105	Q_N#3	VPWR#15	8.55391e-17
C106	a_331_392##9	a_728_331##8	5.80071e-17
C107	VGND#9	VGND#10	7.5834e-17
C108	VPWR#14	a_2363_352##5	1.46132e-18
C109	a_1586_149#	a_2363_352##6	5.11891e-18
C110	VGND#7	a_1499_149#	1.71132e-17
C111	Q_N#1	a_1586_149#	8.39875e-18
C112	VGND#18	a_331_392##7	1.13633e-17
C113	a_2363_352##9	a_2363_352##6	1.8767e-19
C114	VGND#18	RESET_B#5	9.5695e-19
C115	CLK#1	a_728_331##6	2.64765e-18
C116	VGND#3	a_1586_149#	8.65589e-19
C117	VGND#5	a_1586_149##10	4.81973e-19
C118	VGND#9	VGND#8	1.16962e-16
C119	VGND#1	VPWR#1	1.39389e-17
C120	Q#1	a_2363_352##7	5.4694e-17
C121	VPWR#7	a_818_418##5	2.20982e-18
C122	a_70_74##2	a_728_331##4	1.47732e-18
C123	VGND#14	a_1586_149##10	2.90907e-17
C124	VPWR#5	VPWR#4	1.76996e-18
C125	VGND#7	a_1586_149##16	9.0418e-19
C126	a_2363_352##9	a_1586_149##4	4.79847e-20
C127	CLK#2	a_331_392##9	1.89801e-17
C128	VPWR#16	VPWR#15	4.12507e-18
C129	a_2363_352##4	VPWR#3	4.87921e-19
C130	RESET_B#21	a_1586_149##5	6.10267e-20
C131	a_728_331##15	VGND#17	3.3843e-18
C132	a_2363_352##7	VPWR#14	3.50613e-17
C133	a_2363_352##11	a_1586_149##11	2.0039e-19
C134	VGND#4	a_1586_149##10	9.48299e-19
C135	CLK#2	a_728_331##11	3.78838e-17
C136	a_298_294##6	a_818_418##4	1.09151e-18
C137	VGND#18	a_331_392##6	5.97076e-17
C138	a_728_331#	CLK#1	1.36834e-17
C139	a_331_392##7	a_331_392##8	5.97673e-19
C140	Q_N#1	a_1586_149##10	3.09295e-17
C141	RESET_B#21	a_1586_149##4	8.51993e-19
C142	Q#1	a_1586_149##9	2.7952e-19
C143	a_2363_352##9	a_2363_352##10	1.62857e-18
C144	a_331_392##2	a_298_294##2	8.13496e-20
C145	a_1586_149##10	a_1586_149#	3.07521e-17
C146	VPWR#8	a_728_331##6	1.62611e-18
C147	VPWR#2	a_2363_352##5	4.88106e-18
C148	a_2363_352##10	a_2363_352##7	1.47685e-18
C149	a_1586_149##15	VPWR#7	5.59168e-18
C150	a_331_392##7	a_331_392##11	3.78267e-19
C151	a_1586_149##4	a_1586_149##3	8.18697e-19
C152	VGND#7	a_331_392##4	6.14252e-17
C153	a_728_331##2	a_331_392##9	3.18247e-19
C154	RESET_B#21	a_1586_149##3	3.08411e-20
C155	a_2363_352##9	a_1586_149#	2.40097e-18
C156	VGND#14	a_1586_149##11	2.00331e-18
C157	VPWR#16	Q_N#3	5.0896e-17
C158	VGND#3	a_1586_149##10	8.59102e-20
C159	a_70_74##2	a_331_392##3	1.14881e-19
C160	VGND#5	a_1586_149##11	5.08915e-18
C161	VPWR#14	a_1586_149##9	2.64612e-18
C162	a_728_331##2	a_728_331##11	1.72442e-17
C163	a_818_418##12	a_728_331##15	4.39431e-18
C164	VGND#15	a_1586_149##10	5.82748e-19
C165	VPWR#7	a_728_331##6	5.67441e-18
C166	a_818_418##2	a_70_74#	3.52532e-19
C167	a_1586_149##7	a_1586_149##11	3.44688e-18
C168	VPWR#15	a_2363_352##7	1.66597e-18
C169	a_818_418##3	a_728_331#	1.41933e-18
C170	a_728_331##2	VPWR#18	6.15783e-18
C171	a_2363_352##9	a_1586_149##3	1.76139e-17
C172	a_298_294##6	a_728_331##4	1.88726e-17
C173	Q_N#1	a_1586_149##11	3.68884e-17
C174	a_1586_149##9	a_2363_352##10	3.68532e-17
C175	RESET_B#21	a_728_331##7	1.9612e-18
C176	a_728_331##2	a_818_418##9	1.56494e-18
C177	a_331_392##11	a_331_392##6	4.27879e-18
C178	CLK#4	a_728_331##15	2.53155e-17
C179	a_70_74##3	a_331_392##7	4.47713e-18
C180	a_1800_291##5	Q_N#3	3.62172e-17
C181	VGND#19	RESET_B#2	1.92326e-18
C182	a_1586_149##7	RESET_B#7	2.86191e-17
C183	VPWR#14	a_1586_149##12	7.44692e-19
C184	VGND#14	a_1586_149##8	8.61068e-20
C185	VPWR#15	a_2363_352##9	7.21899e-18
C186	a_1586_149##11	a_1586_149##10	3.68447e-17
C187	a_331_392##7	VGND#19	1.51564e-18
C188	a_818_418##11	a_818_418##2	1.14987e-18
C189	VPWR#15	a_1586_149##9	2.57473e-17
C190	a_614_81#	a_728_331##15	2.2529e-18
C191	VGND#9	a_728_331##3	1.19947e-17
C192	a_1586_149##11	VGND#15	1.51322e-17
C193	a_70_74##5	RESET_B#2	2.31046e-18
C194	VPWR#9	a_728_331##4	4.79338e-20
C195	a_728_331##5	a_818_418##3	2.15718e-17
C196	VPWR#8	CLK#1	2.27323e-17
C197	a_2363_352##9	a_1586_149##10	2.89106e-19
C198	VGND#3	a_2363_352##4	6.8586e-19
C199	RESET_B#13	a_331_392##7	6.7802e-17
C200	a_298_294##2	RESET_B#5	1.07916e-18
C201	a_2363_352##10	a_1586_149##12	1.41955e-18
C202	a_331_392##11	D#3	4.74725e-19
C203	VGND#5	a_1586_149##8	6.70446e-19
C204	a_818_418##11	VPWR#8	1.30611e-16
C205	RESET_B#21	a_1586_149##9	1.96332e-19
C206	a_1800_291##5	VPWR#16	5.19859e-17
C207	a_818_418#	a_70_74#	4.34706e-18
C208	VPWR#4	VPWR#3	6.45868e-19
C209	VGND#9	a_728_331##4	8.04115e-18
C210	VGND#7	a_1586_149##7	4.30022e-19
C211	a_1800_291##4	a_1586_149##11	2.0252e-18
C212	RESET_B#21	a_1586_149##12	1.22875e-19
C213	a_2363_352##9	a_2363_352##4	5.77787e-19
C214	VPWR#15	a_1586_149##12	6.28235e-17
C215	a_331_392#	a_728_331##5	4.396e-17
C216	a_70_74##5	D#3	3.06409e-17
C217	VGND#5	a_1586_149##7	2.84388e-20
C218	a_298_294##9	a_818_418##2	2.47155e-18
C219	VGND#9	a_331_392##3	3.86609e-18
C220	Q#2	VGND#1	3.95944e-17
C221	VGND#7	RESET_B#7	3.73922e-18
C222	VGND#15	a_1586_149##8	1.32759e-18
C223	RESET_B#21	a_1586_149##13	6.25355e-19
C224	Q_N#3	a_2363_352##9	5.65905e-19
C225	a_1586_149##8	a_1586_149##11	3.33413e-18
C226	VPWR#17	VPWR#16	1.39973e-17
C227	a_1800_291##2	a_1800_291#	5.9605e-19
C228	VGND#9	RESET_B#4	3.47291e-18
C229	a_1586_149##12	Q_N#3	2.17706e-17
C230	RESET_B#21	a_1586_149##14	1.7426e-18
C231	a_1800_291##2	VPWR#7	1.1958e-18
C232	a_818_418##7	a_1800_291##2	8.05888e-19
C233	VPWR#8	a_728_331#	1.76008e-17
C234	VPWR#15	a_1586_149##13	3.45293e-18
C235	VGND#5	RESET_B#7	5.10093e-20
C236	a_1800_291##4	a_1586_149##8	3.50937e-17
C237	RESET_B#6	a_331_392#	1.02288e-17
C238	VPWR#16	a_1586_149##12	2.50113e-18
C239	a_331_392##5	a_818_418##11	6.37385e-19
C240	a_614_81#	a_818_418##12	4.66561e-17
C241	VGND#9	RESET_B#1	6.80346e-19
C242	a_298_294#	a_818_418##2	1.2239e-19
C243	VPWR#19	a_331_392##2	1.11781e-18
C244	VPWR#6	a_1586_149##14	1.1504e-18
C245	VGND#16	a_1586_149##11	2.92035e-19
C246	a_1800_291##5	VPWR#17	3.03956e-17
C247	VGND#13	VGND#1	1.69805e-18
C248	VGND#15	RESET_B#7	1.17135e-19
C249	a_1586_149##13	Q_N#3	3.00449e-17
C250	a_298_294#	a_298_294##2	3.10577e-19
C251	a_298_294##7	a_70_74##2	4.69191e-17
C252	VGND#9	D#1	6.54702e-19
C253	VGND#10	a_331_392##7	9.43544e-19
C254	VPWR#8	VPWR#18	1.33631e-17
C255	VPWR#6	RESET_B#9	7.70498e-19
C256	a_1800_291##5	a_1586_149##12	1.02581e-18
C257	a_728_331##9	a_818_418##6	1.41076e-17
C258	VGND#7	a_1800_291#	4.11147e-18
C259	RESET_B#7	a_1586_149##8	4.03543e-17
C260	a_70_74##5	a_331_392##7	1.03119e-17
C261	a_298_294##3	RESET_B#6	5.89826e-18
C262	VPWR#16	a_1586_149##13	5.08863e-17
C263	a_818_418##6	VPWR#8	2.47086e-17
C264	a_818_418##6	CLK#3	8.69107e-20
C265	a_1800_291##4	RESET_B#7	3.80427e-18
C266	VPWR#9	a_818_418##11	3.63531e-17
C267	VGND#9	a_331_392##7	5.57111e-18
C268	a_818_418##6	VPWR#7	3.57004e-17
C269	Q_N#3	a_1586_149##14	7.6479e-19
C270	VGND#16	a_1586_149##8	4.31535e-18
C271	a_70_74##2	a_70_74#	1.3602e-17
C272	a_1800_291##5	a_1586_149##13	8.33718e-18
C273	a_331_392##8	RESET_B#5	1.394e-19
C274	VGND#9	a_331_392##6	1.92218e-16
C275	VGND#13	Q#2	3.75764e-17
C276	a_331_392##4	a_728_331##7	1.63925e-19
C277	a_70_74##3	RESET_B#5	2.13479e-19
C278	a_298_294##6	a_70_74##2	7.69991e-17
C279	VPWR#8	a_728_331##3	4.66458e-20
C280	RESET_B#3	a_298_294##3	1.98962e-17
C281	a_1586_149##14	VPWR#16	1.50898e-17
C282	VGND#9	a_331_392##5	5.91814e-17
C283	VGND#7	a_1800_291##2	5.17796e-20
C284	VPWR#17	a_1586_149##13	3.15393e-18
C285	VGND#10	a_331_392##6	2.04652e-17
C286	a_1499_149#	a_1586_149##8	2.43923e-19
C287	a_1586_149##15	a_1800_291##5	1.36642e-18
C288	CLK#2	a_728_331##9	1.32473e-18
C289	a_1800_291##4	a_1800_291#	7.50771e-19
C290	a_1800_291#	RESET_B#7	3.72697e-17
C291	a_298_294#	a_331_392##8	1.25793e-17
C292	VGND#7	a_818_418##7	3.81197e-18
C293	a_1586_149##16	a_1586_149##7	1.0255e-18
C294	a_1800_291##5	a_1586_149##14	4.36354e-17
C295	a_1586_149##9	a_2363_352##4	4.48225e-19
C296	RESET_B#2	a_298_294##2	3.59042e-17
C297	VGND#16	RESET_B#7	2.74609e-17
C298	a_70_74##3	a_298_294#	2.43564e-18
C299	VGND#9	a_818_418##11	7.32465e-19
C300	VGND#14	a_2363_352##10	1.18073e-19
C301	VPWR#8	a_728_331##8	7.38712e-19
C302	D#4	RESET_B#3	2.17033e-17
C303	a_1586_149##16	a_1800_291##4	8.37722e-19
C304	VPWR#16	RESET_B#9	7.57895e-19
C305	a_70_74##2	a_298_294##9	1.01619e-16
C306	a_728_331##2	a_728_331##9	6.81406e-20
C307	VPWR#17	a_1586_149##14	1.30298e-18
C308	a_70_74##3	a_298_294##4	5.45289e-20
C309	a_1586_149##15	VPWR#17	5.35781e-18
C310	VPWR#11	a_298_294#	2.59399e-20
C311	a_728_331##2	CLK#3	3.64734e-18
C312	a_331_392##8	RESET_B#2	1.27246e-18
C313	a_1499_149#	RESET_B#7	4.75057e-19
C314	a_728_331##7	a_818_418##5	2.05196e-18
C315	a_70_74##6	a_614_81#	7.96343e-17
C316	a_1800_291##5	RESET_B#9	3.66447e-17
C317	a_70_74##3	RESET_B#2	1.00016e-17
C318	a_1800_291##4	a_818_418##7	3.72526e-19
C319	a_1586_149##15	a_1755_389#	1.17725e-18
C320	a_728_331##2	a_728_331##3	4.62522e-18
C321	VGND#2	Q#2	1.2274e-17
C322	a_1586_149##7	RESET_B#19	1.98655e-17
C323	VGND#7	a_818_418##6	2.37893e-19
C324	a_728_331##3	a_818_418##2	2.99397e-19
C325	VGND#8	a_331_392##6	2.10642e-17
C326	a_70_74##2	a_614_81#	1.50381e-17
C327	VGND#16	a_1800_291#	2.27185e-17
C328	a_818_418##7	a_1800_291#	6.25841e-18
C329	a_818_418##4	a_728_331##2	9.35852e-20
C330	a_1586_149##17	a_728_331##7	3.75315e-19
C331	VPWR#16	a_1800_291##3	3.38957e-19
C332	a_1586_149##7	a_1586_149##13	3.43437e-18
C333	a_331_392##6	a_536_81#	8.64257e-18
C334	VPWR#11	RESET_B#2	3.19998e-19
C335	RESET_B#9	VPWR#17	1.7661e-17
C336	a_1586_149##16	RESET_B#8	1.5972e-19
C337	a_2363_352##11	VGND#13	5.63412e-17
C338	VGND#7	a_728_331##9	7.84405e-19
C339	a_728_331##3	a_818_418#	2.32686e-18
C340	a_70_74##3	D#3	1.05311e-17
C341	a_1800_291##5	a_1800_291##3	9.075e-19
C342	a_70_74##6	a_298_294##5	5.56279e-17
C343	VPWR#8	CLK#2	8.35363e-20
C344	a_1800_291#	a_1499_149#	1.67435e-17
C345	a_298_294##7	a_298_294##6	8.47352e-19
C346	VPWR#13	D#3	6.2232e-18
C347	a_298_294##7	a_298_294##9	2.78734e-19
C348	RESET_B#8	a_1586_149##14	5.32248e-18
C349	VPWR#11	D#3	1.57764e-19
C350	Q_N#1	VPWR#15	3.75397e-17
C351	VGND#16	a_818_418##7	9.86937e-19
C352	VGND#8	a_728_331##8	1.9498e-19
C353	a_1800_291##3	VPWR#17	1.93736e-17
C354	a_1800_291##2	a_1586_149##13	1.18085e-19
C355	RESET_B#19	RESET_B#8	8.67819e-18
C356	VGND#8	CLK#3	3.19521e-18
C357	VPWR#9	a_818_418##3	3.12693e-18
C358	a_298_294##5	a_70_74##2	1.73596e-17
C359	a_1586_149##15	RESET_B#9	6.23558e-19
C360	a_728_331##9	a_818_418##7	2.30068e-17
C361	a_331_392##4	a_1800_291#	2.34581e-18
C362	VGND#7	a_728_331##8	2.1881e-21
C363	VGND#14	VGND#13	2.4293e-18
C364	VGND#8	a_331_392##5	1.56728e-16
C365	a_70_74##2	VPWR#9	1.65712e-16
C366	a_1800_291##2	a_1586_149##14	2.41143e-19
C367	a_1800_291##5	a_818_418##5	1.78614e-19
C368	a_331_392##2	a_728_331##4	4.62045e-17
C369	VPWR#9	a_728_331##5	3.19685e-18
C370	a_1499_149##2	RESET_B#7	1.68437e-19
C371	a_1586_149##16	a_1800_291##2	6.28398e-17
C372	a_70_74##2	VPWR#19	6.96643e-17
C373	a_1499_149#	a_818_418##7	1.40722e-17
C374	a_1800_291##2	RESET_B#9	1.15308e-18
C375	VPWR#15	a_1586_149##4	1.36986e-19
C376	VPWR#9	a_331_392#	5.81161e-18
C377	VPWR#17	a_818_418##5	2.16074e-18
C378	CLK#3	a_818_418##7	5.19796e-19
C379	VGND#16	a_1586_149##16	5.79417e-18
C380	VGND#9	CLK#4	4.47954e-19
C381	a_1499_149##2	a_728_331##7	6.24987e-19
C382	a_1800_291##2	a_1800_291##3	9.61667e-18
C383	a_1586_149##15	a_1800_291##3	4.86342e-18
C384	VPWR#9	a_298_294##7	6.30805e-18
C385	VPWR#5	a_1586_149##5	5.35838e-20
C386	VPWR#10	RESET_B#6	3.1992e-18
C387	VPWR#8	a_728_331##2	1.01283e-18
C388	a_818_418##6	RESET_B#9	2.11293e-19
C389	a_818_418##5	a_1800_291##2	8.36363e-18
C390	a_331_392##4	a_818_418##7	3.48778e-17
C391	RESET_B#5	a_331_392##3	1.5764e-18
C392	RESET_B#21	Q_N#1	8.50448e-19
C393	VPWR#9	a_298_294##6	3.06846e-18
C394	VGND#14	a_2363_352##11	3.01135e-17
C395	a_818_418##6	a_1800_291##3	3.46283e-19
C396	a_1800_291##2	RESET_B#19	2.4695e-17
C397	VGND#8	CLK#2	7.11545e-20
C398	a_614_81##2	a_70_74##6	7.46524e-17
C399	CLK#3	a_728_331##9	2.50139e-18
C400	VPWR#15	a_1586_149##3	7.15785e-18
C401	a_1499_149##2	a_1800_291#	4.58402e-19
C402	VGND#8	a_728_331##3	1.44649e-17
C403	RESET_B#13	a_298_294##2	4.2147e-18
C404	a_298_294#	a_728_331##4	2.21513e-19
C405	VGND#7	a_331_392##5	2.3433e-17
C406	VPWR#17	a_728_331##6	2.96046e-18
C407	a_818_418##6	a_818_418##5	3.60625e-18
C408	RESET_B#13	D#4	5.95711e-19
C409	a_1586_149##5	Q_N#3	5.27703e-19
C410	a_298_294##4	RESET_B#5	6.08767e-19
C411	a_1586_149##15	a_818_418##5	3.76043e-17
C412	a_298_294##10	a_70_74##2	2.91793e-17
C413	a_70_74##5	VPWR#13	1.19017e-19
C414	VGND#15	Q_N#3	1.9056e-18
C415	a_1586_149##17	a_818_418##7	2.85903e-17
C416	a_1586_149##16	a_818_418##6	5.29189e-17
C417	RESET_B#21	VPWR#6	1.71683e-18
C418	a_818_418##6	a_728_331##6	3.3179e-17
C419	RESET_B#21	a_1800_291##4	2.91009e-18
C420	VPWR#9	D#4	4.53e-18
C421	VGND#9	a_298_294##7	1.25987e-18
C422	a_1499_149#	a_1586_149##16	7.57617e-17
C423	a_818_418##6	CLK#1	3.86091e-19
C424	VPWR#9	RESET_B#15	6.22008e-19
C425	RESET_B#21	VGND#6	1.40134e-18
C426	a_728_331##11	a_331_392##9	1.10018e-18
C427	a_728_331##8	a_728_331##6	9.44614e-18
C428	Q_N#1	a_2363_352##11	2.16696e-17
C429	RESET_B#13	D#8	1.749e-18
C430	VGND#9	a_298_294##6	2.098e-18
C431	a_1499_149##2	a_818_418##7	8.48956e-18
C432	VPWR#10	a_298_294##3	2.54099e-19
C433	a_1586_149##4	Q_N#3	4.48014e-19
C434	a_728_331##6	a_1586_149##15	2.37378e-17
C435	a_331_392##5	a_1800_291##2	4.09427e-20
C436	a_818_418#	VPWR#8	3.15752e-18
C437	a_728_331##4	a_818_418##2	7.53004e-18
C438	CLK#1	a_728_331##8	1.2503e-17
C439	a_728_331##3	CLK#3	4.28805e-18
C440	RESET_B#21	VGND#16	2.40306e-18
C441	a_1586_149##16	a_1800_291##5	3.309e-19
C442	RESET_B#2	a_298_294##4	5.69337e-18
C443	a_1586_149##17	a_728_331##9	2.2102e-17
C444	VGND#8	a_728_331##2	8.60258e-20
C445	VPWR#4	a_1586_149##5	4.64393e-21
C446	a_728_331##6	a_331_392##9	1.98379e-17
C447	a_1800_291##5	Q_N#1	6.24225e-18
C448	RESET_B#21	a_1499_149#	4.63121e-18
C449	a_331_392##8	a_298_294##2	2.78604e-18
C450	VPWR#9	a_818_418##2	2.72525e-19
C451	VPWR#8	a_728_331##7	3.79696e-20
C452	a_331_392##9	VPWR#18	2.09811e-19
C453	RESET_B#15	a_298_294##7	1.69498e-17
C454	Q_N#3	a_1586_149##3	7.58528e-20
C455	RESET_B#21	VPWR#9	8.22801e-18
C456	a_1586_149##16	a_1800_291#	1.94083e-17
C457	VGND#9	RESET_B#15	1.34462e-18
C458	Q	a_1586_149##3	4.45158e-19
C459	RESET_B#21	a_331_392##4	8.64322e-19
C460	Q_N#1	VGND#14	5.10305e-17
C461	a_1499_149##2	a_728_331##9	3.12874e-17
C462	a_728_331##11	a_728_331##6	6.68055e-19
C463	VPWR#2	a_2363_352##4	4.5102e-20
C464	a_1586_149##16	a_331_392##4	3.38852e-18
C465	VPWR#9	D#8	4.03333e-18
C466	a_728_331##2	CLK#1	1.48002e-18
C467	D#3	RESET_B#1	1.5642e-17
C468	a_1586_149##5	VPWR#16	5.53069e-19
C469	VGND#9	RESET_B#21	8.15379e-18
C470	VGND#2	a_2363_352##4	4.85621e-20
C471	a_331_392##9	CLK#1	1.40381e-18
C472	RESET_B#21	a_1586_149##17	6.2557e-18
C473	VGND#10	a_728_331##4	2.50462e-19
C474	a_728_331##2	a_728_331#	8.59979e-18
C475	a_331_392##5	a_818_418##6	1.15339e-18
C476	a_728_331##3	a_818_418##4	4.95554e-18
C477	a_728_331##11	VPWR#18	2.58992e-18
C478	VGND#6	a_1800_291##4	1.47513e-17
C479	a_728_331##15	a_728_331##9	1.03002e-18
C480	a_70_74##6	a_298_294##6	6.89908e-18
C481	RESET_B#21	a_1499_149##2	6.50802e-18
C482	a_728_331##11	CLK#1	5.37469e-17
C483	a_818_418#	a_728_331#	1.07886e-17
C484	VGND#8	a_818_418#	1.46012e-19
C485	a_1586_149##8	a_1974_74#	8.8457e-18
C486	a_818_418##11	a_818_418##6	2.95465e-18
C487	VPWR#4	a_1586_149##4	4.50659e-20
C488	a_298_294##7	a_331_392##8	4.25404e-17
C489	a_1499_149##2	CLK#3	1.10106e-18
C490	a_1586_149##7	RESET_B#21	3.68813e-17
C491	a_728_331##4	a_728_331##3	1.11905e-18
C492	VGND#15	VGND#14	2.43359e-18
C493	RESET_B#7	a_1974_74#	8.8457e-18
C494	RESET_B#21	a_728_331##15	2.31064e-18
C495	a_331_392##9	a_728_331#	3.71007e-19
C496	D#5	D#1	1.99686e-18
C497	RESET_B#13	VPWR#9	2.00417e-17
C498	CLK#1	VPWR#18	2.05367e-17
C499	a_1800_291##4	a_1800_291##5	1.39376e-18
C500	a_818_418##2	a_728_331#	2.69613e-19
C501	a_1586_149##16	a_818_418##7	8.04991e-19
C502	RESET_B#21	RESET_B#8	7.02031e-18
C503	a_70_74##3	a_298_294##2	7.95133e-19
C504	VGND#9	RESET_B#13	1.94356e-17
C505	a_728_331##11	a_728_331#	6.89056e-19
C506	VPWR#7	a_728_331##7	2.38303e-22
C507	a_728_331##15	CLK#3	4.86973e-17
C508	VGND#6	a_1586_149##7	3.31698e-18
C509	a_728_331##4	a_818_418##4	3.73182e-17
C510	a_331_392##5	a_728_331##8	7.832e-19
C511	RESET_B#21	a_1800_291##2	3.08876e-17
C512	a_331_392##2	a_728_331##5	2.37434e-18
C513	RESET_B#19	a_1800_291##5	1.87129e-17
C514	a_614_81##2	a_298_294##6	4.59383e-19
C515	VPWR#10	RESET_B#5	1.89627e-20
C516	a_818_418##11	a_728_331##6	2.39707e-18
C517	a_728_331#	VPWR#18	2.74485e-17
C518	a_1800_291##5	a_1586_149##5	4.6917e-18
C519	VGND#15	Q_N#1	7.55729e-17
C520	RESET_B#21	a_818_418##6	3.11316e-17
C521	a_298_294##7	a_70_74##3	3.99794e-18
C522	VGND#9	D#5	1.06032e-17
C523	CLK#3	VGND#17	2.21131e-17
C524	a_728_331##8	a_818_418##11	2.94424e-17
C525	RESET_B#6	a_331_392##2	2.14381e-19
C526	VPWR#4	a_1586_149##3	1.66772e-19
C527	RESET_B#21	a_728_331##8	1.48185e-17
C528	a_728_331#	a_818_418##9	2.70855e-17
C529	a_1586_149##3	a_2363_352##4	8.70643e-18
C530	a_728_331##15	a_728_331##3	2.67273e-18
C531	a_1586_149##16	a_728_331##9	2.66405e-19
C532	a_1499_149##2	a_1586_149##16	1.9373e-18
C533	a_331_392##3	a_728_331##4	9.97633e-18
C534	a_818_418##12	CLK#3	1.37501e-18
C535	RESET_B#21	CLK#2	3.29049e-17
C536	a_298_294##3	RESET_B#5	1.58617e-18
C537	a_1800_291##5	a_1586_149##4	1.87175e-19
C538	a_331_392##5	CLK#2	1.32408e-18
C539	RESET_B#19	VPWR#17	1.2646e-18
C540	a_1800_291##4	Q_N#1	1.9565e-17
C541	a_728_331##3	VGND#17	2.25789e-17
C542	RESET_B#21	a_728_331##2	2.62952e-17
C543	a_1800_291##3	a_1755_389#	6.44348e-18
C544	VGND#10	RESET_B#4	9.08401e-19
C545	a_818_418##11	CLK#1	3.81502e-17
C546	a_298_294#	a_298_294##3	1.30769e-18
C547	VPWR#10	a_298_294#	5.4996e-20
C548	a_298_294##9	a_728_331#	1.97039e-19
C549	a_1586_149##16	a_1586_149##15	8.5312e-19
C550	a_818_418##5	a_1755_389#	8.33955e-18
C551	a_614_81#	CLK#3	4.7168e-19
C552	a_818_418##11	CLK#2	7.55401e-19
C553	a_331_392##11	VGND#18	3.37796e-17
C554	VPWR	a_1586_149##5	4.79373e-23
C555	VPWR	a_1586_149##4	1.37797e-20
C556	a_1586_149##7	RESET_B#8	5.50688e-17
C557	VPWR	a_1586_149##3	5.30813e-20
C558	a_1586_149##7	a_1586_149##5	6.21721e-19
C559	a_818_418##12	a_728_331##3	3.15604e-17
C560	a_2363_352##4	Q#2	3.64643e-19
C561	a_331_392##5	CLK#4	1.40756e-17
C562	a_70_74##3	VPWR#10	6.89645e-17
C563	RESET_B#4	a_331_392##3	4.48531e-17
C564	a_1586_149##16	CLK#3	2.35221e-19
C565	a_298_294##4	a_728_331##4	2.50269e-20
C566	a_2363_352##9	Q	8.14739e-19
C567	VPWR#2	VPWR#1	2.04502e-17
C568	a_298_294##9	a_818_418##3	2.14874e-17
C569	D#4	RESET_B#2	6.2728e-18
C570	a_1800_291##4	VGND#15	7.27036e-17
C571	a_2363_352##4	VGND#13	4.17527e-17
C572	a_331_392##5	a_728_331##2	2.86068e-17
C573	a_1800_291##2	RESET_B#8	3.89323e-17
C574	VPWR#3	a_1586_149##3	1.39539e-19
C575	a_331_392##5	a_1800_291#	6.78229e-20
C576	a_614_81#	a_728_331##3	1.22473e-17
C577	VGND#19	VGND#18	1.67876e-18
C578	Q#1	VPWR#2	8.4779e-18
C579	VPWR#9	a_728_331##2	3.83751e-18
C580	VGND#10	a_331_392##11	7.66951e-18
C581	a_818_418##11	a_728_331#	5.68925e-17
C582	VGND#10	a_298_294##4	1.12239e-18
C583	VGND#9	a_728_331##2	4.49359e-18
C584	a_818_418##12	a_818_418##4	6.74222e-19
C585	a_818_418##11	a_728_331##2	7.75669e-17
C586	VPWR#9	a_818_418#	9.06386e-18
C587	a_298_294##9	a_728_331##5	2.10125e-17
C588	a_818_418##6	a_1800_291##2	3.43892e-17
C589	VGND#2	VPWR#1	5.58341e-18
C590	VGND#10	a_298_294#	1.62246e-19
C591	a_331_392#	a_683_485#	7.48834e-18
C592	VGND#9	a_818_418#	8.95571e-19
C593	a_728_331##5	a_818_418##2	1.47588e-17
C594	a_298_294##4	RESET_B#4	4.77651e-18
C595	VGND#17	a_728_331##4	5.50629e-20
C596	VPWR#9	a_331_392##2	9.42886e-19
C597	Q_N#1	a_2363_352##4	1.21342e-18
C598	VPWR#11	a_298_294##2	2.94772e-21
C599	a_331_392##6	a_818_418#	1.40722e-19
C600	VGND#19	a_331_392##11	4.81286e-17
C601	a_818_418##4	a_614_81#	1.69136e-17
C602	VGND#9	a_331_392##2	1.41379e-18
C603	a_818_418##6	a_728_331##8	1.22796e-18
C604	VGND#7	VGND#5	5.7618e-19
C605	RESET_B#13	a_298_294#	1.0732e-17
C606	a_331_392##5	a_818_418#	1.16115e-18
C607	a_70_74##6	a_728_331##3	8.79105e-19
C608	a_298_294##9	a_331_392#	2.62119e-18
C609	a_331_392##5	a_818_418##7	5.22507e-19
C610	a_2363_352##9	VPWR#3	1.46948e-19
C611	a_818_418##12	a_728_331##4	8.77859e-20
C612	a_331_392##5	a_1499_149#	3.63014e-19
C613	a_818_418##11	a_818_418##3	1.5527e-18
C614	CLK#4	CLK#2	5.49281e-18
C615	RESET_B#13	RESET_B#2	1.87385e-17
C616	a_818_418##4	a_298_294##5	1.09134e-17
C617	a_614_81#	a_818_418##2	1.07011e-19
C618	CLK#2	a_728_331##8	3.54479e-18
C619	VGND#9	a_298_294#	3.74067e-18
C620	a_70_74##2	VPWR#10	3.63473e-18
C621	a_818_418##11	a_818_418#	1.93785e-17
C622	VGND#10	RESET_B#1	1.50006e-19
C623	Q_N#1	a_1586_149##7	2.55736e-19
C624	RESET_B#13	D#3	2.63796e-18
C625	VGND#16	VGND#15	1.40607e-18
C626	VPWR	VPWR#8	6.12421e-17
C627	RESET_B#1	a_298_294##4	2.77604e-17
C628	a_728_331##2	a_728_331##8	1.36312e-19
C629	a_1586_149##3	a_2363_352##6	2.67791e-19
C630	VPWR	VPWR#7	1.28305e-16
C631	a_614_81#	a_728_331##4	2.82008e-18
C632	VGND#9	RESET_B#2	8.30137e-19
C633	VPWR	VPWR#5	6.46074e-17
C634	VPWR	VPWR#4	8.37106e-17
C635	a_331_392##7	a_331_392##2	1.27371e-18
C636	a_298_294##9	RESET_B#6	6.47926e-20
C637	VPWR	VPWR#3	6.80978e-17
C638	VGND#15	a_1586_149##7	5.83541e-19
C639	a_331_392#	VPWR#19	8.74087e-18
C640	a_331_392##3	a_536_81#	7.42579e-18
C641	a_728_331##2	CLK#2	5.70639e-17
C642	Q	VGND#1	2.91043e-17
C643	a_70_74##6	a_818_418##4	2.20816e-17
C644	a_331_392##6	a_331_392##2	4.28138e-18
C645	VGND#9	D#3	8.78456e-19
C646	VGND#13	Q	2.76209e-17
C647	a_331_392##7	a_298_294##7	2.24835e-18
C648	a_1800_291##4	a_1586_149##7	7.44902e-17
C649	VPWR	a_2363_352##9	9.31389e-19
C650	a_298_294##5	a_728_331##4	2.17288e-17
C651	VGND#9	a_728_331##15	8.45742e-18
C652	VPWR#9	a_614_81#	1.06807e-18
C653	VPWR#11	VPWR#10	2.51449e-19
C654	VPWR#3	VPWR#2	9.5684e-19
C655	a_331_392##5	a_728_331##9	1.07907e-17
C656	a_1586_149##16	RESET_B#19	6.95549e-19
C657	a_728_331##2	CLK#4	1.82711e-17
C658	a_614_81##2	a_818_418##4	1.17638e-18
C659	a_70_74##5	a_331_392##11	3.07798e-18
C660	RESET_B#6	VPWR#19	1.53543e-17
C661	a_70_74##2	VPWR#8	1.01154e-17
C662	VGND#16	a_1800_291##4	1.5188e-17
C663	a_614_81#	a_331_392##3	3.85408e-19
C664	VPWR	RESET_B#19	9.47846e-19
C665	VGND#9	VGND#17	1.45883e-17
C666	RESET_B#21	VPWR#15	7.59821e-19
C667	D#1	RESET_B#1	3.15209e-17
C668	VGND#16	a_1586_149##7	2.08262e-17
C669	a_70_74##6	a_728_331##4	3.3452e-17
C670	VGND	a_1586_149##5	2.29346e-18
C671	VPWR	a_818_418##11	2.22465e-17
C672	VGND	a_1586_149##4	2.9091e-19
C673	VGND#9	a_818_418##12	5.12196e-18
C674	VGND	a_1586_149##3	2.93226e-18
C675	a_70_74##2	a_728_331##2	1.64593e-20
C676	VPWR#9	a_70_74##6	2.23066e-18
C677	RESET_B#21	Q_N#3	1.18528e-18
C678	RESET_B#6	a_298_294##10	1.08871e-17
C679	a_331_392##7	RESET_B#5	6.11404e-19
C680	a_70_74##3	a_331_392#	4.92254e-19
C681	a_1800_291##4	RESET_B#8	3.79215e-19
C682	D#8	a_70_74##3	3.15656e-17
C683	VGND#9	a_614_81#	8.13715e-18
C684	a_331_392##6	a_298_294##7	2.04114e-18
C685	a_331_392##6	RESET_B#5	1.63321e-17
C686	VPWR#19	a_298_294##3	8.69723e-20
C687	RESET_B#5	a_331_392##2	4.77932e-17
C688	a_70_74##5	VGND#19	2.50099e-17
C689	a_331_392##8	RESET_B#6	8.04662e-19
C690	a_614_81##2	a_728_331##4	2.46635e-17
C691	a_1586_149##3	a_1586_149#	7.46407e-19
C692	a_614_81#	RESET_B#4	2.31689e-19
C693	VGND#9	a_298_294##5	2.31484e-18
C694	a_298_294#	a_331_392##2	6.26104e-19
C695	Q	Q#1	2.2776e-18
C696	a_331_392##5	CLK#3	2.72943e-17
C697	a_1499_149#	a_1800_291##4	1.00539e-18
C698	VGND#19	RESET_B#13	1.43566e-17
C699	VGND#3	VGND#1	7.02642e-20
C700	RESET_B#21	a_1800_291##5	3.84784e-17
C701	a_298_294##10	a_298_294##3	2.84788e-18
C702	VGND#5	VGND#4	1.0294e-18
C703	VGND#16	RESET_B#8	8.41718e-19
C704	a_70_74##6	a_331_392##3	3.28502e-18
C705	RESET_B#21	VPWR#8	5.53531e-18
C706	a_298_294#	RESET_B#5	3.10664e-17
C707	a_70_74##3	RESET_B#6	1.86808e-17
C708	RESET_B#1	a_156_74#	4.629e-19
C709	VGND#9	a_70_74##6	9.65351e-18
C710	D#1	a_156_74#	7.67489e-18
C711	Q_N#1	a_1586_149##9	4.86913e-18
C712	RESET_B#21	VPWR#17	6.65668e-18
C713	a_331_392##8	a_298_294##3	3.59453e-17
C714	a_70_74##2	a_818_418#	6.81792e-17
C715	RESET_B#21	VPWR#7	7.37395e-18
C716	a_1800_291##4	a_1800_291##2	8.59091e-20
C717	VGND#9	a_614_81##2	6.92185e-18
C718	a_70_74##2	a_818_418##11	3.36229e-17
C719	VPWR	Q_N#1	8.58863e-18
C720	a_331_392##6	a_728_331##3	1.15822e-17
C721	D#8	VPWR#13	2.10462e-17
C722	a_614_81##2	a_331_392##3	1.91698e-17
C723	a_331_392##7	a_298_294#	5.21432e-17
C724	a_298_294##10	RESET_B#3	2.43286e-19
C725	a_1800_291##5	VPWR#6	4.16328e-18
C726	a_70_74##3	a_298_294##3	3.62983e-17
C727	VGND#18	a_728_331##4	2.45551e-20
C728	a_70_74##6	RESET_B#4	2.27903e-19
C729	D#3	RESET_B#2	3.20548e-17
C730	a_1586_149##5	VNB	2.85186e-17
C731	VGND	VGND#8	4.38751e-17
C732	RESET_B#21	a_1586_149##15	2.30732e-17
C733	a_1586_149##4	VNB	2.01429e-17
C734	VGND	VGND#7	1.26566e-16
C735	a_1586_149##3	VNB	5.61238e-17
C736	a_331_392##8	RESET_B#3	5.48034e-18
C737	VGND	VGND#5	5.89258e-17
C738	a_70_74##2	a_728_331#	4.73669e-18
C739	a_728_331##7	VNB	2.6543e-17
C740	VGND	VGND#4	5.7488e-17
C741	a_818_418##2	VNB	3.70367e-17
C742	a_331_392##5	a_728_331##3	5.55704e-17
C743	VGND	VGND#3	7.18492e-17
C744	a_298_294##2	VNB	2.45384e-17
C745	VPWR#13	a_298_294##3	5.10412e-19
C746	VGND	a_2363_352##9	2.76848e-18
C747	a_331_392##5	a_1499_149##2	9.22071e-17
C748	Q	a_2363_352#	1.34441e-17
C749	a_1499_149#	a_1800_291##2	5.758e-19
C750	a_70_74##6	a_818_418##2	7.54532e-20
C751	Q	a_2363_352##6	9.69205e-18
C752	VGND#3	Q#2	8.98985e-18
C753	VGND#9	a_331_392##11	2.03329e-17
C754	VGND	a_1586_149##16	8.66721e-18
C755	RESET_B#21	a_331_392##9	4.73077e-17
C756	a_1800_291##4	a_818_418##6	1.2518e-19
C757	Q_N#1	a_1586_149##5	9.43175e-18
C758	a_70_74##3	RESET_B#3	3.31578e-17
C759	a_614_81##2	RESET_B#4	5.87011e-19
C760	a_70_74##2	a_331_392##2	1.46765e-18
C761	Q#1	VPWR#3	8.56121e-18
C762	VPWR	Q#1	2.05396e-17
C763	a_298_294##3	VPWR#11	2.49538e-17
C764	VGND	a_331_392##5	4.21639e-17
C765	VPWR	VPWR#14	2.07363e-17
C766	a_1586_149##3	VGND#14	2.71216e-18
C767	VPWR	a_2363_352##10	1.90287e-17
C768	a_1499_149##2	a_331_392##9	2.47829e-17
C769	VGND#18	a_331_392##3	1.08646e-18
C770	VPWR	Q_N#3	1.25145e-17
C771	RESET_B#21	a_728_331##11	1.95709e-17
C772	a_331_392##8	D#4	8.70009e-20
C773	a_331_392##6	a_818_418##4	9.77864e-19
C774	a_331_392##5	a_331_392##9	1.67893e-18
C775	VPWR	a_1800_291##5	1.50186e-17
C776	a_1499_149#	VGND#16	3.41519e-17
C777	a_331_392##7	RESET_B#2	5.02397e-18
C778	VGND	CLK#4	3.09861e-18
C779	VPWR#4	a_2363_352##7	1.71839e-19
C780	VPWR	a_1586_149##15	1.0895e-17
C781	a_331_392##2	a_298_294##7	2.40331e-17
C782	VPWR	a_331_392##9	7.33112e-18
C783	VPWR	a_728_331##11	2.65508e-18
C784	a_1499_149##2	a_1800_291##2	1.32641e-19
C785	VPWR#4	VPWR#14	2.71023e-19
C786	a_70_74##3	D#4	2.94034e-17
C787	a_2363_352##7	a_2363_352##5	4.66354e-17
C788	a_818_418##6	a_728_331##7	1.98904e-17
C789	VPWR#10	VNB	4.27377e-17
C790	a_298_294##6	a_331_392##2	3.83567e-17
C791	a_1499_149#	a_818_418##6	1.29531e-18
C792	VPWR#11	RESET_B#3	1.71774e-18
C793	a_70_74##2	a_818_418##3	1.90841e-17
C794	VPWR#8	VNB	1.0683e-16
C795	a_331_392##11	a_331_392##3	3.26324e-19
C796	VPWR#7	VNB	6.81751e-17
C797	VGND#9	a_70_74##5	2.22341e-17
C798	VPWR#5	VNB	2.39996e-17
C799	a_818_418##11	a_728_331##3	7.57883e-18
C800	VPWR#4	VNB	3.40613e-17
C801	VPWR#3	VNB	3.51996e-17
C802	VGND#10	VNB	3.56221e-17
C803	VGND#8	VNB	9.62835e-17
C804	VGND	Q#2	1.52612e-17
C805	VGND#7	VNB	7.15824e-17
C806	VPWR#3	a_2363_352##7	4.66338e-18
C807	Q_N#1	a_1586_149##4	1.8634e-17
C808	VGND#5	VNB	2.64492e-17
C809	VGND#4	VNB	3.06995e-17
C810	VGND	a_2363_352##11	1.76658e-17
C811	a_331_392##5	a_728_331##15	9.35884e-17
C812	VGND#3	VNB	3.06515e-17
C813	a_818_418##6	a_331_392##4	2.49567e-18
C814	RESET_B#21	VGND#8	4.19746e-18
C815	a_331_392##8	a_298_294##10	1.35798e-17
C816	VGND	VGND#14	1.50988e-17
C817	VGND#5	a_1586_149##5	3.333e-19
C818	a_70_74##3	VPWR#19	3.78987e-17
C819	VPWR#13	D#4	1.39783e-17
C820	a_2363_352##9	VNB	7.96342e-18
C821	VGND	Q_N#1	2.36715e-17
C822	VGND#3	VGND#2	1.28077e-18
C823	a_1586_149##15	a_728_331##7	1.41849e-18
C824	VGND#18	RESET_B#4	3.31839e-17
C825	VGND	a_1800_291##4	2.22709e-17
C826	a_70_74##2	a_818_418##2	1.92635e-17
C827	VGND	VGND#16	1.09415e-17
C828	a_1586_149##16	VNB	6.10883e-18
C829	VGND	a_1499_149#	2.06625e-17
C830	VGND	a_331_392##4	2.88639e-17
C831	VGND#4	VGND#3	9.13945e-19
C832	RESET_B#19	VNB	2.01546e-18
C833	VGND	a_1586_149##17	3.41474e-18
C834	a_1586_149##17	a_818_418##6	3.47512e-17
C835	VGND	a_1499_149##2	6.78359e-18
C836	a_331_392##7	VNB	8.49473e-18
C837	a_331_392##6	VNB	3.04848e-17
C838	VGND	a_728_331##15	4.53322e-18
C839	a_331_392##4	VGND#16	3.5604e-18
C840	a_331_392##5	VNB	5.55694e-17
C841	RESET_B#21	VGND#7	2.57735e-18
C842	a_818_418##11	VNB	3.99348e-17
C843	VPWR#11	D#4	6.77158e-18
C844	VGND#4	a_2363_352##11	9.12632e-18
C845	a_331_392##6	a_728_331##4	2.39359e-17
C846	a_331_392##5	a_728_331##11	3.46791e-19
C847	CLK#4	VNB	3.9326e-18
C848	a_614_81##2	a_818_418##2	6.42214e-20
C849	a_331_392##7	D#3	2.80128e-18
C850	a_70_74##2	VNB	3.11338e-17
C851	a_298_294##7	RESET_B#5	1.86646e-17
C852	a_331_392##11	RESET_B#4	2.61747e-18
C853	a_1586_149##9	a_2363_352##7	4.33907e-18
C854	a_298_294##7	VNB	1.52791e-17
C855	a_298_294##6	VNB	6.10663e-18
C856	a_70_74##3	a_298_294##10	4.47304e-17
C857	VGND	Q#1	2.72775e-18
C858	RESET_B#15	VNB	2.23973e-18
C859	VGND	VPWR#14	3.82064e-18
C860	VGND#15	a_1586_149##5	9.75292e-18
C861	VGND	VPWR#15	3.61646e-18
C862	a_818_418##11	a_331_392##9	3.15186e-17
C863	VPWR#4	a_1586_149##9	5.32174e-18
C864	D#8	VNB	1.58141e-17
C865	a_298_294##6	RESET_B#5	3.10221e-20
C866	VGND#5	VGND#14	8.73047e-20
C867	a_728_331##15	a_728_331##11	7.52439e-19
C868	a_70_74##2	a_728_331##5	1.67426e-17
C869	D#5	VNB	1.84461e-17
C870	VGND#1	VNB	4.28247e-17
C871	Q_N#1	a_1586_149##3	3.0195e-17
C872	a_331_392##7	RESET_B#15	1.09105e-18
C873	Q#2	VNB	2.14726e-18
C874	VGND#18	a_298_294##4	1.68543e-18
C875	VGND#13	VNB	1.03272e-17
C876	VPWR	a_2363_352##5	3.26444e-18
C877	VPWR#17	a_1800_291#	5.41849e-19
C878	VGND	a_1586_149##15	3.82984e-19
C879	a_2363_352##11	VNB	1.20251e-17
C880	VGND#14	VNB	1.13128e-18
C881	VGND	a_331_392##9	3.38965e-18
C882	VPWR	a_2363_352##7	3.29627e-18
C883	a_818_418##11	a_818_418##4	5.39103e-19
C884	Q_N#1	VNB	5.62165e-18
C885	a_2363_352##10	VPWR#4	4.23989e-18
C886	VGND	a_728_331##11	5.69176e-19
C887	VGND#15	VNB	2.13646e-18
C888	VPWR	a_1586_149##9	8.1591e-18
C889	a_1800_291##4	VNB	2.02338e-17
C890	VPWR	a_1586_149##12	5.14765e-18
C891	a_331_392##5	a_728_331##4	1.00657e-18
C892	a_1499_149#	VNB	7.51319e-18
C893	VPWR	a_1586_149##13	5.00036e-18
C894	a_1586_149##12	a_2363_352##7	4.29896e-19
C895	a_331_392##4	VNB	5.07646e-18
C896	VGND#19	RESET_B#4	3.57285e-19
C897	VPWR	a_1586_149##14	6.1909e-18
C898	a_1499_149##2	VNB	3.89387e-18
C899	Q#1	a_2363_352##4	5.1817e-18
C900	a_331_392##5	VGND#17	7.44038e-17
C901	a_728_331##15	VNB	2.55796e-18
C902	VPWR	RESET_B#9	4.66005e-18
C903	VGND#17	VNB	1.55593e-18
C904	a_1499_149#	a_331_392##4	5.2301e-17
C905	a_818_418##12	VNB	6.38208e-18
C906	VPWR	a_1800_291##3	4.69404e-18
C907	a_614_81#	VNB	1.76525e-17
C908	a_818_418##4	a_728_331#	2.52433e-19
C909	VPWR	a_818_418##5	5.97884e-18
C910	a_331_392##5	a_1586_149##16	1.02437e-18
C911	a_70_74##6	VNB	1.06071e-17
C912	a_614_81##2	VNB	2.80505e-18
C913	VPWR	a_728_331##6	3.86128e-18
C914	VGND#5	a_1586_149##4	3.61128e-20
C915	Q#1	VPWR#1	1.07557e-16
C916	a_70_74##3	a_331_392##8	6.04866e-17
C917	VGND#18	VNB	5.2807e-18
C918	VGND	a_2363_352##6	4.20298e-18
C919	a_331_392##11	VNB	8.1774e-18
C920	VGND#19	VNB	7.10508e-19
C921	VGND	a_1586_149#	7.06099e-18
C922	a_1499_149##2	a_728_331##8	6.76158e-19
C923	VGND	a_1586_149##10	3.37951e-19
C924	a_331_392##11	a_298_294##4	4.29779e-17
C925	a_70_74##5	VNB	1.89451e-17
C926	RESET_B#15	RESET_B#5	8.96044e-18
C927	a_2363_352##4	VPWR#14	3.66985e-17
C928	VGND	a_1586_149##11	2.526e-19
C929	VGND#3	a_2363_352##11	7.56481e-18
C930	VPWR#1	VNB	5.50276e-17
C931	Q#1	VNB	5.71747e-18
C932	VGND	a_1586_149##8	9.88866e-19
C933	VPWR#14	VNB	1.60535e-17
C934	a_2363_352##10	VNB	1.74975e-17
C935	VGND	a_1800_291#	2.32913e-19
C936	VPWR#15	VNB	5.18692e-18
C937	Q_N#3	VNB	6.78414e-18
C938	VPWR#5	VPWR#15	3.40625e-19
C939	a_1586_149##12	a_1586_149##9	3.12949e-17
C940	VPWR#16	VNB	1.23811e-17
C941	Q	a_2363_352##4	6.55934e-17
C942	a_1800_291##5	VNB	4.84885e-18
C943	VPWR#17	VNB	2.22366e-17
C944	a_298_294##7	a_728_331##5	1.32382e-19
C945	a_1586_149##15	VNB	6.46938e-18
C946	a_331_392##9	VNB	1.02532e-17
C947	VGND#15	a_1586_149##4	6.94751e-19
C948	a_728_331##11	VNB	2.58961e-18
C949	a_331_392##6	a_331_392##3	2.87956e-17
C950	VGND#18	RESET_B#1	1.56295e-19
C951	a_2363_352##10	VPWR#3	7.72699e-18
C952	VPWR	VPWR#2	1.28694e-17
C953	a_331_392##9	a_728_331##7	2.11871e-17
C954	a_298_294##9	VNB	7.15264e-19
C955	RESET_B#3	a_298_294##2	3.2836e-19
C956	VPWR#19	VNB	2.96215e-18
C957	a_298_294##10	VNB	3.9804e-18
C958	RESET_B#21	VPWR	5.77167e-17
C959	a_331_392##8	VNB	1.08682e-18
C960	a_70_74##3	VNB	4.00605e-17
C961	VPWR	VPWR#6	2.65516e-17
C962	VPWR#13	VNB	4.53865e-17
C963	a_70_74##2	a_331_392#	2.85473e-17
C964	VPWR#11	VNB	8.21314e-17
C965	a_331_392##6	RESET_B#15	1.29174e-17
C966	a_298_294##4	VGND#19	1.32805e-17
C967	a_818_418##11	a_728_331##11	5.30539e-17
C968	a_2363_352#	VNB	3.09473e-17
C969	a_2363_352##6	VNB	2.97884e-17
C970	a_1586_149#	VNB	3.1041e-17
C971	a_1586_149##10	VNB	2.14859e-17
C972	a_298_294##6	a_728_331##5	9.37931e-18
C973	a_1586_149##11	VNB	2.65615e-17
C974	a_1586_149##8	VNB	2.57105e-17
C975	RESET_B#7	VNB	2.7693e-17
C976	a_1800_291#	VNB	4.47501e-17
C977	VPWR#14	VPWR#1	1.68725e-18
C978	VGND#5	Q_N#1	6.71352e-18
C979	a_2363_352##9	VGND#13	7.16863e-18
C980	a_1499_149#	a_1586_149##17	1.09034e-17
C981	a_818_418##7	VNB	3.34296e-17
C982	VPWR#4	a_1586_149##12	1.82741e-18
C983	a_728_331##9	VNB	3.38271e-17
C984	VPWR	a_2363_352##4	3.79119e-18
C985	CLK#3	VNB	4.28495e-17
C986	a_728_331##3	VNB	1.38854e-16
C987	a_818_418##4	VNB	2.84877e-17
C988	a_728_331##4	VNB	1.10068e-16
C989	a_331_392##5	a_331_392##3	2.81014e-19
C990	a_331_392##11	RESET_B#1	1.52369e-18
C991	a_331_392##3	VNB	3.85985e-17
C992	RESET_B#4	VNB	3.8756e-17
C993	VPWR	a_1800_291##2	4.04443e-18
C994	a_298_294##4	VNB	3.96033e-17
C995	RESET_B#1	VNB	2.83451e-17
C996	VPWR	a_818_418##6	3.44483e-17
C997	D#1	VNB	3.03581e-17
C998	a_331_392##5	a_818_418##12	3.83695e-17
C999	VPWR	a_728_331##8	2.09724e-18
C1000	a_2363_352##5	VNB	3.90846e-17
C1001	a_2363_352##7	VNB	3.61521e-17
C1002	a_1586_149##9	VNB	4.2152e-17
C1003	a_1586_149##12	VNB	3.56313e-17
C1004	a_1586_149##13	VNB	3.87743e-17
C1005	a_298_294#	RESET_B#15	2.17556e-17
C1006	a_1586_149##14	VNB	2.76826e-17
C1007	VGND	VGND#2	9.24546e-18
C1008	a_1800_291##4	a_1586_149##5	1.56222e-17
C1009	a_1586_149##13	a_1586_149##12	4.79589e-17
C1010	RESET_B#9	VNB	2.77851e-17
C1011	VGND	RESET_B#21	5.34427e-17
C1012	a_1800_291##3	VNB	2.65747e-17
C1013	CLK#2	a_728_331##15	4.96838e-18
C1014	a_818_418##5	VNB	2.62251e-17
C1015	VPWR#7	a_1586_149##13	9.48418e-19
C1016	CLK#4	a_728_331##9	2.64333e-19
C1017	a_728_331##6	VNB	3.4405e-17
C1018	VGND	VGND#6	3.84919e-17
C1019	CLK#1	VNB	5.27429e-17
C1020	a_728_331#	VNB	4.45851e-17
C1021	VPWR#13	a_70_74##3	6.76145e-17
C1022	VGND#2	a_2363_352#	1.0963e-17
C1023	a_818_418##3	VNB	2.53954e-17
C1024	a_331_392##6	a_614_81#	4.91377e-17
C1025	a_728_331##5	VNB	3.40817e-17
C1026	a_331_392#	VNB	3.29355e-17
C1027	VGND#1	a_2363_352#	2.13282e-17
C1028	RESET_B#6	VNB	4.53132e-17
C1029	a_298_294##7	a_331_392#	4.62214e-19
C1030	VGND	a_2363_352##4	4.26614e-18
C1031	a_298_294##3	VNB	4.44856e-17
C1032	VGND#14	VGND#3	4.24631e-19
C1033	RESET_B#3	VNB	2.1303e-17
C1034	VGND	a_1586_149##7	1.32894e-17
C1035	VGND#19	RESET_B#1	2.92348e-17
C1036	D#4	VNB	3.16799e-17
C1037	a_1586_149##4	a_1586_149##9	2.19891e-19
C1038	VGND	a_1800_291##2	1.93639e-18
C1039	VGND#4	a_2363_352##9	8.19886e-20
C1040	VPWR#2	VNB	9.41271e-17
C1041	VGND#2	VNB	9.496e-17
C1042	VGND	a_818_418##6	2.30118e-18
C1043	RESET_B#13	VPWR#10	4.97187e-20
C1044	VPWR#9	a_728_331##11	2.54183e-18
C1045	RESET_B#21	VNB	1.47002e-17
C1046	VGND	a_728_331##8	1.93866e-18
C1047	VPWR#6	VNB	1.56061e-17
C1048	VGND#6	VNB	2.09781e-17
C1049	a_331_392##6	RESET_B#4	2.29627e-17
C1050	VPWR#14	Q#1	1.00376e-16
C1051	Q_N#3	VPWR#5	4.06437e-18
C1052	RESET_B#13	VNB	3.05103e-18
C1053	VPWR#9	VNB	3.16239e-16
C1054	VGND#2	a_2363_352##6	6.0338e-19
C1055	a_70_74##5	a_298_294##4	1.16932e-18
C1056	VGND#9	VNB	3.27045e-16
C1057	a_2363_352##9	a_2363_352##5	7.54993e-20
C1058	a_2363_352##4	VNB	8.9227e-17
C1059	VPWR#5	a_1586_149##13	4.00477e-19
C1060	a_70_74##2	RESET_B#6	1.12842e-17
C1061	a_1586_149##7	VNB	6.01416e-17
C1062	RESET_B#8	VNB	4.17102e-17
C1063	Q_N#3	a_1586_149##7	2.83656e-20
C1064	VGND#4	a_1586_149##4	3.52099e-20
C1065	a_1800_291##2	VNB	4.19479e-17
C1066	VGND#4	Q_N#1	8.03206e-18
C1067	a_331_392##11	D#1	1.19642e-19
C1068	a_818_418##6	VNB	7.4483e-17
C1069	a_298_294##6	a_331_392#	4.14833e-19
C1070	a_728_331##8	VNB	6.19054e-17
C1071	a_818_418##11	VPWR#18	3.09703e-18
C1072	CLK#2	VNB	3.97973e-17
C1073	a_728_331##2	VNB	3.40051e-17
C1074	CLK#2	a_728_331##7	3.17609e-18
C1075	a_818_418#	VNB	5.88423e-17
C1076	a_331_392##2	VNB	6.59719e-17
C1077	RESET_B#5	VNB	5.9903e-17
C1078	a_298_294#	VNB	5.09127e-17
C1079	RESET_B#2	VNB	4.28811e-17
C1080	a_70_74##3	VPWR#11	1.25316e-16
C1081	D#3	VNB	1.10154e-16
C1082	VGND#2	a_1586_149#	2.26576e-20
C1083	Q#2	a_2363_352#	3.00757e-17
C1084	a_1586_149##7	VPWR#16	9.36134e-19
C1085	a_1586_149##14	a_1586_149##13	2.23274e-17
C1086	VGND#7	a_728_331##7	9.13954e-20
C1087	VPWR#7	VPWR#16	3.45947e-18
C1088	a_331_392##5	a_614_81#	4.22725e-17
C1089	VGND#9	a_728_331##11	5.86992e-19
C1090	a_331_392##7	a_298_294##4	1.96885e-17
C1091	VGND#19	D#1	4.32162e-18
C1092	a_1800_291##5	a_1586_149##7	1.68689e-17
C1093	CLK#4	CLK#3	3.71097e-18
C1094	a_728_331##2	VGND#17	1.21354e-17
C1095	Q_N#3	VPWR#4	4.02612e-18
C1096	Q	VNB	1.13659e-17
C1097	VGND#1	a_2363_352##6	6.45756e-19
C1098	D#8	a_70_74##5	3.28808e-19
C1099	VPWR	VNB	2.5754e-16
C1100	VGND	VNB	2.37401e-16
C1101	a_298_294##7	RESET_B#6	8.01268e-18
C1102	a_70_74##5	RESET_B#1	9.13917e-18
C1103	RESET_B	a_298_294#	2.64761e-17
C1104	VGND#11	a_298_294#	2.91553e-20
C1105	RESET_B	a_331_392##8	9.91247e-19
C1106	RESET_B	a_298_294##5	1.44898e-17
C1107	RESET_B	a_298_294##6	3.33856e-17
C1108	VGND#11	D#3	1.79202e-18
C1109	VGND#11	a_70_74##5	2.46583e-17
C1110	VGND#11	D#5	4.17188e-18
C1111	RESET_B	VGND#8	2.52574e-18
C1112	VGND#9	RESET_B	7.04233e-17
C1113	RESET_B	a_728_331##4	2.00688e-18
C1114	RESET_B	a_331_392##7	6.55613e-18
C1115	RESET_B	RESET_B#5	6.59751e-18
C1116	RESET_B	a_614_81#	2.28191e-17
C1117	RESET_B	a_298_294##7	4.05851e-17
C1118	RESET_B	VPWR#9	7.5302e-17
C1119	RESET_B	VGND#10	1.81398e-18
C1120	VGND#11	a_298_294##4	8.31597e-18
C1121	RESET_B	a_818_418##4	1.29412e-18
C1122	RESET_B	VPWR#8	6.9735e-18
C1123	VGND#11	D#1	6.77877e-18
C1124	VGND#11	VGND#10	1.20135e-18
C1125	RESET_B	VGND#18	3.24138e-18
C1126	RESET_B	a_331_392##2	5.56633e-17
C1127	RESET_B	VPWR#19	1.63414e-18
C1128	VGND#11	VNB	6.60346e-17
C1129	RESET_B	a_818_418##11	5.5058e-17
C1130	RESET_B	VPWR#10	2.38676e-18
C1131	VGND#11	a_331_392##11	9.98234e-18
C1132	RESET_B	VNB	1.02135e-17
C1133	RESET_B	a_818_418#	1.30367e-17
C1134	RESET_B	RESET_B#15	1.29473e-17
C1135	VGND#11	RESET_B#2	2.63449e-19
C1136	RESET_B	VGND#17	1.20475e-18
C1137	RESET_B	a_70_74##2	4.18374e-17
C1138	VGND#11	a_331_392##7	1.25662e-18
C1139	RESET_B	a_728_331##2	3.93757e-17
C1140	RESET_B	a_614_81##2	6.51714e-18
C1141	VGND#11	RESET_B#4	4.31389e-19
C1142	VGND#11	RESET_B#1	5.14067e-18
C1143	VGND#11	RESET_B#13	2.48708e-18
C1144	RESET_B	a_331_392##5	9.949e-18
C1145	VGND#9	VGND#11	1.28098e-16
C1146	VGND#11	a_298_294##2	5.57616e-21
C1147	RESET_B	a_70_74##3	2.07932e-18
C1148	RESET_B	a_70_74##6	2.05271e-17
C1149	RESET_B	a_818_418##2	7.48795e-19
C1150	VGND#11	VGND#18	3.48187e-19
C1151	a_331_392##6	RESET_B	2.1957e-17
*
*
.ENDS sky130_fd_sc_hs__dfrbp_2
*
