* Extracted by Quantus, converted by sky130cad/quantus.py
*
*
*
*                       LINUX           Wed Nov 18 08:24:53 2026
*
*
*
*  PROGRAM  advgen
*
*  Name           : advgen - Quantus - (64-bit)
*  Version        : 25.1.0-p047
*  Build Date     : Thu Dec 11 23:20:30 PST 2025
*
*  HSPICE LIBRARY
*
*  OPERATING_TEMPERATURE 150
*  QRC_TECH_DIR <path>/tech
*
*
*

*
.SUBCKT sky130_fd_sc_hs__clkinv_4 VPB VNB VGND VPWR Y A
*
*
*  caps2d version: 10
*
*
*       TRANSISTOR CARDS
*
*
XM8 VGND#4 A#11 Y#8 VNB sky130_fd_pr__nfet_01v8_lvt l=0.15 w=0.42 ad=0.3066 as=0.2961 pd=2.3 ps=2.25
XM5 Y#8 A#8 VGND#5 VNB sky130_fd_pr__nfet_01v8_lvt l=0.15 w=0.42 ad=0.2961 as=0.1764 pd=2.25 ps=1.68
XM2 VGND#5 A#6 Y#10 VNB sky130_fd_pr__nfet_01v8_lvt l=0.15 w=0.42 ad=0.1764 as=0.1281 pd=1.68 ps=1.45
XM3 Y#10 A#1 VGND#1 VNB sky130_fd_pr__nfet_01v8_lvt l=0.15 w=0.42 ad=0.1281 as=0.1386 pd=1.45 ps=1.5
XM0 VPWR#5 A#14 Y#5 VPB sky130_fd_pr__pfet_01v8 l=0.15 w=1.12 ad=0.3304 as=0.336 pd=2.83 ps=2.84
XM1 VPWR#7 A#15 Y#5 VPB sky130_fd_pr__pfet_01v8 l=0.15 w=1.12 ad=0.336 as=0.336 pd=2.84 ps=2.84
XM4 Y#6 A#13 VPWR#7 VPB sky130_fd_pr__pfet_01v8 l=0.15 w=1.12 ad=0.336 as=0.336 pd=2.84 ps=2.84
XM6 Y#6 A#12 VPWR#6 VPB sky130_fd_pr__pfet_01v8 l=0.15 w=1.12 ad=0.336 as=0.392 pd=2.84 ps=2.94
XM7 Y#1 A#7 VPWR#6 VPB sky130_fd_pr__pfet_01v8 l=0.15 w=1.12 ad=0.336 as=0.392 pd=2.84 ps=2.94
XM9 VPWR#1 A#5 Y#1 VPB sky130_fd_pr__pfet_01v8 l=0.15 w=1.12 ad=0.3864 as=0.336 pd=2.93 ps=2.84
*
*
*       RESISTOR AND CAP/DIODE CARDS
*
Rg1	A#1	A#2	472.157806
Rg2	A#2	A#3	63.986771
Rg3	A#3	A#4	113.741295
Rg4	A#2	A#5	449.655212
Rg5	A#3	A#6	491.096527
Rg6	A#3	A#7	430.841003
Rg7	A#4	A#8	484.373840
Rg8	A#4	A#9	56.222851
Rg9	A#9	A#10	79.886787
Rg10	A#10	A#11	492.604095
Rg11	A#4	A#12	429.126801
Rg12	A#9	A#13	419.554810
Rg13	A#10	A#14	598.551941
Rg14	A#10	A#15	432.348541
Rf1	A	A#16	0.916808
Rf2	A#16	A	13.752123
Rf3	Y#1	Y#2	17.026701
Rf4	Y#2	Y#3	69.348907
Rf5	Y#3	Y#4	65.696381
Rf6	Y#4	Y#5	17.027714
Rf7	Y#3	Y#6	17.027714
Rf8	Y#4	Y#7	161.310944
Rf9	Y#7	Y#8	14.410048
Rf10	Y#7	Y#9	88.656273
Rf11	Y#9	Y#10	30.767605
Rf12	Y#9	Y	45.357964
Rf13	Y	Y#11	54.409801
Rf14	Y#11	Y#2	22.475019
Rf15	VPWR#1	VPWR#2	98.039597
Rf16	VPWR#2	VPWR#3	32.175034
Rf17	VPWR#3	VPWR#4	36.623291
Rf18	VPWR#4	VPWR#5	107.540840
Rf19	VPWR#2	VPWR#6	38.736572
Rf20	VPWR#4	VPWR#7	53.143215
Rf21	VGND#1	VGND#2	105.058044
Rf22	VGND#2	VGND#3	29.195665
Rf23	VGND#3	VGND#4	92.185226
Rf24	VGND#2	VGND#5	35.688515
Rf25	A#4	A#16	32.046562
Re1	VPWR#3	VPWR	1.403190
Re2	VGND	VGND#3	1.403242
*
*       CAPACITOR CARDS
*
*
C1	A#2	Y#1	2.97865e-19
C2	VPWR#2	A#2	2.22453e-20
C3	VGND	VNB	5.51421e-17
C4	VPWR	VNB	5.82407e-17
C5	Y	VNB	3.60392e-17
C6	A	VNB	2.82717e-17
C7	VGND	Y	4.0519e-18
C8	A#10	A#9	2.96014e-18
C9	VGND#3	VNB	1.78824e-16
C10	VGND	A	1.24441e-17
C11	VPWR#3	VNB	1.6697e-16
C12	A#14	VNB	6.67568e-17
C13	VPWR	A	1.16255e-17
C14	A#15	VNB	3.19663e-17
C15	VGND	VGND#3	1.88914e-17
C16	A#13	VNB	3.32702e-17
C17	A#12	VNB	3.30842e-17
C18	A	Y	1.99137e-17
C19	A#3	Y#1	2.46698e-19
C20	A#7	VNB	3.0845e-17
C21	A#5	VNB	4.08925e-17
C22	A#11	VNB	4.49994e-17
C23	A#8	VNB	3.59631e-17
C24	VPWR	VPWR#3	8.89391e-18
C25	A#6	VNB	3.41056e-17
C26	A#10	A#13	2.31942e-19
C27	A#1	VNB	3.8817e-17
C28	VPWR#2	A#3	1.84241e-20
C29	VPWR#5	VNB	6.02627e-17
C30	VPWR	A#14	1.96613e-18
C31	Y#5	VNB	4.50184e-18
C32	VPWR#7	VNB	2.92383e-18
C33	VPWR	A#15	8.47949e-19
C34	Y#6	VNB	2.15003e-18
C35	VPWR#6	VNB	3.0111e-18
C36	VPWR	A#13	1.53726e-18
C37	Y#1	VNB	4.4837e-18
C38	VGND	A#11	8.39405e-18
C39	VPWR#1	VNB	6.37104e-17
C40	VGND#4	VNB	7.11188e-17
C41	VPWR	A#12	8.51504e-19
C42	VGND	A#8	8.39405e-18
C43	VGND	A#6	8.20161e-18
C44	VGND#5	VNB	8.12777e-18
C45	VPWR	A#7	1.99636e-19
C46	Y#10	VNB	4.20434e-18
C47	VGND	A#1	6.32626e-18
C48	VPWR	A#5	1.19702e-19
C49	VGND#1	VNB	5.95948e-17
C50	A	A#14	5.29765e-18
C51	Y#2	VNB	2.55031e-17
C52	Y#4	VNB	2.90281e-17
C53	Y#7	VNB	3.74851e-17
C54	Y#9	VNB	1.31894e-18
C55	A	A#13	2.04676e-18
C56	VPWR#2	VNB	2.50517e-17
C57	VPWR#4	VNB	2.54362e-17
C58	VGND#2	VNB	3.12088e-17
C59	VGND	VGND#4	6.58059e-17
C60	A	A#12	2.05474e-18
C61	VPWR	VPWR#5	3.2142e-17
C62	VPWR	Y#5	1.58676e-17
C63	VGND	Y#10	1.52399e-17
C64	A	A#5	9.71806e-19
C65	VGND	VGND#1	4.11196e-17
C66	VPWR	Y#6	1.58676e-17
C67	VGND#3	A#14	1.48131e-20
C68	VPWR	Y#1	1.5835e-17
C69	VPWR	VPWR#1	3.89239e-17
C70	VGND	Y#7	3.36085e-17
C71	VGND	Y#9	2.44209e-18
C72	VGND	VGND#2	4.41163e-17
C73	VPWR#3	A#13	1.60165e-18
C74	VPWR	Y#2	4.70105e-18
C75	VPWR#3	A#12	2.09802e-18
C76	A#12	A#3	1.85656e-19
C77	VPWR	Y#3	2.70438e-18
C78	A#14	A#15	4.65929e-17
C79	VPWR	Y#4	4.18905e-18
C80	VPWR	VPWR#2	3.28043e-17
C81	VGND#1	Y	3.08521e-17
C82	VPWR	VPWR#4	2.96696e-17
C83	VGND#3	A#8	2.63906e-18
C84	A#15	A#13	4.84384e-17
C85	Y	Y#2	1.07092e-19
C86	A#13	A#12	4.5864e-17
C87	A	Y#2	7.04967e-17
C88	A	Y#3	7.77484e-17
C89	VPWR#3	VPWR#5	2.60272e-17
C90	Y#4	A	9.0595e-17
C91	A#12	A#7	3.85807e-17
C92	Y#7	A	1.30762e-16
C93	Y#9	A	5.99285e-17
C94	Y#6	VPWR#3	1.66935e-17
C95	VPWR#4	A#10	3.8118e-20
C96	VGND#3	VGND#4	4.74779e-17
C97	A#2	VNB	4.40087e-17
C98	A#3	VNB	3.59903e-17
C99	A#7	A#5	4.65372e-17
C100	VGND#2	A#2	4.99888e-20
C101	A#9	VNB	7.26941e-17
C102	A#10	VNB	4.20498e-17
C103	A#14	VPWR#5	3.00053e-17
C104	Y#5	A#14	4.77515e-17
C105	VPWR#3	VPWR#1	2.95983e-17
C106	VPWR#5	A#15	1.23306e-18
C107	VPWR#7	A#14	6.79311e-19
C108	VGND#3	VGND#1	2.78711e-17
C109	Y#5	A#15	5.31574e-17
C110	VGND#2	A#3	3.28658e-20
C111	VPWR#5	A#13	2.59902e-19
C112	A#15	VPWR#7	2.84583e-17
C113	Y#5	A#13	2.11308e-18
C114	Y#6	A#15	1.76565e-18
C115	A#13	VPWR#7	2.47104e-17
C116	VPWR#6	A#15	1.72497e-19
C117	VGND#3	Y#7	2.35883e-17
C118	VGND#4	A#14	1.29624e-18
C119	VGND#4	A#10	5.98106e-19
C120	Y#6	A#13	4.64918e-17
C121	VPWR#7	A#12	3.44144e-19
C122	VPWR#6	A#13	3.71489e-19
C123	A#11	A#8	6.86762e-18
C124	Y#3	VPWR#3	8.33049e-20
C125	Y#6	A#12	5.30095e-17
C126	VGND#3	VGND#2	3.70888e-17
C127	VPWR#7	A#7	1.54166e-19
C128	A#12	VPWR#6	3.1819e-17
C129	Y#6	A#7	1.58905e-18
C130	VPWR#3	VPWR#2	3.3363e-17
C131	A#8	A#6	1.91449e-17
C132	Y#1	A#12	1.82447e-18
C133	A#3	A#5	2.31808e-19
C134	VPWR#3	VPWR#4	3.49679e-17
C135	A#7	VPWR#6	2.81456e-17
C136	VPWR#1	A#12	2.79651e-19
C137	Y#1	A#7	4.62673e-17
C138	VPWR#6	A#5	7.67688e-19
C139	A#6	A#1	2.99365e-17
C140	VPWR#1	A#7	1.34148e-18
C141	Y#4	A#14	3.71547e-17
C142	Y#1	A#5	4.83532e-17
C143	Y#7	A#14	2.37024e-18
C144	Y#2	A#15	2.15722e-19
C145	A#5	VPWR#1	2.85689e-17
C146	Y#3	A#15	5.11358e-21
C147	Y#4	A#15	1.74928e-17
C148	VPWR#4	A#14	2.15767e-18
C149	Y#2	A#13	1.14487e-19
C150	Y#3	A#13	1.78928e-17
C151	VPWR#2	A#15	8.74044e-20
C152	Y#4	A#13	3.67674e-19
C153	VPWR#5	Y#5	5.30395e-17
C154	Y#2	A#12	2.95247e-19
C155	VPWR#4	A#15	5.07729e-18
C156	Y#3	A#12	1.77134e-17
C157	A#11	VGND#4	2.32387e-17
C158	VGND#5	A#3	8.22081e-19
C159	VPWR#5	VPWR#7	1.94092e-18
C160	Y#4	A#12	1.32593e-19
C161	VPWR#2	A#13	3.00302e-19
C162	A#11	Y#8	1.34563e-17
C163	Y#2	A#7	1.7564e-17
C164	Y#5	VPWR#7	5.20507e-17
C165	VGND#4	A#8	2.12591e-18
C166	VPWR#4	A#13	4.44794e-18
C167	VGND#5	A#9	1.01276e-18
C168	VGND#5	A#11	2.05958e-18
C169	Y#3	A#7	4.93999e-21
C170	A#8	Y#8	1.343e-17
C171	Y#5	Y#6	2.96061e-18
C172	Y#4	A#7	1.23552e-19
C173	Y#2	A#5	2.51029e-17
C174	VGND#4	A#6	6.93822e-19
C175	VPWR#2	A#12	3.21401e-18
C176	A#8	VGND#5	1.98689e-17
C177	VPWR#4	A#12	2.85183e-19
C178	VPWR#7	Y#6	5.21059e-17
C179	Y#10	A#8	4.30132e-19
C180	A#6	VGND#5	1.58491e-17
C181	VPWR#2	A#7	4.52664e-18
C182	VPWR#7	VPWR#6	1.94092e-18
C183	Y	A#2	1.43516e-17
C184	VGND#1	A#8	5.1462e-19
C185	Y	A#3	2.664e-19
C186	Y	A#9	2.14763e-19
C187	VPWR#4	A#7	7.86402e-20
C188	VGND#4	VPWR#5	2.34657e-18
C189	Y	A#10	1.49977e-19
C190	Y#10	A#6	2.49545e-17
C191	Y#6	VPWR#6	5.29637e-17
C192	VGND#5	A#1	1.55236e-18
C193	VPWR#2	A#5	6.22645e-19
C194	VGND#1	A#6	2.23935e-18
C195	Y#10	A#1	1.40781e-17
C196	Y#6	Y#1	2.73117e-18
C197	VGND#1	A#1	2.02057e-17
C198	VPWR#6	Y#1	6.12484e-17
C199	Y#7	A#11	3.68573e-17
C200	VPWR#6	VPWR#1	2.24827e-18
C201	Y#7	A#8	3.62684e-17
C202	A	A#2	1.13614e-17
C203	Y#1	VPWR#1	6.41065e-17
C204	A	A#3	2.04792e-17
C205	Y#9	A#8	3.9736e-19
C206	A	A#9	3.68699e-17
C207	A	A#10	2.34295e-17
C208	Y#7	A#6	8.04147e-19
C209	Y#9	A#6	1.22946e-17
C210	VGND#2	A#8	1.59856e-19
C211	Y#4	VPWR#5	2.46539e-17
C212	Y#9	A#1	1.31069e-17
C213	VGND#2	A#6	2.65366e-18
C214	Y#2	VPWR#7	1.64125e-22
C215	Y#4	Y#5	1.83419e-18
C216	Y#3	VPWR#7	9.42755e-18
C217	VGND#4	VGND#5	3.08459e-18
C218	Y#4	VPWR#7	9.55251e-18
C219	VGND#1	VPWR#1	1.83867e-19
C220	Y#3	Y#6	9.72469e-19
C221	VPWR#5	VPWR#4	7.0017e-19
C222	Y#2	VPWR#6	1.44373e-17
C223	Y#3	VPWR#6	1.16841e-17
C224	Y#5	VPWR#4	1.66935e-17
C225	Y#2	Y#1	1.34708e-18
C226	VGND#5	Y#10	4.27102e-17
C227	Y#2	VPWR#1	3.87203e-17
C228	VGND#5	VGND#1	2.91511e-18
C229	Y#10	VGND#1	4.26836e-17
C230	Y#1	VPWR#2	1.49329e-17
C231	VGND#4	Y#7	7.27476e-17
C232	Y#2	A#2	5.48236e-18
C233	VPWR#2	VPWR#1	8.05022e-19
C234	VGND#3	A#9	2.2319e-19
C235	Y#7	Y#8	7.44423e-18
C236	VGND#3	A#10	4.11309e-20
C237	Y#2	A#3	2.17561e-18
C238	Y#7	VGND#5	5.36483e-17
C239	Y#2	A#9	1.38913e-19
C240	VGND#5	Y#9	1.61612e-17
C241	VGND#4	VGND#2	6.89595e-19
C242	Y#7	Y#10	1.49256e-18
C243	A#3	A#2	9.04891e-18
C244	VPWR#3	A#9	4.50366e-20
C245	VGND#1	Y#9	4.08383e-18
C246	Y#3	Y#2	2.75876e-20
C247	A#10	Y#5	5.35427e-19
C248	Y#3	A#9	4.91163e-18
C249	VGND#2	Y#10	1.57099e-17
C250	Y#4	Y#3	2.96061e-20
C251	VGND#2	VGND#1	1.38629e-18
C252	Y#9	Y#2	2.99508e-18
C253	A#9	VPWR#7	7.3833e-19
C254	Y#2	VPWR#2	1.6661e-19
C255	Y#7	Y#4	2.18568e-18
C256	A#10	VPWR#7	5.18082e-19
C257	Y#4	A#9	1.76409e-19
C258	Y#3	VPWR#2	2.25413e-19
C259	Y#4	A#10	4.56219e-18
C260	A#9	A#3	6.08706e-18
C261	Y#3	VPWR#4	4.75328e-19
C262	Y#7	Y#9	1.37885e-18
C263	A#14	A#10	1.1591e-18
C264	Y#7	A#3	7.3055e-20
C265	A#9	Y#6	6.03041e-19
C266	Y#4	VPWR#4	3.13618e-19
C267	Y#7	A#9	2.39826e-17
C268	Y#7	A#10	1.84288e-17
C269	Y#9	A#2	1.65886e-17
C270	VGND#2	Y#7	4.00489e-20
C271	A#3	VPWR#6	7.17558e-19
C272	Y#9	A#3	1.46194e-17
C273	VGND#2	Y#9	2.26944e-19
C274	VPWR#4	VPWR#2	6.99578e-19
C275	A#9	VPWR#6	9.62447e-19
C276	Y#9	A#9	5.72276e-19
*
*
.ENDS sky130_fd_sc_hs__clkinv_4
*
