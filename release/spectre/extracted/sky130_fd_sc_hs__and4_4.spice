* Extracted by Quantus, converted by sky130cad/quantus.py
*
*
*
*                       LINUX           Wed Nov 18 08:18:40 2026
*
*
*
*  PROGRAM  advgen
*
*  Name           : advgen - Quantus - (64-bit)
*  Version        : 25.1.0-p047
*  Build Date     : Thu Dec 11 23:20:30 PST 2025
*
*  HSPICE LIBRARY
*
*  OPERATING_TEMPERATURE 150
*  QRC_TECH_DIR <path>/tech
*
*
*

*
.SUBCKT sky130_fd_sc_hs__and4_4 VPB VNB VGND VPWR X C B A D
*
*
*  caps2d version: 10
*
*
*       TRANSISTOR CARDS
*
*
XM21 a_119_119##2 B#3 a_32_119# VNB sky130_fd_pr__nfet_01v8_lvt l=0.15 w=0.64 ad=0.1792 as=0.1824 pd=1.84 ps=1.85
XM17 a_119_119##2 A#5 a_116_392##22 VNB sky130_fd_pr__nfet_01v8_lvt l=0.15 w=0.64 ad=0.1792 as=0.1792 pd=1.84 ps=1.84
XM22 a_116_392##22 A#6 a_119_119# VNB sky130_fd_pr__nfet_01v8_lvt l=0.15 w=0.64 ad=0.1792 as=0.1792 pd=1.84 ps=1.84
XM14 a_32_119##2 B#2 a_119_119# VNB sky130_fd_pr__nfet_01v8_lvt l=0.15 w=0.64 ad=0.1792 as=0.1792 pd=1.84 ps=1.84
XM2 a_463_119##3 C#4 a_32_119##2 VNB sky130_fd_pr__nfet_01v8_lvt l=0.15 w=0.64 ad=0.1792 as=0.1792 pd=1.84 ps=1.84
XM4 a_463_119##3 D#5 VGND#9 VNB sky130_fd_pr__nfet_01v8_lvt l=0.15 w=0.64 ad=0.1792 as=0.34105 pd=1.84 ps=2.57
XM19 VGND#9 D#6 a_463_119# VNB sky130_fd_pr__nfet_01v8_lvt l=0.15 w=0.64 ad=0.34105 as=0.1792 pd=2.57 ps=1.84
XM5 a_32_119##4 C#5 a_463_119# VNB sky130_fd_pr__nfet_01v8_lvt l=0.15 w=0.64 ad=0.1705 as=0.1792 pd=1.85 ps=1.84
XM6 VGND#8 a_116_392##10 X#4 VNB sky130_fd_pr__nfet_01v8_lvt l=0.15 w=0.74 ad=0.2405 as=0.2294 pd=2.13 ps=2.1
XM10 X#4 a_116_392##8 VGND#7 VNB sky130_fd_pr__nfet_01v8_lvt l=0.15 w=0.74 ad=0.2294 as=0.259 pd=2.1 ps=2.18
XM11 X#6 a_116_392##6 VGND#7 VNB sky130_fd_pr__nfet_01v8_lvt l=0.15 w=0.74 ad=0.2072 as=0.259 pd=2.04 ps=2.18
XM16 VGND#1 a_116_392##5 X#6 VNB sky130_fd_pr__nfet_01v8_lvt l=0.15 w=0.74 ad=0.2146 as=0.2072 pd=2.06 ps=2.04
XM9 VPWR#7 B#5 a_116_392##17 VPB sky130_fd_pr__pfet_01v8 l=0.15 w=1 ad=0.295 as=0.3 pd=2.59 ps=2.6
XM13 VPWR#12 A#7 a_116_392##17 VPB sky130_fd_pr__pfet_01v8 l=0.15 w=1 ad=0.3 as=0.3 pd=2.6 ps=2.6
XM23 a_116_392##21 A#1 VPWR#12 VPB sky130_fd_pr__pfet_01v8 l=0.15 w=1 ad=0.315 as=0.3 pd=2.63 ps=2.6
XM12 a_116_392##21 B#1 VPWR#11 VPB sky130_fd_pr__pfet_01v8 l=0.15 w=1 ad=0.315 as=0.35 pd=2.63 ps=2.7
XM1 a_116_392##20 C#6 VPWR#11 VPB sky130_fd_pr__pfet_01v8 l=0.15 w=1 ad=0.3 as=0.35 pd=2.6 ps=2.7
XM7 a_116_392##20 D#7 VPWR#10 VPB sky130_fd_pr__pfet_01v8 l=0.15 w=1 ad=0.3 as=0.735 pd=2.6 ps=3.47
XM20 VPWR#10 D#1 a_116_392##19 VPB sky130_fd_pr__pfet_01v8 l=0.15 w=1 ad=0.735 as=0.35 pd=3.47 ps=2.7
XM18 VPWR#9 C#1 a_116_392##19 VPB sky130_fd_pr__pfet_01v8 l=0.15 w=1 ad=0.4418 as=0.35 pd=3.06 ps=2.7
XM15 VPWR#9 a_116_392##12 X#5 VPB sky130_fd_pr__pfet_01v8 l=0.15 w=1.12 ad=0.4418 as=0.392 pd=3.06 ps=2.94
XM3 X#5 a_116_392##11 VPWR#8 VPB sky130_fd_pr__pfet_01v8 l=0.15 w=1.12 ad=0.392 as=0.336 pd=2.94 ps=2.84
XM0 X#1 a_116_392##7 VPWR#8 VPB sky130_fd_pr__pfet_01v8 l=0.15 w=1.12 ad=0.336 as=0.336 pd=2.84 ps=2.84
XM8 VPWR#1 a_116_392# X#1 VPB sky130_fd_pr__pfet_01v8 l=0.15 w=1.12 ad=0.3864 as=0.336 pd=2.93 ps=2.84
*
*
*       RESISTOR AND CAP/DIODE CARDS
*
Rg1	A#1	A#2	425.091339
Rg2	A#2	A#3	17.800245
Rg3	A#3	A#4	35.535461
Rg4	A#4	A#5	356.528717
Rg5	A#2	A#6	356.235535
Rg6	A#4	A#7	429.729614
Rg7	B#1	B#2	846.734070
Rg8	B#2	B#3	1545.767822
Rg9	B#3	B#4	334.917725
Rg10	B#4	B#5	404.508209
Rg11	D#1	D#2	608.596558
Rg12	D#2	D#3	23.088646
Rg13	D#3	D#4	38.032951
Rg14	D#4	D#5	332.402710
Rg15	D#2	D#6	268.546509
Rg16	D#4	D#7	386.233704
Rg17	C#1	C#2	463.631226
Rg18	C#2	C#3	937.240356
Rg19	C#3	C#4	1321.079712
Rg20	C#3	C#5	386.082367
Rg21	C#4	C#6	889.763245
Rg22	a_116_392#	a_116_392##2	472.847595
Rg23	a_116_392##2	a_116_392##3	63.912682
Rg24	a_116_392##3	a_116_392##4	91.714249
Rg25	a_116_392##2	a_116_392##5	370.582062
Rg26	a_116_392##3	a_116_392##6	394.814545
Rg27	a_116_392##3	a_116_392##7	437.854187
Rg28	a_116_392##4	a_116_392##8	375.516602
Rg29	a_116_392##4	a_116_392##9	64.081955
Rg30	a_116_392##9	a_116_392##10	368.862610
Rg31	a_116_392##4	a_116_392##11	451.334412
Rg32	a_116_392##9	a_116_392##12	471.862823
Rf1	B#6	B	0.772649
Rf2	B#4	B#8	161.005447
Rf3	B#6	B#8	5.708254
Rf4	A#3	A	162.201172
Rf5	a_119_119#	a_119_119##2	89.634422
Rf6	D#3	D	161.413818
Rf7	a_463_119##2	a_463_119##3	84.343460
Rf8	a_463_119#	a_463_119##2	15.000000
Rf9	a_32_119#	a_32_119##3	189.635590
Rf10	a_32_119##3	a_32_119##4	166.394348
Rf11	a_32_119##2	a_32_119##3	7.500000
Rf12	C#7	C#2	162.046143
Rf13	C	C#9	1.813333
Rf14	C#7	C#9	5.267086
Rf15	a_116_392##4	a_116_392##14	152.587326
Rf16	a_116_392##14	a_116_392##15	94.023041
Rf17	a_116_392##15	a_116_392##16	102.154907
Rf18	a_116_392##16	a_116_392##18	37.373039
Rf19	a_116_392##14	a_116_392##19	18.602406
Rf20	a_116_392##15	a_116_392##20	20.927776
Rf21	a_116_392##16	a_116_392##21	31.665260
Rf22	a_116_392##18	a_116_392##22	97.692970
Rf23	a_116_392##17	a_116_392##18	15.000000
Rf24	X#1	X#2	31.350826
Rf25	X#2	X	57.066441
Rf26	X	X#3	48.981602
Rf27	X#3	X#4	88.590958
Rf28	X#2	X#5	81.099731
Rf29	X#3	X#6	16.181496
Rf30	VPWR#1	VPWR#2	101.138374
Rf31	VPWR#2	VPWR#3	76.711304
Rf32	VPWR#3	VPWR#4	83.873962
Rf33	VPWR#4	VPWR#5	95.525513
Rf34	VPWR#5	VPWR#6	66.792137
Rf35	VPWR#6	VPWR#7	107.686035
Rf36	VPWR#2	VPWR#8	42.573776
Rf37	VPWR#3	VPWR#9	31.534731
Rf38	VPWR#4	VPWR#10	16.571053
Rf39	VPWR#5	VPWR#11	35.924004
Rf40	VPWR#6	VPWR#12	30.353714
Rf41	VGND#1	VGND#2	105.078629
Rf42	VGND#2	VGND#3	67.887894
Rf43	VGND#3	VGND#4	82.887779
Rf44	VGND#4	VGND#5	28.830414
Rf46	VGND#2	VGND#7	36.279022
Rf47	VGND#3	VGND#8	33.306259
Rf48	VGND#5	VGND#9	32.735970
Re1	VPWR#4	VPWR	0.701577
Re2	VGND	VGND#4	0.701602
*
*       CAPACITOR CARDS
*
*
C1	a_32_119#	a_32_119##2	2.32641e-18
C2	a_116_392##14	VPWR#3	1.6661e-19
C3	VGND#9	C#3	1.97535e-17
C4	a_116_392##22	a_119_119##2	3.83673e-17
C5	a_32_119#	a_119_119#	7.36717e-18
C6	C#3	a_116_392##10	1.23187e-17
C7	VGND#9	D#4	6.01709e-19
C8	a_32_119#	a_116_392##22	1.45067e-17
C9	a_32_119#	a_119_119##2	7.35532e-17
C10	a_463_119##3	C#3	4.78488e-19
C11	a_116_392##14	C#5	2.48062e-18
C12	C#5	C#3	7.52387e-18
C13	a_463_119##3	D#4	5.58822e-19
C14	VGND#4	C#3	1.93799e-17
C15	a_116_392##16	a_116_392##15	2.30663e-18
C16	a_32_119##2	C#3	5.26047e-19
C17	a_116_392##4	a_116_392##9	2.02233e-17
C18	X#1	VPWR#1	7.28623e-17
C19	C#7	C#5	2.66235e-18
C20	C#3	D#6	1.90228e-17
C21	a_116_392##4	a_116_392##3	1.68141e-17
C22	a_116_392##4	a_116_392##2	4.45206e-20
C23	a_32_119##2	D#4	7.06575e-18
C24	a_116_392##15	C#4	1.52152e-17
C25	a_116_392##5	VGND#1	2.14009e-17
C26	VPWR#8	VPWR#1	2.45231e-18
C27	a_116_392##4	D#4	4.64872e-20
C28	a_116_392##16	B#2	1.22388e-18
C29	a_116_392##15	a_116_392##14	1.54937e-20
C30	a_116_392##5	X#6	1.5442e-17
C31	a_116_392##15	C#3	1.8966e-19
C32	VPWR#8	X#1	6.09509e-17
C33	C#3	D#4	7.29025e-19
C34	VGND#1	a_116_392##6	1.37221e-18
C35	VGND#7	a_116_392##5	6.77051e-19
C36	a_116_392##6	X#6	1.4935e-17
C37	C#2	a_116_392##9	2.28246e-17
C38	a_116_392##16	A#4	1.02608e-19
C39	a_116_392##15	D#4	1.38308e-17
C40	VGND#1	a_116_392##8	2.75937e-19
C41	a_116_392##6	VGND#7	1.71352e-17
C42	X#5	VPWR#8	6.42748e-17
C43	C#3	C#2	4.33557e-19
C44	C#7	C#4	4.22367e-19
C45	X#4	a_116_392##6	4.04506e-19
C46	VPWR#9	VPWR#8	1.97235e-18
C47	a_116_392##14	C#3	9.07207e-19
C48	VGND#7	a_116_392##8	3.18689e-17
C49	C#7	B#2	4.0929e-19
C50	X#4	a_116_392##8	2.59725e-17
C51	VPWR#9	X#5	4.78384e-17
C52	VGND#7	a_116_392##10	1.20394e-18
C53	C#4	C#3	3.63082e-19
C54	VGND#8	a_116_392##8	2.40122e-18
C55	a_116_392##22	D#4	3.84275e-19
C56	VPWR#2	a_116_392#	2.1812e-18
C57	VGND#2	VGND#1	1.33519e-18
C58	a_116_392##19	X#5	1.8616e-18
C59	C#4	D#4	2.37321e-17
C60	C#3	D#3	9.70618e-19
C61	a_116_392##10	X#4	2.30433e-17
C62	a_116_392##22	a_116_392##17	2.222e-18
C63	a_116_392##10	VGND#8	2.23485e-17
C64	a_116_392##19	VPWR#9	6.22197e-17
C65	X#2	a_116_392#	9.38977e-18
C66	VPWR#2	a_116_392##7	4.91606e-18
C67	a_32_119##4	a_116_392##10	3.14491e-19
C68	a_119_119##2	a_116_392##17	5.57354e-19
C69	VPWR#10	VPWR#9	1.78529e-18
C70	a_116_392##22	A#4	3.54694e-18
C71	VGND#8	C#5	2.46899e-18
C72	a_463_119#	a_116_392##10	1.13371e-18
C73	a_32_119#	a_116_392##17	6.97725e-19
C74	X#2	a_116_392##7	1.22827e-17
C75	a_32_119##4	C#5	3.85607e-17
C76	VPWR#10	a_116_392##19	7.22743e-17
C77	VPWR#2	a_116_392##11	7.54985e-18
C78	VGND#9	a_116_392##10	4.5654e-19
C79	VGND#8	D#6	6.08591e-19
C80	a_463_119#	C#5	3.01775e-17
C81	VGND#3	X#4	7.4696e-18
C82	a_116_392##20	a_116_392##19	1.43317e-18
C83	a_32_119##4	D#6	1.07693e-17
C84	A#4	A#3	4.1115e-18
C85	VPWR#3	a_116_392##12	4.22812e-18
C86	X#2	a_116_392##11	4.00009e-19
C87	VGND#9	C#5	1.4713e-18
C88	VGND#8	D#5	3.3077e-19
C89	VPWR#2	a_116_392##12	2.89928e-19
C90	a_116_392##20	VPWR#10	7.14709e-17
C91	a_463_119#	D#6	3.73872e-17
C92	VGND#2	X#4	7.24253e-18
C93	a_32_119##4	D#5	4.75375e-19
C94	D#6	VGND#9	2.20639e-17
C95	VPWR#11	VPWR#10	1.94421e-18
C96	VPWR#3	C#1	2.58166e-18
C97	VGND#8	C#4	3.12533e-19
C98	a_32_119##2	C#5	1.75932e-19
C99	a_463_119#	D#5	5.71827e-19
C100	C#7	a_116_392##9	3.25265e-18
C101	VPWR#2	C#1	6.9671e-20
C102	a_463_119##3	D#6	5.5638e-19
C103	a_116_392##14	a_116_392##11	3.82862e-20
C104	a_32_119##4	C#4	2.2803e-19
C105	VPWR#11	a_116_392##20	6.65984e-17
C106	VGND#8	VGND#2	6.97234e-20
C107	D#5	VGND#9	2.22511e-17
C108	a_32_119##2	D#6	6.33097e-19
C109	B#4	A#4	2.79129e-17
C110	VGND#3	a_32_119##4	2.05452e-18
C111	a_116_392##15	a_116_392##12	1.33804e-19
C112	a_463_119##3	D#5	3.73986e-17
C113	X#3	VGND#1	3.60128e-17
C114	a_32_119##4	B#2	1.58302e-19
C115	VGND#9	C#4	3.03933e-18
C116	a_116_392##14	a_116_392##12	1.6176e-19
C117	a_32_119##2	D#5	1.13384e-17
C118	a_116_392##21	VPWR#11	4.93495e-17
C119	a_463_119##3	C#4	3.32473e-17
C120	a_116_392##15	C#1	2.07437e-19
C121	a_116_392##3	X#1	9.94324e-20
C122	VGND#9	B#2	9.23683e-19
C123	X#3	X#6	4.68449e-19
C124	a_32_119##2	C#4	3.41947e-17
C125	VPWR#12	VPWR#11	1.9829e-18
C126	a_116_392##14	C#1	1.77106e-17
C127	a_463_119##3	B#2	9.57646e-19
C128	a_119_119#	C#4	5.66346e-19
C129	a_116_392##2	X#1	1.28497e-19
C130	VPWR#5	C#6	2.60826e-18
C131	VPWR#12	a_116_392##21	4.08196e-17
C132	C#7	C#3	3.25681e-19
C133	a_116_392##15	D#1	2.25506e-19
C134	a_32_119##2	B#2	4.49223e-17
C135	a_116_392##22	C#4	1.28511e-18
C136	X#3	VGND#7	6.32358e-17
C137	a_116_392##14	D#1	1.57427e-17
C138	a_119_119#	B#2	2.7329e-17
C139	a_32_119##2	A#6	8.15281e-18
C140	VPWR#5	B#1	1.88754e-18
C141	a_116_392##22	B#2	3.12634e-18
C142	a_116_392##15	D#7	2.1819e-17
C143	a_116_392##17	VPWR#12	1.93133e-17
C144	VPWR#7	a_116_392##21	1.27115e-18
C145	a_32_119#	C#4	2.28701e-19
C146	VPWR#8	a_116_392##3	3.49053e-19
C147	a_119_119#	A#6	3.28267e-17
C148	X#4	X#3	2.49329e-18
C149	a_116_392##14	D#7	4.22936e-21
C150	a_32_119##2	A#5	4.90694e-19
C151	VPWR#7	VPWR#12	1.57959e-17
C152	VPWR#6	A#1	4.04268e-18
C153	a_116_392##22	A#6	2.63327e-17
C154	a_116_392##16	C#6	4.79588e-19
C155	a_32_119#	B#2	1.40726e-18
C156	a_116_392##15	C#6	1.84834e-17
C157	VPWR#7	a_116_392##17	3.36839e-17
C158	a_32_119##2	B#3	6.45414e-19
C159	a_116_392##22	A#5	3.1471e-17
C160	a_32_119#	A#6	5.4977e-19
C161	X#5	a_116_392##9	6.68645e-19
C162	a_119_119#	B#3	3.56729e-20
C163	a_116_392##16	B#1	2.59115e-17
C164	VPWR#6	A#7	4.03547e-18
C165	a_119_119##2	A#5	2.52855e-17
C166	a_116_392##15	B#1	1.34108e-18
C167	a_116_392##22	B#3	8.82423e-18
C168	a_32_119#	A#5	9.62283e-18
C169	a_119_119##2	B#3	2.16919e-17
C170	a_116_392##16	A#1	2.03453e-17
C171	VPWR#6	B#5	3.08515e-18
C172	a_32_119#	B#3	5.15295e-17
C173	a_116_392##15	A#1	1.92678e-19
C174	a_116_392##3	a_116_392#	1.34827e-18
C175	a_116_392##6	a_116_392##5	3.72572e-17
C176	a_116_392##16	A#7	3.89201e-20
C177	VPWR#11	C#4	7.47059e-19
C178	a_116_392##8	a_116_392##6	2.3836e-17
C179	VPWR#1	a_116_392#	3.44522e-17
C180	VPWR#4	VPWR#6	4.36949e-17
C181	a_32_119##4	D#1	1.89577e-18
C182	X#1	a_116_392#	4.63737e-17
C183	VPWR#4	VPWR#5	3.83784e-17
C184	VGND#4	VGND#3	4.32434e-17
C185	VGND#8	a_116_392##14	3.56537e-18
C186	VPWR#1	a_116_392##7	1.25472e-18
C187	a_116_392##10	a_116_392##8	3.51194e-17
C188	VPWR#4	VPWR#3	4.18893e-17
C189	VPWR#8	a_116_392#	2.28722e-18
C190	a_32_119##4	a_116_392##15	1.32748e-18
C191	VGND#4	VGND#2	4.56649e-17
C192	VPWR#4	VPWR#2	4.29927e-17
C193	a_116_392##7	X#1	1.54243e-17
C194	X#5	a_116_392#	2.11095e-19
C195	VPWR#8	a_116_392##7	5.35473e-17
C196	a_32_119##4	a_116_392##14	1.69031e-17
C197	VGND#3	a_116_392##4	5.51707e-19
C198	X#5	a_116_392##7	2.04001e-18
C199	VGND#2	a_116_392##4	6.72022e-20
C200	a_116_392##11	VPWR#8	2.09746e-17
C201	VPWR#9	a_116_392##7	2.59975e-19
C202	X#5	a_116_392##11	7.70439e-17
C203	a_116_392##11	a_116_392##3	1.71475e-18
C204	D#6	C#5	3.44011e-17
C205	VPWR#8	a_116_392##12	3.62677e-19
C206	VGND#3	C#2	5.28573e-19
C207	VPWR#9	a_116_392##11	1.69688e-18
C208	a_116_392##4	VPWR#3	3.23051e-19
C209	a_463_119##3	C#6	1.79999e-19
C210	VPWR#2	a_116_392##4	6.6434e-20
C211	X#5	a_116_392##12	1.94906e-17
C212	a_116_392##17	B#3	7.95816e-21
C213	a_32_119##2	C#6	8.93048e-19
C214	a_116_392##19	a_116_392##11	1.45852e-19
C215	X#3	a_116_392##4	3.11303e-17
C216	VPWR#8	C#1	1.60883e-19
C217	a_116_392##12	VPWR#9	3.06228e-17
C218	a_116_392##4	X#2	4.59193e-17
C219	D#5	D#6	1.70562e-17
C220	C#4	C#5	1.33241e-19
C221	X#5	C#1	1.43587e-18
C222	VGND#8	C#7	6.3498e-18
C223	a_116_392##19	a_116_392##12	6.16228e-19
C224	D	D#4	4.99043e-18
C225	VPWR#3	C#2	2.5387e-20
C226	a_32_119##2	a_116_392##16	1.46158e-17
C227	C#1	VPWR#9	3.36705e-17
C228	VPWR#10	a_116_392##12	3.57035e-19
C229	a_116_392##19	C#1	5.34127e-17
C230	C#4	D#5	4.72667e-17
C231	VGND#3	a_116_392##9	3.80223e-20
C232	a_32_119##4	C#7	2.17793e-17
C233	VPWR#9	D#1	1.18275e-18
C234	a_32_119##2	a_116_392##15	3.68731e-17
C235	VPWR#10	C#1	2.27592e-18
C236	a_119_119#	a_116_392##16	7.76019e-18
C237	D#1	a_116_392##19	1.88088e-17
C238	a_116_392##20	C#1	1.22514e-19
C239	a_116_392##15	C#2	5.443e-20
C240	C#7	a_116_392##4	2.52633e-17
C241	a_116_392##14	C#2	2.69146e-18
C242	VPWR#10	D#1	6.93179e-17
C243	VPWR#10	D#4	3.24939e-20
C244	B#2	C#4	7.29975e-17
C245	a_116_392##19	D#7	4.18707e-19
C246	a_116_392##20	D#1	4.37394e-19
C247	A	D#4	7.96953e-19
C248	D#7	VPWR#10	5.58463e-17
C249	VPWR#11	D#1	8.68064e-20
C250	a_116_392##15	D#3	6.4028e-18
C251	C#7	C#2	1.49984e-17
C252	VGND#4	VGND#1	2.89809e-17
C253	VPWR#2	VPWR#1	5.74821e-20
C254	a_116_392##14	D#3	7.24084e-18
C255	a_116_392##20	D#7	5.02332e-17
C256	B#2	A#6	5.48426e-17
C257	VPWR#10	C#6	8.68074e-19
C258	VPWR#11	D#7	1.2717e-18
C259	B#4	VPWR#6	2.6376e-19
C260	a_116_392##16	A#3	8.57465e-18
C261	a_116_392##20	C#6	4.24898e-17
C262	VGND#3	VGND#2	1.13178e-18
C263	a_116_392##15	A#3	6.92774e-20
C264	C#7	D#3	3.6563e-18
C265	VPWR#10	B#1	3.55662e-19
C266	VPWR#11	C#6	2.02411e-17
C267	A#5	A#6	3.56744e-17
C268	X#1	VPWR#2	1.25526e-17
C269	B#3	B#2	4.9253e-19
C270	VGND#4	a_32_119##4	2.33817e-18
C271	a_116_392##4	VGND#7	4.3097e-18
C272	a_116_392##20	B#1	1.09555e-18
C273	X#2	VPWR#1	3.01961e-17
C274	VGND#4	a_463_119#	8.53194e-18
C275	a_116_392##4	X#4	5.77678e-17
C276	VGND#2	a_116_392##3	5.01069e-20
C277	VPWR#11	B#1	5.3408e-17
C278	VGND#3	C#3	1.48547e-17
C279	VGND#8	a_116_392##4	3.09431e-17
C280	B#3	A#5	5.23028e-17
C281	B#1	a_116_392##21	1.37708e-17
C282	VPWR#11	A#1	2.46998e-18
C283	VPWR#12	B#1	1.93342e-18
C284	VGND#7	VGND#1	1.89333e-18
C285	X#4	C#2	6.55547e-19
C286	X#2	X#1	9.21927e-19
C287	X#5	VPWR#3	8.47627e-18
C288	A#1	a_116_392##21	2.45992e-17
C289	a_116_392##17	B#1	1.88385e-19
C290	VGND#8	C#2	1.34336e-17
C291	VPWR#4	VPWR#1	2.85952e-17
C292	VGND#2	a_116_392##2	4.36225e-20
C293	a_32_119##4	C#2	6.62327e-18
C294	VPWR#12	A#1	4.54135e-17
C295	VPWR#7	B#1	1.21954e-19
C296	C#5	D#1	8.25517e-18
C297	a_463_119#	C#2	1.94172e-18
C298	a_116_392##21	A#7	3.3748e-19
C299	a_116_392##17	A#1	9.94154e-20
C300	X#5	VPWR#2	9.48614e-18
C301	C	a_116_392##9	5.46668e-19
C302	VPWR#12	A#7	4.37169e-17
C303	VPWR#7	A#1	2.06513e-19
C304	D#4	D#1	4.08507e-19
C305	X#2	VPWR#8	2.42876e-17
C306	a_32_119##4	D#3	1.37233e-17
C307	a_32_119##2	C#2	7.64177e-20
C308	a_116_392##17	A#7	4.78446e-17
C309	a_116_392##21	B#5	1.67748e-19
C310	VGND#2	C#3	5.27019e-19
C311	a_463_119#	D#3	1.21607e-18
C312	VPWR#7	A#7	6.79009e-18
C313	VGND#9	D#3	3.3191e-19
C314	VPWR#12	B#5	7.86675e-18
C315	VPWR#4	VPWR#10	5.67787e-17
C316	a_463_119##3	D#3	6.78819e-21
C317	VGND#1	C#3	2.35926e-20
C318	VPWR#9	VPWR#2	1.99968e-19
C319	a_116_392##17	B#5	4.53128e-17
C320	a_116_392##7	a_116_392#	4.70773e-17
C321	a_116_392##4	VPWR#8	2.78835e-18
C322	X#5	X#2	2.59773e-18
C323	VPWR#7	B#5	3.79038e-17
C324	a_116_392##19	VPWR#3	8.43957e-18
C325	a_116_392##4	X#5	9.28361e-17
C326	X#4	VGND#7	4.66425e-17
C327	C#4	C#6	2.19184e-19
C328	a_116_392##4	VPWR#9	1.66152e-17
C329	VPWR#5	VPWR#10	9.95448e-19
C330	a_116_392##11	a_116_392##7	4.73588e-17
C331	B#1	C#4	2.81332e-18
C332	a_119_119#	A#3	1.01945e-19
C333	a_116_392##22	A#3	3.7902e-18
C334	X	a_116_392##2	1.78862e-17
C335	VGND#8	VGND#7	2.17276e-18
C336	VPWR#9	C#2	4.21994e-19
C337	VPWR#4	VPWR#7	2.5626e-17
C338	VPWR#10	VPWR#3	9.95448e-19
C339	a_119_119##2	A#3	3.23761e-19
C340	a_116_392##12	a_116_392##11	3.81205e-17
C341	a_32_119#	A#3	2.58224e-19
C342	a_116_392##20	VPWR#5	8.50451e-18
C343	B#4	a_116_392##22	1.48547e-17
C344	VGND#8	X#4	6.86423e-17
C345	a_32_119#	B#4	1.62468e-17
C346	C#1	a_116_392##12	3.04084e-17
C347	VPWR#10	D#3	3.38527e-18
C348	VGND#7	a_116_392##3	3.63246e-19
C349	a_116_392##14	X#5	4.88669e-19
C350	D#1	C#1	3.59491e-17
C351	VPWR#6	VPWR#5	9.90437e-19
C352	a_116_392##15	VPWR#9	2.42185e-22
C353	C#6	D#4	1.03699e-17
C354	VGND#4	D#6	1.67135e-18
C355	a_116_392##21	VPWR#6	4.89324e-18
C356	a_116_392##15	D	4.97806e-17
C357	X#4	a_116_392##9	1.21452e-18
C358	a_32_119##4	VGND#8	1.44222e-17
C359	D#7	D#1	7.66523e-18
C360	VPWR#12	A#3	1.12091e-18
C361	a_116_392##14	VPWR#9	1.96555e-17
C362	C#2	a_116_392##10	1.6774e-17
C363	a_116_392##17	A#3	3.05017e-18
C364	VGND#7	C#3	1.69034e-19
C365	a_116_392##21	VPWR#5	5.58697e-18
C366	C#5	C#2	2.76803e-17
C367	D	C#7	3.58675e-18
C368	a_116_392##15	a_116_392##19	1.00709e-19
C369	VGND#2	X#3	1.70206e-17
C370	C#6	D#7	4.11457e-17
C371	VPWR#3	a_116_392##9	2.10273e-20
C372	A	a_116_392##16	3.56126e-17
C373	a_463_119#	VGND#8	1.25626e-17
C374	B#4	a_116_392##17	3.48247e-17
C375	D#3	C#5	4.05395e-18
C376	B#4	VPWR#7	2.32741e-17
C377	a_116_392##14	a_116_392##19	1.07459e-18
C378	B#1	C#6	4.54923e-17
C379	VPWR#12	VPWR#5	1.66616e-19
C380	a_116_392##15	VPWR#10	3.35422e-17
C381	VGND	a_116_392##9	3.47941e-20
C382	a_32_119##4	a_463_119#	5.00112e-17
C383	VGND#9	VGND#8	4.42079e-18
C384	VGND	a_116_392##3	6.4495e-19
C385	VGND	C#3	1.50323e-17
C386	A#1	B#1	3.93263e-17
C387	a_116_392##17	VPWR#6	2.57036e-18
C388	a_32_119##4	D	2.87554e-17
C389	a_116_392##14	VPWR#10	3.11512e-17
C390	B#2	A#3	1.7448e-17
C391	X#4	C#3	3.82271e-19
C392	a_32_119##4	VGND#9	9.69355e-19
C393	a_116_392##4	a_116_392##11	6.98469e-19
C394	a_116_392##15	a_116_392##20	2.04842e-19
C395	a_116_392##17	A#4	7.50179e-18
C396	A#7	A#1	4.24163e-17
C397	a_116_392##4	a_116_392##12	8.40434e-18
C398	B#3	A#3	4.4217e-19
C399	a_116_392##4	C#1	9.39394e-19
C400	a_116_392##16	VPWR#11	4.6519e-17
C401	C	a_116_392##14	3.66616e-17
C402	C#2	a_116_392##12	3.11706e-18
C403	VGND#2	a_116_392##5	2.54989e-18
C404	VPWR#7	VPWR#6	8.9994e-19
C405	a_116_392##4	D#1	5.82098e-19
C406	B#5	A#7	4.61548e-17
C407	a_463_119#	VGND#9	2.5833e-17
C408	a_463_119##3	a_32_119##4	5.32887e-18
C409	a_119_119#	A	2.97476e-18
C410	a_116_392##4	D#7	4.89339e-21
C411	a_116_392##22	A	2.97807e-17
C412	D#1	C#2	1.27807e-17
C413	a_116_392##15	VPWR#11	4.31334e-17
C414	X#3	X	2.27553e-18
C415	D	VPWR#10	4.90808e-18
C416	a_116_392##9	VNB	2.45735e-17
C417	a_116_392##3	VNB	3.05069e-17
C418	VPWR#3	VPWR#2	7.86162e-19
C419	a_116_392##2	VNB	3.36832e-17
C420	C#3	VNB	1.10133e-16
C421	D#4	VNB	3.08768e-17
C422	A#4	VNB	1.82568e-17
C423	VPWR#2	a_116_392##3	3.96166e-20
C424	a_116_392##16	a_116_392##21	2.14782e-18
C425	a_463_119##3	a_463_119#	2.62965e-18
C426	a_32_119##2	a_32_119##4	1.48856e-18
C427	a_32_119##4	a_116_392##9	8.3778e-19
C428	VGND#2	a_116_392##6	5.03952e-18
C429	a_32_119#	B	1.35855e-17
C430	VGND#8	C#3	1.03374e-17
C431	VPWR	VPWR#6	2.78674e-17
C432	VPWR	VPWR#5	2.23462e-17
C433	VPWR	VPWR#3	2.41112e-17
C434	VPWR	VPWR#2	4.26783e-17
C435	A	VPWR#12	3.87284e-18
C436	A#3	B#1	1.18384e-17
C437	a_463_119##3	VGND#9	2.46136e-17
C438	VPWR	X#2	2.4547e-18
C439	X	VGND#1	2.3419e-17
C440	a_116_392##17	A	3.97748e-17
C441	VPWR	a_116_392##16	2.93029e-18
C442	VPWR	a_116_392##15	2.94274e-18
C443	a_116_392##16	VPWR#12	1.07111e-17
C444	VPWR#2	a_116_392##2	5.11968e-20
C445	VPWR	a_116_392##14	3.60003e-18
C446	D	C#4	5.25839e-19
C447	VGND#2	a_116_392##8	4.73263e-18
C448	D	B#2	1.55655e-19
C449	VGND	VGND#3	3.13259e-17
C450	VGND	VGND#2	4.62885e-17
C451	B	VPWR#7	1.96356e-17
C452	a_32_119##2	VGND#9	8.21869e-18
C453	a_116_392##4	C#2	6.83523e-18
C454	VGND#4	D#3	2.18579e-19
C455	A	C#4	1.08033e-18
C456	VGND	X#3	1.87214e-17
C457	X	VPWR#1	3.305e-17
C458	VGND	X#2	4.6868e-18
C459	A	B#2	2.22303e-18
C460	a_116_392##4	D#3	4.18819e-19
C461	VGND	a_116_392##16	4.5449e-18
C462	VGND#3	a_116_392##10	5.59717e-18
C463	VGND	a_116_392##15	4.22558e-18
C464	a_116_392##17	a_116_392##16	2.30239e-18
C465	X#3	a_116_392##3	3.30046e-18
C466	a_116_392##16	VPWR#6	3.94439e-19
C467	D#3	C#2	2.50506e-18
C468	A	B#3	1.35963e-19
C469	VGND	C#7	4.38919e-18
C470	a_32_119##2	a_463_119##3	8.49497e-17
C471	X#3	a_116_392##5	4.24793e-17
C472	VGND#2	a_116_392##10	5.00125e-19
C473	VPWR	VPWR#1	4.07382e-17
C474	a_32_119##4	C#3	3.48828e-18
C475	VGND	VGND#1	3.42227e-17
C476	VPWR	X#1	1.47497e-17
C477	VGND#3	VNB	3.08325e-17
C478	VGND#2	VNB	3.59095e-17
C479	VPWR	X#5	1.78138e-17
C480	VPWR#6	VNB	3.50087e-17
C481	VGND	X#4	1.4378e-17
C482	VPWR#5	VNB	2.90612e-17
C483	VPWR	VPWR#9	2.14894e-17
C484	VGND	VGND#8	2.02192e-17
C485	VPWR#3	VNB	3.18081e-17
C486	VGND	a_32_119##4	1.04668e-17
C487	VPWR	a_116_392##19	1.64344e-17
C488	VPWR#2	VNB	3.31375e-17
C489	X#3	VNB	7.96702e-18
C490	VGND	a_463_119#	1.31508e-17
C491	VPWR	VPWR#10	7.74434e-17
C492	X#2	VNB	4.07378e-18
C493	VGND	VGND#9	1.56638e-17
C494	VPWR	a_116_392##20	1.61831e-17
C495	D	B#1	3.01269e-21
C496	VGND	a_463_119##3	1.36553e-17
C497	a_116_392##16	VNB	5.51894e-18
C498	VPWR	VPWR#11	2.1337e-17
C499	X#2	VPWR#2	2.5317e-19
C500	a_116_392##15	VNB	3.0797e-18
C501	VGND	a_32_119##2	2.95392e-17
C502	a_116_392##14	VNB	4.29034e-18
C503	VGND	a_119_119#	8.08429e-18
C504	VPWR	a_116_392##21	1.17579e-17
C505	X#2	a_116_392##9	8.04742e-20
C506	a_116_392##16	VPWR#5	1.91556e-19
C507	VGND	a_116_392##22	6.15293e-18
C508	X#3	a_116_392##2	2.17328e-18
C509	VPWR	VPWR#12	2.23058e-17
C510	VGND	a_119_119##2	7.71935e-18
C511	VPWR	a_116_392##17	8.95411e-18
C512	C#7	VNB	3.56272e-18
C513	VGND	a_32_119#	3.15301e-17
C514	VPWR	VPWR#7	3.65579e-17
C515	VGND	VPWR#1	1.96134e-18
C516	A	B#1	4.74191e-19
C517	a_32_119##4	D#4	1.51147e-18
C518	VGND	X#5	2.57921e-18
C519	VGND#1	VNB	5.02816e-17
C520	X#3	a_116_392##6	3.9944e-17
C521	C	a_116_392##12	5.17359e-19
C522	VGND#7	VNB	4.56457e-19
C523	X#4	VNB	4.98596e-18
C524	VGND#8	VNB	1.59656e-17
C525	a_32_119##4	VNB	2.10797e-18
C526	C	D#1	5.04668e-18
C527	a_463_119#	VNB	6.90453e-19
C528	VGND#9	VNB	5.98283e-18
C529	a_463_119##3	VNB	3.71998e-19
C530	D	a_116_392##4	1.18577e-18
C531	a_32_119##2	VNB	1.05721e-17
C532	a_116_392##22	VNB	2.93643e-18
C533	VGND	a_116_392##5	1.29128e-18
C534	a_32_119##2	a_119_119#	6.0518e-17
C535	D	C#2	2.52863e-18
C536	VGND	a_116_392##6	1.63433e-19
C537	a_32_119#	VNB	5.28095e-17
C538	VGND	a_116_392##8	6.33898e-19
C539	VPWR#1	VNB	8.68233e-17
C540	X#1	VNB	2.40111e-18
C541	VGND	a_116_392##10	1.08926e-18
C542	D	D#3	1.9196e-17
C543	VPWR#8	VNB	4.09278e-19
C544	VGND	C#5	1.0573e-18
C545	VPWR	a_116_392#	3.67404e-18
C546	X#5	VNB	3.33921e-18
C547	X#3	X#2	2.32281e-17
C548	VGND	D#6	3.62448e-18
C549	VPWR#9	VNB	3.96198e-18
C550	VPWR	a_116_392##7	1.1919e-18
C551	D	A#3	1.76204e-19
C552	a_116_392##19	VNB	2.77013e-18
C553	VGND	D#5	3.36401e-18
C554	X#2	a_116_392##3	1.13522e-17
C555	VPWR#10	VNB	4.60245e-17
C556	VPWR	a_116_392##11	3.92106e-19
C557	VGND	C#4	9.40302e-18
C558	a_116_392##20	VNB	2.15328e-18
C559	a_116_392##15	VPWR#5	1.01764e-19
C560	VGND	B#2	8.60595e-18
C561	VPWR	a_116_392##12	3.96363e-18
C562	VPWR#11	VNB	2.84672e-18
C563	a_116_392##21	VNB	4.70542e-18
C564	VPWR	C#1	2.01474e-19
C565	VPWR#12	VNB	3.13885e-19
C566	A	A#3	2.42116e-17
C567	a_116_392##17	VNB	2.7658e-18
C568	VPWR	D#1	5.3817e-19
C569	a_116_392##3	a_116_392##2	3.91241e-18
C570	VGND	B#3	1.14194e-17
C571	VPWR#7	VNB	7.83165e-17
C572	a_116_392##5	VNB	3.95399e-17
C573	a_116_392##6	VNB	2.67956e-17
C574	VPWR	C#6	3.24376e-19
C575	C	a_116_392##4	1.79988e-17
C576	a_116_392##8	VNB	2.49402e-17
C577	a_116_392##10	VNB	3.21659e-17
C578	VPWR	B#1	1.4095e-18
C579	C	C#2	9.16037e-18
C580	X#3	a_116_392##8	1.63905e-18
C581	C#5	VNB	2.49892e-17
C582	VPWR	A#1	4.8183e-19
C583	D#6	VNB	2.21913e-17
C584	B	B#4	9.90598e-18
C585	D#5	VNB	2.12703e-17
C586	C	D#3	1.42222e-20
C587	VPWR	A#7	3.02428e-19
C588	a_116_392##22	a_32_119##2	9.36972e-18
C589	C#4	VNB	8.38801e-17
C590	a_463_119#	C#3	4.82774e-18
C591	B#2	VNB	8.33718e-17
C592	VGND	D#1	4.35636e-19
C593	VPWR	B#5	1.93148e-18
C594	a_116_392##4	X	3.63259e-18
C595	A#6	VNB	2.0263e-17
C596	A#5	VNB	2.00911e-17
C597	X	C#2	1.44799e-19
C598	B#3	VNB	9.62266e-17
C599	a_116_392#	VNB	4.23143e-17
C600	a_116_392##7	VNB	2.82007e-17
C601	VPWR	a_116_392##4	5.8685e-18
C602	a_116_392##11	VNB	3.50187e-17
C603	a_116_392##12	VNB	3.54518e-17
C604	C#1	VNB	3.29428e-17
C605	D#1	VNB	3.72959e-17
C606	VPWR	D#3	1.19537e-20
C607	A	D	1.31241e-18
C608	D#7	VNB	3.10172e-17
C609	C#6	VNB	4.09752e-17
C610	VGND	VGND#4	1.96485e-17
C611	B#1	VNB	4.07031e-17
C612	VGND	a_116_392##4	8.39906e-18
C613	VPWR	B#4	2.31305e-18
C614	A#1	VNB	2.85014e-17
C615	A#7	VNB	2.60435e-17
C616	X#2	a_116_392##2	1.39474e-17
C617	B#5	VNB	3.28383e-17
C618	D	C	4.59203e-18
C619	VPWR#4	VNB	2.64019e-16
C620	VGND	B#4	1.94802e-18
C621	VGND#4	VNB	2.83561e-16
C622	a_119_119#	a_116_392##22	1.6011e-17
C623	a_116_392##4	VNB	4.70398e-17
C624	C#2	VNB	6.96818e-17
C625	D#3	VNB	3.75086e-17
C626	A#3	VNB	3.8366e-17
C627	VPWR	D	1.75576e-18
C628	B#4	VNB	6.0486e-17
C629	VPWR	A	1.76609e-18
C630	X#3	a_116_392##10	2.0188e-19
C631	VGND	D	1.56946e-18
C632	VPWR	B	1.07083e-18
C633	VGND	A	2.60503e-18
C634	VPWR	C	2.78657e-18
C635	VGND	B	2.34664e-18
C636	D	VNB	1.58297e-20
C637	VPWR	X	2.07981e-18
C638	A	VNB	8.87925e-19
C639	B	VNB	1.97344e-17
C640	VGND	X	3.77939e-18
C641	C	VNB	3.71417e-19
C642	VGND#3	C#7	8.15329e-19
C643	X	VNB	3.97715e-17
C644	VPWR	VNB	6.05177e-17
C645	VGND	VNB	6.48116e-17
C646	VGND#5	A#6	4.64498e-18
C647	VGND#5	D#5	1.53977e-18
C648	VGND#5	VNB	9.38649e-17
C649	VGND#5	B#4	8.78457e-20
C650	VGND#5	VGND#8	3.09958e-20
C651	VGND#5	A#5	4.66052e-18
C652	VGND#5	C#4	1.52429e-17
C653	VGND#5	a_463_119##3	7.40341e-18
C654	VGND#5	C#6	1.16734e-19
C655	VGND#5	B	5.8296e-19
C656	VGND#5	VGND#3	2.18693e-19
C657	VGND#4	VGND#5	1.32902e-16
C658	VGND#5	C#3	1.19683e-17
C659	VGND#5	B#3	1.78629e-17
C660	VGND#5	a_32_119##2	4.42842e-17
C661	VGND#5	B#2	1.70997e-17
C662	VGND#5	D#6	5.95808e-20
C663	VGND	VGND#5	8.3715e-17
C664	VGND#5	a_463_119#	4.57194e-20
C665	VGND#5	a_32_119#	5.91029e-17
*
*
.ENDS sky130_fd_sc_hs__and4_4
*
