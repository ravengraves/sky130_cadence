* Extracted by Quantus, converted by sky130cad/quantus.py
*
*
*
*                       LINUX           Wed Nov 18 09:12:18 2026
*
*
*
*  PROGRAM  advgen
*
*  Name           : advgen - Quantus - (64-bit)
*  Version        : 25.1.0-p047
*  Build Date     : Thu Dec 11 23:20:30 PST 2025
*
*  HSPICE LIBRARY
*
*  OPERATING_TEMPERATURE 150
*  QRC_TECH_DIR <path>/tech
*
*
*

*
.SUBCKT sky130_fd_sc_hs__sdlclkp_4 VNB VPB VGND VPWR GCLK CLK SCE GATE
*
*
*  caps2d version: 10
*
*
*       TRANSISTOR CARDS
*
*
XM20 VGND#9 SCE#1 a_119_143# VNB sky130_fd_pr__nfet_01v8_lvt l=0.15 w=0.55 ad=0.1705 as=0.17875 pd=1.72 ps=1.75
XM15 a_119_143# GATE#1 VGND#14 VNB sky130_fd_pr__nfet_01v8_lvt l=0.15 w=0.55 ad=0.17875 as=0.54875 pd=1.75 ps=3.36
XM10 VGND#14 a_324_79##4 a_354_105##7 VNB sky130_fd_pr__nfet_01v8_lvt l=0.15 w=0.74 ad=0.54875 as=0.2109 pd=3.36 ps=2.05
XM9 a_119_143##5 a_324_79##6 a_634_74##6 VNB sky130_fd_pr__nfet_01v8_lvt l=0.15 w=0.55 ad=0.38225 as=0.21025 pd=2.49 ps=1.9
XM3 a_634_74##6 a_354_105# a_744_74# VNB sky130_fd_pr__nfet_01v8_lvt l=0.15 w=0.42 ad=0.21025 as=0.1008 pd=1.9 ps=1.32
XM22 a_744_74# a_792_48##3 VGND#13 VNB sky130_fd_pr__nfet_01v8_lvt l=0.15 w=0.42 ad=0.1008 as=0.3782 pd=1.32 ps=2.9
XM27 VGND#13 a_634_74# a_792_48##12 VNB sky130_fd_pr__nfet_01v8_lvt l=0.15 w=0.74 ad=0.3782 as=0.2109 pd=2.9 ps=2.05
XM2 a_324_79##8 CLK#5 VGND#12 VNB sky130_fd_pr__nfet_01v8_lvt l=0.15 w=0.74 ad=0.2109 as=0.259 pd=2.05 ps=2.18
XM26 VGND#12 CLK#1 a_1292_74# VNB sky130_fd_pr__nfet_01v8_lvt l=0.15 w=0.74 ad=0.259 as=0.1776 pd=2.18 ps=1.96
XM24 a_1292_74# a_792_48##6 a_1289_368##17 VNB sky130_fd_pr__nfet_01v8_lvt l=0.15 w=0.74 ad=0.1776 as=0.2109 pd=1.96 ps=2.05
XM13 GCLK#1 a_1289_368##11 VGND#11 VNB sky130_fd_pr__nfet_01v8_lvt l=0.15 w=0.74 ad=0.2442 as=0.2109 pd=2.14 ps=2.05
XM19 GCLK#1 a_1289_368##9 VGND#10 VNB sky130_fd_pr__nfet_01v8_lvt l=0.15 w=0.74 ad=0.2442 as=0.2072 pd=2.14 ps=2.04
XM5 VGND#10 a_1289_368##7 GCLK#5 VNB sky130_fd_pr__nfet_01v8_lvt l=0.15 w=0.74 ad=0.2072 as=0.2072 pd=2.04 ps=2.04
XM23 VGND#1 a_1289_368# GCLK#5 VNB sky130_fd_pr__nfet_01v8_lvt l=0.15 w=0.74 ad=0.2109 as=0.2072 pd=2.05 ps=2.04
XM25 VPWR#13 SCE#3 a_116_395# VPB sky130_fd_pr__pfet_01v8 l=0.15 w=0.84 ad=0.2478 as=0.2268 pd=2.27 ps=2.22
XM14 a_116_395# GATE#3 a_119_143##3 VPB sky130_fd_pr__pfet_01v8 l=0.15 w=0.84 ad=0.2268 as=0.2478 pd=2.22 ps=2.27
XM4 VPWR#12 a_324_79##2 a_354_105##8 VPB sky130_fd_pr__pfet_01v8 l=0.15 w=0.84 ad=0.4872 as=0.4033 pd=2.84 ps=3.02
XM12 a_119_143##6 a_354_105##4 a_634_74##7 VPB sky130_fd_pr__pfet_01v8 l=0.15 w=0.84 ad=0.2478 as=0.2856 pd=2.27 ps=2.45
XM8 a_634_74##7 a_324_79# a_785_455# VPB sky130_fd_pr__pfet_01v8 l=0.15 w=0.42 ad=0.2856 as=0.1134 pd=2.45 ps=1.38
XM11 a_785_455# a_792_48# VPWR#9 VPB sky130_fd_pr__pfet_01v8 l=0.15 w=0.42 ad=0.1134 as=0.3745 pd=1.38 ps=3.04
XM17 VPWR#9 a_634_74##3 a_792_48##8 VPB sky130_fd_pr__pfet_01v8 l=0.15 w=1.12 ad=0.3745 as=0.3304 pd=3.04 ps=2.83
XM21 a_324_79##10 CLK#6 VPWR#7 VPB sky130_fd_pr__pfet_01v8 l=0.15 w=0.84 ad=0.252 as=0.406 pd=2.28 ps=3.01
XM16 VPWR#7 CLK#4 a_1289_368##16 VPB sky130_fd_pr__pfet_01v8 l=0.15 w=1.12 ad=0.406 as=0.5544 pd=3.01 ps=3.23
XM0 a_1289_368##16 a_792_48##4 VPWR#5 VPB sky130_fd_pr__pfet_01v8 l=0.15 w=1.12 ad=0.5544 as=0.392 pd=3.23 ps=2.94
XM7 VPWR#5 a_1289_368##13 GCLK#4 VPB sky130_fd_pr__pfet_01v8 l=0.15 w=1.12 ad=0.392 as=0.4816 pd=2.94 ps=3.1
XM18 GCLK#4 a_1289_368##12 VPWR#3 VPB sky130_fd_pr__pfet_01v8 l=0.15 w=1.12 ad=0.4816 as=0.392 pd=3.1 ps=2.94
XM6 VPWR#3 a_1289_368##8 GCLK#6 VPB sky130_fd_pr__pfet_01v8 l=0.15 w=1.12 ad=0.392 as=0.3864 pd=2.94 ps=2.93
XM1 GCLK#6 a_1289_368##6 VPWR#1 VPB sky130_fd_pr__pfet_01v8 l=0.15 w=1.12 ad=0.3864 as=0.336 pd=2.93 ps=2.84
*
*
*       RESISTOR AND CAP/DIODE CARDS
*
Rg1	SCE#1	SCE#2	294.747375
Rg2	SCE#2	SCE#3	363.040771
Rg3	GATE#1	GATE#2	311.748383
Rg4	GATE#2	GATE#3	383.980133
Rg5	a_354_105#	a_354_105##2	642.068787
Rg6	a_354_105##2	a_354_105##3	43.434376
Rg7	a_354_105##2	a_354_105##4	335.866638
Rg8	a_324_79#	a_324_79##2	1494.549316
Rg9	a_324_79##2	a_324_79##3	545.347534
Rg10	a_324_79##3	a_324_79##4	543.648499
Rg11	a_324_79##3	a_324_79##5	27.124250
Rg12	a_324_79##5	a_324_79##6	561.591553
Rg13	a_792_48#	a_792_48##2	342.973663
Rg14	a_792_48##2	a_792_48##3	630.330017
Rg15	a_634_74#	a_634_74##2	312.407532
Rg16	a_634_74##2	a_634_74##3	443.825714
Rg17	CLK#1	CLK#2	322.953644
Rg18	CLK#2	CLK#3	65.049614
Rg19	CLK#2	CLK#4	507.075531
Rg20	CLK#3	CLK#5	325.793304
Rg21	CLK#3	CLK#6	423.392242
Rg22	a_792_48##4	a_792_48##5	473.810669
Rg23	a_792_48##5	a_792_48##6	380.700043
Rg24	a_1289_368#	a_1289_368##2	368.862610
Rg25	a_1289_368##2	a_1289_368##3	75.228996
Rg26	a_1289_368##3	a_1289_368##4	60.081322
Rg27	a_1289_368##4	a_1289_368##5	52.210712
Rg28	a_1289_368##2	a_1289_368##6	471.862823
Rg29	a_1289_368##3	a_1289_368##7	389.052795
Rg30	a_1289_368##3	a_1289_368##8	475.629547
Rg31	a_1289_368##4	a_1289_368##9	344.154114
Rg32	a_1289_368##5	a_1289_368##10	29.373684
Rg33	a_1289_368##10	a_1289_368##11	342.058960
Rg34	a_1289_368##5	a_1289_368##12	451.334412
Rg35	a_1289_368##10	a_1289_368##13	491.775146
Rf1	SCE#4	SCE	0.695385
Rf2	SCE#2	SCE#6	160.928192
Rf3	SCE#4	SCE#6	5.708254
Rf4	GATE#2	GATE#5	160.851227
Rf5	GATE#6	GATE	0.618430
Rf6	GATE#5	GATE#6	7.873454
Rf7	a_119_143#	a_119_143##2	77.242493
Rf8	a_119_143##2	a_119_143##4	99.673950
Rf9	a_119_143##2	a_119_143##5	76.116089
Rf10	a_119_143##4	a_119_143##6	113.170174
Rf11	a_119_143##3	a_119_143##4	7.500000
Rf12	a_354_105##3	a_354_105##6	195.558807
Rf13	a_354_105##6	a_354_105##7	79.112869
Rf14	a_354_105##6	a_354_105##8	24.468842
Rf15	a_634_74##2	a_634_74##5	234.811920
Rf16	a_634_74##5	a_634_74##6	53.619286
Rf17	a_634_74##5	a_634_74##7	54.516548
Rf18	a_324_79##5	a_324_79##9	517.628540
Rf19	a_324_79##9	a_324_79##10	95.451027
Rf20	a_324_79##8	a_324_79##9	7.500000
Rf21	CLK#7	CLK	0.882458
Rf22	CLK#3	CLK#9	161.115265
Rf23	CLK#7	CLK#9	3.543054
Rf24	a_792_48##5	a_792_48##9	319.800903
Rf25	a_792_48##9	a_792_48##10	17.427141
Rf26	a_792_48##10	a_792_48##2	213.714081
Rf27	a_792_48##10	a_792_48##12	76.662170
Rf28	a_792_48##8	a_792_48##9	5.000000
Rf29	a_1289_368##5	a_1289_368##15	68.980690
Rf30	a_1289_368##15	a_1289_368##16	92.839134
Rf31	a_1289_368##15	a_1289_368##17	72.461906
Rf32	GCLK#1	GCLK#2	75.229309
Rf33	GCLK#2	GCLK	9.825849
Rf34	GCLK	GCLK#3	27.841198
Rf35	GCLK#3	GCLK#4	79.819977
Rf36	GCLK#2	GCLK#5	19.491049
Rf37	GCLK#3	GCLK#6	25.503868
Rf38	VPWR#1	VPWR#2	121.742325
Rf39	VPWR#2	VPWR#3	47.191006
Rf40	VPWR#2	VPWR#4	63.529400
Rf41	VPWR#4	VPWR#5	34.487274
Rf42	VPWR#4	VPWR#6	83.593750
Rf43	VPWR#6	VPWR#7	34.704330
Rf44	VPWR#6	VPWR#8	116.158577
Rf45	VPWR#8	VPWR#9	46.410976
Rf46	VPWR#8	VPWR#10	87.328156
Rf47	VPWR#10	VPWR#11	110.106606
Rf48	VPWR#11	VPWR#12	25.169979
Rf49	VPWR#11	VPWR#13	153.737991
Rf50	VGND#1	VGND#2	108.421173
Rf51	VGND#2	VGND#3	19.025946
Rf52	VGND#3	VGND#4	47.515640
Rf53	VGND#4	VGND#5	97.895943
Rf54	VGND#5	VGND#6	138.746887
Rf55	VGND#6	VGND#7	66.451416
Rf56	VGND#7	VGND#8	147.132812
Rf57	VGND#8	VGND#9	126.283150
Rf58	VGND#2	VGND#10	39.841232
Rf59	VGND#4	VGND#11	39.841232
Rf60	VGND#5	VGND#12	32.518913
Rf61	VGND#6	VGND#13	32.735970
Rf62	VGND#8	VGND#14	20.844378
Re1	VPWR#2	VPWR	2.920302
Re2	VPWR	VPWR#10	1.251558
Re3	VGND#3	VGND	2.920302
Re4	VGND	VGND#7	1.251558
*
*       CAPACITOR CARDS
*
*
C1	VPWR#13	VPWR#11	3.47453e-18
C2	GCLK#3	VPWR#2	1.64593e-18
C3	a_324_79##8	a_792_48##12	1.42405e-16
C4	VGND#13	VGND#12	5.35563e-20
C5	a_354_105##6	a_324_79##2	1.20711e-17
C6	VGND#2	a_1289_368#	2.88347e-18
C7	VPWR#2	a_1289_368##15	4.68901e-18
C8	a_1289_368##3	GCLK#6	1.49149e-19
C9	VGND#4	a_1289_368##17	1.65969e-17
C10	a_324_79##8	VGND#13	8.40747e-17
C11	VPWR#3	a_1289_368##10	8.07595e-19
C12	VGND#3	GCLK#3	2.20084e-18
C13	VGND#6	VGND#12	3.13085e-20
C14	a_1289_368##2	GCLK#6	1.47619e-19
C15	a_354_105##6	GATE#3	5.02706e-19
C16	VGND#1	VPWR#1	1.12128e-17
C17	a_1289_368##7	a_1289_368#	3.83273e-17
C18	VGND#3	a_1289_368##15	4.04681e-18
C19	a_354_105##6	a_634_74##5	1.45304e-19
C20	VGND#2	a_1289_368##7	5.39579e-18
C21	VPWR#1	a_1289_368##6	4.96793e-17
C22	a_1289_368##6	GCLK#6	1.74305e-17
C23	VGND#4	a_1289_368##9	6.5807e-19
C24	VPWR#3	a_1289_368##3	1.65341e-19
C25	a_634_74##6	a_324_79##8	2.04604e-17
C26	VGND#6	a_324_79##8	4.60624e-17
C27	VPWR#1	a_1289_368##8	2.94746e-18
C28	VPWR#3	a_1289_368##6	6.99776e-19
C29	a_1289_368##9	a_1289_368##7	3.60286e-17
C30	GCLK#4	a_1289_368##10	7.44972e-18
C31	VGND#2	a_1289_368##9	3.72901e-18
C32	VGND#4	a_1289_368##5	9.34021e-19
C33	VGND#12	VGND#4	2.31615e-20
C34	GCLK#6	a_1289_368##8	5.06848e-17
C35	VPWR#1	a_1289_368##12	2.79651e-19
C36	VGND#5	a_324_79##8	4.72055e-17
C37	CLK#2	a_792_48##6	2.50679e-18
C38	a_1289_368##8	VPWR#3	2.79088e-17
C39	VPWR#8	VPWR#6	4.75769e-19
C40	VGND#4	a_1289_368##11	1.1684e-17
C41	GCLK#6	a_1289_368##12	1.38068e-18
C42	VGND#5	a_792_48##5	1.45396e-18
C43	GCLK#4	a_1289_368##8	2.04954e-18
C44	a_1289_368##11	a_1289_368##9	3.21231e-17
C45	a_119_143##6	a_324_79##6	1.82432e-19
C46	VGND#2	a_1289_368##11	8.52327e-19
C47	VGND#4	a_792_48##5	1.54477e-19
C48	a_1289_368##12	VPWR#3	3.23562e-17
C49	VGND#5	a_792_48##6	7.57734e-18
C50	a_1289_368##5	VPWR#4	1.74747e-19
C51	VPWR#5	a_1289_368##8	2.475e-19
C52	a_1289_368##3	GCLK#5	7.41962e-20
C53	a_1289_368##5	GCLK#3	2.58114e-17
C54	GCLK#4	a_1289_368##12	8.29858e-17
C55	VGND#10	a_1289_368##10	1.5432e-19
C56	VGND#4	a_792_48##6	1.17545e-18
C57	VPWR#3	a_1289_368##13	4.02403e-19
C58	a_324_79##8	a_324_79#	1.15819e-18
C59	VPWR#5	a_1289_368##12	2.55365e-18
C60	a_792_48##6	a_1289_368##11	4.94073e-18
C61	VGND#5	CLK#3	4.81264e-20
C62	a_354_105##6	a_634_74##7	2.43389e-18
C63	a_792_48##5	VPWR#6	1.00675e-18
C64	a_1289_368##15	GCLK#1	1.21252e-17
C65	VGND#2	a_792_48##6	3.6318e-20
C66	GCLK#4	a_1289_368##13	1.76635e-17
C67	VPWR#4	a_792_48##5	8.16628e-20
C68	VGND#5	CLK#1	3.8383e-18
C69	a_1289_368##2	GCLK#5	3.57283e-19
C70	a_1289_368##16	a_1289_368##12	2.0289e-19
C71	a_1289_368##15	a_1289_368##7	1.01684e-20
C72	VPWR#5	a_1289_368##13	6.04552e-17
C73	VPWR#6	VPWR#4	7.23149e-19
C74	VGND#4	CLK#1	1.29266e-19
C75	VGND#6	a_634_74##2	9.05451e-20
C76	GCLK#4	a_792_48##4	3.74301e-19
C77	a_119_143##3	a_324_79##4	1.89617e-18
C78	a_354_105##6	a_119_143##6	5.44682e-17
C79	CLK#1	a_792_48##6	5.17016e-17
C80	a_1289_368##16	a_1289_368##13	1.71796e-18
C81	a_792_48##5	a_1289_368##15	2.73694e-17
C82	VGND#10	a_1289_368##3	6.0566e-19
C83	a_1289_368##15	VGND#11	1.82931e-17
C84	a_792_48##4	VPWR#5	2.5592e-17
C85	GCLK#1	a_1289_368##10	3.89229e-18
C86	VPWR#7	a_1289_368##13	1.69445e-19
C87	VGND#5	CLK#5	4.40653e-18
C88	a_119_143##2	a_354_105##6	1.35485e-18
C89	a_1289_368##16	a_792_48##4	8.65754e-17
C90	a_1289_368##15	a_1289_368##9	1.01603e-18
C91	a_324_79##3	a_324_79##2	7.12929e-19
C92	a_354_105##6	a_354_105##8	4.80361e-18
C93	VPWR#5	CLK#4	1.09408e-18
C94	CLK#5	CLK#1	2.84745e-17
C95	VPWR#7	a_792_48##4	1.83023e-18
C96	VGND#6	a_634_74#	4.45179e-18
C97	a_1289_368##17	a_1289_368##15	5.74209e-18
C98	CLK#4	a_1289_368##16	3.11226e-17
C99	VGND#8	a_119_143##5	1.54586e-17
C100	VPWR#7	CLK#4	4.49936e-17
C101	a_1289_368##15	a_1289_368##11	5.42781e-18
C102	a_792_48##10	CLK#3	3.81069e-19
C103	a_792_48##8	a_792_48##4	1.32807e-19
C104	a_119_143##5	a_354_105##7	1.12118e-17
C105	a_1289_368##16	CLK#6	3.46631e-19
C106	a_634_74#	CLK#5	4.32651e-18
C107	a_324_79##10	CLK#4	1.6995e-18
C108	a_792_48##2	VPWR#8	2.3682e-18
C109	a_1289_368##10	VGND#11	1.67317e-18
C110	VGND#3	VGND#1	5.27933e-17
C111	VGND#6	a_792_48##3	9.60501e-19
C112	CLK#6	VPWR#7	1.71507e-17
C113	a_792_48##8	CLK#4	1.54124e-18
C114	VGND#3	GCLK#5	1.72448e-17
C115	a_1289_368##16	a_634_74##3	1.63695e-19
C116	a_324_79##10	CLK#6	2.44995e-17
C117	a_1289_368##15	a_792_48##6	3.24134e-19
C118	VPWR#9	CLK#4	5.46435e-19
C119	a_119_143##3	a_354_105##6	4.43591e-17
C120	a_634_74##2	a_792_48##10	5.13356e-17
C121	VGND#8	a_354_105#	8.64981e-20
C122	a_792_48##3	a_634_74#	8.30391e-18
C123	VPWR#7	a_634_74##3	2.14924e-18
C124	VGND#3	GCLK#1	3.09697e-17
C125	a_792_48##8	CLK#6	3.79049e-17
C126	VGND#8	a_324_79##5	3.1773e-18
C127	a_1289_368##17	a_1289_368##16	2.21536e-18
C128	VGND#6	a_324_79##5	1.26839e-17
C129	a_324_79##10	a_634_74##3	6.25551e-19
C130	VGND#3	a_1289_368##17	1.88357e-17
C131	a_792_48##8	a_634_74##3	6.46064e-17
C132	a_792_48##2	a_792_48##10	3.20357e-18
C133	VGND#8	VGND#14	9.1687e-18
C134	a_354_105#	a_792_48##3	4.85324e-17
C135	a_1289_368##15	VPWR#4	5.4079e-19
C136	a_634_74##3	VPWR#9	2.94028e-17
C137	VGND#8	a_324_79##6	1.18981e-18
C138	VGND#8	GATE#2	3.71148e-19
C139	VPWR#7	a_324_79#	5.50825e-19
C140	a_792_48##8	a_792_48#	1.5182e-18
C141	a_119_143##2	a_119_143##3	2.75197e-18
C142	a_634_74##5	a_634_74##2	4.08393e-18
C143	a_792_48#	VPWR#9	2.30906e-17
C144	a_119_143#	VGND#14	4.57175e-19
C145	a_634_74##7	a_634_74##3	1.58436e-18
C146	a_324_79##6	a_354_105#	2.27508e-17
C147	VPWR#7	CLK#2	1.04077e-19
C148	a_792_48##8	a_324_79#	3.17958e-19
C149	VGND#8	a_119_143#	1.71412e-17
C150	a_1289_368##15	GCLK#3	4.18918e-19
C151	VGND#8	a_324_79##4	1.07943e-17
C152	VPWR#11	GATE#2	6.08742e-20
C153	a_792_48##10	VPWR#8	2.35155e-19
C154	a_1289_368##5	VGND#10	8.58201e-19
C155	VPWR#9	a_324_79#	6.99385e-18
C156	a_634_74##7	a_792_48#	3.13277e-18
C157	a_1289_368##5	GCLK#1	4.70601e-17
C158	a_634_74##5	a_792_48##2	5.24153e-17
C159	a_792_48##8	a_354_105##4	8.39256e-20
C160	a_119_143##6	a_792_48#	4.70656e-20
C161	a_324_79##4	a_324_79##6	1.59582e-18
C162	VPWR#9	a_354_105##4	2.49053e-18
C163	a_324_79#	a_634_74##7	2.25212e-17
C164	a_354_105##6	a_792_48##2	2.39158e-19
C165	VGND#9	VGND#8	7.26825e-18
C166	VGND#9	a_119_143#	6.04546e-17
C167	VPWR#2	a_1289_368##10	5.24201e-19
C168	GATE#5	a_119_143##3	1.79792e-17
C169	a_119_143##6	a_324_79#	1.74237e-18
C170	VGND#8	GATE#1	2.13694e-18
C171	VPWR#2	VPWR#1	6.60497e-17
C172	a_634_74##5	a_354_105##3	7.4531e-17
C173	a_354_105##4	a_634_74##7	2.55977e-17
C174	GATE#1	a_324_79##4	1.24503e-17
C175	a_324_79##10	CLK#2	2.58685e-19
C176	GCLK#6	VPWR#2	3.59532e-17
C177	a_324_79##8	a_324_79##10	4.06481e-18
C178	VPWR#2	a_1289_368##3	5.60284e-20
C179	a_792_48##5	a_1289_368##17	3.69218e-17
C180	a_324_79##8	a_792_48##10	1.89263e-19
C181	a_119_143##6	a_354_105##4	5.71783e-17
C182	VGND#12	a_792_48##8	1.44163e-18
C183	a_354_105##6	a_354_105##3	1.03125e-19
C184	VPWR#2	a_1289_368##2	5.88154e-20
C185	VGND#3	VPWR#1	5.55873e-18
C186	a_634_74##7	a_324_79##2	1.14943e-19
C187	VGND#7	a_119_143##5	1.14892e-17
C188	VGND#12	a_792_48##5	6.03126e-18
C189	GCLK#4	VPWR#2	3.30833e-17
C190	a_792_48##12	a_324_79##10	5.20689e-18
C191	VPWR#11	a_324_79##4	1.04601e-18
C192	a_324_79##5	a_634_74##5	9.91042e-18
C193	a_119_143##6	a_324_79##2	2.75686e-17
C194	VGND#8	SCE#1	2.62887e-18
C195	SCE#1	GATE#1	2.49316e-17
C196	a_324_79##8	a_792_48##8	1.27488e-19
C197	VPWR#2	VPWR#5	2.20351e-17
C198	a_324_79##2	a_354_105##8	1.20631e-17
C199	a_792_48##12	a_792_48##10	4.79585e-18
C200	VPWR#2	a_1289_368##16	1.45044e-17
C201	a_119_143##3	a_354_105##4	6.33923e-19
C202	a_324_79##5	a_354_105##6	4.60621e-17
C203	VGND#3	GCLK#4	3.13131e-18
C204	VGND#3	a_1289_368##10	2.97967e-19
C205	CLK#3	VGND#12	4.81064e-18
C206	a_119_143##6	GATE#3	3.3124e-19
C207	a_324_79##2	VPWR#12	1.54303e-17
C208	a_324_79##8	CLK#3	5.75592e-18
C209	a_792_48##8	CLK#2	3.10584e-19
C210	a_119_143##3	a_324_79##2	2.5706e-17
C211	a_119_143##2	a_324_79##5	8.22794e-19
C212	VGND#3	a_1289_368##16	2.5328e-18
C213	a_792_48##12	CLK#3	4.89161e-19
C214	VGND#3	a_1289_368##3	1.54354e-21
C215	a_354_105##6	GATE#2	8.11958e-19
C216	VGND#3	a_1289_368##2	9.39579e-20
C217	GCLK#6	VPWR#1	7.89829e-17
C218	a_119_143##3	GATE#3	5.99368e-17
C219	VPWR#13	a_324_79##2	1.40162e-18
C220	a_324_79##8	a_634_74##2	6.66174e-17
C221	SCE#6	VPWR#13	2.16041e-17
C222	a_634_74##2	a_792_48##12	1.93088e-17
C223	a_119_143##2	GATE#2	9.94507e-19
C224	a_634_74##2	VGND#13	2.55833e-18
C225	a_119_143##3	SCE#3	9.27501e-18
C226	VPWR#13	GATE#3	1.02716e-17
C227	VPWR#3	VPWR#1	2.28363e-18
C228	a_1289_368##5	VPWR#3	2.98762e-18
C229	a_324_79##8	a_792_48##2	9.43604e-19
C230	GATE#5	GATE#2	1.56725e-17
C231	a_1289_368##5	GCLK#4	5.13116e-17
C232	a_1289_368##8	a_1289_368##6	3.82208e-17
C233	a_324_79##4	a_324_79##3	9.97866e-18
C234	VPWR#13	SCE#3	5.3239e-17
C235	a_119_143##2	SCE#2	1.96066e-19
C236	VGND#13	a_792_48##2	1.04143e-18
C237	SCE#6	GATE#2	4.22137e-18
C238	VPWR#3	GCLK#6	7.20139e-17
C239	SCE#6	GATE#5	1.89603e-17
C240	VGND#12	CLK#2	1.22442e-18
C241	a_634_74##7	VPWR#10	8.6254e-18
C242	GATE#5	SCE#2	5.85708e-18
C243	a_1289_368##12	a_1289_368##8	3.86877e-17
C244	GCLK#4	GCLK#6	1.03453e-18
C245	a_119_143##6	VPWR#10	1.08503e-17
C246	VGND#8	a_324_79##3	1.03262e-18
C247	VGND#1	a_1289_368#	2.46946e-17
C248	VPWR#10	a_324_79##3	1.49972e-19
C249	a_792_48##5	a_1289_368##16	1.10592e-16
C250	SCE#6	SCE#2	1.27949e-17
C251	a_634_74##5	a_634_74#	1.45736e-19
C252	a_792_48##5	VPWR#7	8.7627e-18
C253	a_324_79##5	a_324_79##8	2.45612e-18
C254	a_634_74##6	a_354_105##3	9.96476e-18
C255	GCLK#5	a_1289_368#	3.34213e-17
C256	a_324_79##10	a_792_48##5	1.63424e-17
C257	a_1289_368##13	a_1289_368##12	2.72836e-17
C258	GCLK#4	VPWR#3	6.38411e-17
C259	a_324_79##5	VGND#13	4.2489e-17
C260	a_792_48##8	a_792_48##5	1.79502e-18
C261	a_354_105##7	a_354_105##3	4.59537e-18
C262	VGND#1	a_1289_368##7	1.34033e-18
C263	VPWR#7	CLK#3	8.91158e-19
C264	VGND#3	a_1289_368#	4.75741e-18
C265	VGND#10	a_1289_368#	5.40396e-19
C266	a_634_74##5	a_792_48##3	3.93679e-19
C267	a_324_79##5	a_634_74##6	9.56675e-17
C268	a_324_79##10	CLK#3	2.38284e-17
C269	VPWR#5	VPWR#3	1.9565e-18
C270	VGND#3	a_1289_368##7	7.85579e-19
C271	a_792_48##4	a_1289_368##13	3.80182e-17
C272	a_324_79##5	a_119_143##5	9.14618e-17
C273	GCLK#5	a_1289_368##7	3.29615e-17
C274	CLK#3	a_792_48##8	1.13399e-17
C275	a_324_79##6	a_324_79##2	1.1006e-19
C276	a_354_105##7	a_324_79##5	3.34668e-17
C277	VGND#3	a_1289_368##9	3.90086e-18
C278	VGND#1	a_1289_368##9	2.73732e-19
C279	VGND#7	a_324_79##3	8.67964e-19
C280	a_324_79##10	a_634_74##2	5.4736e-19
C281	VGND#3	a_1289_368##11	1.20087e-18
C282	a_1289_368##7	VGND#10	1.48238e-17
C283	VPWR#5	GCLK#4	5.35177e-17
C284	a_324_79##8	a_634_74##5	3.34689e-17
C285	a_634_74##5	a_354_105#	2.8736e-18
C286	CLK#4	a_792_48##4	2.15461e-17
C287	VGND#3	a_792_48##6	1.39355e-18
C288	GCLK#5	a_1289_368##9	1.65003e-18
C289	a_1289_368##5	a_1289_368##10	2.91074e-17
C290	a_634_74##2	VPWR#9	1.87941e-18
C291	GCLK#3	a_1289_368##6	7.97759e-18
C292	GCLK#1	a_1289_368##7	5.80425e-19
C293	GCLK#3	VPWR#1	3.26064e-17
C294	a_1289_368##16	GCLK#4	2.32904e-18
C295	a_119_143#	GATE#2	2.66173e-18
C296	a_792_48##8	a_792_48##2	1.92924e-19
C297	VGND#10	a_1289_368##9	2.80377e-17
C298	a_1289_368##5	a_1289_368##3	7.47015e-18
C299	a_634_74##5	a_324_79##3	3.93349e-19
C300	GATE	a_324_79##3	3.68151e-19
C301	CLK#6	CLK#4	3.02285e-17
C302	VGND#8	a_119_143##2	4.28856e-17
C303	a_792_48##2	VPWR#9	2.00965e-17
C304	a_634_74##5	a_792_48##12	6.93127e-19
C305	a_634_74##5	a_324_79##6	3.48948e-18
C306	GCLK#5	a_1289_368##11	3.02048e-19
C307	a_634_74##3	CLK#4	6.46646e-19
C308	GCLK#1	a_1289_368##9	2.76819e-17
C309	a_1289_368##16	VPWR#5	7.45618e-17
C310	a_634_74##7	a_792_48##2	1.49277e-17
C311	GCLK#3	a_1289_368##8	1.76866e-17
C312	a_119_143##6	a_792_48##2	1.08948e-19
C313	GCLK#3	GCLK#6	1.29435e-18
C314	VGND#9	SCE#2	6.68324e-18
C315	a_634_74##3	CLK#6	5.45606e-18
C316	VGND#2	a_1289_368##3	1.91585e-20
C317	VGND#10	a_1289_368##11	1.23972e-18
C318	VGND#11	a_1289_368##9	1.06547e-18
C319	a_634_74##7	a_354_105##3	1.14171e-19
C320	VPWR#7	VPWR#5	2.01986e-18
C321	a_792_48##5	a_1289_368##10	1.98209e-17
C322	a_1289_368##11	GCLK#1	2.46573e-17
C323	a_354_105##3	a_119_143##6	3.59803e-17
C324	VPWR#10	a_324_79##6	4.09646e-20
C325	a_792_48#	a_634_74##3	2.122e-17
C326	a_1289_368##17	a_1289_368##9	1.87331e-19
C327	VGND#10	a_792_48##6	4.28604e-20
C328	VGND#7	a_354_105#	4.62016e-18
C329	GCLK#3	a_1289_368##12	3.13689e-19
C330	VGND#11	a_1289_368##11	1.09778e-17
C331	VPWR#7	a_1289_368##16	2.23304e-17
C332	a_324_79#	a_634_74##3	2.00453e-18
C333	GCLK#3	VPWR#3	2.37036e-17
C334	VGND#2	a_1289_368##2	9.22556e-20
C335	VGND#7	a_324_79##6	4.64531e-18
C336	a_119_143##3	a_354_105##3	6.10372e-21
C337	VPWR#2	a_1289_368##6	5.07801e-18
C338	a_119_143##6	a_324_79##3	1.13457e-18
C339	VPWR#6	a_1289_368##13	5.24494e-20
C340	GCLK#1	a_792_48##6	5.5813e-19
C341	a_324_79#	a_792_48#	4.64965e-17
C342	a_792_48##5	CLK#2	5.12619e-17
C343	GCLK#4	VPWR#4	4.02159e-18
C344	VPWR#2	a_1289_368##8	4.73477e-18
C345	a_1289_368##17	a_1289_368##11	1.90765e-18
C346	VPWR#4	a_1289_368##13	3.48889e-19
C347	a_354_105##4	a_792_48#	4.40587e-19
C348	a_119_143##2	a_324_79##6	1.82692e-19
C349	VPWR#2	a_1289_368##12	7.85208e-18
C350	a_1289_368##15	a_1289_368##12	2.89616e-19
C351	a_634_74#	CLK#3	3.56979e-20
C352	VGND#11	a_792_48##6	1.51678e-18
C353	VPWR#6	VPWR#5	3.73326e-20
C354	GCLK#5	VGND#1	4.79417e-17
C355	VPWR#2	a_1289_368##13	3.06333e-18
C356	a_354_105##4	a_324_79#	4.35598e-17
C357	GCLK#3	a_1289_368##13	6.81873e-20
C358	GCLK#4	GCLK#3	1.75181e-18
C359	a_119_143##3	GATE#2	5.83348e-18
C360	VPWR#2	a_792_48##4	1.55689e-19
C361	a_792_48##8	a_1289_368##16	1.27894e-18
C362	a_1289_368##17	a_792_48##6	5.80878e-17
C363	VPWR#6	a_792_48##4	5.66868e-19
C364	a_324_79##2	a_324_79#	8.92068e-19
C365	CLK	a_1289_368##10	5.87522e-20
C366	a_792_48##3	a_634_74##2	2.07758e-19
C367	VGND#12	a_1289_368##11	2.97208e-19
C368	a_354_105##6	a_324_79##3	3.01699e-17
C369	a_119_143##2	a_324_79##4	5.01318e-17
C370	VGND#11	CLK#1	1.15524e-19
C371	a_324_79##2	a_354_105##4	6.49024e-18
C372	VGND#10	VGND#1	1.49391e-18
C373	VPWR#4	a_792_48##4	5.72893e-18
C374	a_1289_368##15	a_1289_368##13	9.38074e-18
C375	a_119_143##3	SCE#2	4.90613e-19
C376	a_1289_368##16	VPWR#6	5.58073e-18
C377	a_792_48##8	VPWR#7	3.59602e-17
C378	VPWR#8	CLK#4	3.4203e-19
C379	CLK#3	CLK#2	3.01415e-18
C380	a_1289_368##17	CLK#1	4.9538e-18
C381	VPWR#13	SCE#2	5.86987e-18
C382	GATE#3	a_324_79##2	3.38982e-18
C383	VGND#12	a_792_48##6	5.47177e-18
C384	VPWR#8	VPWR#7	7.55235e-19
C385	a_354_105##3	a_792_48##3	1.57511e-19
C386	VPWR#6	CLK#4	7.28165e-18
C387	a_1289_368##15	GCLK#4	2.65718e-17
C388	VGND#10	GCLK#5	3.83514e-17
C389	a_119_143##2	GATE#1	5.03345e-18
C390	a_792_48##8	a_324_79##10	3.96284e-17
C391	a_1289_368##16	VPWR#4	1.22538e-17
C392	VPWR#9	VPWR#7	1.95618e-18
C393	a_324_79##5	a_634_74#	3.77499e-19
C394	a_324_79##6	a_354_105##3	2.44599e-17
C395	a_324_79##8	a_792_48##6	6.32394e-20
C396	a_324_79##5	a_792_48##3	9.32264e-18
C397	a_792_48##5	a_1289_368##13	1.67016e-18
C398	SCE#3	GATE#3	5.09874e-17
C399	a_1289_368##17	CLK#5	4.29209e-19
C400	a_324_79##5	a_354_105#	2.06077e-17
C401	VGND#12	CLK#1	4.83665e-17
C402	a_354_105##7	a_634_74##5	1.531e-19
C403	GCLK	a_1289_368##10	8.14298e-19
C404	a_792_48##5	a_792_48##4	1.15867e-18
C405	GCLK	a_1289_368##3	1.07601e-17
C406	a_324_79##5	a_324_79##6	3.2483e-17
C407	GCLK	a_1289_368##2	1.57569e-17
C408	GCLK#1	GCLK#5	3.84605e-18
C409	VPWR#10	a_324_79#	2.03235e-17
C410	a_792_48##5	CLK#4	3.03004e-17
C411	a_119_143##2	SCE#1	4.1454e-19
C412	a_324_79##5	a_324_79##4	1.33524e-18
C413	a_1289_368##15	VPWR#5	3.37889e-17
C414	VPWR#6	CLK#6	4.58504e-18
C415	a_324_79##8	CLK#1	1.41596e-18
C416	VPWR#10	a_354_105##4	2.52506e-18
C417	a_792_48##5	CLK#6	3.83576e-18
C418	a_119_143##5	a_354_105##6	1.90954e-18
C419	a_1289_368##17	a_634_74#	2.58643e-19
C420	VPWR#9	a_792_48##8	6.2566e-17
C421	VPWR#4	a_1289_368##10	2.63471e-19
C422	VGND#9	VPWR#13	4.23876e-19
C423	a_792_48##5	a_634_74##3	2.66219e-19
C424	a_1289_368##15	CLK#4	1.83388e-19
C425	VPWR#10	a_324_79##2	1.20925e-17
C426	CLK#5	VGND#12	1.86985e-17
C427	GATE#2	a_324_79##4	4.8884e-18
C428	VGND#8	SCE#6	4.54509e-19
C429	VPWR#11	a_324_79##3	9.5209e-19
C430	GCLK#1	VGND#10	4.27347e-17
C431	VPWR#8	a_634_74##3	5.08739e-18
C432	a_634_74##3	CLK#3	6.30054e-19
C433	a_324_79##8	CLK#5	6.07612e-17
C434	a_792_48##8	VPWR#8	1.77329e-17
C435	a_1289_368##13	a_1289_368##10	1.39948e-18
C436	VGND#13	CLK#1	3.71815e-20
C437	VGND#12	a_634_74#	2.73903e-19
C438	VGND#6	a_324_79#	1.32049e-19
C439	a_1289_368##10	a_1289_368##3	3.92919e-18
C440	a_792_48##12	CLK#5	9.11986e-19
C441	a_792_48##2	a_634_74##3	1.58422e-17
C442	VPWR#11	a_792_48#	3.44907e-19
C443	VGND#11	VGND#10	1.58629e-18
C444	a_634_74##7	a_792_48##8	4.68251e-19
C445	a_792_48##8	VPWR#6	5.5785e-18
C446	a_324_79##8	a_634_74#	3.33987e-17
C447	VPWR#8	a_792_48#	5.36565e-18
C448	VGND#13	CLK#5	1.22596e-19
C449	a_119_143##3	a_324_79##3	1.4429e-18
C450	VGND#12	a_792_48##3	2.8081e-20
C451	VPWR#2	a_1289_368##5	5.56943e-18
C452	a_119_143##2	GATE	1.3492e-17
C453	a_354_105##4	a_792_48##2	4.50678e-18
C454	GCLK#3	a_1289_368##10	2.51349e-18
C455	a_792_48##6	a_1292_74#	1.73994e-17
C456	a_792_48##12	a_634_74#	3.88766e-17
C457	a_634_74##7	VPWR#9	1.75202e-17
C458	a_354_105##3	a_324_79#	9.12428e-19
C459	CLK#1	a_1292_74#	1.73994e-17
C460	VGND#3	a_1289_368##5	6.83568e-18
C461	VPWR#2	a_792_48##5	2.53489e-18
C462	VGND#11	GCLK#1	3.03751e-17
C463	a_119_143##2	a_119_143##5	1.65474e-18
C464	VGND#5	CLK	5.26101e-19
C465	a_634_74##5	a_792_48##10	1.04116e-19
C466	a_324_79##8	a_792_48##3	1.883e-17
C467	a_792_48##10	CLK#6	6.73393e-19
C468	VGND#6	VGND#5	2.20899e-19
C469	VGND#3	a_792_48##5	4.17457e-18
C470	VPWR#11	a_324_79#	1.4018e-18
C471	a_324_79##3	a_119_143##5	1.37502e-17
C472	a_354_105##3	a_324_79##2	1.38256e-18
C473	GATE#5	VPWR#11	8.08823e-19
C474	a_634_74#	VGND#13	6.402e-18
C475	CLK	a_1289_368##15	2.57645e-18
C476	VPWR#8	a_324_79#	6.16288e-18
C477	a_324_79##5	a_324_79##2	2.41442e-19
C478	a_792_48##12	a_792_48##3	5.92383e-19
C479	a_1289_368##17	GCLK#1	2.52654e-18
C480	VPWR#6	a_324_79#	1.40309e-19
C481	a_324_79##8	a_354_105#	4.02777e-18
C482	GATE#2	a_324_79##2	3.38317e-19
C483	a_119_143##2	a_354_105##7	6.29183e-17
C484	a_119_143##2	a_324_79##3	1.08583e-18
C485	VGND	CLK#2	1.48149e-18
C486	VGND	a_324_79##3	9.41358e-19
C487	VGND#13	a_792_48##3	3.0974e-17
C488	a_792_48##10	a_634_74##3	1.99554e-17
C489	VGND#2	GCLK	3.16169e-19
C490	a_792_48##3	a_744_74#	1.6106e-18
C491	VPWR#11	a_354_105##4	2.19591e-18
C492	a_792_48##12	a_354_105#	7.65068e-20
C493	a_792_48#	a_785_455#	1.06762e-17
C494	GATE	VGND#14	5.53262e-19
C495	a_354_105#	a_744_74#	4.51333e-18
C496	CLK#3	a_792_48##5	2.0644e-17
C497	a_119_143#	GATE	1.9413e-18
C498	GCLK	GCLK#3	4.46513e-18
C499	VPWR#10	a_354_105##3	8.88467e-19
C500	a_324_79#	a_785_455#	1.06762e-17
C501	a_1289_368##15	GCLK	4.22834e-19
C502	a_1289_368##17	VGND#11	3.36481e-17
C503	a_119_143##6	a_634_74##7	8.02847e-17
C504	a_792_48##5	a_634_74##2	2.69333e-19
C505	a_324_79##3	a_354_105##3	1.44553e-17
C506	VGND#7	a_354_105##3	5.89898e-20
C507	VGND#13	a_354_105#	1.65652e-18
C508	a_119_143##2	VGND#14	4.39523e-18
C509	a_634_74##2	CLK#3	4.2792e-18
C510	GCLK#3	a_1289_368##3	5.67961e-18
C511	VGND#7	a_324_79##5	6.83197e-17
C512	a_354_105##7	a_324_79##3	1.41386e-17
C513	a_634_74##6	a_792_48##3	9.73747e-19
C514	a_792_48##2	CLK#3	7.5629e-20
C515	SCE	VGND#9	1.93919e-17
C516	a_792_48##2	a_634_74##2	4.62544e-17
C517	GATE#3	a_116_395#	2.12401e-17
C518	VGND#12	CLK	2.77889e-17
C519	VPWR	VPWR#11	1.55082e-16
C520	a_324_79##8	CLK	2.71702e-17
C521	VPWR#11	a_324_79##2	3.9857e-17
C522	VPWR	VPWR#8	9.97058e-17
C523	a_119_143##6	VPWR#11	9.51803e-18
C524	VGND#5	VGND#4	4.81514e-19
C525	VPWR	VPWR#6	1.03262e-16
C526	SCE#3	a_116_395#	2.19445e-17
C527	a_634_74##2	a_354_105##3	5.3004e-19
C528	VGND#13	a_324_79##6	4.21648e-19
C529	a_792_48##10	a_324_79##10	5.84866e-17
C530	a_354_105##3	a_792_48##2	3.05338e-17
C531	a_119_143#	a_119_143##2	1.38134e-17
C532	a_634_74##6	a_354_105#	2.69983e-17
C533	VPWR	a_792_48##10	1.08499e-18
C534	GCLK	VGND#1	1.83822e-17
C535	GATE	a_119_143##3	4.28925e-17
C536	a_119_143##6	a_354_105##8	4.03283e-18
C537	GCLK	VGND#10	1.87409e-17
C538	GCLK#3	a_1289_368##2	6.00052e-18
C539	VPWR	a_634_74##5	2.1227e-18
C540	a_324_79##5	a_354_105##3	2.15284e-17
C541	VPWR	a_354_105##6	9.18623e-18
C542	VGND#12	VGND#11	1.06497e-18
C543	a_1289_368##15	a_1289_368##10	1.3328e-17
C544	VGND	VGND#8	1.65024e-16
C545	VGND	VGND#6	8.24382e-17
C546	VGND	VGND#5	8.60831e-17
C547	a_324_79##5	a_324_79##3	2.68702e-17
C548	VPWR	GATE#5	3.5446e-18
C549	SCE	VPWR#13	1.96284e-17
C550	a_634_74##6	a_324_79##6	2.61927e-17
C551	VPWR#11	GATE#3	9.1412e-18
C552	VPWR	SCE#6	2.46679e-18
C553	a_792_48##10	a_792_48##8	1.38664e-18
C554	VGND	a_792_48##10	2.43586e-18
C555	VGND#2	VGND#1	1.25309e-18
C556	GATE	a_324_79##4	1.63222e-18
C557	SCE#2	GATE#2	3.04692e-17
C558	a_324_79##6	a_119_143##5	1.11619e-17
C559	a_119_143##3	a_119_143##6	2.8835e-18
C560	VGND#12	a_1289_368##17	2.39678e-17
C561	VGND	a_634_74##5	2.76782e-18
C562	VGND	a_354_105##6	3.78744e-18
C563	VGND	a_119_143##2	1.43523e-17
C564	a_792_48##10	a_354_105##4	1.80964e-19
C565	a_1289_368##3	a_1289_368##2	3.17018e-18
C566	CLK	a_1289_368##11	1.90081e-19
C567	CLK	a_792_48##6	3.32064e-19
C568	a_1289_368##10	VNB	7.18073e-17
C569	VGND	GATE#5	1.98051e-18
C570	a_1289_368##3	VNB	2.64999e-17
C571	a_1289_368##2	VNB	4.04254e-17
C572	a_354_105##7	a_324_79##6	4.52941e-19
C573	CLK#2	VNB	2.08477e-17
C574	VGND	SCE#6	2.35805e-18
C575	a_324_79##3	VNB	7.3265e-17
C576	VPWR#11	SCE#3	1.11691e-18
C577	VPWR	a_1289_368##16	4.57902e-18
C578	GCLK	a_1289_368#	6.82961e-18
C579	VPWR#11	VPWR#12	8.22172e-18
C580	VGND#4	VGND#2	9.52088e-19
C581	a_119_143##5	a_324_79##4	4.58066e-18
C582	GCLK	a_1289_368##7	1.78439e-17
C583	VPWR	a_324_79##10	3.34172e-18
C584	a_792_48##10	VPWR#9	8.73828e-18
C585	VGND	VGND#12	1.87775e-17
C586	GCLK	a_1289_368##9	7.25766e-20
C587	VPWR	a_792_48##8	3.1865e-17
C588	VGND	a_324_79##8	5.16139e-17
C589	VGND	a_792_48##12	8.37923e-18
C590	GCLK	a_1289_368##11	2.90553e-20
C591	VGND	VGND#13	1.84034e-17
C592	a_324_79##8	a_1289_368##17	1.93612e-18
C593	GCLK	a_792_48##6	9.77004e-21
C594	GATE#5	a_119_143#	2.15915e-17
C595	VPWR	a_634_74##7	1.45787e-17
C596	VGND	a_634_74##6	1.10271e-17
C597	VPWR	a_119_143##6	2.37584e-17
C598	VGND#2	GCLK#5	1.67999e-17
C599	VGND	a_119_143##5	2.27837e-17
C600	VGND	a_354_105##7	5.03088e-18
C601	VGND	a_119_143#	1.58555e-17
C602	VPWR	a_119_143##3	2.58151e-17
C603	VGND	VGND#9	3.07512e-17
C604	GATE#2	a_324_79##3	1.82264e-18
C605	a_119_143##3	VPWR#12	5.47323e-18
C606	a_324_79##5	a_744_74#	9.56365e-18
C607	a_354_105##7	a_324_79##4	2.52372e-17
C608	VPWR	VPWR#13	7.81815e-17
C609	VGND	a_1289_368##16	8.21293e-19
C610	VGND	a_324_79##10	1.41483e-18
C611	a_1289_368##15	a_1289_368##3	9.84561e-20
C612	a_324_79##4	VGND#14	1.88989e-17
C613	VGND#8	VNB	9.10271e-17
C614	VGND#6	VNB	4.62894e-17
C615	VGND#5	VNB	5.20062e-17
C616	VGND#4	VNB	3.30046e-17
C617	VGND#2	VNB	2.54632e-17
C618	VPWR#11	VNB	6.68444e-17
C619	VPWR#8	VNB	4.58041e-17
C620	VPWR#6	VNB	4.77873e-17
C621	VPWR#4	VNB	3.2432e-17
C622	a_119_143##3	VPWR#11	9.01825e-17
C623	GCLK#3	VNB	8.20707e-18
C624	a_1289_368##15	VNB	4.16846e-18
C625	a_792_48##10	VNB	8.03751e-18
C626	VGND	CLK#1	3.3129e-19
C627	a_634_74##5	a_324_79#	8.62152e-18
C628	VGND	CLK#5	1.82007e-18
C629	VGND	a_634_74#	2.32952e-18
C630	a_634_74##5	VNB	5.76262e-18
C631	VGND	a_792_48##3	6.01838e-19
C632	a_354_105##6	VNB	1.39406e-17
C633	a_119_143#	a_324_79##4	2.61268e-18
C634	VGND	a_354_105#	1.3409e-18
C635	VPWR	CLK#4	4.62685e-19
C636	a_119_143##2	VNB	3.7818e-18
C637	VGND	a_324_79##6	2.5623e-18
C638	VPWR	CLK#6	7.63184e-18
C639	VGND	a_324_79##4	1.19367e-17
C640	GATE#5	VNB	1.48468e-19
C641	VPWR	a_634_74##3	8.94891e-18
C642	VGND	GATE#1	5.67866e-18
C643	SCE#6	VNB	4.24617e-19
C644	VGND	SCE#1	3.96359e-18
C645	VPWR	a_792_48#	8.70559e-18
C646	VGND#1	VNB	6.87127e-17
C647	VPWR#2	GCLK	1.21347e-18
C648	GATE	GATE#2	6.60967e-18
C649	GCLK#5	VNB	2.06727e-18
C650	CLK	a_792_48##5	5.53155e-18
C651	VPWR	a_324_79#	1.57337e-17
C652	VGND#10	VNB	2.87774e-19
C653	GCLK#1	VNB	4.97412e-18
C654	VGND#3	GCLK	2.16157e-18
C655	VGND#11	VNB	6.10654e-18
C656	VPWR	a_354_105##4	4.92075e-18
C657	CLK	CLK#3	9.52827e-18
C658	a_1289_368##17	VNB	1.35479e-17
C659	VPWR	a_324_79##2	1.48902e-17
C660	GATE#1	VGND#14	2.0322e-18
C661	VGND#12	VNB	1.05368e-18
C662	a_324_79##8	VNB	3.45725e-17
C663	a_792_48##12	VNB	8.34226e-18
C664	VPWR	GATE#3	1.01154e-17
C665	VGND#13	VNB	1.12949e-18
C666	VPWR	SCE#3	4.34752e-18
C667	a_634_74##6	VNB	9.72706e-19
C668	GCLK	a_1289_368##5	2.37476e-17
C669	a_324_79##8	VGND#12	6.55247e-17
C670	a_119_143##5	VNB	1.21834e-17
C671	a_1289_368##15	a_1289_368##2	7.99681e-20
C672	a_354_105##7	VNB	1.76595e-18
C673	GCLK	a_792_48##5	3.62887e-20
C674	SCE	SCE#2	9.82369e-18
C675	a_119_143#	VNB	1.51823e-17
C676	VGND#9	a_324_79##4	2.0016e-18
C677	VGND#9	VNB	5.86678e-17
C678	VPWR#1	VNB	8.25368e-17
C679	GCLK#6	VNB	2.98658e-18
C680	VPWR#3	VNB	3.0111e-18
C681	GCLK#4	VNB	3.54751e-18
C682	VPWR	VPWR#10	7.14768e-17
C683	VPWR#5	VNB	1.15291e-18
C684	a_1289_368##16	VNB	3.89797e-18
C685	VPWR#7	VNB	4.49117e-18
C686	a_324_79##10	VNB	7.51725e-18
C687	a_792_48##8	VNB	1.81271e-17
C688	VPWR#9	VNB	1.10171e-17
C689	a_634_74##7	VNB	2.41404e-18
C690	VPWR	a_792_48##5	5.78789e-18
C691	a_119_143##6	VNB	9.74078e-18
C692	VPWR	CLK#3	4.15575e-18
C693	a_119_143#	GATE#1	4.29222e-17
C694	a_119_143##3	VNB	2.14844e-17
C695	a_634_74##7	a_792_48##10	1.00967e-18
C696	VPWR	a_634_74##2	4.1145e-18
C697	VPWR#13	VNB	8.48243e-17
C698	a_1289_368#	VNB	3.15543e-17
C699	VPWR	a_792_48##2	9.77532e-18
C700	VPWR#13	a_119_143##3	3.00787e-17
C701	a_1289_368##7	VNB	2.60999e-17
C702	a_1289_368##9	VNB	2.60975e-17
C703	a_1289_368##11	VNB	3.67549e-17
C704	VGND	VGND#7	7.28454e-17
C705	VPWR	a_354_105##3	3.26653e-18
C706	a_792_48##6	VNB	3.22084e-17
C707	CLK#1	VNB	2.25294e-17
C708	CLK#5	VNB	2.71048e-17
C709	a_634_74#	VNB	3.53132e-17
C710	VGND	a_792_48##5	6.54639e-18
C711	a_792_48##3	VNB	3.28299e-17
C712	a_354_105#	VNB	3.89706e-17
C713	VGND	CLK#3	1.18337e-18
C714	a_324_79##6	VNB	4.78705e-17
C715	VPWR	SCE#2	4.72915e-21
C716	a_324_79##4	VNB	4.97835e-17
C717	VGND	a_634_74##2	5.02202e-18
C718	GATE#1	VNB	2.76261e-17
C719	SCE#1	VNB	2.6418e-17
C720	VGND	a_792_48##2	3.89384e-18
C721	a_1289_368##6	VNB	3.58556e-17
C722	VGND	a_354_105##3	4.54725e-18
C723	a_1289_368##8	VNB	3.24666e-17
C724	VGND#3	VGND#5	1.29532e-17
C725	a_1289_368##12	VNB	3.68356e-17
C726	VGND	a_324_79##5	4.56909e-17
C727	a_1289_368##13	VNB	3.16406e-17
C728	a_792_48##4	VNB	3.47188e-17
C729	CLK#4	VNB	3.97029e-17
C730	CLK#6	VNB	4.5701e-17
C731	VGND	SCE#2	6.43986e-21
C732	SCE#6	VGND#9	2.16702e-17
C733	VGND#9	GATE#1	1.25496e-18
C734	a_634_74##3	VNB	4.52496e-17
C735	a_792_48#	VNB	3.84624e-17
C736	a_324_79#	VNB	9.3517e-17
C737	a_354_105##4	VNB	2.97097e-17
C738	a_324_79##2	VNB	1.20454e-16
C739	GATE#3	VNB	3.10821e-17
C740	SCE#3	VNB	2.96476e-17
C741	VPWR#2	VNB	1.93364e-16
C742	VGND#3	VNB	1.68979e-16
C743	VPWR#10	VNB	3.13755e-17
C744	VGND#3	VGND#4	7.74687e-17
C745	VGND#7	VNB	4.25125e-17
C746	VPWR#2	VPWR#6	2.88187e-18
C747	a_1289_368##5	VNB	2.0546e-19
C748	a_792_48##5	VNB	5.29518e-17
C749	CLK#3	VNB	3.36212e-17
C750	a_634_74##2	VNB	5.073e-17
C751	a_119_143#	SCE#1	1.60043e-17
C752	a_792_48##2	VNB	6.70236e-17
C753	a_1289_368##15	CLK#2	5.32353e-19
C754	a_354_105##3	VNB	6.71797e-17
C755	VPWR#1	a_1289_368##2	2.30172e-18
C756	a_324_79##5	VNB	1.73282e-17
C757	VPWR	GATE	1.65607e-18
C758	GATE#2	VNB	4.46565e-17
C759	a_354_105##6	a_354_105##4	1.59384e-18
C760	SCE#2	VNB	5.85491e-17
C761	VPWR	SCE	1.0741e-18
C762	VGND	GATE	2.58931e-18
C763	VGND	SCE	1.13295e-18
C764	VGND#3	VGND#2	6.38652e-17
C765	VGND	CLK	4.34714e-18
C766	VPWR#2	VPWR#4	6.32211e-17
C767	GATE	VNB	5.00369e-18
C768	VGND#5	a_1289_368##17	1.94492e-18
C769	SCE	VNB	1.65449e-17
C770	CLK	VNB	1.52527e-18
C771	GCLK	VNB	1.11883e-17
C772	VPWR	VNB	3.07513e-16
C773	VGND	VNB	3.08923e-16
C774	a_634_74##5	a_324_79##2	1.0084e-20
C775	VGND#9	SCE#1	2.07089e-17
*
*
.ENDS sky130_fd_sc_hs__sdlclkp_4
*
