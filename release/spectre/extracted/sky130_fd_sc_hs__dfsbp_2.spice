* Extracted by Quantus, converted by sky130cad/quantus.py
*
*
*
*                       LINUX           Wed Nov 18 08:27:48 2026
*
*
*
*  PROGRAM  advgen
*
*  Name           : advgen - Quantus - (64-bit)
*  Version        : 25.1.0-p047
*  Build Date     : Thu Dec 11 23:20:30 PST 2025
*
*  HSPICE LIBRARY
*
*  OPERATING_TEMPERATURE 150
*  QRC_TECH_DIR <path>/tech
*
*
*

*
.SUBCKT sky130_fd_sc_hs__dfsbp_2 VPB VNB VGND SET_B VPWR Q_N Q D CLK
*
*
*  caps2d version: 10
*
*
*       TRANSISTOR CARDS
*
*
XM33 a_27_74##4 D#2 VGND#19 VNB sky130_fd_pr__nfet_01v8_lvt l=0.15 w=0.42 ad=0.1197 as=0.1197 pd=1.41 ps=1.41
XM26 a_225_74##13 CLK#3 VGND#18 VNB sky130_fd_pr__nfet_01v8_lvt l=0.15 w=0.74 ad=0.2109 as=0.2072 pd=2.05 ps=2.04
XM21 VGND#18 a_225_74##8 a_398_74##9 VNB sky130_fd_pr__nfet_01v8_lvt l=0.15 w=0.74 ad=0.2072 as=0.2072 pd=2.04 ps=2.04
XM17 a_27_74##5 a_225_74##7 a_595_97##12 VNB sky130_fd_pr__nfet_01v8_lvt l=0.15 w=0.42 ad=0.1197 as=0.2226 pd=1.41 ps=1.9
XM6 a_595_97##12 a_398_74# a_731_97# VNB sky130_fd_pr__nfet_01v8_lvt l=0.15 w=0.42 ad=0.2226 as=0.0882 pd=1.9 ps=1.26
XM9 a_731_97# a_757_401# VGND#17 VNB sky130_fd_pr__nfet_01v8_lvt l=0.15 w=0.42 ad=0.0882 as=0.1197 pd=1.26 ps=1.41
XM12 a_757_401##5 a_595_97# a_1001_74# VNB sky130_fd_pr__nfet_01v8_lvt l=0.15 w=0.42 ad=0.1197 as=0.0882 pd=1.41 ps=1.26
XM0 a_1001_74# SET_B#2 VGND#16 VNB sky130_fd_pr__nfet_01v8_lvt l=0.15 w=0.42 ad=0.0882 as=0.3868 pd=1.26 ps=2.86
XM25 VGND#16 a_595_97##4 a_1261_74# VNB sky130_fd_pr__nfet_01v8_lvt l=0.15 w=0.64 ad=0.3868 as=0.1536 pd=2.86 ps=1.76
XM15 a_1261_74# a_398_74##6 a_1339_74##19 VNB sky130_fd_pr__nfet_01v8_lvt l=0.15 w=0.64 ad=0.1536 as=0.2314 pd=1.76 ps=2.12
XM19 a_1339_74##19 a_225_74# a_1453_118# VNB sky130_fd_pr__nfet_01v8_lvt l=0.15 w=0.42 ad=0.2314 as=0.1008 pd=2.12 ps=1.32
XM4 a_1453_118# a_1501_92##3 a_1531_118# VNB sky130_fd_pr__nfet_01v8_lvt l=0.15 w=0.42 ad=0.1008 as=0.1008 pd=1.32 ps=1.32
XM31 a_1531_118# SET_B#6 VGND#15 VNB sky130_fd_pr__nfet_01v8_lvt l=0.15 w=0.42 ad=0.1008 as=0.52125 pd=1.32 ps=3.01
XM22 VGND#15 a_1339_74##7 a_1501_92##5 VNB sky130_fd_pr__nfet_01v8_lvt l=0.15 w=0.42 ad=0.52125 as=0.1533 pd=3.01 ps=1.57
XM2 VGND#14 a_1339_74##11 Q_N#2 VNB sky130_fd_pr__nfet_01v8_lvt l=0.15 w=0.74 ad=0.2109 as=0.2072 pd=2.05 ps=2.04
XM28 Q_N#2 a_1339_74##9 VGND#13 VNB sky130_fd_pr__nfet_01v8_lvt l=0.15 w=0.74 ad=0.2072 as=0.2109 pd=2.04 ps=2.05
XM13 a_2221_74##9 a_1339_74##8 VGND#12 VNB sky130_fd_pr__nfet_01v8_lvt l=0.15 w=0.64 ad=0.1824 as=0.2938 pd=1.85 ps=2.32
XM29 Q#2 a_2221_74##5 VGND#12 VNB sky130_fd_pr__nfet_01v8_lvt l=0.15 w=0.74 ad=0.2072 as=0.2938 pd=2.04 ps=2.32
XM34 VGND#1 a_2221_74# Q#2 VNB sky130_fd_pr__nfet_01v8_lvt l=0.15 w=0.74 ad=0.2109 as=0.2072 pd=2.05 ps=2.04
XM35 a_27_74##6 D#3 VPWR#19 VPB sky130_fd_pr__pfet_01v8 l=0.15 w=0.42 ad=0.1239 as=0.1239 pd=1.43 ps=1.43
XM16 a_225_74##11 CLK#1 VPWR#18 VPB sky130_fd_pr__pfet_01v8 l=0.15 w=1.12 ad=0.3304 as=0.336 pd=2.83 ps=2.84
XM32 VPWR#18 a_225_74##9 a_398_74##14 VPB sky130_fd_pr__pfet_01v8 l=0.15 w=1.12 ad=0.336 as=0.3304 pd=2.84 ps=2.83
XM18 a_27_74# a_398_74##4 a_595_97##11 VPB sky130_fd_pr__pfet_01v8 l=0.15 w=0.42 ad=0.1239 as=0.126 pd=1.43 ps=1.44
XM36 a_595_97##11 a_225_74##6 a_706_463# VPB sky130_fd_pr__pfet_01v8 l=0.15 w=0.42 ad=0.126 as=0.1134 pd=1.44 ps=1.38
XM20 a_706_463# a_757_401##4 VPWR#17 VPB sky130_fd_pr__pfet_01v8 l=0.15 w=0.42 ad=0.1134 as=0.3922 pd=1.38 ps=2.85
XM23 VPWR#17 a_595_97##3 a_757_401##7 VPB sky130_fd_pr__pfet_01v8 l=0.15 w=0.42 ad=0.3922 as=0.1533 pd=2.85 ps=1.57
XM37 a_757_401##7 SET_B#3 VPWR#16 VPB sky130_fd_pr__pfet_01v8 l=0.15 w=0.42 ad=0.1533 as=0.5086 pd=1.57 ps=3.77
XM30 VPWR#16 a_595_97##7 a_1258_341# VPB sky130_fd_pr__pfet_01v8 l=0.15 w=1 ad=0.5086 as=0.399625 pd=3.77 ps=3.22
XM3 a_1258_341# a_225_74##2 a_1339_74##16 VPB sky130_fd_pr__pfet_01v8 l=0.15 w=1 ad=0.399625 as=0.4483 pd=3.22 ps=3.32
XM5 a_1339_74##16 a_398_74##7 a_1521_508# VPB sky130_fd_pr__pfet_01v8 l=0.15 w=0.42 ad=0.4483 as=0.1134 pd=3.32 ps=1.38
XM11 a_1521_508# a_1501_92# VPWR#15 VPB sky130_fd_pr__pfet_01v8 l=0.15 w=0.42 ad=0.1134 as=0.126 pd=1.38 ps=1.44
XM27 VPWR#15 SET_B#4 a_1339_74##18 VPB sky130_fd_pr__pfet_01v8 l=0.15 w=0.42 ad=0.126 as=0.1218 pd=1.44 ps=1.42
XM7 a_1501_92##4 a_1339_74##13 VPWR#14 VPB sky130_fd_pr__pfet_01v8 l=0.15 w=0.42 ad=0.2544 as=0.3682 pd=2.27 ps=3.01
XM1 VPWR#14 a_1339_74##12 Q_N#1 VPB sky130_fd_pr__pfet_01v8 l=0.15 w=1.12 ad=0.3682 as=0.336 pd=3.01 ps=2.84
XM14 Q_N#1 a_1339_74##10 VPWR#13 VPB sky130_fd_pr__pfet_01v8 l=0.15 w=1.12 ad=0.336 as=0.3248 pd=2.84 ps=2.82
XM8 a_2221_74##10 a_1339_74# VPWR#12 VPB sky130_fd_pr__pfet_01v8 l=0.15 w=1 ad=0.295 as=0.4148 pd=2.59 ps=3
XM10 VPWR#12 a_2221_74##6 Q#1 VPB sky130_fd_pr__pfet_01v8 l=0.15 w=1.12 ad=0.4148 as=0.336 pd=3 ps=2.84
XM24 Q#1 a_2221_74##4 VPWR#1 VPB sky130_fd_pr__pfet_01v8 l=0.15 w=1.12 ad=0.336 as=0.3304 pd=2.84 ps=2.83
*
*
*       RESISTOR AND CAP/DIODE CARDS
*
Rg1	D#1	D#2	311.105377
Rg2	D#1	D#3	453.390839
Rg3	CLK#1	CLK#2	478.349915
Rg4	CLK#2	CLK#3	320.356293
Rg5	a_398_74#	a_398_74##2	447.191040
Rg6	a_398_74##2	a_398_74##3	132.178070
Rg7	a_398_74##3	a_398_74##4	288.164215
Rg8	a_757_401#	a_757_401##2	404.357574
Rg9	a_757_401##2	a_757_401##3	341.280426
Rg10	a_757_401##3	a_757_401##4	379.480347
Rg11	a_595_97#	a_595_97##2	591.999390
Rg12	a_595_97##2	a_595_97##3	352.111298
Rg13	SET_B#1	SET_B#2	662.341614
Rg14	SET_B#1	SET_B#3	293.382996
Rg15	a_595_97##4	a_595_97##5	268.837128
Rg16	a_595_97##5	a_595_97##6	162.590912
Rg17	a_595_97##5	a_595_97##7	510.298920
Rg18	a_398_74##5	a_398_74##6	279.244598
Rg19	a_225_74#	a_225_74##2	1094.576660
Rg20	a_225_74##2	a_225_74##3	2180.056885
Rg21	a_225_74##3	a_225_74##4	1406.904419
Rg22	a_225_74##4	a_225_74##5	59.143440
Rg23	a_225_74##3	a_225_74##6	283.919525
Rg24	a_225_74##4	a_225_74##7	531.442993
Rg25	a_225_74##5	a_225_74##8	371.702240
Rg26	a_225_74##5	a_225_74##9	446.312561
Rg27	a_398_74##7	a_398_74##8	242.974045
Rg28	a_1501_92#	a_1501_92##2	490.156921
Rg29	a_1501_92##2	a_1501_92##3	472.403717
Rg30	SET_B#4	SET_B#5	613.125916
Rg31	SET_B#5	SET_B#6	415.720520
Rg32	a_1339_74#	a_1339_74##2	430.352753
Rg33	a_1339_74##2	a_1339_74##3	209.960617
Rg34	a_1339_74##3	a_1339_74##4	92.361191
Rg35	a_1339_74##4	a_1339_74##5	117.374794
Rg36	a_1339_74##5	a_1339_74##6	46.121056
Rg37	a_1339_74##6	a_1339_74##7	396.349426
Rg38	a_1339_74##2	a_1339_74##8	419.170471
Rg39	a_1339_74##3	a_1339_74##9	415.274414
Rg40	a_1339_74##3	a_1339_74##10	429.620972
Rg41	a_1339_74##4	a_1339_74##11	387.864044
Rg42	a_1339_74##4	a_1339_74##12	462.880615
Rg43	a_1339_74##5	a_1339_74##13	217.827377
Rg44	a_2221_74#	a_2221_74##2	368.862610
Rg45	a_2221_74##2	a_2221_74##3	78.574142
Rg46	a_2221_74##2	a_2221_74##4	471.862823
Rg47	a_2221_74##3	a_2221_74##5	349.462952
Rg48	a_2221_74##3	a_2221_74##6	452.177277
Rf1	D#4	D	0.532052
Rf2	D#1	D#6	53.942986
Rf3	D#4	D#6	7.479781
Rf4	D#7	D	0.532052
Rf5	D#6	D#7	7.086109
Rf6	CLK#4	CLK#2	161.521530
Rf7	CLK	CLK#6	1.288721
Rf8	CLK#4	CLK#6	7.589135
Rf9	a_225_74##5	a_225_74##12	223.872650
Rf10	a_225_74##12	a_225_74##13	88.222649
Rf11	a_225_74##11	a_225_74##12	15.000000
Rf12	a_27_74#	a_27_74##2	40.360710
Rf13	a_27_74##2	a_27_74##3	154.010620
Rf14	a_27_74##3	a_27_74##4	135.415131
Rf15	a_27_74##2	a_27_74##5	113.596024
Rf16	a_27_74##3	a_27_74##6	39.304317
Rf17	a_398_74##9	a_398_74##3	265.867981
Rf18	a_757_401##5	a_757_401##2	199.279541
Rf19	a_757_401##7	a_757_401##3	233.861618
Rf20	SET_B#7	SET_B#8	1.942951
Rf21	SET_B#1	SET_B#10	162.175751
Rf22	SET_B#7	SET_B#10	6.078417
Rf23	a_595_97##6	a_595_97##9	235.197968
Rf24	a_595_97##9	a_595_97##10	119.882790
Rf25	a_595_97##10	a_595_97##11	107.715485
Rf26	a_595_97##10	a_595_97##12	40.559441
Rf27	a_398_74##5	a_398_74##12	168.519608
Rf28	a_398_74##12	a_398_74##13	327.959839
Rf29	a_398_74##13	a_398_74##14	171.020844
Rf30	a_398_74##12	a_398_74##8	422.350037
Rf31	a_398_74##13	a_398_74##2	210.976151
Rf32	SET_B#11	SET_B#5	161.063065
Rf33	SET_B	SET_B#14	10.608036
Rf34	SET_B#11	SET_B#14	11.750918
Rf35	a_1339_74##6	a_1339_74##15	119.563980
Rf36	a_1339_74##15	a_1339_74##17	69.778038
Rf37	a_1339_74##15	a_1339_74##18	27.780993
Rf38	a_1339_74##17	a_1339_74##19	131.264481
Rf39	a_1339_74##17	a_1339_74##16	21.652687
Rf40	a_1339_74##16	a_1339_74##17	5.000000
Rf41	a_1501_92##4	a_1501_92##6	186.578125
Rf42	a_1501_92##6	a_1501_92##2	275.621704
Rf43	a_1501_92##5	a_1501_92##6	15.000000
Rf44	Q_N	Q_N#1	20.272545
Rf45	Q_N	Q_N#3	9.123401
Rf46	Q_N#3	Q_N	9.123401
Rf47	Q_N#2	Q_N#3	7.500000
Rf48	a_2221_74##3	a_2221_74##8	182.059448
Rf49	a_2221_74##8	a_2221_74##9	37.821369
Rf50	a_2221_74##8	a_2221_74##10	39.258099
Rf51	Q	Q#1	90.818436
Rf52	Q	Q#3	7.078941
Rf53	Q#3	Q	7.078941
Rf54	Q#2	Q#3	7.500000
Rf55	VPWR#1	VPWR#2	118.564102
Rf56	VPWR#2	VPWR#3	73.659950
Rf57	VPWR#3	VPWR#4	66.102928
Rf58	VPWR#4	VPWR#5	123.261177
Rf59	VPWR#5	VPWR#6	167.338806
Rf60	VPWR#6	VPWR#7	124.116425
Rf61	VPWR#7	VPWR#8	60.242126
Rf62	VPWR#8	VPWR#9	118.317268
Rf63	VPWR#9	VPWR#10	73.731934
Rf65	VPWR#2	VPWR#12	51.329571
Rf66	VPWR#3	VPWR#13	47.715668
Rf67	VPWR#4	VPWR#14	35.840199
Rf68	VPWR#5	VPWR#15	47.494125
Rf69	VPWR#6	VPWR#16	34.432526
Rf70	VPWR#7	VPWR#17	31.751787
Rf71	VPWR#9	VPWR#18	35.294842
Rf72	VPWR#10	VPWR#19	34.310661
Rf73	VGND#1	VGND#2	110.555344
Rf74	VGND#2	VGND#3	74.519791
Rf75	VGND#3	VGND#4	66.180038
Rf76	VGND#4	VGND#5	101.270943
Rf77	VGND#5	VGND#6	199.162445
Rf78	VGND#6	VGND#7	119.656853
Rf79	VGND#7	VGND#8	55.185940
Rf80	VGND#8	VGND#9	118.731796
Rf81	VGND#9	VGND#10	77.856331
Rf83	VGND#2	VGND#12	31.337896
Rf84	VGND#3	VGND#13	41.038895
Rf85	VGND#4	VGND#14	41.745289
Rf86	VGND#5	VGND#15	15.038546
Rf87	VGND#6	VGND#16	14.526239
Rf88	VGND#7	VGND#17	44.190063
Rf89	VGND#9	VGND#18	36.622520
Rf90	VGND#10	VGND#19	40.352859
Rf99	a_595_97##2	a_595_97##9	160.232803
Re2	SET_B	SET_B#8	14.521620
Re3	VPWR#4	VPWR	2.042809
Re4	VPWR	VPWR#8	1.896894
Re5	VGND#4	VGND	2.042809
Re6	VGND	VGND#8	1.896894
*
*       CAPACITOR CARDS
*
*
C1	SET_B#4	a_1339_74##12	1.3614e-18
C2	a_27_74##6	VPWR#19	3.41227e-17
C3	VGND#4	a_1339_74##8	1.95457e-19
C4	a_27_74##5	a_225_74##4	2.46175e-17
C5	VGND#1	a_2221_74#	2.65991e-17
C6	a_1339_74##16	a_1501_92##2	3.68822e-17
C7	VGND#4	a_2221_74##8	6.5066e-19
C8	VGND#3	a_2221_74##5	7.65459e-20
C9	VGND#19	D#2	2.83868e-17
C10	a_757_401##2	a_225_74##3	3.85588e-19
C11	D#6	CLK#2	4.30435e-19
C12	D#3	a_225_74##3	1.40658e-19
C13	VGND#4	a_1339_74##9	5.34881e-18
C14	a_27_74##2	a_225_74##6	3.12032e-19
C15	a_398_74##13	a_757_401#	3.68082e-19
C16	SET_B#4	a_1339_74##13	2.34104e-18
C17	D#4	CLK#2	4.52603e-19
C18	a_398_74##12	a_1339_74##16	4.97021e-17
C19	VGND#3	a_1339_74##2	4.81544e-19
C20	VPWR#2	a_2221_74##4	2.78534e-18
C21	a_2221_74##10	VPWR#12	7.82705e-17
C22	VGND#5	a_1501_92##5	5.25879e-17
C23	a_398_74##12	a_1258_341#	1.0061e-17
C24	a_2221_74#	Q#2	1.54402e-17
C25	VGND#4	a_1339_74##11	1.28918e-17
C26	a_27_74##4	D#2	1.43176e-17
C27	SET_B#7	a_398_74##12	1.97953e-18
C28	a_1339_74##3	a_1339_74#	1.89369e-19
C29	VGND#2	a_2221_74##5	4.73805e-18
C30	a_1339_74##16	a_398_74##8	1.37237e-16
C31	D#7	D#1	1.92504e-17
C32	a_595_97##10	a_595_97#	1.57709e-20
C33	a_1339_74##15	VPWR#4	1.24342e-17
C34	VGND#4	a_1339_74##7	8.08288e-18
C35	VGND#1	a_2221_74##5	1.34515e-18
C36	D#6	a_225_74##13	3.30718e-19
C37	VGND#6	a_595_97##5	2.12624e-18
C38	a_398_74##12	a_1339_74##19	1.39398e-16
C39	D#6	D#1	6.92938e-18
C40	VPWR#3	a_2221_74##6	1.77716e-19
C41	VGND#12	a_2221_74#	1.48368e-18
C42	a_1501_92#	SET_B#4	3.58587e-17
C43	VPWR#13	VPWR#12	3.73165e-18
C44	VGND#4	SET_B#6	6.40308e-18
C45	a_27_74##2	a_398_74##4	2.47411e-18
C46	D#4	D#1	1.75359e-17
C47	VPWR#7	VPWR#6	1.66502e-19
C48	VGND#3	a_1339_74##8	8.26606e-19
C49	a_1339_74##16	a_398_74##5	2.25544e-18
C50	VGND#13	a_1339_74##3	1.45504e-17
C51	VPWR#4	SET_B#14	2.92363e-18
C52	a_398_74##13	a_706_463#	7.79714e-19
C53	a_2221_74##5	Q#2	1.49333e-17
C54	VGND#2	a_2221_74##3	8.45366e-19
C55	VGND#4	a_1501_92##3	2.17507e-18
C56	a_398_74##9	a_225_74##4	4.06612e-18
C57	VPWR#2	a_2221_74##6	9.44862e-18
C58	D#4	a_225_74##13	4.14421e-17
C59	a_757_401##3	a_225_74##3	4.06155e-18
C60	VGND#5	VGND#15	1.28771e-17
C61	a_595_97##10	a_757_401#	1.19536e-17
C62	VGND#1	a_1339_74##8	3.68838e-19
C63	a_27_74##5	a_398_74##2	1.12095e-19
C64	a_398_74##13	VPWR#16	3.31169e-17
C65	VGND#2	a_1339_74##8	2.74659e-18
C66	a_27_74##3	a_225_74##9	3.29419e-19
C67	VPWR#13	a_2221_74##10	8.13981e-17
C68	a_398_74##7	a_1501_92#	2.78569e-17
C69	VGND#2	a_1339_74##2	7.3597e-20
C70	SET_B#14	a_1339_74##5	2.75903e-18
C71	a_2221_74##5	VGND#12	2.18059e-17
C72	VGND#4	a_398_74##6	9.4214e-19
C73	a_27_74##2	a_225_74##9	2.39892e-17
C74	a_2221_74##5	a_2221_74#	3.92755e-17
C75	a_398_74##3	a_595_97##12	4.09528e-17
C76	a_398_74##12	VPWR#16	5.98519e-17
C77	VPWR#16	a_595_97##6	8.93324e-19
C78	VGND#3	a_1339_74##9	7.45313e-18
C79	VPWR#1	a_2221_74##4	3.25881e-17
C80	a_27_74##5	a_398_74##3	6.08441e-17
C81	D#4	VGND#19	3.53411e-17
C82	a_2221_74##9	a_2221_74##5	5.35605e-19
C83	a_27_74##4	D#6	4.21982e-18
C84	VPWR#2	a_1339_74#	4.79387e-18
C85	a_225_74##2	a_398_74##7	9.33367e-18
C86	a_398_74##9	a_398_74##3	4.23658e-18
C87	a_595_97##10	a_398_74#	9.02388e-18
C88	a_27_74##3	CLK#1	7.0991e-19
C89	VGND#14	a_1339_74##5	9.07516e-19
C90	a_757_401##7	a_398_74##13	7.06048e-17
C91	a_1339_74##8	VGND#12	2.55713e-17
C92	Q#1	a_2221_74##4	5.94382e-17
C93	a_1339_74##5	a_1339_74##12	7.84693e-19
C94	a_225_74##4	a_398_74##2	7.43897e-19
C95	VGND#4	SET_B#11	2.86799e-18
C96	VPWR#2	VPWR#1	1.04636e-18
C97	VGND#5	a_1339_74##11	2.44965e-18
C98	a_27_74##2	CLK#1	2.53811e-17
C99	VGND#13	a_2221_74##5	1.67072e-19
C100	VPWR#1	a_2221_74##6	1.23306e-18
C101	a_398_74##2	a_225_74##3	4.55907e-19
C102	VPWR#4	a_398_74##12	8.55981e-19
C103	Q_N#1	VPWR#13	6.93632e-17
C104	a_225_74##5	a_27_74##5	1.96183e-17
C105	VGND#5	SET_B#5	3.85485e-18
C106	a_757_401##7	SET_B#1	3.37763e-18
C107	VPWR#4	a_1339_74##5	2.26179e-19
C108	VPWR#12	a_2221_74##4	2.59149e-19
C109	a_1339_74##8	a_2221_74##5	2.20971e-17
C110	VPWR#3	a_1339_74##10	7.72545e-18
C111	a_27_74##4	D#4	3.69701e-17
C112	a_2221_74##9	a_1339_74##8	2.72502e-17
C113	a_757_401##7	a_398_74##12	4.70904e-17
C114	a_225_74##5	a_398_74##9	3.46837e-17
C115	a_595_97##7	a_225_74##2	5.6133e-17
C116	a_1339_74##19	a_225_74##2	2.49939e-18
C117	Q#1	a_2221_74##6	5.63952e-17
C118	VGND#14	a_1339_74##4	1.34536e-18
C119	VPWR#4	a_1339_74##4	5.10331e-20
C120	VGND#3	a_1339_74##11	5.13006e-19
C121	a_2221_74##3	VPWR#2	3.71664e-19
C122	VGND#18	a_225_74##5	2.50102e-18
C123	a_27_74##3	D#3	1.6969e-17
C124	VGND#12	a_1339_74##9	4.73417e-19
C125	a_1339_74##12	a_1339_74##3	1.39655e-18
C126	VGND#2	a_2221_74##8	1.47272e-19
C127	a_595_97##10	a_225_74##7	2.8869e-18
C128	a_2221_74##10	a_2221_74##4	5.65872e-20
C129	VPWR#2	a_1339_74##10	3.51685e-19
C130	a_398_74##13	VPWR#17	1.05526e-16
C131	SET_B#3	a_225_74##2	1.95414e-17
C132	VPWR#4	a_1339_74##3	1.21325e-18
C133	VPWR#14	VPWR#13	2.56814e-18
C134	a_757_401##7	a_595_97##2	3.01596e-17
C135	VGND#13	a_1339_74##8	2.26791e-18
C136	a_27_74##5	CLK#2	7.00992e-20
C137	a_2221_74##6	VPWR#12	2.47017e-17
C138	SET_B#5	a_1339_74##7	9.70361e-18
C139	VPWR#5	a_1339_74##12	1.22831e-19
C140	Q#1	VPWR#2	1.64371e-17
C141	SET_B#3	a_595_97##7	5.74299e-18
C142	VGND#4	a_398_74##12	3.79458e-17
C143	VPWR#4	a_1339_74##2	1.35698e-18
C144	a_2221_74##9	a_1339_74##9	1.72922e-18
C145	VGND#5	a_1339_74##7	1.32452e-17
C146	VPWR#16	a_595_97##5	8.3888e-20
C147	Q#1	a_1339_74#	1.76581e-18
C148	a_1501_92##5	a_1339_74##5	1.99436e-17
C149	a_1501_92##2	a_1339_74##11	1.45553e-19
C150	a_1339_74##19	a_595_97##7	3.29109e-19
C151	CLK#2	VGND#18	1.91538e-18
C152	a_2221_74##8	a_2221_74##3	2.76275e-19
C153	a_1339_74##9	a_1339_74##8	5.31381e-18
C154	VGND#5	a_1501_92##2	2.69899e-17
C155	a_2221_74##10	a_2221_74##6	1.57194e-18
C156	VPWR#3	a_1339_74##12	5.23697e-19
C157	a_225_74##4	a_398_74##3	5.16664e-17
C158	VGND#4	a_2221_74##2	3.06952e-19
C159	CLK#2	a_225_74##13	4.66782e-17
C160	a_225_74##13	a_225_74##4	1.96653e-19
C161	a_1501_92##2	a_1339_74##7	1.91167e-19
C162	VPWR#1	a_1339_74##10	1.70263e-19
C163	VPWR#14	Q_N#1	3.77158e-17
C164	a_398_74##3	a_225_74##3	1.96684e-18
C165	a_1339_74#	VPWR#12	3.27089e-17
C166	a_27_74##5	D#1	5.20565e-20
C167	VPWR#8	a_225_74##7	5.18327e-20
C168	a_1339_74##9	VGND#13	2.8445e-17
C169	a_595_97##11	a_595_97##12	9.0093e-19
C170	a_1501_92##2	SET_B#6	4.77901e-17
C171	VGND#4	a_1339_74##5	1.26929e-18
C172	VPWR#13	a_2221_74##6	5.08972e-19
C173	VPWR#4	a_2221_74##4	3.93342e-18
C174	a_595_97##3	SET_B#3	1.8724e-17
C175	a_398_74##9	D#1	2.54266e-19
C176	VGND#8	a_398_74#	4.60706e-18
C177	VGND#1	VPWR#1	1.03343e-17
C178	SET_B#14	a_1339_74##15	3.34355e-17
C179	SET_B#11	a_1339_74##5	5.42681e-18
C180	VGND#14	a_1339_74##8	3.75677e-20
C181	D#7	CLK#1	4.83921e-19
C182	a_757_401##5	a_398_74##12	4.36353e-18
C183	a_1501_92##2	a_1501_92##3	5.70341e-18
C184	a_398_74##8	a_1339_74##7	5.58571e-19
C185	a_1501_92##5	a_1339_74##4	1.43858e-17
C186	a_2221_74##10	a_1339_74#	7.66948e-17
C187	VGND#4	a_1339_74##4	1.09131e-18
C188	a_757_401##7	a_225_74##3	1.39313e-18
C189	VPWR#4	a_2221_74##6	2.46039e-18
C190	SET_B#8	a_398_74##12	6.39148e-17
C191	VGND#8	a_225_74##7	3.16385e-18
C192	a_1501_92##4	Q_N#1	2.63731e-17
C193	a_225_74##13	D#1	7.27926e-18
C194	a_1339_74##9	Q_N#2	1.49771e-17
C195	a_225_74#	a_1501_92##2	1.59835e-17
C196	VPWR#5	SET_B#5	9.39804e-20
C197	a_398_74##8	SET_B#6	3.93258e-18
C198	VPWR#17	a_757_401##3	9.18261e-19
C199	VPWR#12	a_1339_74##10	4.47728e-19
C200	VGND#5	SET_B#6	1.59208e-17
C201	VGND#4	a_1339_74##3	5.22726e-18
C202	VGND#19	D#1	6.47326e-18
C203	VPWR#4	a_1339_74#	8.75412e-18
C204	a_1339_74##11	a_1339_74##9	4.05979e-17
C205	VPWR#13	a_1339_74#	3.55715e-18
C206	a_398_74##8	a_1501_92##3	2.0629e-17
C207	a_398_74##8	VGND#5	7.49852e-18
C208	VGND#13	a_1339_74##11	6.3395e-19
C209	a_27_74##4	D#1	1.13878e-17
C210	a_757_401##4	a_595_97##3	3.82973e-18
C211	a_2221_74##8	a_2221_74#	1.23384e-19
C212	a_2221_74##10	VPWR#3	5.82787e-18
C213	VPWR#14	a_2221_74##6	2.02774e-19
C214	VGND#4	a_1339_74##2	1.76785e-18
C215	VGND#12	a_2221_74##8	2.1967e-18
C216	a_595_97##11	a_757_401##3	2.33268e-19
C217	VPWR#4	a_1339_74##10	4.12444e-18
C218	a_2221_74##10	a_1339_74##10	1.9077e-18
C219	a_398_74##8	a_225_74#	1.32881e-17
C220	a_595_97##11	a_398_74##13	9.71279e-17
C221	VGND#14	a_1339_74##9	1.40046e-18
C222	a_398_74##13	VPWR#8	4.6419e-17
C223	a_1501_92##4	VPWR#14	4.19456e-17
C224	a_1339_74##18	Q_N#1	1.40322e-19
C225	a_1501_92##5	a_1339_74##3	6.76185e-19
C226	a_225_74##5	a_225_74##4	3.93622e-18
C227	SET_B#11	a_1339_74##4	2.93929e-19
C228	a_398_74##8	a_398_74##6	6.11538e-19
C229	VPWR#4	a_1339_74##12	8.41644e-18
C230	a_27_74##3	a_225_74##4	2.93415e-19
C231	a_27_74##5	a_27_74#	2.48973e-18
C232	VPWR#13	a_1339_74##10	2.27789e-17
C233	a_2221_74##8	Q#1	4.9789e-19
C234	VGND#6	a_225_74##2	2.50136e-20
C235	a_398_74##8	a_595_97##4	1.86837e-19
C236	a_225_74##6	a_757_401##4	3.39777e-17
C237	VPWR#5	SET_B#4	5.77365e-18
C238	a_398_74##5	a_225_74#	2.31732e-17
C239	a_2221_74##10	VPWR#2	5.87564e-18
C240	a_595_97##11	a_398_74##2	2.0025e-17
C241	VPWR#4	a_1339_74##13	1.50303e-18
C242	a_1501_92##5	a_1339_74##9	1.61626e-18
C243	VPWR#5	a_1501_92##2	8.3592e-20
C244	VGND#6	a_398_74##5	1.5453e-19
C245	a_1339_74##7	a_1339_74##11	3.70126e-18
C246	a_595_97##10	a_757_401##5	2.31653e-18
C247	a_1339_74##18	VPWR#14	8.5684e-18
C248	VGND#5	a_1501_92##3	6.26956e-18
C249	Q_N#1	a_1339_74##10	5.34222e-17
C250	VPWR#17	a_225_74##3	1.30413e-17
C251	a_398_74##4	a_757_401##4	6.55177e-19
C252	VGND#14	a_1339_74##11	3.86075e-17
C253	a_2221_74##8	a_2221_74##5	2.07455e-19
C254	VGND#6	VGND#16	8.97324e-18
C255	VPWR#13	a_1339_74##12	6.91215e-19
C256	SET_B#8	SET_B#10	1.32713e-17
C257	a_398_74##3	a_595_97##11	4.42731e-17
C258	a_398_74##4	a_225_74##6	3.0258e-17
C259	VPWR#14	a_1339_74##10	2.28772e-18
C260	a_595_97##5	a_225_74#	2.94758e-19
C261	VPWR#6	a_1501_92#	5.95123e-20
C262	Q#1	a_2221_74##2	6.41266e-18
C263	a_398_74##3	a_27_74#	1.80446e-17
C264	SET_B#8	SET_B#7	1.55015e-17
C265	a_1501_92##5	a_1339_74##11	7.53863e-18
C266	a_1339_74##18	a_1501_92##4	8.14792e-18
C267	VGND#6	a_225_74#	7.55994e-19
C268	a_27_74#	a_225_74##7	7.01337e-19
C269	VPWR#15	VPWR#14	2.03103e-18
C270	a_1339_74##12	Q_N#1	1.3762e-17
C271	a_398_74##3	a_398_74##14	4.75924e-18
C272	VPWR#5	a_1501_92#	7.81059e-18
C273	a_1501_92##4	a_1339_74##10	1.41738e-18
C274	VPWR#13	VPWR#2	1.61611e-18
C275	VGND#14	a_1339_74##7	2.72659e-18
C276	SET_B#2	a_595_97##6	1.81833e-17
C277	VPWR#5	a_398_74##8	2.99408e-19
C278	VPWR#4	a_225_74##2	3.74736e-18
C279	VGND#17	a_595_97##10	1.57287e-17
C280	a_398_74##12	a_1261_74#	1.36952e-17
C281	a_27_74##2	a_225_74##4	2.67356e-17
C282	SET_B#14	a_1339_74##6	1.89237e-17
C283	SET_B#6	a_1339_74##7	2.71127e-18
C284	VPWR#9	a_225_74##4	7.84201e-21
C285	VPWR#5	a_1339_74##5	1.53175e-19
C286	VGND#6	a_595_97##6	3.92778e-17
C287	a_398_74##14	a_225_74##7	4.64497e-20
C288	VPWR#14	a_1339_74##12	3.02449e-17
C289	VGND#8	a_595_97##10	4.99838e-19
C290	VGND#5	a_225_74#	1.75558e-18
C291	a_595_97##6	a_595_97#	3.90665e-19
C292	a_2221_74##8	a_1339_74##8	5.60304e-19
C293	a_398_74##14	a_398_74##13	1.04214e-18
C294	a_595_97##2	a_225_74#	1.33071e-19
C295	a_1339_74##18	a_1339_74##10	1.04541e-20
C296	Q_N#1	VPWR#3	7.36683e-18
C297	a_225_74##5	a_398_74##14	1.73729e-18
C298	VGND#4	a_225_74##2	4.62726e-21
C299	VPWR#3	VPWR#2	1.13217e-18
C300	Q_N#1	a_1339_74##13	4.35824e-19
C301	a_1501_92##5	a_1339_74##7	4.06881e-17
C302	SET_B#8	a_595_97##5	7.38769e-19
C303	a_1501_92##4	a_1339_74##12	1.37072e-17
C304	a_225_74##5	VPWR#18	6.3748e-19
C305	a_1339_74##15	SET_B#5	1.29612e-17
C306	SET_B#11	a_1339_74##6	1.11086e-17
C307	VPWR#6	a_398_74##7	1.23532e-19
C308	a_225_74##11	a_225_74##5	2.2654e-18
C309	SET_B#8	a_225_74##2	2.59361e-18
C310	VGND#14	SET_B#6	3.81105e-19
C311	VPWR#5	VPWR#14	6.94116e-20
C312	CLK#1	a_225_74##9	4.63458e-17
C313	VGND#7	a_757_401##5	1.98095e-17
C314	a_1339_74##13	VPWR#14	8.72798e-18
C315	VGND#6	a_398_74##6	6.80755e-18
C316	VPWR#6	a_398_74##5	1.19103e-19
C317	VGND#7	VGND#6	7.77838e-19
C318	a_595_97##2	SET_B#2	7.90188e-18
C319	a_1339_74##6	a_1339_74##12	3.52862e-19
C320	a_1339_74##18	a_1339_74##12	1.21079e-18
C321	a_1339_74##15	a_1339_74##12	1.11573e-18
C322	a_1339_74##7	VGND#15	1.22819e-17
C323	VPWR#15	a_1339_74##18	2.18738e-17
C324	VPWR#5	a_398_74##7	6.04638e-18
C325	a_757_401##2	a_398_74##6	4.35344e-20
C326	SET_B#8	a_595_97##7	3.93335e-18
C327	VGND#17	a_757_401##5	4.76565e-17
C328	SET_B#14	SET_B#5	1.02091e-17
C329	a_1501_92##3	SET_B#6	4.35984e-17
C330	Q_N#1	SET_B#4	9.59979e-20
C331	VPWR#9	a_225_74##3	7.40426e-18
C332	a_1339_74##6	a_1339_74##13	3.90728e-18
C333	a_757_401##2	a_595_97##4	6.44995e-20
C334	a_1501_92##4	a_1339_74##13	2.36545e-17
C335	a_1501_92##5	SET_B#6	4.68138e-19
C336	VGND#6	SET_B#1	7.07785e-19
C337	a_225_74##11	CLK#2	4.55537e-17
C338	a_2221_74##8	a_1339_74##9	6.72841e-19
C339	VGND#5	a_398_74##6	9.4103e-19
C340	VPWR#15	a_1339_74##12	4.51734e-19
C341	a_1339_74##16	a_1521_508#	2.26551e-18
C342	a_757_401##2	SET_B#2	4.09458e-19
C343	D#3	CLK#1	4.98007e-18
C344	VPWR#14	VPWR#3	5.27679e-20
C345	VPWR#8	a_225_74##4	6.15081e-20
C346	VPWR#14	SET_B#4	2.08806e-18
C347	a_595_97##11	a_225_74##4	1.04839e-18
C348	VGND#6	a_757_401##5	2.209e-17
C349	SET_B#11	SET_B#5	1.83128e-17
C350	SET_B#5	a_1339_74##13	1.44618e-18
C351	a_1501_92##2	a_1339_74##15	9.47444e-18
C352	a_757_401##2	a_595_97#	1.68778e-17
C353	VPWR#8	a_225_74##3	2.49778e-17
C354	VPWR#6	a_225_74##2	5.42958e-17
C355	SET_B#6	VGND#15	1.29838e-17
C356	a_1501_92##4	SET_B#4	1.10058e-18
C357	a_225_74##11	D#1	9.36835e-18
C358	VPWR#6	a_595_97##6	5.82434e-20
C359	VGND#6	a_595_97##4	3.26792e-17
C360	a_1339_74##15	a_1339_74##13	1.26467e-17
C361	VPWR#2	a_2221_74##2	4.5102e-20
C362	VPWR#19	D#1	1.37624e-18
C363	a_595_97##11	a_225_74##3	1.13509e-18
C364	a_1501_92##5	a_1501_92##3	1.14627e-19
C365	a_225_74#	a_1501_92##3	4.14784e-17
C366	VPWR#5	a_225_74##2	5.12142e-19
C367	a_1501_92##2	SET_B#14	1.62215e-17
C368	VPWR#14	a_1501_92#	1.93369e-19
C369	a_27_74##3	VPWR#9	1.81139e-18
C370	a_1501_92##2	SET_B#4	6.21604e-18
C371	VGND#7	a_595_97##2	2.27524e-19
C372	a_1339_74##18	SET_B#4	2.91168e-17
C373	a_1339_74##16	a_1339_74##18	7.13939e-18
C374	Q#1	a_1339_74##2	2.22211e-19
C375	a_757_401#	a_757_401##3	7.27307e-19
C376	a_398_74##8	a_1339_74##13	7.30904e-20
C377	VGND#6	a_595_97##2	2.32301e-18
C378	VGND#5	a_595_97##4	1.12706e-19
C379	a_225_74##13	a_225_74##11	2.78462e-18
C380	a_2221_74##10	a_2221_74##2	2.99579e-20
C381	a_595_97##12	a_757_401##5	1.8826e-18
C382	a_1501_92##2	SET_B#11	3.33266e-17
C383	a_398_74##8	a_1339_74##15	1.55544e-19
C384	SET_B#4	VPWR#15	1.37461e-17
C385	VPWR#7	a_225_74##3	2.68411e-17
C386	VGND#7	SET_B#2	5.16612e-19
C387	VGND#17	VGND#6	3.99003e-19
C388	a_757_401#	a_398_74##2	3.48333e-18
C389	VPWR#8	a_398_74##4	7.82552e-19
C390	SET_B#14	a_1339_74##13	1.03676e-19
C391	VPWR#6	a_595_97##7	4.02315e-18
C392	a_398_74##8	a_1501_92#	1.66555e-17
C393	a_1339_74##18	a_1501_92#	1.15621e-18
C394	a_1339_74##16	VPWR#15	8.54712e-18
C395	CLK	a_225_74##4	8.86421e-19
C396	VGND#8	a_225_74##4	1.24366e-19
C397	a_27_74#	a_225_74##4	1.68724e-17
C398	a_225_74##2	a_1501_92##2	8.79206e-18
C399	a_1339_74##18	VPWR#5	1.65819e-17
C400	a_1339_74##5	a_1339_74##4	2.13742e-18
C401	VGND#4	VGND#1	5.34334e-17
C402	a_1339_74##15	SET_B#4	2.76346e-17
C403	a_398_74##6	a_225_74#	1.67613e-17
C404	a_2221_74##3	a_2221_74##2	3.56321e-18
C405	VGND#12	VGND#1	1.71243e-18
C406	a_225_74##7	a_398_74##2	7.79705e-19
C407	VGND#6	SET_B#2	2.89909e-17
C408	a_1501_92#	VPWR#15	1.24981e-17
C409	a_595_97##12	VGND#17	1.44138e-17
C410	a_27_74##2	VPWR#9	8.69631e-19
C411	a_225_74##2	a_398_74##8	1.97902e-17
C412	VGND#7	a_757_401##2	7.37716e-19
C413	a_1339_74##16	SET_B#4	3.13856e-18
C414	a_398_74##3	a_398_74#	9.06991e-19
C415	VGND#13	VPWR#13	8.63919e-18
C416	a_27_74#	a_225_74##3	1.36818e-18
C417	a_398_74##3	a_225_74##7	3.38712e-17
C418	VGND#4	VGND#12	2.21102e-17
C419	a_398_74##5	a_225_74##2	1.86819e-17
C420	VPWR#3	a_1339_74##3	3.36416e-19
C421	a_398_74##3	a_225_74##8	9.87641e-20
C422	VGND#7	a_595_97#	2.1777e-18
C423	VGND#4	a_2221_74##9	2.08995e-17
C424	VPWR#15	a_398_74##7	2.98912e-18
C425	VPWR#6	SET_B#3	8.12419e-19
C426	VPWR#7	a_595_97##2	1.32658e-19
C427	a_1339_74##16	a_1501_92#	2.9807e-17
C428	a_595_97##4	a_398_74##6	4.08579e-17
C429	a_595_97##6	a_225_74##2	1.07644e-18
C430	a_1339_74##19	a_1501_92##3	3.30687e-18
C431	VPWR#6	a_225_74##3	2.5643e-18
C432	a_1339_74##2	a_2221_74##3	3.08172e-17
C433	SET_B#8	VPWR#4	4.47174e-18
C434	VGND#4	VGND#13	1.0526e-18
C435	VGND#6	a_595_97#	1.26749e-17
C436	VGND#4	SET_B#8	4.56669e-18
C437	SET_B#1	a_225_74##2	1.19799e-18
C438	a_398_74##14	a_225_74##4	5.17431e-18
C439	a_398_74##12	a_398_74##8	3.74595e-18
C440	VPWR#15	a_225_74##2	5.09169e-19
C441	a_2221_74##10	a_1339_74##3	1.30658e-18
C442	SET_B#1	a_595_97##7	1.11674e-17
C443	a_1339_74##16	a_398_74##7	4.25527e-17
C444	VPWR#7	a_595_97##3	7.43002e-19
C445	CLK#2	a_225_74##8	1.39546e-18
C446	a_2221_74##8	VPWR#2	2.17145e-19
C447	VPWR#16	a_1501_92#	1.52002e-19
C448	a_595_97##2	a_225_74##2	3.51138e-19
C449	a_398_74##9	VGND#17	2.25539e-18
C450	a_1339_74##6	a_1339_74##5	3.6052e-17
C451	a_1339_74##19	a_225_74#	3.79965e-17
C452	VPWR#3	a_1339_74##2	1.12152e-18
C453	VGND#7	a_757_401#	3.11109e-18
C454	a_398_74##14	a_225_74##3	2.28768e-17
C455	a_595_97##2	a_595_97##7	2.89589e-19
C456	VPWR#4	a_2221_74##3	3.55419e-18
C457	SET_B#2	a_595_97##4	6.69778e-18
C458	VGND#4	a_1501_92##5	3.03146e-17
C459	a_595_97##3	SET_B#1	2.35502e-18
C460	a_1339_74##6	a_1339_74##4	1.3126e-19
C461	a_595_97##5	a_225_74##2	4.85382e-20
C462	a_2221_74##10	a_1339_74##2	7.44576e-19
C463	a_1339_74##16	a_225_74##2	8.13218e-17
C464	VGND#4	a_2221_74##3	7.20312e-18
C465	D#1	CLK#3	3.9242e-18
C466	VPWR#16	a_1339_74##16	1.34876e-17
C467	VPWR#16	a_398_74##7	8.48937e-20
C468	a_398_74##12	a_398_74##5	1.98211e-17
C469	VGND#4	a_1339_74##6	6.71186e-18
C470	Q	a_2221_74##2	1.61555e-17
C471	a_1339_74##16	VPWR#6	1.54723e-17
C472	a_2221_74##9	VGND#12	6.13703e-17
C473	a_1339_74##19	a_398_74##6	2.56862e-17
C474	VGND#7	a_398_74##2	1.98924e-19
C475	VPWR#7	a_757_401##4	1.59992e-18
C476	Q	a_1339_74##2	3.31477e-19
C477	VGND#9	a_398_74##9	4.04986e-17
C478	VPWR#4	a_1501_92##2	1.92968e-18
C479	a_1339_74##16	a_595_97##7	6.22234e-18
C480	VPWR#18	a_225_74##4	4.19841e-19
C481	a_27_74##2	a_595_97##11	4.5024e-18
C482	a_398_74##13	a_225_74##4	3.61605e-20
C483	a_595_97#	SET_B#2	6.3784e-17
C484	a_1339_74##4	a_1339_74##3	4.65297e-18
C485	VPWR#16	a_225_74##2	3.33409e-18
C486	VPWR#13	a_1339_74##3	8.30524e-18
C487	a_1339_74##15	a_225_74##2	2.24798e-20
C488	a_757_401##3	a_595_97##3	1.07733e-17
C489	VGND#4	a_1501_92##2	1.03002e-17
C490	VPWR#7	a_757_401##3	1.67965e-19
C491	VPWR#4	a_398_74##8	4.30252e-18
C492	VGND#4	a_1339_74##19	9.81915e-18
C493	a_398_74##9	a_595_97##12	1.09886e-17
C494	a_1339_74##16	VPWR#5	2.6152e-17
C495	a_757_401##3	a_757_401##4	1.87166e-18
C496	SET_B#5	a_1339_74##5	2.50315e-17
C497	VPWR#2	a_1339_74##2	6.24038e-20
C498	a_757_401##7	a_225_74##2	1.00283e-18
C499	a_1339_74##19	a_595_97##4	1.06704e-18
C500	VGND#4	a_398_74##8	2.63313e-20
C501	VGND#13	VGND#12	2.23706e-18
C502	VGND#14	VPWR#14	2.90788e-19
C503	SET_B#6	a_1531_118#	7.54996e-18
C504	VPWR#18	a_225_74##3	4.27559e-19
C505	a_595_97##6	a_398_74##12	2.46721e-17
C506	a_1339_74##16	SET_B#3	9.68387e-19
C507	a_2221_74##8	a_2221_74##2	1.70965e-19
C508	D#4	CLK#3	3.11999e-19
C509	a_398_74##9	VGND#7	4.06633e-18
C510	a_1501_92##3	a_1531_118#	5.43875e-18
C511	a_595_97##7	VPWR#16	1.8004e-17
C512	a_398_74##2	a_757_401##4	1.97039e-17
C513	a_27_74##2	a_27_74#	3.80703e-18
C514	a_398_74##2	a_225_74##6	5.59426e-18
C515	a_1339_74##4	Q_N#1	1.22424e-19
C516	a_757_401#	a_595_97#	3.54892e-18
C517	a_2221_74##3	VGND#12	2.79851e-17
C518	a_398_74##13	a_225_74##3	3.7555e-17
C519	a_398_74##9	a_27_74##5	6.81849e-17
C520	SET_B#8	a_1339_74##19	3.52106e-18
C521	a_757_401##7	a_595_97##7	1.49663e-19
C522	a_398_74##3	a_757_401##4	3.52536e-18
C523	a_1339_74##6	SET_B#5	4.47997e-18
C524	Q_N	a_1339_74##5	1.74323e-19
C525	a_27_74##3	a_398_74##14	1.07059e-21
C526	Q_N	a_1339_74##4	1.19917e-17
C527	SET_B#8	a_595_97##6	2.61875e-17
C528	SET_B#3	VPWR#16	1.57522e-17
C529	Q_N	a_1339_74##3	1.98951e-17
C530	VGND#13	a_2221_74##9	5.58768e-17
C531	Q_N	a_1339_74##2	5.26077e-19
C532	a_1339_74##6	a_1501_92##2	1.58846e-19
C533	a_595_97##4	VGND#16	1.74221e-17
C534	a_225_74##11	a_225_74##4	3.69588e-19
C535	a_398_74##12	SET_B#1	5.94509e-18
C536	SET_B#8	SET_B#1	1.18428e-18
C537	a_1339_74##3	Q_N#1	9.7952e-20
C538	a_1339_74##15	SET_B#6	1.33226e-19
C539	a_757_401##7	SET_B#3	8.82224e-18
C540	a_757_401##5	a_398_74##6	4.72952e-19
C541	a_1501_92##3	a_1453_118#	7.48834e-18
C542	a_1501_92##2	SET_B#5	4.22976e-17
C543	a_398_74##8	a_1339_74##6	1.15362e-18
C544	a_1339_74##5	VPWR#14	3.7854e-19
C545	VGND#3	VGND#2	8.31493e-19
C546	a_27_74##2	a_398_74##14	2.74487e-17
C547	a_1501_92#	a_1521_508#	8.32237e-18
C548	SET_B#8	a_595_97##2	8.83886e-18
C549	a_398_74#	a_757_401#	5.3842e-17
C550	VGND#9	a_225_74##5	9.28537e-19
C551	a_398_74##8	SET_B#5	3.25716e-19
C552	a_225_74##5	a_225_74##9	7.73984e-18
C553	a_1501_92##5	a_1501_92##4	1.42554e-18
C554	a_398_74##7	a_1521_508#	8.32237e-18
C555	a_1339_74##15	VPWR#14	1.7048e-18
C556	VGND#9	a_225_74##8	5.97335e-18
C557	a_595_97##6	SET_B#7	3.24533e-17
C558	CLK#1	a_225_74##5	2.17201e-18
C559	a_398_74##8	a_1501_92##2	1.05459e-16
C560	a_27_74##3	a_27_74##2	1.88192e-18
C561	SET_B#2	VGND#16	1.38883e-17
C562	VGND#9	a_225_74##13	1.18645e-17
C563	a_757_401##7	a_595_97##3	2.87362e-17
C564	a_595_97##2	a_398_74##13	4.28395e-18
C565	a_757_401##5	a_595_97##4	8.57784e-19
C566	SET_B#8	a_757_401##3	2.99452e-19
C567	a_1339_74##4	VPWR#14	5.34688e-19
C568	a_1501_92##5	a_1339_74##15	4.35061e-18
C569	VGND#18	a_398_74##9	6.10409e-17
C570	a_225_74##13	a_27_74##5	5.51586e-19
C571	a_595_97##2	a_398_74##12	1.47585e-18
C572	a_225_74##2	a_1258_341#	1.417e-17
C573	VGND#7	a_225_74##8	3.07838e-19
C574	a_595_97##3	VPWR#17	5.27912e-18
C575	VGND#2	Q	1.72834e-17
C576	a_595_97##7	a_1258_341#	1.65317e-17
C577	SET_B#8	a_398_74##2	2.35359e-18
C578	a_27_74##2	VPWR#18	3.45422e-17
C579	a_398_74##13	a_225_74##2	1.14717e-17
C580	D#1	CLK#1	6.5815e-18
C581	a_225_74##7	a_398_74#	1.30378e-17
C582	VPWR#9	a_225_74##9	3.70366e-18
C583	SET_B#10	SET_B#1	1.77809e-17
C584	a_757_401##7	a_757_401##4	3.23591e-19
C585	VPWR	a_225_74##3	2.6884e-17
C586	a_398_74##6	a_1261_74#	1.13155e-17
C587	VPWR#8	a_398_74##2	2.95041e-19
C588	a_595_97##10	a_595_97##2	2.92508e-18
C589	a_1339_74##3	a_1339_74##2	6.50256e-19
C590	a_1339_74##15	a_1501_92##4	9.9573e-17
C591	a_27_74##3	a_225_74##11	4.91399e-17
C592	VGND#9	CLK#2	7.45638e-19
C593	SET_B#7	SET_B#1	1.02013e-17
C594	VGND#8	a_398_74##2	5.60496e-20
C595	a_595_97##6	a_398_74##5	1.86099e-18
C596	a_1501_92##5	a_1339_74##6	9.45118e-17
C597	a_398_74##12	a_225_74##2	2.3599e-17
C598	a_757_401##5	SET_B#2	6.37644e-18
C599	VPWR#8	a_398_74##3	3.5332e-19
C600	a_2221_74##8	Q	1.26734e-18
C601	a_225_74##13	a_398_74##9	2.26895e-18
C602	a_757_401##4	VPWR#17	1.63932e-17
C603	VGND#6	a_398_74##12	9.73902e-17
C604	a_595_97##3	a_225_74##3	1.92106e-17
C605	VGND#9	CLK#3	9.2848e-18
C606	a_1339_74##15	VPWR#5	1.24793e-18
C607	a_1339_74##5	a_1501_92##4	3.17938e-18
C608	a_398_74##13	a_757_401##2	2.81595e-19
C609	a_225_74##7	a_225_74##3	8.01567e-20
C610	VGND#8	a_398_74##3	5.56927e-19
C611	VPWR#9	a_225_74##5	7.95404e-20
C612	a_398_74##12	a_595_97##5	9.15991e-18
C613	VPWR#19	a_225_74##3	7.05568e-20
C614	a_757_401##4	a_706_463#	8.28702e-18
C615	a_398_74##12	a_757_401##2	2.08545e-19
C616	a_595_97##6	SET_B#1	2.46603e-17
C617	SET_B#2	a_1001_74#	8.8457e-18
C618	VPWR#4	VPWR#1	5.47401e-17
C619	a_27_74##2	a_225_74##11	2.76347e-17
C620	VGND#17	SET_B#2	7.42185e-20
C621	a_595_97#	a_1001_74#	8.8457e-18
C622	a_225_74##8	a_225_74##7	3.61622e-18
C623	VGND#3	Q_N	6.91482e-18
C624	a_398_74##13	a_595_97##7	2.04029e-19
C625	a_2221_74##8	a_1339_74##3	1.02997e-18
C626	VGND#14	VGND#13	1.41696e-18
C627	a_757_401##2	a_398_74##5	1.09342e-19
C628	a_595_97##2	SET_B#10	1.42815e-17
C629	VPWR#17	a_225_74##6	1.57374e-19
C630	VPWR#4	Q#1	2.01198e-17
C631	a_595_97##11	a_757_401##4	2.99386e-18
C632	a_225_74##13	VGND#18	5.79429e-17
C633	a_757_401##5	a_595_97#	4.36335e-17
C634	a_595_97##10	a_757_401##2	3.29096e-17
C635	a_1501_92##5	SET_B#5	1.13407e-17
C636	VPWR#9	CLK#1	3.66843e-18
C637	a_27_74##3	VPWR#19	3.72343e-17
C638	a_595_97##2	SET_B#1	5.95722e-17
C639	a_757_401##2	a_595_97##6	2.99687e-18
C640	a_595_97##2	SET_B#7	2.26199e-17
C641	VPWR#17	VPWR#6	8.18861e-20
C642	a_398_74##12	a_595_97##7	4.23177e-17
C643	VGND#5	a_398_74##12	3.73449e-17
C644	Q_N	a_2221_74##8	1.54589e-17
C645	a_398_74##13	a_757_401##3	6.51006e-17
C646	VGND#4	VPWR#1	4.93889e-18
C647	a_225_74##8	a_225_74##4	6.4376e-18
C648	VGND#17	a_595_97#	9.90404e-19
C649	a_27_74##6	a_225_74##4	4.60517e-20
C650	VGND#9	D#2	2.95056e-19
C651	CLK	a_27_74##5	3.55291e-18
C652	a_595_97##2	a_757_401##2	7.81623e-17
C653	a_757_401##3	SET_B#1	2.53026e-19
C654	a_595_97##10	a_225_74##4	1.67427e-19
C655	VGND#8	a_595_97##12	9.10669e-18
C656	VPWR#4	a_2221_74##10	1.78637e-17
C657	a_595_97##11	a_225_74##6	3.08706e-17
C658	VPWR#9	CLK#2	2.30914e-19
C659	VGND#18	CLK	1.89808e-17
C660	VGND#7	a_595_97##10	1.25342e-18
C661	VGND#4	Q#1	1.51368e-18
C662	a_398_74##14	a_757_401##4	3.73209e-20
C663	VGND#19	VGND#18	1.29568e-18
C664	CLK#3	a_225_74##8	3.87359e-17
C665	a_595_97##2	a_757_401##3	8.34062e-17
C666	a_757_401##5	a_757_401#	2.90162e-18
C667	SET_B#8	a_1258_341#	7.42946e-19
C668	a_757_401##4	a_225_74##3	1.75039e-17
C669	a_1501_92##2	a_1501_92##5	3.16671e-18
C670	a_398_74##13	SET_B#3	9.43956e-18
C671	a_757_401#	a_731_97#	8.8457e-18
C672	a_398_74#	a_731_97#	8.8457e-18
C673	a_757_401##2	a_757_401##3	3.45242e-18
C674	a_398_74##2	a_595_97##2	3.45164e-17
C675	a_2221_74##8	a_1339_74##2	6.57231e-17
C676	VGND#4	VPWR#12	3.24529e-18
C677	Q	VGND#1	7.41427e-17
C678	a_1501_92##2	VGND#15	8.9625e-19
C679	Q	Q#2	2.42853e-19
C680	VGND#8	a_398_74##9	4.64633e-17
C681	VPWR	VPWR#9	1.02334e-16
C682	VGND#12	Q	6.14437e-17
C683	a_398_74##2	a_757_401##2	1.02908e-17
C684	VPWR	VPWR#7	7.6989e-17
C685	a_595_97##2	a_398_74##3	6.09627e-20
C686	Q_N#1	VPWR#4	2.78056e-17
C687	a_595_97##11	a_398_74##4	2.62832e-17
C688	VPWR#9	D#3	5.132e-19
C689	a_398_74##12	SET_B#3	1.8097e-17
C690	VPWR	VPWR#6	1.23499e-16
C691	a_2221_74##9	Q	2.60913e-18
C692	a_1339_74##15	VPWR#15	1.91181e-17
C693	VGND#17	a_757_401#	3.14453e-17
C694	a_398_74##14	a_225_74##6	1.78041e-19
C695	a_398_74##9	a_27_74##2	9.54954e-19
C696	a_398_74##2	a_757_401##3	1.81975e-17
C697	a_398_74##13	a_398_74##2	4.27144e-20
C698	VGND#19	a_225_74##13	4.3191e-17
C699	SET_B#10	a_225_74##2	1.54557e-18
C700	a_595_97##12	a_595_97#	1.72618e-19
C701	VPWR#4	VPWR#14	1.68933e-17
C702	a_27_74#	a_398_74##4	8.16423e-18
C703	a_757_401##5	a_398_74#	6.81797e-19
C704	VGND#4	VPWR#13	2.93126e-18
C705	a_398_74##3	a_757_401##3	1.41144e-18
C706	D#2	CLK#3	3.19328e-18
C707	a_398_74##8	a_1501_92##5	9.3338e-19
C708	a_398_74##3	a_398_74##2	5.08775e-19
C709	a_1501_92##5	SET_B#11	3.38065e-17
C710	a_1501_92##4	VPWR#4	3.00273e-17
C711	a_757_401##3	SET_B#10	5.96924e-18
C712	SET_B#7	a_225_74##2	3.02693e-19
C713	a_1339_74##19	a_1501_92##2	1.43986e-18
C714	a_398_74##13	a_595_97##3	1.24223e-17
C715	a_398_74##14	a_398_74##4	4.59653e-18
C716	VPWR	a_398_74##13	7.06354e-17
C717	VGND	a_225_74##4	3.62975e-18
C718	VPWR	a_398_74##12	1.11993e-17
C719	a_595_97##10	a_398_74##2	7.90164e-17
C720	VGND#17	a_398_74#	3.36648e-18
C721	Q_N	a_2221_74##9	9.47619e-19
C722	VPWR#4	a_1339_74##18	1.69272e-17
C723	Q_N	VGND#13	6.60194e-17
C724	VGND#2	VGND#1	9.1825e-19
C725	a_27_74#	a_225_74##9	1.40919e-18
C726	Q_N	Q_N#2	2.78058e-18
C727	a_27_74##4	a_225_74##13	2.59987e-18
C728	VPWR	SET_B#10	2.64488e-18
C729	VGND#14	Q_N	4.74443e-17
C730	a_398_74##12	a_595_97##3	1.04311e-18
C731	a_595_97##12	a_757_401#	2.87815e-18
C732	a_27_74#	a_595_97##11	3.30612e-17
C733	CLK	a_225_74##11	1.06127e-17
C734	a_1501_92##5	Q_N	4.72134e-17
C735	a_2221_74##2	Q#2	1.71222e-19
C736	a_225_74##3	a_225_74##6	7.07219e-19
C737	a_1501_92##5	VGND#14	4.42164e-17
C738	Q	Q#1	3.04969e-18
C739	VPWR	a_27_74##3	1.09077e-17
C740	a_398_74##3	a_398_74##13	8.88838e-19
C741	SET_B#10	a_595_97##7	3.49247e-18
C742	a_398_74##9	a_595_97#	7.60976e-19
C743	VPWR	a_27_74##2	6.79395e-18
C744	a_595_97##5	a_398_74##5	2.50828e-17
C745	a_225_74##9	a_398_74##14	2.55856e-17
C746	a_1501_92##2	a_1531_118#	2.32801e-18
C747	CLK#2	a_225_74##5	3.98884e-17
C748	a_1339_74##19	a_398_74##8	8.0803e-17
C749	VPWR	D#7	4.23002e-18
C750	a_595_97##10	a_398_74##13	7.27771e-19
C751	a_27_74#	CLK#1	2.09305e-19
C752	a_225_74##5	D#1	1.90557e-19
C753	VGND#17	a_225_74##7	5.97395e-19
C754	VPWR#18	a_225_74##9	4.01487e-17
C755	SET_B#7	a_595_97##7	2.87117e-18
C756	a_757_401##5	a_225_74##3	5.19243e-20
C757	a_398_74##12	a_1501_92##3	3.01266e-19
C758	a_398_74##13	a_757_401##4	2.93189e-17
C759	a_27_74##4	VGND#19	3.76178e-17
C760	D#1	CLK#2	1.16207e-17
C761	a_595_97##12	a_398_74#	3.15677e-17
C762	a_1339_74##2	a_2221_74##5	8.04123e-19
C763	a_595_97##10	a_398_74##3	8.51498e-17
C764	VPWR#4	a_1339_74##16	4.68587e-17
C765	a_398_74##14	CLK#1	1.55311e-18
C766	a_225_74##11	a_225_74##9	7.98959e-19
C767	a_398_74##9	a_757_401#	3.62211e-19
C768	Q_N	a_2221_74##10	2.54274e-18
C769	D#7	a_225_74##11	3.63396e-17
C770	Q_N	VPWR#13	3.5129e-17
C771	VGND	VGND#9	9.5075e-17
C772	VGND	VGND#7	8.25544e-17
C773	Q_N	Q_N#1	1.39364e-18
C774	VGND	VGND#6	1.43801e-16
C775	a_1501_92##4	Q_N	2.19161e-17
C776	a_2221_74##2	VNB	3.88128e-17
C777	VPWR#18	CLK#1	3.6275e-17
C778	a_1339_74##5	VNB	6.69809e-17
C779	a_1339_74##4	VNB	2.43759e-17
C780	a_398_74##14	a_27_74#	7.54076e-17
C781	CLK	a_225_74##8	2.33222e-18
C782	a_1339_74##3	VNB	5.72968e-17
C783	a_1339_74##19	a_398_74##5	7.17822e-18
C784	a_1339_74##2	VNB	4.274e-17
C785	VGND#5	a_1339_74##5	8.42763e-20
C786	a_225_74##4	VNB	7.3655e-17
C787	a_225_74##3	VNB	1.84359e-16
C788	a_595_97##5	VNB	1.96139e-17
C789	a_225_74##4	a_398_74##4	1.97068e-17
C790	a_2221_74##3	Q#1	1.66858e-17
C791	VPWR#9	a_398_74##14	3.84455e-17
C792	Q	a_2221_74#	2.48934e-17
C793	VGND#17	a_225_74##8	4.38922e-20
C794	Q	a_2221_74##5	2.43594e-17
C795	VGND#3	VGND#12	3.38007e-19
C796	VGND#9	a_225_74##4	2.17292e-19
C797	Q	a_1339_74##8	1.08769e-18
C798	VGND#4	a_1339_74##16	2.09056e-18
C799	a_398_74##14	D#3	1.00878e-18
C800	a_225_74##11	CLK#1	3.11351e-17
C801	a_225_74##7	a_595_97##12	1.72267e-17
C802	a_595_97##7	a_225_74#	5.97592e-19
C803	a_2221_74##3	VPWR#12	3.36145e-17
C804	a_27_74##6	a_225_74##9	3.65752e-20
C805	a_27_74##3	D#7	6.01087e-17
C806	a_225_74##3	a_398_74##4	1.72531e-17
C807	a_398_74##12	a_225_74#	1.88977e-17
C808	a_398_74##13	a_225_74##6	1.31057e-17
C809	a_1339_74##19	a_1339_74##16	1.69799e-18
C810	a_398_74##9	a_398_74#	2.29655e-18
C811	a_595_97##10	a_757_401##4	2.6657e-19
C812	a_595_97##6	a_595_97##5	9.65831e-18
C813	VPWR#18	D#3	3.74874e-18
C814	VGND	a_398_74##12	1.84819e-17
C815	VGND#4	VGND#6	2.40517e-17
C816	a_1501_92##5	VGND#15	5.3617e-18
C817	VPWR#19	CLK#1	6.83115e-18
C818	VGND	a_595_97##10	7.82167e-18
C819	a_2221_74##10	a_2221_74##3	4.64998e-20
C820	VGND	SET_B#7	2.13833e-18
C821	Q_N	a_1339_74##8	1.644e-19
C822	a_225_74##7	a_27_74##5	2.42448e-17
C823	Q_N	a_1339_74##9	3.02271e-17
C824	Q_N	a_1339_74##11	1.42462e-17
C825	VPWR	a_757_401##7	8.96296e-18
C826	SET_B#8	a_1339_74##16	1.52576e-17
C827	a_2221_74##6	a_2221_74##4	4.66375e-17
C828	VGND#4	VGND#5	1.59283e-16
C829	a_27_74##4	a_27_74##3	2.27069e-19
C830	VPWR	VPWR#17	1.61161e-17
C831	Q_N	a_1339_74##7	3.91197e-19
C832	D#6	a_225_74##11	1.47996e-17
C833	a_27_74##6	CLK#1	3.14669e-20
C834	VPWR	a_595_97##11	1.03141e-17
C835	VGND#9	VNB	4.35815e-17
C836	VPWR	a_27_74#	1.11174e-17
C837	VGND#7	VNB	3.87096e-17
C838	VGND#6	VNB	7.59983e-17
C839	VPWR	a_398_74##14	3.07346e-17
C840	VGND#5	VNB	7.73458e-17
C841	VGND#3	VNB	3.13388e-17
C842	VGND	D#4	4.53551e-18
C843	VGND#2	VNB	3.77923e-17
C844	VPWR	a_225_74##11	5.61674e-18
C845	VPWR#9	VNB	4.35374e-17
C846	VGND#4	VGND#3	7.04937e-17
C847	VPWR#18	a_398_74##14	4.13558e-17
C848	VPWR#7	VNB	3.12325e-17
C849	VPWR#19	D#3	3.00569e-17
C850	VPWR#6	VNB	5.37602e-17
C851	VPWR	a_27_74##6	1.66012e-17
C852	VPWR#5	VNB	5.93741e-17
C853	a_398_74##9	a_225_74##7	2.62227e-17
C854	VPWR#3	VNB	3.24124e-17
C855	VPWR#2	VNB	3.78905e-17
C856	a_595_97##6	VGND#16	1.58075e-19
C857	VGND#3	a_2221_74##9	7.76094e-18
C858	a_1339_74##15	VNB	1.67445e-17
C859	a_398_74##12	a_398_74##6	2.58645e-17
C860	SET_B#8	VPWR#16	7.59109e-18
C861	SET_B#14	VNB	1.82619e-18
C862	VGND#4	VGND#2	7.3001e-17
C863	a_398_74##13	a_398_74##4	1.95163e-18
C864	a_595_97##10	a_225_74##6	4.38486e-19
C865	SET_B#11	VNB	9.04956e-19
C866	VGND	a_757_401##5	2.2162e-17
C867	a_27_74##6	D#3	1.217e-17
C868	a_27_74##5	a_225_74##8	2.53495e-18
C869	a_27_74##2	a_398_74##3	6.4888e-17
C870	a_398_74##13	VNB	2.69556e-17
C871	a_398_74##12	VNB	2.34393e-17
C872	VGND	a_595_97##12	1.31346e-17
C873	VGND	a_27_74##5	8.49906e-18
C874	a_225_74##9	a_225_74##4	3.07864e-17
C875	a_595_97##10	VNB	8.32214e-18
C876	VGND	a_398_74##9	4.28483e-17
C877	Q_N	a_1339_74#	4.27784e-19
C878	VGND	a_225_74##13	2.26709e-17
C879	Q_N	a_1339_74##10	1.06402e-17
C880	VGND#18	a_225_74##7	1.10015e-19
C881	a_1339_74#	a_2221_74##6	3.32313e-17
C882	VGND	a_27_74##4	1.65747e-17
C883	VPWR	a_757_401#	4.59254e-19
C884	Q_N	a_1339_74##12	8.52666e-18
C885	a_225_74##4	a_225_74##3	9.51193e-20
C886	SET_B#8	VGND#6	1.33496e-17
C887	Q_N	a_1339_74##13	5.05864e-19
C888	a_398_74##13	VPWR#7	4.55675e-17
C889	a_27_74##3	VNB	6.00031e-17
C890	VPWR#4	VPWR#6	2.31093e-17
C891	VPWR#15	SET_B#6	3.04114e-19
C892	D#7	VNB	3.99725e-18
C893	a_225_74##9	a_225_74##3	1.103e-17
C894	VGND#2	a_2221_74##2	5.87174e-20
C895	D#6	VNB	5.24283e-19
C896	D#4	VNB	1.83719e-18
C897	a_225_74##8	a_398_74##9	1.64158e-17
C898	VGND#1	VNB	6.84278e-17
C899	VGND#12	VNB	6.5072e-18
C900	SET_B#1	a_595_97##5	5.76638e-19
C901	a_2221_74##9	VNB	1.28352e-17
C902	VGND#13	VNB	9.80031e-18
C903	VGND#14	VNB	6.02969e-18
C904	a_1339_74##6	VPWR#14	1.82032e-19
C905	VPWR#4	VPWR#5	1.13931e-16
C906	a_1501_92##5	VNB	1.3891e-17
C907	a_1339_74##10	a_2221_74##6	2.65702e-19
C908	a_1339_74##19	VNB	1.13642e-18
C909	VGND#2	a_2221_74##9	9.96647e-18
C910	VGND#4	Q	1.91481e-17
C911	a_27_74##5	CLK#3	6.35252e-20
C912	a_757_401##5	VNB	1.36423e-17
C913	VGND	a_225_74##11	2.31809e-18
C914	VGND#17	VNB	1.36715e-18
C915	a_27_74##3	D#6	9.44792e-18
C916	a_595_97##12	VNB	2.42509e-18
C917	VPWR	a_225_74##2	6.38565e-18
C918	Q#1	VPWR#1	1.08097e-16
C919	a_225_74##11	VPWR#18	2.22986e-19
C920	a_27_74##5	VNB	6.81118e-18
C921	a_398_74##9	VNB	1.89001e-17
C922	VPWR	a_595_97##7	3.98752e-18
C923	a_1339_74##6	a_1501_92##4	8.02691e-18
C924	VGND#18	VNB	9.01598e-19
C925	a_225_74##13	VNB	1.81695e-17
C926	VPWR#4	VPWR#3	7.70439e-17
C927	VGND#19	VNB	2.35534e-18
C928	a_2221_74##3	Q	3.38242e-17
C929	VGND#18	a_225_74##8	4.4104e-17
C930	a_398_74##12	a_595_97##4	1.36942e-17
C931	a_27_74##4	VNB	5.29201e-17
C932	a_225_74##5	a_27_74##2	8.86787e-17
C933	VPWR#1	VNB	7.99315e-17
C934	Q#1	VNB	7.78173e-18
C935	VPWR	a_757_401##4	2.84966e-18
C936	a_398_74##13	a_225_74##9	9.94106e-20
C937	VPWR#12	VNB	3.37939e-18
C938	a_2221_74##10	VNB	1.44027e-17
C939	a_1339_74##5	a_1339_74##11	2.45805e-19
C940	VGND#4	Q_N	2.51375e-17
C941	VPWR#13	VNB	1.4549e-17
C942	Q_N#1	VNB	2.57657e-18
C943	VPWR	a_398_74##4	1.52009e-20
C944	a_1339_74##10	a_1339_74#	6.30771e-18
C945	VPWR#14	VNB	7.81376e-18
C946	a_1501_92##4	VNB	1.29082e-17
C947	VPWR	a_225_74##9	3.37269e-18
C948	a_1501_92##5	a_1339_74##12	1.70832e-18
C949	a_1339_74##9	a_1339_74##2	3.01423e-19
C950	VGND	a_595_97##4	2.59766e-18
C951	a_1339_74##18	VNB	8.3865e-18
C952	VPWR#15	VNB	3.03865e-18
C953	VGND	SET_B#2	1.0333e-18
C954	VPWR	CLK#1	4.97433e-18
C955	VGND	a_595_97#	1.3452e-18
C956	a_1339_74##16	VNB	9.16922e-18
C957	VPWR	D#3	2.0336e-18
C958	VGND	a_757_401#	4.09652e-18
C959	VPWR#16	VNB	5.95179e-18
C960	VGND	a_398_74#	1.05607e-17
C961	CLK	a_225_74##5	4.60162e-17
C962	VPWR#4	VPWR#2	8.5634e-17
C963	a_398_74##9	CLK#3	4.94284e-19
C964	a_757_401##7	VNB	3.56442e-18
C965	VGND	a_225_74##7	1.09415e-18
C966	VPWR#17	VNB	1.78245e-18
C967	VGND	a_225_74##8	4.2481e-18
C968	CLK	CLK#2	5.71581e-18
C969	a_595_97##11	VNB	5.7596e-18
C970	VGND	CLK#3	1.35769e-18
C971	a_398_74##13	VPWR#6	3.88131e-17
C972	a_27_74#	VNB	2.22527e-18
C973	VGND	D#2	2.82843e-18
C974	a_398_74##14	VNB	1.03518e-17
C975	VPWR#18	VNB	2.29586e-19
C976	a_225_74##11	VNB	8.58185e-18
C977	SET_B#8	VPWR	2.28325e-17
C978	VPWR#19	VNB	6.52887e-18
C979	a_225_74##13	a_225_74##8	1.66843e-18
C980	a_27_74##6	VNB	2.40398e-17
C981	VPWR	VPWR#8	6.78272e-17
C982	a_2221_74#	VNB	3.28933e-17
C983	VPWR#19	VPWR#18	1.37998e-17
C984	a_2221_74##5	VNB	2.96138e-17
C985	a_27_74##6	a_398_74##14	1.6803e-22
C986	a_1339_74##8	VNB	3.4622e-17
C987	a_1339_74##9	VNB	3.27363e-17
C988	a_1339_74##11	VNB	3.63295e-17
C989	a_1339_74##7	VNB	3.62517e-17
C990	SET_B#6	VNB	3.29806e-17
C991	a_1501_92##3	VNB	2.47939e-17
C992	VPWR#12	VPWR#1	7.03824e-19
C993	a_225_74#	VNB	4.65403e-17
C994	a_398_74##6	VNB	3.04076e-17
C995	a_595_97##4	VNB	2.12773e-17
C996	SET_B#2	VNB	3.74938e-17
C997	a_595_97#	VNB	3.65786e-17
C998	a_757_401#	VNB	3.54947e-17
C999	VPWR	a_398_74##5	4.39291e-19
C1000	CLK#3	VGND#18	1.52573e-17
C1001	a_398_74#	VNB	3.32718e-17
C1002	a_225_74##7	VNB	4.65801e-17
C1003	VPWR	a_595_97##6	9.57524e-19
C1004	a_27_74##3	CLK#2	4.64313e-19
C1005	a_225_74##8	VNB	3.12901e-17
C1006	CLK#3	VNB	3.43467e-17
C1007	D#2	VNB	2.87361e-17
C1008	VPWR	a_595_97##2	8.19566e-18
C1009	a_2221_74##4	VNB	4.18093e-17
C1010	a_757_401##5	a_595_97##2	1.85474e-17
C1011	a_2221_74##6	VNB	3.65497e-17
C1012	a_595_97##2	a_225_74##3	2.15437e-18
C1013	a_1339_74#	VNB	4.53244e-17
C1014	SET_B#10	a_398_74##13	2.88195e-18
C1015	a_1339_74##10	VNB	3.55116e-17
C1016	VPWR	a_757_401##3	4.20608e-18
C1017	VGND#19	a_225_74##8	1.82877e-19
C1018	a_1339_74##12	VNB	3.77631e-17
C1019	a_1339_74##13	VNB	3.21011e-17
C1020	VPWR	a_398_74##2	3.79415e-19
C1021	a_1339_74##12	a_1339_74##10	4.72424e-17
C1022	SET_B#4	VNB	5.49009e-17
C1023	a_1501_92#	VNB	3.51695e-17
C1024	VPWR	a_398_74##3	5.56008e-18
C1025	a_1501_92##5	a_1339_74##13	8.41769e-19
C1026	VGND	SET_B#8	2.13038e-17
C1027	a_398_74##7	VNB	2.05108e-17
C1028	a_398_74##12	SET_B#2	1.48332e-18
C1029	a_225_74##2	VNB	1.4459e-16
C1030	VPWR	a_225_74##5	3.85067e-18
C1031	a_595_97##7	VNB	4.49533e-17
C1032	VGND	VGND#8	6.33169e-17
C1033	SET_B#3	VNB	2.66452e-17
C1034	VPWR	CLK#2	1.67712e-18
C1035	a_595_97##3	VNB	2.42152e-17
C1036	a_757_401##4	VNB	3.36225e-17
C1037	a_595_97##2	a_595_97##5	1.49067e-19
C1038	VPWR#19	VPWR#9	3.69177e-19
C1039	a_225_74##6	VNB	2.35677e-17
C1040	VPWR#15	SET_B#5	2.55915e-19
C1041	a_398_74##4	VNB	2.93095e-17
C1042	a_225_74##9	VNB	3.28241e-17
C1043	a_757_401#	a_757_401##4	5.63462e-19
C1044	CLK#1	VNB	4.37548e-17
C1045	VPWR#4	a_2221_74##8	1.59694e-18
C1046	a_225_74##13	CLK#3	5.50229e-17
C1047	D#3	VNB	4.61034e-17
C1048	VGND	a_595_97##6	5.24768e-18
C1049	VPWR#4	VNB	3.27268e-16
C1050	VGND#4	VNB	3.05363e-16
C1051	VGND	a_595_97##2	1.03479e-17
C1052	SET_B#8	VNB	8.87936e-18
C1053	VGND	a_757_401##2	2.04687e-18
C1054	VPWR#8	VNB	2.90621e-17
C1055	VPWR#12	Q#1	8.43797e-17
C1056	VGND#8	VNB	3.72475e-17
C1057	a_398_74##14	VPWR#8	3.02975e-17
C1058	a_2221_74##3	VNB	3.38265e-17
C1059	VGND	a_398_74##2	3.31114e-18
C1060	a_1339_74##6	VNB	1.02141e-17
C1061	VGND	a_398_74##3	5.0199e-18
C1062	SET_B#5	VNB	5.50188e-17
C1063	a_1501_92##2	VNB	5.31156e-17
C1064	VGND	a_225_74##5	6.87642e-18
C1065	a_398_74##8	VNB	3.41668e-17
C1066	VGND	CLK#2	3.65271e-18
C1067	a_398_74##5	VNB	2.0711e-17
C1068	VGND	D#1	8.72319e-19
C1069	a_595_97##6	VNB	4.29606e-17
C1070	VGND#3	a_1339_74##3	1.52062e-19
C1071	VGND#18	D#2	5.63076e-19
C1072	SET_B#1	VNB	5.65794e-17
C1073	a_398_74##12	VPWR#6	3.82655e-18
C1074	a_595_97##2	VNB	5.63898e-17
C1075	a_757_401##2	VNB	4.63777e-17
C1076	a_757_401##3	VNB	4.81885e-17
C1077	a_398_74##2	VNB	5.97559e-17
C1078	a_398_74##3	VNB	4.56422e-17
C1079	a_225_74##5	VNB	3.72567e-17
C1080	VGND#5	VGND#14	7.91828e-18
C1081	a_27_74##2	a_757_401##4	3.23545e-19
C1082	CLK#2	VNB	3.5912e-17
C1083	D#1	VNB	1.09185e-16
C1084	VGND#4	a_2221_74#	4.34187e-18
C1085	a_757_401##5	a_757_401##2	5.29669e-18
C1086	SET_B#8	VPWR#6	4.87054e-18
C1087	VGND#19	CLK#3	1.2532e-18
C1088	a_27_74##3	D#1	3.05004e-17
C1089	VGND#2	a_2221_74#	2.04961e-18
C1090	a_1339_74##13	a_1339_74##12	1.71296e-17
C1091	VPWR	CLK	1.45115e-18
C1092	VGND#17	a_757_401##2	1.5552e-18
C1093	SET_B#10	a_398_74##12	3.36952e-17
C1094	a_27_74##2	D#1	1.18822e-18
C1095	VGND	CLK	1.4839e-18
C1096	a_225_74##13	D#2	1.25232e-18
C1097	VGND#4	a_2221_74##5	1.42178e-18
C1098	Q	VNB	1.2883e-17
C1099	a_398_74##12	a_595_97#	4.11098e-19
C1100	a_2221_74##10	Q#1	5.19839e-19
C1101	Q_N	VNB	3.31175e-18
C1102	D#7	CLK#2	7.44424e-20
C1103	VPWR	VNB	2.81036e-16
C1104	VGND	VNB	3.13664e-16
C1105	a_27_74##4	CLK#3	1.65806e-19
C1106	VPWR#10	a_225_74##3	5.11327e-20
C1107	SET_B	VPWR#15	2.55895e-18
C1108	SET_B	a_225_74##2	1.53337e-18
C1109	a_27_74##6	VPWR#10	1.76169e-17
C1110	VPWR#10	VPWR#9	1.34865e-18
C1111	SET_B	a_1339_74##19	9.63638e-19
C1112	SET_B	VPWR#5	4.73811e-18
C1113	SET_B	SET_B#6	5.95506e-19
C1114	VPWR#10	D#3	5.29625e-18
C1115	SET_B	VGND#5	9.13032e-18
C1116	SET_B	a_398_74##8	3.59813e-17
C1117	SET_B	VPWR#6	4.98374e-19
C1118	VGND#4	SET_B	2.70208e-17
C1119	SET_B	VNB	5.09632e-18
C1120	SET_B	VGND#6	4.61061e-19
C1121	SET_B	a_1501_92##2	3.65036e-17
C1122	SET_B	SET_B#14	2.47199e-17
C1123	VGND#10	VNB	5.21649e-17
C1124	VGND#10	a_27_74##4	1.75155e-17
C1125	SET_B	VPWR#4	2.80054e-17
C1126	VGND#10	D#2	8.42255e-18
C1127	SET_B	SET_B#5	7.12837e-19
C1128	SET_B	a_398_74##12	1.63775e-18
C1129	VGND	VGND#10	9.70846e-17
C1130	VPWR	VPWR#10	1.03226e-16
C1131	VGND#10	CLK#3	1.11921e-18
C1132	SET_B	a_1339_74##6	6.70532e-18
C1133	SET_B	a_1339_74##15	1.56724e-17
C1134	SET_B	a_1501_92##5	2.63563e-18
C1135	SET_B	a_1339_74##16	3.66036e-17
C1136	VGND#10	a_225_74##13	1.22026e-17
C1137	VGND#10	VGND#9	1.00735e-18
C1138	VPWR#10	VNB	4.99906e-17
C1139	VGND#10	a_225_74##8	2.24031e-19
C1140	SET_B	Q_N	1.80141e-18
C1141	a_27_74##3	VPWR#10	3.36789e-18
C1142	VGND#10	VGND#18	8.96175e-19
*
*
.ENDS sky130_fd_sc_hs__dfsbp_2
*
