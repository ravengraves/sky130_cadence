* Extracted by Quantus, converted by sky130cad/quantus.py
*
*
*
*                       LINUX           Wed Nov 18 08:09:29 2026
*
*
*
*  PROGRAM  advgen
*
*  Name           : advgen - Quantus - (64-bit)
*  Version        : 25.1.0-p047
*  Build Date     : Thu Dec 11 23:20:30 PST 2025
*
*  HSPICE LIBRARY
*
*  OPERATING_TEMPERATURE 150
*  QRC_TECH_DIR <path>/tech
*
*
*

*
.SUBCKT sky130_fd_sc_hs__a22oi_2 VPB VNB VGND VPWR Y B1 A1 A2 B2
*
*
*  caps2d version: 10
*
*
*       TRANSISTOR CARDS
*
*
XM12 a_148_74##2 A1#3 Y#9 VNB sky130_fd_pr__nfet_01v8_lvt l=0.15 w=0.74 ad=0.2072 as=0.1961 pd=2.04 ps=2.01
XM3 a_148_74##2 A2#5 VGND#7 VNB sky130_fd_pr__nfet_01v8_lvt l=0.15 w=0.74 ad=0.2072 as=0.259 pd=2.04 ps=2.18
XM14 VGND#7 A2#1 a_148_74# VNB sky130_fd_pr__nfet_01v8_lvt l=0.15 w=0.74 ad=0.259 as=0.2072 pd=2.18 ps=2.04
XM13 Y#5 A1#6 a_148_74# VNB sky130_fd_pr__nfet_01v8_lvt l=0.15 w=0.74 ad=0.3996 as=0.2072 pd=2.56 ps=2.04
XM6 a_558_74##2 B1#3 Y#5 VNB sky130_fd_pr__nfet_01v8_lvt l=0.15 w=0.74 ad=0.2886 as=0.3996 pd=2.26 ps=2.56
XM7 VGND#6 B2#5 a_558_74##2 VNB sky130_fd_pr__nfet_01v8_lvt l=0.15 w=0.74 ad=0.2072 as=0.2886 pd=2.04 ps=2.26
XM2 a_558_74# B2#3 VGND#6 VNB sky130_fd_pr__nfet_01v8_lvt l=0.15 w=0.74 ad=0.2072 as=0.2072 pd=2.04 ps=2.04
XM1 Y#1 B1#6 a_558_74# VNB sky130_fd_pr__nfet_01v8_lvt l=0.15 w=0.74 ad=0.1961 as=0.2072 pd=2.01 ps=2.04
XM4 a_66_368##7 A1#1 VPWR#6 VPB sky130_fd_pr__pfet_01v8 l=0.15 w=1.12 ad=0.308 as=0.336 pd=2.79 ps=2.84
XM5 a_66_368##9 A2#6 VPWR#6 VPB sky130_fd_pr__pfet_01v8 l=0.15 w=1.12 ad=0.336 as=0.336 pd=2.84 ps=2.84
XM11 VPWR#5 A2#4 a_66_368##9 VPB sky130_fd_pr__pfet_01v8 l=0.15 w=1.12 ad=0.6832 as=0.336 pd=3.46 ps=2.84
XM9 VPWR#5 A1#4 a_66_368##3 VPB sky130_fd_pr__pfet_01v8 l=0.15 w=1.12 ad=0.6832 as=0.336 pd=3.46 ps=2.84
XM10 Y#8 B1#1 a_66_368##3 VPB sky130_fd_pr__pfet_01v8 l=0.15 w=1.12 ad=0.3696 as=0.336 pd=2.9 ps=2.84
XM15 a_66_368##5 B2#6 Y#8 VPB sky130_fd_pr__pfet_01v8 l=0.15 w=1.12 ad=0.336 as=0.3696 pd=2.84 ps=2.9
XM8 Y#7 B2#1 a_66_368##5 VPB sky130_fd_pr__pfet_01v8 l=0.15 w=1.12 ad=0.336 as=0.336 pd=2.84 ps=2.84
XM0 a_66_368# B1#4 Y#7 VPB sky130_fd_pr__pfet_01v8 l=0.15 w=1.12 ad=0.308 as=0.336 pd=2.79 ps=2.84
*
*
*       RESISTOR AND CAP/DIODE CARDS
*
Rg1	A1#1	A1#2	434.639221
Rg2	A1#2	A1#3	382.539734
Rg3	A2#1	A2#2	397.555725
Rg4	A2#2	A2#3	54.221630
Rg5	A2#2	A2#4	449.655212
Rg6	A2#3	A2#5	401.056915
Rg7	A2#3	A2#6	447.848328
Rg8	A1#4	A1#5	476.133820
Rg9	A1#5	A1#6	400.258301
Rg10	B1#1	B1#2	492.059540
Rg11	B1#2	B1#3	307.937683
Rg12	B2#1	B2#2	451.603058
Rg13	B2#2	B2#3	410.796234
Rg14	B2#2	B2#4	41.441631
Rg15	B2#4	B2#5	397.555725
Rg16	B2#4	B2#6	449.655212
Rg17	B1#4	B1#5	456.846832
Rg18	B1#5	B1#6	353.846649
Rf1	A2	A2#3	165.527542
Rf2	a_148_74#	a_148_74##2	104.479324
Rf3	A1#5	A1	288.140137
Rf4	A1	A1#8	4.298599
Rf5	A1#8	A1	13.585999
Rf6	B2#2	B2	166.137894
Rf7	a_558_74#	a_558_74##2	89.100418
Rf8	B1#5	B1	244.821808
Rf9	B1#2	B1	169.253845
Rf10	a_66_368#	a_66_368##2	81.592201
Rf11	a_66_368##2	a_66_368##4	81.054619
Rf12	a_66_368##2	a_66_368##5	19.527714
Rf13	a_66_368##4	a_66_368##6	86.158577
Rf14	a_66_368##6	a_66_368##8	67.809097
Rf15	a_66_368##6	a_66_368##9	12.835279
Rf16	a_66_368##3	a_66_368##4	5.000000
Rf17	a_66_368##7	a_66_368##8	5.000000
Rf18	Y#1	Y#2	134.389023
Rf19	Y#2	Y#3	61.458511
Rf20	Y#3	Y#4	94.641670
Rf21	Y#4	Y	7.066643
Rf22	Y	Y#6	4.795412
Rf23	Y#2	Y#7	21.914129
Rf24	Y#3	Y#8	22.807920
Rf25	Y#4	Y#9	148.368774
Rf26	Y#5	Y#6	7.500000
Rf28	VGND#2	VGND#3	78.139503
Rf29	VGND#3	VGND#4	79.600510
Rf31	VGND#2	VGND#6	31.161278
Rf32	VGND#4	VGND#7	31.161278
Rf33	VPWR#1	VPWR#2	32.089069
Rf34	VPWR#2	VPWR#3	79.969955
Rf36	VPWR#2	VPWR#5	25.803661
Rf37	VPWR#3	VPWR#6	37.538910
Rf40	A1#2	A1#8	160.232803
Re1	VPWR#1	VPWR	0.982218
Re2	VGND	VGND#3	0.982254
*
*       CAPACITOR CARDS
*
*
C1	Y#1	Y#2	2.3675e-18
C2	VPWR#1	B2#4	2.87681e-20
C3	a_66_368##3	VPWR#2	7.10332e-17
C4	VPWR#2	VPWR#5	1.99734e-17
C5	B2#4	a_66_368##5	1.47285e-18
C6	Y#2	a_66_368#	3.99476e-17
C7	Y#2	Y#7	2.6903e-18
C8	a_558_74#	Y#1	4.91087e-17
C9	Y#3	a_66_368##5	1.45441e-17
C10	VPWR#6	VPWR#2	2.1503e-18
C11	Y#2	a_66_368##5	1.51198e-17
C12	Y#3	Y#8	2.64874e-18
C13	B1#5	B2#4	4.48375e-17
C14	a_558_74#	VGND#6	3.89705e-17
C15	Y#8	Y#2	3.9068e-19
C16	Y#3	a_66_368##3	3.83696e-17
C17	a_558_74##2	a_558_74#	2.42535e-18
C18	a_66_368##2	Y#7	1.02168e-17
C19	a_558_74##2	VGND#6	4.11083e-17
C20	a_66_368##2	a_66_368##5	4.35239e-20
C21	a_66_368##6	a_66_368##3	1.99644e-18
C22	Y#3	B2#4	3.26568e-18
C23	a_66_368##2	Y#8	2.1502e-17
C24	Y#5	a_558_74##2	3.11298e-17
C25	a_66_368##6	VPWR#5	1.72206e-18
C26	Y#3	A2#2	7.35266e-20
C27	a_66_368##6	a_66_368##9	1.33634e-18
C28	B1#2	B2#4	2.976e-17
C29	a_148_74#	Y#5	3.68353e-17
C30	VGND#7	a_558_74##2	1.16553e-18
C31	Y#2	B2#4	1.37705e-18
C32	a_66_368##6	VPWR#6	4.30104e-17
C33	a_148_74#	VGND#7	3.60457e-17
C34	a_66_368##7	a_66_368##6	2.59773e-18
C35	A2#2	A1#5	4.11259e-17
C36	a_148_74##2	a_148_74#	2.43309e-18
C37	a_148_74##2	VGND#7	4.4225e-17
C38	Y#9	VGND#7	2.05961e-20
C39	Y#9	a_148_74##2	9.23973e-17
C40	A2#3	A2#2	2.17147e-18
C41	a_66_368##6	A2#2	3.501e-20
C42	VPWR#2	B1#4	5.36234e-20
C43	A1#2	A2#2	2.08174e-19
C44	a_66_368#	Y#7	4.48205e-17
C45	VPWR#2	B2#1	7.53193e-20
C46	Y#1	B1#6	2.28114e-17
C47	a_66_368##5	a_66_368#	5.01824e-18
C48	a_558_74#	B1#6	3.42008e-17
C49	VPWR#2	B2#6	2.49104e-19
C50	Y#1	B2#3	1.78098e-18
C51	a_66_368##5	Y#7	3.46413e-17
C52	VGND#6	B1#6	2.19527e-18
C53	a_558_74#	B2#3	2.56831e-17
C54	Y#8	Y#7	2.4983e-18
C55	Y#1	B2#5	4.15656e-19
C56	a_558_74##2	B1#6	2.04326e-19
C57	VGND#6	B2#3	2.79813e-17
C58	VPWR#2	B1#1	5.42671e-19
C59	Y#3	B1#4	1.83279e-19
C60	a_558_74#	B2#5	4.33069e-19
C61	Y#8	a_66_368##5	3.4911e-17
C62	Y#1	B1#3	2.80445e-19
C63	a_558_74##2	B2#3	4.68073e-19
C64	Y#2	B1#4	2.18742e-17
C65	VGND#6	B2#5	2.5685e-17
C66	a_66_368##3	a_66_368##5	4.80579e-18
C67	a_558_74#	B1#3	1.91608e-19
C68	VPWR#2	A1#4	1.22771e-17
C69	Y#3	B2#1	6.59187e-19
C70	a_558_74##2	B2#5	2.67968e-17
C71	VGND#6	B1#3	1.22388e-18
C72	Y#2	B2#1	1.97527e-17
C73	a_66_368##3	Y#8	4.51528e-17
C74	Y#5	B2#5	8.80091e-19
C75	B1#3	a_558_74##2	2.56188e-17
C76	Y#3	B2#6	1.92733e-17
C77	VPWR#2	A2#4	1.55806e-17
C78	VGND#6	A1#6	4.33919e-19
C79	Y#2	B2#6	2.28536e-19
C80	B1#3	Y#5	1.50503e-17
C81	a_558_74##2	A1#6	1.31009e-18
C82	a_66_368##3	VPWR#5	1.45911e-18
C83	VGND#7	B2#5	2.43044e-19
C84	a_148_74#	B1#3	4.05446e-20
C85	Y#3	B1#1	1.56489e-17
C86	VGND#6	A2#1	1.93104e-19
C87	VPWR#2	A2#6	1.11167e-18
C88	a_66_368##2	B2#1	2.10045e-17
C89	Y#5	A1#6	2.88833e-17
C90	Y#2	B1#1	8.48558e-20
C91	a_558_74##2	A2#1	1.57795e-19
C92	VGND#7	B1#3	5.37522e-19
C93	a_148_74#	A1#6	2.9098e-17
C94	Y#3	A1#4	5.02907e-18
C95	Y#5	A2#1	1.00293e-18
C96	a_66_368##2	B2#6	2.15219e-17
C97	VPWR#2	A1#1	5.08376e-19
C98	VGND#7	A1#6	1.18327e-18
C99	a_558_74##2	A2#5	1.17335e-19
C100	a_148_74#	A2#1	4.28237e-17
C101	Y#3	A2#4	7.01985e-19
C102	A2#1	VGND#7	2.04125e-17
C103	a_66_368##6	A1#4	5.46777e-19
C104	a_66_368##7	VPWR#5	2.75659e-19
C105	a_148_74#	A2#5	9.38027e-19
C106	Y#9	A1#6	1.17419e-19
C107	Y#1	B1#4	2.44982e-18
C108	a_148_74##2	A2#1	4.04506e-19
C109	VGND#7	A2#5	2.96267e-17
C110	Y#9	A2#1	2.08193e-19
C111	a_148_74#	A1#3	1.89704e-19
C112	a_66_368##6	A2#4	3.81381e-17
C113	Y#1	B2#1	4.32571e-19
C114	a_148_74##2	A2#5	2.64148e-17
C115	a_66_368##7	VPWR#6	3.90646e-17
C116	VPWR#1	VPWR#2	3.81364e-17
C117	VGND#7	A1#3	2.19527e-18
C118	Y#9	A2#5	9.08315e-18
C119	a_148_74##2	A1#3	3.44398e-17
C120	a_66_368##6	A2#6	3.15363e-17
C121	Y#9	A1#3	2.89396e-17
C122	a_66_368##6	A1#1	1.76808e-18
C123	B2	B2#4	2.03217e-17
C124	B2#3	B1#6	3.90695e-17
C125	a_66_368#	B1#4	4.63698e-17
C126	Y#2	VPWR#1	1.93477e-18
C127	B1#4	Y#7	2.5123e-17
C128	B2#5	B2#3	4.00471e-17
C129	VGND#3	Y#3	2.89389e-19
C130	a_66_368#	B2#1	2.31105e-18
C131	a_66_368##5	B1#4	2.42148e-18
C132	B2#1	Y#7	2.7059e-17
C133	A2	A2#2	3.66805e-19
C134	a_66_368##2	VPWR#1	7.31285e-17
C135	Y#8	B1#4	2.35575e-19
C136	a_66_368##5	B2#1	4.40815e-17
C137	B1#3	B2#5	2.4509e-17
C138	Y#7	B2#6	9.02424e-19
C139	B1#5	Y#2	3.04629e-17
C140	Y#8	B2#1	5.38303e-19
C141	a_66_368##5	B2#6	3.95191e-17
C142	Y#7	B1#1	1.94788e-19
C143	B2#6	Y#8	1.98472e-17
C144	A1#6	B1#3	1.44128e-17
C145	VPWR#2	A1#5	1.1849e-18
C146	a_66_368##5	B1#1	1.62902e-18
C147	a_66_368##3	B2#6	2.08585e-18
C148	B1#1	Y#8	2.52596e-17
C149	B1#2	Y#3	2.58794e-17
C150	a_66_368##3	B1#1	6.58115e-17
C151	A2#1	A1#6	3.9579e-17
C152	VPWR#2	A2#3	2.16994e-20
C153	a_66_368##3	A1#4	6.84209e-17
C154	Y#3	A1#5	2.11914e-17
C155	A2#5	A2#1	2.90846e-17
C156	A1#4	VPWR#5	1.91174e-17
C157	a_66_368##2	B1#2	1.1044e-19
C158	a_66_368##3	A2#4	1.72758e-18
C159	B1#5	Y#1	7.74408e-17
C160	VGND#3	a_558_74##2	7.68072e-18
C161	A2#4	VPWR#5	2.70602e-17
C162	B1#5	a_558_74#	3.9792e-17
C163	A1#5	a_66_368##6	4.27588e-17
C164	VGND#3	Y#5	2.59041e-17
C165	VPWR#6	A1#4	1.21881e-19
C166	a_66_368##6	VPWR#2	7.05268e-17
C167	a_66_368##3	A2#6	3.29221e-19
C168	A1#3	A2#5	4.0177e-17
C169	B1	B2#4	2.03762e-17
C170	A2#4	a_66_368##9	2.32435e-17
C171	VGND#3	a_148_74#	6.74249e-18
C172	a_66_368##7	A1#4	2.56872e-19
C173	VPWR#6	A2#4	6.66983e-19
C174	Y#1	B2#4	4.32571e-19
C175	a_66_368##3	A1#1	2.95961e-19
C176	a_66_368#	VPWR#1	5.0507e-17
C177	A2#6	a_66_368##9	2.32435e-17
C178	a_66_368##6	A2#3	5.78695e-19
C179	a_66_368##7	A2#4	5.63342e-19
C180	A2#6	VPWR#6	2.22263e-17
C181	a_66_368##7	A2#6	1.50381e-18
C182	VPWR#6	A1#1	3.6297e-17
C183	A1#2	a_66_368##6	4.39522e-17
C184	B1#2	a_558_74##2	2.08334e-17
C185	a_66_368##3	VPWR#1	3.62946e-17
C186	a_66_368##7	A1#1	3.70846e-17
C187	B1#5	a_66_368#	1.30204e-18
C188	Y	B2#4	3.54073e-19
C189	Y	A2#2	1.23463e-17
C190	B2#1	B1#4	4.6536e-17
C191	a_558_74#	B2#4	3.19786e-19
C192	a_148_74#	A1#5	6.23859e-20
C193	B2#6	B2#1	4.59994e-17
C194	B2#4	B1#4	1.31487e-18
C195	a_148_74#	A2#3	2.6993e-19
C196	VGND#7	A2#3	7.78702e-19
C197	a_148_74##2	A2#3	6.10902e-19
C198	B1#1	B2#6	4.01251e-17
C199	Y#9	A2#3	3.35129e-17
C200	B1#5	B1#6	5.60709e-18
C201	B1#5	B2#3	8.83555e-18
C202	VGND#3	B1#3	8.67939e-18
C203	A1#5	a_66_368##3	3.26111e-17
C204	VGND#6	B2#4	7.31401e-19
C205	VGND#3	A1#6	2.82255e-18
C206	A1#4	B1#1	4.74317e-17
C207	Y#9	A1#2	5.93046e-17
C208	A1#5	VPWR#5	8.60431e-18
C209	Y#3	Y#2	1.29922e-18
C210	A2#4	A1#4	1.40167e-17
C211	Y#3	B2	1.57437e-17
C212	B2	Y#2	2.13583e-17
C213	A2#3	a_66_368##9	5.11671e-19
C214	B1#2	B2#5	5.43105e-18
C215	VPWR#1	B1#4	4.46728e-18
C216	B1#2	B1#3	6.42232e-18
C217	VPWR#1	B2#1	4.464e-18
C218	A2#6	A2#4	4.57504e-17
C219	A1#6	B1#2	1.29447e-18
C220	A1#2	a_66_368##9	1.17413e-18
C221	VPWR#1	B2#6	4.46413e-18
C222	A1#2	VPWR#6	1.50892e-18
C223	VPWR#1	B1#1	4.48042e-18
C224	A1#2	a_66_368##7	5.41791e-17
C225	a_558_74##2	B2#4	4.96965e-19
C226	A1#1	A2#6	4.63042e-17
C227	VPWR#1	A1#4	2.97708e-18
C228	B2	Y#1	2.92271e-18
C229	A1#5	B2#6	2.11542e-19
C230	B1	Y#3	1.83168e-17
C231	B2#4	VNB	4.96076e-17
C232	A2#2	VNB	2.13325e-17
C233	A1#5	B1#1	1.72633e-18
C234	A1#5	A1#4	7.72025e-18
C235	Y#3	a_66_368##2	3.54799e-18
C236	A1#5	A2#4	2.35847e-17
C237	VPWR#1	B1#5	4.66787e-20
C238	A1#5	A2#6	3.82201e-19
C239	A1#5	A1#1	1.51754e-19
C240	A1#2	A1#4	6.79477e-20
C241	Y#9	A1	1.71067e-17
C242	a_558_74#	B1	8.16644e-18
C243	VPWR#1	B1#2	3.69145e-20
C244	B1	VGND#6	5.44149e-19
C245	VPWR	VPWR#2	5.06517e-17
C246	A1#2	A2#4	3.03479e-19
C247	Y#2	a_66_368##2	3.54799e-18
C248	B1	a_558_74##2	3.88591e-17
C249	B1#1	B2#4	2.32977e-18
C250	VGND#3	B1#2	9.71189e-19
C251	A1#2	A2#6	1.65169e-17
C252	A1#2	A1#1	1.06801e-17
C253	VGND#3	A1#5	1.61628e-19
C254	VPWR	Y#3	4.49665e-18
C255	Y	Y#1	1.63772e-18
C256	VPWR	Y#2	9.26384e-18
C257	VPWR	a_66_368##6	1.94005e-17
C258	Y	a_558_74##2	2.47264e-18
C259	A1	a_66_368##7	1.61386e-17
C260	VPWR	a_66_368##2	2.71734e-17
C261	Y	Y#5	2.59733e-18
C262	Y	a_148_74#	4.40916e-17
C263	Y	VGND#7	5.11815e-19
C264	B2	B1#4	1.31607e-18
C265	a_148_74##2	Y	7.67291e-18
C266	A1#5	B1#2	3.03532e-17
C267	Y#9	Y	1.07433e-18
C268	B2	B2#1	2.01902e-18
C269	B2	B2#6	1.42171e-18
C270	VGND	Y#3	2.96535e-18
C271	B2	B1#1	5.12617e-19
C272	A2#3	A1#5	5.34865e-18
C273	Y	a_66_368##3	1.63095e-18
C274	B1	B2#5	7.61338e-18
C275	A1#2	A1#5	1.59972e-18
C276	VPWR	a_66_368#	2.21664e-17
C277	A2	A1#4	3.80357e-19
C278	VPWR	Y#7	5.68174e-18
C279	Y	B1#6	6.49461e-19
C280	A1#2	A2#3	5.07894e-17
C281	VPWR#2	VNB	3.42594e-17
C282	Y	B2#3	3.79108e-19
C283	A2	A2#4	1.54444e-18
C284	VGND	Y#1	2.15902e-17
C285	VPWR	Y#8	5.69233e-18
C286	a_148_74#	A2#2	1.67469e-19
C287	VGND	a_558_74#	1.5274e-17
C288	Y	B2#5	1.67681e-18
C289	VPWR	a_66_368##3	2.14537e-17
C290	A2	A2#6	2.01766e-18
C291	VGND	VGND#6	1.61502e-17
C292	Y	B1#3	5.92058e-18
C293	VGND	a_558_74##2	1.69713e-17
C294	VGND	Y#5	2.23625e-17
C295	Y	A1#6	1.39124e-17
C296	A2	A1#1	6.15785e-19
C297	VGND	a_148_74#	1.51222e-17
C298	Y#3	VNB	2.14551e-18
C299	Y	A2#1	9.39395e-18
C300	VGND	VGND#7	1.66393e-17
C301	Y#2	VNB	2.35223e-17
C302	VPWR	a_66_368##7	1.53974e-17
C303	VGND	a_148_74##2	1.58209e-17
C304	Y	A2#5	2.88658e-19
C305	a_66_368##6	VNB	2.08637e-18
C306	VGND	Y#9	1.81413e-17
C307	B1#5	B2	3.90068e-17
C308	Y	A1#3	4.01947e-19
C309	a_66_368##2	VNB	5.94309e-18
C310	A2#2	A1#4	4.92706e-19
C311	B2	B1#2	3.6788e-19
C312	Y#1	VNB	7.66552e-17
C313	a_558_74#	VNB	4.23594e-18
C314	B2	A1#5	2.58111e-19
C315	VGND#6	VNB	3.59291e-19
C316	Y	B1#1	2.42308e-19
C317	a_558_74##2	VNB	5.5927e-18
C318	Y#5	VNB	6.25074e-18
C319	VGND	B1#6	9.21606e-19
C320	a_148_74#	VNB	1.97113e-18
C321	VGND#7	VNB	1.75382e-18
C322	VGND	B2#3	7.62544e-19
C323	VPWR	B1#4	2.28081e-18
C324	a_148_74##2	VNB	4.23594e-18
C325	A2	A1#5	1.0235e-17
C326	VGND	B2#5	6.17717e-19
C327	Y#9	VNB	4.81914e-17
C328	VPWR	B2#1	1.67353e-18
C329	VGND	B1#3	3.32181e-18
C330	a_66_368#	VNB	4.27406e-17
C331	VPWR	B2#6	1.57928e-18
C332	Y#7	VNB	3.29031e-19
C333	VGND	A1#6	3.98839e-19
C334	A2	A2#3	8.88942e-18
C335	VPWR	B1#1	1.42487e-18
C336	B1	B1#5	3.5246e-18
C337	VGND	A2#5	7.62544e-19
C338	a_66_368##3	VNB	1.92167e-18
C339	VPWR	A1#4	7.24931e-19
C340	A1#2	A2	5.53362e-17
C341	VGND	A1#3	2.37667e-18
C342	VPWR#6	VNB	2.47035e-18
C343	VPWR	A2#6	5.48072e-19
C344	a_66_368##7	VNB	5.09804e-17
C345	B1#6	VNB	3.015e-17
C346	VPWR	A1#1	1.97585e-18
C347	B2#3	VNB	2.39712e-17
C348	B2#5	VNB	2.37488e-17
C349	B1#3	VNB	3.03275e-17
C350	VPWR	VPWR#1	5.28004e-17
C351	A1#6	VNB	2.69904e-17
C352	Y	B1#2	5.90766e-17
C353	A2#1	VNB	2.63873e-17
C354	VPWR#2	A2#2	2.32007e-21
C355	A2#5	VNB	2.46624e-17
C356	Y	A1#5	9.38216e-17
C357	VPWR	B1#5	3.91127e-18
C358	A1#3	VNB	3.80217e-17
C359	Y	A2#3	2.23794e-17
C360	B1#4	VNB	4.03587e-17
C361	B2#1	VNB	3.13724e-17
C362	VPWR	B1#2	1.48843e-18
C363	Y	A1#2	6.59644e-19
C364	B2#6	VNB	3.40589e-17
C365	VPWR	A1#5	5.29398e-18
C366	B1#1	VNB	3.53718e-17
C367	VGND	VGND#3	2.19385e-17
C368	A1#4	VNB	3.43647e-17
C369	VGND	B1#5	6.9523e-18
C370	A2#4	VNB	3.44419e-17
C371	A2#6	VNB	3.09052e-17
C372	VPWR	A1#2	4.93442e-18
C373	A1#1	VNB	3.90057e-17
C374	VGND	B1#2	3.95295e-18
C375	B1	B2	2.96725e-17
C376	VGND#7	A2#2	1.41738e-19
C377	VGND	A1#5	3.34421e-18
C378	VPWR#1	VNB	2.89303e-16
C379	VGND	A2#3	2.40405e-18
C380	VGND#3	VNB	2.33474e-16
C381	B1#5	VNB	5.09059e-17
C382	VGND	A1#2	3.43967e-18
C383	Y	B2	3.02739e-18
C384	B1#2	VNB	3.10401e-17
C385	A1#5	VNB	4.50893e-17
C386	VPWR	B2	1.83923e-18
C387	A2#3	VNB	3.21837e-17
C388	A1#2	VNB	4.80601e-17
C389	VPWR	A2	1.9695e-18
C390	VGND	B2	2.24974e-18
C391	VPWR	A1	4.48709e-18
C392	VPWR	B1	1.12473e-18
C393	VGND	A1	4.77879e-18
C394	B2	VNB	2.3685e-18
C395	VGND	B1	3.59174e-18
C396	A2	VNB	1.57361e-18
C397	A1	VNB	3.2676e-17
C398	VGND	Y	3.98184e-18
C399	B1	VNB	2.63134e-18
C400	Y	VNB	3.8793e-18
C401	VPWR	VNB	7.77202e-17
C402	VGND	VNB	7.74588e-17
C403	VPWR#3	A1#2	4.50366e-20
C404	VGND#2	B2#5	9.28585e-19
C405	a_66_368##6	VPWR#3	8.26862e-18
C406	VGND#2	B2#3	1.2017e-18
C407	VGND#2	VNB	6.94576e-17
C408	A1	VPWR#3	1.29392e-18
C409	VGND#2	B1#6	5.49379e-18
C410	VGND	VGND#2	4.51301e-17
C411	VGND#3	VGND#4	8.01345e-17
C412	VGND#4	VNB	7.06989e-17
C413	VPWR#3	A2#3	1.63769e-20
C414	VGND	VGND#4	4.87894e-17
C415	VPWR#3	A1#1	4.58808e-18
C416	VPWR#3	A2#6	5.44083e-18
C417	VPWR#3	VNB	5.21515e-17
C418	VGND#4	A1	1.4664e-18
C419	VGND#2	a_558_74##2	1.41452e-17
C420	VGND#2	B1#2	1.16535e-19
C421	VPWR#3	A2#4	5.90851e-19
C422	VGND#2	a_558_74#	1.81374e-17
C423	VGND#2	B1#5	1.16332e-18
C424	VPWR#3	VPWR#2	7.65033e-19
C425	a_66_368##7	VPWR#3	1.81039e-17
C426	VGND#2	Y#1	2.82772e-17
C427	VGND#3	VGND#2	8.04977e-17
C428	VPWR#3	A1#4	4.69462e-20
C429	VPWR	VPWR#3	4.92816e-17
C430	VGND#4	Y#9	1.83386e-17
C431	VGND#4	a_148_74##2	1.81374e-17
C432	VGND#4	A1#3	7.36691e-18
C433	VGND#4	A1#2	7.481e-20
C434	VGND#4	A2#5	1.2017e-18
C435	VGND#4	a_148_74#	1.25616e-17
C436	VGND#4	A2#1	2.72844e-18
C437	VGND#4	A1#5	3.85385e-20
C438	VPWR#1	VPWR#3	5.7384e-17
*
*
.ENDS sky130_fd_sc_hs__a22oi_2
*
