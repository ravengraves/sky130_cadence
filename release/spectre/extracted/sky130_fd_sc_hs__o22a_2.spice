* Extracted by Quantus, converted by sky130cad/quantus.py
*
*
*
*                       LINUX           Wed Nov 18 08:58:23 2026
*
*
*
*  PROGRAM  advgen
*
*  Name           : advgen - Quantus - (64-bit)
*  Version        : 25.1.0-p047
*  Build Date     : Thu Dec 11 23:20:30 PST 2025
*
*  HSPICE LIBRARY
*
*  OPERATING_TEMPERATURE 150
*  QRC_TECH_DIR <path>/tech
*
*
*

*
.SUBCKT sky130_fd_sc_hs__o22a_2 VNB VPB VGND VPWR X A1 B1 B2 A2
*
*
*  caps2d version: 10
*
*
*       TRANSISTOR CARDS
*
*
XM2 X#1 a_82_48##4 VGND#5 VNB sky130_fd_pr__nfet_01v8_lvt l=0.15 w=0.74 ad=0.2072 as=0.2035 pd=2.04 ps=2.03
XM4 VGND#7 a_82_48##5 X#1 VNB sky130_fd_pr__nfet_01v8_lvt l=0.15 w=0.74 ad=0.19325 as=0.2072 pd=2.03 ps=2.04
XM7 a_307_74##4 B1#1 a_82_48##9 VNB sky130_fd_pr__nfet_01v8_lvt l=0.15 w=0.74 ad=0.195 as=0.2294 pd=2.03 ps=2.1
XM11 a_82_48##9 B2#1 a_307_74##2 VNB sky130_fd_pr__nfet_01v8_lvt l=0.15 w=0.74 ad=0.2294 as=0.259 pd=2.1 ps=2.18
XM9 a_307_74##2 A2#1 VGND#6 VNB sky130_fd_pr__nfet_01v8_lvt l=0.15 w=0.74 ad=0.259 as=0.259 pd=2.18 ps=2.18
XM8 VGND#6 A1#4 a_307_74# VNB sky130_fd_pr__nfet_01v8_lvt l=0.15 w=0.74 ad=0.259 as=0.2109 pd=2.18 ps=2.05
XM0 VPWR#4 a_82_48##6 X#2 VPB sky130_fd_pr__pfet_01v8 l=0.15 w=1.12 ad=0.3864 as=0.336 pd=2.93 ps=2.84
XM1 X#2 a_82_48# VPWR#5 VPB sky130_fd_pr__pfet_01v8 l=0.15 w=1.12 ad=0.336 as=0.7 pd=2.84 ps=3.57
XM10 VPWR#5 B1#3 a_383_384# VPB sky130_fd_pr__pfet_01v8 l=0.15 w=1 ad=0.7 as=0.3 pd=3.57 ps=2.6
XM5 a_383_384# B2#3 a_82_48##7 VPB sky130_fd_pr__pfet_01v8 l=0.15 w=1 ad=0.3 as=0.36 pd=2.6 ps=2.72
XM3 a_82_48##7 A2#3 a_575_384# VPB sky130_fd_pr__pfet_01v8 l=0.15 w=1 ad=0.36 as=0.39 pd=2.72 ps=2.78
XM6 a_575_384# A1#3 VPWR#1 VPB sky130_fd_pr__pfet_01v8 l=0.15 w=1 ad=0.39 as=0.29 pd=2.78 ps=2.58
*
*
*       RESISTOR AND CAP/DIODE CARDS
*
Rg1	a_82_48#	a_82_48##2	443.503967
Rg2	a_82_48##2	a_82_48##3	119.223122
Rg3	a_82_48##3	a_82_48##4	512.029358
Rg4	a_82_48##2	a_82_48##5	340.503784
Rg5	a_82_48##3	a_82_48##6	436.409119
Rg6	B1#1	B1#2	420.757507
Rg7	B1#2	B1#3	392.516327
Rg8	B2#1	B2#2	440.867310
Rg9	B2#2	B2#3	408.386017
Rg10	A2#1	A2#2	428.448700
Rg11	A2#2	A2#3	400.207520
Rg12	A1#1	A1#2	27.660566
Rg13	A1#2	A1#3	472.643829
Rg14	A1#2	A1#4	368.862610
Rf1	X	X#1	17.164852
Rf2	X	X#2	90.549034
Rf3	B1#2	B1	162.988510
Rf4	B2#4	B2	1.012957
Rf5	B2#2	B2#6	161.245758
Rf6	B2#4	B2#6	6.513835
Rf7	a_82_48##7	a_82_48##8	139.682831
Rf8	a_82_48##8	a_82_48##9	82.190498
Rf9	A2#2	A2#5	161.114929
Rf10	A2#6	A2	0.882132
Rf11	A2#5	A2#6	9.119370
Rf12	a_307_74#	a_307_74##3	93.789673
Rf13	a_307_74##3	a_307_74##4	84.078918
Rf14	a_307_74##2	a_307_74##3	7.500000
Rf15	A1	A1#1	168.106262
Rf16	VPWR#1	VPWR#2	153.419815
Rf17	VPWR#2	VPWR#3	33.431927
Rf18	VPWR#3	VPWR#4	121.309883
Rf19	VPWR#3	VPWR#5	19.819580
Rf21	VGND#2	VGND#3	88.366570
Rf22	VGND#3	VGND#4	57.685360
Rf23	VGND#4	VGND#5	105.351418
Rf24	VGND#2	VGND#6	36.279022
Rf25	VGND#4	VGND#7	32.735970
Rf28	a_82_48##2	a_82_48##8	160.232803
Re1	VPWR#2	VPWR	1.227783
Re2	VGND	VGND#3	1.227829
*
*       CAPACITOR CARDS
*
*
C1	a_307_74#	A1#2	6.99472e-18
C2	A1#1	A1#2	1.55921e-17
C3	VGND#4	a_307_74##4	3.91024e-18
C4	VGND#4	X#1	1.47827e-17
C5	A2#2	A1#2	3.44395e-17
C6	VGND#5	VGND#4	1.29379e-18
C7	X#1	a_82_48##3	1.39038e-17
C8	VPWR#3	VPWR#1	1.49029e-18
C9	a_307_74#	VGND#6	4.93415e-17
C10	VPWR#3	a_82_48##7	3.49119e-18
C11	a_307_74##2	a_307_74#	2.49329e-18
C12	VPWR#1	A1#2	5.56666e-18
C13	a_307_74##2	VGND#6	6.29639e-17
C14	a_82_48##2	A1#2	5.78755e-19
C15	a_82_48##3	a_82_48##2	6.07318e-18
C16	VPWR#3	VPWR#5	1.5498e-18
C17	X#2	VPWR#3	2.79517e-17
C18	a_307_74##2	a_82_48##9	3.91319e-17
C19	a_307_74##4	a_307_74##2	3.85403e-18
C20	VGND#7	VGND#6	7.23477e-19
C21	VPWR#4	VPWR#3	2.50089e-18
C22	a_82_48##9	a_307_74##4	4.26265e-17
C23	X#1	a_307_74##2	7.54354e-19
C24	a_307_74#	VPWR#1	1.98522e-18
C25	VGND#7	a_307_74##4	2.75448e-17
C26	X#1	a_307_74##4	2.25095e-18
C27	VGND#4	a_82_48##5	1.23137e-18
C28	X#1	VGND#7	3.23283e-17
C29	VGND#5	VGND#7	1.81511e-18
C30	VGND#4	a_82_48##4	3.27767e-18
C31	a_307_74##2	a_82_48##7	7.92339e-18
C32	VGND#5	X#1	6.65266e-17
C33	a_82_48##9	a_82_48##7	3.03669e-18
C34	a_307_74#	A1#4	3.23237e-17
C35	VGND#6	A1#4	3.33084e-17
C36	VPWR#3	A1#3	6.11103e-19
C37	a_307_74#	A2#1	7.39424e-19
C38	a_307_74##2	A1#4	1.91782e-18
C39	a_82_48##7	VPWR#1	2.62681e-17
C40	A2#1	VGND#6	1.76074e-17
C41	VPWR#3	A2#3	5.51453e-19
C42	a_307_74##2	A2#1	6.36699e-17
C43	VGND#6	B2#1	6.73272e-19
C44	VGND#4	a_82_48##3	5.27662e-20
C45	a_82_48##9	A2#1	7.51185e-19
C46	X#2	a_82_48##3	1.41502e-18
C47	VPWR#3	B2#3	1.67612e-18
C48	a_307_74##2	B2#1	3.35695e-17
C49	VGND#7	A1#4	2.173e-19
C50	VGND#6	B1#1	3.30793e-19
C51	a_307_74##4	A2#1	4.27501e-19
C52	a_82_48##9	B2#1	3.43183e-17
C53	VGND#5	VPWR#4	1.30213e-17
C54	a_307_74##2	B1#1	8.98932e-19
C55	VPWR#3	B1#3	1.2544e-17
C56	VGND#7	A2#1	1.43535e-19
C57	VGND#6	a_82_48##5	1.04873e-19
C58	a_82_48##7	VPWR#5	2.4075e-17
C59	a_307_74##4	B2#1	1.11562e-18
C60	a_82_48##9	B1#1	4.20071e-17
C61	X#1	A2#1	7.39399e-20
C62	a_307_74##2	a_82_48##5	1.75091e-19
C63	VGND#7	B2#1	2.86358e-19
C64	X#2	a_82_48##7	1.17851e-18
C65	a_307_74##4	B1#1	5.06247e-17
C66	VPWR#3	a_82_48#	1.29727e-17
C67	A2	A1#2	7.93511e-18
C68	X#1	B2#1	1.03256e-19
C69	a_307_74##2	a_82_48##4	1.1319e-19
C70	VGND#7	B1#1	2.7985e-18
C71	a_307_74##4	a_82_48##5	2.26148e-18
C72	VPWR#3	a_82_48##6	1.57477e-18
C73	X#1	B1#1	9.29181e-19
C74	X#2	VPWR#5	5.69873e-17
C75	VGND#7	a_82_48##5	4.05583e-17
C76	a_307_74##4	a_82_48##4	6.73393e-19
C77	X#1	a_82_48##5	2.39764e-17
C78	VGND#7	a_82_48##4	2.30972e-18
C79	VGND#5	a_82_48##5	1.29218e-18
C80	VPWR#4	X#2	1.09545e-16
C81	X#1	a_82_48##4	4.33572e-17
C82	VGND#3	VGND#4	4.34452e-17
C83	VPWR#2	VPWR#3	4.59017e-17
C84	VGND#5	a_82_48##4	2.47997e-17
C85	A2#1	A1#4	2.37077e-17
C86	A2#1	A1#2	2.70933e-18
C87	VPWR#1	A1#3	5.61396e-17
C88	VPWR#3	a_82_48##3	1.62076e-20
C89	VPWR#1	A2#3	1.62603e-17
C90	B2#1	A2#1	3.05215e-17
C91	a_82_48##7	A1#3	9.07887e-18
C92	VPWR#1	B2#3	2.4023e-18
C93	A2#3	a_82_48##7	2.59737e-17
C94	B1#1	B2#1	3.5914e-17
C95	VPWR#1	B1#3	4.5305e-19
C96	a_82_48##7	B2#3	6.65658e-17
C97	VGND#4	B1#2	3.12351e-20
C98	A1	A1#2	1.23684e-17
C99	a_82_48##7	B1#3	2.68473e-17
C100	a_82_48##5	B1#1	5.21479e-18
C101	VPWR#5	B2#3	3.89879e-18
C102	VGND#4	a_82_48##2	2.50575e-18
C103	VGND#3	a_307_74##2	1.27068e-17
C104	X#2	B2#3	1.45315e-19
C105	a_82_48##7	a_82_48#	1.93273e-19
C106	A1#1	a_307_74#	3.98556e-17
C107	VPWR#5	B1#3	5.12661e-17
C108	a_82_48##2	VPWR#3	5.01566e-19
C109	a_82_48##4	a_82_48##5	3.93831e-17
C110	X#2	B1#3	1.35563e-18
C111	VGND#3	a_307_74##4	2.7203e-17
C112	a_82_48#	VPWR#5	2.27907e-17
C113	VPWR#4	B1#3	3.01752e-19
C114	VGND#6	A2#2	6.22789e-19
C115	X#2	a_82_48#	6.23454e-17
C116	VPWR#2	VPWR#1	4.31401e-17
C117	a_307_74##2	A2#2	2.11137e-17
C118	VPWR#4	a_82_48#	1.3945e-18
C119	VGND#3	VGND#5	2.33712e-17
C120	X#2	a_82_48##6	5.6455e-17
C121	a_82_48##7	VPWR#2	2.00484e-17
C122	VPWR#4	a_82_48##6	3.64533e-17
C123	a_307_74##2	B2#2	1.45477e-17
C124	a_82_48##9	B2#2	8.60963e-18
C125	a_307_74##4	B2#2	1.89098e-19
C126	A2#2	VPWR#1	6.59374e-19
C127	a_82_48##9	B1#2	2.2628e-18
C128	VPWR#2	VPWR#4	3.04409e-17
C129	A2#3	A1#3	3.50653e-17
C130	a_307_74##4	B1#2	9.27831e-19
C131	B2#3	A2#3	3.25945e-17
C132	a_82_48##2	a_307_74##4	7.88168e-18
C133	B2#2	a_82_48##7	3.24575e-17
C134	a_82_48##2	VGND#7	1.88724e-17
C135	X#1	a_82_48##2	6.35097e-17
C136	a_307_74#	a_575_384#	1.20909e-19
C137	VGND#3	B2#1	5.36655e-18
C138	B1#3	B2#3	4.41356e-17
C139	VGND#3	B1#1	5.36655e-18
C140	B1#2	VPWR#5	1.9016e-18
C141	a_82_48#	B1#3	1.27284e-17
C142	X#2	B1#2	1.22648e-19
C143	a_82_48##2	VPWR#5	6.29243e-17
C144	VPWR#2	A2#3	1.16443e-17
C145	VGND	A1#2	8.2883e-19
C146	a_82_48##2	X#2	4.54313e-17
C147	a_82_48##6	a_82_48#	4.65552e-17
C148	VPWR#2	B2#3	9.25099e-18
C149	a_82_48##2	A1#4	1.44845e-20
C150	VPWR#2	B1#3	9.58516e-18
C151	a_82_48##2	A2#1	1.52574e-19
C152	A2#2	A1#3	2.18609e-18
C153	a_82_48##2	B2#1	2.58093e-19
C154	a_82_48##7	a_383_384#	6.63353e-18
C155	a_82_48##2	B1#1	1.43801e-18
C156	a_82_48##2	a_82_48##5	4.86469e-18
C157	a_307_74#	A2	4.50604e-18
C158	a_82_48##4	a_82_48##2	2.06953e-18
C159	a_307_74##2	A2	9.17217e-18
C160	a_82_48##2	A1#3	2.89364e-19
C161	a_82_48##2	A2#3	1.8368e-19
C162	a_82_48##9	B2	1.12537e-17
C163	a_82_48##2	B2#3	3.14765e-19
C164	A2	VPWR#1	1.66398e-18
C165	a_82_48#	B1#2	2.72005e-18
C166	A2#2	VPWR#2	7.82716e-19
C167	a_82_48##2	B1#3	1.13425e-18
C168	A1#3	a_575_384#	3.10318e-17
C169	a_82_48##2	a_82_48#	5.08462e-18
C170	VPWR#2	B2#2	4.77027e-20
C171	A2#3	a_575_384#	3.05556e-17
C172	a_82_48##9	B1	2.02657e-17
C173	a_82_48##2	a_82_48##6	7.66976e-20
C174	A1#1	A2#2	1.61307e-18
C175	VGND#3	B2#2	3.81189e-20
C176	B2	a_82_48##7	2.41281e-17
C177	A1#1	B2#2	7.27651e-19
C178	VGND#3	B1#2	6.04975e-20
C179	B2#3	a_383_384#	2.57967e-17
C180	B2#2	A2#2	6.46208e-17
C181	A1#1	B1#2	3.88362e-19
C182	B1#3	a_383_384#	2.57967e-17
C183	B1	a_82_48##7	1.68853e-17
C184	A1#1	a_82_48##2	3.3723e-19
C185	VPWR	VPWR#3	7.05052e-17
C186	A1#2	VNB	6.43083e-17
C187	B1#2	B2#2	3.23585e-17
C188	a_82_48##3	VNB	4.03944e-17
C189	a_82_48##2	A2#2	2.8385e-19
C190	A1	VPWR#1	3.06477e-17
C191	A2	A1#3	1.86912e-18
C192	a_82_48##2	B2#2	4.74166e-19
C193	a_82_48##2	B1#2	3.38214e-17
C194	A2#2	a_575_384#	5.04082e-19
C195	VGND	VGND#4	2.7998e-17
C196	VPWR	VPWR#1	5.43516e-17
C197	VPWR	a_82_48##7	2.21862e-17
C198	VGND	a_307_74#	1.47441e-17
C199	A1	A1#3	2.90079e-19
C200	B1	a_82_48#	1.05215e-19
C201	A2	A1#1	9.92403e-18
C202	VGND	a_307_74##2	2.20214e-17
C203	VGND	a_82_48##9	7.62395e-18
C204	VPWR	X#2	1.71135e-17
C205	A2	A2#2	6.499e-18
C206	VGND	a_307_74##4	1.98163e-17
C207	VPWR	VPWR#4	3.8179e-17
C208	VGND	VGND#7	1.59727e-17
C209	VGND	X#1	1.51539e-17
C210	VGND	VGND#5	3.01259e-17
C211	B2	B2#2	5.36428e-18
C212	B2	B1#2	7.19537e-18
C213	VGND	X#2	1.6461e-18
C214	VGND	VPWR#4	4.84005e-18
C215	VPWR	A1#3	4.0961e-18
C216	VGND	A1#4	1.4702e-18
C217	B1	B2#2	2.15588e-18
C218	VGND	A2#1	4.00037e-19
C219	VPWR	A2#3	9.30361e-18
C220	VGND	B2#1	9.19907e-19
C221	B1	B1#2	2.00184e-17
C222	VPWR	B2#3	9.30361e-18
C223	A1	A2#2	6.73361e-19
C224	VGND	B1#1	1.15294e-18
C225	VGND#4	VNB	3.62479e-17
C226	VPWR	B1#3	3.82655e-18
C227	VGND	a_82_48##5	4.34091e-18
C228	a_82_48##2	B1	5.01231e-17
C229	VPWR	a_82_48#	3.165e-18
C230	VPWR#3	VNB	3.94673e-17
C231	VGND	a_82_48##4	5.6773e-18
C232	VPWR	a_82_48##6	4.98442e-18
C233	VPWR	VPWR#2	2.71494e-17
C234	a_307_74#	VNB	4.13601e-17
C235	VGND#6	VNB	2.38162e-18
C236	a_307_74##2	VNB	8.45901e-18
C237	a_82_48##9	VNB	1.99143e-18
C238	VPWR	A2#2	4.68313e-18
C239	a_307_74##4	VNB	7.31328e-18
C240	VGND#7	VNB	2.39135e-18
C241	X#1	VNB	1.27752e-17
C242	VPWR	B2#2	1.43319e-18
C243	VGND#5	VNB	6.76407e-17
C244	VPWR#1	VNB	9.18758e-17
C245	VGND	VGND#3	2.13679e-17
C246	a_82_48##7	VNB	2.96681e-18
C247	VGND	A1#1	3.81894e-18
C248	VPWR	a_82_48##2	6.42157e-18
C249	X#2	VNB	5.69581e-18
C250	VGND	A2#2	2.43731e-18
C251	VPWR#4	VNB	8.46121e-17
C252	A1#4	VNB	3.08912e-17
C253	VGND	B2#2	1.74934e-18
C254	B1	B2	3.02519e-17
C255	A2#1	VNB	3.11611e-17
C256	A2	A1	2.21499e-17
C257	B2#1	VNB	3.29698e-17
C258	B1#1	VNB	3.65431e-17
C259	a_82_48##5	VNB	2.65761e-17
C260	VGND	a_82_48##2	9.54735e-18
C261	a_82_48##4	VNB	3.62238e-17
C262	A1#3	VNB	3.15603e-17
C263	A2#3	VNB	2.84009e-17
C264	B2#3	VNB	3.00651e-17
C265	B1#3	VNB	2.90536e-17
C266	a_82_48#	VNB	3.47964e-17
C267	VPWR	A2	4.43753e-18
C268	a_82_48##6	VNB	4.2124e-17
C269	VPWR	B2	1.11661e-18
C270	VPWR#2	VNB	2.01846e-16
C271	VGND#3	VNB	1.98489e-16
C272	A1#1	VNB	9.06625e-18
C273	VGND	A2	2.41346e-18
C274	VPWR	B1	1.80713e-18
C275	A2#2	VNB	3.29576e-17
C276	B2#2	VNB	3.60246e-17
C277	VGND	B2	1.7457e-18
C278	VPWR	A1	2.16443e-18
C279	B1#2	VNB	4.16395e-17
C280	a_82_48##2	VNB	5.15605e-17
C281	VGND	B1	2.7566e-18
C282	B2	VNB	4.71072e-19
C283	B1	VNB	5.55728e-18
C284	A1	VNB	1.11535e-17
C285	VPWR	VNB	5.96709e-17
C286	VGND	VNB	7.06993e-17
C287	VGND#4	VGND#2	2.17898e-19
C288	VGND#2	a_307_74#	1.78605e-17
C289	VGND#2	A1#2	3.11098e-19
C290	VGND#2	A1#4	4.6101e-18
C291	VGND#2	a_307_74##2	1.57454e-17
C292	VGND#2	A2#1	5.3258e-18
C293	VGND#3	VGND#2	5.83009e-17
C294	VGND#2	B2#1	7.15841e-19
C295	VGND#2	A1#1	5.01029e-19
C296	VGND#2	B1#1	2.5636e-19
C297	VGND#7	VGND#2	4.57017e-20
C298	VGND#2	a_82_48##5	5.26608e-20
C299	VGND#2	B2#2	2.92624e-20
C300	VGND	VGND#2	5.67361e-17
C301	VGND#2	VNB	5.35893e-17
*
*
.ENDS sky130_fd_sc_hs__o22a_2
*
