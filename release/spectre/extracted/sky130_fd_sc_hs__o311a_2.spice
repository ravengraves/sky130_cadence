* Extracted by Quantus, converted by sky130cad/quantus.py
*
*
*
*                       LINUX           Wed Nov 18 09:00:33 2026
*
*
*
*  PROGRAM  advgen
*
*  Name           : advgen - Quantus - (64-bit)
*  Version        : 25.1.0-p047
*  Build Date     : Thu Dec 11 23:20:30 PST 2025
*
*  HSPICE LIBRARY
*
*  OPERATING_TEMPERATURE 150
*  QRC_TECH_DIR <path>/tech
*
*
*

*
.SUBCKT sky130_fd_sc_hs__o311a_2 VNB VPB VGND VPWR X C1 B1 A3 A2 A1
*
*
*  caps2d version: 10
*
*
*       TRANSISTOR CARDS
*
*
XM5 a_32_74##9 C1#4 a_135_74# VNB sky130_fd_pr__nfet_01v8_lvt l=0.15 w=0.74 ad=0.2701 as=0.1998 pd=2.21 ps=2.02
XM0 a_135_74# B1#3 a_219_74##2 VNB sky130_fd_pr__nfet_01v8_lvt l=0.15 w=0.74 ad=0.1998 as=0.2886 pd=2.02 ps=2.26
XM4 a_219_74##2 A3#3 VGND#6 VNB sky130_fd_pr__nfet_01v8_lvt l=0.15 w=0.74 ad=0.2886 as=0.4974 pd=2.26 ps=2.98
XM6 VGND#6 A2#1 a_219_74# VNB sky130_fd_pr__nfet_01v8_lvt l=0.15 w=0.74 ad=0.4974 as=0.2072 pd=2.98 ps=2.04
XM1 a_219_74# A1#1 VGND#4 VNB sky130_fd_pr__nfet_01v8_lvt l=0.15 w=0.74 ad=0.2072 as=0.3293 pd=2.04 ps=2.37
XM2 VGND#4 a_32_74##5 X#1 VNB sky130_fd_pr__nfet_01v8_lvt l=0.15 w=0.74 ad=0.3293 as=0.2072 pd=2.37 ps=2.04
XM7 X#1 a_32_74# VGND#1 VNB sky130_fd_pr__nfet_01v8_lvt l=0.15 w=0.74 ad=0.2072 as=0.2775 pd=2.04 ps=2.23
XM10 a_32_74##11 C1#1 VPWR#7 VPB sky130_fd_pr__pfet_01v8 l=0.15 w=1 ad=0.295 as=0.42 pd=2.59 ps=2.84
XM3 VPWR#7 B1#1 a_32_74##12 VPB sky130_fd_pr__pfet_01v8 l=0.15 w=1 ad=0.42 as=0.4254 pd=2.84 ps=3.02
XM9 a_32_74##12 A3#1 a_360_368# VPB sky130_fd_pr__pfet_01v8 l=0.15 w=1.12 ad=0.4254 as=0.3024 pd=3.02 ps=2.78
XM11 a_360_368# A2#3 a_444_368# VPB sky130_fd_pr__pfet_01v8 l=0.15 w=1.12 ad=0.3024 as=0.4368 pd=2.78 ps=3.02
XM12 a_444_368# A1#3 VPWR#6 VPB sky130_fd_pr__pfet_01v8 l=0.15 w=1.12 ad=0.4368 as=0.4872 pd=3.02 ps=3.11
XM8 VPWR#6 a_32_74##6 X#2 VPB sky130_fd_pr__pfet_01v8 l=0.15 w=1.12 ad=0.4872 as=0.336 pd=3.11 ps=2.84
XM13 X#2 a_32_74##4 VPWR#1 VPB sky130_fd_pr__pfet_01v8 l=0.15 w=1.12 ad=0.336 as=0.3864 pd=2.84 ps=2.93
*
*
*       RESISTOR AND CAP/DIODE CARDS
*
Rg1	C1#1	C1#2	472.643829
Rg2	C1#2	C1#3	50.284184
Rg3	C1#2	C1#4	322.953644
Rg4	B1#1	B1#2	400.207520
Rg5	B1#2	B1#3	382.539734
Rg6	A3#1	A3#2	434.639221
Rg7	A3#2	A3#3	382.539734
Rg8	A2#1	A2#2	382.539734
Rg9	A2#2	A2#3	434.639221
Rg10	A1#1	A1#2	382.539734
Rg11	A1#2	A1#3	434.639221
Rg12	a_32_74#	a_32_74##2	322.953644
Rg13	a_32_74##2	a_32_74##3	56.190357
Rg14	a_32_74##2	a_32_74##4	507.075531
Rg15	a_32_74##3	a_32_74##5	326.454865
Rg16	a_32_74##3	a_32_74##6	505.268646
Rf1	C1	C1#3	163.775864
Rf2	B1#2	B1#5	161.608017
Rf3	B1#6	B1	1.375212
Rf4	B1#5	B1#6	5.294745
Rf5	A3#2	A3	166.137894
Rf6	A2	A2#2	166.137894
Rf7	a_219_74#	a_219_74##2	98.792824
Rf8	A1#4	A1#2	162.066422
Rf9	A1	A1#6	1.833616
Rf10	A1#4	A1#6	4.913828
Rf11	a_32_74##3	a_32_74##8	346.586914
Rf12	a_32_74##8	a_32_74##9	30.153120
Rf13	a_32_74##8	a_32_74##10	56.005695
Rf14	a_32_74##10	a_32_74##11	24.641068
Rf15	a_32_74##10	a_32_74##12	74.871323
Rf16	X#1	X	42.190876
Rf17	X	X#2	66.996124
Rf18	VGND#1	VGND#2	102.389061
Rf19	VGND#2	VGND#3	60.972630
Rf20	VGND#2	VGND#4	35.098007
Rf22	VGND#3	VGND#6	24.683773
Rf23	VPWR#1	VPWR#2	110.518646
Rf24	VPWR#2	VPWR#3	54.763340
Rf25	VPWR#3	VPWR#4	89.097069
Rf27	VPWR#2	VPWR#6	35.727165
Rf28	VPWR#4	VPWR#7	35.077789
Re1	VPWR#3	VPWR	1.091357
Re2	VGND	VGND#3	1.091398
*
*       CAPACITOR CARDS
*
*
C1	VGND#2	VGND#1	1.28898e-18
C2	VGND#2	X#1	1.09217e-17
C3	VGND#2	a_219_74#	5.00638e-18
C4	a_32_74##9	C1#2	7.55769e-18
C5	VGND#6	VGND#2	1.34321e-18
C6	a_32_74##3	a_32_74##2	4.72558e-18
C7	VPWR#2	VPWR#1	8.0943e-19
C8	X#2	a_32_74##2	5.11479e-19
C9	X#2	VPWR#2	1.26623e-17
C10	a_32_74##9	a_32_74##10	5.10467e-18
C11	VPWR#2	a_32_74##2	7.74711e-21
C12	X#1	VGND#1	2.54631e-17
C13	VGND#4	VGND#1	2.25031e-18
C14	VGND#2	a_32_74##2	3.51041e-20
C15	VGND#4	X#1	2.95923e-17
C16	C1#2	B1#2	3.21042e-17
C17	a_219_74#	VGND#4	4.46478e-17
C18	X#1	VGND#6	1.7467e-19
C19	a_32_74##10	VPWR#7	3.19294e-17
C20	VGND#6	VGND#4	2.36364e-18
C21	VGND#2	a_32_74#	5.97225e-19
C22	a_32_74##10	a_32_74##11	1.70425e-18
C23	a_219_74#	VGND#6	5.24403e-17
C24	VGND#2	a_32_74##5	8.62218e-18
C25	a_219_74##2	a_219_74#	2.16306e-18
C26	VGND#2	A1#1	6.75575e-18
C27	a_219_74##2	VGND#6	6.1079e-17
C28	a_32_74##10	C1#2	5.34095e-18
C29	a_219_74#	a_32_74##9	2.92859e-18
C30	VGND#2	A2#1	5.84833e-19
C31	X#1	X#2	8.15363e-18
C32	B1#6	a_32_74##12	1.34894e-17
C33	a_32_74##9	VGND#6	2.82923e-18
C34	VGND#2	A3#3	6.88035e-20
C35	a_32_74##9	a_219_74##2	8.37226e-17
C36	X#2	VPWR#1	8.86977e-17
C37	a_32_74#	VGND#1	2.37434e-17
C38	VPWR#2	a_32_74##6	7.89206e-18
C39	VPWR#6	VPWR#1	1.3144e-18
C40	X#1	a_32_74#	5.3683e-17
C41	VGND#1	a_32_74##5	1.3929e-18
C42	VPWR#2	A1#3	4.17592e-18
C43	VPWR#6	X#2	6.80742e-17
C44	VGND#4	a_32_74#	3.14378e-18
C45	a_32_74##5	X#1	1.44908e-17
C46	VGND#1	A1#1	2.89657e-19
C47	a_32_74##5	VGND#4	2.22874e-17
C48	a_32_74##9	a_32_74##12	4.70982e-18
C49	X#1	A1#1	1.68184e-18
C50	A1#1	VGND#4	2.48428e-17
C51	X#1	A2#1	5.28948e-19
C52	VGND#6	a_32_74##5	3.02973e-19
C53	a_219_74#	A1#1	3.63453e-17
C54	VGND#4	A2#1	7.13355e-19
C55	X#1	A3#3	3.09948e-19
C56	a_32_74##10	A2#3	9.50006e-20
C57	a_32_74##12	VPWR#6	2.71209e-18
C58	VGND#6	A1#1	1.37424e-18
C59	a_219_74#	A2#1	4.3352e-17
C60	VGND#4	A3#3	1.65897e-19
C61	VPWR#7	VPWR#6	8.16188e-19
C62	A2#1	VGND#6	3.0159e-17
C63	a_32_74##10	A3#1	1.75256e-19
C64	a_219_74#	A3#3	5.67365e-19
C65	a_219_74##2	A2#1	5.67365e-19
C66	A3#3	VGND#6	3.12871e-17
C67	a_32_74##9	A1#1	2.40629e-19
C68	a_32_74##10	B1#1	1.43922e-17
C69	a_219_74##2	A3#3	5.14536e-17
C70	VGND#6	B1#3	9.79454e-18
C71	a_32_74##9	A2#1	3.92666e-19
C72	VPWR#7	a_32_74##12	4.79973e-17
C73	B1#3	a_219_74##2	1.83327e-17
C74	a_32_74##10	C1#1	2.21984e-17
C75	VGND#6	C1#4	7.3546e-19
C76	a_32_74##9	A3#3	1.93015e-17
C77	a_32_74##11	a_32_74##12	3.0501e-18
C78	VPWR#3	VPWR#2	4.34942e-17
C79	a_219_74##2	C1#4	3.35225e-18
C80	a_32_74##11	VPWR#7	5.24811e-17
C81	a_32_74##9	B1#3	3.46512e-17
C82	B1#6	A3#1	3.69521e-19
C83	a_32_74##9	C1#4	4.80537e-17
C84	A1	a_32_74##2	1.19466e-19
C85	B1#6	B1#1	2.01848e-18
C86	a_32_74##3	VPWR#2	8.87775e-19
C87	B1#6	C1#1	1.4944e-18
C88	a_32_74##5	a_32_74#	3.81903e-17
C89	VGND#2	a_32_74##3	2.12403e-18
C90	a_32_74##4	VPWR#1	3.20346e-17
C91	C1#2	B1#3	4.65913e-18
C92	X#2	a_32_74##4	8.08901e-17
C93	VPWR#1	a_32_74##6	1.39032e-18
C94	A1#1	a_32_74##5	1.96316e-17
C95	VPWR#6	a_32_74##4	1.21875e-18
C96	X#2	a_32_74##6	6.18757e-17
C97	VPWR#1	A1#3	2.86533e-19
C98	a_32_74##6	VPWR#6	2.41517e-17
C99	X#2	A1#3	2.92141e-18
C100	A2#1	A1#1	3.89985e-17
C101	a_32_74##3	A1#4	6.3585e-17
C102	VPWR#6	A1#3	6.73606e-17
C103	B1#6	C1#2	7.36785e-19
C104	X#2	A2#3	2.78329e-19
C105	VPWR#6	A2#3	6.4459e-18
C106	A1#4	A1#2	1.15671e-17
C107	A3#3	A2#1	1.23955e-17
C108	a_32_74##12	A1#3	4.36499e-19
C109	VPWR#6	A3#1	4.55884e-19
C110	A1#4	A2#2	3.42216e-18
C111	VPWR#7	A1#3	1.13216e-19
C112	B1#3	A3#3	2.50596e-17
C113	a_32_74##12	A2#3	5.85932e-18
C114	a_32_74##10	B1#2	1.45678e-17
C115	VPWR#7	A2#3	1.67041e-19
C116	a_32_74##3	X#1	2.92461e-17
C117	a_32_74##12	A3#1	6.48862e-17
C118	a_32_74##3	VGND#4	3.98057e-17
C119	C1#4	B1#3	3.99253e-17
C120	VPWR#7	A3#1	2.54279e-18
C121	a_32_74##10	C1#3	8.58691e-18
C122	a_32_74##3	a_219_74#	6.51279e-17
C123	a_32_74##12	B1#1	3.18155e-17
C124	VPWR#3	VPWR#1	3.33097e-17
C125	B1#6	A3#2	1.69942e-18
C126	a_32_74##3	VGND#6	2.17577e-19
C127	a_32_74##11	A3#1	2.59258e-19
C128	VGND#4	A1#2	8.02726e-19
C129	B1#1	VPWR#7	2.80983e-17
C130	a_32_74##12	C1#1	2.25364e-18
C131	a_32_74##11	B1#1	2.13846e-18
C132	C1#1	VPWR#7	3.50929e-17
C133	B1#6	B1#2	6.43181e-18
C134	a_219_74#	A2#2	5.64443e-19
C135	a_32_74##11	C1#1	3.63095e-17
C136	VGND#6	A2#2	6.79753e-19
C137	a_32_74##3	X#2	2.44448e-17
C138	a_32_74##9	A1#2	8.6777e-20
C139	a_32_74##12	VPWR#3	6.67067e-18
C140	a_32_74##3	VPWR#6	4.43128e-18
C141	VGND#6	A3#2	6.79753e-19
C142	X#2	A1#2	6.98255e-19
C143	a_32_74##6	a_32_74##4	4.78359e-17
C144	a_32_74##9	A2#2	1.48852e-19
C145	a_219_74##2	A3#2	5.64443e-19
C146	A1#2	VPWR#6	3.48726e-18
C147	VGND#6	B1#2	1.03855e-19
C148	a_32_74##9	A3#2	2.90776e-18
C149	A1#3	a_32_74##6	2.66987e-17
C150	a_219_74##2	B1#2	9.76089e-19
C151	X	a_32_74##2	1.37885e-17
C152	a_32_74##9	B1#2	5.87333e-17
C153	a_32_74##3	a_32_74#	8.01122e-19
C154	A2#3	A1#3	3.28244e-17
C155	a_32_74##3	a_32_74##5	7.98785e-18
C156	C1#3	a_32_74##9	8.30079e-18
C157	a_32_74##3	A1#1	2.49257e-17
C158	A3#2	a_32_74##12	3.78182e-18
C159	a_32_74##3	A2#1	1.7073e-17
C160	A3#1	A2#3	5.59273e-17
C161	a_32_74##3	A3#3	2.75607e-20
C162	a_32_74##3	B1#3	2.46128e-20
C163	B1#2	VPWR#7	1.54111e-18
C164	B1#1	A3#1	3.08139e-17
C165	A1	VPWR#2	7.60966e-19
C166	C1#1	B1#1	2.54067e-17
C167	VPWR#3	A2#3	6.14085e-18
C168	VPWR#3	A3#1	7.77703e-18
C169	X#1	a_32_74##2	1.56094e-18
C170	A1#2	a_32_74##6	1.71132e-18
C171	a_32_74##10	A2	1.38246e-18
C172	a_32_74##9	a_135_74#	1.25951e-18
C173	A2	A1#4	2.07583e-17
C174	VGND	a_32_74##2	6.53185e-19
C175	VGND	C1#2	6.51109e-19
C176	B1#6	A3	1.64842e-17
C177	A1	X#2	4.5859e-18
C178	VPWR#3	A2#2	5.38156e-20
C179	A1	VPWR#6	2.11284e-17
C180	C1#1	B1#2	1.83084e-18
C181	A1#2	a_32_74##3	3.35254e-17
C182	A1#3	a_444_368#	2.03405e-18
C183	C1	a_32_74##10	2.76329e-17
C184	a_32_74##3	A2#2	2.91982e-18
C185	A2	X#2	3.22054e-18
C186	A2#3	a_444_368#	2.52298e-17
C187	A2	VPWR#6	4.15141e-17
C188	B1#3	a_135_74#	1.96195e-18
C189	A2#2	A1#2	3.05166e-17
C190	a_32_74##3	A3#2	1.80676e-19
C191	C1#4	a_135_74#	1.48983e-17
C192	a_32_74##9	A3	4.10671e-17
C193	A2#3	a_360_368#	2.17389e-17
C194	a_32_74##12	A2	4.556e-17
C195	a_32_74##3	B1#2	1.45215e-19
C196	A3#1	a_360_368#	1.67053e-18
C197	A3#2	A2#2	2.90381e-17
C198	A3	a_32_74##12	2.61383e-17
C199	A1#4	X	6.42272e-19
C200	B1#2	A3#2	3.74524e-17
C201	VPWR	VPWR#2	3.09713e-17
C202	A1	a_32_74##6	1.40391e-18
C203	a_32_74##9	C1	6.05228e-17
C204	VPWR	a_32_74##10	2.25652e-18
C205	X	VGND#1	3.67515e-17
C206	A1	A1#3	2.58481e-18
C207	A1	A2#3	5.89988e-19
C208	A2	a_32_74##6	7.91453e-19
C209	a_32_74##2	VNB	2.82007e-17
C210	C1#2	VNB	2.12542e-17
C211	A2	A1#3	1.35713e-17
C212	VPWR	B1#6	2.72921e-18
C213	A2	A2#3	3.74104e-17
C214	X	VPWR#1	3.38662e-17
C215	A2	A3#1	1.15737e-17
C216	X	X#2	8.36778e-19
C217	VGND	VGND#2	4.8208e-17
C218	A2	B1#1	2.99323e-19
C219	VGND	a_32_74##10	2.47471e-18
C220	A3	A2#3	5.38552e-19
C221	A2	C1#1	1.62907e-19
C222	A3	A3#1	4.63975e-18
C223	VGND	A1#4	3.47421e-18
C224	A1	a_32_74##3	8.03468e-19
C225	A3	B1#1	5.57291e-19
C226	A2	VPWR#3	1.17213e-17
C227	X	a_32_74#	1.26382e-18
C228	VPWR	VPWR#1	4.27637e-17
C229	A1	A1#2	7.62041e-18
C230	VPWR	X#2	1.67462e-17
C231	X	a_32_74##5	2.90794e-19
C232	VPWR	VPWR#6	2.04034e-17
C233	A1	A2#2	2.01309e-18
C234	a_32_74##3	A2	4.31288e-17
C235	VGND	VGND#1	3.72151e-17
C236	A3	VPWR#3	6.3307e-19
C237	VGND	X#1	1.41905e-17
C238	VPWR	a_32_74##12	1.76196e-17
C239	A2	A1#2	2.28167e-18
C240	VGND	a_219_74#	1.78186e-17
C241	VGND	VGND#6	5.95196e-17
C242	VPWR	a_32_74##11	1.58356e-17
C243	A2	A2#2	1.70351e-17
C244	VGND	a_219_74##2	1.80506e-17
C245	VGND	a_32_74##9	3.29243e-17
C246	A2	A3#2	2.97831e-18
C247	VGND	X#2	3.56935e-18
C248	A3	A2#2	3.59536e-18
C249	A3	A3#2	1.5467e-17
C250	B1#2	A3	2.32366e-17
C251	VPWR	a_32_74##4	2.4892e-19
C252	VPWR	a_32_74##6	2.07375e-18
C253	VGND	A1#1	1.39946e-18
C254	VPWR	A1#3	9.72143e-19
C255	VGND	A2#1	1.21569e-19
C256	VPWR	A2#3	2.11877e-19
C257	VGND	A3#3	3.19535e-19
C258	VPWR#2	VNB	3.39753e-17
C259	VPWR	A3#1	2.53128e-18
C260	VGND	B1#3	1.42969e-18
C261	VGND#2	VNB	3.3699e-17
C262	VGND	C1#4	1.43015e-18
C263	VPWR	B1#1	5.49988e-18
C264	a_32_74##10	VNB	2.42558e-17
C265	a_32_74##3	X	1.5325e-17
C266	VPWR	C1#1	9.36822e-18
C267	X	A1#2	1.87046e-19
C268	A1#4	VNB	1.56399e-18
C269	C1	C1#3	2.27072e-17
C270	VPWR	VPWR#3	2.64255e-17
C271	B1#6	VNB	1.87109e-18
C272	VPWR	a_32_74##3	5.04649e-18
C273	VGND#1	VNB	5.2433e-17
C274	X#1	VNB	5.83151e-18
C275	VGND#4	VNB	3.2056e-18
C276	A2	A1	2.45175e-17
C277	a_32_74##10	B1#6	3.51105e-17
C278	a_219_74#	VNB	1.93806e-18
C279	VGND#6	VNB	5.71793e-17
C280	a_219_74##2	VNB	2.64963e-18
C281	a_32_74##9	VNB	4.6488e-17
C282	VPWR#1	VNB	7.57734e-17
C283	X#2	VNB	5.28315e-18
C284	VPWR#6	VNB	1.09661e-18
C285	VGND	a_32_74##3	1.32854e-17
C286	VPWR	C1#3	2.31046e-18
C287	A3	A2	3.69684e-17
C288	a_32_74##12	VNB	3.12968e-18
C289	VPWR#7	VNB	9.13191e-18
C290	a_32_74##11	VNB	3.3103e-17
C291	a_32_74#	VNB	3.71187e-17
C292	a_32_74##5	VNB	2.95298e-17
C293	A1#1	VNB	2.9943e-17
C294	A2#1	VNB	2.90392e-17
C295	VGND	B1#2	3.15012e-18
C296	A3#3	VNB	2.9821e-17
C297	B1#3	VNB	3.11005e-17
C298	VGND	C1#3	1.39648e-18
C299	C1#4	VNB	3.68287e-17
C300	a_32_74##4	VNB	4.35636e-17
C301	A1	X	9.79465e-19
C302	a_32_74##6	VNB	3.93371e-17
C303	A1#3	VNB	3.09362e-17
C304	A2#3	VNB	3.20189e-17
C305	A3#1	VNB	3.76583e-17
C306	B1#1	VNB	3.20579e-17
C307	VPWR	A1	5.02424e-18
C308	C1#1	VNB	5.04537e-17
C309	VPWR#3	VNB	2.1265e-16
C310	VPWR	A2	1.59877e-17
C311	a_32_74##3	VNB	4.48956e-17
C312	VPWR	A3	4.74347e-18
C313	A1#2	VNB	3.18948e-17
C314	A2#2	VNB	2.82041e-17
C315	A3#2	VNB	2.73619e-17
C316	VGND	A2	4.06382e-18
C317	B1#2	VNB	3.23697e-17
C318	C1#3	VNB	4.94682e-17
C319	VGND	A3	2.67512e-18
C320	VPWR	C1	4.525e-18
C321	VPWR	X	1.75715e-18
C322	VGND	C1	5.68051e-18
C323	VGND	X	5.89247e-18
C324	A1	VNB	1.6756e-18
C325	A2	VNB	2.97287e-18
C326	A3	VNB	3.64232e-18
C327	C1	VNB	2.60448e-17
C328	X	VNB	5.72915e-17
C329	VPWR	VNB	7.77208e-17
C330	VGND	VNB	6.30517e-17
C331	VPWR#4	A3#1	1.37874e-18
C332	VPWR#4	A3#2	6.67361e-20
C333	a_32_74##10	VPWR#4	8.6303e-20
C334	VPWR#4	VNB	6.11964e-17
C335	VPWR#4	A1#3	4.60868e-20
C336	VGND#3	VGND#1	3.13015e-17
C337	a_32_74##11	VPWR#4	1.51054e-17
C338	VPWR#4	VPWR#2	1.97628e-19
C339	a_32_74##12	VPWR#4	1.42395e-17
C340	VGND	VGND#3	2.31848e-17
C341	VGND#3	a_32_74##9	3.4546e-17
C342	VPWR#4	B1#1	4.33271e-18
C343	VPWR#4	A2#3	1.07219e-19
C344	VGND#3	VNB	2.21824e-16
C345	VPWR	VPWR#4	6.55693e-17
C346	VGND#3	VGND#2	4.32232e-17
C347	VGND#3	C1	1.52323e-18
C348	VPWR#3	VPWR#4	6.7415e-17
C349	C1	VPWR#4	6.03527e-19
C350	VGND#3	VGND#6	6.97684e-17
C351	VGND#3	C1#3	8.36352e-19
C352	VPWR#4	C1#1	4.27901e-18
C353	VPWR#4	C1#3	1.08089e-18
C354	VPWR#4	VPWR#6	5.28111e-20
C355	VGND#3	C1#4	5.31202e-18
*
*
.ENDS sky130_fd_sc_hs__o311a_2
*
