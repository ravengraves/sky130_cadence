* Extracted by Quantus, converted by sky130cad/quantus.py
*
*
*
*                       LINUX           Wed Nov 18 08:54:05 2026
*
*
*
*  PROGRAM  advgen
*
*  Name           : advgen - Quantus - (64-bit)
*  Version        : 25.1.0-p047
*  Build Date     : Thu Dec 11 23:20:30 PST 2025
*
*  HSPICE LIBRARY
*
*  OPERATING_TEMPERATURE 150
*  QRC_TECH_DIR <path>/tech
*
*
*

*
.SUBCKT sky130_fd_sc_hs__o211a_4 VNB VPB VGND VPWR X B1 C1 A2 A1
*
*
*  caps2d version: 10
*
*
*       TRANSISTOR CARDS
*
*
XM2 VGND#7 a_91_48##8 X#5 VNB sky130_fd_pr__nfet_01v8_lvt l=0.15 w=0.74 ad=0.2109 as=0.2072 pd=2.05 ps=2.04
XM8 X#5 a_91_48##12 VGND#11 VNB sky130_fd_pr__nfet_01v8_lvt l=0.15 w=0.74 ad=0.2072 as=0.259 pd=2.04 ps=2.18
XM9 X#6 a_91_48##11 VGND#11 VNB sky130_fd_pr__nfet_01v8_lvt l=0.15 w=0.74 ad=0.2072 as=0.259 pd=2.04 ps=2.18
XM10 VGND#10 a_91_48##9 X#6 VNB sky130_fd_pr__nfet_01v8_lvt l=0.15 w=0.74 ad=0.2109 as=0.2072 pd=2.05 ps=2.04
XM7 a_510_125##5 B1#6 a_597_125##2 VNB sky130_fd_pr__nfet_01v8_lvt l=0.15 w=0.64 ad=0.1817 as=0.1792 pd=1.85 ps=1.84
XM14 a_91_48##19 C1#6 a_597_125##2 VNB sky130_fd_pr__nfet_01v8_lvt l=0.15 w=0.64 ad=0.1792 as=0.1792 pd=1.84 ps=1.84
XM16 a_597_125# C1#1 a_91_48##19 VNB sky130_fd_pr__nfet_01v8_lvt l=0.15 w=0.64 ad=0.224 as=0.1792 pd=1.98 ps=1.84
XM21 a_597_125# B1#2 a_510_125##3 VNB sky130_fd_pr__nfet_01v8_lvt l=0.15 w=0.64 ad=0.224 as=0.2304 pd=1.98 ps=2
XM23 VGND#9 A1#4 a_510_125##3 VNB sky130_fd_pr__nfet_01v8_lvt l=0.15 w=0.64 ad=0.1984 as=0.2304 pd=1.9 ps=2
XM17 VGND#9 A2#7 a_510_125##6 VNB sky130_fd_pr__nfet_01v8_lvt l=0.15 w=0.64 ad=0.1984 as=0.2144 pd=1.9 ps=1.95
XM20 a_510_125##6 A2#1 VGND#8 VNB sky130_fd_pr__nfet_01v8_lvt l=0.15 w=0.64 ad=0.2144 as=0.224 pd=1.95 ps=1.98
XM11 a_510_125# A1#3 VGND#8 VNB sky130_fd_pr__nfet_01v8_lvt l=0.15 w=0.64 ad=0.1824 as=0.224 pd=1.85 ps=1.98
XM4 VPWR#6 a_91_48##14 X#3 VPB sky130_fd_pr__pfet_01v8 l=0.15 w=1.12 ad=0.3864 as=0.336 pd=2.93 ps=2.84
XM6 X#3 a_91_48##13 VPWR#10 VPB sky130_fd_pr__pfet_01v8 l=0.15 w=1.12 ad=0.336 as=0.448 pd=2.84 ps=3.04
XM18 VPWR#10 a_91_48##10 X#1 VPB sky130_fd_pr__pfet_01v8 l=0.15 w=1.12 ad=0.448 as=0.336 pd=3.04 ps=2.84
XM19 X#1 a_91_48# VPWR#9 VPB sky130_fd_pr__pfet_01v8 l=0.15 w=1.12 ad=0.336 as=0.5578 pd=2.84 ps=3.36
XM13 a_91_48##21 B1#5 VPWR#9 VPB sky130_fd_pr__pfet_01v8 l=0.15 w=0.84 ad=0.252 as=0.5578 pd=2.28 ps=3.36
XM0 VPWR#8 C1#4 a_91_48##21 VPB sky130_fd_pr__pfet_01v8 l=0.15 w=0.84 ad=0.3486 as=0.252 pd=2.51 ps=2.28
XM3 a_91_48##20 C1#5 VPWR#8 VPB sky130_fd_pr__pfet_01v8 l=0.15 w=0.84 ad=0.252 as=0.3486 pd=2.28 ps=2.51
XM15 VPWR#7 B1#1 a_91_48##20 VPB sky130_fd_pr__pfet_01v8 l=0.15 w=0.84 ad=0.4206 as=0.252 pd=2.87 ps=2.28
XM1 VPWR#7 A1#5 a_968_391##2 VPB sky130_fd_pr__pfet_01v8 l=0.15 w=1 ad=0.4206 as=0.3 pd=2.87 ps=2.6
XM5 a_968_391##2 A2#5 a_91_48##15 VPB sky130_fd_pr__pfet_01v8 l=0.15 w=1 ad=0.3 as=0.35 pd=2.6 ps=2.7
XM12 a_91_48##15 A2#6 a_968_391# VPB sky130_fd_pr__pfet_01v8 l=0.15 w=1 ad=0.35 as=0.3 pd=2.7 ps=2.6
XM22 a_968_391# A1#1 VPWR#1 VPB sky130_fd_pr__pfet_01v8 l=0.15 w=1 ad=0.3 as=0.345 pd=2.6 ps=2.69
*
*
*       RESISTOR AND CAP/DIODE CARDS
*
Rg1	a_91_48#	a_91_48##2	465.854401
Rg2	a_91_48##2	a_91_48##3	48.870445
Rg3	a_91_48##3	a_91_48##4	26.825764
Rg4	a_91_48##4	a_91_48##5	25.038866
Rg5	a_91_48##5	a_91_48##6	52.800449
Rg6	a_91_48##6	a_91_48##7	76.896950
Rg7	a_91_48##7	a_91_48##8	365.821045
Rg8	a_91_48##2	a_91_48##9	359.320251
Rg9	a_91_48##3	a_91_48##10	411.085419
Rg10	a_91_48##4	a_91_48##11	379.087921
Rg11	a_91_48##6	a_91_48##12	414.365143
Rg12	a_91_48##6	a_91_48##13	457.404785
Rg13	a_91_48##7	a_91_48##14	469.818115
Rg14	C1#1	C1#2	342.894104
Rg15	C1#2	C1#3	37.729713
Rg16	C1#3	C1#4	375.864197
Rg17	C1#2	C1#5	337.506409
Rg18	C1#3	C1#6	310.812256
Rg19	B1#1	B1#2	820.740967
Rg20	B1#2	B1#3	2165.218750
Rg21	B1#3	B1#4	22.987724
Rg22	B1#4	B1#5	363.415497
Rg23	B1#3	B1#6	282.321686
Rg24	A2#1	A2#2	334.700989
Rg25	A2#2	A2#3	24.690777
Rg26	A2#3	A2#4	38.488544
Rg27	A2#4	A2#5	478.685547
Rg28	A2#2	A2#6	421.490570
Rg29	A2#4	A2#7	394.834656
Rg30	A1#1	A1#2	406.869812
Rg31	A1#2	A1#3	322.284241
Rg32	A1#3	A1#4	1611.541626
Rg33	A1#4	A1#5	796.488403
Rf1	X#1	X#2	91.318153
Rf2	X#2	X	46.464069
Rf3	X#2	X#3	21.948624
Rf4	X	X#4	42.464405
Rf5	X#4	X#5	18.783115
Rf6	X#4	X#6	85.726288
Rf7	B1#4	B1	162.791672
Rf8	C1#2	C1	162.201172
Rf9	a_597_125#	a_597_125##2	99.204887
Rf10	a_91_48##15	a_91_48##16	123.973167
Rf11	a_91_48##16	a_91_48##17	73.338890
Rf12	a_91_48##17	a_91_48##5	160.249023
Rf13	a_91_48##16	a_91_48##19	98.345398
Rf14	a_91_48##16	a_91_48##20	21.552395
Rf15	a_91_48##17	a_91_48##21	17.854607
Rf16	A2	A2#8	0.787345
Rf17	A2#8	A2	18.108944
Rf18	a_968_391#	a_968_391##2	114.586929
Rf19	A1#2	A1#7	160.868759
Rf20	A1#8	A1	0.635961
Rf21	A1#7	A1#8	9.448145
Rf22	a_510_125#	a_510_125##2	81.350082
Rf23	a_510_125##2	a_510_125##4	76.508087
Rf24	a_510_125##4	a_510_125##5	194.256226
Rf25	a_510_125##2	a_510_125##6	16.097075
Rf26	a_510_125##3	a_510_125##4	7.500000
Rf27	VPWR#1	VPWR#2	174.593079
Rf28	VPWR#2	VPWR#3	84.312263
Rf29	VPWR#3	VPWR#4	79.490936
Rf30	VPWR#4	VPWR#5	73.001427
Rf31	VPWR#5	VPWR#6	105.413460
Rf32	VPWR#2	VPWR#7	32.518913
Rf33	VPWR#3	VPWR#8	49.618740
Rf34	VPWR#4	VPWR#9	32.518913
Rf35	VPWR#5	VPWR#10	34.487274
Rf37	VGND#2	VGND#3	68.427391
Rf38	VGND#3	VGND#4	119.952515
Rf39	VGND#4	VGND#5	91.653839
Rf40	VGND#5	VGND#6	67.887894
Rf41	VGND#6	VGND#7	105.942245
Rf42	VGND#2	VGND#8	41.987278
Rf43	VGND#3	VGND#9	40.868980
Rf44	VGND#5	VGND#10	33.306259
Rf45	VGND#6	VGND#11	34.113823
Rf49	A2#3	A2#8	80.116402
Re1	VPWR#3	VPWR	0.701577
Re2	VGND	VGND#4	0.701602
*
*       CAPACITOR CARDS
*
*
C1	X#5	X#6	2.43346e-18
C2	VPWR#5	VPWR#4	9.53351e-19
C3	a_510_125##2	A2#1	1.77153e-17
C4	VPWR#4	B1#3	5.55799e-20
C5	VPWR#5	a_91_48##7	5.02826e-20
C6	VGND#3	a_510_125##2	2.02844e-19
C7	A1#7	A1#3	1.42225e-19
C8	X#5	VGND#11	3.83514e-17
C9	VPWR#3	B1#3	1.2521e-19
C10	a_510_125##2	A2#7	1.40303e-17
C11	a_510_125##5	B1#3	3.44651e-17
C12	VPWR#5	a_91_48##6	3.82142e-20
C13	VGND#7	VGND#11	2.83393e-18
C14	X#2	X#1	1.64357e-18
C15	a_510_125##5	C1#3	3.22445e-19
C16	a_510_125##2	A1#4	4.11797e-19
C17	B1#3	B1#2	2.61183e-19
C18	VGND#7	X#5	3.77155e-17
C19	X#2	VPWR#10	2.76076e-17
C20	B1#2	C1#3	1.89218e-17
C21	a_510_125##5	a_91_48##7	7.27553e-20
C22	VGND#6	a_91_48##9	2.72115e-19
C23	VGND#4	B1#3	4.95929e-18
C24	VGND#10	B1#3	1.83793e-17
C25	VGND#4	C1#3	3.96055e-19
C26	VGND#5	a_91_48##9	3.78885e-18
C27	X#2	X#3	2.08835e-19
C28	a_510_125##5	a_91_48##6	7.99522e-20
C29	VGND#6	a_91_48##11	4.36932e-18
C30	X#2	VPWR#6	3.82392e-18
C31	a_968_391#	VPWR#1	1.34116e-16
C32	VGND#6	a_91_48##12	4.0113e-18
C33	a_91_48##16	A1#4	2.79434e-19
C34	a_510_125#	A1#3	4.71435e-17
C35	a_91_48##17	B1#2	4.15879e-19
C36	VGND#6	a_91_48##8	2.57707e-18
C37	A1#3	VGND#8	2.34666e-17
C38	B1#3	C1#6	2.94343e-18
C39	a_968_391#	a_91_48##15	7.35148e-17
C40	a_91_48##7	a_91_48##6	4.0559e-18
C41	a_510_125#	A2#1	1.74875e-18
C42	a_91_48##16	B1#2	5.41364e-18
C43	a_510_125##6	A1#3	4.34307e-18
C44	A2#4	A2#3	2.72366e-18
C45	a_968_391##2	a_968_391#	2.41843e-18
C46	VGND#8	A2#1	3.11075e-17
C47	VPWR#7	VPWR#1	8.03431e-20
C48	VGND#9	A1#3	9.11885e-19
C49	a_510_125#	A2#7	2.54292e-19
C50	A2#1	a_510_125##6	1.51782e-17
C51	a_91_48##15	a_968_391##2	9.62916e-17
C52	VGND#8	A2#7	2.10087e-18
C53	VGND#9	A2#1	1.45183e-18
C54	B1#3	B1#6	3.98244e-17
C55	A2#7	a_510_125##6	1.83895e-17
C56	a_510_125##3	A2#1	2.38039e-19
C57	VGND#8	A1#4	1.10524e-18
C58	VGND#9	A2#7	3.17979e-17
C59	a_91_48##19	A1#3	1.9339e-19
C60	VPWR#7	a_968_391##2	6.77661e-17
C61	a_91_48##20	a_91_48##15	1.61237e-18
C62	VGND#6	X#4	3.59283e-19
C63	a_510_125##6	A1#4	4.94338e-18
C64	a_510_125##3	A2#7	5.45367e-19
C65	a_91_48##19	A2#1	1.47964e-19
C66	VGND#9	A1#4	2.82784e-17
C67	a_510_125##6	B1#2	2.4872e-19
C68	a_510_125##3	A1#4	3.55091e-17
C69	a_91_48##20	VPWR#7	4.08472e-17
C70	a_91_48##17	VPWR#4	9.45413e-19
C71	a_91_48##9	B1#3	3.31704e-17
C72	a_91_48##19	A2#7	2.39131e-19
C73	VGND#9	B1#2	9.07525e-19
C74	a_597_125#	A1#4	6.89007e-19
C75	VPWR#8	VPWR#7	2.7575e-18
C76	a_510_125##3	B1#2	5.1363e-17
C77	a_91_48##19	A1#4	2.20642e-18
C78	VGND#7	B1#3	2.53593e-20
C79	a_597_125#	B1#2	3.71995e-17
C80	VPWR#8	a_91_48##20	4.47473e-17
C81	a_510_125##3	C1#1	7.76897e-18
C82	a_91_48##19	B1#2	1.34189e-17
C83	a_91_48##21	a_91_48##20	3.086e-18
C84	a_91_48##16	VPWR#2	4.79355e-19
C85	a_510_125##5	A1#4	9.15931e-20
C86	a_597_125#	C1#1	2.91869e-17
C87	a_597_125##2	B1#2	2.16212e-18
C88	a_510_125##3	C1#6	3.30919e-19
C89	a_91_48##21	VPWR#8	4.82043e-17
C90	a_91_48##19	C1#1	3.68832e-17
C91	a_510_125##5	B1#2	1.03569e-17
C92	a_597_125#	C1#6	4.62933e-19
C93	VPWR#2	A2#5	4.35391e-18
C94	X#4	a_91_48##12	1.75834e-17
C95	a_597_125##2	C1#1	4.01042e-19
C96	VPWR#9	VPWR#8	2.39957e-18
C97	a_91_48##5	B1#3	4.49083e-17
C98	a_510_125##3	B1#6	2.02372e-19
C99	VGND#10	B1#2	7.72572e-20
C100	a_91_48##19	C1#6	2.62263e-17
C101	a_91_48##5	C1#3	7.15752e-19
C102	a_510_125##5	C1#1	3.5662e-19
C103	a_91_48##5	a_91_48##7	9.58869e-18
C104	a_968_391#	A1#3	7.37856e-19
C105	a_597_125#	B1#6	2.02452e-19
C106	a_91_48##5	a_91_48##6	1.37656e-17
C107	VPWR#9	a_91_48##21	2.76073e-17
C108	VGND#3	VGND#8	4.35318e-19
C109	a_597_125##2	C1#6	4.17221e-17
C110	X#4	a_91_48##8	2.48788e-17
C111	VPWR#2	A1#5	4.21009e-18
C112	a_91_48##19	B1#6	1.02129e-18
C113	X#2	VPWR#5	1.34496e-19
C114	a_510_125##5	C1#6	9.24532e-18
C115	X#1	a_91_48##21	2.5367e-18
C116	a_91_48##16	A1#1	2.15567e-19
C117	a_597_125##2	B1#6	1.22901e-17
C118	VGND#3	a_510_125##6	2.62717e-18
C119	VPWR#2	B1#1	4.22539e-18
C120	X#1	VPWR#9	6.76347e-17
C121	B1#6	a_510_125##5	2.70186e-17
C122	a_91_48##16	A2#6	2.56231e-19
C123	VGND#10	B1#6	1.08622e-18
C124	VPWR#10	VPWR#9	1.69573e-18
C125	a_510_125##5	a_91_48##9	1.32542e-18
C126	a_91_48##15	A1#4	1.88054e-19
C127	X#1	VPWR#10	7.94215e-17
C128	a_91_48##16	A2#5	3.88886e-19
C129	VGND#10	a_91_48##9	3.54548e-17
C130	a_510_125##5	a_91_48##11	2.63481e-20
C131	a_968_391##2	A1#4	3.08861e-19
C132	X#6	a_91_48##9	1.3016e-17
C133	X#3	X#1	9.70615e-19
C134	VGND#3	a_510_125##3	4.97413e-17
C135	VGND#10	a_91_48##11	2.58945e-18
C136	a_91_48##16	A1#5	1.53662e-17
C137	VGND#11	a_91_48##9	4.55311e-19
C138	X#3	VPWR#10	7.31559e-17
C139	a_510_125##5	a_91_48##12	1.64607e-20
C140	X#6	a_91_48##11	4.90209e-17
C141	VPWR#4	B1#5	4.21605e-18
C142	VGND#10	a_91_48##12	3.17193e-19
C143	VPWR#7	B1#2	5.16731e-19
C144	VPWR#6	VPWR#10	1.69608e-18
C145	a_91_48##11	VGND#11	1.76742e-17
C146	a_91_48##16	B1#1	2.45619e-17
C147	a_510_125##5	a_91_48##8	1.4979e-20
C148	X#6	a_91_48##12	1.18611e-18
C149	X#5	a_91_48##11	7.43048e-19
C150	VPWR#6	X#3	7.51213e-17
C151	a_91_48##17	B1#3	1.47395e-17
C152	VGND#11	a_91_48##12	3.25896e-17
C153	VPWR#4	a_91_48#	4.6495e-18
C154	a_91_48##16	A2#4	1.15594e-18
C155	X#6	a_91_48##8	1.92637e-19
C156	a_91_48##16	C1#5	1.84792e-17
C157	a_91_48##12	X#5	1.22903e-17
C158	VGND#11	a_91_48##8	1.89135e-18
C159	VPWR#5	a_91_48##10	2.59781e-18
C160	a_91_48##17	C1#3	6.65837e-18
C161	VGND#7	a_91_48##12	1.21692e-18
C162	a_91_48##17	C1#4	1.80584e-17
C163	a_510_125##2	VGND#8	1.53179e-17
C164	X#5	a_91_48##8	3.20029e-17
C165	a_91_48##8	VGND#7	2.04596e-17
C166	VPWR#5	a_91_48##13	2.57176e-18
C167	a_91_48##17	B1#5	1.84706e-17
C168	VGND#5	a_510_125##5	1.81471e-17
C169	A1#3	A2#1	4.13719e-17
C170	a_510_125##2	a_510_125##6	5.91793e-19
C171	a_91_48##16	B1#5	2.27169e-19
C172	VGND#6	VGND#10	5.79011e-20
C173	a_510_125#	A1#7	3.09262e-17
C174	a_91_48##16	C1#3	1.19561e-17
C175	a_510_125##2	VGND#9	2.06701e-17
C176	A2#7	A2#1	2.70577e-17
C177	a_91_48##16	a_91_48#	9.29032e-20
C178	A1#4	A1#3	5.95569e-19
C179	VGND#6	X#6	5.86038e-18
C180	VPWR#1	A1#1	3.56811e-17
C181	a_968_391#	A1#1	5.03552e-17
C182	VGND#5	X#6	6.92636e-18
C183	VPWR#1	A2#6	5.16176e-18
C184	A1#4	A2#7	4.66031e-17
C185	a_91_48##15	A1#1	1.94161e-18
C186	a_968_391#	A2#6	3.36546e-17
C187	a_968_391##2	A1#1	2.00227e-19
C188	VGND#4	VGND#6	4.57658e-17
C189	VPWR#1	A2#5	1.85238e-19
C190	a_91_48##15	A2#6	5.36367e-17
C191	VPWR#3	VPWR#5	4.54001e-17
C192	VGND#4	VGND#5	4.56649e-17
C193	VPWR#7	A1#1	2.25855e-19
C194	VPWR#3	VPWR#4	4.39979e-17
C195	a_968_391#	A2#5	3.97021e-19
C196	B1#2	A1#4	5.22855e-17
C197	X#2	a_91_48##10	5.18568e-19
C198	VGND#4	VGND#3	5.39382e-17
C199	a_968_391##2	A2#6	1.20309e-18
C200	VPWR#3	VPWR#2	6.64574e-17
C201	VPWR#1	A1#5	1.06171e-19
C202	VGND#6	X#5	1.36893e-17
C203	a_91_48##15	A2#5	3.3321e-17
C204	VPWR#7	A2#6	1.85238e-19
C205	a_968_391##2	A2#5	5.70352e-17
C206	a_91_48##20	A2#6	1.39505e-19
C207	X#2	a_91_48##13	1.65978e-17
C208	B1#2	C1#1	4.23909e-17
C209	a_91_48##15	A1#5	1.06164e-17
C210	VPWR#7	A2#5	3.77405e-19
C211	a_968_391##2	A1#5	4.31248e-17
C212	VGND#7	VGND#6	1.14454e-18
C213	a_91_48##20	A2#5	2.2815e-19
C214	B1#2	C1#6	1.63232e-17
C215	a_91_48##15	B1#1	2.73969e-19
C216	X#2	a_91_48##14	2.28378e-17
C217	A1#5	VPWR#7	2.99194e-17
C218	C1#6	C1#1	3.48653e-17
C219	a_968_391##2	B1#1	1.03979e-19
C220	a_91_48##20	A1#5	1.44094e-18
C221	A1#5	A2#4	1.55683e-17
C222	VGND#3	A2#3	2.59286e-19
C223	a_91_48##17	VPWR#3	1.7231e-19
C224	B1#1	VPWR#7	2.91751e-17
C225	a_91_48##16	VPWR#3	2.48329e-19
C226	VPWR#8	A1#5	2.65906e-19
C227	VPWR#8	C1#3	2.15516e-18
C228	X#4	X#2	4.09732e-18
C229	a_91_48##20	B1#1	4.2254e-17
C230	B1#6	C1#6	3.32516e-17
C231	VPWR#7	C1#5	7.56053e-19
C232	VPWR#8	B1#1	1.34784e-18
C233	VPWR#2	A2#3	3.9411e-20
C234	A1#7	A1#2	1.45755e-17
C235	a_91_48##20	C1#5	3.6902e-17
C236	A2	A2#4	1.29384e-17
C237	a_510_125##2	A2#3	6.16577e-18
C238	VPWR#7	C1#4	3.61559e-19
C239	C1#5	VPWR#8	2.57993e-17
C240	a_91_48##20	C1#4	1.74823e-18
C241	a_91_48##21	C1#5	9.20503e-19
C242	a_91_48##16	A1#2	6.60408e-20
C243	A1#7	A2#3	3.40331e-18
C244	C1#4	VPWR#8	2.91375e-17
C245	VPWR#9	C1#5	3.04937e-19
C246	a_510_125##3	a_91_48##16	1.31012e-17
C247	a_91_48##21	C1#4	4.26808e-17
C248	X#4	a_91_48##7	2.30665e-18
C249	a_91_48##11	a_91_48##9	3.92446e-17
C250	VPWR#8	B1#5	8.57475e-19
C251	VPWR#9	C1#4	5.92126e-19
C252	VGND#6	a_91_48##5	2.66897e-20
C253	VGND#5	a_91_48##5	6.0367e-19
C254	a_91_48##16	A2#3	7.76013e-20
C255	C1#3	B1#1	1.03639e-17
C256	a_91_48##21	B1#5	3.77723e-17
C257	a_597_125#	a_91_48##16	1.52816e-18
C258	a_510_125#	A1#2	3.75429e-18
C259	VGND#4	a_510_125##3	3.04653e-17
C260	a_91_48##19	a_91_48##17	1.86107e-18
C261	X#4	a_91_48##6	6.87289e-19
C262	VPWR#8	a_91_48#	2.38498e-19
C263	B1#5	VPWR#9	2.30657e-17
C264	a_91_48##12	a_91_48##11	2.36489e-17
C265	VGND#8	A1#2	2.52677e-19
C266	a_91_48##21	a_91_48#	1.50468e-18
C267	C1	B1#3	2.40399e-18
C268	VPWR#5	a_91_48##5	4.57114e-20
C269	X#1	B1#5	1.13516e-18
C270	a_510_125#	VGND#8	5.03157e-17
C271	B1#3	VPWR#9	1.5485e-18
C272	C1	C1#3	2.2902e-17
C273	a_91_48##5	VPWR#4	2.94947e-19
C274	a_91_48#	VPWR#9	3.62195e-17
C275	a_91_48##19	a_91_48##16	2.09836e-18
C276	a_597_125##2	a_91_48##17	1.14573e-17
C277	B1#2	A1#5	2.64619e-18
C278	VGND#4	a_510_125##5	6.10145e-17
C279	a_91_48##8	a_91_48##12	3.91018e-17
C280	X#1	a_91_48#	6.30629e-17
C281	X#2	a_91_48##7	2.30737e-18
C282	a_91_48##19	A1#2	8.51998e-20
C283	VPWR#9	a_91_48##10	1.25159e-18
C284	VPWR#10	a_91_48#	1.2717e-18
C285	a_510_125##6	a_510_125#	3.15328e-18
C286	X#1	a_91_48##10	6.43312e-17
C287	VPWR#3	VPWR#1	4.85568e-17
C288	VPWR#2	VPWR#1	2.12106e-19
C289	a_510_125##5	a_91_48##17	2.46716e-18
C290	a_91_48##10	VPWR#10	3.16592e-17
C291	VPWR#9	a_91_48##13	2.8528e-19
C292	a_91_48##19	A2#3	6.51868e-20
C293	X#2	a_91_48##6	4.54805e-18
C294	a_510_125##6	VGND#8	3.00055e-17
C295	VGND#4	VGND#7	2.40774e-17
C296	X#1	a_91_48##13	5.19482e-19
C297	X#3	a_91_48##10	3.06241e-19
C298	a_91_48##5	a_91_48##16	7.9812e-19
C299	a_91_48##13	VPWR#10	3.68577e-17
C300	B1	B1#3	2.31483e-17
C301	VPWR#6	a_91_48##10	2.8528e-19
C302	B1	C1#3	5.27288e-18
C303	VPWR#3	VPWR#7	3.0443e-18
C304	X#3	a_91_48##13	5.66136e-17
C305	a_968_391#	VPWR#2	6.48691e-18
C306	X#4	a_91_48##5	5.4795e-17
C307	a_91_48##20	VPWR#3	4.54594e-18
C308	VGND#9	VGND#8	6.38594e-18
C309	VPWR#6	a_91_48##13	1.34947e-18
C310	VPWR#10	a_91_48##14	1.4381e-18
C311	VPWR#1	A1#2	4.37454e-18
C312	a_91_48##5	X#2	7.19799e-17
C313	X#3	a_91_48##14	4.86435e-17
C314	A2#6	A1#1	4.19359e-17
C315	a_91_48##21	VPWR#3	6.93152e-18
C316	a_91_48##14	VPWR#6	3.13125e-17
C317	VPWR#9	VPWR#3	2.57154e-18
C318	VGND#9	a_510_125##6	3.12157e-17
C319	a_91_48##15	VPWR#2	3.55639e-19
C320	C1#4	C1#3	4.27192e-19
C321	a_968_391#	A2#3	8.55034e-20
C322	A2#5	A2#6	3.02833e-17
C323	a_510_125##2	a_968_391#	4.6168e-18
C324	a_91_48##15	A2#3	4.44324e-18
C325	a_91_48##5	a_91_48##19	2.5072e-18
C326	a_968_391##2	A2#3	2.92928e-19
C327	X	B1#3	2.1601e-19
C328	a_510_125##3	a_510_125##6	3.04958e-18
C329	X	a_91_48##7	1.69321e-17
C330	VPWR#3	VPWR#6	2.96384e-17
C331	VGND#6	B1#3	3.98825e-19
C332	X	a_91_48##6	4.37499e-19
C333	a_510_125##5	a_91_48##5	3.63465e-19
C334	a_968_391##2	VPWR#2	4.99192e-17
C335	a_91_48##5	VGND#10	4.5091e-17
C336	A1#5	A2#5	4.1718e-17
C337	a_91_48##5	X#6	5.92887e-17
C338	A1#7	VPWR#1	1.78595e-17
C339	a_91_48##5	VGND#11	5.07848e-18
C340	a_510_125##3	VGND#9	5.99227e-17
C341	a_91_48##5	X#5	2.51339e-18
C342	B1#1	A1#5	2.98601e-17
C343	B1#5	C1#3	5.43178e-18
C344	A1#3	A1#2	3.19722e-19
C345	A1#7	a_968_391#	1.76475e-17
C346	C1#5	B1#1	3.59357e-17
C347	VGND#4	B1#2	2.41453e-17
C348	VGND#6	VGND#5	1.13428e-18
C349	A1#3	A2#3	4.90564e-19
C350	VPWR	C1#3	2.66761e-19
C351	VGND#4	C1#1	1.3447e-18
C352	VGND#5	B1#3	1.80721e-17
C353	a_91_48##20	VPWR#2	4.42879e-18
C354	VGND#6	a_91_48##7	7.22129e-20
C355	VGND#4	C1#6	1.3958e-18
C356	a_510_125##3	a_597_125#	7.97805e-17
C357	C1#4	C1#5	2.20497e-17
C358	VGND#4	B1#6	1.09194e-18
C359	A1#4	A2#3	6.70543e-19
C360	a_91_48##5	VPWR#9	1.85272e-17
C361	X#1	a_91_48##5	9.70937e-17
C362	X#4	VGND#11	1.97442e-17
C363	a_91_48##5	VPWR#10	5.34316e-18
C364	a_91_48#	B1#3	1.67034e-18
C365	B1#5	C1#4	3.61168e-17
C366	a_91_48##19	a_510_125##3	1.6709e-17
C367	a_91_48##5	X#3	2.35532e-18
C368	VGND#6	a_91_48##6	2.15165e-20
C369	a_510_125##2	A2	8.08271e-17
C370	a_91_48##21	VPWR#4	2.38776e-18
C371	A2	A1#7	2.30656e-17
C372	a_91_48#	B1#5	1.82679e-17
C373	X#4	X#5	4.59562e-19
C374	A1	a_510_125#	2.1922e-17
C375	a_597_125#	a_91_48##19	5.08469e-17
C376	VGND	B1#3	1.15508e-17
C377	VGND	a_91_48##7	5.24673e-20
C378	a_91_48##16	A2	6.74202e-18
C379	VGND	a_91_48##6	4.65762e-20
C380	a_91_48##5	B1#2	2.66211e-19
C381	VPWR#3	A1#5	1.37609e-18
C382	a_91_48##10	a_91_48#	4.6187e-17
C383	a_91_48##5	C1#1	1.94975e-19
C384	X#4	VGND#7	2.99004e-18
C385	a_91_48##5	C1#6	2.63557e-19
C386	VGND#5	B1	4.80198e-19
C387	a_597_125##2	a_597_125#	2.37845e-18
C388	VPWR#3	C1#5	2.29973e-18
C389	a_510_125##5	a_510_125##3	8.63391e-19
C390	a_91_48##5	B1#6	3.30667e-19
C391	a_91_48##13	a_91_48##10	3.0801e-17
C392	C1	a_91_48##16	5.18069e-17
C393	a_510_125##3	A2	4.77467e-18
C394	VPWR#3	C1#4	1.9931e-18
C395	X#1	VPWR#5	8.63016e-18
C396	a_510_125##3	B1#3	9.41131e-20
C397	a_91_48##19	A2	1.58755e-18
C398	A1	VPWR#1	2.36167e-17
C399	a_91_48##14	a_91_48##13	4.60437e-17
C400	VPWR#3	a_91_48#	8.88786e-19
C401	a_597_125##2	a_91_48##19	3.94382e-17
C402	a_510_125##5	a_597_125#	1.53919e-17
C403	X#1	VPWR#4	8.44616e-18
C404	B1	a_91_48##17	3.66875e-17
C405	a_91_48##19	C1	3.75003e-17
C406	A2	a_968_391#	2.2739e-18
C407	A2	a_91_48##15	7.59647e-17
C408	a_91_48##5	B1#1	1.31764e-19
C409	B1	a_91_48##19	1.36971e-18
C410	a_510_125#	VPWR#1	4.07569e-19
C411	a_510_125##5	B1	2.44882e-17
C412	X#4	X	8.88721e-19
C413	a_91_48##16	VPWR#7	4.17854e-17
C414	a_510_125##5	a_597_125##2	7.81764e-17
C415	VPWR	VPWR#5	2.59926e-17
C416	X#3	VPWR#5	1.48955e-17
C417	VPWR	VPWR#4	2.77229e-17
C418	a_91_48##5	B1#5	2.7487e-18
C419	VPWR	VPWR#2	3.68867e-17
C420	A2	A1#3	1.04159e-19
C421	a_91_48##5	a_91_48#	6.62496e-18
C422	VPWR	A1#7	1.76723e-18
C423	VGND#3	A1#3	3.20763e-19
C424	VPWR	a_91_48##17	5.03859e-18
C425	A2	A1#4	5.81827e-18
C426	a_510_125#	a_968_391#	3.81267e-18
C427	VPWR	a_91_48##16	4.43944e-18
C428	a_91_48##19	A2#4	4.16495e-19
C429	A2	B1#2	1.72172e-18
C430	VGND	VGND#6	4.4961e-17
C431	a_91_48##16	a_91_48##20	1.69703e-19
C432	VGND	VGND#5	2.80924e-17
C433	VPWR	X#2	2.12891e-18
C434	A2#3	A1#2	2.54647e-17
C435	VGND	VGND#3	5.27647e-17
C436	a_597_125#	C1#3	1.87246e-19
C437	X	VGND#7	2.56475e-17
C438	A2#4	VNB	1.87051e-17
C439	B1#3	VNB	1.60511e-16
C440	C1#3	VNB	6.96467e-17
C441	a_91_48##7	VNB	3.77794e-17
C442	VPWR#6	VPWR#5	9.5684e-19
C443	a_91_48##6	VNB	2.04959e-17
C444	a_91_48##17	VPWR#8	1.66313e-17
C445	C1	B1#2	1.59712e-18
C446	VGND	a_510_125##2	3.00497e-18
C447	VGND	A1#7	1.55273e-18
C448	VGND#10	a_510_125##5	5.34217e-17
C449	VGND	X#4	2.39872e-18
C450	B1	B1#2	1.64064e-19
C451	VPWR	VPWR#1	5.25056e-17
C452	VGND	X#2	4.07693e-18
C453	a_91_48##16	VPWR#8	1.49269e-17
C454	VGND	a_510_125#	1.41536e-17
C455	VPWR	a_968_391#	2.11005e-17
C456	VPWR	a_91_48##15	1.05146e-17
C457	X	VPWR#6	3.23507e-17
C458	VGND	a_510_125##6	1.09664e-17
C459	VPWR	a_968_391##2	2.34025e-17
C460	A2	A1#5	4.85127e-18
C461	VPWR	VPWR#7	2.211e-17
C462	VGND	a_510_125##3	3.12735e-17
C463	VGND	a_597_125#	1.02316e-17
C464	VPWR	a_91_48##20	1.35049e-17
C465	A2	B1#1	8.65769e-19
C466	VGND	a_91_48##19	6.78607e-18
C467	a_91_48##17	a_91_48##21	1.69703e-19
C468	VGND	a_597_125##2	8.00159e-18
C469	VPWR	a_91_48##21	1.35836e-17
C470	VGND	a_510_125##5	3.39225e-17
C471	VPWR	VPWR#9	2.15836e-17
C472	VGND	VGND#10	2.19262e-17
C473	a_91_48##19	B1#3	3.72114e-19
C474	VGND	X#6	1.41451e-17
C475	VPWR	X#1	1.66231e-17
C476	VPWR	VPWR#10	2.08952e-17
C477	VGND	X#5	1.34617e-17
C478	VPWR	X#3	1.61685e-17
C479	VGND	VGND#7	3.27084e-17
C480	C1	B1#1	8.08713e-19
C481	VPWR	VPWR#6	4.06562e-17
C482	X	a_91_48##9	1.38823e-20
C483	X	a_91_48##11	2.92677e-20
C484	X	a_91_48##12	4.53873e-20
C485	VGND#3	A2#7	4.55572e-19
C486	C1	B1#5	2.68477e-19
C487	X	a_91_48##8	2.18461e-19
C488	VGND	X#1	2.60463e-18
C489	A1	A1#2	9.79537e-18
C490	a_91_48##14	a_91_48##6	1.5243e-18
C491	B1	B1#5	3.90709e-18
C492	a_91_48##17	VPWR#9	1.66708e-17
C493	VGND#6	VNB	3.50775e-17
C494	VGND	A1#3	6.54458e-18
C495	a_91_48##19	C1#3	6.40489e-18
C496	X#6	VGND#10	6.52384e-17
C497	VGND#5	VNB	3.16395e-17
C498	B1	a_91_48#	7.84367e-19
C499	VGND#3	VNB	3.63635e-17
C500	VGND	A2#1	2.38621e-18
C501	VGND	A2#7	2.50477e-18
C502	VPWR#5	VNB	3.4752e-17
C503	VPWR#4	VNB	3.41104e-17
C504	VGND	A1#4	5.77806e-18
C505	A2	A1#2	5.36577e-18
C506	VPWR#2	VNB	5.0348e-17
C507	VGND	B1#2	2.16099e-17
C508	VPWR	A1#1	3.93786e-18
C509	a_510_125##2	VNB	1.8486e-18
C510	A2	A2#3	2.49897e-17
C511	VPWR	A2#6	3.93897e-18
C512	A1#7	VNB	1.77399e-19
C513	VPWR	A2#5	3.93897e-18
C514	VGND	B1#6	4.09409e-18
C515	a_91_48##17	VNB	5.64553e-18
C516	a_91_48##16	VNB	2.62418e-18
C517	VGND	a_91_48##9	3.14304e-19
C518	VPWR	A1#5	4.28982e-18
C519	VGND	a_91_48##11	1.5421e-19
C520	VPWR	B1#1	7.15697e-18
C521	X#4	VNB	1.18203e-18
C522	X#2	VNB	2.99575e-18
C523	VGND	a_91_48##12	6.50602e-19
C524	a_510_125#	VNB	4.0192e-17
C525	VPWR	C1#5	7.89507e-18
C526	B1#3	C1#3	2.5845e-17
C527	VGND#8	VNB	5.50768e-18
C528	VGND	a_91_48##8	4.60559e-19
C529	a_510_125##6	VNB	3.11423e-18
C530	VPWR	C1#4	8.03448e-18
C531	VGND#9	VNB	1.5706e-18
C532	a_510_125##3	VNB	1.84616e-17
C533	VPWR	B1#5	8.67769e-18
C534	a_91_48##19	VNB	6.36136e-19
C535	a_597_125##2	VNB	2.00673e-18
C536	VPWR	a_91_48#	3.20707e-18
C537	a_510_125##5	VNB	2.41586e-17
C538	VGND#10	VNB	7.50961e-19
C539	VGND#3	A1#4	2.25463e-17
C540	X#6	VNB	2.58789e-18
C541	VPWR	a_91_48##10	1.94665e-19
C542	VGND#11	VNB	5.85201e-19
C543	X#5	VNB	4.49802e-18
C544	VPWR	a_91_48##13	1.87826e-19
C545	VGND#11	VGND#10	2.95222e-18
C546	VGND#7	VNB	5.06699e-17
C547	VPWR#1	VNB	9.43159e-17
C548	a_968_391#	VNB	6.79912e-18
C549	VPWR	a_91_48##14	1.64798e-19
C550	a_91_48##15	VNB	2.44466e-18
C551	a_968_391##2	VNB	3.678e-18
C552	VPWR#7	VNB	5.5195e-18
C553	a_91_48##20	VNB	2.74984e-18
C554	a_91_48##5	B1	3.45871e-17
C555	VPWR#8	VNB	3.9576e-18
C556	VPWR	VPWR#3	4.88759e-17
C557	a_91_48##21	VNB	2.72974e-18
C558	VPWR#9	VNB	5.7165e-18
C559	X#1	VNB	2.32698e-18
C560	VPWR#10	VNB	3.74405e-18
C561	X#3	VNB	3.09418e-18
C562	VPWR	A1#2	4.63624e-21
C563	VPWR#6	VNB	7.33776e-17
C564	A1#3	VNB	8.62101e-17
C565	X	a_91_48##5	2.44578e-17
C566	A2#1	VNB	2.18969e-17
C567	A2#7	VNB	2.17545e-17
C568	A1#4	VNB	8.36766e-17
C569	a_510_125##3	a_91_48##15	3.78842e-18
C570	B1#2	VNB	1.44421e-16
C571	C1#1	VNB	2.20834e-17
C572	C1#6	VNB	2.2732e-17
C573	VGND	VGND#4	3.39715e-17
C574	B1#6	VNB	2.78595e-17
C575	A1#4	A2#4	1.08082e-17
C576	a_91_48##9	VNB	2.93782e-17
C577	VPWR	a_91_48##5	8.83983e-18
C578	a_597_125##2	B1#3	1.59961e-18
C579	a_91_48##11	VNB	2.63374e-17
C580	a_510_125##2	A1#3	2.74335e-19
C581	a_91_48##12	VNB	2.49523e-17
C582	a_91_48##8	VNB	3.45163e-17
C583	A1#1	VNB	3.66385e-17
C584	A2#6	VNB	2.62735e-17
C585	A2#5	VNB	2.63093e-17
C586	A1#5	VNB	4.44179e-17
C587	VGND	a_91_48##5	1.03323e-17
C588	B1#1	VNB	4.25075e-17
C589	X#6	VGND#11	5.07998e-17
C590	C1#5	VNB	3.12206e-17
C591	C1#4	VNB	3.27234e-17
C592	B1#5	VNB	4.27325e-17
C593	B1	C1	9.29674e-18
C594	a_91_48#	VNB	3.60801e-17
C595	a_91_48##10	VNB	3.09072e-17
C596	a_91_48##13	VNB	3.13908e-17
C597	VPWR	A1	1.26579e-18
C598	a_91_48##14	VNB	3.94409e-17
C599	VPWR	A2	5.29906e-18
C600	VPWR#3	VNB	3.0498e-16
C601	VGND#4	VNB	3.00401e-16
C602	A1#2	VNB	4.76458e-17
C603	VGND	A1	1.3429e-18
C604	VPWR	C1	1.71026e-18
C605	A2#3	VNB	4.08749e-17
C606	VGND#3	B1#2	7.16881e-18
C607	VGND	A2	4.37141e-18
C608	VPWR	B1	1.97031e-18
C609	a_91_48##5	VNB	9.24642e-17
C610	VGND	C1	1.87258e-18
C611	VPWR	X	2.777e-18
C612	VGND	B1	2.59158e-18
C613	VGND	X	2.64325e-18
C614	A1	VNB	1.7257e-17
C615	A2	VNB	2.4538e-18
C616	C1	VNB	9.55898e-19
C617	X	VNB	5.53067e-17
C618	a_597_125##2	C1#3	3.72287e-18
C619	VPWR	VNB	7.6182e-17
C620	VGND	VNB	6.52993e-17
C621	VGND#2	A1#2	5.91211e-20
C622	VGND#2	A2#1	6.12815e-19
C623	VGND#4	VGND#2	5.38615e-17
C624	VGND#2	a_510_125##6	2.44131e-18
C625	VGND#2	VNB	4.53286e-17
C626	VGND#2	A1#3	2.4459e-17
C627	VGND#2	a_510_125##2	2.62504e-19
C628	VGND#3	VGND#2	3.07007e-18
C629	VGND#2	a_510_125#	9.33129e-18
C630	VGND	VGND#2	5.52602e-17
C631	VGND#2	A1#4	7.81113e-19
C632	VGND#2	A2#3	1.90051e-19
*
*
.ENDS sky130_fd_sc_hs__o211a_4
*
