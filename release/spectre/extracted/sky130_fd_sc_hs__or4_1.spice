* Extracted by Quantus, converted by sky130cad/quantus.py
*
*
*
*                       LINUX           Wed Nov 18 09:06:57 2026
*
*
*
*  PROGRAM  advgen
*
*  Name           : advgen - Quantus - (64-bit)
*  Version        : 25.1.0-p047
*  Build Date     : Thu Dec 11 23:20:30 PST 2025
*
*  HSPICE LIBRARY
*
*  OPERATING_TEMPERATURE 150
*  QRC_TECH_DIR <path>/tech
*
*
*

*
.SUBCKT sky130_fd_sc_hs__or4_1 VNB VPB VGND VPWR X A D C B
*
*
*  caps2d version: 10
*
*
*       TRANSISTOR CARDS
*
*
XM4 VGND#5 D#3 a_44_392##8 VNB sky130_fd_pr__nfet_01v8_lvt l=0.15 w=0.55 ad=0.19525 as=0.154 pd=1.81 ps=1.66
XM7 a_44_392##8 C#3 VGND#6 VNB sky130_fd_pr__nfet_01v8_lvt l=0.15 w=0.55 ad=0.154 as=0.3348 pd=1.66 ps=2.33
XM1 VGND#6 B#1 a_44_392##4 VNB sky130_fd_pr__nfet_01v8_lvt l=0.15 w=0.55 ad=0.3348 as=0.242 pd=2.33 ps=1.98
XM3 a_44_392##4 A#1 VGND#4 VNB sky130_fd_pr__nfet_01v8_lvt l=0.15 w=0.55 ad=0.242 as=0.25215 pd=1.98 ps=2.2
XM0 VGND#4 a_44_392##3 X#3 VNB sky130_fd_pr__nfet_01v8_lvt l=0.15 w=0.74 ad=0.25215 as=0.2109 pd=2.2 ps=2.05
XM9 a_44_392##7 D#1 a_133_392# VPB sky130_fd_pr__pfet_01v8 l=0.15 w=1 ad=0.295 as=0.27 pd=2.59 ps=2.54
XM2 a_133_392# C#1 a_217_392# VPB sky130_fd_pr__pfet_01v8 l=0.15 w=1 ad=0.27 as=0.42 pd=2.54 ps=2.84
XM5 a_217_392# B#3 a_331_392# VPB sky130_fd_pr__pfet_01v8 l=0.15 w=1 ad=0.42 as=0.42 pd=2.84 ps=2.84
XM8 a_331_392# A#3 VPWR#4 VPB sky130_fd_pr__pfet_01v8 l=0.15 w=1 ad=0.42 as=0.5718 pd=2.84 ps=3.32
XM6 VPWR#4 a_44_392# X#1 VPB sky130_fd_pr__pfet_01v8 l=0.15 w=1.12 ad=0.5718 as=0.3304 pd=3.32 ps=2.83
*
*
*       RESISTOR AND CAP/DIODE CARDS
*
Rg1	D#1	D#2	431.392609
Rg2	D#2	D#3	368.193207
Rg3	C#1	C#2	422.415131
Rg4	C#2	C#3	368.193207
Rg5	B#1	B#2	368.193207
Rg6	B#2	B#3	422.415131
Rg7	A#1	A#2	354.876251
Rg8	A#2	A#3	470.241455
Rg9	a_44_392#	a_44_392##2	465.025360
Rg10	a_44_392##2	a_44_392##3	366.265259
Rf1	D#4	D	1.008151
Rf2	D#2	D#6	161.240952
Rf3	D#4	D#6	8.877476
Rf4	C#2	C#5	161.626724
Rf5	C#6	C	1.393923
Rf6	C#5	C#6	4.166978
Rf7	B#2	B	163.382187
Rf8	A#4	A#2	161.226013
Rf9	A	A#6	0.993209
Rf10	A#4	A#6	5.660404
Rf11	a_44_392##4	a_44_392##5	21.908955
Rf12	a_44_392##5	a_44_392##6	61.228493
Rf13	a_44_392##6	a_44_392##7	212.513412
Rf14	a_44_392##5	a_44_392##8	109.617386
Rf15	X	X#2	0.174240
Rf16	X#2	X	12.719545
Rf17	X	X#3	87.781708
Rf18	X#1	X#2	5.000000
Rf20	VGND#2	VGND#3	68.277679
Rf21	VGND#2	VGND#4	38.247387
Rf22	VGND#3	VGND#5	148.771378
Rf23	VGND#3	VGND#6	33.825928
Rf25	VPWR#2	VPWR#3	49.432076
Rf26	VPWR#2	VPWR#4	26.805510
Rf31	a_44_392##2	a_44_392##6	160.232803
Re1	VPWR#3	VPWR	1.403190
Re2	VGND	VGND#3	1.403242
*
*       CAPACITOR CARDS
*
*
C1	a_44_392##5	A#4	3.8824e-17
C2	a_44_392##5	X#3	2.19673e-18
C3	a_44_392##5	VGND#4	2.02011e-17
C4	a_44_392##5	a_44_392##4	1.36565e-17
C5	a_44_392##5	VGND#6	3.95396e-17
C6	a_44_392##8	a_44_392##5	1.86652e-18
C7	a_44_392##8	C#5	1.90063e-17
C8	VGND#4	X#3	4.28536e-17
C9	a_44_392##5	a_44_392##7	2.17754e-18
C10	a_44_392##5	a_44_392##3	1.3665e-18
C11	VGND#6	VGND#4	4.87463e-18
C12	a_44_392##5	A#1	3.32777e-17
C13	a_44_392##5	B#1	3.677e-17
C14	a_44_392##8	VGND#6	5.38083e-17
C15	a_44_392##5	C#3	9.95315e-19
C16	VGND#5	VGND#6	6.80101e-18
C17	C#5	a_44_392##7	2.46654e-17
C18	VGND#5	a_44_392##8	5.50795e-17
C19	X#3	a_44_392##3	2.13209e-17
C20	VPWR#4	X#1	1.89503e-17
C21	VGND#4	a_44_392##3	3.24249e-17
C22	X#3	A#1	1.20234e-18
C23	A#1	VGND#4	1.70408e-17
C24	X#3	B#1	2.34336e-19
C25	a_44_392##8	a_44_392##7	7.06312e-18
C26	VGND#6	a_44_392##3	1.13652e-18
C27	A#1	a_44_392##4	5.62015e-18
C28	VGND#4	B#1	1.33646e-18
C29	VGND#6	A#1	1.4513e-18
C30	B#1	a_44_392##4	8.6432e-18
C31	VGND#4	C#3	2.66448e-19
C32	a_44_392##8	A#1	1.46219e-19
C33	B#1	VGND#6	2.29227e-17
C34	a_44_392##7	VPWR#4	8.53141e-18
C35	a_44_392##8	B#1	5.68344e-19
C36	C#3	VGND#6	2.41074e-17
C37	VGND#5	B#1	3.22523e-19
C38	a_44_392##8	C#3	4.83872e-17
C39	VGND#6	D#3	1.68866e-18
C40	VGND#5	C#3	1.58416e-18
C41	a_44_392##8	D#3	3.64288e-17
C42	VGND#5	D#3	2.01112e-17
C43	VGND#3	a_44_392##5	8.71454e-18
C44	a_44_392##5	a_44_392##2	6.54071e-18
C45	A#1	a_44_392##3	2.49821e-17
C46	X#1	a_44_392#	2.54215e-17
C47	a_44_392#	VPWR#4	2.5038e-17
C48	a_44_392##5	A#2	4.63201e-18
C49	A#4	a_44_392##2	2.56656e-17
C50	X#1	A#3	2.25935e-18
C51	B#1	A#1	1.71295e-17
C52	VPWR#4	A#3	6.75316e-17
C53	X#1	B#3	4.9913e-19
C54	a_44_392##5	B#2	2.63396e-18
C55	A#4	A#2	9.37227e-18
C56	VPWR#4	B#3	6.60339e-18
C57	X#1	C#1	3.17075e-19
C58	C#3	B#1	1.07921e-17
C59	VPWR#4	C#1	2.50519e-18
C60	A#4	B#2	3.5208e-18
C61	VGND#3	VGND#4	3.30963e-19
C62	a_44_392##7	A#3	1.39453e-18
C63	VPWR#4	D#1	1.43789e-18
C64	D#3	C#3	3.23869e-17
C65	a_44_392##2	X#3	3.56815e-17
C66	A#4	C#2	5.92538e-19
C67	a_44_392##7	B#3	1.85574e-17
C68	a_44_392##2	VGND#4	2.79562e-17
C69	VGND#3	a_44_392##8	8.76052e-18
C70	a_44_392##7	C#1	3.56976e-17
C71	X#3	A#2	7.40224e-21
C72	A#4	D#2	2.9521e-19
C73	VGND#3	VGND#5	2.42656e-17
C74	C#5	C#2	1.49472e-17
C75	a_44_392##7	D#1	6.32445e-17
C76	D#2	C#5	2.63407e-17
C77	a_44_392##2	VPWR#4	5.15939e-17
C78	VGND#6	B#2	7.44061e-19
C79	a_44_392##7	VPWR#3	2.79961e-17
C80	A#3	a_44_392#	1.92599e-17
C81	VPWR#4	A#2	1.06546e-18
C82	VGND#6	C#2	9.45076e-19
C83	a_44_392##8	C#2	2.32231e-18
C84	VGND#3	a_44_392##3	6.79401e-19
C85	B#3	A#3	2.83342e-17
C86	a_44_392##2	a_44_392##3	4.96991e-18
C87	a_44_392##8	D#2	1.35577e-17
C88	VGND#3	B#1	2.36417e-18
C89	A#1	a_44_392##2	7.33609e-19
C90	VGND#5	D#2	1.12942e-17
C91	VGND#3	C#3	2.2136e-18
C92	C#1	B#3	3.19748e-17
C93	a_44_392##2	B#1	1.05971e-19
C94	VGND#3	D#3	5.36389e-18
C95	a_44_392##2	C#3	3.92414e-20
C96	B#1	A#2	1.1883e-18
C97	a_44_392##2	D#3	3.50615e-20
C98	D#1	C#1	6.09989e-17
C99	a_44_392##7	C#2	2.50616e-18
C100	VPWR#3	B#3	8.56686e-18
C101	a_44_392##5	B	2.5179e-17
C102	D#2	a_44_392##7	3.45291e-17
C103	a_44_392##2	a_44_392#	6.1967e-18
C104	VPWR#3	C#1	8.61359e-18
C105	B	A#4	1.29404e-17
C106	a_44_392##2	A#3	2.14142e-17
C107	A#2	a_44_392#	2.00365e-18
C108	VPWR#3	D#1	5.69385e-18
C109	a_44_392##2	B#3	1.20988e-17
C110	a_44_392##2	C#1	5.86308e-20
C111	B#2	A#3	1.36752e-18
C112	a_44_392##2	D#1	4.7963e-20
C113	a_44_392##7	a_217_392#	6.53042e-18
C114	a_44_392##2	VPWR#3	1.98757e-18
C115	a_44_392##7	a_133_392#	4.10185e-18
C116	VGND#3	A#2	8.16535e-20
C117	VPWR#3	B#2	1.69695e-19
C118	A#2	a_44_392##2	4.00785e-17
C119	a_44_392##8	C	1.46418e-17
C120	A#3	a_331_392#	2.99673e-17
C121	VPWR#3	C#2	1.75492e-19
C122	B#3	a_331_392#	2.99673e-17
C123	a_44_392##2	B#2	2.60884e-18
C124	VPWR#3	D#2	7.12256e-20
C125	B	a_44_392##7	1.70721e-17
C126	B#2	A#2	3.21859e-17
C127	a_44_392##2	C#2	3.29318e-19
C128	B#3	a_217_392#	2.99673e-17
C129	VGND#3	D#2	6.17676e-19
C130	VGND#5	D	1.54389e-17
C131	C#1	a_217_392#	2.99673e-17
C132	a_44_392##2	D#2	3.35573e-19
C133	C	a_44_392##7	2.05258e-17
C134	C#2	B#2	2.66998e-17
C135	C#1	a_133_392#	2.43792e-17
C136	D#1	a_133_392#	2.52006e-17
C137	D	a_44_392##7	2.17292e-17
C138	a_44_392##2	a_331_392#	6.51555e-18
C139	X#3	X	3.89141e-18
C140	D#2	C#2	3.61427e-17
C141	B#2	a_331_392#	2.58147e-19
C142	VPWR	C#5	9.82446e-19
C143	X	X#1	3.11644e-18
C144	VPWR#4	X	1.70319e-17
C145	VGND	a_44_392##5	1.78192e-17
C146	C#2	a_217_392#	2.58147e-19
C147	VGND	A#4	2.60826e-18
C148	VGND	C#5	1.52609e-18
C149	B	a_44_392##2	2.42202e-17
C150	A	a_44_392#	2.44041e-19
C151	VPWR	VPWR#4	2.59501e-17
C152	B	A#2	3.28158e-18
C153	VGND	X#3	1.84536e-17
C154	B	B#2	1.93278e-17
C155	D	VPWR#3	8.28509e-19
C156	VPWR	a_44_392##7	3.02367e-17
C157	B	C#2	2.9361e-18
C158	VGND	a_44_392##8	1.52371e-17
C159	X	a_44_392#	2.12815e-17
C160	VGND	VGND#5	3.81712e-17
C161	X	A#3	1.97372e-18
C162	C	B#2	3.17548e-18
C163	C	C#2	5.7211e-18
C164	VPWR	a_44_392#	4.01636e-18
C165	A	a_44_392##2	5.70833e-17
C166	VGND	a_44_392##3	1.06685e-18
C167	A	A#2	7.74016e-18
C168	VGND	A#1	7.08597e-18
C169	VPWR	B#3	1.55882e-18
C170	VGND	B#1	7.20979e-18
C171	D	D#2	1.05894e-17
C172	A	B#2	2.05842e-18
C173	VPWR	C#1	1.71054e-18
C174	VGND	C#3	7.79466e-18
C175	VGND	D#3	7.79466e-18
C176	VPWR	D#1	1.42882e-18
C177	a_44_392##2	X	6.10952e-17
C178	a_44_392##5	VNB	1.31486e-17
C179	X	A#2	2.32005e-20
C180	VPWR	VPWR#3	5.71452e-17
C181	A#4	VNB	4.29841e-18
C182	C#5	VNB	3.54654e-19
C183	VPWR	a_44_392##2	1.4187e-17
C184	X#3	VNB	5.28227e-17
C185	VGND#4	VNB	4.31476e-18
C186	C	B	2.75902e-17
C187	VGND#6	VNB	9.57173e-18
C188	a_44_392##8	VNB	1.35929e-17
C189	VGND	VGND#3	7.14963e-17
C190	VGND#5	VNB	7.44236e-17
C191	X#1	VNB	2.02145e-17
C192	VGND	a_44_392##2	5.40675e-18
C193	VPWR	D#2	1.53118e-18
C194	VPWR#4	VNB	1.39028e-18
C195	a_44_392##7	VNB	5.71303e-17
C196	B	A	1.24728e-17
C197	a_44_392##3	VNB	3.53704e-17
C198	A#1	VNB	2.96888e-17
C199	B#1	VNB	3.48551e-17
C200	VGND	D#2	3.12067e-18
C201	C#3	VNB	3.35655e-17
C202	D#3	VNB	3.75772e-17
C203	a_44_392#	VNB	3.83433e-17
C204	A#3	VNB	3.31989e-17
C205	B#3	VNB	2.89035e-17
C206	C#1	VNB	2.82397e-17
C207	VPWR	B	1.76666e-18
C208	D#1	VNB	4.06703e-17
C209	VPWR	C	9.67214e-19
C210	VPWR#3	VNB	2.29015e-16
C211	VGND#3	VNB	2.10151e-16
C212	a_44_392##2	VNB	5.33372e-17
C213	VGND	B	2.76663e-18
C214	VPWR	D	2.9652e-18
C215	A#2	VNB	3.90727e-17
C216	B#2	VNB	2.6584e-17
C217	VGND	C	1.42913e-18
C218	VPWR	A	2.24664e-18
C219	C#2	VNB	3.79853e-17
C220	D#2	VNB	5.49373e-17
C221	VGND	D	2.13683e-18
C222	VPWR	X	2.12952e-17
C223	VGND	X	1.82941e-18
C224	B	VNB	2.56588e-18
C225	C	VNB	3.33182e-18
C226	D	VNB	2.23859e-17
C227	A	VNB	1.13502e-18
C228	X	VNB	5.12228e-17
C229	VPWR	VNB	5.71468e-17
C230	VGND	VNB	6.38104e-17
C231	X	VPWR#2	2.26624e-17
C232	VGND#2	a_44_392##2	8.52333e-19
C233	VGND#3	VGND#2	5.40195e-17
C234	VGND#2	VNB	5.10437e-17
C235	VPWR#2	VNB	5.51274e-17
C236	VGND	VGND#2	5.66406e-17
C237	VGND#2	A#1	4.03602e-18
C238	a_44_392##2	VPWR#2	2.41071e-18
C239	VGND#2	a_44_392##3	7.97591e-18
C240	VPWR#2	A#3	2.35204e-18
C241	VGND#2	X#3	2.08369e-17
C242	VPWR#3	VPWR#2	5.98516e-17
C243	VPWR#2	a_44_392#	4.6431e-18
C244	VPWR	VPWR#2	4.18143e-17
C245	VGND#2	a_44_392##5	3.00951e-18
C246	VGND#2	A#2	3.08959e-20
*
*
.ENDS sky130_fd_sc_hs__or4_1
*
