* Extracted by Quantus, converted by sky130cad/quantus.py
*
*
*
*                       LINUX           Wed Nov 18 09:05:29 2026
*
*
*
*  PROGRAM  advgen
*
*  Name           : advgen - Quantus - (64-bit)
*  Version        : 25.1.0-p047
*  Build Date     : Thu Dec 11 23:20:30 PST 2025
*
*  HSPICE LIBRARY
*
*  OPERATING_TEMPERATURE 150
*  QRC_TECH_DIR <path>/tech
*
*
*

*
.SUBCKT sky130_fd_sc_hs__or2_4 VNB VPB VGND VPWR X A B
*
*
*  caps2d version: 10
*
*
*       TRANSISTOR CARDS
*
*
XM4 X#5 a_83_260##10 VGND#4 VNB sky130_fd_pr__nfet_01v8_lvt l=0.15 w=0.74 ad=0.2072 as=0.2109 pd=2.04 ps=2.05
XM1 VGND#6 a_83_260##7 X#5 VNB sky130_fd_pr__nfet_01v8_lvt l=0.15 w=0.74 ad=0.2072 as=0.2072 pd=2.04 ps=2.04
XM7 X#6 a_83_260##5 VGND#6 VNB sky130_fd_pr__nfet_01v8_lvt l=0.15 w=0.74 ad=0.2701 as=0.2072 pd=2.21 ps=2.04
XM13 VGND#5 a_83_260# X#6 VNB sky130_fd_pr__nfet_01v8_lvt l=0.15 w=0.74 ad=0.259 as=0.2701 pd=2.18 ps=2.21
XM5 VGND#5 A#3 a_83_260##16 VNB sky130_fd_pr__nfet_01v8_lvt l=0.15 w=0.74 ad=0.259 as=0.2479 pd=2.18 ps=2.15
XM6 a_83_260##16 B#5 VGND#1 VNB sky130_fd_pr__nfet_01v8_lvt l=0.15 w=0.74 ad=0.2479 as=0.9287 pd=2.15 ps=3.99
XM0 VPWR#4 a_83_260##12 X#3 VPB sky130_fd_pr__pfet_01v8 l=0.15 w=1.12 ad=0.3304 as=0.336 pd=2.83 ps=2.84
XM2 VPWR#6 a_83_260##11 X#3 VPB sky130_fd_pr__pfet_01v8 l=0.15 w=1.12 ad=0.336 as=0.336 pd=2.84 ps=2.84
XM8 X#1 a_83_260##8 VPWR#6 VPB sky130_fd_pr__pfet_01v8 l=0.15 w=1.12 ad=0.336 as=0.336 pd=2.84 ps=2.84
XM10 X#1 a_83_260##4 VPWR#5 VPB sky130_fd_pr__pfet_01v8 l=0.15 w=1.12 ad=0.336 as=0.4204 pd=2.84 ps=3.01
XM9 VPWR#5 A#1 a_493_388##2 VPB sky130_fd_pr__pfet_01v8 l=0.15 w=1 ad=0.4204 as=0.3 pd=3.01 ps=2.6
XM3 a_493_388##2 B#4 a_83_260##13 VPB sky130_fd_pr__pfet_01v8 l=0.15 w=1 ad=0.3 as=0.3 pd=2.6 ps=2.6
XM11 a_83_260##13 B#1 a_493_388# VPB sky130_fd_pr__pfet_01v8 l=0.15 w=1 ad=0.3 as=0.35 pd=2.6 ps=2.7
XM12 a_493_388# A#4 VPWR#1 VPB sky130_fd_pr__pfet_01v8 l=0.15 w=1 ad=0.35 as=0.32 pd=2.7 ps=2.64
*
*
*       RESISTOR AND CAP/DIODE CARDS
*
Rg1	a_83_260#	a_83_260##2	368.862610
Rg2	a_83_260##2	a_83_260##3	90.016602
Rg3	a_83_260##2	a_83_260##4	471.862823
Rg4	a_83_260##3	a_83_260##5	370.669800
Rg5	a_83_260##3	a_83_260##6	57.428749
Rg6	a_83_260##6	a_83_260##7	366.112152
Rg7	a_83_260##3	a_83_260##8	451.334412
Rg8	a_83_260##6	a_83_260##9	66.386436
Rg9	a_83_260##9	a_83_260##10	368.862610
Rg10	a_83_260##6	a_83_260##11	470.238159
Rg11	a_83_260##9	a_83_260##12	471.862823
Rg12	A#1	A#2	452.755615
Rg13	A#2	A#3	394.958344
Rg14	B#1	B#2	422.999237
Rg15	B#2	B#3	31.598013
Rg16	B#3	B#4	469.506683
Rg17	B#3	B#5	509.225098
Rg18	A#4	A#5	400.207520
Rf1	X#1	X#2	84.013107
Rf2	X#2	X	42.811546
Rf3	X#2	X#3	21.948624
Rf4	X	X#4	39.907639
Rf5	X#4	X#5	18.783115
Rf6	X#4	X#6	79.384628
Rf7	B#2	B	162.201172
Rf8	a_493_388#	a_493_388##2	100.420242
Rf9	A#5	A	268.240051
Rf10	A	A#2	166.175201
Rf11	a_83_260##13	a_83_260##14	288.165161
Rf12	a_83_260##14	a_83_260##3	128.745728
Rf13	a_83_260##14	a_83_260##16	18.149860
Rf14	VPWR#1	VPWR#2	173.970612
Rf15	VPWR#2	VPWR#3	72.892860
Rf16	VPWR#3	VPWR#4	111.378036
Rf17	VPWR#2	VPWR#5	47.702633
Rf18	VPWR#3	VPWR#6	58.622005
Rf19	VGND#1	VGND#2	82.695007
Rf20	VGND#2	VGND#3	79.219551
Rf21	VGND#3	VGND#4	102.736237
Rf22	VGND#2	VGND#5	41.745289
Rf23	VGND#3	VGND#6	39.841232
Re1	VPWR#2	VPWR	1.091357
Re2	VGND	VGND#2	1.091398
*
*       CAPACITOR CARDS
*
*
C1	X#4	a_83_260##9	1.88298e-18
C2	X#4	a_83_260##6	2.67516e-18
C3	A#1	B#3	2.22664e-18
C4	X#2	a_83_260##9	1.4791e-18
C5	X#2	a_83_260##6	4.13e-18
C6	VGND#1	B#3	2.04128e-18
C7	VGND#3	X#4	3.59283e-19
C8	X#2	VPWR#3	2.5317e-19
C9	X#6	a_83_260##6	3.55795e-18
C10	X#6	a_83_260##2	3.00637e-18
C11	VGND#6	a_83_260##6	8.66824e-19
C12	a_83_260##14	VGND#1	1.14502e-16
C13	VGND#3	X#6	7.7842e-18
C14	a_83_260##14	a_83_260##16	5.30814e-19
C15	VPWR#2	B#3	2.46748e-20
C16	a_83_260##14	VGND#5	7.96439e-18
C17	VGND#3	X#5	1.36893e-17
C18	VPWR#2	a_83_260##2	4.5102e-20
C19	X#4	X#2	4.86909e-18
C20	VGND#4	VGND#3	1.1306e-18
C21	a_83_260##9	a_83_260##6	4.29816e-18
C22	VGND#2	a_83_260##6	3.27408e-20
C23	VGND#2	a_83_260##2	1.07867e-19
C24	a_83_260##16	VGND#1	4.858e-17
C25	VGND#5	VGND#1	1.56245e-18
C26	B#3	A#5	2.90233e-17
C27	X#4	VGND#6	1.45838e-17
C28	VGND#5	a_83_260##16	4.526e-17
C29	X#4	X#5	4.59562e-19
C30	X#6	a_83_260##16	2.76344e-18
C31	a_83_260##14	a_83_260##13	1.47057e-18
C32	X#4	VGND#4	4.62144e-19
C33	a_493_388#	B#3	8.36263e-20
C34	X#6	VGND#5	3.58878e-17
C35	a_83_260##6	a_83_260##2	3.76959e-18
C36	VGND#6	VGND#5	1.25421e-18
C37	X#1	VPWR#3	8.7607e-18
C38	a_83_260##14	VPWR#5	9.07945e-19
C39	X#6	VGND#6	4.57882e-17
C40	X#5	X#6	2.73513e-18
C41	a_83_260##13	B#3	6.10713e-19
C42	X#3	VPWR#3	1.67068e-17
C43	A#2	B#3	4.86798e-17
C44	X#5	VGND#6	3.77155e-17
C45	A#2	a_83_260##9	1.37666e-19
C46	A#2	a_83_260##6	4.43758e-19
C47	a_83_260##2	A#2	3.1198e-17
C48	VPWR#4	VPWR#3	7.0017e-19
C49	VGND#4	VGND#6	1.70644e-18
C50	VGND#4	X#5	3.77155e-17
C51	a_493_388##2	B#3	1.70666e-19
C52	X#2	X#1	1.87999e-18
C53	a_83_260##3	B#3	6.8658e-20
C54	a_83_260##3	a_83_260##9	8.55136e-18
C55	a_83_260##14	B#5	2.47046e-17
C56	a_83_260##3	a_83_260##6	3.461e-17
C57	a_83_260##3	a_83_260##2	1.5904e-17
C58	X#2	VPWR#6	1.7292e-17
C59	VGND#3	a_83_260#	4.1617e-19
C60	a_83_260##14	A#3	1.94835e-17
C61	X#2	X#3	2.08835e-19
C62	VGND#3	a_83_260##5	5.37252e-18
C63	a_493_388#	VPWR#1	7.09723e-17
C64	X#2	VPWR#4	3.54355e-19
C65	VGND#3	a_83_260##7	4.95096e-18
C66	a_83_260##13	VPWR#1	4.24134e-17
C67	a_493_388#	a_83_260##13	6.28267e-17
C68	VGND#3	a_83_260##10	2.94393e-18
C69	VGND#1	B#5	4.92477e-17
C70	a_493_388##2	a_493_388#	2.7787e-18
C71	VPWR#5	VPWR#1	1.58905e-20
C72	B#5	a_83_260##16	1.57253e-17
C73	VGND#1	A#3	1.85657e-18
C74	a_493_388##2	a_83_260##13	4.74836e-17
C75	VGND#5	B#5	3.92525e-19
C76	a_83_260##16	A#3	3.62433e-17
C77	VGND#1	a_83_260#	2.68863e-19
C78	A#3	VGND#5	1.61713e-17
C79	X#1	a_83_260##6	1.45358e-18
C80	a_83_260##16	a_83_260#	1.85869e-18
C81	VPWR#5	a_493_388##2	5.77316e-17
C82	X#4	a_83_260##7	1.69418e-17
C83	X#6	A#3	4.48701e-19
C84	VGND#4	VPWR#4	1.99913e-19
C85	VGND#5	a_83_260#	3.27799e-17
C86	X#1	a_83_260##2	1.4342e-18
C87	a_83_260##16	a_83_260##5	2.36324e-19
C88	X#4	a_83_260##10	2.33024e-17
C89	X#6	a_83_260#	1.33352e-17
C90	VGND#5	a_83_260##5	1.13652e-18
C91	X#1	VPWR#5	6.52556e-17
C92	VGND#6	a_83_260#	2.61393e-19
C93	X#6	a_83_260##5	5.38768e-17
C94	VPWR#6	VPWR#5	1.94092e-18
C95	VGND#5	a_83_260##7	1.06236e-19
C96	a_83_260##5	VGND#6	1.48035e-17
C97	VPWR#6	a_83_260##6	1.28599e-18
C98	X#6	a_83_260##7	1.43869e-18
C99	X#1	VPWR#6	6.23583e-17
C100	X#5	a_83_260##5	7.83819e-19
C101	VGND#6	a_83_260##7	2.80169e-17
C102	X#3	X#1	1.11023e-18
C103	X#6	a_83_260##10	3.30898e-19
C104	a_83_260##7	X#5	1.22075e-17
C105	VGND#6	a_83_260##10	1.43616e-18
C106	X#3	VPWR#6	6.11996e-17
C107	VPWR#3	a_83_260##4	2.85183e-19
C108	VGND#4	a_83_260##7	1.21536e-18
C109	X#5	a_83_260##10	3.20029e-17
C110	B	B#3	1.87113e-17
C111	VPWR#4	VPWR#6	1.94092e-18
C112	a_83_260##10	VGND#4	2.29319e-17
C113	VPWR#3	a_83_260##8	7.39871e-18
C114	VPWR#4	X#3	6.23622e-17
C115	VPWR#3	a_83_260##11	5.1289e-18
C116	A#4	VPWR#1	2.37241e-17
C117	VPWR#3	a_83_260##12	2.14851e-18
C118	a_493_388#	A#4	3.87514e-17
C119	A#3	B#5	3.03747e-17
C120	X#2	a_83_260##8	5.45335e-19
C121	VPWR#1	B#1	2.41564e-18
C122	a_83_260##13	A#4	2.90076e-17
C123	a_493_388#	B#1	2.98067e-17
C124	a_493_388##2	A#4	2.1004e-19
C125	X#2	a_83_260##11	1.82884e-17
C126	a_83_260##13	B#1	4.46056e-17
C127	a_83_260#	A#3	2.56902e-17
C128	VPWR#5	A#4	6.17891e-19
C129	a_493_388#	B#4	4.50208e-19
C130	a_493_388##2	B#1	1.39076e-18
C131	VPWR#2	VPWR#3	4.36923e-17
C132	B#4	a_83_260##13	2.06622e-17
C133	X#2	a_83_260##12	2.53356e-17
C134	VPWR#5	B#1	7.71312e-19
C135	a_493_388##2	B#4	4.67874e-17
C136	a_83_260##5	a_83_260#	2.59477e-17
C137	VGND#2	VGND#3	4.53252e-17
C138	VPWR#1	a_83_260##4	1.3429e-19
C139	a_83_260##13	A#1	1.82806e-19
C140	X	a_83_260##9	1.99325e-17
C141	VPWR#5	B#4	1.35686e-18
C142	X	a_83_260##6	7.38426e-19
C143	X	a_83_260##2	1.21698e-19
C144	a_493_388##2	A#1	3.88421e-17
C145	X#1	B#4	2.82818e-19
C146	VGND#2	a_83_260##14	2.25448e-19
C147	A#1	VPWR#5	2.63467e-17
C148	a_83_260##7	a_83_260##5	3.61447e-17
C149	a_493_388##2	a_83_260##4	1.5714e-18
C150	X#1	A#1	2.88054e-18
C151	a_83_260##4	VPWR#5	3.18863e-17
C152	VPWR#6	A#1	2.7787e-19
C153	a_83_260##14	A#5	4.40204e-17
C154	X#1	a_83_260##4	6.46387e-17
C155	a_83_260##10	a_83_260##7	3.90993e-17
C156	VPWR#5	a_83_260##8	3.71489e-19
C157	VPWR#6	a_83_260##4	3.44144e-19
C158	VGND#2	VGND#1	6.79158e-17
C159	X#1	a_83_260##8	6.64848e-17
C160	VGND#2	a_83_260##16	1.75399e-17
C161	VPWR#5	a_83_260##11	1.72497e-19
C162	a_83_260##8	VPWR#6	2.42267e-17
C163	X#1	a_83_260##11	2.01285e-18
C164	VGND#2	X#6	7.29675e-18
C165	VGND#1	A#5	2.21213e-18
C166	X#3	a_83_260##8	1.81843e-18
C167	VGND#6	VGND#2	2.74731e-19
C168	a_83_260##11	VPWR#6	2.88136e-17
C169	a_83_260##14	A#2	6.62174e-17
C170	VPWR#2	VPWR#1	4.62072e-17
C171	VPWR#4	a_83_260##8	2.59902e-19
C172	a_83_260##2	A#3	8.3325e-19
C173	X#3	a_83_260##11	5.58067e-17
C174	a_493_388#	VPWR#2	1.26823e-17
C175	VGND#2	VGND#4	2.26649e-17
C176	VPWR#6	a_83_260##12	6.79311e-19
C177	VPWR#4	a_83_260##11	1.23306e-18
C178	X#3	a_83_260##12	4.91005e-17
C179	VPWR#2	a_493_388##2	5.03947e-17
C180	B#1	A#4	3.19654e-17
C181	a_83_260##12	VPWR#4	3.3773e-17
C182	A#5	VPWR#1	1.79401e-18
C183	X#1	VPWR#2	8.44616e-18
C184	VGND#3	a_83_260##9	5.89493e-20
C185	A#5	a_493_388#	3.607e-18
C186	X#4	a_83_260##3	4.9279e-17
C187	VGND#5	A#2	4.81089e-19
C188	VGND	a_83_260##9	4.97058e-20
C189	VGND	a_83_260##6	1.32181e-19
C190	a_83_260##3	X#2	6.16984e-17
C191	A#5	a_83_260##13	1.13631e-16
C192	B#4	B#1	3.76263e-17
C193	VPWR#2	VPWR#4	2.60272e-17
C194	a_83_260##3	VGND#5	2.35383e-17
C195	VGND#3	a_83_260##6	8.25874e-20
C196	a_83_260##3	X#6	7.60084e-17
C197	A#1	B#4	4.26139e-17
C198	a_83_260##3	VGND#6	2.76631e-18
C199	a_83_260##3	X#5	2.51339e-18
C200	VGND#2	B#5	8.35722e-19
C201	A#2	a_83_260##13	3.06262e-17
C202	VGND#2	A#3	5.60583e-18
C203	A#2	a_493_388##2	3.63225e-17
C204	a_83_260##4	A#1	3.57159e-17
C205	VGND#2	a_83_260#	6.58564e-18
C206	A#2	VPWR#5	1.31099e-17
C207	X#1	A#2	1.40794e-17
C208	VGND#2	a_83_260##5	6.17789e-19
C209	VPWR#3	a_83_260##9	4.57114e-20
C210	VGND#2	a_83_260##7	1.75707e-19
C211	a_83_260##8	a_83_260##4	4.70287e-17
C212	a_83_260##3	VPWR#5	5.72198e-18
C213	a_83_260##3	X#1	4.65423e-17
C214	a_83_260##14	B	2.42801e-17
C215	a_83_260##3	VPWR#6	2.76631e-18
C216	A#2	B#5	2.19968e-18
C217	VPWR#2	B#1	1.73538e-18
C218	a_83_260##3	X#3	2.35532e-18
C219	a_83_260##11	a_83_260##8	4.87041e-17
C220	VPWR#3	a_83_260##6	9.08134e-20
C221	VPWR#2	B#4	4.16505e-18
C222	a_83_260##3	B#5	2.44117e-19
C223	VPWR#2	A#1	1.2919e-17
C224	A#5	A#4	9.18483e-18
C225	a_83_260##12	a_83_260##11	4.68894e-17
C226	A#5	B#1	9.08872e-18
C227	VPWR#2	a_83_260##4	8.02649e-18
C228	a_83_260##3	a_83_260#	5.00499e-18
C229	a_83_260##3	a_83_260##5	6.04912e-19
C230	A#5	B#4	2.24621e-19
C231	VPWR#2	a_83_260##8	5.45681e-19
C232	a_83_260##3	a_83_260##7	4.74275e-20
C233	VPWR#2	a_83_260##11	8.74044e-20
C234	A#2	A#4	3.14231e-19
C235	a_83_260##3	a_83_260##10	7.36877e-20
C236	A#2	B#1	6.96067e-18
C237	B	a_83_260##13	2.37113e-18
C238	A#2	B#4	1.78477e-17
C239	B#3	VNB	5.65084e-17
C240	X#4	X	7.59591e-19
C241	a_83_260##9	VNB	3.81083e-17
C242	a_83_260##6	VNB	6.67377e-17
C243	a_83_260##2	VNB	2.78204e-17
C244	A#2	A#1	1.27832e-17
C245	a_83_260##4	A#2	6.24091e-18
C246	VPWR	VPWR#3	3.32562e-17
C247	X	VGND#4	2.6582e-17
C248	VPWR	X#2	3.33252e-18
C249	VGND	VGND#3	3.9758e-17
C250	A#2	VPWR#2	5.26176e-19
C251	VGND	a_83_260##14	1.06012e-17
C252	a_83_260##14	B#3	7.51355e-18
C253	VPWR	VPWR#1	4.50277e-17
C254	VGND#2	A#2	4.90066e-20
C255	VPWR	a_493_388#	2.07428e-17
C256	VGND	X#4	2.80231e-18
C257	X	VPWR#4	2.71432e-17
C258	a_83_260##3	VPWR#2	3.26282e-19
C259	VGND	X#2	3.82935e-18
C260	VPWR	a_83_260##13	1.32518e-17
C261	VGND	VGND#1	1.22428e-16
C262	VPWR	a_493_388##2	2.2611e-17
C263	A#2	A#5	2.27728e-18
C264	VGND	a_83_260##16	1.61947e-17
C265	VGND#2	a_83_260##3	5.30463e-19
C266	X	a_83_260#	3.06578e-20
C267	VPWR	X#1	1.70517e-17
C268	VGND	X#6	1.54778e-17
C269	X	a_83_260##5	4.84199e-20
C270	VGND	X#5	1.34617e-17
C271	VPWR	X#3	1.6164e-17
C272	X	a_83_260##7	2.2178e-19
C273	VGND	VGND#4	3.32524e-17
C274	VPWR	VPWR#4	3.48922e-17
C275	X	a_83_260##10	7.86018e-19
C276	a_83_260##3	A#2	3.74638e-17
C277	VGND	X#1	2.45054e-18
C278	VGND	B#5	5.80174e-19
C279	VPWR	A#4	2.73477e-18
C280	VGND	A#3	2.11072e-19
C281	VPWR	B#1	1.74783e-21
C282	VGND	a_83_260##5	4.52735e-19
C283	B	A#5	1.92529e-17
C284	VGND#3	VNB	3.44103e-17
C285	VGND	a_83_260##7	6.3997e-19
C286	VPWR	A#1	2.84243e-18
C287	VPWR#3	VNB	3.1734e-17
C288	a_83_260##14	VNB	3.71044e-17
C289	VPWR	a_83_260##4	2.61321e-18
C290	VPWR	a_83_260##8	3.58914e-19
C291	A#2	B	6.17696e-17
C292	X#4	VNB	9.81154e-19
C293	X#2	VNB	3.21007e-18
C294	VPWR	a_83_260##11	9.13497e-19
C295	VGND#1	VNB	9.23287e-17
C296	a_83_260##16	VNB	2.93598e-18
C297	VPWR	a_83_260##12	1.56974e-18
C298	VGND#5	VNB	3.39417e-19
C299	X#6	VNB	3.02515e-18
C300	VGND#6	VNB	2.8912e-19
C301	X#5	VNB	4.49802e-18
C302	VGND#4	VNB	5.03208e-17
C303	VPWR	VPWR#2	5.03925e-17
C304	VPWR#1	VNB	6.44348e-17
C305	a_493_388#	VNB	4.72034e-18
C306	a_83_260##13	VNB	4.50392e-17
C307	a_493_388##2	VNB	4.54904e-18
C308	X	A#2	3.64053e-19
C309	VPWR#5	VNB	3.35538e-18
C310	VPWR	A#5	4.13484e-18
C311	X#1	VNB	2.61e-18
C312	VPWR#6	VNB	2.92383e-18
C313	X	a_83_260##3	2.56882e-17
C314	X#3	VNB	3.08937e-18
C315	VPWR#4	VNB	6.61994e-17
C316	B#5	VNB	3.1906e-17
C317	VPWR	A#2	8.12034e-18
C318	A#3	VNB	2.70113e-17
C319	VGND	VGND#2	4.79927e-17
C320	a_83_260#	VNB	2.66213e-17
C321	a_83_260##5	VNB	2.68823e-17
C322	VGND	A#5	3.82102e-18
C323	VPWR	a_83_260##3	8.43441e-18
C324	a_83_260##7	VNB	2.46267e-17
C325	a_83_260##10	VNB	3.75296e-17
C326	A#4	VNB	3.86056e-17
C327	VGND	A#2	5.24702e-18
C328	B#1	VNB	2.89292e-17
C329	B#4	VNB	2.7318e-17
C330	VGND	a_83_260##3	9.24903e-18
C331	A#1	VNB	3.32894e-17
C332	a_83_260##4	VNB	3.63229e-17
C333	a_83_260##8	VNB	3.5669e-17
C334	a_83_260##11	VNB	3.39677e-17
C335	VPWR	B	1.7121e-18
C336	a_83_260##12	VNB	4.42965e-17
C337	VPWR#2	VNB	2.35113e-16
C338	VGND#2	VNB	2.23324e-16
C339	VGND	B	2.73345e-18
C340	A#5	VNB	5.65474e-17
C341	VPWR	X	2.52435e-18
C342	A#2	VNB	3.69374e-17
C343	a_83_260##3	VNB	4.80587e-18
C344	VGND	X	3.66778e-18
C345	B	VNB	4.80285e-18
C346	X	VNB	5.45187e-17
C347	VPWR	VNB	6.89911e-17
C348	VGND	VNB	5.32604e-17
*
*
.ENDS sky130_fd_sc_hs__or2_4
*
