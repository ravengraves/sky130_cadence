* Extracted by Quantus, converted by sky130cad/quantus.py
*
*
*
*                       LINUX           Wed Nov 18 09:11:46 2026
*
*
*
*  PROGRAM  advgen
*
*  Name           : advgen - Quantus - (64-bit)
*  Version        : 25.1.0-p047
*  Build Date     : Thu Dec 11 23:20:30 PST 2025
*
*  HSPICE LIBRARY
*
*  OPERATING_TEMPERATURE 150
*  QRC_TECH_DIR <path>/tech
*
*
*

*
.SUBCKT sky130_fd_sc_hs__sdlclkp_1 VNB VPB VGND VPWR GCLK SCE CLK GATE
*
*
*  caps2d version: 10
*
*
*       TRANSISTOR CARDS
*
*
XM13 VGND#7 SCE#3 a_114_112##3 VNB sky130_fd_pr__nfet_01v8_lvt l=0.15 w=0.55 ad=0.15675 as=0.154 pd=1.67 ps=1.66
XM15 a_114_112##3 GATE#1 VGND#11 VNB sky130_fd_pr__nfet_01v8_lvt l=0.15 w=0.55 ad=0.154 as=0.37805 pd=1.66 ps=2.82
XM0 VGND#11 a_288_48##5 a_318_74##7 VNB sky130_fd_pr__nfet_01v8_lvt l=0.15 w=0.74 ad=0.37805 as=0.2109 pd=2.82 ps=2.05
XM8 a_114_112##6 a_288_48##6 a_566_74##6 VNB sky130_fd_pr__nfet_01v8_lvt l=0.15 w=0.55 ad=0.29425 as=0.1846 pd=2.17 ps=1.81
XM10 a_566_74##6 a_318_74# a_667_80# VNB sky130_fd_pr__nfet_01v8_lvt l=0.15 w=0.42 ad=0.1846 as=0.0882 pd=1.81 ps=1.26
XM18 a_667_80# a_709_54##3 VGND#10 VNB sky130_fd_pr__nfet_01v8_lvt l=0.15 w=0.42 ad=0.0882 as=0.3026 pd=1.26 ps=2.54
XM21 VGND#10 a_566_74##3 a_709_54##12 VNB sky130_fd_pr__nfet_01v8_lvt l=0.15 w=0.74 ad=0.3026 as=0.2072 pd=2.54 ps=2.04
XM7 a_288_48##8 CLK#4 VGND#9 VNB sky130_fd_pr__nfet_01v8_lvt l=0.15 w=0.74 ad=0.2072 as=0.233 pd=2.04 ps=2.13
XM16 VGND#9 CLK#6 a_1166_94# VNB sky130_fd_pr__nfet_01v8_lvt l=0.15 w=0.64 ad=0.233 as=0.1344 pd=2.13 ps=1.7
XM4 a_1166_94# a_709_54##6 a_1238_94##6 VNB sky130_fd_pr__nfet_01v8_lvt l=0.15 w=0.64 ad=0.1344 as=0.1824 pd=1.7 ps=1.85
XM1 VGND#8 a_1238_94# GCLK#1 VNB sky130_fd_pr__nfet_01v8_lvt l=0.15 w=0.74 ad=0.2664 as=0.2072 pd=2.2 ps=2.04
XM19 VPWR#7 SCE#1 a_116_424# VPB sky130_fd_pr__pfet_01v8 l=0.15 w=0.84 ad=0.2478 as=0.2016 pd=2.27 ps=2.16
XM5 a_116_424# GATE#3 a_114_112# VPB sky130_fd_pr__pfet_01v8 l=0.15 w=0.84 ad=0.2016 as=0.2478 pd=2.16 ps=2.27
XM6 VPWR#11 a_288_48##2 a_318_74##9 VPB sky130_fd_pr__pfet_01v8 l=0.15 w=0.84 ad=0.4033 as=0.2478 pd=3.02 ps=2.27
XM12 a_114_112##5 a_318_74##4 a_566_74##7 VPB sky130_fd_pr__pfet_01v8 l=0.15 w=0.84 ad=0.2478 as=0.310975 pd=2.27 ps=2.74
XM20 a_566_74##7 a_288_48# a_722_492# VPB sky130_fd_pr__pfet_01v8 l=0.15 w=0.42 ad=0.310975 as=0.1008 pd=2.74 ps=1.32
XM2 a_722_492# a_709_54# VPWR#10 VPB sky130_fd_pr__pfet_01v8 l=0.15 w=0.42 ad=0.1008 as=0.3346 pd=1.32 ps=2.95
XM9 VPWR#10 a_566_74# a_709_54##8 VPB sky130_fd_pr__pfet_01v8 l=0.15 w=1.12 ad=0.3346 as=0.3304 pd=2.95 ps=2.83
XM11 a_288_48##7 CLK#5 VPWR#9 VPB sky130_fd_pr__pfet_01v8 l=0.15 w=0.84 ad=0.2478 as=0.56365 pd=2.27 ps=3.35
XM3 VPWR#9 CLK#1 a_1238_94##7 VPB sky130_fd_pr__pfet_01v8 l=0.15 w=0.84 ad=0.56365 as=0.252 pd=3.35 ps=2.28
XM14 a_1238_94##7 a_709_54##4 VPWR#8 VPB sky130_fd_pr__pfet_01v8 l=0.15 w=0.84 ad=0.252 as=0.3724 pd=2.28 ps=2.95
XM17 VPWR#8 a_1238_94##3 GCLK#2 VPB sky130_fd_pr__pfet_01v8 l=0.15 w=1.12 ad=0.3724 as=0.4256 pd=2.95 ps=3
*
*
*       RESISTOR AND CAP/DIODE CARDS
*
Rg1	SCE#1	SCE#2	378.463257
Rg2	SCE#2	SCE#3	317.755829
Rg3	GATE#1	GATE#2	488.704193
Rg4	GATE#2	GATE#3	354.298584
Rg5	a_318_74#	a_318_74##2	510.960907
Rg6	a_318_74##2	a_318_74##3	37.519978
Rg7	a_318_74##2	a_318_74##4	348.097198
Rg8	a_288_48#	a_288_48##2	1487.828491
Rg9	a_288_48##2	a_288_48##3	465.333984
Rg10	a_288_48##3	a_288_48##4	91.910866
Rg11	a_288_48##3	a_288_48##5	509.568146
Rg12	a_288_48##4	a_288_48##6	444.514008
Rg13	a_709_54#	a_709_54##2	329.922943
Rg14	a_709_54##2	a_709_54##3	736.494446
Rg15	a_566_74#	a_566_74##2	488.223389
Rg16	a_566_74##2	a_566_74##3	306.012482
Rg17	CLK#1	CLK#2	470.846863
Rg18	CLK#2	CLK#3	40.778732
Rg19	CLK#3	CLK#4	420.806152
Rg20	CLK#2	CLK#5	314.013733
Rg21	CLK#3	CLK#6	381.807465
Rg22	a_709_54##4	a_709_54##5	546.076904
Rg23	a_709_54##5	a_709_54##6	306.097992
Rg24	a_1238_94#	a_1238_94##2	336.169464
Rg25	a_1238_94##2	a_1238_94##3	443.943878
Rf1	SCE	SCE#2	82.999611
Rf2	GATE#2	GATE#5	163.158218
Rf3	GATE#6	GATE	2.925421
Rf4	GATE#5	GATE#6	6.596592
Rf5	a_114_112#	a_114_112##2	39.367592
Rf6	a_114_112##2	a_114_112##4	147.453079
Rf7	a_114_112##2	a_114_112##5	88.303192
Rf8	a_114_112##4	a_114_112##6	123.717316
Rf9	a_114_112##3	a_114_112##4	15.000000
Rf10	a_318_74##3	a_318_74##6	190.041748
Rf11	a_318_74##6	a_318_74##8	45.988651
Rf12	a_318_74##6	a_318_74##9	23.613857
Rf13	a_318_74##7	a_318_74##8	15.000000
Rf14	a_566_74##2	a_566_74##5	190.560654
Rf15	a_566_74##5	a_566_74##6	57.001823
Rf16	a_566_74##5	a_566_74##7	46.369385
Rf17	a_288_48##7	a_288_48##9	100.522705
Rf18	a_288_48##9	a_288_48##4	488.423035
Rf19	a_288_48##8	a_288_48##9	7.500000
Rf20	CLK	CLK#3	165.941055
Rf21	a_709_54##5	a_709_54##9	342.936798
Rf22	a_709_54##9	a_709_54##10	16.261833
Rf23	a_709_54##10	a_709_54##2	185.197433
Rf24	a_709_54##10	a_709_54##12	81.416473
Rf25	a_709_54##8	a_709_54##9	5.000000
Rf26	a_1238_94##2	a_1238_94##5	177.377243
Rf27	a_1238_94##5	a_1238_94##6	52.398129
Rf28	a_1238_94##5	a_1238_94##7	54.799160
Rf29	GCLK#1	GCLK	87.083542
Rf30	GCLK	GCLK#3	13.585999
Rf31	GCLK#3	GCLK	0.186110
Rf32	GCLK#2	GCLK#3	5.000000
Rf33	VGND#1	VGND#2	19.025946
Rf34	VGND#2	VGND#3	102.701584
Rf35	VGND#3	VGND#4	124.316704
Rf36	VGND#4	VGND#5	34.797028
Rf37	VGND#5	VGND#6	156.303528
Rf38	VGND#6	VGND#7	124.747253
Rf39	VGND#2	VGND#8	41.038895
Rf40	VGND#3	VGND#9	43.597031
Rf41	VGND#4	VGND#10	49.685638
Rf42	VGND#6	VGND#11	22.894152
Rf43	VPWR#1	VPWR#2	24.812635
Rf44	VPWR#2	VPWR#3	78.264992
Rf45	VPWR#3	VPWR#4	119.538521
Rf46	VPWR#4	VPWR#5	57.685360
Rf47	VPWR#5	VPWR#6	122.700302
Rf48	VPWR#6	VPWR#7	134.830505
Rf49	VPWR#2	VPWR#8	38.128750
Rf50	VPWR#3	VPWR#9	22.947691
Rf51	VPWR#4	VPWR#10	37.656876
Rf52	VPWR#6	VPWR#11	31.554951
Re1	VPWR#1	VPWR	6.179563
Re2	VPWR	VPWR#5	0.882795
Re3	VGND#1	VGND	6.179563
Re4	VGND	VGND#5	0.882795
*
*       CAPACITOR CARDS
*
*
C1	VGND#7	VGND#6	4.20654e-18
C2	a_566_74##6	a_709_54##3	2.19698e-18
C3	a_114_112##5	a_566_74##7	6.45226e-17
C4	a_566_74##5	a_566_74#	6.10482e-20
C5	VGND#4	VGND#3	3.36229e-19
C6	VPWR#3	VPWR#8	4.73789e-18
C7	a_566_74##6	a_318_74#	2.60575e-17
C8	a_288_48##8	a_566_74##5	2.40119e-17
C9	a_1238_94##5	CLK#2	1.34418e-18
C10	a_114_112##5	a_318_74##9	5.57318e-18
C11	a_288_48##6	a_566_74##6	1.40144e-17
C12	VPWR#3	a_1238_94##7	1.12041e-17
C13	a_288_48##6	a_114_112##6	2.56999e-17
C14	VPWR#11	a_114_112##5	4.67691e-18
C15	a_566_74##5	a_709_54##12	8.87456e-19
C16	a_566_74##5	a_288_48#	3.50206e-18
C17	a_1238_94##7	VPWR#2	6.86549e-18
C18	a_318_74##7	a_288_48##6	4.40571e-19
C19	VGND#3	VGND#2	5.83021e-19
C20	a_114_112#	a_114_112##5	1.41135e-18
C21	a_114_112##6	a_288_48##5	2.00952e-17
C22	VPWR#3	VPWR#9	1.05655e-17
C23	a_709_54##10	VPWR#4	1.95693e-19
C24	VPWR#1	VPWR#2	4.71134e-17
C25	a_566_74##5	a_318_74##4	2.06527e-18
C26	a_318_74##7	a_288_48##5	2.04183e-17
C27	a_114_112##3	a_288_48##6	1.74733e-19
C28	a_114_112##6	GATE#1	6.06626e-19
C29	a_566_74#	CLK#2	2.11349e-18
C30	a_288_48##5	VGND#11	1.70668e-17
C31	a_114_112#	VPWR#11	2.64197e-17
C32	a_318_74##7	GATE#1	2.38002e-18
C33	a_566_74##5	a_288_48##2	5.46846e-20
C34	a_114_112##3	a_288_48##5	1.60944e-17
C35	a_114_112##6	SCE#3	3.06596e-19
C36	a_318_74##6	a_318_74##4	1.71144e-18
C37	a_709_54##8	VPWR#4	1.68873e-17
C38	GATE#1	VGND#11	1.4581e-17
C39	VGND#7	a_288_48##5	2.22797e-18
C40	a_114_112##3	GATE#1	5.03082e-17
C41	a_709_54##8	VPWR#3	3.64697e-17
C42	VPWR#7	VPWR#11	7.91292e-19
C43	VPWR#1	a_1238_94##5	6.57464e-19
C44	a_318_74##6	a_288_48##2	2.62026e-17
C45	VGND#7	GATE#1	8.64893e-19
C46	a_1238_94##5	VPWR#8	5.46338e-18
C47	a_114_112##2	a_318_74##4	2.71009e-19
C48	VGND#1	VGND#2	4.62082e-17
C49	VPWR#7	a_114_112#	2.4166e-17
C50	a_114_112##3	SCE#3	3.44788e-17
C51	VGND#9	CLK#2	4.56e-18
C52	VGND#2	a_1238_94##5	4.70548e-19
C53	VGND#7	SCE#3	1.78491e-17
C54	VPWR#10	VPWR#3	1.90342e-18
C55	VGND#1	a_1238_94##5	1.3457e-18
C56	a_318_74##6	GATE#3	2.46854e-19
C57	a_114_112##2	a_288_48##2	3.17969e-17
C58	VGND#8	GCLK#1	6.54703e-17
C59	a_709_54##10	CLK#2	3.29911e-18
C60	VPWR#11	a_288_48##3	3.12579e-19
C61	a_114_112##2	GATE#3	1.47719e-18
C62	a_288_48##8	CLK#2	4.69429e-18
C63	a_1238_94##3	GCLK#2	2.4726e-20
C64	a_114_112##2	SCE#1	5.37554e-19
C65	a_114_112##6	a_318_74##6	2.85753e-18
C66	a_1238_94##6	VGND#8	6.45564e-17
C67	a_114_112##5	VPWR#6	4.33086e-18
C68	a_288_48##8	a_288_48#	4.06908e-19
C69	VPWR#8	a_1238_94##3	5.27748e-17
C70	a_709_54##5	VPWR#3	1.72344e-17
C71	a_709_54##6	a_1238_94#	3.99801e-18
C72	VPWR#2	a_709_54##5	6.29597e-20
C73	a_1238_94##7	a_1238_94##3	3.90446e-18
C74	a_114_112##5	a_288_48##6	3.0167e-19
C75	a_709_54##4	VPWR#8	1.96356e-17
C76	a_1238_94##5	a_1238_94##2	1.74132e-18
C77	a_709_54##12	CLK#2	3.30699e-19
C78	VGND#3	a_709_54##5	2.68063e-18
C79	a_1238_94##7	a_709_54##4	5.8382e-17
C80	CLK#6	a_709_54##6	5.35032e-17
C81	CLK#4	a_1238_94#	8.80873e-20
C82	VPWR#8	CLK#1	8.46402e-19
C83	VGND#2	a_709_54##5	4.13746e-19
C84	VGND#9	VGND#8	2.00877e-18
C85	a_566_74##5	VPWR#5	5.65978e-19
C86	a_1238_94##7	CLK#1	4.5781e-17
C87	a_1238_94##5	a_709_54##5	9.23554e-17
C88	VPWR#11	a_288_48##5	6.64685e-19
C89	a_114_112##6	a_114_112##2	1.51333e-18
C90	VPWR#8	CLK#5	3.39991e-19
C91	a_709_54##10	a_288_48##7	5.5635e-17
C92	VGND#3	CLK#3	3.89408e-19
C93	CLK#4	CLK#6	3.34288e-17
C94	CLK#1	VPWR#9	9.86396e-18
C95	VGND#9	a_1238_94##6	2.30944e-17
C96	a_1238_94##7	CLK#5	1.30908e-18
C97	a_288_48##7	CLK#1	2.07349e-18
C98	CLK#5	VPWR#9	1.80894e-17
C99	a_318_74##7	a_114_112##2	1.39066e-17
C100	VGND#4	a_566_74##2	4.35367e-19
C101	a_709_54##8	CLK#1	6.0059e-19
C102	a_709_54##2	VPWR#4	1.29836e-18
C103	a_1238_94##7	a_566_74#	1.68152e-19
C104	a_709_54##10	a_709_54##8	1.99487e-18
C105	a_566_74##3	CLK#4	4.18444e-18
C106	a_114_112#	VPWR#6	1.77819e-17
C107	a_288_48##7	CLK#5	3.31164e-17
C108	VPWR#10	CLK#1	3.01281e-19
C109	a_709_54##8	CLK#5	3.69266e-17
C110	a_288_48##7	a_566_74#	1.01679e-18
C111	VGND#1	GCLK#1	4.14019e-17
C112	VGND#4	a_709_54##2	1.54046e-21
C113	VPWR#10	CLK#5	1.03388e-18
C114	a_709_54##10	VPWR#10	8.94323e-18
C115	a_709_54##3	a_566_74##3	1.60392e-17
C116	a_709_54##8	a_566_74#	6.08917e-17
C117	a_114_112##3	a_114_112##2	3.02853e-18
C118	a_288_48##8	VGND#9	6.59547e-17
C119	a_566_74#	VPWR#10	2.31022e-17
C120	a_709_54##10	a_566_74##2	3.98538e-17
C121	a_709_54##8	a_709_54#	1.71329e-18
C122	VPWR#6	a_288_48##4	6.61061e-19
C123	a_318_74#	a_709_54##3	5.39045e-17
C124	a_288_48##6	a_566_74##3	8.18409e-20
C125	VPWR#10	a_709_54#	3.01115e-17
C126	VPWR#7	VPWR#6	4.365e-19
C127	a_566_74##7	a_566_74#	4.81383e-19
C128	a_709_54##8	a_288_48#	2.53811e-19
C129	a_709_54##10	a_709_54##2	2.54378e-19
C130	VGND#6	a_288_48##4	3.68051e-18
C131	VPWR#10	a_288_48#	5.35117e-18
C132	a_566_74##7	a_709_54#	2.74631e-18
C133	a_288_48##4	VGND#4	2.67035e-18
C134	VPWR#6	GATE#2	6.98052e-20
C135	a_288_48##6	a_318_74#	2.94672e-17
C136	a_566_74##5	a_566_74##2	1.41174e-19
C137	a_709_54##8	a_318_74##4	5.21761e-19
C138	a_288_48##8	a_709_54##12	1.19122e-16
C139	GCLK#1	a_1238_94##2	2.90628e-17
C140	VPWR#10	a_318_74##4	2.05148e-18
C141	a_288_48#	a_566_74##7	2.03899e-17
C142	VGND#8	a_1238_94##2	3.95956e-17
C143	a_114_112##2	VPWR#6	2.79985e-18
C144	VGND#6	GATE#2	2.66397e-19
C145	a_288_48##8	VGND#10	6.29516e-17
C146	a_114_112##5	a_288_48#	3.28337e-18
C147	a_288_48##5	a_288_48##6	2.23039e-18
C148	a_566_74##5	a_709_54##2	3.34742e-17
C149	VPWR#10	a_288_48##2	1.00724e-18
C150	VPWR#11	a_709_54#	5.33513e-19
C151	GCLK#1	a_709_54##5	5.42186e-19
C152	a_566_74##7	a_318_74##4	4.10219e-17
C153	a_318_74##4	a_114_112##5	1.75749e-17
C154	a_709_54##5	a_1238_94##6	2.14376e-17
C155	VPWR#11	a_288_48#	1.05047e-18
C156	a_566_74##7	a_288_48##2	1.18616e-18
C157	VGND#6	SCE#2	6.95342e-20
C158	a_566_74##5	a_318_74##3	7.27105e-17
C159	GATE#1	a_288_48##5	2.571e-17
C160	a_114_112##5	a_288_48##2	1.03542e-17
C161	VPWR#11	a_318_74##4	1.45729e-18
C162	VGND#5	a_114_112##6	3.15781e-18
C163	a_566_74##6	a_288_48##8	2.01081e-17
C164	a_288_48##8	a_709_54##5	5.45e-18
C165	a_288_48##2	a_318_74##9	2.16793e-17
C166	a_318_74##6	a_318_74##3	3.84349e-18
C167	a_114_112#	a_318_74##4	1.73338e-19
C168	a_114_112##5	GATE#3	3.58586e-19
C169	a_288_48##2	VPWR#11	2.9766e-17
C170	a_114_112##6	a_288_48##3	1.09009e-18
C171	SCE#3	GATE#1	3.08134e-17
C172	a_288_48##4	a_566_74##5	1.56676e-17
C173	VGND#9	CLK#3	2.48116e-17
C174	a_114_112#	a_288_48##2	2.34103e-18
C175	a_288_48##8	CLK#3	1.48064e-17
C176	VPWR#11	GATE#3	3.2391e-18
C177	a_318_74##6	a_288_48##4	3.89849e-17
C178	VGND#3	a_1238_94#	3.83147e-19
C179	a_114_112#	GATE#3	4.86155e-17
C180	VPWR#7	a_288_48##2	9.61483e-19
C181	VPWR#11	SCE#1	7.88337e-19
C182	a_288_48##8	a_566_74##2	6.18251e-17
C183	a_114_112##2	a_288_48##4	8.47351e-20
C184	VGND#2	a_1238_94#	3.03127e-18
C185	a_709_54##12	a_566_74##2	1.58032e-17
C186	a_114_112#	SCE#1	7.44565e-18
C187	a_318_74##6	GATE#2	1.02426e-18
C188	VPWR#7	GATE#3	1.29485e-17
C189	a_566_74##2	VGND#10	2.76631e-18
C190	a_318_74##7	a_288_48##3	7.10426e-18
C191	VGND#3	a_709_54##6	6.36419e-18
C192	a_1238_94##2	VPWR#8	1.4433e-17
C193	a_288_48##8	a_709_54##2	7.6359e-19
C194	VPWR#7	SCE#1	4.89257e-17
C195	GATE#2	a_114_112##2	2.96865e-17
C196	VGND#10	a_709_54##2	7.35507e-19
C197	a_566_74##5	a_709_54##10	7.60612e-19
C198	a_566_74##7	VPWR#5	9.55184e-18
C199	a_318_74##6	a_566_74##7	6.93048e-20
C200	a_709_54##4	a_1238_94##3	3.87124e-17
C201	a_709_54##5	a_1238_94##7	6.52325e-17
C202	a_114_112##5	VPWR#5	7.99188e-18
C203	VGND#3	CLK#6	2.35418e-18
C204	a_709_54##12	a_318_74##3	2.29377e-21
C205	a_114_112##2	SCE#2	1.58834e-19
C206	a_709_54##5	VPWR#9	1.44668e-17
C207	a_288_48##7	a_709_54##5	1.67314e-17
C208	VGND#4	CLK#4	1.17092e-19
C209	CLK#1	a_709_54##4	4.29108e-17
C210	a_318_74##6	a_114_112##5	4.83756e-17
C211	a_288_48##4	a_288_48##8	3.19072e-18
C212	a_709_54##8	a_709_54##5	1.77074e-18
C213	a_566_74##6	a_318_74##3	7.52764e-18
C214	a_288_48##6	a_288_48##2	4.04465e-20
C215	VGND#3	CLK#4	8.72445e-18
C216	a_288_48##4	VGND#10	3.76617e-17
C217	a_288_48##7	CLK#3	8.18463e-18
C218	VGND#1	a_1238_94#	9.33199e-18
C219	CLK#5	CLK#1	1.55601e-17
C220	a_288_48##4	a_566_74##6	8.93691e-17
C221	a_318_74##6	a_318_74##9	2.39325e-18
C222	VGND#2	CLK#4	1.60507e-19
C223	a_1238_94##5	CLK#6	9.77824e-20
C224	VGND#4	a_566_74##3	6.17105e-18
C225	a_288_48##4	a_114_112##6	7.02391e-17
C226	a_288_48##7	a_566_74##2	1.00905e-18
C227	a_114_112##6	a_318_74##7	3.25811e-17
C228	a_318_74##7	a_288_48##4	3.08798e-17
C229	VGND#3	a_566_74##3	3.84494e-19
C230	a_566_74#	CLK#5	4.59889e-18
C231	a_566_74##2	VPWR#10	4.18664e-18
C232	a_114_112##3	a_288_48##4	9.80087e-19
C233	a_114_112##2	a_114_112##5	1.75682e-18
C234	a_318_74##6	VPWR#11	2.59603e-18
C235	a_1238_94##5	CLK#4	6.47047e-20
C236	a_709_54##8	a_709_54##2	1.27712e-18
C237	VGND#4	a_709_54##3	3.24976e-18
C238	a_709_54##2	VPWR#10	1.41677e-17
C239	a_709_54#	a_566_74#	2.36363e-17
C240	a_114_112##3	GATE#2	5.46961e-17
C241	a_709_54##6	a_1238_94##2	1.09274e-19
C242	a_114_112##2	a_318_74##9	1.93019e-19
C243	a_566_74##7	a_709_54##2	3.14687e-17
C244	VPWR#6	a_288_48##5	5.68587e-20
C245	VGND#5	a_709_54##3	1.48911e-18
C246	a_288_48#	a_709_54#	4.90037e-17
C247	a_318_74##6	a_288_48##3	1.30125e-17
C248	a_114_112##3	SCE#2	5.86671e-18
C249	VPWR#5	a_288_48##6	1.61184e-20
C250	CLK#6	a_709_54##5	1.06681e-17
C251	SCE#2	VGND#7	9.95986e-18
C252	VGND#5	a_318_74#	4.11994e-18
C253	a_114_112##3	a_318_74##7	7.93329e-18
C254	CLK	CLK#2	1.67445e-17
C255	a_318_74##4	a_709_54#	3.12014e-19
C256	a_114_112##2	VPWR#11	3.89231e-17
C257	a_318_74##3	a_114_112##5	3.16906e-17
C258	a_709_54##5	CLK#4	5.11648e-19
C259	VGND#6	a_288_48##6	6.06939e-19
C260	VGND#5	a_288_48##6	4.41564e-18
C261	VPWR#1	a_1238_94##3	7.56653e-18
C262	a_318_74##4	a_288_48#	3.66267e-17
C263	VGND#4	a_288_48##6	7.41867e-19
C264	a_114_112##3	VGND#11	4.20141e-18
C265	a_114_112##5	a_288_48##4	9.18777e-19
C266	a_288_48##2	a_288_48#	1.48099e-18
C267	a_288_48##2	a_318_74##4	8.69043e-18
C268	a_566_74##2	CLK#4	1.00311e-18
C269	a_288_48##8	a_709_54##8	1.67751e-18
C270	VGND#6	a_288_48##5	1.42818e-17
C271	a_566_74##2	a_709_54##3	1.01012e-17
C272	a_114_112##3	a_116_424#	8.74745e-20
C273	GATE#3	a_288_48##2	5.58591e-18
C274	SCE	a_288_48##3	2.65805e-19
C275	GATE#2	a_114_112#	1.54785e-18
C276	VGND#7	a_114_112##3	4.94714e-17
C277	VGND#6	GATE#1	2.94292e-18
C278	a_709_54##4	a_1238_94##2	5.98122e-18
C279	VGND#3	VGND#8	7.86583e-19
C280	SCE#1	GATE#3	5.61267e-17
C281	a_318_74##3	a_709_54##3	9.48688e-18
C282	VPWR#7	a_114_112##2	1.67107e-18
C283	a_709_54##5	a_709_54##4	1.40344e-20
C284	a_709_54##5	CLK#2	4.25343e-17
C285	a_288_48##4	a_566_74##3	7.15057e-19
C286	VPWR#7	SCE#2	6.89127e-18
C287	VPWR#5	a_288_48#	3.01646e-17
C288	a_709_54##5	CLK#1	3.24229e-17
C289	a_288_48##6	a_318_74##3	1.67209e-17
C290	a_288_48##4	a_709_54##3	1.44517e-17
C291	a_566_74##5	CLK#4	8.38863e-20
C292	VPWR#5	a_318_74##4	4.23487e-18
C293	a_709_54##5	CLK#5	5.23263e-18
C294	a_288_48##4	a_318_74#	1.49145e-17
C295	VPWR#3	CLK#2	1.82676e-18
C296	VGND#6	SCE#3	5.30364e-18
C297	VGND#3	a_1238_94##6	2.59791e-18
C298	a_288_48##4	a_288_48##6	3.06102e-17
C299	a_709_54##5	a_566_74#	3.6326e-19
C300	VPWR#5	a_288_48##2	1.64558e-18
C301	a_288_48##5	a_288_48##4	6.78963e-18
C302	a_318_74##6	a_566_74##5	3.16445e-18
C303	a_1238_94##5	GCLK#1	1.1235e-18
C304	a_288_48##4	GATE#1	1.1133e-19
C305	a_566_74##5	a_566_74##3	2.0609e-19
C306	VGND#2	a_1238_94##6	1.51271e-17
C307	GATE	VPWR#6	5.50628e-19
C308	CLK#3	CLK#2	1.29169e-17
C309	VPWR#3	a_1238_94##3	1.68736e-18
C310	a_709_54##2	a_566_74#	2.13471e-17
C311	SCE#2	GATE#1	9.08405e-18
C312	a_566_74##5	a_709_54##3	4.29781e-18
C313	a_114_112##2	a_288_48##3	2.44655e-18
C314	VPWR#2	a_1238_94##3	4.14085e-18
C315	a_709_54##2	a_288_48#	1.12711e-17
C316	a_1238_94##2	VPWR#1	5.81127e-18
C317	VPWR	CLK#2	2.58486e-20
C318	a_318_74##4	a_709_54##2	8.98097e-18
C319	a_318_74##3	a_288_48#	1.32619e-18
C320	VGND#1	a_1238_94##2	5.02872e-18
C321	VPWR#3	a_709_54##4	1.37468e-18
C322	VGND#4	a_288_48##8	4.67759e-17
C323	a_566_74##5	a_318_74#	2.19885e-18
C324	a_1238_94##6	a_1238_94##5	3.18286e-18
C325	a_709_54##6	a_1166_94#	1.34792e-17
C326	a_288_48##2	a_318_74##3	3.59205e-18
C327	CLK#6	a_1166_94#	1.34792e-17
C328	VPWR#2	a_709_54##4	4.37639e-18
C329	a_1238_94##7	VPWR#8	7.28374e-17
C330	GCLK#1	a_1238_94#	3.65808e-17
C331	a_288_48##4	a_288_48##2	1.08098e-18
C332	a_566_74##2	CLK#2	4.86925e-18
C333	GATE	a_114_112##2	2.31291e-17
C334	VGND#3	a_288_48##8	4.92039e-17
C335	a_566_74##6	a_114_112##5	1.69649e-19
C336	GATE#2	a_288_48##2	4.99377e-18
C337	CLK#2	VPWR#9	9.34629e-19
C338	VPWR#4	VPWR#3	5.11307e-19
C339	a_709_54##5	a_1238_94##2	3.03695e-17
C340	VPWR#3	CLK#1	1.1901e-17
C341	a_1238_94#	VGND#8	2.10235e-17
C342	a_566_74##5	a_288_48##6	2.03819e-18
C343	VGND#6	SCE	1.17174e-18
C344	a_709_54##2	VPWR#5	2.94595e-18
C345	a_709_54#	a_722_492#	9.87534e-18
C346	VGND	a_288_48##3	1.05786e-18
C347	CLK#3	a_709_54##5	2.50086e-17
C348	a_1238_94##6	a_1238_94#	2.81327e-18
C349	a_318_74##3	VPWR#5	1.76826e-18
C350	a_288_48#	a_722_492#	9.87534e-18
C351	a_709_54##3	a_667_80#	6.40345e-18
C352	a_709_54##5	a_566_74##2	3.54337e-19
C353	VGND#5	a_318_74##3	5.26734e-20
C354	VGND#8	a_709_54##6	2.59518e-18
C355	a_1238_94##5	a_1238_94##3	3.66088e-19
C356	a_318_74#	a_667_80#	3.9673e-19
C357	VGND#5	a_288_48##4	8.41767e-17
C358	VPWR#3	CLK#5	1.43531e-17
C359	VGND#6	a_288_48##3	3.91036e-19
C360	a_1238_94##6	a_709_54##6	4.67786e-17
C361	a_566_74##2	a_709_54##2	6.97158e-17
C362	GATE#3	a_116_424#	1.92873e-17
C363	SCE	a_114_112##2	1.95691e-18
C364	a_1238_94##5	GCLK	2.4811e-18
C365	VGND#9	a_1238_94#	7.10664e-19
C366	VGND#3	CLK#1	1.23325e-19
C367	VGND#8	CLK#6	2.68312e-19
C368	SCE#1	a_116_424#	1.95459e-17
C369	a_288_48##7	CLK#2	1.22571e-17
C370	VPWR#4	a_566_74#	2.45078e-18
C371	a_1238_94##5	a_709_54##4	3.22717e-18
C372	a_318_74##3	a_709_54##2	3.16632e-17
C373	a_709_54##8	a_1238_94##7	1.25331e-18
C374	VPWR#3	VPWR#2	1.2535e-18
C375	VPWR	VPWR#6	1.08009e-16
C376	a_288_48##8	a_1238_94##5	4.591e-19
C377	a_1238_94##6	CLK#6	4.53507e-18
C378	VPWR	VPWR#4	9.53292e-17
C379	VPWR#3	a_566_74#	1.56365e-18
C380	a_288_48##8	a_1238_94#	2.217e-19
C381	VPWR	VPWR#3	1.01912e-16
C382	VPWR	VPWR#2	1.76739e-17
C383	a_288_48##4	a_318_74##3	2.34034e-17
C384	VGND#9	a_709_54##6	6.97751e-18
C385	VGND#8	CLK#4	4.82334e-19
C386	a_288_48##7	CLK	2.70425e-17
C387	a_114_112##2	a_318_74##6	1.00986e-16
C388	GATE	a_114_112#	3.092e-17
C389	CLK	a_709_54##8	6.75041e-18
C390	a_709_54##8	VPWR#9	2.85696e-18
C391	GCLK#1	GCLK	3.18062e-18
C392	VPWR#7	GATE	6.45718e-18
C393	VPWR	a_709_54##10	1.46799e-18
C394	SCE	a_114_112##3	3.08823e-17
C395	SCE	VGND#7	3.44786e-17
C396	a_1238_94##5	CLK#1	2.87574e-18
C397	VPWR#4	a_709_54#	3.58431e-18
C398	a_1238_94##6	CLK#4	1.96934e-18
C399	VPWR	a_566_74##5	2.10027e-18
C400	VPWR	a_318_74##6	6.88153e-18
C401	CLK#6	VGND#9	2.16422e-17
C402	SCE#2	GATE#2	4.68837e-17
C403	VPWR#3	a_709_54#	2.34792e-19
C404	VPWR	a_114_112##2	7.61309e-18
C405	a_709_54##8	a_288_48##7	6.15592e-17
C406	VGND	VGND#6	1.28048e-16
C407	VGND	VGND#4	7.15514e-17
C408	VGND	VGND#3	1.09181e-16
C409	a_288_48##3	a_318_74##3	6.1107e-18
C410	VGND	VGND#2	2.52066e-17
C411	a_709_54##8	CLK#2	4.48089e-18
C412	GCLK	GCLK#2	1.91774e-17
C413	VGND	a_1238_94##5	2.24888e-18
C414	VPWR#8	GCLK	6.7925e-17
C415	VGND#6	a_114_112##6	2.53767e-17
C416	a_1238_94##7	GCLK	7.09857e-18
C417	VGND	a_709_54##10	4.17734e-18
C418	a_288_48##8	CLK#6	1.59019e-18
C419	a_114_112##2	a_288_48##5	1.93162e-17
C420	SCE	VPWR#7	3.56799e-17
C421	VGND#3	CLK#2	2.01903e-19
C422	VGND	a_566_74##5	3.38825e-18
C423	VPWR#4	a_288_48#	3.69562e-18
C424	CLK#4	VGND#9	2.20598e-17
C425	CLK#2	VNB	7.76156e-17
C426	VGND	a_318_74##6	2.29763e-18
C427	a_288_48##3	VNB	2.54912e-17
C428	VPWR	a_114_112##3	5.03838e-18
C429	VGND	a_114_112##2	1.51929e-18
C430	VPWR	a_1238_94##7	1.76354e-17
C431	VPWR#3	a_288_48#	4.20969e-19
C432	a_114_112##3	a_114_112#	1.98004e-18
C433	VGND	a_1238_94##6	2.13125e-17
C434	VPWR	a_288_48##7	6.3971e-18
C435	SCE	GATE#1	1.06289e-18
C436	VPWR	a_709_54##8	3.45165e-17
C437	GATE	a_288_48##2	2.68599e-19
C438	a_288_48##8	a_709_54##10	1.07613e-17
C439	a_288_48##8	CLK#4	6.52407e-17
C440	VGND	a_288_48##8	4.81759e-17
C441	CLK	a_566_74#	1.10201e-19
C442	VGND	a_709_54##12	8.56796e-18
C443	GATE	GATE#3	7.38448e-18
C444	VPWR#10	a_709_54##8	4.28528e-17
C445	a_288_48##4	a_667_80#	2.80032e-19
C446	VPWR	a_566_74##7	1.55023e-17
C447	VPWR	a_114_112##5	1.94999e-17
C448	GATE	SCE#1	3.46787e-18
C449	VGND	a_566_74##6	9.9442e-18
C450	VGND	a_114_112##6	2.56869e-17
C451	VPWR	VPWR#11	1.85004e-17
C452	VGND	a_318_74##7	6.07665e-18
C453	VPWR	a_114_112#	1.70687e-17
C454	VGND	a_114_112##3	2.40655e-17
C455	VGND	VGND#7	4.83948e-17
C456	VPWR	VPWR#7	8.03614e-17
C457	a_709_54##12	CLK#4	9.65891e-19
C458	GCLK	a_1238_94##3	2.94074e-17
C459	a_709_54##10	CLK#5	1.88644e-19
C460	GCLK	a_709_54##4	1.66885e-18
C461	a_288_48##8	a_566_74##3	4.5581e-17
C462	VPWR#6	VNB	4.91236e-17
C463	VPWR#4	VNB	4.08741e-17
C464	VPWR#3	VNB	5.00356e-17
C465	VPWR#2	VNB	2.46818e-17
C466	VGND#6	VNB	6.51374e-17
C467	VGND	a_709_54##6	1.0892e-17
C468	CLK	a_709_54##5	2.04002e-17
C469	VGND#4	VNB	3.44298e-17
C470	VGND#3	VNB	5.41327e-17
C471	VGND	CLK#6	6.99061e-18
C472	VPWR	a_709_54##4	8.72369e-18
C473	VGND#2	VNB	3.0507e-17
C474	VGND	CLK#4	4.39345e-18
C475	VPWR	CLK#1	8.72477e-18
C476	a_1238_94##5	VNB	4.75576e-19
C477	VGND	a_566_74##3	1.93903e-18
C478	VPWR	CLK#5	9.20264e-18
C479	a_709_54##10	VNB	9.06069e-18
C480	VGND	a_709_54##3	3.1696e-18
C481	VPWR	a_566_74#	8.99041e-18
C482	VGND#6	VGND#11	6.52143e-18
C483	VGND	a_288_48##6	2.08103e-18
C484	VPWR	a_709_54#	4.0845e-18
C485	GCLK	VPWR#1	4.49284e-17
C486	GATE	GATE#2	6.0335e-18
C487	a_566_74##5	VNB	1.69016e-18
C488	VGND	a_288_48##5	1.5003e-18
C489	VPWR	a_288_48#	1.61767e-17
C490	a_566_74##3	a_709_54##12	1.37133e-17
C491	VPWR#6	a_288_48##2	2.37467e-17
C492	VGND	GATE#1	8.72706e-18
C493	VGND#1	GCLK	1.68982e-18
C494	a_318_74##6	VNB	1.09361e-17
C495	VPWR	a_318_74##4	4.93154e-18
C496	GATE	SCE#2	2.3182e-18
C497	a_566_74##7	a_709_54##8	4.62895e-18
C498	VGND	SCE#3	9.10762e-18
C499	VPWR	a_288_48##2	1.2985e-17
C500	a_114_112##2	VNB	1.07181e-17
C501	VPWR	GATE#3	1.6856e-18
C502	VPWR	SCE#1	1.76643e-18
C503	GCLK#1	VNB	5.12972e-17
C504	a_1238_94##2	GCLK	3.23235e-17
C505	VGND#8	VNB	5.6797e-18
C506	a_1238_94##6	VNB	1.53258e-17
C507	GCLK	a_709_54##5	3.91022e-20
C508	VGND#9	VNB	5.28908e-18
C509	a_709_54##10	a_566_74#	2.45574e-17
C510	a_288_48##8	a_709_54##3	2.00972e-17
C511	a_288_48##8	VNB	2.49515e-17
C512	a_709_54##12	VNB	6.69024e-18
C513	GATE	a_116_424#	1.71347e-18
C514	CLK#2	a_709_54##4	2.9662e-19
C515	VGND#10	VNB	2.2674e-18
C516	a_566_74##6	VNB	2.07407e-18
C517	VPWR	VPWR#5	7.05512e-17
C518	a_114_112##6	VNB	9.62586e-18
C519	SCE	GATE#2	2.50434e-17
C520	a_318_74##7	VNB	2.23695e-19
C521	a_114_112##3	VNB	1.68851e-17
C522	SCE	SCE#2	4.28486e-17
C523	VGND#7	VNB	6.52808e-17
C524	VPWR#8	VNB	4.02018e-18
C525	a_566_74##3	VGND#10	2.02764e-17
C526	a_1238_94##7	VNB	3.25239e-18
C527	VPWR	a_709_54##5	5.71469e-18
C528	a_288_48##7	VNB	8.56435e-18
C529	VGND#7	VPWR#7	2.76382e-19
C530	a_709_54##8	VNB	9.40051e-18
C531	VPWR#10	VNB	3.233e-18
C532	VPWR	a_566_74##2	4.18848e-18
C533	a_114_112##5	VNB	1.07667e-17
C534	VPWR	a_709_54##2	1.03918e-17
C535	a_566_74##7	VPWR#10	1.1952e-17
C536	VPWR#11	VNB	9.2728e-18
C537	a_114_112#	VNB	8.618e-18
C538	VGND	VGND#5	6.58301e-17
C539	VPWR	a_318_74##3	3.60647e-18
C540	VPWR#7	VNB	7.49631e-17
C541	a_1238_94#	VNB	3.36444e-17
C542	a_709_54##12	a_709_54##3	3.12788e-19
C543	a_709_54##6	VNB	2.79726e-17
C544	VGND	a_709_54##5	1.43424e-17
C545	CLK#6	VNB	2.86859e-17
C546	CLK#4	VNB	3.32388e-17
C547	VGND	CLK#3	4.48082e-18
C548	a_566_74##3	VNB	3.40811e-17
C549	a_709_54##3	VNB	3.7229e-17
C550	VGND	a_566_74##2	3.91051e-18
C551	a_318_74#	VNB	3.23008e-17
C552	a_288_48##6	VNB	4.06511e-17
C553	VGND	a_709_54##2	3.60979e-18
C554	a_288_48##5	VNB	5.01397e-17
C555	GATE#1	VNB	3.33207e-17
C556	VGND	a_318_74##3	3.81903e-18
C557	SCE#3	VNB	3.05759e-17
C558	VGND	a_288_48##4	4.50842e-17
C559	a_1238_94##3	VNB	3.96731e-17
C560	VGND#6	a_114_112##3	4.46764e-17
C561	a_709_54##4	VNB	4.14383e-17
C562	VGND	GATE#2	3.9487e-18
C563	CLK#1	VNB	4.19686e-17
C564	CLK#5	VNB	3.97695e-17
C565	VGND	SCE#2	4.23737e-19
C566	a_288_48##8	a_318_74#	3.97232e-18
C567	a_566_74#	VNB	4.17478e-17
C568	a_709_54#	VNB	2.68579e-17
C569	a_288_48#	VNB	8.57308e-17
C570	VPWR#6	GATE#3	4.61573e-18
C571	a_318_74##4	VNB	2.83818e-17
C572	a_288_48##2	VNB	1.01015e-16
C573	GATE#3	VNB	3.52115e-17
C574	SCE#1	VNB	2.90257e-17
C575	VPWR#1	VNB	1.07495e-16
C576	VGND#1	VNB	1.09055e-16
C577	SCE	GATE	7.95821e-18
C578	VPWR#5	VNB	3.18447e-17
C579	VGND#10	a_709_54##3	7.11326e-18
C580	VGND#5	VNB	3.89717e-17
C581	GATE#2	a_288_48##3	1.31003e-18
C582	a_1238_94##2	VNB	5.47304e-17
C583	a_709_54##5	VNB	6.43525e-17
C584	CLK#3	VNB	3.76976e-18
C585	a_566_74##2	VNB	5.00767e-17
C586	a_709_54##2	VNB	6.40785e-17
C587	a_318_74##3	VNB	6.83126e-17
C588	a_288_48##4	VNB	3.7293e-17
C589	VPWR	GATE	7.64237e-18
C590	GATE#2	VNB	4.86184e-17
C591	SCE#2	VNB	7.96556e-17
C592	VPWR	CLK	4.23692e-18
C593	VPWR	SCE	5.55735e-18
C594	a_709_54##12	a_318_74#	8.659e-20
C595	VGND	SCE	7.68144e-18
C596	GATE	VNB	5.64824e-18
C597	CLK	VNB	2.59105e-19
C598	SCE	VNB	2.71893e-17
C599	GCLK	VNB	7.04232e-17
C600	VPWR	VNB	3.00552e-16
C601	VGND	VNB	3.0923e-16
C602	a_288_48##8	a_288_48##6	6.88329e-20
*
*
.ENDS sky130_fd_sc_hs__sdlclkp_1
*
