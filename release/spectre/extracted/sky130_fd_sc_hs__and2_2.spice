* Extracted by Quantus, converted by sky130cad/quantus.py
*
*
*
*                       LINUX           Wed Nov 18 08:16:14 2026
*
*
*
*  PROGRAM  advgen
*
*  Name           : advgen - Quantus - (64-bit)
*  Version        : 25.1.0-p047
*  Build Date     : Thu Dec 11 23:20:30 PST 2025
*
*  HSPICE LIBRARY
*
*  OPERATING_TEMPERATURE 150
*  QRC_TECH_DIR <path>/tech
*
*
*

*
.SUBCKT sky130_fd_sc_hs__and2_2 VPB VNB VGND VPWR X A B
*
*
*  caps2d version: 10
*
*
*       TRANSISTOR CARDS
*
*
XM4 a_31_74##9 A#1 a_118_74# VNB sky130_fd_pr__nfet_01v8_lvt l=0.15 w=0.74 ad=0.2109 as=0.1776 pd=2.05 ps=1.96
XM3 a_118_74# B#3 VGND#4 VNB sky130_fd_pr__nfet_01v8_lvt l=0.15 w=0.74 ad=0.1776 as=0.2664 pd=1.96 ps=2.2
XM1 X#1 a_31_74##4 VGND#4 VNB sky130_fd_pr__nfet_01v8_lvt l=0.15 w=0.74 ad=0.2072 as=0.2664 pd=2.04 ps=2.2
XM7 VGND#1 a_31_74##5 X#1 VNB sky130_fd_pr__nfet_01v8_lvt l=0.15 w=0.74 ad=0.2553 as=0.2072 pd=2.17 ps=2.04
XM5 VPWR#3 A#4 a_31_74##7 VPB sky130_fd_pr__pfet_01v8 l=0.15 w=1 ad=0.29 as=0.3 pd=2.58 ps=2.6
XM0 a_31_74##7 B#1 VPWR#4 VPB sky130_fd_pr__pfet_01v8 l=0.15 w=1 ad=0.3 as=0.3868 pd=2.6 ps=2.95
XM2 X#2 a_31_74##6 VPWR#4 VPB sky130_fd_pr__pfet_01v8 l=0.15 w=1.12 ad=0.336 as=0.3868 pd=2.84 ps=2.95
XM6 VPWR#1 a_31_74# X#2 VPB sky130_fd_pr__pfet_01v8 l=0.15 w=1.12 ad=0.3192 as=0.336 pd=2.81 ps=2.84
*
*
*       RESISTOR AND CAP/DIODE CARDS
*
Rg1	A#1	A#2	368.862610
Rg2	A#2	A#3	27.643862
Rg3	A#2	A#4	490.044800
Rg4	B#1	B#2	475.028809
Rg5	B#2	B#3	353.846649
Rg6	a_31_74#	a_31_74##2	511.615417
Rg7	a_31_74##2	a_31_74##3	55.599739
Rg8	a_31_74##3	a_31_74##4	302.425262
Rg9	a_31_74##2	a_31_74##5	339.802612
Rg10	a_31_74##3	a_31_74##6	486.547119
Rf1	A	A#3	168.106262
Rf2	B#4	B	2.748580
Rf3	B#2	B#6	162.981384
Rf4	B#4	B#6	6.734021
Rf5	a_31_74##7	a_31_74##8	99.247948
Rf6	a_31_74##8	a_31_74##9	102.175888
Rf7	X#1	X	118.317703
Rf10	X#2	X	5.000000
Rf11	VPWR#1	VPWR#2	115.549225
Rf12	VPWR#2	VPWR#3	102.173759
Rf13	VPWR#2	VPWR#4	35.032631
Rf14	VGND#1	VGND#2	98.455093
Rf16	VGND#2	VGND#4	37.611725
Rf19	a_31_74##3	a_31_74##8	160.232803
Re1	VPWR#2	VPWR	1.964508
Re2	VGND	VGND#2	1.964582
*
*       CAPACITOR CARDS
*
*
C1	VPWR#2	a_31_74##2	5.97864e-21
C2	a_31_74##3	a_31_74##2	4.784e-18
C3	X#1	VGND#1	4.70549e-17
C4	VGND#4	VGND#1	2.54068e-18
C5	VGND#4	X#1	3.72702e-17
C6	a_31_74##9	X#1	6.02159e-19
C7	VGND#1	VPWR#1	5.98284e-18
C8	a_31_74##9	VGND#4	1.63394e-17
C9	a_31_74##5	VGND#1	2.0362e-17
C10	X#1	a_31_74##5	4.81979e-17
C11	VGND#1	a_31_74##4	1.33532e-18
C12	VPWR#4	VPWR#1	1.54146e-18
C13	a_31_74##9	a_31_74##7	1.73379e-19
C14	VGND#4	a_31_74##5	9.44964e-19
C15	X#1	a_31_74##4	3.02454e-17
C16	a_31_74##2	VGND#1	8.05381e-19
C17	VGND#1	B#3	2.7992e-19
C18	a_31_74##9	VPWR#3	1.31212e-19
C19	a_31_74##4	VGND#4	1.80678e-17
C20	X#1	B#3	1.14257e-18
C21	a_31_74##9	a_31_74##5	1.1022e-19
C22	X	a_31_74##2	1.32581e-17
C23	VGND#4	B#3	3.47587e-17
C24	a_31_74##7	VPWR#4	6.95199e-17
C25	X#1	A#1	1.96567e-19
C26	a_31_74##9	a_31_74##4	1.02198e-19
C27	VPWR#3	VPWR#4	1.77567e-18
C28	VGND#4	A#1	5.96089e-18
C29	a_31_74##9	B#3	1.5947e-17
C30	VPWR#3	a_31_74##7	7.68481e-17
C31	a_31_74##9	A#1	5.38193e-17
C32	X#1	a_31_74##2	5.9696e-18
C33	a_31_74#	VPWR#1	3.36207e-17
C34	a_31_74##4	a_31_74##5	3.73526e-17
C35	a_31_74#	X#2	2.43399e-17
C36	VPWR#1	a_31_74##6	1.1828e-18
C37	VPWR#4	a_31_74#	2.88979e-18
C38	B#3	a_31_74##4	2.37253e-17
C39	a_31_74##7	a_31_74#	1.88542e-19
C40	VPWR#4	a_31_74##6	5.41416e-17
C41	a_31_74##7	a_31_74##6	1.44413e-18
C42	VGND	a_31_74##2	3.8597e-19
C43	A#1	B#3	5.1707e-17
C44	B#1	VPWR#4	2.38576e-17
C45	VPWR#3	a_31_74##6	3.0495e-19
C46	a_31_74##7	B#1	6.52362e-17
C47	VPWR#4	A#4	1.34665e-18
C48	VPWR#3	B#1	3.29427e-18
C49	a_31_74##7	A#4	1.88858e-17
C50	VPWR#2	VPWR#1	2.50559e-17
C51	a_31_74##3	X#1	4.33873e-17
C52	VPWR#3	A#4	5.22376e-17
C53	a_31_74##3	VGND#4	3.79106e-17
C54	a_31_74##7	VPWR#2	1.38643e-17
C55	B#2	VGND#4	1.52103e-18
C56	VPWR#2	VPWR#3	2.95142e-17
C57	a_31_74##6	a_31_74#	4.92622e-17
C58	a_31_74##9	B#2	2.73193e-18
C59	a_31_74##2	VNB	3.35961e-17
C60	a_31_74##3	VPWR#4	2.41109e-17
C61	a_31_74##3	a_31_74##7	1.07366e-18
C62	A#3	a_31_74##9	3.82101e-17
C63	B#1	a_31_74##6	3.83303e-17
C64	VPWR#4	B#2	5.06849e-19
C65	B#2	a_31_74##7	2.34804e-17
C66	a_31_74##3	a_31_74##5	1.44011e-18
C67	a_31_74##3	a_31_74##4	9.91506e-18
C68	A#4	B#1	4.67013e-17
C69	a_31_74##3	B#3	8.96554e-18
C70	VPWR#2	a_31_74#	1.60768e-18
C71	VPWR#3	A#3	5.58441e-18
C72	a_31_74##3	A#1	3.87982e-20
C73	a_31_74##9	a_118_74#	3.09316e-18
C74	VPWR#2	a_31_74##6	3.35711e-18
C75	VPWR#2	B#1	2.58145e-18
C76	a_31_74##3	a_31_74#	1.30551e-18
C77	a_31_74##3	a_31_74##6	9.4401e-18
C78	a_31_74##3	B#1	1.26233e-18
C79	B#2	a_31_74##6	6.13491e-18
C80	a_31_74##9	B	2.73752e-17
C81	a_31_74##3	A#4	5.81607e-19
C82	B#3	a_118_74#	1.63029e-17
C83	A#1	a_118_74#	1.70186e-17
C84	B	a_31_74##7	1.97666e-17
C85	a_31_74##3	VPWR#2	3.50167e-19
C86	B	VPWR#3	5.07797e-19
C87	X#1	X	2.79203e-18
C88	A	VPWR#3	2.67317e-17
C89	X	VPWR#1	7.63131e-17
C90	B#2	a_31_74##3	1.09675e-16
C91	X	X#2	4.77818e-18
C92	VPWR#4	X	5.18219e-17
C93	a_31_74##7	X	2.33079e-18
C94	a_31_74##3	A#3	3.39751e-19
C95	A#3	B#2	3.82716e-17
C96	VPWR	VPWR#1	3.3393e-17
C97	VPWR	VPWR#4	2.18693e-17
C98	VGND	VGND#1	3.18268e-17
C99	VGND	X#1	1.68322e-17
C100	VPWR	a_31_74##7	1.42823e-17
C101	VPWR	VPWR#3	4.31059e-17
C102	VGND	a_31_74##9	2.05037e-17
C103	B	VPWR#2	1.11976e-19
C104	X	a_31_74#	4.12179e-17
C105	X	a_31_74##6	2.01688e-17
C106	X	B#1	4.01122e-19
C107	VGND#1	VNB	4.96333e-17
C108	X#1	VNB	2.05652e-17
C109	VPWR	a_31_74#	8.67654e-19
C110	VGND	a_31_74##5	9.25913e-19
C111	B	B#2	5.40184e-18
C112	VGND#4	VNB	6.59415e-19
C113	VGND	a_31_74##4	7.51203e-19
C114	VPWR	a_31_74##6	3.47157e-18
C115	a_31_74##9	VNB	4.00825e-17
C116	VGND	B#3	4.42553e-19
C117	X	VPWR#2	1.37154e-17
C118	A#3	B	3.06873e-17
C119	VPWR	B#1	1.10408e-19
C120	VPWR#1	VNB	6.91666e-17
C121	VGND	A#1	1.96333e-18
C122	A	B#2	6.75403e-19
C123	VPWR	A#4	3.98354e-18
C124	VPWR#4	VNB	1.16101e-18
C125	a_31_74##7	VNB	3.65775e-18
C126	a_31_74##3	X	7.95545e-17
C127	A	A#3	1.30416e-17
C128	VPWR#3	VNB	7.73285e-17
C129	VPWR	VPWR#2	2.81102e-17
C130	a_31_74##5	VNB	3.23406e-17
C131	a_31_74##4	VNB	2.58532e-17
C132	B#3	VNB	2.36482e-17
C133	VPWR	a_31_74##3	3.23415e-18
C134	A#1	VNB	3.21966e-17
C135	VPWR	B#2	1.56431e-18
C136	a_31_74#	VNB	4.89173e-17
C137	a_31_74##6	VNB	3.53979e-17
C138	B#1	VNB	3.1626e-17
C139	VGND	a_31_74##3	7.74989e-18
C140	A	B	2.21262e-17
C141	A#4	VNB	4.62508e-17
C142	VGND	B#2	1.74903e-18
C143	VPWR#2	VNB	1.60167e-16
C144	VGND	A#3	5.25134e-18
C145	a_31_74##3	VNB	3.46414e-17
C146	VPWR	B	3.10224e-18
C147	B#2	VNB	3.4919e-17
C148	A#3	VNB	7.32516e-17
C149	VPWR	A	2.14794e-18
C150	VGND	B	1.95227e-18
C151	VPWR	X	1.7614e-17
C152	VGND	X	1.72522e-18
C153	A	VNB	1.03847e-17
C154	X	VNB	2.36983e-17
C155	VPWR	VNB	5.27678e-17
C156	VGND	VNB	5.58602e-17
C157	VGND#2	a_31_74##5	2.17112e-18
C158	VGND#2	a_31_74##3	1.37352e-18
C159	VGND#2	X#1	1.52793e-17
C160	VGND#2	VNB	1.89267e-16
C161	VGND#2	VGND#1	2.96546e-17
C162	VGND#2	A#1	7.69005e-18
C163	VGND	VGND#2	7.02203e-17
C164	VGND#2	B#3	6.43896e-18
C165	VGND#2	a_31_74##4	5.5334e-18
C166	VGND#2	A#3	9.71596e-19
C167	VGND#2	a_31_74##9	2.34612e-17
*
*
.ENDS sky130_fd_sc_hs__and2_2
*
