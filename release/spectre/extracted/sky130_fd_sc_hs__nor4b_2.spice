* Extracted by Quantus, converted by sky130cad/quantus.py
*
*
*
*                       LINUX           Wed Nov 18 08:51:41 2026
*
*
*
*  PROGRAM  advgen
*
*  Name           : advgen - Quantus - (64-bit)
*  Version        : 25.1.0-p047
*  Build Date     : Thu Dec 11 23:20:30 PST 2025
*
*  HSPICE LIBRARY
*
*  OPERATING_TEMPERATURE 150
*  QRC_TECH_DIR <path>/tech
*
*
*

*
.SUBCKT sky130_fd_sc_hs__nor4b_2 VNB VPB VGND VPWR Y C B A D_N
*
*
*  caps2d version: 10
*
*
*       TRANSISTOR CARDS
*
*
XM14 a_27_392##10 D_N#1 VGND#10 VNB sky130_fd_pr__nfet_01v8_lvt l=0.15 w=0.64 ad=0.1824 as=0.2938 pd=1.85 ps=2.32
XM1 VGND#10 a_27_392##5 Y#6 VNB sky130_fd_pr__nfet_01v8_lvt l=0.15 w=0.74 ad=0.2938 as=0.259 pd=2.32 ps=2.18
XM17 Y#6 a_27_392##4 VGND#9 VNB sky130_fd_pr__nfet_01v8_lvt l=0.15 w=0.74 ad=0.259 as=0.3996 pd=2.18 ps=2.56
XM0 Y#4 C#4 VGND#9 VNB sky130_fd_pr__nfet_01v8_lvt l=0.15 w=0.74 ad=0.2072 as=0.3996 pd=2.04 ps=2.56
XM2 VGND#8 C#5 Y#4 VNB sky130_fd_pr__nfet_01v8_lvt l=0.15 w=0.74 ad=0.296 as=0.2072 pd=2.28 ps=2.04
XM10 Y#7 B#4 VGND#8 VNB sky130_fd_pr__nfet_01v8_lvt l=0.15 w=0.74 ad=0.2738 as=0.296 pd=2.22 ps=2.28
XM15 VGND#4 B#5 Y#7 VNB sky130_fd_pr__nfet_01v8_lvt l=0.15 w=0.74 ad=0.5365 as=0.2738 pd=2.93 ps=2.22
XM12 Y#1 A#5 VGND#4 VNB sky130_fd_pr__nfet_01v8_lvt l=0.15 w=0.74 ad=0.2479 as=0.5365 pd=2.15 ps=2.93
XM5 VGND#1 A#1 Y#1 VNB sky130_fd_pr__nfet_01v8_lvt l=0.15 w=0.74 ad=0.222 as=0.2479 pd=2.08 ps=2.15
XM7 a_27_392##9 D_N#3 VPWR#7 VPB sky130_fd_pr__pfet_01v8 l=0.15 w=1 ad=0.295 as=0.295 pd=2.59 ps=2.59
XM3 a_229_368##4 a_27_392##6 Y#9 VPB sky130_fd_pr__pfet_01v8 l=0.15 w=1.12 ad=0.3304 as=0.336 pd=2.83 ps=2.84
XM11 Y#9 a_27_392# a_229_368##2 VPB sky130_fd_pr__pfet_01v8 l=0.15 w=1.12 ad=0.336 as=0.336 pd=2.84 ps=2.84
XM13 a_498_368##2 C#6 a_229_368##2 VPB sky130_fd_pr__pfet_01v8 l=0.15 w=1.12 ad=0.336 as=0.336 pd=2.84 ps=2.84
XM6 a_229_368# C#1 a_498_368##2 VPB sky130_fd_pr__pfet_01v8 l=0.15 w=1.12 ad=0.3304 as=0.336 pd=2.83 ps=2.84
XM8 a_701_368##3 B#6 a_498_368# VPB sky130_fd_pr__pfet_01v8 l=0.15 w=1.12 ad=0.3304 as=0.336 pd=2.83 ps=2.84
XM16 a_498_368# B#1 a_701_368##4 VPB sky130_fd_pr__pfet_01v8 l=0.15 w=1.12 ad=0.336 as=0.336 pd=2.84 ps=2.84
XM4 VPWR#6 A#7 a_701_368##4 VPB sky130_fd_pr__pfet_01v8 l=0.15 w=1.12 ad=0.3472 as=0.336 pd=2.86 ps=2.84
XM9 a_701_368# A#6 VPWR#6 VPB sky130_fd_pr__pfet_01v8 l=0.15 w=1.12 ad=0.3304 as=0.3472 pd=2.83 ps=2.86
*
*
*       RESISTOR AND CAP/DIODE CARDS
*
Rg1	D_N#1	D_N#2	486.009918
Rg2	D_N#2	D_N#3	423.910217
Rg3	a_27_392#	a_27_392##2	524.537720
Rg4	a_27_392##2	a_27_392##3	42.564133
Rg5	a_27_392##2	a_27_392##4	296.149994
Rg6	a_27_392##3	a_27_392##5	348.457489
Rg7	a_27_392##3	a_27_392##6	486.547119
Rg8	C#1	C#2	452.585358
Rg9	C#2	C#3	52.646652
Rg10	C#3	C#4	377.027313
Rg11	C#2	C#5	406.014496
Rg12	C#3	C#6	429.126801
Rg13	B#1	B#2	630.023499
Rg14	B#2	B#3	46.351898
Rg15	B#3	B#4	430.781128
Rg16	B#2	B#5	394.561310
Rg17	B#2	B#6	446.660797
Rg18	A#1	A#2	397.555725
Rg19	A#2	A#3	30.596949
Rg20	A#3	A#4	24.707481
Rg21	A#4	A#5	394.956482
Rg22	A#2	A#6	449.655212
Rg23	A#4	A#7	449.259979
Rf1	D_N#2	D_N	161.413818
Rf2	a_27_392##3	a_27_392##8	136.334885
Rf3	a_27_392##8	a_27_392##9	69.859528
Rf4	a_27_392##8	a_27_392##10	22.783760
Rf5	C#7	C	1.409262
Rf6	C#3	C#9	161.642059
Rf7	C#7	C#9	9.779288
Rf8	C#10	C	1.409262
Rf9	C#9	C#10	4.889644
Rf10	a_229_368#	a_229_368##3	90.728615
Rf11	a_229_368##3	a_229_368##4	97.031921
Rf12	a_229_368##2	a_229_368##3	7.500000
Rf13	B#7	B	1.117266
Rf14	B#3	B#9	81.233665
Rf15	B#7	B#9	0.916808
Rf16	B#10	B	1.117266
Rf17	B#9	B#10	13.752123
Rf18	a_498_368#	a_498_368##2	136.888657
Rf19	Y#1	Y#2	114.913330
Rf20	Y#2	Y#3	43.538555
Rf21	Y#3	Y#5	37.563591
Rf22	Y#5	Y#6	87.797478
Rf23	Y#2	Y	3.366916
Rf24	Y	Y#8	7.282945
Rf25	Y#8	Y	7.282945
Rf26	Y#3	Y#9	172.002319
Rf27	Y#4	Y#5	7.500000
Rf28	Y#7	Y#8	7.500000
Rf29	a_701_368#	a_701_368##2	88.809959
Rf30	a_701_368##2	a_701_368##3	84.603409
Rf31	a_701_368##2	a_701_368##4	28.362816
Rf32	A	A#8	1.528014
Rf33	A#8	A	13.140918
Rf34	VGND#1	VGND#2	116.452248
Rf35	VGND#2	VGND#3	106.087746
Rf36	VGND#2	VGND#4	17.726639
Rf37	VGND#3	VGND#5	63.495102
Rf38	VGND#5	VGND#6	79.906929
Rf40	VGND#3	VGND#8	41.745289
Rf41	VGND#5	VGND#9	25.951664
Rf42	VGND#6	VGND#10	30.353714
Rf44	VPWR#2	VPWR#3	154.842514
Rf45	VPWR#3	VPWR#4	157.034042
Rf47	VPWR#2	VPWR#6	31.534731
Rf48	VPWR#4	VPWR#7	35.333496
Rf53	A#3	A#8	80.116402
Re1	VPWR#3	VPWR	0.818510
Re2	VGND	VGND#3	0.818540
*
*       CAPACITOR CARDS
*
*
C1	Y#4	C#9	1.4724e-17
C2	a_701_368##3	a_701_368##2	8.60298e-19
C3	a_229_368#	C#2	1.14988e-20
C4	VGND#1	Y#1	7.42894e-17
C5	VGND#4	VGND#1	2.67466e-18
C6	Y#1	VGND#4	8.24315e-17
C7	Y#3	a_701_368##3	1.37871e-17
C8	C#2	a_498_368##2	2.41013e-20
C9	Y#7	Y#1	1.95548e-18
C10	Y#3	a_229_368#	3.54802e-17
C11	VGND#4	Y#7	5.18489e-17
C12	VGND#10	a_27_392##8	1.07869e-17
C13	VGND#8	VGND#4	1.45157e-18
C14	B#9	a_701_368##3	2.06953e-17
C15	a_27_392##8	a_27_392##10	1.39105e-19
C16	VGND#8	Y#7	4.52402e-17
C17	VPWR#3	C#2	5.93845e-22
C18	Y#4	Y#7	2.31467e-18
C19	Y#9	Y#3	1.89883e-18
C20	Y#4	VGND#8	4.57569e-17
C21	Y#9	C#2	4.44055e-20
C22	Y#4	VGND#9	2.11695e-18
C23	Y#6	Y#4	2.39054e-18
C24	VGND#5	B#4	3.26218e-19
C25	VGND#5	C#5	8.1128e-19
C26	B#3	A#4	3.32419e-18
C27	VGND#10	Y#6	5.66109e-17
C28	C#9	Y#9	1.76212e-17
C29	Y#2	A#5	1.11108e-19
C30	C#2	B#3	2.14569e-17
C31	VGND#5	C#4	1.3217e-17
C32	Y#2	B#5	1.77133e-17
C33	a_27_392##10	VGND#10	5.44699e-17
C34	VGND#5	a_27_392##4	1.70805e-17
C35	Y#2	B#4	2.04462e-17
C36	C#3	C#2	4.06532e-18
C37	VGND#5	a_27_392##5	1.39376e-18
C38	Y#3	C#5	1.15239e-17
C39	Y#2	C#5	3.28321e-19
C40	VGND#5	D_N#1	3.68966e-19
C41	a_701_368#	VPWR#6	5.55849e-17
C42	a_27_392##3	C#2	7.88779e-20
C43	a_701_368##4	a_701_368#	1.24037e-18
C44	a_701_368##4	VPWR#6	5.21059e-17
C45	Y#4	Y#9	4.8246e-19
C46	a_498_368#	VPWR#6	3.40317e-18
C47	VGND#1	A#1	4.08499e-17
C48	a_498_368#	a_701_368##4	5.2833e-17
C49	Y#1	A#1	2.04378e-17
C50	VGND#1	A#5	3.25195e-18
C51	Y#6	Y#9	4.56359e-18
C52	VGND#1	A#4	1.42819e-20
C53	VGND#4	A#1	1.3305e-18
C54	a_701_368##3	a_701_368##4	1.25897e-18
C55	a_701_368##2	A#6	3.07908e-19
C56	Y#1	A#5	5.83193e-17
C57	VGND#1	B#5	1.13894e-19
C58	a_498_368#	a_701_368##3	7.85322e-17
C59	A#5	VGND#4	2.86345e-17
C60	Y#1	B#5	7.41008e-19
C61	a_701_368##2	A#7	1.40955e-17
C62	Y#7	A#5	5.21999e-19
C63	VGND#4	B#5	4.70671e-17
C64	a_27_392##8	C#4	2.16449e-19
C65	Y#1	B#4	2.08233e-19
C66	a_229_368#	a_701_368##3	3.78639e-17
C67	Y#1	A#4	6.86778e-18
C68	a_498_368##2	a_498_368#	1.49989e-18
C69	B#5	Y#7	1.39229e-17
C70	a_701_368##2	B#1	2.24438e-17
C71	Y#3	A#7	2.22135e-19
C72	VGND#4	B#4	1.88945e-18
C73	a_27_392##8	a_27_392##4	4.13175e-19
C74	VGND#8	B#5	3.62516e-19
C75	Y#7	B#4	3.62334e-17
C76	C#2	B#4	2.48138e-19
C77	VGND#4	C#5	3.47256e-19
C78	a_229_368#	a_498_368##2	6.4558e-17
C79	a_701_368##2	B#6	2.963e-19
C80	a_27_392##8	a_27_392##5	7.67322e-19
C81	Y#3	B#1	3.67822e-19
C82	B#4	VGND#8	2.02793e-17
C83	Y#7	C#5	5.49662e-19
C84	Y#2	B#1	3.2074e-18
C85	a_229_368##2	a_229_368#	2.20892e-18
C86	Y#4	B#4	5.72701e-19
C87	Y#9	a_701_368##3	8.59826e-19
C88	C#5	VGND#8	2.28542e-17
C89	VGND#4	A#4	1.12215e-19
C90	a_27_392##8	D_N#1	1.65953e-17
C91	a_701_368##2	C#1	3.44605e-20
C92	Y#3	B#6	2.11999e-18
C93	a_229_368##2	a_498_368##2	4.72076e-17
C94	Y#9	a_229_368#	1.08544e-17
C95	Y#4	C#5	4.73527e-17
C96	VGND#8	C#4	2.36947e-19
C97	Y#9	a_498_368##2	2.01658e-18
C98	Y#3	C#1	1.98687e-17
C99	Y#4	C#4	5.50924e-17
C100	a_229_368##2	Y#9	8.52478e-17
C101	VGND#8	a_27_392##4	9.87767e-20
C102	B#9	B#6	7.78195e-19
C103	C#4	VGND#9	1.48265e-17
C104	Y#2	a_701_368##2	2.98301e-18
C105	Y#4	a_27_392##4	1.69837e-18
C106	a_229_368##4	a_229_368##2	2.94218e-18
C107	Y#6	C#4	5.87332e-19
C108	Y#3	C#6	6.52462e-19
C109	a_27_392##4	VGND#9	2.06588e-17
C110	a_229_368##4	Y#9	8.55405e-17
C111	Y#4	a_27_392##5	5.24437e-19
C112	Y#6	a_27_392##4	3.17696e-17
C113	Y#3	a_27_392#	1.04137e-19
C114	VGND#10	a_27_392##4	1.00941e-18
C115	Y#4	D_N#1	3.17463e-19
C116	Y#6	a_27_392##5	3.83953e-17
C117	VPWR#7	a_229_368##4	8.17727e-17
C118	a_27_392##5	VGND#10	2.22635e-17
C119	Y#3	a_27_392##6	1.02668e-19
C120	a_27_392##9	a_229_368##4	5.45637e-18
C121	D_N#1	VGND#10	2.73737e-17
C122	a_27_392##9	VPWR#7	7.62104e-17
C123	Y#1	B#1	3.01554e-18
C124	a_27_392##10	D_N#1	2.9656e-17
C125	C#9	C#6	2.0889e-18
C126	VGND#4	B#1	1.32563e-18
C127	VGND#3	VGND#5	4.72923e-17
C128	a_701_368#	A#6	3.77687e-17
C129	A#5	A#1	3.0384e-17
C130	VPWR#6	A#6	4.78502e-17
C131	a_701_368#	A#7	7.67623e-19
C132	a_701_368##4	A#6	4.50597e-19
C133	VPWR#6	A#7	4.67588e-17
C134	B#5	A#5	6.55833e-18
C135	VGND#3	Y#3	3.21595e-19
C136	a_701_368#	B#1	1.79423e-19
C137	VGND#3	Y#2	2.25448e-19
C138	A#7	a_701_368##4	2.14339e-17
C139	Y#2	B#9	2.10001e-17
C140	VPWR#6	B#1	2.6292e-18
C141	a_498_368#	A#7	2.07404e-18
C142	B#1	a_701_368##4	2.61894e-17
C143	B#4	B#5	2.59951e-17
C144	a_701_368##3	A#7	1.8144e-19
C145	a_701_368##2	B#3	1.28489e-18
C146	VPWR#6	B#6	2.90035e-19
C147	VGND#5	C#3	1.24683e-20
C148	a_498_368#	B#1	5.25647e-17
C149	A	A#4	4.14567e-17
C150	a_701_368##4	B#6	4.3361e-19
C151	a_701_368##3	B#1	7.88066e-19
C152	VPWR#6	C#1	8.13196e-20
C153	Y#3	B#3	4.77105e-17
C154	C#5	B#4	2.40979e-17
C155	a_498_368#	B#6	6.08732e-17
C156	Y#2	B#3	3.47333e-17
C157	a_701_368##4	C#1	5.043e-20
C158	a_701_368##3	B#6	4.38557e-17
C159	VGND#5	a_27_392##3	1.46935e-18
C160	a_498_368#	C#1	4.0822e-19
C161	a_229_368#	B#6	8.70958e-19
C162	B#9	B#3	9.29224e-18
C163	C#4	C#5	3.82349e-17
C164	Y#3	C#3	3.87158e-19
C165	a_701_368##3	C#1	3.12507e-18
C166	a_701_368##2	A#4	1.8493e-18
C167	a_498_368##2	B#6	4.0822e-19
C168	a_229_368#	C#1	5.1834e-17
C169	a_229_368##2	B#6	6.61978e-20
C170	B	A#4	3.35615e-18
C171	a_701_368##3	C#6	1.96372e-19
C172	VGND#3	VGND#1	2.97881e-17
C173	a_498_368##2	C#1	5.05986e-17
C174	Y#9	B#6	1.20234e-19
C175	a_27_392##4	C#4	1.3599e-17
C176	a_27_392##3	Y#3	2.06031e-18
C177	a_229_368#	C#6	4.09642e-19
C178	a_229_368##2	C#1	4.09642e-19
C179	VGND#3	VGND#4	6.31388e-17
C180	a_701_368##3	a_27_392#	1.17792e-19
C181	a_498_368##2	C#6	3.7247e-17
C182	Y#9	C#1	2.75081e-19
C183	VGND#3	Y#7	8.62932e-18
C184	a_229_368#	a_27_392#	1.83236e-19
C185	a_229_368##2	C#6	3.69008e-17
C186	a_27_392##5	a_27_392##4	2.65809e-17
C187	a_701_368##3	a_27_392##6	8.10661e-20
C188	a_498_368##2	a_27_392#	1.0013e-18
C189	C#9	C#3	1.02541e-17
C190	Y#9	C#6	1.29169e-17
C191	VGND#3	Y#4	1.20145e-17
C192	VPWR#7	C#1	4.53332e-20
C193	a_229_368##2	a_27_392#	5.39205e-17
C194	Y#9	a_27_392#	3.56493e-17
C195	D_N#1	a_27_392##5	2.23776e-17
C196	VPWR#7	C#6	6.53077e-20
C197	VGND#4	B#3	7.41473e-19
C198	a_229_368##2	a_27_392##6	1.34221e-18
C199	a_229_368##4	a_27_392#	2.04083e-18
C200	C	C#2	5.7838e-18
C201	a_27_392##6	Y#9	2.8358e-17
C202	VPWR#7	a_27_392#	1.82874e-19
C203	a_27_392##8	a_27_392##3	2.89878e-18
C204	a_229_368##4	a_27_392##6	8.88095e-17
C205	a_498_368#	VPWR#3	3.72982e-17
C206	VPWR#7	a_27_392##6	2.76839e-18
C207	a_229_368##4	D_N#3	3.46828e-18
C208	a_27_392##9	a_27_392##6	2.48322e-19
C209	a_27_392##8	D_N#2	2.01251e-17
C210	Y#4	C#3	3.85958e-18
C211	a_498_368##2	VPWR#3	6.9329e-17
C212	VPWR#7	D_N#3	6.48207e-17
C213	a_229_368##2	VPWR#3	3.79711e-17
C214	a_27_392##9	D_N#3	2.79891e-17
C215	Y#1	a_701_368##2	2.06441e-18
C216	a_27_392##3	Y#4	6.02598e-18
C217	VGND#5	VGND#8	1.37761e-18
C218	A#7	A#6	4.42178e-17
C219	B#1	A#4	1.74644e-17
C220	a_27_392##3	Y#6	6.26477e-17
C221	B#3	a_498_368#	4.55372e-18
C222	VGND#10	a_27_392##3	2.24272e-17
C223	B#3	a_701_368##3	1.95935e-17
C224	B#1	A#7	4.77107e-17
C225	VGND#5	Y#4	5.32692e-17
C226	B#3	a_498_368##2	4.61285e-18
C227	VGND#10	D_N#2	9.45724e-19
C228	Y#3	A#4	1.06186e-19
C229	a_229_368#	C#3	3.4708e-19
C230	B#6	B#1	4.62419e-17
C231	C#3	a_498_368##2	8.90701e-19
C232	a_229_368##2	C#3	9.64667e-20
C233	VGND#3	B#5	7.88923e-19
C234	VGND#5	VGND#9	6.47446e-18
C235	Y#9	C#3	1.67593e-18
C236	VGND#3	B#4	5.42285e-18
C237	C#1	B#6	5.56509e-18
C238	VGND#3	C#5	6.07946e-18
C239	a_27_392##3	Y#9	1.73512e-17
C240	VGND#3	C#4	5.2065e-19
C241	a_27_392##3	a_229_368##4	3.42686e-17
C242	A#4	VPWR#6	1.38155e-18
C243	VGND#3	a_27_392##4	1.51903e-19
C244	C#6	C#1	4.59986e-17
C245	Y#2	Y#1	4.16227e-19
C246	a_27_392##3	VPWR#7	1.7215e-18
C247	VGND#5	Y#6	5.84545e-17
C248	B#4	B#3	3.7314e-19
C249	A	a_701_368##2	6.40363e-17
C250	a_229_368##4	D_N#2	2.30705e-19
C251	VPWR#7	D_N#2	8.4395e-18
C252	a_27_392#	C#6	4.6491e-17
C253	a_27_392##9	D_N#2	6.59578e-18
C254	Y#2	VGND#4	2.90995e-17
C255	a_27_392##8	D_N	4.51402e-17
C256	VGND#10	VGND#5	1.25105e-18
C257	Y#3	C#2	8.86277e-18
C258	a_27_392##6	a_27_392#	5.0569e-17
C259	B	a_701_368##2	1.97816e-17
C260	VPWR#3	B#6	2.59735e-18
C261	a_27_392##3	C#4	6.43756e-18
C262	Y#2	B	3.46974e-17
C263	VPWR#3	C#1	4.464e-18
C264	a_27_392##3	a_27_392##4	3.25188e-18
C265	D_N#3	a_27_392##6	5.57752e-18
C266	Y#2	Y#7	1.13339e-18
C267	a_27_392##3	a_27_392##5	6.3018e-18
C268	VPWR#3	C#6	5.04999e-18
C269	Y#3	VGND#8	3.34766e-17
C270	D_N#1	a_27_392##3	2.57618e-18
C271	VGND#1	A	2.66834e-17
C272	VPWR#3	a_27_392#	4.47117e-18
C273	B#3	B#1	8.8329e-19
C274	Y#1	A	7.56329e-17
C275	C	Y#3	4.31339e-17
C276	B#3	C#1	4.60343e-19
C277	Y#2	VGND#8	1.4696e-18
C278	Y#4	Y#3	1.24922e-18
C279	A	a_701_368#	4.34153e-17
C280	a_27_392#	C#3	6.2605e-18
C281	Y#4	Y#2	1.38259e-18
C282	a_27_392##3	a_27_392#	2.72497e-18
C283	D_N	VPWR#7	3.28358e-17
C284	a_27_392##9	D_N	1.8821e-17
C285	VPWR#3	B#3	1.33999e-19
C286	Y#4	C	2.91861e-17
C287	VPWR	a_701_368##2	4.67046e-18
C288	B	a_701_368##3	1.52917e-17
C289	D_N#2	a_27_392##6	2.95652e-18
C290	VGND#3	B#3	4.53394e-20
C291	VPWR#3	C#3	2.19546e-20
C292	VPWR	Y#3	3.03288e-18
C293	VGND#3	C#3	8.0024e-20
C294	VPWR	B#9	1.22714e-18
C295	VPWR	C#9	1.08151e-18
C296	VGND	VGND#5	4.93162e-17
C297	A#4	VNB	7.20606e-17
C298	C#2	VNB	2.19061e-17
C299	a_27_392##3	B#3	5.73951e-20
C300	C	Y#9	4.5476e-17
C301	VGND	Y#3	2.72517e-18
C302	VGND	Y#2	3.36546e-18
C303	a_27_392##3	C#3	2.20897e-17
C304	VGND	B#9	1.2758e-18
C305	A	A#6	3.04221e-18
C306	A	A#7	2.10025e-18
C307	VGND	C#9	9.51037e-19
C308	a_701_368##2	a_701_368#	8.47588e-19
C309	D_N#2	a_27_392##3	2.43453e-17
C310	VPWR	a_701_368#	1.47188e-17
C311	A	B#1	7.36096e-18
C312	VGND	a_27_392##8	8.58717e-19
C313	VPWR	VPWR#6	2.20112e-17
C314	A	B#6	2.96832e-19
C315	VPWR	a_701_368##4	1.10857e-17
C316	D_N	a_27_392#	3.84399e-19
C317	VGND	VGND#1	4.15917e-17
C318	VPWR	a_498_368#	2.90231e-17
C319	VGND	Y#1	1.80065e-17
C320	VPWR	a_701_368##3	7.83165e-18
C321	D_N	a_27_392##6	1.44826e-18
C322	VGND	VGND#4	7.68193e-17
C323	B	A#7	3.62128e-19
C324	VPWR	a_229_368#	8.76538e-18
C325	VGND	Y#7	1.60575e-17
C326	VPWR	a_498_368##2	2.78409e-17
C327	B	B#1	4.01621e-18
C328	VGND	Y#4	1.85631e-17
C329	VPWR	a_229_368##2	1.92373e-17
C330	B	B#6	1.29497e-18
C331	VPWR	Y#9	1.00797e-17
C332	VGND	Y#6	1.90044e-17
C333	VPWR	a_229_368##4	2.55865e-17
C334	VGND	VGND#10	2.30095e-17
C335	VGND	a_27_392##10	2.14116e-17
C336	VPWR	VPWR#7	2.21872e-17
C337	VPWR	a_27_392##9	1.75201e-17
C338	C	C#1	1.4191e-18
C339	a_701_368##2	VPWR#6	2.6607e-17
C340	VGND	Y#9	2.23966e-18
C341	C	a_27_392#	1.6551e-18
C342	VGND	a_229_368##4	3.00739e-18
C343	C	a_27_392##6	8.33105e-19
C344	A	B#3	1.77811e-18
C345	VGND#5	VNB	3.72365e-17
C346	a_27_392##3	D_N	1.93079e-17
C347	VGND	A#1	5.10397e-19
C348	VGND	B#5	5.03121e-19
C349	VPWR	A#6	2.10089e-18
C350	D_N	D_N#2	1.68095e-17
C351	Y#3	VNB	6.10944e-18
C352	VGND	B#4	8.90151e-20
C353	VPWR	A#7	1.28992e-18
C354	Y#2	VNB	2.34851e-18
C355	VGND	C#5	5.46337e-19
C356	B	B#3	1.32819e-17
C357	VPWR	B#1	2.5152e-18
C358	B#9	VNB	4.10776e-18
C359	VGND	C#4	1.15205e-19
C360	VPWR	B#6	1.53011e-18
C361	VGND	a_27_392##4	3.97459e-19
C362	VGND	a_27_392##5	1.25537e-18
C363	VPWR	C#1	1.63835e-18
C364	C#9	VNB	1.24917e-18
C365	VGND	D_N#1	1.24936e-18
C366	VPWR	C#6	2.24728e-18
C367	a_27_392##8	VNB	3.31294e-17
C368	VPWR	a_27_392#	1.53819e-18
C369	VGND#1	VNB	7.1446e-17
C370	Y#1	VNB	5.19147e-18
C371	C	C#3	1.05887e-17
C372	VPWR	a_27_392##6	2.01756e-18
C373	VGND#4	VNB	5.06735e-17
C374	Y#7	VNB	2.85672e-18
C375	VGND#8	VNB	2.01971e-18
C376	VGND	B#1	1.74528e-20
C377	VPWR	D_N#3	5.25194e-18
C378	C	a_27_392##3	2.65698e-17
C379	Y#4	VNB	2.30526e-18
C380	Y#6	VNB	2.60568e-18
C381	a_701_368##2	a_701_368##4	3.71555e-18
C382	VGND#10	VNB	4.2017e-18
C383	C	D_N#2	5.6715e-19
C384	a_27_392##10	VNB	3.44776e-17
C385	VPWR	VPWR#3	3.86035e-17
C386	a_701_368#	VNB	4.97754e-17
C387	VPWR#6	VNB	2.59667e-18
C388	a_701_368##4	VNB	4.62062e-18
C389	a_498_368#	VNB	7.43611e-18
C390	a_701_368##3	VNB	5.66999e-18
C391	a_229_368#	VNB	4.88346e-18
C392	a_498_368##2	VNB	7.59179e-18
C393	VPWR	B#3	4.08211e-18
C394	a_229_368##2	VNB	2.27251e-18
C395	Y#9	VNB	6.48144e-19
C396	a_229_368##4	VNB	1.71582e-17
C397	VPWR#7	VNB	1.49117e-17
C398	a_27_392##9	VNB	5.92756e-17
C399	VPWR	a_27_392##3	6.29087e-18
C400	A#1	VNB	3.19194e-17
C401	VGND	VGND#3	4.67787e-17
C402	A#5	VNB	2.90166e-17
C403	B#5	VNB	2.70485e-17
C404	B#4	VNB	2.86075e-17
C405	C#5	VNB	2.92993e-17
C406	VGND	B#3	2.17367e-18
C407	C#4	VNB	2.73356e-17
C408	a_27_392##4	VNB	2.27085e-17
C409	B	A	3.1214e-17
C410	a_27_392##5	VNB	3.15929e-17
C411	D_N	C	3.64481e-18
C412	D_N#1	VNB	4.09217e-17
C413	VGND	a_27_392##3	8.36399e-18
C414	A#6	VNB	3.72139e-17
C415	A#7	VNB	2.86686e-17
C416	B#1	VNB	5.12742e-17
C417	B#6	VNB	3.3559e-17
C418	C#1	VNB	3.68764e-17
C419	C#6	VNB	3.01993e-17
C420	a_27_392#	VNB	3.74487e-17
C421	a_27_392##6	VNB	4.12676e-17
C422	VPWR	D_N	1.45758e-18
C423	D_N#3	VNB	4.0032e-17
C424	VPWR	A	8.06896e-18
C425	VPWR#3	VNB	2.9728e-16
C426	VGND#3	VNB	2.68382e-16
C427	VGND	D_N	1.95753e-18
C428	VPWR	B	2.177e-18
C429	B#3	VNB	6.91458e-17
C430	C#3	VNB	3.16804e-17
C431	VGND	A	7.77565e-18
C432	VPWR	C	3.50085e-18
C433	a_27_392##3	VNB	8.59981e-17
C434	D_N#2	VNB	5.44182e-17
C435	VGND	B	2.29698e-18
C436	a_701_368##2	a_498_368#	1.8412e-17
C437	VGND	C	4.05204e-18
C438	D_N	VNB	2.78488e-18
C439	A	VNB	3.89299e-17
C440	B	VNB	3.70235e-18
C441	C	VNB	8.93994e-18
C442	VPWR	VNB	8.98361e-17
C443	VGND	VNB	6.24545e-17
C444	VPWR	VPWR#2	4.60662e-17
C445	VGND#6	D_N#1	2.76572e-18
C446	a_701_368##4	VPWR#2	1.05092e-17
C447	VPWR	VPWR#4	4.49771e-17
C448	VPWR#2	B#1	5.16828e-18
C449	VGND#6	D_N#2	4.73627e-20
C450	VGND	VGND#6	3.88701e-17
C451	a_229_368##2	VPWR#4	8.38196e-19
C452	a_27_392##3	VPWR#4	8.45284e-19
C453	VGND#6	a_27_392##5	7.42892e-18
C454	VPWR#4	D_N#3	3.29266e-18
C455	a_229_368##4	VPWR#4	5.24622e-17
C456	VGND#6	Y#6	8.04583e-18
C457	VGND#6	a_27_392##3	7.58758e-19
C458	VPWR#3	VPWR#4	7.76466e-17
C459	VPWR#2	A#7	1.84214e-18
C460	VGND#6	VGND#5	8.23714e-19
C461	a_27_392##9	VPWR#4	1.76458e-17
C462	VGND#6	VNB	5.36888e-17
C463	A	VPWR#2	4.93589e-19
C464	a_498_368#	VPWR#2	2.75309e-17
C465	VPWR#2	B#3	2.17556e-20
C466	VGND#6	a_27_392##8	1.87469e-19
C467	VPWR#2	B#6	1.84041e-18
C468	VPWR#2	VNB	6.38943e-17
C469	VGND#3	VGND#6	6.07627e-17
C470	VPWR#4	a_27_392##6	4.46319e-18
C471	VGND#6	a_27_392##10	2.74888e-17
C472	a_701_368##2	VPWR#2	9.60456e-19
C473	VPWR#4	VNB	6.82573e-17
C474	a_701_368#	VPWR#2	1.79315e-17
C475	VPWR#3	VPWR#2	7.82083e-17
C476	VPWR#2	A#6	2.1266e-18
*
*
.ENDS sky130_fd_sc_hs__nor4b_2
*
