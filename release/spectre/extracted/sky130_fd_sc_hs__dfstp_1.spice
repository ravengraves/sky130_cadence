* Extracted by Quantus, converted by sky130cad/quantus.py
*
*
*
*                       LINUX           Wed Nov 18 08:28:31 2026
*
*
*
*  PROGRAM  advgen
*
*  Name           : advgen - Quantus - (64-bit)
*  Version        : 25.1.0-p047
*  Build Date     : Thu Dec 11 23:20:30 PST 2025
*
*  HSPICE LIBRARY
*
*  OPERATING_TEMPERATURE 150
*  QRC_TECH_DIR <path>/tech
*
*
*

*
.SUBCKT sky130_fd_sc_hs__dfstp_1 VPB VNB VGND SET_B VPWR Q D CLK
*
*
*  caps2d version: 10
*
*
*       TRANSISTOR CARDS
*
*
XM30 a_27_74##6 D#3 VGND#16 VNB sky130_fd_pr__nfet_01v8_lvt l=0.15 w=0.42 ad=0.1197 as=0.1197 pd=1.41 ps=1.41
XM23 a_224_350##14 CLK#1 VGND#15 VNB sky130_fd_pr__nfet_01v8_lvt l=0.15 w=0.74 ad=0.2109 as=0.2072 pd=2.05 ps=2.04
XM18 VGND#15 a_224_350##7 a_398_74##10 VNB sky130_fd_pr__nfet_01v8_lvt l=0.15 w=0.74 ad=0.2072 as=0.1961 pd=2.04 ps=2.01
XM24 a_27_74##5 a_224_350##9 a_604_74##9 VNB sky130_fd_pr__nfet_01v8_lvt l=0.15 w=0.42 ad=0.17595 as=0.2226 pd=1.76 ps=1.9
XM16 a_604_74##9 a_398_74# a_740_74# VNB sky130_fd_pr__nfet_01v8_lvt l=0.15 w=0.42 ad=0.2226 as=0.1008 pd=1.9 ps=1.32
XM29 a_740_74# a_760_395# VGND#14 VNB sky130_fd_pr__nfet_01v8_lvt l=0.15 w=0.42 ad=0.1008 as=0.1449 pd=1.32 ps=1.53
XM8 a_760_395##5 a_604_74# a_1027_118# VNB sky130_fd_pr__nfet_01v8_lvt l=0.15 w=0.42 ad=0.1176 as=0.0882 pd=1.4 ps=1.26
XM1 a_1027_118# SET_B#1 VGND#13 VNB sky130_fd_pr__nfet_01v8_lvt l=0.15 w=0.42 ad=0.0882 as=0.2433 pd=1.26 ps=2.14
XM21 VGND#13 a_604_74##4 a_1215_74# VNB sky130_fd_pr__nfet_01v8_lvt l=0.15 w=0.64 ad=0.2433 as=0.24 pd=2.14 ps=2.03
XM5 a_1215_74# a_398_74##5 a_1298_392##14 VNB sky130_fd_pr__nfet_01v8_lvt l=0.15 w=0.64 ad=0.24 as=0.2139 pd=2.03 ps=2
XM20 a_1298_392##14 a_224_350# a_1422_74# VNB sky130_fd_pr__nfet_01v8_lvt l=0.15 w=0.42 ad=0.2139 as=0.1008 pd=2 ps=1.32
XM17 a_1422_74# a_1470_48##3 a_1500_74# VNB sky130_fd_pr__nfet_01v8_lvt l=0.15 w=0.42 ad=0.1008 as=0.1008 pd=1.32 ps=1.32
XM6 a_1500_74# SET_B#6 VGND#12 VNB sky130_fd_pr__nfet_01v8_lvt l=0.15 w=0.42 ad=0.1008 as=0.3843 pd=1.32 ps=2.67
XM25 VGND#12 a_1298_392##4 a_1470_48##7 VNB sky130_fd_pr__nfet_01v8_lvt l=0.15 w=0.42 ad=0.3843 as=0.1197 pd=2.67 ps=1.41
XM7 a_1902_74##6 a_1298_392##5 VGND#11 VNB sky130_fd_pr__nfet_01v8_lvt l=0.15 w=0.55 ad=0.15675 as=0.30395 pd=1.67 ps=2.34
XM3 VGND#11 a_1902_74##3 Q#3 VNB sky130_fd_pr__nfet_01v8_lvt l=0.15 w=0.74 ad=0.30395 as=0.2109 pd=2.34 ps=2.05
XM10 a_27_74##4 D#1 VPWR#16 VPB sky130_fd_pr__pfet_01v8 l=0.15 w=0.42 ad=0.1197 as=0.1176 pd=1.41 ps=1.4
XM26 a_224_350##12 CLK#3 VPWR#14 VPB sky130_fd_pr__pfet_01v8 l=0.15 w=1.12 ad=0.3192 as=0.336 pd=2.81 ps=2.84
XM12 VPWR#14 a_224_350##10 a_398_74##13 VPB sky130_fd_pr__pfet_01v8 l=0.15 w=1.12 ad=0.336 as=0.3304 pd=2.84 ps=2.83
XM4 a_27_74# a_398_74##4 a_604_74##7 VPB sky130_fd_pr__pfet_01v8 l=0.15 w=0.42 ad=0.1239 as=0.147 pd=1.43 ps=1.54
XM13 a_604_74##7 a_224_350##8 a_709_463# VPB sky130_fd_pr__pfet_01v8 l=0.15 w=0.42 ad=0.147 as=0.1134 pd=1.54 ps=1.38
XM2 a_709_463# a_760_395##4 VPWR#11 VPB sky130_fd_pr__pfet_01v8 l=0.15 w=0.42 ad=0.1134 as=0.2835 pd=1.38 ps=2.19
XM27 VPWR#11 a_604_74##3 a_760_395##7 VPB sky130_fd_pr__pfet_01v8 l=0.15 w=0.42 ad=0.2835 as=0.126 pd=2.19 ps=1.44
XM31 a_760_395##7 SET_B#3 VPWR#9 VPB sky130_fd_pr__pfet_01v8 l=0.15 w=0.42 ad=0.126 as=0.4723 pd=1.44 ps=3.72
XM15 VPWR#9 a_604_74##6 a_1197_341# VPB sky130_fd_pr__pfet_01v8 l=0.15 w=1 ad=0.4723 as=0.399625 pd=3.72 ps=3.22
XM22 a_1197_341# a_224_350##2 a_1298_392##9 VPB sky130_fd_pr__pfet_01v8 l=0.15 w=1 ad=0.399625 as=0.4333 pd=3.22 ps=3.29
XM11 a_1298_392##9 a_398_74##7 a_1457_508# VPB sky130_fd_pr__pfet_01v8 l=0.15 w=0.42 ad=0.4333 as=0.1134 pd=3.29 ps=1.38
XM0 a_1457_508# a_1470_48# VPWR#7 VPB sky130_fd_pr__pfet_01v8 l=0.15 w=0.42 ad=0.1134 as=0.126 pd=1.38 ps=1.44
XM14 VPWR#7 SET_B#7 a_1298_392##12 VPB sky130_fd_pr__pfet_01v8 l=0.15 w=0.42 ad=0.126 as=0.1155 pd=1.44 ps=1.39
XM28 VPWR#5 a_1298_392##6 a_1470_48##4 VPB sky130_fd_pr__pfet_01v8 l=0.15 w=0.42 ad=0.1176 as=0.1155 pd=1.4 ps=1.39
XM9 a_1902_74##7 a_1298_392# VPWR#4 VPB sky130_fd_pr__pfet_01v8 l=0.15 w=0.84 ad=0.231 as=0.3892 pd=2.23 ps=2.98
XM19 VPWR#4 a_1902_74# Q#1 VPB sky130_fd_pr__pfet_01v8 l=0.15 w=1.12 ad=0.3892 as=0.3192 pd=2.98 ps=2.81
*
*
*       RESISTOR AND CAP/DIODE CARDS
*
Rg1	D#1	D#2	451.019897
Rg2	D#2	D#3	308.734436
Rg3	CLK#1	CLK#2	320.356293
Rg4	CLK#2	CLK#3	460.583832
Rg5	a_398_74#	a_398_74##2	521.882141
Rg6	a_398_74##2	a_398_74##3	325.709045
Rg7	a_398_74##3	a_398_74##4	297.641968
Rg8	a_760_395#	a_760_395##2	330.972839
Rg9	a_760_395##2	a_760_395##3	306.834442
Rg10	a_760_395##3	a_760_395##4	385.489197
Rg11	a_604_74#	a_604_74##2	265.124237
Rg12	a_604_74##2	a_604_74##3	507.232117
Rg13	SET_B#1	SET_B#2	638.646179
Rg14	SET_B#2	SET_B#3	252.972153
Rg15	a_604_74##4	a_604_74##5	393.354034
Rg16	a_604_74##5	a_604_74##6	401.310760
Rg17	a_398_74##5	a_398_74##6	439.477417
Rg18	a_224_350#	a_224_350##2	1306.905640
Rg19	a_224_350##2	a_224_350##3	1996.420898
Rg20	a_224_350##3	a_224_350##4	1458.552002
Rg21	a_224_350##4	a_224_350##5	44.378014
Rg22	a_224_350##5	a_224_350##6	25.691843
Rg23	a_224_350##6	a_224_350##7	345.908142
Rg24	a_224_350##3	a_224_350##8	283.919525
Rg25	a_224_350##4	a_224_350##9	620.391602
Rg26	a_224_350##6	a_224_350##10	449.655212
Rg27	a_398_74##7	a_398_74##8	242.974045
Rg28	a_1470_48#	a_1470_48##2	608.333984
Rg29	a_1470_48##2	a_1470_48##3	437.085266
Rg30	SET_B#4	SET_B#5	10.206202
Rg31	SET_B#5	SET_B#6	536.669312
Rg32	SET_B#5	SET_B#7	477.881989
Rg33	a_1298_392#	a_1298_392##2	344.089294
Rg34	a_1298_392##2	a_1298_392##3	444.717560
Rg35	a_1298_392##3	a_1298_392##4	559.598022
Rg36	a_1298_392##2	a_1298_392##5	664.405457
Rg37	a_1298_392##3	a_1298_392##6	300.380188
Rg38	a_1902_74#	a_1902_74##2	510.359009
Rg39	a_1902_74##2	a_1902_74##3	336.001343
Rf1	D#4	D	0.532052
Rf2	D#2	D#6	53.942986
Rf3	D#4	D#6	7.479781
Rf4	D#7	D	0.532052
Rf5	D#6	D#7	7.086109
Rf6	CLK#4	CLK#2	161.469666
Rf7	CLK	CLK#6	1.236861
Rf8	CLK#4	CLK#6	7.589135
Rf9	a_224_350##5	a_224_350##13	230.344635
Rf10	a_224_350##13	a_224_350##14	86.504349
Rf11	a_224_350##12	a_224_350##13	15.000000
Rf12	a_27_74#	a_27_74##2	37.878487
Rf13	a_27_74##2	a_27_74##3	161.968460
Rf14	a_27_74##3	a_27_74##4	37.763580
Rf15	a_27_74##2	a_27_74##5	111.496475
Rf16	a_27_74##3	a_27_74##6	136.379623
Rf17	a_398_74##3	a_398_74##10	252.690735
Rf18	a_760_395##5	a_760_395##2	191.719803
Rf19	a_760_395##7	a_760_395##3	259.611481
Rf20	SET_B#8	SET_B#2	171.058807
Rf21	a_604_74##7	a_604_74##8	126.496178
Rf22	a_604_74##8	a_604_74##9	29.577969
Rf23	a_604_74##8	a_604_74##10	127.705719
Rf24	a_604_74##10	a_604_74##5	196.844360
Rf25	a_398_74##2	a_398_74##12	201.969635
Rf26	a_398_74##12	a_398_74##13	190.288376
Rf27	a_398_74##12	a_398_74##6	332.789764
Rf28	a_398_74##6	a_398_74##8	412.585327
Rf29	SET_B	SET_B#4	78.935623
Rf30	a_1298_392##3	a_1298_392##8	113.262497
Rf31	a_1298_392##8	a_1298_392##10	95.164536
Rf32	a_1298_392##10	a_1298_392##11	12.189062
Rf33	a_1298_392##8	a_1298_392##12	26.240368
Rf34	a_1298_392##11	a_1298_392##13	20.059952
Rf35	a_1298_392##13	a_1298_392##14	105.187988
Rf36	a_1298_392##9	a_1298_392##10	15.000000
Rf37	a_1298_392##9	a_1298_392##11	7.500000
Rf38	a_1298_392##9	a_1298_392##13	15.000000
Rf39	a_1470_48##4	a_1470_48##5	155.772491
Rf40	a_1470_48##5	a_1470_48##2	282.498657
Rf41	a_1470_48##5	a_1470_48##7	27.215935
Rf42	a_1902_74##2	a_1902_74##5	175.800995
Rf43	a_1902_74##5	a_1902_74##6	59.103394
Rf44	a_1902_74##5	a_1902_74##7	49.694118
Rf45	Q	Q#2	0.255814
Rf46	Q#2	Q	18.674389
Rf47	Q	Q#4	6.799999
Rf48	Q#4	Q	4.382222
Rf49	Q#1	Q#2	5.000000
Rf50	Q#3	Q#4	7.500000
Rf52	VPWR#2	VPWR#3	105.168182
Rf53	VPWR#2	VPWR#4	38.286041
Rf54	VPWR#3	VPWR#5	41.644516
Rf55	VPWR#3	VPWR#6	76.545387
Rf56	VPWR#6	VPWR#7	47.494125
Rf57	VPWR#6	VPWR#8	160.476700
Rf58	VPWR#8	VPWR#9	36.515656
Rf59	VPWR#8	VPWR#10	114.731308
Rf60	VPWR#10	VPWR#11	45.150959
Rf61	VPWR#10	VPWR#12	53.336079
Rf62	VPWR#12	VPWR#13	120.874039
Rf63	VPWR#13	VPWR#14	36.869534
Rf64	VPWR#13	VPWR#15	71.905670
Rf65	VPWR#15	VPWR#16	33.523315
Rf68	VGND#2	VGND#3	93.845360
Rf69	VGND#3	VGND#4	41.558834
Rf70	VGND#4	VGND#5	185.078522
Rf71	VGND#5	VGND#6	111.324936
Rf72	VGND#6	VGND#7	65.692909
Rf73	VGND#7	VGND#8	121.361870
Rf74	VGND#8	VGND#9	75.372871
Rf76	VGND#2	VGND#11	32.223660
Rf77	VGND#4	VGND#12	13.983959
Rf78	VGND#5	VGND#13	31.337896
Rf79	VGND#6	VGND#14	29.449923
Rf80	VGND#8	VGND#15	51.316956
Rf81	VGND#9	VGND#16	40.352859
Rf89	a_604_74##2	a_604_74##10	160.232803
Re2	SET_B	SET_B#8	14.521620
Re3	VPWR#3	VPWR	2.377092
Re4	VPWR	VPWR#12	1.528131
Re5	VGND#3	VGND	2.377092
Re6	VGND	VGND#7	1.528131
*
*       CAPACITOR CARDS
*
*
C1	a_1298_392##6	a_1902_74#	2.93834e-19
C2	VGND#8	a_398_74#	3.60612e-20
C3	VPWR#11	a_224_350##3	2.73516e-19
C4	VGND#14	a_604_74#	2.65689e-18
C5	a_760_395##5	a_604_74##5	7.07694e-20
C6	a_1298_392##3	VPWR#5	3.36916e-17
C7	a_1470_48##5	a_1298_392##4	4.73368e-17
C8	a_760_395##5	a_760_395#	1.66132e-18
C9	a_1298_392##6	a_1298_392#	5.39504e-18
C10	a_398_74##10	a_224_350##6	1.64033e-17
C11	a_27_74##2	a_398_74##3	6.48978e-17
C12	VGND#4	VGND#12	1.39745e-17
C13	a_398_74##12	a_224_350##6	4.18721e-20
C14	a_398_74##12	a_604_74##3	1.83983e-17
C15	VGND#14	a_760_395#	2.9328e-17
C16	a_224_350##3	a_224_350##8	6.58896e-19
C17	a_604_74##9	a_604_74#	2.39002e-19
C18	a_760_395##5	a_398_74#	2.34566e-19
C19	VGND#8	a_224_350##9	2.86505e-19
C20	SET_B#7	a_1298_392##6	4.71391e-18
C21	a_398_74##10	VGND#14	5.18962e-18
C22	a_1470_48##5	SET_B#6	7.10644e-19
C23	a_224_350##5	a_27_74##2	8.69968e-17
C24	VPWR#8	a_224_350##3	2.51042e-18
C25	VGND#14	a_398_74#	4.30797e-18
C26	a_604_74##2	a_760_395##5	4.45616e-17
C27	a_224_350##6	a_398_74##4	1.93824e-17
C28	a_398_74##13	VPWR#12	4.13697e-17
C29	a_398_74##12	a_760_395##4	1.95506e-17
C30	a_604_74##9	a_760_395#	4.05195e-18
C31	VGND#14	a_604_74##2	4.19852e-18
C32	a_604_74##7	a_224_350##6	2.97283e-19
C33	a_1470_48#	SET_B#7	2.76519e-17
C34	a_27_74##3	CLK#2	3.3843e-19
C35	VGND#3	a_1902_74##3	2.13233e-18
C36	VGND#3	VGND#5	1.23581e-17
C37	a_604_74##8	a_398_74##12	5.25139e-18
C38	VGND#14	a_224_350##9	1.10493e-18
C39	VGND#8	a_224_350##7	9.07843e-18
C40	a_1470_48##5	a_1470_48##3	1.44711e-19
C41	a_27_74#	a_604_74##7	3.7818e-17
C42	a_760_395##5	a_760_395##2	4.58657e-18
C43	a_27_74##2	a_604_74##7	4.83433e-18
C44	a_224_350##3	a_398_74##4	1.70127e-17
C45	VGND#3	a_1298_392##5	4.37043e-19
C46	VGND#3	VGND#4	1.54167e-16
C47	a_604_74##9	a_398_74#	2.89058e-17
C48	a_398_74##12	a_224_350##3	3.66446e-17
C49	a_1470_48##2	a_1298_392##9	4.63835e-18
C50	a_760_395##2	VGND#14	3.20049e-17
C51	a_398_74##10	a_604_74##9	3.16472e-17
C52	VGND#3	a_1298_392##4	5.25516e-18
C53	a_398_74##12	a_224_350##8	1.33722e-17
C54	a_398_74##10	a_760_395#	4.68401e-19
C55	a_398_74##7	a_1470_48#	2.46292e-17
C56	a_27_74##3	D#2	3.10465e-17
C57	a_604_74##7	a_398_74##13	1.75772e-17
C58	a_1298_392##8	VPWR#6	1.05633e-18
C59	VGND#3	SET_B#6	1.38668e-18
C60	a_604_74##7	a_224_350##3	7.26079e-19
C61	VGND#14	a_224_350##7	8.20741e-20
C62	a_27_74##2	D#2	1.57513e-18
C63	a_1902_74##5	VPWR#4	8.48359e-18
C64	CLK#4	CLK#2	1.28983e-17
C65	a_398_74##8	a_1298_392##9	1.2206e-16
C66	a_224_350##10	a_224_350##6	3.29689e-17
C67	a_224_350##9	a_604_74##9	1.69599e-17
C68	a_27_74##2	a_27_74#	4.5771e-18
C69	VGND#3	a_1470_48##3	5.15146e-18
C70	VGND#6	a_604_74##8	2.68195e-18
C71	D#7	CLK#2	5.01543e-20
C72	VGND#14	a_760_395##3	4.76602e-19
C73	a_1470_48##5	a_224_350#	1.02793e-19
C74	a_27_74#	a_224_350##6	1.44496e-17
C75	a_1298_392##12	VPWR#6	6.97557e-18
C76	a_398_74##10	a_27_74##5	8.33235e-17
C77	a_1298_392##8	SET_B#6	3.10544e-19
C78	VGND#11	a_1298_392##2	7.86984e-19
C79	a_398_74##10	a_398_74#	2.65747e-18
C80	a_224_350##14	a_224_350##6	1.88158e-19
C81	VGND#8	CLK#1	9.21575e-18
C82	VPWR#7	SET_B#6	5.03951e-19
C83	VPWR#3	VPWR#8	6.27231e-18
C84	a_398_74##13	a_27_74#	7.54198e-17
C85	a_604_74##2	a_224_350##3	5.35542e-19
C86	a_27_74##3	a_398_74##13	1.243e-21
C87	VGND#3	a_224_350#	1.41817e-18
C88	a_224_350##2	a_398_74##7	9.72758e-18
C89	a_398_74##12	a_398_74##4	2.59904e-19
C90	a_224_350##9	a_27_74##5	8.85848e-18
C91	D#6	CLK#2	4.32282e-19
C92	a_398_74##6	a_1298_392##9	7.40763e-17
C93	VPWR#3	VPWR#6	9.12072e-17
C94	a_224_350##10	a_224_350##3	9.58056e-18
C95	D#4	CLK#2	4.50756e-19
C96	VGND#15	a_398_74#	1.74784e-20
C97	CLK#4	D#2	8.79015e-19
C98	a_604_74##8	a_224_350##8	7.7612e-19
C99	a_398_74##10	a_224_350##9	2.7723e-17
C100	a_27_74##2	a_398_74##13	3.52696e-17
C101	D#7	D#2	2.00831e-17
C102	a_398_74##6	VPWR#9	6.68557e-17
C103	a_604_74##6	a_224_350##2	5.08588e-17
C104	a_27_74##5	a_224_350##7	1.23529e-18
C105	a_1298_392##9	a_604_74##5	3.80023e-19
C106	a_760_395##7	a_398_74##6	3.85461e-17
C107	a_27_74#	a_224_350##3	1.63147e-18
C108	D#6	D#2	7.12592e-18
C109	a_1298_392##5	a_1902_74##2	1.14034e-17
C110	VGND#8	D#3	2.78616e-19
C111	VGND#15	a_224_350##9	4.93069e-20
C112	a_398_74##12	a_224_350##10	9.52838e-20
C113	VPWR#14	a_398_74##13	3.74894e-17
C114	VGND#14	a_604_74##8	4.28542e-18
C115	a_27_74##5	a_398_74##2	9.29247e-20
C116	CLK#3	a_224_350##6	1.08403e-18
C117	D#4	D#2	1.80659e-17
C118	a_1470_48##5	a_1902_74##5	6.93435e-17
C119	a_224_350##7	a_224_350##6	6.69883e-18
C120	SET_B#3	a_224_350##2	1.96508e-17
C121	VGND#15	a_398_74##10	6.15663e-17
C122	a_224_350##14	a_27_74##5	9.46187e-19
C123	a_224_350##6	a_398_74##13	8.89314e-18
C124	a_398_74##10	a_224_350##7	4.85605e-17
C125	VPWR#9	a_604_74##5	1.69177e-19
C126	a_1902_74##6	a_1298_392##2	3.0508e-18
C127	a_27_74##2	VPWR#14	3.45268e-17
C128	a_760_395##2	a_224_350##3	1.56581e-19
C129	a_1298_392##3	a_1298_392##5	4.20093e-19
C130	a_27_74##5	CLK#1	1.29522e-19
C131	a_398_74##12	a_709_463#	1.22333e-17
C132	SET_B#3	a_604_74##6	8.1273e-18
C133	a_1470_48##4	a_1902_74##5	1.88388e-18
C134	a_398_74##3	a_604_74##9	5.95427e-18
C135	a_224_350##7	VGND#15	1.67362e-17
C136	a_27_74##3	a_224_350##12	4.27806e-17
C137	a_27_74##2	a_760_395##4	3.79189e-20
C138	a_27_74##5	a_398_74##3	5.38342e-17
C139	a_224_350##14	a_398_74##10	1.94335e-18
C140	a_398_74##10	CLK#1	2.04598e-18
C141	a_398_74##10	a_398_74##3	2.3356e-18
C142	SET_B#4	a_1298_392##5	2.72826e-19
C143	SET_B#8	VPWR#8	6.21069e-18
C144	VPWR#3	a_1902_74##5	4.80798e-19
C145	a_604_74##8	a_709_463#	3.75339e-19
C146	a_760_395##7	SET_B#2	1.9873e-17
C147	a_1298_392##9	a_224_350#	3.43515e-18
C148	a_224_350##14	a_224_350##7	1.73054e-18
C149	a_224_350##12	VPWR#14	8.4317e-19
C150	SET_B#4	a_1298_392##4	2.10912e-18
C151	a_604_74##3	SET_B#3	2.20026e-17
C152	a_27_74##2	a_224_350##12	3.69317e-17
C153	SET_B#8	VPWR#6	7.93563e-19
C154	a_1298_392##9	VPWR#8	1.55938e-17
C155	a_398_74##13	a_224_350##3	2.54799e-17
C156	CLK#1	VGND#15	2.06311e-17
C157	a_224_350##5	a_27_74##5	1.74814e-17
C158	a_1470_48##2	a_1298_392##5	1.19045e-19
C159	VGND#16	a_224_350##7	1.7595e-19
C160	a_224_350##14	VGND#15	5.40664e-17
C161	a_27_74##3	VPWR#16	3.95092e-17
C162	a_27_74##2	a_224_350##8	3.29877e-19
C163	a_224_350##5	a_398_74##10	3.25731e-17
C164	a_604_74##2	a_760_395##7	5.062e-18
C165	VPWR#14	a_224_350##6	3.7244e-19
C166	VPWR#16	VPWR#14	1.25991e-17
C167	a_27_74##4	a_398_74##13	1.3213e-21
C168	a_398_74##12	VPWR#10	6.32038e-17
C169	a_1470_48##2	a_1298_392##4	1.11743e-19
C170	a_224_350##14	CLK#1	5.48196e-17
C171	a_760_395##3	a_224_350##3	2.48919e-18
C172	a_1298_392##9	VPWR#6	3.8081e-17
C173	a_604_74##8	a_224_350##6	3.08173e-19
C174	a_1470_48##2	SET_B#6	2.27161e-17
C175	a_760_395##4	a_604_74##3	6.16212e-18
C176	VGND#3	a_1902_74##5	1.39674e-18
C177	VGND#15	D#3	5.19691e-19
C178	VPWR#3	a_1902_74#	5.3624e-18
C179	VGND#7	a_398_74#	5.71926e-18
C180	a_27_74##5	CLK#2	3.48072e-20
C181	D#1	a_224_350##3	1.9993e-19
C182	a_1470_48##2	a_1470_48##3	6.60281e-18
C183	VGND#16	CLK#1	1.25471e-18
C184	a_398_74##8	a_1298_392##4	2.22484e-19
C185	VGND#6	a_760_395##5	1.07313e-17
C186	VGND#16	VGND#15	1.23449e-18
C187	VGND#7	a_224_350##9	4.40562e-18
C188	VPWR#3	a_1298_392#	8.56489e-18
C189	a_224_350#	a_1470_48##2	2.934e-17
C190	a_27_74##2	a_398_74##4	3.05535e-18
C191	a_224_350##14	D#3	1.25251e-18
C192	a_1470_48##5	a_1470_48##4	8.81991e-19
C193	a_398_74##8	SET_B#6	2.03332e-18
C194	CLK#2	VGND#15	1.89451e-18
C195	a_398_74##12	VPWR#8	1.73187e-17
C196	a_27_74##6	CLK#1	1.61936e-19
C197	a_224_350##8	a_760_395##4	3.39652e-17
C198	CLK#2	a_224_350##14	6.73494e-18
C199	a_398_74##8	a_1470_48##3	7.12112e-18
C200	VPWR#3	a_1298_392##6	9.6598e-18
C201	VPWR#10	VPWR#9	2.33211e-20
C202	VGND#11	Q#3	4.03659e-17
C203	VPWR#14	a_224_350##3	3.92276e-19
C204	a_1902_74##5	Q#3	1.03252e-18
C205	a_760_395##7	a_760_395##3	2.43631e-19
C206	a_27_74##5	D#2	1.08328e-19
C207	VGND#3	a_1470_48##5	5.23508e-17
C208	a_224_350##6	a_398_74##2	6.27309e-19
C209	VGND#16	D#3	2.83868e-17
C210	VGND#16	a_224_350##14	4.3191e-17
C211	a_1902_74##5	a_1298_392##2	3.21176e-17
C212	a_398_74##8	a_224_350#	1.35294e-17
C213	a_398_74##6	SET_B#6	2.03377e-18
C214	a_27_74##3	a_224_350##10	2.94806e-19
C215	a_1298_392##14	a_1298_392##9	5.38342e-18
C216	a_398_74##10	D#2	3.95786e-19
C217	a_398_74##4	a_760_395##4	6.92213e-20
C218	VPWR#11	a_760_395##3	1.00211e-18
C219	a_1298_392##8	VPWR#3	6.06938e-18
C220	a_224_350##12	a_224_350##6	4.35304e-19
C221	a_398_74##8	a_398_74##5	4.65625e-19
C222	a_398_74##6	a_1470_48##3	5.22993e-18
C223	a_398_74##2	a_224_350##3	4.78743e-19
C224	a_27_74##4	VPWR#16	3.12264e-17
C225	a_27_74##2	a_224_350##10	2.45817e-17
C226	a_27_74##6	D#3	1.44346e-17
C227	VPWR#4	a_1298_392##2	6.17932e-18
C228	a_224_350##14	D#2	6.851e-18
C229	a_398_74##4	a_224_350##8	2.67654e-17
C230	a_398_74##8	a_604_74##4	1.83713e-19
C231	a_398_74##6	a_224_350#	3.5331e-17
C232	a_604_74##7	a_760_395##3	7.77545e-19
C233	VGND#16	D#2	6.70039e-18
C234	a_27_74##6	a_224_350##14	2.56756e-18
C235	a_398_74##6	a_398_74##5	2.80835e-17
C236	a_27_74##6	D#2	1.12954e-17
C237	a_1298_392##14	a_224_350##2	1.72884e-18
C238	a_1902_74##5	VGND#11	1.30556e-17
C239	a_27_74##3	CLK#3	6.01357e-19
C240	a_604_74##4	a_398_74##6	1.26181e-17
C241	VPWR#3	a_224_350##2	4.45668e-22
C242	a_604_74##5	a_224_350#	4.97693e-19
C243	CLK#4	a_224_350##12	4.06663e-17
C244	SET_B#5	VGND#12	1.69569e-18
C245	a_760_395##7	a_398_74##3	5.88237e-20
C246	a_604_74##7	a_398_74##2	1.69001e-17
C247	VGND#14	VGND#5	9.08439e-20
C248	a_398_74##6	SET_B#1	2.08492e-19
C249	a_27_74##2	CLK#3	2.52756e-17
C250	a_27_74##6	VGND#16	3.76986e-17
C251	VGND#3	a_224_350##2	4.01357e-20
C252	a_224_350##6	a_398_74##3	4.40901e-17
C253	a_1902_74##6	VGND#11	5.34596e-17
C254	a_398_74##6	a_604_74#	1.57721e-20
C255	a_224_350##2	VGND#13	1.44826e-18
C256	D#7	a_224_350##12	3.8184e-17
C257	a_398_74##3	a_604_74##7	4.17466e-17
C258	a_604_74##5	SET_B#1	2.6248e-17
C259	SET_B#8	a_224_350##2	7.34055e-18
C260	CLK#3	a_224_350##10	4.31095e-17
C261	a_398_74##3	a_224_350##3	8.40162e-19
C262	a_27_74##3	D#1	1.38174e-17
C263	a_398_74##3	a_27_74#	1.93812e-17
C264	a_1902_74##7	a_1298_392##2	1.16623e-17
C265	a_1298_392##3	a_1298_392#	2.02047e-18
C266	a_398_74##3	a_398_74##13	4.88558e-18
C267	SET_B#8	a_604_74##6	4.55112e-18
C268	a_1298_392##2	a_1902_74#	1.3452e-17
C269	a_1298_392##3	a_1298_392##6	1.71631e-17
C270	VPWR#3	a_1298_392##2	2.0934e-18
C271	D#1	CLK#3	3.70262e-18
C272	a_1298_392##5	a_1902_74##3	2.10904e-17
C273	VGND#4	a_1470_48##2	2.99679e-17
C274	VPWR#4	a_1902_74#	5.83837e-17
C275	a_224_350##5	a_398_74##13	1.4692e-18
C276	SET_B#8	a_604_74##3	3.34284e-20
C277	VPWR#3	SET_B#5	1.80242e-19
C278	a_604_74##2	SET_B#1	2.90887e-17
C279	D#6	a_224_350##12	1.5213e-17
C280	VPWR#16	a_224_350##3	1.33761e-19
C281	a_1298_392##3	a_1470_48#	6.77788e-20
C282	a_224_350##5	VPWR#14	2.25454e-20
C283	a_224_350##5	a_224_350##6	2.75656e-17
C284	a_1902_74##7	a_1902_74#	1.34106e-18
C285	a_224_350##12	a_224_350##5	1.98126e-18
C286	a_1902_74##5	a_1902_74##2	8.6066e-19
C287	a_27_74##4	a_224_350##6	1.00154e-19
C288	SET_B#4	a_1470_48#	1.31969e-19
C289	D#7	CLK#3	5.23519e-19
C290	VPWR#4	a_1298_392#	1.91502e-17
C291	D#4	a_224_350##12	1.98431e-18
C292	a_760_395##2	a_604_74#	8.2119e-18
C293	a_1470_48##4	a_1902_74#	5.54644e-19
C294	SET_B#8	a_398_74##12	2.55619e-18
C295	a_1298_392##4	a_1298_392##5	5.93296e-18
C296	VGND#8	a_224_350##6	4.76838e-19
C297	a_224_350##12	CLK#2	7.47418e-18
C298	a_1298_392##9	a_1457_508#	4.87913e-19
C299	a_1902_74##7	a_1298_392#	5.2124e-17
C300	a_398_74##8	VGND#4	4.76993e-18
C301	SET_B#4	a_224_350##2	1.06334e-18
C302	a_398_74#	a_760_395##2	3.04401e-20
C303	VPWR#5	a_1902_74#	3.49308e-19
C304	VGND#3	a_1298_392##2	4.85368e-19
C305	VPWR#12	a_398_74##4	7.40226e-19
C306	VPWR#4	a_1298_392##6	1.57715e-18
C307	a_398_74##8	a_1470_48#	2.60631e-17
C308	a_760_395#	a_760_395##3	2.09498e-18
C309	a_1470_48##5	a_1298_392##8	1.2459e-18
C310	a_1470_48##4	a_1298_392#	3.18826e-18
C311	a_224_350##2	a_1470_48##2	1.18821e-17
C312	a_1902_74##5	a_1298_392##3	1.06056e-18
C313	a_224_350##12	D#2	1.15664e-17
C314	VGND#3	SET_B#5	2.26525e-20
C315	VGND#8	a_398_74##10	4.30978e-17
C316	a_1470_48##5	a_1902_74##6	4.63824e-17
C317	VPWR#16	D#2	1.38672e-18
C318	a_1902_74##7	a_1298_392##6	1.21081e-18
C319	CLK#2	a_224_350##6	3.44193e-17
C320	a_1470_48##5	a_1298_392##2	1.51673e-18
C321	a_224_350##2	a_398_74##8	3.47863e-17
C322	a_398_74##12	VPWR#12	3.41811e-17
C323	VPWR#5	a_1298_392#	2.78371e-19
C324	VGND#5	a_398_74##6	4.98773e-17
C325	VPWR#4	SET_B#7	2.68934e-19
C326	SET_B#6	a_1298_392##4	2.0227e-18
C327	VPWR#6	a_1470_48##2	1.07059e-19
C328	a_1470_48##4	a_1298_392##6	3.05496e-17
C329	VGND#4	a_398_74##6	3.95842e-17
C330	a_398_74##6	a_224_350##2	5.73943e-17
C331	a_398_74##10	a_27_74##2	8.73551e-19
C332	a_1470_48##5	a_1298_392##3	8.73207e-17
C333	a_1298_392##12	a_1298_392#	6.49443e-20
C334	a_224_350##9	a_398_74##2	1.8473e-18
C335	a_398_74##12	a_760_395#	6.74715e-19
C336	a_604_74##8	SET_B#1	9.01454e-20
C337	a_1298_392##8	VPWR#7	1.96378e-17
C338	a_398_74##6	a_604_74##6	4.40538e-17
C339	VPWR#10	VPWR#8	2.64019e-19
C340	a_1298_392##6	VPWR#5	1.31583e-17
C341	a_398_74##3	a_398_74#	4.56873e-19
C342	a_604_74##5	a_224_350##2	1.48714e-18
C343	a_1470_48##5	a_1470_48##7	1.64936e-18
C344	SET_B#8	VPWR#3	6.58997e-18
C345	a_398_74##6	SET_B#3	1.97885e-17
C346	a_1902_74##7	VPWR#4	7.58137e-17
C347	a_1470_48##4	SET_B#7	1.03164e-19
C348	a_398_74##3	a_224_350##9	3.14405e-17
C349	a_1470_48##5	SET_B#5	5.61397e-18
C350	a_1298_392##12	a_1298_392##6	1.05899e-18
C351	a_398_74##6	a_604_74##3	1.63588e-18
C352	SET_B#5	a_1298_392##6	1.43215e-18
C353	SET_B#2	a_224_350##2	1.70209e-18
C354	a_1470_48##3	SET_B#6	4.14366e-17
C355	a_27_74#	a_224_350##9	1.78242e-19
C356	VPWR#13	a_398_74##13	4.1711e-17
C357	VGND#5	a_604_74##5	1.02478e-18
C358	VPWR#6	a_398_74##8	2.84867e-19
C359	CLK	a_224_350##6	8.65092e-18
C360	VPWR#5	SET_B#7	2.19602e-18
C361	a_398_74##6	a_760_395##4	1.4365e-19
C362	SET_B#2	a_604_74##6	2.26214e-17
C363	a_1470_48##5	SET_B#4	3.65099e-17
C364	VPWR#7	a_1298_392##6	5.37763e-19
C365	VPWR#6	a_1298_392##6	3.17594e-19
C366	a_604_74##2	a_224_350##2	5.25535e-19
C367	a_1470_48##4	VPWR#4	3.21524e-18
C368	a_1298_392##12	SET_B#7	3.04835e-17
C369	VPWR#3	a_1902_74##2	2.20776e-18
C370	Q#3	a_1902_74##3	2.20296e-17
C371	a_1470_48##5	VGND#12	3.09866e-18
C372	a_604_74##3	SET_B#2	1.47152e-17
C373	a_27_74##3	a_224_350##6	1.69594e-19
C374	a_1902_74##5	a_1902_74#	1.98056e-18
C375	VGND#8	a_224_350##14	1.16181e-17
C376	VPWR#5	a_1470_48#	2.65134e-19
C377	a_398_74##6	VPWR#8	2.09055e-17
C378	CLK#2	a_224_350##7	5.66076e-19
C379	VGND#3	a_1902_74##2	4.21112e-18
C380	a_1298_392##3	VPWR#3	1.20432e-17
C381	VGND#7	a_604_74##8	8.098e-19
C382	SET_B#7	VPWR#7	1.22828e-17
C383	a_224_350#	a_1470_48##3	3.90428e-17
C384	a_1470_48##4	a_1902_74##7	7.67435e-17
C385	VPWR#5	VPWR#4	1.12716e-18
C386	VGND#5	a_224_350##2	3.64327e-20
C387	a_1902_74##3	VGND#11	2.53384e-17
C388	a_224_350##6	a_224_350##3	1.90027e-19
C389	VGND#5	SET_B#2	3.23078e-19
C390	VGND#3	a_1298_392##3	5.01333e-18
C391	a_604_74##8	a_760_395#	2.0193e-17
C392	VPWR#3	SET_B#4	3.76867e-18
C393	a_1298_392##12	a_1470_48#	1.37464e-18
C394	VGND#4	SET_B#5	5.81444e-18
C395	a_1470_48##2	a_1470_48##5	1.21737e-18
C396	SET_B#4	a_1298_392##8	3.37115e-17
C397	a_760_395##3	a_604_74##6	4.46185e-19
C398	VPWR#6	SET_B#7	5.68093e-18
C399	Q#3	a_1298_392##5	8.5268e-19
C400	SET_B#5	a_1298_392##4	1.40602e-17
C401	VGND#3	SET_B#4	4.5753e-18
C402	D#2	CLK#1	3.91014e-18
C403	VPWR#3	a_1470_48##2	2.37376e-18
C404	VGND#8	CLK#4	6.44731e-19
C405	a_1470_48#	VPWR#7	1.20627e-17
C406	a_398_74##2	a_604_74##6	1.52625e-19
C407	VGND#3	a_1470_48##2	1.39445e-17
C408	a_760_395##3	a_604_74##3	1.25507e-17
C409	a_1298_392##9	SET_B#7	1.45304e-18
C410	VPWR#12	a_224_350##6	1.3822e-19
C411	VPWR#3	a_398_74##8	2.80663e-18
C412	a_27_74##3	VPWR#13	1.3828e-18
C413	VPWR#8	a_604_74##5	7.50706e-20
C414	a_1298_392##5	VGND#11	2.48047e-17
C415	a_398_74##5	a_224_350#	2.3425e-17
C416	VGND#6	a_604_74##2	4.56526e-19
C417	VGND#3	a_398_74##8	2.6454e-19
C418	VPWR#8	a_1470_48#	3.33122e-20
C419	a_27_74##6	a_27_74##3	1.58155e-18
C420	a_604_74##8	a_398_74#	1.77389e-17
C421	a_27_74##2	a_224_350##6	3.08484e-17
C422	VPWR#7	a_398_74##7	7.09876e-19
C423	VGND#5	a_604_74##2	1.85982e-18
C424	a_398_74##8	a_1470_48##5	1.05924e-18
C425	a_1470_48##2	a_1298_392##8	3.14187e-18
C426	VGND#3	a_398_74##6	2.4348e-17
C427	VPWR#12	a_224_350##3	2.46007e-17
C428	VPWR#5	a_1470_48##4	2.54336e-17
C429	a_1298_392##9	a_1470_48#	2.85452e-17
C430	a_398_74##4	a_760_395##3	4.7532e-19
C431	a_27_74##3	a_27_74##2	2.48242e-18
C432	VPWR#6	a_1470_48#	5.41301e-18
C433	a_1902_74##6	a_1298_392##5	4.34495e-17
C434	a_398_74##2	a_224_350##8	3.82252e-18
C435	SET_B#8	a_398_74##6	1.1364e-16
C436	SET_B#6	a_1500_74#	8.35249e-18
C437	VGND#4	a_1902_74##3	3.96981e-19
C438	VGND#11	a_1298_392##4	1.01331e-18
C439	SET_B#4	a_1298_392##3	5.26727e-17
C440	a_1470_48##3	a_1500_74#	8.35249e-18
C441	VPWR#7	a_224_350##2	4.62197e-19
C442	a_604_74##5	SET_B#8	2.39357e-17
C443	a_27_74##2	VPWR#13	1.48224e-18
C444	a_1470_48#	SET_B#5	1.59053e-17
C445	VPWR#8	SET_B#2	3.76286e-19
C446	Q	a_1298_392##2	2.14594e-18
C447	a_604_74##8	a_224_350##9	4.15421e-18
C448	a_1298_392##12	a_1470_48##4	9.05132e-19
C449	a_1298_392##9	a_398_74##7	4.19592e-17
C450	a_604_74##4	a_398_74##5	2.16702e-17
C451	a_604_74##7	a_604_74##9	9.2277e-19
C452	VPWR#8	a_398_74##7	7.93701e-20
C453	VGND#6	a_760_395##2	1.21149e-18
C454	SET_B#8	SET_B#2	3.08405e-17
C455	VPWR#9	a_1470_48#	1.66868e-19
C456	VPWR#16	VPWR#13	1.17126e-19
C457	VGND#7	a_224_350##6	2.34764e-19
C458	a_1902_74##6	a_1298_392##4	1.2783e-18
C459	a_1470_48##2	SET_B#4	2.42756e-17
C460	VGND#3	VGND#11	2.34184e-17
C461	a_398_74##8	a_1298_392##3	4.76516e-19
C462	a_604_74##2	SET_B#8	4.68127e-18
C463	a_1470_48#	a_1457_508#	8.25246e-18
C464	VPWR#6	a_398_74##7	5.90908e-18
C465	a_398_74##8	SET_B#4	7.04771e-18
C466	VGND#3	a_1902_74##6	1.92645e-17
C467	a_224_350##5	a_224_350##10	8.84045e-18
C468	a_1298_392##9	a_224_350##2	8.97075e-17
C469	a_1298_392##12	VPWR#5	2.63133e-17
C470	a_398_74##7	a_1457_508#	6.57e-18
C471	a_1470_48##3	a_1422_74#	1.69678e-18
C472	a_398_74##8	a_1470_48##2	8.64961e-17
C473	a_1298_392##4	a_1470_48##7	1.42891e-17
C474	VPWR#9	a_398_74##7	1.2282e-19
C475	a_224_350##5	CLK#3	1.05856e-20
C476	VPWR#10	a_604_74##2	1.82989e-20
C477	VGND#4	a_1298_392##5	7.94799e-19
C478	a_224_350#	a_1422_74#	4.40091e-18
C479	SET_B#1	a_604_74##4	1.59394e-17
C480	VPWR#8	a_604_74##2	3.93425e-19
C481	a_398_74##6	a_1470_48##2	8.4407e-21
C482	SET_B#8	a_760_395##3	2.70692e-18
C483	a_1298_392##2	a_1902_74##2	1.65754e-17
C484	VPWR#8	a_224_350##2	3.83641e-17
C485	a_224_350##2	a_1197_341#	2.35911e-17
C486	VGND#4	a_1470_48##5	7.72766e-17
C487	a_1298_392##9	a_604_74##6	4.00094e-18
C488	a_398_74##6	a_398_74##8	2.73936e-18
C489	VGND#6	a_760_395##3	7.17716e-20
C490	VPWR#7	VPWR#5	3.26064e-18
C491	a_1298_392##4	VGND#12	6.76677e-18
C492	a_27_74##5	a_27_74#	1.49495e-18
C493	a_604_74##6	a_1197_341#	2.39313e-17
C494	VPWR#9	a_224_350##2	1.49405e-17
C495	a_224_350##14	CLK#4	3.70406e-17
C496	D#2	CLK#3	7.23562e-18
C497	VPWR#12	a_398_74##2	7.91275e-20
C498	VPWR#6	a_224_350##2	4.63938e-19
C499	VPWR	a_224_350##3	2.83445e-17
C500	VGND#7	a_398_74##2	6.46468e-20
C501	a_604_74##5	a_398_74##6	1.14625e-16
C502	a_760_395##7	a_224_350##2	5.48141e-19
C503	VPWR#12	a_398_74##3	2.78078e-19
C504	a_1298_392##9	SET_B#3	6.84062e-19
C505	VPWR#10	a_760_395##2	8.90518e-20
C506	VPWR#7	a_1298_392##12	2.29408e-17
C507	VGND#4	a_1298_392##4	1.21397e-17
C508	a_604_74#	SET_B#1	4.29057e-17
C509	a_760_395#	a_604_74##4	2.34e-19
C510	SET_B#2	a_398_74##6	3.01291e-17
C511	a_604_74##6	VPWR#9	2.12314e-17
C512	a_398_74##5	a_1215_74#	1.53768e-17
C513	VGND#7	a_398_74##3	3.57504e-19
C514	VGND#3	a_1298_392##14	7.3372e-18
C515	SET_B#6	VGND#12	1.3689e-17
C516	a_760_395##4	a_709_463#	2.18612e-18
C517	a_604_74##5	SET_B#2	1.77777e-17
C518	a_398_74##6	a_604_74##2	7.60434e-19
C519	VPWR#8	a_604_74##6	2.67022e-18
C520	a_224_350##8	a_709_463#	4.31134e-18
C521	a_760_395##7	a_604_74##6	8.55516e-20
C522	VGND#6	a_398_74##2	1.67313e-19
C523	a_398_74##12	a_398_74##6	2.47229e-18
C524	a_398_74##6	a_760_395##2	8.63433e-20
C525	SET_B#3	VPWR#9	1.38007e-17
C526	a_1298_392##3	a_1298_392##2	4.93598e-18
C527	a_604_74##2	SET_B#2	6.04176e-17
C528	SET_B#1	a_1027_118#	8.8457e-18
C529	a_760_395##3	a_398_74##6	2.06667e-18
C530	a_1298_392##8	SET_B#5	2.13692e-17
C531	a_604_74#	a_1027_118#	8.8457e-18
C532	SET_B#8	a_1298_392##14	2.38155e-18
C533	a_760_395#	a_604_74#	2.14262e-18
C534	SET_B#5	a_1298_392##3	5.6582e-17
C535	VPWR#10	a_760_395##3	2.67666e-19
C536	a_760_395##7	SET_B#3	9.79078e-18
C537	SET_B	SET_B#5	4.38494e-18
C538	VGND#4	SET_B#6	2.2955e-17
C539	a_604_74##2	a_760_395##2	5.79862e-17
C540	a_760_395##3	SET_B#2	1.99039e-17
C541	a_398_74##2	a_604_74##5	3.62484e-20
C542	a_1298_392##9	a_1298_392##12	3.39559e-18
C543	Q#3	a_1902_74##2	6.12944e-18
C544	VPWR#8	SET_B#3	6.43812e-19
C545	a_1902_74##5	Q	5.58417e-18
C546	a_604_74##2	a_760_395##3	1.26341e-16
C547	a_398_74##2	SET_B#2	1.42896e-19
C548	SET_B#8	a_1197_341#	5.23038e-18
C549	SET_B#8	VGND#13	5.26367e-18
C550	a_1902_74##2	VGND#11	2.88476e-17
C551	a_760_395##2	a_760_395##3	2.11909e-18
C552	a_604_74##2	a_398_74##2	9.98972e-19
C553	a_760_395##7	a_604_74##3	2.77872e-17
C554	a_1298_392##8	SET_B#7	1.11656e-17
C555	a_398_74##2	a_760_395##2	5.64921e-18
C556	a_1298_392##9	VPWR#7	3.26754e-17
C557	a_398_74#	a_760_395#	4.73545e-17
C558	a_760_395#	a_740_74#	8.35249e-18
C559	a_604_74##3	VPWR#11	1.97562e-18
C560	a_398_74#	a_740_74#	8.35249e-18
C561	a_398_74##2	a_760_395##3	4.50521e-17
C562	VPWR	VPWR#13	1.01219e-16
C563	VPWR#10	a_604_74##3	1.06656e-18
C564	VPWR	VPWR#10	8.99646e-17
C565	CLK	a_27_74##5	4.01966e-18
C566	VPWR	VPWR#8	1.15789e-16
C567	VGND#15	CLK	1.69934e-17
C568	VGND#4	a_1470_48##3	1.04478e-17
C569	a_760_395##7	a_760_395##4	1.54401e-20
C570	a_398_74##3	a_760_395##3	4.10509e-18
C571	D#4	a_224_350##14	3.93751e-17
C572	a_398_74##12	a_760_395##7	8.5618e-17
C573	SET_B#2	a_398_74##12	1.76134e-18
C574	a_398_74##3	a_398_74##2	5.10408e-18
C575	a_1298_392##14	a_1470_48##3	8.89723e-19
C576	VPWR#9	a_224_350##8	3.37656e-20
C577	SET_B#4	SET_B#5	4.75644e-17
C578	VGND#8	a_224_350##5	4.88085e-19
C579	VGND	a_224_350##6	3.79728e-18
C580	VPWR#11	a_760_395##4	2.77504e-17
C581	a_1298_392##8	a_1470_48#	1.69971e-17
C582	a_398_74##6	a_1197_341#	2.67148e-18
C583	VGND#13	SET_B#6	4.22856e-20
C584	a_27_74##3	D#7	5.48044e-17
C585	VGND#3	a_1422_74#	9.29877e-19
C586	a_224_350##9	a_398_74#	1.40731e-17
C587	Q	Q#3	8.83205e-19
C588	VPWR	a_398_74##12	4.85664e-17
C589	VGND#11	Q	1.99032e-17
C590	SET_B	VGND#4	4.56668e-18
C591	VPWR	a_604_74##8	2.08052e-18
C592	a_760_395##5	a_224_350##3	1.13387e-19
C593	D#4	VGND#16	3.55083e-17
C594	VPWR#10	a_760_395##4	6.73937e-19
C595	VPWR#11	a_224_350##8	1.12065e-18
C596	a_224_350##5	CLK#2	2.48377e-18
C597	a_224_350##14	a_224_350##12	2.81859e-18
C598	a_1298_392##14	a_224_350#	3.45254e-17
C599	SET_B	VPWR#6	4.2333e-18
C600	VPWR	a_27_74##3	1.06216e-17
C601	a_398_74##12	VPWR#11	1.30447e-16
C602	a_27_74##6	D#6	4.03186e-18
C603	VPWR	a_27_74##2	8.52485e-18
C604	a_604_74##2	a_398_74##12	1.3732e-18
C605	a_604_74##7	a_760_395##4	1.03139e-18
C606	VGND#4	a_224_350#	6.06883e-18
C607	a_224_350##5	D#2	1.06837e-19
C608	VPWR	CLK#4	1.67518e-18
C609	VGND#13	a_1470_48##3	5.40943e-20
C610	VPWR	D#7	4.76205e-18
C611	SET_B	a_1470_48##5	3.38454e-18
C612	CLK	a_224_350##12	1.37071e-17
C613	SET_B#8	a_1215_74#	1.7139e-19
C614	D#2	CLK#2	1.05364e-17
C615	SET_B	a_1298_392##8	2.72746e-17
C616	VGND#8	CLK#2	1.00231e-19
C617	a_224_350##7	a_224_350##9	3.45914e-18
C618	a_398_74##8	a_1422_74#	8.39268e-18
C619	Q	Q#1	1.51636e-17
C620	VGND#6	VGND#5	3.14709e-19
C621	VPWR#4	Q	8.54107e-17
C622	a_604_74##7	a_224_350##8	3.34417e-17
C623	a_398_74##6	a_1422_74#	1.01515e-18
C624	a_27_74##6	D#4	3.53234e-17
C625	VGND#5	a_398_74##5	4.44586e-18
C626	a_760_395##5	VGND#13	1.57812e-17
C627	VPWR#3	VPWR#4	2.07975e-17
C628	a_1470_48##2	SET_B#5	7.36057e-17
C629	a_1298_392##14	a_398_74##5	2.40861e-17
C630	VGND	VGND#8	9.24279e-17
C631	VGND	VGND#6	7.97716e-17
C632	a_1298_392##2	VNB	4.62915e-17
C633	a_398_74##13	a_760_395##4	4.4338e-20
C634	SET_B#5	VNB	1.26724e-16
C635	VGND	VGND#5	9.76137e-17
C636	a_224_350##6	VNB	1.15957e-16
C637	a_224_350##3	VNB	1.77341e-16
C638	a_604_74##8	a_604_74##2	2.49522e-18
C639	VGND#13	a_224_350#	2.2224e-19
C640	a_398_74##12	a_760_395##2	3.4872e-19
C641	a_27_74#	a_224_350##8	7.26997e-19
C642	VPWR#3	a_1902_74##7	1.77041e-17
C643	VPWR#9	a_1298_392##9	1.03058e-17
C644	VGND#7	a_604_74##9	1.38719e-17
C645	a_398_74##6	a_1215_74#	1.59653e-17
C646	VGND#4	a_398_74##5	1.01884e-19
C647	CLK	a_224_350##7	1.99662e-18
C648	a_604_74##7	a_398_74##4	1.11518e-17
C649	a_27_74##3	D#6	9.02709e-18
C650	a_1470_48##4	VPWR#3	3.68732e-17
C651	a_398_74##13	a_224_350##8	2.15851e-19
C652	VGND#3	VPWR#4	3.89663e-18
C653	CLK#1	a_224_350##7	3.93188e-17
C654	VGND#14	VGND#13	4.36585e-18
C655	a_1470_48##2	VGND#12	7.96018e-19
C656	a_1298_392##14	a_604_74##4	8.25114e-19
C657	Q	a_1902_74##3	1.16915e-17
C658	VPWR	a_1298_392##9	1.08251e-17
C659	Q	a_1298_392##5	2.82455e-19
C660	a_27_74#	a_398_74##4	2.23963e-17
C661	VPWR#13	a_224_350##6	8.5194e-20
C662	VGND	a_604_74##8	7.99017e-18
C663	VPWR	a_760_395##7	7.48373e-18
C664	VGND#7	a_398_74##10	4.48008e-17
C665	VGND#13	a_398_74##5	3.76424e-18
C666	VPWR	a_604_74##7	1.01929e-17
C667	VPWR	a_27_74#	1.11001e-17
C668	VGND#5	a_604_74##4	3.88061e-18
C669	VPWR	a_398_74##13	3.63294e-17
C670	VPWR#13	CLK#2	8.3897e-20
C671	a_604_74##8	a_760_395##2	3.27079e-17
C672	VGND#8	VNB	4.3054e-17
C673	a_604_74##7	a_398_74##12	9.68698e-17
C674	VGND#6	VNB	4.20118e-17
C675	VGND	CLK#4	3.18722e-18
C676	VGND#5	VNB	6.11398e-17
C677	a_398_74##13	a_398_74##4	6.43589e-18
C678	VGND#4	VNB	6.39348e-17
C679	VPWR	a_224_350##12	5.69165e-18
C680	a_398_74##12	a_760_395##3	6.72444e-17
C681	a_1298_392##12	VPWR#3	2.14453e-17
C682	SET_B	a_1902_74##7	2.10175e-18
C683	VPWR	VPWR#16	1.83501e-17
C684	VGND	D#4	4.53551e-18
C685	SET_B	a_1470_48##4	1.95629e-18
C686	VPWR	a_27_74##4	1.4848e-17
C687	VPWR#13	VNB	4.3627e-17
C688	a_1902_74##5	a_1902_74##3	4.63279e-19
C689	VPWR#10	VNB	3.0167e-17
C690	VPWR#8	VNB	4.9362e-17
C691	VPWR#6	VNB	4.65172e-17
C692	SET_B	VPWR#7	3.15647e-18
C693	a_27_74#	a_224_350##10	1.34616e-18
C694	SET_B	a_1298_392##9	1.70655e-17
C695	a_1902_74##5	VNB	4.79205e-18
C696	VGND	a_1298_392##14	2.59634e-18
C697	a_398_74##8	SET_B#5	1.51653e-18
C698	a_1298_392##14	a_1470_48##2	6.77446e-19
C699	VGND	VGND#13	1.88012e-17
C700	a_1470_48##5	VNB	3.24944e-17
C701	D#3	CLK#1	3.19328e-18
C702	Q	a_1902_74#	3.07847e-17
C703	VGND#4	a_604_74##4	7.8221e-20
C704	VGND	a_760_395##5	1.40044e-17
C705	VGND	VGND#14	2.25645e-17
C706	a_1298_392##8	VNB	8.60033e-18
C707	VGND	a_604_74##9	1.56224e-17
C708	VGND	a_27_74##5	8.64743e-18
C709	a_398_74##12	VNB	2.76669e-17
C710	VGND	a_398_74##10	4.43801e-17
C711	VPWR	a_760_395#	4.6258e-19
C712	VPWR#9	a_224_350##3	6.42718e-20
C713	VGND#13	a_604_74##4	4.84844e-17
C714	a_224_350##10	a_398_74##13	2.50236e-17
C715	VGND	a_224_350##14	2.26756e-17
C716	a_604_74##8	VNB	1.73414e-17
C717	VGND	a_27_74##6	1.70028e-17
C718	VGND#4	VGND#11	8.46602e-19
C719	a_27_74##3	VNB	5.88432e-17
C720	SET_B	SET_B#6	2.18379e-18
C721	a_27_74#	CLK#3	2.77488e-19
C722	CLK#4	VNB	2.40458e-19
C723	D#7	VNB	4.13803e-18
C724	VPWR#13	a_224_350##10	3.427e-18
C725	a_604_74##8	a_760_395##3	1.1373e-17
C726	VGND	a_1298_392##9	1.4564e-18
C727	D#6	VNB	4.7379e-19
C728	D#4	VNB	1.75317e-18
C729	VPWR#14	a_224_350##10	3.77681e-17
C730	Q#3	VNB	2.35649e-17
C731	VGND#11	VNB	7.32656e-18
C732	a_1902_74##6	VNB	1.03395e-17
C733	VPWR#3	a_1298_392##9	3.66712e-17
C734	a_398_74##12	a_398_74##2	1.73863e-18
C735	VGND#14	a_760_395##5	1.44312e-17
C736	VGND#5	SET_B#1	5.53306e-18
C737	VPWR	a_224_350##2	1.34276e-17
C738	a_1298_392##14	VNB	2.98097e-20
C739	VPWR	a_604_74##6	3.582e-18
C740	a_1298_392##14	a_398_74##8	6.73379e-17
C741	VGND#13	VNB	5.61054e-18
C742	VPWR	SET_B#3	6.88959e-19
C743	VGND	a_224_350##12	2.35079e-18
C744	a_760_395##5	VNB	6.36379e-18
C745	a_1902_74##5	a_1298_392##5	1.43574e-17
C746	a_398_74##13	CLK#3	1.45558e-18
C747	VGND#14	VNB	6.70798e-18
C748	a_604_74##9	VNB	4.46116e-20
C749	VPWR	a_760_395##4	2.85315e-18
C750	VPWR#3	Q	1.79411e-17
C751	a_27_74##5	VNB	4.75008e-18
C752	a_398_74##10	VNB	1.17006e-17
C753	VGND#3	Q	2.33081e-17
C754	VGND#15	VNB	3.17612e-18
C755	a_224_350##12	a_224_350##10	6.39205e-19
C756	a_224_350##14	VNB	1.76026e-17
C757	VGND#16	VNB	2.36654e-18
C758	a_27_74##6	VNB	5.55603e-17
C759	VPWR	a_224_350##10	3.30218e-18
C760	VGND#13	SET_B#1	1.45844e-17
C761	VPWR#4	VNB	2.75179e-18
C762	VPWR	CLK#3	4.76591e-18
C763	SET_B	a_1470_48#	1.58562e-18
C764	VGND	a_398_74##5	1.42269e-18
C765	a_1902_74##7	VNB	1.23663e-17
C766	a_604_74##3	a_224_350##3	1.92014e-17
C767	D#4	CLK#1	3.10843e-19
C768	a_1470_48##4	VNB	1.56605e-17
C769	VGND	a_604_74##4	1.08483e-18
C770	VPWR	D#1	1.9756e-18
C771	a_398_74##12	a_224_350##2	2.37214e-18
C772	VPWR#5	VNB	4.44118e-18
C773	VGND	SET_B#1	1.11085e-17
C774	SET_B	a_224_350##2	2.0545e-18
C775	a_1298_392##12	VNB	3.49877e-18
C776	a_1902_74##2	Q	5.17511e-17
C777	VGND	a_604_74#	1.02291e-17
C778	VPWR#7	VNB	3.06405e-18
C779	VGND	a_760_395#	3.83968e-19
C780	VPWR#14	CLK#3	3.40294e-17
C781	a_1298_392##9	VNB	1.17175e-17
C782	VGND	a_398_74#	2.69922e-19
C783	VGND	a_224_350##9	6.07087e-19
C784	VPWR#9	VNB	3.78971e-18
C785	a_760_395##5	a_604_74##4	1.84407e-18
C786	VGND	a_224_350##7	4.99504e-19
C787	VPWR#11	VNB	2.73004e-18
C788	VGND	CLK#1	1.45708e-18
C789	VGND#3	a_1298_392##9	1.88022e-18
C790	SET_B#8	VPWR	3.60439e-17
C791	VGND	D#3	2.82843e-18
C792	a_604_74##7	VNB	7.21311e-18
C793	VPWR	VPWR#12	6.67898e-17
C794	a_398_74##13	VNB	1.83445e-17
C795	CLK	a_224_350##5	3.26143e-17
C796	VGND#6	a_604_74#	1.85413e-18
C797	VPWR#14	VNB	5.38477e-19
C798	a_224_350##12	VNB	7.92207e-18
C799	VPWR#16	VNB	5.67618e-18
C800	CLK	CLK#2	5.54728e-18
C801	a_398_74##13	D#1	3.88161e-19
C802	a_27_74##4	VNB	2.31906e-17
C803	a_1902_74##3	VNB	3.1933e-17
C804	a_1298_392##5	VNB	4.66925e-17
C805	a_604_74##8	a_398_74##2	6.82558e-17
C806	a_1298_392##4	VNB	4.57574e-17
C807	SET_B#6	VNB	2.82807e-17
C808	a_224_350##12	CLK#3	3.45319e-17
C809	SET_B	VPWR#3	4.13089e-17
C810	a_1470_48##3	VNB	2.65192e-17
C811	VPWR#13	a_224_350##3	7.82276e-18
C812	a_224_350#	VNB	5.90209e-17
C813	a_398_74##13	a_398_74##12	1.12661e-18
C814	a_398_74##6	a_1298_392##14	1.09869e-16
C815	a_398_74##5	VNB	2.6404e-17
C816	a_604_74##4	VNB	2.80012e-17
C817	SET_B#1	VNB	3.83055e-17
C818	VPWR	a_398_74##6	1.82476e-17
C819	a_398_74##12	a_398_74##3	6.71118e-19
C820	a_604_74#	VNB	2.68152e-17
C821	VPWR#13	CLK#3	3.37154e-18
C822	a_27_74##4	a_224_350##10	7.93897e-20
C823	a_760_395#	VNB	3.18972e-17
C824	VGND	a_224_350##8	1.69612e-19
C825	VPWR	a_604_74##5	7.10189e-19
C826	a_398_74#	VNB	2.92579e-17
C827	a_224_350##9	VNB	4.15494e-17
C828	VPWR	SET_B#2	2.66061e-18
C829	a_224_350##7	VNB	3.17103e-17
C830	SET_B	a_1298_392##3	7.9642e-18
C831	a_760_395##7	a_224_350##3	1.04586e-18
C832	CLK#1	VNB	3.56402e-17
C833	VPWR	a_604_74##2	6.68251e-18
C834	VGND#14	a_604_74##4	1.14518e-18
C835	D#3	VNB	2.87369e-17
C836	VPWR#14	D#1	3.51135e-18
C837	SET_B	SET_B#4	3.57245e-17
C838	VGND#13	a_604_74#	2.62664e-18
C839	a_1902_74#	VNB	4.53095e-17
C840	SET_B	a_1470_48##2	2.05718e-17
C841	a_1298_392#	VNB	3.42217e-17
C842	VPWR	a_760_395##3	2.67722e-18
C843	SET_B	a_398_74##8	4.88962e-17
C844	a_1298_392##6	VNB	4.49952e-17
C845	a_27_74##2	a_760_395##3	2.60377e-19
C846	SET_B#7	VNB	3.22612e-17
C847	VGND#5	a_604_74#	3.15173e-18
C848	SET_B	a_398_74##6	8.28175e-19
C849	a_1902_74##2	VPWR#4	2.75055e-17
C850	VPWR#16	CLK#3	6.18514e-18
C851	a_1470_48#	VNB	3.92781e-17
C852	a_1902_74##5	a_1298_392##4	5.61387e-19
C853	a_398_74##7	VNB	2.74282e-17
C854	VGND	SET_B#8	1.8859e-18
C855	VPWR	a_398_74##3	5.06044e-18
C856	a_224_350##2	VNB	1.39841e-16
C857	SET_B#8	a_1298_392##9	5.01584e-17
C858	a_604_74##6	VNB	2.81513e-17
C859	VPWR	a_224_350##5	4.05355e-18
C860	VGND	VGND#7	6.74272e-17
C861	SET_B#3	VNB	2.19186e-17
C862	a_604_74##3	VNB	3.33346e-17
C863	a_760_395##4	VNB	2.13024e-17
C864	a_760_395##5	SET_B#1	4.38099e-18
C865	a_224_350##8	VNB	2.71332e-17
C866	a_398_74##4	VNB	2.89771e-17
C867	a_224_350##10	VNB	3.30606e-17
C868	VGND#13	a_398_74##6	4.30081e-17
C869	CLK#3	VNB	4.10718e-17
C870	D#1	VNB	4.42269e-17
C871	a_27_74##5	a_224_350##6	2.85098e-17
C872	VGND	a_398_74##6	2.36464e-17
C873	VGND	a_604_74##5	5.84456e-18
C874	VPWR#3	VNB	2.50556e-16
C875	VGND	SET_B#2	2.68372e-18
C876	VGND#3	VNB	2.3191e-16
C877	VGND	a_604_74##2	1.23107e-17
C878	SET_B#8	VNB	3.35454e-18
C879	a_27_74##4	CLK#3	2.53009e-19
C880	a_604_74##9	a_760_395##5	2.01866e-18
C881	VPWR#12	VNB	2.8614e-17
C882	VGND	a_760_395##2	3.51217e-18
C883	VGND#7	VNB	3.91493e-17
C884	VGND	a_760_395##3	3.87284e-18
C885	a_1902_74##2	VNB	5.59814e-17
C886	VGND	a_398_74##2	5.11222e-18
C887	a_1298_392##3	VNB	8.61354e-17
C888	SET_B#4	VNB	9.7728e-18
C889	VGND	a_398_74##3	3.54318e-18
C890	a_1470_48##2	VNB	7.11213e-17
C891	VGND	a_224_350##5	4.68589e-18
C892	a_398_74##8	VNB	5.51777e-17
C893	VGND	CLK#2	4.85419e-19
C894	a_398_74##6	VNB	3.53444e-17
C895	a_604_74##5	VNB	4.03769e-17
C896	VGND	D#2	8.72319e-19
C897	SET_B#2	VNB	4.94904e-17
C898	SET_B	a_1500_74#	1.15949e-19
C899	a_604_74##2	VNB	7.04768e-17
C900	a_604_74##8	a_398_74##3	8.70268e-17
C901	VPWR#16	D#1	3.15674e-17
C902	a_760_395##2	VNB	5.07506e-17
C903	a_760_395##3	VNB	6.35964e-17
C904	a_1470_48##5	a_1298_392##5	4.58052e-18
C905	a_398_74##2	VNB	5.6912e-17
C906	a_398_74##3	VNB	6.76701e-17
C907	VGND#14	SET_B#1	3.34416e-19
C908	a_224_350##5	VNB	2.61668e-18
C909	VGND#6	a_760_395#	3.76317e-18
C910	SET_B#8	VPWR#9	7.3522e-18
C911	CLK#2	VNB	3.37839e-17
C912	VGND#13	a_760_395#	8.26116e-19
C913	a_760_395##5	a_398_74##6	1.92672e-18
C914	D#2	VNB	1.11844e-16
C915	a_760_395##4	a_224_350##3	1.66973e-17
C916	a_1298_392#	a_1902_74#	2.94334e-17
C917	VPWR	CLK	1.57183e-18
C918	VPWR#13	D#1	6.70481e-19
C919	a_760_395##5	a_604_74#	3.41819e-17
C920	a_27_74##4	D#1	1.29988e-17
C921	VPWR#6	SET_B#5	7.84188e-20
C922	a_1902_74##7	a_1298_392##3	5.57492e-19
C923	a_604_74##5	VGND#13	4.42584e-17
C924	SET_B#8	a_760_395##7	2.84135e-18
C925	VGND	CLK	9.89265e-19
C926	a_604_74##9	VGND#14	1.0549e-17
C927	Q	VNB	1.00394e-16
C928	VPWR	VNB	2.81258e-16
C929	SET_B	VNB	1.18809e-17
C930	VGND	VNB	3.20994e-16
C931	a_398_74##12	SET_B#3	3.27692e-18
C932	VPWR#10	a_224_350##3	3.20638e-17
C933	a_1470_48##4	a_1298_392##3	6.88274e-17
C934	VGND#9	a_224_350##14	1.24507e-17
C935	VGND#2	a_1902_74##6	2.07549e-17
C936	VGND#4	VGND#2	3.23692e-19
C937	VPWR#2	VNB	5.51618e-17
C938	VGND	VGND#9	9.70891e-17
C939	VGND#2	a_1298_392##2	1.78427e-19
C940	VGND#9	CLK#1	1.12127e-18
C941	Q	VPWR#2	1.76458e-17
C942	VGND#2	a_1298_392##5	3.06161e-18
C943	VGND#9	VGND#15	8.53856e-19
C944	VGND#2	Q	2.49216e-17
C945	VPWR#15	VNB	4.97475e-17
C946	VPWR#2	a_1298_392#	2.73387e-18
C947	VGND#9	a_27_74##6	1.80122e-17
C948	VGND#2	a_1902_74##5	2.1385e-19
C949	VPWR#2	a_1902_74#	3.34195e-18
C950	VGND#2	a_1902_74##3	4.68233e-18
C951	VGND#9	a_224_350##7	2.15575e-19
C952	VGND#2	VNB	5.86431e-17
C953	a_1902_74##2	VPWR#2	2.60483e-20
C954	VPWR#15	D#1	1.83512e-18
C955	VPWR#2	a_1298_392##2	9.84775e-20
C956	VGND#3	VGND#2	9.91963e-17
C957	VPWR#15	a_224_350##3	4.06976e-20
C958	VPWR#3	VPWR#2	9.29452e-17
C959	VPWR	VPWR#15	8.2907e-17
C960	VPWR#15	VPWR#13	1.29967e-18
C961	a_1902_74##7	VPWR#2	1.22136e-17
C962	a_27_74##3	VPWR#15	3.43659e-18
C963	VGND#9	VNB	5.21449e-17
C964	a_1902_74##5	VPWR#2	9.9457e-20
C965	VGND#2	a_1902_74##2	5.94781e-19
C966	VGND#9	VGND#8	9.71959e-19
C967	a_27_74##4	VPWR#15	1.75414e-17
C968	VGND#9	D#3	8.42255e-18
*
*
.ENDS sky130_fd_sc_hs__dfstp_1
*
