* Extracted by Quantus, converted by sky130cad/quantus.py
*
*
*
*                       LINUX           Wed Nov 18 08:50:09 2026
*
*
*
*  PROGRAM  advgen
*
*  Name           : advgen - Quantus - (64-bit)
*  Version        : 25.1.0-p047
*  Build Date     : Thu Dec 11 23:20:30 PST 2025
*
*  HSPICE LIBRARY
*
*  OPERATING_TEMPERATURE 150
*  QRC_TECH_DIR <path>/tech
*
*
*

*
.SUBCKT sky130_fd_sc_hs__nor3_2 VPB VNB VGND VPWR Y A C B
*
*
*  caps2d version: 10
*
*
*       TRANSISTOR CARDS
*
*
XM7 Y#2 C#4 VGND#7 VNB sky130_fd_pr__nfet_01v8_lvt l=0.15 w=0.74 ad=0.2109 as=0.6549 pd=2.05 ps=3.25
XM8 VGND#7 B#1 Y#1 VNB sky130_fd_pr__nfet_01v8_lvt l=0.15 w=0.74 ad=0.6549 as=0.259 pd=3.25 ps=2.18
XM4 Y#1 A#6 VGND#6 VNB sky130_fd_pr__nfet_01v8_lvt l=0.15 w=0.74 ad=0.259 as=0.2627 pd=2.18 ps=2.19
XM0 a_27_368##4 C#5 Y#4 VPB sky130_fd_pr__pfet_01v8 l=0.15 w=1.12 ad=0.3304 as=0.392 pd=2.83 ps=2.94
XM2 Y#4 C#1 a_27_368##2 VPB sky130_fd_pr__pfet_01v8 l=0.15 w=1.12 ad=0.392 as=0.336 pd=2.94 ps=2.84
XM6 a_27_368##2 B#3 a_306_368##2 VPB sky130_fd_pr__pfet_01v8 l=0.15 w=1.12 ad=0.336 as=0.3696 pd=2.84 ps=2.9
XM5 a_306_368##2 A#4 VPWR#4 VPB sky130_fd_pr__pfet_01v8 l=0.15 w=1.12 ad=0.3696 as=0.3584 pd=2.9 ps=2.88
XM3 VPWR#4 A#5 a_306_368# VPB sky130_fd_pr__pfet_01v8 l=0.15 w=1.12 ad=0.3584 as=0.336 pd=2.88 ps=2.84
XM1 a_306_368# B#4 a_27_368# VPB sky130_fd_pr__pfet_01v8 l=0.15 w=1.12 ad=0.336 as=0.3304 pd=2.84 ps=2.83
*
*
*       RESISTOR AND CAP/DIODE CARDS
*
Rg1	C#1	C#2	399.828430
Rg2	C#2	C#3	45.612778
Rg3	C#3	C#4	401.657837
Rg4	C#2	C#5	451.202362
Rg5	B#1	B#2	320.356293
Rg6	B#2	B#3	500.238068
Rg7	A#1	A#2	275.496094
Rg8	A#2	A#3	163.812912
Rg9	A#3	A#4	597.197388
Rg10	A#2	A#5	556.550232
Rg11	A#3	A#6	302.725922
Rg12	B#4	B#5	638.806030
Rf1	C	C#6	1.588424
Rf2	C#7	C#3	161.821228
Rf3	C#6	C#7	3.176847
Rf4	Y#1	Y	117.500214
Rf5	Y	Y#3	8.242671
Rf6	Y	Y#4	60.095352
Rf7	Y#3	Y	6.495599
Rf8	Y#2	Y#3	7.500000
Rf9	a_306_368#	a_306_368##2	97.602142
Rf10	A#7	A#1	81.137527
Rf11	A	A#9	1.021129
Rf12	A#7	A#9	6.064680
Rf13	a_27_368#	a_27_368##3	201.934311
Rf14	a_27_368##3	a_27_368##4	126.073227
Rf15	a_27_368##2	a_27_368##3	5.000000
Rf16	B	B#5	3.723547
Rf17	B#5	B#2	269.837463
Rf19	VGND#2	VGND#3	46.362534
Rf20	VGND#3	VGND#4	46.452953
Rf22	VGND#2	VGND#6	33.306259
Rf23	VGND#4	VGND#7	14.167749
Rf25	VPWR#2	VPWR#3	36.500717
Rf26	VPWR#2	VPWR#4	30.747387
Re1	VPWR#3	VPWR	1.403190
Re2	VGND	VGND#3	1.403242
*
*       CAPACITOR CARDS
*
*
C1	VGND	VNB	5.64486e-17
C2	VPWR	VNB	6.44502e-17
C3	Y	VNB	7.60607e-17
C4	A	VNB	3.39129e-17
C5	VGND	Y	2.20273e-17
C6	B	VNB	2.51715e-17
C7	VGND	A	1.14253e-17
C8	VPWR	Y	3.21684e-18
C9	VGND	B	7.67118e-18
C10	B#2	VNB	3.46435e-17
C11	A#1	VNB	8.97129e-17
C12	B#5	VNB	6.54978e-17
C13	VGND#3	VNB	1.66647e-16
C14	VPWR	B	4.70999e-18
C15	VPWR#3	VNB	2.20126e-16
C16	C#5	VNB	4.48706e-17
C17	VGND	B#2	6.41861e-18
C18	C#1	VNB	3.22182e-17
C19	B#3	VNB	3.45061e-17
C20	VGND	A#1	7.04335e-18
C21	A#4	VNB	3.81455e-17
C22	VGND	B#5	3.98495e-19
C23	A#5	VNB	3.60867e-17
C24	VGND	VGND#3	8.83454e-18
C25	B#4	VNB	3.95415e-17
C26	A	B	1.97591e-17
C27	C#4	VNB	3.53585e-17
C28	VPWR	B#2	3.7427e-18
C29	B#1	VNB	2.32209e-17
C30	A#6	VNB	2.88624e-17
C31	a_27_368##4	VNB	4.8539e-17
C32	Y#4	VNB	8.5745e-19
C33	VPWR	B#5	6.15463e-19
C34	a_27_368##2	VNB	9.7427e-18
C35	a_306_368##2	VNB	2.76037e-18
C36	Y	B#2	2.78849e-19
C37	VPWR#4	VNB	1.53758e-18
C38	VPWR	VPWR#3	4.19272e-17
C39	a_306_368#	VNB	4.33789e-18
C40	a_27_368#	VNB	6.16572e-17
C41	VPWR	C#5	2.39389e-18
C42	Y#1	VNB	2.61516e-18
C43	VGND	C#4	6.85318e-19
C44	VGND#6	VNB	7.55196e-18
C45	C#6	VNB	7.35844e-18
C46	VPWR	C#1	1.6036e-18
C47	VGND	B#1	5.80375e-19
C48	C#7	VNB	1.41277e-18
C49	VPWR	B#3	2.72131e-18
C50	VGND	A#6	1.44809e-18
C51	A	A#1	1.79528e-17
C52	A#6	A#2	1.28638e-18
C53	VPWR	A#4	4.60894e-19
C54	A#7	VNB	4.83723e-18
C55	VGND	Y#4	1.98027e-18
C56	A	B#5	5.95313e-18
C57	VPWR	A#5	7.01276e-19
C58	VGND	a_27_368##2	4.9245e-18
C59	Y	C#5	1.10515e-17
C60	VPWR	B#4	2.64114e-18
C61	B#2	B	1.49145e-18
C62	VGND	a_27_368#	4.63539e-18
C63	Y	A#4	1.53309e-19
C64	B	A#1	3.87889e-18
C65	VGND	Y#1	1.9706e-17
C66	Y	A#5	1.86226e-19
C67	VPWR	a_27_368##4	2.07392e-17
C68	VGND	VGND#6	2.23436e-17
C69	B	B#5	2.37164e-17
C70	VPWR	Y#4	8.12319e-18
C71	VGND	C#6	3.89716e-18
C72	VPWR	a_27_368##2	2.52366e-17
C73	VPWR	a_306_368##2	1.79148e-17
C74	Y	C#4	4.81531e-17
C75	VPWR	VPWR#4	2.28498e-17
C76	VGND	A#7	1.23179e-17
C77	Y	B#1	1.59431e-18
C78	VPWR	a_306_368#	1.57367e-17
C79	VPWR	a_27_368#	1.8195e-17
C80	Y	A#6	4.4451e-19
C81	Y	a_27_368##4	3.55137e-17
C82	Y	Y#4	1.25798e-19
C83	VPWR	C#7	2.44774e-18
C84	Y	Y#2	5.01275e-18
C85	A#2	B#5	1.74053e-17
C86	Y	VGND#7	4.65157e-18
C87	Y	Y#1	1.62342e-18
C88	B#2	B#5	1.62791e-19
C89	a_27_368##4	C#2	4.31097e-20
C90	Y	C#6	5.33992e-17
C91	Y	C#7	1.47453e-17
C92	A#1	B#5	1.0138e-17
C93	VPWR#3	B#2	5.45534e-20
C94	VGND#3	A#1	1.752e-21
C95	C#2	VNB	6.48545e-17
C96	B	a_27_368#	7.96362e-17
C97	A#2	VNB	4.31569e-17
C98	A#3	VNB	2.09344e-17
C99	B#2	A#4	5.50111e-18
C100	VGND#6	B	1.81273e-17
C101	VPWR#3	C#5	4.47704e-18
C102	C#4	B#2	3.51468e-19
C103	Y#4	C#2	1.16182e-17
C104	VPWR#3	C#1	4.42504e-18
C105	VGND#3	A#3	1.11247e-19
C106	A#5	B#5	6.28655e-18
C107	A#7	B	1.97185e-17
C108	VPWR#3	B#3	5.43886e-18
C109	C#5	C#1	3.29217e-17
C110	A#6	A#1	2.14718e-17
C111	B#2	a_27_368##2	7.61555e-17
C112	a_306_368##2	B#2	4.60917e-19
C113	C#1	B#3	4.71057e-17
C114	VGND	C#2	4.18971e-19
C115	VGND	A#2	1.12616e-19
C116	VGND#3	B#1	1.21776e-18
C117	VGND#3	A#6	1.36935e-18
C118	VPWR#3	C#2	3.42331e-20
C119	B#2	a_27_368#	1.20329e-17
C120	B#3	A#4	4.19539e-17
C121	a_306_368#	A#1	6.6609e-20
C122	a_27_368##2	C#2	4.67439e-18
C123	B#2	VGND#7	1.45331e-18
C124	a_27_368#	A#1	3.29797e-19
C125	a_27_368##4	VPWR#3	4.6237e-17
C126	Y#1	B#2	4.35489e-17
C127	A#4	A#5	5.00806e-17
C128	VGND#6	B#2	1.37538e-17
C129	C#6	B#2	8.80236e-18
C130	a_27_368#	B#5	3.79431e-18
C131	a_27_368##2	VPWR#3	4.79964e-17
C132	Y#1	A#1	1.03424e-18
C133	C#7	B#2	1.28281e-17
C134	a_27_368##2	A#3	1.99902e-19
C135	a_306_368##2	VPWR#3	1.75978e-17
C136	VGND#6	A#1	1.96291e-17
C137	a_27_368##4	C#5	5.76252e-17
C138	A#5	B#4	4.86858e-17
C139	C#5	Y#4	2.29251e-17
C140	a_27_368##4	C#1	1.89447e-18
C141	a_27_368##2	C#5	6.97159e-19
C142	Y#4	C#1	5.77132e-17
C143	VGND#3	Y#1	1.60716e-17
C144	a_27_368##4	B#3	2.00227e-19
C145	A#7	A#1	2.78585e-17
C146	a_27_368##2	C#1	3.45518e-17
C147	VPWR#4	C#5	8.93119e-20
C148	Y#4	B#3	2.16766e-18
C149	a_306_368##2	C#1	1.78109e-18
C150	a_27_368##2	B#3	6.63329e-17
C151	VPWR#4	C#1	3.79321e-19
C152	A#7	B#5	2.05943e-18
C153	a_306_368##2	B#3	5.18804e-17
C154	a_27_368##2	A#4	1.30778e-17
C155	a_306_368##2	A#3	2.70359e-19
C156	VPWR#4	B#3	2.09993e-18
C157	Y	C#2	2.91974e-17
C158	a_27_368#	C#1	8.59728e-20
C159	C#4	B#1	3.89805e-18
C160	a_306_368##2	A#4	3.81348e-17
C161	Y	A#2	1.05384e-19
C162	Y	A#3	3.40333e-20
C163	A#3	A#2	7.56963e-18
C164	a_27_368##2	A#5	4.94673e-19
C165	a_306_368#	B#3	1.89876e-19
C166	A#4	VPWR#4	3.92687e-17
C167	C#5	C#2	1.06118e-18
C168	a_27_368#	B#3	1.28154e-19
C169	a_306_368##2	A#5	1.3382e-18
C170	a_27_368##2	B#4	1.0008e-19
C171	a_306_368#	A#4	4.45339e-19
C172	B#1	A#6	2.67176e-17
C173	VPWR#4	A#5	5.13106e-17
C174	a_306_368##2	B#4	1.98864e-19
C175	a_27_368#	A#4	2.17838e-19
C176	a_306_368#	A#5	3.23151e-17
C177	VPWR#4	A#2	1.34576e-19
C178	VPWR#4	B#4	2.63184e-18
C179	a_27_368#	A#5	1.26605e-17
C180	a_306_368#	B#4	5.23978e-17
C181	VPWR#4	A#3	3.95329e-19
C182	a_27_368#	B#4	4.51546e-17
C183	a_27_368##4	Y#4	6.765e-17
C184	a_27_368##4	a_27_368##2	2.34568e-18
C185	a_27_368##2	Y#4	1.00999e-16
C186	a_306_368#	A#2	1.13214e-18
C187	C#4	Y#2	6.6853e-18
C188	C#4	VGND#7	1.61531e-17
C189	a_306_368#	A#3	9.46127e-21
C190	Y#1	C#4	7.76276e-19
C191	a_27_368##2	a_306_368##2	1.20779e-16
C192	B#1	VGND#7	2.45151e-17
C193	C#2	B#3	3.1924e-18
C194	VGND#6	C#4	8.92805e-19
C195	a_27_368##2	VPWR#4	3.16212e-18
C196	Y#1	B#1	3.26161e-17
C197	C#6	C#4	2.59385e-18
C198	VGND#6	B#1	2.61848e-18
C199	a_306_368##2	VPWR#4	7.50205e-17
C200	Y#1	A#6	4.43526e-17
C201	a_27_368#	A#2	2.18705e-18
C202	a_27_368##2	a_27_368#	8.15463e-19
C203	a_306_368##2	a_306_368#	2.50307e-18
C204	A#6	VGND#6	2.71345e-17
C205	a_27_368#	A#3	2.95856e-19
C206	a_27_368#	a_306_368##2	5.88308e-18
C207	a_306_368#	VPWR#4	6.72236e-17
C208	B	A#2	2.78023e-17
C209	a_27_368#	VPWR#4	7.09125e-19
C210	Y#1	a_27_368##2	7.74724e-18
C211	a_27_368#	a_306_368#	1.28084e-16
C212	C#7	Y#4	2.95667e-17
C213	C#7	a_27_368##2	9.24343e-19
C214	C#2	VGND#7	1.35503e-18
C215	Y#1	VGND#7	2.23646e-18
C216	Y#1	C#2	8.35443e-19
C217	Y#1	VGND#6	6.45435e-17
C218	Y#1	A#3	3.77375e-18
C219	VGND#6	A#2	1.51789e-17
C220	VGND#6	A#3	1.2149e-18
C221	VGND#6	A#7	6.23719e-17
C222	C#6	C#2	9.71542e-18
C223	C#2	B#2	3.84645e-17
C224	B#2	A#2	9.02835e-19
C225	B#2	A#3	5.23728e-17
C226	C#7	C#2	1.47146e-17
C227	B#1	A#3	6.77858e-19
C228	VGND#2	A	1.9857e-17
C229	VGND#2	B#2	4.3294e-19
C230	VPWR#2	B#5	4.5797e-19
C231	VPWR#3	VPWR#2	6.256e-17
C232	VGND#2	VNB	5.18084e-17
C233	VGND#4	A#6	2.06535e-18
C234	VPWR#2	A#5	9.73738e-19
C235	VGND#4	VGND#2	1.0032e-18
C236	VGND#3	VGND#2	6.02179e-17
C237	VGND#4	VGND#6	1.84822e-18
C238	VGND#4	VNB	6.29847e-17
C239	VGND#4	C#4	1.71013e-17
C240	VGND#4	B#2	8.17652e-19
C241	VGND#2	A#7	1.71261e-17
C242	VGND#4	VGND#7	1.22862e-17
C243	a_27_368#	VPWR#2	1.94838e-17
C244	VGND#2	A#1	7.97361e-18
C245	VGND#2	A#6	3.32147e-18
C246	VPWR#2	VNB	5.40966e-17
C247	VPWR	VPWR#2	3.99994e-17
C248	B	VPWR#2	2.79683e-19
C249	VGND	VGND#2	3.94039e-17
C250	VGND#4	Y	8.75453e-17
C251	VGND#4	C#2	2.83968e-18
C252	VPWR#2	A#4	1.6038e-18
C253	VGND#3	VGND#4	6.68753e-17
C254	VPWR#2	B#4	4.57164e-18
C255	VGND	VGND#4	8.33169e-17
C256	VGND#4	B#1	2.27687e-17
C257	VGND#2	Y#1	1.79748e-18
C258	VGND#4	A#1	7.36777e-19
C259	VGND#2	B	1.26605e-18
C260	VGND#2	B#5	4.98592e-19
C261	VGND#4	Y#1	6.49413e-17
C262	VPWR#2	A#2	1.31369e-19
C263	a_306_368##2	VPWR#2	3.23038e-19
C264	a_306_368#	VPWR#2	1.87196e-17
*
*
.ENDS sky130_fd_sc_hs__nor3_2
*
