* Extracted by Quantus, converted by sky130cad/quantus.py
*
*
*
*                       LINUX           Wed Nov 18 09:02:51 2026
*
*
*
*  PROGRAM  advgen
*
*  Name           : advgen - Quantus - (64-bit)
*  Version        : 25.1.0-p047
*  Build Date     : Thu Dec 11 23:20:30 PST 2025
*
*  HSPICE LIBRARY
*
*  OPERATING_TEMPERATURE 150
*  QRC_TECH_DIR <path>/tech
*
*
*

*
.SUBCKT sky130_fd_sc_hs__o32a_2 VNB VPB VGND VPWR X B1 A1 A2 A3 B2
*
*
*  caps2d version: 10
*
*
*       TRANSISTOR CARDS
*
*
XM2 X#1 a_83_264##6 VGND#4 VNB sky130_fd_pr__nfet_01v8_lvt l=0.15 w=0.74 ad=0.2072 as=0.3404 pd=2.04 ps=2.4
XM12 VGND#7 a_83_264# X#1 VNB sky130_fd_pr__nfet_01v8_lvt l=0.15 w=0.74 ad=0.3108 as=0.2072 pd=2.32 ps=2.04
XM6 VGND#7 A1#1 a_349_74##4 VNB sky130_fd_pr__nfet_01v8_lvt l=0.15 w=0.74 ad=0.3108 as=0.2072 pd=2.32 ps=2.04
XM8 a_349_74##4 A2#1 VGND#6 VNB sky130_fd_pr__nfet_01v8_lvt l=0.15 w=0.74 ad=0.2072 as=0.3108 pd=2.04 ps=2.32
XM13 VGND#6 A3#1 a_349_74##2 VNB sky130_fd_pr__nfet_01v8_lvt l=0.15 w=0.74 ad=0.3108 as=0.259 pd=2.32 ps=2.18
XM10 a_349_74##2 B2#3 a_83_264##7 VNB sky130_fd_pr__nfet_01v8_lvt l=0.15 w=0.74 ad=0.259 as=0.6771 pd=2.18 ps=3.31
XM4 a_83_264##7 B1#1 a_349_74# VNB sky130_fd_pr__nfet_01v8_lvt l=0.15 w=0.74 ad=0.6771 as=0.2627 pd=3.31 ps=2.19
XM0 VPWR#5 a_83_264##4 X#2 VPB sky130_fd_pr__pfet_01v8 l=0.15 w=1.12 ad=0.3304 as=0.336 pd=2.83 ps=2.84
XM9 X#2 a_83_264##5 VPWR#7 VPB sky130_fd_pr__pfet_01v8 l=0.15 w=1.12 ad=0.336 as=0.5818 pd=2.84 ps=3.34
XM1 VPWR#7 A1#3 a_346_368# VPB sky130_fd_pr__pfet_01v8 l=0.15 w=1 ad=0.5818 as=0.27 pd=3.34 ps=2.54
XM11 a_346_368# A2#3 a_430_368# VPB sky130_fd_pr__pfet_01v8 l=0.15 w=1 ad=0.27 as=0.39 pd=2.54 ps=2.78
XM7 a_430_368# A3#3 a_83_264##11 VPB sky130_fd_pr__pfet_01v8 l=0.15 w=1 ad=0.39 as=0.42 pd=2.78 ps=2.84
XM3 a_83_264##11 B2#1 a_652_368# VPB sky130_fd_pr__pfet_01v8 l=0.15 w=1 ad=0.42 as=0.42 pd=2.84 ps=2.84
XM5 a_652_368# B1#3 VPWR#6 VPB sky130_fd_pr__pfet_01v8 l=0.15 w=1 ad=0.42 as=0.295 pd=2.84 ps=2.59
*
*
*       RESISTOR AND CAP/DIODE CARDS
*
Rg1	a_83_264#	a_83_264##2	359.018188
Rg2	a_83_264##2	a_83_264##3	122.376297
Rg3	a_83_264##3	a_83_264##4	549.778137
Rg4	a_83_264##2	a_83_264##5	441.658081
Rg5	a_83_264##3	a_83_264##6	340.173401
Rg6	A1#1	A1#2	382.539734
Rg7	A1#2	A1#3	405.436951
Rg8	A2#1	A2#2	382.539734
Rg9	A2#2	A2#3	400.207520
Rg10	A3#1	A3#2	382.539734
Rg11	A3#2	A3#3	400.207520
Rg12	B2#1	B2#2	400.207520
Rg13	B2#2	B2#3	382.539734
Rg14	B1#1	B1#2	292.883667
Rg15	B1#2	B1#3	675.384644
Rg16	B1#2	B1#4	215.719086
Rf1	X#1	X	94.994637
Rf2	X	X#3	13.225628
Rf3	X#3	X	0.181173
Rf4	X#2	X#3	5.000000
Rf5	A1#2	A1#5	161.760818
Rf6	A1#6	A1	1.528014
Rf7	A1#5	A1#6	5.161376
Rf8	A2	A2#2	166.137894
Rf9	A3#4	A3#2	160.996811
Rf10	A3	A3#6	0.764007
Rf11	A3#4	A3#6	5.905091
Rf12	B2#2	B2#5	161.841171
Rf13	B2#6	B2	1.608372
Rf14	B2#5	B2#6	10.390493
Rf15	a_83_264##8	a_83_264##7	39.998215
Rf16	a_83_264##8	a_83_264##9	168.960266
Rf17	a_83_264##9	a_83_264##2	316.799561
Rf18	a_83_264##9	a_83_264##11	12.722367
Rf19	a_83_264##7	a_83_264##8	15.000000
Rf20	a_349_74#	a_349_74##3	135.647415
Rf21	a_349_74##3	a_349_74##4	94.977859
Rf22	a_349_74##2	a_349_74##3	7.500000
Rf23	B1	B1#4	11.022836
Rf24	B1#4	B1	3.543054
Rf26	VPWR#2	VPWR#3	115.395248
Rf27	VPWR#3	VPWR#4	77.926674
Rf28	VPWR#4	VPWR#5	128.051514
Rf29	VPWR#2	VPWR#6	35.077789
Rf30	VPWR#4	VPWR#7	28.795341
Rf32	VGND#2	VGND#3	75.436630
Rf33	VGND#3	VGND#5	65.075981
Rf34	VGND#5	VGND#4	35.172562
Rf35	VGND#2	VGND#6	41.745289
Rf36	VGND#3	VGND#7	33.306259
Rf37	VGND#4	VGND#5	15.000000
Re1	VPWR#3	VPWR	0.982218
Re2	VGND	VGND#2	0.982254
*
*       CAPACITOR CARDS
*
*
C1	a_83_264##9	A3#3	4.70807e-17
C2	VGND	VNB	7.77767e-17
C3	VPWR	VNB	6.69936e-17
C4	X	VNB	8.53685e-18
C5	B1	VNB	9.7241e-17
C6	A1	VNB	1.49082e-18
C7	A2	VNB	3.17815e-18
C8	B2	VNB	6.26543e-18
C9	VGND	X	1.05189e-18
C10	a_83_264##2	VNB	3.17002e-17
C11	A1#2	VNB	3.01754e-17
C12	VGND	B1	6.77771e-18
C13	A2#2	VNB	2.71753e-17
C14	A3#2	VNB	3.41045e-17
C15	VPWR	X	1.75983e-17
C16	B2#2	VNB	2.67575e-17
C17	a_83_264##7	A3#1	9.20479e-19
C18	A3#6	B2#5	1.21164e-17
C19	VPWR#3	VNB	2.41045e-16
C20	VGND	A2	2.59275e-18
C21	VPWR	B1	1.65833e-17
C22	a_83_264##4	VNB	4.82215e-17
C23	a_83_264##5	VNB	3.48356e-17
C24	A1#3	VNB	2.95239e-17
C25	VPWR	A1	2.78804e-18
C26	A2#3	VNB	2.66848e-17
C27	A3#3	VNB	2.935e-17
C28	VGND	B2	2.49307e-18
C29	B2#1	VNB	2.9032e-17
C30	VPWR#4	A1#3	1.33656e-17
C31	B1#3	VNB	4.75947e-17
C32	VPWR	A2	2.51368e-18
C33	a_83_264##6	VNB	3.21975e-17
C34	a_83_264#	VNB	3.17767e-17
C35	A1#1	VNB	3.15849e-17
C36	A2#1	VNB	2.94341e-17
C37	a_349_74##2	B2#3	3.79695e-17
C38	A3#1	VNB	2.89357e-17
C39	B2#3	VNB	3.43489e-17
C40	B1#1	VNB	3.67932e-17
C41	VPWR	B2	1.84084e-18
C42	VPWR#5	VNB	8.00095e-17
C43	VPWR#6	VNB	1.66867e-17
C44	VGND#4	VNB	8.13287e-17
C45	X#1	VNB	1.22344e-17
C46	VGND#7	VNB	9.60894e-18
C47	VGND	a_83_264##2	4.72919e-18
C48	VGND#6	B1#1	2.28409e-19
C49	a_349_74##4	VNB	6.85771e-18
C50	VGND#6	VNB	2.03623e-18
C51	a_349_74##2	VNB	1.28897e-17
C52	a_83_264##7	VNB	1.12549e-17
C53	a_349_74#	VNB	3.42271e-17
C54	A1	A2	1.43121e-17
C55	A1#5	VNB	2.08389e-18
C56	a_349_74#	A3#1	3.0043e-19
C57	A3#4	VNB	9.77003e-19
C58	A3#6	VNB	1.62049e-18
C59	B2#5	VNB	2.01713e-18
C60	VPWR	a_83_264##2	7.03264e-18
C61	a_83_264##9	VNB	7.30743e-18
C62	a_83_264##9	B2#1	4.25964e-17
C63	VPWR#4	VNB	5.17001e-17
C64	a_83_264##7	B2#3	4.06492e-17
C65	VGND#3	VNB	3.09392e-17
C66	X	a_83_264##2	4.79094e-17
C67	X	A1#2	3.57294e-19
C68	a_349_74##2	B1#1	1.09006e-18
C69	VPWR	VPWR#3	2.98946e-17
C70	VGND	B1#3	1.74779e-19
C71	VGND	a_83_264##6	7.07379e-19
C72	VPWR	a_83_264##4	4.05784e-18
C73	VGND	a_83_264#	1.33689e-18
C74	VPWR#4	A2#3	2.05515e-18
C75	VPWR	a_83_264##5	3.11215e-18
C76	VGND	A1#1	1.31883e-18
C77	VGND	A2#1	2.49878e-19
C78	VPWR	A1#3	3.78685e-18
C79	VGND	A3#1	3.58036e-19
C80	a_349_74#	B2#3	7.95786e-19
C81	VPWR	A2#3	9.00216e-18
C82	VGND	B2#3	1.10069e-18
C83	a_83_264##2	A1	5.08183e-17
C84	VGND	B1#1	5.05882e-18
C85	VPWR	A3#3	7.25174e-18
C86	VGND	VPWR#5	4.07979e-18
C87	VPWR	B2#1	7.43629e-18
C88	A1	A1#2	6.76564e-18
C89	VPWR	B1#3	4.39397e-18
C90	X	a_83_264##4	3.54493e-17
C91	a_83_264##7	B1#1	4.19336e-17
C92	A1	A2#2	1.54533e-18
C93	X	a_83_264##5	3.64048e-17
C94	a_83_264##9	B1#3	2.99444e-17
C95	X	A1#3	2.18787e-18
C96	A2	A1#2	3.48021e-18
C97	X	A2#3	5.14513e-19
C98	VGND	VGND#4	4.61115e-17
C99	VGND	X#1	1.71907e-17
C100	X	A3#3	3.45929e-19
C101	A2	A2#2	1.52683e-17
C102	VGND	VGND#7	2.01054e-17
C103	VGND	a_349_74##4	1.73475e-17
C104	a_83_264##3	VNB	3.67929e-17
C105	B1#2	VNB	6.45252e-17
C106	A2	A3#2	3.00595e-18
C107	VGND	a_349_74##2	3.12714e-17
C108	VPWR	VPWR#5	3.14465e-17
C109	VGND	a_83_264##7	1.51628e-17
C110	VGND	a_349_74#	2.72521e-17
C111	a_349_74#	B1#1	3.99461e-17
C112	VGND	A1#5	3.39851e-18
C113	B1	A3#3	1.19754e-19
C114	VPWR#4	A3#3	1.18639e-18
C115	VGND	A3#4	2.79646e-18
C116	B1	B2#1	4.70597e-19
C117	A1	a_83_264##5	2.20796e-19
C118	B1	B1#3	6.19617e-18
C119	VGND	B2#5	3.06037e-18
C120	A1	A1#3	2.05839e-18
C121	A1	A2#3	6.82982e-19
C122	VPWR#5	X	1.0747e-16
C123	X	X#2	8.92839e-19
C124	X	VPWR#7	5.33444e-17
C125	a_83_264##2	a_346_368#	8.63586e-19
C126	A2	A1#3	5.04407e-19
C127	VGND	VGND#3	2.68987e-17
C128	A2	A2#3	2.04094e-18
C129	A2	A3#3	8.02098e-19
C130	X#1	X	4.9859e-18
C131	VPWR	A3#6	2.51368e-18
C132	VPWR#4	B2#1	5.12105e-19
C133	a_349_74##2	B1#2	5.83044e-19
C134	VPWR	B2#5	2.0747e-18
C135	A2#2	a_430_368#	5.29945e-19
C136	VPWR	a_83_264##9	4.03664e-17
C137	A3#6	a_83_264##9	4.2391e-17
C138	VPWR#6	B1	5.01958e-17
C139	VPWR	VPWR#4	7.01605e-17
C140	a_83_264##2	A1#2	4.00767e-17
C141	B2#2	a_652_368#	5.29945e-19
C142	B2	B1#3	1.71522e-17
C143	VGND#3	A1#5	4.12191e-19
C144	a_83_264##7	B1	6.92846e-17
C145	VPWR#4	B1#3	4.87929e-19
C146	a_349_74#	B1	3.52126e-17
C147	A1#2	A2#2	3.00777e-17
C148	B2#5	a_83_264##9	3.53889e-17
C149	A1#3	a_346_368#	2.38236e-17
C150	X	VPWR#4	3.27145e-17
C151	A2#3	a_346_368#	2.38236e-17
C152	A2#2	A3#2	2.92613e-17
C153	X#1	VGND#4	8.29064e-17
C154	A2#3	a_430_368#	2.85037e-17
C155	a_83_264##9	B1	2.71459e-17
C156	a_83_264##7	B1#2	2.59316e-17
C157	a_349_74##4	A2	4.25016e-17
C158	A3#3	a_430_368#	2.85037e-17
C159	A3#2	B2#2	2.98643e-17
C160	VGND#4	VGND#7	1.85989e-18
C161	a_83_264##4	a_83_264##2	4.33003e-18
C162	VPWR#3	A2#2	1.64442e-19
C163	a_83_264##2	a_83_264##5	5.67328e-18
C164	A1#5	A2	1.88174e-17
C165	B2#1	a_652_368#	2.97807e-17
C166	VGND	a_83_264##3	2.77603e-18
C167	VGND	B1#2	3.36799e-18
C168	a_83_264##2	A1#3	2.05991e-17
C169	B1#3	a_652_368#	3.01654e-17
C170	VPWR#3	A3#2	5.45936e-20
C171	X#1	VGND#7	6.83686e-17
C172	a_83_264##5	A1#2	2.61455e-19
C173	a_83_264##2	A2#3	6.33151e-19
C174	A2	A3#4	1.71674e-17
C175	a_83_264##2	A3#3	3.02458e-19
C176	A2	A3#6	1.30199e-17
C177	a_83_264##2	B2#1	2.22322e-19
C178	a_83_264##7	B2	4.08622e-17
C179	A2	a_83_264##9	4.03157e-17
C180	a_83_264##9	B1#2	1.70718e-18
C181	a_83_264##7	VPWR#6	1.90366e-18
C182	B1#2	a_349_74#	7.692e-18
C183	VGND#7	a_349_74##4	7.08255e-17
C184	a_83_264##3	a_83_264##2	9.71834e-18
C185	a_83_264##2	A1#1	5.1415e-19
C186	VGND#3	a_83_264#	4.74518e-18
C187	VPWR	B1#2	1.43469e-18
C188	VGND#7	VGND#6	1.31479e-18
C189	B2#2	B1#3	2.41204e-17
C190	a_349_74##4	VGND#6	6.089e-17
C191	B2	a_83_264##9	2.49831e-17
C192	VPWR#3	A2#3	6.84131e-18
C193	a_83_264##4	a_83_264##5	4.70326e-17
C194	VGND#3	A1#1	4.76531e-18
C195	VPWR#3	A3#3	4.59111e-18
C196	a_83_264##2	VPWR#7	6.16103e-17
C197	a_349_74##4	a_349_74##2	2.65318e-18
C198	a_83_264##5	A1#3	1.77897e-17
C199	a_83_264##7	a_430_368#	3.38107e-20
C200	A1#2	VPWR#7	1.58607e-18
C201	a_83_264##2	a_83_264##11	1.32599e-19
C202	X	a_83_264##3	4.94874e-18
C203	a_349_74##2	VGND#6	6.33578e-17
C204	A1#3	A2#3	5.40775e-17
C205	VGND#4	a_83_264##2	3.77461e-20
C206	a_83_264##2	X#1	4.20654e-17
C207	VGND#7	a_83_264##2	2.06845e-17
C208	A2#3	A3#3	3.3248e-17
C209	a_349_74##4	a_83_264##2	2.76206e-19
C210	VGND#7	A1#5	1.33908e-17
C211	a_83_264##9	a_346_368#	5.28373e-18
C212	VPWR#7	a_83_264##9	1.04228e-17
C213	X#1	A1#2	1.54623e-19
C214	a_349_74##2	a_83_264##7	7.75803e-17
C215	VGND#7	A1#2	3.61793e-18
C216	A3#2	a_83_264##11	5.29945e-19
C217	A3#3	B2#1	2.54969e-17
C218	a_349_74##4	A1#5	2.05567e-17
C219	B1	B1#2	3.00145e-17
C220	X#1	A2#2	1.35166e-19
C221	a_349_74##2	a_349_74#	1.45617e-18
C222	a_83_264##9	a_430_368#	9.22029e-18
C223	VPWR#3	VPWR#5	2.54254e-17
C224	a_83_264##2	A1#5	2.29565e-17
C225	a_349_74##4	A2#2	2.22432e-18
C226	B2#1	B1#3	2.7326e-17
C227	X#1	A3#2	1.02057e-19
C228	VPWR#5	VPWR#4	2.15116e-18
C229	VGND#6	A2#2	8.02726e-19
C230	a_349_74#	a_83_264##7	7.84904e-17
C231	a_83_264##9	a_652_368#	6.70931e-18
C232	a_83_264##9	VPWR#4	3.66914e-18
C233	A1#5	A1#2	1.04553e-17
C234	a_83_264##7	A2#2	1.05353e-19
C235	VGND#6	A3#2	3.73812e-19
C236	VPWR#5	a_83_264##4	3.23688e-17
C237	a_349_74##2	A3#2	3.60892e-18
C238	a_83_264##4	X#2	2.44089e-17
C239	a_83_264##7	A3#2	1.4062e-19
C240	A1#5	A2#2	2.34847e-18
C241	a_83_264##9	a_83_264##11	1.5456e-17
C242	VPWR#5	a_83_264##5	1.26546e-18
C243	a_83_264##5	X#2	2.37354e-17
C244	a_349_74##2	B2#2	5.09238e-19
C245	a_83_264##7	B2#2	3.05747e-18
C246	VPWR#4	VPWR#7	1.0829e-18
C247	a_83_264##5	VPWR#7	2.15288e-17
C248	A3#4	A2#2	2.05383e-18
C249	a_83_264##6	a_83_264#	3.77538e-17
C250	VPWR#7	A1#3	4.82979e-17
C251	A3#6	A2#2	1.4957e-18
C252	A3#4	A3#2	9.70408e-18
C253	a_83_264##9	VPWR#6	5.47893e-17
C254	VPWR#7	A2#3	3.5835e-18
C255	B2#2	B1#2	3.59553e-19
C256	a_83_264#	A1#1	2.27879e-17
C257	a_83_264##2	VPWR#4	7.76275e-19
C258	a_349_74##2	A3#4	4.24525e-17
C259	A3#6	A3#2	5.89104e-18
C260	VPWR#7	A3#3	1.77849e-18
C261	B2#5	A3#2	3.92593e-18
C262	A3#4	B2#2	2.74955e-18
C263	VGND#3	a_83_264##2	4.75039e-19
C264	a_83_264##9	A2#2	2.07911e-18
C265	A1#1	A2#1	3.81745e-17
C266	VPWR#6	A1#3	3.82333e-19
C267	A3#6	B2#2	9.38406e-19
C268	B2#5	B2#2	2.49449e-17
C269	VPWR#6	B1#2	1.57969e-18
C270	A3#3	a_83_264##11	2.5206e-17
C271	a_83_264##9	A3#2	2.49024e-18
C272	VPWR#6	A2#3	3.74499e-19
C273	A2#1	A3#1	2.18993e-17
C274	B2#1	a_83_264##11	7.03137e-18
C275	VPWR#4	a_83_264##3	6.47435e-20
C276	VPWR#6	A3#3	1.87797e-18
C277	a_349_74##2	B2#5	3.17605e-18
C278	a_83_264##9	B2#2	2.07911e-18
C279	A3#1	B2#3	2.82926e-17
C280	VGND#4	a_83_264##3	2.75153e-18
C281	VPWR#6	B2#1	4.95793e-18
C282	a_83_264##7	B2#5	1.20619e-17
C283	a_349_74##4	a_83_264##9	6.60996e-18
C284	VPWR#6	B1#3	3.49492e-17
C285	B2#3	B1#1	2.91179e-18
C286	a_83_264##7	A2#3	2.22374e-19
C287	X#1	a_83_264##3	1.72872e-17
C288	a_83_264##7	A3#3	3.00535e-19
C289	a_83_264##9	VPWR#3	2.28329e-17
C290	a_349_74##2	a_83_264##9	1.21967e-17
C291	a_83_264##6	VGND#4	2.66112e-17
C292	X#1	a_83_264##6	4.89815e-17
C293	VGND#4	VGND#3	9.45154e-19
C294	a_83_264##7	B2#1	7.79407e-19
C295	VGND#4	a_83_264#	1.37228e-18
C296	a_83_264##7	a_83_264##9	4.1487e-18
C297	a_349_74##2	B1#3	2.37343e-19
C298	VGND#7	a_83_264##6	1.48368e-18
C299	X#1	a_83_264#	4.77511e-17
C300	a_83_264##7	B1#3	1.08302e-17
C301	VGND#4	A1#1	3.0286e-19
C302	VGND#3	X#1	8.67788e-18
C303	a_83_264#	VGND#7	2.75987e-17
C304	a_349_74#	B1#3	3.22787e-19
C305	VPWR#3	VPWR#4	5.67351e-17
C306	X#1	A1#1	2.47397e-19
C307	A1#1	VGND#7	2.27564e-17
C308	X#1	A2#1	1.10386e-19
C309	VGND#6	a_83_264#	1.09125e-19
C310	A3#6	A2#3	3.88406e-19
C311	a_83_264##9	a_83_264##5	4.15284e-19
C312	a_349_74##4	A1#1	3.89101e-17
C313	VGND#7	A2#1	7.57597e-19
C314	X#1	A3#1	8.33468e-20
C315	VGND#6	A1#1	4.26514e-19
C316	A3#6	A3#3	2.0006e-18
C317	a_349_74##4	A2#1	5.9781e-17
C318	a_83_264##9	A1#3	2.08679e-18
C319	VGND#3	a_349_74##4	8.48245e-18
C320	VGND#7	A3#1	2.8808e-19
C321	VPWR#4	a_83_264##4	3.5619e-18
C322	B2#5	A3#3	4.33726e-19
C323	A2#1	VGND#6	2.32874e-17
C324	A3#4	B2#5	1.60074e-17
C325	a_349_74##4	A3#1	5.46317e-19
C326	A3#6	B2#1	7.71094e-19
C327	a_349_74##2	A2#1	5.46317e-19
C328	a_83_264##9	A2#3	2.85215e-17
C329	VGND#4	VPWR#5	1.07164e-17
C330	A3#1	VGND#6	2.02443e-17
C331	B2#5	B2#1	2.05553e-18
C332	B2#3	B1#2	3.91593e-19
C333	VPWR#4	a_83_264##5	1.37274e-17
C334	a_83_264##7	A2#1	8.60382e-20
C335	a_349_74##2	A3#1	5.5363e-17
C336	VGND#6	B2#3	4.46366e-19
C337	VGND#7	VGND#2	5.00495e-19
C338	a_83_264##9	VPWR#2	2.75611e-18
C339	VGND#2	B2#3	6.15588e-18
C340	B1	VPWR#2	1.61008e-17
C341	VGND#2	a_349_74#	4.53838e-17
C342	VPWR#2	VNB	6.68718e-17
C343	VPWR#2	B1#2	1.2122e-18
C344	VGND#2	B2#2	8.84118e-20
C345	VGND#2	A3#1	5.84979e-18
C346	VGND#2	B1#3	1.0448e-19
C347	VGND	VGND#2	9.39544e-17
C348	VPWR#2	B1#3	3.26973e-18
C349	VGND#2	VGND#4	3.92116e-17
C350	VGND#2	A3#2	5.66743e-20
C351	VGND#2	A2#1	5.86243e-18
C352	VGND#2	a_349_74##2	4.50974e-17
C353	VGND#2	VGND#3	4.14761e-17
C354	VGND#2	B1#2	8.01851e-19
C355	VGND#2	A1#1	9.38173e-19
C356	VPWR#3	VPWR#2	6.97823e-17
C357	VGND#2	VNB	3.06763e-16
C358	VPWR#2	B2#1	4.20503e-18
C359	VGND#2	a_83_264#	1.78955e-19
C360	VGND#2	B1	1.32876e-18
C361	VGND#2	a_349_74##4	8.6585e-18
C362	VPWR#2	B2#2	1.64442e-19
C363	VGND#2	B1#1	5.6311e-18
C364	VPWR	VPWR#2	7.11305e-17
*
*
.ENDS sky130_fd_sc_hs__o32a_2
*
