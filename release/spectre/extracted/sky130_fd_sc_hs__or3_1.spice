* Extracted by Quantus, converted by sky130cad/quantus.py
*
*
*
*                       LINUX           Wed Nov 18 09:06:10 2026
*
*
*
*  PROGRAM  advgen
*
*  Name           : advgen - Quantus - (64-bit)
*  Version        : 25.1.0-p047
*  Build Date     : Thu Dec 11 23:20:30 PST 2025
*
*  HSPICE LIBRARY
*
*  OPERATING_TEMPERATURE 150
*  QRC_TECH_DIR <path>/tech
*
*
*

*
.SUBCKT sky130_fd_sc_hs__or3_1 VNB VPB VGND VPWR X C B A
*
*
*  caps2d version: 10
*
*
*       TRANSISTOR CARDS
*
*
XM7 a_27_74##6 C#3 VGND#7 VNB sky130_fd_pr__nfet_01v8_lvt l=0.15 w=0.55 ad=0.15675 as=0.1925 pd=1.67 ps=1.8
XM5 VGND#7 B#1 a_27_74##4 VNB sky130_fd_pr__nfet_01v8_lvt l=0.15 w=0.55 ad=0.1925 as=0.36575 pd=1.8 ps=2.43
XM3 a_27_74##4 A#1 VGND#6 VNB sky130_fd_pr__nfet_01v8_lvt l=0.15 w=0.55 ad=0.36575 as=0.2785 pd=2.43 ps=2.32
XM1 VGND#6 a_27_74# X#2 VNB sky130_fd_pr__nfet_01v8_lvt l=0.15 w=0.74 ad=0.2785 as=0.2109 pd=2.32 ps=2.05
XM0 a_27_74##8 C#1 a_116_368# VPB sky130_fd_pr__pfet_01v8 l=0.15 w=1 ad=0.295 as=0.27 pd=2.59 ps=2.54
XM4 a_116_368# B#3 a_200_368# VPB sky130_fd_pr__pfet_01v8 l=0.15 w=1 ad=0.27 as=0.42 pd=2.54 ps=2.84
XM6 a_200_368# A#3 VPWR#4 VPB sky130_fd_pr__pfet_01v8 l=0.15 w=1 ad=0.42 as=0.7618 pd=2.84 ps=3.7
XM2 VPWR#4 a_27_74##3 X#1 VPB sky130_fd_pr__pfet_01v8 l=0.15 w=1.12 ad=0.7618 as=0.3304 pd=3.7 ps=2.83
*
*
*       RESISTOR AND CAP/DIODE CARDS
*
Rg1	C#1	C#2	405.685516
Rg2	C#2	C#3	437.056641
Rg3	B#1	B#2	449.475250
Rg4	B#2	B#3	416.564545
Rg5	A#1	A#2	454.926544
Rg6	A#2	A#3	417.171356
Rg7	a_27_74#	a_27_74##2	352.702850
Rg8	a_27_74##2	a_27_74##3	455.703033
Rf1	C#4	C	2.217604
Rf2	C#2	C#6	162.450409
Rf3	C#4	C#6	5.042445
Rf4	B#2	B#5	162.294235
Rf5	B#6	B	2.061435
Rf6	B#5	B#6	6.112055
Rf7	A#2	A	166.137894
Rf8	a_27_74##4	a_27_74##5	14.787436
Rf9	a_27_74##5	a_27_74##6	117.661018
Rf10	a_27_74##5	a_27_74##7	72.608459
Rf11	a_27_74##7	a_27_74##8	184.677460
Rf12	X#1	X	94.842651
Rf13	X	X#3	6.615660
Rf14	X#3	X	6.615660
Rf15	X#2	X#3	7.500000
Rf17	VPWR#2	VPWR#3	36.272724
Rf18	VPWR#2	VPWR#4	16.065693
Rf20	VGND#2	VGND#3	47.823540
Rf21	VGND#3	VGND#4	53.302330
Rf23	VGND#2	VGND#6	37.066368
Rf24	VGND#4	VGND#7	37.066368
Rf28	a_27_74##2	a_27_74##7	160.232803
Re1	VPWR#3	VPWR	1.637070
Re2	VGND	VGND#3	1.637131
*
*       CAPACITOR CARDS
*
*
C1	a_27_74##5	B#5	2.92185e-17
C2	VGND	VNB	5.37143e-17
C3	VPWR	VNB	5.82764e-17
C4	X	VNB	1.50867e-17
C5	C	VNB	2.29634e-17
C6	B	VNB	2.24037e-18
C7	A	VNB	4.9647e-18
C8	C#2	VNB	5.76052e-17
C9	B#2	VNB	4.07655e-17
C10	A#2	VNB	4.69081e-17
C11	VGND	X	2.02758e-17
C12	a_27_74##2	VNB	4.33061e-17
C13	VGND#3	VNB	1.58819e-16
C14	VPWR#3	VNB	1.98673e-16
C15	VGND	C	1.61153e-18
C16	C#1	VNB	4.35689e-17
C17	B#3	VNB	2.7236e-17
C18	VGND	B	1.71138e-18
C19	A#3	VNB	3.1267e-17
C20	a_27_74##3	VNB	4.12874e-17
C21	VPWR	C	1.55245e-18
C22	VGND	A	2.5755e-18
C23	C#3	VNB	3.45609e-17
C24	B#1	VNB	2.9645e-17
C25	A#1	VNB	3.18017e-17
C26	a_27_74#	VNB	3.15725e-17
C27	VPWR	B	1.64068e-18
C28	a_27_74##8	VNB	4.58614e-17
C29	VPWR#4	VNB	6.36396e-18
C30	VPWR	A	2.48302e-18
C31	X#1	VNB	6.06526e-17
C32	a_27_74##6	VNB	4.43555e-17
C33	VGND#7	VNB	2.03801e-18
C34	VGND#6	VNB	2.646e-18
C35	X#2	VNB	4.6788e-17
C36	VGND	C#2	1.5587e-18
C37	B#5	VNB	1.39564e-18
C38	a_27_74##5	VNB	1.11033e-17
C39	VGND	a_27_74##2	4.5267e-18
C40	VGND	VGND#3	1.57658e-17
C41	VPWR	C#2	1.47411e-18
C42	B	A	3.71953e-17
C43	VPWR	a_27_74##2	9.11613e-18
C44	VPWR	VPWR#3	4.47344e-17
C45	VGND	C#3	1.6266e-18
C46	C	C#2	1.10746e-17
C47	VGND	B#1	2.66354e-19
C48	VPWR	C#1	9.40193e-18
C49	VGND	A#1	2.66354e-19
C50	VGND	a_27_74#	2.149e-18
C51	VPWR	B#3	9.00216e-18
C52	VPWR	A#3	3.87163e-18
C53	VPWR	a_27_74##3	3.9858e-18
C54	B	B#2	5.89203e-18
C55	VGND	X#1	1.14073e-18
C56	VGND	a_27_74##6	1.40239e-17
C57	B	A#2	5.45108e-18
C58	A	B#2	2.06087e-18
C59	VPWR	a_27_74##8	2.64546e-17
C60	A	A#2	1.87897e-17
C61	VGND	B#5	1.76316e-18
C62	A	a_27_74##2	6.61012e-17
C63	VPWR	X#1	1.74037e-17
C64	X	A#1	6.96048e-19
C65	VGND	a_27_74##5	2.78823e-17
C66	X	a_27_74#	1.07803e-17
C67	B#2	a_200_368#	5.2629e-19
C68	B	A#3	1.28161e-18
C69	VPWR	B#5	1.69059e-18
C70	A	B#3	1.23712e-19
C71	C	a_27_74##8	1.9048e-17
C72	a_27_74##2	a_200_368#	1.59798e-19
C73	A	A#3	2.22204e-18
C74	C#2	B#2	3.38339e-17
C75	A	a_27_74##3	9.31286e-19
C76	VGND#6	X	2.14567e-17
C77	X	X#2	1.05516e-18
C78	C#1	a_116_368#	2.4664e-17
C79	B	a_27_74##8	2.59987e-17
C80	a_27_74##6	C	1.81983e-17
C81	a_27_74##2	C#2	1.19183e-19
C82	B#3	a_116_368#	2.3859e-17
C83	B#2	A#2	2.48759e-17
C84	a_27_74##2	B#2	2.33771e-19
C85	B#3	a_200_368#	2.92558e-17
C86	VPWR#3	C#2	6.42603e-20
C87	VGND#3	B#2	5.00544e-20
C88	A#2	a_27_74##2	4.10562e-17
C89	A#3	a_200_368#	2.92558e-17
C90	VPWR#3	B#2	1.62629e-19
C91	VGND#3	A#2	1.53355e-19
C92	C#2	C#1	4.13686e-18
C93	C#2	B#3	7.38518e-19
C94	a_27_74##2	VPWR#3	6.27637e-19
C95	a_27_74##8	a_116_368#	6.03698e-18
C96	a_27_74##8	a_200_368#	7.93422e-18
C97	a_27_74##2	C#1	1.45042e-19
C98	a_27_74##5	B	2.82065e-17
C99	X#1	a_116_368#	7.83376e-22
C100	a_27_74##2	B#3	2.28715e-19
C101	A#2	a_27_74##3	2.5795e-19
C102	a_27_74##2	A#3	2.86521e-17
C103	VPWR#3	C#1	4.64866e-18
C104	a_27_74##5	A	3.86605e-17
C105	a_27_74##2	a_27_74##3	8.97074e-18
C106	C#2	a_27_74##8	3.08171e-17
C107	VPWR#3	B#3	6.84131e-18
C108	VPWR#3	A#3	4.44685e-18
C109	a_27_74##8	B#2	1.9916e-18
C110	C#1	B#3	5.83259e-17
C111	A#2	a_27_74#	1.74683e-18
C112	a_27_74##6	C#2	2.73055e-17
C113	a_27_74##2	a_27_74#	5.13447e-18
C114	B#3	A#3	3.01485e-17
C115	a_27_74##2	a_27_74##8	4.05424e-22
C116	A#2	VPWR#4	2.76714e-18
C117	VGND#7	B#2	4.71698e-19
C118	X#1	A#2	2.1668e-20
C119	A#3	a_27_74##3	8.24779e-18
C120	a_27_74##2	VPWR#4	7.95056e-17
C121	a_27_74##8	VPWR#3	1.99323e-17
C122	a_27_74##2	X#1	3.23863e-17
C123	C#2	B#5	3.17535e-17
C124	X#2	A#2	1.01572e-19
C125	a_27_74##8	C#1	6.02095e-17
C126	B#5	B#2	1.25735e-17
C127	a_27_74##2	VGND#6	2.3302e-17
C128	a_27_74##5	C#2	1.07123e-17
C129	a_27_74##2	X#2	6.48324e-17
C130	a_27_74##8	B#3	3.18082e-17
C131	a_27_74##8	A#3	3.26646e-18
C132	VPWR#4	C#1	2.79327e-18
C133	a_27_74##5	B#2	1.35756e-17
C134	C#3	B#1	2.41293e-17
C135	X#1	C#1	2.7761e-19
C136	a_27_74##8	a_27_74##3	4.39956e-19
C137	VPWR#4	B#3	5.46079e-18
C138	a_27_74##5	A#2	2.01765e-17
C139	X#1	B#3	2.60699e-19
C140	B#1	A#1	8.8227e-18
C141	VPWR#4	A#3	6.44816e-17
C142	X#1	A#3	1.42584e-18
C143	VPWR#4	a_27_74##3	5.81519e-17
C144	a_27_74##5	a_27_74##2	5.93697e-18
C145	A#1	a_27_74#	2.12676e-17
C146	X#1	a_27_74##3	2.86532e-17
C147	VGND#3	a_27_74##5	2.13015e-17
C148	B#5	C#1	3.94733e-20
C149	a_27_74##6	C#3	2.23708e-17
C150	VGND#7	C#3	2.91177e-17
C151	B#5	B#3	2.33891e-18
C152	a_27_74##6	B#1	9.82118e-19
C153	B#1	VGND#7	1.45434e-17
C154	VGND#6	C#3	4.66657e-19
C155	a_27_74##8	VPWR#4	1.23916e-17
C156	B#1	a_27_74##4	1.72065e-17
C157	VGND#7	A#1	7.86615e-19
C158	VGND#6	B#1	7.86615e-19
C159	A#1	a_27_74##4	1.72065e-17
C160	VGND#7	a_27_74#	4.66026e-19
C161	a_27_74##6	a_27_74##8	3.1685e-19
C162	A#1	VGND#6	2.08272e-17
C163	X#2	A#1	1.61991e-18
C164	a_27_74#	VGND#6	2.07331e-17
C165	VPWR#4	X#1	5.59157e-17
C166	X#2	a_27_74#	2.47542e-17
C167	a_27_74##5	C#3	4.98412e-18
C168	a_27_74##6	VGND#7	4.30145e-17
C169	a_27_74##5	B#1	3.40252e-17
C170	B#5	a_27_74##8	2.72729e-17
C171	a_27_74##5	A#1	3.99891e-17
C172	X#2	X#1	2.31386e-18
C173	a_27_74##5	a_27_74#	1.22539e-18
C174	VGND#7	VGND#6	2.61724e-18
C175	a_27_74##5	a_27_74##8	5.0448e-18
C176	VGND#6	X#2	2.68155e-17
C177	a_27_74##6	a_27_74##5	3.526e-18
C178	VGND#7	a_27_74##5	6.10297e-17
C179	a_27_74##5	a_27_74##4	7.65938e-18
C180	a_27_74##5	VGND#6	4.14089e-17
C181	a_27_74##5	X#2	3.76507e-18
C182	VGND#4	a_27_74##6	1.7841e-17
C183	VPWR#2	a_27_74##3	8.57748e-18
C184	VGND#4	a_27_74#	1.53233e-19
C185	VGND#4	B#1	5.97044e-18
C186	VPWR#3	VPWR#2	5.82104e-17
C187	VGND#4	VGND#2	6.86597e-19
C188	VGND#3	VGND#2	5.01284e-17
C189	VGND#2	a_27_74#	8.16765e-18
C190	VGND#2	B#1	6.92385e-19
C191	a_27_74##2	VPWR#2	4.5031e-19
C192	VGND#2	a_27_74##5	1.51641e-18
C193	VGND#4	A#1	6.92385e-19
C194	VGND#4	C#3	4.92477e-18
C195	VGND#3	VGND#4	4.86554e-17
C196	VGND#2	X	2.2606e-17
C197	VPWR#2	VNB	5.35988e-17
C198	VGND#2	a_27_74##2	4.41816e-19
C199	VGND#4	C#2	9.02254e-20
C200	VGND	VGND#2	5.4809e-17
C201	X#1	VPWR#2	1.91172e-17
C202	VGND#2	A#1	5.994e-18
C203	VGND#4	a_27_74##5	2.69059e-18
C204	VPWR	VPWR#2	8.71942e-17
C205	VGND#2	VNB	4.6741e-17
C206	VGND#2	C#3	1.5223e-19
C207	VGND	VGND#4	5.19681e-17
C208	VGND#4	VNB	4.57974e-17
*
*
.ENDS sky130_fd_sc_hs__or3_1
*
