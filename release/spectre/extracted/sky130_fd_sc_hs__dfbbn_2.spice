* Extracted by Quantus, converted by sky130cad/quantus.py
*
*
*
*                       LINUX           Wed Nov 18 08:26:02 2026
*
*
*
*  PROGRAM  advgen
*
*  Name           : advgen - Quantus - (64-bit)
*  Version        : 25.1.0-p047
*  Build Date     : Thu Dec 11 23:20:30 PST 2025
*
*  HSPICE LIBRARY
*
*  OPERATING_TEMPERATURE 150
*  QRC_TECH_DIR <path>/tech
*
*
*

*
.SUBCKT sky130_fd_sc_hs__dfbbn_2 VPB VNB VGND SET_B VPWR Q Q_N D CLK_N RESET_B
*
*
*  caps2d version: 10
*
*
*       TRANSISTOR CARDS
*
*
XM41 a_27_74##12 CLK_N#3 VGND#19 VNB sky130_fd_pr__nfet_01v8_lvt l=0.15 w=0.74 ad=0.2109 as=0.2072 pd=2.05 ps=2.04
XM14 VGND#19 a_27_74##4 a_200_74##14 VNB sky130_fd_pr__nfet_01v8_lvt l=0.15 w=0.74 ad=0.2072 as=0.2109 pd=2.04 ps=2.05
XM25 a_311_119##4 D#3 VGND#18 VNB sky130_fd_pr__nfet_01v8_lvt l=0.15 w=0.42 ad=0.1197 as=0.267125 pd=1.41 ps=2.16
XM3 VGND#18 a_473_405# a_529_119# VNB sky130_fd_pr__nfet_01v8_lvt l=0.15 w=0.42 ad=0.267125 as=0.0882 pd=2.16 ps=1.26
XM22 a_529_119# a_27_74##2 a_601_119##7 VNB sky130_fd_pr__nfet_01v8_lvt l=0.15 w=0.42 ad=0.0882 as=0.1176 pd=1.26 ps=1.4
XM19 a_601_119##7 a_200_74##3 a_311_119##2 VNB sky130_fd_pr__nfet_01v8_lvt l=0.15 w=0.42 ad=0.1176 as=0.38115 pd=1.4 ps=2.52
XM43 a_867_125##2 a_601_119# a_473_405##14 VNB sky130_fd_pr__nfet_01v8_lvt l=0.15 w=0.55 ad=0.15675 as=0.154 pd=1.67 ps=1.66
XM42 a_473_405##14 a_975_322# a_867_125# VNB sky130_fd_pr__nfet_01v8_lvt l=0.15 w=0.55 ad=0.154 as=0.1925 pd=1.66 ps=1.8
XM11 a_867_125# SET_B#1 VGND#17 VNB sky130_fd_pr__nfet_01v8_lvt l=0.15 w=0.55 ad=0.1925 as=0.1925 pd=1.8 ps=1.8
XM23 VGND#17 a_473_405##6 a_1240_125# VNB sky130_fd_pr__nfet_01v8_lvt l=0.15 w=0.55 ad=0.1925 as=0.190125 pd=1.8 ps=1.88
XM1 a_1240_125# a_27_74##5 a_1335_112##6 VNB sky130_fd_pr__nfet_01v8_lvt l=0.15 w=0.55 ad=0.190125 as=0.61 pd=1.88 ps=3.85
XM24 a_1335_112##6 a_200_74##7 a_1640_138# VNB sky130_fd_pr__nfet_01v8_lvt l=0.15 w=0.42 ad=0.61 as=0.1008 pd=3.85 ps=1.32
XM13 a_1640_138# a_1555_410# VGND#16 VNB sky130_fd_pr__nfet_01v8_lvt l=0.15 w=0.42 ad=0.1008 as=0.2676 pd=1.32 ps=2.32
XM9 VGND#16 SET_B#4 a_1832_74##2 VNB sky130_fd_pr__nfet_01v8_lvt l=0.15 w=0.74 ad=0.2676 as=0.2072 pd=2.32 ps=2.04
XM38 a_1832_74##2 a_975_322##6 a_1555_410##13 VNB sky130_fd_pr__nfet_01v8_lvt l=0.15 w=0.74 ad=0.2072 as=0.2368 pd=2.04 ps=2.12
XM17 a_1555_410##13 a_1335_112##3 a_1832_74# VNB sky130_fd_pr__nfet_01v8_lvt l=0.15 w=0.74 ad=0.2368 as=0.2907 pd=2.12 ps=2.39
XM26 a_975_322##7 RESET_B#3 VGND#15 VNB sky130_fd_pr__nfet_01v8_lvt l=0.15 w=0.42 ad=0.1176 as=0.47475 pd=1.4 ps=4.02
XM5 Q_N#2 a_1555_410##11 VGND#15 VNB sky130_fd_pr__nfet_01v8_lvt l=0.15 w=0.74 ad=0.2072 as=0.47475 pd=2.04 ps=4.02
XM32 VGND#14 a_1555_410##9 Q_N#2 VNB sky130_fd_pr__nfet_01v8_lvt l=0.15 w=0.74 ad=0.222 as=0.2072 pd=2.08 ps=2.04
XM33 a_2516_368##10 a_1555_410##4 VGND#13 VNB sky130_fd_pr__nfet_01v8_lvt l=0.15 w=0.64 ad=0.1824 as=0.233 pd=1.85 ps=2.13
XM2 Q#3 a_2516_368##5 VGND#13 VNB sky130_fd_pr__nfet_01v8_lvt l=0.15 w=0.74 ad=0.2072 as=0.233 pd=2.04 ps=2.13
XM7 VGND#1 a_2516_368# Q#3 VNB sky130_fd_pr__nfet_01v8_lvt l=0.15 w=0.74 ad=0.1998 as=0.2072 pd=2.02 ps=2.04
XM20 a_27_74##11 CLK_N#1 VPWR#23 VPB sky130_fd_pr__pfet_01v8 l=0.15 w=1.12 ad=0.3192 as=0.336 pd=2.81 ps=2.84
XM0 VPWR#23 a_27_74##8 a_200_74##12 VPB sky130_fd_pr__pfet_01v8 l=0.15 w=1.12 ad=0.336 as=0.3136 pd=2.84 ps=2.8
XM6 a_311_119##6 D#1 VPWR#22 VPB sky130_fd_pr__pfet_01v8 l=0.15 w=0.42 ad=0.17805 as=0.1869 pd=1.75 ps=1.73
XM16 VPWR#22 a_473_405##3 a_536_503# VPB sky130_fd_pr__pfet_01v8 l=0.15 w=0.42 ad=0.1869 as=0.1134 pd=1.73 ps=1.38
XM27 a_536_503# a_200_74# a_601_119##5 VPB sky130_fd_pr__pfet_01v8 l=0.15 w=0.42 ad=0.1134 as=0.1512 pd=1.38 ps=1.56
XM18 a_601_119##5 a_27_74# a_311_119# VPB sky130_fd_pr__pfet_01v8 l=0.15 w=0.42 ad=0.1512 as=0.1653 pd=1.56 ps=1.7
XM28 a_473_405##10 a_601_119##4 a_930_424# VPB sky130_fd_pr__pfet_01v8 l=0.15 w=0.84 ad=0.2352 as=0.2268 pd=2.24 ps=2.22
XM10 a_930_424# a_975_322##3 VPWR#21 VPB sky130_fd_pr__pfet_01v8 l=0.15 w=0.84 ad=0.2268 as=0.3024 pd=2.22 ps=2.4
XM30 VPWR#21 SET_B#3 a_473_405##13 VPB sky130_fd_pr__pfet_01v8 l=0.15 w=0.84 ad=0.3024 as=0.2352 pd=2.4 ps=2.24
XM35 VPWR#20 a_473_405##4 a_1312_424# VPB sky130_fd_pr__pfet_01v8 l=0.15 w=0.84 ad=0.2352 as=0.2268 pd=2.24 ps=2.22
XM40 a_1312_424# a_200_74##5 a_1335_112##7 VPB sky130_fd_pr__pfet_01v8 l=0.15 w=0.84 ad=0.2268 as=0.2877 pd=2.22 ps=2.46
XM15 a_1335_112##7 a_27_74##6 a_1504_508# VPB sky130_fd_pr__pfet_01v8 l=0.15 w=0.42 ad=0.2877 as=0.1134 pd=2.46 ps=1.38
XM21 a_1504_508# a_1555_410##3 VPWR#19 VPB sky130_fd_pr__pfet_01v8 l=0.15 w=0.42 ad=0.1134 as=0.22775 pd=1.38 ps=2.07
XM34 a_1555_410##17 SET_B#6 VPWR#18 VPB sky130_fd_pr__pfet_01v8 l=0.15 w=1 ad=0.295 as=0.53815 pd=2.59 ps=3.41
XM29 VPWR#18 a_975_322##4 a_1931_392# VPB sky130_fd_pr__pfet_01v8 l=0.15 w=1 ad=0.53815 as=0.27 pd=3.41 ps=2.54
XM8 a_1931_392# a_1335_112# a_1555_410##15 VPB sky130_fd_pr__pfet_01v8 l=0.15 w=1 ad=0.27 as=0.28 pd=2.54 ps=2.56
XM39 a_975_322##11 RESET_B#1 VPWR#17 VPB sky130_fd_pr__pfet_01v8 l=0.15 w=0.64 ad=0.1792 as=0.3768 pd=1.84 ps=2.99
XM31 Q_N#1 a_1555_410##12 VPWR#17 VPB sky130_fd_pr__pfet_01v8 l=0.15 w=1.12 ad=0.336 as=0.3768 pd=2.84 ps=2.99
XM4 VPWR#16 a_1555_410##10 Q_N#1 VPB sky130_fd_pr__pfet_01v8 l=0.15 w=1.12 ad=0.3136 as=0.336 pd=2.8 ps=2.84
XM36 a_2516_368##9 a_1555_410##8 VPWR#15 VPB sky130_fd_pr__pfet_01v8 l=0.15 w=1 ad=0.28 as=0.4036 pd=2.56 ps=2.98
XM12 VPWR#15 a_2516_368##6 Q#1 VPB sky130_fd_pr__pfet_01v8 l=0.15 w=1.12 ad=0.4036 as=0.336 pd=2.98 ps=2.84
XM37 Q#1 a_2516_368##4 VPWR#1 VPB sky130_fd_pr__pfet_01v8 l=0.15 w=1.12 ad=0.336 as=0.3192 pd=2.84 ps=2.81
*
*
*       RESISTOR AND CAP/DIODE CARDS
*
Rg1	CLK_N#1	CLK_N#2	448.815094
Rg2	CLK_N#2	CLK_N#3	345.814911
Rg3	D#1	D#2	611.648071
Rg4	D#2	D#3	280.752472
Rg5	a_473_405#	a_473_405##2	732.595520
Rg6	a_473_405##2	a_473_405##3	233.787552
Rg7	a_200_74#	a_200_74##2	233.787552
Rg8	a_200_74##3	a_200_74##4	216.119781
Rg9	a_601_119#	a_601_119##2	362.464844
Rg10	a_601_119##2	a_601_119##3	95.564819
Rg11	a_601_119##2	a_601_119##4	441.960724
Rg12	a_975_322#	a_975_322##2	439.925964
Rg13	a_975_322##2	a_975_322##3	363.181610
Rg14	SET_B#1	SET_B#2	451.403168
Rg15	SET_B#2	SET_B#3	354.298584
Rg16	a_473_405##4	a_473_405##5	390.871368
Rg17	a_473_405##5	a_473_405##6	478.256561
Rg18	a_200_74##5	a_200_74##6	376.506195
Rg19	a_27_74#	a_27_74##2	1247.607666
Rg20	a_27_74##2	a_27_74##3	322.957550
Rg21	a_27_74##3	a_27_74##4	1399.995239
Rg22	a_27_74##3	a_27_74##5	2409.992432
Rg23	a_27_74##5	a_27_74##6	1352.977783
Rg24	a_27_74##4	a_27_74##7	353.846649
Rg25	a_27_74##7	a_27_74##8	456.846832
Rg26	a_200_74##7	a_200_74##8	268.456512
Rg27	a_1555_410#	a_1555_410##2	724.553955
Rg28	a_1555_410##2	a_1555_410##3	266.904297
Rg29	SET_B#4	SET_B#5	439.925934
Rg30	SET_B#5	SET_B#6	409.090576
Rg31	a_975_322##4	a_975_322##5	518.009277
Rg32	a_975_322##5	a_975_322##6	320.356293
Rg33	a_1335_112#	a_1335_112##2	400.207520
Rg34	a_1335_112##2	a_1335_112##3	451.403168
Rg35	RESET_B#1	RESET_B#2	296.912354
Rg36	RESET_B#2	RESET_B#3	216.119781
Rg37	a_1555_410##4	a_1555_410##5	446.438995
Rg38	a_1555_410##5	a_1555_410##6	186.467041
Rg39	a_1555_410##6	a_1555_410##7	83.451691
Rg40	a_1555_410##5	a_1555_410##8	418.990204
Rg41	a_1555_410##6	a_1555_410##9	326.451965
Rg42	a_1555_410##6	a_1555_410##10	450.571655
Rg43	a_1555_410##7	a_1555_410##11	325.600159
Rg44	a_1555_410##7	a_1555_410##12	435.120483
Rg45	a_2516_368#	a_2516_368##2	351.646759
Rg46	a_2516_368##2	a_2516_368##3	56.190357
Rg47	a_2516_368##2	a_2516_368##4	485.187408
Rg48	a_2516_368##3	a_2516_368##5	355.147949
Rg49	a_2516_368##3	a_2516_368##6	483.380493
Rf1	CLK_N#4	CLK_N#2	161.469666
Rf2	CLK_N	CLK_N#6	1.236861
Rf3	CLK_N#4	CLK_N#6	7.059660
Rf4	a_27_74##7	a_27_74##10	165.173401
Rf5	a_27_74##10	a_27_74##11	87.301407
Rf6	a_27_74##10	a_27_74##12	80.905365
Rf7	D	D#2	161.807495
Rf8	a_200_74##4	a_200_74##10	170.691376
Rf9	a_200_74##10	a_200_74##11	27.133429
Rf10	a_200_74##11	a_200_74##13	219.123322
Rf11	a_200_74##13	a_200_74##14	95.320961
Rf12	a_200_74##11	a_200_74##2	181.493515
Rf13	a_200_74##12	a_200_74##13	5.000000
Rf14	a_601_119##5	a_601_119##6	112.751656
Rf15	a_601_119##6	a_601_119##7	98.757294
Rf16	a_601_119##6	a_601_119##3	168.708847
Rf17	a_311_119#	a_311_119##3	181.122711
Rf18	a_311_119##3	a_311_119##5	171.628616
Rf19	a_311_119##5	a_311_119##6	146.636993
Rf20	a_311_119##2	a_311_119##3	15.000000
Rf21	a_311_119##4	a_311_119##5	15.000000
Rf22	a_867_125#	a_867_125##2	137.680466
Rf23	SET_B#7	SET_B#2	160.995956
Rf24	SET_B#9	SET_B#10	0.763153
Rf25	SET_B#7	SET_B#10	9.448145
Rf26	a_473_405##5	a_473_405##8	212.669846
Rf27	a_473_405##8	a_473_405##9	76.955307
Rf28	a_473_405##9	a_473_405##11	17.395531
Rf29	a_473_405##11	a_473_405##2	340.518585
Rf30	a_473_405##8	a_473_405##13	12.244770
Rf31	a_473_405##9	a_473_405##14	114.880173
Rf32	a_473_405##10	a_473_405##11	7.500000
Rf33	a_200_74##8	a_200_74##17	207.990723
Rf34	a_200_74##17	a_200_74##6	178.181290
Rf35	SET_B#5	SET_B	189.584290
Rf36	a_1335_112##2	a_1335_112##5	362.064301
Rf37	a_1335_112##5	a_1335_112##6	94.786575
Rf38	a_1335_112##5	a_1335_112##7	100.236580
Rf39	a_1832_74#	a_1832_74##2	109.533714
Rf40	a_975_322##7	a_975_322##8	41.761475
Rf41	a_975_322##8	a_975_322##9	67.645218
Rf42	a_975_322##9	a_975_322##2	600.883911
Rf43	a_975_322##8	a_975_322##11	95.326920
Rf44	a_975_322##9	a_975_322##5	168.323792
Rf45	RESET_B#4	RESET_B#2	162.524826
Rf46	RESET_B	RESET_B#6	2.292021
Rf47	RESET_B#4	RESET_B#6	4.913828
Rf48	a_1555_410##13	a_1555_410##14	174.695694
Rf49	a_1555_410##14	a_1555_410##16	139.767700
Rf50	a_1555_410##16	a_1555_410##18	100.598137
Rf51	a_1555_410##18	a_1555_410##2	214.580841
Rf52	a_1555_410##15	a_1555_410##16	7.500000
Rf53	a_1555_410##17	a_1555_410##18	15.000000
Rf54	Q_N	Q_N#1	110.847275
Rf55	Q_N	Q_N#3	3.488554
Rf56	Q_N#3	Q_N	10.098445
Rf57	Q_N#2	Q_N#3	7.500000
Rf58	a_2516_368##3	a_2516_368##8	185.644379
Rf59	a_2516_368##8	a_2516_368##9	46.504173
Rf60	a_2516_368##8	a_2516_368##10	45.026772
Rf61	Q	Q#2	0.196836
Rf62	Q#2	Q	14.369054
Rf63	Q	Q#3	103.554893
Rf64	Q#1	Q#2	5.000000
Rf65	VGND#1	VGND#2	35.348125
Rf66	VGND#2	VGND#3	50.235222
Rf67	VGND#3	VGND#4	69.626419
Rf68	VGND#4	VGND#5	89.479202
Rf69	VGND#5	VGND#6	71.549019
Rf70	VGND#6	VGND#7	88.489143
Rf71	VGND#7	VGND#8	216.302979
Rf72	VGND#8	VGND#9	186.254227
Rf73	VGND#9	VGND#10	81.579750
Rf74	VGND#10	VGND#11	111.871170
Rf76	VGND#3	VGND#13	35.828152
Rf77	VGND#4	VGND#14	47.690044
Rf78	VGND#5	VGND#15	11.766943
Rf79	VGND#7	VGND#16	53.338165
Rf80	VGND#8	VGND#17	45.530331
Rf81	VGND#10	VGND#18	31.595499
Rf82	VGND#11	VGND#19	36.279022
Rf83	VPWR#1	VPWR#2	60.285839
Rf84	VPWR#2	VPWR#3	53.359676
Rf85	VPWR#3	VPWR#4	73.789284
Rf86	VPWR#4	VPWR#5	65.696381
Rf87	VPWR#5	VPWR#6	87.636063
Rf88	VPWR#6	VPWR#7	59.146370
Rf89	VPWR#7	VPWR#8	79.941223
Rf90	VPWR#8	VPWR#9	139.842636
Rf91	VPWR#9	VPWR#10	75.923454
Rf92	VPWR#10	VPWR#11	135.849396
Rf93	VPWR#11	VPWR#12	71.687523
Rf94	VPWR#12	VPWR#13	121.459908
Rf96	VPWR#3	VPWR#15	51.329571
Rf97	VPWR#4	VPWR#16	33.503098
Rf98	VPWR#5	VPWR#17	32.342297
Rf99	VPWR#7	VPWR#18	22.500479
Rf100	VPWR#8	VPWR#19	22.500479
Rf101	VPWR#9	VPWR#20	33.326477
Rf102	VPWR#10	VPWR#21	33.326477
Rf103	VPWR#12	VPWR#22	52.972916
Rf104	VPWR#13	VPWR#23	53.143215
Rf121	a_1555_410##7	a_1555_410##14	160.232803
Re1	a_200_74##17	a_200_74##10	25.946058
Re3	SET_B	SET_B#9	15.344948
Re4	VPWR#2	VPWR#25	6.363944
Re5	VPWR#25	VPWR	1.106290
Re6	VPWR	VPWR#11	2.173466
Re7	VGND#2	VGND#21	6.363944
Re8	VGND#21	VGND	1.106290
Re9	VGND	VGND#9	2.173466
Re18	VGND#6	VGND#21	0.698413
Re15	VPWR#6	VPWR#25	0.698413
*
*       CAPACITOR CARDS
*
*
C1	VGND#8	a_975_322##2	4.52523e-17
C2	SET_B#3	VPWR#21	2.30482e-17
C3	a_200_74##3	a_601_119#	1.90941e-18
C4	a_1555_410##15	VPWR#17	1.53189e-17
C5	VGND#7	SET_B#4	7.98655e-18
C6	a_200_74##8	a_27_74##5	4.13526e-17
C7	a_200_74##14	a_27_74##2	3.27545e-20
C8	a_2516_368##10	a_1555_410##9	1.05906e-18
C9	a_200_74##17	a_867_125#	9.9937e-18
C10	a_601_119##7	a_601_119##6	1.65304e-18
C11	a_200_74##2	a_601_119##5	3.85236e-17
C12	a_473_405##10	a_473_405##4	2.14135e-19
C13	VGND#3	a_2516_368##10	7.68734e-18
C14	VPWR#8	SET_B#6	2.12585e-18
C15	a_311_119##4	a_473_405#	1.97405e-17
C16	a_27_74##8	D#1	5.68472e-18
C17	a_1335_112##5	a_200_74##8	5.89924e-17
C18	a_473_405##2	a_473_405##10	1.18828e-18
C19	a_311_119##2	a_311_119#	1.14459e-18
C20	VPWR#2	VPWR#1	1.30809e-17
C21	VGND#19	a_27_74##2	2.18298e-20
C22	a_27_74##5	a_200_74##6	2.1196e-17
C23	a_2516_368##8	Q#3	2.40888e-18
C24	VGND#5	SET_B#4	7.62695e-20
C25	D#3	VGND#18	1.85519e-17
C26	VPWR#7	SET_B#6	1.11194e-17
C27	a_1555_410##9	VGND#14	2.96668e-17
C28	SET_B#10	a_601_119##4	7.18324e-19
C29	VPWR#21	a_975_322##3	3.49951e-17
C30	a_1555_410##15	a_975_322##11	5.43728e-17
C31	VGND#2	VGND#3	1.40577e-17
C32	a_473_405##2	a_601_119##5	3.58296e-17
C33	a_2516_368##3	Q#3	3.86574e-17
C34	a_473_405##10	SET_B#3	1.53012e-18
C35	SET_B#9	a_1335_112##6	2.32389e-18
C36	a_200_74##14	a_473_405#	4.42311e-19
C37	a_2516_368##8	a_1555_410##10	5.91691e-19
C38	a_1555_410##7	a_1555_410##10	1.56491e-18
C39	a_27_74##2	a_200_74##3	2.63709e-17
C40	a_601_119##7	a_311_119##2	1.0818e-16
C41	CLK_N#1	a_27_74##8	4.86402e-17
C42	a_311_119##4	a_27_74##3	9.35456e-19
C43	VPWR#4	a_1555_410##6	2.01982e-20
C44	a_200_74##12	VPWR#22	4.70636e-17
C45	VGND#13	a_2516_368##3	2.0931e-17
C46	a_27_74##5	a_473_405##5	5.97597e-18
C47	a_311_119##4	D#3	2.93789e-17
C48	a_200_74##11	a_27_74##3	2.30377e-19
C49	SET_B#9	a_200_74##5	2.12068e-18
C50	a_473_405##2	VPWR#22	6.11297e-17
C51	VGND#7	a_1555_410#	2.10927e-18
C52	a_1555_410##9	Q_N#2	1.4938e-17
C53	a_1555_410##7	a_1555_410##12	2.1136e-17
C54	a_975_322##9	a_1335_112##6	1.56329e-16
C55	VPWR#21	a_601_119##4	3.4365e-18
C56	a_27_74##3	a_601_119##2	1.16116e-18
C57	VGND#18	a_27_74##4	8.62628e-19
C58	a_200_74##6	a_1335_112##5	2.05543e-18
C59	a_473_405##10	a_975_322##3	3.02935e-17
C60	VPWR#8	a_1555_410##3	1.55861e-17
C61	SET_B#9	a_473_405##4	3.2909e-18
C62	a_975_322##8	a_975_322##11	6.31844e-19
C63	a_1555_410##7	RESET_B#1	4.64478e-18
C64	VGND#14	a_1555_410##11	5.87909e-19
C65	a_311_119##2	a_200_74##11	1.09953e-18
C66	a_200_74##12	a_473_405##2	1.52993e-17
C67	a_1555_410##15	a_1931_392#	2.7395e-18
C68	a_200_74##14	D#3	3.57553e-18
C69	a_27_74##5	SET_B#2	4.87096e-19
C70	a_200_74##12	a_311_119##6	1.51719e-16
C71	a_2516_368##8	VGND#13	7.10036e-18
C72	a_2516_368##9	VPWR#4	6.07943e-18
C73	a_975_322##2	a_1555_410#	1.61181e-19
C74	SET_B#9	SET_B#3	7.03416e-20
C75	a_1555_410##7	a_1335_112#	2.26293e-19
C76	VPWR#7	a_1555_410##3	6.09321e-19
C77	a_311_119##4	a_27_74##4	8.08414e-18
C78	a_975_322##2	a_200_74##7	6.90953e-19
C79	a_311_119##6	D#2	2.75998e-18
C80	a_473_405#	a_27_74##2	6.56179e-17
C81	SET_B#9	a_975_322##3	1.23654e-18
C82	a_1555_410##7	a_975_322##4	7.82208e-20
C83	VPWR#2	a_2516_368##2	8.04828e-21
C84	a_473_405##10	a_601_119##4	6.2534e-17
C85	VGND#19	D#3	3.76377e-19
C86	a_1555_410##11	Q_N#2	1.37163e-17
C87	a_1335_112##2	a_1555_410##12	9.49451e-20
C88	a_200_74##12	D#2	5.704e-19
C89	SET_B#10	a_473_405##8	2.58334e-17
C90	a_975_322##2	a_27_74##5	5.1912e-17
C91	VPWR#5	VPWR#16	7.69549e-20
C92	a_601_119##2	a_975_322#	6.59994e-18
C93	VPWR#11	a_473_405##4	1.67102e-18
C94	VPWR#4	a_1555_410##5	2.47553e-19
C95	SET_B#9	VPWR#10	7.79587e-19
C96	a_27_74##4	a_200_74##14	3.85077e-17
C97	VGND#7	a_200_74##7	2.04587e-18
C98	a_975_322##2	a_473_405##6	1.92397e-17
C99	a_1335_112##2	RESET_B#1	1.93457e-18
C100	a_2516_368##9	VPWR#3	5.66984e-18
C101	a_311_119#	a_601_119##4	6.46575e-18
C102	a_1335_112##5	a_473_405##5	3.76801e-20
C103	a_200_74##14	a_27_74##3	1.34377e-19
C104	a_200_74##10	a_867_125#	5.26583e-19
C105	a_473_405##2	VPWR#12	2.42955e-17
C106	a_975_322##8	a_1555_410##15	1.70933e-18
C107	a_27_74##12	D#3	6.43218e-20
C108	SET_B#9	VPWR#9	6.22485e-18
C109	a_975_322##2	SET_B#1	1.36511e-17
C110	VGND#18	a_311_119##2	3.27216e-17
C111	a_1335_112##2	a_1335_112#	1.25194e-17
C112	VPWR#8	a_27_74##6	4.61957e-18
C113	a_975_322##7	a_1555_410##11	1.31942e-18
C114	a_473_405##10	a_27_74#	1.73576e-17
C115	a_200_74##12	a_27_74##7	6.19094e-18
C116	a_200_74##12	VPWR#12	4.96431e-17
C117	a_975_322##2	a_975_322#	7.32817e-18
C118	VPWR#11	a_975_322##3	5.53463e-19
C119	a_200_74##10	a_473_405##14	3.43494e-17
C120	VGND#19	a_27_74##4	3.22575e-17
C121	VPWR#23	a_200_74##12	5.87253e-17
C122	a_1335_112##2	a_975_322##4	3.64759e-17
C123	a_975_322##7	a_975_322##11	1.50453e-18
C124	a_1335_112##6	a_1335_112##5	2.35934e-18
C125	a_200_74##17	VGND#8	5.05557e-18
C126	D#3	a_473_405#	1.1643e-17
C127	a_27_74##4	a_27_74##2	2.52784e-20
C128	VGND#8	a_27_74##5	6.25335e-17
C129	a_311_119##4	a_601_119##6	1.73646e-18
C130	a_200_74##10	a_27_74#	3.10219e-18
C131	a_975_322##2	a_601_119#	8.89084e-20
C132	VGND#5	VGND#15	1.70031e-17
C133	a_1555_410##7	a_975_322##7	2.58875e-17
C134	a_27_74#	a_311_119#	1.52128e-17
C135	VPWR#11	a_601_119##4	1.77891e-18
C136	a_200_74##10	a_867_125##2	9.5609e-18
C137	a_200_74##14	CLK_N#3	1.50826e-18
C138	a_27_74##3	a_601_119#	1.63482e-17
C139	a_1335_112##2	SET_B#6	2.24318e-18
C140	a_1555_410##11	VGND#15	1.06593e-17
C141	VGND#14	a_1335_112##3	9.9175e-20
C142	VGND#9	a_1335_112##6	9.7626e-19
C143	a_601_119##6	a_473_405##10	1.99974e-18
C144	a_975_322##9	a_975_322##8	5.56978e-18
C145	a_27_74##12	a_27_74##4	9.1599e-19
C146	a_1555_410##7	VGND#15	1.29345e-17
C147	a_473_405##10	a_200_74#	2.13411e-19
C148	a_200_74##12	CLK_N#2	1.12199e-19
C149	Q_N#1	VPWR#5	5.25753e-18
C150	VPWR#11	a_27_74#	4.17119e-18
C151	a_311_119##4	a_311_119##2	1.92621e-19
C152	a_200_74##10	a_311_119##2	4.70875e-17
C153	a_601_119##5	a_27_74#	2.6383e-17
C154	VPWR#9	a_200_74##5	7.65645e-18
C155	a_27_74##11	a_200_74##12	3.09619e-18
C156	a_975_322##7	RESET_B#3	2.29241e-17
C157	VGND#7	a_27_74##5	1.04935e-19
C158	VGND#2	a_2516_368##2	9.93724e-19
C159	a_1555_410##17	a_1555_410##15	1.45473e-18
C160	VGND#19	CLK_N#3	2.84178e-17
C161	a_601_119##6	a_601_119#	2.36709e-19
C162	VPWR#16	VPWR#3	1.02298e-18
C163	VPWR#11	a_200_74#	3.97716e-18
C164	a_601_119##7	a_200_74##10	5.53822e-17
C165	CLK_N#2	a_27_74##11	4.07047e-18
C166	VPWR#3	a_1555_410##5	2.67187e-20
C167	SET_B#5	a_975_322##4	5.87531e-18
C168	VPWR#12	D#2	1.15466e-19
C169	a_1832_74#	a_1555_410##11	2.42535e-19
C170	VPWR#8	a_200_74##5	3.03663e-19
C171	VPWR#7	VPWR#17	4.40918e-19
C172	a_601_119##6	a_27_74#	2.56448e-17
C173	a_975_322##7	RESET_B#2	2.82171e-17
C174	a_1555_410##2	a_1335_112#	2.80752e-19
C175	a_27_74##4	D#3	1.18559e-17
C176	a_27_74##2	a_601_119##3	1.63946e-18
C177	VGND#14	a_2516_368##8	2.23728e-17
C178	VPWR#11	a_473_405##3	2.59675e-18
C179	VGND#19	a_27_74##3	1.87508e-19
C180	a_473_405##10	a_473_405##3	1.24783e-19
C181	a_1555_410##13	a_975_322##7	1.81084e-17
C182	a_200_74##4	a_601_119#	1.00273e-18
C183	a_27_74##12	CLK_N#3	2.5581e-17
C184	a_601_119##5	a_200_74#	1.6543e-17
C185	RESET_B#3	VGND#15	6.28062e-18
C186	a_27_74##11	VPWR#23	5.3053e-17
C187	Q_N#1	VPWR#4	6.01726e-18
C188	VGND#9	a_867_125#	2.64055e-17
C189	a_1555_410##2	a_975_322##4	3.80373e-19
C190	VGND#8	a_473_405##6	5.02474e-19
C191	a_311_119##4	a_601_119##7	2.29796e-17
C192	RESET_B#2	VGND#15	1.91305e-18
C193	VGND#5	a_1832_74#	2.47659e-17
C194	a_601_119##6	a_311_119#	6.4274e-17
C195	a_1555_410##13	a_1555_410##11	4.08993e-19
C196	a_975_322##9	a_1335_112##5	7.89249e-18
C197	a_1555_410##2	SET_B#6	1.25192e-17
C198	a_1335_112##7	a_27_74##5	2.70223e-19
C199	VGND#9	a_473_405##14	8.22514e-18
C200	VPWR#11	VPWR#12	8.11118e-17
C201	a_27_74##2	a_200_74##4	3.05317e-17
C202	SET_B#5	a_27_74##6	6.39395e-20
C203	VPWR#11	a_27_74##8	4.21905e-18
C204	a_601_119##6	a_200_74##3	2.52011e-20
C205	VPWR#12	a_27_74##2	4.11503e-20
C206	a_311_119##4	a_200_74##10	3.54546e-18
C207	a_27_74##3	a_200_74##3	1.55972e-17
C208	a_1555_410##2	a_1555_410##3	1.38026e-17
C209	VPWR#9	a_473_405##4	4.55246e-18
C210	a_601_119##5	a_473_405##3	1.81644e-18
C211	a_1555_410##13	RESET_B#2	4.25238e-19
C212	VGND#9	a_867_125##2	3.51513e-17
C213	VPWR#11	VPWR#10	8.96145e-17
C214	SET_B#10	a_473_405##5	1.25182e-17
C215	a_1555_410##5	a_2516_368##5	4.54074e-19
C216	VPWR#11	CLK_N#1	1.12951e-18
C217	VGND#8	a_975_322##9	1.79413e-17
C218	a_200_74##10	a_200_74##14	7.60285e-19
C219	a_27_74##6	a_1555_410##2	3.34025e-17
C220	CLK_N#3	a_27_74##4	4.23306e-17
C221	a_27_74##2	a_200_74##2	2.57744e-17
C222	a_1555_410##17	VPWR#18	6.48717e-18
C223	VGND#9	a_311_119##2	1.61029e-16
C224	a_200_74##11	a_27_74#	1.25704e-18
C225	VPWR#11	VPWR#9	6.49772e-17
C226	RESET_B#6	a_1555_410##12	4.03516e-19
C227	VPWR#8	a_473_405##4	1.38533e-19
C228	SET_B#7	a_473_405##5	1.83738e-17
C229	VGND#9	a_601_119##7	6.99398e-18
C230	a_473_405##8	SET_B#2	9.48607e-19
C231	a_1555_410##15	VPWR#6	2.61609e-17
C232	a_1832_74#	a_1335_112##2	4.15035e-19
C233	a_311_119##4	a_200_74##11	1.66489e-17
C234	VGND#8	SET_B#1	1.98353e-18
C235	VGND#5	a_1555_410##13	2.71064e-17
C236	VPWR#22	a_473_405##3	8.04407e-18
C237	a_473_405##2	a_27_74##2	2.47251e-17
C238	a_473_405##10	a_930_424#	2.78043e-18
C239	VPWR#10	SET_B#3	2.81159e-18
C240	a_1832_74#	a_1335_112##3	4.0807e-17
C241	a_601_119##6	a_27_74##2	4.83029e-19
C242	a_1555_410##13	a_1335_112##2	5.85258e-19
C243	VPWR#10	VPWR#9	1.12416e-18
C244	VGND#7	a_1832_74##2	3.11605e-17
C245	a_1832_74#	a_1555_410##13	6.53034e-17
C246	a_200_74##6	a_27_74##6	3.09866e-17
C247	a_311_119##4	VGND#18	5.32491e-17
C248	SET_B#10	SET_B#2	5.05116e-18
C249	VGND#7	a_975_322##9	5.98676e-17
C250	a_200_74##17	SET_B#9	7.37864e-17
C251	a_2516_368##4	VPWR#1	2.8129e-17
C252	D#1	VPWR#22	1.65998e-17
C253	a_1555_410##13	a_1335_112##3	4.02411e-17
C254	a_27_74##3	a_27_74##2	4.27065e-19
C255	VPWR#2	a_2516_368##3	3.14656e-18
C256	a_311_119##4	a_311_119##6	5.55688e-19
C257	a_473_405##5	a_27_74##6	5.33697e-20
C258	D#2	a_473_405#	3.13428e-17
C259	RESET_B#6	RESET_B#1	4.76466e-18
C260	VGND#9	a_311_119##4	1.60712e-17
C261	a_200_74##12	a_473_405##3	1.82687e-18
C262	a_975_322##8	a_1555_410##11	9.31892e-20
C263	SET_B#7	SET_B#2	1.22836e-17
C264	a_1555_410##15	VPWR#7	5.93351e-18
C265	CLK_N#6	a_27_74##10	1.96174e-17
C266	a_975_322##2	a_473_405##8	1.06656e-17
C267	a_1555_410##17	VPWR#19	3.11057e-19
C268	a_473_405##5	a_200_74##5	8.36502e-19
C269	VGND#2	a_2516_368##3	3.79699e-18
C270	a_1832_74#	a_975_322##6	3.88627e-19
C271	D#1	a_311_119##6	1.17052e-17
C272	a_1335_112##5	a_1555_410##17	6.17333e-17
C273	a_975_322##5	a_1555_410##13	1.13064e-18
C274	VGND#9	a_200_74##14	2.12075e-17
C275	a_200_74##10	VGND#8	1.35614e-18
C276	a_2516_368##5	a_2516_368#	3.88748e-17
C277	a_473_405##8	VPWR#10	9.4173e-18
C278	a_601_119##6	a_473_405#	1.19679e-19
C279	VGND#8	a_975_322#	1.45759e-18
C280	a_200_74##14	VGND#18	7.44887e-18
C281	a_2516_368##4	Q#1	2.44089e-17
C282	a_27_74##4	D#2	6.73493e-19
C283	a_1832_74##2	a_1832_74#	6.33654e-19
C284	a_473_405##5	a_473_405##4	3.25166e-18
C285	a_1832_74##2	a_1335_112##3	1.25942e-18
C286	a_975_322##9	RESET_B#3	1.18693e-19
C287	a_975_322##5	a_1832_74##2	1.14542e-18
C288	VPWR#10	a_975_322##3	3.94982e-18
C289	a_975_322##2	SET_B#10	4.2777e-18
C290	a_200_74##12	D#1	2.95693e-17
C291	VPWR#1	a_2516_368##6	1.23306e-18
C292	a_473_405##5	SET_B#3	1.8392e-18
C293	VGND#9	a_200_74##17	3.95024e-17
C294	a_200_74##12	a_311_119##4	2.00352e-17
C295	a_975_322##6	a_1555_410##13	2.34709e-17
C296	a_975_322##2	a_27_74##6	9.27682e-21
C297	VPWR#15	a_2516_368##4	2.5089e-19
C298	SET_B#2	a_473_405##4	1.63695e-19
C299	a_1555_410##15	VPWR#5	4.09992e-18
C300	a_27_74##4	a_27_74##7	7.43549e-19
C301	VGND#9	a_27_74##12	1.5941e-17
C302	a_200_74##11	a_27_74##2	2.51312e-17
C303	a_311_119##6	a_27_74##8	1.06557e-18
C304	a_473_405##5	a_975_322##3	1.4303e-19
C305	SET_B#9	VPWR#11	3.6106e-17
C306	a_975_322##2	SET_B#7	6.15888e-17
C307	a_1832_74#	SET_B#4	1.73754e-19
C308	a_975_322##8	RESET_B#3	6.08645e-19
C309	a_2516_368##6	Q#1	2.37354e-17
C310	a_473_405##5	a_601_119##4	7.80201e-20
C311	a_200_74##14	a_311_119##4	8.51695e-17
C312	VGND#19	VGND#18	9.07088e-19
C313	a_200_74##12	a_27_74##8	6.68988e-17
C314	a_1832_74##2	a_1555_410##13	3.40523e-17
C315	a_975_322##3	SET_B#2	3.39032e-19
C316	VPWR#11	a_200_74##10	1.07018e-18
C317	a_1335_112##6	a_975_322##5	1.57287e-19
C318	a_601_119##6	D#3	4.17277e-20
C319	a_1832_74##2	a_975_322##6	3.12612e-17
C320	a_473_405##8	VPWR#9	9.77748e-18
C321	a_200_74##14	a_200_74##12	3.48587e-18
C322	a_27_74##3	a_473_405#	1.87674e-17
C323	VPWR#12	a_601_119##4	1.91199e-19
C324	a_1555_410##4	a_2516_368##5	3.20821e-17
C325	VGND#8	a_601_119#	1.03861e-18
C326	a_2516_368##6	VPWR#15	2.45909e-17
C327	a_2516_368##6	a_2516_368##4	4.86435e-17
C328	a_1335_112##7	a_1555_410##17	1.73457e-18
C329	a_27_74##8	VPWR#23	2.09899e-17
C330	a_975_322##9	a_1335_112##3	9.30228e-18
C331	VGND#9	a_200_74##10	5.77004e-17
C332	a_1555_410##9	a_1555_410##5	7.12166e-19
C333	a_1555_410##13	SET_B#4	7.51733e-19
C334	VGND#16	SET_B#5	8.2951e-19
C335	a_200_74##11	D#1	3.58087e-18
C336	VPWR#6	a_1335_112##2	5.00623e-20
C337	a_200_74##17	a_1335_112##7	7.37116e-18
C338	VPWR#10	a_601_119##4	2.64789e-18
C339	a_200_74##12	CLK_N#1	3.45651e-18
C340	VPWR#9	VPWR#8	2.74091e-19
C341	a_601_119##4	a_975_322##2	3.86717e-18
C342	a_27_74##11	a_27_74##8	2.64567e-18
C343	CLK_N#4	a_27_74##10	2.47623e-17
C344	a_2516_368##9	a_2516_368##6	1.39656e-18
C345	a_1335_112##6	SET_B#5	2.37485e-19
C346	a_975_322##8	a_1335_112##3	8.78665e-18
C347	VPWR#1	a_1555_410##10	1.29295e-19
C348	a_1832_74##2	SET_B#4	3.34965e-17
C349	CLK_N#1	VPWR#23	2.9432e-17
C350	VGND#6	a_1335_112##2	3.45065e-20
C351	a_1555_410##8	VPWR#15	3.25978e-17
C352	a_200_74##17	VPWR#20	1.18944e-19
C353	VGND#9	VGND#10	1.05788e-16
C354	a_2516_368##3	VPWR#15	1.77362e-17
C355	a_27_74##10	a_200_74##14	4.42657e-17
C356	a_27_74#	a_601_119##3	1.81984e-17
C357	VPWR#16	a_2516_368##6	7.49143e-19
C358	a_1555_410##8	a_2516_368##6	3.35551e-17
C359	a_27_74##11	CLK_N#1	6.07234e-17
C360	VPWR#7	VPWR#18	6.01079e-18
C361	VGND#6	a_975_322##5	7.44499e-20
C362	a_1555_410##9	a_1555_410##4	4.28609e-18
C363	a_975_322##9	a_975_322##6	9.50246e-18
C364	VGND#9	VGND#8	1.46321e-16
C365	VGND#19	a_200_74##14	3.92513e-17
C366	a_2516_368##3	VPWR#3	3.15904e-19
C367	SET_B#4	VGND#16	1.19449e-17
C368	a_200_74##17	a_975_322##9	2.7347e-19
C369	a_2516_368##9	a_1555_410##8	7.19993e-17
C370	a_200_74##4	a_27_74#	2.40096e-17
C371	a_601_119##6	a_601_119##3	2.23071e-17
C372	a_200_74##11	VPWR#22	2.83313e-18
C373	a_27_74##3	D#3	1.60243e-17
C374	a_1555_410##10	a_2516_368##6	3.6532e-19
C375	a_1335_112##6	a_1555_410##2	3.56673e-19
C376	VGND#16	a_1832_74##2	4.26444e-17
C377	a_200_74##17	VPWR#21	2.74456e-18
C378	VPWR#15	a_1555_410##5	1.73827e-18
C379	a_2516_368##8	VPWR#3	2.71819e-19
C380	VPWR#15	a_1555_410##10	4.67924e-19
C381	a_1555_410##17	VPWR#8	2.05358e-17
C382	SET_B#9	a_1335_112##7	1.44044e-17
C383	VGND#10	a_27_74##3	3.98427e-17
C384	VPWR#16	a_1555_410##8	3.18311e-18
C385	a_200_74##2	a_27_74#	3.05233e-17
C386	a_200_74##17	a_200_74##8	5.43202e-19
C387	a_2516_368##8	VPWR#15	1.26783e-17
C388	a_1555_410##7	VPWR#5	6.72295e-19
C389	a_200_74##17	a_1335_112##5	7.6783e-19
C390	a_27_74##10	VGND#19	2.47689e-17
C391	a_1555_410##10	a_1555_410##8	5.93554e-18
C392	a_473_405##2	a_601_119##4	1.46812e-19
C393	D	a_27_74##3	9.86089e-19
C394	a_1335_112##7	a_1335_112##5	5.40796e-19
C395	a_27_74##12	a_200_74##14	2.4542e-18
C396	a_2516_368##9	a_1555_410##10	3.55309e-18
C397	RESET_B#2	a_1555_410##7	5.99938e-17
C398	a_1555_410#	VGND#16	1.35221e-17
C399	a_473_405##2	a_27_74#	1.5354e-18
C400	a_200_74##17	a_473_405##10	7.41161e-19
C401	Q_N#1	a_1555_410##8	1.30208e-18
C402	SET_B#9	VPWR#20	3.95083e-18
C403	a_27_74##10	a_27_74##8	7.04283e-18
C404	a_975_322##9	SET_B#4	2.80535e-17
C405	a_1555_410##17	VPWR#7	4.74161e-17
C406	a_1335_112#	a_1931_392#	1.15846e-17
C407	a_473_405##2	a_200_74#	1.51586e-17
C408	a_1335_112##6	a_200_74##8	7.83395e-17
C409	a_1555_410##11	a_1555_410##9	3.72787e-17
C410	a_1335_112##6	SET_B#4	1.05172e-19
C411	a_311_119##6	a_200_74##11	3.76543e-17
C412	a_1335_112##2	a_1555_410##7	1.01805e-18
C413	a_601_119##6	a_200_74##4	1.0683e-17
C414	a_200_74##17	a_473_405##5	8.5204e-18
C415	VPWR#16	a_1555_410##10	5.83964e-17
C416	a_975_322##4	a_1931_392#	1.62026e-17
C417	a_473_405##2	a_473_405##3	1.10943e-17
C418	SET_B#9	a_473_405##13	6.73598e-20
C419	a_1555_410##7	Q_N#1	7.23033e-17
C420	SET_B#9	a_200_74##6	1.51782e-17
C421	a_1335_112##2	RESET_B#2	8.48277e-18
C422	a_1335_112##5	a_1335_112#	9.99263e-20
C423	a_27_74##12	a_27_74##11	9.46745e-19
C424	D#1	a_473_405##2	2.8108e-17
C425	a_27_74##12	VGND#19	3.83514e-17
C426	a_2516_368##9	a_1555_410##12	1.93727e-19
C427	a_311_119##4	a_529_119#	1.60742e-18
C428	a_1555_410##7	VPWR#17	3.11718e-17
C429	a_1555_410##12	a_1555_410##10	4.74114e-17
C430	VPWR#8	VPWR#19	2.89035e-18
C431	SET_B#9	VPWR#21	2.38441e-18
C432	VPWR#8	VPWR#7	2.0343e-18
C433	SET_B#9	a_473_405##5	4.68349e-17
C434	a_27_74##4	a_27_74##3	1.28764e-19
C435	a_473_405##2	a_27_74##8	2.43845e-19
C436	Q_N#1	a_1555_410##10	6.25312e-17
C437	a_2516_368##8	a_2516_368##9	1.74699e-19
C438	CLK_N#6	a_27_74##8	2.65095e-19
C439	a_1555_410##5	a_2516_368##9	4.81957e-19
C440	a_200_74##17	a_975_322##2	9.68215e-17
C441	a_975_322##11	a_1555_410##7	1.15991e-17
C442	VGND#10	a_473_405#	1.50005e-18
C443	VPWR#5	RESET_B#2	1.14856e-19
C444	a_975_322##5	a_1335_112##2	3.62111e-17
C445	a_27_74##10	CLK_N#1	2.55213e-18
C446	a_1335_112##6	a_1555_410#	6.54384e-18
C447	VGND#2	a_2516_368#	1.30483e-18
C448	VGND#8	a_27_74##3	6.95584e-18
C449	VPWR#16	a_1555_410##12	2.7068e-18
C450	a_1555_410##3	a_1504_508#	1.06762e-17
C451	a_27_74##8	D#2	1.72806e-18
C452	a_975_322##9	a_1555_410#	2.22091e-17
C453	a_200_74##2	a_601_119##6	1.35e-17
C454	Q_N	a_1555_410##6	1.14508e-17
C455	a_1555_410##7	a_1555_410##15	1.07809e-19
C456	VPWR#17	a_1555_410##10	2.14578e-18
C457	Q_N	a_1555_410##5	1.1067e-19
C458	a_27_74##6	a_1504_508#	1.06762e-17
C459	SET_B#9	a_975_322##9	2.97937e-19
C460	SET_B#5	a_1335_112##2	1.93626e-17
C461	a_200_74##7	a_1640_138#	7.51797e-18
C462	SET_B#9	a_473_405##10	4.571e-18
C463	SET_B#9	a_975_322##2	1.6329e-17
C464	RESET_B#3	a_1555_410##11	1.76625e-17
C465	VGND#3	a_2516_368##3	4.61192e-19
C466	VPWR#20	a_1335_112##7	1.36838e-17
C467	a_27_74##3	a_975_322##2	2.93235e-19
C468	VGND#2	a_2516_368##5	1.24094e-18
C469	VPWR#11	VPWR#20	1.34896e-17
C470	Q_N#1	a_1555_410##12	1.80102e-17
C471	SET_B#5	a_975_322##5	3.1299e-17
C472	a_1335_112##2	a_1555_410##2	1.44131e-19
C473	VPWR#12	a_473_405##3	3.97351e-18
C474	a_200_74##10	a_975_322##2	5.93817e-18
C475	a_1335_112##5	a_975_322##4	2.76997e-19
C476	VGND#5	VGND#4	2.03677e-18
C477	a_27_74##10	a_27_74##4	5.46553e-18
C478	RESET_B#1	a_1555_410##12	2.47486e-17
C479	a_601_119##2	a_975_322##2	4.25309e-17
C480	SET_B#9	a_311_119#	2.32635e-18
C481	VPWR#16	a_1555_410##6	5.63717e-18
C482	RESET_B#2	a_975_322##11	2.58596e-18
C483	VGND#5	a_1555_410##6	3.23927e-20
C484	CLK_N#6	CLK_N#1	3.73738e-18
C485	VPWR#11	a_975_322##2	6.47879e-18
C486	a_200_74##11	a_200_74##2	2.80267e-18
C487	a_200_74##5	a_1312_424#	2.13523e-17
C488	a_200_74##10	a_601_119##3	6.24754e-18
C489	a_1335_112##6	a_200_74##7	4.34122e-17
C490	a_1335_112##3	a_1555_410##11	1.05188e-18
C491	Q#3	a_2516_368##2	9.42438e-18
C492	a_1555_410##15	RESET_B#2	4.06387e-19
C493	a_200_74##10	a_473_405##10	1.03263e-17
C494	VGND#5	a_1555_410##7	5.85959e-17
C495	VPWR#17	a_1555_410##12	5.12338e-17
C496	VGND#9	a_975_322##2	2.41556e-17
C497	a_473_405##4	a_1312_424#	2.13523e-17
C498	VPWR#11	VPWR#21	1.67427e-17
C499	a_1335_112#	a_1555_410##12	1.05358e-18
C500	a_1555_410##2	SET_B#5	2.22064e-17
C501	VPWR#11	a_601_119##3	8.04796e-20
C502	VGND#8	a_867_125#	5.84546e-17
C503	a_1555_410##15	a_1555_410##10	2.31332e-19
C504	VGND#10	D#3	1.96447e-18
C505	a_200_74##10	a_200_74##4	1.76942e-17
C506	a_601_119##6	a_473_405##2	7.3447e-20
C507	a_2516_368##8	a_2516_368##3	2.07095e-19
C508	a_200_74##10	a_311_119#	7.77479e-18
C509	Q_N#1	RESET_B#1	5.56779e-19
C510	a_975_322##9	a_200_74##7	1.16875e-17
C511	a_200_74##17	a_473_405##8	3.2195e-18
C512	VGND#9	a_601_119##3	3.62153e-19
C513	a_1335_112##5	a_1555_410#	1.79947e-18
C514	SET_B#5	a_200_74##8	1.06286e-18
C515	VPWR#11	a_200_74##4	2.51236e-19
C516	a_1335_112##2	a_975_322##11	3.13268e-17
C517	a_975_322##11	a_1555_410##12	1.70577e-18
C518	a_200_74##10	a_200_74##2	1.29446e-18
C519	a_1335_112#	RESET_B#1	4.21402e-18
C520	a_1335_112##7	VPWR#9	1.27601e-17
C521	a_1335_112##3	RESET_B#3	2.63021e-18
C522	a_27_74##5	a_1240_125#	1.18358e-17
C523	a_27_74##10	CLK_N#3	6.78259e-18
C524	a_200_74##8	a_1555_410##2	1.30066e-17
C525	a_200_74##10	a_601_119##5	1.49764e-18
C526	VGND#9	a_200_74##4	9.33559e-20
C527	a_473_405##10	VPWR#11	1.20167e-16
C528	a_1335_112##5	SET_B#6	2.35227e-17
C529	VPWR#11	a_200_74##2	5.37824e-18
C530	a_1335_112##2	a_1555_410##15	6.80025e-17
C531	Q	a_2516_368##2	9.13656e-18
C532	RESET_B#1	VPWR#17	4.56098e-18
C533	a_975_322##3	a_930_424#	1.52812e-17
C534	a_1335_112##6	a_27_74##5	5.60499e-17
C535	Q	a_1555_410##5	1.83468e-19
C536	a_200_74##10	a_473_405##2	1.65476e-18
C537	a_200_74##11	a_473_405##2	7.43466e-17
C538	a_200_74##6	a_1555_410##2	3.22667e-19
C539	VPWR#12	D#1	5.10413e-18
C540	a_601_119##4	a_930_424#	1.92399e-17
C541	a_1555_410##15	a_1555_410##12	2.27429e-18
C542	a_27_74##3	a_601_119##3	2.35977e-18
C543	VPWR#11	a_311_119#	1.1708e-17
C544	a_473_405##2	VPWR#11	5.78714e-17
C545	Q_N#1	a_1335_112#	1.63788e-19
C546	a_27_74##10	a_200_74##12	6.07762e-17
C547	a_200_74##6	a_200_74##8	3.07957e-18
C548	a_200_74##10	D#2	1.20106e-19
C549	Q_N#1	a_2516_368##8	9.72704e-18
C550	Q_N#1	a_1555_410##6	1.16881e-17
C551	VGND#5	RESET_B#2	7.96089e-19
C552	a_975_322##11	RESET_B#1	2.32391e-17
C553	VPWR#7	a_975_322##5	2.06462e-19
C554	a_1335_112##7	VPWR#8	1.37379e-17
C555	VPWR#7	VPWR#5	1.98976e-19
C556	a_601_119##6	D#2	4.60075e-20
C557	VPWR#11	a_601_119##5	9.334e-18
C558	a_1335_112##2	VPWR#18	6.64882e-18
C559	VGND#4	a_1555_410##6	3.23927e-20
C560	a_200_74##8	a_473_405##5	1.04576e-19
C561	a_975_322##4	a_1335_112#	5.03815e-17
C562	VGND#10	a_27_74##4	1.30365e-17
C563	a_975_322##9	a_27_74##5	1.57188e-18
C564	a_867_125#	SET_B#2	1.73571e-19
C565	VPWR#17	a_1335_112#	2.32474e-18
C566	a_1335_112##2	a_1555_410##17	3.19652e-17
C567	a_473_405##5	a_200_74##6	5.27419e-17
C568	a_200_74#	a_536_503#	5.88358e-19
C569	a_200_74##17	SET_B#7	6.06325e-18
C570	a_975_322##2	a_1335_112##6	6.55016e-17
C571	a_1335_112##6	a_473_405##6	1.8332e-18
C572	a_1555_410##15	RESET_B#1	2.68883e-17
C573	a_975_322##6	a_1335_112##3	2.73966e-17
C574	a_200_74##10	a_27_74##3	3.59273e-19
C575	a_473_405##3	a_536_503#	8.30788e-18
C576	VGND#9	a_27_74##7	2.78599e-19
C577	a_200_74##11	D#2	1.70845e-17
C578	a_200_74##6	SET_B#2	2.74975e-19
C579	Q#3	a_1555_410##5	8.56051e-20
C580	CLK_N#4	a_27_74##12	3.5912e-17
C581	VGND#17	a_27_74##5	1.33076e-18
C582	a_473_405##10	a_27_74##3	5.89969e-20
C583	VGND#5	Q_N	1.51055e-17
C584	a_975_322##11	a_1335_112#	4.33731e-18
C585	Q_N#1	a_1555_410##5	4.8792e-20
C586	VGND#4	Q_N	6.60403e-18
C587	a_867_125#	a_27_74##3	2.24861e-19
C588	VGND#4	VGND#3	1.13274e-18
C589	a_200_74##10	a_601_119##2	7.72877e-19
C590	SET_B#2	a_473_405##5	2.60787e-17
C591	a_27_74##10	VPWR#23	2.00909e-17
C592	a_975_322##2	a_200_74##6	1.43786e-18
C593	VGND#17	a_975_322##2	7.52019e-17
C594	VPWR#12	a_27_74##8	2.56811e-19
C595	VPWR#21	VPWR#20	1.56801e-18
C596	Q_N	a_2516_368##8	7.3556e-18
C597	VPWR#11	a_311_119##6	7.47868e-18
C598	VPWR#17	a_975_322##4	1.38012e-19
C599	a_1555_410##17	a_975_322##5	2.24402e-19
C600	SET_B#6	a_975_322##4	2.23677e-17
C601	a_975_322##2	a_473_405##5	4.10876e-17
C602	VPWR	a_1555_410##6	9.10603e-19
C603	a_867_125#	a_975_322##2	2.09994e-17
C604	VPWR	a_1555_410##5	1.47523e-18
C605	a_1555_410##15	a_1335_112#	6.99235e-17
C606	a_27_74##10	D#2	9.26773e-20
C607	SET_B#9	a_473_405##8	1.46918e-17
C608	a_867_125#	a_27_74##5	1.31547e-17
C609	a_27_74##3	a_200_74##4	1.99731e-18
C610	VPWR#11	a_200_74##12	4.94759e-17
C611	VGND#4	a_1555_410##5	3.8752e-19
C612	VPWR#7	SET_B#5	4.33261e-19
C613	a_975_322##2	SET_B#2	5.36413e-17
C614	a_1335_112##5	a_27_74##5	2.26114e-19
C615	VPWR#15	VPWR#1	7.03824e-19
C616	a_473_405##14	a_975_322##2	3.87763e-17
C617	a_473_405##10	a_601_119##2	6.34526e-18
C618	VGND#8	a_867_125##2	1.94675e-17
C619	a_200_74##4	a_601_119##2	2.14724e-18
C620	a_975_322##11	a_975_322##4	7.01569e-19
C621	D	a_200_74##11	6.61229e-17
C622	SET_B#5	VPWR#18	8.6732e-19
C623	VGND#17	a_473_405##6	3.78705e-17
C624	a_867_125##2	a_975_322##2	1.33568e-19
C625	a_200_74##11	a_27_74##7	7.22454e-20
C626	SET_B#4	a_975_322##6	3.59284e-17
C627	a_1335_112##5	a_27_74##6	7.81463e-19
C628	Q	VPWR#3	3.29899e-18
C629	Q#3	VGND#1	4.81591e-17
C630	a_1555_410##17	SET_B#5	1.00605e-18
C631	VGND#10	a_311_119##2	2.39266e-17
C632	a_473_405##14	a_27_74##5	1.06712e-18
C633	VPWR#17	SET_B#6	1.05684e-19
C634	a_27_74##10	a_27_74##11	1.62206e-18
C635	SET_B#9	SET_B#10	2.04312e-17
C636	VPWR#11	a_27_74##11	1.9578e-17
C637	VGND#9	a_200_74##12	2.32854e-18
C638	a_1555_410##15	a_975_322##4	2.31749e-17
C639	a_1555_410##3	SET_B#6	2.69709e-18
C640	a_200_74##10	a_930_424#	6.48524e-19
C641	a_867_125#	a_473_405##6	9.20922e-19
C642	a_27_74##2	a_529_119#	1.14255e-19
C643	a_2516_368##8	Q	2.47598e-18
C644	VGND#7	a_975_322##5	5.27426e-20
C645	a_27_74##10	a_27_74##7	1.7538e-17
C646	a_1335_112##2	a_1931_392#	8.08996e-18
C647	a_473_405#	a_529_119#	6.41029e-18
C648	RESET_B#6	a_1555_410##7	1.9651e-17
C649	a_473_405##8	a_1335_112##7	1.18617e-17
C650	VPWR#12	CLK_N#1	6.67168e-20
C651	VPWR#11	a_930_424#	4.65921e-19
C652	a_311_119#	a_27_74##3	4.03076e-19
C653	VGND#6	a_1335_112##3	4.43427e-18
C654	a_1555_410##2	VPWR#8	2.94194e-17
C655	a_473_405##14	a_27_74##3	1.47478e-18
C656	a_311_119##2	a_27_74#	2.66291e-19
C657	VGND#1	VPWR#1	5.63323e-18
C658	SET_B#1	VGND#17	1.46618e-17
C659	VPWR#3	a_2516_368##4	1.02617e-18
C660	VGND#2	VGND#1	1.47011e-17
C661	a_1555_410##17	a_1555_410##2	2.97024e-18
C662	VPWR#5	VPWR#4	1.22166e-18
C663	a_1555_410##17	a_1335_112#	3.48615e-19
C664	VPWR#20	VPWR#8	2.97528e-19
C665	CLK_N#6	a_27_74##7	1.15069e-18
C666	VGND#6	a_975_322##6	2.79359e-18
C667	a_311_119##2	VGND#8	1.51854e-18
C668	a_311_119##2	a_601_119##3	1.16585e-17
C669	a_473_405##14	a_473_405##6	5.54468e-19
C670	a_200_74##17	a_1555_410#	2.54252e-21
C671	a_1555_410##15	SET_B#6	1.15051e-18
C672	VGND#13	VGND#1	1.83038e-18
C673	a_601_119##7	a_27_74#	1.13689e-18
C674	VPWR	VPWR#9	2.64926e-17
C675	a_1555_410##2	VPWR#19	3.01077e-18
C676	a_1555_410#	SET_B#4	1.7837e-17
C677	VPWR	VPWR#8	1.04367e-16
C678	VGND#3	a_1555_410##5	5.78452e-20
C679	a_27_74##6	a_1555_410##3	2.78374e-17
C680	a_975_322##4	VPWR#18	2.63051e-17
C681	VPWR	VPWR#7	6.80389e-17
C682	VGND#2	Q#3	2.83987e-17
C683	VPWR	VPWR#5	6.76986e-17
C684	a_27_74##3	a_27_74#	4.70891e-19
C685	VPWR	VPWR#4	5.9963e-17
C686	a_311_119#	a_601_119##2	6.434e-18
C687	VPWR	VPWR#3	5.88788e-17
C688	a_867_125#	SET_B#1	3.8025e-17
C689	CLK_N#4	a_27_74##7	1.97994e-18
C690	a_473_405##14	a_200_74##4	9.03884e-20
C691	Q_N	VGND#14	7.71242e-17
C692	a_473_405##2	a_200_74##2	7.1595e-17
C693	CLK_N#6	a_27_74##11	3.62704e-17
C694	Q_N	Q_N#2	2.8645e-19
C695	a_311_119##4	D	1.04991e-16
C696	a_27_74##10	CLK_N#2	7.70514e-18
C697	a_473_405##14	a_601_119##2	1.28999e-17
C698	VGND#4	a_2516_368##5	1.96201e-19
C699	a_1555_410##5	a_2516_368##6	1.78719e-18
C700	a_1555_410##17	a_975_322##4	9.51674e-19
C701	a_1335_112##7	a_1555_410##2	3.16685e-17
C702	a_27_74#	a_601_119##2	9.91177e-19
C703	a_1555_410##13	Q_N	1.24028e-18
C704	a_200_74##2	D#2	1.00852e-19
C705	a_200_74##17	a_27_74##5	3.35409e-17
C706	VPWR	a_2516_368##8	1.74637e-18
C707	VPWR#11	a_473_405##8	2.46254e-17
C708	RESET_B#6	RESET_B#2	6.50246e-18
C709	a_311_119##2	a_200_74##4	9.44565e-19
C710	D#2	a_473_405##2	1.45019e-17
C711	a_473_405##14	SET_B#1	1.92235e-18
C712	a_311_119##4	a_601_119##3	1.50572e-19
C713	CLK_N#6	CLK_N#2	9.13167e-18
C714	SET_B#6	VPWR#18	2.63051e-17
C715	VPWR#8	a_200_74##8	3.85427e-19
C716	a_200_74##12	a_27_74##4	2.35487e-19
C717	VPWR	RESET_B#6	4.29226e-18
C718	VGND#9	a_27_74##3	3.96058e-17
C719	VGND#13	Q#3	6.21656e-17
C720	a_200_74##17	a_473_405##6	3.75891e-18
C721	a_2516_368##9	VPWR#15	7.51961e-17
C722	a_473_405##10	VPWR#21	2.63011e-17
C723	a_200_74##5	a_27_74##6	2.96832e-17
C724	a_601_119##7	a_200_74##4	3.18332e-18
C725	VPWR#3	a_2516_368##6	9.31063e-18
C726	VPWR	a_975_322##9	4.68626e-18
C727	VGND#5	a_1555_410##4	3.59806e-19
C728	VGND#3	a_2516_368##5	4.72743e-18
C729	a_975_322#	a_867_125#	1.91856e-17
C730	VPWR	a_1335_112##5	7.46479e-18
C731	Q#3	Q	4.66998e-18
C732	a_867_125##2	a_27_74##3	1.17537e-17
C733	a_27_74##7	D#2	5.10422e-18
C734	CLK_N#4	CLK_N#2	1.56406e-17
C735	VGND#9	a_601_119##2	6.39977e-19
C736	a_200_74##7	a_1555_410#	3.18729e-17
C737	a_975_322##8	a_1555_410##7	2.20868e-18
C738	VPWR#11	SET_B#10	1.90552e-18
C739	a_200_74##17	SET_B#1	3.05092e-18
C740	a_200_74##8	a_1335_112##7	1.33283e-17
C741	a_1555_410##17	SET_B#6	5.21788e-17
C742	a_867_125##2	SET_B#1	1.75739e-19
C743	VGND	a_1555_410##6	2.10892e-18
C744	VGND	a_1555_410##5	2.13306e-18
C745	CLK_N#2	a_27_74##7	2.99043e-17
C746	a_2516_368##3	a_2516_368##2	4.12799e-18
C747	a_200_74##17	a_975_322#	1.17589e-18
C748	a_473_405##8	VPWR#20	6.37118e-17
C749	a_473_405##14	a_975_322#	3.58706e-17
C750	a_27_74##3	a_473_405##2	5.25603e-19
C751	Q_N	Q_N#1	3.12388e-18
C752	VGND#14	a_1555_410##6	1.23768e-17
C753	VGND#4	a_1555_410##4	1.77351e-18
C754	SET_B#9	a_27_74##5	2.90343e-18
C755	VPWR#16	VPWR#15	3.99449e-18
C756	a_2516_368##8	a_2516_368#	3.76046e-20
C757	RESET_B#6	a_1335_112##2	2.20218e-19
C758	a_473_405##4	a_200_74##5	4.97047e-17
C759	a_200_74##6	VPWR#9	1.11629e-18
C760	VGND#7	a_1555_410##2	1.10151e-19
C761	a_867_125#	a_601_119#	7.99705e-19
C762	a_200_74##6	a_1335_112##7	4.00994e-17
C763	a_867_125##2	a_601_119##2	3.98257e-18
C764	a_1555_410##17	a_1555_410##3	1.31527e-18
C765	a_200_74##10	a_601_119##6	8.485e-17
C766	a_975_322##9	RESET_B#2	5.20336e-19
C767	a_867_125#	VGND#17	5.37766e-17
C768	a_1555_410##5	a_2516_368##3	2.53294e-17
C769	a_867_125##2	a_975_322#	4.01042e-19
C770	a_1555_410##7	a_1555_410##9	1.45836e-19
C771	Q	VPWR#1	7.37357e-17
C772	Q	Q#1	8.9284e-19
C773	VPWR#3	a_1555_410##8	4.07108e-18
C774	VPWR#15	Q	8.56406e-17
C775	VGND#5	a_1555_410##9	6.50498e-19
C776	VGND#3	a_1555_410##4	2.13049e-18
C777	a_27_74##5	a_200_74##7	1.44282e-18
C778	a_975_322##8	RESET_B#2	2.45424e-17
C779	VPWR#4	VPWR#3	8.47442e-19
C780	a_2516_368##8	a_2516_368##2	1.34252e-19
C781	a_473_405##2	a_536_503#	2.64814e-19
C782	a_1555_410##3	VPWR#19	8.7987e-18
C783	a_1555_410##7	a_1555_410##11	9.15553e-18
C784	a_473_405##14	a_601_119#	3.23927e-17
C785	VPWR#16	a_2516_368##9	6.17012e-17
C786	VPWR#2	a_2516_368##4	6.05972e-18
C787	VGND#14	a_1555_410##5	2.46054e-19
C788	a_1335_112##7	SET_B#6	3.55896e-19
C789	SET_B#3	a_473_405##4	4.83551e-18
C790	a_473_405##8	a_473_405##13	5.21668e-18
C791	a_473_405##5	a_1335_112##7	3.8961e-18
C792	a_311_119##2	a_27_74##3	5.93349e-17
C793	a_1555_410##17	a_27_74##6	4.21406e-19
C794	a_1555_410##7	RESET_B#3	2.12895e-17
C795	a_2516_368##10	VGND#13	4.80219e-17
C796	a_867_125#	a_200_74##3	6.36028e-20
C797	VPWR#11	a_27_74##5	1.14196e-18
C798	VGND	VGND#8	3.70095e-17
C799	VGND	VGND#7	1.30265e-16
C800	VGND	VGND#5	1.15972e-16
C801	VGND	VGND#4	7.14409e-17
C802	VGND#3	a_2516_368##8	3.3459e-19
C803	VGND#4	a_1555_410##9	5.59945e-18
C804	VGND	VGND#3	4.12543e-17
C805	Q_N	a_1555_410##9	2.85873e-17
C806	VPWR#2	a_2516_368##6	2.42349e-18
C807	a_2516_368##8	a_2516_368##5	2.93417e-19
C808	Q_N	a_1555_410##11	2.30165e-17
C809	a_473_405##10	a_311_119#	1.4097e-16
C810	VGND	a_2516_368##8	3.07735e-18
C811	a_200_74##10	a_200_74##11	2.63999e-18
C812	Q_N	RESET_B#3	6.37955e-19
C813	a_601_119#	a_867_125##2	1.72144e-17
C814	a_1555_410##6	a_1555_410##5	1.42283e-19
C815	VPWR#4	a_1555_410##10	2.95136e-18
C816	a_2516_368##2	VNB	3.35848e-17
C817	D	a_27_74##2	6.68828e-18
C818	VGND#18	a_473_405##2	1.58155e-19
C819	a_1555_410##7	a_1335_112##3	2.0673e-19
C820	Q_N	a_1335_112##3	5.87961e-19
C821	a_473_405##8	a_27_74##5	1.87889e-19
C822	a_1555_410##6	VNB	3.8782e-17
C823	VPWR#11	a_601_119##6	4.36451e-18
C824	a_1555_410##5	VNB	4.7984e-17
C825	a_27_74##3	VNB	1.88893e-16
C826	VPWR	a_2516_368##9	1.94723e-17
C827	Q_N	a_975_322##6	2.26048e-19
C828	D	a_473_405#	2.03182e-17
C829	a_601_119##2	VNB	4.51425e-17
C830	VGND#7	a_200_74##8	3.13631e-19
C831	VPWR	VPWR#16	1.83797e-17
C832	VPWR	Q_N#1	1.61121e-17
C833	a_975_322##2	a_1240_125#	1.33477e-17
C834	a_473_405##5	VPWR#20	3.71356e-18
C835	a_975_322##9	a_1335_112##2	3.40976e-17
C836	a_27_74##3	D#2	1.82548e-18
C837	VGND#1	a_2516_368#	2.53548e-17
C838	VPWR	VPWR#17	1.76012e-17
C839	a_1555_410##6	Q_N#2	3.00716e-19
C840	VPWR	a_975_322##11	5.46215e-18
C841	a_311_119##4	a_473_405##2	5.36702e-19
C842	VGND	a_975_322##9	5.26152e-17
C843	Q_N#1	a_2516_368##9	9.33712e-18
C844	VPWR	a_1555_410##15	3.93208e-17
C845	VGND	a_975_322##8	4.85377e-18
C846	VGND	a_1335_112##5	3.14486e-18
C847	a_1335_112##7	a_1555_410##3	5.92597e-18
C848	a_473_405##14	a_200_74##3	9.36421e-20
C849	a_1555_410##7	a_975_322##6	5.821e-20
C850	VPWR#7	a_1555_410##12	3.63446e-19
C851	VGND#9	a_27_74##5	7.41818e-18
C852	VPWR	a_1555_410##17	2.26514e-17
C853	a_1335_112##7	SET_B#2	3.33611e-21
C854	a_1555_410##7	a_1555_410##6	9.50016e-19
C855	a_473_405##8	a_200_74##5	2.04875e-18
C856	a_975_322##8	a_1335_112##2	3.26168e-17
C857	a_27_74##5	a_473_405##6	4.37715e-17
C858	a_975_322##3	SET_B#3	2.82939e-17
C859	VPWR	a_1335_112##7	2.50854e-17
C860	a_200_74##10	a_601_119#	1.62178e-19
C861	VPWR#3	a_1555_410##10	3.79414e-19
C862	VGND#5	a_1555_410##11	1.06377e-17
C863	a_975_322##9	a_1832_74#	4.16149e-20
C864	a_311_119##2	a_601_119##2	1.16082e-17
C865	a_200_74##11	a_601_119##6	3.025e-17
C866	a_311_119##2	a_601_119#	4.11689e-18
C867	a_2516_368##8	a_1555_410##6	1.1262e-19
C868	a_473_405##10	VPWR#10	3.07442e-17
C869	a_473_405##10	a_601_119##5	2.91739e-17
C870	VGND#9	a_473_405##6	1.28667e-18
C871	VGND#14	VGND#13	6.85483e-19
C872	a_1335_112##5	a_1335_112##2	1.06195e-18
C873	a_473_405##8	VPWR#21	5.5702e-17
C874	a_200_74##11	VPWR#12	1.88053e-19
C875	a_867_125#	a_473_405##14	5.49363e-17
C876	Q#3	a_2516_368#	3.2976e-17
C877	VPWR#5	a_1555_410##12	3.75983e-18
C878	VPWR#12	VNB	3.94609e-17
C879	a_867_125##2	a_200_74##3	5.18666e-19
C880	VGND#18	D#2	7.77387e-19
C881	VPWR#10	VNB	4.71558e-17
C882	VPWR#9	VNB	4.80937e-17
C883	VPWR#8	VNB	4.88511e-17
C884	VPWR#7	VNB	3.39697e-17
C885	VPWR#5	VNB	3.5383e-17
C886	a_1335_112##2	RESET_B#3	2.58469e-20
C887	VPWR#4	VNB	3.05592e-17
C888	VGND#9	SET_B#1	1.28667e-18
C889	VPWR#3	VNB	2.86311e-17
C890	VPWR#11	a_200_74##11	3.04876e-18
C891	VGND	VGND#13	1.71308e-17
C892	a_27_74##5	SET_B#1	1.81477e-17
C893	VGND	a_2516_368##10	1.66143e-17
C894	VGND#10	a_311_119##4	6.22774e-18
C895	a_1335_112##7	a_27_74##6	7.37433e-17
C896	Q_N#1	VPWR#16	6.37542e-17
C897	VGND#10	VNB	3.38193e-17
C898	VGND#8	VNB	8.09189e-17
C899	SET_B#10	a_473_405##13	1.01707e-18
C900	VGND#7	VNB	6.81158e-17
C901	a_311_119##4	D#2	1.5303e-17
C902	a_601_119##7	a_601_119#	3.31494e-19
C903	VGND#9	a_601_119##6	7.08622e-19
C904	VGND#5	VNB	4.8967e-17
C905	VGND	a_975_322##7	3.39278e-18
C906	VGND#4	VNB	3.29204e-17
C907	SET_B#2	a_473_405##13	5.19868e-19
C908	VGND#3	VNB	2.62251e-17
C909	a_200_74##10	a_27_74##2	1.41456e-17
C910	a_2516_368##8	a_1555_410##4	1.85637e-18
C911	VGND	a_1832_74#	2.09079e-17
C912	a_473_405##10	a_473_405##5	8.12266e-19
C913	VGND#1	a_2516_368##5	2.20217e-18
C914	VGND	a_1555_410##13	1.53631e-17
C915	a_2516_368##8	VNB	1.97287e-18
C916	VGND	a_1832_74##2	2.12775e-17
C917	VPWR#20	a_1555_410##3	1.48414e-19
C918	VPWR#10	SET_B#2	3.47032e-20
C919	a_601_119##7	a_27_74##3	2.78467e-18
C920	VGND	a_1335_112##6	1.88311e-17
C921	a_200_74##14	D#2	8.77731e-19
C922	a_601_119##4	a_975_322##3	4.34104e-17
C923	RESET_B#6	VNB	3.88141e-18
C924	a_975_322##9	a_975_322##5	2.19258e-17
C925	a_601_119##5	a_311_119#	5.02049e-17
C926	a_601_119##6	a_27_74##3	1.38142e-19
C927	Q	a_2516_368##4	4.23382e-17
C928	VGND#3	VGND#1	2.73705e-19
C929	Q	a_2516_368##6	3.21379e-17
C930	a_975_322##9	VNB	3.95504e-17
C931	a_200_74##3	a_311_119##2	2.03929e-17
C932	a_975_322##8	VNB	9.81126e-18
C933	VPWR	a_27_74##5	6.92519e-20
C934	a_1335_112##5	VNB	1.25557e-17
C935	Q	a_1555_410##8	1.73757e-18
C936	a_975_322##8	a_1832_74#	4.01327e-19
C937	a_200_74##10	a_473_405#	2.3867e-18
C938	VGND#13	a_2516_368#	1.31405e-18
C939	VPWR#9	SET_B#2	3.22536e-20
C940	Q	a_1555_410##10	4.99958e-20
C941	a_311_119##4	a_27_74##8	1.28662e-20
C942	a_473_405##8	a_473_405##4	1.01474e-17
C943	SET_B#1	a_473_405##6	2.87277e-17
C944	a_473_405##8	VNB	1.04529e-17
C945	VPWR#2	VPWR#3	1.35198e-17
C946	a_975_322##2	VPWR#20	6.13924e-19
C947	a_975_322##8	a_975_322##5	5.52412e-19
C948	a_27_74##5	a_975_322#	1.63195e-17
C949	SET_B#10	VNB	1.6021e-18
C950	VGND	VPWR#15	3.35628e-18
C951	SET_B#7	VNB	2.75187e-19
C952	a_975_322##9	a_1555_410##13	4.30168e-17
C953	VPWR#11	a_27_74##2	4.01341e-20
C954	a_867_125##2	a_867_125#	2.37845e-18
C955	VGND#14	a_2516_368##10	4.64545e-17
C956	VGND	Q_N#1	1.44047e-18
C957	a_601_119##6	VNB	1.46913e-17
C958	a_867_125##2	a_27_74##2	5.41156e-20
C959	a_1335_112##7	a_200_74##5	4.30227e-17
C960	VGND#5	RESET_B#3	6.28933e-18
C961	a_200_74##11	VNB	6.3951e-18
C962	Q#3	a_2516_368##5	3.97628e-17
C963	a_2516_368##8	a_1555_410##5	6.75798e-17
C964	VPWR#17	VPWR#16	2.06267e-18
C965	a_27_74##10	VNB	6.26677e-18
C966	a_473_405##10	SET_B#2	2.14012e-19
C967	a_975_322##5	a_1335_112##3	9.42417e-18
C968	a_1335_112##5	a_975_322##5	1.54172e-19
C969	CLK_N#6	VNB	1.20455e-17
C970	a_975_322##11	RESET_B#6	3.52957e-17
C971	VPWR	a_2516_368##6	1.77229e-20
C972	VGND#9	a_200_74##3	1.25976e-18
C973	CLK_N#4	VNB	1.12552e-17
C974	VPWR#20	a_27_74##6	3.54957e-19
C975	a_311_119##4	a_27_74##7	7.57699e-19
C976	VGND#1	VNB	2.0739e-17
C977	VPWR	a_1555_410##8	8.52713e-18
C978	VPWR#11	a_27_74##10	3.1059e-18
C979	VGND	a_1335_112##7	3.51624e-18
C980	Q#3	VNB	2.18335e-17
C981	a_601_119##7	a_200_74##3	3.38353e-17
C982	VGND#13	VNB	5.36675e-18
C983	VPWR	a_1555_410##10	2.16936e-18
C984	a_2516_368##10	VNB	1.06171e-17
C985	D	a_200_74##10	2.61523e-17
C986	VGND#14	VNB	1.14077e-17
C987	VPWR	a_1555_410##12	3.77996e-18
C988	VPWR#10	a_601_119##2	9.26343e-20
C989	VGND#9	a_200_74##11	5.26817e-18
C990	a_975_322##7	VNB	1.05801e-18
C991	VPWR	RESET_B#1	6.39643e-18
C992	VPWR#11	D	4.58775e-18
C993	a_975_322##2	VPWR#21	1.39377e-18
C994	a_1832_74#	VNB	7.58002e-18
C995	a_1555_410##13	VNB	6.81921e-18
C996	VGND#9	D	5.2736e-18
C997	a_200_74##10	a_27_74##4	2.18004e-19
C998	a_27_74#	a_601_119##4	6.25471e-18
C999	a_1832_74##2	VNB	4.57092e-18
C1000	VPWR	a_975_322##4	9.08242e-19
C1001	a_200_74##14	a_27_74##7	8.62058e-18
C1002	VGND#16	VNB	2.09127e-18
C1003	VPWR#5	RESET_B#1	2.15579e-18
C1004	VGND#1	a_1555_410##4	5.38554e-19
C1005	SET_B#10	VPWR#21	5.02852e-20
C1006	a_1335_112##6	VNB	4.76032e-18
C1007	VPWR	a_1555_410##3	1.53966e-18
C1008	VGND#17	VNB	2.2828e-18
C1009	VGND#9	a_27_74##2	7.91728e-20
C1010	a_867_125#	VNB	9.36615e-18
C1011	VPWR	a_27_74##6	3.79636e-19
C1012	a_867_125##2	VNB	9.20738e-18
C1013	VPWR	a_200_74##5	1.21414e-18
C1014	a_311_119##2	a_27_74##2	3.26006e-18
C1015	a_311_119##2	VNB	2.82023e-17
C1016	VGND#18	VNB	7.07566e-18
C1017	Q	VPWR#2	3.64475e-17
C1018	SET_B#7	a_27_74##5	1.85052e-19
C1019	a_311_119##4	VNB	1.42314e-17
C1020	VGND	a_1555_410##4	1.05916e-18
C1021	a_200_74##14	VNB	1.86645e-17
C1022	a_2516_368##8	a_1555_410##9	6.72446e-19
C1023	VGND#2	Q	3.07818e-18
C1024	VGND	a_1555_410##9	6.57747e-18
C1025	SET_B#10	a_473_405##4	3.0776e-19
C1026	VGND#8	a_473_405##5	2.6553e-19
C1027	VGND#19	VNB	1.90168e-18
C1028	a_601_119##6	a_601_119##2	3.39602e-19
C1029	SET_B#4	a_975_322##5	8.70923e-18
C1030	a_27_74##12	VNB	3.96722e-17
C1031	VGND	a_1555_410##11	6.57747e-18
C1032	VPWR#1	VNB	4.15325e-17
C1033	VGND#7	a_1335_112##3	2.62277e-19
C1034	a_2516_368##5	VGND#13	2.01266e-17
C1035	VGND	a_1335_112##3	2.06081e-18
C1036	VPWR#15	VNB	3.35688e-18
C1037	a_975_322##9	SET_B#5	4.15569e-17
C1038	a_2516_368##9	VNB	1.1472e-17
C1039	VGND	a_975_322##6	1.43946e-18
C1040	VPWR#16	VNB	1.0845e-17
C1041	a_1335_112##7	a_473_405##4	7.87099e-18
C1042	VGND	SET_B#4	1.74067e-18
C1043	a_1555_410##7	Q_N	6.97268e-17
C1044	Q_N#1	VNB	4.82045e-18
C1045	VGND#9	a_473_405#	2.2169e-18
C1046	VPWR#17	VNB	5.83466e-18
C1047	a_473_405##10	a_975_322##2	3.98795e-17
C1048	a_473_405##14	a_867_125##2	5.25313e-17
C1049	a_975_322##11	VNB	5.40006e-18
C1050	VGND	a_200_74##7	7.16263e-19
C1051	VPWR#11	CLK_N#6	3.36636e-18
C1052	a_1555_410##15	VNB	1.37884e-17
C1053	a_1555_410##13	a_975_322##8	5.01135e-17
C1054	VGND#3	Q#3	3.41788e-18
C1055	VPWR#17	Q_N#1	2.78907e-17
C1056	a_473_405##8	SET_B#3	3.86188e-17
C1057	a_1555_410##17	VNB	5.00743e-18
C1058	VPWR#20	a_200_74##5	3.0322e-18
C1059	a_1335_112##7	VNB	2.96631e-18
C1060	a_975_322#	SET_B#1	2.83466e-17
C1061	VPWR#20	VNB	3.32862e-18
C1062	a_311_119##4	a_601_119#	1.29596e-19
C1063	VPWR#21	VNB	5.64567e-19
C1064	a_2516_368##3	Q	4.01342e-17
C1065	a_975_322##8	RESET_B#6	3.08433e-18
C1066	Q#3	a_1555_410##4	2.58254e-18
C1067	a_473_405##10	VNB	1.2229e-17
C1068	a_311_119#	VNB	1.26549e-17
C1069	VPWR	VPWR#6	5.30714e-17
C1070	D	a_601_119##3	4.33141e-19
C1071	a_601_119##7	a_27_74##2	1.83612e-17
C1072	a_975_322##9	a_1832_74##2	3.79536e-17
C1073	VGND#9	D#3	6.57847e-18
C1074	VPWR#22	VNB	1.68692e-18
C1075	D	a_200_74##4	1.4188e-18
C1076	a_311_119##6	VNB	1.05479e-17
C1077	VGND#4	VGND#13	8.38671e-19
C1078	a_200_74##12	VNB	3.29094e-17
C1079	VPWR#23	VNB	2.82484e-18
C1080	SET_B#9	VPWR	1.02444e-17
C1081	a_200_74#	a_27_74#	1.61521e-17
C1082	a_27_74##11	VNB	5.22806e-17
C1083	a_473_405##10	a_473_405##8	2.95173e-18
C1084	VGND#9	a_27_74##10	5.75761e-18
C1085	a_2516_368#	VNB	2.91618e-17
C1086	a_200_74##14	CLK_N#2	7.7248e-20
C1087	a_2516_368##5	VNB	2.89116e-17
C1088	D	a_473_405##2	5.96992e-19
C1089	VPWR#7	a_1335_112#	2.21949e-18
C1090	a_1555_410##4	VNB	3.49103e-17
C1091	VPWR#9	a_27_74##5	9.87635e-19
C1092	a_1555_410##9	VNB	3.06783e-17
C1093	a_1335_112##5	SET_B#5	2.56926e-17
C1094	a_1555_410##11	VNB	2.85455e-17
C1095	D	D#2	2.0398e-17
C1096	VGND#5	a_1335_112##3	2.04671e-18
C1097	RESET_B#3	VNB	1.83918e-17
C1098	a_1335_112##3	VNB	3.40199e-17
C1099	VPWR	a_2516_368##3	1.2823e-18
C1100	a_2516_368##10	a_2516_368##5	9.05765e-19
C1101	RESET_B#6	a_1555_410##15	4.79338e-18
C1102	a_975_322##6	VNB	2.63663e-17
C1103	SET_B#4	VNB	3.31386e-17
C1104	VPWR	a_1555_410##7	6.19007e-18
C1105	a_1555_410#	VNB	3.77944e-17
C1106	VPWR#6	a_1335_112#	4.79526e-18
C1107	a_200_74##7	VNB	2.8829e-17
C1108	a_311_119##2	a_473_405#	6.14238e-18
C1109	VGND#9	a_27_74##4	1.0498e-17
C1110	a_27_74##5	VNB	1.84435e-16
C1111	a_473_405##6	VNB	2.75741e-17
C1112	VPWR	a_1335_112##2	1.09188e-17
C1113	SET_B#1	VNB	2.65053e-17
C1114	a_473_405##14	a_473_405##10	1.0574e-18
C1115	a_975_322#	VNB	2.65531e-17
C1116	a_601_119#	VNB	2.74119e-17
C1117	VGND#6	a_1832_74#	4.74709e-17
C1118	a_1335_112##7	SET_B#3	5.35429e-19
C1119	a_473_405##10	a_601_119##3	1.77266e-18
C1120	a_200_74##3	VNB	1.7245e-17
C1121	VPWR	SET_B#5	1.21332e-18
C1122	a_27_74##2	VNB	5.97452e-17
C1123	a_1555_410#	SET_B#5	1.41196e-17
C1124	a_473_405#	VNB	3.17311e-17
C1125	VPWR	a_1555_410##2	6.14281e-18
C1126	D#3	VNB	2.43116e-17
C1127	a_27_74##4	VNB	9.64437e-17
C1128	VPWR	a_200_74##8	1.24158e-18
C1129	CLK_N#3	VNB	3.48059e-17
C1130	a_27_74##12	CLK_N#2	5.78863e-18
C1131	VPWR	a_200_74##6	3.06013e-18
C1132	VPWR#20	a_473_405##4	3.63249e-17
C1133	a_2516_368##8	a_2516_368##6	8.15204e-20
C1134	a_2516_368##4	VNB	4.6361e-17
C1135	a_2516_368##6	VNB	3.67668e-17
C1136	a_1555_410##4	VGND#13	2.64073e-17
C1137	a_1555_410##8	VNB	3.92815e-17
C1138	a_1555_410##10	VNB	3.92463e-17
C1139	a_311_119##2	a_473_405##14	4.47499e-17
C1140	a_1555_410##12	VNB	3.43292e-17
C1141	VGND#9	CLK_N#3	2.59646e-18
C1142	RESET_B#1	VNB	3.06468e-17
C1143	SET_B#10	SET_B#3	3.40601e-18
C1144	a_311_119#	a_601_119##3	1.41025e-17
C1145	a_1335_112#	VNB	3.42294e-17
C1146	a_975_322##4	VNB	3.86678e-17
C1147	SET_B#6	VNB	4.00677e-17
C1148	VGND	a_200_74##17	1.43752e-17
C1149	a_1555_410##3	VNB	2.72779e-17
C1150	VGND	VGND#6	4.9288e-17
C1151	a_27_74##6	VNB	5.85557e-17
C1152	a_200_74##5	VNB	2.73725e-17
C1153	VPWR#8	a_27_74##5	1.25888e-20
C1154	VGND#19	VGND#10	2.99733e-19
C1155	a_473_405##4	VNB	2.76348e-17
C1156	a_311_119##4	a_200_74##3	5.57339e-19
C1157	a_1335_112##5	VPWR#8	1.19591e-18
C1158	SET_B#3	VNB	3.30158e-17
C1159	a_975_322##3	VNB	2.64016e-17
C1160	a_975_322##9	a_1555_410##2	2.86119e-19
C1161	VGND#4	a_1335_112##3	1.24106e-19
C1162	a_601_119##4	VNB	3.42868e-17
C1163	VGND#14	VPWR#16	9.38493e-18
C1164	a_27_74#	VNB	7.5059e-17
C1165	VGND	a_2516_368##3	2.08752e-18
C1166	a_601_119##7	a_473_405#	2.36572e-18
C1167	a_200_74#	VNB	2.16187e-17
C1168	VPWR#3	VPWR#1	3.89612e-19
C1169	VGND	a_1555_410##7	1.14902e-17
C1170	VGND#7	a_975_322##6	2.07867e-18
C1171	a_473_405##3	VNB	2.1696e-17
C1172	VGND#14	a_2516_368##5	4.93585e-20
C1173	D#1	VNB	4.52662e-17
C1174	VGND	RESET_B#2	4.55882e-18
C1175	a_473_405##8	a_975_322##3	1.57908e-18
C1176	a_473_405##3	a_200_74#	2.46782e-17
C1177	a_27_74##8	VNB	3.88585e-17
C1178	VGND	a_1335_112##2	3.87619e-18
C1179	Q#3	a_1555_410##9	1.52797e-19
C1180	CLK_N#1	VNB	4.74132e-17
C1181	VGND	a_975_322##5	3.32079e-19
C1182	VPWR#2	VNB	1.16464e-16
C1183	VGND	SET_B#5	4.44441e-18
C1184	VGND#2	VNB	1.17848e-16
C1185	VGND	a_1555_410##2	8.83443e-21
C1186	SET_B#5	a_27_74##5	3.01403e-20
C1187	a_601_119#	a_975_322#	2.98621e-17
C1188	VGND	a_200_74##8	5.56898e-18
C1189	VPWR#8	a_975_322##4	3.10824e-19
C1190	VPWR#6	VNB	2.97784e-17
C1191	a_200_74##17	VNB	5.60616e-18
C1192	VGND#6	VNB	2.9478e-17
C1193	a_867_125##2	a_473_405##10	8.42036e-19
C1194	VGND#18	a_27_74##2	1.78812e-19
C1195	SET_B#9	VNB	6.50048e-18
C1196	VPWR#10	a_601_119##3	1.21541e-20
C1197	VGND#6	a_1832_74##2	1.85618e-17
C1198	a_200_74##10	VNB	7.55147e-18
C1199	VPWR#11	VNB	3.45892e-16
C1200	VGND	a_975_322##2	7.16053e-18
C1201	VGND#9	VNB	3.24617e-16
C1202	a_2516_368##3	VNB	3.39746e-17
C1203	a_975_322##9	VGND#16	7.14603e-17
C1204	a_1555_410##7	VNB	2.56081e-17
C1205	a_1335_112##6	a_200_74##17	6.8709e-17
C1206	a_601_119##6	a_311_119##2	4.90253e-17
C1207	RESET_B#2	VNB	2.66897e-17
C1208	a_311_119##2	D#3	3.17647e-19
C1209	a_1335_112##2	VNB	4.25713e-17
C1210	a_1555_410##4	a_2516_368##10	1.86498e-17
C1211	a_975_322##5	VNB	2.9446e-17
C1212	SET_B#5	VNB	4.1236e-17
C1213	a_1555_410##2	VNB	8.09004e-17
C1214	VPWR#20	SET_B#3	2.67804e-18
C1215	a_200_74##8	VNB	4.97694e-17
C1216	a_200_74##6	VNB	2.67763e-17
C1217	a_473_405##5	VNB	5.69224e-17
C1218	VGND#4	a_2516_368##10	6.76754e-18
C1219	SET_B#2	VNB	3.17978e-17
C1220	a_1335_112##5	a_1555_410##2	1.13279e-16
C1221	a_975_322##2	VNB	5.47345e-17
C1222	VGND#9	CLK_N#4	3.35985e-18
C1223	a_601_119##3	VNB	5.61744e-17
C1224	a_1555_410##15	Q_N#1	1.29597e-18
C1225	a_200_74##4	VNB	2.1661e-17
C1226	VPWR#21	a_473_405##4	4.80942e-19
C1227	a_200_74##2	VNB	2.63709e-17
C1228	a_473_405##2	VNB	4.19558e-17
C1229	D#2	VNB	6.32017e-17
C1230	a_27_74##7	VNB	4.38779e-17
C1231	VGND#5	a_975_322##6	1.95902e-19
C1232	a_311_119##2	a_867_125##2	8.07651e-17
C1233	CLK_N#2	VNB	5.38138e-17
C1234	VPWR#7	a_975_322##4	1.34656e-17
C1235	a_473_405##10	SET_B#10	3.27954e-18
C1236	a_601_119##5	a_200_74##4	5.2446e-20
C1237	a_27_74##5	a_1555_410##2	1.40504e-19
C1238	a_311_119##4	a_27_74##2	4.77002e-18
C1239	a_200_74##8	a_1555_410#	1.67503e-17
C1240	VGND#5	VGND#14	3.02611e-18
C1241	a_27_74##3	VGND#18	7.08313e-19
C1242	SET_B#3	a_473_405##13	2.57566e-17
C1243	D#1	a_473_405##3	1.19832e-17
C1244	SET_B#10	a_975_322##3	2.31154e-18
C1245	a_311_119##2	a_473_405##10	1.27216e-18
C1246	a_2516_368##8	a_1555_410##8	3.44349e-18
C1247	VGND#14	a_1555_410##4	1.61841e-18
C1248	a_200_74##17	VGND#17	1.38484e-17
C1249	VGND	Q_N	1.76285e-17
C1250	a_200_74##8	a_200_74##7	1.10615e-18
C1251	D	VNB	1.79893e-18
C1252	Q_N	VNB	2.5347e-18
C1253	a_473_405#	VGND#18	1.65146e-17
C1254	Q	VNB	2.25238e-17
C1255	VPWR	VNB	2.50671e-16
C1256	a_975_322##9	a_200_74##8	1.5816e-18
C1257	VPWR#20	a_975_322##3	3.84869e-19
C1258	VGND	VNB	2.68917e-16
C1259	a_473_405##8	a_601_119##4	3.03057e-19
C1260	a_311_119##2	a_27_74##4	7.48049e-20
C1261	a_27_74##10	VPWR#13	2.51872e-19
C1262	VPWR#13	VNB	5.6762e-17
C1263	VPWR#13	CLK_N#1	7.91686e-18
C1264	VPWR#13	a_27_74##8	6.49876e-18
C1265	VPWR#13	CLK_N#2	1.54809e-19
C1266	VPWR#13	a_27_74##7	3.6845e-20
C1267	a_27_74##11	VPWR#13	2.11451e-17
C1268	VPWR#11	VPWR#13	1.06396e-16
C1269	VPWR#13	a_200_74##12	4.40203e-17
C1270	VPWR#13	VPWR#12	2.33391e-19
C1271	VGND#11	CLK_N#3	7.03105e-18
C1272	SET_B	SET_B#5	5.98632e-19
C1273	VGND#11	a_27_74##7	2.83249e-19
C1274	SET_B	SET_B#6	1.60522e-17
C1275	SET_B	a_1335_112##6	4.96994e-18
C1276	VGND#11	VNB	5.11025e-17
C1277	VGND#9	VGND#11	1.18058e-16
C1278	VGND#11	a_27_74##12	1.82593e-17
C1279	SET_B	a_975_322##4	3.68321e-18
C1280	SET_B	a_975_322##11	1.74758e-18
C1281	SET_B	VPWR#7	1.51188e-18
C1282	SET_B	a_1335_112##7	3.44248e-17
C1283	VGND#11	CLK_N#2	1.61521e-19
C1284	SET_B	a_1335_112##2	8.45249e-18
C1285	SET_B	VNB	1.74162e-17
C1286	SET_B	a_1335_112#	5.96302e-19
C1287	SET_B	VGND#16	2.89038e-18
C1288	SET_B	VPWR#8	8.32196e-18
C1289	SET_B	RESET_B#1	2.47142e-19
C1290	a_1335_112##5	SET_B	9.8431e-17
C1291	SET_B	a_200_74##17	1.47846e-18
C1292	SET_B	VPWR#9	7.31548e-20
C1293	VGND#11	a_200_74##14	1.81767e-17
C1294	SET_B	a_1555_410##17	7.06947e-18
C1295	VGND#11	a_27_74##4	2.0232e-17
C1296	SET_B	VPWR	3.95231e-17
C1297	SET_B	a_200_74##8	8.35142e-18
C1298	SET_B	a_975_322##9	1.18129e-17
C1299	SET_B	a_27_74##6	1.74366e-18
C1300	VGND#11	a_27_74##10	5.28711e-19
C1301	SET_B	a_1555_410##2	2.86366e-17
C1302	VGND#11	VGND#10	5.92995e-19
*
*
.ENDS sky130_fd_sc_hs__dfbbn_2
*
