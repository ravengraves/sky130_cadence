* Extracted by Quantus, converted by sky130cad/quantus.py
*
*
*
*                       LINUX           Wed Nov 18 09:07:38 2026
*
*
*
*  PROGRAM  advgen
*
*  Name           : advgen - Quantus - (64-bit)
*  Version        : 25.1.0-p047
*  Build Date     : Thu Dec 11 23:20:30 PST 2025
*
*  HSPICE LIBRARY
*
*  OPERATING_TEMPERATURE 150
*  QRC_TECH_DIR <path>/tech
*
*
*

*
.SUBCKT sky130_fd_sc_hs__or4_4 VNB VPB VGND VPWR X D B C A
*
*
*  caps2d version: 10
*
*
*       TRANSISTOR CARDS
*
*
XM10 VGND#7 a_83_264##13 X#3 VNB sky130_fd_pr__nfet_01v8_lvt l=0.15 w=0.74 ad=0.2627 as=0.2072 pd=2.19 ps=2.04
XM13 VGND#10 a_83_264##11 X#3 VNB sky130_fd_pr__nfet_01v8_lvt l=0.15 w=0.74 ad=0.259 as=0.2072 pd=2.18 ps=2.04
XM18 X#5 a_83_264##9 VGND#10 VNB sky130_fd_pr__nfet_01v8_lvt l=0.15 w=0.74 ad=0.4477 as=0.259 pd=2.69 ps=2.18
XM19 X#5 a_83_264# VGND#9 VNB sky130_fd_pr__nfet_01v8_lvt l=0.15 w=0.74 ad=0.4477 as=0.367 pd=2.69 ps=2.54
XM3 VGND#9 B#1 a_83_264##19 VNB sky130_fd_pr__nfet_01v8_lvt l=0.15 w=0.74 ad=0.367 as=0.2072 pd=2.54 ps=2.04
XM8 a_83_264##19 A#4 VGND#8 VNB sky130_fd_pr__nfet_01v8_lvt l=0.15 w=0.74 ad=0.2072 as=1.007 pd=2.04 ps=4.14
XM2 VGND#8 C#3 a_83_264##15 VNB sky130_fd_pr__nfet_01v8_lvt l=0.15 w=0.74 ad=1.007 as=0.259 pd=4.14 ps=2.18
XM6 a_83_264##15 D#4 VGND#4 VNB sky130_fd_pr__nfet_01v8_lvt l=0.15 w=0.74 ad=0.259 as=0.3445 pd=2.18 ps=3.08
XM0 VPWR#8 a_83_264##7 X#4 VPB sky130_fd_pr__pfet_01v8 l=0.15 w=1.12 ad=0.3304 as=0.336 pd=2.83 ps=2.84
XM14 X#4 a_83_264##12 VPWR#7 VPB sky130_fd_pr__pfet_01v8 l=0.15 w=1.12 ad=0.336 as=0.336 pd=2.84 ps=2.84
XM16 X#1 a_83_264##10 VPWR#7 VPB sky130_fd_pr__pfet_01v8 l=0.15 w=1.12 ad=0.336 as=0.336 pd=2.84 ps=2.84
XM7 VPWR#5 a_83_264##8 X#1 VPB sky130_fd_pr__pfet_01v8 l=0.15 w=1.12 ad=0.3304 as=0.336 pd=2.83 ps=2.84
XM4 a_499_392##4 B#3 a_588_392# VPB sky130_fd_pr__pfet_01v8 l=0.15 w=1 ad=0.295 as=0.3 pd=2.59 ps=2.6
XM5 VPWR#3 A#5 a_588_392# VPB sky130_fd_pr__pfet_01v8 l=0.15 w=1 ad=0.3 as=0.3 pd=2.6 ps=2.6
XM15 a_588_392##2 A#1 VPWR#3 VPB sky130_fd_pr__pfet_01v8 l=0.15 w=1 ad=0.32 as=0.3 pd=2.64 ps=2.6
XM11 a_588_392##2 B#4 a_499_392##2 VPB sky130_fd_pr__pfet_01v8 l=0.15 w=1 ad=0.32 as=0.35 pd=2.64 ps=2.7
XM17 a_499_392##2 C#1 a_962_392##2 VPB sky130_fd_pr__pfet_01v8 l=0.15 w=1 ad=0.35 as=0.35 pd=2.7 ps=2.7
XM9 a_962_392##2 D#6 a_83_264##14 VPB sky130_fd_pr__pfet_01v8 l=0.15 w=1 ad=0.35 as=0.3 pd=2.7 ps=2.6
XM1 a_83_264##14 D#5 a_962_392# VPB sky130_fd_pr__pfet_01v8 l=0.15 w=1 ad=0.3 as=0.3 pd=2.6 ps=2.6
XM12 a_962_392# C#4 a_499_392# VPB sky130_fd_pr__pfet_01v8 l=0.15 w=1 ad=0.3 as=0.345 pd=2.6 ps=2.69
*
*
*       RESISTOR AND CAP/DIODE CARDS
*
Rg1	a_83_264#	a_83_264##2	432.173248
Rg2	a_83_264##2	a_83_264##3	49.655273
Rg3	a_83_264##3	a_83_264##4	26.440405
Rg4	a_83_264##4	a_83_264##5	91.708717
Rg5	a_83_264##5	a_83_264##6	90.766624
Rg6	a_83_264##6	a_83_264##7	490.476624
Rg7	a_83_264##2	a_83_264##8	446.171570
Rg8	a_83_264##3	a_83_264##9	398.499390
Rg9	a_83_264##4	a_83_264##10	414.808441
Rg10	a_83_264##5	a_83_264##11	418.669952
Rg11	a_83_264##5	a_83_264##12	450.232361
Rg12	a_83_264##6	a_83_264##13	384.750488
Rg13	B#1	B#2	307.937683
Rg14	B#2	B#3	510.276459
Rg15	A#1	A#2	422.014893
Rg16	A#2	A#3	32.582375
Rg17	A#3	A#4	466.419159
Rg18	A#3	A#5	415.223511
Rg19	B#4	B#5	509.830780
Rg20	C#1	C#2	413.532104
Rg21	C#2	C#3	434.187317
Rg22	C#4	C#5	425.824738
Rg23	D#1	D#2	598.099670
Rg24	D#2	D#3	59.891499
Rg25	D#3	D#4	298.617615
Rg26	D#2	D#5	548.872437
Rg27	D#3	D#6	548.872437
Rf1	X	X#1	23.586817
Rf2	X	X#2	24.350956
Rf3	X#2	X#3	20.278393
Rf4	X	X#4	24.496561
Rf5	X#2	X#5	78.822159
Rf6	A#2	A	161.413818
Rf7	a_588_392#	a_588_392##2	67.393311
Rf8	B#5	B	232.665054
Rf9	B	B#7	4.376343
Rf10	B#7	B	10.628263
Rf11	a_962_392#	a_962_392##2	71.395279
Rf12	C#2	C	168.898529
Rf13	C	C#5	164.976013
Rf14	a_499_392#	a_499_392##3	137.745316
Rf15	a_499_392##3	a_499_392##4	161.655884
Rf16	a_499_392##2	a_499_392##3	5.000000
Rf17	D	D#1	81.494255
Rf18	a_83_264##14	a_83_264##16	276.871643
Rf19	a_83_264##16	a_83_264##17	126.760597
Rf20	a_83_264##17	a_83_264##2	164.904114
Rf21	a_83_264##17	a_83_264##19	11.260589
Rf22	a_83_264##15	a_83_264##16	7.500000
Rf24	VGND#2	VGND#3	179.595764
Rf25	VGND#2	VGND#4	14.322456
Rf26	VGND#3	VGND#5	58.399990
Rf27	VGND#5	VGND#6	93.439697
Rf28	VGND#6	VGND#7	104.232445
Rf29	VGND#3	VGND#8	10.295258
Rf30	VGND#5	VGND#9	28.425774
Rf31	VGND#6	VGND#10	34.507496
Rf33	VPWR#2	VPWR#3	35.446526
Rf34	VPWR#2	VPWR#4	93.480103
Rf35	VPWR#4	VPWR#5	32.518913
Rf36	VPWR#4	VPWR#6	65.696381
Rf37	VPWR#6	VPWR#7	32.518913
Rf38	VPWR#6	VPWR#8	96.140053
Rf41	B#2	B#7	160.232803
Re1	VPWR#2	VPWR	0.701577
Re2	VGND	VGND#3	0.701602
*
*       CAPACITOR CARDS
*
*
C1	VGND#10	VGND#9	1.80191e-18
C2	VPWR#8	VPWR#6	1.22366e-18
C3	X#5	VGND#10	5.4251e-17
C4	VGND#3	A#3	2.19072e-18
C5	D#4	D#2	1.7939e-17
C6	D#3	VGND#4	6.9557e-19
C7	a_83_264##15	a_83_264##14	2.38635e-18
C8	X#2	a_83_264##6	2.1244e-17
C9	D#2	VGND#4	5.56456e-19
C10	VGND#7	VGND#10	2.50436e-18
C11	X#2	a_83_264##5	1.18727e-17
C12	C#3	D#3	4.42226e-18
C13	a_83_264##15	a_499_392##2	4.20646e-18
C14	X#2	a_83_264##4	6.39255e-18
C15	a_83_264##15	D#3	6.01604e-18
C16	a_83_264##15	D#2	2.66485e-17
C17	D#2	C#5	2.41572e-17
C18	VPWR#4	a_83_264#	1.68438e-19
C19	VGND#6	B#1	2.62048e-20
C20	VGND#5	B#1	3.02481e-18
C21	a_83_264##17	C#3	4.37904e-19
C22	a_499_392#	a_962_392#	8.01201e-17
C23	VGND#6	a_83_264#	3.58091e-19
C24	C#2	D#3	4.43393e-17
C25	C#2	D#2	3.03854e-18
C26	VGND#5	a_83_264#	8.41451e-18
C27	C#2	A#3	1.56496e-18
C28	a_499_392#	a_83_264##14	9.60101e-17
C29	a_83_264##17	A#4	3.76552e-17
C30	VGND#6	a_83_264##9	3.88119e-18
C31	a_962_392#	a_83_264##14	1.02025e-18
C32	a_83_264##17	B#1	2.99104e-17
C33	VPWR#6	VPWR#4	1.22166e-18
C34	VGND#6	a_83_264##11	4.58221e-18
C35	a_499_392##2	a_499_392#	9.8276e-19
C36	B#5	D#3	1.02574e-18
C37	a_83_264##17	a_83_264#	9.78762e-19
C38	A#3	B#5	3.3802e-17
C39	a_962_392##2	a_83_264##14	6.56511e-19
C40	VGND#6	a_83_264##13	5.86232e-19
C41	a_499_392##2	a_83_264##14	2.34983e-17
C42	a_83_264##17	a_83_264##9	1.4727e-19
C43	a_499_392##2	a_962_392##2	8.24935e-17
C44	D#4	VGND#4	9.84465e-18
C45	a_83_264##15	D#4	2.44126e-17
C46	a_83_264##4	a_83_264#	6.39205e-19
C47	a_499_392##2	a_588_392##2	1.10586e-16
C48	a_83_264##15	C#3	6.25218e-17
C49	C#3	VGND#8	2.06978e-17
C50	a_83_264##15	A#4	1.15441e-18
C51	a_588_392##2	VPWR#3	3.78641e-17
C52	B#2	A#3	2.50213e-17
C53	A#4	VGND#8	2.30895e-17
C54	X#2	a_83_264#	2.42774e-19
C55	VGND#9	C#3	7.23445e-20
C56	a_83_264##15	B#1	2.07854e-19
C57	a_588_392#	a_588_392##2	2.39437e-18
C58	a_499_392##4	a_499_392##2	4.69995e-19
C59	a_83_264##4	B#2	4.94332e-19
C60	A#4	a_83_264##19	1.49617e-17
C61	VGND#6	VGND#5	2.42157e-19
C62	X#2	a_83_264##9	1.2604e-18
C63	VGND#7	VPWR#8	2.30757e-19
C64	a_588_392#	VPWR#3	4.19508e-17
C65	VGND#9	A#4	1.34738e-18
C66	a_499_392##4	a_588_392##2	2.26357e-18
C67	B#1	a_83_264##19	1.49617e-17
C68	a_499_392##4	VPWR#3	8.96845e-19
C69	X#2	a_83_264##11	4.1181e-17
C70	B#1	VGND#9	2.11959e-17
C71	a_83_264##2	A#3	9.00375e-19
C72	a_499_392##4	a_588_392#	9.84828e-17
C73	VPWR#5	VPWR#3	8.04116e-19
C74	VPWR#6	a_83_264##6	5.39805e-20
C75	a_83_264##2	a_83_264##5	1.10753e-18
C76	X#5	B#1	1.31974e-18
C77	a_83_264##4	X#5	8.84899e-18
C78	a_83_264##2	a_83_264##4	3.7944e-17
C79	X#2	a_83_264##13	2.40519e-17
C80	a_83_264#	VGND#9	2.90025e-17
C81	VGND#10	B#1	1.4659e-19
C82	a_83_264#	X#5	1.94783e-17
C83	VPWR#6	a_83_264##5	2.63232e-20
C84	VGND#9	a_83_264##9	1.8552e-18
C85	VPWR#5	a_499_392##4	4.94524e-17
C86	VGND#10	a_83_264#	1.06679e-18
C87	VGND#10	a_83_264##5	2.44798e-19
C88	X#5	a_83_264##9	3.96635e-17
C89	X#1	a_499_392##4	2.41824e-18
C90	VGND#10	a_83_264##9	3.77651e-17
C91	VPWR#6	a_83_264##4	2.23066e-20
C92	VGND#10	a_83_264##4	1.31409e-18
C93	X#5	a_83_264##11	4.24687e-19
C94	X#1	VPWR#5	5.84992e-17
C95	a_83_264##6	X#3	8.95007e-20
C96	a_83_264##11	VGND#10	1.75349e-17
C97	VGND#7	a_83_264##9	4.19974e-19
C98	VPWR#7	VPWR#5	2.06267e-18
C99	VPWR#4	a_83_264##8	9.75531e-19
C100	a_83_264##11	X#3	1.4935e-17
C101	a_83_264##5	X#3	1.57988e-19
C102	VGND#5	a_83_264##17	5.0543e-18
C103	VGND#10	a_83_264##13	8.93548e-19
C104	VPWR#7	X#1	5.8479e-17
C105	VGND#7	a_83_264##11	1.36469e-18
C106	VPWR#6	a_83_264##10	2.50507e-18
C107	a_83_264##13	X#3	1.5442e-17
C108	VPWR#4	a_83_264##4	2.02358e-20
C109	X#4	X#1	2.38265e-18
C110	VGND#7	a_83_264##13	2.62828e-17
C111	a_83_264##6	VGND#7	1.89224e-18
C112	X#4	VPWR#7	5.84992e-17
C113	VPWR#6	a_83_264##12	9.67868e-19
C114	VPWR#8	VPWR#7	2.06271e-18
C115	a_499_392#	D#2	2.39629e-19
C116	VPWR#8	X#4	5.8479e-17
C117	VGND#6	a_83_264##6	3.01711e-20
C118	a_499_392#	C#4	3.38835e-17
C119	a_962_392#	C#4	3.30865e-17
C120	a_499_392#	D#5	1.42548e-17
C121	VGND#6	a_83_264##5	6.47529e-20
C122	a_83_264##14	C#4	1.93944e-17
C123	VPWR#5	a_83_264#	7.59057e-19
C124	a_962_392#	D#2	1.50407e-19
C125	a_962_392#	D#5	4.14488e-17
C126	D#3	D#2	8.18755e-18
C127	a_499_392#	D#6	4.05548e-19
C128	a_83_264##14	D#5	3.61417e-17
C129	a_499_392##2	C#4	5.7541e-19
C130	C#3	D#4	2.62689e-17
C131	VGND#6	a_83_264##4	1.48395e-19
C132	a_499_392#	C#1	2.44698e-19
C133	a_83_264##14	D#6	3.05192e-17
C134	a_499_392##2	D#5	6.70033e-19
C135	a_83_264##14	D#3	3.43302e-19
C136	a_962_392##2	D#6	4.65202e-17
C137	A#4	C#3	1.55962e-18
C138	a_83_264##14	C#1	3.20875e-18
C139	a_499_392##2	D#6	2.23863e-17
C140	a_83_264##14	D#2	1.4816e-18
C141	VPWR#3	D#5	2.32635e-19
C142	C#1	a_962_392##2	2.35035e-17
C143	VGND#3	VGND#6	5.10123e-17
C144	VGND#3	VGND#5	4.45527e-17
C145	a_499_392##2	C#1	6.97034e-17
C146	VGND#5	a_83_264##4	2.7206e-19
C147	B#1	A#4	3.65953e-17
C148	VPWR#3	D#6	3.51269e-19
C149	a_588_392##2	C#1	1.1459e-18
C150	a_499_392##2	B#4	3.25763e-17
C151	VPWR#3	C#1	7.70125e-19
C152	a_962_392##2	D#3	9.4158e-20
C153	VGND#3	a_83_264##17	9.49393e-17
C154	a_588_392##2	B#4	4.68586e-17
C155	a_83_264#	B#1	1.78231e-17
C156	a_499_392##2	A#1	1.59178e-17
C157	VPWR#3	B#4	1.98283e-18
C158	VGND#6	X#2	1.51482e-17
C159	a_499_392##4	C#1	4.63667e-20
C160	a_588_392##2	A#1	3.52638e-17
C161	a_588_392#	B#4	1.96184e-19
C162	A	A#3	2.02648e-17
C163	a_499_392##2	A#5	1.0947e-19
C164	VPWR#3	A#1	3.4697e-17
C165	a_83_264##9	a_83_264#	1.22513e-17
C166	a_499_392##4	B#4	6.60352e-20
C167	A	a_83_264##4	4.0144e-19
C168	a_588_392##2	A#5	4.33021e-19
C169	a_588_392#	A#1	4.62907e-19
C170	a_499_392##2	B#3	1.36222e-19
C171	VPWR#3	A#5	3.25203e-17
C172	a_499_392##4	A#1	1.10137e-19
C173	a_499_392##2	D#3	1.583e-19
C174	a_588_392##2	B#3	1.91568e-19
C175	A#3	B#4	6.5655e-18
C176	a_588_392#	A#5	3.33055e-17
C177	a_83_264##11	a_83_264##9	2.38373e-17
C178	VPWR#3	B#3	2.19311e-18
C179	a_499_392##4	A#5	1.63158e-17
C180	a_588_392#	B#3	3.98557e-17
C181	VPWR#5	A#5	2.58443e-19
C182	C	D#2	1.66073e-17
C183	VPWR#3	a_83_264##8	3.9422e-19
C184	VGND#3	a_83_264##15	8.64715e-17
C185	a_499_392##4	B#3	4.66179e-17
C186	a_83_264##13	a_83_264##11	3.88454e-17
C187	a_499_392##2	A#3	4.22553e-19
C188	VGND#3	VGND#8	2.55263e-17
C189	VPWR#5	B#3	3.06888e-18
C190	a_499_392##4	a_83_264##8	3.15239e-18
C191	a_83_264##17	B#5	3.08697e-17
C192	X#1	B#3	2.99483e-19
C193	a_83_264##15	D#1	1.66054e-17
C194	VGND#9	VGND#3	2.94663e-18
C195	VPWR#5	a_83_264##8	5.36675e-17
C196	VPWR#4	B#2	1.00426e-19
C197	a_499_392##4	a_83_264##10	3.5194e-19
C198	a_83_264##8	X#1	2.40685e-17
C199	a_83_264##17	A#3	1.68822e-18
C200	a_83_264##15	C#5	7.26188e-18
C201	VPWR#5	a_83_264##10	2.34914e-18
C202	VPWR#7	a_83_264##8	2.3706e-18
C203	VGND#3	VGND#7	2.98284e-17
C204	a_83_264##10	X#1	2.79343e-17
C205	B	A#3	1.68486e-17
C206	X#4	a_83_264##8	2.82718e-19
C207	a_83_264##2	VPWR#4	4.4811e-19
C208	a_588_392##2	A#3	2.47566e-19
C209	VPWR#7	a_83_264##10	5.14082e-17
C210	VGND#6	VGND#9	1.70097e-19
C211	a_83_264##15	C#2	7.17492e-17
C212	X#1	a_83_264##12	4.42046e-19
C213	X#4	a_83_264##10	8.49649e-19
C214	a_83_264##17	B#2	2.83542e-17
C215	D#5	C#4	4.24829e-17
C216	VGND#5	a_83_264##2	2.44145e-18
C217	VPWR#7	a_83_264##12	4.46584e-17
C218	a_499_392#	D#1	7.90323e-19
C219	X#1	a_83_264##7	2.81839e-19
C220	a_962_392#	D#1	5.67376e-20
C221	a_83_264##12	X#4	2.36734e-17
C222	a_83_264##15	B#5	4.70852e-17
C223	VGND#6	X#5	1.598e-17
C224	a_83_264##14	D#1	8.88999e-19
C225	VPWR#7	a_83_264##7	2.56658e-18
C226	a_83_264##17	a_83_264##15	1.05538e-18
C227	B#5	VGND#8	2.42997e-18
C228	VPWR#8	a_83_264##12	2.47203e-18
C229	a_499_392#	C#5	4.42531e-19
C230	D#6	D#5	4.95085e-17
C231	a_83_264##7	X#4	2.9987e-17
C232	VPWR#8	a_83_264##7	4.50395e-17
C233	a_83_264##14	C#5	1.34299e-17
C234	VGND#5	X#5	2.60539e-18
C235	VPWR#3	A#3	4.56195e-19
C236	a_83_264##17	VGND#8	6.39453e-18
C237	C#1	D#6	3.48524e-17
C238	C#2	a_83_264##14	2.41777e-17
C239	C#2	a_962_392##2	1.07906e-18
C240	B#4	C#1	3.46952e-17
C241	B#3	A#3	7.13009e-18
C242	X#2	a_83_264##2	1.22601e-17
C243	C#2	a_499_392##2	3.72919e-17
C244	a_83_264##17	a_83_264##19	1.35597e-18
C245	B#2	VGND#9	2.36868e-18
C246	a_83_264##14	B#5	1.13268e-19
C247	a_83_264##2	VGND#8	3.58381e-19
C248	B#5	a_499_392##2	2.49021e-17
C249	a_83_264##6	a_83_264##5	5.36611e-18
C250	VGND#3	D#4	8.88077e-19
C251	A#1	B#4	3.84771e-17
C252	a_588_392##2	B#5	3.50056e-19
C253	X	A#3	7.06167e-19
C254	X	a_83_264##6	1.22438e-17
C255	a_83_264##17	VGND#9	6.19578e-17
C256	VGND#3	C#3	1.24363e-17
C257	X	a_83_264##5	1.20658e-17
C258	X	a_83_264##4	1.17518e-17
C259	VGND#7	VGND#6	1.35535e-18
C260	a_588_392#	A#3	3.32969e-19
C261	a_83_264##2	X#5	1.02195e-16
C262	D#4	D#1	2.59463e-18
C263	VGND#3	A#4	1.24382e-17
C264	a_83_264##2	VGND#10	7.92594e-19
C265	A#5	A#1	4.17991e-17
C266	VGND#3	B#1	5.83948e-19
C267	VGND#3	a_83_264#	2.7609e-19
C268	X#5	a_83_264##17	1.78181e-18
C269	B#3	A#5	4.22746e-17
C270	B#2	a_499_392##4	1.69725e-17
C271	a_83_264##8	B#3	7.60304e-18
C272	a_83_264##4	a_83_264##8	1.14316e-18
C273	VPWR	a_83_264##4	3.17746e-21
C274	B#5	C#3	9.00279e-18
C275	a_499_392##4	A#3	1.57619e-18
C276	A#4	B#5	1.47118e-18
C277	a_83_264##2	VPWR#5	3.46184e-18
C278	a_83_264##10	a_83_264##8	4.72917e-17
C279	a_83_264##2	X#1	2.39191e-18
C280	D#5	C#5	1.01794e-17
C281	a_83_264##12	a_83_264##10	4.61335e-17
C282	B#2	A#4	5.54801e-18
C283	B#2	B#1	2.83025e-18
C284	a_83_264##5	a_83_264##4	9.4026e-18
C285	a_83_264#	B#2	2.52069e-17
C286	a_83_264##2	A#4	4.89736e-19
C287	a_83_264##7	a_83_264##12	4.79366e-17
C288	C#2	D#6	2.05575e-17
C289	VGND	a_83_264##5	5.26011e-19
C290	a_83_264##2	B#1	1.19252e-18
C291	VGND	a_83_264##4	2.02573e-18
C292	a_83_264##2	a_83_264#	2.43618e-17
C293	B#4	C#2	7.20189e-18
C294	a_83_264##2	a_83_264##9	5.44889e-19
C295	a_83_264##17	B	6.99926e-17
C296	a_83_264##15	C	6.07529e-17
C297	a_83_264##15	VGND#4	3.1458e-19
C298	A	a_499_392##2	1.9419e-17
C299	A	VPWR#3	2.37112e-18
C300	VPWR#5	a_83_264##4	7.0854e-19
C301	X	VPWR#6	6.28702e-19
C302	C	a_83_264##14	9.98193e-17
C303	A	a_499_392##4	2.17034e-17
C304	X	VPWR#4	1.75212e-19
C305	VGND#3	D#1	1.752e-21
C306	a_83_264##8	B#2	1.30853e-19
C307	a_83_264##15	D	4.09918e-17
C308	D#1	C#5	1.04402e-17
C309	VGND#3	C#2	2.44689e-20
C310	a_83_264##15	VGND#8	8.13748e-18
C311	VGND#3	B#5	2.23301e-18
C312	VPWR	VPWR#6	2.44607e-17
C313	VPWR	VPWR#4	2.84965e-17
C314	X#2	X	7.31187e-18
C315	A	a_83_264#	6.11195e-19
C316	B	a_499_392##4	1.78849e-17
C317	X#2	X#5	2.5966e-18
C318	B#5	C#2	5.63969e-17
C319	a_499_392##4	VPWR#4	1.91031e-17
C320	a_83_264##7	a_83_264##5	2.78169e-18
C321	A	D#5	1.95656e-19
C322	D#3	VNB	2.46938e-17
C323	B	A#4	1.26493e-17
C324	D#2	VNB	6.11051e-17
C325	A#3	VNB	6.07651e-17
C326	a_83_264##6	VNB	3.29132e-17
C327	a_83_264##5	VNB	2.71171e-17
C328	a_83_264##4	VNB	7.85038e-17
C329	VGND	VGND#6	4.99212e-17
C330	B	a_83_264#	7.29352e-18
C331	VGND	VGND#5	2.43488e-17
C332	A	B#4	1.15666e-18
C333	C	D#5	9.15248e-18
C334	D	D#4	9.87781e-19
C335	VGND	a_83_264##17	2.42938e-17
C336	D	C#3	6.42433e-19
C337	X	a_499_392##4	3.62645e-17
C338	X#2	VGND#10	6.21486e-17
C339	X	VPWR#5	3.06987e-17
C340	VPWR	a_499_392#	2.19188e-17
C341	X	X#1	1.16246e-18
C342	A	B#3	1.30616e-18
C343	VPWR	a_962_392#	1.88712e-17
C344	X	VPWR#7	3.17907e-17
C345	VPWR	a_83_264##14	9.94471e-18
C346	A	a_83_264##8	4.08338e-19
C347	X	X#4	1.15464e-18
C348	VPWR	a_962_392##2	1.90139e-17
C349	X	VPWR#8	3.5086e-17
C350	VGND	X#2	2.24078e-17
C351	VPWR	a_499_392##2	2.69971e-17
C352	VPWR	a_588_392##2	1.60862e-17
C353	VGND	a_83_264##15	3.32214e-17
C354	a_83_264##2	B#2	5.27352e-18
C355	VPWR	VPWR#3	1.54831e-17
C356	VPWR	a_588_392#	1.58184e-17
C357	VGND	VGND#9	2.1661e-17
C358	VPWR	a_499_392##4	2.08547e-17
C359	VGND	X#5	1.70836e-17
C360	VPWR	VPWR#5	2.1352e-17
C361	X	a_83_264#	3.31521e-18
C362	X#1	VPWR#6	6.74314e-18
C363	VPWR	X#1	1.33243e-17
C364	VPWR	VPWR#7	2.17844e-17
C365	VGND	VGND#7	4.11153e-17
C366	X#2	X#3	4.68449e-19
C367	VPWR	X#4	1.67256e-17
C368	VPWR	VPWR#8	4.13277e-17
C369	VPWR#7	a_83_264##5	2.84021e-19
C370	VGND	a_499_392##2	2.71847e-18
C371	VPWR	a_83_264#	6.61679e-19
C372	VGND	a_499_392##4	2.75166e-18
C373	X#1	VPWR#4	6.69365e-18
C374	A	C#2	6.17543e-18
C375	X	B#4	4.63274e-19
C376	C	D#1	1.0136e-18
C377	X	A#1	2.06033e-19
C378	B#5	A	1.76053e-17
C379	C	C#5	2.0242e-17
C380	X	A#5	3.64786e-19
C381	VPWR	C#4	2.14966e-18
C382	VGND	D#4	5.41608e-19
C383	VPWR#7	a_83_264##4	2.94409e-19
C384	VPWR	D#5	9.81745e-19
C385	X	B#3	3.49358e-18
C386	VPWR	D#6	9.90756e-19
C387	VPWR#6	VNB	3.18009e-17
C388	X	a_83_264##8	2.08261e-17
C389	VPWR#4	VNB	3.75005e-17
C390	VGND	B#1	3.2207e-19
C391	VGND#7	X#2	1.07466e-16
C392	VPWR	C#1	2.95856e-19
C393	A	B#2	2.65462e-18
C394	VGND#6	VNB	4.04947e-17
C395	VGND	a_83_264#	7.98426e-19
C396	X	a_83_264##10	2.04667e-17
C397	VGND#5	VNB	3.34521e-17
C398	VPWR	B#4	1.68868e-18
C399	VGND	a_83_264##9	5.60471e-19
C400	X	a_83_264##12	1.70797e-17
C401	VGND	a_83_264##11	4.07948e-19
C402	VPWR	A#1	8.42355e-19
C403	a_83_264##2	A	3.36745e-18
C404	a_83_264##17	VNB	5.29065e-18
C405	VGND	a_83_264##13	8.25267e-20
C406	X	a_83_264##7	2.31668e-17
C407	VPWR	A#5	4.64846e-19
C408	D	D#1	4.05107e-17
C409	B	B#5	2.62421e-18
C410	VPWR	B#3	3.58923e-19
C411	D	C#5	6.30783e-19
C412	VPWR	a_83_264##8	5.06283e-19
C413	X#2	VNB	1.71605e-17
C414	VPWR	a_83_264##10	1.55049e-18
C415	a_83_264##15	VNB	3.14964e-17
C416	B	B#2	4.5593e-18
C417	VPWR	a_83_264##12	4.95419e-19
C418	VGND#9	VNB	4.92987e-18
C419	VPWR	a_83_264##7	5.0012e-19
C420	X#5	VNB	6.84515e-18
C421	a_83_264##2	B	3.1767e-17
C422	VGND#10	VNB	5.9355e-19
C423	VGND#7	VNB	7.13585e-17
C424	a_499_392#	VNB	3.79012e-17
C425	a_962_392#	VNB	3.2381e-18
C426	a_83_264##14	VNB	4.63017e-17
C427	a_962_392##2	VNB	3.60094e-18
C428	a_499_392##2	VNB	7.2641e-18
C429	a_588_392##2	VNB	2.37413e-18
C430	VPWR#3	VNB	1.34395e-19
C431	a_588_392#	VNB	2.37161e-18
C432	a_499_392##4	VNB	1.59618e-17
C433	VPWR#5	VNB	7.6923e-18
C434	X	B#2	1.65528e-19
C435	X#1	VNB	4.89928e-18
C436	VPWR	C#2	6.587e-18
C437	VPWR#7	VNB	2.12063e-19
C438	X#4	VNB	5.34316e-18
C439	X	a_83_264##2	1.03492e-16
C440	VPWR	B#5	2.58215e-18
C441	VPWR#8	VNB	6.00681e-17
C442	D#4	VNB	2.5967e-17
C443	VGND	VGND#3	9.83667e-17
C444	C#3	VNB	3.15581e-17
C445	A#4	VNB	3.40508e-17
C446	VGND	D#1	6.99133e-18
C447	B#1	VNB	2.9329e-17
C448	VPWR	B#2	1.46323e-18
C449	a_83_264#	VNB	5.66152e-17
C450	a_83_264##9	VNB	2.56692e-17
C451	a_83_264##11	VNB	2.65709e-17
C452	VGND	C#2	5.35597e-18
C453	VPWR	a_83_264##2	7.29516e-18
C454	B	A	3.26939e-17
C455	a_83_264##13	VNB	3.21062e-17
C456	X#4	VPWR#6	1.35355e-17
C457	VGND	B#5	4.79206e-18
C458	C#4	VNB	4.11796e-17
C459	D#5	VNB	3.70168e-17
C460	D#6	VNB	3.68247e-17
C461	C#1	VNB	2.97655e-17
C462	VGND	B#2	1.88994e-18
C463	B#4	VNB	3.35588e-17
C464	A#1	VNB	2.65823e-17
C465	VGND	a_83_264##2	9.61398e-18
C466	A#5	VNB	2.58773e-17
C467	X#5	VGND#9	1.21497e-17
C468	B#3	VNB	3.98415e-17
C469	a_83_264##8	VNB	3.54995e-17
C470	a_83_264##10	VNB	2.89301e-17
C471	a_83_264##12	VNB	2.75089e-17
C472	a_83_264##7	VNB	4.73951e-17
C473	VPWR	A	1.8008e-18
C474	VGND#3	VNB	3.29267e-16
C475	VPWR	C	3.88124e-18
C476	D#1	VNB	9.89043e-17
C477	C#5	VNB	4.97295e-17
C478	C#2	VNB	3.75856e-17
C479	VGND	A	1.89742e-18
C480	VPWR	B	3.4686e-18
C481	B#5	VNB	4.52677e-17
C482	VGND	C	4.14663e-18
C483	B#2	VNB	3.99522e-17
C484	a_83_264##2	VNB	6.1574e-18
C485	VGND	B	4.74014e-18
C486	VPWR	X	1.08539e-17
C487	VGND	D	1.6123e-17
C488	VGND	X	1.62714e-18
C489	A	VNB	5.37117e-18
C490	C	VNB	3.36805e-19
C491	B	VNB	8.07636e-18
C492	D	VNB	2.61126e-17
C493	X	VNB	3.94047e-17
C494	VPWR	VNB	8.74124e-17
C495	a_83_264##17	a_499_392##4	2.70416e-18
C496	VGND	VNB	5.92776e-17
C497	a_83_264##14	VPWR#2	1.17918e-18
C498	VPWR#2	VPWR#6	4.13877e-17
C499	a_499_392##4	VPWR#2	8.07385e-19
C500	VGND#3	VGND#2	8.03704e-17
C501	VGND#2	D#4	2.22965e-17
C502	VGND#2	VGND#4	1.06236e-17
C503	VPWR	VPWR#2	9.66045e-17
C504	VPWR#2	C#1	5.56468e-18
C505	a_962_392##2	VPWR#2	3.13751e-17
C506	VPWR#2	VPWR#4	4.5733e-17
C507	VGND#2	D#1	2.57389e-17
C508	VGND#2	C#3	2.09082e-18
C509	VGND#2	a_83_264##15	8.54377e-17
C510	VGND	VGND#2	9.07209e-17
C511	VPWR#2	B#4	4.52946e-18
C512	a_499_392##2	VPWR#2	2.46108e-17
C513	VGND#2	C#5	2.33898e-18
C514	VPWR#2	C#5	3.00556e-20
C515	VGND#2	A#4	9.7161e-20
C516	VPWR#2	A#1	1.50059e-18
C517	a_588_392##2	VPWR#2	1.83735e-17
C518	VPWR#2	C#2	3.69742e-20
C519	VGND#2	C#2	2.5774e-20
C520	VPWR#2	C#4	4.43723e-18
C521	VGND#2	VNB	6.75141e-17
C522	VPWR#2	VNB	3.96102e-16
C523	VPWR#2	A#5	9.46831e-19
C524	a_499_392#	VPWR#2	2.5647e-17
C525	VGND#2	D#3	1.2703e-18
C526	VPWR#2	D#3	4.05643e-20
C527	VPWR#2	B#5	1.03295e-19
C528	VGND#2	D	7.32002e-17
C529	VPWR#2	D#5	5.33705e-18
C530	VPWR#2	B#3	5.66883e-18
C531	a_962_392#	VPWR#2	3.02824e-17
C532	VGND#2	D#2	1.06371e-17
C533	VPWR#2	D#2	4.00234e-20
C534	a_588_392#	VPWR#2	1.81308e-17
C535	VPWR#2	VPWR#8	2.76322e-17
C536	VPWR#2	D#6	5.3297e-18
*
*
.ENDS sky130_fd_sc_hs__or4_4
*
