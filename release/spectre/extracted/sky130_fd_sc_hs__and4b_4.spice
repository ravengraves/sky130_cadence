* Extracted by Quantus, converted by sky130cad/quantus.py
*
*
*
*                       LINUX           Wed Nov 18 08:19:11 2026
*
*
*
*  PROGRAM  advgen
*
*  Name           : advgen - Quantus - (64-bit)
*  Version        : 25.1.0-p047
*  Build Date     : Thu Dec 11 23:20:30 PST 2025
*
*  HSPICE LIBRARY
*
*  OPERATING_TEMPERATURE 150
*  QRC_TECH_DIR <path>/tech
*
*
*

*
.SUBCKT sky130_fd_sc_hs__and4b_4 VPB VNB VGND VPWR X A_N C D B
*
*
*  caps2d version: 10
*
*
*       TRANSISTOR CARDS
*
*
XM16 a_27_368##10 A_N#1 VGND#11 VNB sky130_fd_pr__nfet_01v8_lvt l=0.15 w=0.64 ad=0.1824 as=0.2842 pd=1.85 ps=2.29
XM5 VGND#11 a_199_294##13 X#5 VNB sky130_fd_pr__nfet_01v8_lvt l=0.15 w=0.74 ad=0.2842 as=0.2072 pd=2.29 ps=2.04
XM7 VGND#10 a_199_294##11 X#5 VNB sky130_fd_pr__nfet_01v8_lvt l=0.15 w=0.74 ad=0.3626 as=0.2072 pd=2.46 ps=2.04
XM17 X#1 a_199_294##9 VGND#10 VNB sky130_fd_pr__nfet_01v8_lvt l=0.15 w=0.74 ad=0.2072 as=0.3626 pd=2.04 ps=2.46
XM24 X#1 a_199_294# VGND#9 VNB sky130_fd_pr__nfet_01v8_lvt l=0.15 w=0.74 ad=0.2072 as=0.2627 pd=2.04 ps=2.19
XM8 a_664_125##4 C#5 a_751_125##2 VNB sky130_fd_pr__nfet_01v8_lvt l=0.15 w=0.64 ad=0.178725 as=0.208 pd=1.85 ps=1.93
XM3 a_751_125##2 D#5 VGND#8 VNB sky130_fd_pr__nfet_01v8_lvt l=0.15 w=0.64 ad=0.208 as=0.34975 pd=1.93 ps=2.63
XM21 VGND#8 D#1 a_751_125# VNB sky130_fd_pr__nfet_01v8_lvt l=0.15 w=0.64 ad=0.34975 as=0.1792 pd=2.63 ps=1.84
XM20 a_751_125# C#2 a_664_125##2 VNB sky130_fd_pr__nfet_01v8_lvt l=0.15 w=0.64 ad=0.1792 as=0.1792 pd=1.84 ps=1.84
XM12 a_1136_125##2 B#4 a_664_125##2 VNB sky130_fd_pr__nfet_01v8_lvt l=0.15 w=0.64 ad=0.1792 as=0.1792 pd=1.84 ps=1.84
XM9 a_1136_125##2 a_27_368##4 a_199_294##23 VNB sky130_fd_pr__nfet_01v8_lvt l=0.15 w=0.64 ad=0.1792 as=0.1792 pd=1.84 ps=1.84
XM10 a_199_294##23 a_27_368##5 a_1136_125# VNB sky130_fd_pr__nfet_01v8_lvt l=0.15 w=0.64 ad=0.1792 as=0.32 pd=1.84 ps=2.28
XM19 a_664_125# B#3 a_1136_125# VNB sky130_fd_pr__nfet_01v8_lvt l=0.15 w=0.64 ad=0.1792 as=0.32 pd=1.84 ps=2.28
XM0 a_27_368##8 A_N#3 VPWR#16 VPB sky130_fd_pr__pfet_01v8 l=0.15 w=1 ad=0.295 as=0.4708 pd=2.59 ps=3.1
XM6 VPWR#16 a_199_294##7 X#3 VPB sky130_fd_pr__pfet_01v8 l=0.15 w=1.12 ad=0.4708 as=0.336 pd=3.1 ps=2.84
XM22 VPWR#15 a_199_294##12 X#3 VPB sky130_fd_pr__pfet_01v8 l=0.15 w=1.12 ad=0.3696 as=0.336 pd=2.9 ps=2.84
XM23 X#7 a_199_294##10 VPWR#15 VPB sky130_fd_pr__pfet_01v8 l=0.15 w=1.12 ad=0.4592 as=0.3696 pd=3.06 ps=2.9
XM25 X#7 a_199_294##8 VPWR#14 VPB sky130_fd_pr__pfet_01v8 l=0.15 w=1.12 ad=0.4592 as=0.4318 pd=3.06 ps=3.04
XM2 VPWR#14 C#6 a_199_294##20 VPB sky130_fd_pr__pfet_01v8 l=0.15 w=1 ad=0.4318 as=0.3 pd=3.04 ps=2.6
XM13 VPWR#13 D#4 a_199_294##20 VPB sky130_fd_pr__pfet_01v8 l=0.15 w=1 ad=0.385 as=0.3 pd=2.77 ps=2.6
XM18 a_199_294##18 D#6 VPWR#13 VPB sky130_fd_pr__pfet_01v8 l=0.15 w=1 ad=0.86 as=0.385 pd=3.72 ps=2.77
XM4 a_199_294##18 C#1 VPWR#12 VPB sky130_fd_pr__pfet_01v8 l=0.15 w=1 ad=0.86 as=0.32 pd=3.72 ps=2.64
XM11 VPWR#12 B#5 a_199_294##16 VPB sky130_fd_pr__pfet_01v8 l=0.15 w=1 ad=0.32 as=0.3 pd=2.64 ps=2.6
XM1 VPWR#11 a_27_368##6 a_199_294##16 VPB sky130_fd_pr__pfet_01v8 l=0.15 w=1 ad=0.3 as=0.3 pd=2.6 ps=2.6
XM14 a_199_294##14 a_27_368# VPWR#11 VPB sky130_fd_pr__pfet_01v8 l=0.15 w=1 ad=0.3 as=0.3 pd=2.6 ps=2.6
XM15 a_199_294##14 B#1 VPWR#1 VPB sky130_fd_pr__pfet_01v8 l=0.15 w=1 ad=0.3 as=0.53 pd=2.6 ps=3.06
*
*
*       RESISTOR AND CAP/DIODE CARDS
*
Rg1	A_N#1	A_N#2	290.705231
Rg2	A_N#2	A_N#3	473.390503
Rg3	a_199_294#	a_199_294##2	380.339874
Rg4	a_199_294##2	a_199_294##3	59.450104
Rg5	a_199_294##3	a_199_294##4	28.948608
Rg6	a_199_294##4	a_199_294##5	78.413567
Rg7	a_199_294##5	a_199_294##6	173.937698
Rg8	a_199_294##6	a_199_294##7	519.847412
Rg9	a_199_294##2	a_199_294##8	462.979767
Rg10	a_199_294##3	a_199_294##9	356.880188
Rg11	a_199_294##4	a_199_294##10	447.267700
Rg12	a_199_294##5	a_199_294##11	405.827179
Rg13	a_199_294##5	a_199_294##12	437.389587
Rg14	a_199_294##6	a_199_294##13	356.748444
Rg15	D#1	D#2	337.403595
Rg16	D#2	D#3	48.696255
Rg17	D#3	D#4	658.586731
Rg18	D#3	D#5	390.186188
Rg19	D#3	D#6	522.836365
Rg20	C#1	C#2	834.676514
Rg21	C#2	C#3	1224.967407
Rg22	C#3	C#4	972.060791
Rg23	C#3	C#5	403.298218
Rg24	C#4	C#6	453.277618
Rg25	a_27_368#	a_27_368##2	394.695099
Rg26	a_27_368##2	a_27_368##3	50.694633
Rg27	a_27_368##3	a_27_368##4	403.060638
Rg28	a_27_368##2	a_27_368##5	328.249054
Rg29	a_27_368##3	a_27_368##6	469.506683
Rg30	B#1	B#2	417.171356
Rg31	B#2	B#3	360.614868
Rg32	B#3	B#4	1648.842651
Rg33	B#4	B#5	806.299561
Rf1	A_N#4	A_N#2	161.672424
Rf2	A_N	A_N#6	1.439625
Rf3	A_N#4	A_N#6	4.710497
Rf4	X#1	X#2	83.535515
Rf5	X#2	X	13.337975
Rf6	X	X#4	20.450989
Rf7	X#4	X	0.890898
Rf8	X#2	X	5.170291
Rf9	X	X#6	6.286522
Rf10	X#6	X	6.286522
Rf11	X#4	X#7	45.465736
Rf12	X#3	X#4	15.000000
Rf13	X#5	X#6	7.500000
Rf14	C#4	C#8	160.844009
Rf15	C#9	C	0.611206
Rf16	C#8	C#9	5.905091
Rf17	a_751_125#	a_751_125##2	96.523201
Rf18	D	D#7	5.708254
Rf19	D#7	D	13.188036
Rf20	a_199_294##14	a_199_294##15	51.698013
Rf21	a_199_294##15	a_199_294##17	8.409770
Rf22	a_199_294##17	a_199_294##19	60.699860
Rf23	a_199_294##19	a_199_294##21	64.219276
Rf24	a_199_294##21	a_199_294##4	143.975006
Rf25	a_199_294##15	a_199_294##23	82.227676
Rf26	a_199_294##16	a_199_294##17	15.000000
Rf27	a_199_294##18	a_199_294##19	7.500000
Rf28	a_199_294##20	a_199_294##21	15.000000
Rf29	a_1136_125#	a_1136_125##2	94.391548
Rf30	B	B#2	162.398010
Rf31	a_664_125#	a_664_125##3	206.489594
Rf32	a_664_125##3	a_664_125##4	176.835175
Rf33	a_664_125##2	a_664_125##3	7.500000
Rf34	a_27_368##2	a_27_368##9	843.092163
Rf35	a_27_368##9	a_27_368##10	107.004852
Rf36	a_27_368##8	a_27_368##9	5.000000
Rf37	VPWR#1	VPWR#2	27.212402
Rf38	VPWR#2	VPWR#3	69.738693
Rf39	VPWR#3	VPWR#4	66.415901
Rf40	VPWR#4	VPWR#5	107.324181
Rf41	VPWR#5	VPWR#6	38.326977
Rf42	VPWR#6	VPWR#7	40.327480
Rf43	VPWR#7	VPWR#8	75.351311
Rf44	VPWR#8	VPWR#9	68.397476
Rf46	VPWR#3	VPWR#11	31.948624
Rf47	VPWR#4	VPWR#12	31.024939
Rf48	VPWR#5	VPWR#13	31.948624
Rf49	VPWR#7	VPWR#14	31.246290
Rf50	VPWR#8	VPWR#15	30.599850
Rf51	VPWR#9	VPWR#16	30.002884
Rf52	VGND#1	VGND#2	200.864334
Rf53	VGND#2	VGND#3	79.600510
Rf54	VGND#3	VGND#4	35.404957
Rf55	VGND#4	VGND#5	75.923454
Rf56	VGND#5	VGND#6	79.210724
Rf58	VGND#2	VGND#8	32.735970
Rf59	VGND#4	VGND#9	33.306259
Rf60	VGND#5	VGND#10	37.066368
Rf61	VGND#6	VGND#11	34.290443
Rf64	D#2	D#7	80.116402
Re1	VPWR#2	VPWR	6.179563
Re2	VPWR	VPWR#6	0.882795
Re3	VGND#1	VGND	6.179563
Re4	VGND	VGND#3	0.882795
*
*       CAPACITOR CARDS
*
*
C1	a_1136_125##2	B#4	2.84533e-17
C2	VGND#4	X#1	9.41962e-18
C3	VPWR#3	a_27_368#	3.95433e-18
C4	a_199_294##23	C#2	2.07147e-18
C5	a_199_294##18	VPWR#12	1.34356e-18
C6	a_664_125##2	B#4	5.27759e-17
C7	a_199_294##16	D#3	4.27511e-20
C8	a_1136_125##2	C#2	8.52517e-19
C9	a_27_368##3	a_27_368##2	3.16432e-18
C10	a_751_125#	B#4	8.57331e-19
C11	a_199_294##23	D#1	5.45218e-19
C12	VPWR#13	VPWR#12	3.4826e-18
C13	VPWR#3	a_27_368##6	3.94747e-18
C14	a_664_125##2	C#2	3.52221e-17
C15	VGND#8	B#4	1.36664e-18
C16	a_199_294##18	VPWR#13	4.78495e-19
C17	a_751_125#	C#2	3.69835e-17
C18	a_199_294##23	D#5	9.68968e-21
C19	VPWR#4	B#5	3.96811e-18
C20	a_664_125##2	D#1	1.46258e-17
C21	VGND#8	C#2	9.15832e-18
C22	VGND#11	a_27_368##8	2.36777e-18
C23	a_664_125##4	B#4	8.5656e-20
C24	a_751_125#	D#1	3.59132e-17
C25	VGND#11	VGND#5	5.34079e-19
C26	VPWR#8	a_199_294##6	3.93175e-21
C27	a_27_368##10	a_27_368##8	2.69227e-18
C28	a_664_125##2	D#5	5.17043e-19
C29	A_N#6	a_199_294##6	5.03314e-18
C30	a_199_294##20	VPWR#13	4.3734e-19
C31	VPWR#4	C#1	3.96006e-18
C32	D#1	VGND#8	2.21327e-17
C33	a_664_125##4	C#2	1.22264e-19
C34	VPWR#7	D#6	8.56456e-20
C35	a_751_125#	D#5	6.82156e-19
C36	a_751_125##2	D#1	9.72189e-19
C37	VPWR#14	VPWR#13	7.79718e-18
C38	a_664_125##2	C#5	1.7529e-19
C39	VPWR#5	D#6	3.94608e-18
C40	a_199_294##18	C#3	7.37595e-20
C41	VGND#9	C#2	2.84385e-19
C42	A_N#6	a_199_294##13	1.37996e-18
C43	D#5	VGND#8	2.25944e-17
C44	VPWR#8	a_199_294##5	4.02249e-20
C45	a_664_125##4	D#1	4.79072e-19
C46	a_751_125#	C#5	1.88027e-20
C47	a_199_294##20	VPWR#14	2.08867e-18
C48	a_751_125##2	D#5	3.87344e-17
C49	a_199_294##18	D#3	9.62908e-18
C50	VPWR#7	D#4	3.00608e-19
C51	VGND#9	D#1	2.38082e-19
C52	VGND#8	C#5	1.55744e-18
C53	a_199_294##14	B#3	2.45611e-19
C54	VPWR#5	D#4	3.96122e-18
C55	a_664_125##4	D#5	1.49762e-17
C56	C#4	D#3	1.66088e-18
C57	C#5	a_751_125##2	1.38663e-17
C58	VGND#9	D#5	3.5137e-19
C59	VGND#8	a_199_294#	4.78713e-19
C60	VPWR#5	D#3	1.48018e-19
C61	VPWR#7	C#6	6.21361e-18
C62	a_664_125##4	C#5	5.13085e-17
C63	a_199_294##2	C#4	2.91669e-17
C64	VPWR#15	VPWR#14	8.86766e-18
C65	VGND#9	C#5	1.49703e-18
C66	a_27_368##8	a_199_294##18	9.69155e-17
C67	VPWR#13	D#3	4.51775e-19
C68	a_664_125##4	a_199_294#	8.69289e-19
C69	X#1	C#5	2.0145e-19
C70	VPWR#7	a_199_294##8	7.07211e-18
C71	X#7	VPWR#15	8.39886e-19
C72	a_27_368##8	VPWR#13	4.50229e-17
C73	a_199_294#	VGND#9	2.47152e-17
C74	a_199_294##4	D#3	3.74163e-19
C75	a_199_294##4	a_199_294##6	9.23532e-19
C76	X#1	a_199_294#	4.78666e-17
C77	VPWR#8	VPWR#7	8.26649e-19
C78	a_27_368##8	a_199_294##20	8.85087e-17
C79	a_199_294##4	a_199_294##5	1.50291e-17
C80	VPWR#8	a_199_294##10	3.9591e-18
C81	VPWR#4	D#3	1.3264e-20
C82	a_199_294##20	C#3	4.1692e-19
C83	VGND#9	a_199_294##9	1.39155e-18
C84	VPWR#7	a_199_294##10	5.728e-19
C85	a_199_294##16	B#4	6.11233e-19
C86	a_199_294##4	a_199_294##2	1.88038e-17
C87	VGND#10	a_199_294#	4.66443e-19
C88	a_27_368##8	VPWR#14	4.67203e-17
C89	VPWR#7	a_199_294##2	2.23515e-20
C90	X#1	a_199_294##9	5.67912e-17
C91	a_199_294##20	D#3	2.23482e-18
C92	VGND#9	a_199_294##11	2.74187e-19
C93	VPWR#16	VPWR#15	1.03247e-17
C94	a_27_368##8	X#7	6.64058e-17
C95	VPWR#8	a_199_294##12	3.92548e-18
C96	a_199_294##9	VGND#10	2.17968e-17
C97	X#1	a_199_294##11	1.46722e-18
C98	a_27_368##8	VPWR#15	4.67036e-17
C99	A_N#2	a_199_294##6	2.73644e-17
C100	a_199_294##11	VGND#10	2.49901e-17
C101	VGND#11	a_199_294##9	1.66952e-19
C102	a_199_294##18	C#2	1.75724e-19
C103	VPWR#7	VPWR#5	8.31333e-19
C104	a_27_368##8	X#3	3.68636e-18
C105	C#9	D#4	4.13016e-18
C106	a_199_294##11	X#5	1.49241e-17
C107	VGND#10	a_199_294##13	2.80724e-19
C108	a_199_294##23	a_27_368##3	6.05577e-18
C109	a_199_294##18	D#1	2.96726e-18
C110	VGND#11	a_199_294##11	6.43539e-19
C111	a_27_368##8	VPWR#16	5.81565e-17
C112	a_199_294##13	X#5	1.49241e-17
C113	VGND#10	A_N#1	2.46655e-19
C114	a_199_294##13	VGND#11	1.58288e-17
C115	VPWR#3	VPWR#1	1.25638e-18
C116	a_27_368##10	a_199_294##13	6.01437e-19
C117	C#9	a_199_294##8	5.69532e-19
C118	VGND#11	A_N#1	4.27207e-17
C119	VPWR#5	VPWR#4	3.98743e-19
C120	B#5	a_27_368##3	1.58645e-17
C121	a_199_294##23	C#1	1.61369e-20
C122	a_1136_125##2	a_27_368##3	4.96716e-20
C123	a_27_368##10	A_N#1	1.73448e-17
C124	a_199_294##20	C#5	2.1944e-18
C125	B#3	a_27_368##5	2.93774e-17
C126	a_27_368##4	a_27_368##5	3.61891e-17
C127	B#4	B#3	2.34875e-19
C128	C#3	D#3	1.77514e-18
C129	VPWR#4	VPWR#3	1.1289e-18
C130	VPWR#1	B#1	3.09657e-17
C131	a_664_125##2	a_27_368##3	1.47678e-20
C132	a_664_125#	a_1136_125#	8.48325e-17
C133	VPWR#2	VPWR#3	3.01412e-18
C134	a_27_368##8	D#1	9.76738e-19
C135	VPWR#5	VPWR#12	2.72645e-20
C136	a_199_294##14	B#1	3.10304e-17
C137	D#3	C#1	3.06938e-19
C138	X#7	a_199_294##2	2.21109e-18
C139	VPWR#1	a_27_368#	4.54648e-18
C140	B#4	a_27_368##4	5.06909e-17
C141	VPWR#11	B#1	4.57633e-18
C142	a_664_125##2	C#3	3.04702e-19
C143	a_199_294##23	a_664_125#	1.33931e-18
C144	a_199_294##14	a_27_368#	3.87783e-17
C145	a_199_294##16	B#1	4.81915e-19
C146	VPWR#15	a_199_294##5	6.32992e-20
C147	VPWR#11	a_27_368#	3.45502e-17
C148	VGND#9	C#8	1.26364e-17
C149	VPWR#12	VPWR#3	7.71898e-20
C150	a_664_125##2	D#3	3.42227e-18
C151	a_664_125##4	D#4	4.04187e-18
C152	C#2	B#4	7.13862e-17
C153	a_1136_125#	a_199_294##23	8.16857e-18
C154	a_664_125#	a_1136_125##2	5.7182e-18
C155	a_199_294##16	a_27_368#	9.79106e-19
C156	VPWR#7	VPWR#13	2.11653e-19
C157	VPWR#11	a_27_368##6	3.33871e-17
C158	a_199_294##16	a_27_368##6	3.77875e-17
C159	a_1136_125##2	a_1136_125#	2.31218e-18
C160	a_664_125##2	a_664_125#	8.31855e-19
C161	C#2	D#1	6.94552e-17
C162	a_751_125#	C#3	1.98356e-19
C163	VPWR#11	B#5	2.59362e-18
C164	VPWR#12	a_27_368##6	3.79186e-18
C165	a_199_294##16	B#5	4.55901e-17
C166	a_199_294##23	a_1136_125##2	2.86039e-17
C167	VPWR#12	B#5	3.56e-17
C168	a_751_125#	D#3	8.53237e-19
C169	D#5	D#1	1.64135e-17
C170	C#5	C#2	1.70975e-19
C171	a_199_294##16	C#1	9.5893e-19
C172	C#3	D#4	3.51923e-19
C173	VPWR#12	C#1	3.52235e-17
C174	a_664_125##2	a_199_294##23	1.53786e-17
C175	D#4	D#3	8.35586e-19
C176	a_199_294##18	C#1	5.45456e-17
C177	VGND#8	C#3	1.41113e-17
C178	C#5	D#5	2.83488e-17
C179	VPWR#12	D#6	1.96724e-18
C180	VPWR#13	C#1	2.45749e-18
C181	a_664_125##2	a_1136_125##2	8.16729e-17
C182	a_27_368##2	VPWR#4	5.41165e-18
C183	a_199_294##18	D#6	5.43168e-17
C184	a_27_368##2	VPWR#3	4.95415e-18
C185	VGND#8	D#3	1.11362e-18
C186	VPWR#13	D#6	4.03307e-17
C187	a_27_368##8	D#3	1.84901e-18
C188	D#4	VPWR#13	2.98178e-17
C189	VPWR#15	VPWR#7	4.67452e-20
C190	VPWR#14	D#6	8.31257e-19
C191	a_27_368##8	a_199_294##6	4.22598e-19
C192	VGND#1	a_664_125#	1.23384e-16
C193	a_199_294##20	D#4	4.12093e-17
C194	VGND#3	C#8	6.74139e-19
C195	a_199_294##9	a_199_294#	3.77003e-17
C196	a_751_125##2	C#3	6.61219e-18
C197	a_664_125##2	a_751_125#	8.58878e-17
C198	VGND#1	a_1136_125#	5.19967e-18
C199	VPWR#13	C#6	3.49523e-18
C200	VPWR#14	D#4	1.76596e-18
C201	VGND#5	a_199_294##4	3.21032e-20
C202	a_27_368##8	a_199_294##5	1.96463e-19
C203	VGND#4	a_199_294##4	4.33544e-19
C204	a_199_294##20	C#6	3.90875e-17
C205	a_751_125##2	D#3	1.43312e-18
C206	a_199_294##6	a_199_294##5	7.81461e-18
C207	a_664_125##2	VGND#8	1.00501e-17
C208	VPWR#13	a_199_294##8	9.029e-19
C209	C#6	VPWR#14	2.78915e-17
C210	a_199_294##11	a_199_294##9	1.66863e-17
C211	VGND#1	a_664_125##2	3.02975e-17
C212	VPWR#8	a_199_294##4	4.29809e-20
C213	VPWR#7	a_199_294##4	2.11598e-20
C214	a_27_368##8	D#6	2.1317e-17
C215	a_27_368##8	a_199_294##2	2.98696e-19
C216	VGND#11	A_N#6	1.98604e-17
C217	VPWR#14	a_199_294##8	3.77628e-17
C218	a_751_125#	VGND#8	2.40094e-17
C219	a_199_294##13	a_199_294##11	3.98499e-17
C220	a_199_294##8	X#7	2.42616e-17
C221	VGND#4	C#8	1.94576e-19
C222	a_664_125##4	C#3	5.64426e-18
C223	a_27_368##8	D#4	2.24007e-17
C224	VPWR#14	a_199_294##10	3.26108e-18
C225	VPWR#15	a_199_294##8	2.65165e-18
C226	a_27_368##8	VPWR#8	5.7806e-18
C227	a_751_125##2	a_751_125#	2.30095e-18
C228	X#7	a_199_294##10	5.18805e-17
C229	a_664_125##4	a_664_125##2	8.41587e-19
C230	a_664_125#	B#2	3.8249e-19
C231	a_27_368##8	C#6	2.2546e-17
C232	A_N#1	a_199_294##13	2.1956e-17
C233	a_1136_125#	B#2	5.2229e-19
C234	a_664_125##4	D#3	7.70537e-18
C235	VPWR#15	a_199_294##10	3.98396e-17
C236	a_27_368##8	VPWR#7	4.06553e-18
C237	VGND#11	A_N#4	1.30715e-17
C238	VPWR#2	VPWR#1	9.42605e-17
C239	D#1	C#1	1.2037e-17
C240	a_27_368##8	a_199_294##8	2.34034e-17
C241	a_751_125##2	VGND#8	1.66847e-17
C242	a_751_125#	a_664_125##4	3.68072e-18
C243	C#9	C#4	8.67959e-18
C244	VGND#3	a_751_125##2	1.22087e-18
C245	a_27_368##2	a_664_125#	3.37123e-17
C246	VPWR#2	a_199_294##14	1.53723e-18
C247	VPWR#15	a_199_294##12	3.82052e-17
C248	a_27_368##8	VPWR#5	7.00912e-18
C249	VGND#3	a_664_125##4	8.09794e-18
C250	a_27_368##2	a_1136_125#	3.68164e-17
C251	D	a_27_368##3	2.79305e-18
C252	C#8	C#4	1.56324e-17
C253	a_199_294##12	X#3	2.38309e-17
C254	a_27_368##8	a_199_294##10	1.80502e-17
C255	D	C#3	8.61066e-20
C256	a_199_294##23	a_27_368##2	4.86344e-17
C257	a_27_368##10	A_N#4	1.85553e-17
C258	D	D#3	3.26504e-17
C259	VGND#9	C#3	1.01946e-17
C260	VPWR#15	a_199_294##7	2.62084e-18
C261	a_1136_125##2	a_27_368##2	1.83785e-19
C262	VPWR#16	a_199_294##12	3.23383e-18
C263	a_27_368##8	VPWR#4	3.67475e-18
C264	a_664_125##4	VGND#8	3.93125e-18
C265	a_199_294##5	a_199_294##10	1.02932e-18
C266	a_664_125##2	a_27_368##2	4.79953e-21
C267	a_199_294##4	C#9	1.81471e-17
C268	a_199_294##7	X#3	2.38309e-17
C269	a_664_125##4	a_199_294##5	2.61818e-20
C270	a_27_368##8	a_199_294##12	1.68788e-17
C271	VPWR#16	a_199_294##7	4.59823e-17
C272	a_199_294##4	C#8	2.21083e-17
C273	a_664_125##4	a_751_125##2	8.2852e-17
C274	VGND#9	VGND#8	3.05531e-18
C275	C#5	D#4	1.0678e-17
C276	a_27_368##8	a_199_294##7	2.99827e-17
C277	A_N#3	VPWR#16	3.59e-17
C278	VGND#2	B#4	6.41358e-18
C279	a_27_368#	B#1	4.41625e-17
C280	a_27_368##8	A_N#3	6.49629e-17
C281	C#9	a_199_294##20	3.13901e-17
C282	a_664_125##4	a_199_294##2	8.95376e-19
C283	X#1	C#3	3.95547e-19
C284	VPWR#1	B#2	8.3377e-19
C285	B#4	a_27_368##3	1.10399e-17
C286	a_27_368##6	a_27_368#	4.14371e-17
C287	VGND#8	C#4	9.97072e-21
C288	A_N#6	A_N#2	6.74002e-18
C289	VGND#2	C#2	1.68963e-17
C290	VGND#9	a_664_125##4	3.34186e-17
C291	a_199_294##16	B#2	4.88015e-19
C292	A_N#4	A_N#2	1.22153e-17
C293	a_27_368##2	VPWR#1	7.93301e-17
C294	a_664_125##4	C#4	1.36685e-17
C295	a_27_368##2	a_199_294##14	9.82596e-17
C296	VGND#9	C#4	1.48918e-17
C297	B#5	a_27_368##6	4.38036e-17
C298	X#1	C#4	1.17495e-18
C299	a_27_368##2	VPWR#11	4.65876e-17
C300	X#1	a_664_125##4	6.67146e-19
C301	a_27_368##2	a_199_294##16	1.18032e-16
C302	a_664_125##4	a_199_294##4	3.65419e-20
C303	VGND#1	B#3	2.8975e-17
C304	a_27_368##2	VPWR#12	4.59561e-17
C305	VGND#2	D#1	1.70381e-18
C306	VGND#9	a_199_294##4	1.3604e-17
C307	C#1	B#5	5.12483e-17
C308	VGND#1	a_27_368##5	1.91567e-18
C309	a_27_368##2	a_199_294##18	4.07741e-17
C310	a_27_368##8	VPWR#6	4.87258e-18
C311	a_199_294##4	X#1	6.25603e-17
C312	VGND#10	C#3	1.31883e-19
C313	X#1	VGND#9	6.91193e-17
C314	VGND#1	a_27_368##4	1.91567e-18
C315	a_199_294##4	VGND#10	7.64015e-18
C316	a_199_294##7	a_199_294##5	5.09195e-18
C317	VGND#1	B#4	1.30477e-17
C318	D#6	C#1	5.70805e-18
C319	C#3	C#2	3.8547e-19
C320	VGND#2	D#5	1.74106e-18
C321	VGND#10	VGND#9	1.59744e-18
C322	C#2	D#3	1.63695e-19
C323	A_N#2	VGND#11	3.85384e-18
C324	D#4	D#6	2.93085e-17
C325	B#3	B#2	1.49572e-18
C326	a_27_368##10	A_N#2	2.99368e-18
C327	a_199_294##23	a_199_294##16	2.5668e-18
C328	a_199_294##20	C#4	1.77767e-18
C329	X#1	VGND#10	4.66646e-17
C330	VPWR#14	C#4	3.51226e-19
C331	X#1	a_199_294##2	1.83032e-18
C332	a_27_368##2	B#3	2.33958e-17
C333	X	a_199_294##6	1.75808e-17
C334	C#6	D#4	4.83226e-17
C335	X	a_199_294##5	4.22099e-18
C336	a_27_368##2	a_27_368##5	6.78402e-18
C337	X	a_199_294##2	7.56625e-20
C338	a_1136_125##2	a_199_294##16	3.71092e-18
C339	VGND#5	a_199_294#	6.83426e-19
C340	VGND#10	a_199_294##5	6.43015e-19
C341	a_27_368##2	a_27_368##4	4.03418e-19
C342	a_199_294##4	VPWR#14	2.0337e-19
C343	B#4	a_27_368##2	6.672e-19
C344	a_199_294##4	X#7	1.09542e-16
C345	a_199_294##8	C#6	3.1452e-17
C346	VGND#4	a_199_294#	4.75902e-18
C347	VPWR#4	D#1	1.22166e-19
C348	a_27_368##8	C#4	4.0375e-19
C349	a_199_294##4	VPWR#15	3.21947e-18
C350	VPWR#2	B#1	2.84552e-19
C351	a_664_125##2	a_199_294##16	7.75396e-18
C352	a_199_294##10	a_199_294##8	3.00649e-17
C353	a_199_294##4	a_27_368##8	2.92615e-17
C354	VGND#5	a_199_294##9	8.17973e-18
C355	a_199_294##6	X#5	1.42687e-19
C356	VPWR#16	A_N#2	4.02433e-19
C357	VGND#11	VGND#10	1.5021e-18
C358	a_27_368##8	A_N#2	9.06294e-18
C359	a_199_294##12	a_199_294##10	4.03579e-17
C360	C#4	C#5	2.57767e-17
C361	a_664_125##2	a_199_294##18	4.59382e-18
C362	a_199_294#	C#4	1.56409e-17
C363	C#3	D#5	1.68933e-17
C364	VGND#5	a_199_294##11	8.0673e-18
C365	a_199_294##7	a_199_294##12	4.88377e-17
C366	VGND#5	C#3	4.57653e-19
C367	a_199_294##4	C#5	6.39903e-19
C368	a_27_368##2	B#1	3.09059e-17
C369	C#9	D	5.34795e-18
C370	a_27_368##2	a_27_368#	1.076e-17
C371	VPWR#6	D#4	4.40914e-18
C372	A_N#3	a_199_294##7	2.91838e-17
C373	C#8	D	4.31115e-18
C374	a_27_368##2	a_27_368##6	9.54813e-18
C375	VPWR#6	C#6	4.0771e-18
C376	VGND#3	D#4	2.43948e-19
C377	a_27_368##2	B#5	1.62181e-17
C378	VGND#5	a_199_294##13	4.0394e-19
C379	VGND	C#3	1.45627e-17
C380	a_27_368##2	C#1	2.13646e-17
C381	VGND	a_199_294##6	3.02229e-20
C382	VGND	a_199_294##5	1.38144e-18
C383	a_27_368##10	VGND#11	4.76803e-17
C384	A_N#2	a_199_294##13	9.49262e-19
C385	D	a_199_294##23	4.39531e-18
C386	a_664_125##2	D	5.68487e-17
C387	C#3	C#5	6.60208e-18
C388	B	VPWR#1	1.57736e-18
C389	VGND#5	X	9.4457e-18
C390	a_664_125##4	D	4.37603e-17
C391	VGND#4	C#3	4.08728e-18
C392	B	a_199_294##14	1.19243e-17
C393	C#4	D#4	1.39957e-17
C394	C#5	D#3	5.42506e-18
C395	VGND#5	a_199_294##6	1.22037e-20
C396	A_N#6	a_27_368##8	5.10611e-18
C397	a_664_125##4	a_199_294##18	2.85654e-18
C398	a_199_294##4	D#4	4.96836e-19
C399	a_199_294##8	C#4	2.9285e-18
C400	a_199_294##4	C#6	6.84211e-19
C401	D	a_199_294##16	5.14557e-18
C402	a_199_294##4	a_199_294##8	1.18288e-17
C403	VGND#2	a_664_125##2	3.3292e-17
C404	a_27_368##3	VNB	2.1195e-17
C405	C#3	VNB	1.14007e-16
C406	D	a_199_294##18	1.17834e-16
C407	D#3	VNB	5.62224e-17
C408	a_199_294##6	VNB	1.82823e-17
C409	a_199_294##5	VNB	2.2848e-17
C410	a_199_294##4	a_199_294##10	8.31404e-19
C411	a_199_294##2	VNB	2.6346e-17
C412	VPWR#2	a_27_368##2	1.3376e-17
C413	VPWR	VPWR#8	6.20772e-17
C414	B	B#3	3.23166e-19
C415	VPWR	VPWR#7	6.96084e-17
C416	C#9	a_199_294##2	6.8113e-19
C417	VPWR	VPWR#5	6.61956e-17
C418	VPWR	VPWR#4	7.5992e-17
C419	VGND#1	a_27_368##2	1.02979e-17
C420	C#8	D#3	2.80312e-18
C421	VGND#5	a_199_294##5	3.38144e-20
C422	a_199_294##4	a_199_294##7	3.43558e-20
C423	a_27_368##8	A_N#4	2.70018e-17
C424	VPWR	VPWR#3	5.44109e-17
C425	A_N#6	X	2.8172e-17
C426	a_199_294#	C#3	1.06352e-17
C427	A_N#2	a_199_294##7	1.37819e-18
C428	VGND#2	C#3	1.86363e-17
C429	a_664_125##4	a_199_294##20	1.80179e-17
C430	a_27_368##2	B#2	4.56509e-17
C431	VPWR	C#9	2.98928e-18
C432	VGND#2	a_751_125#	6.82983e-18
C433	D	B#4	1.0086e-18
C434	VGND	VGND#5	8.48543e-17
C435	D	C#2	8.39383e-18
C436	VGND	VGND#4	5.12928e-17
C437	VGND	VGND#2	1.13777e-16
C438	D	D#1	1.0146e-17
C439	X	X#1	3.37163e-18
C440	X	VGND#10	5.57224e-17
C441	VPWR	A_N#6	2.73656e-18
C442	X	X#5	2.08848e-19
C443	VPWR	A_N#4	1.75465e-18
C444	VGND#11	X	6.72602e-17
C445	VGND#9	a_199_294##20	2.83284e-18
C446	a_27_368##10	X	2.26043e-18
C447	C#8	C#2	3.3878e-19
C448	VPWR#11	VPWR#1	9.04952e-18
C449	a_664_125#	B#3	5.45137e-17
C450	VGND#2	D#3	2.11123e-19
C451	VGND	C#8	4.17982e-18
C452	VGND#5	VGND#4	8.77876e-19
C453	VGND	A_N#6	2.22072e-18
C454	a_199_294##4	C#4	6.23453e-18
C455	VGND#5	VNB	3.46901e-17
C456	VGND#4	VNB	2.40021e-17
C457	VGND	A_N#4	4.13235e-18
C458	VPWR	a_199_294##14	1.54281e-18
C459	VGND#2	VNB	4.81981e-17
C460	D	B#5	2.51432e-18
C461	VGND	a_664_125#	1.13607e-17
C462	VPWR	VPWR#11	1.56309e-17
C463	a_27_368##8	X	7.45757e-17
C464	B#3	a_1136_125#	2.26113e-17
C465	VGND	a_1136_125#	5.40983e-18
C466	VPWR	a_199_294##16	7.64544e-18
C467	VPWR#8	VNB	3.21262e-17
C468	VGND	a_199_294##23	6.02731e-18
C469	D	C#1	1.15218e-17
C470	VPWR#7	VNB	2.71514e-17
C471	VGND	a_1136_125##2	9.6195e-18
C472	VPWR	VPWR#12	1.70938e-17
C473	VPWR#5	VNB	3.44315e-17
C474	VGND	a_664_125##2	3.36142e-17
C475	VPWR#4	VNB	4.01022e-17
C476	VPWR	a_199_294##18	8.75636e-18
C477	VPWR#3	VNB	2.93322e-17
C478	VGND	a_751_125#	1.37384e-17
C479	VPWR	VPWR#13	1.53247e-17
C480	VGND	VGND#8	1.56658e-17
C481	VPWR	a_199_294##20	7.19175e-18
C482	VGND	a_751_125##2	1.26021e-17
C483	VGND	a_664_125##4	1.91822e-17
C484	a_664_125#	a_27_368##5	1.11767e-17
C485	VGND	VGND#9	2.0271e-17
C486	VPWR	X#7	4.41384e-18
C487	VGND	X#1	1.83199e-17
C488	VPWR	VPWR#15	1.76179e-17
C489	C#9	VNB	2.54423e-19
C490	VGND	a_27_368##10	1.62606e-17
C491	VPWR	a_27_368##8	7.34581e-17
C492	a_199_294##23	B#3	2.54417e-18
C493	C#8	VNB	4.09665e-18
C494	X	a_199_294##9	8.14753e-19
C495	X	a_199_294##11	4.42124e-17
C496	VGND	a_199_294##16	2.91383e-18
C497	VPWR#2	B	3.06188e-18
C498	A_N#6	VNB	3.2661e-18
C499	X	a_199_294##13	2.5365e-17
C500	A_N#4	VNB	3.47711e-18
C501	X	A_N#1	2.3915e-18
C502	VGND#1	B	2.50532e-18
C503	a_664_125#	VNB	5.00365e-17
C504	VGND#3	C#3	2.07571e-17
C505	a_1136_125#	a_27_368##5	4.20796e-17
C506	a_199_294##23	VNB	3.09159e-18
C507	VGND#2	a_751_125##2	5.638e-18
C508	a_664_125##2	VNB	1.74558e-17
C509	a_751_125#	VNB	4.56862e-19
C510	VGND#8	VNB	7.90962e-18
C511	a_664_125##4	VNB	7.23826e-18
C512	VGND#3	D#3	2.46771e-19
C513	VGND#9	VNB	1.5229e-17
C514	a_1136_125##2	B#3	1.81729e-19
C515	VGND	a_27_368##8	1.89767e-18
C516	B	B#2	1.90359e-17
C517	X#1	VNB	2.68504e-18
C518	a_664_125#	a_27_368##4	5.17547e-19
C519	VGND#10	VNB	2.54891e-18
C520	VGND	B#3	4.27426e-18
C521	VGND#11	VNB	6.31444e-18
C522	a_27_368##2	B	1.06103e-16
C523	a_27_368##10	VNB	4.38698e-17
C524	VPWR#1	VNB	6.29797e-17
C525	VGND	B#4	1.14824e-17
C526	VGND	C#2	9.12839e-18
C527	VPWR#11	VNB	2.15564e-19
C528	VGND	D#1	5.40908e-18
C529	a_199_294##16	VNB	6.09548e-18
C530	VPWR	a_27_368#	2.89256e-19
C531	a_27_368##5	a_199_294##23	1.53428e-17
C532	VPWR#12	VNB	4.58461e-19
C533	VGND	D#5	4.07345e-18
C534	X	a_199_294##8	1.17376e-20
C535	a_199_294##16	VPWR#11	1.27176e-18
C536	VPWR	a_27_368##6	3.08677e-19
C537	VGND	C#5	1.08141e-18
C538	VPWR#13	VNB	1.23569e-18
C539	X	a_199_294##10	2.18029e-20
C540	VPWR	B#5	3.3369e-19
C541	VGND	a_199_294#	1.08883e-18
C542	a_199_294##20	VNB	1.97181e-18
C543	VPWR#14	VNB	8.49308e-19
C544	VPWR	C#1	3.88451e-19
C545	X	a_199_294##12	2.25063e-17
C546	X#7	VNB	9.46645e-19
C547	VPWR	D#6	4.32376e-19
C548	VPWR#15	VNB	4.45982e-19
C549	X	a_199_294##7	1.76857e-17
C550	VGND	a_199_294##13	2.28542e-18
C551	D	C#4	2.75275e-18
C552	VPWR	D#4	7.86323e-19
C553	VPWR#16	VNB	4.95808e-18
C554	VGND	A_N#1	4.39248e-18
C555	X	A_N#3	4.76987e-18
C556	a_664_125##2	B#3	2.32017e-19
C557	a_27_368##8	VNB	7.40454e-17
C558	VPWR	C#6	7.15135e-19
C559	a_1136_125#	a_27_368##4	7.50598e-19
C560	C#8	a_199_294##2	3.29506e-18
C561	VGND#5	VGND#9	3.51704e-19
C562	B#3	VNB	9.56912e-17
C563	a_199_294##4	D	1.4787e-18
C564	VPWR	a_199_294##8	3.2606e-19
C565	a_27_368##5	VNB	2.37071e-17
C566	a_27_368##4	VNB	2.20878e-17
C567	VPWR	a_199_294##10	2.64553e-19
C568	B#4	VNB	1.03361e-16
C569	C#2	VNB	7.98272e-17
C570	VPWR	a_199_294##12	3.18414e-19
C571	D#1	VNB	3.44823e-17
C572	VPWR	a_199_294##7	3.54386e-19
C573	D#5	VNB	2.27679e-17
C574	C#5	VNB	2.98221e-17
C575	a_1136_125##2	a_27_368##5	4.34922e-19
C576	VPWR	A_N#3	8.65047e-18
C577	a_199_294#	VNB	3.2474e-17
C578	VGND	D#4	4.19108e-19
C579	a_199_294##9	VNB	3.14727e-17
C580	VGND#4	VGND#2	2.03711e-19
C581	a_664_125#	B#4	3.24636e-18
C582	a_199_294##11	VNB	3.11396e-17
C583	C#8	C#5	2.61697e-18
C584	a_199_294##13	VNB	3.37347e-17
C585	A_N#1	VNB	3.46399e-17
C586	VPWR#12	VPWR#11	8.54369e-18
C587	B#1	VNB	3.30927e-17
C588	VPWR	VPWR#6	2.90204e-17
C589	a_27_368#	VNB	2.5916e-17
C590	a_27_368##6	VNB	2.69334e-17
C591	X	C#4	1.42571e-19
C592	a_199_294##23	a_27_368##4	2.86925e-17
C593	VGND#4	a_199_294##2	4.98442e-20
C594	B#5	VNB	4.11355e-17
C595	C#1	VNB	4.19181e-17
C596	X	a_199_294##4	9.18794e-17
C597	D#6	VNB	2.98064e-17
C598	VPWR	a_27_368##2	2.3167e-17
C599	D#4	VNB	4.75849e-17
C600	X	A_N#2	4.30579e-18
C601	VGND	VGND#1	5.44824e-17
C602	C#6	VNB	3.47718e-17
C603	a_199_294##8	VNB	3.24937e-17
C604	a_199_294##10	VNB	3.03463e-17
C605	VGND	VGND#3	4.42209e-17
C606	a_199_294##12	VNB	2.81676e-17
C607	VPWR	a_199_294##4	8.22786e-18
C608	a_664_125##2	a_27_368##5	3.2107e-19
C609	a_199_294##7	VNB	3.77644e-17
C610	A_N#3	VNB	4.26389e-17
C611	VGND	a_27_368##2	3.13875e-18
C612	a_1136_125#	B#4	8.05763e-19
C613	VPWR#2	VNB	7.76149e-17
C614	VGND#1	VNB	1.45996e-16
C615	VPWR#6	VNB	1.4954e-17
C616	VGND	a_199_294##4	9.08124e-18
C617	VGND#3	VNB	1.77738e-17
C618	VGND	A_N#2	1.45649e-20
C619	B#2	VNB	4.15898e-17
C620	a_27_368##2	VNB	9.74414e-17
C621	a_1136_125##2	a_27_368##4	2.69602e-17
C622	a_199_294##16	VPWR#12	1.41561e-18
C623	C#4	VNB	6.47102e-17
C624	a_199_294##4	VNB	5.59086e-17
C625	a_199_294##16	a_27_368##3	7.07467e-18
C626	A_N#2	VNB	3.97364e-17
C627	VGND#5	X#1	7.88987e-18
C628	a_664_125#	C#2	1.55983e-19
C629	VPWR	D	4.97044e-18
C630	VGND	D	4.71942e-18
C631	a_199_294##23	B#4	8.96306e-18
C632	B	VNB	3.023e-18
C633	VPWR	X	6.08747e-18
C634	D	VNB	3.80274e-18
C635	VGND	X	2.23066e-17
C636	X	VNB	3.92566e-18
C637	VGND#9	VGND#2	2.88724e-20
C638	VPWR	VNB	2.69543e-16
C639	VGND	VNB	2.89987e-16
C640	a_664_125##2	a_27_368##4	1.04596e-17
C641	VPWR#9	VPWR#15	6.71651e-20
C642	VPWR#9	a_199_294##7	8.02186e-18
C643	VGND#6	a_199_294##13	9.90498e-18
C644	VGND#6	A_N#1	3.13184e-18
C645	VGND#6	a_199_294##6	3.43229e-20
C646	VGND#6	VGND#5	1.14667e-18
C647	VGND#6	A_N#4	8.93733e-19
C648	VPWR#9	A_N#3	4.502e-18
C649	VGND#6	a_27_368##10	1.49013e-17
C650	VPWR#9	VNB	5.18739e-17
C651	VGND#6	X	9.08168e-18
C652	VGND	VGND#6	1.06813e-16
C653	a_27_368##8	VPWR#9	1.80212e-17
C654	VPWR#9	a_199_294##12	6.33636e-19
C655	VGND#6	VNB	5.16062e-17
C656	VPWR	VPWR#9	1.05777e-16
C657	VPWR#9	a_199_294##6	4.53664e-20
C658	VGND#6	a_199_294##9	6.9883e-20
C659	VPWR#9	VPWR#8	1.09007e-18
C660	VGND#6	a_199_294##11	5.03708e-19
*
*
.ENDS sky130_fd_sc_hs__and4b_4
*
