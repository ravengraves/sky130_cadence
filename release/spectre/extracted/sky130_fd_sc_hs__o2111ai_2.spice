* Extracted by Quantus, converted by sky130cad/quantus.py
*
*
*
*                       LINUX           Wed Nov 18 08:53:24 2026
*
*
*
*  PROGRAM  advgen
*
*  Name           : advgen - Quantus - (64-bit)
*  Version        : 25.1.0-p047
*  Build Date     : Thu Dec 11 23:20:30 PST 2025
*
*  HSPICE LIBRARY
*
*  OPERATING_TEMPERATURE 150
*  QRC_TECH_DIR <path>/tech
*
*
*

*
.SUBCKT sky130_fd_sc_hs__o2111ai_2 VNB VPB VGND VPWR Y D1 C1 B1 A2 A1
*
*
*  caps2d version: 10
*
*
*       TRANSISTOR CARDS
*
*
XM18 Y#9 D1#6 a_40_74# VNB sky130_fd_pr__nfet_01v8_lvt l=0.15 w=0.74 ad=0.2072 as=0.2109 pd=2.04 ps=2.05
XM14 a_40_74##2 D1#5 Y#9 VNB sky130_fd_pr__nfet_01v8_lvt l=0.15 w=0.74 ad=0.2072 as=0.2072 pd=2.04 ps=2.04
XM12 a_299_74##2 C1#5 a_40_74##2 VNB sky130_fd_pr__nfet_01v8_lvt l=0.15 w=0.74 ad=0.259 as=0.2072 pd=2.18 ps=2.04
XM16 a_40_74##4 C1#6 a_299_74##2 VNB sky130_fd_pr__nfet_01v8_lvt l=0.15 w=0.74 ad=0.2109 as=0.259 pd=2.05 ps=2.18
XM4 a_299_74# B1#5 a_510_74##4 VNB sky130_fd_pr__nfet_01v8_lvt l=0.15 w=0.74 ad=0.259 as=0.2109 pd=2.18 ps=2.05
XM7 a_510_74##6 B1#1 a_299_74# VNB sky130_fd_pr__nfet_01v8_lvt l=0.15 w=0.74 ad=0.2072 as=0.259 pd=2.04 ps=2.18
XM3 VGND#6 A2#5 a_510_74##6 VNB sky130_fd_pr__nfet_01v8_lvt l=0.15 w=0.74 ad=0.222 as=0.2072 pd=2.08 ps=2.04
XM8 a_510_74##5 A2#6 VGND#6 VNB sky130_fd_pr__nfet_01v8_lvt l=0.15 w=0.74 ad=0.2072 as=0.222 pd=2.04 ps=2.08
XM0 a_510_74##5 A1#4 VGND#5 VNB sky130_fd_pr__nfet_01v8_lvt l=0.15 w=0.74 ad=0.2072 as=0.259 pd=2.04 ps=2.18
XM5 VGND#5 A1#5 a_510_74# VNB sky130_fd_pr__nfet_01v8_lvt l=0.15 w=0.74 ad=0.259 as=0.2109 pd=2.18 ps=2.05
XM1 VPWR#7 D1#7 Y#5 VPB sky130_fd_pr__pfet_01v8 l=0.15 w=1.12 ad=0.3304 as=0.336 pd=2.83 ps=2.84
XM15 Y#5 D1#1 VPWR#11 VPB sky130_fd_pr__pfet_01v8 l=0.15 w=1.12 ad=0.336 as=0.392 pd=2.84 ps=2.94
XM17 VPWR#11 C1#7 Y#8 VPB sky130_fd_pr__pfet_01v8 l=0.15 w=1.12 ad=0.392 as=0.336 pd=2.94 ps=2.84
XM9 Y#8 C1#1 VPWR#10 VPB sky130_fd_pr__pfet_01v8 l=0.15 w=1.12 ad=0.336 as=0.336 pd=2.84 ps=2.84
XM19 VPWR#10 B1#4 Y#7 VPB sky130_fd_pr__pfet_01v8 l=0.15 w=1.12 ad=0.336 as=0.336 pd=2.84 ps=2.84
XM10 Y#7 B1#6 VPWR#9 VPB sky130_fd_pr__pfet_01v8 l=0.15 w=1.12 ad=0.336 as=0.3304 pd=2.84 ps=2.83
XM2 Y#1 A2#7 a_697_368##4 VPB sky130_fd_pr__pfet_01v8 l=0.15 w=1.12 ad=0.336 as=0.3304 pd=2.84 ps=2.83
XM11 a_697_368##2 A2#1 Y#1 VPB sky130_fd_pr__pfet_01v8 l=0.15 w=1.12 ad=0.336 as=0.336 pd=2.84 ps=2.84
XM6 VPWR#8 A1#6 a_697_368##2 VPB sky130_fd_pr__pfet_01v8 l=0.15 w=1.12 ad=0.392 as=0.336 pd=2.94 ps=2.84
XM13 a_697_368# A1#1 VPWR#8 VPB sky130_fd_pr__pfet_01v8 l=0.15 w=1.12 ad=0.3304 as=0.392 pd=2.83 ps=2.94
*
*
*       RESISTOR AND CAP/DIODE CARDS
*
Rg1	D1#1	D1#2	507.075531
Rg2	D1#2	D1#3	66.369736
Rg3	D1#3	D1#4	49.553852
Rg4	D1#2	D1#5	322.953644
Rg5	D1#3	D1#6	319.959229
Rg6	D1#3	D1#7	504.081116
Rg7	C1#1	C1#2	472.847595
Rg8	C1#2	C1#3	34.534393
Rg9	C1#3	C1#4	18.801310
Rg10	C1#4	C1#5	363.941650
Rg11	C1#2	C1#6	370.582062
Rg12	C1#4	C1#7	472.702087
Rg13	B1#1	B1#2	426.003052
Rg14	B1#2	B1#3	44.016792
Rg15	B1#3	B1#4	612.551453
Rg16	B1#3	B1#5	453.979462
Rg17	B1#3	B1#6	468.326019
Rg18	A2#1	A2#2	449.655212
Rg19	A2#2	A2#3	16.815884
Rg20	A2#3	A2#4	36.519821
Rg21	A2#4	A2#5	397.555725
Rg22	A2#2	A2#6	397.555725
Rg23	A2#4	A2#7	449.655212
Rg24	A1#1	A1#2	437.757690
Rg25	A1#2	A1#3	96.089226
Rg26	A1#3	A1#4	393.531403
Rg27	A1#2	A1#5	385.612549
Rg28	A1#3	A1#6	453.121765
Rf1	D1	D1#4	163.775864
Rf2	C1	C1#3	85.130844
Rf3	a_40_74#	a_40_74##3	102.757668
Rf4	a_40_74##3	a_40_74##4	84.543983
Rf5	a_40_74##2	a_40_74##3	7.500000
Rf6	a_299_74#	a_299_74##2	150.315857
Rf9	Y#1	Y#2	119.252678
Rf10	Y#2	Y#3	65.695732
Rf11	Y#3	Y#4	61.391537
Rf12	Y#4	Y	5.889122
Rf13	Y	Y#6	14.369054
Rf14	Y#6	Y	0.196836
Rf15	Y#2	Y#7	18.602406
Rf16	Y#3	Y#8	16.043533
Rf17	Y#4	Y	8.644831
Rf18	Y	Y#9	36.807693
Rf19	Y#5	Y#6	5.000000
Rf20	A2#8	A2	1.409262
Rf21	A2#3	A2#10	161.642059
Rf22	A2#8	A2#10	1.528014
Rf23	A2#11	A2	1.409262
Rf24	A2#10	A2#11	13.140918
Rf25	a_510_74#	a_510_74##2	87.993027
Rf26	a_510_74##2	a_510_74##3	67.337318
Rf27	a_510_74##3	a_510_74##4	85.744865
Rf28	a_510_74##2	a_510_74##5	21.341251
Rf29	a_510_74##3	a_510_74##6	28.306047
Rf30	A1#7	A1	1.409262
Rf31	A1#2	A1#9	161.642059
Rf32	A1#7	A1#9	6.417657
Rf33	A1#10	A1	1.409262
Rf34	A1#9	A1#10	8.251274
Rf35	a_697_368#	a_697_368##3	110.992096
Rf36	a_697_368##3	a_697_368##4	122.570045
Rf37	a_697_368##2	a_697_368##3	5.000000
Rf39	VGND#2	VGND#3	69.348907
Rf40	VGND#3	VGND#4	85.809799
Rf41	VGND#2	VGND#5	35.098007
Rf42	VGND#3	VGND#6	35.098007
Rf44	VPWR#2	VPWR#3	136.612701
Rf45	VPWR#3	VPWR#4	16.834431
Rf46	VPWR#4	VPWR#5	51.963894
Rf47	VPWR#5	VPWR#6	68.798325
Rf48	VPWR#6	VPWR#7	118.119370
Rf49	VPWR#2	VPWR#8	31.534731
Rf50	VPWR#3	VPWR#9	38.736572
Rf51	VPWR#5	VPWR#10	53.143215
Rf52	VPWR#6	VPWR#11	42.573776
Rf55	B1#2	B1	80.116402
Re1	VPWR#4	VPWR	0.818510
Re2	VGND	VGND#4	0.818540
*
*       CAPACITOR CARDS
*
*
C1	VGND#3	A1#5	2.68047e-19
C2	a_510_74##4	a_510_74##6	1.8378e-18
C3	VPWR#3	B1#3	2.43993e-19
C4	a_299_74#	a_510_74##4	7.76097e-17
C5	VPWR#6	D1#2	4.24656e-20
C6	VGND#3	A1#4	6.81891e-19
C7	VPWR#4	B1#3	2.96618e-20
C8	Y#2	Y#1	3.08802e-19
C9	VGND#3	A2#6	4.87438e-18
C10	a_40_74##4	a_510_74##4	4.85426e-17
C11	a_299_74##2	a_299_74#	1.29289e-18
C12	Y#2	VPWR#9	3.03863e-17
C13	VGND#5	A1#3	8.22569e-19
C14	VGND#4	B1#3	7.40025e-20
C15	VGND#3	A2#5	4.11908e-18
C16	VGND#4	C1#4	5.98486e-20
C17	a_40_74##4	a_299_74##2	6.57606e-17
C18	Y#2	Y#7	1.05792e-18
C19	Y#3	VPWR#10	1.22221e-17
C20	VGND#4	D1#2	6.37226e-20
C21	VGND#3	B1#1	1.88603e-18
C22	a_40_74##2	a_40_74##4	3.65188e-18
C23	A1#3	A1#2	2.96422e-18
C24	Y#2	VPWR#10	1.2182e-17
C25	a_510_74##2	A1#5	2.23038e-19
C26	Y#3	Y#8	2.68731e-19
C27	a_40_74##2	a_299_74##2	5.00051e-17
C28	a_510_74##3	A1#4	3.80638e-20
C29	VGND#3	B1#5	2.87058e-19
C30	Y#8	Y#2	9.32592e-19
C31	a_510_74##2	A1#4	2.16938e-17
C32	Y#3	VPWR#11	1.67378e-17
C33	a_510_74##3	A2#6	9.02533e-20
C34	VGND#3	C1#6	7.09386e-20
C35	A2#3	A1#3	2.79894e-17
C36	a_40_74##2	Y#9	4.66372e-17
C37	a_510_74##2	A2#6	1.75885e-17
C38	A2#4	A2#3	3.87512e-18
C39	a_510_74##3	A2#5	2.14821e-17
C40	a_40_74#	a_40_74##2	2.67476e-18
C41	VGND#3	a_510_74##3	5.80197e-19
C42	a_510_74##2	A2#5	9.73365e-20
C43	a_40_74#	Y#9	6.57489e-17
C44	a_510_74##3	B1#1	1.70777e-17
C45	VGND#3	a_510_74##2	4.24373e-19
C46	a_510_74##2	B1#1	4.26554e-20
C47	a_510_74##3	B1#5	1.44497e-19
C48	a_697_368#	VPWR#8	8.42335e-17
C49	a_697_368##2	a_697_368#	2.34568e-18
C50	B1#1	A2#4	1.24762e-18
C51	a_510_74#	A1#5	3.09344e-17
C52	VPWR#3	A1#6	2.36762e-20
C53	Y#3	VPWR#6	2.5317e-19
C54	a_697_368##2	VPWR#8	6.89886e-17
C55	VGND#5	A1#5	3.49065e-17
C56	a_510_74#	A1#4	7.32174e-19
C57	B1#3	B1#1	1.00585e-18
C58	Y#3	VPWR#5	3.13618e-19
C59	a_510_74##5	A1#5	1.4597e-18
C60	VPWR#3	A2#1	7.96674e-20
C61	A1#4	VGND#5	1.73219e-17
C62	VGND#6	A1#5	2.929e-19
C63	Y#1	a_697_368##2	6.0765e-17
C64	a_510_74##5	A1#4	3.62995e-17
C65	VPWR#5	A2#7	1.76788e-20
C66	a_299_74#	B1#3	1.25247e-18
C67	Y#2	VPWR#5	3.13618e-19
C68	VGND#5	A2#6	7.05086e-19
C69	a_697_368##4	a_697_368##2	2.14025e-18
C70	VPWR#3	A2#7	5.35432e-18
C71	VGND#6	A1#4	1.43101e-18
C72	D1#4	D1#2	3.89437e-18
C73	A1#9	A1#1	3.27854e-18
C74	A2#6	a_510_74##5	1.14919e-17
C75	Y#1	a_697_368##4	9.75631e-17
C76	a_510_74##6	A1#4	1.25529e-19
C77	Y#2	VPWR#3	5.84736e-19
C78	VPWR#5	B1#6	5.03407e-19
C79	VGND#6	A2#6	3.48183e-17
C80	C1#4	B1#5	4.12824e-19
C81	VPWR#3	B1#6	2.33493e-18
C82	a_510_74##5	A2#5	3.21003e-19
C83	a_510_74##6	A2#6	2.97644e-19
C84	VPWR#6	B1#4	8.74044e-20
C85	VGND#6	A2#5	3.02799e-17
C86	a_510_74##4	B1#3	3.07746e-18
C87	VPWR#9	a_697_368##4	5.52566e-17
C88	VPWR#5	B1#4	5.12698e-18
C89	Y#7	Y#1	1.17639e-18
C90	a_510_74##5	B1#1	1.40672e-19
C91	A2#5	a_510_74##6	1.38208e-17
C92	VPWR#3	B1#4	5.45681e-19
C93	a_510_74##3	a_510_74##2	5.07427e-19
C94	VGND#6	B1#1	1.43011e-18
C95	VPWR#6	C1#1	3.00302e-19
C96	a_299_74#	A2#5	1.79423e-18
C97	a_40_74#	VPWR#7	4.1321e-19
C98	B1#1	a_510_74##6	1.7219e-17
C99	VPWR#5	C1#1	5.10975e-18
C100	Y#7	VPWR#9	5.29637e-17
C101	a_510_74##4	A2#5	2.00467e-19
C102	VPWR#3	C1#1	8.74044e-20
C103	a_299_74#	B1#1	4.23592e-17
C104	a_510_74##6	B1#5	4.76533e-19
C105	VPWR#10	VPWR#9	1.94092e-18
C106	VPWR#6	C1#7	5.36173e-18
C107	a_510_74##4	B1#1	9.69416e-19
C108	VPWR#5	C1#7	2.85183e-19
C109	a_299_74#	B1#5	3.27494e-17
C110	VPWR#10	Y#7	5.21059e-17
C111	A2#10	A2#1	4.04133e-18
C112	a_40_74##4	C1#4	1.79659e-18
C113	a_510_74##4	B1#5	5.53151e-17
C114	a_299_74##2	B1#1	1.16007e-19
C115	Y#8	Y#7	2.36849e-18
C116	VPWR#6	D1#1	4.56693e-18
C117	a_299_74#	C1#6	3.73987e-19
C118	a_40_74##4	B1#5	1.0688e-18
C119	VPWR#5	D1#1	7.86402e-20
C120	a_510_74##4	C1#6	9.41268e-19
C121	Y#8	VPWR#10	5.20507e-17
C122	a_299_74##2	B1#5	3.73987e-19
C123	a_299_74#	C1#5	1.16007e-19
C124	a_40_74##4	C1#6	5.17733e-17
C125	VPWR#6	D1#7	2.93878e-18
C126	VPWR#11	VPWR#10	1.94092e-18
C127	a_299_74##2	C1#6	3.38549e-17
C128	a_510_74##2	A2#10	1.95675e-17
C129	D1#2	C1#5	1.93068e-18
C130	a_40_74##4	C1#5	1.47128e-18
C131	C1#4	a_299_74##2	1.36548e-18
C132	VPWR#11	Y#8	5.96469e-17
C133	a_40_74##2	C1#6	8.82108e-19
C134	Y#3	A2#7	2.10945e-19
C135	a_299_74##2	C1#5	3.26052e-17
C136	Y#9	C1#6	5.52944e-20
C137	Y#2	A2#7	8.40454e-20
C138	a_40_74##4	D1#5	4.81932e-19
C139	a_40_74##2	C1#5	3.01501e-17
C140	a_299_74##2	D1#5	9.57431e-19
C141	Y#3	B1#6	4.74115e-19
C142	Y#9	C1#5	1.33875e-18
C143	Y#2	B1#6	2.3439e-17
C144	a_40_74##2	D1#5	3.03038e-17
C145	a_510_74##2	A1#3	3.52839e-18
C146	VPWR#4	VPWR#6	4.56007e-17
C147	VPWR#7	VPWR#11	2.09124e-18
C148	a_40_74#	C1#5	2.16679e-19
C149	VPWR#4	VPWR#5	3.22596e-17
C150	Y#9	D1#5	3.08471e-17
C151	a_40_74##2	C1#4	6.05037e-19
C152	Y#3	B1#4	5.16755e-19
C153	VPWR#4	VPWR#3	4.20899e-17
C154	a_40_74##2	D1#6	7.4152e-19
C155	Y#2	B1#4	2.41293e-17
C156	a_40_74#	D1#5	6.62489e-18
C157	a_510_74##3	B1#3	1.01846e-18
C158	D1#6	Y#9	1.50262e-17
C159	Y#3	C1#1	2.44892e-17
C160	a_40_74#	D1#6	5.05075e-17
C161	Y#2	C1#1	2.34763e-19
C162	Y#3	C1#7	2.08727e-17
C163	Y#9	C1#4	1.32707e-20
C164	VGND#4	VGND#3	4.44542e-17
C165	VGND#3	a_510_74##5	6.4837e-18
C166	A1#4	A1#5	2.46519e-17
C167	Y#3	D1#1	5.52653e-19
C168	A1	A1#3	8.08486e-18
C169	a_697_368#	A1#1	5.5573e-17
C170	B1#3	A2#4	2.37422e-17
C171	A1#1	VPWR#8	2.96403e-17
C172	A2#6	A1#4	4.00687e-17
C173	a_697_368#	A1#3	8.77047e-19
C174	a_697_368#	A1#6	1.91721e-18
C175	VPWR#3	A2#3	1.04473e-20
C176	a_697_368##2	A1#1	6.97159e-19
C177	a_299_74#	B1#4	9.23647e-19
C178	VPWR#8	A1#6	4.9709e-17
C179	Y#9	D1#2	1.05912e-18
C180	a_510_74##4	B1#4	7.7138e-19
C181	VGND#4	a_510_74##3	4.47581e-19
C182	a_697_368#	A2#1	2.00227e-19
C183	VGND#3	a_510_74##6	1.04974e-17
C184	a_697_368##2	A1#6	6.54269e-17
C185	A2#5	A2#6	3.59958e-17
C186	VPWR#8	A2#1	2.16698e-18
C187	A1#9	A1#2	1.08919e-17
C188	Y#1	A1#6	1.60785e-18
C189	A2	A1#3	1.47977e-17
C190	a_299_74##2	B1#4	1.96013e-18
C191	a_510_74#	A1#9	1.97533e-17
C192	A2	A2#4	3.71251e-19
C193	a_697_368##2	A2#1	2.87802e-17
C194	a_697_368##4	A1#6	1.83236e-19
C195	A2	B1#3	3.42527e-18
C196	VPWR#8	A2#7	2.35392e-19
C197	Y#1	A2#1	4.96843e-17
C198	a_299_74#	VGND#3	8.69323e-19
C199	a_510_74##2	A1#2	1.06275e-18
C200	B1#1	A2#5	4.08629e-17
C201	A1#3	VPWR#8	7.04498e-19
C202	a_697_368##2	A2#7	3.79489e-19
C203	Y#2	VPWR#4	3.80219e-19
C204	a_697_368##4	A2#1	6.12222e-18
C205	VPWR#8	B1#6	3.50549e-20
C206	Y#1	A2#7	6.62998e-17
C207	a_40_74#	D1#2	2.26648e-19
C208	a_510_74##3	A2#3	1.60881e-18
C209	a_697_368##2	B1#6	5.87e-20
C210	a_697_368##4	A2#7	4.72415e-17
C211	a_510_74##2	A2#3	1.27194e-18
C212	B1#5	B1#1	2.51139e-17
C213	VPWR#6	D1#4	4.30395e-20
C214	Y#1	B1#6	4.04218e-19
C215	VPWR#9	A2#7	1.26648e-18
C216	a_697_368##4	B1#6	1.36503e-18
C217	B1	A2#4	1.0425e-17
C218	Y#7	A2#7	3.20173e-19
C219	A2#10	A2#3	1.02708e-17
C220	B1	B1#3	4.49977e-17
C221	B1#6	VPWR#9	4.24163e-17
C222	C1#6	B1#5	3.84248e-18
C223	a_510_74##2	a_510_74#	5.57916e-19
C224	B1	C1#4	4.14335e-18
C225	VPWR#10	A2#7	5.6282e-20
C226	a_697_368##2	A1#3	4.98727e-19
C227	B1	D1#2	7.75985e-21
C228	Y#7	B1#6	5.25131e-17
C229	VPWR#9	B1#4	3.71489e-19
C230	VPWR#10	B1#6	6.1269e-19
C231	C1#5	C1#6	2.66657e-17
C232	Y#7	B1#4	4.60726e-17
C233	a_510_74##2	VGND#5	2.42965e-17
C234	VPWR#9	C1#1	1.72497e-19
C235	B1#4	VPWR#10	2.47104e-17
C236	a_510_74#	A1#2	2.4776e-18
C237	VGND#5	A1#2	4.06144e-19
C238	Y#7	C1#1	1.85051e-18
C239	Y#8	B1#4	1.82445e-18
C240	C1#4	B1#3	1.86052e-18
C241	C1	A2#4	3.2906e-19
C242	VGND#4	a_299_74#	6.70961e-17
C243	D1#5	C1#5	3.78409e-17
C244	C1#1	VPWR#10	2.84583e-17
C245	a_510_74##2	a_510_74##5	5.26243e-19
C246	C1	B1#3	1.27953e-18
C247	VPWR#11	B1#4	1.72497e-19
C248	C1	C1#4	3.57897e-17
C249	a_510_74##3	VGND#6	1.52802e-17
C250	Y#8	C1#1	5.33623e-17
C251	C1	D1#2	8.77988e-18
C252	VPWR#10	C1#7	3.44144e-19
C253	VPWR#11	C1#1	3.71489e-19
C254	VGND#4	a_299_74##2	7.46302e-17
C255	D1#6	D1#5	3.72907e-17
C256	Y#8	C1#7	4.63585e-17
C257	VGND#6	A2#3	9.92666e-19
C258	VGND#4	a_40_74##2	3.31667e-17
C259	a_510_74##2	VGND#6	1.37623e-17
C260	VPWR#10	D1#1	1.54166e-19
C261	a_510_74##3	a_510_74##6	1.24483e-18
C262	C1#7	VPWR#11	2.73618e-17
C263	B1#3	A2#7	3.03717e-20
C264	VGND#4	a_40_74#	5.97801e-17
C265	Y#8	D1#1	1.25916e-18
C266	D1#1	VPWR#11	3.27112e-17
C267	VPWR#7	C1#7	2.54733e-19
C268	D1#1	Y#5	2.37354e-17
C269	a_510_74##3	a_299_74#	1.33734e-17
C270	VPWR#11	D1#7	7.81638e-19
C271	Y#1	B1#3	4.64508e-18
C272	A1#2	a_697_368#	2.85762e-18
C273	VPWR#7	D1#1	1.22325e-18
C274	A1#2	VPWR#8	8.4076e-19
C275	D1#7	Y#5	2.44089e-17
C276	Y#7	VPWR#4	1.30919e-17
C277	VPWR#3	VPWR#8	5.76365e-20
C278	VPWR#7	D1#7	3.35123e-17
C279	a_510_74##4	a_510_74##3	5.57268e-19
C280	A1#6	A1#1	3.71508e-17
C281	A2#3	Y#1	3.83589e-18
C282	a_697_368##4	A2#3	2.27774e-19
C283	VPWR#4	VPWR#7	2.70303e-17
C284	A2#1	A1#6	4.72094e-17
C285	Y	B1#3	1.50607e-19
C286	Y	C1#4	3.59118e-18
C287	a_697_368##4	B1#3	1.05863e-18
C288	Y	D1#2	1.54854e-17
C289	Y#9	D1#4	7.41023e-18
C290	A2#7	A2#1	4.61915e-17
C291	D1#4	a_40_74#	4.71541e-17
C292	Y#1	VPWR#3	6.53982e-19
C293	B1#4	B1#3	1.16222e-18
C294	B1#6	A2#7	5.34952e-18
C295	VPWR#6	VPWR#5	6.99578e-19
C296	C1#4	B1#4	1.67106e-17
C297	a_510_74##2	A1	2.19134e-17
C298	VGND#4	B1#1	3.40934e-18
C299	VPWR#3	a_697_368##4	4.34719e-17
C300	VGND#4	B1#5	4.47052e-18
C301	B1#4	B1#6	4.68012e-17
C302	VGND#4	C1#6	4.43427e-18
C303	B1#3	VPWR#9	2.81962e-18
C304	VGND#4	C1#5	4.59124e-18
C305	a_510_74##3	A2	1.55028e-17
C306	a_510_74##2	A2	3.88006e-17
C307	VGND#4	D1#5	4.41949e-18
C308	C1#1	B1#4	4.88857e-17
C309	VGND#4	D1#6	4.48038e-18
C310	D1#4	VPWR#7	3.25744e-17
C311	a_510_74#	A1	2.37054e-17
C312	C1#7	C1#1	4.69321e-17
C313	a_510_74##3	B1	5.15947e-17
C314	Y#7	VPWR#5	3.79675e-18
C315	A1#9	a_697_368#	1.81551e-17
C316	VPWR#5	VPWR#3	6.99578e-19
C317	D1#2	C1#4	2.60499e-17
C318	D1#1	C1#7	3.86472e-17
C319	A1#6	A1#2	2.78423e-19
C320	VGND	C1#4	1.21503e-19
C321	VPWR#4	B1#6	5.64428e-18
C322	Y#3	C1#4	5.04228e-18
C323	B1#3	Y#7	4.16646e-19
C324	VPWR#4	B1#4	9.10669e-21
C325	B1	Y#2	8.13415e-17
C326	A2#3	A1#6	3.47913e-19
C327	D1#7	D1#1	4.92241e-17
C328	VGND#4	B1#4	5.42328e-20
C329	a_299_74#	Y#2	1.09756e-18
C330	A1	a_697_368#	4.3088e-17
C331	Y#8	VPWR#6	8.49566e-18
C332	C1	Y#3	6.07556e-17
C333	a_510_74#	VGND#5	4.84333e-17
C334	Y#2	B1#3	7.05347e-18
C335	Y	VPWR#6	1.68984e-17
C336	a_299_74#	B1	1.73084e-18
C337	a_510_74##4	B1	5.49504e-17
C338	Y#8	VPWR#5	8.42956e-18
C339	a_40_74##4	Y#3	3.76568e-18
C340	A2	a_697_368##2	3.75815e-17
C341	A2	Y#1	2.21358e-17
C342	a_510_74##5	a_510_74#	1.83994e-18
C343	a_40_74##4	C1	4.31518e-17
C344	a_40_74##4	Y#2	5.29231e-18
C345	C1	a_299_74##2	1.60212e-19
C346	B1	Y#1	3.65199e-17
C347	VPWR	VPWR#6	3.90531e-17
C348	a_40_74##2	C1	1.56032e-17
C349	VPWR	VPWR#5	2.68552e-17
C350	Y#9	C1	1.38806e-18
C351	VPWR	VPWR#3	3.93493e-17
C352	a_510_74##5	VGND#5	4.45083e-17
C353	Y	Y#3	3.06422e-18
C354	VPWR	A1#9	1.08151e-18
C355	a_299_74##2	Y#2	1.31813e-18
C356	a_510_74##2	a_697_368##2	4.76261e-18
C357	a_40_74##2	Y#3	4.09296e-18
C358	D1#1	C1#4	1.8269e-18
C359	VPWR	A2#10	1.65262e-18
C360	C1	Y#8	3.1615e-18
C361	VGND#6	VGND#5	2.5199e-18
C362	a_510_74##3	Y#1	4.72353e-18
C363	VPWR	Y#3	2.44781e-18
C364	VGND#4	D1#4	2.07115e-18
C365	VPWR	Y#2	5.08681e-18
C366	VGND	VGND#3	4.57083e-17
C367	A1	A1#6	1.48344e-18
C368	a_40_74##2	Y	7.55717e-18
C369	A1#3	VNB	2.85733e-17
C370	A2#4	VNB	1.77942e-17
C371	B1#3	VNB	6.9687e-17
C372	C1#4	VNB	5.37576e-17
C373	D1#2	VNB	2.29946e-17
C374	VGND	A1#9	1.15042e-18
C375	A2	A1#1	4.35648e-19
C376	C1	A2#5	2.805e-19
C377	VGND	a_510_74##3	3.65707e-18
C378	A2	A1#6	2.84891e-19
C379	VGND	a_510_74##2	3.70502e-18
C380	C1	B1#1	3.39095e-19
C381	VGND#6	a_510_74##5	3.85026e-17
C382	C1	B1#5	8.69856e-19
C383	A2	A2#1	1.25793e-18
C384	VPWR#7	VPWR#6	7.43786e-19
C385	VGND	A2#10	1.25576e-18
C386	C1	C1#6	2.64601e-18
C387	A2	A2#7	1.54362e-18
C388	C1	C1#5	2.41479e-18
C389	VGND	Y#3	2.74087e-18
C390	Y	VPWR#11	8.9083e-17
C391	B1	A2#1	1.38328e-19
C392	VPWR	a_697_368#	1.74507e-17
C393	Y	Y#5	8.92839e-19
C394	VPWR	VPWR#8	2.19308e-17
C395	B1	A2#7	1.43541e-18
C396	VGND	a_510_74#	1.43014e-17
C397	VPWR#7	Y	8.80761e-17
C398	VPWR	a_697_368##2	1.56515e-17
C399	VPWR	Y#1	1.0617e-17
C400	VGND	a_510_74##5	1.32633e-17
C401	VPWR	a_697_368##4	2.53167e-17
C402	B1	B1#4	5.7528e-18
C403	VGND	a_510_74##6	1.09498e-17
C404	VGND	a_299_74#	2.92479e-17
C405	a_510_74##6	a_510_74##5	1.67343e-18
C406	VPWR	Y#7	1.6014e-17
C407	VGND	a_510_74##4	8.80215e-18
C408	B1	C1#1	3.93646e-19
C409	VGND	a_40_74##4	9.65729e-18
C410	A2#10	a_697_368##2	9.29333e-19
C411	VPWR	Y#8	1.59572e-17
C412	VGND	a_299_74##2	2.95985e-17
C413	B1	C1#7	2.18262e-19
C414	VGND	a_40_74##2	1.73107e-17
C415	VGND	Y#9	8.75401e-18
C416	B1	D1#1	2.2038e-19
C417	VGND	a_40_74#	2.55407e-17
C418	C1	B1#4	3.19739e-18
C419	A1	A1#2	1.52126e-17
C420	VPWR	VPWR#7	3.26494e-17
C421	VPWR#6	C1#4	4.57114e-20
C422	A2	A1#2	1.04776e-19
C423	A2	A2#3	1.64264e-17
C424	VPWR#6	VNB	3.38186e-17
C425	a_510_74##6	VGND#6	4.16102e-17
C426	VPWR#5	VNB	2.3161e-17
C427	VPWR#3	VNB	3.42655e-17
C428	VGND	VPWR#7	2.89261e-18
C429	VGND#3	VNB	3.36498e-17
C430	VGND	A1#5	1.48218e-18
C431	B1	A2#3	3.32688e-20
C432	VGND	A1#4	1.49773e-19
C433	Y	B1#4	3.69116e-19
C434	VGND	A2#6	9.53643e-19
C435	A1#9	VNB	5.27173e-19
C436	VPWR	A1#1	6.02079e-19
C437	VGND	A2#5	8.39544e-19
C438	Y	C1#1	2.37759e-19
C439	A2#10	Y#1	1.99396e-17
C440	a_510_74##3	VNB	2.11783e-18
C441	VPWR	A1#6	1.24223e-18
C442	a_510_74##2	VNB	2.09925e-18
C443	VGND	B1#1	2.04553e-18
C444	Y	C1#7	2.81175e-18
C445	VGND	B1#5	1.59434e-18
C446	VPWR	A2#1	1.39622e-18
C447	A2#10	VNB	1.34017e-18
C448	VGND	C1#6	1.69879e-18
C449	Y	D1#1	5.58424e-17
C450	VPWR	A2#7	1.71202e-18
C451	VGND	C1#5	2.07273e-18
C452	Y#3	VNB	1.32399e-18
C453	VPWR	B1#6	2.3281e-19
C454	Y	D1#7	3.41306e-17
C455	Y#2	VNB	2.2659e-18
C456	VGND	D1#5	1.67184e-18
C457	VPWR	B1#4	8.38049e-19
C458	VGND	D1#6	2.39608e-18
C459	VPWR	C1#1	9.03173e-19
C460	a_510_74#	VNB	4.33907e-17
C461	VGND#5	VNB	2.81342e-18
C462	VPWR	C1#7	9.53499e-19
C463	a_510_74##5	VNB	2.12109e-18
C464	VGND#6	VNB	5.92639e-20
C465	a_510_74##6	VNB	4.55828e-18
C466	VPWR	D1#1	2.34428e-19
C467	a_299_74#	VNB	6.29005e-18
C468	a_510_74##4	VNB	5.71117e-18
C469	VPWR	D1#7	5.09974e-18
C470	a_299_74#	VGND#6	3.53461e-18
C471	a_40_74##4	VNB	1.05116e-17
C472	a_299_74##2	VNB	7.20177e-18
C473	a_40_74##2	VNB	9.60949e-18
C474	Y#9	VNB	1.16134e-18
C475	a_40_74#	VNB	4.03077e-17
C476	VGND	B1#4	5.23635e-21
C477	VPWR	VPWR#4	1.02298e-17
C478	a_697_368#	VNB	5.2549e-17
C479	VPWR#8	VNB	1.79317e-18
C480	a_697_368##2	VNB	2.28386e-18
C481	A2	A1	2.86993e-17
C482	Y#1	VNB	1.26606e-18
C483	a_697_368##4	VNB	1.38179e-17
C484	VPWR#9	VNB	8.68609e-18
C485	Y#7	VNB	2.1429e-18
C486	Y	D1#4	5.16984e-17
C487	VPWR#10	VNB	2.92383e-18
C488	Y#8	VNB	2.13725e-18
C489	VPWR#11	VNB	3.0111e-18
C490	VPWR#7	VNB	8.09701e-17
C491	A1#5	VNB	3.05595e-17
C492	B1	A2	2.97109e-17
C493	A1#4	VNB	2.70813e-17
C494	VGND	VGND#4	6.83342e-17
C495	A2#10	a_697_368##4	1.04419e-19
C496	A2#6	VNB	2.50988e-17
C497	VPWR	D1#4	2.25426e-18
C498	A2#5	VNB	2.5425e-17
C499	B1#1	VNB	2.89926e-17
C500	B1#5	VNB	3.17841e-17
C501	C1#6	VNB	2.97017e-17
C502	C1#5	VNB	2.75141e-17
C503	D1#5	VNB	2.69871e-17
C504	D1#6	VNB	3.4628e-17
C505	C1	B1	1.57389e-17
C506	A1#1	VNB	3.79605e-17
C507	VGND	D1#4	5.95355e-18
C508	A1#6	VNB	2.97559e-17
C509	A2#1	VNB	3.22959e-17
C510	A2#7	VNB	3.74574e-17
C511	a_299_74#	a_510_74##6	4.24116e-17
C512	B1#6	VNB	3.50232e-17
C513	B1#4	VNB	5.61603e-17
C514	C1#1	VNB	3.36013e-17
C515	VPWR	A1	3.03675e-18
C516	C1#7	VNB	3.34246e-17
C517	Y	B1	2.78393e-18
C518	D1#1	VNB	3.4985e-17
C519	D1#7	VNB	4.52701e-17
C520	VPWR	A2	3.24896e-18
C521	Y	C1	1.64264e-17
C522	VPWR#4	VNB	2.47578e-16
C523	VPWR	B1	7.22274e-18
C524	VGND#4	VNB	3.5135e-16
C525	VGND	A1	4.86335e-18
C526	A1#2	VNB	4.50695e-17
C527	A2#3	VNB	3.34261e-17
C528	VGND	A2	3.4955e-18
C529	VPWR	C1	3.61579e-18
C530	VPWR#5	C1#4	7.55762e-20
C531	VGND	B1	7.79994e-18
C532	D1#4	VNB	8.74875e-17
C533	VGND	C1	4.74737e-18
C534	VPWR	Y	1.83234e-17
C535	VGND	Y	1.66729e-18
C536	A1	VNB	3.19291e-17
C537	A2	VNB	6.30559e-18
C538	B1	VNB	1.30449e-17
C539	C1	VNB	5.19176e-18
C540	Y	VNB	1.1117e-17
C541	VPWR	VNB	7.45601e-17
C542	VGND	VNB	8.40785e-17
C543	VPWR	VPWR#2	4.28796e-17
C544	VPWR#2	A1#1	2.58372e-18
C545	VGND#2	A1	7.96516e-19
C546	VPWR#2	A2#3	1.9532e-20
C547	VGND#2	a_510_74#	1.7841e-17
C548	VGND#2	A1#2	6.01445e-20
C549	VGND#2	VNB	4.91026e-17
C550	VGND#4	VGND#2	5.32562e-17
C551	VPWR#2	A1#2	2.32007e-20
C552	a_697_368##2	VPWR#2	2.7247e-17
C553	VPWR#2	VNB	6.29889e-17
C554	VGND	VGND#2	5.48383e-17
C555	VGND#3	VGND#2	1.13938e-18
C556	VPWR#3	VPWR#2	2.13734e-19
C557	VGND#2	A2#6	5.71195e-19
C558	VGND#2	a_510_74##2	2.25448e-19
C559	VGND#2	A1#4	4.72588e-18
C560	VPWR#2	A2#1	4.44912e-18
C561	VGND#2	A1#5	4.10851e-18
C562	VPWR#4	VPWR#2	7.31928e-17
C563	a_697_368#	VPWR#2	2.09699e-17
C564	VPWR#2	A1#6	1.84084e-18
C565	VGND#2	a_510_74##5	7.19806e-18
C566	a_697_368##4	VPWR#2	1.61664e-17
*
*
.ENDS sky130_fd_sc_hs__o2111ai_2
*
