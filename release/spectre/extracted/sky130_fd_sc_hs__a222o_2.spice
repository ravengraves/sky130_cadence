* Extracted by Quantus, converted by sky130cad/quantus.py
*
*
*
*                       LINUX           Wed Nov 18 08:07:45 2026
*
*
*
*  PROGRAM  advgen
*
*  Name           : advgen - Quantus - (64-bit)
*  Version        : 25.1.0-p047
*  Build Date     : Thu Dec 11 23:20:30 PST 2025
*
*  HSPICE LIBRARY
*
*  OPERATING_TEMPERATURE 150
*  QRC_TECH_DIR <path>/tech
*
*
*

*
.SUBCKT sky130_fd_sc_hs__a222o_2 VPB VNB VGND VPWR X C2 C1 A1 B1 B2 A2
*
*
*  caps2d version: 10
*
*
*       TRANSISTOR CARDS
*
*
XM1 a_27_82##10 C1#4 a_114_82# VNB sky130_fd_pr__nfet_01v8_lvt l=0.15 w=0.64 ad=0.1824 as=0.1536 pd=1.85 ps=1.76
XM15 a_114_82# C2#3 VGND#9 VNB sky130_fd_pr__nfet_01v8_lvt l=0.15 w=0.64 ad=0.1536 as=0.4154 pd=1.76 ps=2.7
XM3 VGND#9 a_27_82##4 X#2 VNB sky130_fd_pr__nfet_01v8_lvt l=0.15 w=0.74 ad=0.4154 as=0.2072 pd=2.7 ps=2.04
XM6 X#2 a_27_82##5 VGND#8 VNB sky130_fd_pr__nfet_01v8_lvt l=0.15 w=0.74 ad=0.2072 as=0.2586 pd=2.04 ps=2.67
XM13 a_557_74##2 A1#1 a_27_82##7 VNB sky130_fd_pr__nfet_01v8_lvt l=0.15 w=0.64 ad=0.1971 as=0.3008 pd=1.92 ps=2.22
XM4 a_27_82##7 B1#1 a_775_74# VNB sky130_fd_pr__nfet_01v8_lvt l=0.15 w=0.64 ad=0.3008 as=0.1536 pd=2.22 ps=1.76
XM2 a_775_74# B2#3 VGND#7 VNB sky130_fd_pr__nfet_01v8_lvt l=0.15 w=0.64 ad=0.1536 as=0.2688 pd=1.76 ps=2.12
XM7 VGND#7 A2#3 a_557_74# VNB sky130_fd_pr__nfet_01v8_lvt l=0.15 w=0.64 ad=0.2688 as=0.1824 pd=2.12 ps=1.85
XM8 a_27_82##14 C1#1 a_116_392# VPB sky130_fd_pr__pfet_01v8 l=0.15 w=1 ad=0.295 as=0.3 pd=2.59 ps=2.6
XM14 a_116_392# C2#1 a_27_82##12 VPB sky130_fd_pr__pfet_01v8 l=0.15 w=1 ad=0.3 as=0.295 pd=2.6 ps=2.59
XM5 X#1 a_27_82##6 VPWR#5 VPB sky130_fd_pr__pfet_01v8 l=0.15 w=1.12 ad=0.336 as=0.34065 pd=2.84 ps=3.12
XM12 VPWR#3 a_27_82# X#1 VPB sky130_fd_pr__pfet_01v8 l=0.15 w=1.12 ad=0.533 as=0.336 pd=3.3 ps=2.84
XM9 VPWR#3 A1#3 a_639_368##2 VPB sky130_fd_pr__pfet_01v8 l=0.15 w=1 ad=0.533 as=0.5635 pd=3.3 ps=3.37
XM0 a_639_368##2 B1#3 a_116_392##2 VPB sky130_fd_pr__pfet_01v8 l=0.15 w=1 ad=0.5635 as=0.3 pd=3.37 ps=2.6
XM11 a_116_392##2 B2#1 a_639_368# VPB sky130_fd_pr__pfet_01v8 l=0.15 w=1 ad=0.3 as=0.4 pd=2.6 ps=2.8
XM10 a_639_368# A2#1 VPWR#1 VPB sky130_fd_pr__pfet_01v8 l=0.15 w=1 ad=0.4 as=0.295 pd=2.8 ps=2.59
*
*
*       RESISTOR AND CAP/DIODE CARDS
*
Rg1	C1#1	C1#2	519.456787
Rg2	C1#2	C1#3	28.628225
Rg3	C1#2	C1#4	379.815125
Rg4	C2#1	C2#2	492.429810
Rg5	C2#2	C2#3	336.630798
Rg6	a_27_82#	a_27_82##2	472.386536
Rg7	a_27_82##2	a_27_82##3	60.526707
Rg8	a_27_82##3	a_27_82##4	486.106079
Rg9	a_27_82##3	a_27_82##5	319.912079
Rg10	a_27_82##3	a_27_82##6	487.584198
Rg11	A1#1	A1#2	411.232849
Rg12	A1#2	A1#3	400.207520
Rg13	B1#1	B1#2	403.891846
Rg14	B1#2	B1#3	392.866516
Rg15	B2#1	B2#2	400.207520
Rg16	B2#2	B2#3	411.232849
Rg17	A2#1	A2#2	400.207520
Rg18	A2#2	A2#3	411.232849
Rf1	C1	C1#3	168.106262
Rf2	C2#4	C2	2.969661
Rf3	C2#2	C2#6	163.202469
Rf4	C2#4	C2#6	6.486803
Rf5	X#1	X	18.957056
Rf6	X	X#2	59.382519
Rf7	A1	A1#2	166.137894
Rf8	a_27_82##7	a_27_82##8	83.499641
Rf9	a_27_82##8	a_27_82##9	108.478493
Rf10	a_27_82##9	a_27_82##10	98.755333
Rf11	a_27_82##8	a_27_82##2	173.826584
Rf12	a_27_82##9	a_27_82##13	86.216248
Rf13	a_27_82##13	a_27_82##14	67.898949
Rf14	a_27_82##12	a_27_82##13	15.000000
Rf15	B1#2	B1	166.137894
Rf16	a_116_392#	a_116_392##2	244.736374
Rf17	B2#4	B2	2.061435
Rf18	B2#2	B2#6	162.294235
Rf19	B2#4	B2#6	6.112055
Rf20	a_639_368#	a_639_368##2	110.963707
Rf21	a_557_74#	a_557_74##2	220.868256
Rf22	A2#2	A2#5	162.336563
Rf23	A2#6	A2	2.103764
Rf24	A2#5	A2#6	5.806452
Rf25	VPWR#1	VPWR#2	211.779129
Rf26	VPWR#2	VPWR#3	33.084488
Rf27	VPWR#2	VPWR#4	65.720917
Rf28	VPWR#4	VPWR#5	29.586588
Rf31	VGND#2	VGND#3	130.370605
Rf32	VGND#3	VGND#4	19.699100
Rf33	VGND#4	VGND#5	95.704430
Rf35	VGND#2	VGND#7	36.672695
Rf36	VGND#4	VGND#8	24.468842
Rf37	VGND#5	VGND#9	39.841232
Re1	VPWR#2	VPWR	0.892922
Re2	VGND	VGND#3	0.892955
*
*       CAPACITOR CARDS
*
*
C1	a_27_82##9	a_27_82##3	6.03559e-19
C2	a_557_74##2	VGND#7	3.33127e-17
C3	a_116_392#	a_27_82##3	2.0389e-19
C4	VGND#4	B2#3	2.74993e-19
C5	a_557_74##2	a_27_82##7	8.06314e-17
C6	a_27_82##8	a_27_82##3	1.11465e-19
C7	a_27_82##8	a_116_392##2	8.21839e-18
C8	a_27_82##10	C2#4	2.50588e-17
C9	VGND#4	B1#1	5.60568e-19
C10	VGND#4	A1#1	2.98182e-18
C11	a_27_82##3	a_27_82##2	3.6081e-18
C12	VGND#4	a_27_82##5	1.25721e-17
C13	VGND#9	a_557_74##2	2.08009e-18
C14	a_557_74#	a_639_368#	9.66279e-18
C15	VGND#4	a_27_82##4	4.51668e-18
C16	a_27_82##9	a_27_82##12	3.21197e-18
C17	a_557_74#	a_116_392##2	4.06988e-18
C18	C2#2	a_27_82##3	2.18641e-18
C19	VGND#4	C2#3	5.04061e-19
C20	a_27_82##9	a_116_392#	8.48485e-19
C21	a_27_82##7	a_116_392##2	3.26711e-18
C22	a_27_82##10	VGND#9	1.12561e-17
C23	a_557_74##2	a_116_392##2	8.70639e-19
C24	C2#4	a_27_82##12	1.86592e-17
C25	C2#4	a_27_82##14	1.08432e-17
C26	a_27_82##8	B1#1	1.1727e-19
C27	a_27_82##9	A1#1	5.58808e-20
C28	a_27_82##8	A1#1	1.72225e-18
C29	a_639_368#	VPWR#1	1.41305e-16
C30	a_27_82##9	a_27_82##5	8.28937e-19
C31	a_557_74#	A2#3	4.50972e-17
C32	a_27_82##8	a_27_82##5	1.752e-17
C33	a_27_82##9	a_27_82##4	2.21406e-17
C34	A2#3	VGND#7	1.64418e-17
C35	a_557_74#	B2#3	1.83384e-17
C36	a_116_392##2	a_639_368#	8.5787e-17
C37	A2#5	A2#1	3.62634e-18
C38	a_27_82##8	a_27_82##4	6.70341e-19
C39	VGND#7	B2#3	3.27107e-17
C40	a_27_82##9	C2#3	2.09327e-17
C41	a_639_368##2	a_639_368#	2.45086e-18
C42	a_557_74#	B1#1	5.84584e-18
C43	A2#5	B2#1	4.29231e-19
C44	a_27_82##8	C2#3	1.22382e-19
C45	a_116_392##2	a_639_368##2	7.02101e-17
C46	VGND#7	B1#1	1.57575e-18
C47	a_27_82##9	C1#4	6.22649e-19
C48	a_27_82##7	B2#3	1.05754e-18
C49	a_116_392##2	VPWR#3	5.36291e-17
C50	VGND#7	A1#1	5.00202e-19
C51	a_557_74##2	B2#3	6.03993e-18
C52	a_27_82##7	B1#1	3.56062e-17
C53	VPWR#3	a_639_368##2	2.10421e-17
C54	a_116_392##2	X#1	2.06303e-19
C55	a_557_74##2	B1#1	2.12237e-17
C56	a_27_82##7	A1#1	3.68007e-17
C57	a_27_82##10	a_27_82##14	2.45269e-18
C58	a_557_74##2	A1#1	3.68799e-17
C59	a_27_82##7	a_27_82##5	3.23726e-19
C60	a_557_74##2	a_27_82##5	3.35086e-18
C61	VPWR#5	VPWR#3	7.72413e-18
C62	X#2	A1#1	1.28467e-19
C63	a_27_82##5	VGND#8	1.20124e-17
C64	a_557_74##2	a_27_82##4	4.53616e-19
C65	VGND#9	A1#1	4.19999e-19
C66	X#2	a_27_82##5	2.25278e-17
C67	VGND#4	a_27_82##3	1.44387e-19
C68	a_557_74##2	C2#3	2.05879e-19
C69	VGND#9	a_27_82##5	1.41882e-18
C70	X#2	a_27_82##4	3.04727e-17
C71	a_116_392#	X#1	3.82774e-18
C72	a_27_82##4	VGND#9	1.18122e-17
C73	X#2	C2#3	3.00402e-19
C74	a_116_392#	VPWR#5	4.92977e-17
C75	VGND#3	VGND#4	3.42638e-17
C76	VGND#9	C2#3	3.40591e-17
C77	a_27_82##12	a_116_392#	8.97227e-17
C78	a_27_82##10	a_27_82##4	3.09696e-19
C79	VGND#4	a_27_82##9	4.60117e-18
C80	VGND#9	C1#4	5.79717e-18
C81	a_27_82##10	C2#3	4.57455e-18
C82	a_27_82##14	a_116_392#	5.45983e-17
C83	VGND#4	a_27_82##8	3.50981e-17
C84	a_27_82##10	C1#4	4.46622e-17
C85	A2#5	A2#2	1.31659e-17
C86	VPWR#1	A2#1	5.19562e-17
C87	B2#3	A2#3	1.72865e-17
C88	VPWR#5	a_27_82##4	4.26646e-19
C89	A2#1	a_639_368#	3.07472e-17
C90	VPWR#1	B2#1	3.19935e-18
C91	B2#2	A2#5	3.19119e-17
C92	a_639_368#	B2#1	3.91333e-17
C93	B1#1	B2#3	4.82005e-17
C94	a_116_392#	a_27_82##4	1.34867e-18
C95	a_639_368##2	A2#1	1.98216e-19
C96	VGND#3	a_27_82##8	2.22066e-18
C97	a_116_392##2	B2#1	4.76193e-17
C98	VGND#4	a_27_82##2	2.67732e-18
C99	a_639_368#	B1#3	4.66665e-19
C100	a_639_368##2	B2#1	4.24173e-19
C101	A1#1	B1#1	1.6485e-17
C102	a_116_392##2	B1#3	6.07745e-17
C103	X#2	a_27_82##3	1.65374e-17
C104	a_639_368#	A1#3	1.89949e-19
C105	a_639_368##2	B1#3	2.67266e-17
C106	a_116_392##2	A1#3	2.84442e-17
C107	VPWR#3	B1#3	5.11449e-19
C108	a_27_82##5	A1#1	4.14615e-18
C109	A1#3	a_639_368##2	3.30062e-17
C110	a_27_82##8	B2#2	2.05233e-19
C111	a_116_392##2	a_27_82#	3.06691e-17
C112	A1#3	VPWR#3	3.14907e-17
C113	a_639_368##2	a_27_82#	1.286e-18
C114	a_27_82##8	B1#2	1.67287e-19
C115	a_116_392##2	a_27_82##6	4.79179e-19
C116	a_27_82##4	a_27_82##5	3.94193e-17
C117	a_557_74#	A2#2	3.67039e-18
C118	a_27_82#	VPWR#3	3.05208e-17
C119	VPWR#5	A1#3	7.69714e-19
C120	a_27_82#	X#1	2.38609e-17
C121	VGND#3	a_557_74##2	3.39163e-17
C122	VPWR#3	a_27_82##6	3.75906e-18
C123	a_27_82##8	A1#2	2.4314e-18
C124	a_557_74#	B2#2	3.18175e-17
C125	VPWR#5	a_27_82#	3.64163e-18
C126	C2#3	a_27_82##4	1.02049e-17
C127	a_27_82##6	X#1	2.38609e-17
C128	VGND#7	B2#2	8.96446e-19
C129	VPWR#3	C2#1	3.24262e-19
C130	a_27_82##6	VPWR#5	4.29969e-17
C131	a_27_82##8	a_27_82##2	2.95839e-17
C132	a_116_392#	a_27_82#	2.24557e-19
C133	VPWR#2	VPWR#1	5.10645e-17
C134	a_27_82##12	a_27_82##6	1.48406e-18
C135	C1#4	C2#3	4.71658e-17
C136	VPWR#5	C2#1	6.55536e-18
C137	a_639_368#	VPWR#2	7.39799e-18
C138	a_116_392#	a_27_82##6	2.8214e-17
C139	a_27_82##9	C2#2	5.59488e-17
C140	a_27_82##12	C2#1	5.10014e-17
C141	A1	a_27_82##3	1.57816e-19
C142	a_27_82##7	B1#2	8.62742e-18
C143	a_116_392##2	VPWR#2	4.00705e-18
C144	a_27_82##14	a_27_82##6	3.69647e-19
C145	VPWR#5	C1#1	7.5745e-19
C146	a_557_74##2	B1#2	7.62862e-19
C147	a_116_392#	C2#1	5.48313e-17
C148	a_639_368##2	VPWR#2	5.57691e-17
C149	a_27_82##12	C1#1	7.82448e-19
C150	a_27_82##9	C1#3	4.36147e-19
C151	a_27_82##14	C2#1	9.87699e-19
C152	A2#2	VPWR#1	3.46568e-18
C153	a_27_82##7	A1#2	8.3865e-18
C154	a_116_392#	C1#1	4.06871e-17
C155	C2#4	C2#2	5.32792e-18
C156	a_557_74##2	A1#2	8.14388e-19
C157	a_27_82##14	C1#1	4.36617e-17
C158	VPWR#1	B2#2	2.19546e-20
C159	X#2	A1#2	1.92046e-20
C160	B2#2	a_639_368#	3.07725e-17
C161	C1#3	C2#4	3.24444e-17
C162	VGND#4	a_557_74##2	7.6933e-18
C163	a_116_392#	VPWR#2	1.89621e-18
C164	a_27_82##2	VGND#8	8.50476e-19
C165	B2#1	A2#1	2.86016e-17
C166	a_116_392##2	B1#2	2.33373e-18
C167	B1#2	a_639_368##2	1.2859e-18
C168	VGND#4	VGND#8	6.13477e-18
C169	X#2	C2#2	5.48989e-19
C170	B1#3	B2#1	4.21917e-17
C171	a_116_392##2	A1#2	3.76413e-19
C172	C2#2	VGND#9	2.77138e-18
C173	A1#2	VPWR#3	6.60412e-19
C174	A1#3	B1#3	2.02387e-17
C175	a_557_74#	A2#5	2.91032e-17
C176	VGND#3	A1#1	5.35671e-18
C177	a_27_82##9	a_27_82##8	2.15166e-18
C178	a_27_82##10	C1#3	3.18126e-17
C179	a_27_82#	A1#3	2.42745e-17
C180	VGND#9	VGND#4	3.36392e-18
C181	VGND#3	C2#3	3.61871e-20
C182	a_557_74#	a_775_74#	7.8568e-18
C183	a_116_392#	a_27_82##2	4.64673e-19
C184	a_27_82##6	a_27_82#	5.2237e-17
C185	C2#2	a_27_82##12	4.44656e-17
C186	X	a_27_82##3	2.88824e-18
C187	a_116_392#	C2#2	3.11671e-19
C188	a_557_74##2	a_775_74#	5.26544e-18
C189	C2#1	a_27_82##6	5.00324e-18
C190	a_27_82##12	C1#3	9.13446e-20
C191	VPWR#2	B1#3	3.18719e-18
C192	a_27_82##5	A1#2	1.42273e-19
C193	VPWR#2	A1#3	6.57053e-18
C194	a_27_82##14	C1#3	4.91744e-18
C195	C1#1	C2#1	5.16273e-17
C196	B2#2	A2#1	9.43699e-19
C197	VPWR#2	a_27_82#	8.38216e-18
C198	B2#2	B2#1	3.42699e-18
C199	a_27_82##9	C2#4	3.01599e-18
C200	C2#2	a_27_82##4	9.50933e-18
C201	C1#4	C2#2	1.18396e-18
C202	a_27_82##10	a_114_82#	2.72445e-18
C203	a_557_74#	A2	1.79551e-17
C204	a_27_82#	A1#2	1.02726e-18
C205	a_557_74#	B2	2.71654e-17
C206	B2#3	a_775_74#	2.27199e-18
C207	B1#1	a_775_74#	7.25044e-18
C208	VGND	a_27_82##3	7.4945e-19
C209	A2	VPWR#1	2.12823e-17
C210	C2#2	a_27_82##6	1.02069e-18
C211	VPWR#2	B1#2	3.55816e-20
C212	C2#2	C2#1	2.27281e-18
C213	B2#2	A2#2	3.60008e-17
C214	a_27_82##8	A1	1.59074e-17
C215	VGND#3	B1#2	4.64729e-20
C216	a_27_82##7	B1	4.01442e-17
C217	VGND#3	A1#2	8.72694e-20
C218	a_557_74##2	B1	2.18458e-18
C219	C1#3	C2#1	4.66919e-19
C220	VPWR#2	a_27_82##2	8.70912e-20
C221	B2	a_639_368#	1.56629e-19
C222	B1#2	B2#2	2.98035e-17
C223	B2	a_116_392##2	2.6716e-17
C224	VGND#3	a_27_82##2	2.39729e-19
C225	a_27_82##7	A1	2.77374e-17
C226	C2#3	a_114_82#	1.40983e-17
C227	A1#2	B1#2	3.04553e-17
C228	C1#4	a_114_82#	1.47173e-17
C229	C1	C2#4	2.22588e-17
C230	B1	a_116_392##2	9.76942e-18
C231	a_27_82##2	A1#2	1.94739e-17
C232	a_27_82##3	VNB	2.10119e-17
C233	A1	VPWR#1	7.65299e-21
C234	A1	a_116_392##2	3.41744e-17
C235	A1	a_639_368##2	4.10175e-19
C236	a_27_82##8	a_27_82##7	2.15386e-18
C237	a_27_82##8	X	2.17849e-17
C238	C1#3	C2#2	3.43569e-17
C239	VPWR	A2#5	3.04018e-18
C240	B2	B2#1	7.77564e-19
C241	B2	B1#3	1.01627e-18
C242	A2#5	VPWR#1	1.81692e-17
C243	C1	a_27_82##14	3.25692e-17
C244	a_27_82##8	a_557_74##2	3.11849e-17
C245	VPWR	a_27_82##8	3.17958e-18
C246	B1	B2#1	1.65579e-19
C247	VGND	VGND#4	3.52976e-17
C248	B1	B1#3	2.83117e-18
C249	VPWR	C2#4	1.88873e-18
C250	B1	A1#3	5.77241e-19
C251	A1	A2#1	4.77562e-19
C252	X	a_116_392##2	1.39189e-17
C253	A1	B2#1	6.84146e-19
C254	VGND	A2#5	1.86958e-18
C255	A1	B1#3	4.30814e-18
C256	A2	A2#2	1.09248e-17
C257	X	X#1	4.43336e-19
C258	A1	A1#3	1.53138e-17
C259	X	VPWR#5	1.84543e-18
C260	A1	a_27_82#	5.17071e-18
C261	a_27_82##12	X	6.09928e-17
C262	a_27_82##8	VGND#8	6.4389e-18
C263	VGND	a_27_82##9	1.89898e-17
C264	VGND	a_27_82##8	1.46672e-17
C265	X	a_116_392#	6.54812e-17
C266	A1	a_27_82##6	8.87715e-20
C267	a_27_82##9	X#2	7.89681e-17
C268	VPWR	VPWR#1	5.17026e-17
C269	VPWR	a_639_368#	2.43182e-17
C270	B2	B2#2	5.61256e-18
C271	VGND	C2#4	2.04121e-18
C272	VPWR	a_116_392##2	2.23928e-17
C273	VPWR	a_639_368##2	2.27564e-17
C274	VGND#4	VNB	3.04583e-17
C275	VGND	a_557_74#	1.93262e-17
C276	B2	B1#2	7.70949e-18
C277	VPWR	VPWR#3	1.8357e-17
C278	VGND	a_27_82##7	1.022e-17
C279	VPWR	VPWR#5	1.83193e-17
C280	B1	B2#2	2.49767e-18
C281	VGND	a_557_74##2	4.10675e-17
C282	C1	C2#1	2.03115e-19
C283	VPWR	a_27_82##12	6.56433e-18
C284	A2#5	VNB	1.16553e-18
C285	VGND	X#2	5.48045e-18
C286	VPWR	a_116_392#	3.3879e-17
C287	B1	B1#2	1.97575e-17
C288	VPWR	a_27_82##14	1.58776e-17
C289	B1	A1#2	4.33033e-18
C290	VGND	a_27_82##10	1.75661e-17
C291	a_27_82##8	X#2	5.81127e-17
C292	a_27_82##9	VNB	8.84508e-18
C293	a_27_82##8	VNB	1.66876e-17
C294	A1	B1#2	3.74002e-18
C295	X	B1#3	3.38582e-19
C296	a_27_82##9	VGND#9	5.53678e-17
C297	A1	A1#2	1.75353e-17
C298	C2#4	VNB	2.81277e-18
C299	X	A1#3	2.74035e-18
C300	VPWR#5	a_27_82##3	1.5516e-19
C301	a_557_74#	VNB	5.07583e-17
C302	X	a_27_82#	1.41198e-17
C303	A1	a_27_82##2	4.76192e-18
C304	VGND#7	VNB	1.46323e-18
C305	X	a_27_82##6	2.45941e-17
C306	a_557_74#	VGND#7	8.20634e-17
C307	a_27_82##7	VNB	7.29214e-18
C308	a_557_74##2	VNB	1.23166e-17
C309	X	C2#1	8.23909e-19
C310	VPWR	A2#1	2.71316e-18
C311	VGND	A2#3	5.30324e-19
C312	X#2	VNB	2.58309e-18
C313	VGND	B2#3	6.37421e-19
C314	VGND#9	VNB	3.6466e-19
C315	VGND	B1#1	9.1873e-19
C316	VGND	A1#1	1.48867e-18
C317	a_27_82##10	VNB	3.95588e-17
C318	VPWR	A1#3	7.25174e-18
C319	VPWR#1	VNB	9.74545e-17
C320	VGND	a_27_82##5	7.91536e-18
C321	C1	C2#2	7.01938e-19
C322	a_639_368#	VNB	1.00506e-17
C323	VPWR	a_27_82#	8.01617e-19
C324	VGND	a_27_82##4	1.21377e-17
C325	VGND	C2#3	4.24013e-18
C326	VPWR	a_27_82##6	7.95618e-19
C327	C1	C1#3	1.3554e-17
C328	a_639_368##2	VNB	8.50001e-18
C329	VPWR#3	VNB	4.07537e-18
C330	VGND	C1#4	1.0375e-17
C331	VPWR	C2#1	7.27518e-19
C332	VPWR#5	VNB	6.49353e-18
C333	VPWR	C1#1	3.13464e-18
C334	a_27_82##12	VNB	1.55292e-17
C335	a_116_392#	VNB	7.86138e-18
C336	a_27_82##14	VNB	5.05865e-17
C337	VPWR	VPWR#2	3.9604e-17
C338	A2#3	VNB	3.36305e-17
C339	X	A1#2	5.66324e-19
C340	B2#3	VNB	2.33811e-17
C341	B1#1	VNB	3.10733e-17
C342	X	a_27_82##2	2.19072e-18
C343	A1#1	VNB	3.31829e-17
C344	a_27_82##5	VNB	3.70638e-17
C345	X	C2#2	3.11044e-19
C346	VPWR	B2#2	1.86302e-18
C347	a_27_82##4	VNB	4.36373e-17
C348	C2#3	VNB	2.44308e-17
C349	C1#4	VNB	3.69836e-17
C350	A2#1	VNB	3.41982e-17
C351	B1	B2	3.72017e-17
C352	B2#1	VNB	3.11861e-17
C353	VGND	VGND#3	2.28253e-17
C354	B1#3	VNB	3.12432e-17
C355	VPWR	C2#2	1.92555e-18
C356	A1#3	VNB	3.59085e-17
C357	VGND	B2#2	1.97114e-18
C358	a_27_82#	VNB	3.79939e-17
C359	a_27_82##6	VNB	4.08785e-17
C360	C2#1	VNB	4.57163e-17
C361	C1#1	VNB	4.7383e-17
C362	A1	B1	3.20981e-17
C363	VGND	a_27_82##2	4.06844e-19
C364	VPWR#2	VNB	2.76104e-16
C365	VGND	C2#2	2.17942e-18
C366	VGND#3	VNB	2.49918e-16
C367	VGND	C1#3	4.83041e-18
C368	A2#2	VNB	5.06125e-17
C369	B2#2	VNB	4.10926e-17
C370	B1#2	VNB	4.29539e-17
C371	A1#2	VNB	3.7461e-17
C372	a_27_82##2	VNB	3.47563e-17
C373	C2#2	VNB	3.73936e-17
C374	a_27_82##10	a_27_82##9	1.58447e-18
C375	C1#3	VNB	8.04113e-17
C376	VPWR	A2	1.61555e-18
C377	a_27_82##7	a_557_74#	4.14418e-17
C378	VPWR	B2	1.67918e-18
C379	X	A1	1.71899e-17
C380	VPWR	B1	3.98718e-18
C381	VGND	A2	2.73099e-18
C382	VPWR	A1	2.64841e-18
C383	VGND	B2	1.64214e-18
C384	VGND	B1	3.28389e-18
C385	VPWR	C1	3.75451e-18
C386	A2	VNB	2.48958e-17
C387	VGND	A1	3.51314e-18
C388	a_27_82##12	a_27_82##3	1.50654e-19
C389	B2	VNB	1.82083e-19
C390	B1	VNB	6.47031e-18
C391	VPWR	X	6.67283e-18
C392	A1	VNB	3.08779e-18
C393	C1	VNB	1.26838e-17
C394	VGND	X	1.92463e-18
C395	X	VNB	5.86978e-18
C396	VPWR	VNB	7.30377e-17
C397	VGND	VNB	7.68864e-17
C398	VGND#5	a_27_82##5	3.60511e-19
C399	VGND#2	VNB	6.58782e-17
C400	VGND#5	a_27_82##10	1.86759e-17
C401	VGND#5	C1#3	8.14894e-19
C402	VPWR#4	C1#1	5.37245e-18
C403	VGND#2	A1#1	4.65091e-19
C404	VGND#2	A2#2	8.79584e-20
C405	C1	VPWR#4	4.9518e-19
C406	VGND#2	A2#3	8.29995e-18
C407	VGND#2	a_557_74#	2.02506e-17
C408	VGND#5	VNB	6.52271e-17
C409	VGND#2	A2	6.63763e-19
C410	VGND#5	C2#3	6.86063e-18
C411	VPWR	VPWR#4	5.90709e-17
C412	VPWR#4	C2#1	5.58109e-18
C413	VGND	VGND#2	6.59531e-17
C414	VPWR#4	C1#3	4.0583e-19
C415	VGND#2	B1#2	8.68249e-20
C416	VGND#5	A1#1	1.78426e-19
C417	VGND#2	B1#1	6.15545e-18
C418	VGND#3	VGND#2	7.57557e-17
C419	VPWR#2	VPWR#4	9.35317e-17
C420	VGND#5	a_27_82##9	8.38556e-18
C421	VGND	VGND#5	6.31214e-17
C422	VGND#5	a_27_82##4	5.60404e-18
C423	VPWR#4	a_27_82##6	8.38236e-18
C424	VPWR#4	C2#2	8.05046e-20
C425	VGND#5	VGND#4	7.95723e-19
C426	a_27_82##14	VPWR#4	2.15014e-17
C427	VGND#2	a_557_74##2	2.76308e-17
C428	VPWR#4	VNB	7.90595e-17
C429	VGND#5	C1#4	6.38713e-18
C430	VGND#2	B2#3	4.42265e-18
C431	VPWR#4	a_27_82##2	3.22018e-20
C432	VGND#3	VGND#5	7.20629e-17
C433	a_116_392#	VPWR#4	2.86055e-17
*
*
.ENDS sky130_fd_sc_hs__a222o_2
*
