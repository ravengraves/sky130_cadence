* Extracted by Quantus, converted by sky130cad/quantus.py
*
*
*
*                       LINUX           Wed Nov 18 08:32:14 2026
*
*
*
*  PROGRAM  advgen
*
*  Name           : advgen - Quantus - (64-bit)
*  Version        : 25.1.0-p047
*  Build Date     : Thu Dec 11 23:20:30 PST 2025
*
*  HSPICE LIBRARY
*
*  OPERATING_TEMPERATURE 150
*  QRC_TECH_DIR <path>/tech
*
*
*

*
.SUBCKT sky130_fd_sc_hs__dlrtp_1 VPB VNB VGND VPWR Q D RESET_B GATE
*
*
*  caps2d version: 10
*
*
*       TRANSISTOR CARDS
*
*
XM11 a_27_424##7 D#1 VGND#11 VNB sky130_fd_pr__nfet_01v8_lvt l=0.15 w=0.55 ad=0.15675 as=0.2934 pd=1.67 ps=2.35
XM7 VGND#11 GATE#1 a_216_424##10 VNB sky130_fd_pr__nfet_01v8_lvt l=0.15 w=0.74 ad=0.2934 as=0.2109 pd=2.35 ps=2.05
XM19 a_363_74##7 a_216_424# VGND#10 VNB sky130_fd_pr__nfet_01v8_lvt l=0.15 w=0.74 ad=0.32225 as=0.2554 pd=2.64 ps=2.2
XM8 VGND#10 a_27_424##3 a_565_74# VNB sky130_fd_pr__nfet_01v8_lvt l=0.15 w=0.64 ad=0.2554 as=0.1536 pd=2.2 ps=1.76
XM5 a_565_74# a_363_74##2 a_643_74##8 VNB sky130_fd_pr__nfet_01v8_lvt l=0.15 w=0.64 ad=0.1536 as=0.2907 pd=1.76 ps=2.24
XM9 a_643_74##8 a_216_424##8 a_769_74# VNB sky130_fd_pr__nfet_01v8_lvt l=0.15 w=0.42 ad=0.2907 as=0.1008 pd=2.24 ps=1.32
XM6 a_769_74# a_817_48# VGND#9 VNB sky130_fd_pr__nfet_01v8_lvt l=0.15 w=0.42 ad=0.1008 as=0.1197 pd=1.32 ps=1.41
XM12 a_817_48##11 a_643_74# a_1045_74# VNB sky130_fd_pr__nfet_01v8_lvt l=0.15 w=0.74 ad=0.2109 as=0.1776 pd=2.05 ps=1.96
XM2 a_1045_74# RESET_B#3 VGND#8 VNB sky130_fd_pr__nfet_01v8_lvt l=0.15 w=0.74 ad=0.1776 as=0.2664 pd=1.96 ps=2.2
XM15 VGND#8 a_817_48##6 Q#2 VNB sky130_fd_pr__nfet_01v8_lvt l=0.15 w=0.74 ad=0.2664 as=0.2109 pd=2.2 ps=2.05
XM16 a_27_424##6 D#4 VPWR#11 VPB sky130_fd_pr__pfet_01v8 l=0.15 w=0.84 ad=0.2478 as=0.294 pd=2.27 ps=2.38
XM0 VPWR#11 GATE#3 a_216_424##13 VPB sky130_fd_pr__pfet_01v8 l=0.15 w=0.84 ad=0.294 as=0.43935 pd=2.38 ps=2.87
XM18 a_363_74##9 a_216_424##4 VPWR#10 VPB sky130_fd_pr__pfet_01v8 l=0.15 w=0.84 ad=0.2478 as=0.4156 pd=2.27 ps=2.86
XM13 VPWR#10 a_27_424# a_568_392# VPB sky130_fd_pr__pfet_01v8 l=0.15 w=1 ad=0.4156 as=0.27 pd=2.86 ps=2.54
XM4 a_568_392# a_216_424##7 a_643_74##7 VPB sky130_fd_pr__pfet_01v8 l=0.15 w=1 ad=0.27 as=0.3328 pd=2.54 ps=2.77
XM17 a_643_74##7 a_363_74##3 a_759_508# VPB sky130_fd_pr__pfet_01v8 l=0.15 w=0.42 ad=0.3328 as=0.2121 pd=2.77 ps=1.85
XM10 a_759_508# a_817_48##3 VPWR#9 VPB sky130_fd_pr__pfet_01v8 l=0.15 w=0.42 ad=0.2121 as=0.4099 pd=1.85 ps=3.22
XM1 VPWR#9 a_643_74##4 a_817_48##12 VPB sky130_fd_pr__pfet_01v8 l=0.15 w=1 ad=0.4099 as=0.35 pd=3.22 ps=2.7
XM3 a_817_48##12 RESET_B#1 VPWR#8 VPB sky130_fd_pr__pfet_01v8 l=0.15 w=1 ad=0.35 as=0.4618 pd=2.7 ps=3.1
XM14 VPWR#8 a_817_48##4 Q#1 VPB sky130_fd_pr__pfet_01v8 l=0.15 w=1.12 ad=0.4618 as=0.3304 pd=3.1 ps=2.83
*
*
*       RESISTOR AND CAP/DIODE CARDS
*
Rg1	D#1	D#2	347.763641
Rg2	D#2	D#3	42.689579
Rg3	D#2	D#4	495.286072
Rg4	GATE#1	GATE#2	466.779327
Rg5	GATE#2	GATE#3	450.433960
Rg6	a_216_424#	a_216_424##2	428.006500
Rg7	a_216_424##2	a_216_424##3	355.680969
Rg8	a_216_424##2	a_216_424##4	433.586975
Rg9	a_27_424#	a_27_424##2	400.207520
Rg10	a_27_424##2	a_27_424##3	480.096283
Rg11	a_363_74#	a_363_74##2	439.477417
Rg12	a_363_74##3	a_363_74##4	226.096359
Rg13	a_216_424##5	a_216_424##6	16.832588
Rg14	a_216_424##6	a_216_424##7	784.955566
Rg15	a_216_424##6	a_216_424##8	423.900208
Rg16	a_817_48#	a_817_48##2	908.202820
Rg17	a_817_48##2	a_817_48##3	239.487213
Rg18	a_643_74#	a_643_74##2	466.419159
Rg19	a_643_74##2	a_643_74##3	42.409290
Rg20	a_643_74##2	a_643_74##4	415.223511
Rg21	RESET_B#1	RESET_B#2	464.586731
Rg22	RESET_B#2	RESET_B#3	450.832520
Rg23	a_817_48##4	a_817_48##5	492.059540
Rg24	a_817_48##5	a_817_48##6	307.937683
Rf1	D	D#3	169.752274
Rf2	GATE#2	GATE#5	161.150848
Rf3	GATE#6	GATE	0.918041
Rf4	GATE#5	GATE#6	4.133563
Rf5	a_27_424##2	a_27_424##5	357.979187
Rf6	a_27_424##5	a_27_424##6	15.914418
Rf7	a_27_424##5	a_27_424##7	105.265251
Rf8	a_363_74##4	a_363_74#	361.958984
Rf9	a_363_74#	a_363_74##8	91.361298
Rf10	a_363_74##8	a_363_74##9	75.638542
Rf11	a_363_74##7	a_363_74##8	15.000000
Rf12	a_216_424##5	a_216_424##11	437.816772
Rf13	a_216_424##11	a_216_424##3	44.471710
Rf14	a_216_424##3	a_216_424##13	47.877819
Rf15	a_216_424##10	a_216_424##11	7.500000
Rf16	a_643_74##3	a_643_74##6	247.731506
Rf17	a_643_74##6	a_643_74##7	69.024353
Rf18	a_643_74##6	a_643_74##8	83.097511
Rf19	RESET_B#4	RESET_B#2	161.455215
Rf20	RESET_B	RESET_B#6	1.222411
Rf21	RESET_B#4	RESET_B#6	5.905091
Rf22	a_817_48##5	a_817_48##8	232.836960
Rf23	a_817_48##8	a_817_48##9	74.522888
Rf24	a_817_48##9	a_817_48##2	188.521011
Rf25	a_817_48##8	a_817_48##11	21.444885
Rf26	a_817_48##9	a_817_48##12	14.279337
Rf27	Q#1	Q	123.977058
Rf28	Q	Q#2	20.806911
Rf30	VPWR#2	VPWR#3	84.348778
Rf31	VPWR#3	VPWR#4	101.905434
Rf32	VPWR#4	VPWR#5	61.498089
Rf33	VPWR#5	VPWR#6	126.853745
Rf35	VPWR#2	VPWR#8	35.727165
Rf36	VPWR#3	VPWR#9	23.951298
Rf37	VPWR#5	VPWR#10	30.002884
Rf38	VPWR#6	VPWR#11	31.948624
Rf40	VGND#2	VGND#3	100.760612
Rf41	VGND#3	VGND#4	74.121719
Rf42	VGND#4	VGND#5	63.685772
Rf43	VGND#5	VGND#6	110.901382
Rf45	VGND#2	VGND#8	38.247387
Rf46	VGND#3	VGND#9	34.507496
Rf47	VGND#5	VGND#10	29.629658
Rf48	VGND#6	VGND#11	56.430489
Re1	VPWR#4	VPWR	0.701577
Re2	VGND	VGND#4	0.701602
*
*       CAPACITOR CARDS
*
*
C1	VPWR#3	a_216_424##7	1.39891e-19
C2	a_817_48##11	a_643_74#	4.29643e-17
C3	a_216_424##10	a_216_424##13	2.37046e-18
C4	VPWR#5	a_27_424#	7.09481e-18
C5	VGND#9	a_643_74#	1.81936e-18
C6	GATE#2	a_216_424##2	6.73032e-19
C7	a_817_48##11	a_817_48#	4.20801e-18
C8	a_817_48##9	a_363_74##3	3.00595e-19
C9	VPWR#3	a_27_424#	5.61043e-20
C10	VGND#5	a_216_424##2	1.16065e-19
C11	VGND#9	a_817_48#	4.36872e-17
C12	a_643_74##6	a_643_74##4	5.08561e-20
C13	a_817_48##11	a_216_424##8	2.68173e-19
C14	VPWR#5	a_216_424##4	5.96202e-18
C15	VGND#3	a_216_424##6	4.48752e-19
C16	a_817_48##9	a_216_424##7	8.57818e-20
C17	VGND#9	a_216_424##8	2.65872e-18
C18	VGND#11	a_27_424##6	2.21477e-18
C19	VPWR#5	GATE#3	2.26461e-19
C20	a_27_424##7	a_27_424##6	2.0575e-18
C21	VGND#9	a_363_74##2	1.32544e-20
C22	a_216_424##8	a_643_74##8	1.49902e-17
C23	VGND#5	a_216_424##10	2.08426e-17
C24	VGND#9	a_27_424##3	6.11647e-21
C25	a_817_48##8	VGND#8	5.88801e-18
C26	a_643_74##8	a_363_74##2	3.08807e-17
C27	a_643_74##6	a_216_424##7	1.02393e-17
C28	a_643_74##8	a_27_424##3	1.48108e-18
C29	VGND#10	a_363_74##2	7.27374e-19
C30	VGND#4	VGND#5	5.30235e-17
C31	a_216_424##10	a_216_424##8	4.46328e-19
C32	VGND#4	VGND#3	4.99025e-17
C33	a_643_74##8	a_216_424#	3.32909e-19
C34	VGND#10	a_27_424##3	2.51816e-17
C35	a_817_48##8	a_817_48##11	1.34797e-18
C36	a_216_424##10	a_363_74##2	1.45401e-17
C37	VPWR#4	VPWR#5	5.47122e-17
C38	VPWR#4	VPWR#3	5.9829e-17
C39	VGND#10	a_216_424#	2.53166e-17
C40	a_216_424##10	a_27_424##3	2.10098e-17
C41	a_216_424##13	a_363_74##9	2.51935e-17
C42	VPWR#11	VPWR#10	4.15513e-18
C43	a_363_74##7	a_216_424#	1.77278e-17
C44	VGND#10	GATE#1	1.40749e-18
C45	a_216_424##10	a_216_424#	1.80401e-17
C46	a_27_424##6	VPWR#10	2.70313e-20
C47	a_363_74##7	GATE#1	3.00014e-19
C48	VGND#11	a_216_424#	5.07319e-19
C49	a_27_424##6	a_363_74##9	1.96864e-17
C50	a_216_424##10	GATE#1	5.85515e-17
C51	a_27_424##7	a_216_424#	1.09817e-19
C52	a_27_424##6	a_216_424##13	7.0476e-17
C53	GATE#1	VGND#11	1.65835e-17
C54	a_216_424##10	D#1	9.6522e-19
C55	VGND#3	a_643_74##3	1.12956e-18
C56	a_27_424##7	GATE#1	3.00023e-18
C57	a_27_424##6	VPWR#11	6.80051e-17
C58	D#1	VGND#11	2.50572e-17
C59	a_216_424##6	a_643_74##7	2.89674e-19
C60	a_27_424##7	D#1	3.48571e-17
C61	a_817_48##8	a_817_48##5	2.66874e-18
C62	a_643_74##3	VPWR#3	2.36016e-18
C63	a_817_48##9	RESET_B#2	3.23418e-18
C64	VGND#3	a_216_424##5	1.52347e-17
C65	a_817_48##8	RESET_B#2	3.6507e-18
C66	RESET_B#3	a_817_48##6	2.35762e-17
C67	Q#1	a_817_48##4	5.23967e-17
C68	a_817_48##5	RESET_B#4	2.97041e-17
C69	a_817_48##2	VPWR#3	3.35837e-17
C70	a_817_48##4	VPWR#8	3.31348e-17
C71	a_817_48##9	a_643_74##3	4.1727e-17
C72	VPWR#5	a_216_424##2	4.80899e-20
C73	a_643_74##8	a_216_424##7	5.07732e-19
C74	Q#1	RESET_B#1	1.98203e-18
C75	a_817_48##8	a_643_74##3	4.20906e-17
C76	a_643_74#	RESET_B#3	5.2558e-17
C77	a_643_74##8	a_643_74##6	2.12667e-18
C78	RESET_B#4	RESET_B#2	9.58922e-18
C79	RESET_B#1	VPWR#8	3.5877e-17
C80	VPWR#3	VPWR#8	1.7483e-18
C81	VPWR#3	a_216_424##6	3.16705e-19
C82	Q#1	a_643_74##4	6.65007e-21
C83	a_817_48##9	a_817_48##2	4.01636e-19
C84	RESET_B#1	a_817_48##12	2.32311e-17
C85	VPWR#8	a_643_74##4	1.17163e-18
C86	VPWR#5	a_363_74##4	9.93718e-18
C87	a_817_48#	a_643_74#	9.22625e-18
C88	RESET_B#4	a_643_74##3	2.23296e-18
C89	a_363_74##4	VPWR#3	3.14894e-17
C90	a_643_74##4	a_817_48##12	9.75051e-18
C91	a_643_74##6	a_643_74##3	1.75642e-18
C92	a_643_74##4	VPWR#9	2.03307e-17
C93	a_216_424##5	a_817_48##8	1.33846e-17
C94	a_216_424##8	a_817_48#	3.90064e-17
C95	a_643_74##6	a_817_48##2	5.50459e-19
C96	a_817_48##3	VPWR#9	1.27753e-17
C97	VPWR#3	VPWR#9	6.15389e-18
C98	a_817_48##9	Q#1	2.44309e-18
C99	a_363_74##4	a_817_48##9	2.72367e-18
C100	VGND#5	a_216_424##3	2.59668e-19
C101	a_363_74##2	a_216_424##8	1.25578e-17
C102	a_27_424##2	VPWR#5	4.63677e-18
C103	a_363_74##9	a_216_424##2	3.33388e-18
C104	a_216_424##5	a_643_74##6	4.55267e-17
C105	a_817_48##9	VPWR#8	9.14141e-17
C106	a_817_48##5	Q#2	8.61959e-17
C107	a_363_74##3	a_643_74##7	1.05608e-17
C108	a_27_424##3	a_363_74##2	4.16756e-17
C109	a_817_48##5	VGND#8	3.14242e-17
C110	a_643_74##6	a_363_74##4	5.84135e-17
C111	VPWR#5	a_216_424##3	1.66386e-19
C112	a_643_74##7	a_216_424##7	3.3325e-17
C113	a_817_48##9	a_817_48##12	4.14051e-18
C114	VGND#8	RESET_B#2	7.23266e-19
C115	a_643_74##7	a_27_424#	1.19454e-18
C116	a_216_424#	a_27_424##3	2.86249e-17
C117	a_363_74#	a_643_74##6	6.77942e-17
C118	VPWR#10	a_216_424##7	8.72306e-19
C119	a_817_48##9	VPWR#3	5.61527e-17
C120	a_817_48##9	VPWR#9	9.54913e-19
C121	VPWR#10	a_27_424#	3.87377e-17
C122	RESET_B#4	Q#1	8.75301e-19
C123	a_643_74##6	a_27_424##2	1.9096e-19
C124	GATE#1	a_216_424#	4.55024e-18
C125	a_363_74##9	a_27_424#	1.71267e-18
C126	VGND#4	a_216_424##10	6.76415e-18
C127	VGND#3	a_643_74##6	1.91721e-19
C128	VGND#8	Q#2	4.23286e-17
C129	a_216_424##4	VPWR#10	1.83217e-17
C130	VGND#9	a_643_74##3	9.0877e-18
C131	a_363_74##9	a_216_424##4	4.16741e-17
C132	VPWR#11	a_27_424#	7.71441e-19
C133	D#1	GATE#1	1.88116e-17
C134	VPWR#10	GATE#3	1.51629e-18
C135	a_216_424##13	a_216_424##4	1.30693e-18
C136	VGND#9	a_817_48##2	1.1938e-18
C137	a_27_424##6	a_27_424#	3.28034e-19
C138	a_363_74##9	GATE#3	4.67105e-19
C139	VPWR#11	a_216_424##4	1.23756e-18
C140	GATE#3	a_216_424##13	3.62527e-17
C141	a_216_424##5	a_817_48##11	3.31927e-18
C142	a_817_48##5	Q#1	1.15771e-17
C143	a_27_424##6	a_216_424##4	1.42296e-18
C144	a_817_48##11	Q#2	5.52623e-19
C145	a_216_424##5	VGND#9	4.59012e-17
C146	VPWR#11	GATE#3	3.08037e-17
C147	a_817_48##5	VPWR#8	1.51249e-17
C148	a_216_424##13	D#4	2.33025e-18
C149	a_27_424##6	GATE#3	3.77921e-17
C150	Q#1	RESET_B#2	1.32534e-18
C151	a_216_424##5	a_643_74##8	1.06649e-16
C152	D#4	VPWR#11	2.594e-17
C153	a_817_48##11	VGND#8	1.80326e-17
C154	a_27_424##6	D#4	5.40574e-17
C155	VPWR#11	VPWR#5	1.53732e-20
C156	Q#1	a_643_74##3	1.92852e-19
C157	VPWR#4	a_216_424##6	2.18955e-20
C158	VGND#9	VGND#8	8.874e-19
C159	VGND#3	RESET_B#3	1.46026e-19
C160	RESET_B#1	a_817_48##4	2.92744e-17
C161	a_216_424##10	a_216_424##5	1.86288e-18
C162	a_643_74##3	VPWR#9	4.7553e-19
C163	a_363_74#	a_643_74##8	4.18259e-17
C164	a_27_424##6	VPWR#5	3.95685e-18
C165	a_643_74##4	RESET_B#1	3.30476e-17
C166	GATE#5	GATE#2	1.33927e-17
C167	a_817_48##2	VPWR#9	2.99866e-18
C168	VGND#3	a_643_74#	8.15409e-19
C169	a_363_74##7	a_363_74#	2.6223e-18
C170	VGND#4	a_216_424##6	1.10097e-19
C171	VGND#9	a_817_48##11	4.04819e-17
C172	a_216_424##10	a_363_74#	3.39218e-17
C173	a_643_74##6	a_643_74##7	3.11814e-18
C174	VGND#10	a_27_424##2	4.98285e-19
C175	VGND#5	a_817_48#	6.66636e-20
C176	GATE#5	D#3	2.68698e-18
C177	a_817_48##3	a_643_74##4	8.73948e-18
C178	a_817_48##8	a_216_424##6	8.12859e-19
C179	a_817_48##5	a_817_48##6	9.50307e-18
C180	a_363_74##7	a_27_424##2	2.26875e-17
C181	a_817_48##8	a_817_48##9	5.12483e-18
C182	a_817_48##8	a_1045_74#	3.20755e-18
C183	a_216_424##10	a_27_424##2	5.35567e-19
C184	RESET_B#3	a_817_48##5	2.12753e-18
C185	VGND#3	a_817_48#	7.53296e-18
C186	a_643_74##6	VPWR#3	6.96564e-19
C187	a_817_48##5	a_643_74#	9.88134e-20
C188	a_363_74##3	a_817_48##3	9.11118e-18
C189	a_216_424##3	a_363_74##7	4.06172e-17
C190	VGND#4	a_216_424##8	3.1091e-18
C191	VGND#5	a_216_424##8	1.25169e-19
C192	a_363_74##4	a_643_74##7	8.14869e-17
C193	a_216_424##10	a_216_424##3	4.94913e-18
C194	VGND#4	a_363_74##2	4.43104e-18
C195	a_643_74#	RESET_B#2	3.12691e-18
C196	a_27_424##7	a_216_424##3	5.54326e-18
C197	VGND#3	a_216_424##8	2.11105e-18
C198	a_363_74##7	GATE#2	1.69075e-19
C199	VPWR#10	a_363_74##4	2.58056e-17
C200	a_216_424##7	a_363_74##3	1.6134e-17
C201	VGND#11	GATE#5	1.29286e-17
C202	a_363_74#	a_643_74##7	4.47405e-17
C203	a_363_74##4	a_363_74##9	1.18584e-20
C204	VGND#11	GATE#2	6.91134e-18
C205	a_817_48#	a_643_74##3	8.79729e-18
C206	VGND#5	a_363_74##2	7.97193e-19
C207	a_27_424##7	GATE#2	3.05392e-18
C208	a_27_424#	a_216_424##7	4.87876e-17
C209	a_27_424##7	GATE#5	1.25917e-17
C210	a_363_74#	a_363_74##9	2.87566e-19
C211	VGND#3	a_363_74##2	1.18738e-19
C212	a_27_424##2	VPWR#10	4.81266e-17
C213	a_216_424##5	a_643_74#	1.17851e-18
C214	a_27_424##7	D#3	6.75335e-17
C215	a_27_424##2	a_363_74##9	5.22233e-17
C216	a_216_424##4	a_27_424#	2.30917e-17
C217	a_216_424##5	a_817_48#	2.26578e-17
C218	VGND#5	a_27_424##3	4.03651e-18
C219	a_216_424##5	a_216_424##8	1.91982e-17
C220	a_27_424##2	VPWR#11	1.28949e-20
C221	GATE#3	a_27_424#	2.67095e-19
C222	a_216_424##3	a_363_74##9	2.45734e-17
C223	a_216_424##5	a_363_74##2	1.27184e-17
C224	VGND#3	a_27_424##3	1.85536e-20
C225	a_216_424##3	a_216_424##13	1.64237e-19
C226	GATE#3	a_216_424##4	5.2692e-18
C227	a_216_424##5	a_27_424##3	1.24943e-19
C228	RESET_B#2	a_817_48##4	4.00253e-18
C229	VPWR#4	a_363_74##3	4.61111e-18
C230	a_216_424##6	a_817_48#	2.38731e-17
C231	a_363_74##9	GATE#2	4.56726e-20
C232	a_27_424##6	a_216_424##3	7.08044e-18
C233	VPWR#4	a_216_424##7	4.48763e-18
C234	VGND#5	a_216_424#	6.95922e-18
C235	a_216_424##13	GATE#2	5.35357e-18
C236	Q#2	Q#1	2.23878e-18
C237	D#4	GATE#3	3.2841e-17
C238	VGND#4	a_216_424##7	3.35476e-20
C239	a_817_48##8	RESET_B#3	1.74931e-17
C240	a_643_74##3	RESET_B#1	2.1969e-18
C241	a_643_74##8	a_216_424##6	4.03059e-18
C242	a_27_424##6	GATE#2	4.97633e-18
C243	a_363_74#	a_27_424##3	1.70168e-17
C244	a_643_74##3	a_643_74##4	1.01047e-18
C245	a_643_74##3	a_216_424##6	1.01192e-18
C246	a_817_48##8	RESET_B#4	4.1096e-17
C247	a_643_74##6	a_817_48##9	5.14522e-19
C248	VPWR#11	D#3	6.02026e-19
C249	a_27_424##6	D#3	9.93559e-18
C250	a_817_48##2	a_643_74##4	1.4217e-17
C251	VGND#5	GATE#1	4.03327e-19
C252	a_216_424#	a_27_424##2	1.19267e-18
C253	a_817_48##8	a_643_74#	2.20511e-17
C254	a_363_74##4	RESET_B#1	2.32696e-19
C255	a_216_424##3	a_216_424#	9.64454e-20
C256	a_363_74##4	a_643_74##4	4.33904e-19
C257	a_216_424##7	a_817_48##2	5.40747e-19
C258	a_216_424##10	a_643_74##8	3.11399e-17
C259	a_216_424##3	GATE#1	1.69546e-18
C260	a_363_74##4	a_817_48##3	1.05219e-17
C261	a_216_424##3	D#1	5.20241e-20
C262	a_216_424##5	a_216_424##7	8.28971e-20
C263	a_817_48##8	a_817_48#	6.28464e-18
C264	a_363_74##4	a_363_74##3	2.14777e-17
C265	a_216_424##6	a_817_48##2	1.56787e-17
C266	a_363_74##4	a_216_424##7	3.02245e-17
C267	a_363_74##7	VGND#10	9.21153e-19
C268	a_363_74##4	a_27_424#	5.59806e-18
C269	D#3	GATE#1	1.81319e-18
C270	a_363_74#	a_216_424##7	5.04513e-17
C271	a_363_74##4	a_216_424##4	3.23049e-20
C272	a_363_74##2	a_216_424##6	1.19038e-18
C273	a_817_48##8	a_216_424##8	1.48105e-19
C274	a_363_74#	a_27_424#	1.12096e-17
C275	a_216_424##10	VGND#10	7.78445e-17
C276	a_27_424##2	a_216_424##7	1.67083e-17
C277	a_363_74##4	GATE#3	1.07156e-20
C278	RESET_B#2	a_817_48##5	3.56112e-17
C279	a_363_74#	a_216_424##4	7.83393e-19
C280	RESET_B#3	a_1045_74#	1.68123e-17
C281	VPWR	a_216_424##6	3.11238e-20
C282	a_27_424##2	a_27_424#	1.81203e-17
C283	a_216_424##10	a_565_74#	9.33335e-18
C284	a_643_74#	a_1045_74#	1.68123e-17
C285	a_363_74#	GATE#3	2.59854e-19
C286	a_27_424##2	a_216_424##4	3.96381e-17
C287	a_216_424##10	a_363_74##7	8.32787e-17
C288	a_643_74##3	RESET_B#2	3.42002e-17
C289	VGND#11	VGND#10	1.1326e-18
C290	a_27_424##2	GATE#3	3.47417e-19
C291	VGND#4	a_216_424##5	5.01956e-17
C292	a_363_74##4	VPWR#4	6.63949e-17
C293	a_216_424##3	a_216_424##4	3.07182e-19
C294	a_216_424##5	a_216_424##6	1.86182e-17
C295	a_27_424##2	D#4	2.14553e-19
C296	VPWR#4	a_363_74#	8.0651e-20
C297	GATE#2	a_216_424##4	6.36265e-19
C298	a_643_74##3	a_817_48##2	1.10922e-16
C299	a_643_74##6	a_216_424##6	3.12144e-17
C300	a_216_424##3	D#4	3.00923e-20
C301	a_817_48##9	RESET_B	3.53124e-17
C302	VGND#4	a_363_74#	1.49008e-19
C303	a_817_48##8	RESET_B	2.52172e-18
C304	a_643_74##6	a_817_48#	1.22175e-18
C305	a_216_424##5	a_643_74##3	7.03434e-18
C306	D#4	GATE#2	2.78686e-18
C307	a_216_424##8	a_769_74#	7.462e-18
C308	a_363_74##3	a_759_508#	1.17351e-17
C309	a_216_424##5	a_817_48##2	2.0397e-18
C310	VGND#4	a_216_424##3	7.79155e-20
C311	VGND	a_216_424##6	1.2418e-18
C312	VGND#11	a_216_424##10	6.44238e-17
C313	VGND	a_216_424##2	4.96596e-19
C314	a_363_74##4	a_817_48##2	5.70124e-17
C315	a_216_424##7	a_568_392#	1.62876e-17
C316	a_216_424##5	a_363_74##4	6.88414e-19
C317	a_363_74#	a_817_48##2	6.19114e-20
C318	a_643_74##3	a_27_424##2	1.26639e-19
C319	a_27_424#	a_568_392#	2.4683e-18
C320	a_216_424##5	a_363_74#	3.97187e-18
C321	a_216_424##6	a_363_74##4	2.49208e-17
C322	a_363_74##2	a_565_74#	8.59503e-18
C323	a_363_74#	a_363_74##4	2.5419e-18
C324	a_27_424##3	a_565_74#	4.28005e-18
C325	a_216_424##10	GATE	5.6413e-18
C326	a_363_74##7	a_216_424##2	2.06318e-17
C327	a_363_74#	a_27_424##2	1.32863e-16
C328	a_27_424##7	VGND#11	6.82319e-17
C329	a_216_424##3	a_27_424##2	1.41875e-18
C330	a_216_424##6	VNB	5.96617e-17
C331	a_216_424##2	VNB	2.47336e-17
C332	RESET_B	Q#1	5.02466e-18
C333	VPWR	VPWR#5	5.34688e-17
C334	RESET_B	VPWR#8	1.28559e-17
C335	VPWR	VPWR#3	7.01546e-17
C336	GATE	a_216_424##13	1.32974e-17
C337	VPWR#3	a_817_48##4	4.39804e-19
C338	a_216_424##10	a_216_424##6	1.46604e-19
C339	GATE#2	a_216_424##3	2.86193e-17
C340	GATE	a_27_424##6	4.22994e-20
C341	VPWR	a_817_48##9	1.97163e-17
C342	a_363_74##4	a_759_508#	3.19494e-18
C343	a_27_424##6	GATE#5	1.8708e-17
C344	a_216_424##3	D#3	2.0496e-18
C345	D	a_27_424##7	7.32845e-18
C346	a_363_74#	a_216_424##6	1.9065e-17
C347	VPWR	a_643_74##6	3.82145e-18
C348	a_363_74##4	a_568_392#	4.83667e-18
C349	D#3	GATE#2	1.8922e-17
C350	a_363_74#	a_216_424##2	3.34209e-19
C351	a_363_74#	a_568_392#	1.42025e-17
C352	VGND	VGND#5	5.09916e-17
C353	VGND	VGND#3	4.38518e-17
C354	a_216_424##10	a_216_424##2	4.84763e-19
C355	VPWR#3	RESET_B#1	1.63772e-18
C356	VPWR	GATE#5	2.09264e-18
C357	a_216_424##5	a_769_74#	1.10234e-18
C358	VGND	a_817_48##8	4.84013e-18
C359	D	a_27_424##6	2.99318e-17
C360	VGND	RESET_B#4	3.0805e-18
C361	VGND	a_643_74##6	2.90085e-18
C362	RESET_B	a_817_48##4	2.02394e-18
C363	VGND#3	a_817_48##11	1.56554e-17
C364	VGND#5	VNB	4.3434e-17
C365	VPWR	Q#1	1.97449e-17
C366	VGND#3	VNB	3.9483e-17
C367	VPWR	VPWR#8	2.05727e-17
C368	VGND	GATE#5	1.60516e-18
C369	VPWR#8	Q#1	7.93528e-17
C370	VGND	Q#2	2.41714e-17
C371	VPWR#5	VNB	4.49089e-17
C372	VPWR#3	VNB	4.85171e-17
C373	VGND#5	VGND#9	5.21698e-20
C374	VPWR#3	a_643_74##4	2.37858e-17
C375	VPWR	a_643_74##7	8.732e-18
C376	VGND	a_817_48##11	1.70177e-17
C377	a_817_48##9	a_817_48##4	2.42856e-19
C378	Q#2	a_817_48##6	3.01611e-17
C379	a_817_48##9	VNB	5.43605e-18
C380	a_817_48##8	VNB	2.1007e-18
C381	VGND	a_643_74##8	1.00748e-17
C382	VPWR	a_363_74##9	3.72363e-18
C383	a_27_424##2	a_216_424##6	2.08551e-18
C384	VPWR	a_216_424##13	3.88715e-18
C385	RESET_B#4	VNB	1.46366e-18
C386	VPWR	VPWR#11	1.60847e-17
C387	VGND	a_363_74##7	5.49595e-18
C388	a_643_74##6	VNB	9.16432e-18
C389	VGND	a_216_424##10	4.07678e-17
C390	VPWR	a_27_424##6	3.68891e-17
C391	VGND	a_27_424##7	1.84118e-17
C392	a_216_424##2	a_27_424##2	3.66139e-17
C393	VGND	Q#1	1.48515e-18
C394	VPWR	a_817_48#	3.10726e-21
C395	RESET_B	a_817_48##5	9.51066e-19
C396	VPWR#5	a_817_48##3	7.55737e-20
C397	GATE#5	VNB	2.91862e-18
C398	a_817_48##6	VGND#8	1.82417e-17
C399	Q#2	VNB	6.27465e-17
C400	RESET_B	RESET_B#2	9.91013e-18
C401	VGND#8	VNB	8.74207e-19
C402	RESET_B	a_643_74##3	1.79874e-18
C403	a_817_48##11	VNB	7.36799e-18
C404	VGND#9	VNB	8.53644e-18
C405	a_643_74##8	VNB	5.38668e-18
C406	Q#2	RESET_B#3	1.71373e-18
C407	VGND	a_817_48##6	1.61862e-18
C408	VPWR	a_817_48##4	3.3064e-18
C409	VGND#10	VNB	9.68169e-20
C410	VGND	RESET_B#3	3.54677e-19
C411	VPWR	RESET_B#1	2.05216e-18
C412	a_363_74##7	VNB	5.60451e-18
C413	VGND	a_643_74#	5.24605e-20
C414	a_216_424##10	VNB	1.5323e-17
C415	VPWR	a_643_74##4	1.18156e-18
C416	VGND	a_817_48#	7.68068e-18
C417	VGND#11	VNB	1.41729e-17
C418	GATE	a_216_424##3	3.76764e-17
C419	VPWR#3	a_817_48##3	2.41513e-17
C420	VPWR	a_817_48##3	1.01935e-18
C421	a_27_424##7	VNB	3.72076e-17
C422	VGND	a_216_424##8	1.35172e-18
C423	Q#1	VNB	6.64627e-17
C424	a_817_48##9	RESET_B#1	4.19862e-17
C425	VGND	a_363_74##2	1.38244e-18
C426	VPWR	a_363_74##3	9.33715e-19
C427	VPWR#8	VNB	7.91869e-18
C428	GATE	GATE#2	6.23079e-18
C429	VGND	a_27_424##3	5.80685e-19
C430	VPWR	a_216_424##7	5.21175e-18
C431	VGND	a_216_424#	3.1738e-19
C432	VPWR	a_27_424#	1.29158e-18
C433	VGND	GATE#1	1.74669e-18
C434	VPWR	a_216_424##4	7.01314e-18
C435	VGND	D#1	8.29132e-18
C436	VPWR#10	VNB	1.61756e-18
C437	VPWR	GATE#3	9.29293e-19
C438	a_363_74##9	VNB	3.79218e-18
C439	VPWR	D#4	4.98072e-19
C440	a_216_424##13	VNB	6.14555e-18
C441	VPWR#11	VNB	2.00008e-18
C442	a_27_424##6	VNB	5.62903e-17
C443	VGND#8	RESET_B#3	3.50079e-17
C444	a_817_48##6	VNB	3.29739e-17
C445	VPWR	VPWR#4	1.84814e-17
C446	RESET_B#3	VNB	2.45558e-17
C447	a_643_74#	VNB	3.24094e-17
C448	a_817_48#	VNB	7.61608e-17
C449	VGND	a_216_424##7	1.0909e-19
C450	VPWR	a_817_48##5	3.14867e-18
C451	a_216_424##8	VNB	2.94359e-17
C452	a_363_74##2	VNB	2.56527e-17
C453	a_27_424##3	VNB	2.70152e-17
C454	D	D#3	1.28606e-17
C455	VPWR	a_643_74##3	5.31576e-18
C456	a_216_424#	VNB	4.52849e-17
C457	GATE#1	VNB	3.57817e-17
C458	VPWR#5	a_363_74##3	2.75747e-19
C459	Q#2	a_643_74#	1.17658e-19
C460	VPWR	a_817_48##2	5.29191e-18
C461	D#1	VNB	3.74336e-17
C462	a_817_48##11	a_817_48##6	3.20942e-19
C463	VPWR	a_216_424##5	1.67134e-18
C464	VGND#5	VGND#3	1.21171e-20
C465	a_817_48##4	VNB	4.60148e-17
C466	VPWR	a_363_74##4	4.1598e-17
C467	RESET_B#1	VNB	3.77636e-17
C468	VGND	VGND#4	1.57059e-17
C469	a_643_74##4	VNB	2.947e-17
C470	VPWR	a_363_74#	2.98341e-18
C471	VGND	a_817_48##5	6.19563e-18
C472	a_817_48##3	VNB	2.58654e-17
C473	a_363_74##3	VNB	2.17311e-17
C474	VPWR	a_27_424##2	1.33301e-17
C475	a_216_424##7	VNB	4.31761e-17
C476	VGND	a_643_74##3	7.82813e-18
C477	VPWR	a_216_424##3	1.3184e-18
C478	a_27_424#	VNB	3.17153e-17
C479	VGND	a_817_48##2	6.75607e-19
C480	a_216_424##4	VNB	4.01214e-17
C481	GATE#3	VNB	3.83062e-17
C482	VGND	a_216_424##5	3.05507e-17
C483	D#4	VNB	5.00482e-17
C484	VPWR#3	a_363_74##3	2.75376e-18
C485	a_817_48##9	a_643_74##4	3.88989e-17
C486	VGND	a_363_74#	7.45735e-18
C487	VPWR#4	VNB	2.94377e-16
C488	VGND#4	VNB	2.92841e-16
C489	VGND	a_27_424##2	2.90125e-18
C490	a_817_48##5	VNB	4.39926e-17
C491	VGND	a_216_424##3	2.42874e-18
C492	RESET_B#2	VNB	3.08452e-17
C493	a_363_74##7	a_363_74##9	2.24471e-18
C494	VGND	GATE#2	3.80354e-19
C495	VGND#8	a_643_74#	3.68045e-18
C496	a_643_74##3	VNB	6.63591e-17
C497	a_216_424##3	a_216_424##2	6.65774e-18
C498	a_817_48##2	VNB	6.02527e-17
C499	VGND	D#3	7.28892e-18
C500	a_216_424##5	VNB	7.56143e-18
C501	a_27_424##7	a_216_424##2	1.43807e-19
C502	a_363_74##4	VNB	3.93596e-17
C503	a_363_74#	VNB	3.86811e-17
C504	a_27_424##2	VNB	3.65953e-17
C505	a_216_424##3	VNB	4.43626e-17
C506	GATE#2	VNB	4.75935e-17
C507	D#3	VNB	8.8694e-17
C508	a_817_48##11	RESET_B#3	3.62231e-18
C509	VPWR	GATE	1.22675e-18
C510	VPWR	RESET_B	3.05125e-18
C511	VGND	GATE	1.77682e-18
C512	VPWR	D	4.23384e-18
C513	VPWR#5	a_216_424##7	6.26616e-19
C514	GATE	VNB	2.09255e-18
C515	D	VNB	1.42906e-17
C516	VPWR	VNB	7.6054e-17
C517	VGND	VNB	9.32852e-17
C518	VGND#8	a_817_48#	1.64377e-19
C519	VGND#9	RESET_B#3	1.86903e-19
C520	a_817_48##9	a_817_48##3	1.09513e-18
C521	VGND#2	a_643_74#	6.82444e-18
C522	VPWR#6	VPWR#5	2.94317e-19
C523	VGND#2	Q#2	3.07045e-17
C524	VGND#6	a_216_424##3	6.47428e-20
C525	VPWR#3	VPWR#2	9.89124e-19
C526	VPWR#6	VNB	6.33613e-17
C527	a_27_424##6	VPWR#6	2.9247e-17
C528	VGND#6	D#1	4.12286e-18
C529	VGND#2	RESET_B#3	8.07792e-18
C530	VPWR	VPWR#6	4.70687e-17
C531	D	VPWR#6	4.94776e-19
C532	VGND#2	a_817_48##6	1.07891e-17
C533	VGND#6	GATE	3.03284e-19
C534	VGND#6	GATE#1	7.65439e-18
C535	VGND#2	VNB	6.32405e-17
C536	a_817_48##9	VPWR#2	8.43957e-18
C537	VGND#4	VGND#6	7.12558e-17
C538	VGND#6	a_216_424##10	2.0645e-17
C539	VGND	VGND#2	6.87165e-17
C540	VPWR#2	a_817_48##4	5.55659e-18
C541	VGND#6	a_216_424#	2.93648e-19
C542	VGND#2	a_817_48##5	9.92921e-19
C543	VPWR#2	RESET_B#1	4.60998e-18
C544	VGND#3	VGND#2	3.05677e-19
C545	VGND#6	VNB	6.37718e-17
C546	VPWR#6	D#3	4.05221e-19
C547	VPWR#6	GATE#2	6.88088e-20
C548	VGND#4	VGND#2	7.04082e-17
C549	VPWR#6	a_216_424##3	8.97935e-20
C550	VGND#2	a_817_48##8	2.37667e-18
C551	Q#1	VPWR#2	2.23488e-17
C552	VGND	VGND#6	5.84247e-17
C553	VPWR#4	VPWR#6	6.93209e-17
C554	VPWR#6	D#4	2.541e-18
C555	VPWR#6	GATE#3	3.93933e-18
C556	RESET_B	VPWR#2	3.11398e-19
C557	VGND#9	VGND#2	7.85983e-19
C558	VPWR#4	VPWR#2	5.61402e-17
C559	VGND#6	D#3	1.61341e-18
C560	VGND#6	VGND#5	1.64258e-19
C561	VGND#2	a_817_48##11	2.01752e-18
C562	VPWR	VPWR#2	3.8789e-17
C563	VGND#6	GATE#5	8.59013e-20
C564	a_817_48##5	VPWR#2	2.91041e-19
C565	VPWR#2	RESET_B#2	3.30002e-20
C566	VPWR#2	VNB	4.93085e-17
C567	VGND#2	a_817_48#	2.18891e-19
C568	VGND#6	a_27_424##7	1.44378e-17
*
*
.ENDS sky130_fd_sc_hs__dlrtp_1
*
