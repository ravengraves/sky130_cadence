* Extracted by Quantus, converted by sky130cad/quantus.py
*
*
*
*                       LINUX           Wed Nov 18 09:13:31 2026
*
*
*
*  PROGRAM  advgen
*
*  Name           : advgen - Quantus - (64-bit)
*  Version        : 25.1.0-p047
*  Build Date     : Thu Dec 11 23:20:30 PST 2025
*
*  HSPICE LIBRARY
*
*  OPERATING_TEMPERATURE 150
*  QRC_TECH_DIR <path>/tech
*
*
*
*
.SUBCKT sky130_fd_sc_hs__tapvgnd2_1 VGND VPB VPWR
*
*
*  caps2d version: 10
*
*
*       CAPACITOR CARDS
*
*
C1	VPB	VGND	1.81246e-16
C2	VPWR	VGND	1.26051e-16
C3	VPB	VPWR	7.37504e-17
*
*
.ENDS sky130_fd_sc_hs__tapvgnd2_1
*
