* Extracted by Quantus, converted by sky130cad/quantus.py
*
*
*
*                       LINUX           Wed Nov 18 08:03:25 2026
*
*
*
*  PROGRAM  advgen
*
*  Name           : advgen - Quantus - (64-bit)
*  Version        : 25.1.0-p047
*  Build Date     : Thu Dec 11 23:20:30 PST 2025
*
*  HSPICE LIBRARY
*
*  OPERATING_TEMPERATURE 150
*  QRC_TECH_DIR <path>/tech
*
*
*

*
.SUBCKT sky130_fd_sc_hs__a211oi_2 VPB VNB VGND VPWR Y A1 B1 C1 A2
*
*
*  caps2d version: 10
*
*
*       TRANSISTOR CARDS
*
*
XM4 Y#3 A1#5 a_38_74##4 VNB sky130_fd_pr__nfet_01v8_lvt l=0.15 w=0.74 ad=0.2072 as=0.1961 pd=2.04 ps=2.01
XM6 a_38_74##2 A1#1 Y#3 VNB sky130_fd_pr__nfet_01v8_lvt l=0.15 w=0.74 ad=0.2072 as=0.2072 pd=2.04 ps=2.04
XM8 a_38_74##2 A2#5 VGND#8 VNB sky130_fd_pr__nfet_01v8_lvt l=0.15 w=0.74 ad=0.2072 as=0.2368 pd=2.04 ps=2.12
XM12 VGND#8 A2#1 a_38_74# VNB sky130_fd_pr__nfet_01v8_lvt l=0.15 w=0.74 ad=0.2368 as=0.2183 pd=2.12 ps=2.07
XM13 VGND#7 B1#4 Y#4 VNB sky130_fd_pr__nfet_01v8_lvt l=0.15 w=0.74 ad=0.1961 as=0.5328 pd=2.01 ps=2.92
XM10 Y#4 C1#4 VGND#4 VNB sky130_fd_pr__nfet_01v8_lvt l=0.15 w=0.74 ad=0.5328 as=0.2109 pd=2.92 ps=2.05
XM0 a_114_368##3 A1#6 VPWR#4 VPB sky130_fd_pr__pfet_01v8 l=0.15 w=1.12 ad=0.336 as=0.308 pd=2.84 ps=2.79
XM5 VPWR#6 A1#4 a_114_368##3 VPB sky130_fd_pr__pfet_01v8 l=0.15 w=1.12 ad=0.336 as=0.336 pd=2.84 ps=2.84
XM7 VPWR#6 A2#7 a_114_368##4 VPB sky130_fd_pr__pfet_01v8 l=0.15 w=1.12 ad=0.336 as=0.336 pd=2.84 ps=2.84
XM1 a_114_368##4 A2#6 VPWR#5 VPB sky130_fd_pr__pfet_01v8 l=0.15 w=1.12 ad=0.336 as=0.3304 pd=2.84 ps=2.83
XM2 a_497_368##3 B1#5 a_114_368# VPB sky130_fd_pr__pfet_01v8 l=0.15 w=1.12 ad=0.3304 as=0.336 pd=2.83 ps=2.84
XM9 a_114_368# B1#1 a_497_368##4 VPB sky130_fd_pr__pfet_01v8 l=0.15 w=1.12 ad=0.336 as=0.336 pd=2.84 ps=2.84
XM11 Y#1 C1#5 a_497_368##4 VPB sky130_fd_pr__pfet_01v8 l=0.15 w=1.12 ad=0.336 as=0.336 pd=2.84 ps=2.84
XM3 a_497_368# C1#1 Y#1 VPB sky130_fd_pr__pfet_01v8 l=0.15 w=1.12 ad=0.308 as=0.336 pd=2.79 ps=2.84
*
*
*       RESISTOR AND CAP/DIODE CARDS
*
Rg1	A1#1	A1#2	322.953644
Rg2	A1#2	A1#3	95.737839
Rg3	A1#2	A1#4	507.075531
Rg4	A1#3	A1#5	298.046661
Rg5	A1#3	A1#6	480.518188
Rg6	A2#1	A2#2	397.555725
Rg7	A2#2	A2#3	32.565670
Rg8	A2#3	A2#4	20.770033
Rg9	A2#4	A2#5	392.634735
Rg10	A2#2	A2#6	449.655212
Rg11	A2#4	A2#7	450.494476
Rg12	B1#1	B1#2	504.163422
Rg13	B1#2	B1#3	62.113228
Rg14	B1#3	B1#4	322.953644
Rg15	B1#3	B1#5	507.075531
Rg16	C1#1	C1#2	509.023376
Rg17	C1#2	C1#3	56.207058
Rg18	C1#3	C1#4	320.354431
Rg19	C1#3	C1#5	506.680298
Rf1	A1	A1#7	1.500178
Rf2	A1#8	A1#3	161.732986
Rf3	A1#7	A1#8	3.304946
Rf4	a_38_74#	a_38_74##3	85.497169
Rf5	a_38_74##3	a_38_74##4	87.201561
Rf6	a_38_74##2	a_38_74##3	7.500000
Rf7	A2	A2#8	3.349972
Rf8	A2#8	A2	14.516547
Rf9	a_114_368#	a_114_368##2	102.190804
Rf10	a_114_368##2	a_114_368##3	87.120621
Rf11	a_114_368##2	a_114_368##4	21.948179
Rf12	B1	B1#6	12.001423
Rf13	B1#6	B1	4.941762
Rf14	Y#1	Y	118.403091
Rf15	Y	Y#2	7.081332
Rf16	Y#2	Y#3	168.661591
Rf17	Y#2	Y#4	50.540577
Rf18	a_497_368#	a_497_368##2	98.311989
Rf19	a_497_368##2	a_497_368##3	79.990082
Rf20	a_497_368##2	a_497_368##4	36.706856
Rf21	C1	C1#6	15.178270
Rf22	C1#6	C1	1.764915
Rf24	VGND#2	VGND#3	114.226440
Rf25	VGND#2	VGND#4	31.731567
Rf26	VGND#3	VGND#5	64.017227
Rf28	VGND#3	VGND#7	36.824379
Rf29	VGND#5	VGND#8	39.804005
Rf30	VPWR#1	VPWR#2	24.082130
Rf31	VPWR#2	VPWR#3	65.696381
Rf32	VPWR#3	VPWR#4	116.844124
Rf33	VPWR#2	VPWR#5	30.747387
Rf34	VPWR#3	VPWR#6	33.109421
Rf36	A2#3	A2#8	80.116402
Rf37	B1#2	B1#6	160.232803
Rf38	C1#2	C1#6	160.232803
Re1	VPWR#1	VPWR	0.982218
Re2	VGND	VGND#3	0.982254
*
*       CAPACITOR CARDS
*
*
C1	A2#4	B1#5	4.53823e-19
C2	a_38_74#	A2#4	5.85227e-19
C3	A1#2	A2#4	3.57008e-17
C4	VGND#8	A2#4	8.72674e-19
C5	Y#2	a_114_368##2	2.03224e-18
C6	A1#4	A2#4	2.9769e-18
C7	a_38_74##2	A2#4	1.13099e-18
C8	a_38_74##2	A1#2	3.9902e-21
C9	Y#3	A2#4	8.9838e-18
C10	Y#3	A1#2	1.71036e-17
C11	Y#2	VGND#7	2.5951e-17
C12	a_38_74##4	A1#2	2.70004e-19
C13	VPWR#1	C1#3	5.09771e-21
C14	Y#2	a_38_74#	6.01799e-17
C15	VPWR#1	B1#3	1.03712e-20
C16	Y#2	VGND#8	3.6706e-19
C17	Y#1	C1#3	5.40653e-19
C18	a_38_74##2	Y#2	4.14757e-18
C19	VGND#3	B1#3	4.73532e-20
C20	Y#3	a_114_368##2	2.75937e-19
C21	VPWR#3	VPWR#5	7.70812e-20
C22	C1#3	C1#2	4.74226e-18
C23	Y#4	VGND#4	6.19938e-17
C24	a_497_368##2	Y#1	1.4859e-17
C25	VGND#7	VGND#4	5.07127e-19
C26	a_114_368##4	VPWR#3	5.25459e-18
C27	VPWR#3	A2#4	2.04712e-20
C28	a_497_368##2	a_497_368##4	1.2089e-19
C29	a_114_368##4	VPWR#2	5.20514e-18
C30	VGND#7	Y#4	3.36002e-17
C31	a_497_368##2	a_114_368#	1.54164e-17
C32	B1#2	C1#3	3.11527e-17
C33	a_38_74#	Y#4	2.78817e-18
C34	a_114_368#	B1#3	1.32691e-19
C35	B1#3	B1#2	4.80129e-18
C36	Y#2	a_114_368#	3.84367e-18
C37	a_114_368##3	VPWR#3	1.40209e-17
C38	VPWR#3	A1#2	4.24656e-20
C39	a_38_74#	VGND#7	2.84388e-17
C40	VPWR#2	A2#4	2.01982e-20
C41	VGND#8	VGND#7	8.67012e-20
C42	VPWR#4	VPWR#3	9.86498e-19
C43	a_38_74#	VGND#8	3.84211e-17
C44	a_497_368##3	B1#3	3.10284e-20
C45	a_38_74##2	a_38_74#	2.20492e-18
C46	a_114_368##2	VPWR#5	4.26662e-17
C47	a_38_74##2	VGND#8	4.8302e-17
C48	Y#3	a_38_74#	1.44301e-19
C49	VGND#4	Y#1	8.11725e-18
C50	a_114_368##2	a_114_368##4	3.55094e-18
C51	Y#3	VGND#8	5.08769e-20
C52	a_38_74##2	Y#3	7.44115e-17
C53	a_114_368##2	VPWR#6	2.68578e-17
C54	A1#3	A1#2	4.74226e-18
C55	a_38_74##4	a_38_74##2	4.38056e-18
C56	a_114_368##3	a_114_368##2	2.30229e-18
C57	a_38_74##4	Y#3	5.46787e-17
C58	Y#2	C1#4	9.34243e-19
C59	A2#4	a_114_368##4	5.48219e-19
C60	Y#2	B1#4	9.91528e-18
C61	Y#2	A2#1	1.3838e-17
C62	A1#8	VPWR#4	2.2921e-17
C63	a_497_368#	Y#1	8.46719e-17
C64	Y#2	A2#5	3.75497e-19
C65	a_497_368##4	a_497_368#	3.51463e-18
C66	Y#2	A1#1	2.28196e-19
C67	Y#1	a_497_368##4	7.56592e-17
C68	VGND#4	C1#4	3.71668e-17
C69	a_114_368#	Y#1	1.90777e-18
C70	Y#2	A1#5	2.43752e-19
C71	C1#4	Y#4	2.596e-17
C72	a_114_368#	a_497_368##4	5.0677e-17
C73	VGND#4	B1#4	1.73321e-18
C74	VGND#7	C1#4	1.20027e-18
C75	Y#4	B1#4	4.24196e-17
C76	a_497_368##3	a_497_368##4	4.14108e-18
C77	a_38_74#	C1#4	2.40355e-19
C78	Y#3	a_114_368##3	1.10756e-17
C79	VGND#7	B1#4	4.2822e-17
C80	a_497_368##2	C1#3	1.52512e-20
C81	a_114_368#	a_497_368##3	8.18704e-17
C82	Y#4	A2#1	3.82731e-19
C83	a_114_368##3	A1#2	2.23409e-18
C84	a_38_74##4	a_114_368##3	2.00686e-18
C85	a_38_74#	B1#4	2.36866e-18
C86	VGND#7	A2#1	1.62154e-18
C87	a_497_368##2	C1#5	1.61113e-17
C88	VGND#8	B1#4	1.38713e-19
C89	a_38_74#	A2#1	3.14162e-17
C90	VPWR#2	A2#6	1.82535e-18
C91	VPWR#5	a_497_368##3	5.20437e-17
C92	a_114_368##4	a_114_368#	1.29429e-18
C93	VGND#7	A2#5	9.86134e-20
C94	a_38_74##2	B1#4	6.66581e-20
C95	a_497_368##2	B1#1	1.84383e-17
C96	VGND#8	A2#1	2.95295e-17
C97	a_38_74#	A2#5	4.09795e-19
C98	VPWR#3	A2#7	1.83971e-18
C99	Y#3	B1#4	2.63238e-19
C100	a_38_74##2	A2#1	4.09795e-19
C101	VGND#8	A2#5	2.61529e-17
C102	a_114_368##4	VPWR#5	4.42811e-17
C103	a_38_74#	A1#1	1.81028e-19
C104	Y#3	A2#1	5.03668e-19
C105	a_38_74##2	A2#5	2.68613e-17
C106	VPWR#3	A1#4	1.84299e-18
C107	VGND#8	A1#1	1.33191e-18
C108	VPWR#6	VPWR#5	2.06267e-18
C109	Y#2	B1#3	8.80065e-18
C110	Y#3	A2#5	8.8339e-18
C111	A2	B1#3	2.76544e-18
C112	A2	A2#4	3.33366e-17
C113	a_38_74##2	A1#1	4.13332e-17
C114	VPWR#6	a_114_368##4	5.05407e-17
C115	a_114_368##3	VPWR#5	7.05832e-20
C116	A2	A1#2	9.32778e-18
C117	VGND#8	A1#5	3.08902e-19
C118	VPWR#3	A1#6	3.11958e-18
C119	Y#2	A2#4	1.29034e-17
C120	Y#3	A1#1	1.94388e-17
C121	a_114_368##3	a_114_368##4	1.04914e-19
C122	a_38_74##2	A1#5	1.88523e-18
C123	a_38_74##4	A1#1	2.16217e-18
C124	a_114_368##2	A2#6	2.27177e-17
C125	A1#5	Y#3	2.18332e-17
C126	a_114_368##3	VPWR#6	6.00224e-17
C127	a_38_74##4	A1#5	4.94364e-17
C128	VPWR#4	VPWR#6	1.7987e-18
C129	a_114_368##2	A2#7	1.50386e-17
C130	Y#2	A1#2	2.55439e-19
C131	VPWR#4	a_114_368##3	8.59027e-17
C132	VPWR#1	VPWR#3	4.45976e-17
C133	VPWR#1	VPWR#2	2.6241e-17
C134	a_114_368##2	A1#4	5.46916e-19
C135	a_497_368#	C1#1	4.41798e-17
C136	a_114_368##2	A1#6	2.94757e-19
C137	Y#1	C1#1	5.58878e-17
C138	a_497_368#	C1#5	1.30694e-18
C139	a_497_368##4	C1#1	1.29161e-18
C140	A2#1	B1#3	3.81428e-19
C141	B1	C1#3	2.44893e-17
C142	B1	B1#3	6.11468e-18
C143	a_497_368##2	VPWR#1	6.32383e-17
C144	Y#1	C1#5	6.18723e-17
C145	B1#4	C1#4	8.09266e-18
C146	B1	A2#4	6.73495e-19
C147	a_497_368#	B1#1	3.00902e-19
C148	C1#5	a_497_368##4	2.31681e-17
C149	a_114_368##2	A2#4	2.51275e-18
C150	Y#1	B1#1	5.2081e-18
C151	a_114_368#	C1#5	1.58103e-18
C152	a_114_368##2	VPWR#1	5.94118e-19
C153	A2#1	B1#4	4.84405e-18
C154	VPWR#5	C1#1	4.82053e-20
C155	B1#1	a_497_368##4	2.78375e-17
C156	VGND#3	Y#2	1.37303e-18
C157	a_497_368##3	C1#5	3.46651e-19
C158	Y#1	B1#5	9.41239e-20
C159	a_114_368#	B1#1	4.87303e-17
C160	VPWR#5	C1#5	6.80595e-20
C161	a_497_368##4	B1#5	1.04783e-18
C162	a_497_368##2	C1#2	6.52122e-20
C163	a_497_368##3	B1#1	1.49935e-18
C164	Y#1	A2#6	6.04947e-20
C165	A2#5	A2#1	3.30771e-17
C166	a_114_368#	B1#5	4.03494e-17
C167	VPWR#5	B1#1	1.87397e-19
C168	a_497_368##3	B1#5	6.95239e-17
C169	a_114_368##4	B1#1	1.01226e-19
C170	a_114_368#	A2#6	4.18225e-19
C171	a_497_368##2	B1#2	8.04635e-20
C172	VPWR#5	B1#5	2.09171e-18
C173	A1#1	A2#5	3.71568e-17
C174	VPWR#3	A1#3	4.30395e-20
C175	a_497_368##3	A2#6	1.24862e-18
C176	a_114_368##4	B1#5	3.51809e-19
C177	a_114_368#	A2#7	1.26274e-19
C178	VGND#3	VGND#4	1.45028e-19
C179	VPWR#5	A2#6	5.82211e-17
C180	A1#2	A2#5	2.86744e-18
C181	VGND#3	Y#4	1.85799e-17
C182	A2#6	a_114_368##4	2.41803e-17
C183	A1#5	A1#1	3.78641e-17
C184	a_114_368##3	B1#5	2.01678e-19
C185	VPWR#5	A2#7	1.95451e-18
C186	VPWR#6	A2#6	2.5454e-18
C187	C1#2	VGND#4	6.00082e-18
C188	VGND#3	a_38_74#	1.88707e-17
C189	A2#7	a_114_368##4	2.32783e-17
C190	Y	C1#3	1.74009e-19
C191	VGND#8	VGND#3	2.75039e-19
C192	a_114_368##3	A2#6	4.69959e-19
C193	Y	B1#3	4.87693e-18
C194	Y	A2#4	9.09861e-19
C195	VPWR#6	A2#7	5.15917e-17
C196	a_497_368#	VPWR#1	5.03722e-17
C197	a_114_368##4	A1#4	3.71368e-20
C198	a_114_368##3	A2#7	8.7829e-19
C199	B1#2	Y#4	2.494e-17
C200	VPWR#6	A1#4	4.60106e-17
C201	a_114_368##4	A1#6	1.99798e-20
C202	a_114_368##3	A1#4	3.59076e-17
C203	a_114_368#	VPWR#1	1.09347e-18
C204	VPWR#6	A1#6	2.90342e-18
C205	VPWR#4	A1#4	1.17456e-18
C206	A1#8	A1#3	2.04348e-17
C207	a_497_368##3	VPWR#1	4.56135e-17
C208	a_114_368##3	A1#6	5.71724e-17
C209	a_497_368#	C1#2	7.52044e-20
C210	VPWR#4	A1#6	3.13371e-17
C211	C1#5	C1#1	4.78976e-17
C212	Y#1	C1#2	3.38665e-18
C213	B1#2	Y#1	1.20215e-19
C214	B1#1	C1#5	4.96043e-17
C215	VPWR#1	VPWR#4	2.4021e-17
C216	VPWR#3	VPWR#2	1.12731e-18
C217	a_114_368#	B1#2	5.37511e-19
C218	Y#3	A1#3	2.2224e-17
C219	a_497_368##3	B1#2	4.4176e-20
C220	A1#3	a_38_74##4	3.60897e-17
C221	B1#5	B1#1	4.61629e-17
C222	VGND#3	B1#4	2.0708e-18
C223	A2#6	B1#5	4.24875e-18
C224	VGND	C1#3	1.89952e-18
C225	VGND	B1#3	9.53185e-19
C226	VGND	A1#2	1.20224e-18
C227	Y#2	A2	6.37222e-17
C228	A2	a_114_368##2	1.03209e-16
C229	A2#7	A2#6	4.77798e-17
C230	A1#8	A2#4	2.69996e-18
C231	VPWR#1	C1#1	4.46303e-18
C232	a_114_368##3	A1#3	2.28972e-18
C233	A1#8	A2	7.10183e-18
C234	VPWR#1	C1#5	4.47264e-18
C235	VPWR#4	A1#3	6.2971e-18
C236	A1#4	A2#7	4.65989e-17
C237	VPWR#1	B1#1	4.46303e-18
C238	VPWR#1	B1#5	4.47264e-18
C239	A1#6	A1#4	5.01896e-17
C240	Y#2	B1	2.10436e-17
C241	VGND#4	C1	2.78162e-17
C242	Y#3	A2	4.19897e-17
C243	C1#3	VNB	2.03845e-17
C244	B1#3	VNB	2.64088e-17
C245	A2#4	VNB	6.47067e-17
C246	A1#2	VNB	2.53075e-17
C247	Y#4	B1	5.19323e-17
C248	C1	a_497_368#	2.40477e-17
C249	C1	Y#1	3.14338e-17
C250	VGND#4	C1#3	2.52853e-18
C251	Y	a_497_368##2	1.20599e-18
C252	B1	Y#1	3.34405e-17
C253	VPWR#1	C1#2	4.69341e-20
C254	VPWR	VPWR#3	2.61347e-17
C255	VPWR	VPWR#2	1.64724e-17
C256	VPWR#1	B1#2	4.16606e-20
C257	VGND#3	B1#2	1.89633e-19
C258	Y#4	Y	3.86333e-18
C259	VPWR	a_497_368##2	2.51989e-17
C260	VPWR	a_114_368##2	5.75652e-18
C261	VPWR	A1#8	3.1449e-18
C262	B1	A2#1	1.5321e-19
C263	A2	B1#5	9.22424e-19
C264	Y	a_114_368#	7.28655e-17
C265	Y	a_497_368##3	2.86931e-18
C266	A2	A2#6	2.11575e-18
C267	VGND	Y#2	8.64131e-18
C268	A2	A2#7	2.09036e-18
C269	VPWR	a_497_368#	2.22316e-17
C270	A2	A1#4	3.43965e-18
C271	Y	a_114_368##3	2.801e-21
C272	VPWR	Y#1	9.07149e-18
C273	A2	A1#6	1.492e-18
C274	VGND	VGND#4	1.86989e-17
C275	VPWR	a_114_368#	1.1013e-17
C276	VGND	Y#4	2.66534e-17
C277	A2#4	B1#3	3.35169e-18
C278	VPWR#3	VNB	3.35977e-17
C279	VPWR	a_497_368##3	2.13797e-17
C280	VGND	VGND#7	1.62735e-17
C281	VPWR#2	VNB	2.03676e-17
C282	VPWR	VPWR#5	2.26327e-17
C283	VGND	a_38_74#	1.74915e-17
C284	VGND	VGND#8	1.52102e-17
C285	VPWR	a_114_368##4	1.11396e-17
C286	VGND	a_38_74##2	1.85558e-17
C287	VPWR	VPWR#6	2.15608e-17
C288	VGND	Y#3	9.08198e-18
C289	VPWR	a_114_368##3	1.51609e-17
C290	a_497_368##2	VNB	4.5313e-18
C291	VGND	a_38_74##4	2.3758e-17
C292	Y#2	VNB	1.28207e-17
C293	VPWR	VPWR#4	3.25126e-17
C294	VGND	a_497_368#	2.78098e-18
C295	a_114_368##2	VNB	3.64655e-18
C296	VGND	Y#1	3.73163e-18
C297	C1	VPWR#1	6.50197e-19
C298	B1#3	Y#4	1.63328e-18
C299	A1#8	VNB	1.14552e-17
C300	VGND#4	VNB	3.24794e-17
C301	Y	B1#1	1.73815e-17
C302	C1	C1#2	3.11864e-17
C303	Y#4	VNB	6.37285e-18
C304	VGND#7	VNB	4.22196e-18
C305	Y	B1#5	1.63542e-17
C306	a_38_74#	VNB	7.52289e-18
C307	VGND	a_114_368##3	3.12612e-18
C308	VGND#8	VNB	1.34602e-18
C309	Y	A2#6	2.42468e-18
C310	A2	A1#3	8.64331e-19
C311	VGND	VPWR#4	4.34828e-18
C312	a_38_74##2	VNB	2.45484e-18
C313	VPWR	C1#1	2.3339e-18
C314	Y#3	VNB	3.5935e-18
C315	VGND	C1#4	1.77123e-18
C316	Y	A2#7	6.02256e-19
C317	a_38_74##4	VNB	4.00876e-17
C318	VGND	B1#4	1.11936e-18
C319	VPWR	C1#5	1.67402e-18
C320	a_497_368#	VNB	6.12355e-17
C321	Y	A1#4	3.57059e-19
C322	VGND	A2#1	1.09822e-18
C323	B1	B1#2	1.28408e-17
C324	Y#1	VNB	7.35956e-18
C325	VPWR	B1#1	1.60141e-18
C326	VGND	A2#5	7.62453e-19
C327	Y	A1#6	4.25042e-19
C328	VPWR	B1#5	2.04727e-18
C329	a_114_368#	VNB	4.69247e-18
C330	VGND	A1#1	1.39087e-18
C331	a_497_368##3	VNB	1.13774e-17
C332	VPWR	A2#6	1.01193e-18
C333	VGND	A1#5	2.8213e-18
C334	VPWR#5	VNB	7.65915e-18
C335	a_114_368##4	VNB	4.61348e-18
C336	VPWR	A2#7	1.15118e-18
C337	VPWR#6	VNB	1.1615e-19
C338	VPWR	A1#4	1.03854e-18
C339	a_114_368##3	VNB	3.5116e-18
C340	VPWR#4	VNB	8.12595e-17
C341	VPWR	A1#6	4.13867e-18
C342	C1#4	VNB	3.1351e-17
C343	Y	C1#2	1.21824e-19
C344	B1#4	VNB	3.05775e-17
C345	A2#1	VNB	3.27938e-17
C346	B1#2	Y	1.41157e-17
C347	a_114_368##2	VPWR#3	3.13618e-19
C348	VPWR	VPWR#1	5.43714e-17
C349	A2#5	VNB	2.49161e-17
C350	A1#1	VNB	2.5481e-17
C351	A1#5	VNB	3.49165e-17
C352	C1#1	VNB	4.18017e-17
C353	VPWR	B1#2	5.61397e-19
C354	C1#5	VNB	3.51864e-17
C355	B1#1	VNB	3.51266e-17
C356	B1#5	VNB	3.85275e-17
C357	VGND	VGND#3	3.31206e-17
C358	A2#6	VNB	2.98997e-17
C359	A2#7	VNB	2.83965e-17
C360	VGND	C1#2	7.13855e-19
C361	B1	C1	2.47738e-17
C362	A1#4	VNB	3.33005e-17
C363	VGND	B1#2	1.36287e-18
C364	A1#6	VNB	4.38887e-17
C365	VPWR#1	VNB	2.9059e-16
C366	VGND	A1#3	6.67935e-18
C367	A2	Y	2.42482e-17
C368	VGND#3	VNB	2.46399e-16
C369	C1#2	VNB	5.21065e-17
C370	B1#2	VNB	2.83802e-17
C371	VPWR	A2	5.18654e-18
C372	Y	B1	2.61714e-17
C373	A1#3	VNB	6.9676e-17
C374	VPWR	C1	6.03971e-18
C375	a_114_368##2	VPWR#2	3.70929e-19
C376	VGND	A2	6.73845e-18
C377	VPWR	B1	2.88586e-18
C378	VGND	C1	1.18927e-17
C379	VGND	B1	5.91724e-18
C380	A2	VNB	1.51014e-17
C381	VPWR	Y	4.62616e-18
C382	C1	VNB	3.66377e-17
C383	B1	VNB	4.90838e-18
C384	VGND	Y	1.86593e-18
C385	Y	VNB	6.48357e-18
C386	VPWR	VNB	7.46906e-17
C387	VGND	VNB	7.9455e-17
C388	VGND#5	VNB	6.96018e-17
C389	VGND#5	A1#1	4.48038e-18
C390	VGND#5	A2#4	4.58102e-20
C391	VGND#5	A1#3	1.13839e-18
C392	VGND#2	C1#4	4.41234e-18
C393	VGND#5	a_38_74##4	5.47799e-17
C394	VGND	VGND#2	4.52781e-17
C395	VGND#5	VGND#8	1.00551e-17
C396	VGND#2	B1#2	1.7634e-19
C397	VGND	VGND#5	4.38669e-17
C398	VGND#5	A2#5	1.2017e-18
C399	VGND#5	A1#2	6.32857e-20
C400	VGND#2	Y#4	1.787e-17
C401	VGND#2	B1	8.51046e-19
C402	VGND#3	VGND#5	8.34139e-17
C403	VGND#2	C1#2	7.35578e-19
C404	VGND#5	a_38_74#	1.35091e-18
C405	VGND#5	A1#5	4.44935e-18
C406	VGND#5	A2#1	7.25363e-18
C407	VGND#2	C1	4.9402e-18
C408	VGND#3	VGND#2	6.57199e-17
C409	VGND#5	a_38_74##2	3.30522e-17
C410	VGND#2	VNB	6.27482e-17
*
*
.ENDS sky130_fd_sc_hs__a211oi_2
*
