* Extracted by Quantus, converted by sky130cad/quantus.py
*
*
*
*                       LINUX           Wed Nov 18 08:37:27 2026
*
*
*
*  PROGRAM  advgen
*
*  Name           : advgen - Quantus - (64-bit)
*  Version        : 25.1.0-p047
*  Build Date     : Thu Dec 11 23:20:30 PST 2025
*
*  HSPICE LIBRARY
*
*  OPERATING_TEMPERATURE 150
*  QRC_TECH_DIR <path>/tech
*
*
*

*
.SUBCKT sky130_fd_sc_hs__einvp_1 VPB VNB VGND VPWR Z A TE
*
*
*  caps2d version: 10
*
*
*       TRANSISTOR CARDS
*
*
XM2 a_44_549##3 TE#4 VGND#3 VNB sky130_fd_pr__nfet_01v8_lvt l=0.15 w=0.42 ad=0.2604 as=0.2276 pd=2.08 ps=2.16
XM0 VGND#3 TE#1 a_318_74# VNB sky130_fd_pr__nfet_01v8_lvt l=0.15 w=0.74 ad=0.2276 as=0.1776 pd=2.16 ps=1.96
XM5 a_318_74# A#4 Z#3 VNB sky130_fd_pr__nfet_01v8_lvt l=0.15 w=0.74 ad=0.1776 as=0.2109 pd=1.96 ps=2.05
XM3 a_44_549##4 TE#5 VPWR#4 VPB sky130_fd_pr__pfet_01v8 l=0.15 w=0.42 ad=0.2646 as=0.3328 pd=2.1 ps=2.77
XM4 VPWR#4 a_44_549# a_310_392# VPB sky130_fd_pr__pfet_01v8 l=0.15 w=1 ad=0.3328 as=0.27 pd=2.77 ps=2.54
XM1 a_310_392# A#3 Z#1 VPB sky130_fd_pr__pfet_01v8 l=0.15 w=1 ad=0.27 as=0.295 pd=2.54 ps=2.59
*
*
*       RESISTOR AND CAP/DIODE CARDS
*
Rg1	a_44_549#	a_44_549##2	713.506104
Rg2	TE#1	TE#2	630.104309
Rg3	TE#2	TE#3	46.428108
Rg4	TE#2	TE#4	569.646545
Rg5	TE#3	TE#5	229.842880
Rg6	A#1	A#2	24.707481
Rg7	A#2	A#3	519.456787
Rg8	A#2	A#4	374.076508
Rf1	a_44_549##3	a_44_549##5	107.259735
Rf2	a_44_549##5	a_44_549##2	92.758224
Rf3	a_44_549##4	a_44_549##5	7.500000
Rf4	TE	TE#6	16.071110
Rf5	TE#6	TE	2.295873
Rf6	A#1	A#6	160.919952
Rf7	A#7	A	0.687145
Rf8	A#6	A#7	7.873454
Rf9	Z	Z#2	12.203854
Rf10	Z#2	Z	2.362036
Rf11	Z	Z#3	134.044235
Rf12	Z#1	Z#2	5.000000
Rf14	VGND#2	VGND#3	41.201946
Rf17	VPWR#2	VPWR#4	39.421906
Rf19	TE#3	TE#6	80.116402
Re1	VPWR#2	VPWR	1.964508
Re2	VGND	VGND#2	1.964582
*
*       CAPACITOR CARDS
*
*
C1	a_44_549##3	A#2	5.17235e-19
C2	TE#1	A#2	2.51362e-17
C3	TE#3	A#2	2.23396e-18
C4	A#6	Z#3	5.75787e-17
C5	TE	A#2	2.60848e-18
C6	VGND#3	Z#3	4.49649e-17
C7	a_44_549##3	Z#3	3.37418e-18
C8	A	A#2	1.05344e-17
C9	a_44_549##3	VGND#3	5.43379e-17
C10	A#6	A#2	1.48007e-17
C11	A#6	TE#1	1.06682e-18
C12	VGND#3	VPWR#4	2.87217e-18
C13	Z#3	A#4	4.88724e-17
C14	Z	A#2	7.76231e-18
C15	Z#3	TE#1	1.95162e-17
C16	VGND#3	A#4	6.99744e-18
C17	Z#3	TE#4	3.4345e-18
C18	a_44_549##3	A#4	1.42561e-19
C19	TE#1	VGND#3	2.34474e-17
C20	a_44_549##3	TE#1	2.65116e-18
C21	TE#4	VGND#3	2.40698e-17
C22	TE#4	a_44_549##3	1.86197e-17
C23	VGND#3	a_44_549#	1.14341e-18
C24	A#3	Z#1	1.07679e-17
C25	TE#1	A#4	5.30285e-17
C26	VPWR#4	A#3	7.72445e-18
C27	TE#4	TE#1	2.81879e-17
C28	VPWR#4	a_44_549#	5.56957e-17
C29	TE#5	VPWR#4	1.35052e-17
C30	TE#5	a_44_549##4	7.31409e-18
C31	TE#1	a_44_549#	1.35001e-17
C32	Z#3	TE#3	2.28958e-18
C33	VGND#3	TE#3	7.4095e-18
C34	a_44_549##3	TE#3	1.41093e-17
C35	a_44_549#	A#3	6.6047e-17
C36	A#2	VNB	6.63439e-17
C37	a_44_549##3	a_44_549##2	2.93914e-18
C38	TE#5	a_44_549#	2.04814e-17
C39	VPWR#4	TE#3	4.55054e-18
C40	Z#3	A#2	1.31608e-17
C41	VPWR#4	a_44_549##2	9.12751e-17
C42	a_44_549##2	a_44_549##4	9.65763e-18
C43	TE#3	TE#1	1.12708e-17
C44	Z#3	a_318_74#	4.21216e-18
C45	TE#3	a_44_549#	6.15039e-18
C46	a_44_549##2	A#3	9.71502e-19
C47	TE	Z#3	6.65599e-18
C48	a_44_549##2	a_44_549#	8.71817e-18
C49	A#4	a_318_74#	1.70137e-17
C50	VGND#3	TE	1.85552e-17
C51	a_44_549##2	TE#5	3.55128e-17
C52	a_44_549##3	TE	3.28836e-17
C53	TE#1	a_318_74#	1.36555e-17
C54	A#3	a_310_392#	1.95177e-17
C55	Z	A#6	2.01569e-18
C56	a_44_549#	a_310_392#	2.05886e-17
C57	TE	VPWR#4	2.12115e-17
C58	Z#3	Z	2.15057e-18
C59	TE#3	a_44_549##2	1.75836e-17
C60	Z	Z#1	5.30918e-18
C61	A	TE#1	3.88265e-19
C62	VPWR#4	Z	5.4493e-17
C63	TE	a_44_549#	3.90311e-19
C64	VGND	A#6	2.79359e-18
C65	Z	TE#1	3.33311e-18
C66	VPWR	VPWR#4	2.14661e-17
C67	VGND	Z#3	2.20196e-17
C68	Z	A#3	4.90099e-17
C69	VGND	VGND#3	1.55931e-17
C70	VGND	a_44_549##3	3.24981e-17
C71	VPWR	TE#1	1.0013e-18
C72	Z	a_44_549#	1.61598e-17
C73	Z	TE#5	9.81131e-19
C74	TE	TE#3	4.5694e-17
C75	A#6	VNB	9.89483e-18
C76	VPWR	A#3	1.77829e-18
C77	a_44_549##2	TE	5.65441e-17
C78	VGND	A#4	1.25908e-18
C79	VPWR	a_44_549#	7.43865e-18
C80	Z#3	VNB	4.6746e-17
C81	VGND	TE#1	5.78012e-18
C82	VPWR	TE#5	6.55804e-19
C83	VGND#3	VNB	1.06995e-17
C84	VGND	TE#4	1.7592e-18
C85	a_44_549##3	VNB	6.88639e-17
C86	Z	TE#3	2.11671e-18
C87	VGND	a_44_549#	1.37428e-18
C88	a_44_549##2	Z	2.82196e-18
C89	A#4	VNB	2.8322e-17
C90	TE#1	VNB	5.29533e-17
C91	VPWR	TE#3	1.01851e-19
C92	TE#4	VNB	4.55251e-17
C93	Z	a_310_392#	6.13657e-18
C94	VPWR	a_44_549##2	4.22708e-17
C95	A#3	VNB	3.96453e-17
C96	a_44_549#	VNB	5.57933e-17
C97	TE#5	VNB	2.57708e-17
C98	VGND	TE#3	1.50739e-18
C99	TE	Z	1.44054e-17
C100	TE#3	VNB	1.11899e-16
C101	Z	A	4.80066e-17
C102	VPWR	TE	5.60284e-18
C103	a_44_549##2	VNB	1.73626e-16
C104	VPWR	A	2.63391e-18
C105	VGND	TE	6.75951e-18
C106	VPWR	Z	2.23598e-17
C107	TE	VNB	2.25207e-17
C108	A	VNB	9.03361e-18
C109	Z	VNB	5.58221e-17
C110	VPWR	VNB	4.99375e-17
C111	VGND	VNB	5.48237e-17
C112	VGND#2	Z#3	2.43967e-17
C113	VPWR#2	A#2	1.85893e-19
C114	VGND	VGND#2	7.1674e-17
C115	VGND#2	TE	4.60351e-19
C116	a_44_549##2	VPWR#2	8.73116e-17
C117	VPWR#2	TE#1	9.60221e-19
C118	VGND#2	TE#3	2.03003e-19
C119	Z	VPWR#2	2.38351e-17
C120	VGND#2	a_44_549#	9.25387e-19
C121	TE	VPWR#2	4.29455e-19
C122	VGND#2	TE#1	5.77071e-18
C123	VPWR#2	TE#5	1.41131e-18
C124	VGND#2	a_44_549##3	3.80507e-17
C125	VPWR#2	A#3	6.20911e-18
C126	VGND#2	VNB	2.20492e-16
C127	VPWR#2	VNB	2.08625e-16
C128	VGND#2	A#2	2.15165e-19
C129	VPWR	VPWR#2	7.00081e-17
C130	VGND#2	TE#4	5.64086e-18
C131	VGND#2	A#4	6.19226e-18
C132	VPWR#2	a_44_549#	1.00717e-17
*
*
.ENDS sky130_fd_sc_hs__einvp_1
*
