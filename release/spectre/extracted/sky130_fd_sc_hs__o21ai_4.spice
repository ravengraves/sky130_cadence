* Extracted by Quantus, converted by sky130cad/quantus.py
*
*
*
*                       LINUX           Wed Nov 18 08:55:44 2026
*
*
*
*  PROGRAM  advgen
*
*  Name           : advgen - Quantus - (64-bit)
*  Version        : 25.1.0-p047
*  Build Date     : Thu Dec 11 23:20:30 PST 2025
*
*  HSPICE LIBRARY
*
*  OPERATING_TEMPERATURE 150
*  QRC_TECH_DIR <path>/tech
*
*
*

*
.SUBCKT sky130_fd_sc_hs__o21ai_4 VNB VPB VGND VPWR Y B1 A1 A2
*
*
*  caps2d version: 10
*
*
*       TRANSISTOR CARDS
*
*
XM20 a_27_74##9 A1#6 VGND#11 VNB sky130_fd_pr__nfet_01v8_lvt l=0.15 w=0.74 ad=0.2109 as=0.2072 pd=2.05 ps=2.04
XM1 VGND#11 A1#10 a_27_74##12 VNB sky130_fd_pr__nfet_01v8_lvt l=0.15 w=0.74 ad=0.2072 as=0.2072 pd=2.04 ps=2.04
XM8 VGND#10 A1#8 a_27_74##12 VNB sky130_fd_pr__nfet_01v8_lvt l=0.15 w=0.74 ad=0.2183 as=0.2072 pd=2.07 ps=2.04
XM3 a_27_74##6 A1#7 VGND#10 VNB sky130_fd_pr__nfet_01v8_lvt l=0.15 w=0.74 ad=0.2072 as=0.2183 pd=2.04 ps=2.07
XM4 Y#6 B1#5 a_27_74##6 VNB sky130_fd_pr__nfet_01v8_lvt l=0.15 w=0.74 ad=0.2072 as=0.2072 pd=2.04 ps=2.04
XM21 Y#6 B1#7 a_27_74##11 VNB sky130_fd_pr__nfet_01v8_lvt l=0.15 w=0.74 ad=0.2072 as=0.2072 pd=2.04 ps=2.04
XM10 a_27_74##11 B1#6 Y#4 VNB sky130_fd_pr__nfet_01v8_lvt l=0.15 w=0.74 ad=0.2072 as=0.2072 pd=2.04 ps=2.04
XM6 a_27_74##3 B1#1 Y#4 VNB sky130_fd_pr__nfet_01v8_lvt l=0.15 w=0.74 ad=0.2257 as=0.2072 pd=2.09 ps=2.04
XM17 VGND#9 A2#11 a_27_74##3 VNB sky130_fd_pr__nfet_01v8_lvt l=0.15 w=0.74 ad=0.2072 as=0.2257 pd=2.04 ps=2.09
XM2 a_27_74##10 A2#9 VGND#9 VNB sky130_fd_pr__nfet_01v8_lvt l=0.15 w=0.74 ad=0.2072 as=0.2072 pd=2.04 ps=2.04
XM9 VGND#8 A2#6 a_27_74##10 VNB sky130_fd_pr__nfet_01v8_lvt l=0.15 w=0.74 ad=0.2072 as=0.2072 pd=2.04 ps=2.04
XM18 a_27_74# A2#1 VGND#8 VNB sky130_fd_pr__nfet_01v8_lvt l=0.15 w=0.74 ad=0.2109 as=0.2072 pd=2.05 ps=2.04
XM0 VPWR#8 A1#12 a_116_368##7 VPB sky130_fd_pr__pfet_01v8 l=0.15 w=1.12 ad=0.3304 as=0.336 pd=2.83 ps=2.84
XM5 VPWR#7 A1#11 a_116_368##7 VPB sky130_fd_pr__pfet_01v8 l=0.15 w=1.12 ad=0.336 as=0.336 pd=2.84 ps=2.84
XM13 a_116_368##5 A1#9 VPWR#7 VPB sky130_fd_pr__pfet_01v8 l=0.15 w=1.12 ad=0.336 as=0.336 pd=2.84 ps=2.84
XM14 a_116_368##5 A1#1 VPWR#5 VPB sky130_fd_pr__pfet_01v8 l=0.15 w=1.12 ad=0.336 as=0.336 pd=2.84 ps=2.84
XM7 VPWR#5 B1#9 Y#8 VPB sky130_fd_pr__pfet_01v8 l=0.15 w=1.12 ad=0.336 as=0.336 pd=2.84 ps=2.84
XM16 Y#8 B1#8 VPWR#3 VPB sky130_fd_pr__pfet_01v8 l=0.15 w=1.12 ad=0.336 as=0.4256 pd=2.84 ps=3
XM11 a_116_368##3 A2#13 Y#7 VPB sky130_fd_pr__pfet_01v8 l=0.15 w=1.12 ad=0.3304 as=0.392 pd=2.83 ps=2.94
XM19 Y#7 A2#12 a_116_368##8 VPB sky130_fd_pr__pfet_01v8 l=0.15 w=1.12 ad=0.392 as=0.336 pd=2.94 ps=2.84
XM15 a_116_368##8 A2#7 Y#1 VPB sky130_fd_pr__pfet_01v8 l=0.15 w=1.12 ad=0.336 as=0.336 pd=2.84 ps=2.84
XM12 Y#1 A2#5 a_116_368# VPB sky130_fd_pr__pfet_01v8 l=0.15 w=1.12 ad=0.336 as=0.3304 pd=2.84 ps=2.83
*
*
*       RESISTOR AND CAP/DIODE CARDS
*
Rg1	A1#1	A1#2	467.025726
Rg2	A1#2	A1#3	66.369736
Rg3	A1#3	A1#4	46.177197
Rg4	A1#4	A1#5	94.937218
Rg5	A1#5	A1#6	380.339874
Rg6	A1#2	A1#7	394.071777
Rg7	A1#3	A1#8	381.936401
Rg8	A1#3	A1#9	463.426788
Rg9	A1#4	A1#10	355.070312
Rg10	A1#4	A1#11	436.927094
Rg11	A1#5	A1#12	462.979767
Rg12	B1#1	B1#2	490.044464
Rg13	B1#2	B1#3	65.536888
Rg14	B1#3	B1#4	42.706509
Rg15	B1#4	B1#5	302.383087
Rg16	B1#2	B1#6	274.134094
Rg17	B1#3	B1#7	297.283173
Rg18	B1#3	B1#8	493.089355
Rg19	B1#4	B1#9	512.350403
Rg20	A2#1	A2#2	403.957642
Rg21	A2#2	A2#3	54.976021
Rg22	A2#3	A2#4	24.995329
Rg23	A2#2	A2#5	436.070282
Rg24	A2#3	A2#6	427.444397
Rg25	A2#3	A2#7	441.790924
Rg26	A2#4	A2#8	41.914082
Rg27	A2#8	A2#9	442.592041
Rg28	A2#8	A2#10	59.602261
Rg29	A2#10	A2#11	383.840790
Rg30	A2#8	A2#12	456.938599
Rg31	A2#10	A2#13	431.131989
Rf1	A1#4	A1	41.633305
Rf2	B1#3	B1	54.116901
Rf3	Y#1	Y#2	78.344398
Rf4	Y#2	Y#3	41.434948
Rf5	Y#3	Y	5.351396
Rf6	Y	Y#5	58.171253
Rf7	Y#5	Y#6	78.063393
Rf8	Y#2	Y#7	16.279915
Rf9	Y#3	Y#8	58.920029
Rf10	Y#4	Y#5	15.000000
Rf11	A2	A2#14	12.224110
Rf12	A2#14	A2	2.444822
Rf13	a_116_368#	a_116_368##2	94.986412
Rf14	a_116_368##2	a_116_368##4	76.929947
Rf15	a_116_368##4	a_116_368##6	140.202576
Rf16	a_116_368##6	a_116_368##7	88.873932
Rf17	a_116_368##2	a_116_368##8	28.306047
Rf18	a_116_368##3	a_116_368##4	7.500000
Rf19	a_116_368##5	a_116_368##6	5.000000
Rf20	a_27_74#	a_27_74##2	85.866737
Rf21	a_27_74##2	a_27_74##4	84.090828
Rf22	a_27_74##4	a_27_74##5	89.081787
Rf23	a_27_74##5	a_27_74##7	82.141991
Rf24	a_27_74##7	a_27_74##8	79.054100
Rf25	a_27_74##8	a_27_74##9	85.795815
Rf26	a_27_74##2	a_27_74##10	28.306047
Rf27	a_27_74##5	a_27_74##11	19.941607
Rf28	a_27_74##8	a_27_74##12	16.988226
Rf29	a_27_74##3	a_27_74##4	7.500000
Rf30	a_27_74##6	a_27_74##7	7.500000
Rf32	VGND#2	VGND#3	62.774361
Rf33	VGND#3	VGND#4	95.671616
Rf34	VGND#4	VGND#5	95.671616
Rf35	VGND#5	VGND#6	62.774361
Rf37	VGND#2	VGND#8	35.098007
Rf38	VGND#3	VGND#9	35.098007
Rf39	VGND#5	VGND#10	33.326477
Rf40	VGND#6	VGND#11	36.082184
Rf42	VPWR#2	VPWR#3	35.840199
Rf43	VPWR#2	VPWR#4	55.551193
Rf44	VPWR#4	VPWR#5	37.538910
Rf45	VPWR#4	VPWR#6	68.798325
Rf46	VPWR#6	VPWR#7	53.143215
Rf47	VPWR#6	VPWR#8	117.064072
Rf50	A2#4	A2#14	40.058201
Re1	VPWR#2	VPWR	0.818510
Re2	VGND	VGND#4	0.818540
*
*       CAPACITOR CARDS
*
*
C1	VGND#9	VGND#8	2.92642e-18
C2	Y#3	A2#10	1.17825e-17
C3	VGND#9	a_27_74##10	4.15829e-17
C4	a_116_368##5	VPWR#6	8.80264e-18
C5	Y#3	A2#8	1.38904e-19
C6	a_27_74##3	a_27_74##10	1.67195e-18
C7	A1#2	B1#4	3.18259e-17
C8	a_116_368##5	VPWR#4	1.04973e-17
C9	Y#8	B1#4	3.21681e-18
C10	a_27_74##3	VGND#9	5.58724e-17
C11	Y#2	A2#10	3.10864e-18
C12	VPWR#7	VPWR#4	8.39315e-20
C13	A1#2	B1#9	2.84559e-18
C14	a_116_368##7	VPWR#6	1.70187e-17
C15	Y#2	A2#8	1.75747e-18
C16	a_116_368##2	Y#1	1.6243e-17
C17	a_27_74##3	Y#4	5.84213e-17
C18	Y#3	B1#4	1.16643e-17
C19	VPWR#8	VPWR#6	7.0017e-19
C20	VPWR#6	VPWR#4	6.99578e-19
C21	a_116_368##2	a_116_368##8	5.47123e-20
C22	Y#3	a_116_368#	2.67801e-21
C23	Y#4	a_27_74##11	2.86968e-19
C24	a_116_368##2	Y#7	4.30848e-19
C25	Y#6	Y#4	2.37574e-18
C26	a_116_368##5	B1#4	4.47732e-19
C27	Y#2	Y#1	3.01982e-18
C28	Y#6	a_27_74##11	2.9589e-19
C29	Y#2	a_116_368##8	4.50439e-17
C30	a_27_74#	a_116_368#	1.61677e-19
C31	Y#3	A1#2	2.68246e-19
C32	Y#4	VGND#10	1.55723e-21
C33	Y#2	Y#7	4.93985e-18
C34	Y#3	a_116_368##3	7.56348e-17
C35	a_27_74##6	Y#6	4.03863e-17
C36	A1#2	a_116_368##5	1.25523e-18
C37	Y#2	a_116_368##3	5.70959e-17
C38	VGND#3	A2#6	6.41281e-19
C39	Y#3	VPWR#3	3.50609e-18
C40	a_27_74##6	VGND#10	4.39297e-17
C41	VGND#3	A2#9	4.37361e-18
C42	a_27_74##12	a_27_74##6	3.42363e-18
C43	VGND#3	A2#11	4.11629e-18
C44	a_27_74##12	VGND#10	2.83262e-17
C45	a_116_368##7	A1#5	1.45204e-18
C46	VGND#11	VGND#10	2.53096e-18
C47	a_27_74##2	A2#1	1.95034e-19
C48	VGND#8	A2#8	2.51385e-19
C49	VGND#3	B1#1	3.21682e-18
C50	VGND#11	a_27_74##12	3.75808e-17
C51	a_27_74##2	A2#6	1.70188e-17
C52	VGND#3	B1#6	2.34187e-19
C53	a_27_74##9	a_27_74##12	5.01262e-19
C54	VGND#8	A2#2	8.36869e-19
C55	a_27_74##9	VGND#11	4.68446e-17
C56	a_27_74##5	A2#11	2.18624e-19
C57	a_27_74##2	A2#9	1.69132e-17
C58	VGND#3	B1#7	7.5375e-20
C59	VGND#5	B1#5	2.73447e-18
C60	a_27_74##2	A2#11	9.24914e-20
C61	a_27_74##5	B1#1	6.20522e-18
C62	a_27_74##8	B1#6	1.36953e-19
C63	VGND#3	B1#5	4.47499e-20
C64	VGND#9	A2#10	3.93947e-19
C65	a_27_74##2	B1#1	3.90546e-20
C66	a_27_74##5	B1#6	2.22601e-17
C67	VGND#5	A1#7	1.63996e-18
C68	a_27_74##8	B1#7	1.93488e-19
C69	VGND#9	A2#8	5.566e-19
C70	a_116_368#	Y#1	7.51503e-17
C71	VPWR#4	B1#4	4.90778e-20
C72	VPWR#6	A1#5	2.05092e-20
C73	VGND#4	B1#4	2.93736e-19
C74	a_27_74##5	B1#7	2.10729e-17
C75	VGND#5	A1#8	1.22302e-18
C76	a_27_74##8	B1#5	3.08224e-19
C77	a_27_74#	A2#1	3.25877e-17
C78	a_116_368##8	a_116_368#	3.51463e-18
C79	VGND#5	a_27_74##8	3.87788e-19
C80	VGND#8	A2#1	3.07486e-17
C81	a_27_74##5	B1#5	8.26919e-19
C82	Y#1	a_116_368##8	4.10242e-17
C83	a_27_74##3	A2#10	1.55864e-18
C84	a_27_74##8	A1#7	1.19606e-18
C85	a_27_74#	A2#6	8.48022e-19
C86	a_27_74##10	A2#1	6.43198e-19
C87	a_27_74##6	a_116_368##5	2.43189e-18
C88	VGND#8	A2#6	2.93539e-17
C89	Y#3	B1#1	3.06889e-18
C90	a_27_74##5	A1#7	2.16679e-19
C91	a_27_74#	A2#9	1.87602e-19
C92	a_27_74##8	A1#8	1.78747e-17
C93	A2#6	a_27_74##10	1.38198e-17
C94	VGND#8	A2#9	1.70046e-18
C95	VGND#9	A2#6	1.43011e-18
C96	Y#4	A2#1	1.10442e-19
C97	a_116_368##3	a_116_368##8	3.85197e-18
C98	A2#9	a_27_74##10	1.72195e-17
C99	a_27_74##8	A1#10	1.48646e-17
C100	a_27_74##3	A2#6	1.67688e-19
C101	Y#4	A2#10	8.94314e-19
C102	VGND#9	A2#9	3.38568e-17
C103	B1#3	A2#10	1.02797e-18
C104	a_116_368##3	Y#7	4.79488e-19
C105	Y#4	A2#6	1.19137e-19
C106	a_27_74##10	A2#11	3.05025e-19
C107	a_27_74##3	A2#9	3.97516e-19
C108	Y#4	A2#8	4.15338e-19
C109	VGND#3	A2#10	6.78079e-20
C110	a_27_74##8	A1#6	5.97237e-19
C111	VPWR#4	A1#2	1.9315e-20
C112	B1#3	B1#4	5.69349e-17
C113	VGND#9	A2#11	2.87536e-17
C114	Y#4	A2#9	2.32845e-19
C115	B1#1	A2#10	9.25028e-18
C116	a_27_74##10	B1#1	1.28797e-19
C117	B1#3	A1#5	1.54595e-19
C118	a_27_74##3	A2#11	3.20804e-17
C119	a_116_368##3	VPWR#3	7.93555e-17
C120	B1#3	A1#2	9.62252e-18
C121	VGND#9	B1#1	1.02343e-18
C122	VGND#3	A2#8	3.61404e-20
C123	Y#4	A2#11	1.47707e-18
C124	a_116_368##3	Y#8	2.80328e-17
C125	a_27_74##3	B1#1	2.78176e-17
C126	Y#4	A2#2	1.32981e-19
C127	VGND#3	a_27_74##2	2.91756e-19
C128	A1#4	A2#10	1.30514e-18
C129	a_27_74##9	VPWR#8	1.04249e-17
C130	Y#4	B1#1	4.11244e-17
C131	Y#4	B1#4	4.89473e-18
C132	a_27_74##3	B1#6	3.58411e-19
C133	A1#4	B1#4	5.92009e-18
C134	VPWR#5	VPWR#3	1.10704e-17
C135	a_116_368##5	a_116_368##3	1.00503e-18
C136	VPWR#4	A2#13	3.36314e-20
C137	A1#4	A1#5	2.69233e-17
C138	Y#4	B1#6	2.69307e-17
C139	Y#6	B1#1	1.89459e-19
C140	A1#4	A1#2	1.88294e-17
C141	B1#6	a_27_74##11	1.44923e-17
C142	Y#4	B1#7	8.51353e-19
C143	Y#6	B1#6	4.33532e-19
C144	a_116_368##5	Y#8	4.04577e-17
C145	VPWR#4	B1#8	7.17065e-19
C146	VGND#10	B1#1	4.51311e-20
C147	B1#7	a_27_74##11	1.44923e-17
C148	Y#4	B1#5	4.32032e-19
C149	a_116_368##5	VPWR#5	6.32336e-17
C150	Y#6	B1#7	2.6075e-17
C151	B1#4	a_27_74##11	1.00064e-18
C152	VGND#10	B1#6	7.58546e-20
C153	VPWR#6	B1#9	8.1728e-20
C154	a_27_74##6	B1#7	3.8405e-19
C155	VPWR#4	B1#9	7.20924e-18
C156	VPWR#7	VPWR#5	1.836e-18
C157	a_116_368##7	Y#8	8.41847e-19
C158	Y#4	A1#7	1.86677e-19
C159	Y#6	B1#5	2.80384e-17
C160	VGND#10	B1#7	2.37996e-19
C161	a_116_368##5	VPWR#7	5.95659e-17
C162	a_27_74##6	B1#5	4.08084e-17
C163	a_116_368##2	A2#7	1.58468e-17
C164	Y#3	A2#5	4.16329e-19
C165	VPWR#6	A1#1	2.85183e-19
C166	Y#4	A1#8	1.48681e-19
C167	Y#6	A1#7	9.25772e-19
C168	VGND#10	B1#5	1.44271e-18
C169	VPWR#4	A1#1	5.29838e-18
C170	a_116_368##7	a_116_368##5	3.01982e-18
C171	a_27_74##6	A1#7	3.36742e-17
C172	a_27_74##12	B1#5	2.64824e-19
C173	VGND#5	A1#2	1.89766e-20
C174	a_116_368##2	A2#12	1.61437e-17
C175	a_116_368##7	VPWR#7	6.42369e-17
C176	B1#4	Y#6	4.756e-18
C177	Y#3	A2#7	3.30273e-19
C178	VGND#10	A1#7	2.96283e-17
C179	VPWR#6	A1#9	5.10896e-18
C180	Y#2	A2#7	1.73137e-18
C181	a_27_74##6	A1#8	6.28216e-19
C182	VPWR#4	A1#9	3.16366e-19
C183	a_27_74##12	A1#7	6.28216e-19
C184	VPWR#8	VPWR#7	1.94092e-18
C185	VGND#10	A1#8	2.91819e-17
C186	Y#3	A2#12	5.91469e-19
C187	a_116_368##3	B1#1	9.15016e-19
C188	VPWR#8	a_116_368##7	8.65098e-17
C189	a_27_74##6	A1#10	2.64824e-19
C190	Y#2	A2#12	3.58635e-17
C191	A1#8	a_27_74##12	1.16196e-17
C192	VPWR#6	A1#11	5.10896e-18
C193	VGND#10	A1#10	1.77258e-18
C194	VPWR#4	A1#11	9.48638e-20
C195	VGND#11	A1#8	1.54851e-18
C196	A2#10	A2#8	3.20043e-18
C197	Y#3	A2#13	1.01938e-17
C198	A1#10	a_27_74##12	1.61337e-17
C199	a_27_74##9	A1#8	1.87602e-19
C200	Y#2	A2#13	2.11382e-17
C201	VGND#11	A1#10	3.23887e-17
C202	VPWR#6	A1#12	2.34133e-18
C203	Y#3	B1#8	2.02507e-18
C204	a_27_74##12	A1#6	1.86735e-19
C205	a_27_74##9	A1#10	8.48022e-19
C206	Y#2	B1#8	2.10236e-19
C207	VGND#11	A1#6	2.92408e-17
C208	A2#6	A2#1	3.95494e-17
C209	a_27_74##9	A1#6	3.06774e-17
C210	Y#3	B1#9	3.2603e-19
C211	Y#2	B1#9	7.98299e-20
C212	A2	A2#10	1.14215e-17
C213	A2	A2#8	3.84639e-17
C214	A2#9	A2#6	4.09582e-17
C215	A2	A2#2	2.92071e-17
C216	A1#7	B1#4	2.82013e-18
C217	Y#3	A1#1	1.32395e-19
C218	A2	B1#4	1.97207e-18
C219	Y#2	A1#1	8.50212e-20
C220	a_27_74##6	A1#2	2.89028e-18
C221	a_116_368#	A2#5	4.4208e-17
C222	A2#11	A2#9	3.97309e-17
C223	Y#1	A2#5	4.62706e-17
C224	a_116_368#	A2#7	1.30694e-18
C225	a_116_368##8	A2#5	1.29161e-18
C226	B1#1	A2#11	3.62578e-17
C227	Y#1	A2#7	5.27828e-17
C228	a_27_74##8	B1#4	3.74984e-19
C229	a_116_368#	A2#12	3.00902e-19
C230	A2#7	a_116_368##8	2.39036e-17
C231	VGND#4	VGND#5	4.53622e-17
C232	Y#1	A2#12	1.37698e-18
C233	VGND#4	VGND#3	4.53622e-17
C234	VPWR#3	A2#5	4.81481e-20
C235	B1#6	B1#1	3.52343e-17
C236	A2#12	a_116_368##8	2.73349e-17
C237	a_116_368##3	A2#7	3.28804e-19
C238	VGND#10	A1#2	1.38918e-19
C239	A2#12	Y#7	2.54251e-17
C240	VPWR#3	A2#7	6.56593e-20
C241	VGND#3	a_27_74##10	5.24871e-18
C242	a_116_368##8	A2#13	1.10516e-18
C243	a_116_368##3	A2#12	1.60651e-18
C244	B1#7	B1#6	3.6624e-17
C245	A2#13	Y#7	1.16921e-17
C246	VGND#4	a_27_74##5	8.01945e-17
C247	VPWR#3	A2#12	2.05041e-19
C248	A2#8	A2#2	3.15868e-18
C249	B1#4	A2#10	3.78552e-18
C250	a_116_368##3	A2#13	7.63163e-17
C251	a_27_74##8	A1#5	1.47266e-18
C252	VPWR#3	A2#13	1.83545e-18
C253	B1#5	B1#7	3.46805e-17
C254	a_116_368##3	B1#8	2.80113e-17
C255	A1#4	VPWR#6	5.72576e-20
C256	B1#8	VPWR#3	3.56526e-17
C257	VPWR#5	A2#13	3.22504e-19
C258	Y#8	B1#8	4.79225e-17
C259	a_116_368##3	B1#9	1.91449e-19
C260	a_116_368##5	A2#13	2.75419e-19
C261	A1#7	B1#5	3.75271e-17
C262	VGND#3	a_27_74##3	2.90441e-17
C263	VGND#5	A1#4	4.22692e-20
C264	VPWR#3	B1#9	2.6367e-18
C265	VPWR#5	B1#8	4.34857e-18
C266	VGND#11	A1#5	4.73488e-19
C267	Y#8	B1#9	3.75348e-17
C268	a_116_368##5	B1#8	4.55936e-19
C269	a_116_368##3	A1#1	1.19359e-19
C270	VPWR#5	B1#9	4.18682e-17
C271	A1#8	A1#7	3.77486e-17
C272	a_27_74##5	B1#4	1.32274e-18
C273	a_27_74##8	A1#4	7.98791e-17
C274	a_116_368##5	B1#9	2.54298e-17
C275	Y#8	A1#1	1.55212e-18
C276	A1#1	VPWR#5	2.73055e-17
C277	VPWR#7	B1#9	1.52316e-19
C278	a_27_74##2	A2#10	1.22442e-18
C279	VGND#4	a_27_74##3	1.44144e-18
C280	A1#10	A1#8	4.09284e-17
C281	a_116_368##5	A1#1	7.34112e-17
C282	a_116_368##7	B1#9	7.62911e-20
C283	Y#8	A1#9	1.18195e-19
C284	B1#3	Y#3	3.21277e-17
C285	VPWR#7	A1#1	3.40424e-19
C286	VPWR#5	A1#9	3.51409e-19
C287	a_116_368##7	A1#1	1.27881e-19
C288	a_116_368##5	A1#9	6.34208e-17
C289	Y#8	A1#11	8.3617e-20
C290	Y#2	a_116_368##2	1.8865e-17
C291	A1#6	A1#10	3.90798e-17
C292	a_27_74##9	A1#5	3.58762e-20
C293	VGND#4	a_27_74##6	3.69385e-18
C294	a_27_74##2	A2#8	6.56057e-18
C295	A1#9	VPWR#7	2.46915e-17
C296	VPWR#5	A1#11	1.63173e-19
C297	a_116_368#	A2#2	1.09926e-19
C298	a_27_74##2	a_27_74#	5.2354e-19
C299	A1#4	Y#3	3.95949e-18
C300	a_116_368##7	A1#9	2.07195e-18
C301	a_116_368##5	A1#11	2.18013e-18
C302	VPWR#8	A1#9	2.59902e-19
C303	A1#11	VPWR#7	2.84583e-17
C304	a_116_368##7	A1#11	7.62299e-17
C305	Y#4	B1#3	3.99595e-17
C306	A2#8	Y#1	2.08759e-18
C307	a_27_74##2	VGND#8	2.2917e-17
C308	VPWR#8	A1#11	1.23306e-18
C309	VPWR#7	A1#12	6.79311e-19
C310	VGND#5	a_27_74##6	2.61413e-17
C311	Y#6	B1#3	5.6271e-17
C312	a_116_368##7	A1#12	5.74e-17
C313	a_27_74##6	B1#3	2.34517e-17
C314	VPWR#8	A1#12	3.34022e-17
C315	a_27_74##2	A2#2	1.42151e-18
C316	A2#8	A2#5	9.50502e-19
C317	a_27_74##2	a_27_74##10	1.24483e-18
C318	A2#7	A2#5	4.67763e-17
C319	a_27_74##6	A1#4	9.67577e-18
C320	A2#2	Y#1	1.8172e-18
C321	A1#4	VGND#10	3.33824e-18
C322	a_27_74##5	a_27_74##3	2.58348e-18
C323	A1#4	a_27_74##12	2.76631e-18
C324	A1#4	VGND#11	2.79502e-18
C325	a_27_74##9	A1#4	2.23208e-17
C326	A2#12	A2#7	4.79978e-17
C327	a_27_74##8	a_27_74##11	2.28219e-20
C328	a_27_74##2	VGND#9	2.27977e-17
C329	VGND	B1#4	3.59424e-18
C330	a_27_74##2	A2	8.74051e-17
C331	A2#8	a_116_368##8	2.00497e-18
C332	VGND#5	a_27_74##12	5.19844e-18
C333	a_27_74##5	Y#4	4.81133e-17
C334	B1#3	Y#8	4.07326e-17
C335	A2#13	A2#12	3.46328e-17
C336	Y#3	A2	2.42454e-17
C337	B1#3	a_116_368##5	7.60973e-18
C338	A2	Y#2	5.55428e-17
C339	a_27_74##3	a_27_74##2	5.06977e-19
C340	B1#8	A2#13	4.46582e-18
C341	a_27_74#	A2	4.32952e-17
C342	VGND#4	B1#1	1.87111e-18
C343	A1#4	a_116_368##5	5.27592e-17
C344	a_27_74##5	a_27_74##11	9.42047e-19
C345	VGND#4	B1#6	4.44935e-18
C346	A1#4	VPWR#7	1.58305e-18
C347	VGND#4	B1#7	4.43427e-18
C348	A1#4	a_116_368##7	7.02028e-17
C349	a_27_74##3	A2	1.25077e-17
C350	B1#9	B1#8	5.34792e-17
C351	A2#10	Y#7	1.0224e-18
C352	A1#4	VPWR#8	5.01728e-19
C353	VGND#4	B1#5	1.68502e-18
C354	A1#1	B1#9	4.86892e-17
C355	a_27_74##5	Y#6	4.59091e-17
C356	A2#8	Y#7	4.84297e-20
C357	a_116_368##2	A2#10	1.46284e-19
C358	A2	a_116_368#	3.3278e-17
C359	A2	Y#1	5.83488e-17
C360	B1#3	A1#7	2.21892e-18
C361	A1#9	A1#1	4.65415e-17
C362	a_27_74##8	VGND#10	1.80832e-17
C363	B1#3	A1#8	7.77698e-19
C364	VPWR	VPWR#6	3.2999e-17
C365	VPWR	VPWR#4	3.48887e-17
C366	B1#3	A1#10	4.6009e-19
C367	a_27_74##6	a_27_74##5	2.67476e-18
C368	B1#3	A1#6	4.21622e-19
C369	A1#11	A1#9	4.81972e-17
C370	a_116_368##2	A2#8	1.17613e-19
C371	a_27_74##8	a_27_74##12	1.72575e-18
C372	A1#12	A1#11	4.63609e-17
C373	a_116_368##3	A2#10	1.26107e-19
C374	VPWR	a_116_368##2	2.6001e-17
C375	A2#10	VNB	3.32037e-17
C376	VPWR	Y#3	5.72061e-18
C377	A2#8	VNB	5.40167e-17
C378	VPWR	Y#2	9.33723e-18
C379	A2#2	VNB	4.24851e-17
C380	B1#4	VNB	7.89448e-17
C381	VGND	VGND#5	2.62667e-17
C382	A1#5	VNB	4.21132e-17
C383	VGND	VGND#3	4.64325e-17
C384	A1#2	VNB	2.19827e-17
C385	VGND	a_27_74##8	4.08961e-18
C386	VGND	a_27_74##5	3.18819e-17
C387	A1#4	B1#8	8.81798e-19
C388	VGND	a_27_74##2	3.93663e-18
C389	a_27_74##8	VGND#11	2.13162e-17
C390	A1#4	B1#9	1.73109e-18
C391	A1#4	A1#1	2.72784e-18
C392	VGND	Y#3	2.78472e-18
C393	A1#4	A1#9	2.61782e-18
C394	VPWR	a_116_368#	2.14095e-17
C395	VGND	a_27_74#	1.43319e-17
C396	VPWR	Y#1	8.0904e-18
C397	A1#4	A1#11	2.26877e-18
C398	a_116_368##2	A2#2	1.38369e-20
C399	VGND	a_27_74##10	1.09176e-17
C400	A2#13	A2#8	8.30923e-19
C401	VGND	a_27_74##3	1.55255e-17
C402	A1#4	A1#12	1.1117e-18
C403	VPWR	a_116_368##3	2.83977e-17
C404	VGND	Y#4	1.01762e-17
C405	a_27_74##3	Y#3	6.39035e-18
C406	VPWR	VPWR#3	1.83419e-17
C407	VGND	Y#6	7.44863e-18
C408	VPWR	Y#8	3.57435e-18
C409	VGND	a_27_74##6	1.68404e-17
C410	VGND	VGND#10	1.61978e-17
C411	VPWR	a_116_368##5	2.45078e-17
C412	VGND	a_27_74##12	1.11066e-17
C413	a_27_74##9	a_27_74##8	2.09578e-18
C414	VGND	a_27_74##9	1.46965e-17
C415	A2	B1#8	1.33465e-19
C416	VPWR	a_116_368##7	1.73679e-17
C417	VPWR	VPWR#8	3.32979e-17
C418	a_27_74#	VGND#8	4.90368e-17
C419	VGND	Y#8	3.02964e-18
C420	A1#4	B1#3	1.99477e-17
C421	a_116_368##3	B1#4	2.15126e-18
C422	a_27_74##3	Y#2	2.45526e-18
C423	VPWR#6	VNB	3.15152e-17
C424	VPWR#4	VNB	2.79076e-17
C425	Y#4	Y#3	2.25463e-18
C426	VGND#5	VNB	3.55208e-17
C427	VGND#3	VNB	3.48237e-17
C428	VGND	VPWR#8	4.06173e-18
C429	VGND	A2#1	1.49145e-18
C430	a_27_74##8	VNB	1.30116e-18
C431	VGND	A2#6	6.6321e-19
C432	a_27_74##5	VNB	6.30435e-18
C433	VGND	A2#9	6.6321e-19
C434	a_27_74##2	VNB	1.67639e-18
C435	VGND	A2#11	8.68504e-19
C436	VGND	B1#1	1.47049e-18
C437	a_116_368##2	VNB	4.76547e-18
C438	VGND	B1#6	1.51645e-18
C439	Y#3	VNB	8.83005e-18
C440	VGND	B1#7	1.52804e-18
C441	VPWR	A2#5	2.31657e-18
C442	VGND	B1#5	1.50131e-18
C443	VPWR	A2#7	1.68653e-18
C444	a_27_74#	VNB	4.71372e-17
C445	VGND	A1#7	1.00999e-18
C446	VGND#8	VNB	2.25711e-18
C447	VPWR	A2#12	1.61081e-18
C448	a_27_74##10	VNB	4.55126e-18
C449	VGND	A1#8	5.88513e-19
C450	VGND#9	VNB	4.67461e-20
C451	VPWR	A2#13	1.96735e-18
C452	VPWR#4	VPWR#3	5.09763e-20
C453	a_27_74##10	a_27_74#	1.72657e-18
C454	a_27_74##3	VNB	3.19503e-18
C455	VGND	A1#10	6.43606e-19
C456	Y#4	VNB	7.05282e-19
C457	VGND	A1#6	1.61909e-18
C458	VPWR	B1#8	9.18881e-19
C459	a_27_74##6	VNB	1.99952e-18
C460	VPWR	B1#9	4.07365e-19
C461	a_27_74##12	VNB	4.54572e-18
C462	VGND#11	VNB	1.96092e-18
C463	VPWR	A1#1	6.39756e-19
C464	a_27_74##9	VNB	4.34168e-17
C465	a_116_368#	VNB	5.39343e-17
C466	VPWR	A1#9	8.95111e-19
C467	B1#8	A2#10	4.20949e-19
C468	VPWR	A1#11	8.06842e-19
C469	a_116_368##3	VNB	1.19065e-17
C470	VPWR#3	VNB	5.68301e-18
C471	VPWR	A1#12	2.80944e-18
C472	Y#8	VNB	4.57609e-19
C473	VPWR#5	VNB	3.91088e-19
C474	a_116_368##5	VNB	2.1429e-18
C475	VPWR#7	VNB	2.91397e-18
C476	a_116_368##7	VNB	2.53327e-18
C477	VPWR#8	VNB	7.99652e-17
C478	A2#1	VNB	3.00975e-17
C479	A2#6	VNB	2.5053e-17
C480	A2#9	VNB	2.50926e-17
C481	A2#11	VNB	2.42079e-17
C482	B1#1	VNB	4.39926e-17
C483	B1#6	VNB	2.62058e-17
C484	B1#7	VNB	2.56474e-17
C485	VPWR	B1#3	7.50877e-18
C486	B1#5	VNB	2.56469e-17
C487	A1#7	VNB	2.40922e-17
C488	VPWR	A1#4	8.5499e-18
C489	A1#8	VNB	2.46528e-17
C490	VGND	VGND#4	2.25812e-17
C491	A1#10	VNB	2.46919e-17
C492	a_27_74##10	VGND#8	4.16102e-17
C493	A1#6	VNB	3.2965e-17
C494	A2#5	VNB	3.71465e-17
C495	VGND	B1#3	7.25026e-18
C496	A2#7	VNB	3.14928e-17
C497	A2#12	VNB	3.18305e-17
C498	VGND	A1#4	7.94619e-18
C499	A2#13	VNB	3.70608e-17
C500	B1#8	VNB	4.43395e-17
C501	B1#9	VNB	3.11761e-17
C502	VPWR	A2	9.72635e-18
C503	A1#1	VNB	3.09202e-17
C504	A1#9	VNB	3.28617e-17
C505	A1#11	VNB	3.4733e-17
C506	A1#12	VNB	4.07626e-17
C507	VGND	A2	9.71707e-18
C508	VGND#4	VNB	2.72139e-16
C509	B1#3	VNB	1.10516e-17
C510	A1#4	VNB	7.57127e-17
C511	A2	VNB	3.93216e-17
C512	VPWR	VNB	7.33096e-17
C513	VPWR#3	B1#4	1.38815e-18
C514	VGND	VNB	7.17266e-17
C515	VPWR#2	B1#1	8.97823e-20
C516	VPWR#2	B1#8	8.45393e-18
C517	VPWR#2	A2#2	1.26101e-20
C518	VGND#2	a_27_74#	1.7841e-17
C519	VGND#6	A1#10	4.70869e-18
C520	VGND#6	a_27_74##12	5.24783e-18
C521	VGND#4	VGND#6	4.96643e-17
C522	VGND#6	A1#4	4.54795e-20
C523	VGND	VGND#6	4.96905e-17
C524	VPWR	VPWR#2	7.30131e-17
C525	VPWR#2	VPWR#8	2.60272e-17
C526	VGND#2	A2#8	3.79474e-20
C527	a_116_368#	VPWR#2	5.03579e-17
C528	VGND#6	A1#8	7.44342e-19
C529	VPWR#2	A2#7	4.43427e-18
C530	VPWR#2	A2#10	2.90246e-20
C531	VPWR#2	VPWR#4	3.67215e-17
C532	VGND#3	VGND#2	1.14921e-18
C533	VGND#2	VNB	4.48904e-17
C534	VPWR#2	A2#13	4.43427e-18
C535	VGND#6	VGND#10	7.63531e-20
C536	VGND#2	a_27_74##2	2.91756e-19
C537	VGND#2	A2#9	6.41281e-19
C538	VGND#6	a_27_74##9	1.78524e-17
C539	a_116_368##3	VPWR#2	4.92344e-17
C540	a_116_368##2	VPWR#2	6.57001e-17
C541	VGND#2	a_27_74##10	5.19931e-18
C542	VPWR#2	B1#4	9.31183e-20
C543	VGND#6	VGND#5	1.7314e-18
C544	VGND#6	VNB	4.43791e-17
C545	a_116_368##5	VPWR#2	1.39319e-18
C546	VGND#6	A1#6	4.49145e-18
C547	VGND#2	A2#6	4.33684e-18
C548	VPWR#2	A2#5	4.43427e-18
C549	VGND#4	VGND#2	4.9624e-17
C550	VPWR#2	VPWR#6	4.29927e-17
C551	VPWR#2	VNB	3.44555e-16
C552	VPWR#2	A2#12	4.43427e-18
C553	VGND#6	a_27_74##8	3.0608e-19
C554	VPWR#2	A2#8	3.84567e-20
C555	VGND	VGND#2	5.20668e-17
C556	VGND#2	A2#1	4.11136e-18
*
*
.ENDS sky130_fd_sc_hs__o21ai_4
*
