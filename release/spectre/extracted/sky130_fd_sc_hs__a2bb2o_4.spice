* Extracted by Quantus, converted by sky130cad/quantus.py
*
*
*
*                       LINUX           Wed Nov 18 08:10:17 2026
*
*
*
*  PROGRAM  advgen
*
*  Name           : advgen - Quantus - (64-bit)
*  Version        : 25.1.0-p047
*  Build Date     : Thu Dec 11 23:20:30 PST 2025
*
*  HSPICE LIBRARY
*
*  OPERATING_TEMPERATURE 150
*  QRC_TECH_DIR <path>/tech
*
*
*

*
.SUBCKT sky130_fd_sc_hs__a2bb2o_4 VPB VNB VGND VPWR X B2 B1 A1_N A2_N
*
*
*  caps2d version: 10
*
*
*       TRANSISTOR CARDS
*
*
XM1 VGND#13 a_162_48##12 X#5 VNB sky130_fd_pr__nfet_01v8_lvt l=0.15 w=0.74 ad=0.1961 as=0.2072 pd=2.01 ps=2.04
XM7 X#5 a_162_48##8 VGND#12 VNB sky130_fd_pr__nfet_01v8_lvt l=0.15 w=0.74 ad=0.2072 as=0.2072 pd=2.04 ps=2.04
XM18 X#6 a_162_48##5 VGND#12 VNB sky130_fd_pr__nfet_01v8_lvt l=0.15 w=0.74 ad=0.2072 as=0.2072 pd=2.04 ps=2.04
XM22 VGND#11 a_162_48##4 X#6 VNB sky130_fd_pr__nfet_01v8_lvt l=0.15 w=0.74 ad=0.3657 as=0.2072 pd=2.54 ps=2.04
XM17 VGND#11 A1_N#1 a_586_94##8 VNB sky130_fd_pr__nfet_01v8_lvt l=0.15 w=0.64 ad=0.3657 as=0.1792 pd=2.54 ps=1.84
XM0 a_586_94##8 A2_N#4 VGND#10 VNB sky130_fd_pr__nfet_01v8_lvt l=0.15 w=0.64 ad=0.1792 as=0.6665 pd=1.84 ps=3.48
XM9 VGND#10 a_586_94##4 a_162_48##15 VNB sky130_fd_pr__nfet_01v8_lvt l=0.15 w=0.74 ad=0.6665 as=0.1961 pd=3.48 ps=2.01
XM3 a_162_48##14 B2#7 a_1009_74##4 VNB sky130_fd_pr__nfet_01v8_lvt l=0.15 w=0.64 ad=0.1792 as=0.1696 pd=1.84 ps=1.81
XM5 a_1009_74##2 B2#1 a_162_48##14 VNB sky130_fd_pr__nfet_01v8_lvt l=0.15 w=0.64 ad=0.1792 as=0.1792 pd=1.84 ps=1.84
XM10 a_1009_74##2 B1#4 VGND#9 VNB sky130_fd_pr__nfet_01v8_lvt l=0.15 w=0.64 ad=0.1792 as=0.2048 pd=1.84 ps=1.92
XM13 VGND#9 B1#1 a_1009_74# VNB sky130_fd_pr__nfet_01v8_lvt l=0.15 w=0.64 ad=0.2048 as=0.1696 pd=1.92 ps=1.81
XM8 X#3 a_162_48##13 VPWR#13 VPB sky130_fd_pr__pfet_01v8 l=0.15 w=1.12 ad=0.336 as=0.308 pd=2.84 ps=2.79
XM11 X#3 a_162_48##10 VPWR#12 VPB sky130_fd_pr__pfet_01v8 l=0.15 w=1.12 ad=0.336 as=0.336 pd=2.84 ps=2.84
XM16 VPWR#12 a_162_48##9 X#1 VPB sky130_fd_pr__pfet_01v8 l=0.15 w=1.12 ad=0.336 as=0.336 pd=2.84 ps=2.84
XM20 VPWR#11 a_162_48# X#1 VPB sky130_fd_pr__pfet_01v8 l=0.15 w=1.12 ad=0.4368 as=0.336 pd=3.02 ps=2.84
XM14 VPWR#11 A1_N#3 a_583_368# VPB sky130_fd_pr__pfet_01v8 l=0.15 w=1.12 ad=0.4368 as=0.2688 pd=3.02 ps=2.72
XM21 a_583_368# A2_N#3 a_586_94##9 VPB sky130_fd_pr__pfet_01v8 l=0.15 w=1.12 ad=0.2688 as=0.308 pd=2.72 ps=2.79
XM2 a_162_48##19 a_586_94##5 a_820_392##5 VPB sky130_fd_pr__pfet_01v8 l=0.15 w=1 ad=0.3 as=0.275 pd=2.6 ps=2.55
XM12 a_820_392##3 a_586_94# a_162_48##19 VPB sky130_fd_pr__pfet_01v8 l=0.15 w=1 ad=0.3 as=0.3 pd=2.6 ps=2.6
XM4 a_820_392##3 B2#5 VPWR#10 VPB sky130_fd_pr__pfet_01v8 l=0.15 w=1 ad=0.3 as=0.3 pd=2.6 ps=2.6
XM15 VPWR#10 B2#6 a_820_392##6 VPB sky130_fd_pr__pfet_01v8 l=0.15 w=1 ad=0.3 as=0.3 pd=2.6 ps=2.6
XM19 VPWR#9 B1#6 a_820_392##6 VPB sky130_fd_pr__pfet_01v8 l=0.15 w=1 ad=0.3 as=0.3 pd=2.6 ps=2.6
XM6 a_820_392# B1#5 VPWR#9 VPB sky130_fd_pr__pfet_01v8 l=0.15 w=1 ad=0.275 as=0.3 pd=2.55 ps=2.6
*
*
*       RESISTOR AND CAP/DIODE CARDS
*
Rg1	a_162_48#	a_162_48##2	466.617004
Rg2	a_162_48##2	a_162_48##3	77.730652
Rg3	a_162_48##2	a_162_48##4	353.255280
Rg4	a_162_48##3	a_162_48##5	365.574066
Rg5	a_162_48##3	a_162_48##6	57.207211
Rg6	a_162_48##6	a_162_48##7	19.457472
Rg7	a_162_48##7	a_162_48##8	397.487915
Rg8	a_162_48##3	a_162_48##9	460.795288
Rg9	a_162_48##6	a_162_48##10	441.762421
Rg10	a_162_48##7	a_162_48##11	45.035084
Rg11	a_162_48##11	a_162_48##12	364.725555
Rg12	a_162_48##11	a_162_48##13	472.257874
Rg13	A1_N#1	A1_N#2	353.846649
Rg14	A1_N#2	A1_N#3	434.639221
Rg15	A2_N#1	A2_N#2	24.707481
Rg16	A2_N#2	A2_N#3	453.701172
Rg17	A2_N#2	A2_N#4	382.594543
Rg18	a_586_94#	a_586_94##2	582.559692
Rg19	a_586_94##2	a_586_94##3	180.636749
Rg20	a_586_94##2	a_586_94##4	542.819885
Rg21	a_586_94##2	a_586_94##5	388.329102
Rg22	B2#1	B2#2	374.601257
Rg23	B2#2	B2#3	27.643862
Rg24	B2#3	B2#4	25.691841
Rg25	B2#4	B2#5	509.458435
Rg26	B2#2	B2#6	507.445770
Rg27	B2#4	B2#7	379.205444
Rg28	B1#1	B1#2	379.835144
Rg29	B1#2	B1#3	37.504185
Rg30	B1#3	B1#4	374.601257
Rg31	B1#2	B1#5	509.393646
Rg32	B1#3	B1#6	507.445770
Rf1	X#1	X#2	84.013107
Rf2	X#2	X	35.844456
Rf3	X#2	X#3	21.948624
Rf4	X	X#4	28.204580
Rf5	X#4	X#5	18.783115
Rf6	X#4	X#6	80.612747
Rf7	A1_N#4	A1_N#2	162.142822
Rf8	A1_N	A1_N#6	1.910017
Rf9	A1_N#4	A1_N#6	6.567520
Rf10	A2_N#1	A2_N#6	163.228516
Rf11	A2_N#7	A2_N	2.995711
Rf12	A2_N#6	A2_N#7	4.736843
Rf13	a_586_94##3	a_586_94##7	211.361984
Rf14	a_586_94##7	a_586_94##8	122.268021
Rf15	a_586_94##7	a_586_94##9	18.602406
Rf16	a_162_48##14	a_162_48##16	69.968727
Rf17	a_162_48##16	a_162_48##17	18.498857
Rf18	a_162_48##17	a_162_48##3	338.205170
Rf19	a_162_48##17	a_162_48##19	87.388023
Rf20	a_162_48##15	a_162_48##16	7.500000
Rf21	B2#8	B2	2.254818
Rf22	B2#3	B2#10	162.487625
Rf23	B2#8	B2#10	1.271922
Rf24	B2#11	B2	2.254818
Rf25	B2#10	B2#11	10.938530
Rf26	B1#7	B1	2.254818
Rf27	B1#2	B1#9	162.487625
Rf28	B1#7	B1#9	1.271922
Rf29	B1#10	B1	2.254818
Rf30	B1#9	B1#10	10.938530
Rf31	a_820_392#	a_820_392##2	80.666893
Rf32	a_820_392##2	a_820_392##4	85.294769
Rf33	a_820_392##4	a_820_392##5	98.978271
Rf34	a_820_392##2	a_820_392##6	18.602406
Rf35	a_820_392##3	a_820_392##4	5.000000
Rf36	a_1009_74#	a_1009_74##3	86.748932
Rf37	a_1009_74##3	a_1009_74##4	50.043518
Rf38	a_1009_74##2	a_1009_74##3	7.500000
Rf39	VGND#1	VGND#2	27.857231
Rf40	VGND#2	VGND#3	185.500122
Rf41	VGND#3	VGND#4	49.893410
Rf42	VGND#4	VGND#5	73.813812
Rf43	VGND#5	VGND#6	62.889057
Rf44	VGND#6	VGND#7	62.889057
Rf46	VGND#2	VGND#9	46.159966
Rf47	VGND#3	VGND#10	18.990971
Rf48	VGND#5	VGND#11	45.213318
Rf49	VGND#6	VGND#12	42.655182
Rf50	VGND#7	VGND#13	42.655182
Rf51	VPWR#1	VPWR#2	35.527534
Rf52	VPWR#2	VPWR#3	68.798325
Rf53	VPWR#3	VPWR#4	158.917648
Rf54	VPWR#4	VPWR#5	55.838749
Rf55	VPWR#5	VPWR#6	70.912140
Rf56	VPWR#6	VPWR#7	68.798325
Rf58	VPWR#2	VPWR#9	53.143215
Rf59	VPWR#3	VPWR#10	38.736572
Rf60	VPWR#5	VPWR#11	32.551132
Rf61	VPWR#6	VPWR#12	58.622005
Rf62	VPWR#7	VPWR#13	42.573776
Re1	VPWR#1	VPWR	11.068454
Re2	VPWR	VPWR#4	0.790604
Re3	VGND#1	VGND	11.068454
Re4	VGND	VGND#4	0.790604
*
*       CAPACITOR CARDS
*
*
C1	a_820_392##6	a_820_392#	2.36849e-18
C2	VPWR#2	B2#6	5.30308e-19
C3	a_162_48##17	A1_N#1	1.33536e-18
C4	a_820_392##6	VPWR#9	5.20507e-17
C5	VPWR#3	a_586_94##2	2.40862e-20
C6	VGND#2	a_1009_74#	2.84043e-19
C7	VPWR#3	VPWR#2	6.99578e-19
C8	VPWR#3	B2#5	6.45351e-18
C9	a_1009_74#	B1#1	3.07777e-17
C10	VPWR#10	VPWR#9	1.94092e-18
C11	VPWR#2	B2#5	8.1728e-20
C12	a_162_48##2	A1_N#1	4.04256e-19
C13	VGND#9	B1#1	3.08049e-17
C14	VGND#2	VGND#9	9.36994e-18
C15	B2#3	B2#4	1.16108e-17
C16	VPWR#10	a_820_392##6	5.30395e-17
C17	a_820_392##2	B1#5	1.94029e-19
C18	a_1009_74#	B1#4	7.76998e-19
C19	a_586_94##7	a_586_94##2	6.1003e-20
C20	a_162_48##11	a_162_48##2	4.34835e-18
C21	VPWR#3	a_586_94#	5.08238e-18
C22	a_1009_74##2	B1#1	7.2326e-19
C23	VGND#9	B1#4	2.97174e-17
C24	a_820_392##3	a_820_392##6	2.03743e-18
C25	VPWR#6	a_162_48##2	2.17396e-20
C26	a_1009_74#	B2#1	1.81028e-19
C27	a_162_48##17	a_586_94##7	3.71465e-18
C28	a_586_94##7	A2_N#2	1.07185e-17
C29	VGND#2	a_1009_74##2	1.87786e-17
C30	a_820_392##2	B1#6	2.23932e-17
C31	a_1009_74##2	B1#4	3.40382e-17
C32	a_820_392##3	VPWR#10	5.83052e-17
C33	VGND#3	a_162_48##14	1.30753e-17
C34	VPWR#3	a_586_94##5	2.8267e-18
C35	VGND#9	B2#1	1.45581e-18
C36	VPWR#9	B1#3	6.56236e-19
C37	a_162_48##14	B1#4	6.83188e-19
C38	a_1009_74##2	B2#1	3.50287e-17
C39	a_586_94##3	B2#4	2.911e-19
C40	VGND#2	a_162_48##14	1.75923e-17
C41	a_820_392##2	B2#6	1.84552e-17
C42	VGND#9	B2#7	3.00217e-19
C43	a_586_94##3	a_586_94##2	1.5273e-17
C44	VGND#3	a_586_94#	8.03991e-20
C45	a_162_48##14	B2#1	2.58571e-17
C46	A2_N#2	a_586_94##3	2.63392e-17
C47	a_162_48##19	a_820_392##3	6.52591e-17
C48	VPWR#5	a_162_48##2	4.96109e-20
C49	a_162_48##15	B1#4	3.84542e-20
C50	a_1009_74##2	B2#7	1.24471e-19
C51	VGND#9	a_586_94##4	1.75847e-19
C52	VPWR#6	A1_N#3	7.84449e-20
C53	a_820_392##2	B2#5	4.67733e-18
C54	a_162_48##14	B2#7	4.20152e-17
C55	a_820_392##5	a_820_392##3	2.94218e-18
C56	VPWR#5	A1_N#3	4.60491e-18
C57	a_162_48##15	B2#1	6.45817e-20
C58	a_1009_74##2	a_586_94##4	7.49058e-20
C59	VGND#3	a_162_48##15	7.45969e-17
C60	a_1009_74##4	B2#7	4.31103e-17
C61	a_820_392##5	a_162_48##19	6.84042e-17
C62	a_162_48##15	B2#7	6.25961e-19
C63	VPWR#6	a_162_48#	2.84497e-19
C64	a_1009_74##2	a_820_392##2	4.56261e-18
C65	a_820_392##2	a_586_94#	4.34608e-20
C66	a_586_94##9	a_162_48##19	1.49843e-18
C67	a_1009_74##4	a_586_94##4	8.12849e-19
C68	A2_N#1	A2_N#2	1.11638e-17
C69	VPWR#5	a_162_48#	7.8464e-18
C70	VGND#3	VGND#10	1.1131e-17
C71	a_586_94##4	a_162_48##15	1.48035e-17
C72	a_586_94##9	a_820_392##5	3.30946e-17
C73	VPWR#6	a_162_48##9	7.40531e-18
C74	a_586_94##4	VGND#10	2.43235e-17
C75	X#4	a_162_48##8	1.69418e-17
C76	a_162_48##15	A2_N#4	1.9968e-19
C77	a_586_94##8	a_586_94##4	4.98897e-19
C78	VPWR#10	B2#4	8.82291e-19
C79	VPWR#11	a_820_392##5	3.02427e-18
C80	A1_N#2	A2_N#2	3.39353e-17
C81	VGND#11	a_586_94##4	1.51632e-21
C82	VGND#6	X#6	5.68531e-18
C83	X#4	a_162_48##12	9.05426e-18
C84	VPWR#6	a_162_48##10	5.13386e-18
C85	A2_N#4	a_586_94##8	1.56379e-17
C86	VPWR#11	a_586_94##9	2.60139e-17
C87	a_162_48##2	A1_N#2	3.13078e-17
C88	VGND#5	X#6	7.17328e-18
C89	A1_N#1	a_586_94##8	1.73147e-17
C90	VPWR#6	a_162_48##13	5.42375e-19
C91	A1_N#1	VGND#11	2.14379e-17
C92	VGND#6	VGND#5	1.73975e-18
C93	a_162_48##3	A2_N#2	2.88268e-19
C94	VGND#12	VGND#5	6.30072e-19
C95	X#6	A1_N#1	5.07742e-19
C96	a_162_48##3	a_162_48##11	4.26971e-17
C97	a_586_94##7	a_586_94#	2.91888e-20
C98	VGND#11	a_162_48##4	2.84911e-17
C99	X#1	VPWR#11	9.19e-17
C100	VGND#6	a_162_48##11	9.29286e-20
C101	VGND#6	X#5	7.17328e-18
C102	VGND#2	B1#3	6.07583e-20
C103	a_820_392#	VPWR#2	5.31052e-19
C104	a_162_48##3	a_162_48##2	1.8768e-17
C105	X#6	a_162_48##4	1.3661e-17
C106	A1_N#4	a_586_94##7	9.73446e-18
C107	VPWR#12	VPWR#11	2.11423e-18
C108	VGND#11	a_162_48##5	9.61414e-19
C109	a_586_94##7	a_586_94##5	1.58933e-19
C110	VGND#12	a_162_48##4	2.43441e-19
C111	X#1	VPWR#12	6.23583e-17
C112	X#6	a_162_48##5	4.79377e-17
C113	a_162_48##19	B2#4	4.69603e-19
C114	VGND#2	B2#4	1.32691e-19
C115	VGND#11	a_162_48##8	2.60713e-20
C116	VGND#5	VGND#3	5.54552e-19
C117	a_162_48##5	VGND#12	1.42096e-17
C118	VGND#3	a_586_94##2	2.28301e-19
C119	X#3	X#1	1.11023e-18
C120	a_586_94##7	A2_N#3	2.32444e-17
C121	a_820_392##2	VPWR#3	3.13618e-19
C122	X#6	a_162_48##8	1.37094e-18
C123	VGND#5	a_162_48##11	5.63778e-20
C124	a_820_392##6	VPWR#3	8.48902e-18
C125	X#5	a_162_48##5	7.83819e-19
C126	X#3	VPWR#12	6.11996e-17
C127	VPWR#1	VPWR#2	3.5633e-18
C128	VGND#12	a_162_48##8	2.73591e-17
C129	a_162_48##19	a_586_94##2	1.45145e-17
C130	a_820_392##6	VPWR#2	8.43957e-18
C131	X#6	a_162_48##12	3.18174e-19
C132	VGND#3	A2_N#2	1.36751e-19
C133	a_586_94##7	A1_N#3	6.19317e-18
C134	a_162_48##8	X#5	1.22075e-17
C135	VPWR#13	VPWR#12	1.94092e-18
C136	a_820_392##2	VPWR#2	3.13618e-19
C137	VGND#12	a_162_48##12	1.17396e-18
C138	VGND#13	a_162_48##8	2.73108e-19
C139	VPWR#13	X#3	6.23622e-17
C140	X#5	a_162_48##12	3.18297e-17
C141	a_586_94##7	a_162_48#	4.48235e-19
C142	a_162_48##12	VGND#13	1.51063e-17
C143	a_820_392##3	VPWR#3	2.96767e-17
C144	a_820_392##5	a_586_94##2	1.01111e-18
C145	VGND#1	VGND#2	5.27695e-18
C146	VGND#5	a_162_48##2	1.12004e-20
C147	a_162_48##17	a_1009_74##4	2.56582e-17
C148	a_162_48##15	a_586_94#	1.60727e-18
C149	B1#4	B1#1	2.94413e-17
C150	a_820_392#	B1#5	5.28953e-17
C151	A1_N#4	A2_N#2	1.37525e-18
C152	B1#5	VPWR#9	2.43406e-17
C153	a_162_48##17	a_162_48##15	2.47746e-18
C154	a_820_392#	B1#6	2.12167e-18
C155	a_820_392##6	B1#5	1.99344e-18
C156	B2#1	B1#4	3.74856e-17
C157	a_820_392##5	VPWR#3	2.93589e-17
C158	B1#6	VPWR#9	2.63025e-17
C159	VPWR#10	B1#5	1.72497e-19
C160	A2_N#2	a_586_94##9	8.00399e-19
C161	a_586_94#	B2#4	1.10535e-17
C162	a_820_392##2	a_820_392#	6.21728e-19
C163	a_820_392##6	B1#6	4.98339e-17
C164	a_162_48##17	VGND#10	1.11252e-17
C165	X#2	a_162_48##9	5.45335e-19
C166	VPWR#9	B2#6	6.54315e-19
C167	VPWR#10	B1#6	3.71489e-19
C168	B2#7	B2#1	3.6272e-17
C169	a_586_94##2	a_586_94#	8.84961e-19
C170	a_162_48##19	B1#5	4.02826e-19
C171	a_820_392##6	B2#6	4.34351e-17
C172	a_820_392##2	B1#3	7.54565e-19
C173	VPWR#9	B2#5	1.53981e-19
C174	a_820_392##2	VPWR#9	1.89151e-17
C175	B2#6	VPWR#10	1.94818e-17
C176	a_586_94##8	a_162_48##17	5.8776e-17
C177	X#2	a_162_48##10	1.82884e-17
C178	a_1009_74#	B1#3	8.62228e-19
C179	a_162_48##19	B1#6	3.74707e-19
C180	a_820_392##6	B2#5	1.68066e-18
C181	X#4	a_162_48##11	4.79357e-18
C182	a_820_392##3	B2#6	3.96088e-19
C183	a_586_94##4	B2#7	5.79763e-18
C184	VPWR#10	B2#5	3.95853e-17
C185	VPWR#6	VPWR#11	3.04364e-19
C186	X#4	X#2	3.13988e-18
C187	a_162_48##19	B2#6	7.06093e-19
C188	X#2	a_162_48##13	1.07847e-17
C189	a_820_392##6	a_586_94#	1.65565e-19
C190	a_820_392##2	B2#4	1.08288e-18
C191	A1_N#4	a_162_48##2	5.66878e-18
C192	a_820_392##2	a_820_392##6	1.98852e-19
C193	B1#2	a_820_392##2	5.06542e-18
C194	a_820_392##3	B2#5	3.02909e-17
C195	VPWR#10	a_586_94#	1.3398e-18
C196	A2_N#4	a_586_94##4	3.43788e-18
C197	a_162_48##19	B2#5	1.29163e-18
C198	a_820_392##3	a_586_94#	5.31593e-17
C199	X#1	VPWR#6	8.01825e-18
C200	a_586_94##7	VPWR#4	2.02287e-18
C201	VGND#9	B1#3	1.17271e-18
C202	a_820_392##2	VPWR#10	2.44796e-17
C203	VGND#3	a_586_94##3	2.43795e-18
C204	B2#3	a_820_392##2	1.97924e-17
C205	a_162_48##19	a_586_94#	3.07327e-17
C206	X#2	a_162_48##11	6.44832e-18
C207	a_820_392##3	a_586_94##5	2.12e-18
C208	VGND#4	a_162_48##17	2.22486e-17
C209	A1_N#1	A2_N#4	3.70749e-17
C210	a_820_392##5	a_586_94#	1.20571e-17
C211	X#1	VPWR#5	9.18861e-18
C212	a_586_94##5	a_162_48##19	2.80741e-17
C213	a_586_94##9	a_586_94#	1.11196e-19
C214	a_820_392##5	a_586_94##5	7.40617e-17
C215	a_820_392##3	a_820_392##2	5.34827e-19
C216	B2#4	B1#3	3.1392e-17
C217	a_162_48##19	A2_N#3	3.59902e-19
C218	a_162_48##4	A1_N#1	1.44687e-17
C219	A2_N#3	a_586_94##2	9.33631e-20
C220	a_586_94##9	a_586_94##5	3.53878e-18
C221	VPWR#11	a_586_94#	4.22159e-20
C222	VGND#1	a_1009_74#	3.26545e-17
C223	a_820_392##5	A2_N#3	4.27895e-18
C224	a_1009_74##2	B1#3	3.28062e-18
C225	a_586_94##9	A2_N#3	6.25398e-17
C226	VGND#5	A1_N#2	1.52631e-20
C227	a_1009_74#	VGND#9	4.5155e-17
C228	a_162_48##3	VPWR#5	6.35059e-19
C229	VPWR#11	a_586_94##5	3.2436e-19
C230	a_162_48##5	a_162_48##4	3.92718e-17
C231	X#3	VPWR#6	8.44616e-18
C232	a_820_392##5	A1_N#3	2.8102e-19
C233	A2_N	B2#4	4.96909e-19
C234	a_586_94##9	A1_N#3	4.49414e-18
C235	VPWR#11	A2_N#3	9.47922e-18
C236	A2_N	a_586_94##2	7.01487e-19
C237	a_1009_74##2	B2#4	1.747e-18
C238	A2_N	A2_N#2	6.87461e-18
C239	a_1009_74##2	a_1009_74#	2.53314e-18
C240	X#1	A2_N#3	3.91115e-19
C241	X#1	a_162_48##11	3.8762e-19
C242	a_162_48##8	a_162_48##5	3.62278e-17
C243	VGND#5	a_162_48##3	2.73101e-17
C244	a_162_48##17	a_586_94##3	3.23208e-17
C245	VPWR#11	A1_N#3	6.72e-17
C246	a_586_94##7	a_586_94##3	5.37401e-18
C247	X#1	A1_N#3	2.21326e-18
C248	a_1009_74##2	VGND#9	5.45863e-17
C249	a_162_48#	VPWR#11	2.59904e-17
C250	VPWR#12	A1_N#3	1.54753e-19
C251	a_162_48##12	a_162_48##8	3.90965e-17
C252	a_1009_74#	B1#2	1.57805e-17
C253	a_162_48##17	A2_N#1	1.48718e-17
C254	X#1	a_162_48#	6.74964e-17
C255	a_820_392#	VPWR#1	3.88968e-17
C256	VPWR#11	a_162_48##9	1.3767e-18
C257	VPWR#12	a_162_48#	3.42982e-19
C258	a_586_94##7	A2_N#1	4.47893e-17
C259	a_1009_74##2	B1#2	3.9435e-18
C260	a_586_94##7	VPWR#5	7.58752e-19
C261	a_162_48##14	B2#4	5.94022e-19
C262	A1_N#4	a_586_94##8	1.67694e-17
C263	X#1	a_162_48##9	6.64848e-17
C264	X#1	a_162_48##2	2.44022e-18
C265	A1_N	A2_N#2	1.04992e-18
C266	A1_N	a_162_48##11	5.77384e-19
C267	VPWR#12	a_162_48##11	7.7567e-19
C268	VPWR#11	a_162_48##10	2.93039e-19
C269	a_162_48##17	A1_N#2	7.3414e-20
C270	a_162_48##9	VPWR#12	2.42246e-17
C271	A1_N	a_162_48##2	1.42749e-18
C272	a_1009_74##2	a_162_48##14	3.7489e-17
C273	a_1009_74##2	B2#3	1.58548e-17
C274	X#1	a_162_48##10	2.01285e-18
C275	X#3	a_162_48##9	1.81843e-18
C276	a_586_94##7	A1_N#2	3.21828e-18
C277	a_162_48##10	VPWR#12	2.88136e-17
C278	VPWR#13	a_162_48##9	1.72497e-19
C279	a_1009_74##4	B2#3	4.95643e-18
C280	X#3	a_162_48##10	5.58067e-17
C281	a_162_48##3	a_162_48##17	2.79829e-18
C282	VPWR#12	a_162_48##13	6.79311e-19
C283	VPWR#13	a_162_48##10	6.87375e-19
C284	B1	B1#3	2.28175e-17
C285	B1	B2#4	3.30345e-18
C286	X#3	a_162_48##13	4.91005e-17
C287	B1#6	B1#5	4.80495e-17
C288	a_1009_74##4	B2#4	1.33691e-18
C289	A1_N#4	A1_N#2	9.89224e-18
C290	a_162_48##13	VPWR#13	2.52585e-17
C291	a_162_48##14	a_1009_74##4	3.42914e-17
C292	a_162_48##15	a_1009_74##2	4.58887e-19
C293	a_586_94##2	B2#4	1.98562e-18
C294	B1#2	a_820_392#	1.42086e-17
C295	a_820_392##5	VPWR#4	3.34889e-17
C296	B2#6	B1#6	4.65049e-17
C297	a_586_94##9	VPWR#4	1.75281e-17
C298	a_162_48##3	A1_N#4	4.88058e-17
C299	X#4	a_162_48##3	4.59194e-17
C300	a_586_94##8	A2_N#1	1.68389e-17
C301	a_162_48##3	X#2	6.22436e-17
C302	X#4	VGND#12	1.5865e-17
C303	B2#5	B2#6	4.71997e-17
C304	B2	B1#3	1.17968e-17
C305	a_162_48##15	a_1009_74##4	3.04195e-17
C306	B2	B2#4	2.44356e-17
C307	B2	a_586_94##2	9.72099e-19
C308	a_586_94##8	A1_N#2	2.20968e-18
C309	VGND#1	B1#1	1.57283e-18
C310	X#4	X#5	4.59562e-19
C311	a_586_94#	B2#5	4.77161e-17
C312	VGND#3	a_162_48##17	1.17548e-16
C313	a_586_94##7	a_583_368#	2.66014e-18
C314	a_162_48##17	a_820_392##5	5.11127e-18
C315	a_162_48##3	a_586_94##8	7.95348e-17
C316	VGND#2	B1#1	1.04767e-18
C317	a_586_94##3	a_162_48##19	2.13052e-17
C318	a_162_48##3	VGND#11	7.20775e-17
C319	a_586_94##5	a_586_94#	4.24735e-17
C320	a_586_94##7	a_162_48##19	3.93337e-19
C321	a_586_94##3	a_820_392##5	1.33104e-17
C322	a_162_48##3	X#6	7.12201e-17
C323	a_162_48##3	VGND#12	2.53775e-18
C324	VGND#3	B1#4	1.18625e-19
C325	a_162_48##3	X#5	2.29316e-18
C326	A2_N#3	a_586_94##5	3.95273e-18
C327	VGND#2	B1#4	4.9015e-18
C328	X	a_162_48##11	2.01069e-17
C329	X	a_162_48##2	1.88548e-19
C330	VGND#4	A2_N#4	3.38657e-18
C331	A1_N#3	A2_N#3	6.83656e-17
C332	VGND#3	B2#1	1.77365e-19
C333	VGND#4	A1_N#1	1.46535e-18
C334	VPWR#1	B1#5	3.04764e-18
C335	A1_N#2	VPWR#11	3.37078e-18
C336	a_586_94##7	a_586_94##9	3.01837e-18
C337	VGND#2	B2#1	4.92753e-18
C338	a_162_48#	A1_N#3	3.16506e-17
C339	a_1009_74#	a_820_392#	3.85503e-19
C340	a_162_48##3	VPWR#11	4.65045e-18
C341	VGND#3	B2#7	4.7384e-18
C342	a_162_48##3	X#1	4.68178e-17
C343	a_162_48##9	a_162_48#	4.69383e-17
C344	a_162_48##3	VPWR#12	2.37559e-18
C345	a_586_94##8	B2#4	2.43691e-19
C346	a_162_48##3	X#3	2.37261e-18
C347	a_162_48##17	A2_N	2.47844e-17
C348	VGND#2	B2#7	1.65707e-18
C349	VGND#5	a_586_94##4	1.58749e-19
C350	A2_N	a_586_94##7	1.53949e-17
C351	A2_N#2	a_586_94##2	8.40781e-19
C352	a_162_48##10	a_162_48##9	4.87041e-17
C353	B1#2	B1#5	1.69164e-18
C354	VGND#3	a_586_94##4	3.20402e-17
C355	VPWR#11	a_586_94##7	1.95366e-17
C356	VPWR#4	a_586_94##5	1.89058e-18
C357	a_162_48##13	a_162_48##10	4.68894e-17
C358	B1	a_820_392##2	1.94273e-17
C359	a_162_48##3	a_586_94##4	5.31534e-20
C360	A1_N	a_586_94##7	2.23382e-17
C361	VPWR#4	A2_N#3	5.68243e-18
C362	a_162_48##3	A2_N#4	8.87582e-18
C363	B2#3	B2#6	9.88429e-19
C364	a_162_48##3	A1_N#1	3.66021e-17
C365	VGND	B1#3	3.31959e-19
C366	a_162_48##3	a_162_48##4	8.2153e-18
C367	VGND	B2#4	1.32784e-20
C368	X#1	a_586_94##7	4.36821e-18
C369	VGND	a_586_94##2	5.68322e-20
C370	VGND#3	A2_N#4	2.25192e-18
C371	X#6	VGND#11	3.99628e-17
C372	a_162_48##3	a_162_48##5	7.46531e-19
C373	X#2	VPWR#6	2.5317e-19
C374	VGND	a_162_48##11	1.82255e-19
C375	VGND	a_162_48##2	6.95882e-20
C376	a_162_48##3	a_162_48##8	4.94673e-20
C377	B2	a_820_392##2	5.05148e-17
C378	a_586_94##3	a_586_94#	9.18692e-19
C379	a_162_48##3	a_162_48##12	5.98255e-20
C380	a_586_94##8	A2_N#2	4.91409e-18
C381	a_586_94##3	a_586_94##5	5.12426e-18
C382	VGND#5	A1_N#1	1.93108e-18
C383	VGND#12	VGND#11	3.28162e-19
C384	A2_N#3	a_586_94##3	1.79532e-18
C385	a_162_48##17	B2	1.03062e-17
C386	A2_N#1	A2_N#3	1.4609e-18
C387	a_1009_74#	B1	2.90501e-17
C388	VGND#6	a_162_48##4	8.69363e-19
C389	a_1009_74##2	B1	1.90815e-17
C390	X#6	VGND#12	4.26648e-17
C391	VPWR#1	B1#2	3.8632e-19
C392	VGND#5	a_162_48##4	8.2729e-18
C393	VPWR	VPWR#6	6.17298e-17
C394	B1#3	VNB	8.06907e-17
C395	VPWR	VPWR#5	6.00948e-17
C396	B2#4	VNB	6.9312e-17
C397	a_162_48#	A1_N#2	7.36361e-19
C398	VPWR	VPWR#3	1.06943e-16
C399	a_586_94##2	VNB	3.00319e-17
C400	VPWR	VPWR#2	4.98936e-17
C401	VGND#1	B1#2	4.52909e-19
C402	A2_N#2	VNB	4.89943e-17
C403	a_162_48##11	VNB	1.01239e-16
C404	a_586_94##4	B2#4	2.32389e-18
C405	a_162_48##2	VNB	2.65509e-17
C406	a_1009_74##2	B2	2.89258e-17
C407	X#5	X#6	2.69093e-18
C408	VGND#3	a_162_48##4	2.70247e-19
C409	B1	a_820_392#	3.1825e-17
C410	a_1009_74##4	B2	1.40316e-17
C411	A1_N	VPWR#11	3.24413e-17
C412	VGND#6	a_162_48##5	5.83518e-18
C413	VPWR	a_820_392##2	3.67751e-18
C414	a_162_48##17	B1#1	1.34276e-19
C415	X#4	X	6.00412e-19
C416	a_586_94##3	VPWR#4	2.30732e-18
C417	A2_N	a_586_94##4	9.06416e-19
C418	A2_N#3	a_583_368#	2.47363e-17
C419	VGND#5	a_162_48##5	1.25165e-18
C420	X#5	VGND#12	3.60545e-17
C421	A1_N#3	a_583_368#	1.97507e-17
C422	VPWR	a_586_94##7	8.17846e-18
C423	a_162_48##17	B1#3	7.47913e-19
C424	VGND	VGND#6	6.61584e-17
C425	VGND	VGND#5	7.1601e-17
C426	VGND	VGND#3	1.58059e-16
C427	a_162_48##19	B2	7.27852e-18
C428	VGND	VGND#2	7.38259e-17
C429	a_1009_74##4	a_820_392##3	1.12729e-17
C430	A2_N#2	a_586_94##4	1.63466e-18
C431	a_162_48##17	B1#4	1.20826e-19
C432	X	VGND#13	3.717e-17
C433	VPWR	X#2	1.82758e-18
C434	VGND#6	a_162_48##8	5.6048e-18
C435	VGND#4	a_162_48##3	2.68952e-17
C436	VGND#13	VGND#12	9.84487e-19
C437	VGND#6	X#4	3.16169e-19
C438	VGND	a_162_48##17	1.7762e-17
C439	VPWR#6	VPWR#5	7.34848e-19
C440	a_162_48##15	a_820_392##3	1.95577e-18
C441	VGND#5	a_162_48##8	2.77033e-19
C442	a_162_48##17	B2#4	7.86087e-18
C443	VPWR#6	VNB	2.63612e-17
C444	VPWR#5	VNB	2.97649e-17
C445	VPWR#3	VNB	4.68591e-17
C446	VPWR#2	VNB	2.16981e-17
C447	B2	a_586_94##4	1.09846e-18
C448	VPWR	a_820_392#	1.38157e-18
C449	VGND	A1_N#4	2.30415e-18
C450	VGND#13	X#5	3.60545e-17
C451	VGND#6	VNB	2.69998e-17
C452	VGND	X#4	1.68445e-18
C453	VGND#5	VNB	3.14234e-17
C454	VPWR#4	a_586_94##2	6.83737e-21
C455	VGND	X#2	4.18922e-18
C456	VGND#3	VNB	6.65808e-17
C457	VPWR	a_820_392##6	1.72175e-17
C458	VGND#2	VNB	4.2286e-17
C459	VGND	a_1009_74#	7.21946e-19
C460	X	VPWR#13	3.35545e-17
C461	B1	B1#5	6.29702e-19
C462	a_162_48##17	B2#1	1.92271e-19
C463	VGND	VGND#9	1.64421e-17
C464	a_162_48##3	A1_N#2	7.59094e-18
C465	VPWR	a_820_392##3	1.86787e-17
C466	VGND	a_1009_74##2	1.90583e-17
C467	B1	B1#6	1.66772e-18
C468	a_820_392##2	VNB	4.48525e-18
C469	VGND	a_162_48##14	1.87997e-17
C470	VPWR	a_162_48##19	7.95929e-18
C471	A1_N	A2_N#3	4.50034e-19
C472	VGND	a_1009_74##4	8.10345e-18
C473	B1	B2#6	3.89109e-19
C474	VPWR	a_820_392##5	3.12515e-17
C475	VPWR#4	A2_N#2	8.87084e-20
C476	VGND	a_162_48##15	2.19889e-17
C477	VPWR	a_586_94##9	1.75892e-17
C478	A1_N	A1_N#3	3.62898e-18
C479	VGND#6	a_162_48##12	1.26726e-18
C480	VGND	a_586_94##8	8.13894e-18
C481	VPWR	VPWR#11	2.37074e-17
C482	A1_N	a_162_48#	1.94053e-18
C483	VGND	X#6	1.50718e-17
C484	VPWR	X#1	1.85079e-17
C485	B2	B1#5	4.90683e-19
C486	a_162_48##17	VNB	1.92652e-17
C487	A1_N	a_162_48##9	6.77691e-19
C488	VGND	X#5	1.44433e-17
C489	B2	B1#6	1.60837e-18
C490	VPWR	X#3	1.7612e-17
C491	a_586_94##7	VNB	6.00364e-18
C492	X	a_162_48##4	8.60419e-20
C493	A1_N	a_162_48##10	3.92236e-19
C494	X#6	a_162_48##11	3.26923e-18
C495	B2	B2#6	1.16276e-18
C496	X	a_162_48##5	7.60739e-20
C497	X	a_162_48##8	2.95854e-19
C498	B2	B2#5	1.79896e-18
C499	A1_N	a_162_48##13	3.01405e-19
C500	X	a_162_48##12	1.68237e-17
C501	X#2	X#1	1.87999e-18
C502	B2	a_586_94#	2.79439e-18
C503	A1_N#4	VNB	1.46249e-18
C504	X#4	VNB	4.55553e-19
C505	a_162_48##3	a_583_368#	5.75945e-20
C506	X#2	VNB	3.08069e-18
C507	a_1009_74#	VNB	4.47098e-17
C508	a_162_48##2	VGND#11	1.09121e-18
C509	VGND#9	VNB	3.51696e-18
C510	VPWR#3	B1#5	2.40895e-19
C511	a_1009_74##2	VNB	7.31729e-18
C512	a_162_48##14	VNB	3.11042e-18
C513	a_1009_74##4	VNB	8.32067e-18
C514	a_162_48##17	B2#7	1.13146e-18
C515	VGND	X#1	3.0292e-18
C516	a_162_48##15	VNB	8.90075e-18
C517	a_586_94##8	VNB	3.68908e-18
C518	VGND#11	VNB	4.81351e-20
C519	VPWR#1	B1	2.82031e-18
C520	X#6	VNB	2.49512e-18
C521	VGND#12	VNB	1.96017e-19
C522	VGND	B1#1	3.05638e-20
C523	X#5	VNB	4.49103e-18
C524	VGND	B1#4	1.5965e-18
C525	VGND#1	B1	3.15616e-18
C526	A2_N	a_586_94##3	3.36367e-17
C527	VGND#13	VNB	2.27464e-17
C528	VGND	B2#1	1.41347e-18
C529	a_820_392#	VNB	5.27949e-17
C530	VPWR	B1#5	2.37339e-20
C531	VPWR#9	VNB	2.82484e-18
C532	VGND	B2#7	5.04427e-19
C533	X	A1_N#3	1.9175e-19
C534	VPWR#2	B1#5	6.84293e-18
C535	VPWR	B1#6	7.48501e-19
C536	a_820_392##6	VNB	2.1429e-18
C537	VGND	a_586_94##4	8.48234e-19
C538	VPWR#10	VNB	4.09278e-19
C539	X	a_162_48#	3.20426e-19
C540	VPWR	B2#6	7.05835e-19
C541	VGND	A2_N#4	1.52901e-20
C542	a_820_392##3	VNB	7.71945e-18
C543	VGND	A1_N#1	1.68109e-21
C544	VPWR	B2#5	2.48934e-18
C545	X	a_162_48##9	5.64388e-19
C546	a_820_392##5	VNB	1.45451e-17
C547	VGND	a_162_48##4	7.93597e-20
C548	VPWR	a_586_94#	1.41036e-18
C549	a_586_94##9	VNB	1.1781e-17
C550	X	a_162_48##10	9.86403e-19
C551	VGND	a_162_48##5	3.03099e-19
C552	VPWR	a_586_94##5	1.46421e-18
C553	VPWR#11	VNB	1.60934e-18
C554	VGND	a_162_48##8	6.3997e-19
C555	X	a_162_48##13	1.45137e-17
C556	X#2	VPWR#12	1.88194e-17
C557	X#1	VNB	2.60936e-18
C558	VPWR	A2_N#3	3.55176e-19
C559	VGND	a_162_48##12	9.2764e-19
C560	a_162_48##17	a_586_94##2	5.48366e-18
C561	VPWR#12	VNB	2.92383e-18
C562	A1_N	A1_N#2	5.84486e-18
C563	VPWR	A1_N#3	2.46595e-18
C564	X#3	VNB	3.08215e-18
C565	VPWR#13	VNB	4.11757e-17
C566	VPWR	a_162_48#	2.01627e-18
C567	B1#1	VNB	2.91369e-17
C568	a_162_48##3	A1_N	1.14166e-17
C569	B1#4	VNB	2.7631e-17
C570	VPWR	a_162_48##9	2.70076e-19
C571	B2#1	VNB	2.62186e-17
C572	VPWR	a_162_48##10	8.42828e-19
C573	B2#7	VNB	3.21377e-17
C574	a_586_94##4	VNB	4.28727e-17
C575	VGND	a_586_94#	1.19647e-21
C576	VPWR	a_162_48##13	8.22323e-19
C577	A2_N#4	VNB	3.35737e-17
C578	A1_N#1	VNB	3.02753e-17
C579	a_162_48##4	VNB	3.15383e-17
C580	a_162_48##17	a_586_94##4	2.74321e-17
C581	a_162_48##5	VNB	2.60641e-17
C582	a_162_48##8	VNB	2.47276e-17
C583	a_162_48##12	VNB	3.70449e-17
C584	VPWR	VPWR#4	7.93495e-17
C585	VPWR#3	B1#6	5.45681e-19
C586	B1#5	VNB	4.74507e-17
C587	B1#6	VNB	3.6187e-17
C588	B2#6	VNB	3.35348e-17
C589	VPWR	B1#2	1.01455e-18
C590	VGND#4	A2_N#2	3.8557e-20
C591	B2#5	VNB	3.29936e-17
C592	X	A1_N#2	3.77136e-19
C593	a_586_94#	VNB	4.72899e-17
C594	VPWR	B2#3	1.536e-18
C595	a_586_94##5	VNB	3.95805e-17
C596	X	a_162_48##3	3.132e-17
C597	VPWR	a_586_94##3	6.46736e-18
C598	A2_N#3	VNB	3.13809e-17
C599	A1_N#3	VNB	2.8475e-17
C600	VPWR	A2_N#1	1.65087e-18
C601	a_162_48#	VNB	3.82808e-17
C602	VGND	VGND#4	3.49638e-17
C603	a_162_48##9	VNB	3.50314e-17
C604	VGND	B1#2	1.14085e-18
C605	X#2	X#3	2.08835e-19
C606	a_162_48##10	VNB	3.34372e-17
C607	VPWR	a_162_48##3	1.06324e-17
C608	a_162_48##13	VNB	4.33215e-17
C609	VGND	B2#3	1.70166e-18
C610	VPWR#2	B1#6	5.26078e-18
C611	VGND	a_586_94##3	4.2757e-18
C612	VGND#12	a_162_48##11	7.93094e-19
C613	VPWR#1	VNB	8.98794e-17
C614	VGND	A2_N#1	1.36882e-18
C615	VGND#1	VNB	8.83732e-17
C616	a_162_48##17	A2_N#2	5.45979e-18
C617	VPWR#4	VNB	4.57982e-17
C618	VPWR#6	a_162_48##11	5.67848e-20
C619	VGND#4	VNB	2.13563e-17
C620	VGND	a_162_48##3	3.34647e-17
C621	B1#2	VNB	1.49195e-18
C622	B2#3	VNB	3.23772e-18
C623	a_820_392#	VPWR#9	5.24309e-17
C624	a_586_94##3	VNB	5.90165e-17
C625	A2_N#1	VNB	3.25275e-18
C626	B2	B1	3.48449e-17
C627	A1_N#2	VNB	3.21742e-17
C628	X#6	a_162_48##2	3.57767e-19
C629	a_162_48##3	VNB	1.12528e-17
C630	VPWR	A2_N	1.65021e-18
C631	VPWR	A1_N	3.29731e-18
C632	a_162_48##17	A2_N#4	2.19173e-17
C633	VGND	A2_N	1.4026e-18
C634	VPWR	B1	1.5694e-18
C635	VPWR	B2	3.61978e-18
C636	VGND	B1	1.68112e-18
C637	A2_N	VNB	1.9184e-18
C638	VPWR	X	1.25095e-17
C639	VGND	B2	4.73732e-18
C640	A1_N	VNB	1.923e-18
C641	B1	VNB	2.94774e-17
C642	VGND	X	1.3287e-17
C643	X	VNB	7.58656e-17
C644	VPWR	VNB	3.01243e-16
C645	B1#2	B1#3	1.25409e-17
C646	VGND	VNB	3.07243e-16
C647	VPWR#3	B2#6	5.36613e-18
C648	VPWR#7	a_162_48##10	5.45681e-19
C649	VPWR#7	a_162_48##13	5.9433e-18
C650	VGND#7	VNB	4.91227e-17
C651	VPWR#7	VPWR#6	7.0017e-19
C652	VGND#7	X	5.18262e-18
C653	X#3	VPWR#7	8.49566e-18
C654	VGND#7	a_162_48##8	9.42249e-19
C655	VPWR#7	a_162_48##11	4.57114e-20
C656	VGND#7	VGND#6	1.73976e-18
C657	VGND#7	X#5	5.37938e-18
C658	X#2	VPWR#7	1.1274e-19
C659	X	VPWR#7	2.5075e-18
C660	VPWR	VPWR#7	9.43444e-17
C661	VGND#7	a_162_48##12	7.56716e-18
C662	VPWR#7	VNB	4.9943e-17
C663	VGND#7	a_162_48##11	2.32122e-20
C664	VGND	VGND#7	8.90828e-17
C665	VPWR#7	a_162_48##9	8.74044e-20
*
*
.ENDS sky130_fd_sc_hs__a2bb2o_4
*
