* Extracted by Quantus, converted by sky130cad/quantus.py
*
*
*
*                       LINUX           Wed Nov 18 08:15:49 2026
*
*
*
*  PROGRAM  advgen
*
*  Name           : advgen - Quantus - (64-bit)
*  Version        : 25.1.0-p047
*  Build Date     : Thu Dec 11 23:20:30 PST 2025
*
*  HSPICE LIBRARY
*
*  OPERATING_TEMPERATURE 150
*  QRC_TECH_DIR <path>/tech
*
*
*

*
.SUBCKT sky130_fd_sc_hs__a41oi_4 VPB VNB VGND VPWR Y A2 B1 A1 A3 A4
*
*
*  caps2d version: 10
*
*
*       TRANSISTOR CARDS
*
*
XM30 Y#4 B1#7 VGND#6 VNB sky130_fd_pr__nfet_01v8_lvt l=0.15 w=0.74 ad=0.259 as=0.2109 pd=2.18 ps=2.05
XM36 VGND#9 B1#5 Y#4 VNB sky130_fd_pr__nfet_01v8_lvt l=0.15 w=0.74 ad=0.2109 as=0.259 pd=2.05 ps=2.18
XM27 a_325_74##6 A1#8 Y#7 VNB sky130_fd_pr__nfet_01v8_lvt l=0.15 w=0.74 ad=0.2109 as=0.259 pd=2.05 ps=2.18
XM5 a_325_74##8 A1#13 Y#7 VNB sky130_fd_pr__nfet_01v8_lvt l=0.15 w=0.74 ad=0.4588 as=0.259 pd=2.72 ps=2.18
XM15 Y#1 A1#11 a_325_74##8 VNB sky130_fd_pr__nfet_01v8_lvt l=0.15 w=0.74 ad=0.2072 as=0.4588 pd=2.04 ps=2.72
XM13 Y#1 A1#9 a_325_74##7 VNB sky130_fd_pr__nfet_01v8_lvt l=0.15 w=0.74 ad=0.2072 as=0.259 pd=2.04 ps=2.18
XM6 a_325_74##7 A2#8 a_852_74##5 VNB sky130_fd_pr__nfet_01v8_lvt l=0.15 w=0.74 ad=0.259 as=0.259 pd=2.18 ps=2.18
XM8 a_325_74##2 A2#13 a_852_74##5 VNB sky130_fd_pr__nfet_01v8_lvt l=0.15 w=0.74 ad=0.2072 as=0.259 pd=2.04 ps=2.18
XM7 a_852_74##3 A2#11 a_325_74##2 VNB sky130_fd_pr__nfet_01v8_lvt l=0.15 w=0.74 ad=0.2072 as=0.2072 pd=2.04 ps=2.04
XM33 a_852_74##3 A2#9 a_325_74# VNB sky130_fd_pr__nfet_01v8_lvt l=0.15 w=0.74 ad=0.2072 as=0.2109 pd=2.04 ps=2.05
XM4 a_1235_74##7 A3#12 a_852_74# VNB sky130_fd_pr__nfet_01v8_lvt l=0.15 w=0.74 ad=0.2109 as=0.2072 pd=2.05 ps=2.04
XM14 a_852_74# A3#9 a_1235_74##5 VNB sky130_fd_pr__nfet_01v8_lvt l=0.15 w=0.74 ad=0.2072 as=0.2072 pd=2.04 ps=2.04
XM32 a_852_74##6 A3#7 a_1235_74##5 VNB sky130_fd_pr__nfet_01v8_lvt l=0.15 w=0.74 ad=0.2072 as=0.2072 pd=2.04 ps=2.04
XM37 a_1235_74##3 A3#1 a_852_74##6 VNB sky130_fd_pr__nfet_01v8_lvt l=0.15 w=0.74 ad=0.2072 as=0.2072 pd=2.04 ps=2.04
XM34 VGND#8 A4#10 a_1235_74##3 VNB sky130_fd_pr__nfet_01v8_lvt l=0.15 w=0.74 ad=0.2072 as=0.2072 pd=2.04 ps=2.04
XM16 a_1235_74##8 A4#7 VGND#8 VNB sky130_fd_pr__nfet_01v8_lvt l=0.15 w=0.74 ad=0.2072 as=0.2072 pd=2.04 ps=2.04
XM21 VGND#7 A4#5 a_1235_74##8 VNB sky130_fd_pr__nfet_01v8_lvt l=0.15 w=0.74 ad=0.2368 as=0.2072 pd=2.12 ps=2.04
XM10 a_1235_74# A4#1 VGND#7 VNB sky130_fd_pr__nfet_01v8_lvt l=0.15 w=0.74 ad=0.2109 as=0.2368 pd=2.05 ps=2.12
XM24 a_27_368##13 B1#9 Y#6 VPB sky130_fd_pr__pfet_01v8 l=0.15 w=1.12 ad=0.336 as=0.3864 pd=2.84 ps=2.93
XM3 Y#6 B1#8 a_27_368##20 VPB sky130_fd_pr__pfet_01v8 l=0.15 w=1.12 ad=0.3864 as=0.392 pd=2.93 ps=2.94
XM12 Y#8 B1#4 a_27_368##20 VPB sky130_fd_pr__pfet_01v8 l=0.15 w=1.12 ad=0.336 as=0.392 pd=2.84 ps=2.94
XM31 a_27_368##10 B1#1 Y#8 VPB sky130_fd_pr__pfet_01v8 l=0.15 w=1.12 ad=0.336 as=0.336 pd=2.84 ps=2.84
XM28 a_27_368##10 A1#14 VPWR#19 VPB sky130_fd_pr__pfet_01v8 l=0.15 w=1.12 ad=0.336 as=0.448 pd=2.84 ps=3.04
XM0 a_27_368##19 A1#12 VPWR#19 VPB sky130_fd_pr__pfet_01v8 l=0.15 w=1.12 ad=0.336 as=0.448 pd=2.84 ps=3.04
XM2 VPWR#18 A1#10 a_27_368##19 VPB sky130_fd_pr__pfet_01v8 l=0.15 w=1.12 ad=0.3976 as=0.336 pd=2.95 ps=2.84
XM19 VPWR#18 A1#1 a_27_368##7 VPB sky130_fd_pr__pfet_01v8 l=0.15 w=1.12 ad=0.3976 as=0.336 pd=2.95 ps=2.84
XM17 VPWR#17 A2#14 a_27_368##7 VPB sky130_fd_pr__pfet_01v8 l=0.15 w=1.12 ad=0.4032 as=0.336 pd=2.96 ps=2.84
XM22 a_27_368##18 A2#12 VPWR#17 VPB sky130_fd_pr__pfet_01v8 l=0.15 w=1.12 ad=0.336 as=0.4032 pd=2.84 ps=2.96
XM25 a_27_368##18 A2#10 VPWR#16 VPB sky130_fd_pr__pfet_01v8 l=0.15 w=1.12 ad=0.336 as=0.392 pd=2.84 ps=2.94
XM29 VPWR#16 A2#1 a_27_368##17 VPB sky130_fd_pr__pfet_01v8 l=0.15 w=1.12 ad=0.392 as=0.336 pd=2.94 ps=2.84
XM1 a_27_368##17 A3#14 VPWR#15 VPB sky130_fd_pr__pfet_01v8 l=0.15 w=1.12 ad=0.336 as=0.392 pd=2.84 ps=2.94
XM20 VPWR#15 A3#13 a_27_368##16 VPB sky130_fd_pr__pfet_01v8 l=0.15 w=1.12 ad=0.392 as=0.336 pd=2.94 ps=2.84
XM9 VPWR#14 A3#8 a_27_368##16 VPB sky130_fd_pr__pfet_01v8 l=0.15 w=1.12 ad=0.392 as=0.336 pd=2.94 ps=2.84
XM11 a_27_368##15 A3#6 VPWR#14 VPB sky130_fd_pr__pfet_01v8 l=0.15 w=1.12 ad=0.392 as=0.392 pd=2.94 ps=2.94
XM23 a_27_368##15 A4#12 VPWR#13 VPB sky130_fd_pr__pfet_01v8 l=0.15 w=1.12 ad=0.392 as=0.336 pd=2.94 ps=2.84
XM18 a_27_368##14 A4#11 VPWR#13 VPB sky130_fd_pr__pfet_01v8 l=0.15 w=1.12 ad=0.336 as=0.336 pd=2.84 ps=2.84
XM35 VPWR#12 A4#8 a_27_368##14 VPB sky130_fd_pr__pfet_01v8 l=0.15 w=1.12 ad=0.336 as=0.336 pd=2.84 ps=2.84
XM26 VPWR#12 A4#4 a_27_368# VPB sky130_fd_pr__pfet_01v8 l=0.15 w=1.12 ad=0.336 as=0.3304 pd=2.84 ps=2.83
*
*
*       RESISTOR AND CAP/DIODE CARDS
*
Rg1	B1#1	B1#2	618.056702
Rg2	B1#2	B1#3	94.120613
Rg3	B1#2	B1#4	402.034393
Rg4	B1#3	B1#5	371.694611
Rg5	B1#3	B1#6	56.823479
Rg6	B1#6	B1#7	402.532135
Rg7	B1#3	B1#8	399.026428
Rg8	B1#6	B1#9	439.086304
Rg9	A1#1	A1#2	492.863586
Rg10	A1#2	A1#3	30.900740
Rg11	A1#3	A1#4	15.163222
Rg12	A1#4	A1#5	47.047989
Rg13	A1#5	A1#6	36.227226
Rg14	A1#6	A1#7	7.088342
Rg15	A1#7	A1#8	439.358795
Rg16	A1#2	A1#9	291.046783
Rg17	A1#3	A1#10	398.737762
Rg18	A1#4	A1#11	297.373779
Rg19	A1#5	A1#12	418.716034
Rg20	A1#6	A1#13	350.295746
Rg21	A1#7	A1#14	429.606842
Rg22	A2#1	A2#2	558.155945
Rg23	A2#2	A2#3	29.852238
Rg24	A2#3	A2#4	24.688400
Rg25	A2#4	A2#5	20.244377
Rg26	A2#5	A2#6	31.503216
Rg27	A2#6	A2#7	44.172962
Rg28	A2#7	A2#8	354.274017
Rg29	A2#2	A2#9	288.331329
Rg30	A2#3	A2#10	437.779877
Rg31	A2#4	A2#11	292.367340
Rg32	A2#5	A2#12	443.717072
Rg33	A2#6	A2#13	292.367340
Rg34	A2#7	A2#14	433.684113
Rg35	A3#1	A3#2	420.745697
Rg36	A3#2	A3#3	57.050041
Rg37	A3#3	A3#4	27.519188
Rg38	A3#4	A3#5	34.566891
Rg39	A3#2	A3#6	419.554810
Rg40	A3#3	A3#7	370.752045
Rg41	A3#4	A3#8	419.554810
Rg42	A3#5	A3#9	377.027313
Rg43	A3#5	A3#10	41.869064
Rg44	A3#10	A3#11	39.331528
Rg45	A3#11	A3#12	370.752045
Rg46	A3#10	A3#13	419.554810
Rg47	A3#11	A3#14	472.520630
Rg48	A4#1	A4#2	397.555725
Rg49	A4#2	A4#3	94.103195
Rg50	A4#2	A4#4	449.655212
Rg51	A4#3	A4#5	378.670319
Rg52	A4#3	A4#6	52.506939
Rg53	A4#6	A4#7	394.561310
Rg54	A4#3	A4#8	429.126801
Rg55	A4#6	A4#9	66.386436
Rg56	A4#9	A4#10	402.159912
Rg57	A4#6	A4#11	446.660797
Rg58	A4#9	A4#12	451.667847
Rf1	B1	B1#10	8.404075
Rf2	B1#10	B1	6.264856
Rf3	A1#15	A1	0.997598
Rf4	A1#5	A1#17	54.408531
Rf5	A1#15	A1#17	4.584041
Rf6	A1#18	A1	0.997598
Rf7	A1#17	A1#18	10.084890
Rf8	Y#1	Y	73.652939
Rf9	Y	Y#2	131.150223
Rf10	Y#2	Y#3	29.073498
Rf11	Y#3	Y#4	106.248886
Rf12	Y#2	Y#5	11.345737
Rf13	Y#5	Y#6	82.775909
Rf14	Y#3	Y#7	44.294075
Rf15	Y#5	Y#8	21.951496
Rf16	A2#5	A2	60.093704
Rf17	a_325_74#	a_325_74##3	45.753876
Rf18	a_325_74##3	a_325_74##4	34.271812
Rf19	a_325_74##4	a_325_74##5	78.726372
Rf20	a_325_74##5	a_325_74##6	101.158585
Rf21	a_325_74##4	a_325_74##7	12.937569
Rf22	a_325_74##5	a_325_74##8	11.629504
Rf23	a_325_74##2	a_325_74##3	15.000000
Rf24	a_852_74##2	a_852_74##4	54.335655
Rf25	a_852_74##4	a_852_74##5	47.907509
Rf26	a_852_74##2	a_852_74##6	47.572567
Rf27	a_852_74#	a_852_74##2	15.000000
Rf28	a_852_74##3	a_852_74##4	15.000000
Rf29	A3	A3#15	1.986418
Rf30	A3#15	A3	12.682514
Rf31	A4	A4#13	12.224110
Rf32	A4#13	A4	2.444822
Rf33	a_27_368#	a_27_368##2	79.092201
Rf34	a_27_368##2	a_27_368##3	69.348907
Rf35	a_27_368##3	a_27_368##4	69.348907
Rf36	a_27_368##4	a_27_368##5	69.348907
Rf37	a_27_368##5	a_27_368##6	69.240715
Rf38	a_27_368##6	a_27_368##8	79.081322
Rf39	a_27_368##8	a_27_368##9	60.951988
Rf40	a_27_368##9	a_27_368##11	75.145317
Rf41	a_27_368##11	a_27_368##12	74.289032
Rf42	a_27_368##12	a_27_368##13	93.727028
Rf43	a_27_368##2	a_27_368##14	17.027714
Rf44	a_27_368##3	a_27_368##15	17.027714
Rf45	a_27_368##4	a_27_368##16	17.027714
Rf46	a_27_368##5	a_27_368##17	17.027714
Rf47	a_27_368##6	a_27_368##18	16.043533
Rf48	a_27_368##9	a_27_368##19	12.835279
Rf49	a_27_368##12	a_27_368##20	19.134041
Rf50	a_27_368##7	a_27_368##8	5.000000
Rf51	a_27_368##10	a_27_368##11	7.500000
Rf52	a_1235_74#	a_1235_74##2	88.788757
Rf53	a_1235_74##2	a_1235_74##4	84.090828
Rf54	a_1235_74##4	a_1235_74##6	58.010189
Rf55	a_1235_74##6	a_1235_74##7	58.498375
Rf56	a_1235_74##2	a_1235_74##8	28.306047
Rf57	a_1235_74##3	a_1235_74##4	7.500000
Rf58	a_1235_74##5	a_1235_74##6	15.000000
Rf60	VGND#2	VGND#3	69.629120
Rf61	VGND#3	VGND#4	368.868500
Rf62	VGND#4	VGND#5	157.034042
Rf63	VGND#5	VGND#6	111.912102
Rf64	VGND#2	VGND#7	38.247387
Rf65	VGND#3	VGND#8	41.745289
Rf66	VGND#5	VGND#9	38.247387
Rf68	VPWR#2	VPWR#3	70.080414
Rf69	VPWR#3	VPWR#4	67.750626
Rf70	VPWR#4	VPWR#5	69.463600
Rf71	VPWR#5	VPWR#6	69.463600
Rf72	VPWR#6	VPWR#7	70.194107
Rf73	VPWR#7	VPWR#8	69.828857
Rf74	VPWR#8	VPWR#9	22.678469
Rf75	VPWR#9	VPWR#10	49.649803
Rf77	VPWR#2	VPWR#12	53.143215
Rf78	VPWR#3	VPWR#13	43.353802
Rf79	VPWR#4	VPWR#14	38.736572
Rf80	VPWR#5	VPWR#15	38.736572
Rf81	VPWR#6	VPWR#16	38.736572
Rf82	VPWR#7	VPWR#17	38.992386
Rf83	VPWR#8	VPWR#18	38.050537
Rf84	VPWR#10	VPWR#19	35.098007
Rf88	A3#5	A3#15	32.046562
Rf89	A4#3	A4#13	40.058201
Rf85	B1#3	B1#10	53.410934
Re1	VPWR#3	VPWR	2.687498
Re2	VPWR	VPWR#9	1.343749
Re3	VGND#3	VGND	2.687498
Re4	VGND	VGND#4	1.343749
*
*       CAPACITOR CARDS
*
*
C1	a_325_74##6	Y#7	3.83332e-17
C2	Y#5	VPWR#19	1.8251e-18
C3	A4#7	A4#5	4.09562e-17
C4	a_27_368##9	A1#14	5.24626e-19
C5	a_1235_74##2	A3#1	3.90164e-20
C6	Y#1	A2#7	2.1565e-18
C7	a_27_368##12	B1#1	1.16275e-20
C8	a_27_368#	A4#4	5.58015e-17
C9	Y#5	a_27_368##10	5.64234e-17
C10	VGND#5	Y#4	1.77653e-17
C11	A1#5	A2#7	2.49276e-17
C12	VGND#9	a_325_74##6	4.07081e-17
C13	A4#4	VPWR#12	2.70995e-17
C14	VPWR#5	VPWR#4	7.4289e-19
C15	Y#4	Y#7	1.61611e-18
C16	a_27_368##7	A2#7	9.04038e-19
C17	A4#10	A4#7	3.97309e-17
C18	Y#3	A1#7	1.41979e-17
C19	a_27_368#	A4#8	2.12167e-18
C20	a_27_368##14	A4#4	2.17823e-18
C21	a_27_368##5	A3#11	1.16871e-18
C22	Y#5	Y#8	9.57512e-19
C23	a_27_368##12	B1#4	2.1302e-17
C24	A4#8	VPWR#12	2.89893e-17
C25	VPWR#13	A4#4	2.70458e-19
C26	VGND#6	VGND#5	9.88991e-19
C27	Y#5	A1#10	1.43953e-19
C28	A3#1	A4#10	4.09007e-17
C29	a_27_368##3	A4#9	5.77907e-19
C30	a_27_368##14	A4#8	5.30137e-17
C31	VPWR#12	A4#11	6.54315e-19
C32	VPWR#13	A4#8	3.71489e-19
C33	Y#4	VGND#9	6.63367e-17
C34	Y#5	a_27_368##20	1.69337e-17
C35	a_27_368##5	a_27_368##4	2.75876e-20
C36	a_27_368##12	B1#8	1.59674e-17
C37	a_27_368##14	A4#11	4.65287e-17
C38	Y#5	A1#12	6.66483e-18
C39	A3#7	A3#1	4.06232e-17
C40	VPWR#12	A4#12	1.53981e-19
C41	A4#11	VPWR#13	2.21054e-17
C42	VGND#6	VGND#9	1.28331e-18
C43	a_27_368##4	A3#11	1.38457e-18
C44	A2#8	A2#7	1.74931e-19
C45	a_27_368##14	A4#12	1.77915e-18
C46	a_27_368##15	A4#11	4.4138e-19
C47	a_1235_74#	A4#2	1.00823e-19
C48	VPWR#3	VPWR#5	1.8027e-17
C49	VPWR#13	A4#12	4.25291e-17
C50	Y#5	A1#14	1.69028e-17
C51	VGND#6	Y#4	6.65923e-17
C52	a_27_368##2	A4#9	3.02415e-19
C53	B1#6	B1#3	2.53731e-18
C54	VPWR#3	VPWR#4	6.87597e-17
C55	A3#9	A3#7	4.07681e-17
C56	a_27_368##14	A3#6	2.05922e-19
C57	A4#12	a_27_368##15	2.07877e-17
C58	B1#2	A1#7	1.01955e-18
C59	a_27_368##4	A3#10	2.34832e-18
C60	a_27_368##10	A1#8	3.27887e-19
C61	VPWR#13	A3#6	1.39938e-18
C62	VPWR#14	A4#12	3.82319e-19
C63	VGND#7	A4#6	4.91993e-19
C64	a_27_368##4	a_27_368##3	2.75876e-20
C65	Y#5	B1#1	2.9155e-17
C66	a_27_368##15	VPWR#4	8.48902e-18
C67	a_27_368##15	A3#6	4.91211e-17
C68	a_27_368##6	A2#7	2.13293e-18
C69	VGND#5	Y#3	1.63785e-18
C70	a_27_368##2	A4#6	4.35115e-18
C71	Y#5	B1#2	4.2776e-18
C72	A3#12	A3#9	4.07681e-17
C73	VPWR#13	A3#8	1.77268e-19
C74	A3#6	VPWR#14	2.81456e-17
C75	a_27_368##15	A3#8	1.49612e-18
C76	a_27_368##16	A3#6	1.59399e-18
C77	VGND#7	A4#2	5.31564e-19
C78	Y#5	B1#4	2.04022e-17
C79	Y#3	B1#6	1.93417e-19
C80	A3#8	VPWR#14	3.18165e-17
C81	VPWR#15	A3#6	1.78501e-19
C82	a_27_368##2	A4#2	8.33478e-19
C83	A2#9	A3#12	3.29781e-18
C84	A2#3	A3#11	1.6603e-17
C85	VPWR#8	A2#7	2.44724e-20
C86	a_27_368##16	A3#8	5.3027e-17
C87	A1#15	B1#1	3.61666e-18
C88	a_27_368##4	A3#3	3.84107e-18
C89	a_27_368##16	VPWR#5	9.23085e-18
C90	VPWR#14	A3#13	3.70183e-19
C91	VPWR#15	A3#8	4.09291e-19
C92	Y#5	B1#8	1.12946e-18
C93	Y#3	B1#2	1.17141e-17
C94	a_27_368#	VPWR#12	5.51579e-17
C95	a_27_368##3	a_27_368##2	2.72421e-20
C96	a_27_368##16	A3#13	4.61514e-17
C97	VPWR#5	A3#10	2.37602e-20
C98	VGND#3	a_1235_74##2	4.48381e-18
C99	A2#11	A2#9	3.61585e-17
C100	a_27_368##16	VPWR#4	7.69774e-18
C101	A3#13	VPWR#15	2.81567e-17
C102	VPWR#14	A3#14	1.71283e-19
C103	VPWR#3	a_27_368##4	1.71389e-18
C104	a_1235_74#	VGND#7	4.18839e-17
C105	a_27_368##3	VPWR#3	2.37238e-18
C106	a_27_368##14	a_27_368#	2.96061e-18
C107	a_27_368##16	A3#14	1.49612e-18
C108	a_27_368##17	A3#13	1.59399e-18
C109	VGND#8	A4#9	2.64599e-19
C110	Y#5	B1#9	8.93091e-19
C111	a_27_368##2	VPWR#3	3.10961e-18
C112	A3#14	VPWR#15	3.18165e-17
C113	VPWR#16	A3#13	1.78501e-19
C114	A2#13	A2#11	3.61585e-17
C115	VGND#5	A1#11	6.58805e-20
C116	VPWR#7	A2#7	1.33783e-20
C117	a_27_368##6	A2#3	1.23197e-18
C118	a_27_368##17	A3#14	5.3027e-17
C119	a_27_368##14	VPWR#12	5.20507e-17
C120	a_1235_74##8	a_1235_74#	1.62326e-18
C121	a_27_368##17	VPWR#6	9.23085e-18
C122	a_27_368##3	A3#3	3.3724e-18
C123	a_325_74##4	a_852_74##5	5.27852e-17
C124	VGND#8	A4#6	5.00869e-19
C125	VPWR#16	A3#14	4.09291e-19
C126	VPWR#15	A2#1	3.70183e-19
C127	a_27_368##9	VPWR#9	1.47991e-17
C128	VPWR#4	A3#10	1.55761e-20
C129	A2#8	A2#13	2.69886e-17
C130	VPWR#7	VPWR#16	8.91213e-20
C131	a_27_368##17	A2#1	4.61514e-17
C132	a_27_368##17	VPWR#5	7.69774e-18
C133	VPWR#13	VPWR#12	1.94092e-18
C134	a_27_368#	A4#2	5.04026e-20
C135	VGND#5	A1#13	2.20328e-19
C136	a_1235_74##8	VGND#7	4.16102e-17
C137	A2#1	VPWR#16	2.81567e-17
C138	VPWR#15	A2#10	1.71283e-19
C139	A1#7	VPWR#19	9.26112e-20
C140	a_325_74##4	a_325_74##7	3.87094e-18
C141	a_27_368##18	A2#1	1.6508e-18
C142	a_27_368##17	A2#10	1.49612e-18
C143	Y#5	a_27_368##12	3.54799e-18
C144	VPWR#13	a_27_368##14	5.30395e-17
C145	a_325_74##5	Y#1	6.36811e-17
C146	a_325_74##6	A1#7	8.18156e-19
C147	A1#9	A2#8	2.6178e-17
C148	a_27_368##12	B1#2	1.77642e-19
C149	a_1235_74#	A4#1	3.85099e-17
C150	VPWR#17	A2#1	1.66887e-19
C151	A2#10	VPWR#16	3.17958e-17
C152	a_27_368##5	A2#3	1.66077e-18
C153	A1#15	A1#7	1.81767e-17
C154	VGND#8	VGND#7	1.66094e-18
C155	a_27_368##18	VPWR#7	8.98969e-18
C156	A4#6	VPWR#12	6.47602e-19
C157	a_27_368##18	A2#10	5.33771e-17
C158	VGND#5	A1#8	5.44054e-18
C159	a_1235_74##2	A4#3	6.11036e-17
C160	A4#1	VGND#7	1.88615e-17
C161	a_27_368##15	a_27_368##14	2.72421e-18
C162	a_325_74##4	Y#1	6.9445e-17
C163	VPWR#17	A2#10	3.7474e-19
C164	VPWR#16	A2#12	3.66612e-19
C165	A1#11	A1#9	3.66725e-17
C166	VPWR#7	A2#5	2.20458e-20
C167	VPWR#8	VPWR#17	8.97713e-20
C168	a_325_74##5	a_325_74##8	2.51761e-17
C169	A1#7	A1#12	3.4042e-19
C170	a_1235_74#	A4#5	1.48123e-18
C171	a_27_368##18	VPWR#6	7.93564e-18
C172	VPWR#6	A2#5	2.69737e-20
C173	a_27_368##18	A2#12	4.66434e-17
C174	A4#2	VPWR#12	6.32556e-19
C175	a_1235_74##8	A4#1	5.83278e-19
C176	VGND#8	a_1235_74##8	4.15829e-17
C177	a_27_368##15	VPWR#13	6.12484e-17
C178	a_325_74##6	B1#1	3.68106e-19
C179	A2#12	VPWR#17	2.81892e-17
C180	VPWR#16	A2#14	1.70517e-19
C181	VPWR#4	A3#3	4.24684e-20
C182	VGND#7	A4#5	3.17394e-17
C183	a_27_368##10	A1#7	2.81937e-19
C184	a_27_368##7	A2#12	2.05956e-18
C185	VGND#5	B1#5	5.31507e-18
C186	a_27_368##18	A2#14	1.57497e-18
C187	Y#5	a_27_368##9	1.97004e-17
C188	A1#13	A1#11	9.97726e-18
C189	a_1235_74#	A4#7	1.79254e-19
C190	a_325_74##5	Y#7	5.21977e-17
C191	VPWR#18	A2#12	1.59131e-19
C192	a_325_74##4	A2#9	2.52587e-19
C193	A2#14	VPWR#17	3.20205e-17
C194	A4#3	a_27_368##3	1.74154e-17
C195	VPWR#14	VPWR#13	2.2194e-18
C196	A4#5	a_1235_74##8	1.38218e-17
C197	VGND#4	a_325_74##5	8.20114e-17
C198	a_1235_74##3	a_1235_74##8	1.67195e-18
C199	a_27_368##7	VPWR#8	9.43326e-18
C200	A4#3	a_27_368##2	5.93938e-17
C201	VGND#4	a_325_74##4	7.08984e-17
C202	a_27_368##7	A2#14	7.11619e-17
C203	A4#6	a_27_368##14	5.48219e-19
C204	VGND#7	A4#7	1.37067e-18
C205	VGND#3	a_1235_74#	1.59136e-17
C206	VGND#8	A4#5	1.37067e-18
C207	VPWR#18	A2#14	3.59122e-19
C208	VPWR#17	A1#1	3.46374e-19
C209	A1#8	A1#13	2.43573e-17
C210	VPWR#14	a_27_368##15	6.12484e-17
C211	A3#5	a_27_368##5	3.12845e-17
C212	a_27_368##7	VPWR#7	8.135e-18
C213	VGND#5	B1#7	3.20268e-18
C214	A3#5	a_27_368##4	8.0916e-17
C215	VGND#3	a_1235_74##8	1.70999e-17
C216	A4#7	a_1235_74##8	1.72195e-17
C217	a_27_368##7	A1#1	6.55488e-17
C218	a_1235_74##3	VGND#8	5.1521e-17
C219	a_325_74##6	a_325_74##5	2.72627e-18
C220	a_325_74##4	A2#11	3.72675e-19
C221	A3#5	a_27_368##3	5.73194e-17
C222	a_1235_74##3	A4#5	1.67688e-19
C223	A4	A4#6	9.86006e-18
C224	A1#1	VPWR#18	2.22473e-17
C225	A4	A4#2	2.20723e-17
C226	VPWR#17	A1#10	1.60713e-19
C227	VGND#3	a_1235_74##3	4.24202e-17
C228	a_27_368##2	a_27_368#	2.96061e-20
C229	a_27_368##16	a_27_368##15	2.75876e-18
C230	VGND#8	A4#7	3.27157e-17
C231	B1#5	A1#8	4.17224e-18
C232	VGND#3	a_852_74##6	6.78994e-18
C233	A4#9	VPWR#13	6.34406e-19
C234	a_27_368##7	A1#10	2.51086e-18
C235	A2#5	a_27_368##6	6.51328e-17
C236	VGND#3	a_1235_74##5	6.13764e-17
C237	VPWR#19	A1#1	1.8669e-19
C238	A2#5	a_27_368##5	3.5947e-18
C239	a_1235_74##8	A4#10	3.05025e-19
C240	A1#10	VPWR#18	3.0056e-17
C241	Y#3	Y#1	3.16551e-18
C242	VGND#3	a_852_74#	7.44418e-18
C243	a_325_74##4	A2#13	1.30009e-18
C244	a_1235_74##3	A4#7	3.97516e-19
C245	a_27_368##16	VPWR#14	5.29637e-17
C246	VGND#3	a_1235_74##7	2.99283e-17
C247	A1#10	a_27_368##19	2.32435e-17
C248	a_27_368##7	A1#12	3.11817e-19
C249	A4#6	VPWR#13	6.13865e-19
C250	VGND#3	a_325_74#	1.01183e-17
C251	B1#7	B1#5	2.74295e-17
C252	VGND#8	A4#10	2.82474e-17
C253	VGND#5	B1#3	8.09988e-20
C254	Y#8	A1#1	1.45787e-19
C255	VPWR#19	A1#10	4.18407e-19
C256	a_27_368##2	VPWR#12	1.59634e-17
C257	a_27_368##9	A1#5	1.39782e-18
C258	VPWR#18	A1#12	3.30163e-19
C259	VGND#3	a_852_74##3	1.44162e-18
C260	a_325_74##5	A2#8	2.38413e-19
C261	a_325_74##6	B1#2	4.3446e-19
C262	B1#1	A1#7	1.51296e-17
C263	a_1235_74##3	a_852_74##6	5.0725e-17
C264	a_1235_74##8	A3#1	1.28671e-19
C265	A1#12	a_27_368##19	2.32435e-17
C266	VPWR#15	VPWR#14	2.09124e-18
C267	a_27_368##7	A1#14	1.87355e-19
C268	a_1235_74##3	A4#10	2.62071e-17
C269	Y#8	A1#10	1.40003e-19
C270	a_325_74##4	A2#8	4.09176e-17
C271	A1#12	VPWR#19	3.00004e-17
C272	a_1235_74##3	A3#3	1.35135e-19
C273	VPWR#18	A1#14	1.53979e-19
C274	a_852_74##6	A3#10	2.04084e-18
C275	VGND#8	A3#1	1.43332e-18
C276	a_27_368##12	B1#3	1.11623e-19
C277	a_27_368##10	A1#12	9.23997e-19
C278	a_852_74##6	A4#10	9.73014e-19
C279	VPWR#15	a_27_368##16	6.12484e-17
C280	a_27_368##7	B1#1	1.26224e-19
C281	a_27_368##2	a_27_368##14	1.34628e-18
C282	a_325_74##5	A1#9	1.11177e-18
C283	Y#8	A1#12	2.96622e-19
C284	B1#2	A1#8	3.89424e-18
C285	A1#14	VPWR#19	3.15342e-17
C286	A3	A2#7	4.16089e-20
C287	a_1235_74##3	A3#1	4.20655e-17
C288	a_27_368##3	VPWR#13	1.33909e-17
C289	A1#15	B1#2	2.9322e-19
C290	Y#3	Y#7	4.53667e-19
C291	a_27_368##10	A1#14	5.7744e-17
C292	VPWR#19	VPWR#8	2.09603e-19
C293	a_27_368##6	VPWR#7	2.15613e-19
C294	a_1235_74##3	A4#3	1.44138e-17
C295	A3	A2#3	1.27506e-17
C296	VGND#4	a_325_74#	3.92421e-17
C297	a_325_74##4	A1#9	2.62886e-17
C298	VPWR#3	a_27_368#	1.84047e-17
C299	a_325_74##5	A1#5	3.80584e-17
C300	VGND#8	A3#7	2.90512e-19
C301	a_27_368##17	a_27_368##16	2.75876e-18
C302	Y#8	A1#14	4.78843e-19
C303	a_325_74##4	A1#5	3.38606e-18
C304	a_852_74##6	A3#1	3.0186e-17
C305	VGND#9	B1#2	1.10796e-18
C306	A4#9	A4#6	4.0818e-18
C307	VGND#4	a_325_74##2	6.1366e-17
C308	a_852_74##6	a_1235_74##5	3.87913e-17
C309	a_27_368##14	VPWR#3	2.52522e-17
C310	a_27_368##10	B1#1	5.52629e-17
C311	a_27_368##2	VPWR#13	1.17186e-17
C312	a_325_74##5	A1#11	3.1248e-17
C313	a_1235_74##3	A3#7	2.10074e-18
C314	A1#5	Y#5	2.00723e-17
C315	B1#1	Y#8	2.20581e-17
C316	A4#8	A4#4	4.73903e-17
C317	a_27_368##17	VPWR#15	5.29637e-17
C318	Y#3	a_325_74##6	3.91783e-17
C319	a_1235_74##3	A3#5	2.68242e-17
C320	a_27_368##3	a_27_368##15	3.6075e-18
C321	a_27_368##15	VPWR#3	2.67149e-17
C322	a_852_74##6	A3#3	2.45204e-18
C323	a_852_74##6	A3#5	4.26444e-17
C324	a_27_368##20	B1#1	1.72215e-18
C325	a_325_74##4	A1#11	3.84032e-19
C326	VGND#8	A3#9	1.55626e-19
C327	a_27_368##6	VPWR#6	3.13618e-19
C328	a_27_368##10	B1#4	1.79858e-18
C329	a_1235_74##5	A3#10	8.57829e-19
C330	a_852_74##6	A3#7	3.96561e-17
C331	A1#18	A1#5	2.75854e-17
C332	Y#6	B1#1	2.63043e-19
C333	a_27_368##4	VPWR#14	1.09257e-17
C334	VPWR#4	A4#12	3.13185e-19
C335	B1#4	Y#8	2.46291e-17
C336	a_852_74#	A3#5	7.21444e-17
C337	VPWR#3	a_27_368##16	1.72175e-17
C338	a_1235_74##3	a_1235_74##7	3.8488e-20
C339	Y#4	B1#6	1.24267e-18
C340	VPWR#16	VPWR#15	2.09124e-18
C341	A4#11	A4#8	4.58636e-17
C342	a_1235_74##3	A3#9	1.18156e-18
C343	a_27_368##20	B1#4	4.8253e-17
C344	a_325_74##5	A1#13	3.23571e-17
C345	A1#15	A1#5	7.44235e-18
C346	a_1235_74##5	A3#7	3.31925e-17
C347	Y#5	B1#3	6.40785e-21
C348	Y#3	VGND#9	1.39212e-17
C349	Y#3	A1#9	5.77858e-20
C350	Y#6	B1#4	1.36626e-18
C351	Y#3	B1#3	4.54745e-19
C352	a_1235_74##2	a_1235_74#	4.92215e-19
C353	VGND#8	A3#12	1.22928e-19
C354	Y#8	B1#8	9.2221e-19
C355	a_27_368##3	VPWR#14	1.44232e-17
C356	a_325_74##4	A1#13	1.76783e-19
C357	a_27_368##13	B1#4	3.30616e-19
C358	Y#4	B1#2	7.03401e-19
C359	VPWR#5	A3#6	9.12873e-20
C360	VPWR#16	a_27_368##17	6.12484e-17
C361	a_852_74#	A3#11	4.5321e-18
C362	B1#8	a_27_368##20	2.37687e-17
C363	a_1235_74##5	a_852_74#	3.2394e-17
C364	a_27_368##5	VPWR#6	1.6661e-19
C365	A4#12	A4#11	4.69796e-17
C366	a_27_368##4	a_27_368##16	1.34628e-18
C367	a_325_74#	A3#1	4.03507e-19
C368	Y#6	B1#8	6.48967e-17
C369	a_1235_74##3	A3#12	8.28621e-19
C370	VPWR#4	A3#6	4.54189e-18
C371	a_1235_74##5	A3#9	3.40944e-17
C372	a_325_74##5	A1#8	7.27609e-19
C373	a_27_368##13	B1#8	2.59524e-18
C374	B1#2	a_27_368##20	1.03571e-18
C375	a_852_74##3	A2#5	6.40911e-17
C376	a_27_368##20	B1#9	1.34394e-18
C377	a_27_368##5	VPWR#15	1.16841e-17
C378	Y#3	A1#11	2.04227e-19
C379	a_27_368##18	a_27_368##17	2.75876e-18
C380	a_1235_74##5	A3#3	3.13297e-19
C381	a_325_74##2	A2#5	7.48899e-19
C382	B1#9	Y#6	2.55591e-17
C383	A3#6	A4#12	3.68724e-17
C384	a_852_74##5	A2#5	1.71561e-17
C385	a_852_74#	A3#10	4.53012e-18
C386	a_852_74#	A3#9	3.93428e-17
C387	a_1235_74##2	VGND#7	2.41094e-17
C388	a_27_368##13	B1#9	6.17435e-17
C389	a_325_74#	A3#7	5.55549e-19
C390	a_27_368##5	VPWR#5	3.13618e-19
C391	VPWR#5	A3#8	3.40035e-19
C392	a_27_368##4	VPWR#15	1.40714e-17
C393	a_27_368##18	VPWR#16	5.29637e-17
C394	a_325_74##5	a_325_74##4	3.37154e-18
C395	A3#3	a_27_368##15	3.10657e-19
C396	VPWR#4	A3#8	5.32783e-18
C397	A3#8	A3#6	3.77855e-17
C398	Y#3	A1#13	6.2144e-18
C399	B1	A1#7	3.51367e-19
C400	a_27_368##5	a_27_368##17	1.61996e-18
C401	B1#6	Y#6	7.4287e-19
C402	a_852_74#	a_1235_74##7	5.93287e-17
C403	a_852_74#	A3#12	4.25064e-17
C404	a_325_74#	A3#9	8.36976e-19
C405	a_1235_74##7	A3#11	8.13974e-19
C406	VPWR#17	VPWR#16	1.94953e-18
C407	Y#1	A1#5	9.05157e-18
C408	B1	B1#6	2.32478e-17
C409	a_1235_74##2	a_1235_74##8	1.24483e-18
C410	B1	B1#2	1.35763e-17
C411	A4#6	A4#2	3.65119e-18
C412	VPWR#6	A3#13	9.12873e-20
C413	a_27_368##6	VPWR#16	1.15282e-17
C414	a_1235_74##7	A3#12	4.70329e-17
C415	VGND#6	a_27_368##13	3.4362e-19
C416	A3#13	A3#8	4.58334e-17
C417	Y#6	B1#2	2.75719e-19
C418	a_27_368##4	VPWR#5	1.6661e-19
C419	VPWR#5	A3#13	4.55094e-18
C420	a_27_368##2	A4#4	9.23947e-21
C421	Y#3	A1#8	2.49449e-17
C422	VPWR#17	a_27_368##18	5.82036e-17
C423	a_325_74#	A3#12	3.59778e-18
C424	a_1235_74##7	A3#10	3.00871e-19
C425	VPWR#4	A3#13	2.99535e-19
C426	a_27_368##5	VPWR#16	1.40776e-17
C427	VGND#3	A4#1	1.54223e-18
C428	A3#14	A3#13	3.77855e-17
C429	VPWR#3	A4#6	2.04712e-20
C430	a_1235_74##7	A2#9	6.27148e-19
C431	VGND#3	A4#5	1.60764e-18
C432	a_1235_74##2	VGND#8	2.25618e-17
C433	A2	A2#7	3.09814e-17
C434	a_27_368##6	a_27_368##18	2.68731e-19
C435	a_27_368##7	a_27_368##18	3.0627e-18
C436	VPWR#6	A3#14	3.40035e-19
C437	VGND#9	B1#3	5.9255e-19
C438	A2	A2#3	1.1279e-19
C439	VGND#3	A4#7	6.16358e-18
C440	A3#3	VPWR#14	2.66537e-18
C441	a_325_74#	a_1235_74##7	2.69342e-17
C442	A1#8	B1#1	1.10205e-17
C443	a_1235_74##2	A4#9	8.39338e-19
C444	a_27_368##13	B1#6	5.20405e-20
C445	a_27_368##4	VPWR#4	3.13618e-19
C446	Y#4	B1#3	5.64745e-18
C447	VGND#3	A4#10	6.12321e-18
C448	a_325_74#	A2#9	4.96896e-17
C449	A2#1	A3#14	4.81528e-17
C450	a_27_368##2	A4#8	1.68989e-17
C451	VPWR#5	A3#14	5.33317e-18
C452	VGND#3	A3#1	6.98873e-18
C453	a_1235_74##2	A4	2.79775e-17
C454	A2#5	VPWR#16	2.38725e-18
C455	a_27_368##18	a_27_368##5	3.17257e-19
C456	a_27_368##7	VPWR#17	5.9102e-17
C457	A3#10	a_27_368##16	5.48219e-19
C458	A2#5	a_27_368##18	3.03802e-18
C459	VGND#3	A3#7	6.54204e-18
C460	VPWR#4	A3#14	8.34499e-20
C461	a_852_74##3	A2#9	4.12156e-17
C462	A2#5	VPWR#17	7.75495e-19
C463	a_27_368##9	a_27_368##7	2.79523e-18
C464	VGND#3	A3#9	6.34723e-18
C465	VPWR#7	A2#1	9.64386e-20
C466	A2#10	A2#1	3.83903e-17
C467	a_1235_74##3	a_1235_74##2	5.06977e-19
C468	a_27_368##6	VPWR#17	2.04357e-17
C469	a_27_368##3	A4#11	4.4138e-21
C470	VGND#3	A3#12	5.50332e-18
C471	VPWR#18	VPWR#17	1.85153e-18
C472	VPWR#6	A2#1	4.55643e-18
C473	a_1235_74##2	A4#6	6.69845e-18
C474	A4	a_27_368##2	2.52504e-17
C475	a_27_368##2	A4#11	1.69951e-17
C476	a_27_368##3	VPWR#4	1.6661e-19
C477	VPWR#5	A2#1	2.99535e-19
C478	a_852_74##3	A2#11	3.4828e-17
C479	a_27_368##7	A1#5	5.14734e-19
C480	A2#12	A2#10	4.63879e-17
C481	VGND#3	A4#6	3.62715e-20
C482	Y	A2#7	1.87677e-18
C483	A1#5	VPWR#18	1.59668e-18
C484	a_325_74#	a_852_74##3	5.93967e-17
C485	a_27_368##7	VPWR#18	4.74223e-17
C486	A3#11	VPWR#15	1.80438e-18
C487	A1#5	a_27_368##19	6.35796e-19
C488	a_27_368##9	VPWR#18	4.1242e-17
C489	Y	A1#7	1.99247e-20
C490	A1#5	VPWR#19	1.86965e-18
C491	VGND#3	A3#11	1.29069e-19
C492	a_325_74##2	A2#11	3.65928e-17
C493	a_27_368##3	A4#12	1.67528e-17
C494	A3	a_27_368##5	2.30151e-17
C495	Y#3	a_325_74##5	1.71157e-17
C496	VPWR#7	A2#10	3.4337e-19
C497	a_27_368##10	A1#5	3.88069e-19
C498	A2#14	A2#12	3.66125e-17
C499	VGND#4	A2#9	4.46563e-18
C500	VGND#3	A3#10	1.89297e-19
C501	a_325_74##4	A2#7	1.0681e-18
C502	a_27_368##2	A4#12	5.24866e-21
C503	VGND#4	A2#11	4.46563e-18
C504	a_1235_74##2	A4#2	1.33714e-18
C505	VPWR#6	A2#10	5.32986e-18
C506	VGND#4	A2#13	4.46563e-18
C507	VGND#3	A3#3	7.10063e-20
C508	Y#1	A2#9	6.27008e-20
C509	a_27_368##4	A3#6	4.93999e-21
C510	VPWR#5	A2#10	8.34499e-20
C511	A1#1	A2#14	4.56852e-17
C512	VGND#4	A2#8	4.41758e-18
C513	a_325_74##2	A2#13	3.7554e-17
C514	a_1235_74#	A4	4.38932e-17
C515	VGND#4	A1#9	4.48031e-18
C516	a_27_368##9	a_27_368##19	1.04549e-18
C517	VPWR#8	A2#12	1.07942e-19
C518	B1#3	a_27_368##20	8.56322e-19
C519	a_27_368##3	A3#6	1.73837e-17
C520	VPWR#3	A4#4	1.70801e-18
C521	a_27_368##6	A3#8	9.72826e-20
C522	VGND#4	A1#11	4.48031e-18
C523	B1#3	Y#6	4.48336e-18
C524	a_852_74##5	A2#13	3.75129e-17
C525	VPWR#3	A4#8	1.12805e-18
C526	a_27_368##13	B1#3	1.27461e-19
C527	VGND#4	A1#13	4.48031e-18
C528	A1#10	A1#1	3.78487e-17
C529	VPWR#7	A2#12	4.9091e-18
C530	a_852_74##3	a_325_74##2	3.59406e-17
C531	a_27_368##2	A3#6	2.05922e-21
C532	Y#1	A2#11	5.14462e-20
C533	VGND#5	B1	4.64726e-20
C534	VPWR#3	A4#11	5.95359e-18
C535	VGND#3	A2#3	1.72214e-20
C536	VPWR#6	A2#12	2.9979e-19
C537	VPWR#19	VPWR#18	1.92136e-18
C538	VPWR#3	A4#12	5.16271e-18
C539	a_27_368##4	A3#8	1.77822e-17
C540	A1#12	A1#10	4.71349e-17
C541	VPWR#3	A3#6	5.61761e-19
C542	a_27_368##9	VPWR#19	5.12879e-17
C543	a_325_74##5	A1#18	1.69184e-17
C544	A2#8	a_852_74##5	1.77563e-17
C545	a_27_368##3	A3#8	4.93999e-21
C546	VPWR#3	A3#8	8.59748e-19
C547	a_27_368##6	A3#13	1.50638e-19
C548	Y#1	A2#13	1.1528e-19
C549	VPWR#8	A2#14	3.72242e-19
C550	a_1235_74#	a_27_368#	1.6024e-19
C551	a_852_74#	A3	8.19826e-18
C552	VPWR#3	A3#13	1.99403e-19
C553	A1#14	A1#12	3.13379e-17
C554	a_27_368##5	A3#13	4.93999e-21
C555	A3#3	A4#9	3.18427e-17
C556	A2#8	a_325_74##7	1.72032e-17
C557	VPWR#7	A2#14	5.44671e-18
C558	A1#5	A2#8	1.74931e-19
C559	a_852_74##3	A3	1.23167e-17
C560	A4	a_27_368#	4.64208e-17
C561	A4#3	A4#8	7.83125e-19
C562	VPWR#6	A2#14	8.39831e-20
C563	a_27_368##4	A3#13	1.70377e-17
C564	Y#8	VPWR#18	5.25383e-21
C565	B1#1	A1#14	4.68724e-17
C566	A4#3	A4#11	2.0582e-18
C567	Y#1	A2#8	1.03808e-18
C568	a_325_74##2	a_852_74##5	3.61227e-17
C569	B1	Y#5	2.99312e-17
C570	Y#3	B1	2.13116e-17
C571	a_27_368##12	Y#8	1.62735e-17
C572	A4#3	A4#12	1.32475e-18
C573	a_27_368##10	a_27_368##9	2.64007e-18
C574	A2	a_27_368##6	1.9928e-17
C575	a_27_368##6	A3#14	2.51527e-19
C576	A1#9	a_325_74##7	1.27685e-18
C577	A4#3	A3#6	3.03651e-19
C578	a_325_74##5	A1#7	1.02499e-18
C579	a_27_368##10	VPWR#19	5.89844e-17
C580	B1#4	B1#1	4.8123e-17
C581	VPWR#8	A1#1	4.85614e-18
C582	A3#5	A4#12	1.11934e-18
C583	VGND	A1#7	1.28695e-18
C584	a_27_368##5	A3#14	1.77418e-17
C585	B1#3	A1#8	4.16887e-19
C586	A3#5	A3#6	2.06077e-18
C587	VGND#5	A1#7	1.65798e-19
C588	VPWR#7	A1#1	3.19684e-19
C589	Y#1	A1#9	3.21143e-17
C590	a_325_74##4	A2	2.40712e-17
C591	A3#5	A3#8	2.06618e-18
C592	a_27_368##4	A3#14	4.93999e-21
C593	Y#3	Y#5	1.0911e-17
C594	B1#8	B1#4	3.46761e-17
C595	A3#5	A3#13	2.06618e-18
C596	Y	a_27_368##9	5.76025e-17
C597	A3#5	A3#14	4.13103e-18
C598	a_27_368##12	a_27_368##20	1.26724e-18
C599	Y	a_27_368##6	1.89139e-18
C600	a_27_368##6	A2#1	4.96047e-19
C601	A3#11	A3#10	3.20043e-18
C602	VPWR#9	A1#10	5.54333e-18
C603	B1#9	B1#8	3.85297e-17
C604	Y#1	A1#11	2.89001e-17
C605	a_27_368##10	Y#8	3.94849e-17
C606	VPWR	VPWR#8	4.96616e-17
C607	a_27_368##5	A2#1	1.87563e-17
C608	VPWR	VPWR#7	6.92767e-17
C609	VPWR	VPWR#6	6.8995e-17
C610	VGND#4	A2#7	1.78117e-19
C611	VPWR#8	A1#10	2.09312e-18
C612	VPWR	VPWR#5	5.06599e-17
C613	a_325_74##5	Y	7.65458e-20
C614	a_325_74##4	Y	1.05683e-18
C615	Y#4	B1	7.18821e-17
C616	VGND#6	B1	2.20679e-17
C617	Y#5	Y	1.18922e-18
C618	VPWR#7	A1#10	9.30318e-20
C619	A1#11	a_325_74##8	7.10347e-18
C620	Y#3	Y	3.56068e-19
C621	A4#9	VNB	2.22571e-17
C622	A4#6	VNB	5.72785e-17
C623	A4#2	VNB	3.89641e-17
C624	VPWR#8	VPWR#7	7.36573e-19
C625	a_325_74##5	A1#15	1.09026e-17
C626	a_325_74#	A2#3	9.05296e-19
C627	A3#11	VNB	3.66691e-17
C628	A1#18	Y	7.3862e-17
C629	A3#10	VNB	4.53973e-17
C630	A4#3	A4#9	1.09917e-17
C631	a_852_74##5	A2	3.92069e-17
C632	A3#3	VNB	4.05156e-17
C633	a_27_368##20	a_27_368##10	5.01824e-18
C634	VPWR	a_27_368##12	3.01517e-17
C635	A2#7	VNB	4.7512e-17
C636	VGND#4	A2#3	1.56252e-19
C637	VPWR	a_27_368##9	2.04315e-17
C638	A2#3	VNB	5.15733e-17
C639	A4#3	A4#6	2.65921e-17
C640	a_27_368##12	Y#6	1.73143e-17
C641	Y#1	A1#13	2.30035e-19
C642	A1#7	VNB	2.70302e-17
C643	VPWR	a_27_368##6	2.85134e-18
C644	a_27_368##6	A2#10	2.48456e-17
C645	VPWR	a_27_368##5	2.67356e-18
C646	VPWR	a_27_368##4	6.43948e-19
C647	A1#5	A2#14	8.11797e-19
C648	B1#6	VNB	3.88649e-17
C649	B1#2	VNB	3.81194e-17
C650	A1#5	A1#1	5.49636e-20
C651	VGND#4	A1#7	2.26733e-20
C652	a_27_368##5	A2#10	5.68099e-20
C653	A1#13	a_325_74##8	1.25342e-17
C654	a_27_368##20	Y#8	3.46413e-17
C655	a_325_74##6	A1#11	1.58073e-19
C656	a_1235_74##3	a_27_368##3	5.88431e-18
C657	VPWR	Y#5	7.91797e-18
C658	VPWR#8	A1#12	3.61774e-19
C659	VPWR	A1#18	2.68182e-18
C660	Y#1	Y	2.8053e-18
C661	VGND	VGND#5	1.24725e-16
C662	VPWR	A1#15	3.13852e-18
C663	A4#3	A3#3	6.16697e-18
C664	Y#7	A1#13	3.18994e-17
C665	B1	Y#6	6.50493e-17
C666	a_325_74##4	a_27_368##7	4.22108e-18
C667	a_325_74##2	A2#7	3.21039e-19
C668	B1	a_27_368##13	3.75343e-17
C669	A2	VPWR#17	7.27526e-19
C670	VPWR#3	A4#3	5.41733e-18
C671	Y#6	Y#8	3.08157e-18
C672	A2	a_27_368##7	4.82973e-17
C673	a_27_368##6	A2#12	2.5155e-17
C674	A4	A4#4	2.9741e-18
C675	VGND#3	A4#3	4.97061e-18
C676	VPWR#3	A3#5	8.79857e-18
C677	A3#14	A3#10	1.81943e-18
C678	A4	A4#8	1.26196e-18
C679	B1#3	B1#4	5.35859e-19
C680	a_325_74##6	A1#13	9.72106e-19
C681	VGND#3	A3#5	7.82444e-18
C682	VGND	a_325_74##5	4.06267e-17
C683	VGND	a_325_74##4	3.35829e-17
C684	VGND	Y#5	1.84101e-18
C685	B1#9	B1#3	8.32719e-20
C686	a_852_74##3	A2#3	1.09594e-17
C687	Y#6	a_27_368##20	5.73634e-17
C688	VGND	Y#3	6.71977e-18
C689	A1#8	Y#7	1.59232e-17
C690	VGND	A1#18	2.57505e-18
C691	a_1235_74##2	A4#1	1.76865e-19
C692	Y	a_27_368##7	2.23216e-17
C693	A3#5	A4#9	8.62984e-18
C694	VPWR#8	VNB	2.00619e-17
C695	Y	VPWR#18	9.32857e-19
C696	VGND	A1#15	2.54324e-18
C697	VPWR#7	VNB	2.83636e-17
C698	VPWR#6	VNB	2.82905e-17
C699	Y	a_27_368##19	5.76576e-19
C700	VPWR#5	VNB	2.81636e-17
C701	VPWR#8	A1#14	1.00056e-19
C702	VPWR#4	VNB	2.76183e-17
C703	A3#5	A4#3	3.29552e-17
C704	VGND#4	A2#5	1.32529e-19
C705	a_325_74##4	VPWR#18	8.95389e-20
C706	VGND#5	VNB	5.87695e-17
C707	VPWR#9	A1#5	4.33419e-20
C708	a_325_74##6	A1#8	5.62039e-17
C709	VGND	a_852_74#	6.98541e-18
C710	B1	A1#8	2.21703e-18
C711	a_1235_74##2	VNB	1.87846e-18
C712	a_27_368##12	VNB	5.41791e-18
C713	VGND	a_1235_74##7	1.60379e-17
C714	VGND#4	A1#5	4.99804e-19
C715	VGND	a_325_74#	2.06977e-17
C716	a_27_368##9	VNB	2.08637e-18
C717	VPWR	a_27_368##17	1.72175e-17
C718	Y#4	A1#13	1.45009e-19
C719	a_27_368##13	a_27_368##20	4.30435e-18
C720	VGND	a_852_74##3	1.2694e-17
C721	VPWR#7	VPWR#6	7.30328e-19
C722	a_27_368##6	VNB	3.86392e-19
C723	VGND	a_325_74##2	2.62302e-17
C724	A3#5	A3#11	2.30819e-17
C725	a_27_368##6	A2#14	5.38206e-19
C726	VGND	a_852_74##5	6.35894e-18
C727	VPWR	a_27_368##18	1.72386e-17
C728	A3	A2#1	3.81303e-18
C729	VGND	Y#1	1.01263e-17
C730	VPWR	a_27_368##7	2.01727e-17
C731	A3	A2#10	4.26252e-19
C732	VGND	Y#7	8.78121e-18
C733	A3#5	A3#10	2.83655e-17
C734	VGND	a_325_74##6	2.27073e-17
C735	A3	A2#12	2.04765e-19
C736	Y#7	B1#5	4.67484e-19
C737	a_325_74##5	VNB	8.67437e-18
C738	a_325_74##4	VNB	5.80511e-18
C739	VGND	Y#4	1.90042e-17
C740	VGND#9	A1#8	9.78893e-19
C741	VPWR	a_27_368##10	2.33524e-17
C742	A3	A2#14	1.52033e-19
C743	VGND	VGND#6	5.74479e-17
C744	VPWR	Y#8	6.58389e-18
C745	Y#3	VNB	7.15114e-18
C746	A1#18	VNB	1.5955e-18
C747	VPWR	Y#6	1.04212e-17
C748	VPWR	a_27_368##13	2.59872e-17
C749	A1#15	VNB	2.11432e-18
C750	a_27_368##13	Y#6	8.67708e-17
C751	a_1235_74#	VNB	4.73217e-17
C752	A3#5	A3#3	3.12397e-17
C753	a_27_368##9	A1#1	1.11805e-18
C754	VGND#7	VNB	8.7641e-19
C755	a_1235_74##8	VNB	4.55126e-18
C756	A2#1	A3#11	8.34991e-19
C757	a_1235_74##2	A4#5	1.74084e-17
C758	VGND#8	VNB	3.01253e-20
C759	a_325_74##6	B1#5	1.12136e-18
C760	a_852_74##5	A2#7	8.90729e-18
C761	a_1235_74##3	VNB	7.12005e-18
C762	a_852_74##6	VNB	5.62037e-19
C763	a_1235_74##5	VNB	4.14297e-18
C764	Y#4	A1#8	4.67484e-19
C765	a_852_74#	VNB	5.62128e-18
C766	a_1235_74##7	VNB	6.58163e-18
C767	a_325_74#	VNB	9.82384e-18
C768	a_852_74##3	VNB	4.09128e-18
C769	a_325_74##2	VNB	4.12848e-18
C770	a_852_74##5	VNB	7.68685e-20
C771	Y#1	VNB	2.37973e-19
C772	VPWR#3	A4	5.76321e-18
C773	a_325_74##6	VNB	1.05503e-17
C774	Y#7	B1#7	2.44637e-19
C775	VGND#9	VNB	5.2995e-18
C776	A2	A2#1	3.17933e-19
C777	Y#4	VNB	7.17204e-18
C778	VGND#3	A4	4.99324e-18
C779	VGND#9	B1#5	4.06864e-17
C780	VGND#6	VNB	6.73145e-17
C781	A2	A2#10	4.12116e-19
C782	a_27_368#	VNB	4.97907e-17
C783	VPWR#12	VNB	2.82484e-18
C784	a_27_368##6	A1#1	1.16072e-19
C785	a_27_368##14	VNB	2.1429e-18
C786	A2	A2#12	2.37052e-18
C787	VPWR#13	VNB	4.09278e-19
C788	a_27_368##15	VNB	2.77013e-18
C789	A2	A2#14	2.62275e-18
C790	VPWR#14	VNB	3.0111e-18
C791	a_325_74##2	A2#3	4.29077e-19
C792	a_27_368##16	VNB	2.1429e-18
C793	B1	B1#1	4.58183e-19
C794	A2	A1#1	1.23965e-18
C795	Y#5	A1#15	6.17106e-17
C796	VPWR#15	VNB	3.0111e-18
C797	VPWR#16	A2#3	8.79303e-19
C798	a_27_368##17	VNB	2.1429e-18
C799	VGND	A3#12	8.15093e-19
C800	B1	B1#4	1.69e-18
C801	VPWR#16	VNB	3.00214e-18
C802	A2#3	A3#12	1.17641e-18
C803	a_27_368##18	VNB	2.13748e-18
C804	VGND	A2#9	1.37118e-18
C805	VPWR#17	VNB	2.88193e-18
C806	VGND	A2#11	1.33876e-18
C807	a_27_368##7	VNB	2.1429e-18
C808	VGND	A2#13	1.34441e-18
C809	VPWR#18	VNB	2.74994e-18
C810	VGND	A2#8	1.2809e-18
C811	Y	A2#12	1.02129e-19
C812	B1	B1#9	2.85888e-18
C813	VPWR#19	VNB	3.12618e-18
C814	Y#4	B1#5	3.26792e-17
C815	VGND	A1#9	1.64539e-18
C816	a_27_368##10	VNB	2.45047e-18
C817	Y	A2#14	4.30601e-19
C818	VGND	A1#11	1.64406e-18
C819	Y#8	VNB	1.78523e-20
C820	VGND	A1#13	1.58495e-18
C821	Y	A1#1	6.22769e-18
C822	VGND	A1#8	2.37217e-18
C823	a_27_368##13	VNB	5.47349e-17
C824	Y	A1#10	1.87642e-17
C825	VGND	B1#5	4.82188e-19
C826	A4#1	VNB	3.11817e-17
C827	VPWR	A3#14	8.07125e-19
C828	A4#5	VNB	2.54872e-17
C829	VGND	B1#7	1.42753e-18
C830	Y	A1#12	7.97431e-18
C831	a_27_368##9	A1#10	3.57951e-17
C832	VPWR	A2#1	2.17971e-19
C833	A2#5	A3	2.38206e-17
C834	A4#7	VNB	2.53946e-17
C835	A4#10	VNB	2.53947e-17
C836	Y	A1#14	1.76001e-19
C837	VPWR	A2#10	7.79868e-19
C838	A3#1	VNB	3.09812e-17
C839	a_1235_74##2	A4#7	1.69132e-17
C840	A3#7	VNB	2.96205e-17
C841	VPWR	A2#12	3.85154e-19
C842	Y	B1#1	8.90874e-20
C843	A3#9	VNB	3.01756e-17
C844	VPWR	A2#14	7.67842e-19
C845	A3#12	VNB	3.36515e-17
C846	VGND#9	B1#7	1.24219e-18
C847	A2#9	VNB	2.91644e-17
C848	VPWR	A1#1	1.13217e-19
C849	A2#11	VNB	2.67509e-17
C850	A2#13	VNB	2.68356e-17
C851	VGND#6	B1#5	1.17265e-18
C852	A2#8	VNB	2.78357e-17
C853	VPWR	A1#12	7.03253e-20
C854	A1#9	VNB	2.69505e-17
C855	A2#5	A3#11	8.81481e-19
C856	A1#11	VNB	2.82892e-17
C857	VPWR	A1#14	4.29396e-19
C858	A1#13	VNB	2.8116e-17
C859	A1#8	VNB	4.06583e-17
C860	VPWR	B1#1	1.41053e-18
C861	VGND#5	B1#6	2.91054e-20
C862	B1#5	VNB	2.66534e-17
C863	VPWR	B1#4	1.57026e-18
C864	B1#7	VNB	3.61893e-17
C865	VPWR	B1#8	1.6567e-18
C866	A4#4	VNB	3.93027e-17
C867	B1	B1#3	2.45225e-17
C868	A4#8	VNB	3.26165e-17
C869	VPWR	B1#9	2.3934e-18
C870	A2	A2#5	6.48774e-19
C871	A4#11	VNB	3.07229e-17
C872	A4#12	VNB	2.91669e-17
C873	Y#3	A1#15	3.7374e-17
C874	A3#6	VNB	3.17004e-17
C875	A2	A1#5	1.50918e-17
C876	a_27_368##6	A1#10	1.83781e-19
C877	Y#4	B1#7	4.78999e-17
C878	A3#8	VNB	3.29045e-17
C879	VGND#5	a_325_74##6	5.24018e-17
C880	A3#13	VNB	3.15366e-17
C881	VGND	B1#1	4.73142e-20
C882	A3#14	VNB	3.51742e-17
C883	VPWR	VPWR#9	2.43444e-17
C884	A2#1	VNB	3.47643e-17
C885	A2#10	VNB	3.33073e-17
C886	A2#12	VNB	3.3944e-17
C887	Y	A1#5	2.48153e-17
C888	A2#14	VNB	3.313e-17
C889	A1#1	VNB	3.31726e-17
C890	VPWR	A3#5	3.26192e-18
C891	A1#10	VNB	3.46301e-17
C892	VPWR#6	VPWR#5	7.4289e-19
C893	A1#12	VNB	3.08281e-17
C894	VGND	VGND#3	4.61393e-17
C895	VPWR	A2#5	5.49901e-18
C896	A3#10	A3#3	3.90592e-18
C897	A1#14	VNB	3.0922e-17
C898	B1#1	VNB	4.29567e-17
C899	VPWR	A1#5	1.44117e-18
C900	VGND	VGND#4	1.86785e-16
C901	B1#4	VNB	3.28746e-17
C902	B1#8	VNB	3.13174e-17
C903	B1#9	VNB	4.06155e-17
C904	VGND	A3#5	2.78826e-18
C905	VGND#6	B1#7	2.64173e-17
C906	VGND	A2#5	5.27692e-18
C907	VPWR#3	VNB	2.02057e-16
C908	VGND#3	VNB	2.69284e-16
C909	VGND	A1#5	1.04502e-18
C910	A2	A3	1.15155e-18
C911	VPWR#9	VNB	1.30943e-17
C912	VGND#4	VNB	1.11156e-16
C913	A4#3	VNB	9.26537e-18
C914	A2#5	A2#7	3.38248e-18
C915	a_27_368##9	A1#12	3.21832e-17
C916	A4#5	A4#1	2.92574e-17
C917	A3#5	VNB	2.0751e-17
C918	A2#5	VNB	3.75441e-17
C919	A1#5	VNB	1.07558e-16
C920	B1#3	VNB	3.91709e-17
C921	VPWR	A3	2.0133e-18
C922	a_1235_74##2	A4#10	9.24914e-20
C923	Y	A2	3.02294e-17
C924	VGND#5	B1#1	1.75926e-20
C925	VGND	A3	2.14512e-18
C926	VPWR	B1	9.65528e-18
C927	VPWR	A2	5.00569e-18
C928	A4	VNB	3.16768e-17
C929	VGND	B1	9.29823e-18
C930	A3	VNB	3.0061e-18
C931	VPWR	Y	5.14663e-18
C932	A2#7	VPWR#17	1.84998e-18
C933	VGND	A2	4.24305e-18
C934	VGND#5	a_325_74##5	6.30469e-18
C935	B1	VNB	4.00645e-17
C936	VGND	Y	1.15902e-18
C937	a_852_74##3	a_27_368##5	5.51978e-18
C938	A2	VNB	5.3173e-18
C939	Y	VNB	4.13729e-19
C940	Y#5	A1#7	5.06565e-18
C941	VPWR	VNB	3.01567e-16
C942	VGND	VNB	3.10949e-16
C943	VGND#5	B1#2	3.63062e-19
C944	A2#3	A2#1	2.54683e-18
C945	A2#5	A2#3	2.47046e-17
C946	VPWR#10	VPWR#8	7.50754e-19
C947	VPWR#10	A1#1	9.38594e-20
C948	VGND#2	VNB	4.71296e-17
C949	VPWR#10	A1#10	6.12701e-19
C950	a_27_368##10	VPWR#10	4.19357e-17
C951	a_27_368##14	VPWR#2	8.43957e-18
C952	VPWR#10	A1#12	4.68524e-18
C953	VPWR#10	A1#14	4.38429e-18
C954	VPWR#10	B1#1	5.00578e-18
C955	VGND#2	a_1235_74#	1.81062e-17
C956	VPWR#10	B1#4	4.63585e-18
C957	a_27_368##13	VPWR#10	5.4279e-17
C958	VPWR#10	A1#7	2.0822e-20
C959	VPWR#2	A4#6	2.01982e-20
C960	VPWR#10	B1#8	4.49836e-18
C961	VGND#2	A4#7	9.71076e-19
C962	VPWR#3	VPWR#2	8.74286e-17
C963	VPWR#10	B1#9	4.47634e-18
C964	VPWR#2	A4#4	5.4572e-18
C965	VPWR#10	B1#6	5.34914e-21
C966	VPWR#10	B1#2	3.70351e-20
C967	VPWR#2	VNB	4.56113e-17
C968	a_27_368##12	VPWR#10	7.15806e-17
C969	VGND#2	a_1235_74##2	2.91756e-19
C970	VPWR#2	A4#8	5.25675e-18
C971	a_27_368##9	VPWR#10	2.83492e-18
C972	a_27_368##2	VPWR#2	3.13618e-19
C973	VPWR#10	B1#3	3.81417e-20
C974	VPWR#10	A1#8	2.78987e-20
C975	VGND#2	A4#1	5.74807e-18
C976	VPWR#2	A4#11	5.30308e-19
C977	a_27_368#	VPWR#2	2.11169e-17
C978	VGND#2	a_1235_74##8	5.19931e-18
C979	VGND#2	A4#6	3.80851e-20
C980	VPWR	VPWR#10	1.88874e-16
C981	VPWR#2	A4#12	8.1728e-20
C982	VGND#3	VGND#2	1.00539e-16
C983	VPWR#10	VNB	1.01841e-16
C984	VGND#2	A4#5	5.36697e-18
*
*
.ENDS sky130_fd_sc_hs__a41oi_4
*
