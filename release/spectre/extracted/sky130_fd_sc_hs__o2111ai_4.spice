* Extracted by Quantus, converted by sky130cad/quantus.py
*
*
*
*                       LINUX           Wed Nov 18 08:53:37 2026
*
*
*
*  PROGRAM  advgen
*
*  Name           : advgen - Quantus - (64-bit)
*  Version        : 25.1.0-p047
*  Build Date     : Thu Dec 11 23:20:30 PST 2025
*
*  HSPICE LIBRARY
*
*  OPERATING_TEMPERATURE 150
*  QRC_TECH_DIR <path>/tech
*
*
*

*
.SUBCKT sky130_fd_sc_hs__o2111ai_4 VNB VPB VGND VPWR Y C1 D1 B1 A1 A2
*
*
*  caps2d version: 10
*
*
*       TRANSISTOR CARDS
*
*
XM30 a_27_74##8 D1#5 Y#13 VNB sky130_fd_pr__nfet_01v8_lvt l=0.15 w=0.74 ad=0.2109 as=0.259 pd=2.05 ps=2.18
XM26 Y#13 D1#9 a_27_74##6 VNB sky130_fd_pr__nfet_01v8_lvt l=0.15 w=0.74 ad=0.259 as=0.2072 pd=2.18 ps=2.04
XM1 a_27_74##6 D1#7 Y#6 VNB sky130_fd_pr__nfet_01v8_lvt l=0.15 w=0.74 ad=0.2072 as=0.2072 pd=2.04 ps=2.04
XM28 Y#6 D1#1 a_27_74##4 VNB sky130_fd_pr__nfet_01v8_lvt l=0.15 w=0.74 ad=0.2072 as=0.2072 pd=2.04 ps=2.04
XM6 a_27_74##4 C1#9 a_472_74##5 VNB sky130_fd_pr__nfet_01v8_lvt l=0.15 w=0.74 ad=0.2072 as=0.2072 pd=2.04 ps=2.04
XM19 a_472_74##5 C1#8 a_27_74##2 VNB sky130_fd_pr__nfet_01v8_lvt l=0.15 w=0.74 ad=0.2072 as=0.2072 pd=2.04 ps=2.04
XM3 a_472_74##3 C1#6 a_27_74##2 VNB sky130_fd_pr__nfet_01v8_lvt l=0.15 w=0.74 ad=0.2072 as=0.2072 pd=2.04 ps=2.04
XM14 a_27_74# C1#1 a_472_74##3 VNB sky130_fd_pr__nfet_01v8_lvt l=0.15 w=0.74 ad=0.2109 as=0.2072 pd=2.05 ps=2.04
XM25 a_841_74##8 B1#10 a_472_74# VNB sky130_fd_pr__nfet_01v8_lvt l=0.15 w=0.74 ad=0.2109 as=0.2072 pd=2.05 ps=2.04
XM31 a_472_74# B1#9 a_841_74##6 VNB sky130_fd_pr__nfet_01v8_lvt l=0.15 w=0.74 ad=0.2072 as=0.2072 pd=2.04 ps=2.04
XM20 a_841_74##6 B1#8 a_472_74##6 VNB sky130_fd_pr__nfet_01v8_lvt l=0.15 w=0.74 ad=0.2072 as=0.2072 pd=2.04 ps=2.04
XM18 a_472_74##6 B1#1 a_841_74##12 VNB sky130_fd_pr__nfet_01v8_lvt l=0.15 w=0.74 ad=0.2072 as=0.259 pd=2.04 ps=2.18
XM2 VGND#10 A1#14 a_841_74##12 VNB sky130_fd_pr__nfet_01v8_lvt l=0.15 w=0.74 ad=0.259 as=0.259 pd=2.18 ps=2.18
XM13 a_841_74##11 A1#12 VGND#10 VNB sky130_fd_pr__nfet_01v8_lvt l=0.15 w=0.74 ad=0.2072 as=0.259 pd=2.04 ps=2.18
XM7 VGND#9 A1#10 a_841_74##11 VNB sky130_fd_pr__nfet_01v8_lvt l=0.15 w=0.74 ad=0.2072 as=0.2072 pd=2.04 ps=2.04
XM12 a_841_74##10 A1#1 VGND#9 VNB sky130_fd_pr__nfet_01v8_lvt l=0.15 w=0.74 ad=0.2072 as=0.2072 pd=2.04 ps=2.04
XM8 VGND#8 A2#13 a_841_74##10 VNB sky130_fd_pr__nfet_01v8_lvt l=0.15 w=0.74 ad=0.259 as=0.2072 pd=2.18 ps=2.04
XM17 a_841_74##9 A2#11 VGND#8 VNB sky130_fd_pr__nfet_01v8_lvt l=0.15 w=0.74 ad=0.2664 as=0.259 pd=2.2 ps=2.18
XM29 VGND#7 A2#9 a_841_74##9 VNB sky130_fd_pr__nfet_01v8_lvt l=0.15 w=0.74 ad=0.2072 as=0.2664 pd=2.04 ps=2.2
XM24 a_841_74# A2#1 VGND#7 VNB sky130_fd_pr__nfet_01v8_lvt l=0.15 w=0.74 ad=0.2109 as=0.2072 pd=2.05 ps=2.04
XM32 Y#12 D1#8 VPWR#13 VPB sky130_fd_pr__pfet_01v8 l=0.15 w=1.12 ad=1.176 as=0.448 pd=4.34 ps=3.04
XM27 VPWR#13 D1#6 Y#14 VPB sky130_fd_pr__pfet_01v8 l=0.15 w=1.12 ad=0.448 as=0.336 pd=3.04 ps=2.84
XM15 Y#14 C1#5 VPWR#12 VPB sky130_fd_pr__pfet_01v8 l=0.15 w=1.12 ad=0.336 as=0.8064 pd=2.84 ps=3.68
XM21 VPWR#12 C1#7 Y#10 VPB sky130_fd_pr__pfet_01v8 l=0.15 w=1.12 ad=0.8064 as=0.336 pd=3.68 ps=2.84
XM0 VPWR#11 B1#7 Y#10 VPB sky130_fd_pr__pfet_01v8 l=0.15 w=1.12 ad=0.448 as=0.336 pd=3.04 ps=2.84
XM4 Y#9 B1#11 VPWR#11 VPB sky130_fd_pr__pfet_01v8 l=0.15 w=1.12 ad=0.3304 as=0.448 pd=2.83 ps=3.04
XM22 a_954_368##6 A1#8 VPWR#10 VPB sky130_fd_pr__pfet_01v8 l=0.15 w=1.12 ad=1.5848 as=0.3528 pd=5.07 ps=2.87
XM11 VPWR#10 A1#13 a_954_368##8 VPB sky130_fd_pr__pfet_01v8 l=0.15 w=1.12 ad=0.3528 as=0.336 pd=2.87 ps=2.84
XM5 VPWR#9 A1#11 a_954_368##8 VPB sky130_fd_pr__pfet_01v8 l=0.15 w=1.12 ad=0.336 as=0.336 pd=2.84 ps=2.84
XM23 a_954_368##3 A1#9 VPWR#9 VPB sky130_fd_pr__pfet_01v8 l=0.15 w=1.12 ad=0.3528 as=0.336 pd=2.87 ps=2.84
XM9 a_954_368##3 A2#7 Y#8 VPB sky130_fd_pr__pfet_01v8 l=0.15 w=1.12 ad=0.3528 as=0.3752 pd=2.87 ps=2.91
XM16 Y#8 A2#12 a_954_368##7 VPB sky130_fd_pr__pfet_01v8 l=0.15 w=1.12 ad=0.3752 as=0.392 pd=2.91 ps=2.94
XM10 a_954_368##7 A2#10 Y#1 VPB sky130_fd_pr__pfet_01v8 l=0.15 w=1.12 ad=0.392 as=0.392 pd=2.94 ps=2.94
XM33 Y#1 A2#8 a_954_368# VPB sky130_fd_pr__pfet_01v8 l=0.15 w=1.12 ad=0.392 as=0.3304 pd=2.94 ps=2.83
*
*
*       RESISTOR AND CAP/DIODE CARDS
*
Rg1	D1#1	D1#2	303.466827
Rg2	D1#2	D1#3	89.917320
Rg3	D1#3	D1#4	85.807869
Rg4	D1#4	D1#5	327.471436
Rg5	D1#2	D1#6	482.816986
Rg6	D1#3	D1#7	355.089569
Rg7	D1#3	D1#8	514.835571
Rg8	D1#4	D1#9	319.582886
Rg9	C1#1	C1#2	502.472717
Rg10	C1#2	C1#3	45.375774
Rg11	C1#3	C1#4	38.049484
Rg12	C1#4	C1#5	559.032959
Rg13	C1#2	C1#6	329.458191
Rg14	C1#2	C1#7	456.258057
Rg15	C1#3	C1#8	292.097473
Rg16	C1#4	C1#9	431.845612
Rg17	B1#1	B1#2	443.238434
Rg18	B1#2	B1#3	41.584808
Rg19	B1#3	B1#4	26.365774
Rg20	B1#4	B1#5	70.426933
Rg21	B1#5	B1#6	227.122925
Rg22	B1#6	B1#7	654.695496
Rg23	B1#2	B1#8	372.817749
Rg24	B1#4	B1#9	372.817749
Rg25	B1#5	B1#10	369.205597
Rg26	B1#6	B1#11	385.612793
Rg27	A1#1	A1#2	451.085052
Rg28	A1#2	A1#3	53.670689
Rg29	A1#3	A1#4	23.687782
Rg30	A1#4	A1#5	29.989510
Rg31	A1#5	A1#6	36.899223
Rg32	A1#6	A1#7	51.965252
Rg33	A1#7	A1#8	448.549561
Rg34	A1#2	A1#9	417.407684
Rg35	A1#3	A1#10	375.811493
Rg36	A1#4	A1#11	400.745392
Rg37	A1#5	A1#12	391.342957
Rg38	A1#6	A1#13	393.081268
Rg39	A1#7	A1#14	391.759949
Rg40	A2#1	A2#2	478.316559
Rg41	A2#2	A2#3	41.776009
Rg42	A2#3	A2#4	25.624832
Rg43	A2#4	A2#5	40.825932
Rg44	A2#5	A2#6	51.033195
Rg45	A2#6	A2#7	473.191132
Rg46	A2#2	A2#8	565.566162
Rg47	A2#3	A2#9	347.489960
Rg48	A2#3	A2#10	440.382751
Rg49	A2#5	A2#11	353.059357
Rg50	A2#5	A2#12	472.007294
Rg51	A2#6	A2#13	359.044830
Rf1	D1	D1#10	10.848897
Rf2	D1#10	D1	3.820034
Rf3	a_27_74#	a_27_74##3	50.385483
Rf4	a_27_74##3	a_27_74##5	35.574234
Rf5	a_27_74##5	a_27_74##7	58.010189
Rf6	a_27_74##7	a_27_74##8	60.048397
Rf7	a_27_74##2	a_27_74##3	15.000000
Rf8	a_27_74##4	a_27_74##5	7.500000
Rf9	a_27_74##6	a_27_74##7	15.000000
Rf10	C1	C1#3	112.603592
Rf11	a_472_74##2	a_472_74##4	62.172527
Rf12	a_472_74##4	a_472_74##5	52.653782
Rf13	a_472_74##2	a_472_74##6	51.925110
Rf14	a_472_74#	a_472_74##2	15.000000
Rf15	a_472_74##3	a_472_74##4	15.000000
Rf16	B1	B1#12	10.848897
Rf17	B1#12	B1	3.820034
Rf20	A2	A2#14	14.210527
Rf21	A2#14	A2	0.458404
Rf22	Y#1	Y#2	85.649445
Rf23	Y#2	Y#3	291.787659
Rf24	Y#3	Y#4	73.000786
Rf25	Y#4	Y#5	87.818359
Rf26	Y#5	Y	24.404734
Rf27	Y	Y#7	41.392159
Rf28	Y#2	Y#8	16.279915
Rf29	Y#3	Y#9	18.602406
Rf30	Y#4	Y#10	16.043533
Rf31	Y#5	Y#11	7.279056
Rf32	Y#11	Y#12	73.474442
Rf33	Y#7	Y#13	46.161751
Rf34	Y#11	Y#14	19.353085
Rf35	Y#6	Y#7	15.000000
Rf36	a_954_368#	a_954_368##2	101.841942
Rf37	a_954_368##2	a_954_368##4	80.459900
Rf38	a_954_368##4	a_954_368##5	68.974457
Rf39	a_954_368##5	a_954_368##6	80.696075
Rf40	a_954_368##2	a_954_368##7	18.149860
Rf41	a_954_368##5	a_954_368##8	14.409969
Rf42	a_954_368##3	a_954_368##4	7.500000
Rf43	a_841_74#	a_841_74##2	88.723526
Rf44	a_841_74##2	a_841_74##3	68.002594
Rf45	a_841_74##3	a_841_74##4	65.876305
Rf46	a_841_74##4	a_841_74##5	66.349968
Rf47	a_841_74##5	a_841_74##7	37.598705
Rf48	a_841_74##7	a_841_74##8	52.984047
Rf49	a_841_74##2	a_841_74##9	21.341251
Rf50	a_841_74##3	a_841_74##10	21.341251
Rf51	a_841_74##4	a_841_74##11	28.306047
Rf52	a_841_74##5	a_841_74##12	12.156528
Rf53	a_841_74##6	a_841_74##7	15.000000
Rf55	VGND#2	VGND#3	72.258934
Rf56	VGND#3	VGND#4	66.707092
Rf57	VGND#4	VGND#5	62.774361
Rf58	VGND#5	VGND#6	239.581100
Rf59	VGND#2	VGND#7	37.460041
Rf60	VGND#3	VGND#8	40.957939
Rf61	VGND#4	VGND#9	37.460041
Rf62	VGND#5	VGND#10	37.460041
Rf63	VPWR#1	VPWR#2	73.148537
Rf64	VPWR#2	VPWR#3	68.798325
Rf65	VPWR#3	VPWR#4	190.304825
Rf66	VPWR#4	VPWR#5	36.135464
Rf67	VPWR#5	VPWR#6	48.586033
Rf68	VPWR#6	VPWR#7	84.721497
Rf70	VPWR#2	VPWR#9	48.224632
Rf71	VPWR#3	VPWR#10	37.538910
Rf72	VPWR#4	VPWR#11	31.534731
Rf73	VPWR#6	VPWR#12	17.789598
Rf74	VPWR#7	VPWR#13	31.534731
Rf75	D1#4	D1#10	53.410934
Rf77	B1#3	B1#12	40.058201
Rf78	A1#5	A1	40.058201
Rf79	A2#4	A2#14	40.058201
Re1	VPWR#1	VPWR	2.687498
Re2	VPWR	VPWR#5	1.343749
Re3	VGND#3	VGND	2.687498
Re4	VGND	VGND#6	1.343749
*
*       CAPACITOR CARDS
*
*
C1	VPWR#13	VPWR#12	1.68389e-18
C2	VPWR#6	B1#7	2.88523e-19
C3	a_472_74##3	C1#6	3.55945e-17
C4	Y#2	A2#7	2.17141e-17
C5	VPWR#4	B1#7	1.54575e-18
C6	a_954_368##6	a_954_368##5	3.27522e-18
C7	Y#1	A2#5	5.40685e-19
C8	Y#2	Y#8	5.35286e-18
C9	A2#12	A2#3	1.88201e-19
C10	a_27_74##2	C1#6	3.29432e-17
C11	VPWR#13	Y#14	6.22435e-17
C12	a_27_74##4	C1#1	2.12572e-19
C13	a_954_368##5	A1#13	3.1772e-17
C14	Y#12	Y#14	3.31879e-18
C15	A2#3	Y#1	5.59191e-18
C16	VPWR#6	C1#7	3.81277e-18
C17	Y#2	A1#9	1.78224e-17
C18	a_27_74##2	C1#8	3.29432e-17
C19	a_27_74##4	C1#6	3.10864e-19
C20	Y#2	a_954_368##3	1.07667e-16
C21	a_472_74##6	a_841_74##6	3.73304e-17
C22	Y#12	VPWR#13	7.89938e-17
C23	a_472_74##5	C1#8	3.55945e-17
C24	a_954_368##5	A1#8	5.80342e-18
C25	a_27_74##4	C1#8	5.45185e-19
C26	Y#2	A1#11	1.27673e-17
C27	VPWR#6	C1#5	4.67142e-18
C28	A2#5	a_954_368##7	1.66188e-18
C29	Y#2	VPWR#9	1.11029e-18
C30	a_472_74##5	C1#9	2.64099e-17
C31	a_27_74##4	C1#9	2.72687e-17
C32	VGND#4	a_841_74##10	6.9777e-18
C33	Y#2	A1#13	1.27203e-17
C34	a_472_74##5	D1#1	8.77009e-19
C35	a_841_74##6	a_472_74#	2.63493e-17
C36	Y#6	C1#9	7.20716e-19
C37	Y#2	a_954_368##8	4.76058e-19
C38	C1#3	B1#5	4.66005e-19
C39	VGND#5	VGND#4	1.37529e-18
C40	VPWR#6	D1#6	2.88523e-19
C41	a_27_74##4	D1#1	3.80116e-17
C42	A2#6	Y#8	3.38068e-19
C43	Y#3	A1#8	2.06644e-17
C44	A2#9	A2#1	3.73484e-17
C45	B1#1	a_954_368##6	2.27261e-18
C46	C1#3	C1#4	1.46594e-17
C47	Y#6	D1#1	2.37029e-17
C48	Y#2	A1#8	2.69062e-19
C49	A2#5	Y#8	3.34413e-19
C50	VGND#5	a_841_74##11	5.24871e-18
C51	a_27_74##4	D1#7	8.19829e-19
C52	Y#2	VPWR#10	2.24683e-18
C53	a_27_74##8	C1#9	9.25897e-20
C54	Y#4	B1#11	1.88323e-18
C55	a_841_74##2	a_841_74#	5.40104e-19
C56	VPWR#6	D1#8	9.4842e-20
C57	Y#6	D1#7	3.54267e-17
C58	Y#3	a_954_368##6	1.4179e-16
C59	a_472_74#	a_841_74##8	6.16247e-17
C60	Y#3	B1#11	2.36017e-17
C61	A2#11	A2#9	2.63985e-17
C62	A1#7	A1#9	2.31942e-19
C63	VGND#9	A1#7	8.94762e-19
C64	a_27_74##4	D1#9	1.83787e-19
C65	a_841_74#	a_954_368#	1.06289e-17
C66	a_27_74##6	D1#7	3.37376e-17
C67	VGND#4	a_841_74##11	5.19931e-18
C68	a_27_74##8	D1#1	1.34517e-19
C69	Y#5	B1#7	4.57049e-19
C70	Y#4	B1#7	2.70433e-17
C71	a_954_368##3	A2#6	6.24456e-20
C72	a_841_74##2	VGND#7	2.10432e-17
C73	D1#4	C1#4	3.16145e-17
C74	Y#3	Y#9	1.24011e-18
C75	a_27_74##4	D1#5	2.81932e-19
C76	Y#3	B1#7	2.57243e-19
C77	a_27_74##6	D1#9	3.46365e-17
C78	a_27_74##8	D1#7	2.19979e-19
C79	a_841_74#	Y#1	9.20448e-19
C80	A2#13	A2#11	2.45237e-17
C81	Y#4	VPWR#11	1.61585e-17
C82	Y#13	D1#9	3.83573e-17
C83	Y#5	C1#7	7.58382e-19
C84	a_27_74#	a_841_74##8	2.8941e-17
C85	Y#4	C1#7	2.54699e-17
C86	a_27_74##8	D1#9	1.66927e-18
C87	a_841_74##2	a_841_74##9	1.57363e-18
C88	Y#3	VPWR#11	1.60951e-17
C89	VGND#4	A2#11	1.78207e-19
C90	a_841_74##3	VGND#8	1.55411e-17
C91	D1#5	Y#13	1.80612e-17
C92	A1#1	A2#13	3.77036e-17
C93	Y#4	Y#10	2.68731e-19
C94	Y#5	C1#5	2.4594e-17
C95	a_27_74##8	D1#5	5.0929e-17
C96	Y#2	A2#6	1.44867e-18
C97	VPWR#1	VPWR#3	1.55305e-17
C98	Y#4	C1#5	5.21948e-19
C99	Y#5	VPWR#12	3.47926e-17
C100	VGND#5	a_472_74##6	3.03907e-17
C101	Y#10	Y#3	8.15316e-19
C102	a_841_74##2	VGND#8	1.30558e-17
C103	VPWR#1	VPWR#2	6.32681e-17
C104	a_27_74#	a_472_74##3	5.93671e-17
C105	VGND#4	A2#13	6.05732e-19
C106	a_841_74##3	a_841_74##10	5.26243e-19
C107	VGND#5	a_841_74##5	2.18048e-17
C108	A1#10	A1#1	3.89179e-17
C109	Y#4	VPWR#12	3.47141e-17
C110	a_954_368##3	A1#7	6.3021e-19
C111	a_841_74##4	VGND#9	1.36294e-17
C112	Y#5	D1#6	2.03447e-17
C113	a_841_74##2	A2#1	2.05143e-19
C114	Y#2	A2#5	3.40368e-18
C115	a_841_74##5	a_841_74##11	2.76438e-18
C116	Y#5	Y#14	2.68731e-19
C117	VGND#10	A1#7	1.52374e-18
C118	a_841_74##3	A2#9	4.44571e-20
C119	VGND#4	A1#1	5.22195e-18
C120	a_841_74##3	VGND#9	1.35926e-17
C121	a_954_368#	A2#8	4.98497e-17
C122	A1#12	A1#10	4.01462e-17
C123	VGND#5	a_841_74##4	2.91756e-19
C124	a_841_74##4	a_841_74##11	1.24483e-18
C125	Y#5	D1#8	6.15599e-19
C126	VGND#3	VGND#5	3.25854e-17
C127	a_954_368##5	VPWR#3	9.00067e-18
C128	a_841_74##2	A2#9	9.72922e-18
C129	a_472_74##3	a_27_74##2	3.54547e-17
C130	Y#1	A2#8	5.3413e-17
C131	B1#1	A1#7	3.43001e-17
C132	a_841_74##5	VGND#10	5.9087e-17
C133	VGND#3	VGND#4	7.50205e-17
C134	Y#5	VPWR#13	2.00406e-17
C135	VGND#5	A1#10	8.88627e-19
C136	a_954_368#	A2#10	2.73502e-18
C137	a_954_368##7	A2#8	2.30003e-18
C138	a_841_74##3	A2#11	1.20285e-19
C139	VGND#5	a_472_74#	9.92044e-18
C140	A1#14	A1#12	2.47764e-17
C141	A1#7	VPWR#9	1.07157e-18
C142	VPWR#3	A1#7	2.76797e-20
C143	Y#1	A2#10	3.70815e-17
C144	VGND#4	A1#10	5.07176e-18
C145	a_27_74##4	a_27_74#	1.71913e-20
C146	VPWR#1	a_954_368##5	1.87031e-17
C147	VGND#4	a_841_74##4	2.91756e-19
C148	a_841_74##4	VGND#10	1.32869e-17
C149	a_954_368#	A2#12	8.03487e-19
C150	a_954_368##7	A2#10	4.87544e-17
C151	a_954_368##5	VPWR#2	8.95967e-18
C152	a_841_74##2	A2#11	1.00843e-17
C153	a_841_74##4	A2#13	3.90164e-20
C154	VGND#3	a_841_74##4	2.7847e-18
C155	a_841_74##5	a_841_74##12	4.6011e-18
C156	a_954_368##2	VPWR#1	1.04047e-16
C157	A1#8	A1#7	2.16351e-19
C158	Y#1	A2#12	4.35441e-19
C159	VGND#5	A1#12	5.24152e-18
C160	VGND#3	a_841_74##3	3.18614e-18
C161	a_27_74##2	a_472_74##5	3.83172e-17
C162	B1#1	A1#14	2.80758e-17
C163	a_841_74##3	A2#13	1.34579e-17
C164	VGND#3	a_841_74##2	3.76398e-18
C165	A2#12	a_954_368##7	2.37687e-17
C166	a_954_368#	A2#7	2.97187e-19
C167	a_954_368##3	A2#10	3.30616e-19
C168	VGND#4	A1#12	5.83339e-19
C169	Y#2	A1#7	8.74389e-18
C170	VGND#4	a_841_74##3	2.91756e-19
C171	A2#12	Y#8	2.48371e-17
C172	a_841_74##2	A2#13	9.3195e-20
C173	a_841_74##4	A1#1	9.24914e-20
C174	VPWR#3	B1#1	6.91958e-20
C175	a_841_74##5	a_472_74##6	4.85164e-17
C176	a_954_368##7	A2#7	7.2535e-19
C177	a_954_368##3	A2#12	1.55966e-18
C178	a_954_368#	A1#9	3.32722e-19
C179	VGND#5	A1#14	5.31459e-18
C180	B1#8	B1#1	4.01656e-17
C181	A1#7	a_954_368##8	5.48219e-19
C182	VPWR#2	A1#7	8.70649e-20
C183	VPWR#1	Y#2	1.72549e-17
C184	a_841_74##3	A1#1	1.86197e-17
C185	A2#7	Y#8	1.14335e-17
C186	a_841_74##5	A1#10	2.34731e-19
C187	B1#6	A1#8	2.75362e-21
C188	a_27_74##4	a_472_74##5	4.4448e-17
C189	a_954_368##3	A2#7	4.04598e-17
C190	a_954_368##7	A1#9	3.15374e-19
C191	Y#4	B1#6	9.0414e-19
C192	a_841_74##4	A1#10	1.60503e-17
C193	B1#4	B1#1	3.20043e-18
C194	a_27_74#	B1#7	6.60249e-19
C195	B1#9	B1#8	4.03243e-17
C196	a_472_74##3	B1#7	2.87315e-19
C197	VGND#5	B1#1	5.35777e-18
C198	a_954_368##3	A1#9	5.6308e-17
C199	a_841_74##3	A1#10	9.98825e-20
C200	Y#5	VPWR#6	1.34496e-19
C201	a_841_74##5	A1#12	1.43115e-18
C202	D1#5	Y#12	6.88924e-18
C203	A1#9	VPWR#9	2.47111e-17
C204	a_841_74##4	A1#12	1.65776e-17
C205	a_954_368##3	A1#11	1.45782e-18
C206	B1#10	B1#9	4.08362e-17
C207	A1#7	VPWR#10	1.12515e-18
C208	a_27_74##4	Y#6	5.02918e-17
C209	VPWR#4	B1#6	2.03167e-20
C210	A1#11	VPWR#9	2.6948e-17
C211	VPWR#10	A1#9	1.63173e-19
C212	VGND#5	B1#8	5.68927e-18
C213	a_841_74##3	A1#12	4.36499e-20
C214	a_841_74##5	A1#14	4.46029e-17
C215	Y#4	VPWR#6	2.35369e-19
C216	A1#11	a_954_368##8	2.32435e-17
C217	Y#3	B1#6	2.96597e-18
C218	a_841_74##5	a_841_74##4	7.14739e-19
C219	VPWR#10	A1#11	6.5022e-19
C220	C1#1	B1#10	4.07864e-18
C221	VPWR#9	A1#13	3.25542e-19
C222	Y#5	C1#4	6.39813e-18
C223	a_841_74##5	A1#5	3.74009e-17
C224	a_841_74##4	A1#14	8.67344e-20
C225	a_841_74##4	A1#5	7.16087e-17
C226	a_841_74##5	a_841_74##8	4.04059e-20
C227	A1#13	a_954_368##8	2.32435e-17
C228	a_841_74##3	A1#5	1.83128e-17
C229	VPWR#4	B1#5	2.48181e-19
C230	Y#6	a_27_74##6	3.61779e-17
C231	A1#13	VPWR#10	2.67164e-17
C232	VGND#5	B1#9	3.42283e-18
C233	A2	A2#6	1.86438e-17
C234	VGND#3	a_841_74#	1.6105e-17
C235	VPWR#9	A1#8	1.4546e-19
C236	Y#4	VPWR#4	2.62165e-19
C237	Y#3	B1#5	6.62283e-18
C238	a_841_74##5	B1#1	3.17249e-17
C239	A2	A2#5	3.0412e-17
C240	A2	A2#3	4.01361e-17
C241	C1#6	C1#1	3.62023e-17
C242	a_954_368##6	A1#13	9.67058e-19
C243	A2	A1#7	1.25566e-17
C244	VGND#5	A1#7	1.07118e-19
C245	VGND#3	a_841_74##9	2.18726e-17
C246	A1#8	VPWR#10	3.28054e-17
C247	a_27_74##8	a_27_74##4	9.37712e-19
C248	VGND#3	a_841_74##10	2.10127e-17
C249	a_954_368##6	A1#8	3.62323e-17
C250	VPWR#4	B1#4	1.52222e-19
C251	Y#3	B1#4	1.87123e-17
C252	C1#8	C1#6	3.62023e-17
C253	VGND#5	B1#10	1.12029e-19
C254	a_841_74##5	B1#8	1.11022e-18
C255	Y#9	A1#8	7.72782e-19
C256	Y#3	VPWR#4	1.41302e-18
C257	VGND#3	a_841_74##11	1.18512e-17
C258	a_841_74##4	a_841_74##3	5.2354e-19
C259	a_27_74##6	Y#13	3.72751e-17
C260	A1#5	Y#3	1.12783e-17
C261	a_954_368##6	B1#11	1.1601e-18
C262	A1#5	Y#2	1.11546e-16
C263	Y#9	B1#11	6.72877e-17
C264	C1#9	C1#8	3.62023e-17
C265	B1#11	VPWR#11	3.50267e-17
C266	a_841_74##5	B1#9	6.1355e-19
C267	VGND#4	A1#7	4.89177e-20
C268	Y#10	B1#11	9.17267e-19
C269	Y#9	B1#7	6.53314e-19
C270	VPWR#12	B1#11	3.63043e-19
C271	B1#7	VPWR#11	3.67485e-17
C272	D1#1	C1#9	3.69234e-17
C273	a_27_74##8	Y#13	5.28326e-17
C274	VPWR#3	B1#4	1.85553e-19
C275	a_472_74##6	B1#4	9.98478e-19
C276	Y#10	B1#7	5.40467e-17
C277	Y#5	C1#3	5.74962e-17
C278	C1#3	Y#4	8.46551e-17
C279	VPWR#12	B1#7	5.61667e-19
C280	VPWR#11	C1#7	1.38798e-18
C281	a_841_74##5	B1#10	4.15845e-19
C282	a_841_74##3	a_841_74##2	5.57916e-19
C283	Y#10	C1#7	4.58974e-17
C284	D1#7	D1#1	3.68854e-17
C285	C1#7	VPWR#12	3.79003e-17
C286	VPWR#11	C1#5	1.12252e-19
C287	a_841_74#	A2#1	2.56739e-17
C288	VGND#6	a_472_74#	3.95457e-17
C289	a_954_368#	VPWR#1	7.35308e-17
C290	Y#5	D1#4	7.60508e-18
C291	B1#5	a_954_368##6	4.78826e-19
C292	B1	A1#7	1.08658e-17
C293	VPWR#1	Y#1	1.02687e-17
C294	C1#1	B1#5	1.55466e-18
C295	D1#9	D1#7	3.61898e-17
C296	VPWR#13	C1#7	1.12252e-19
C297	C1#5	VPWR#12	4.47228e-17
C298	VGND#7	A2#1	2.95143e-17
C299	VGND#6	a_472_74##3	5.05861e-17
C300	B1	B1#6	9.73994e-19
C301	Y#14	C1#5	5.42008e-17
C302	B1	B1#5	1.84065e-17
C303	a_841_74##6	B1#4	4.69189e-18
C304	VGND#3	a_954_368#	4.52699e-18
C305	B1#4	a_954_368##6	9.31672e-18
C306	B1	B1#4	4.35615e-17
C307	a_841_74#	A2#9	1.01595e-18
C308	VPWR#13	C1#5	1.38798e-18
C309	VGND#6	a_472_74##5	2.93541e-17
C310	a_954_368##3	VPWR#1	5.29163e-17
C311	a_472_74#	B1#6	1.28254e-18
C312	VPWR#12	D1#6	5.61667e-19
C313	a_841_74##9	A2#1	8.51124e-19
C314	D1#5	D1#9	2.67448e-17
C315	VGND#6	a_27_74##4	2.69188e-17
C316	Y#14	D1#6	4.65486e-17
C317	Y#3	B1#1	2.99552e-18
C318	VGND#7	A2#9	2.8328e-17
C319	D1#6	VPWR#13	3.25117e-17
C320	VGND#6	a_27_74##6	3.8023e-17
C321	VPWR#12	D1#8	3.63043e-19
C322	a_954_368#	Y#1	7.5535e-17
C323	a_841_74#	A2#11	2.26013e-19
C324	Y#12	D1#6	7.87995e-19
C325	a_472_74#	B1#5	4.08751e-19
C326	Y#14	D1#8	9.25494e-19
C327	A2#9	a_841_74##9	1.65234e-17
C328	VGND#6	a_27_74##8	3.47123e-17
C329	B1#5	Y#9	2.95959e-19
C330	D1#8	VPWR#13	3.9815e-17
C331	VGND#7	A2#11	1.24511e-18
C332	a_954_368##7	a_954_368#	4.01887e-18
C333	Y#12	D1#8	8.51648e-17
C334	VGND#8	A2#9	1.06468e-18
C335	a_472_74#	B1#4	4.61407e-19
C336	A2#11	a_841_74##9	2.04315e-17
C337	a_841_74##8	B1#6	3.69019e-18
C338	a_841_74##10	A2#9	1.8445e-19
C339	Y#1	a_954_368##7	5.41187e-17
C340	D1#6	C1#4	8.17515e-19
C341	B1#6	VPWR#11	9.48016e-19
C342	VGND#8	A2#11	3.68451e-17
C343	A2#10	A2#8	3.4349e-17
C344	a_27_74#	C1#3	2.18239e-17
C345	a_472_74##3	C1#3	7.90807e-19
C346	a_841_74##9	A2#13	3.8666e-19
C347	a_841_74##8	B1#5	2.66348e-18
C348	C1#1	B1#7	1.35694e-17
C349	Y#10	VPWR#5	1.66734e-17
C350	a_27_74##2	C1#3	8.52087e-17
C351	a_841_74##10	A2#11	1.19813e-18
C352	a_841_74#	VGND#7	4.63641e-17
C353	a_472_74##5	C1#3	7.49697e-19
C354	A2#12	A2#10	3.47903e-17
C355	a_27_74##4	C1#3	2.42919e-17
C356	A2#13	VGND#8	1.65068e-17
C357	VGND#3	A2#1	1.49145e-18
C358	a_841_74##8	Y#3	6.38019e-18
C359	Y#6	C1#3	2.90145e-18
C360	C1	B1#6	2.01283e-17
C361	VGND#9	A2#11	1.37863e-19
C362	C1	B1#5	5.70879e-18
C363	VGND#5	B1#4	1.6218e-19
C364	VGND#3	A2#9	1.27715e-18
C365	a_841_74##8	B1#4	4.5417e-19
C366	VGND#3	A2#11	5.93087e-18
C367	a_841_74##10	A2#13	3.63006e-17
C368	a_27_74#	B1#6	1.08102e-18
C369	A2#7	A2#12	3.63666e-17
C370	a_841_74##9	a_841_74#	2.24086e-18
C371	a_27_74##4	D1#4	1.85318e-19
C372	VGND#3	A2#13	5.45963e-18
C373	Y#4	C1#1	4.09581e-19
C374	Y#6	D1#4	1.59647e-17
C375	a_954_368##3	a_954_368##7	4.22922e-18
C376	VGND#8	A1#1	2.71018e-19
C377	VGND#3	A1#1	1.95858e-18
C378	a_27_74##6	D1#4	1.18203e-18
C379	VGND#9	A2#13	1.25033e-18
C380	A2#6	A2#5	7.52203e-19
C381	VGND#3	A1#10	6.62287e-19
C382	Y#13	D1#4	1.29496e-17
C383	A1#9	A2#7	4.12764e-17
C384	a_27_74##8	D1#4	7.91564e-19
C385	a_841_74##3	A2#6	7.28221e-18
C386	a_841_74##3	A2	6.20275e-17
C387	VGND#3	A1#12	7.25711e-19
C388	A1#1	a_841_74##10	1.14152e-17
C389	a_841_74##2	A2	8.62e-17
C390	a_841_74##9	VGND#7	4.07359e-17
C391	a_954_368##3	Y#8	3.67805e-19
C392	VPWR#1	A2#6	1.35488e-20
C393	a_841_74##11	A2#13	1.61877e-19
C394	VPWR#1	A2#5	4.49712e-20
C395	a_841_74##5	A1#7	7.50859e-18
C396	A1#11	A1#9	4.82113e-17
C397	VGND#9	A1#1	3.24984e-17
C398	VPWR#1	A2#3	4.32063e-20
C399	a_841_74##5	Y#3	4.02448e-18
C400	B1#5	B1#4	3.20043e-18
C401	a_841_74##10	A1#10	4.14406e-19
C402	a_954_368##3	VPWR#2	1.96442e-17
C403	Y	C1#4	6.02327e-19
C404	A2	Y#2	9.75504e-17
C405	VGND#8	VGND#7	1.75582e-18
C406	a_841_74##3	A2#5	2.51462e-18
C407	a_841_74##11	A1#1	3.83741e-19
C408	a_472_74##3	B1#6	1.26456e-18
C409	A1#13	A1#11	4.66915e-17
C410	VPWR#12	C1#3	3.93141e-18
C411	VGND#9	A1#10	2.80849e-17
C412	a_954_368##3	VPWR#9	4.39524e-17
C413	VPWR#5	C1#1	2.47715e-20
C414	a_841_74##10	A1#12	1.81101e-19
C415	VGND#6	B1#9	2.0562e-18
C416	A1#8	A1#13	4.50891e-17
C417	VGND#8	a_841_74##9	4.06958e-17
C418	A1#10	a_841_74##11	1.39479e-17
C419	VGND#6	B1#10	5.36401e-18
C420	a_841_74##5	B1	4.99628e-17
C421	a_841_74#	A2	9.28599e-18
C422	VGND#3	A2#6	6.61642e-20
C423	VGND#6	C1#1	5.33626e-18
C424	VGND#9	A1#12	1.23785e-18
C425	D1#4	VPWR#13	1.60969e-18
C426	a_27_74##4	Y#5	9.15381e-18
C427	VGND#3	A2#5	9.56892e-20
C428	VPWR#2	A2#8	4.03959e-20
C429	A1#5	B1#1	3.05594e-18
C430	a_841_74##4	A1#7	7.7442e-18
C431	VGND#6	C1#6	5.36658e-18
C432	B1#11	A1#8	1.10139e-18
C433	D1#4	Y#12	1.31094e-17
C434	VGND#10	A1#10	1.42052e-18
C435	VPWR	B1#6	1.15097e-20
C436	VGND#6	C1#8	5.36401e-18
C437	a_841_74##10	a_841_74##9	2.31476e-18
C438	A1#12	a_841_74##11	1.7347e-17
C439	VGND#6	C1#9	4.93165e-18
C440	VPWR#1	A2#8	6.72433e-18
C441	B1	Y#3	1.57165e-16
C442	B1#7	B1#11	3.22783e-17
C443	a_841_74##2	A2#5	1.18312e-17
C444	VGND#6	D1#1	5.30069e-18
C445	VPWR#1	A2#10	6.09994e-18
C446	VGND#6	D1#7	5.35265e-18
C447	VGND#10	A1#12	3.68255e-17
C448	Y#6	Y#5	1.85782e-20
C449	VPWR#1	A2#12	6.03217e-18
C450	VGND#6	D1#9	5.35671e-18
C451	VPWR#10	VPWR#9	1.836e-18
C452	VPWR#2	A2#10	6.00994e-20
C453	C1#7	B1#7	4.62614e-17
C454	VPWR#1	A2#7	5.95522e-18
C455	VGND#6	D1#5	5.46391e-18
C456	a_841_74##11	A1#14	3.59856e-19
C457	Y#6	Y#12	2.69384e-18
C458	a_841_74##10	VGND#8	4.28366e-17
C459	A2#5	A2#3	5.77777e-18
C460	a_841_74##3	Y#2	2.8778e-18
C461	VPWR#1	A1#9	9.93651e-19
C462	VPWR#12	C1#4	4.49293e-19
C463	VPWR#6	VPWR#4	9.91238e-19
C464	C1#3	C1#1	5.13617e-18
C465	VPWR#1	A1#11	6.1874e-19
C466	a_841_74##2	A2#3	8.6474e-18
C467	C1#5	C1#7	9.43634e-18
C468	A1#14	VGND#10	1.65363e-17
C469	VPWR#1	A1#13	5.30619e-19
C470	a_841_74##3	A1#7	1.23351e-18
C471	a_954_368##6	VPWR#4	2.52975e-17
C472	A2	Y#1	5.33663e-17
C473	VGND#9	VGND#8	1.75728e-18
C474	A1#14	a_841_74##12	1.71961e-17
C475	D1#6	C1#5	4.6972e-17
C476	VPWR#2	A2#12	1.7517e-19
C477	a_841_74##6	B1	7.01069e-17
C478	Y#3	a_954_368##5	4.06638e-18
C479	C1	Y#4	1.16282e-17
C480	a_841_74##8	B1	2.60097e-17
C481	C1	Y#3	3.49491e-17
C482	VGND#10	B1#1	4.66552e-19
C483	a_954_368##6	VPWR#3	5.02116e-17
C484	a_472_74##6	A1#14	7.54567e-19
C485	D1#8	D1#6	3.05331e-17
C486	A1#5	A2#7	1.5506e-19
C487	a_27_74##8	Y#12	3.00164e-19
C488	VGND#9	a_841_74##10	4.06958e-17
C489	a_954_368##6	VPWR#10	3.55113e-17
C490	B1#1	a_841_74##12	6.03603e-18
C491	A1#5	A1#9	2.24117e-18
C492	VPWR#5	B1#7	1.60996e-18
C493	Y#9	VPWR#4	2.06809e-17
C494	A1#7	A2#6	3.28027e-17
C495	a_841_74#	A2#3	1.15047e-17
C496	VPWR#5	C1#7	1.59361e-18
C497	VGND#10	B1#8	2.67612e-19
C498	Y#2	a_954_368##5	8.35351e-17
C499	VGND#6	B1#7	4.10081e-20
C500	Y	Y#5	3.25495e-17
C501	VPWR#2	A2#7	4.18006e-19
C502	a_472_74##6	B1#1	3.0057e-17
C503	VPWR	VPWR#6	7.3367e-17
C504	A1#5	A1#8	1.81132e-18
C505	VPWR	VPWR#4	9.53872e-17
C506	VPWR	VPWR#3	1.00209e-16
C507	Y#6	D1	9.54051e-18
C508	VPWR#6	VPWR#11	3.64861e-19
C509	a_841_74##11	a_841_74##10	2.17214e-18
C510	Y#13	D1	4.84153e-17
C511	a_27_74##8	D1	3.24821e-17
C512	a_954_368##2	Y#1	2.126e-17
C513	a_472_74#	C1	3.04043e-18
C514	a_841_74##8	C1	1.62647e-17
C515	a_27_74#	C1	2.73356e-17
C516	a_472_74##3	C1	3.09068e-18
C517	VGND#10	B1#9	1.51085e-19
C518	Y#9	a_954_368##6	5.44605e-17
C519	VPWR	a_954_368##5	1.99037e-18
C520	VPWR#3	A1#9	9.67286e-20
C521	a_472_74##6	B1#8	3.65859e-17
C522	VPWR	Y#5	3.19703e-18
C523	VPWR	Y#4	3.47771e-18
C524	C1#3	B1#7	1.80601e-17
C525	VPWR	Y#3	1.11438e-17
C526	VPWR	Y#2	1.43049e-18
C527	VPWR#2	A1#9	4.8945e-18
C528	a_841_74##11	VGND#9	4.00474e-17
C529	a_841_74##6	B1#8	3.67687e-17
C530	VGND	VGND#5	1.10608e-16
C531	a_954_368##2	a_954_368##7	1.26724e-18
C532	VGND#10	B1#10	1.35349e-19
C533	VPWR#1	A1#5	6.13025e-18
C534	D1	Y#12	1.15646e-16
C535	VGND	a_841_74##5	2.19137e-17
C536	VGND	a_841_74##4	1.18644e-19
C537	VGND#3	A1#5	5.45236e-18
C538	B1	B1#1	1.2982e-17
C539	VGND#7	A2#3	1.53096e-18
C540	D1#4	D1#6	3.55877e-19
C541	Y#2	a_954_368##2	2.16002e-17
C542	a_954_368##2	A2#6	3.69243e-20
C543	VPWR#11	Y#9	6.22435e-17
C544	VGND#6	B1#6	1.54441e-19
C545	a_472_74##5	C1#4	1.9687e-19
C546	VGND	Y#5	4.51816e-18
C547	VPWR#3	A1#11	5.82836e-19
C548	VGND#10	VGND#9	1.97731e-18
C549	VGND	Y#4	3.92518e-18
C550	a_841_74##6	B1#9	3.7422e-17
C551	VGND#6	B1#5	5.67139e-20
C552	A2#6	VNB	2.99906e-17
C553	A2#5	VNB	4.80038e-17
C554	A2#3	VNB	8.43993e-17
C555	a_954_368##2	A2#10	2.11867e-17
C556	A1#7	VNB	1.13606e-16
C557	a_954_368##5	A1#7	1.74421e-18
C558	A2	A2#12	2.07841e-18
C559	a_841_74##5	B1#4	2.01222e-18
C560	a_954_368##5	a_954_368##3	3.01982e-18
C561	VPWR#2	A1#11	5.29615e-18
C562	B1#6	VNB	2.7507e-17
C563	VPWR#5	C1#3	3.18104e-20
C564	B1#5	VNB	3.85937e-17
C565	VGND#6	B1#4	3.56886e-20
C566	B1#4	VNB	6.17095e-17
C567	A2	A2#7	2.0979e-18
C568	C1#4	VNB	2.87729e-17
C569	A2	A1#9	9.61627e-19
C570	VGND#6	C1#3	3.72403e-19
C571	a_472_74#	B1#9	3.61675e-17
C572	Y#10	Y#9	2.07064e-18
C573	a_954_368##2	Y#8	5.0961e-19
C574	VGND#6	D1#4	5.20741e-19
C575	VPWR#3	VPWR#2	6.99578e-19
C576	VGND#6	C1#4	4.50568e-20
C577	VGND	a_472_74##6	1.91937e-17
C578	Y#5	Y#4	2.36557e-18
C579	VGND#10	a_841_74##11	4.00211e-17
C580	VGND	a_841_74##6	7.18487e-18
C581	VGND	a_472_74#	3.07156e-17
C582	VGND	a_841_74##8	7.75544e-18
C583	a_954_368##2	A2#5	1.07197e-19
C584	VPWR	a_954_368##6	5.49656e-17
C585	VGND	a_27_74#	6.08305e-18
C586	C1	C1#1	4.21983e-18
C587	VGND	a_472_74##3	3.12566e-17
C588	VPWR	Y#9	1.75892e-17
C589	VGND	a_27_74##2	7.73574e-18
C590	D1	D1#5	2.16381e-17
C591	VPWR	VPWR#11	2.22758e-17
C592	VGND	a_472_74##5	1.85444e-17
C593	VPWR	Y#10	1.67949e-17
C594	VGND	a_27_74##4	2.14929e-17
C595	VPWR	VPWR#12	3.89357e-17
C596	VGND	Y#6	8.24796e-18
C597	Y#10	VPWR#11	6.22197e-17
C598	VPWR#3	A1#13	5.46063e-18
C599	VGND	a_27_74##6	2.33534e-17
C600	VPWR	Y#14	1.80061e-17
C601	VGND	Y#13	6.82423e-18
C602	VPWR	VPWR#13	2.22701e-17
C603	VGND	a_27_74##8	2.44282e-17
C604	VPWR	Y#12	4.58865e-17
C605	a_954_368##2	A2#12	1.58878e-17
C606	C1#3	D1#4	7.68155e-18
C607	Y#2	A2#8	4.39187e-19
C608	a_472_74#	B1#10	3.95639e-17
C609	a_954_368##5	VPWR#9	3.87071e-17
C610	B1	A1#8	1.26619e-18
C611	VPWR#2	A1#13	5.65677e-19
C612	VPWR#1	A2	1.14766e-17
C613	VPWR#6	VNB	3.60565e-17
C614	VGND#3	A2	8.5104e-18
C615	VPWR#4	VNB	5.12666e-17
C616	VPWR#3	VNB	5.54652e-17
C617	VPWR#2	VNB	2.91488e-17
C618	VPWR#12	VPWR#11	1.68389e-18
C619	VGND#5	VNB	6.5872e-17
C620	VGND#4	VNB	2.70923e-17
C621	a_841_74##8	B1#10	4.90548e-17
C622	Y#14	VPWR#6	8.44616e-18
C623	a_27_74##4	C1#4	1.46857e-18
C624	a_841_74##5	VNB	5.59572e-18
C625	a_841_74##4	VNB	5.68391e-19
C626	VGND#8	A2#6	3.78553e-19
C627	a_841_74##3	VNB	1.87369e-18
C628	a_841_74##2	VNB	8.11043e-19
C629	a_954_368##5	VNB	2.08637e-18
C630	a_954_368##2	VNB	5.8189e-18
C631	C1	A1#8	3.10709e-20
C632	a_954_368##2	A2#3	3.65368e-19
C633	Y#5	VNB	2.09887e-18
C634	Y#4	VNB	1.12672e-18
C635	D1	D1#6	7.37432e-19
C636	Y#3	VNB	4.86183e-18
C637	A1#5	A2#6	2.28858e-18
C638	Y#2	VNB	1.64869e-19
C639	A1#5	A2	4.28536e-17
C640	C1	B1#7	5.91654e-18
C641	D1	D1#8	3.4318e-18
C642	VGND	B1#1	1.36538e-18
C643	VGND	B1#8	6.52744e-19
C644	VGND	B1#9	7.38356e-19
C645	a_27_74#	B1#10	6.70819e-19
C646	VGND	B1#10	7.6453e-19
C647	a_841_74#	VNB	4.50801e-17
C648	VGND#7	VNB	1.54625e-18
C649	VGND	C1#1	7.28553e-19
C650	C1	D1#6	1.61763e-19
C651	a_841_74##9	VNB	4.9792e-18
C652	VGND#8	VNB	3.86233e-19
C653	VGND	C1#6	7.38395e-19
C654	VPWR#3	A1#8	5.80239e-18
C655	Y#2	A2#10	1.58292e-18
C656	VPWR#12	Y#10	7.25498e-17
C657	a_841_74##10	VNB	2.12109e-18
C658	VGND#9	VNB	3.42804e-20
C659	VGND	C1#8	7.32117e-19
C660	a_841_74##11	VNB	4.55126e-18
C661	VGND#10	VNB	1.11516e-18
C662	VGND	C1#9	1.60477e-18
C663	a_472_74##6	VNB	3.09233e-18
C664	VGND	D1#1	7.54777e-19
C665	B1	A1#5	4.27784e-17
C666	a_954_368##5	a_954_368##8	1.02659e-18
C667	a_841_74##6	VNB	5.40264e-19
C668	a_472_74#	VNB	8.39514e-18
C669	VGND	D1#7	7.85757e-19
C670	a_841_74##8	VNB	4.19263e-18
C671	a_27_74#	VNB	3.21268e-18
C672	VGND	D1#9	7.93336e-19
C673	a_472_74##3	VNB	8.56847e-18
C674	VPWR	A1#13	2.90828e-20
C675	a_27_74##2	VNB	2.39899e-19
C676	VGND	D1#5	1.51195e-18
C677	Y	D1#6	3.81962e-18
C678	a_472_74##5	VNB	2.9651e-18
C679	VPWR	A1#8	7.55187e-19
C680	a_27_74##4	VNB	4.66723e-18
C681	a_841_74##8	C1#1	6.83756e-19
C682	Y#6	VNB	1.07359e-18
C683	Y	D1#8	9.93943e-19
C684	B1	C1#3	7.64409e-19
C685	Y#2	Y#1	2.59148e-18
C686	a_27_74##6	VNB	4.12104e-18
C687	VPWR	B1#11	2.98132e-19
C688	VPWR#2	A1#8	2.44613e-19
C689	a_27_74##8	VNB	4.41735e-17
C690	VPWR	B1#7	5.50637e-19
C691	a_954_368#	VNB	6.1232e-17
C692	VPWR	C1#7	4.0468e-19
C693	a_954_368##5	A1#9	1.22713e-18
C694	a_954_368##3	VNB	3.0385e-18
C695	VGND#8	A2#5	1.21977e-18
C696	VPWR#9	VNB	2.79388e-18
C697	A1#5	A1#7	6.66118e-17
C698	VPWR#10	VNB	2.23731e-18
C699	VPWR	D1#6	1.23993e-19
C700	a_954_368##6	VNB	1.95684e-17
C701	Y#9	VNB	7.27575e-18
C702	D1	D1#4	4.41821e-17
C703	VPWR	D1#8	1.171e-18
C704	VPWR#11	VNB	3.90042e-18
C705	Y#10	VNB	2.11065e-18
C706	VPWR#12	VNB	3.08637e-18
C707	Y#14	VNB	2.19416e-18
C708	VPWR#13	VNB	3.92129e-18
C709	C1	C1#3	8.79357e-19
C710	VPWR#6	B1#11	9.4842e-20
C711	Y#12	VNB	6.12806e-17
C712	VGND	B1#7	4.9298e-21
C713	A2#1	VNB	2.64414e-17
C714	A2#9	VNB	2.29391e-17
C715	C1	D1#4	8.48163e-20
C716	A2#11	VNB	2.32902e-17
C717	VPWR#13	VPWR#6	3.64861e-19
C718	A2#13	VNB	2.43621e-17
C719	VPWR	VPWR#5	2.2474e-17
C720	a_27_74#	C1#1	4.72133e-17
C721	A1#1	VNB	2.47158e-17
C722	A1#10	VNB	2.454e-17
C723	A1#12	VNB	2.51781e-17
C724	A1#14	VNB	2.76677e-17
C725	Y	C1#3	6.71664e-18
C726	B1#1	VNB	4.45163e-17
C727	B1#8	VNB	2.99423e-17
C728	B1#9	VNB	3.06372e-17
C729	Y	D1#4	1.62806e-17
C730	B1#10	VNB	3.35896e-17
C731	VPWR	A1#5	2.80069e-18
C732	C1#1	VNB	4.66889e-17
C733	C1#6	VNB	2.74265e-17
C734	C1#8	VNB	2.73095e-17
C735	VPWR#4	B1#11	2.5923e-18
C736	C1#9	VNB	2.527e-17
C737	D1#1	VNB	2.76695e-17
C738	VPWR	C1#3	7.85798e-18
C739	D1#7	VNB	2.68029e-17
C740	VGND	VGND#6	2.91707e-16
C741	D1#9	VNB	2.74206e-17
C742	D1#5	VNB	7.89395e-17
C743	a_954_368#	A2#3	1.23948e-19
C744	Y#2	A2#12	3.7152e-17
C745	A2#8	VNB	3.27292e-17
C746	VGND	A1#5	2.25023e-18
C747	A2#10	VNB	3.12953e-17
C748	A2#12	VNB	3.24662e-17
C749	A2#7	VNB	3.24461e-17
C750	A1#9	VNB	3.23972e-17
C751	VGND	C1#3	6.24809e-18
C752	A1#11	VNB	3.20065e-17
C753	A1#13	VNB	3.1363e-17
C754	A1#8	VNB	3.57349e-17
C755	a_472_74##3	C1#1	4.01816e-17
C756	B1#11	VNB	3.38256e-17
C757	C1	B1	3.40713e-17
C758	B1#7	VNB	4.57592e-17
C759	a_954_368##5	VPWR#10	5.66984e-17
C760	Y#14	VPWR#12	7.25165e-17
C761	C1#7	VNB	3.27114e-17
C762	C1#5	VNB	3.23286e-17
C763	D1#6	VNB	3.24228e-17
C764	D1#8	VNB	3.83079e-17
C765	Y#2	a_954_368##7	5.99354e-17
C766	VPWR#1	VNB	2.57586e-16
C767	VGND#3	VNB	1.98427e-16
C768	D1	Y	3.10448e-17
C769	Y#6	C1#4	2.57943e-18
C770	VPWR#5	VNB	1.26644e-17
C771	VPWR	B1	1.2275e-17
C772	VGND#6	VNB	1.6564e-16
C773	A1#5	VNB	6.70238e-18
C774	VPWR	D1	9.01128e-18
C775	C1#3	VNB	8.96726e-17
C776	VGND	B1	9.26208e-18
C777	VPWR	C1	4.1119e-18
C778	D1#4	VNB	9.54898e-17
C779	VGND	D1	6.66737e-18
C780	a_954_368##5	A1#11	3.50227e-17
C781	VPWR	Y	1.68337e-18
C782	VGND	C1	4.84884e-18
C783	A2	VNB	2.50185e-17
C784	B1	VNB	2.73865e-17
C785	D1	VNB	3.65845e-17
C786	A1#1	A2#6	1.42161e-18
C787	C1	VNB	1.03475e-17
C788	Y	VNB	1.14567e-18
C789	VPWR	VNB	3.03562e-16
C790	VGND	VNB	3.21156e-16
C791	VGND#2	a_841_74##9	7.1753e-18
C792	VPWR#7	VNB	7.28044e-17
C793	Y#5	VPWR#7	1.6661e-19
C794	VGND#2	A2#11	8.46413e-19
C795	Y#12	VPWR#7	5.78917e-17
C796	VPWR#7	VPWR#6	9.91238e-19
C797	VGND#2	A2#3	3.23834e-20
C798	VPWR#7	D1#6	2.57649e-18
C799	VGND#3	VGND#2	9.83611e-17
C800	Y#14	VPWR#7	8.07018e-18
C801	VGND#2	VNB	4.69749e-17
C802	VPWR#7	D1#5	9.31103e-20
C803	VGND#2	A2#9	5.113e-18
C804	VGND#2	A2#5	6.65837e-20
C805	VGND#2	a_841_74#	1.7841e-17
C806	VPWR#7	D1#8	2.57874e-18
C807	VPWR	VPWR#7	1.25088e-16
C808	VGND#2	a_841_74##2	2.91756e-19
C809	VGND#2	A2#1	5.06676e-18
C810	VPWR#7	D1#4	1.38258e-19
*
*
.ENDS sky130_fd_sc_hs__o2111ai_4
*
