* Extracted by Quantus, converted by sky130cad/quantus.py
*
*
*
*                       LINUX           Wed Nov 18 09:09:38 2026
*
*
*
*  PROGRAM  advgen
*
*  Name           : advgen - Quantus - (64-bit)
*  Version        : 25.1.0-p047
*  Build Date     : Thu Dec 11 23:20:30 PST 2025
*
*  HSPICE LIBRARY
*
*  OPERATING_TEMPERATURE 150
*  QRC_TECH_DIR <path>/tech
*
*
*

*
.SUBCKT sky130_fd_sc_hs__sdfrtn_1 VNB VPB VGND RESET_B VPWR Q SCE CLK_N SCD D
*
*
*  caps2d version: 10
*
*
*       TRANSISTOR CARDS
*
*
XM35 a_27_88##8 SCE#4 VGND#16 VNB sky130_fd_pr__nfet_01v8_lvt l=0.15 w=0.42 ad=0.1197 as=0.1491 pd=1.41 ps=1.55
XM32 a_239_81##2 a_27_88# a_324_81# VNB sky130_fd_pr__nfet_01v8_lvt l=0.15 w=0.42 ad=0.1155 as=0.0882 pd=1.39 ps=1.26
XM5 a_324_81# D#1 a_284_464##8 VNB sky130_fd_pr__nfet_01v8_lvt l=0.15 w=0.42 ad=0.0882 as=0.2352 pd=1.26 ps=1.96
XM6 a_284_464##8 SCE#6 a_538_81# VNB sky130_fd_pr__nfet_01v8_lvt l=0.15 w=0.42 ad=0.2352 as=0.1008 pd=1.96 ps=1.32
XM33 a_538_81# SCD#1 a_239_81# VNB sky130_fd_pr__nfet_01v8_lvt l=0.15 w=0.42 ad=0.1008 as=0.1218 pd=1.32 ps=1.42
XM30 a_239_81# RESET_B#1 VGND#15 VNB sky130_fd_pr__nfet_01v8_lvt l=0.15 w=0.42 ad=0.1218 as=0.447375 pd=1.42 ps=3.15
XM36 VGND#15 CLK_N#3 a_854_74##15 VNB sky130_fd_pr__nfet_01v8_lvt l=0.15 w=0.74 ad=0.447375 as=0.2109 pd=3.15 ps=2.05
XM34 VGND#14 a_854_74##10 a_1074_88##11 VNB sky130_fd_pr__nfet_01v8_lvt l=0.15 w=0.74 ad=0.3899 as=0.2109 pd=2.88 ps=2.05
XM8 a_284_464##6 a_1074_88##2 a_1272_131##9 VNB sky130_fd_pr__nfet_01v8_lvt l=0.15 w=0.42 ad=0.1197 as=0.2289 pd=1.41 ps=1.93
XM19 a_1272_131##9 a_854_74##3 a_1411_131# VNB sky130_fd_pr__nfet_01v8_lvt l=0.15 w=0.42 ad=0.2289 as=0.1008 pd=1.93 ps=1.32
XM31 a_1411_131# a_1429_308# a_1489_131# VNB sky130_fd_pr__nfet_01v8_lvt l=0.15 w=0.42 ad=0.1008 as=0.1008 pd=1.32 ps=1.32
XM14 a_1489_131# RESET_B#4 VGND#13 VNB sky130_fd_pr__nfet_01v8_lvt l=0.15 w=0.42 ad=0.1008 as=0.328025 pd=1.32 ps=2.82
XM7 VGND#13 a_1272_131##3 a_1429_308##5 VNB sky130_fd_pr__nfet_01v8_lvt l=0.15 w=0.64 ad=0.328025 as=0.3584 pd=2.82 ps=2.4
XM22 a_1429_308##5 a_854_74##2 a_1827_144##8 VNB sky130_fd_pr__nfet_01v8_lvt l=0.15 w=0.64 ad=0.3584 as=0.62565 pd=2.4 ps=4.26
XM11 a_1827_144##8 a_1074_88##5 a_2073_74# VNB sky130_fd_pr__nfet_01v8_lvt l=0.15 w=0.42 ad=0.62565 as=0.105 pd=4.26 ps=1.34
XM38 a_2073_74# a_2087_410# VGND#12 VNB sky130_fd_pr__nfet_01v8_lvt l=0.15 w=0.42 ad=0.105 as=0.1722 pd=1.34 ps=1.66
XM20 VGND#12 RESET_B#7 a_2265_74# VNB sky130_fd_pr__nfet_01v8_lvt l=0.15 w=0.42 ad=0.1722 as=0.1008 pd=1.66 ps=1.32
XM16 a_2265_74# a_1827_144##3 a_2087_410##4 VNB sky130_fd_pr__nfet_01v8_lvt l=0.15 w=0.42 ad=0.1008 as=0.21 pd=1.32 ps=1.84
XM2 a_2492_424##5 a_1827_144# VGND#11 VNB sky130_fd_pr__nfet_01v8_lvt l=0.15 w=0.55 ad=0.15675 as=0.30395 pd=1.67 ps=2.34
XM17 VGND#11 a_2492_424# Q#3 VNB sky130_fd_pr__nfet_01v8_lvt l=0.15 w=0.74 ad=0.30395 as=0.2109 pd=2.34 ps=2.05
XM29 a_27_88##9 SCE#5 VPWR#22 VPB sky130_fd_pr__pfet_01v8 l=0.15 w=0.64 ad=0.1888 as=0.192 pd=1.87 ps=1.88
XM13 VPWR#22 SCE#1 a_206_464# VPB sky130_fd_pr__pfet_01v8 l=0.15 w=0.64 ad=0.192 as=0.1536 pd=1.88 ps=1.76
XM25 a_206_464# D#3 a_284_464##7 VPB sky130_fd_pr__pfet_01v8 l=0.15 w=0.64 ad=0.1536 as=0.5024 pd=1.76 ps=2.85
XM39 a_284_464##7 a_27_88##3 a_471_464# VPB sky130_fd_pr__pfet_01v8 l=0.15 w=0.64 ad=0.5024 as=0.1536 pd=2.85 ps=1.76
XM26 a_471_464# SCD#3 VPWR#21 VPB sky130_fd_pr__pfet_01v8 l=0.15 w=0.64 ad=0.1536 as=0.36895 pd=1.76 ps=2.69
XM0 VPWR#21 RESET_B#3 a_284_464##3 VPB sky130_fd_pr__pfet_01v8 l=0.15 w=0.64 ad=0.36895 as=0.1888 pd=2.69 ps=1.87
XM21 VPWR#20 CLK_N#1 a_854_74##13 VPB sky130_fd_pr__pfet_01v8 l=0.15 w=1.12 ad=0.4144 as=0.3304 pd=2.98 ps=2.83
XM3 VPWR#19 a_854_74##9 a_1074_88##12 VPB sky130_fd_pr__pfet_01v8 l=0.15 w=1.12 ad=0.3304 as=0.3304 pd=2.83 ps=2.83
XM4 a_284_464# a_854_74##8 a_1272_131##7 VPB sky130_fd_pr__pfet_01v8 l=0.15 w=0.42 ad=0.1239 as=0.126 pd=1.43 ps=1.44
XM27 a_1272_131##7 a_1074_88##4 a_1384_508# VPB sky130_fd_pr__pfet_01v8 l=0.15 w=0.42 ad=0.126 as=0.1008 pd=1.44 ps=1.32
XM37 a_1384_508# a_1429_308##3 VPWR#18 VPB sky130_fd_pr__pfet_01v8 l=0.15 w=0.42 ad=0.1008 as=0.126 pd=1.32 ps=1.44
XM18 VPWR#18 RESET_B#6 a_1272_131##8 VPB sky130_fd_pr__pfet_01v8 l=0.15 w=0.42 ad=0.126 as=0.1239 pd=1.44 ps=1.43
XM9 VPWR#17 a_1272_131# a_1429_308##7 VPB sky130_fd_pr__pfet_01v8 l=0.15 w=1 ad=0.285 as=0.785 pd=2.57 ps=3.57
XM1 a_1429_308##7 a_1074_88##7 a_1827_144##11 VPB sky130_fd_pr__pfet_01v8 l=0.15 w=1 ad=0.785 as=0.3128 pd=3.57 ps=2.73
XM23 a_1827_144##11 a_854_74##11 a_2042_508# VPB sky130_fd_pr__pfet_01v8 l=0.15 w=0.42 ad=0.3128 as=0.1092 pd=2.73 ps=1.36
XM24 a_2042_508# a_2087_410##3 VPWR#16 VPB sky130_fd_pr__pfet_01v8 l=0.15 w=0.42 ad=0.1092 as=0.2625 pd=1.36 ps=2.09
XM28 VPWR#16 RESET_B#9 a_2087_410##7 VPB sky130_fd_pr__pfet_01v8 l=0.15 w=0.42 ad=0.2625 as=0.126 pd=2.09 ps=1.44
XM10 a_2087_410##7 a_1827_144##6 VPWR#15 VPB sky130_fd_pr__pfet_01v8 l=0.15 w=0.42 ad=0.126 as=0.1449 pd=1.44 ps=1.53
XM15 a_2492_424##7 a_1827_144##7 VPWR#14 VPB sky130_fd_pr__pfet_01v8 l=0.15 w=0.84 ad=0.2478 as=0.4564 pd=2.27 ps=3.1
XM12 VPWR#14 a_2492_424##4 Q#1 VPB sky130_fd_pr__pfet_01v8 l=0.15 w=1.12 ad=0.4564 as=0.336 pd=3.1 ps=2.84
*
*
*       RESISTOR AND CAP/DIODE CARDS
*
Rg1	SCE#1	SCE#2	354.089325
Rg2	SCE#2	SCE#3	36.515739
Rg3	SCE#3	SCE#4	518.770752
Rg4	SCE#2	SCE#5	339.441101
Rg5	a_27_88#	a_27_88##2	216.119781
Rg6	D#1	D#2	695.520752
Rg7	D#2	D#3	467.481720
Rg8	a_27_88##3	a_27_88##4	414.695190
Rg9	SCE#6	SCE#7	259.247986
Rg10	SCD#1	SCD#2	554.698364
Rg11	SCD#2	SCD#3	491.832642
Rg12	RESET_B#1	RESET_B#2	483.139801
Rg13	RESET_B#2	RESET_B#3	391.580994
Rg14	CLK_N#1	CLK_N#2	487.389984
Rg15	CLK_N#2	CLK_N#3	348.047638
Rg16	a_1074_88#	a_1074_88##2	413.765991
Rg17	a_1074_88##3	a_1074_88##4	434.360352
Rg18	a_1429_308#	a_1429_308##2	419.840759
Rg19	a_1429_308##2	a_1429_308##3	456.517151
Rg20	RESET_B#4	RESET_B#5	379.670441
Rg21	RESET_B#5	RESET_B#6	517.399109
Rg22	a_1272_131#	a_1272_131##2	441.702118
Rg23	a_1272_131##2	a_1272_131##3	297.761749
Rg24	a_854_74#	a_854_74##2	278.662445
Rg25	a_854_74##2	a_854_74##3	1938.162598
Rg26	a_854_74##3	a_854_74##4	772.994812
Rg27	a_854_74##4	a_854_74##5	280.857391
Rg28	a_854_74##5	a_854_74##6	22.806219
Rg29	a_854_74##6	a_854_74##7	207.525604
Rg30	a_854_74##4	a_854_74##8	836.823181
Rg31	a_854_74##5	a_854_74##9	442.856445
Rg32	a_854_74##6	a_854_74##10	341.113190
Rg33	a_1074_88##5	a_1074_88##6	463.071716
Rg34	a_1074_88##6	a_1074_88##7	654.367004
Rg35	a_854_74##11	a_854_74##12	591.340088
Rg36	a_2087_410#	a_2087_410##2	876.061035
Rg37	a_2087_410##2	a_2087_410##3	233.787552
Rg38	RESET_B#7	RESET_B#8	394.016998
Rg39	RESET_B#8	RESET_B#9	693.099670
Rg40	a_1827_144#	a_1827_144##2	755.928711
Rg41	a_1827_144##2	a_1827_144##3	221.143997
Rg42	a_1827_144##2	a_1827_144##4	29.373684
Rg43	a_1827_144##4	a_1827_144##5	286.952454
Rg44	a_1827_144##5	a_1827_144##6	369.980438
Rg45	a_1827_144##5	a_1827_144##7	838.396484
Rg46	a_2492_424#	a_2492_424##2	400.425018
Rg47	a_2492_424##2	a_2492_424##3	293.203369
Rg48	a_2492_424##2	a_2492_424##4	447.434448
Rf1	D#2	D	165.398514
Rf2	a_27_88##4	a_27_88##6	329.064026
Rf3	a_27_88##6	a_27_88##7	62.857162
Rf4	a_27_88##7	a_27_88##8	34.771320
Rf5	a_27_88##6	a_27_88##9	21.060150
Rf6	a_27_88##7	a_27_88##2	227.944916
Rf7	SCE#7	SCE	166.744659
Rf8	SCE	SCE#3	191.591324
Rf9	SCD#4	SCD	1.649041
Rf10	SCD#2	SCD#6	161.881851
Rf11	SCD#4	SCD#6	0.755555
Rf12	SCD#7	SCD	1.649041
Rf13	SCD#6	SCD#7	10.426665
Rf14	a_239_81#	a_239_81##2	174.984604
Rf15	RESET_B	RESET_B#2	90.878372
Rf16	CLK_N#4	CLK_N#2	161.706955
Rf17	CLK_N	CLK_N#6	1.474148
Rf18	CLK_N#4	CLK_N#6	4.591745
Rf19	a_854_74##13	a_854_74##7	54.482704
Rf20	a_854_74##7	a_854_74##15	79.190208
Rf21	a_284_464#	a_284_464##2	184.114258
Rf22	a_284_464##2	a_284_464##4	38.722599
Rf23	a_284_464##2	a_284_464##5	88.921394
Rf24	a_284_464##5	a_284_464##6	202.229538
Rf25	a_284_464##4	a_284_464##7	121.414375
Rf26	a_284_464##5	a_284_464##8	157.404541
Rf27	a_284_464##3	a_284_464##4	7.500000
Rf28	RESET_B#5	RESET_B#13	172.766296
Rf29	a_1272_131##2	a_1272_131##5	215.465195
Rf30	a_1272_131##5	a_1272_131##6	74.368843
Rf31	a_1272_131##6	a_1272_131##7	20.614525
Rf32	a_1272_131##5	a_1272_131##8	30.955824
Rf33	a_1272_131##6	a_1272_131##9	116.468445
Rf34	a_1429_308##2	a_1429_308##6	274.446259
Rf35	a_1429_308##6	a_1429_308##7	76.445137
Rf36	a_1429_308##5	a_1429_308##6	15.000000
Rf37	a_1074_88##6	a_1074_88#	396.497925
Rf38	a_1074_88#	a_1074_88##10	125.064941
Rf39	a_1074_88##10	a_1074_88##11	27.384722
Rf40	a_1074_88##10	a_1074_88##13	25.401381
Rf41	a_1074_88##13	a_1074_88##3	195.960571
Rf42	a_1074_88##12	a_1074_88##13	15.000000
Rf43	a_854_74##12	a_854_74#	394.683533
Rf44	RESET_B#14	RESET_B#8	173.506927
Rf45	a_1827_144##9	a_1827_144##8	40.195053
Rf46	a_1827_144##9	a_1827_144##10	157.981705
Rf47	a_1827_144##10	a_1827_144##11	191.427551
Rf48	a_1827_144##8	a_1827_144##9	15.000000
Rf49	a_2087_410##4	a_2087_410##5	189.979736
Rf50	a_2087_410##5	a_2087_410##2	228.426819
Rf51	a_2087_410##5	a_2087_410##7	26.437206
Rf52	a_2492_424##5	a_2492_424##3	46.896568
Rf53	a_2492_424##3	a_2492_424##7	44.721207
Rf54	Q	Q#2	0.196836
Rf55	Q#2	Q	14.369054
Rf56	Q	Q#4	7.282945
Rf57	Q#4	Q	7.282945
Rf58	Q#1	Q#2	5.000000
Rf59	Q#3	Q#4	7.500000
Rf60	VPWR#1	VPWR#2	39.422733
Rf61	VPWR#2	VPWR#3	79.941223
Rf62	VPWR#3	VPWR#4	83.047264
Rf63	VPWR#4	VPWR#5	60.426147
Rf64	VPWR#5	VPWR#6	118.317268
Rf65	VPWR#6	VPWR#7	75.980797
Rf66	VPWR#7	VPWR#8	165.102402
Rf67	VPWR#8	VPWR#9	79.210724
Rf68	VPWR#9	VPWR#10	52.206570
Rf69	VPWR#10	VPWR#11	27.734655
Rf70	VPWR#11	VPWR#12	164.314545
Rf72	VPWR#2	VPWR#14	38.286041
Rf73	VPWR#3	VPWR#15	32.342297
Rf74	VPWR#4	VPWR#16	24.455004
Rf75	VPWR#6	VPWR#17	31.141060
Rf76	VPWR#7	VPWR#18	38.050537
Rf77	VPWR#8	VPWR#19	32.145462
Rf78	VPWR#9	VPWR#20	32.145462
Rf79	VPWR#11	VPWR#21	22.500479
Rf80	VPWR#12	VPWR#22	32.342297
Rf81	VGND#1	VGND#2	39.422733
Rf82	VGND#2	VGND#3	158.794922
Rf83	VGND#3	VGND#4	64.584320
Rf84	VGND#4	VGND#5	147.902725
Rf85	VGND#5	VGND#6	224.200073
Rf86	VGND#6	VGND#7	84.999344
Rf87	VGND#7	VGND#8	33.539146
Rf88	VGND#8	VGND#9	188.445755
Rf90	VGND#2	VGND#11	26.023314
Rf91	VGND#3	VGND#12	27.076115
Rf92	VGND#5	VGND#13	32.735970
Rf93	VGND#6	VGND#14	21.903545
Rf94	VGND#7	VGND#15	20.133238
Rf95	VGND#9	VGND#16	37.263206
Rf114	a_1827_144##4	a_1827_144##10	80.116402
Re1	RESET_B#14	RESET_B#13	15.344948
Re2	RESET_B#13	RESET_B	7.213822
Re4	VPWR#1	VPWR#24	11.160645
Re5	VPWR#24	VPWR	1.198481
Re6	VPWR	VPWR#10	2.081275
Re7	VGND#1	VGND#18	11.160645
Re8	VGND#18	VGND	1.198481
Re9	VGND	VGND#8	2.081275
Re14	VPWR#5	VPWR#24	0.698413
Re17	VGND#4	VGND#18	0.698413
*
*       CAPACITOR CARDS
*
*
C1	a_1272_131##7	CLK_N#1	4.28899e-19
C2	RESET_B#1	CLK_N#3	1.24269e-17
C3	a_284_464##8	CLK_N#3	2.17606e-19
C4	VPWR#15	VPWR#14	1.46493e-18
C5	VGND#5	a_854_74##2	3.01378e-17
C6	a_1074_88#	a_1429_308#	1.63057e-17
C7	a_284_464##5	a_854_74##6	3.36479e-20
C8	a_1074_88##12	a_854_74##9	3.33345e-17
C9	a_2492_424##3	VGND#11	1.80499e-17
C10	VPWR#2	a_2492_424##4	2.51724e-18
C11	a_1074_88#	a_854_74##3	7.33264e-17
C12	VPWR#4	a_1827_144##7	1.79484e-19
C13	VPWR#9	CLK_N#2	1.16387e-19
C14	a_284_464#	CLK_N#1	3.50701e-19
C15	VPWR#1	VPWR#2	3.56047e-18
C16	a_284_464##2	a_854_74##9	7.26123e-19
C17	a_284_464##3	VPWR#21	3.76019e-18
C18	a_2087_410##2	RESET_B#9	1.29133e-17
C19	a_1074_88#	a_1074_88##2	1.41274e-17
C20	VPWR#3	a_1827_144#	2.30188e-19
C21	a_27_88##4	a_284_464##3	1.0355e-17
C22	a_284_464##7	SCE#7	2.00615e-18
C23	a_239_81#	SCD#1	2.72411e-17
C24	VPWR#19	a_854_74##9	4.50794e-17
C25	VGND#3	a_854_74##2	8.03011e-20
C26	a_284_464##6	a_854_74##6	6.52841e-19
C27	a_284_464##5	CLK_N#1	7.85758e-19
C28	a_1827_144##11	VPWR#4	1.24998e-17
C29	a_1827_144##11	a_1074_88##5	2.30379e-20
C30	a_1272_131##9	a_854_74##4	1.10494e-19
C31	VPWR#15	a_2492_424##7	2.90361e-17
C32	SCD#7	a_284_464##2	5.31719e-18
C33	a_2087_410##4	a_2492_424##3	4.61384e-17
C34	a_854_74##10	a_1074_88#	7.5967e-18
C35	a_2087_410##5	a_2492_424##7	4.23022e-17
C36	a_1074_88##10	a_1429_308##2	4.0731e-19
C37	a_284_464##8	RESET_B#1	7.75889e-19
C38	a_1074_88##12	CLK_N#1	7.01832e-19
C39	a_854_74##3	a_1074_88##3	2.40674e-17
C40	VPWR#3	a_1827_144##7	4.63818e-19
C41	a_854_74##13	a_854_74##9	6.06393e-18
C42	VGND#7	a_284_464##5	3.43677e-17
C43	a_284_464##8	a_471_464#	4.62477e-19
C44	CLK_N#3	a_1074_88#	1.25165e-18
C45	SCD#1	RESET_B#1	3.23551e-17
C46	a_1429_308##7	VPWR#6	2.71556e-17
C47	a_854_74##11	a_2087_410##2	3.70357e-17
C48	VPWR#2	a_1827_144#	3.95746e-19
C49	a_27_88##4	a_284_464##7	9.64689e-17
C50	VGND#8	a_854_74##8	2.93866e-19
C51	VPWR#19	CLK_N#1	6.82526e-18
C52	VGND#5	a_1272_131##3	2.22583e-18
C53	RESET_B#5	a_1272_131##5	3.06023e-17
C54	a_284_464##5	VGND#14	2.65274e-19
C55	a_239_81#	SCE#6	1.07866e-17
C56	VPWR#2	a_1827_144##7	7.57689e-18
C57	VPWR#20	a_854_74##9	1.69985e-18
C58	a_854_74##6	a_854_74##3	4.85825e-19
C59	a_284_464##2	CLK_N#1	4.6449e-17
C60	a_2087_410##7	a_2492_424##7	2.696e-18
C61	VPWR#7	VPWR#17	2.30005e-19
C62	a_2492_424#	Q#3	7.72968e-18
C63	VPWR#4	a_1827_144##6	1.47421e-18
C64	VPWR#9	RESET_B#2	8.6889e-22
C65	a_284_464##8	SCD#1	1.29851e-17
C66	a_27_88##7	SCE#2	2.44966e-17
C67	a_854_74##13	CLK_N#1	4.30017e-17
C68	a_284_464##5	RESET_B#3	1.86124e-18
C69	a_2087_410##4	a_1827_144##4	9.35427e-17
C70	VPWR#10	RESET_B#3	8.31951e-18
C71	a_284_464##7	a_284_464##3	1.47011e-18
C72	a_284_464##3	a_854_74##9	4.54953e-19
C73	D#2	a_284_464##7	4.61275e-18
C74	a_1074_88##7	a_854_74##12	1.93373e-17
C75	a_854_74##7	a_854_74##10	6.23092e-18
C76	a_1074_88##10	a_1074_88#	3.09716e-18
C77	a_284_464##5	SCD#4	7.89776e-18
C78	VPWR#19	RESET_B#3	3.70296e-19
C79	a_2087_410##5	VPWR#15	3.36156e-17
C80	a_1827_144##9	VGND#12	1.7825e-17
C81	VGND#6	a_284_464##5	2.13308e-17
C82	RESET_B#14	VPWR#4	7.80336e-18
C83	VPWR#3	a_1827_144##6	2.5934e-18
C84	CLK_N#1	VPWR#20	2.78462e-17
C85	VPWR#10	SCD#3	4.61481e-18
C86	SCE#6	SCD#1	3.11124e-17
C87	a_854_74##7	CLK_N#3	6.08818e-19
C88	a_854_74##6	a_1074_88##11	5.18127e-19
C89	VGND#8	RESET_B#3	9.56048e-20
C90	a_239_81#	D#1	4.33845e-19
C91	RESET_B#13	VPWR#8	2.46449e-18
C92	a_2492_424#	VGND#11	2.61154e-17
C93	a_284_464##5	a_854_74##10	7.61611e-19
C94	a_2087_410##7	VPWR#15	3.33396e-17
C95	a_284_464##6	a_854_74##4	6.291e-18
C96	VGND#12	a_1827_144##4	3.7587e-17
C97	a_284_464##5	a_854_74##15	7.37598e-17
C98	a_1429_308##2	a_1272_131##5	1.28759e-17
C99	VPWR#10	a_27_88##3	7.63876e-20
C100	a_284_464##8	SCE#6	3.32958e-17
C101	CLK_N#2	a_854_74##10	1.25139e-18
C102	VGND#8	SCD#3	5.66485e-19
C103	a_284_464##3	CLK_N#1	2.79351e-18
C104	VGND#5	RESET_B#4	2.72786e-18
C105	RESET_B#13	VPWR#7	5.7775e-18
C106	VPWR#17	a_854_74##2	1.31315e-19
C107	VPWR#11	SCD#2	4.44244e-19
C108	a_239_81##2	SCD#1	1.20357e-19
C109	VPWR#10	D#3	1.2511e-18
C110	VPWR#20	RESET_B#3	2.90031e-18
C111	a_284_464##6	a_1074_88##11	3.27601e-18
C112	a_1272_131##8	VPWR#7	8.96829e-18
C113	VPWR#4	RESET_B#9	1.57904e-17
C114	VGND#8	a_1272_131##9	3.16195e-18
C115	a_854_74#	a_1074_88##7	4.04366e-17
C116	RESET_B#13	VPWR#6	3.91395e-18
C117	a_1074_88##10	a_1074_88##3	1.55608e-17
C118	a_239_81#	a_27_88#	1.83212e-19
C119	VPWR#10	SCE#1	7.7676e-19
C120	VGND#8	a_284_464##6	3.11082e-17
C121	a_1827_144#	VGND#11	2.88014e-17
C122	VGND#8	D#3	5.38323e-21
C123	a_284_464##3	RESET_B#3	4.36442e-17
C124	D#1	SCE#6	8.52554e-18
C125	a_27_88##6	SCE#2	1.57511e-17
C126	a_2087_410##5	a_2492_424##4	1.40185e-19
C127	VGND#12	RESET_B#8	9.82816e-19
C128	VGND#16	SCD#1	2.71619e-19
C129	RESET_B#2	CLK_N#3	1.11502e-18
C130	a_284_464##8	D#1	2.14881e-17
C131	a_1272_131##2	a_1074_88##7	4.17826e-19
C132	a_284_464##5	CLK_N#3	4.01789e-17
C133	VPWR#10	SCE#5	1.94246e-18
C134	a_284_464##5	VGND#15	6.61429e-18
C135	VPWR#20	SCD#3	3.10824e-19
C136	a_2087_410##4	a_2492_424#	3.9331e-20
C137	a_239_81##2	SCE#6	2.92713e-19
C138	a_1272_131##8	VPWR#6	8.65122e-18
C139	a_284_464##2	SCD#3	3.52046e-19
C140	a_1272_131##2	a_1272_131#	7.37201e-18
C141	RESET_B#3	VPWR#21	1.72553e-17
C142	a_284_464##6	VGND#14	2.03912e-18
C143	RESET_B#14	VPWR#5	4.25711e-18
C144	SCD#1	RESET_B#2	3.5321e-18
C145	VGND#11	VPWR#14	1.13442e-17
C146	a_2492_424##5	a_1827_144#	5.75133e-17
C147	a_284_464##7	CLK_N#1	3.05902e-19
C148	VGND#5	a_1429_308#	2.23811e-18
C149	VGND#11	a_2492_424##2	1.1366e-17
C150	VPWR#11	SCE#7	2.29288e-20
C151	RESET_B#8	a_1827_144##8	2.31543e-20
C152	a_284_464##3	SCD#3	2.14527e-17
C153	VPWR#4	a_2087_410##3	2.51843e-17
C154	RESET_B#13	VPWR#5	1.20663e-18
C155	SCD#7	CLK_N#1	4.38416e-19
C156	RESET_B#5	a_1272_131#	3.04466e-18
C157	RESET_B#14	VGND#4	2.82915e-18
C158	VGND#16	SCE#6	3.54037e-19
C159	a_854_74##15	a_284_464##2	5.2106e-19
C160	a_284_464##8	a_27_88#	2.57915e-18
C161	VGND#11	a_1827_144##3	6.669e-19
C162	a_854_74##15	a_854_74##13	1.64202e-18
C163	VGND#8	a_854_74##15	4.95407e-18
C164	a_1074_88##2	a_854_74##4	1.56068e-17
C165	a_854_74##7	a_1074_88##10	4.95281e-17
C166	a_1429_308##5	RESET_B#8	3.98728e-19
C167	a_27_88#	D#1	3.6828e-17
C168	SCD#3	VPWR#21	1.72553e-17
C169	a_1827_144##9	a_1827_144##8	9.19044e-18
C170	a_239_81##2	D#1	1.21894e-17
C171	a_2087_410##5	a_1827_144##7	5.88213e-19
C172	RESET_B#13	VGND#4	1.56623e-18
C173	RESET_B#14	a_1827_144##5	1.32562e-18
C174	a_284_464##5	RESET_B#1	1.82463e-17
C175	a_2087_410##4	a_1827_144#	8.88658e-19
C176	a_284_464##7	RESET_B#3	5.64629e-19
C177	a_1429_308##2	a_1272_131#	2.94094e-19
C178	VGND#6	a_854_74##3	2.5256e-19
C179	a_239_81#	a_284_464##5	4.00708e-17
C180	a_284_464##3	a_27_88##3	8.87934e-19
C181	a_1272_131##5	a_1074_88##3	8.92808e-19
C182	a_27_88##8	SCE#6	2.70285e-20
C183	VGND#7	VGND#6	3.14021e-18
C184	a_2492_424##5	a_1827_144##3	2.01231e-18
C185	VPWR#7	VPWR#6	8.0087e-19
C186	D#1	SCD#2	7.78932e-20
C187	RESET_B#14	a_1827_144##2	1.84853e-18
C188	a_1429_308##2	RESET_B#6	1.96157e-18
C189	VGND#8	a_239_81#	1.17517e-16
C190	SCE#7	SCD#1	1.54241e-17
C191	VGND#16	D#1	1.92499e-19
C192	RESET_B#14	a_1827_144##11	4.09023e-17
C193	RESET_B#14	a_2087_410##5	5.55267e-18
C194	VGND#11	RESET_B#7	2.26502e-19
C195	SCD#7	RESET_B#3	1.17872e-17
C196	VGND#5	a_854_74##3	2.89216e-17
C197	VPWR#22	a_284_464##7	1.33151e-17
C198	RESET_B#13	VPWR#10	1.67045e-17
C199	VPWR#11	a_27_88##4	6.05495e-20
C200	a_284_464##7	SCD#3	1.74197e-17
C201	a_239_81##2	a_27_88#	3.64071e-17
C202	a_284_464##3	D#3	3.58076e-19
C203	VPWR#4	a_854_74##11	4.13264e-18
C204	a_1074_88##10	CLK_N#2	1.65822e-19
C205	D#1	SCE#7	2.3149e-17
C206	a_284_464##2	VPWR#19	2.16389e-17
C207	SCE#4	a_27_88#	3.29948e-18
C208	a_2087_410##4	a_1827_144##3	2.84849e-17
C209	a_1827_144##11	a_2087_410##7	1.56547e-18
C210	a_27_88##8	D#1	1.13507e-19
C211	VGND#8	VGND#7	7.83044e-17
C212	VGND#8	a_284_464##8	1.54505e-17
C213	a_284_464##5	SCD#1	1.96789e-19
C214	VGND#8	RESET_B#13	1.69182e-17
C215	RESET_B#14	a_2492_424##3	2.956e-18
C216	a_2087_410##5	a_1827_144##6	1.07044e-17
C217	a_2492_424##5	RESET_B#7	2.80724e-19
C218	VGND#16	a_27_88#	1.48518e-18
C219	VGND#12	a_1827_144#	8.45615e-19
C220	VGND#8	VGND#6	1.38779e-16
C221	RESET_B#14	a_1827_144##9	1.03281e-17
C222	a_27_88##9	a_284_464##7	2.69572e-19
C223	a_284_464##7	a_27_88##3	4.53912e-17
C224	a_284_464##7	a_471_464#	2.4765e-18
C225	VPWR#8	a_854_74##6	9.71477e-20
C226	RESET_B#14	a_1827_144##4	8.17353e-17
C227	a_854_74##4	a_1429_308##2	6.39954e-19
C228	VPWR#22	SCD#3	2.16368e-19
C229	a_1074_88##3	a_1429_308##3	2.46841e-18
C230	a_239_81##2	SCE#4	1.95616e-18
C231	a_1429_308##5	a_854_74##12	5.94845e-18
C232	RESET_B#13	a_1429_308##7	3.11551e-17
C233	SCD#7	SCD#3	5.74093e-18
C234	VGND#8	VGND#5	1.35796e-17
C235	VGND#8	a_239_81##2	5.06641e-17
C236	a_27_88##8	a_27_88#	5.30429e-19
C237	a_2492_424##5	VGND#11	5.98177e-17
C238	RESET_B#14	RESET_B#8	1.91468e-17
C239	a_2087_410##4	RESET_B#7	2.67089e-18
C240	VPWR#11	D#2	1.92043e-19
C241	RESET_B#13	VPWR#17	8.72813e-18
C242	a_284_464##2	a_854_74##13	7.83373e-17
C243	a_284_464##5	a_854_74##7	1.08333e-17
C244	a_1827_144##11	VPWR#5	2.17114e-17
C245	a_284_464##7	D#3	3.93846e-17
C246	VPWR#4	a_1074_88##7	9.5391e-19
C247	a_27_88##2	SCD#1	1.33722e-19
C248	a_1074_88##3	a_854_74##8	2.579e-17
C249	VPWR#10	VPWR#11	9.1838e-17
C250	VGND#16	SCE#4	1.57849e-17
C251	a_1272_131##7	VPWR#7	2.31017e-17
C252	VGND#7	a_854_74##10	8.50819e-19
C253	a_284_464##5	SCE#6	4.76956e-20
C254	a_1074_88##6	a_1827_144##8	6.63252e-17
C255	VGND#12	a_1827_144##3	5.92199e-18
C256	VPWR#22	a_27_88##3	5.41749e-19
C257	RESET_B#14	a_2087_410##2	1.04491e-17
C258	a_284_464##8	a_284_464##5	1.47844e-18
C259	a_2087_410##5	RESET_B#9	1.49336e-17
C260	VPWR#7	a_1272_131#	3.60319e-19
C261	VGND#2	a_2492_424##5	2.20454e-17
C262	a_1429_308##7	VPWR#5	1.54883e-17
C263	VGND#8	a_27_88##8	1.86774e-17
C264	VPWR#10	VPWR#9	5.91709e-17
C265	a_27_88##2	D#1	3.07401e-17
C266	a_1074_88##6	a_1429_308##5	9.05992e-17
C267	a_284_464##2	a_854_74##7	2.63654e-18
C268	RESET_B#14	a_854_74##12	2.45001e-17
C269	a_27_88##8	SCE#4	2.38183e-17
C270	a_284_464#	VPWR#8	2.37359e-17
C271	a_27_88##9	a_27_88##3	1.47331e-19
C272	a_2087_410##4	a_2492_424##2	9.27618e-20
C273	a_27_88##9	VPWR#22	2.84205e-17
C274	VGND#6	a_854_74##10	1.03007e-17
C275	SCD#7	a_27_88##3	4.98525e-19
C276	VGND#3	a_2087_410##4	1.3239e-17
C277	RESET_B#13	VPWR#18	2.81693e-18
C278	a_284_464##7	SCE#1	3.4325e-18
C279	a_284_464##5	a_284_464##3	1.74806e-18
C280	VPWR#10	VPWR#8	1.03862e-16
C281	a_854_74##7	a_854_74##9	1.50454e-18
C282	a_1074_88##6	VGND#13	2.64434e-17
C283	VPWR#6	a_1272_131#	1.05803e-18
C284	a_2087_410##4	a_2087_410#	4.02589e-19
C285	VPWR#22	D#3	4.10098e-18
C286	SCE#4	a_27_88##2	5.35583e-18
C287	a_2492_424##5	a_1827_144##2	2.04736e-19
C288	a_1827_144##9	a_1827_144##3	1.48692e-19
C289	RESET_B#14	a_1074_88##6	2.21816e-18
C290	a_854_74##7	CLK_N#1	1.99022e-18
C291	a_284_464##2	VPWR#20	4.5442e-17
C292	RESET_B#13	a_854_74##4	1.18641e-17
C293	a_284_464##5	CLK_N#2	1.04614e-17
C294	a_854_74#	a_1827_144##8	1.55529e-18
C295	VPWR#10	VPWR#7	2.77243e-17
C296	a_854_74##15	CLK_N#4	1.9951e-17
C297	VGND#12	RESET_B#7	2.89765e-17
C298	a_1074_88#	a_854_74##4	3.46308e-19
C299	VGND#4	a_2087_410##2	6.17212e-20
C300	VPWR#5	a_854_74##12	2.49934e-19
C301	a_284_464##5	D#1	2.09573e-20
C302	RESET_B#13	a_1074_88##6	1.25588e-17
C303	a_27_88##9	D#3	3.08117e-19
C304	VPWR#4	a_1272_131#	4.17446e-19
C305	RESET_B#14	a_854_74#	4.45499e-18
C306	D	SCE#2	9.17169e-18
C307	a_1429_308##5	a_854_74#	1.89536e-17
C308	VGND#7	CLK_N#3	1.57289e-17
C309	RESET_B#13	a_1272_131##7	2.80838e-17
C310	a_1272_131##7	a_854_74##3	6.16953e-19
C311	a_1827_144##5	a_2492_424##2	3.76795e-20
C312	VGND#4	a_854_74##12	3.16901e-19
C313	VPWR#22	SCE#1	3.10644e-17
C314	a_1272_131##5	VPWR#7	5.21371e-19
C315	VPWR#5	a_1074_88##6	3.43255e-20
C316	a_284_464##2	CLK_N#2	1.17e-18
C317	a_2087_410##4	a_1827_144##5	2.73533e-19
C318	VPWR#7	RESET_B#6	5.71724e-18
C319	VGND#2	a_2492_424##3	3.11506e-19
C320	RESET_B#13	a_854_74#	3.88111e-17
C321	VGND#2	a_2087_410##4	6.01272e-18
C322	a_2087_410##4	a_2492_424##5	4.80344e-17
C323	a_1827_144##4	a_2492_424##3	9.56578e-19
C324	a_1827_144##9	a_1827_144##11	3.85453e-18
C325	a_2087_410##4	a_1074_88##5	2.4467e-19
C326	RESET_B#13	a_284_464#	2.37662e-18
C327	a_2492_424##3	VPWR#14	2.18654e-17
C328	VGND#4	a_1074_88##6	1.2868e-18
C329	RESET_B#2	CLK_N#1	9.4908e-18
C330	a_27_88##9	SCE#1	4.00714e-19
C331	VPWR#8	a_854_74##4	1.17328e-19
C332	VPWR#5	a_854_74#	2.54863e-20
C333	VGND#6	CLK_N#3	3.65463e-18
C334	RESET_B#13	a_1272_131##2	2.7825e-17
C335	a_1429_308##7	a_1827_144##11	9.39388e-17
C336	a_1827_144##7	a_2492_424##4	2.72868e-17
C337	VGND#12	a_2087_410#	2.83179e-17
C338	a_1827_144##9	RESET_B#7	2.16157e-19
C339	a_284_464##8	a_284_464##3	1.02568e-18
C340	a_284_464##5	RESET_B#2	9.00497e-17
C341	RESET_B#13	a_1074_88##12	8.25382e-18
C342	VPWR#22	SCE#5	2.85e-17
C343	VGND#4	a_854_74#	6.42833e-20
C344	a_1429_308##5	a_1272_131##2	5.64547e-17
C345	RESET_B#13	RESET_B#5	2.90131e-17
C346	a_1827_144##3	a_2265_74#	9.87534e-18
C347	a_1827_144##4	RESET_B#8	1.14246e-16
C348	a_2087_410##4	a_1827_144##2	2.81457e-17
C349	RESET_B#7	a_2265_74#	9.87534e-18
C350	CLK_N#4	CLK_N#2	1.92181e-17
C351	SCE#5	a_27_88##9	1.24589e-17
C352	VGND#3	a_1827_144##4	4.09933e-18
C353	RESET_B#2	a_284_464##2	3.23699e-17
C354	a_1272_131##5	VPWR#6	3.31702e-19
C355	a_1827_144##4	a_2087_410##2	4.2068e-17
C356	RESET_B#13	a_1074_88##10	2.14553e-17
C357	a_1074_88##3	a_854_74##4	4.79329e-17
C358	RESET_B#13	a_1429_308##2	4.72365e-17
C359	VGND#7	RESET_B#1	4.53921e-18
C360	a_2492_424##4	Q#1	1.22393e-17
C361	CLK_N#4	a_854_74##13	3.55306e-18
C362	VPWR#7	a_1429_308##3	7.02019e-18
C363	VGND#4	a_1827_144##9	3.28457e-17
C364	VGND#12	a_1074_88##5	6.05534e-18
C365	a_2087_410##2	RESET_B#8	2.62604e-17
C366	a_1827_144##4	a_854_74##12	5.00199e-19
C367	a_1827_144##6	a_1827_144##7	4.04148e-18
C368	VPWR#22	SCE#2	7.68538e-19
C369	RESET_B#13	a_1074_88#	1.12809e-17
C370	a_1827_144##2	a_2492_424##2	1.537e-19
C371	a_27_88##4	CLK_N#1	8.97903e-19
C372	a_1429_308##5	RESET_B#5	1.76657e-17
C373	SCE#7	SCD#3	5.66776e-18
C374	a_1827_144#	a_2492_424#	2.05439e-17
C375	a_284_464##5	SCD#2	2.04531e-19
C376	VPWR#4	VPWR#3	1.06423e-18
C377	a_2492_424##4	VPWR#14	3.18006e-17
C378	VGND#6	RESET_B#1	5.4892e-19
C379	a_1827_144##9	a_2087_410#	2.03197e-17
C380	a_854_74##12	RESET_B#8	1.32342e-17
C381	VPWR#7	a_854_74##3	1.47738e-19
C382	a_1827_144##4	a_1074_88##6	3.3887e-19
C383	VPWR#3	a_1827_144##5	4.52734e-19
C384	a_27_88##4	RESET_B#3	2.68413e-18
C385	RESET_B#13	a_1074_88##3	2.26951e-17
C386	VGND#13	RESET_B#5	6.75269e-19
C387	VPWR#17	a_1429_308##7	6.88872e-17
C388	VGND#12	a_2492_424##5	2.80353e-18
C389	CLK_N#4	RESET_B#2	8.29908e-19
C390	a_854_74##12	a_2087_410##2	2.86182e-17
C391	a_2087_410##3	a_2042_508#	1.04298e-17
C392	a_27_88##4	SCD#3	1.67323e-17
C393	RESET_B#8	a_1074_88##6	7.16285e-19
C394	a_1827_144##2	a_2492_424#	6.51688e-20
C395	a_284_464##2	SCD#2	2.93815e-20
C396	a_2492_424##7	a_2492_424##4	1.39163e-18
C397	VGND#3	a_1827_144##9	2.07996e-18
C398	a_854_74##7	a_854_74##6	5.88001e-19
C399	a_854_74##11	a_2042_508#	1.04298e-17
C400	a_27_88##4	a_27_88##3	1.28621e-17
C401	VGND#12	a_854_74##2	1.22859e-18
C402	a_1429_308##5	a_2087_410#	7.5608e-20
C403	a_2087_410#	a_2073_74#	1.01636e-17
C404	a_854_74#	RESET_B#8	3.92457e-20
C405	a_27_88##6	a_27_88##3	2.20713e-19
C406	RESET_B#9	a_1827_144##6	2.80134e-17
C407	a_1827_144##7	VPWR#14	3.64118e-17
C408	a_1074_88##5	a_2073_74#	1.01636e-17
C409	a_27_88##4	D#3	5.61061e-19
C410	VPWR#7	a_1074_88##4	6.65149e-18
C411	SCD#7	RESET_B#2	1.78934e-17
C412	a_1429_308##2	a_1429_308##5	1.40037e-18
C413	a_1074_88##5	a_1827_144##8	3.34062e-18
C414	VPWR#11	VPWR#20	1.48541e-18
C415	a_1074_88##6	a_854_74##12	3.45323e-17
C416	a_854_74#	a_2087_410##2	6.18029e-20
C417	D#2	a_27_88##3	5.32626e-18
C418	VPWR#15	a_2492_424##4	5.00335e-19
C419	a_27_88##4	SCE#1	7.16689e-20
C420	a_284_464##5	SCE#7	2.41951e-19
C421	VPWR#10	a_1272_131##7	1.63603e-17
C422	VGND#8	a_1074_88#	2.14881e-17
C423	a_1827_144##9	a_1074_88##5	2.78444e-17
C424	VPWR#10	a_1074_88##3	4.05603e-18
C425	a_1074_88##10	a_854_74##6	2.0102e-17
C426	a_1827_144##3	a_1827_144#	2.50253e-18
C427	VGND#12	a_2087_410##4	9.13985e-18
C428	a_27_88##4	SCE#5	6.89348e-20
C429	a_854_74#	a_854_74##12	1.11962e-18
C430	a_2492_424##7	a_1827_144##7	7.80857e-17
C431	SCD#6	RESET_B#2	1.81143e-17
C432	a_1827_144##11	a_1827_144##4	2.46233e-18
C433	VPWR#3	a_1827_144##2	5.21219e-19
C434	VPWR#10	a_284_464#	2.62075e-17
C435	a_1827_144##2	a_1827_144##5	7.20252e-18
C436	VGND#8	a_1074_88##3	3.67328e-18
C437	SCD#4	RESET_B#2	1.80908e-17
C438	a_854_74#	a_1074_88##6	5.36022e-17
C439	VPWR#10	a_854_74##7	9.32877e-19
C440	VPWR#14	a_1827_144##6	6.7315e-19
C441	VPWR#8	a_854_74##8	1.61326e-18
C442	VGND#1	a_2492_424#	6.73937e-18
C443	RESET_B#13	a_1272_131##5	1.6819e-17
C444	a_27_88##2	D#3	2.76254e-18
C445	VPWR#2	a_2492_424##3	2.36841e-19
C446	a_27_88##6	D#3	1.92431e-17
C447	VPWR#10	a_1074_88##12	5.16617e-18
C448	a_1272_131##8	VPWR#17	3.59407e-17
C449	a_1074_88#	a_1429_308##5	8.18951e-18
C450	a_2087_410##3	RESET_B#9	6.70493e-18
C451	a_1429_308##3	a_1384_508#	9.87534e-18
C452	VPWR#15	a_1827_144##7	2.49255e-18
C453	VGND#8	a_854_74##7	3.27338e-18
C454	SCD#7	SCD#2	5.21967e-18
C455	a_1074_88##6	a_1272_131##2	8.16629e-19
C456	a_854_74##2	a_1827_144##8	1.9852e-17
C457	VGND#3	a_2087_410##2	6.92866e-20
C458	a_1272_131##9	a_1429_308##2	3.8173e-17
C459	a_239_81#	a_538_81#	8.42613e-19
C460	a_1074_88##4	a_1384_508#	9.87534e-18
C461	a_1827_144##2	a_1827_144#	7.22321e-19
C462	a_1074_88#	VGND#13	2.66372e-17
C463	SCE#3	D#3	3.87762e-18
C464	VPWR#7	a_854_74##8	8.04758e-18
C465	a_1827_144##11	RESET_B#8	1.72549e-19
C466	VPWR#10	VPWR#19	1.10604e-17
C467	a_2492_424##7	a_1827_144##6	1.84999e-18
C468	CLK_N#2	a_854_74##6	1.12083e-19
C469	a_1272_131##2	a_854_74#	3.42437e-17
C470	a_284_464##8	a_538_81#	1.09281e-18
C471	VGND#13	a_1074_88##5	5.49024e-19
C472	a_2087_410##2	VPWR#16	4.58257e-19
C473	a_284_464##3	VPWR#11	4.27401e-17
C474	VPWR#10	RESET_B#2	2.42608e-18
C475	a_2087_410##7	a_1827_144##7	5.8338e-19
C476	SCD#6	SCD#2	9.99475e-18
C477	a_1827_144##9	a_854_74##2	4.12332e-19
C478	a_284_464##2	VPWR#9	4.20428e-18
C479	VPWR#10	a_854_74##13	5.13275e-18
C480	VPWR#3	VPWR#2	7.9461e-19
C481	RESET_B#4	a_1489_131#	7.5313e-18
C482	VGND#8	a_1074_88##12	4.92595e-19
C483	a_1429_308##5	a_854_74##2	3.39866e-17
C484	a_854_74##4	a_854_74##8	1.65739e-18
C485	VGND#8	RESET_B#2	3.07909e-18
C486	RESET_B#7	a_1827_144##3	3.67356e-17
C487	VPWR#18	VPWR#17	1.94969e-18
C488	a_239_81#	a_284_464##8	8.02642e-17
C489	SCD#4	SCD#2	1.16728e-17
C490	a_27_88##4	a_284_464##2	1.54573e-18
C491	a_1429_308#	a_1489_131#	7.5313e-18
C492	VPWR#15	a_1827_144##6	1.25642e-17
C493	a_27_88##6	SCE#1	1.56359e-17
C494	RESET_B#5	a_1272_131##2	5.08588e-17
C495	a_854_74##11	a_2087_410##3	2.97428e-17
C496	VPWR#10	VPWR#20	1.90104e-17
C497	a_1827_144##8	a_1272_131##3	8.63524e-19
C498	VGND#8	SCD#2	2.44635e-20
C499	a_1827_144##11	a_2087_410##2	6.77027e-17
C500	a_1074_88#	a_1272_131##9	9.33657e-17
C501	SCE	SCE#2	2.30236e-19
C502	VPWR#8	a_854_74##9	3.99488e-18
C503	a_284_464##3	VPWR#9	1.18055e-18
C504	VPWR#10	SCE#7	7.80759e-19
C505	SCD#7	a_284_464##3	1.8615e-17
C506	a_1429_308##2	a_1272_131##2	3.94145e-18
C507	VGND#13	a_854_74##2	1.5057e-17
C508	a_2087_410##7	a_1827_144##6	2.67875e-17
C509	a_284_464##6	a_1074_88#	5.47642e-17
C510	a_284_464##3	VPWR#10	4.14197e-17
C511	VGND#8	a_854_74##13	9.33929e-19
C512	VGND#8	SCE#7	3.54972e-19
C513	a_284_464##5	D#2	6.66824e-20
C514	VPWR#11	CLK_N#1	7.85941e-19
C515	VPWR#18	a_1272_131##8	2.95066e-17
C516	VPWR#10	a_27_88##4	1.15363e-17
C517	a_1429_308##2	RESET_B#5	1.08669e-16
C518	VPWR#7	a_854_74##9	1.34458e-19
C519	SCD#3	a_471_464#	8.98164e-18
C520	VPWR#15	RESET_B#9	1.29448e-18
C521	a_1429_308##5	a_1272_131##3	3.59213e-17
C522	a_284_464##2	VPWR#8	3.94852e-18
C523	VPWR#4	RESET_B#8	5.99173e-19
C524	VPWR#11	VPWR#21	6.01079e-18
C525	VGND#8	a_27_88##4	3.63215e-18
C526	a_27_88##3	a_471_464#	1.0861e-17
C527	a_1074_88##10	a_854_74##4	3.12034e-17
C528	a_1827_144##9	a_1272_131##3	9.78837e-20
C529	a_1074_88#	RESET_B#5	5.68096e-19
C530	a_1272_131##2	a_1074_88##3	6.96031e-20
C531	a_1827_144##11	a_854_74##12	8.06213e-17
C532	a_2087_410##5	a_2492_424##3	1.80751e-17
C533	VPWR#10	D#2	4.1038e-19
C534	a_27_88##6	SCE#5	1.6903e-17
C535	VPWR#9	CLK_N#1	6.09435e-18
C536	a_1827_144##8	RESET_B#4	5.08403e-19
C537	a_1272_131##9	a_1074_88##3	5.00361e-19
C538	a_1074_88##7	a_854_74##11	3.21377e-17
C539	a_2087_410#	RESET_B#7	1.8071e-17
C540	a_1429_308#	a_1411_131#	3.48837e-18
C541	a_1074_88#	a_1429_308##2	6.56381e-17
C542	a_2087_410##7	RESET_B#9	2.42732e-17
C543	a_854_74##3	a_1411_131#	5.35636e-18
C544	a_1429_308##7	a_854_74##12	4.42646e-19
C545	a_27_88##4	SCD#7	2.02378e-17
C546	VPWR#10	a_1074_88##10	3.05324e-18
C547	a_1272_131##3	VGND#13	1.84977e-17
C548	a_239_81##2	a_324_81#	3.8371e-18
C549	a_854_74##9	a_854_74##4	1.08698e-17
C550	D#3	a_206_464#	1.42261e-17
C551	a_1074_88##3	a_1429_308##2	3.05064e-17
C552	VPWR#10	a_284_464##7	3.6652e-17
C553	VGND#8	a_27_88##2	6.45123e-18
C554	VPWR#15	a_2087_410##3	1.92097e-19
C555	VGND#5	a_1074_88##6	8.39584e-18
C556	Q	a_2492_424##2	2.33116e-17
C557	Q	a_1827_144##5	7.11818e-21
C558	a_239_81##2	a_239_81#	1.0172e-18
C559	Q	a_1827_144##2	7.66644e-20
C560	SCE#1	a_206_464#	1.42261e-17
C561	VPWR#10	SCE#3	6.0156e-18
C562	a_1074_88#	a_1074_88##3	6.57098e-19
C563	a_27_88##4	SCD#6	1.30203e-17
C564	a_1827_144##11	a_1074_88##6	7.32458e-19
C565	RESET_B#9	VPWR#16	4.12487e-18
C566	VPWR#10	SCE#2	1.71309e-18
C567	VGND#8	SCE#3	6.36526e-18
C568	VPWR#11	RESET_B#3	6.97632e-18
C569	SCE#2	D#1	3.59319e-19
C570	a_27_88##4	SCD#4	9.82554e-18
C571	a_1074_88##6	a_1429_308##7	1.19111e-19
C572	a_2087_410##7	a_2087_410##3	1.07182e-18
C573	a_1272_131#	a_1074_88##7	6.7676e-18
C574	a_2087_410##2	VPWR#4	4.3556e-17
C575	a_1272_131##7	a_1272_131##8	1.77384e-18
C576	a_27_88##6	D	3.7312e-17
C577	CLK_N#1	a_854_74##6	2.46583e-19
C578	a_1827_144##4	a_2087_410##5	1.11836e-16
C579	VPWR#10	VPWR#22	1.81085e-17
C580	a_284_464##6	a_854_74##7	2.17373e-17
C581	RESET_B#4	VGND#13	1.66023e-17
C582	a_1272_131##9	a_854_74##2	2.47934e-19
C583	a_1074_88##5	a_2087_410#	4.30349e-17
C584	VGND#8	a_1074_88##10	4.89121e-18
C585	RESET_B#13	a_854_74##2	2.06994e-19
C586	a_854_74#	a_1827_144##11	5.66918e-18
C587	a_2087_410##3	VPWR#16	1.28925e-17
C588	VPWR#10	a_27_88##9	1.65232e-17
C589	RESET_B#7	a_1827_144##2	5.72182e-18
C590	a_1827_144##11	RESET_B#9	2.91968e-19
C591	a_854_74##7	VGND#14	7.08421e-18
C592	CLK_N#2	a_854_74##7	3.10199e-17
C593	a_854_74#	a_1429_308##7	6.37318e-17
C594	a_1827_144##9	a_1827_144##4	8.63211e-20
C595	a_2087_410##7	a_854_74##11	1.81171e-19
C596	a_1272_131##7	VPWR#18	1.74246e-17
C597	a_1272_131##7	a_854_74##6	2.08151e-20
C598	SCD#4	D#2	7.07803e-19
C599	RESET_B#6	a_1272_131#	5.68167e-18
C600	a_854_74##7	RESET_B#2	3.10395e-19
C601	a_2492_424##3	a_2492_424##2	8.18035e-19
C602	VPWR#11	SCD#3	1.50182e-17
C603	a_1074_88##10	a_1272_131##9	1.44414e-17
C604	a_1272_131##9	a_1272_131##3	2.61135e-19
C605	VGND#13	a_1429_308#	1.8747e-18
C606	VPWR	a_2492_424##2	5.48282e-19
C607	VPWR	a_1827_144##5	9.33591e-19
C608	VPWR	a_1827_144##2	6.45284e-19
C609	RESET_B#2	CLK_N#2	1.46441e-17
C610	a_239_81##2	a_284_464##8	3.71927e-17
C611	a_1827_144##11	a_1272_131##2	1.89762e-19
C612	VPWR#4	a_854_74##12	2.09945e-19
C613	VGND#4	a_1074_88##5	6.05923e-18
C614	a_2087_410##5	RESET_B#8	2.58097e-19
C615	VGND#6	a_1074_88##10	6.08503e-19
C616	a_1429_308##5	a_1429_308##7	1.76041e-18
C617	a_284_464##7	VPWR#11	2.77688e-17
C618	a_1827_144##5	a_2492_424##3	8.1568e-19
C619	a_1429_308##5	a_854_74##3	1.4642e-19
C620	a_1827_144##11	a_2087_410##3	2.7535e-18
C621	a_1429_308##7	a_1272_131##2	4.5167e-17
C622	a_284_464##8	SCD#4	1.80747e-17
C623	a_854_74##2	a_1074_88##5	3.36615e-18
C624	VGND#4	a_854_74##2	3.41046e-18
C625	a_1827_144##2	a_2492_424##3	5.91016e-18
C626	SCD#2	RESET_B#2	4.83245e-17
C627	a_1272_131##2	VPWR#17	3.52686e-17
C628	a_27_88##7	D#2	1.7412e-19
C629	CLK_N#2	a_854_74##15	6.54689e-18
C630	a_1429_308##3	RESET_B#6	3.27307e-17
C631	RESET_B#13	a_854_74##3	6.47998e-18
C632	a_1272_131##9	RESET_B#4	4.74485e-19
C633	a_27_88##6	D#2	6.7921e-19
C634	VGND#13	a_854_74##3	1.0804e-17
C635	a_1429_308##5	a_1272_131##5	2.41998e-18
C636	SCD#1	a_538_81#	3.71439e-18
C637	VGND#5	a_1272_131##2	1.38043e-18
C638	a_2492_424##3	a_2492_424#	4.67651e-19
C639	SCE#6	a_538_81#	6.55872e-18
C640	SCE#7	SCD#2	1.12566e-17
C641	a_1827_144##11	a_854_74##11	4.20193e-17
C642	SCE	a_284_464##5	1.31259e-18
C643	a_284_464##6	a_1074_88##10	8.14545e-17
C644	a_1429_308##5	VPWR#17	1.24293e-18
C645	a_1429_308##7	RESET_B#5	4.05397e-19
C646	a_1272_131##7	a_854_74##4	7.23845e-19
C647	VPWR#11	a_27_88##3	6.97922e-18
C648	a_27_88##4	SCD#2	2.91035e-17
C649	RESET_B#2	D#2	3.44437e-19
C650	VPWR#17	a_2087_410##3	2.28943e-19
C651	a_2492_424##3	a_1827_144#	4.40519e-17
C652	a_2087_410##2	a_2087_410##5	1.23892e-18
C653	a_284_464#	a_854_74##6	7.13791e-19
C654	SCE#7	a_27_88##4	2.20867e-17
C655	a_1272_131##5	a_1074_88##7	6.57717e-20
C656	D#2	SCD#2	1.67326e-18
C657	a_1827_144##4	a_2492_424##2	5.49056e-20
C658	a_1429_308##7	a_854_74##11	1.8311e-18
C659	a_1827_144##4	a_2492_424#	1.91167e-20
C660	a_854_74##2	a_1272_131##3	2.04174e-17
C661	a_27_88##7	a_27_88##2	2.05535e-18
C662	SCE	SCD#4	6.75704e-18
C663	a_1074_88##4	a_1429_308##3	4.47196e-17
C664	RESET_B	a_854_74##6	2.65449e-18
C665	a_1272_131##9	a_1429_308#	2.02222e-18
C666	RESET_B	a_854_74##4	7.48018e-19
C667	a_1272_131##7	a_1272_131##2	3.75549e-19
C668	a_1827_144##4	a_1827_144##5	1.78075e-17
C669	a_284_464#	a_1272_131##7	5.10915e-17
C670	a_1827_144##11	a_1074_88##7	2.4177e-17
C671	a_27_88##7	SCE	3.77704e-19
C672	VPWR#10	a_284_464##2	1.60856e-17
C673	D#2	a_27_88##4	5.92121e-17
C674	a_1827_144##4	a_1827_144#	1.65352e-19
C675	a_239_81#	RESET_B#3	3.42606e-19
C676	a_1827_144##9	a_2087_410##2	8.55006e-19
C677	a_854_74##15	CLK_N	1.70484e-17
C678	VPWR#17	a_854_74##11	3.55703e-19
C679	a_284_464##5	a_284_464##2	9.76841e-19
C680	a_1827_144##4	a_1827_144##2	3.18588e-17
C681	D#1	a_324_81#	7.45713e-18
C682	a_27_88##7	SCE#4	2.25593e-17
C683	RESET_B#4	a_854_74##2	5.86859e-19
C684	a_1074_88##10	a_1074_88##11	1.55343e-18
C685	VGND#5	RESET_B#5	2.20787e-19
C686	VPWR	VPWR#7	8.06795e-17
C687	a_1827_144##4	a_1827_144##3	4.31322e-18
C688	a_27_88#	a_324_81#	7.45713e-18
C689	VPWR#6	a_854_74#	1.54456e-19
C690	VPWR	VPWR#6	8.17683e-17
C691	VGND#8	a_284_464##5	2.92051e-17
C692	a_1429_308##7	a_1074_88##7	8.42142e-17
C693	VPWR	VPWR#4	9.35424e-17
C694	a_27_88##2	D#2	2.77597e-18
C695	VPWR	VPWR#3	6.50881e-17
C696	SCE#3	a_27_88##4	2.91458e-18
C697	VPWR	VPWR#2	4.88856e-17
C698	a_1827_144##5	a_2492_424##4	2.02679e-19
C699	VPWR#11	D#3	7.62153e-19
C700	a_1272_131##7	RESET_B#5	6.63186e-19
C701	VGND#16	a_239_81##2	3.94878e-17
C702	a_1074_88##12	a_1272_131##7	4.12141e-19
C703	a_854_74##8	a_1074_88##4	2.84997e-17
C704	SCE#3	D#2	6.41669e-19
C705	a_1272_131##5	a_1272_131#	7.54527e-19
C706	a_1827_144##4	RESET_B#7	1.12696e-17
C707	a_1827_144##11	a_1272_131#	5.48008e-19
C708	a_27_88##7	SCE#3	6.43524e-17
C709	VPWR	a_2087_410##5	6.21071e-18
C710	a_1272_131##9	a_854_74##3	4.35346e-17
C711	VPWR#18	a_1429_308##2	5.44236e-19
C712	VGND#6	a_284_464##6	5.72058e-17
C713	a_27_88##2	SCE#3	4.88984e-17
C714	a_284_464#	a_854_74##4	6.42613e-19
C715	VPWR#17	a_1074_88##7	1.34026e-18
C716	a_239_81#	SCD#3	3.49519e-20
C717	a_2087_410##5	VPWR#4	1.71826e-17
C718	a_27_88##6	SCE#3	5.79208e-17
C719	RESET_B#4	a_1272_131##3	1.59436e-17
C720	VGND#13	a_1827_144##8	9.02744e-18
C721	a_239_81#	SCD#2	2.28726e-19
C722	VGND#6	a_854_74##6	1.59478e-19
C723	a_1827_144##4	a_2087_410#	7.56181e-18
C724	a_1272_131##5	a_1429_308##7	2.89849e-18
C725	a_1074_88##12	a_854_74##6	3.60821e-18
C726	Q	Q#3	3.85735e-18
C727	SCE	a_284_464##8	8.74719e-17
C728	VGND#11	Q	7.53271e-17
C729	a_1429_308##7	a_1272_131#	6.21869e-17
C730	VPWR#10	a_854_74##3	1.48696e-19
C731	a_239_81##2	SCE	5.93445e-18
C732	a_1827_144##9	a_854_74##12	4.1548e-17
C733	VPWR	a_1272_131##5	3.11204e-18
C734	RESET_B	VGND#7	5.64877e-18
C735	RESET_B	VGND#6	5.51026e-18
C736	a_1272_131##7	a_1429_308##2	2.66588e-17
C737	VGND	a_2492_424##2	2.45002e-18
C738	VPWR#1	a_2492_424##4	6.4108e-18
C739	VGND	a_1827_144##5	7.93814e-19
C740	a_284_464#	a_1074_88##12	6.66741e-17
C741	VPWR#10	CLK_N#4	1.74723e-18
C742	VGND	a_1827_144##2	4.48775e-18
C743	VGND#2	a_2492_424#	2.54289e-18
C744	a_284_464##8	SCD#2	1.2714e-17
C745	a_27_88##4	SCE#2	1.19556e-18
C746	CLK_N	a_854_74##13	8.40199e-18
C747	RESET_B	VPWR#9	2.0352e-18
C748	a_854_74##3	a_854_74##2	1.5788e-19
C749	RESET_B#8	a_1827_144##5	1.27719e-17
C750	a_854_74##9	a_854_74##8	1.51614e-17
C751	RESET_B	VPWR#8	2.18479e-18
C752	VPWR#14	a_2492_424##2	8.01418e-18
C753	a_1272_131##2	VPWR#6	4.15869e-19
C754	a_1074_88##2	a_1272_131##9	1.62107e-17
C755	a_2087_410#	RESET_B#8	2.45982e-17
C756	VGND#16	SCE#2	2.866e-18
C757	VPWR#17	a_1272_131#	5.70468e-17
C758	a_284_464##8	SCD#3	2.2174e-18
C759	a_854_74##6	a_854_74##4	2.97602e-18
C760	a_1272_131##5	RESET_B#6	1.93479e-17
C761	a_239_81#	SCE#7	5.13977e-19
C762	a_1429_308##5	VGND#13	2.39644e-18
C763	RESET_B#8	a_1827_144##2	4.106e-17
C764	VPWR#11	SCE#1	3.52949e-19
C765	a_1074_88##12	a_1429_308##2	1.95236e-19
C766	a_1429_308##7	RESET_B#6	6.61327e-19
C767	a_1272_131##5	a_854_74##2	4.64374e-20
C768	VPWR#3	VPWR#14	5.00542e-20
C769	a_1074_88#	a_1489_131#	2.10228e-18
C770	VPWR#10	SCD#7	5.86449e-18
C771	a_1074_88#	a_1272_131##7	1.47519e-18
C772	a_284_464#	VPWR#19	2.71504e-17
C773	a_2087_410##5	VPWR#3	2.84251e-19
C774	RESET_B#14	a_2087_410##4	1.18458e-18
C775	a_1272_131##8	a_1272_131#	8.25822e-19
C776	a_1429_308#	RESET_B#4	3.92229e-17
C777	a_1272_131##5	VPWR#17	1.74227e-17
C778	RESET_B	a_1074_88##10	7.21002e-18
C779	Q	Q#1	5.99777e-18
C780	a_1074_88##2	a_284_464##6	1.10154e-17
C781	a_1827_144##5	a_1827_144##7	1.11178e-18
C782	VPWR#14	Q	1.07587e-16
C783	RESET_B#8	a_854_74##2	1.98952e-19
C784	a_284_464##8	SCE#7	1.19015e-17
C785	a_27_88##8	VGND#16	4.26831e-17
C786	a_1074_88##10	a_854_74##8	1.13517e-19
C787	VPWR#17	RESET_B#6	3.01543e-18
C788	VPWR#14	a_1827_144##5	6.45664e-21
C789	a_1827_144##9	a_1074_88##6	5.49062e-17
C790	VGND#8	CLK_N#4	1.78688e-18
C791	CLK_N#1	a_854_74##9	5.94316e-18
C792	RESET_B	a_284_464##5	4.82666e-17
C793	VGND#8	a_854_74##10	9.34115e-18
C794	SCE	a_284_464##7	1.30969e-18
C795	a_1074_88##12	a_854_74##4	2.2065e-17
C796	RESET_B	a_284_464##2	1.11529e-17
C797	a_1074_88#	a_1411_131#	6.92717e-18
C798	a_1272_131##9	a_854_74##10	1.54223e-20
C799	a_2087_410##5	a_2492_424##2	2.65583e-20
C800	VPWR#18	a_1272_131#	4.4807e-19
C801	RESET_B	CLK_N#4	1.11527e-17
C802	VGND	VGND#5	1.49422e-16
C803	VPWR#19	a_854_74##6	8.87051e-20
C804	VGND#6	a_1074_88#	3.35144e-17
C805	VGND	VGND#3	1.00388e-16
C806	VGND	VGND#2	8.18389e-17
C807	CLK_N	a_854_74##10	2.04288e-20
C808	a_854_74##3	RESET_B#4	1.9869e-17
C809	VGND#2	a_1827_144#	5.73071e-18
C810	a_1827_144##2	a_1827_144##7	4.4572e-19
C811	a_239_81##2	SCE#7	3.94321e-19
C812	RESET_B	SCD#6	3.13203e-18
C813	RESET_B	SCD#4	3.83165e-18
C814	a_1272_131##7	a_1074_88##3	8.30141e-17
C815	a_1074_88##10	a_854_74##3	5.96741e-18
C816	VPWR#6	RESET_B#5	4.92232e-20
C817	RESET_B#14	VGND#12	3.92937e-18
C818	a_1272_131##8	RESET_B#6	2.91542e-17
C819	a_1272_131##5	a_1429_308##3	5.66729e-21
C820	a_854_74##12	a_2087_410#	2.06032e-17
C821	VGND#3	a_1827_144##2	6.32079e-19
C822	VGND#5	a_1074_88#	6.10464e-17
C823	VPWR	VPWR#14	2.0795e-17
C824	a_1074_88##3	a_284_464#	1.7886e-17
C825	VPWR	a_2492_424##7	2.03066e-17
C826	a_284_464##6	a_854_74##10	3.96827e-17
C827	VPWR	VPWR#15	1.72562e-17
C828	SCE#2	D#2	3.90964e-18
C829	a_284_464##8	a_27_88##4	2.95149e-19
C830	VGND#8	RESET_B#1	7.78012e-18
C831	VPWR#17	a_1429_308##3	4.0955e-19
C832	VGND	a_1827_144##9	2.90145e-17
C833	VPWR	a_2087_410##7	1.70045e-17
C834	a_2087_410##2	a_1827_144##5	2.12775e-19
C835	a_1074_88##5	a_854_74##12	2.75661e-17
C836	a_2492_424##7	VPWR#3	8.63042e-18
C837	a_27_88##8	SCE#7	1.50158e-20
C838	VGND#2	a_1827_144##5	4.24794e-19
C839	VPWR	a_1827_144##11	2.38612e-17
C840	D	a_27_88##3	6.05036e-20
C841	a_854_74##3	a_1429_308#	6.11213e-17
C842	VPWR	a_1429_308##7	3.91219e-17
C843	RESET_B#3	CLK_N#1	2.97703e-18
C844	Q	a_2492_424#	2.68434e-17
C845	RESET_B#6	VPWR#18	1.04627e-17
C846	VPWR	VPWR#17	1.52085e-17
C847	D	D#3	9.4947e-18
C848	VGND#3	a_1827_144##3	7.6288e-18
C849	Q	a_1827_144#	9.75675e-19
C850	VPWR	a_1272_131##8	1.10328e-17
C851	SCE	SCD#1	6.41053e-19
C852	RESET_B	a_284_464##6	3.19505e-18
C853	VGND#8	SCD#1	4.06029e-18
C854	VGND#6	VGND#14	4.6069e-18
C855	a_854_74##12	a_854_74##2	2.41057e-19
C856	VPWR	a_1272_131##7	1.07166e-17
C857	a_1074_88##6	a_2087_410#	3.18141e-18
C858	RESET_B#14	RESET_B#9	3.50948e-19
C859	a_854_74##13	a_1074_88##12	1.94307e-17
C860	SCE	D#1	1.31437e-17
C861	RESET_B	a_854_74##15	5.82088e-18
C862	a_1272_131##7	a_1272_131#	4.19872e-19
C863	a_239_81##2	a_27_88##4	1.75222e-19
C864	VGND#6	a_854_74##4	3.08378e-19
C865	RESET_B#14	a_1827_144##8	1.36078e-19
C866	a_1272_131##8	a_1429_308##3	1.18551e-18
C867	VPWR#4	VPWR#15	1.83732e-18
C868	a_854_74##10	a_1074_88##11	1.79267e-17
C869	a_27_88##6	a_284_464##7	1.21917e-17
C870	a_2087_410##5	a_1827_144##5	2.82621e-17
C871	a_854_74##7	a_284_464#	1.22646e-18
C872	a_1074_88##6	a_1074_88##5	1.59645e-19
C873	VGND#8	SCE#6	6.38641e-18
C874	a_284_464##6	CLK_N#3	3.53706e-19
C875	a_1074_88##10	a_1074_88##2	5.43079e-18
C876	a_2492_424##7	VPWR#2	1.01117e-17
C877	VPWR	a_1827_144#	1.99766e-19
C878	VGND	VGND#11	1.62212e-17
C879	a_2492_424##7	a_1827_144##5	2.83367e-19
C880	a_854_74##7	a_1074_88##12	4.48255e-18
C881	VGND	a_2492_424##5	2.2025e-17
C882	VGND	a_2087_410##4	2.12617e-17
C883	VPWR#18	a_1429_308##3	2.07229e-17
C884	VPWR#10	D	5.97507e-18
C885	a_1074_88##6	a_854_74##2	6.2718e-17
C886	VGND#8	SCD#4	5.19605e-18
C887	VGND	VGND#12	2.25318e-17
C888	VGND#8	D	6.10835e-18
C889	SCD#3	RESET_B#3	2.92347e-17
C890	VGND	a_1827_144##8	2.1964e-17
C891	VGND	a_1429_308##5	5.65008e-18
C892	VGND	VGND#13	1.09829e-17
C893	a_854_74##10	VGND#14	1.62037e-17
C894	Q	a_2492_424##4	3.4771e-17
C895	RESET_B	a_284_464#	6.68542e-18
C896	VGND#2	a_1827_144##7	5.98342e-19
C897	a_1272_131##7	RESET_B#6	3.95451e-19
C898	RESET_B	a_1074_88##12	2.4259e-17
C899	VPWR#19	a_854_74##7	8.83014e-19
C900	VGND	a_1272_131##9	3.83915e-18
C901	RESET_B	VPWR#19	3.77369e-18
C902	a_1272_131##5	VPWR#18	2.14515e-17
C903	RESET_B	a_854_74##13	1.44391e-17
C904	a_1272_131##8	a_1074_88##4	1.88036e-19
C905	RESET_B	VPWR#20	3.92621e-18
C906	a_1074_88##6	a_1272_131##3	2.1519e-17
C907	a_239_81##2	D#2	8.47274e-19
C908	RESET_B	a_284_464##3	6.25315e-18
C909	a_1074_88##10	a_1074_88##12	7.10054e-18
C910	a_1074_88##2	a_854_74##3	1.19988e-17
C911	a_284_464##5	CLK_N#4	2.74628e-17
C912	RESET_B#13	a_1827_144##8	7.61116e-19
C913	VGND#2	a_1827_144##2	1.37661e-18
C914	SCE	D#3	8.66222e-20
C915	a_27_88##7	a_27_88##6	1.31843e-18
C916	a_2492_424##2	VNB	5.35081e-17
C917	a_1827_144##5	VNB	5.12125e-17
C918	RESET_B#14	a_1074_88##7	4.88219e-18
C919	a_1827_144##2	VNB	5.5986e-17
C920	a_854_74##6	VNB	2.49774e-17
C921	VGND	VPWR#14	4.37802e-18
C922	a_854_74##4	VNB	6.49033e-17
C923	VGND#3	RESET_B#7	3.67688e-18
C924	SCE#2	VNB	1.08781e-16
C925	a_1074_88##6	RESET_B#4	2.55304e-19
C926	a_854_74#	a_854_74##2	1.99687e-18
C927	SCE#2	a_27_88##2	1.45515e-18
C928	a_1074_88##12	CLK_N#2	1.61952e-20
C929	SCE#2	D#3	2.06548e-17
C930	VPWR	a_2492_424##4	2.03582e-18
C931	VPWR#10	CLK_N	5.26691e-19
C932	VGND#16	a_27_88##7	2.28934e-17
C933	VGND	a_1827_144##11	4.05809e-18
C934	VPWR	a_1827_144##7	4.00056e-18
C935	VPWR#10	a_27_88##6	1.1543e-17
C936	a_27_88##2	a_284_464##8	1.68083e-18
C937	VGND#8	SCE#4	9.73272e-18
C938	VPWR#18	a_1074_88##4	3.09032e-18
C939	VGND#8	CLK_N	6.91876e-19
C940	VPWR#4	a_2087_410##7	4.11261e-17
C941	RESET_B#13	a_1429_308##5	2.21959e-17
C942	a_2087_410##5	a_1827_144##2	7.83293e-19
C943	VPWR#20	VPWR#19	8.03956e-18
C944	a_1074_88##6	a_1429_308#	2.22644e-19
C945	a_854_74#	a_1272_131##3	1.43037e-19
C946	a_1272_131##7	a_1429_308##3	2.18235e-17
C947	a_27_88##3	SCD#3	5.03679e-17
C948	VPWR	a_1272_131#	1.17781e-18
C949	a_854_74##10	a_854_74##3	1.09791e-19
C950	RESET_B#13	a_1074_88##7	1.01729e-18
C951	VPWR#10	SCE	5.22352e-18
C952	a_1074_88##10	a_854_74##10	1.27819e-17
C953	Q	VPWR#1	4.18273e-17
C954	VGND#8	SCE	1.13179e-17
C955	VGND#1	Q	4.17582e-17
C956	VPWR#5	a_854_74##11	5.80019e-18
C957	VGND#7	VGND#15	7.7042e-18
C958	a_27_88##2	a_239_81##2	4.01791e-17
C959	VGND#7	VNB	3.21212e-17
C960	VPWR#11	VPWR#9	8.25894e-19
C961	a_854_74##13	CLK_N#2	1.99551e-18
C962	VGND#6	VNB	7.34527e-17
C963	VGND#5	VNB	7.17786e-17
C964	VGND#3	VNB	5.34166e-17
C965	VGND	a_2492_424#	1.35069e-18
C966	RESET_B#13	VGND#13	2.4369e-18
C967	VGND#2	VNB	4.53508e-17
C968	a_1074_88##6	a_854_74##3	9.4105e-20
C969	VGND	a_1827_144#	4.84816e-18
C970	VGND#6	a_854_74##7	1.44224e-18
C971	a_854_74##2	a_1272_131##2	1.53554e-18
C972	VPWR#11	VNB	4.74548e-17
C973	VGND	a_1827_144##3	1.22807e-18
C974	VPWR#9	VNB	3.05724e-17
C975	VPWR#8	VNB	5.65845e-17
C976	VPWR#7	VNB	4.93364e-17
C977	VPWR#6	VNB	4.41421e-17
C978	VPWR#4	VNB	3.92357e-17
C979	VPWR#3	VNB	3.41384e-17
C980	D	a_27_88##4	7.45757e-17
C981	VPWR#2	VNB	2.73572e-17
C982	VGND	a_854_74##2	2.02001e-18
C983	VGND#16	a_27_88##2	1.4151e-17
C984	VGND	a_1272_131##3	3.64448e-18
C985	VGND#8	a_27_88##7	2.13024e-18
C986	RESET_B#9	a_1827_144##5	9.86639e-18
C987	D	D#2	2.40227e-17
C988	VGND	RESET_B#4	2.31822e-18
C989	a_2087_410##5	VNB	9.62155e-18
C990	VPWR#20	CLK_N#2	3.82619e-19
C991	VGND	a_1429_308#	2.91081e-18
C992	a_1827_144##9	VNB	9.74625e-18
C993	D	a_27_88##2	1.14769e-18
C994	a_2492_424##3	Q	1.6812e-17
C995	VPWR#18	a_854_74##8	5.1886e-19
C996	CLK_N	a_854_74##7	3.83606e-17
C997	VPWR#5	a_1074_88##7	8.41246e-18
C998	a_1074_88##10	VNB	9.78894e-18
C999	SCE#3	D	5.16603e-17
C1000	RESET_B#14	VPWR	3.19418e-17
C1001	CLK_N	CLK_N#2	6.39831e-18
C1002	a_854_74##10	a_1074_88##2	3.75318e-18
C1003	RESET_B	a_854_74##9	1.03091e-18
C1004	VPWR#15	a_1827_144##5	1.48865e-18
C1005	a_1272_131##5	VNB	1.06381e-17
C1006	RESET_B#13	VPWR	4.5264e-17
C1007	a_2087_410##7	VPWR#3	8.42461e-18
C1008	a_854_74##15	CLK_N#3	3.82717e-17
C1009	a_27_88##6	VPWR#22	3.64093e-17
C1010	RESET_B	CLK_N#1	1.29427e-18
C1011	a_284_464##5	VNB	1.74274e-17
C1012	VPWR	VPWR#5	6.14305e-17
C1013	a_284_464##2	VNB	1.07646e-17
C1014	a_1272_131##7	a_1074_88##4	4.06284e-17
C1015	a_2087_410##4	a_2087_410##5	8.99116e-19
C1016	CLK_N#4	VNB	1.53861e-18
C1017	a_1272_131##9	a_1272_131##7	5.25346e-19
C1018	SCD#7	VNB	2.09326e-18
C1019	VGND#1	VGND#2	3.55926e-18
C1020	VGND	a_1827_144##7	3.9147e-19
C1021	SCD#4	VNB	3.95111e-19
C1022	a_27_88##6	a_206_464#	2.78569e-18
C1023	D#3	a_27_88##3	4.96447e-18
C1024	SCE	CLK_N#2	1.16458e-19
C1025	a_27_88##7	VNB	3.93527e-17
C1026	VPWR	a_2492_424##3	9.77201e-19
C1027	a_27_88##6	VNB	3.91693e-17
C1028	VPWR	a_1827_144##4	8.30048e-18
C1029	SCE	RESET_B#2	7.55246e-18
C1030	VGND#11	VNB	5.61091e-18
C1031	a_854_74##13	RESET_B#2	1.39782e-18
C1032	a_239_81#	a_854_74##10	6.77848e-19
C1033	a_2492_424##5	VNB	8.05208e-18
C1034	VGND#3	a_2087_410#	3.39848e-18
C1035	a_2087_410##4	VNB	1.10774e-17
C1036	SCE	SCD#2	5.821e-18
C1037	VGND#12	VNB	1.82623e-18
C1038	VPWR	a_2087_410##2	6.68589e-18
C1039	a_2492_424##3	a_2492_424##4	1.11719e-18
C1040	a_1827_144##8	VNB	5.0868e-18
C1041	SCE	SCE#7	2.08346e-17
C1042	a_1429_308##5	VNB	2.69894e-18
C1043	VPWR	a_854_74##12	1.3193e-19
C1044	VGND#13	VNB	9.72075e-18
C1045	SCE	a_27_88##4	5.28664e-17
C1046	a_1272_131##9	VNB	3.89278e-18
C1047	a_1074_88##3	VPWR#8	7.12587e-19
C1048	a_284_464##6	VNB	9.96009e-18
C1049	VPWR	a_854_74#	1.12392e-19
C1050	VPWR#4	VPWR#16	1.01664e-17
C1051	SCE	D#2	3.25841e-17
C1052	a_854_74##15	VNB	4.29687e-18
C1053	VPWR	a_1272_131##2	3.11254e-18
C1054	RESET_B	VPWR#10	4.04293e-17
C1055	a_239_81#	VNB	8.72268e-18
C1056	a_27_88##2	SCE	4.64218e-17
C1057	a_284_464##8	VNB	3.29433e-18
C1058	VGND#8	RESET_B	4.07468e-17
C1059	VPWR	RESET_B#5	1.88992e-18
C1060	a_239_81##2	VNB	1.3226e-17
C1061	RESET_B#5	a_1272_131##3	2.58629e-18
C1062	VGND#16	VNB	1.05081e-17
C1063	VPWR	a_1429_308##2	1.28628e-18
C1064	a_27_88##8	VNB	2.52993e-17
C1065	CLK_N#3	VGND#15	1.53248e-17
C1066	VPWR#14	VNB	5.37107e-18
C1067	a_1074_88##10	CLK_N#3	3.46857e-19
C1068	a_2492_424##7	VNB	7.81301e-18
C1069	VPWR#15	VNB	5.32098e-18
C1070	a_2087_410##7	VNB	2.14163e-18
C1071	VPWR#18	a_854_74##9	2.91047e-19
C1072	SCE#3	SCE#2	4.08357e-17
C1073	a_1827_144#	a_1827_144##7	5.05708e-19
C1074	a_2492_424##3	a_1827_144##7	3.94319e-17
C1075	a_1827_144##11	VNB	8.37637e-18
C1076	a_1429_308##7	VNB	6.15102e-18
C1077	a_1074_88##3	VPWR#7	7.41844e-19
C1078	VPWR#17	VNB	6.47847e-18
C1079	a_1272_131##5	a_854_74##3	8.7298e-20
C1080	VGND#7	CLK_N#2	1.47173e-19
C1081	a_1272_131##8	VNB	7.35707e-18
C1082	VGND	RESET_B#14	3.10502e-17
C1083	RESET_B#13	a_1272_131##9	2.42122e-17
C1084	VPWR#18	VNB	4.39195e-19
C1085	VGND#4	a_1827_144##8	3.63861e-17
C1086	VPWR#19	a_1429_308##3	2.02398e-19
C1087	VGND	RESET_B#13	4.66246e-17
C1088	a_1272_131##7	VNB	7.63415e-18
C1089	a_284_464#	VNB	9.50186e-18
C1090	a_1074_88##12	VNB	1.40301e-18
C1091	RESET_B#2	a_284_464##3	3.10448e-17
C1092	VPWR#19	VNB	2.12599e-18
C1093	VGND	VGND#4	7.47547e-17
C1094	a_854_74##13	VNB	7.13205e-18
C1095	a_1272_131##7	a_854_74##8	3.05853e-17
C1096	VPWR#20	VNB	4.11743e-18
C1097	a_284_464##3	VNB	8.35683e-18
C1098	a_1827_144##4	a_2492_424##4	5.13848e-20
C1099	a_284_464##7	VNB	1.98766e-19
C1100	a_1272_131##7	a_1272_131##5	5.44489e-18
C1101	a_239_81#	VGND#7	1.1742e-17
C1102	a_854_74##15	RESET_B#1	2.92631e-19
C1103	a_1429_308##2	a_854_74##2	6.70888e-20
C1104	VPWR#22	VNB	2.3684e-18
C1105	VGND	a_2492_424##3	1.7797e-18
C1106	a_27_88##9	VNB	2.40139e-17
C1107	a_2492_424#	VNB	3.31625e-17
C1108	VGND	a_1827_144##4	1.54413e-17
C1109	a_1827_144#	VNB	5.0613e-17
C1110	RESET_B	a_854_74##7	5.03497e-17
C1111	a_1827_144##3	VNB	2.5259e-17
C1112	VGND	RESET_B#8	2.50318e-18
C1113	CLK_N#4	a_284_464##2	1.62799e-18
C1114	RESET_B#7	VNB	2.50177e-17
C1115	VGND#6	CLK_N#2	2.58948e-19
C1116	a_2087_410#	VNB	4.48794e-17
C1117	RESET_B	CLK_N#2	4.40532e-18
C1118	a_1074_88##5	VNB	3.208e-17
C1119	a_854_74##2	VNB	1.05129e-16
C1120	VGND	a_854_74##12	3.35726e-18
C1121	RESET_B	RESET_B#2	3.40645e-17
C1122	a_1272_131##3	VNB	2.30311e-17
C1123	a_27_88##6	a_27_88##9	1.58697e-18
C1124	RESET_B#4	VNB	2.70253e-17
C1125	VGND	a_1074_88##6	1.82865e-17
C1126	SCE#1	D#3	4.47326e-17
C1127	a_1429_308#	VNB	2.25422e-17
C1128	RESET_B	SCD#2	1.03208e-20
C1129	a_854_74##3	VNB	1.32339e-16
C1130	VGND	a_854_74#	2.149e-18
C1131	a_1074_88##2	VNB	2.00951e-17
C1132	a_854_74##10	VNB	3.45498e-17
C1133	VGND	a_1272_131##2	1.61722e-18
C1134	a_1074_88##6	a_1827_144##2	5.91857e-19
C1135	RESET_B#14	VGND#3	2.89879e-18
C1136	CLK_N#3	VNB	3.93134e-17
C1137	RESET_B#1	VNB	2.85366e-17
C1138	VGND	RESET_B#5	7.955e-19
C1139	RESET_B	a_27_88##4	3.2132e-18
C1140	RESET_B#13	a_284_464##6	2.18144e-18
C1141	SCD#1	VNB	3.00446e-17
C1142	SCE#6	VNB	2.03568e-17
C1143	VGND	a_1429_308##2	4.20535e-18
C1144	a_1429_308#	RESET_B#5	1.82108e-18
C1145	RESET_B	D#2	3.89395e-19
C1146	D#1	VNB	3.60348e-17
C1147	CLK_N#3	a_854_74##10	3.81901e-18
C1148	a_27_88#	VNB	2.23074e-17
C1149	VGND	a_1074_88#	3.1701e-17
C1150	SCE#4	VNB	5.40162e-17
C1151	a_239_81#	CLK_N#3	4.64628e-18
C1152	a_1429_308##2	a_1272_131##3	1.68001e-19
C1153	a_2492_424##4	VNB	4.01522e-17
C1154	a_1827_144##4	a_1827_144##7	8.48804e-20
C1155	a_1827_144##7	VNB	6.43742e-17
C1156	a_1827_144##6	VNB	3.218e-17
C1157	RESET_B#9	VNB	4.30813e-17
C1158	a_2087_410##3	VNB	1.87049e-17
C1159	a_854_74##11	VNB	3.87591e-17
C1160	a_1074_88##7	VNB	5.4925e-17
C1161	a_284_464#	a_854_74##8	3.72987e-17
C1162	a_1272_131#	VNB	3.57164e-17
C1163	RESET_B#6	VNB	4.26788e-17
C1164	a_1429_308##3	VNB	2.91661e-17
C1165	a_1074_88##4	VNB	2.72319e-17
C1166	a_1272_131##9	a_854_74##6	1.35431e-19
C1167	a_854_74##8	VNB	6.60343e-17
C1168	a_854_74##9	VNB	5.32843e-17
C1169	CLK_N#1	VNB	5.67826e-17
C1170	RESET_B#3	VNB	4.36669e-17
C1171	SCD#3	VNB	4.51764e-17
C1172	a_284_464##3	VPWR#20	2.78118e-17
C1173	a_27_88##3	VNB	2.88478e-17
C1174	D#3	VNB	4.03865e-17
C1175	a_854_74##3	RESET_B#5	1.25256e-18
C1176	SCE#1	VNB	2.26947e-17
C1177	SCE#5	VNB	2.97997e-17
C1178	a_1429_308##2	RESET_B#4	8.91696e-18
C1179	VPWR#1	VNB	8.91546e-17
C1180	VPWR#19	a_1074_88##4	3.45859e-19
C1181	RESET_B#1	VGND#15	4.60619e-18
C1182	VGND#1	VNB	8.96624e-17
C1183	RESET_B#14	VNB	3.7842e-18
C1184	a_284_464##3	SCD#2	1.43359e-18
C1185	RESET_B#13	VNB	2.12328e-17
C1186	VPWR#5	VNB	3.38413e-17
C1187	a_2492_424##7	VPWR#14	8.8663e-17
C1188	a_1074_88#	a_854_74##2	4.37993e-19
C1189	VGND#4	VNB	4.2422e-17
C1190	VPWR#10	VNB	2.88792e-16
C1191	a_1272_131##7	a_854_74##9	1.75014e-18
C1192	VGND#8	VNB	3.44302e-16
C1193	a_2492_424##3	VNB	4.8691e-17
C1194	a_1827_144##4	VNB	1.90943e-17
C1195	RESET_B#8	VNB	6.23615e-17
C1196	a_2087_410##2	VNB	6.75276e-17
C1197	a_854_74##12	VNB	5.49036e-17
C1198	a_1074_88##6	VNB	5.13258e-17
C1199	a_854_74#	VNB	2.55103e-17
C1200	RESET_B#13	VGND#6	3.05049e-18
C1201	a_1272_131##2	VNB	3.86754e-17
C1202	RESET_B#5	VNB	5.91304e-17
C1203	a_1429_308##2	VNB	5.64592e-17
C1204	SCE	D	4.24018e-17
C1205	a_284_464##2	a_854_74##8	2.73983e-19
C1206	a_1074_88#	VNB	6.48241e-17
C1207	a_1074_88##3	VNB	5.69815e-17
C1208	VPWR#8	a_854_74##7	1.47358e-19
C1209	a_854_74##7	VNB	2.61791e-17
C1210	a_1429_308##2	a_1429_308#	7.14554e-18
C1211	CLK_N#2	VNB	4.64749e-17
C1212	RESET_B#2	VNB	8.47878e-17
C1213	SCD#2	VNB	4.69726e-17
C1214	a_284_464##6	a_284_464#	4.75809e-19
C1215	SCE#7	VNB	4.10063e-17
C1216	a_27_88##4	VNB	4.41286e-17
C1217	a_1074_88#	a_1272_131##3	3.58261e-19
C1218	D#2	VNB	5.58158e-17
C1219	a_27_88##2	VNB	4.42055e-17
C1220	SCE#3	VNB	1.54496e-17
C1221	a_1827_144##4	RESET_B#9	1.24644e-17
C1222	SCE#5	SCE#1	3.12028e-17
C1223	a_284_464##5	a_854_74##9	1.75805e-20
C1224	a_1074_88##12	a_1272_131##9	9.52928e-20
C1225	RESET_B	CLK_N	8.56976e-18
C1226	RESET_B	SCE	2.56672e-18
C1227	a_284_464#	a_854_74##9	3.38148e-17
C1228	a_854_74##3	a_1429_308##2	1.67193e-17
C1229	a_1827_144##9	a_2087_410##4	1.06255e-18
C1230	RESET_B#13	VGND#5	8.16597e-18
C1231	a_239_81#	RESET_B#1	2.53823e-17
C1232	VGND#7	RESET_B#2	2.32657e-18
C1233	a_1074_88#	RESET_B#4	1.91004e-17
C1234	D	VNB	5.05364e-18
C1235	CLK_N	VNB	4.43792e-18
C1236	SCE	VNB	8.9594e-18
C1237	VPWR#9	VPWR#8	8.41297e-19
C1238	Q	VNB	1.11768e-16
C1239	VPWR	VNB	2.25146e-16
C1240	RESET_B	VNB	6.68282e-18
C1241	VPWR#19	a_854_74##8	2.98e-18
C1242	VGND	VNB	2.2949e-16
C1243	a_2087_410##2	a_1827_144##7	1.2569e-19
C1244	VGND#9	D#1	4.01236e-18
C1245	VPWR#12	VNB	6.85123e-17
C1246	a_27_88##9	VPWR#12	1.75321e-17
C1247	VGND#9	a_239_81##2	7.57851e-17
C1248	VGND#9	a_27_88##7	2.15159e-19
C1249	VGND#9	SCE#4	2.50278e-18
C1250	VPWR#12	SCE#5	1.78789e-18
C1251	VPWR#12	D#2	3.31036e-19
C1252	VGND#9	SCE#2	1.83413e-19
C1253	a_284_464##7	VPWR#12	2.00844e-17
C1254	VPWR#12	SCE#1	3.93988e-18
C1255	VGND#9	D#3	3.26056e-20
C1256	VPWR#12	D#3	7.52829e-18
C1257	VGND#9	a_27_88##2	1.72054e-18
C1258	VGND#9	VNB	7.97963e-17
C1259	VGND#9	a_27_88##8	1.64653e-17
C1260	VGND#9	a_27_88#	4.34188e-18
C1261	VGND#8	VGND#9	1.48767e-16
C1262	VPWR#10	VPWR#12	1.20963e-16
C1263	VGND#9	D#2	6.85554e-20
C1264	a_27_88##6	VPWR#12	4.32323e-18
*
*
.ENDS sky130_fd_sc_hs__sdfrtn_1
*
