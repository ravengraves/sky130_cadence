* Extracted by Quantus, converted by sky130cad/quantus.py
*
*
*
*                       LINUX           Wed Nov 18 08:31:44 2026
*
*
*
*  PROGRAM  advgen
*
*  Name           : advgen - Quantus - (64-bit)
*  Version        : 25.1.0-p047
*  Build Date     : Thu Dec 11 23:20:30 PST 2025
*
*  HSPICE LIBRARY
*
*  OPERATING_TEMPERATURE 150
*  QRC_TECH_DIR <path>/tech
*
*
*

*
.SUBCKT sky130_fd_sc_hs__dlrtn_1 VPB VNB VGND VPWR Q RESET_B D GATE_N
*
*
*  caps2d version: 10
*
*
*       TRANSISTOR CARDS
*
*
XM4 a_27_136##5 D#3 VGND#11 VNB sky130_fd_pr__nfet_01v8_lvt l=0.15 w=0.55 ad=0.15675 as=0.40125 pd=1.67 ps=2.98
XM0 VGND#11 GATE_N#3 a_232_98##12 VNB sky130_fd_pr__nfet_01v8_lvt l=0.15 w=0.74 ad=0.40125 as=0.1961 pd=2.98 ps=2.01
XM6 a_357_392##9 a_232_98# VGND#10 VNB sky130_fd_pr__nfet_01v8_lvt l=0.15 w=0.74 ad=0.2109 as=0.79615 pd=2.05 ps=3.85
XM15 VGND#10 a_27_136# a_681_74# VNB sky130_fd_pr__nfet_01v8_lvt l=0.15 w=0.64 ad=0.79615 as=0.1536 pd=3.85 ps=1.76
XM7 a_681_74# a_232_98##7 a_654_392##4 VNB sky130_fd_pr__nfet_01v8_lvt l=0.15 w=0.64 ad=0.1536 as=0.1915 pd=1.76 ps=1.93
XM16 a_654_392##4 a_357_392##3 a_854_74# VNB sky130_fd_pr__nfet_01v8_lvt l=0.15 w=0.42 ad=0.1915 as=0.1155 pd=1.93 ps=1.39
XM18 a_854_74# a_897_406# VGND#9 VNB sky130_fd_pr__nfet_01v8_lvt l=0.15 w=0.42 ad=0.1155 as=0.1239 pd=1.39 ps=1.43
XM14 a_897_406##12 a_654_392# a_1139_74# VNB sky130_fd_pr__nfet_01v8_lvt l=0.15 w=0.74 ad=0.2109 as=0.1776 pd=2.05 ps=1.96
XM8 a_1139_74# RESET_B#3 VGND#8 VNB sky130_fd_pr__nfet_01v8_lvt l=0.15 w=0.74 ad=0.1776 as=0.32705 pd=1.96 ps=2.37
XM19 VGND#8 a_897_406##6 Q#3 VNB sky130_fd_pr__nfet_01v8_lvt l=0.15 w=0.74 ad=0.32705 as=0.2701 pd=2.37 ps=2.21
XM3 a_27_136##7 D#1 VPWR#11 VPB sky130_fd_pr__pfet_01v8 l=0.15 w=0.84 ad=0.2478 as=0.39625 pd=2.27 ps=2.63
XM1 VPWR#11 GATE_N#1 a_232_98##13 VPB sky130_fd_pr__pfet_01v8 l=0.15 w=0.84 ad=0.39625 as=0.2478 pd=2.63 ps=2.27
XM9 a_357_392##8 a_232_98##4 VPWR#10 VPB sky130_fd_pr__pfet_01v8 l=0.15 w=0.84 ad=0.2478 as=0.4933 pd=2.27 ps=3.2
XM17 VPWR#10 a_27_136##3 a_570_392# VPB sky130_fd_pr__pfet_01v8 l=0.15 w=1 ad=0.4933 as=0.27 pd=3.2 ps=2.54
XM2 a_570_392# a_357_392# a_654_392##6 VPB sky130_fd_pr__pfet_01v8 l=0.15 w=1 ad=0.27 as=0.4029 pd=2.54 ps=3.09
XM13 a_654_392##6 a_232_98##8 a_793_508# VPB sky130_fd_pr__pfet_01v8 l=0.15 w=0.42 ad=0.4029 as=0.2247 pd=3.09 ps=1.91
XM11 a_793_508# a_897_406##3 VPWR#9 VPB sky130_fd_pr__pfet_01v8 l=0.15 w=0.42 ad=0.2247 as=0.4468 pd=1.91 ps=3.77
XM5 VPWR#9 a_654_392##3 a_897_406##9 VPB sky130_fd_pr__pfet_01v8 l=0.15 w=1 ad=0.4468 as=0.47 pd=3.77 ps=2.94
XM10 a_897_406##9 RESET_B#1 VPWR#8 VPB sky130_fd_pr__pfet_01v8 l=0.15 w=1 ad=0.47 as=0.4764 pd=2.94 ps=3.11
XM12 VPWR#8 a_897_406##4 Q#1 VPB sky130_fd_pr__pfet_01v8 l=0.15 w=1.12 ad=0.4764 as=0.3304 pd=3.11 ps=2.83
*
*
*       RESISTOR AND CAP/DIODE CARDS
*
Rg1	D#1	D#2	365.937134
Rg2	D#2	D#3	314.859589
Rg3	GATE_N#1	GATE_N#2	367.623138
Rg4	GATE_N#2	GATE_N#3	371.062500
Rg5	a_232_98#	a_232_98##2	380.521820
Rg6	a_232_98##2	a_232_98##3	240.053009
Rg7	a_232_98##2	a_232_98##4	429.287018
Rg8	a_357_392#	a_357_392##2	571.544128
Rg9	a_27_136#	a_27_136##2	561.815308
Rg10	a_27_136##2	a_27_136##3	492.429810
Rg11	a_232_98##5	a_232_98##6	19.785671
Rg12	a_232_98##6	a_232_98##7	797.768066
Rg13	a_232_98##6	a_232_98##8	257.686584
Rg14	a_357_392##3	a_357_392##4	382.539764
Rg15	a_897_406#	a_897_406##2	861.653503
Rg16	a_897_406##2	a_897_406##3	259.027618
Rg17	a_654_392#	a_654_392##2	490.298737
Rg18	a_654_392##2	a_654_392##3	504.445984
Rg19	RESET_B#1	RESET_B#2	469.301178
Rg20	RESET_B#2	RESET_B#3	366.980591
Rg21	a_897_406##4	a_897_406##5	464.927643
Rg22	a_897_406##5	a_897_406##6	410.288940
Rf1	D#2	D#5	161.051773
Rf2	D#6	D	0.818971
Rf3	D#5	D#6	4.724072
Rf4	GATE_N#2	GATE_N	162.201172
Rf5	a_27_136##2	a_27_136##6	364.580780
Rf6	a_27_136##6	a_27_136##7	92.425804
Rf7	a_27_136##5	a_27_136##6	15.000000
Rf8	a_232_98##5	a_232_98##10	352.025146
Rf9	a_232_98##10	a_232_98##3	32.889606
Rf10	a_232_98##3	a_232_98##12	43.908150
Rf11	a_232_98##10	a_232_98##13	11.530245
Rf12	a_357_392##4	a_357_392##2	201.530563
Rf13	a_357_392##2	a_357_392##7	86.914368
Rf14	a_357_392##7	a_357_392##8	21.548222
Rf15	a_357_392##7	a_357_392##9	76.869354
Rf16	a_654_392##4	a_654_392##5	122.779854
Rf17	a_654_392##5	a_654_392##6	166.525940
Rf18	RESET_B	RESET_B#4	1.235440
Rf19	RESET_B#5	RESET_B#2	161.468246
Rf20	RESET_B#4	RESET_B#5	3.349972
Rf21	a_897_406##5	a_897_406##8	219.151184
Rf22	a_897_406##8	a_897_406##10	11.304021
Rf23	a_897_406##10	a_897_406##2	202.726944
Rf24	a_897_406##8	a_897_406##12	70.485718
Rf25	a_897_406##9	a_897_406##10	5.000000
Rf26	Q	Q#2	0.181173
Rf27	Q#2	Q	13.225628
Rf28	Q	Q#3	86.356293
Rf29	Q#1	Q#2	5.000000
Rf30	VPWR#1	VPWR#2	39.422733
Rf31	VPWR#2	VPWR#3	101.487488
Rf32	VPWR#3	VPWR#4	122.331413
Rf33	VPWR#4	VPWR#5	65.355659
Rf34	VPWR#5	VPWR#6	120.118996
Rf36	VPWR#2	VPWR#8	34.939823
Rf37	VPWR#3	VPWR#9	16.761354
Rf38	VPWR#5	VPWR#10	26.830879
Rf39	VPWR#6	VPWR#11	41.081295
Rf40	VGND#1	VGND#2	47.823540
Rf41	VGND#2	VGND#3	106.964226
Rf42	VGND#3	VGND#4	108.084511
Rf43	VGND#4	VGND#5	42.772175
Rf44	VGND#5	VGND#6	145.383591
Rf46	VGND#2	VGND#8	31.534731
Rf47	VGND#3	VGND#9	31.473843
Rf48	VGND#5	VGND#10	11.311455
Rf49	VGND#6	VGND#11	24.468842
Rf57	a_654_392##2	a_654_392##5	160.232803
Re1	VPWR#1	VPWR	11.068454
Re2	VPWR	VPWR#4	0.790604
Re3	VGND#1	VGND	11.068454
Re4	VGND	VGND#4	0.790604
*
*       CAPACITOR CARDS
*
*
C1	a_27_136##5	a_27_136##7	3.0947e-18
C2	VGND#9	a_232_98##7	3.3893e-19
C3	a_654_392##4	a_357_392##3	3.93537e-17
C4	GATE_N#2	a_232_98##2	1.20517e-18
C5	VGND#3	VGND#2	3.48667e-19
C6	VGND#9	a_27_136#	3.57785e-19
C7	a_654_392##4	a_232_98##7	1.80997e-17
C8	a_357_392##8	a_654_392##6	5.14555e-18
C9	a_654_392##4	a_27_136#	7.72156e-18
C10	a_232_98##13	a_654_392##6	1.13877e-19
C11	a_897_406##12	a_897_406##8	2.13087e-18
C12	a_654_392##4	a_232_98#	2.27983e-18
C13	a_357_392##8	VPWR#10	3.75988e-18
C14	a_27_136#	VGND#10	1.00335e-17
C15	VGND#5	a_27_136##5	1.22891e-18
C16	VGND#1	VGND#2	4.12156e-19
C17	a_357_392##9	a_27_136#	1.77904e-19
C18	a_232_98##13	VPWR#10	5.14739e-17
C19	a_232_98#	VGND#10	1.69692e-17
C20	VPWR#1	VPWR#2	4.43522e-18
C21	a_232_98##13	a_357_392##8	1.11876e-16
C22	VPWR#11	VPWR#10	3.56077e-18
C23	a_357_392##9	a_232_98#	3.62762e-17
C24	a_232_98##12	a_232_98#	7.13271e-19
C25	a_654_392##6	a_232_98##6	3.4163e-17
C26	a_357_392##9	GATE_N#3	5.34464e-19
C27	VPWR#11	a_232_98##13	6.8115e-17
C28	a_232_98##12	GATE_N#3	4.40008e-17
C29	a_27_136##5	a_232_98#	4.92278e-19
C30	a_232_98##6	a_793_508#	7.08377e-19
C31	a_27_136##7	a_232_98##13	8.12413e-19
C32	GATE_N#3	VGND#11	2.05529e-17
C33	a_232_98##12	D#3	5.04315e-18
C34	a_357_392#	a_232_98##6	1.25939e-17
C35	a_27_136##5	GATE_N#3	3.38516e-17
C36	a_27_136##7	VPWR#11	6.51283e-17
C37	VGND#2	a_897_406##5	5.62732e-19
C38	D#3	VGND#11	1.75794e-17
C39	a_27_136##5	D#3	5.08976e-17
C40	a_897_406##5	VPWR#2	1.9307e-19
C41	a_232_98##2	a_27_136##3	1.06023e-18
C42	VGND#3	a_654_392##2	1.14445e-18
C43	RESET_B#3	a_897_406##6	2.04718e-17
C44	VPWR#5	a_232_98##2	7.78678e-21
C45	a_897_406##4	Q#1	1.20052e-17
C46	VPWR#2	RESET_B#2	8.13392e-20
C47	a_897_406##4	VPWR#8	3.69774e-17
C48	VPWR#3	VPWR#8	3.8647e-18
C49	VGND#3	a_897_406##2	8.82695e-20
C50	VPWR#3	a_232_98##6	1.32004e-18
C51	a_897_406##8	a_897_406##5	2.4696e-18
C52	a_654_392#	RESET_B#3	5.13476e-17
C53	a_654_392##2	VPWR#3	3.47811e-18
C54	RESET_B#1	VPWR#8	3.61497e-17
C55	a_357_392##8	a_232_98##6	6.9909e-20
C56	RESET_B#1	a_897_406##9	4.72242e-18
C57	a_897_406##8	RESET_B#2	5.00676e-17
C58	VGND#3	a_357_392##4	2.77765e-19
C59	VPWR#8	a_654_392##3	2.25983e-18
C60	a_897_406#	a_654_392#	4.64624e-18
C61	a_897_406##2	VPWR#3	5.51675e-17
C62	a_357_392##8	a_232_98##2	1.00609e-17
C63	a_654_392##3	a_897_406##9	2.07629e-17
C64	VPWR#3	VPWR#2	6.86514e-19
C65	VPWR#8	a_897_406##3	4.28127e-19
C66	a_654_392##3	VPWR#9	2.21384e-17
C67	a_897_406##8	a_654_392##2	5.78219e-17
C68	VPWR#3	VPWR#9	4.92789e-18
C69	VPWR#3	a_357_392##4	4.12291e-19
C70	a_357_392##3	a_897_406#	3.31276e-17
C71	a_897_406##3	VPWR#9	1.16985e-17
C72	a_654_392##6	a_654_392##3	1.63786e-19
C73	VGND#2	a_897_406##8	7.84265e-19
C74	VGND#5	a_357_392##2	8.09569e-18
C75	a_897_406##8	a_897_406##2	1.12026e-18
C76	VGND#1	Q#3	4.58772e-17
C77	a_232_98##5	VPWR#5	1.49024e-18
C78	a_232_98##13	a_232_98##2	5.08441e-20
C79	a_232_98##5	VPWR#3	1.59718e-17
C80	a_232_98##7	a_357_392##3	2.56022e-17
C81	a_897_406##8	VPWR#8	4.79363e-17
C82	VGND#5	a_27_136##2	8.0052e-17
C83	a_232_98##8	a_654_392##6	1.22604e-17
C84	VPWR#10	a_897_406##3	9.47005e-19
C85	a_27_136#	a_232_98##7	6.13779e-17
C86	a_654_392##6	a_357_392#	3.74438e-17
C87	VPWR#10	a_232_98##8	1.39662e-18
C88	a_897_406##8	a_897_406##9	1.99381e-17
C89	a_232_98##5	a_897_406##8	1.21661e-18
C90	VGND#5	a_232_98##3	1.90629e-19
C91	VPWR#5	a_27_136##2	1.13229e-20
C92	a_654_392##6	a_27_136##3	1.98956e-18
C93	a_232_98#	a_27_136#	3.67134e-18
C94	VGND#8	Q#3	4.1728e-17
C95	a_897_406##5	Q#3	3.41123e-17
C96	VPWR#10	a_357_392#	2.79133e-18
C97	a_897_406##5	VGND#8	1.09937e-17
C98	a_357_392##8	a_357_392#	6.40905e-19
C99	a_897_406##8	VPWR#9	5.6129e-19
C100	a_654_392##6	a_232_98##4	9.39461e-19
C101	a_27_136##3	VPWR#10	2.61353e-17
C102	VPWR#5	a_232_98##3	1.10086e-19
C103	Q#3	RESET_B#2	8.68781e-19
C104	a_232_98##13	a_357_392#	6.71979e-19
C105	GATE_N#3	a_232_98#	4.49698e-18
C106	a_357_392##8	a_27_136##3	7.94087e-18
C107	VGND#4	a_654_392##4	1.3008e-17
C108	RESET_B#2	VGND#8	3.7278e-18
C109	a_232_98##4	VPWR#10	2.82992e-17
C110	a_897_406##8	VPWR#3	6.3096e-17
C111	a_232_98##13	a_27_136##3	2.83899e-17
C112	a_897_406##12	Q#3	3.19646e-18
C113	a_357_392##8	a_232_98##4	4.3123e-17
C114	a_897_406##12	RESET_B#2	9.54481e-19
C115	VPWR#11	a_27_136##3	6.6387e-19
C116	VPWR#10	GATE_N#1	1.57496e-18
C117	D#3	GATE_N#3	1.9425e-17
C118	a_232_98##13	a_232_98##4	1.67978e-17
C119	a_232_98##13	VPWR#5	1.41685e-17
C120	a_357_392##8	GATE_N#1	5.75626e-19
C121	a_897_406##8	VPWR#2	5.29557e-18
C122	VPWR#11	a_232_98##4	1.06744e-18
C123	a_897_406##12	VGND#8	2.36247e-17
C124	VPWR#10	D#1	7.38229e-19
C125	a_654_392##2	a_897_406##12	5.06806e-17
C126	a_232_98##13	GATE_N#1	5.98219e-17
C127	VGND#9	a_654_392##2	3.55307e-17
C128	a_27_136##7	a_232_98##4	8.6309e-20
C129	GATE_N#1	VPWR#11	2.58482e-17
C130	a_232_98##13	D#1	1.99124e-18
C131	VGND#9	VGND#8	8.38026e-19
C132	a_654_392##4	a_654_392##2	7.2186e-18
C133	a_27_136##7	GATE_N#1	1.87556e-18
C134	VGND#9	a_897_406##2	2.17777e-19
C135	D#1	VPWR#11	3.41512e-17
C136	VGND#2	a_897_406##6	3.88957e-18
C137	a_27_136##7	D#1	3.95178e-17
C138	a_654_392##4	a_897_406##2	1.0907e-18
C139	a_897_406##5	VPWR#8	3.10616e-17
C140	RESET_B#1	a_897_406##4	2.69051e-17
C141	VGND#9	a_897_406##12	2.77641e-17
C142	VGND#2	RESET_B#3	6.03494e-18
C143	a_654_392##4	a_357_392##4	6.45718e-17
C144	VGND#3	a_654_392#	1.88678e-18
C145	a_897_406##8	a_232_98##6	2.9027e-19
C146	a_654_392##3	RESET_B#1	2.22158e-17
C147	a_897_406##3	a_897_406##4	9.86304e-20
C148	VPWR#4	a_232_98##6	5.92184e-20
C149	VGND#2	a_654_392#	1.04864e-18
C150	VGND#5	a_897_406#	3.75314e-19
C151	VGND#1	a_897_406##6	2.40382e-18
C152	a_654_392##4	a_897_406##12	1.67726e-18
C153	VGND#3	a_897_406#	3.87983e-18
C154	a_897_406##3	a_654_392##3	5.03238e-18
C155	a_897_406##2	VPWR#9	1.42267e-18
C156	VGND#5	a_357_392##3	7.6087e-19
C157	a_654_392##4	VGND#9	1.19152e-17
C158	a_27_136##2	a_654_392##4	1.40148e-17
C159	a_232_98##8	a_897_406##3	1.2355e-17
C160	a_654_392##6	a_897_406##2	5.56007e-19
C161	VGND#4	a_232_98##6	8.57317e-20
C162	VGND#3	a_357_392##3	5.47191e-18
C163	a_27_136##2	VGND#10	1.53662e-17
C164	a_27_136##2	a_357_392##9	8.09864e-17
C165	D#5	D#2	1.18516e-17
C166	VPWR#3	a_654_392#	7.19114e-20
C167	a_357_392##4	a_654_392##6	4.10527e-17
C168	VGND#5	a_232_98##7	2.5739e-18
C169	a_357_392#	a_232_98##8	1.38284e-17
C170	a_27_136##5	D#5	3.24175e-17
C171	RESET_B#2	a_897_406##6	8.23505e-19
C172	a_27_136##2	VGND#11	2.00884e-20
C173	a_654_392##4	a_232_98##6	5.634e-19
C174	a_232_98##3	a_357_392##9	2.99957e-17
C175	a_232_98##5	a_654_392##6	1.0942e-16
C176	VGND#4	a_232_98##7	8.62776e-18
C177	a_654_392#	RESET_B#2	1.80332e-17
C178	GATE_N	a_232_98##2	1.49123e-19
C179	a_27_136##3	a_357_392#	5.17957e-17
C180	VGND#4	a_27_136#	8.51945e-18
C181	VGND#5	a_27_136#	1.10638e-17
C182	a_27_136##5	a_232_98##3	3.84969e-18
C183	VPWR#1	a_897_406##4	4.69768e-18
C184	a_357_392##2	a_654_392##6	7.35044e-17
C185	a_654_392#	a_654_392##2	7.89503e-18
C186	a_232_98##12	GATE_N#2	3.0279e-18
C187	a_654_392##2	a_897_406#	3.44592e-17
C188	a_232_98##4	a_27_136##3	2.13397e-17
C189	a_27_136##5	GATE_N#2	8.8956e-19
C190	a_357_392##8	a_357_392##2	4.1239e-18
C191	GATE_N#1	a_27_136##3	2.09127e-19
C192	a_654_392##2	a_232_98##7	1.29174e-19
C193	VGND#5	a_232_98#	1.49276e-17
C194	a_357_392##2	a_232_98##13	4.30275e-18
C195	VPWR#10	a_27_136##2	2.54992e-19
C196	GATE_N#1	a_232_98##4	4.70929e-18
C197	a_654_392##2	a_27_136#	3.07847e-19
C198	a_27_136##5	D#2	8.76673e-18
C199	a_27_136##2	a_357_392##8	2.35961e-17
C200	a_357_392##4	a_897_406#	2.94276e-17
C201	a_654_392##4	a_357_392##9	1.33345e-21
C202	a_232_98##13	a_27_136##2	1.13404e-18
C203	a_897_406##5	a_897_406##4	2.68129e-18
C204	D#1	GATE_N#1	1.87946e-17
C205	a_357_392##4	a_232_98##7	3.93753e-17
C206	a_232_98##3	a_357_392##8	3.19892e-17
C207	a_897_406##8	a_654_392#	4.9411e-18
C208	RESET_B#1	a_897_406##5	1.32023e-18
C209	VGND#5	GATE_N#3	1.37627e-18
C210	VPWR#4	a_232_98##8	8.0606e-18
C211	a_232_98##3	a_232_98##13	3.37501e-18
C212	VPWR#4	a_357_392#	7.47709e-18
C213	a_357_392##8	GATE_N#2	7.55319e-19
C214	a_27_136##7	a_232_98##3	3.42195e-19
C215	a_232_98##13	GATE_N#2	3.53621e-18
C216	a_654_392##2	RESET_B#1	8.00475e-19
C217	a_357_392##2	a_232_98##7	1.53798e-17
C218	a_27_136##2	a_897_406#	9.11338e-20
C219	a_27_136##7	GATE_N#2	2.55807e-19
C220	a_654_392##2	a_654_392##3	2.48887e-18
C221	a_357_392##2	a_27_136#	3.52563e-17
C222	a_27_136##2	a_357_392##3	8.39173e-19
C223	a_232_98##13	D#2	1.52565e-19
C224	a_27_136##2	a_232_98##7	4.24211e-18
C225	VPWR#11	D#2	5.02762e-18
C226	a_654_392##2	a_232_98##6	2.51669e-18
C227	a_897_406##2	a_654_392##3	1.04693e-17
C228	a_27_136##2	a_27_136#	8.04919e-18
C229	a_27_136##7	D#2	4.42742e-18
C230	a_27_136##2	a_232_98#	4.12527e-17
C231	VPWR#10	a_793_508#	2.3712e-19
C232	a_27_136##2	GATE_N#3	5.6619e-19
C233	a_232_98##5	RESET_B#1	1.71511e-19
C234	a_232_98##12	a_357_392##9	2.68265e-17
C235	a_27_136##2	D#3	3.21868e-19
C236	a_232_98##5	a_654_392##3	1.85772e-19
C237	a_232_98##3	GATE_N#3	4.75501e-19
C238	a_232_98##5	a_897_406##3	5.02112e-18
C239	a_232_98##3	D#3	4.91486e-19
C240	a_232_98##5	a_232_98##8	1.27065e-17
C241	a_897_406##5	VPWR#1	1.61753e-18
C242	a_232_98##5	a_357_392#	2.5536e-17
C243	a_357_392##9	a_232_98##2	1.08643e-17
C244	VGND#1	a_897_406##5	2.58237e-18
C245	a_232_98##6	a_897_406##2	3.39341e-17
C246	a_232_98##5	a_27_136##3	5.06136e-19
C247	a_357_392##2	a_357_392#	7.0823e-18
C248	a_232_98##5	a_232_98##4	3.35944e-19
C249	a_357_392##2	a_27_136##3	2.15911e-17
C250	RESET_B#3	a_1139_74#	1.73994e-17
C251	a_27_136##5	a_232_98##12	6.62987e-17
C252	a_654_392#	a_1139_74#	1.73994e-17
C253	RESET_B#2	a_897_406##5	6.47804e-17
C254	VPWR	a_232_98##6	6.78459e-21
C255	a_897_406##5	a_654_392##2	6.87762e-19
C256	a_232_98##12	a_232_98##2	3.52048e-20
C257	a_27_136##5	VGND#11	4.98522e-18
C258	a_654_392##2	RESET_B#2	7.64957e-18
C259	a_357_392##4	a_232_98##6	1.95603e-17
C260	VGND#4	a_357_392##4	5.59661e-19
C261	GATE_N#2	a_232_98##4	4.31238e-19
C262	a_232_98##5	VPWR#4	1.74822e-17
C263	VPWR#4	a_357_392##2	4.74784e-20
C264	a_897_406##3	a_793_508#	9.41686e-18
C265	a_654_392##2	a_897_406##2	1.11277e-16
C266	a_897_406#	a_854_74#	9.10064e-18
C267	VGND#4	a_357_392##2	2.69486e-18
C268	D#5	VPWR#11	8.91364e-18
C269	a_232_98##8	a_793_508#	1.21506e-17
C270	a_357_392##3	a_854_74#	9.10064e-18
C271	VGND#3	VGND#8	6.15295e-20
C272	VPWR#4	a_27_136##2	5.00268e-20
C273	a_357_392##4	a_654_392##2	3.76679e-17
C274	VPWR#3	a_897_406##4	1.38068e-18
C275	VGND#2	RESET_B	1.43933e-18
C276	GATE_N#3	a_232_98##2	1.82605e-19
C277	a_357_392##4	a_897_406##2	8.41905e-18
C278	a_654_392##2	a_232_98##5	1.45357e-17
C279	a_357_392#	a_570_392#	2.06649e-17
C280	VPWR#2	a_897_406##4	2.3103e-18
C281	a_232_98##5	a_897_406##2	3.27181e-17
C282	a_357_392##2	a_654_392##2	6.08283e-19
C283	a_27_136##3	a_570_392#	2.06649e-17
C284	a_27_136##7	D#5	2.1139e-17
C285	a_232_98##5	a_357_392##4	1.85757e-18
C286	a_897_406##8	RESET_B	2.13083e-18
C287	a_357_392##2	a_897_406##2	1.12923e-19
C288	a_27_136##2	a_654_392##2	2.13718e-19
C289	a_232_98##5	a_232_98##6	2.11715e-17
C290	a_232_98##7	a_681_74#	1.50481e-17
C291	VPWR#3	RESET_B#1	2.22796e-18
C292	a_27_136#	a_681_74#	1.50481e-17
C293	a_357_392##2	a_232_98##5	1.19019e-17
C294	a_232_98##12	GATE_N	2.78686e-17
C295	a_27_136##2	a_357_392##4	1.63439e-19
C296	a_27_136##5	GATE_N	3.51103e-18
C297	VPWR#2	RESET_B#1	7.02727e-18
C298	a_232_98##5	a_27_136##2	2.53761e-19
C299	a_897_406##8	Q	2.41926e-18
C300	a_357_392##2	a_27_136##2	8.25067e-17
C301	Q#3	a_897_406##6	2.4545e-17
C302	RESET_B	Q#3	3.8649e-18
C303	VGND#3	a_897_406##12	1.70301e-17
C304	VGND#8	RESET_B	1.37933e-17
C305	VPWR#3	a_654_392##3	2.57302e-17
C306	a_27_136##5	D	5.98295e-18
C307	a_897_406##12	RESET_B	1.20155e-17
C308	a_232_98##6	VNB	7.43536e-17
C309	a_27_136##2	a_232_98##3	5.59237e-18
C310	a_232_98##2	VNB	2.51905e-17
C311	GATE_N	a_232_98##13	2.30746e-17
C312	VGND#5	VGND#9	6.3181e-19
C313	VPWR	VPWR#5	7.53394e-17
C314	VPWR	VPWR#3	1.62534e-16
C315	VPWR	VPWR#2	5.12934e-17
C316	a_897_406##6	VGND#8	2.83902e-17
C317	a_27_136##5	a_232_98##2	7.32336e-20
C318	GATE_N#2	a_232_98##3	2.74787e-17
C319	a_357_392##2	a_232_98##6	2.74836e-17
C320	a_897_406##8	a_897_406##4	2.31511e-18
C321	VPWR	a_897_406##8	2.42109e-17
C322	a_232_98##5	a_793_508#	4.07562e-18
C323	Q#3	RESET_B#3	3.15717e-18
C324	Q#3	Q	3.95354e-18
C325	VGND#2	a_897_406##12	3.38208e-18
C326	a_232_98##3	D#2	1.45886e-19
C327	a_232_98##2	a_357_392##2	1.17219e-18
C328	D	VPWR#11	2.69887e-17
C329	a_232_98##5	a_570_392#	5.31993e-18
C330	D#2	GATE_N#2	2.1162e-17
C331	VPWR#3	a_897_406##3	2.69179e-17
C332	a_357_392##2	a_570_392#	2.08524e-18
C333	VGND	VGND#5	1.26321e-16
C334	VGND	VGND#3	9.2047e-17
C335	VGND	VGND#2	6.85887e-17
C336	RESET_B#3	VGND#8	3.17523e-17
C337	VPWR	D#5	2.12475e-18
C338	Q	Q#1	5.75544e-18
C339	Q#3	a_654_392#	6.37313e-19
C340	VPWR#8	Q	8.74006e-17
C341	a_897_406##12	a_897_406##6	2.8341e-18
C342	a_897_406##8	RESET_B#1	4.17857e-17
C343	VGND	a_897_406##8	5.07867e-18
C344	RESET_B	a_897_406##6	2.07182e-18
C345	RESET_B	a_654_392#	3.09924e-18
C346	VGND#8	a_654_392#	4.63591e-18
C347	a_357_392##9	a_357_392##8	2.65967e-18
C348	VPWR#3	a_232_98##8	5.19556e-18
C349	VGND#9	a_897_406##6	3.51847e-19
C350	VPWR	VPWR#8	2.2828e-17
C351	VGND#5	VNB	5.3377e-17
C352	VGND#3	VNB	4.87702e-17
C353	VGND	D#5	1.9648e-18
C354	VGND#2	VNB	3.5384e-17
C355	a_897_406##12	RESET_B#3	5.89921e-18
C356	VGND	VGND#8	2.11023e-17
C357	VPWR#5	VNB	3.98146e-17
C358	VPWR	a_654_392##6	6.81252e-18
C359	VPWR#3	VNB	6.76954e-17
C360	VGND	a_897_406##12	2.02819e-17
C361	VPWR#2	VNB	2.75893e-17
C362	VGND#5	a_654_392##4	4.96588e-18
C363	VGND	VGND#9	1.89493e-17
C364	VPWR	VPWR#10	1.94153e-17
C365	VPWR	a_357_392##8	9.64136e-18
C366	VGND	a_654_392##4	2.39214e-17
C367	a_897_406##8	a_654_392##3	4.45887e-17
C368	a_897_406##8	VNB	1.37235e-17
C369	VPWR	a_232_98##13	4.0147e-17
C370	a_232_98##2	a_27_136##2	3.48864e-17
C371	VGND	a_357_392##9	6.20611e-18
C372	VPWR	a_27_136##7	1.70824e-17
C373	VGND	a_232_98##12	1.11494e-17
C374	VGND	a_27_136##5	3.61662e-17
C375	Q	a_897_406##4	3.44695e-17
C376	VGND#8	a_897_406#	3.90209e-19
C377	Q	RESET_B#1	1.8099e-18
C378	VGND#9	RESET_B#3	5.16081e-19
C379	Q	a_654_392##3	2.33403e-19
C380	VGND	a_654_392##6	3.20985e-18
C381	D#5	VNB	1.77453e-18
C382	VPWR#3	a_357_392#	1.5108e-18
C383	Q#3	VNB	5.51977e-17
C384	a_897_406##12	a_654_392#	6.23334e-17
C385	VGND	a_357_392##8	3.07441e-18
C386	VGND#8	VNB	4.79e-18
C387	VGND#3	a_654_392##4	8.16747e-18
C388	a_897_406##12	VNB	7.84983e-18
C389	VGND#9	VNB	3.83324e-18
C390	VPWR	a_897_406##4	1.55622e-18
C391	a_654_392##4	VNB	8.76871e-18
C392	VGND	a_897_406##6	1.95485e-18
C393	VPWR	RESET_B#1	8.96655e-18
C394	VGND	RESET_B#3	1.60488e-18
C395	a_232_98##12	a_232_98##13	3.26995e-18
C396	VGND	a_654_392#	2.23377e-18
C397	VPWR	a_654_392##3	4.57914e-18
C398	a_357_392##9	VNB	3.16366e-18
C399	RESET_B	a_897_406##5	4.9142e-18
C400	a_232_98##12	VNB	5.18071e-18
C401	VGND	a_897_406#	9.84798e-19
C402	VPWR	a_897_406##3	9.83869e-19
C403	VGND	a_357_392##3	1.28781e-20
C404	a_27_136##5	VNB	6.00024e-17
C405	VPWR	a_232_98##8	6.04264e-19
C406	Q	VPWR#1	4.44812e-17
C407	RESET_B	RESET_B#2	9.34019e-18
C408	VGND	a_232_98##7	1.51425e-18
C409	GATE_N	a_232_98##3	3.28249e-17
C410	VPWR	a_357_392#	4.34846e-19
C411	VPWR#8	VNB	5.66001e-18
C412	VGND	a_27_136#	1.50467e-18
C413	VGND#1	Q	1.09259e-18
C414	a_897_406##8	a_897_406##3	3.96516e-19
C415	VGND	a_232_98#	9.98413e-18
C416	VPWR	a_27_136##3	4.55039e-19
C417	GATE_N	GATE_N#2	1.73446e-17
C418	VGND	GATE_N#3	9.47289e-18
C419	VPWR	a_232_98##4	8.17306e-18
C420	a_654_392##6	VNB	6.42989e-18
C421	VGND	D#3	6.44247e-18
C422	VGND#9	a_654_392#	2.75151e-18
C423	VPWR	GATE_N#1	8.33394e-18
C424	GATE_N	D#2	2.98253e-18
C425	VPWR#10	VNB	1.13934e-17
C426	a_897_406##5	Q	4.46596e-17
C427	VPWR	D#1	8.33394e-18
C428	a_357_392##8	VNB	6.83777e-18
C429	VPWR#5	a_27_136##3	7.50261e-18
C430	a_232_98##13	VNB	2.12386e-17
C431	VPWR#11	VNB	1.86247e-17
C432	D	GATE_N#2	3.47481e-18
C433	a_27_136##7	VNB	5.53298e-17
C434	a_897_406##6	VNB	3.61329e-17
C435	RESET_B#3	VNB	2.59203e-17
C436	D	D#2	5.17574e-18
C437	a_897_406##12	a_897_406#	2.41804e-18
C438	a_654_392#	VNB	3.31559e-17
C439	VPWR	VPWR#4	6.93051e-17
C440	a_897_406#	VNB	4.72674e-17
C441	a_357_392##3	VNB	2.43411e-17
C442	a_232_98##7	VNB	4.05789e-17
C443	VPWR	a_897_406##5	2.72075e-18
C444	a_27_136#	VNB	3.74277e-17
C445	a_232_98#	VNB	3.9959e-17
C446	VPWR	RESET_B#2	2.57125e-18
C447	GATE_N#3	VNB	3.89367e-17
C448	VPWR	a_654_392##2	9.85902e-18
C449	D#3	VNB	3.18043e-17
C450	VPWR#3	a_27_136##3	1.04693e-18
C451	VPWR	a_897_406##2	5.91595e-18
C452	a_897_406##4	VNB	3.62794e-17
C453	RESET_B#1	VNB	3.92684e-17
C454	VPWR	a_357_392##4	3.49179e-18
C455	VGND#5	VGND#3	2.59948e-19
C456	a_654_392##3	VNB	3.63184e-17
C457	VPWR	a_232_98##5	3.23528e-17
C458	a_897_406##3	VNB	2.75782e-17
C459	VGND	VGND#4	5.14618e-17
C460	a_232_98##8	VNB	2.38621e-17
C461	VPWR	a_357_392##2	7.84521e-18
C462	VGND	a_897_406##5	4.07524e-18
C463	a_357_392#	VNB	2.94255e-17
C464	a_27_136##3	VNB	3.66348e-17
C465	VGND	RESET_B#2	2.54594e-19
C466	VPWR	a_27_136##2	3.38797e-18
C467	a_232_98##4	VNB	4.36688e-17
C468	VGND	a_654_392##2	1.10791e-17
C469	VPWR	a_232_98##3	2.06919e-18
C470	GATE_N#1	VNB	3.82776e-17
C471	VGND#9	a_897_406#	2.99096e-17
C472	D#1	VNB	4.01249e-17
C473	a_232_98##3	a_232_98##2	6.60371e-19
C474	VGND	a_357_392##4	5.83275e-18
C475	VPWR#1	VNB	8.80805e-17
C476	VPWR	D#2	4.63624e-21
C477	VGND#1	VNB	9.27144e-17
C478	a_897_406##8	a_232_98##8	1.36873e-19
C479	VGND	a_357_392##2	1.40449e-17
C480	VPWR#4	VNB	3.52663e-17
C481	VGND#4	VNB	2.59788e-17
C482	VGND	a_27_136##2	2.9105e-17
C483	a_897_406##5	VNB	4.40987e-17
C484	VGND	a_232_98##3	2.31591e-18
C485	RESET_B#2	VNB	3.39908e-17
C486	VGND#5	VGND#10	1.60678e-17
C487	a_897_406##12	a_357_392##3	2.05999e-19
C488	a_654_392##2	VNB	7.62157e-17
C489	a_897_406##2	VNB	7.50262e-17
C490	a_357_392##4	VNB	4.5619e-17
C491	a_654_392##4	a_654_392#	2.87588e-19
C492	a_232_98##5	VNB	2.63228e-18
C493	a_357_392##2	VNB	3.50356e-17
C494	VPWR#5	a_232_98##4	5.1611e-18
C495	a_27_136##2	VNB	5.30216e-17
C496	D	GATE_N	2.85427e-17
C497	a_232_98##3	VNB	5.36455e-17
C498	GATE_N#2	VNB	3.07226e-17
C499	D#2	VNB	4.38066e-17
C500	VPWR	GATE_N	4.345e-18
C501	VPWR	D	1.41575e-18
C502	VGND	GATE_N	3.73818e-18
C503	VGND#9	a_357_392##3	3.94414e-18
C504	VGND	D	2.34191e-18
C505	a_27_136##5	VPWR#11	4.52241e-18
C506	VGND	RESET_B	6.55234e-18
C507	GATE_N	VNB	2.17148e-18
C508	D	VNB	2.94722e-18
C509	RESET_B	VNB	3.53126e-19
C510	Q	VNB	6.90007e-17
C511	VPWR	VNB	2.90062e-16
C512	VGND	VNB	3.07512e-16
C513	a_654_392##4	a_897_406#	1.87631e-17
C514	VGND#5	a_232_98##2	5.27962e-20
C515	a_27_136##7	VPWR#6	1.33162e-17
C516	VGND#6	D#3	2.26649e-18
C517	D#5	VPWR#6	4.3191e-19
C518	VPWR#6	VNB	6.51927e-17
C519	VGND#6	VGND#5	2.29778e-18
C520	a_232_98##13	VPWR#6	1.35021e-17
C521	VPWR#6	GATE_N#1	5.96208e-18
C522	GATE_N	VPWR#6	9.45522e-19
C523	VGND	VGND#6	1.19708e-16
C524	VPWR	VPWR#6	1.30235e-16
C525	VGND#6	a_232_98##3	9.62072e-20
C526	VPWR#6	a_232_98##3	4.82387e-20
C527	VGND#6	VGND#11	6.01522e-18
C528	VGND#6	VNB	7.76763e-17
C529	VGND#6	GATE_N#2	9.04548e-20
C530	VGND#6	a_27_136##5	7.04306e-17
C531	VPWR#6	D#1	5.96208e-18
C532	VGND#6	a_232_98#	2.0324e-18
C533	VGND#6	D#2	8.61335e-19
C534	VPWR#6	VPWR#10	4.73911e-19
C535	VGND#6	GATE_N#3	1.14477e-17
C536	VPWR#6	GATE_N#2	4.85446e-20
C537	VPWR#6	a_27_136##3	2.77875e-19
*
*
.ENDS sky130_fd_sc_hs__dlrtn_1
*
