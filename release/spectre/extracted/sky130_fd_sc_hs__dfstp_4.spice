* Extracted by Quantus, converted by sky130cad/quantus.py
*
*
*
*                       LINUX           Wed Nov 18 08:28:27 2026
*
*
*
*  PROGRAM  advgen
*
*  Name           : advgen - Quantus - (64-bit)
*  Version        : 25.1.0-p047
*  Build Date     : Thu Dec 11 23:20:30 PST 2025
*
*  HSPICE LIBRARY
*
*  OPERATING_TEMPERATURE 150
*  QRC_TECH_DIR <path>/tech
*
*
*

*
.SUBCKT sky130_fd_sc_hs__dfstp_4 VPB VNB VGND SET_B VPWR Q D CLK
*
*
*  caps2d version: 10
*
*
*       TRANSISTOR CARDS
*
*
XM38 a_27_74##4 D#2 VGND#18 VNB sky130_fd_pr__nfet_01v8_lvt l=0.15 w=0.42 ad=0.1197 as=0.1197 pd=1.41 ps=1.41
XM31 a_225_74##12 CLK#3 VGND#17 VNB sky130_fd_pr__nfet_01v8_lvt l=0.15 w=0.74 ad=0.2109 as=0.2072 pd=2.05 ps=2.04
XM27 VGND#17 a_225_74##8 a_398_74##10 VNB sky130_fd_pr__nfet_01v8_lvt l=0.15 w=0.74 ad=0.2072 as=0.2109 pd=2.04 ps=2.05
XM6 a_27_74##5 a_225_74##7 a_612_74##11 VNB sky130_fd_pr__nfet_01v8_lvt l=0.15 w=0.42 ad=0.18665 as=0.189 pd=1.8 ps=1.74
XM13 a_612_74##11 a_398_74# a_732_74# VNB sky130_fd_pr__nfet_01v8_lvt l=0.15 w=0.42 ad=0.189 as=0.1008 pd=1.74 ps=1.32
XM36 a_732_74# a_767_402# VGND#16 VNB sky130_fd_pr__nfet_01v8_lvt l=0.15 w=0.42 ad=0.1008 as=0.147 pd=1.32 ps=1.54
XM11 a_767_402##5 a_612_74# a_1035_118# VNB sky130_fd_pr__nfet_01v8_lvt l=0.15 w=0.42 ad=0.1491 as=0.1008 pd=1.55 ps=1.32
XM12 a_1035_118# SET_B#1 VGND#15 VNB sky130_fd_pr__nfet_01v8_lvt l=0.15 w=0.42 ad=0.1008 as=0.2349 pd=1.32 ps=2.1
XM30 VGND#15 a_612_74##4 a_1225_74# VNB sky130_fd_pr__nfet_01v8_lvt l=0.15 w=0.64 ad=0.2349 as=0.2528 pd=2.1 ps=2.07
XM1 a_1225_74# a_398_74##5 a_1321_392##15 VNB sky130_fd_pr__nfet_01v8_lvt l=0.15 w=0.64 ad=0.2528 as=0.21145 pd=2.07 ps=2
XM23 a_1321_392##15 a_225_74# a_1436_88# VNB sky130_fd_pr__nfet_01v8_lvt l=0.15 w=0.42 ad=0.21145 as=0.1008 pd=2 ps=1.32
XM7 a_1436_88# a_1484_62##3 a_1514_88# VNB sky130_fd_pr__nfet_01v8_lvt l=0.15 w=0.42 ad=0.1008 as=0.1008 pd=1.32 ps=1.32
XM2 a_1514_88# SET_B#4 VGND#14 VNB sky130_fd_pr__nfet_01v8_lvt l=0.15 w=0.42 ad=0.1008 as=0.4347 pd=1.32 ps=2.91
XM34 VGND#14 a_1321_392##8 a_1484_62##6 VNB sky130_fd_pr__nfet_01v8_lvt l=0.15 w=0.42 ad=0.4347 as=0.1197 pd=2.91 ps=1.41
XM20 a_1940_74##16 a_1321_392##7 VGND#13 VNB sky130_fd_pr__nfet_01v8_lvt l=0.15 w=0.74 ad=0.2627 as=0.259 pd=2.19 ps=2.18
XM28 Q#4 a_1940_74##7 VGND#13 VNB sky130_fd_pr__nfet_01v8_lvt l=0.15 w=0.74 ad=0.2072 as=0.259 pd=2.04 ps=2.18
XM10 VGND#12 a_1940_74##12 Q#4 VNB sky130_fd_pr__nfet_01v8_lvt l=0.15 w=0.74 ad=0.5254 as=0.2072 pd=2.9 ps=2.04
XM18 Q#6 a_1940_74##10 VGND#12 VNB sky130_fd_pr__nfet_01v8_lvt l=0.15 w=0.74 ad=0.2405 as=0.5254 pd=2.13 ps=2.9
XM37 VGND#1 a_1940_74##8 Q#6 VNB sky130_fd_pr__nfet_01v8_lvt l=0.15 w=0.74 ad=0.2627 as=0.2405 pd=2.19 ps=2.13
XM0 a_27_74##6 D#3 VPWR#21 VPB sky130_fd_pr__pfet_01v8 l=0.15 w=0.42 ad=0.1239 as=0.1239 pd=1.43 ps=1.43
XM8 a_225_74##13 CLK#1 VPWR#20 VPB sky130_fd_pr__pfet_01v8 l=0.15 w=1.12 ad=0.3304 as=0.336 pd=2.83 ps=2.84
XM26 VPWR#20 a_225_74##9 a_398_74##14 VPB sky130_fd_pr__pfet_01v8 l=0.15 w=1.12 ad=0.336 as=0.3304 pd=2.84 ps=2.83
XM22 a_27_74# a_398_74##4 a_612_74##10 VPB sky130_fd_pr__pfet_01v8 l=0.15 w=0.42 ad=0.1239 as=0.147 pd=1.43 ps=1.54
XM24 a_612_74##10 a_225_74##6 a_716_463# VPB sky130_fd_pr__pfet_01v8 l=0.15 w=0.42 ad=0.147 as=0.1134 pd=1.54 ps=1.38
XM16 a_716_463# a_767_402##4 VPWR#19 VPB sky130_fd_pr__pfet_01v8 l=0.15 w=0.42 ad=0.1134 as=0.3297 pd=1.38 ps=2.41
XM3 VPWR#19 a_612_74##3 a_767_402##7 VPB sky130_fd_pr__pfet_01v8 l=0.15 w=0.42 ad=0.3297 as=0.126 pd=2.41 ps=1.44
XM9 a_767_402##7 SET_B#3 VPWR#18 VPB sky130_fd_pr__pfet_01v8 l=0.15 w=0.42 ad=0.126 as=0.391 pd=1.44 ps=3.13
XM32 VPWR#18 a_612_74##6 a_1220_347# VPB sky130_fd_pr__pfet_01v8 l=0.15 w=1 ad=0.391 as=0.394375 pd=3.13 ps=3.16
XM4 a_1220_347# a_225_74##2 a_1321_392##12 VPB sky130_fd_pr__pfet_01v8 l=0.15 w=1 ad=0.394375 as=0.4333 pd=3.16 ps=3.29
XM25 a_1321_392##12 a_398_74##7 a_1480_508# VPB sky130_fd_pr__pfet_01v8 l=0.15 w=0.42 ad=0.4333 as=0.1134 pd=3.29 ps=1.38
XM29 a_1480_508# a_1484_62# VPWR#17 VPB sky130_fd_pr__pfet_01v8 l=0.15 w=0.42 ad=0.1134 as=0.126 pd=1.38 ps=1.44
XM17 VPWR#17 SET_B#6 a_1321_392##14 VPB sky130_fd_pr__pfet_01v8 l=0.15 w=0.42 ad=0.126 as=0.1155 pd=1.44 ps=1.39
XM5 VPWR#16 a_1321_392##9 a_1484_62##7 VPB sky130_fd_pr__pfet_01v8 l=0.15 w=0.42 ad=0.1176 as=0.1155 pd=1.4 ps=1.39
XM14 VPWR#15 a_1321_392##6 a_1940_74##14 VPB sky130_fd_pr__pfet_01v8 l=0.15 w=0.84 ad=0.2352 as=0.252 pd=2.24 ps=2.28
XM33 a_1940_74##14 a_1321_392# VPWR#14 VPB sky130_fd_pr__pfet_01v8 l=0.15 w=0.84 ad=0.252 as=0.3892 pd=2.28 ps=2.98
XM15 VPWR#14 a_1940_74##13 Q#5 VPB sky130_fd_pr__pfet_01v8 l=0.15 w=1.12 ad=0.3892 as=0.336 pd=2.98 ps=2.84
XM35 VPWR#13 a_1940_74##11 Q#5 VPB sky130_fd_pr__pfet_01v8 l=0.15 w=1.12 ad=0.336 as=0.336 pd=2.84 ps=2.84
XM21 Q#1 a_1940_74##9 VPWR#13 VPB sky130_fd_pr__pfet_01v8 l=0.15 w=1.12 ad=0.336 as=0.336 pd=2.84 ps=2.84
XM19 Q#1 a_1940_74# VPWR#1 VPB sky130_fd_pr__pfet_01v8 l=0.15 w=1.12 ad=0.336 as=0.3192 pd=2.84 ps=2.81
*
*
*       RESISTOR AND CAP/DIODE CARDS
*
Rg1	D#1	D#2	311.105377
Rg2	D#1	D#3	444.690369
Rg3	CLK#1	CLK#2	500.238068
Rg4	CLK#2	CLK#3	320.356293
Rg5	a_398_74#	a_398_74##2	535.122375
Rg6	a_398_74##2	a_398_74##3	124.138969
Rg7	a_398_74##3	a_398_74##4	272.921448
Rg8	a_767_402#	a_767_402##2	346.154083
Rg9	a_767_402##2	a_767_402##3	340.836578
Rg10	a_767_402##3	a_767_402##4	359.813354
Rg11	a_612_74#	a_612_74##2	234.974045
Rg12	a_612_74##2	a_612_74##3	558.310791
Rg13	SET_B#1	SET_B#2	552.858643
Rg14	SET_B#2	SET_B#3	319.045105
Rg15	a_612_74##4	a_612_74##5	325.153564
Rg16	a_612_74##5	a_612_74##6	420.194366
Rg17	a_398_74##5	a_398_74##6	439.477417
Rg18	a_225_74#	a_225_74##2	1240.911499
Rg19	a_225_74##2	a_225_74##3	2042.329834
Rg20	a_225_74##3	a_225_74##4	1406.904541
Rg21	a_225_74##4	a_225_74##5	59.143440
Rg22	a_225_74##3	a_225_74##6	283.919525
Rg23	a_225_74##4	a_225_74##7	674.908508
Rg24	a_225_74##5	a_225_74##8	400.395355
Rg25	a_225_74##5	a_225_74##9	446.312561
Rg26	a_398_74##7	a_398_74##8	242.974045
Rg27	a_1484_62#	a_1484_62##2	561.356567
Rg28	a_1484_62##2	a_1484_62##3	459.222931
Rg29	SET_B#4	SET_B#5	410.778198
Rg30	SET_B#5	SET_B#6	483.781464
Rg31	a_1321_392#	a_1321_392##2	503.784332
Rg32	a_1321_392##2	a_1321_392##3	65.826790
Rg33	a_1321_392##3	a_1321_392##4	240.693542
Rg34	a_1321_392##4	a_1321_392##5	49.825264
Rg35	a_1321_392##2	a_1321_392##6	312.498138
Rg36	a_1321_392##3	a_1321_392##7	401.625000
Rg37	a_1321_392##4	a_1321_392##8	429.927612
Rg38	a_1321_392##5	a_1321_392##9	295.494476
Rg39	a_1940_74#	a_1940_74##2	531.963257
Rg40	a_1940_74##2	a_1940_74##3	74.763275
Rg41	a_1940_74##3	a_1940_74##4	22.786335
Rg42	a_1940_74##4	a_1940_74##5	53.667305
Rg43	a_1940_74##5	a_1940_74##6	51.777424
Rg44	a_1940_74##6	a_1940_74##7	486.625458
Rg45	a_1940_74##2	a_1940_74##8	468.274780
Rg46	a_1940_74##3	a_1940_74##9	432.702454
Rg47	a_1940_74##4	a_1940_74##10	339.561127
Rg48	a_1940_74##5	a_1940_74##11	449.555756
Rg49	a_1940_74##6	a_1940_74##12	394.487335
Rg50	a_1940_74##6	a_1940_74##13	480.566620
Rf1	D#4	D	0.532052
Rf2	D#1	D#6	53.942986
Rf3	D#4	D#6	7.479781
Rf4	D#7	D	0.532052
Rf5	D#6	D#7	7.086109
Rf6	CLK#4	CLK#2	161.521530
Rf7	CLK	CLK#6	1.288721
Rf8	CLK#4	CLK#6	7.589135
Rf9	a_225_74##5	a_225_74##11	217.174225
Rf10	a_225_74##11	a_225_74##12	76.773445
Rf11	a_225_74##11	a_225_74##13	20.543768
Rf12	a_27_74#	a_27_74##2	39.630203
Rf13	a_27_74##2	a_27_74##3	158.235580
Rf14	a_27_74##3	a_27_74##4	137.328201
Rf15	a_27_74##2	a_27_74##5	114.331299
Rf16	a_27_74##3	a_27_74##6	36.228699
Rf17	a_398_74##3	a_398_74##10	270.579803
Rf18	a_767_402##5	a_767_402##2	201.207657
Rf19	a_767_402##7	a_767_402##3	245.835724
Rf20	SET_B#7	SET_B#8	2.787846
Rf21	SET_B#2	SET_B#10	163.020645
Rf22	SET_B#7	SET_B#10	4.782650
Rf23	a_612_74##5	a_612_74##8	232.786102
Rf24	a_612_74##8	a_612_74##9	116.660530
Rf25	a_612_74##9	a_612_74##10	105.285141
Rf26	a_612_74##9	a_612_74##11	47.996124
Rf27	a_398_74##8	a_398_74##6	408.188934
Rf28	a_398_74##6	a_398_74##13	338.923767
Rf29	a_398_74##13	a_398_74##14	200.980972
Rf30	a_398_74##13	a_398_74##2	205.256897
Rf31	SET_B#5	SET_B#12	80.613510
Rf32	SET_B#13	SET_B	10.274887
Rf33	SET_B#12	SET_B#13	5.905091
Rf34	a_1321_392##5	a_1321_392##11	105.226944
Rf35	a_1321_392##11	a_1321_392##13	98.949188
Rf36	a_1321_392##11	a_1321_392##14	25.649860
Rf37	a_1321_392##13	a_1321_392##15	138.484009
Rf38	a_1321_392##13	a_1321_392##12	22.274963
Rf39	a_1321_392##12	a_1321_392##13	5.000000
Rf40	a_1484_62##2	a_1484_62##5	281.776917
Rf41	a_1484_62##5	a_1484_62##6	26.428589
Rf42	a_1484_62##5	a_1484_62##7	148.132782
Rf43	a_1940_74##14	a_1940_74##15	31.840164
Rf44	a_1940_74##15	a_1940_74##16	63.804264
Rf45	a_1940_74##15	a_1940_74##5	98.489426
Rf46	Q#1	Q#2	21.257261
Rf47	Q#2	Q	19.385790
Rf48	Q	Q#3	46.779736
Rf49	Q#3	Q#4	111.250793
Rf50	Q#2	Q#5	65.814774
Rf51	Q#3	Q#6	16.968842
Rf52	VPWR#1	VPWR#2	94.583397
Rf53	VPWR#2	VPWR#3	67.556396
Rf54	VPWR#3	VPWR#4	76.091309
Rf55	VPWR#4	VPWR#5	68.955956
Rf56	VPWR#5	VPWR#6	68.433075
Rf57	VPWR#6	VPWR#7	157.911865
Rf58	VPWR#7	VPWR#8	127.230644
Rf59	VPWR#8	VPWR#9	51.963894
Rf60	VPWR#9	VPWR#10	118.317268
Rf61	VPWR#10	VPWR#11	73.731934
Rf63	VPWR#2	VPWR#13	33.896767
Rf64	VPWR#3	VPWR#14	43.889961
Rf65	VPWR#4	VPWR#15	62.539814
Rf66	VPWR#5	VPWR#16	37.027283
Rf67	VPWR#6	VPWR#17	47.494125
Rf68	VPWR#7	VPWR#18	46.834885
Rf69	VPWR#8	VPWR#19	57.855865
Rf70	VPWR#10	VPWR#20	34.901169
Rf71	VPWR#11	VPWR#21	35.294842
Rf72	VGND#1	VGND#2	118.715729
Rf73	VGND#2	VGND#3	85.281258
Rf74	VGND#3	VGND#4	36.865967
Rf75	VGND#4	VGND#5	102.579704
Rf76	VGND#5	VGND#6	190.946274
Rf77	VGND#6	VGND#7	117.715218
Rf78	VGND#7	VGND#8	62.951874
Rf79	VGND#8	VGND#9	118.374619
Rf80	VGND#9	VGND#10	78.229668
Rf82	VGND#2	VGND#12	18.526756
Rf83	VGND#3	VGND#13	33.306259
Rf84	VGND#5	VGND#14	11.625160
Rf85	VGND#6	VGND#15	31.337896
Rf86	VGND#7	VGND#16	29.274549
Rf87	VGND#9	VGND#17	37.457504
Rf88	VGND#10	VGND#18	40.352859
Rf97	a_612_74##2	a_612_74##8	160.232803
Re2	SET_B	SET_B#8	14.521620
Re3	VPWR#4	VPWR	2.042809
Re4	VPWR	VPWR#9	1.896894
Re5	VGND#4	VGND	2.042809
Re6	VGND	VGND#8	1.896894
*
*       CAPACITOR CARDS
*
*
C1	VGND#4	a_1940_74##8	6.67238e-19
C2	a_27_74##6	VPWR#21	3.05928e-17
C3	a_1940_74##8	VGND#1	2.18264e-17
C4	a_225_74##4	a_225_74##3	1.84034e-19
C5	a_27_74##4	D#2	1.43176e-17
C6	a_767_402##2	VGND#16	2.68949e-17
C7	VPWR#4	a_1940_74##7	1.76793e-19
C8	a_27_74##2	a_767_402##4	1.05021e-19
C9	a_398_74##13	a_767_402#	4.61161e-19
C10	D#4	a_225_74##11	1.98431e-18
C11	a_1321_392##9	a_1321_392##6	3.98428e-18
C12	VPWR#4	Q#2	3.6429e-18
C13	a_612_74##2	a_225_74##3	3.99039e-19
C14	a_27_74##3	D#1	2.97801e-17
C15	VPWR#14	Q#5	1.00692e-16
C16	VGND#5	VGND#14	9.43837e-18
C17	SET_B#8	VPWR#7	5.16919e-18
C18	a_27_74##2	D#1	1.51155e-18
C19	a_1940_74##8	Q#6	1.68622e-17
C20	a_612_74##11	a_767_402##2	6.36317e-18
C21	VGND#2	a_1940_74##10	2.28474e-17
C22	a_1484_62##2	a_1321_392##12	7.18879e-18
C23	D#7	CLK#2	1.0546e-19
C24	a_225_74##11	D#1	1.17833e-17
C25	a_398_74##10	a_225_74##4	5.35839e-18
C26	D#4	a_225_74##12	3.93751e-17
C27	VGND#4	a_1940_74##7	1.60205e-18
C28	SET_B#8	VPWR#6	1.94743e-19
C29	VGND#1	a_1940_74##10	1.24489e-18
C30	VPWR#4	a_1940_74##15	3.6978e-18
C31	VGND#16	a_767_402##3	2.65398e-19
C32	D#6	CLK#2	4.32282e-19
C33	VGND#4	a_1321_392##7	8.00998e-19
C34	SET_B#6	a_1321_392##9	6.77001e-18
C35	VGND#4	Q#3	2.12055e-17
C36	a_27_74##2	a_225_74##6	2.98123e-19
C37	VGND#3	a_1321_392#	2.6641e-20
C38	D#4	CLK#2	4.50756e-19
C39	VPWR#8	VPWR#7	1.84937e-19
C40	a_1321_392##12	a_398_74##8	1.02917e-16
C41	VGND#4	a_1321_392##8	9.73272e-18
C42	VGND#4	Q#2	3.48429e-18
C43	a_1940_74##10	Q#6	2.89731e-18
C44	D#7	D#1	1.96631e-17
C45	D#4	VGND#18	3.53411e-17
C46	VGND#4	SET_B#4	4.04021e-18
C47	Q#4	a_1940_74##8	2.32119e-19
C48	a_612_74##9	a_767_402#	7.09624e-18
C49	VGND#1	a_1940_74##12	1.08374e-19
C50	a_398_74##13	VPWR#18	1.1628e-17
C51	a_27_74##4	D#6	4.59326e-18
C52	VPWR#18	a_398_74##8	1.34522e-19
C53	VGND#2	a_1940_74##12	1.82852e-17
C54	a_1484_62##5	a_1321_392##11	2.17697e-18
C55	a_1940_74##14	VPWR#14	7.02474e-17
C56	a_767_402##2	a_225_74##3	4.13895e-19
C57	a_1484_62#	SET_B#6	3.44388e-17
C58	D#6	D#1	6.92865e-18
C59	a_398_74##6	a_1321_392##12	6.05313e-17
C60	VGND#4	a_1484_62##3	8.68604e-18
C61	VPWR#2	a_1940_74##9	9.82941e-19
C62	a_1940_74##10	VGND#12	1.35652e-17
C63	VGND#4	a_1940_74##15	9.42375e-18
C64	VPWR#1	a_1940_74#	4.20821e-17
C65	a_1321_392#	a_1940_74##6	7.90721e-18
C66	D#4	D#1	1.75366e-17
C67	VPWR#4	a_1321_392##11	3.46327e-18
C68	a_27_74##2	a_398_74##4	1.34711e-18
C69	Q#2	a_1940_74#	1.41302e-17
C70	VGND#13	a_1321_392##3	1.02723e-18
C71	a_1940_74##10	a_1940_74##8	2.95285e-17
C72	VGND#4	a_1484_62##5	3.11876e-17
C73	a_27_74##5	a_398_74##2	1.12122e-19
C74	a_398_74##13	a_716_463#	9.46239e-18
C75	a_398_74##6	VPWR#18	6.82824e-17
C76	VGND#3	a_1940_74##7	7.56009e-18
C77	a_1940_74#	Q#1	2.65014e-17
C78	a_27_74##4	D#4	3.69701e-17
C79	Q#4	a_1940_74##10	5.60976e-19
C80	VPWR#15	VPWR#14	5.45031e-18
C81	VGND#4	a_398_74##5	1.12167e-18
C82	a_1321_392##12	a_612_74##5	8.65599e-20
C83	VPWR#2	VPWR#1	1.22366e-18
C84	a_767_402##7	a_398_74##6	5.62474e-17
C85	VPWR#3	a_1940_74##11	2.7067e-19
C86	a_398_74##7	a_1484_62#	2.78566e-17
C87	VPWR#4	SET_B#13	3.64197e-18
C88	VPWR#1	a_1940_74##9	2.47203e-18
C89	a_612_74##9	a_398_74#	6.015e-18
C90	a_27_74##3	a_225_74##9	2.59931e-19
C91	a_398_74##13	a_767_402##7	8.20622e-17
C92	a_1940_74##12	VGND#12	1.71813e-17
C93	a_398_74##3	a_612_74##11	2.15647e-17
C94	VPWR#13	a_1940_74#	2.66768e-18
C95	a_1940_74##16	a_1321_392##4	6.79173e-19
C96	VGND#2	a_1940_74##7	8.53232e-19
C97	a_27_74##5	a_398_74##3	5.46386e-17
C98	VPWR#18	a_612_74##5	3.76991e-19
C99	VGND#5	a_1321_392##7	1.19693e-18
C100	a_27_74##2	a_225_74##9	2.47948e-17
C101	VPWR#2	a_1940_74##11	9.8024e-19
C102	VGND#13	a_1940_74##10	2.57283e-19
C103	a_1940_74##9	Q#1	2.5272e-17
C104	VPWR#15	a_1940_74##14	6.67972e-17
C105	a_398_74##10	a_398_74##3	3.83674e-18
C106	Q#2	a_1940_74##9	1.90531e-17
C107	Q#5	a_1940_74#	1.93787e-19
C108	a_1940_74##12	a_1940_74##10	7.07641e-18
C109	VPWR#5	a_1940_74##13	1.34493e-20
C110	a_767_402##3	a_225_74##3	3.68169e-18
C111	Q#4	a_1940_74##12	5.78796e-17
C112	a_225_74##11	a_225_74##9	7.01127e-19
C113	a_225_74##2	a_398_74##7	9.83304e-18
C114	Q#3	VGND#1	4.73384e-17
C115	VPWR#13	a_1940_74##9	5.35245e-17
C116	VGND#3	a_1321_392##7	3.79406e-18
C117	a_27_74##3	CLK#1	7.13432e-19
C118	VGND#2	Q#3	9.29994e-17
C119	a_612_74##9	a_225_74##7	4.26247e-18
C120	a_1940_74##16	a_1321_392##3	1.88326e-17
C121	Q#1	VPWR#2	1.34863e-17
C122	a_225_74##12	a_225_74##4	2.01247e-19
C123	VPWR#3	a_1940_74##13	6.51302e-18
C124	a_398_74##13	VPWR#19	1.13206e-16
C125	a_225_74##5	a_27_74##5	1.61034e-17
C126	Q#1	a_1940_74##11	2.61112e-19
C127	a_767_402##7	SET_B#2	7.34756e-18
C128	VGND#13	a_1940_74##12	1.41935e-18
C129	a_1321_392##15	a_225_74##2	2.82974e-18
C130	a_398_74##10	a_225_74##5	2.57188e-17
C131	a_27_74##2	CLK#1	2.61607e-17
C132	Q#5	a_1940_74##9	4.55367e-19
C133	VGND#1	VPWR#1	1.75181e-19
C134	VPWR#3	VPWR#13	1.72863e-20
C135	VGND#2	a_1321_392##7	3.52389e-19
C136	VGND#17	a_225_74##5	2.50102e-18
C137	a_612_74##6	a_225_74##2	5.52586e-17
C138	a_1940_74##14	a_1940_74#	1.75737e-20
C139	a_612_74##10	a_612_74##11	1.04005e-18
C140	Q#4	a_1940_74##7	4.01048e-17
C141	VGND#5	a_1321_392##8	1.28617e-17
C142	VPWR#18	a_225_74##3	4.93465e-20
C143	VPWR#13	a_1940_74##11	4.6263e-17
C144	VGND#4	SET_B#12	2.54427e-18
C145	a_225_74##11	CLK#1	2.17033e-17
C146	Q#2	a_1940_74##11	5.70287e-19
C147	a_1940_74##7	a_1940_74##12	3.60847e-17
C148	VGND#5	SET_B#5	7.20167e-18
C149	a_1940_74##6	a_1940_74##4	1.94338e-18
C150	a_767_402##7	a_612_74##2	2.4056e-17
C151	SET_B#3	a_225_74##2	1.92022e-17
C152	SET_B#5	a_1321_392##8	2.34652e-18
C153	Q#1	a_1940_74##13	8.68842e-20
C154	a_1484_62##7	VPWR#15	7.08818e-17
C155	a_27_74##3	D#3	1.51485e-17
C156	Q#3	Q#6	3.88374e-18
C157	a_225_74##4	a_398_74##2	1.10468e-18
C158	Q#5	a_1940_74##11	3.53887e-17
C159	a_1940_74##5	VPWR#3	2.5912e-19
C160	VGND#15	a_225_74##2	4.90443e-19
C161	a_767_402##5	VGND#15	1.26585e-17
C162	Q#2	VPWR#1	4.58643e-19
C163	VGND#13	a_1940_74##7	1.74034e-17
C164	VGND#7	VGND#15	1.5681e-19
C165	a_1940_74##14	a_1940_74##9	2.04297e-20
C166	a_398_74##2	a_225_74##3	6.60338e-19
C167	VPWR#3	a_1321_392#	2.08473e-18
C168	SET_B#3	a_612_74##6	1.03514e-17
C169	CLK#2	VGND#17	1.91538e-18
C170	VPWR#13	a_1940_74##13	2.55833e-18
C171	Q#4	a_1321_392##7	1.89709e-18
C172	CLK#2	a_225_74##12	4.3744e-17
C173	a_1484_62##2	a_1321_392##8	1.03812e-19
C174	VPWR#14	a_1940_74##11	4.69131e-19
C175	a_1321_392##4	a_1321_392##6	3.24582e-18
C176	Q#5	VPWR#3	7.2575e-18
C177	VPWR#4	a_1940_74#	8.97887e-19
C178	a_1940_74##16	a_1940_74##7	4.1817e-19
C179	a_27_74##5	D#1	5.20565e-20
C180	a_1484_62##2	SET_B#4	2.59071e-17
C181	Q#5	a_1940_74##13	5.54638e-17
C182	VGND#8	a_398_74#	5.59221e-18
C183	VGND#5	SET_B#4	2.36796e-17
C184	VPWR#4	a_1321_392##4	2.24632e-18
C185	Q#2	a_1940_74##13	1.9144e-19
C186	a_398_74##10	D#1	2.54266e-19
C187	a_1321_392##7	a_1940_74##7	2.98883e-17
C188	Q#3	a_1940_74##5	4.2544e-17
C189	SET_B#13	a_1321_392##4	2.93665e-18
C190	a_1940_74##14	a_1940_74##11	3.56833e-20
C191	a_27_74##5	a_27_74#	2.56012e-18
C192	VGND#16	VGND#15	6.75834e-18
C193	a_1321_392##5	VPWR#5	6.62487e-19
C194	a_1484_62##2	a_1484_62##3	7.5527e-18
C195	VPWR#4	a_1940_74##9	5.24071e-19
C196	VGND#5	a_1484_62##2	3.50353e-17
C197	VGND#13	a_1321_392##7	4.38506e-17
C198	a_398_74##8	a_1321_392##8	3.44514e-19
C199	a_612_74##3	SET_B#3	2.57535e-17
C200	Q#3	a_1940_74##8	4.51301e-17
C201	VGND#8	a_225_74##7	4.4296e-18
C202	VPWR#4	a_1321_392##3	1.08394e-18
C203	VPWR#6	VPWR#5	7.9523e-19
C204	Q#3	VGND#12	1.15033e-18
C205	a_767_402##7	a_767_402##3	3.75736e-19
C206	a_1940_74##5	Q#2	2.75346e-17
C207	a_767_402##7	a_225_74##3	7.90983e-19
C208	VGND#4	a_1940_74##6	1.01902e-20
C209	a_1940_74##13	VPWR#14	2.86567e-17
C210	a_225_74##12	D#1	6.84948e-18
C211	a_225_74#	a_1484_62##2	2.53476e-17
C212	a_612_74##10	a_398_74##13	1.04067e-16
C213	a_398_74##8	SET_B#4	2.00576e-18
C214	Q#2	Q#1	1.96021e-18
C215	VPWR#4	a_1940_74##11	6.14609e-19
C216	VPWR#16	a_1484_62##7	2.54336e-17
C217	D#7	CLK#1	4.58893e-19
C218	Q#5	VPWR#2	8.08872e-18
C219	VPWR#19	a_767_402##3	7.53692e-19
C220	VGND#18	D#1	6.47326e-18
C221	a_398_74##8	a_1484_62##3	7.41949e-18
C222	Q#5	a_1321_392#	1.41191e-18
C223	a_1484_62##5	SET_B#12	2.13474e-17
C224	VGND#3	a_1940_74##15	7.64952e-19
C225	a_1321_392##7	a_1940_74##16	1.67396e-17
C226	a_27_74##4	D#1	1.14841e-17
C227	VPWR#4	a_1940_74##13	3.38944e-18
C228	a_225_74##4	a_398_74##3	5.67125e-17
C229	VGND#5	a_1484_62##5	9.18544e-17
C230	a_1940_74##14	a_1940_74##13	1.2754e-18
C231	a_767_402##4	a_612_74##3	3.87131e-18
C232	VPWR#6	a_1321_392##9	3.24794e-19
C233	a_398_74##8	a_225_74#	1.36882e-17
C234	a_612_74##10	a_767_402##3	1.09705e-19
C235	a_398_74##6	SET_B#4	1.78389e-18
C236	a_398_74##3	a_225_74##3	2.00627e-18
C237	VPWR#13	a_1940_74##6	1.73158e-19
C238	VPWR#6	SET_B#5	2.31131e-20
C239	VGND#13	a_1321_392##8	5.91491e-19
C240	VPWR#4	a_1321_392#	7.90155e-18
C241	a_1321_392#	VPWR#14	2.93925e-17
C242	a_1321_392##8	a_1321_392##7	5.44683e-18
C243	a_398_74##8	a_398_74##5	3.41372e-19
C244	VGND#16	a_612_74##9	7.50109e-18
C245	a_1321_392##14	a_1484_62##7	1.22068e-18
C246	VGND#5	a_1484_62##3	9.15929e-18
C247	a_398_74##6	a_1484_62##3	4.58913e-18
C248	VPWR#15	a_1940_74##13	6.22409e-19
C249	VGND#4	a_1940_74##2	1.69431e-20
C250	VPWR#5	SET_B#5	5.46744e-20
C251	VPWR#5	a_1321_392##9	8.03624e-18
C252	Q#3	a_1940_74##10	2.44388e-17
C253	VPWR#4	a_1321_392##6	1.19053e-17
C254	a_398_74##8	VGND#5	6.00916e-18
C255	a_398_74##8	a_612_74##4	1.31957e-19
C256	a_398_74##6	a_225_74#	3.00291e-17
C257	Q#4	Q#3	1.83359e-18
C258	a_1940_74##14	a_1321_392#	5.22175e-17
C259	a_398_74##13	VPWR#9	4.05174e-17
C260	Q#2	VPWR#13	2.54086e-17
C261	VGND#4	a_1321_392##4	3.6438e-18
C262	a_612_74##10	a_398_74##2	8.85676e-18
C263	a_1940_74##16	a_1321_392##8	3.10104e-18
C264	a_767_402##7	a_398_74##3	4.84324e-20
C265	a_225_74##6	a_767_402##4	3.39098e-17
C266	a_27_74##3	a_225_74##4	1.27629e-19
C267	a_1484_62##7	a_1940_74##13	1.3344e-19
C268	VPWR#4	a_1321_392##9	7.0197e-18
C269	SET_B#13	a_1321_392##11	1.26629e-17
C270	a_398_74##6	a_398_74##5	2.85391e-17
C271	VPWR#13	a_1940_74##4	5.41127e-19
C272	VPWR#3	a_1321_392##9	1.55704e-20
C273	a_767_402##7	SET_B#10	2.41702e-17
C274	VGND#7	a_767_402##5	7.84834e-18
C275	VPWR#14	a_1321_392##6	7.88074e-19
C276	VGND#4	a_1321_392##3	1.83384e-18
C277	a_1321_392##14	VPWR#16	3.03929e-17
C278	VPWR#19	a_225_74##3	3.6847e-18
C279	a_612_74##4	a_398_74##6	1.31185e-17
C280	VPWR#15	a_1321_392#	7.42108e-19
C281	a_1940_74##15	a_1321_392#	1.10679e-17
C282	a_612_74##5	a_225_74#	1.1032e-18
C283	VPWR#6	SET_B#6	5.24507e-18
C284	VPWR#16	a_1940_74##13	5.46904e-20
C285	a_1940_74##14	VPWR#3	3.45519e-18
C286	VGND#6	a_225_74##2	3.79064e-20
C287	a_1321_392##8	a_1484_62##6	1.45608e-17
C288	a_398_74##6	SET_B#1	5.78438e-19
C289	VPWR#6	a_1484_62##2	8.07261e-20
C290	a_398_74##3	a_612_74##10	3.13576e-17
C291	a_1940_74##14	a_1321_392##6	4.22436e-17
C292	SET_B#4	a_1321_392##8	1.49078e-18
C293	a_1484_62##5	a_1321_392##5	5.60848e-17
C294	a_398_74##4	a_225_74##6	2.28937e-17
C295	a_225_74##5	a_225_74##4	4.12923e-18
C296	VGND#6	a_398_74##6	4.89129e-17
C297	VGND#5	a_225_74#	4.79053e-18
C298	a_767_402##7	SET_B#7	8.23985e-18
C299	a_398_74##3	a_27_74#	1.91747e-17
C300	a_398_74##6	a_612_74#	1.05673e-19
C301	Q#3	a_1940_74##12	8.66952e-19
C302	a_1940_74##16	SET_B#4	1.04528e-19
C303	VPWR#5	SET_B#6	8.74657e-19
C304	a_398_74##14	a_398_74##13	1.00966e-18
C305	VGND#5	a_225_74##2	2.08659e-22
C306	SET_B#8	SET_B#10	1.32679e-17
C307	VPWR#14	a_1321_392##9	3.16163e-19
C308	VPWR#17	VPWR#16	2.11656e-18
C309	Q#5	a_1940_74##6	3.06677e-18
C310	VGND#5	a_398_74##6	4.15728e-17
C311	a_398_74##3	a_398_74##14	4.49454e-18
C312	VGND#6	a_767_402##5	1.46297e-18
C313	a_1321_392##6	VPWR#15	2.37989e-17
C314	a_612_74##5	SET_B#1	2.35513e-17
C315	Q#5	Q#2	1.59923e-18
C316	a_1321_392##8	VGND#14	6.96346e-18
C317	SET_B#8	SET_B#7	2.23285e-17
C318	VPWR#7	a_1484_62#	2.08131e-19
C319	SET_B#6	a_1321_392##4	1.87276e-18
C320	a_612_74##2	a_225_74#	5.63266e-20
C321	a_1484_62##7	a_1321_392##6	1.51652e-18
C322	VGND#6	a_398_74##5	4.47407e-18
C323	VGND#7	VGND#6	3.62088e-19
C324	VPWR#3	a_1940_74##6	1.37215e-20
C325	a_27_74##2	a_225_74##4	2.66584e-17
C326	a_225_74##5	a_398_74##14	1.37124e-18
C327	VPWR#17	a_1321_392##14	2.64975e-17
C328	VPWR#6	a_1484_62#	7.89819e-18
C329	SET_B#12	a_1321_392##4	5.16586e-18
C330	VGND#4	a_225_74##2	4.86518e-20
C331	a_1484_62##3	SET_B#4	4.27114e-17
C332	VPWR#15	a_1321_392##9	1.9012e-18
C333	VPWR#6	a_398_74##8	2.89714e-19
C334	a_1484_62##5	SET_B#5	4.29619e-18
C335	a_225_74##5	VPWR#20	4.04141e-19
C336	VGND#8	a_612_74##9	5.64354e-19
C337	VPWR#10	a_225_74##4	3.17963e-21
C338	a_1484_62##5	a_1321_392##6	1.51338e-19
C339	SET_B#4	VGND#14	1.40205e-17
C340	VGND#6	a_612_74##5	1.5243e-18
C341	SET_B#13	a_1321_392##5	1.29842e-17
C342	VGND#16	a_767_402##4	1.92141e-19
C343	VGND#5	a_398_74##5	5.12181e-19
C344	VPWR#5	a_1484_62#	8.85228e-20
C345	SET_B#8	a_225_74##2	1.80847e-18
C346	a_612_74##2	SET_B#1	2.13432e-17
C347	CLK#1	a_225_74##9	4.30435e-17
C348	a_1484_62##7	VPWR#5	8.43647e-18
C349	a_1484_62##7	a_1321_392##9	3.10096e-17
C350	a_767_402##2	a_398_74##5	8.0343e-20
C351	a_1940_74##4	a_1940_74##2	4.25206e-18
C352	VGND#7	a_612_74##4	1.60296e-19
C353	a_1321_392##5	a_1321_392##6	2.11454e-20
C354	a_1321_392##14	a_1321_392##6	3.34417e-20
C355	SET_B#8	a_612_74##6	1.09415e-18
C356	a_767_402##2	a_612_74##4	2.50703e-19
C357	VPWR#7	a_398_74##7	2.09378e-19
C358	Q#4	a_1940_74##15	2.38246e-17
C359	a_612_74##11	VGND#16	1.19426e-17
C360	SET_B#12	a_1321_392##5	1.30431e-17
C361	a_1321_392##5	a_1321_392##9	1.60524e-17
C362	a_1321_392##11	SET_B#5	3.88505e-18
C363	a_1321_392##9	VPWR#16	1.35855e-17
C364	VPWR#14	a_1940_74##6	7.38684e-19
C365	a_767_402##2	SET_B#1	4.9047e-19
C366	a_398_74##6	VPWR#7	4.35427e-18
C367	SET_B#12	a_1321_392##3	5.28822e-20
C368	VGND#6	a_612_74##4	3.78604e-18
C369	a_1321_392##12	a_1480_508#	2.23866e-18
C370	D#3	CLK#1	4.03122e-18
C371	a_612_74##10	a_225_74##4	1.44098e-19
C372	a_225_74#	a_1484_62##3	4.02963e-17
C373	VPWR#6	a_398_74##7	6.0091e-18
C374	a_1321_392##5	SET_B#6	5.34312e-19
C375	a_767_402##2	a_612_74#	5.89465e-18
C376	a_1484_62##7	SET_B#6	1.43005e-19
C377	a_1484_62##2	a_1484_62##5	1.15172e-18
C378	a_27_74##3	VPWR#10	9.70719e-19
C379	a_1321_392##14	a_1321_392##9	1.23027e-18
C380	a_1321_392##12	a_1321_392##14	7.06612e-18
C381	VPWR#10	a_225_74##3	7.22625e-18
C382	a_767_402##2	a_767_402#	5.08753e-18
C383	SET_B#13	SET_B#5	1.77862e-17
C384	a_1321_392##5	a_1484_62#	3.10911e-19
C385	a_225_74##11	a_225_74##4	3.24333e-19
C386	VPWR#2	a_1940_74##6	2.71685e-20
C387	VGND#6	SET_B#2	3.46138e-19
C388	VGND#5	a_612_74##4	6.3878e-20
C389	a_398_74#	a_767_402##2	2.03138e-18
C390	VPWR#16	SET_B#6	1.63637e-18
C391	VPWR#3	VPWR#2	1.06617e-18
C392	VPWR#21	D#1	1.24906e-18
C393	VPWR#17	a_1321_392##9	5.17671e-19
C394	a_612_74##10	a_225_74##3	9.1261e-19
C395	a_1484_62#	SET_B#5	5.44656e-18
C396	a_767_402#	a_767_402##3	1.28097e-19
C397	VPWR#7	a_225_74##2	5.27089e-17
C398	SET_B#12	SET_B#5	2.05956e-17
C399	VGND#13	a_1940_74##15	2.88853e-17
C400	a_1484_62##2	a_1321_392##11	1.68885e-18
C401	a_1940_74##15	VPWR#14	1.76667e-17
C402	a_1321_392##14	SET_B#6	3.21331e-17
C403	a_1321_392##12	VPWR#17	8.52733e-18
C404	a_1940_74##15	a_1940_74##7	1.02328e-17
C405	a_1321_392##14	VPWR#6	8.41968e-18
C406	a_1321_392##3	a_1940_74##6	8.80672e-19
C407	a_398_74##5	a_225_74#	2.32658e-17
C408	VGND#6	SET_B#1	5.52389e-18
C409	VPWR#16	a_1484_62#	1.73436e-19
C410	VPWR#6	a_225_74##2	4.75314e-19
C411	VPWR#9	a_225_74##4	1.15294e-19
C412	a_398_74##8	SET_B#6	3.68478e-19
C413	SET_B#6	VPWR#17	1.2209e-17
C414	a_27_74##2	VPWR#10	1.88854e-18
C415	a_398_74##10	VGND#16	2.10701e-18
C416	a_1484_62##2	SET_B#13	5.20021e-18
C417	VPWR#9	a_398_74##4	7.28633e-19
C418	a_1940_74##14	a_1940_74##6	1.75976e-19
C419	VGND#7	a_612_74##2	9.74508e-19
C420	VPWR#9	a_225_74##3	2.46007e-17
C421	a_398_74##8	a_1484_62#	2.17135e-17
C422	a_1321_392##14	a_1484_62#	1.26459e-18
C423	VPWR#2	a_1940_74##4	2.05092e-20
C424	a_27_74#	a_225_74##4	1.60937e-17
C425	a_225_74##2	a_1484_62##2	1.50688e-17
C426	a_1321_392##15	a_1484_62##3	9.46995e-19
C427	a_1321_392##14	VPWR#5	9.25976e-18
C428	a_225_74##7	a_398_74##2	2.42153e-18
C429	VGND#6	a_612_74##2	1.78841e-18
C430	VPWR#8	a_225_74##3	3.54906e-17
C431	VPWR#5	a_1321_392##4	4.23575e-20
C432	a_1484_62##2	SET_B#12	3.95618e-17
C433	VGND#7	a_612_74#	1.37586e-18
C434	a_398_74##3	a_398_74#	7.51706e-19
C435	VGND#4	VGND#1	6.4319e-17
C436	a_1484_62#	VPWR#17	1.23591e-17
C437	VPWR#7	a_612_74##6	2.22352e-18
C438	a_225_74##2	a_398_74##8	3.1518e-17
C439	a_1321_392##12	SET_B#6	2.36928e-18
C440	a_612_74##4	a_398_74##5	1.99435e-17
C441	a_1940_74##14	a_1940_74##4	2.04297e-20
C442	a_398_74##3	a_225_74##7	3.49906e-17
C443	a_27_74#	a_225_74##3	1.55909e-18
C444	VGND#7	a_767_402##4	2.06463e-19
C445	a_398_74##3	a_225_74##8	1.09688e-20
C446	a_398_74##6	a_225_74##2	5.58323e-17
C447	VGND#6	a_612_74#	3.72709e-18
C448	a_1940_74##5	a_1940_74##6	3.72609e-17
C449	a_398_74##8	SET_B#13	3.41093e-18
C450	a_1321_392##15	a_225_74#	3.61316e-17
C451	CLK	a_225_74##4	1.22452e-18
C452	a_1321_392##11	SET_B#6	2.74749e-17
C453	a_1484_62##5	a_1321_392##7	1.53615e-18
C454	VPWR#4	a_1940_74##16	4.2066e-18
C455	a_398_74##6	a_612_74##6	3.84146e-17
C456	VGND#9	a_767_402#	1.59116e-20
C457	VPWR#17	a_398_74##7	1.99524e-18
C458	VGND#7	a_767_402##2	3.54488e-18
C459	a_1484_62##5	a_1940_74##14	1.88637e-18
C460	a_1940_74##5	a_1940_74##4	1.99996e-17
C461	a_612_74##5	a_225_74##2	9.32369e-19
C462	a_1321_392##12	a_1484_62#	3.51383e-17
C463	VGND#8	a_225_74##4	2.01515e-19
C464	VGND#9	a_398_74##10	4.04986e-17
C465	a_1484_62##5	a_1940_74##16	8.37622e-17
C466	SET_B#8	VPWR#4	4.45511e-18
C467	VGND#4	Q#4	1.89011e-17
C468	a_398_74##6	SET_B#3	1.82033e-17
C469	a_398_74##10	a_612_74##11	3.0613e-17
C470	a_398_74##6	a_612_74##3	2.79377e-18
C471	VGND#4	SET_B#8	4.55506e-18
C472	VGND#7	a_767_402#	6.94929e-18
C473	a_1940_74##16	VPWR#15	1.62957e-17
C474	a_398_74##14	a_225_74##4	6.22281e-18
C475	VGND#4	VGND#13	2.20982e-17
C476	SET_B#2	a_225_74##2	8.17832e-19
C477	SET_B#1	a_612_74##4	1.69441e-17
C478	VPWR#7	SET_B#3	6.79152e-19
C479	CLK#2	a_225_74##8	5.44145e-18
C480	a_1321_392##15	a_398_74##5	2.37809e-17
C481	VPWR#17	a_225_74##2	4.62197e-19
C482	a_398_74##6	a_767_402##4	6.15043e-20
C483	VPWR#7	a_225_74##3	3.37864e-18
C484	SET_B#2	a_612_74##6	1.53506e-17
C485	VPWR#7	a_612_74##2	5.87223e-19
C486	a_1321_392##12	a_398_74##7	4.16331e-17
C487	VGND#4	a_1940_74##16	3.68305e-17
C488	a_612_74##2	a_225_74##2	7.48269e-19
C489	a_1940_74##14	a_1940_74##2	2.05026e-20
C490	VPWR#18	a_1321_392##12	1.52437e-17
C491	a_398_74##10	VGND#7	1.97034e-18
C492	VGND#5	VGND#3	3.93192e-19
C493	Q#3	a_1940_74##6	6.2156e-18
C494	a_1484_62##5	a_1321_392##8	4.08241e-17
C495	a_398_74##10	a_27_74##5	7.78594e-17
C496	VPWR#4	a_1940_74##5	6.88409e-18
C497	a_398_74##14	a_225_74##3	2.2137e-17
C498	VPWR#7	a_1321_392##12	1.70952e-17
C499	a_1484_62##5	VPWR#15	1.69307e-18
C500	Q#4	VGND#12	9.01123e-19
C501	a_612_74##3	SET_B#2	1.45223e-17
C502	VPWR#2	a_1940_74##2	1.9315e-20
C503	VGND#9	a_398_74#	4.07793e-20
C504	a_1484_62##5	a_1484_62##6	1.89786e-18
C505	D#1	CLK#3	3.9242e-18
C506	VPWR#8	a_612_74##3	7.75252e-19
C507	VGND#4	a_1940_74##5	6.2494e-18
C508	VPWR#4	a_1321_392##5	6.3135e-18
C509	a_1321_392##12	a_225_74##2	6.8479e-17
C510	a_1321_392##15	a_612_74##4	1.51093e-19
C511	a_27_74##2	a_612_74##10	4.25325e-18
C512	a_612_74#	SET_B#1	3.47566e-17
C513	a_767_402#	a_612_74##4	1.92185e-19
C514	VPWR#18	a_398_74##7	2.09908e-19
C515	a_1940_74##14	a_1321_392##4	3.67338e-19
C516	VGND#4	a_1321_392##5	4.85761e-18
C517	VPWR#7	a_612_74##3	3.41858e-19
C518	VGND#15	a_398_74##5	4.38681e-18
C519	VGND#7	a_398_74#	6.55445e-19
C520	VPWR#8	a_767_402##2	2.6711e-21
C521	a_1321_392##12	VPWR#6	2.4367e-17
C522	a_398_74##13	a_398_74##6	2.36008e-18
C523	VPWR#3	a_1321_392##3	1.46177e-20
C524	VPWR#4	a_1484_62##2	3.49811e-18
C525	VPWR#20	a_225_74##4	4.19841e-19
C526	a_1321_392##12	a_612_74##6	3.04566e-18
C527	Q#3	a_1940_74##4	7.28815e-18
C528	a_1484_62##5	SET_B#4	7.93224e-19
C529	D#4	CLK#3	3.11999e-19
C530	VPWR#18	a_225_74##2	3.36303e-18
C531	VGND#4	a_1484_62##2	1.11615e-17
C532	a_767_402##3	a_612_74##3	2.28538e-17
C533	VGND#4	a_1321_392##15	7.00455e-18
C534	VPWR#4	a_398_74##8	4.9457e-18
C535	a_1940_74##14	a_1321_392##3	4.06096e-18
C536	a_1321_392##5	a_1321_392##4	5.32294e-17
C537	VGND#9	a_225_74##7	3.42087e-19
C538	a_27_74##2	a_27_74#	4.92021e-18
C539	VGND#7	a_398_74##2	2.94074e-19
C540	VPWR#8	a_767_402##4	6.55761e-19
C541	VGND#15	a_612_74##4	4.4438e-17
C542	Q#2	VPWR#2	1.57793e-19
C543	a_767_402#	a_612_74#	1.76398e-18
C544	a_398_74##13	a_225_74##4	1.17719e-19
C545	VGND#4	a_398_74##8	3.65085e-19
C546	VGND#17	a_398_74##10	6.09171e-17
C547	a_225_74##12	a_27_74##5	5.51586e-19
C548	SET_B#4	a_1514_88#	8.30758e-18
C549	a_767_402##7	a_225_74##2	1.02671e-18
C550	Q#2	a_1940_74##6	5.46387e-19
C551	VGND#9	a_225_74##12	1.21009e-17
C552	VPWR#20	a_225_74##3	3.68239e-19
C553	Q	a_1940_74##6	1.60955e-19
C554	a_1321_392##5	a_1321_392##3	2.37421e-19
C555	Q	a_1940_74##4	6.21226e-19
C556	a_1484_62##3	a_1514_88#	8.30758e-18
C557	a_1321_392##12	SET_B#3	1.20283e-18
C558	a_27_74##3	a_398_74##14	4.65682e-22
C559	Q	a_1940_74##2	1.84117e-17
C560	a_398_74##2	a_767_402##4	1.00852e-17
C561	VGND#4	a_398_74##6	3.15117e-17
C562	a_612_74##6	VPWR#18	1.78483e-17
C563	VGND#13	Q#4	6.95203e-17
C564	VPWR#8	a_767_402##3	9.50483e-19
C565	VGND#7	a_225_74##7	3.37664e-19
C566	a_398_74##2	a_225_74##6	7.43882e-18
C567	SET_B#8	a_398_74##6	5.41709e-17
C568	SET_B#8	a_1321_392##15	2.03386e-18
C569	VPWR#15	a_1321_392##4	2.95128e-18
C570	a_398_74##3	a_767_402##4	3.57394e-18
C571	a_767_402##7	a_612_74##6	1.49974e-19
C572	a_1484_62##5	a_1484_62##3	2.16062e-19
C573	a_1321_392##5	SET_B#5	8.52338e-18
C574	VGND#15	SET_B#1	1.38607e-17
C575	a_225_74##12	a_398_74##10	2.26895e-18
C576	a_398_74##3	a_225_74##6	1.86185e-18
C577	SET_B#8	a_612_74##5	2.77531e-17
C578	VGND#3	VGND#2	9.91946e-19
C579	a_27_74##2	a_398_74##14	2.74805e-17
C580	SET_B#3	VPWR#18	1.5248e-17
C581	a_398_74#	a_767_402#	5.32948e-17
C582	SET_B#10	a_398_74##6	3.31226e-17
C583	a_1321_392##5	a_1484_62##2	5.40004e-19
C584	a_767_402##5	a_612_74##4	1.42963e-18
C585	a_398_74##13	a_225_74##3	3.9712e-17
C586	SET_B#8	SET_B#2	8.69562e-20
C587	a_1940_74##15	VPWR#3	1.453e-19
C588	VGND#9	a_225_74##8	6.04015e-18
C589	SET_B#8	VGND#15	3.73856e-18
C590	Q#4	a_1940_74##5	4.52385e-17
C591	Q#2	a_1940_74##4	4.66733e-18
C592	a_1321_392##11	SET_B#4	2.34645e-19
C593	SET_B#7	a_398_74##6	2.27728e-18
C594	a_1484_62##2	SET_B#5	7.36167e-17
C595	a_1940_74##16	Q#4	1.33074e-18
C596	a_1484_62##3	a_1436_88#	1.98249e-18
C597	a_398_74##8	a_1321_392##5	5.99099e-18
C598	SET_B#12	a_1321_392##7	1.11129e-19
C599	a_27_74##3	a_27_74##2	2.39401e-18
C600	a_767_402##7	SET_B#3	8.68447e-18
C601	VPWR#15	a_1321_392##3	7.73828e-18
C602	a_225_74#	a_1436_88#	3.87798e-18
C603	SET_B#13	a_225_74##2	6.70131e-19
C604	SET_B#8	a_612_74##2	1.00134e-17
C605	a_1484_62#	a_1480_508#	8.32237e-18
C606	SET_B#5	a_1321_392##4	4.29352e-17
C607	a_398_74##8	SET_B#5	1.2425e-18
C608	VGND#16	a_612_74##4	8.80623e-19
C609	a_225_74##12	VGND#17	5.57702e-17
C610	a_225_74##5	a_225_74##9	6.06526e-18
C611	VGND#15	a_612_74#	2.56147e-18
C612	a_398_74##7	a_1480_508#	8.32237e-18
C613	VGND#7	a_225_74##8	9.00964e-20
C614	a_1940_74##7	a_1321_392#	9.09206e-18
C615	a_398_74##8	a_1484_62##2	9.6153e-17
C616	CLK#1	a_225_74##5	2.25834e-18
C617	a_767_402##5	SET_B#1	5.00788e-18
C618	a_1484_62##5	a_225_74#	1.40751e-19
C619	a_27_74##2	VPWR#20	3.46184e-17
C620	Q#3	a_1940_74##2	1.03843e-18
C621	a_225_74##7	a_398_74#	1.87484e-17
C622	a_767_402##7	a_612_74##3	2.91895e-17
C623	SET_B#8	a_767_402##3	6.73028e-19
C624	VPWR	a_225_74##3	2.88513e-17
C625	a_1940_74##16	VGND#13	6.99087e-17
C626	a_1321_392##4	a_1321_392##3	1.77252e-18
C627	a_225_74##2	a_1220_347#	2.34978e-17
C628	a_27_74##3	a_225_74##13	4.33381e-18
C629	VGND#9	a_225_74##5	8.55207e-19
C630	Q#3	Q#2	1.36394e-17
C631	a_612_74##5	SET_B#7	1.49121e-17
C632	a_27_74##3	a_225_74##11	3.65564e-17
C633	a_1484_62##7	a_1321_392##4	1.0767e-17
C634	a_398_74##6	a_398_74##8	3.31409e-18
C635	a_1940_74##4	a_1940_74##8	2.15043e-18
C636	VGND#16	SET_B#1	5.22989e-19
C637	SET_B#8	a_398_74##2	2.58259e-18
C638	a_612_74##6	a_1220_347#	1.76395e-17
C639	VGND#18	VGND#17	1.06428e-18
C640	a_612_74##3	VPWR#19	2.5809e-18
C641	VGND#9	CLK#3	9.2103e-18
C642	VGND#15	a_767_402#	1.00248e-18
C643	D#1	CLK#1	5.87362e-18
C644	a_612_74##2	a_398_74##13	9.95405e-19
C645	a_225_74##11	VPWR#20	3.42561e-19
C646	VPWR#9	a_398_74##2	1.47581e-19
C647	a_398_74##5	a_1225_74#	1.57447e-17
C648	a_767_402##5	a_612_74#	2.88402e-17
C649	a_767_402##7	a_767_402##4	4.03668e-19
C650	VPWR#19	VPWR#8	2.67295e-18
C651	VGND#8	a_398_74##2	6.57133e-20
C652	a_612_74##5	a_398_74##6	8.3995e-17
C653	CLK	a_225_74##11	1.18768e-17
C654	VPWR#9	a_398_74##3	3.47749e-19
C655	a_27_74##2	a_225_74##13	8.61949e-19
C656	a_225_74##8	a_225_74##7	3.26247e-18
C657	a_398_74##13	a_225_74##2	1.20953e-17
C658	VPWR#18	a_225_74##6	3.20953e-20
C659	a_398_74##6	SET_B#2	1.13813e-17
C660	SET_B#10	SET_B#2	1.25089e-17
C661	VPWR#19	a_767_402##4	2.61423e-17
C662	VGND#8	a_398_74##3	1.57217e-19
C663	a_1484_62##2	a_1321_392##4	1.1223e-20
C664	VGND#18	a_225_74##12	4.40726e-17
C665	VGND#16	a_612_74#	3.19184e-18
C666	a_612_74##9	a_612_74##2	4.55047e-18
C667	VPWR#10	a_225_74##9	6.82453e-18
C668	a_767_402##4	a_716_463#	8.2607e-18
C669	VPWR#14	a_1940_74##7	1.18596e-18
C670	a_27_74##3	VPWR#21	3.94891e-17
C671	a_225_74##11	a_27_74##2	3.60143e-17
C672	a_612_74##5	SET_B#2	2.43493e-17
C673	VPWR#4	VPWR#1	6.59019e-17
C674	a_612_74##2	a_398_74##6	2.32658e-18
C675	SET_B#7	SET_B#2	1.03409e-17
C676	VGND#15	a_398_74#	4.05961e-20
C677	SET_B#1	a_1035_118#	9.87534e-18
C678	a_1940_74##15	a_1940_74##6	2.90359e-18
C679	a_612_74##11	SET_B#1	2.82942e-20
C680	a_612_74#	a_1035_118#	9.87534e-18
C681	a_225_74##11	a_225_74##13	3.49055e-18
C682	a_612_74##2	a_612_74##5	6.17356e-18
C683	Q#2	a_1940_74##2	2.74644e-18
C684	a_398_74##6	a_767_402##2	1.90014e-19
C685	VGND#9	CLK#2	7.44925e-19
C686	Q#3	Q	1.628e-18
C687	a_398_74##10	a_27_74##2	9.49102e-19
C688	VPWR#8	a_225_74##9	2.9594e-20
C689	a_398_74##13	a_767_402##2	3.21504e-19
C690	VPWR#4	Q#1	1.45606e-17
C691	a_1321_392##11	VPWR#6	5.54141e-19
C692	VGND#9	D#2	2.85197e-19
C693	VPWR#19	a_225_74##6	9.37542e-19
C694	a_612_74##2	SET_B#2	3.43618e-17
C695	a_767_402##2	a_612_74##5	4.73047e-20
C696	a_612_74##10	a_767_402##4	1.52173e-18
C697	VPWR#10	a_225_74##5	3.22505e-20
C698	VGND#7	a_612_74##9	1.7673e-18
C699	VPWR#4	VPWR#13	2.17355e-17
C700	a_27_74##4	a_225_74##12	2.59987e-18
C701	CLK#3	a_225_74##8	3.87542e-17
C702	VGND#16	a_767_402#	2.66408e-17
C703	SET_B#5	VGND#14	1.88394e-18
C704	a_398_74##13	a_612_74##6	1.40429e-19
C705	SET_B#10	a_612_74##2	7.92082e-19
C706	a_225_74##8	a_225_74##4	6.73781e-18
C707	a_612_74##2	a_767_402##2	8.35622e-17
C708	a_612_74##11	a_612_74#	3.42544e-19
C709	VPWR#4	Q#5	1.67548e-17
C710	a_612_74##9	a_767_402##2	2.63902e-17
C711	a_27_74##3	a_27_74##6	1.43974e-19
C712	a_27_74##6	a_225_74##4	1.38155e-19
C713	VGND#8	a_612_74##11	1.37015e-17
C714	a_612_74##2	SET_B#7	3.39113e-17
C715	VPWR	VPWR#10	1.01373e-16
C716	a_612_74##2	a_767_402##3	7.38683e-17
C717	a_612_74##3	a_225_74##3	1.9197e-17
C718	VPWR	VPWR#8	8.45878e-17
C719	a_398_74##2	SET_B#2	2.36015e-19
C720	a_612_74##10	a_225_74##6	3.10743e-17
C721	VPWR#10	CLK#1	6.98765e-18
C722	VPWR	VPWR#7	1.30963e-16
C723	CLK	a_27_74##5	4.81003e-18
C724	a_1940_74##15	a_1940_74##4	4.9615e-20
C725	VPWR#4	VPWR#14	1.9183e-17
C726	a_398_74##14	a_767_402##4	3.53248e-20
C727	a_767_402#	a_732_74#	9.87534e-18
C728	VGND#17	CLK	1.79883e-17
C729	a_767_402##2	a_767_402##3	2.18535e-18
C730	a_612_74##2	a_398_74##2	8.38343e-19
C731	a_398_74##13	a_767_402##3	6.49027e-17
C732	a_398_74#	a_732_74#	9.87534e-18
C733	a_27_74##4	VGND#18	3.76178e-17
C734	a_398_74##8	a_1321_392##4	9.26825e-19
C735	a_1321_392##11	VPWR#5	3.80637e-19
C736	a_27_74#	a_225_74##6	7.7713e-19
C737	a_612_74##9	a_225_74##4	3.57248e-19
C738	VGND#16	a_398_74#	3.91288e-18
C739	a_1940_74##14	VPWR#4	1.82223e-17
C740	a_398_74##2	a_767_402##2	9.43519e-18
C741	VGND#8	a_398_74##10	4.48012e-17
C742	D#2	CLK#3	3.19023e-18
C743	a_612_74##11	a_767_402#	4.86341e-18
C744	VPWR#10	CLK#2	1.10171e-19
C745	a_398_74##2	a_767_402##3	2.85249e-17
C746	a_612_74##10	a_398_74##4	9.59871e-18
C747	a_398_74##13	SET_B#3	4.79236e-18
C748	a_398_74##14	a_225_74##6	1.78498e-19
C749	a_1321_392##11	VPWR#17	1.79965e-17
C750	VPWR	a_398_74##13	6.6361e-17
C751	Q	VGND#1	3.09984e-17
C752	VGND	a_225_74##4	2.30615e-18
C753	a_398_74##3	a_767_402##3	7.81974e-19
C754	a_612_74##9	a_767_402##3	1.13435e-17
C755	VPWR	a_612_74##9	1.91537e-18
C756	VGND#2	VGND#1	3.07147e-18
C757	a_27_74#	a_398_74##4	2.20901e-17
C758	a_398_74##3	a_398_74##2	5.69926e-19
C759	a_1484_62##7	VPWR#4	3.30268e-17
C760	VPWR	SET_B#10	2.51179e-18
C761	a_27_74#	a_612_74##10	3.8187e-17
C762	VGND#16	a_225_74##7	3.81401e-19
C763	VPWR	a_27_74##3	1.04546e-17
C764	a_1321_392##15	a_1484_62##2	8.07447e-19
C765	a_398_74##13	a_398_74##2	1.27475e-18
C766	SET_B#10	a_225_74##2	1.03909e-18
C767	VPWR	a_27_74##2	8.30973e-18
C768	a_398_74##6	a_1220_347#	4.26959e-18
C769	VPWR#16	VPWR#4	2.18658e-18
C770	a_398_74##14	a_398_74##4	6.41617e-18
C771	VPWR	a_225_74##11	5.79841e-18
C772	VGND#1	a_1940_74##2	3.68146e-19
C773	a_612_74##11	a_398_74#	3.09194e-17
C774	a_612_74##9	a_225_74##3	5.93168e-20
C775	VGND#4	VPWR#15	3.71578e-18
C776	VGND#3	a_1940_74##6	2.18583e-20
C777	VPWR	D#7	4.73378e-18
C778	a_767_402##4	a_225_74##3	1.68281e-17
C779	a_398_74##10	a_767_402#	3.67914e-19
C780	a_612_74##9	a_398_74##13	5.80634e-18
C781	a_27_74#	a_225_74##9	1.68804e-18
C782	VPWR#4	a_1321_392##14	1.83311e-17
C783	SET_B#7	a_225_74##2	3.07395e-19
C784	a_1484_62##2	a_1514_88#	2.21104e-18
C785	a_398_74##13	a_612_74##3	1.68128e-17
C786	CLK#2	a_225_74##5	3.24838e-17
C787	a_225_74##12	a_225_74##11	2.82952e-18
C788	a_612_74##9	a_398_74##2	1.04215e-16
C789	Q	VPWR#1	3.47904e-17
C790	SET_B#7	a_767_402##3	6.40804e-19
C791	a_225_74##9	a_398_74##14	2.48808e-17
C792	a_225_74##5	D#1	1.90557e-19
C793	VGND#17	a_767_402#	1.56e-20
C794	a_1321_392##15	a_398_74##8	8.1504e-17
C795	VGND	VGND#9	9.40003e-17
C796	a_1321_392##15	a_1321_392##12	1.62617e-18
C797	a_225_74##7	a_612_74##11	1.7515e-17
C798	VGND	VGND#7	1.00918e-16
C799	D#1	CLK#2	1.19634e-17
C800	VGND	VGND#6	9.55802e-17
C801	a_27_74#	CLK#1	3.06913e-19
C802	a_1940_74##6	VNB	7.86504e-17
C803	a_27_74##4	a_27_74##3	2.15335e-19
C804	a_1940_74##4	VNB	3.8306e-17
C805	VPWR#20	a_225_74##9	3.52232e-17
C806	a_1940_74##15	a_1940_74##2	4.97921e-20
C807	SET_B#10	a_612_74##6	3.43253e-18
C808	a_1940_74##2	VNB	3.00398e-17
C809	a_398_74##14	a_27_74#	8.08142e-17
C810	a_398_74##3	a_398_74##13	1.1844e-18
C811	a_1321_392##4	VNB	1.29581e-16
C812	a_398_74##10	a_398_74#	2.28536e-18
C813	a_1321_392##3	VNB	4.67336e-17
C814	a_398_74##8	a_1436_88#	9.17025e-18
C815	a_225_74##4	VNB	8.49295e-17
C816	a_225_74##3	VNB	1.81731e-16
C817	a_398_74##14	VPWR#10	3.61434e-17
C818	a_398_74##6	a_1436_88#	1.45726e-18
C819	VPWR#4	a_1321_392##12	3.90085e-17
C820	a_398_74##14	CLK#1	1.3499e-18
C821	a_225_74##7	a_27_74##5	2.16258e-17
C822	SET_B#7	a_612_74##6	1.69133e-18
C823	a_27_74##3	D#7	5.5404e-17
C824	a_398_74##13	a_767_402##4	2.6399e-17
C825	CLK	a_225_74##8	2.11268e-19
C826	VGND#17	a_398_74#	2.01679e-20
C827	a_398_74##2	SET_B#7	2.2815e-18
C828	VPWR#20	CLK#1	3.17814e-17
C829	a_612_74##9	a_398_74##3	8.81768e-17
C830	a_398_74##6	a_1321_392##15	1.15098e-16
C831	VGND	a_612_74##9	8.05601e-18
C832	a_398_74##6	a_1225_74#	1.5954e-17
C833	VGND	SET_B#7	3.01731e-18
C834	VPWR	a_1321_392##12	5.76098e-18
C835	a_225_74##3	a_225_74##6	6.58896e-19
C836	a_398_74##10	a_225_74##7	3.79028e-17
C837	VGND#2	a_1940_74##6	3.7587e-18
C838	a_1940_74##5	VPWR#13	2.37773e-18
C839	a_398_74##14	D#3	2.81075e-19
C840	VPWR	a_767_402##7	7.99371e-18
C841	VGND#4	a_1321_392##12	6.80946e-19
C842	CLK#1	a_225_74##13	1.51688e-17
C843	a_1940_74##9	a_1940_74#	4.81048e-17
C844	VGND	a_225_74##11	2.39688e-18
C845	VPWR	VPWR#19	4.82155e-18
C846	Q#1	VPWR#1	5.84992e-17
C847	a_27_74##6	a_225_74##9	1.09726e-19
C848	VPWR	a_612_74##10	1.09821e-17
C849	VGND#9	VNB	4.36773e-17
C850	VPWR	a_27_74#	1.19782e-17
C851	VGND#7	VNB	4.46072e-17
C852	VGND#2	VGND#12	1.50637e-17
C853	VGND#6	VNB	6.1181e-17
C854	VPWR	a_398_74##14	3.26298e-17
C855	VGND#15	a_398_74##6	4.07026e-17
C856	a_1940_74##5	Q#5	5.47398e-17
C857	a_1940_74##15	a_1321_392##4	4.72436e-19
C858	a_27_74##5	a_225_74##8	2.71516e-18
C859	VGND#5	VNB	8.46312e-17
C860	VGND#3	VNB	2.4842e-17
C861	VGND	D#4	4.53551e-18
C862	VGND#2	VNB	5.22166e-17
C863	Q#4	a_1940_74##6	8.86991e-18
C864	VPWR#20	D#3	3.83543e-18
C865	VPWR#10	VNB	4.24381e-17
C866	VPWR#20	a_398_74##14	3.84417e-17
C867	VPWR#8	VNB	2.8883e-17
C868	VPWR#21	CLK#1	5.97613e-18
C869	VPWR#7	VNB	5.31564e-17
C870	VPWR	a_27_74##6	1.61413e-17
C871	VPWR#6	VNB	4.67623e-17
C872	VGND#17	a_225_74##7	1.76313e-19
C873	VPWR#5	VNB	2.96984e-17
C874	VPWR#3	VNB	3.00179e-17
C875	VPWR#2	VNB	3.23623e-17
C876	Q#3	VNB	5.38154e-18
C877	a_1940_74##5	VPWR#14	1.48989e-17
C878	Q#2	VNB	8.5289e-20
C879	VGND#3	Q#4	8.48119e-18
C880	a_1940_74##15	VNB	8.22322e-18
C881	VGND#13	a_1321_392#	1.10713e-18
C882	VGND	a_1321_392##15	1.322e-18
C883	VGND#9	a_225_74##4	3.12505e-19
C884	a_1484_62##5	VNB	2.45653e-17
C885	a_1321_392##15	a_612_74##5	4.51987e-19
C886	VGND	VGND#15	1.58606e-17
C887	a_1321_392##11	VNB	9.86101e-18
C888	a_398_74##13	a_225_74##6	1.35512e-17
C889	VGND	a_767_402##5	1.16185e-17
C890	SET_B#13	VNB	3.60302e-18
C891	a_612_74##9	a_767_402##4	2.6836e-18
C892	SET_B#8	a_1321_392##12	2.60808e-17
C893	a_27_74##6	CLK#1	3.46922e-19
C894	a_225_74##8	a_398_74##10	1.56393e-17
C895	SET_B#12	VNB	3.95693e-18
C896	VGND	a_612_74##11	1.45984e-17
C897	a_398_74##13	VNB	3.49759e-17
C898	Q	a_1940_74#	1.05218e-17
C899	VGND	a_27_74##5	8.58656e-18
C900	VGND	a_398_74##10	4.24428e-17
C901	Q	a_1940_74##9	4.27816e-20
C902	a_612_74##9	VNB	1.08918e-17
C903	VPWR#13	VPWR#1	2.06271e-18
C904	Q	a_1940_74##11	2.78027e-20
C905	VGND	a_225_74##12	2.29971e-17
C906	VGND#5	VGND#13	8.48781e-19
C907	VGND	a_27_74##4	1.65747e-17
C908	SET_B#7	VNB	1.02456e-18
C909	a_1940_74##11	a_1940_74##9	4.70846e-17
C910	VPWR	a_767_402#	9.28902e-19
C911	Q	a_1321_392#	1.17202e-19
C912	VPWR#21	D#3	3.48712e-17
C913	VGND#4	VGND#6	1.52988e-17
C914	a_398_74##13	VPWR#8	4.93097e-17
C915	a_27_74##3	VNB	6.14646e-17
C916	a_27_74##5	CLK#3	6.35252e-20
C917	a_225_74##11	VNB	1.00636e-17
C918	a_612_74##5	VGND#15	4.57602e-17
C919	VPWR#17	SET_B#4	5.14683e-19
C920	SET_B#10	a_612_74##3	7.45317e-19
C921	D#7	VNB	4.12118e-18
C922	a_225_74##4	a_398_74##4	1.81335e-17
C923	VGND#2	a_1940_74##4	3.25298e-19
C924	D#6	VNB	5.24283e-19
C925	D#4	VNB	1.83719e-18
C926	VGND#17	a_225_74##8	4.39804e-17
C927	VGND#1	VNB	5.38926e-17
C928	Q#4	VNB	2.4906e-18
C929	VGND#4	VGND#5	1.87903e-16
C930	VGND#13	VNB	3.30467e-18
C931	SET_B#8	VPWR#18	2.6679e-18
C932	D#3	a_27_74##6	1.21686e-17
C933	a_1940_74##16	VNB	1.80788e-17
C934	VGND	a_767_402##7	1.26752e-18
C935	a_1940_74##15	a_1321_392##3	1.51738e-17
C936	a_1321_392##15	VNB	1.48496e-18
C937	VGND#2	Q#4	7.75157e-17
C938	D#7	a_225_74##11	3.81966e-17
C939	VGND#15	VNB	7.62838e-18
C940	a_1484_62##5	a_1940_74##15	4.24434e-18
C941	a_767_402##5	VNB	1.08659e-18
C942	a_398_74##10	CLK#3	4.94284e-19
C943	a_225_74##3	a_398_74##4	1.52097e-17
C944	VGND#16	VNB	6.39892e-18
C945	a_27_74##3	D#6	9.07449e-18
C946	a_612_74##11	VNB	2.64322e-18
C947	a_27_74##5	VNB	7.33871e-18
C948	VPWR#13	Q#1	6.25372e-17
C949	VGND#4	VGND#3	5.19028e-17
C950	a_398_74##10	VNB	9.91781e-18
C951	SET_B#8	a_767_402##7	3.34202e-18
C952	VGND#17	VNB	4.16079e-19
C953	VPWR	a_225_74##2	1.08137e-17
C954	VGND#5	a_1321_392##4	1.23843e-18
C955	a_225_74##12	VNB	1.77069e-17
C956	VGND#18	VNB	2.39998e-18
C957	VPWR	a_612_74##6	3.03212e-18
C958	a_27_74##4	VNB	5.31569e-17
C959	a_225_74##12	a_225_74##8	1.70856e-18
C960	VPWR#1	VNB	6.02471e-17
C961	a_27_74##2	a_398_74##3	6.67802e-17
C962	Q#1	VNB	5.15633e-18
C963	VPWR#13	VNB	2.30711e-19
C964	a_398_74##13	a_398_74##4	1.46924e-19
C965	a_612_74##9	a_225_74##6	1.97345e-19
C966	Q#5	VNB	2.6327e-18
C967	VPWR#14	VNB	1.09065e-17
C968	VPWR	a_767_402##4	3.19071e-18
C969	VPWR#4	Q	3.89495e-18
C970	a_1940_74##14	VNB	3.14049e-18
C971	VPWR#15	VNB	1.44331e-17
C972	a_1940_74##13	a_1940_74##11	4.63974e-17
C973	VGND#4	Q	5.10743e-18
C974	a_1484_62##7	VNB	2.11682e-17
C975	a_1484_62##5	a_1321_392##4	3.92666e-17
C976	VPWR#16	VNB	4.23588e-18
C977	a_1321_392##3	a_1940_74##7	6.03821e-18
C978	a_1321_392##14	VNB	6.00933e-18
C979	VGND#4	VGND#2	1.33223e-16
C980	VPWR#17	VNB	3.06405e-18
C981	VGND	SET_B#1	9.52863e-18
C982	VPWR	a_225_74##9	1.22554e-18
C983	VGND	a_612_74#	9.46917e-18
C984	a_1321_392##12	VNB	1.10998e-17
C985	VPWR	CLK#1	5.77768e-19
C986	VGND	a_767_402#	1.05829e-18
C987	VPWR#18	VNB	4.56769e-18
C988	VPWR	D#3	4.68285e-18
C989	CLK#3	VGND#17	1.48797e-17
C990	a_767_402##7	VNB	8.04271e-19
C991	VGND	a_225_74##7	5.57737e-19
C992	VPWR#19	VNB	3.40932e-18
C993	a_1940_74##5	Q	1.21717e-17
C994	VGND	a_225_74##8	2.9292e-18
C995	a_612_74##10	VNB	5.78071e-18
C996	VGND	CLK#3	1.39527e-18
C997	a_1321_392##5	a_1484_62##7	5.65634e-17
C998	a_398_74##13	VPWR#7	5.37886e-17
C999	a_27_74#	VNB	6.00857e-19
C1000	VGND	D#2	2.82843e-18
C1001	a_398_74##14	VNB	1.03213e-17
C1002	VPWR#20	VNB	7.8146e-20
C1003	VGND#5	a_1940_74##16	2.56473e-18
C1004	VPWR#21	VNB	4.44182e-18
C1005	VGND#18	a_225_74##8	1.46625e-19
C1006	a_27_74##6	VNB	2.25114e-17
C1007	SET_B#8	VPWR	2.24289e-17
C1008	a_1940_74##8	VNB	3.53063e-17
C1009	VPWR#21	VPWR#20	1.30133e-17
C1010	a_1940_74##10	VNB	2.43517e-17
C1011	VPWR	VPWR#9	6.67898e-17
C1012	a_27_74##6	a_398_74##14	1.05421e-21
C1013	SET_B#8	VGND#6	4.20955e-18
C1014	VPWR#4	VPWR#7	1.39008e-17
C1015	a_1940_74##12	VNB	2.63364e-17
C1016	CLK	a_225_74##5	4.03654e-17
C1017	a_1940_74##7	VNB	4.4677e-17
C1018	a_1321_392##7	VNB	3.35603e-17
C1019	a_1321_392##8	VNB	4.22432e-17
C1020	CLK	CLK#2	5.53501e-18
C1021	SET_B#4	VNB	2.98324e-17
C1022	a_1321_392##5	VPWR#16	3.43557e-17
C1023	a_1484_62##3	VNB	3.09505e-17
C1024	Q#5	Q#1	7.46308e-19
C1025	a_225_74#	VNB	5.5926e-17
C1026	a_398_74##5	VNB	3.03767e-17
C1027	a_612_74##4	VNB	2.85061e-17
C1028	SET_B#1	VNB	3.50153e-17
C1029	a_612_74#	VNB	2.71321e-17
C1030	a_767_402#	VNB	3.76542e-17
C1031	a_225_74##12	CLK#3	5.50364e-17
C1032	a_398_74#	VNB	3.07693e-17
C1033	a_225_74##7	VNB	4.62868e-17
C1034	VPWR	a_398_74##6	1.06574e-17
C1035	a_225_74##8	VNB	2.84934e-17
C1036	CLK#3	VNB	3.42047e-17
C1037	VPWR	a_612_74##5	2.29022e-18
C1038	VPWR#4	VPWR#6	8.94991e-17
C1039	D#2	VNB	2.86528e-17
C1040	a_1940_74#	VNB	3.78178e-17
C1041	a_1940_74##9	VNB	2.86992e-17
C1042	VPWR	a_612_74##2	3.60168e-18
C1043	a_1940_74##11	VNB	2.8733e-17
C1044	SET_B#10	a_398_74##13	2.78829e-18
C1045	a_1940_74##13	VNB	3.40367e-17
C1046	VPWR	a_767_402##2	1.01553e-19
C1047	VGND#13	VGND#2	2.0713e-18
C1048	a_1321_392#	VNB	4.38832e-17
C1049	a_225_74##5	a_27_74##2	8.48533e-17
C1050	a_1321_392##6	VNB	3.17332e-17
C1051	VPWR	a_767_402##3	3.94766e-18
C1052	a_1321_392#	a_1940_74##13	2.98676e-17
C1053	a_1321_392##9	VNB	5.2575e-17
C1054	SET_B#6	VNB	3.74509e-17
C1055	VPWR	a_398_74##2	1.69338e-19
C1056	a_1484_62#	VNB	3.72534e-17
C1057	a_225_74##9	a_225_74##4	3.06719e-17
C1058	a_398_74##7	VNB	2.16197e-17
C1059	VGND	SET_B#8	2.33663e-17
C1060	VPWR	a_398_74##3	6.1772e-18
C1061	VGND#17	D#2	4.96346e-19
C1062	a_225_74##2	VNB	1.50553e-16
C1063	a_612_74##6	VNB	2.92224e-17
C1064	VPWR	a_225_74##5	4.34351e-18
C1065	a_398_74##13	a_225_74##9	9.08378e-20
C1066	VGND	VGND#8	6.23661e-17
C1067	SET_B#3	VNB	2.53747e-17
C1068	a_612_74##3	VNB	3.58168e-17
C1069	VPWR	CLK#2	1.68102e-18
C1070	VPWR#4	VPWR#5	6.80876e-17
C1071	a_767_402##4	VNB	3.20847e-17
C1072	a_225_74##11	a_225_74##5	2.23267e-18
C1073	a_225_74##6	VNB	2.58623e-17
C1074	a_1321_392##4	a_1321_392##7	6.70539e-19
C1075	a_398_74##4	VNB	2.33141e-17
C1076	a_225_74##9	VNB	3.38249e-17
C1077	VGND#18	CLK#3	1.15952e-18
C1078	CLK#1	VNB	4.49267e-17
C1079	a_1940_74##6	a_1940_74##11	1.14316e-18
C1080	D#3	VNB	4.81443e-17
C1081	a_1484_62##5	a_1321_392##3	1.71677e-18
C1082	VGND	a_398_74##6	1.98559e-17
C1083	VGND	a_612_74##5	5.44337e-18
C1084	VPWR#4	VNB	3.12653e-16
C1085	VGND#4	VNB	2.94248e-16
C1086	VGND	a_612_74##2	1.11658e-17
C1087	SET_B#8	VNB	2.33282e-18
C1088	Q#5	VPWR#13	7.08108e-17
C1089	VPWR#9	VNB	2.8614e-17
C1090	VGND	a_767_402##2	6.30807e-18
C1091	a_225_74##9	a_225_74##3	1.17932e-17
C1092	VGND#8	VNB	3.61858e-17
C1093	VGND	a_767_402##3	4.11381e-18
C1094	a_1940_74##5	VNB	2.41941e-19
C1095	VGND	a_398_74##2	2.15444e-18
C1096	a_1321_392##5	VNB	6.6453e-18
C1097	VPWR#4	VPWR#3	6.1796e-17
C1098	SET_B#5	VNB	1.00856e-16
C1099	VGND	a_398_74##3	4.35824e-18
C1100	a_1484_62##2	VNB	7.36804e-17
C1101	a_612_74##2	a_767_402##5	3.48525e-17
C1102	VGND	a_225_74##5	5.05575e-18
C1103	a_398_74##8	VNB	5.69888e-17
C1104	VGND	CLK#2	3.67485e-18
C1105	a_398_74##6	VNB	3.89759e-17
C1106	a_225_74##12	D#2	1.27352e-18
C1107	a_612_74##5	VNB	3.86003e-17
C1108	VGND	D#1	8.72319e-19
C1109	a_27_74##5	a_225_74##4	3.00947e-17
C1110	SET_B#2	VNB	5.19288e-17
C1111	a_612_74##2	VNB	5.87574e-17
C1112	a_767_402##2	VNB	4.93739e-17
C1113	a_767_402##3	VNB	4.67818e-17
C1114	a_398_74##2	VNB	6.12626e-17
C1115	a_398_74##3	VNB	5.11917e-17
C1116	a_225_74##5	VNB	4.13592e-17
C1117	D#6	a_225_74##11	1.5213e-17
C1118	CLK#2	VNB	3.63179e-17
C1119	VGND#16	a_612_74##2	2.23432e-18
C1120	a_27_74##4	CLK#3	1.65806e-19
C1121	D#1	VNB	1.09261e-16
C1122	a_767_402#	a_767_402##4	1.34044e-18
C1123	VPWR#4	VPWR#2	6.1859e-17
C1124	a_27_74##3	CLK#2	3.0398e-19
C1125	VGND#2	a_1940_74##8	4.29549e-18
C1126	VPWR#17	SET_B#5	5.32798e-21
C1127	a_1321_392##6	a_1321_392#	3.59903e-17
C1128	a_767_402##2	VGND#15	1.83033e-18
C1129	a_1321_392##9	a_1940_74##13	2.97426e-19
C1130	VPWR	CLK	1.45159e-18
C1131	VGND#2	a_1940_74##2	1.0166e-20
C1132	a_27_74##2	CLK#2	1.40791e-19
C1133	VGND#18	D#2	2.83201e-17
C1134	a_398_74##14	VPWR#9	3.49948e-17
C1135	VGND	CLK	1.42571e-18
C1136	CLK	VNB	2.52362e-19
C1137	VPWR#14	VPWR#13	1.69967e-18
C1138	Q	VNB	6.09136e-17
C1139	VPWR	VNB	2.80472e-16
C1140	a_225_74##11	CLK#2	4.86738e-17
C1141	Q#4	a_1321_392##4	7.66463e-20
C1142	VGND	VNB	3.07303e-16
C1143	SET_B	a_398_74##6	1.0607e-18
C1144	SET_B	SET_B#12	1.29887e-17
C1145	SET_B	VPWR#5	8.29431e-19
C1146	SET_B	VPWR#17	2.35724e-18
C1147	VPWR#11	a_225_74##3	4.16995e-20
C1148	SET_B	a_1940_74##15	1.85032e-18
C1149	SET_B	a_398_74##8	4.13796e-17
C1150	VGND#10	VGND#17	8.83349e-19
C1151	a_27_74##6	VPWR#11	1.64089e-17
C1152	VPWR#11	VPWR#10	9.30138e-19
C1153	SET_B	VPWR#6	4.72187e-18
C1154	VGND#4	SET_B	2.6144e-17
C1155	SET_B	SET_B#4	1.59718e-18
C1156	VPWR#11	CLK#1	9.77519e-19
C1157	SET_B	VGND#5	9.71446e-18
C1158	SET_B	a_1484_62##2	3.56866e-17
C1159	VPWR#11	D#3	1.77781e-18
C1160	SET_B	SET_B#13	1.75146e-17
C1161	SET_B	VPWR#4	2.88071e-17
C1162	SET_B	VNB	1.01253e-17
C1163	SET_B	SET_B#5	1.66443e-18
C1164	VGND#10	VNB	5.2326e-17
C1165	VGND#10	D#2	8.42255e-18
C1166	SET_B	a_1321_392##5	7.91606e-18
C1167	SET_B	a_1321_392##11	1.30217e-17
C1168	VGND	VGND#10	9.72934e-17
C1169	VGND#10	a_27_74##4	1.75155e-17
C1170	VPWR	VPWR#11	1.0268e-16
C1171	VGND#10	CLK#3	1.12127e-18
C1172	SET_B	a_1940_74##14	9.75377e-19
C1173	SET_B	a_1321_392##12	2.82927e-17
C1174	VGND#10	VGND#9	9.87704e-19
C1175	VPWR#11	VNB	5.1096e-17
C1176	VGND#10	a_225_74##8	2.15575e-19
C1177	SET_B	a_1321_392##4	2.30704e-18
C1178	a_27_74##3	VPWR#11	3.63689e-18
C1179	VPWR#11	VPWR#20	1.06231e-19
C1180	VGND#10	a_225_74##12	1.29299e-17
C1181	SET_B	a_225_74##2	3.18512e-18
C1182	SET_B	a_1484_62##5	5.29791e-18
*
*
.ENDS sky130_fd_sc_hs__dfstp_4
*
