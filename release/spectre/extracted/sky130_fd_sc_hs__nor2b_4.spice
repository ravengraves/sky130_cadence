* Extracted by Quantus, converted by sky130cad/quantus.py
*
*
*
*                       LINUX           Wed Nov 18 08:49:52 2026
*
*
*
*  PROGRAM  advgen
*
*  Name           : advgen - Quantus - (64-bit)
*  Version        : 25.1.0-p047
*  Build Date     : Thu Dec 11 23:20:30 PST 2025
*
*  HSPICE LIBRARY
*
*  OPERATING_TEMPERATURE 150
*  QRC_TECH_DIR <path>/tech
*
*
*

*
.SUBCKT sky130_fd_sc_hs__nor2b_4 VPB VNB VGND VPWR Y A B_N
*
*
*  caps2d version: 10
*
*
*       TRANSISTOR CARDS
*
*
XM2 Y#2 a_353_323##10 VGND#8 VNB sky130_fd_pr__nfet_01v8_lvt l=0.15 w=0.74 ad=0.2072 as=0.3223 pd=2.04 ps=2.57
XM14 VGND#7 a_353_323##8 Y#2 VNB sky130_fd_pr__nfet_01v8_lvt l=0.15 w=0.74 ad=0.8194 as=0.2072 pd=3.68 ps=2.04
XM8 Y#1 A#7 VGND#7 VNB sky130_fd_pr__nfet_01v8_lvt l=0.15 w=0.74 ad=0.2072 as=0.8194 pd=2.04 ps=3.68
XM5 VGND#4 A#5 Y#1 VNB sky130_fd_pr__nfet_01v8_lvt l=0.15 w=0.74 ad=0.2072 as=0.2072 pd=2.04 ps=2.04
XM7 VGND#4 B_N#5 a_353_323##11 VNB sky130_fd_pr__nfet_01v8_lvt l=0.15 w=0.74 ad=0.2072 as=0.518 pd=2.04 ps=2.88
XM0 VPWR#5 A#3 a_116_368##5 VPB sky130_fd_pr__pfet_01v8 l=0.15 w=1.12 ad=0.3304 as=0.336 pd=2.83 ps=2.84
XM3 VPWR#7 A#4 a_116_368##5 VPB sky130_fd_pr__pfet_01v8 l=0.15 w=1.12 ad=0.336 as=0.336 pd=2.84 ps=2.84
XM10 a_116_368##3 A#1 VPWR#7 VPB sky130_fd_pr__pfet_01v8 l=0.15 w=1.12 ad=0.336 as=0.336 pd=2.84 ps=2.84
XM4 Y#4 a_353_323##6 a_116_368##3 VPB sky130_fd_pr__pfet_01v8 l=0.15 w=1.12 ad=0.336 as=0.336 pd=2.84 ps=2.84
XM6 Y#4 a_353_323##9 a_116_368##6 VPB sky130_fd_pr__pfet_01v8 l=0.15 w=1.12 ad=0.336 as=0.336 pd=2.84 ps=2.84
XM12 a_116_368##6 a_353_323##7 Y#6 VPB sky130_fd_pr__pfet_01v8 l=0.15 w=1.12 ad=0.336 as=0.336 pd=2.84 ps=2.84
XM13 a_116_368# a_353_323# Y#6 VPB sky130_fd_pr__pfet_01v8 l=0.15 w=1.12 ad=0.392 as=0.336 pd=2.94 ps=2.84
XM11 a_116_368# A#8 VPWR#6 VPB sky130_fd_pr__pfet_01v8 l=0.15 w=1.12 ad=0.392 as=0.462 pd=2.94 ps=3.11
XM9 VPWR#6 B_N#4 a_353_323##14 VPB sky130_fd_pr__pfet_01v8 l=0.15 w=0.84 ad=0.462 as=0.252 pd=3.11 ps=2.28
XM1 a_353_323##14 B_N#1 VPWR#1 VPB sky130_fd_pr__pfet_01v8 l=0.15 w=0.84 ad=0.252 as=0.2478 pd=2.28 ps=2.27
*
*
*       RESISTOR AND CAP/DIODE CARDS
*
Rg1	A#1	A#2	621.956177
Rg2	A#2	A#3	685.609802
Rg3	A#2	A#4	577.902283
Rg4	a_353_323#	a_353_323##2	470.369812
Rg5	a_353_323##2	a_353_323##3	28.105186
Rg6	a_353_323##3	a_353_323##4	14.729391
Rg7	a_353_323##4	a_353_323##5	32.138695
Rg8	a_353_323##5	a_353_323##6	451.298920
Rg9	a_353_323##2	a_353_323##7	399.121185
Rg10	a_353_323##3	a_353_323##8	308.851013
Rg11	a_353_323##4	a_353_323##9	394.930298
Rg12	a_353_323##5	a_353_323##10	302.524048
Rg13	A#5	A#6	329.853149
Rg14	A#6	A#7	372.561188
Rg15	A#6	A#8	484.151703
Rg16	B_N#1	B_N#2	353.970673
Rg17	B_N#2	B_N#3	63.119663
Rg18	B_N#3	B_N#4	444.028259
Rg19	B_N#3	B_N#5	495.155243
Rf1	a_116_368#	a_116_368##2	87.271957
Rf2	a_116_368##2	a_116_368##4	90.922676
Rf3	a_116_368##4	a_116_368##5	95.928307
Rf4	a_116_368##2	a_116_368##6	17.362514
Rf5	a_116_368##3	a_116_368##4	5.000000
Rf6	Y#1	Y#3	116.340584
Rf7	Y#3	Y	146.603882
Rf8	Y	Y#5	176.391708
Rf9	Y#5	Y#6	85.435371
Rf10	Y#2	Y#3	15.000000
Rf11	Y#4	Y#5	7.500000
Rf12	A#6	A#10	315.654022
Rf13	A#10	A	0.514679
Rf14	B_N#6	B_N	1.496045
Rf15	B_N#2	B_N#8	161.728851
Rf16	B_N#8	B_N	1.496045
Rf17	B_N#6	B_N#8	11.815311
Rf18	a_353_323##11	a_353_323##12	74.741730
Rf19	a_353_323##12	a_353_323##2	170.261292
Rf20	a_353_323##12	a_353_323##14	36.928257
Rf21	VPWR#1	VPWR#2	122.503334
Rf22	VPWR#2	VPWR#3	97.863129
Rf23	VPWR#3	VPWR#4	106.751762
Rf24	VPWR#4	VPWR#5	116.296631
Rf25	VPWR#2	VPWR#6	34.939823
Rf26	VPWR#4	VPWR#7	54.238976
Rf28	VGND#2	VGND#3	113.188034
Rf29	VGND#2	VGND#4	45.213318
Rf30	VGND#3	VGND#5	67.547173
Rf32	VGND#3	VGND#7	13.063021
Rf33	VGND#5	VGND#8	24.862514
Rf35	A#2	A#10	80.116402
Re1	VPWR#3	VPWR	0.892922
Re2	VGND	VGND#3	0.892955
*
*       CAPACITOR CARDS
*
*
C1	A#8	B_N#3	1.13945e-17
C2	a_116_368##2	a_353_323##5	4.32293e-19
C3	a_353_323##12	VPWR#2	4.75379e-19
C4	a_353_323##11	B_N#3	1.05137e-18
C5	VGND#4	B_N#3	1.48838e-18
C6	a_353_323##12	B_N#6	9.73518e-18
C7	Y#1	a_353_323##5	2.60239e-19
C8	a_116_368##2	VPWR#4	3.62037e-18
C9	A#1	a_353_323##5	9.91499e-18
C10	Y#2	a_353_323##5	5.37399e-18
C11	a_353_323##11	a_353_323##12	2.42252e-18
C12	VGND#4	a_353_323##12	8.67754e-18
C13	VGND#8	a_353_323##5	3.66098e-19
C14	a_353_323##11	B_N#6	6.00305e-17
C15	VPWR#2	VPWR#1	7.58824e-19
C16	a_353_323##14	VPWR#2	1.1295e-17
C17	a_353_323##12	VPWR#1	6.07365e-18
C18	B_N#3	a_353_323##14	7.84615e-19
C19	a_353_323##12	a_353_323##14	5.11107e-20
C20	a_116_368#	VPWR#2	2.87369e-17
C21	a_353_323##12	VPWR#6	4.21899e-17
C22	VPWR#3	a_353_323##5	9.76345e-20
C23	VGND#4	a_353_323##11	5.06933e-17
C24	VGND#3	B_N#3	1.31985e-20
C25	VGND#3	a_353_323##5	2.31019e-18
C26	Y#1	VGND#4	2.98108e-17
C27	a_116_368##3	VPWR#4	3.14938e-17
C28	Y#1	VGND#7	4.21606e-18
C29	a_116_368##5	VPWR#4	1.69965e-17
C30	Y#2	Y#1	9.87123e-19
C31	Y#2	VGND#7	2.84716e-18
C32	VPWR#5	VPWR#4	6.99578e-19
C33	Y#6	a_353_323##5	3.14192e-18
C34	A#6	B_N#3	2.22296e-17
C35	Y#2	VGND#8	4.73088e-17
C36	a_353_323##5	A#6	8.35958e-18
C37	a_116_368##2	Y#6	2.31342e-17
C38	a_116_368##2	a_116_368##6	7.70654e-20
C39	a_116_368##6	a_353_323##5	8.81454e-19
C40	a_116_368##2	Y#4	2.63356e-17
C41	a_353_323##2	B_N#3	3.74601e-19
C42	a_353_323##2	a_353_323##5	4.65647e-17
C43	a_353_323##14	VPWR#1	5.90192e-17
C44	B_N#6	B_N#5	2.2298e-18
C45	VPWR#6	VPWR#1	3.95508e-18
C46	Y#4	a_353_323##5	3.03485e-17
C47	VPWR#6	a_353_323##14	5.8849e-17
C48	A#2	a_353_323##5	3.96643e-17
C49	a_116_368#	VPWR#6	8.98399e-17
C50	VPWR#2	B_N#1	3.02128e-18
C51	a_353_323##11	B_N#5	4.95252e-17
C52	Y#6	a_116_368#	6.21127e-17
C53	a_353_323##12	B_N#1	4.29437e-18
C54	VPWR#2	B_N#4	4.8241e-18
C55	B_N#5	VGND#4	1.59657e-17
C56	a_353_323##11	A#5	4.21493e-18
C57	a_116_368##6	a_116_368#	3.47337e-18
C58	Y#4	VPWR#6	8.58708e-21
C59	VGND#4	A#5	3.39029e-17
C60	a_353_323##12	B_N#4	2.42216e-18
C61	Y#6	a_116_368##6	3.97488e-17
C62	VPWR#2	A#8	4.29139e-18
C63	a_353_323##11	A#7	1.47233e-18
C64	A#5	Y#1	1.61919e-17
C65	VPWR#4	a_353_323#	3.56997e-20
C66	VGND#4	A#7	2.31684e-18
C67	Y#4	Y#6	2.23467e-18
C68	a_353_323##12	A#8	1.75627e-17
C69	a_353_323##11	a_353_323##8	5.6295e-19
C70	VPWR#2	a_353_323#	1.25817e-18
C71	Y#1	A#7	4.50747e-17
C72	VPWR#2	B_N#3	5.40346e-20
C73	Y#4	a_116_368##6	4.36485e-17
C74	VGND#4	a_353_323##8	1.35947e-19
C75	VPWR#4	a_353_323##7	6.40414e-20
C76	A#7	VGND#7	2.14931e-17
C77	a_353_323##12	a_353_323#	1.0654e-18
C78	a_116_368##3	a_116_368##6	3.24716e-18
C79	Y#1	a_353_323##8	9.69724e-19
C80	Y#2	A#7	1.07985e-18
C81	VGND#4	a_353_323##10	2.15607e-20
C82	a_353_323##8	VGND#7	2.26561e-17
C83	Y#4	a_116_368##3	1.16898e-16
C84	VPWR#4	a_353_323##9	1.86473e-19
C85	VGND#8	A#7	3.51872e-19
C86	Y#1	a_353_323##10	3.00365e-19
C87	a_353_323##12	a_353_323##7	7.5455e-20
C88	Y#2	a_353_323##8	4.25045e-17
C89	VGND#8	a_353_323##8	3.56881e-18
C90	Y#2	a_353_323##10	4.88655e-17
C91	VPWR#4	a_353_323##6	3.47902e-18
C92	a_116_368##3	VPWR#7	6.66157e-17
C93	Y#4	a_116_368##5	1.4618e-18
C94	a_353_323##12	a_353_323##9	1.03009e-19
C95	a_353_323##10	VGND#8	1.7172e-17
C96	a_116_368##5	a_116_368##3	2.94218e-18
C97	VPWR#5	Y#4	1.47884e-18
C98	VPWR#4	A#1	4.89413e-18
C99	a_116_368##5	VPWR#7	6.95926e-17
C100	a_116_368##2	a_353_323#	4.75555e-18
C101	VPWR#5	VPWR#7	1.94092e-18
C102	VPWR#4	A#4	5.27778e-18
C103	VPWR#1	B_N#1	2.98641e-17
C104	VPWR#5	a_116_368##5	8.08587e-17
C105	a_353_323##12	B_N#3	3.35187e-17
C106	a_116_368##2	a_353_323##7	1.65292e-17
C107	a_353_323##14	B_N#1	4.10754e-17
C108	Y#1	a_353_323#	1.50108e-18
C109	VPWR#4	A#3	2.3655e-18
C110	VPWR#1	B_N#4	1.37686e-18
C111	VPWR#6	B_N#1	1.4555e-18
C112	a_116_368##2	a_353_323##9	1.6553e-17
C113	a_353_323##14	B_N#4	3.98386e-17
C114	VPWR#1	A#8	1.08215e-18
C115	B_N#4	VPWR#6	2.5181e-17
C116	a_116_368##2	a_353_323##6	6.79149e-18
C117	a_353_323##14	A#8	1.10016e-18
C118	a_116_368#	B_N#4	1.72411e-19
C119	A#5	B_N#5	3.92571e-17
C120	A#8	VPWR#6	3.62382e-17
C121	a_116_368#	A#8	6.5182e-17
C122	VPWR#3	VPWR#4	5.42274e-17
C123	VPWR#6	a_353_323#	4.62441e-19
C124	VPWR#3	VPWR#2	5.88416e-17
C125	Y#6	A#8	1.04404e-18
C126	A#7	A#5	3.95728e-17
C127	Y#4	B_N#4	8.39433e-20
C128	a_116_368#	a_353_323#	3.30546e-17
C129	a_116_368##6	A#8	2.6255e-19
C130	VPWR#6	a_353_323##7	1.91368e-19
C131	Y#6	a_353_323#	4.88869e-17
C132	Y#4	A#8	1.06585e-19
C133	a_116_368#	a_353_323##7	5.6276e-19
C134	a_116_368##6	a_353_323#	1.34706e-18
C135	a_353_323##8	A#7	2.31634e-18
C136	VPWR#6	a_353_323##9	6.85395e-20
C137	Y#6	a_353_323##7	4.06524e-17
C138	Y#4	a_353_323#	6.02647e-19
C139	a_116_368##6	a_353_323##7	3.93223e-17
C140	VPWR#6	a_353_323##6	3.85648e-20
C141	VPWR#2	B_N#2	2.05969e-20
C142	Y#6	a_353_323##9	4.09642e-19
C143	Y#4	a_353_323##7	1.75983e-18
C144	a_353_323##10	a_353_323##8	3.89631e-17
C145	Y	a_353_323##5	6.33153e-19
C146	a_116_368##6	a_353_323##9	3.58684e-17
C147	a_353_323##12	B_N#2	1.22265e-17
C148	Y#6	a_353_323##6	1.83236e-19
C149	Y#4	a_353_323##9	3.76472e-17
C150	a_116_368##2	VPWR#3	8.52543e-17
C151	VPWR#2	A#6	4.21328e-20
C152	a_116_368##6	a_353_323##6	1.3574e-18
C153	a_116_368##3	a_353_323##9	5.00011e-19
C154	Y#4	a_353_323##6	4.64362e-17
C155	A#6	a_353_323##12	4.31241e-17
C156	a_116_368##6	A#1	2.63869e-19
C157	a_116_368##3	a_353_323##6	2.6881e-17
C158	a_353_323##5	A#7	5.74045e-20
C159	a_353_323##2	VPWR#2	1.32632e-19
C160	Y#4	A#1	1.74734e-17
C161	VGND#3	VGND#4	5.45442e-18
C162	a_116_368##3	A#1	6.5521e-17
C163	a_353_323##2	a_353_323##12	2.02269e-18
C164	B_N#6	B_N#3	1.40235e-18
C165	VGND#3	Y#1	4.54642e-17
C166	Y#4	A#4	2.97311e-19
C167	A#1	VPWR#7	2.41145e-17
C168	VPWR	a_353_323##5	8.82629e-21
C169	VPWR#5	a_353_323##6	1.81997e-19
C170	VPWR#4	A#2	4.45822e-20
C171	VGND#3	VGND#7	1.9897e-17
C172	a_353_323##11	B_N#2	5.16502e-18
C173	VPWR#3	VPWR#1	2.53853e-17
C174	a_116_368##3	A#4	1.91628e-18
C175	a_116_368##5	A#1	1.82429e-18
C176	B_N#4	B_N#1	3.58709e-17
C177	VGND#3	Y#2	4.96118e-17
C178	Y#4	A#3	3.16493e-19
C179	A#4	VPWR#7	2.8439e-17
C180	VGND#8	VGND#3	7.4301e-18
C181	VPWR#5	A#1	5.6286e-19
C182	a_116_368##5	A#4	7.56929e-17
C183	A#6	a_353_323##11	1.97751e-17
C184	a_116_368#	VPWR#3	9.15148e-18
C185	VPWR#7	A#3	6.54953e-19
C186	A#8	B_N#4	2.50622e-17
C187	VPWR#5	A#4	2.64156e-18
C188	A#6	Y#1	7.90632e-17
C189	a_116_368##5	A#3	5.62675e-17
C190	VPWR#1	B_N#2	1.23185e-17
C191	A#6	VGND#7	4.17138e-18
C192	A#3	VPWR#5	3.41774e-17
C193	B_N#2	a_353_323##14	1.44852e-19
C194	Y#2	A#6	1.86532e-17
C195	a_353_323#	A#8	3.56051e-17
C196	VPWR#6	A#6	1.62567e-18
C197	a_353_323##7	a_353_323#	4.51182e-17
C198	VPWR#3	VPWR#5	2.60272e-17
C199	a_116_368#	A#6	6.89112e-19
C200	A#2	Y#2	1.32229e-16
C201	A#2	VGND#8	9.37796e-19
C202	a_353_323##9	a_353_323##7	4.79701e-17
C203	a_353_323##2	a_116_368#	3.59305e-17
C204	a_353_323##2	Y#6	4.16124e-17
C205	VGND#3	A#5	1.75911e-18
C206	VGND#3	A#7	1.47644e-17
C207	Y#4	a_353_323##2	3.41914e-17
C208	a_353_323##6	a_353_323##9	4.4849e-17
C209	VGND#3	a_353_323##8	1.53852e-17
C210	a_353_323##12	B_N	3.64905e-17
C211	VGND#3	a_353_323##10	3.22176e-18
C212	A#6	B_N#5	1.07002e-17
C213	A#2	Y#4	5.91451e-17
C214	B_N#3	VNB	3.40672e-17
C215	a_353_323##5	VNB	9.97766e-17
C216	A#6	A#5	1.08112e-17
C217	A#1	a_353_323##6	4.7903e-17
C218	a_116_368##3	A#2	1.17524e-19
C219	A#6	A#7	1.13174e-17
C220	VPWR#7	A#2	5.37517e-19
C221	a_116_368##5	A#2	1.0857e-18
C222	VPWR#3	a_353_323#	3.21381e-18
C223	A#4	A#1	5.4387e-17
C224	VPWR#3	a_353_323##7	4.42502e-18
C225	B_N#4	B_N#2	1.4152e-18
C226	VGND#3	a_353_323#	1.47257e-18
C227	VPWR#3	a_353_323##9	4.43427e-18
C228	Y	VPWR#4	1.8958e-20
C229	A#3	A#4	5.25865e-17
C230	VPWR#3	a_353_323##6	1.40255e-18
C231	A#2	a_353_323##8	1.06024e-17
C232	B_N	VPWR#1	3.2331e-17
C233	A#2	a_353_323##10	1.63864e-17
C234	a_353_323#	A#6	4.41269e-17
C235	a_353_323##2	A#8	9.14747e-18
C236	a_353_323##2	a_353_323#	2.125e-17
C237	VPWR	VPWR#4	4.06545e-17
C238	VPWR	VPWR#2	3.43573e-17
C239	a_353_323##2	a_353_323##7	1.44813e-18
C240	VPWR	a_353_323##12	2.72358e-18
C241	a_353_323##2	a_353_323##9	3.29021e-19
C242	a_353_323##2	a_353_323##6	2.06789e-19
C243	VPWR	a_116_368##2	3.59332e-17
C244	A#2	A#1	4.17495e-19
C245	a_353_323##2	A#3	5.88717e-21
C246	VGND	a_353_323##12	2.94408e-18
C247	VGND#3	B_N#2	1.60091e-19
C248	VGND	B_N#6	3.95056e-18
C249	A#3	A#2	6.33558e-18
C250	VPWR	VPWR#1	3.65947e-17
C251	VGND#3	A#6	6.68092e-20
C252	VPWR	a_353_323##14	1.48742e-17
C253	Y	a_116_368##5	5.29825e-17
C254	VPWR	VPWR#6	2.28565e-17
C255	VPWR	a_116_368#	1.92705e-17
C256	Y	VPWR#5	3.69386e-17
C257	VPWR	Y#6	7.57725e-18
C258	VGND	a_353_323##11	3.20507e-17
C259	VGND	Y#1	1.52427e-17
C260	VPWR	Y#4	1.08155e-17
C261	VPWR#4	VNB	4.07179e-17
C262	VPWR	a_116_368##3	1.67898e-17
C263	VPWR#2	VNB	4.49728e-17
C264	VGND	Y#2	2.67813e-17
C265	VGND	VGND#8	2.23332e-17
C266	a_353_323##12	VNB	6.81099e-18
C267	A#6	a_353_323##2	7.28324e-17
C268	VPWR	a_116_368##5	1.72099e-17
C269	Y	a_353_323##10	8.12266e-19
C270	VPWR	VPWR#5	3.1461e-17
C271	B_N#6	VNB	2.35443e-17
C272	A#2	A#6	4.76938e-19
C273	a_116_368##2	VNB	6.47341e-18
C274	VGND	Y#4	4.4849e-18
C275	A#2	a_353_323##2	4.98327e-17
C276	a_353_323##11	VNB	4.77374e-17
C277	VGND#4	VNB	1.86385e-19
C278	Y#2	VNB	9.91027e-18
C279	VGND	VPWR#5	1.91498e-18
C280	VPWR	B_N#1	7.92465e-18
C281	VGND#8	VNB	1.61023e-17
C282	VGND	B_N#5	4.12663e-18
C283	VPWR#1	VNB	7.64754e-17
C284	VPWR	B_N#4	8.12102e-18
C285	a_353_323##14	VNB	2.56373e-18
C286	VGND	A#5	1.09334e-18
C287	VPWR	A#8	1.81237e-18
C288	VPWR#6	VNB	5.25168e-18
C289	VGND	A#7	1.14109e-18
C290	a_116_368#	VNB	2.90322e-18
C291	VPWR	a_353_323#	1.51229e-18
C292	VGND	a_353_323##10	2.42443e-19
C293	VPWR	a_353_323##7	1.5484e-18
C294	Y	A#4	1.18997e-17
C295	B_N	B_N#2	2.99324e-17
C296	Y#4	VNB	2.02675e-18
C297	VPWR	a_353_323##9	1.55388e-18
C298	a_116_368##3	VNB	2.11165e-18
C299	Y	A#3	2.34607e-17
C300	VPWR#7	VNB	2.92383e-18
C301	VPWR	a_353_323##6	1.52035e-18
C302	a_116_368##5	VNB	2.20287e-18
C303	VPWR#5	VNB	7.87856e-17
C304	VPWR	A#1	1.2288e-18
C305	B_N#5	VNB	3.42056e-17
C306	VPWR	A#4	8.46339e-19
C307	A#5	VNB	2.46567e-17
C308	A#7	VNB	2.46211e-17
C309	VPWR	A#3	4.22524e-18
C310	a_353_323##8	VNB	2.46572e-17
C311	a_353_323##10	VNB	3.48892e-17
C312	VPWR	VPWR#3	2.54727e-17
C313	B_N#1	VNB	3.27802e-17
C314	B_N#4	VNB	3.37901e-17
C315	A#8	VNB	3.98995e-17
C316	a_353_323#	VNB	6.57853e-17
C317	VPWR	B_N#2	3.31601e-20
C318	a_353_323##7	VNB	3.09316e-17
C319	Y	A#2	1.26099e-16
C320	VPWR	A#6	2.15067e-18
C321	a_353_323##9	VNB	3.14673e-17
C322	a_353_323##6	VNB	3.20061e-17
C323	VPWR	a_353_323##2	8.5284e-18
C324	VGND	VGND#3	6.59773e-17
C325	A#1	VNB	3.95132e-17
C326	A#4	VNB	3.96706e-17
C327	A#3	VNB	5.63502e-17
C328	VGND	A#6	1.06222e-17
C329	VGND	a_353_323##2	6.16679e-18
C330	VPWR#3	VNB	2.59568e-16
C331	VGND#3	VNB	2.64206e-16
C332	VGND	A#2	1.37331e-17
C333	B_N#2	VNB	6.15943e-17
C334	A#6	VNB	5.24854e-17
C335	VPWR	B_N	3.49145e-18
C336	a_353_323##2	VNB	4.14871e-18
C337	A#2	VNB	1.36862e-16
C338	VPWR	Y	5.13936e-18
C339	B_N	VNB	1.14847e-17
C340	VGND	Y	2.8569e-17
C341	Y	VNB	7.83237e-17
C342	VPWR	VNB	6.80904e-17
C343	VGND	VNB	7.55496e-17
C344	VGND#5	VNB	7.87091e-17
C345	VGND#5	Y	2.10961e-17
C346	VGND#2	B_N#3	1.57115e-20
C347	VGND#5	a_353_323##5	7.11595e-20
C348	VGND#5	A#2	5.57858e-18
C349	VGND#5	Y#2	1.15e-17
C350	VGND#2	Y#1	4.08887e-18
C351	VGND	VGND#2	5.6631e-17
C352	VGND#2	A#5	1.02069e-17
C353	VGND#2	A#6	1.57993e-18
C354	VGND#5	a_353_323##10	3.39723e-18
C355	VGND	VGND#5	5.4292e-17
C356	VGND#3	VGND#5	9.31499e-17
C357	VGND#2	B_N#5	6.95831e-18
C358	VGND#2	a_353_323##8	1.13746e-19
C359	VGND#2	B_N#2	2.19949e-19
C360	VGND#2	a_353_323##11	4.21031e-17
C361	VGND#2	VNB	6.22048e-17
C362	VGND#2	A#7	1.53043e-18
C363	VGND#2	a_353_323##12	1.00436e-19
C364	VGND#3	VGND#2	7.07147e-17
*
*
.ENDS sky130_fd_sc_hs__nor2b_4
*
