* Extracted by Quantus, converted by sky130cad/quantus.py
*
*
*
*                       LINUX           Wed Nov 18 08:37:52 2026
*
*
*
*  PROGRAM  advgen
*
*  Name           : advgen - Quantus - (64-bit)
*  Version        : 25.1.0-p047
*  Build Date     : Thu Dec 11 23:20:30 PST 2025
*
*  HSPICE LIBRARY
*
*  OPERATING_TEMPERATURE 150
*  QRC_TECH_DIR <path>/tech
*
*
*

*
.SUBCKT sky130_fd_sc_hs__einvp_4 VPB VNB VGND VPWR Z TE A
*
*
*  caps2d version: 10
*
*
*       TRANSISTOR CARDS
*
*
XM6 Z#4 A#10 a_27_74##6 VNB sky130_fd_pr__nfet_01v8_lvt l=0.15 w=0.74 ad=0.259 as=0.2109 pd=2.18 ps=2.05
XM13 Z#4 A#8 a_27_74##8 VNB sky130_fd_pr__nfet_01v8_lvt l=0.15 w=0.74 ad=0.259 as=0.2775 pd=2.18 ps=2.23
XM15 a_27_74##8 A#6 Z#7 VNB sky130_fd_pr__nfet_01v8_lvt l=0.15 w=0.74 ad=0.2775 as=0.2405 pd=2.23 ps=2.13
XM16 a_27_74##3 A#1 Z#7 VNB sky130_fd_pr__nfet_01v8_lvt l=0.15 w=0.74 ad=0.259 as=0.2405 pd=2.18 ps=2.13
XM2 a_27_74##3 TE#7 VGND#6 VNB sky130_fd_pr__nfet_01v8_lvt l=0.15 w=0.74 ad=0.259 as=0.3108 pd=2.18 ps=2.32
XM8 VGND#6 TE#11 a_27_74##7 VNB sky130_fd_pr__nfet_01v8_lvt l=0.15 w=0.74 ad=0.3108 as=0.2072 pd=2.32 ps=2.04
XM11 a_27_74##7 TE#10 VGND#4 VNB sky130_fd_pr__nfet_01v8_lvt l=0.15 w=0.74 ad=0.2072 as=0.3108 pd=2.04 ps=2.32
XM17 VGND#4 TE#9 a_27_74# VNB sky130_fd_pr__nfet_01v8_lvt l=0.15 w=0.74 ad=0.3108 as=0.2109 pd=2.32 ps=2.05
XM12 a_473_323##11 TE#8 VGND#1 VNB sky130_fd_pr__nfet_01v8_lvt l=0.15 w=0.74 ad=0.2109 as=0.2627 pd=2.05 ps=2.19
XM1 Z#1 A#12 a_27_368##6 VPB sky130_fd_pr__pfet_01v8 l=0.15 w=1.12 ad=0.3864 as=0.336 pd=2.93 ps=2.84
XM5 Z#1 A#11 a_27_368##8 VPB sky130_fd_pr__pfet_01v8 l=0.15 w=1.12 ad=0.3864 as=0.392 pd=2.93 ps=2.94
XM10 a_27_368##8 A#7 Z#5 VPB sky130_fd_pr__pfet_01v8 l=0.15 w=1.12 ad=0.392 as=0.336 pd=2.94 ps=2.84
XM14 a_27_368##3 A#5 Z#5 VPB sky130_fd_pr__pfet_01v8 l=0.15 w=1.12 ad=0.392 as=0.336 pd=2.94 ps=2.84
XM9 VPWR#5 a_473_323##5 a_27_368##3 VPB sky130_fd_pr__pfet_01v8 l=0.15 w=1.12 ad=0.392 as=0.392 pd=2.94 ps=2.94
XM0 a_27_368##7 a_473_323##8 VPWR#5 VPB sky130_fd_pr__pfet_01v8 l=0.15 w=1.12 ad=0.336 as=0.392 pd=2.84 ps=2.94
XM3 VPWR#4 a_473_323##7 a_27_368##7 VPB sky130_fd_pr__pfet_01v8 l=0.15 w=1.12 ad=0.3472 as=0.336 pd=2.86 ps=2.84
XM4 a_27_368# a_473_323##6 VPWR#4 VPB sky130_fd_pr__pfet_01v8 l=0.15 w=1.12 ad=0.3304 as=0.3472 pd=2.83 ps=2.86
XM7 a_473_323##9 TE#1 VPWR#1 VPB sky130_fd_pr__pfet_01v8 l=0.15 w=1.12 ad=0.3304 as=0.3304 pd=2.83 ps=2.83
*
*
*       RESISTOR AND CAP/DIODE CARDS
*
Rg1	A#1	A#2	371.176086
Rg2	A#2	A#3	206.023483
Rg3	A#3	A#4	106.624664
Rg4	A#2	A#5	504.124847
Rg5	A#3	A#6	394.561310
Rg6	A#3	A#7	446.660797
Rg7	A#4	A#8	378.670319
Rg8	A#4	A#9	64.081955
Rg9	A#9	A#10	397.555725
Rg10	A#4	A#11	429.126801
Rg11	A#9	A#12	449.655212
Rg12	a_473_323#	a_473_323##2	478.655853
Rg13	a_473_323##2	a_473_323##3	227.710632
Rg14	a_473_323##3	a_473_323##4	221.972031
Rg15	a_473_323##4	a_473_323##5	621.293152
Rg16	a_473_323##2	a_473_323##6	371.735809
Rg17	a_473_323##3	a_473_323##7	371.735809
Rg18	a_473_323##4	a_473_323##8	371.735809
Rg19	TE#1	TE#2	473.036835
Rg20	TE#2	TE#3	37.395123
Rg21	TE#3	TE#4	551.575989
Rg22	TE#4	TE#5	290.835480
Rg23	TE#5	TE#6	210.494781
Rg24	TE#6	TE#7	576.503418
Rg25	TE#3	TE#8	298.520782
Rg26	TE#4	TE#9	285.656525
Rg27	TE#5	TE#10	285.656525
Rg28	TE#6	TE#11	285.656525
Rf1	A	A#13	8.404075
Rf2	A#13	A	6.264856
Rf3	Z#1	Z#2	73.115471
Rf4	Z#2	Z#3	42.746872
Rf5	Z#3	Z#4	83.921158
Rf6	Z#2	Z#6	11.574670
Rf7	Z#6	Z	3.149382
Rf8	Z#3	Z#7	25.787323
Rf9	Z#5	Z#6	7.500000
Rf10	a_27_368#	a_27_368##2	100.404083
Rf11	a_27_368##2	a_27_368##4	86.540230
Rf12	a_27_368##4	a_27_368##5	88.597549
Rf13	a_27_368##5	a_27_368##6	90.862358
Rf14	a_27_368##2	a_27_368##7	35.213318
Rf15	a_27_368##5	a_27_368##8	21.341251
Rf16	a_27_368##3	a_27_368##4	5.000000
Rf17	a_27_74#	a_27_74##2	98.935905
Rf18	a_27_74##2	a_27_74##4	91.876404
Rf19	a_27_74##4	a_27_74##5	81.790916
Rf20	a_27_74##5	a_27_74##6	89.731430
Rf21	a_27_74##2	a_27_74##7	29.566370
Rf22	a_27_74##5	a_27_74##8	23.287825
Rf23	a_27_74##3	a_27_74##4	7.500000
Rf24	a_473_323##9	a_473_323#	10.472372
Rf25	a_473_323#	a_473_323##11	87.114799
Rf26	TE	TE#2	91.851074
Rf27	VPWR#1	VPWR#2	187.588760
Rf28	VPWR#2	VPWR#3	52.255848
Rf29	VPWR#2	VPWR#4	42.506184
Rf30	VPWR#3	VPWR#5	48.528210
Rf32	VGND#1	VGND#2	142.403046
Rf33	VGND#2	VGND#3	65.720909
Rf34	VGND#2	VGND#4	33.306259
Rf36	VGND#3	VGND#6	36.804161
Rf37	A#4	A#13	53.410934
Re1	VPWR#3	VPWR	0.818510
Re2	VGND	VGND#3	0.818540
*
*       CAPACITOR CARDS
*
*
C1	Z#2	a_27_368##5	1.3403e-17
C2	Z#4	A#9	1.16003e-18
C3	VPWR#2	TE#4	5.17324e-19
C4	Z#4	A#3	2.00907e-19
C5	VPWR#2	TE#3	2.10517e-21
C6	VPWR#1	TE#3	9.34954e-18
C7	a_27_74##6	A#9	1.58541e-19
C8	Z#3	Z#2	2.51219e-18
C9	VPWR#2	a_473_323##3	5.94283e-21
C10	VGND#4	a_27_74##2	2.38819e-17
C11	VPWR#2	a_473_323##2	4.76041e-19
C12	A#2	a_473_323##5	6.72051e-18
C13	a_27_74##5	a_27_74##3	4.16953e-18
C14	a_27_368#	TE#5	1.00066e-18
C15	VGND#6	a_27_74##2	2.37935e-17
C16	a_27_74##5	Z#7	4.53578e-19
C17	a_27_368#	TE#4	4.13897e-18
C18	a_27_74##3	a_27_74##2	1.74223e-19
C19	A#3	A#5	4.13847e-18
C20	a_27_74##5	a_27_74##8	1.1942e-17
C21	VPWR#2	VPWR#1	1.47191e-19
C22	a_27_74##5	Z#4	3.95131e-17
C23	VGND#1	a_473_323##11	7.58631e-17
C24	a_27_368#	a_473_323##2	1.8589e-17
C25	a_27_74##6	a_27_74##5	4.25129e-18
C26	a_27_368#	VPWR#2	1.3923e-17
C27	a_27_74#	a_473_323##11	8.83468e-17
C28	VGND#4	VGND#1	5.88918e-19
C29	TE#6	a_473_323##4	2.46434e-17
C30	a_27_74##3	Z#3	8.43401e-17
C31	a_473_323##3	VPWR#4	2.13379e-18
C32	a_473_323##2	VPWR#4	3.21076e-18
C33	Z#3	Z#7	2.38082e-18
C34	a_27_368##7	VPWR#2	2.21695e-18
C35	VGND#4	a_27_74#	7.87677e-17
C36	Z#3	a_27_74##8	4.58593e-19
C37	a_473_323##4	a_27_368##7	5.35694e-19
C38	a_27_74##7	a_27_74#	2.18497e-18
C39	a_27_74##2	TE#6	1.09345e-17
C40	TE#6	a_473_323##3	5.32535e-18
C41	a_473_323##3	a_27_368##7	5.32439e-19
C42	Z#4	Z#3	3.606e-18
C43	a_27_74##2	a_27_368#	1.7833e-17
C44	a_27_74##7	VGND#4	6.98644e-17
C45	a_27_74##2	TE#5	1.00523e-17
C46	VGND#6	VGND#4	1.83903e-18
C47	a_473_323##4	VPWR#5	4.48029e-18
C48	a_27_74##2	TE#4	1.23042e-18
C49	VGND#6	a_27_74##7	6.99087e-17
C50	TE#5	a_473_323##3	1.94604e-17
C51	a_27_74##3	a_27_74##7	2.21193e-18
C52	a_27_74##5	A#3	8.90817e-19
C53	a_27_368##2	VPWR#4	1.76175e-17
C54	a_27_74##3	VGND#6	8.67614e-17
C55	a_27_74##2	a_473_323##4	6.17965e-18
C56	a_27_74##5	A#2	1.12976e-19
C57	a_27_368##3	a_473_323##4	6.05361e-19
C58	a_27_368##2	a_27_368##7	7.3646e-20
C59	a_27_74##2	a_27_368##3	3.18446e-19
C60	TE#5	a_473_323##2	7.74597e-18
C61	a_27_74##2	a_473_323##3	6.38202e-18
C62	a_27_74##3	Z#7	2.77779e-19
C63	a_27_368##2	VPWR#5	1.31976e-17
C64	a_27_74##2	a_473_323##2	2.76872e-18
C65	a_27_368##5	Z#5	2.46992e-19
C66	VGND#2	TE#9	2.74586e-18
C67	a_27_368##3	A#3	1.11155e-20
C68	a_27_368##5	a_27_368##8	8.25549e-20
C69	TE#4	a_473_323##2	3.13442e-17
C70	VGND#2	TE#10	2.75299e-18
C71	a_27_74#	a_27_368#	3.58534e-17
C72	a_27_368##3	A#2	2.04631e-18
C73	a_27_368##2	TE#6	3.94062e-18
C74	a_27_368##5	Z#1	1.54404e-17
C75	Z#2	a_27_368##3	1.23348e-16
C76	a_27_368##2	TE#5	3.89101e-18
C77	Z#4	a_27_74##8	5.20036e-19
C78	Z#2	Z#5	1.30497e-18
C79	TE#2	TE#3	3.30649e-17
C80	a_27_74##6	Z#4	5.78137e-17
C81	Z#2	a_27_368##8	4.84683e-17
C82	a_27_368##5	A#3	4.76379e-20
C83	Z#1	Z#2	2.81393e-18
C84	a_27_368##2	a_473_323##4	8.90495e-18
C85	A#3	a_27_368##8	7.93043e-19
C86	TE#4	a_473_323#	1.46417e-17
C87	a_473_323#	TE#3	3.14676e-17
C88	a_27_368##2	a_473_323##3	8.40135e-18
C89	a_27_74##5	TE#7	3.30182e-19
C90	a_27_368##2	a_473_323##2	7.69396e-20
C91	a_27_74##3	a_27_368##3	5.57572e-17
C92	A#9	Z#1	6.50944e-19
C93	a_27_74##2	TE#7	3.84105e-19
C94	a_27_74##5	A#1	1.11474e-18
C95	TE#8	VGND#1	2.85837e-17
C96	VPWR#4	VPWR#1	7.33578e-19
C97	a_473_323##11	TE#8	5.37841e-17
C98	a_27_74##5	A#6	2.63949e-17
C99	VGND#1	TE#9	9.84053e-19
C100	a_27_368##2	TE#7	1.54778e-19
C101	a_27_74#	TE#8	1.31118e-18
C102	A#9	A#4	3.25764e-18
C103	A#4	A#3	3.12034e-18
C104	a_473_323##11	TE#9	1.47336e-18
C105	VGND#4	TE#8	1.01596e-18
C106	a_27_74##5	A#8	2.30585e-17
C107	a_27_368#	VPWR#4	8.4622e-17
C108	VGND#1	TE#10	2.41538e-19
C109	a_27_368##6	A#9	3.94884e-20
C110	a_27_74#	TE#9	4.97768e-17
C111	Z#3	TE#7	2.12399e-18
C112	a_27_368##7	a_27_368#	3.05055e-18
C113	TE#9	VGND#4	2.38446e-17
C114	a_27_74##5	A#10	1.28445e-18
C115	a_27_74#	TE#10	2.00852e-19
C116	Z#3	A#1	2.24478e-17
C117	a_27_74##7	TE#9	2.78952e-19
C118	a_27_368##7	VPWR#4	7.43518e-17
C119	VPWR#2	TE#1	1.15942e-19
C120	TE#10	VGND#4	2.77877e-17
C121	VGND#6	TE#9	2.90158e-19
C122	VPWR#5	VPWR#4	2.42234e-18
C123	a_27_74##7	TE#10	4.48679e-17
C124	Z#3	A#6	2.171e-17
C125	VGND#4	TE#11	1.37281e-18
C126	VPWR#2	a_473_323##6	5.29112e-18
C127	VPWR#5	a_27_368##7	7.41857e-17
C128	VGND#6	TE#10	7.6211e-19
C129	a_27_74##7	TE#11	3.73712e-17
C130	a_27_74##6	a_27_368##6	3.05711e-19
C131	Z#3	A#8	6.51706e-19
C132	VGND#4	TE#7	2.90158e-19
C133	a_27_368##3	a_27_368##7	3.35666e-18
C134	Z#3	A#9	2.23984e-19
C135	TE#11	VGND#6	2.27797e-17
C136	VPWR#2	a_473_323##7	5.65411e-18
C137	a_27_74##7	TE#7	2.00852e-19
C138	a_27_368##3	VPWR#5	1.10088e-16
C139	a_27_74##3	TE#11	6.86848e-19
C140	Z#3	A#3	9.0919e-18
C141	TE#7	VGND#6	2.8769e-17
C142	VPWR#2	a_473_323##8	6.38127e-19
C143	a_27_74##3	TE#7	5.74594e-17
C144	VGND#6	A#1	4.52683e-19
C145	Z#3	A#2	9.75612e-18
C146	a_27_368##3	Z#5	2.21041e-19
C147	a_27_74##3	A#1	2.9843e-17
C148	a_27_368##8	a_27_368##3	3.90094e-18
C149	VPWR#2	a_473_323##5	8.87064e-20
C150	VGND#6	A#6	1.82764e-19
C151	A#1	Z#7	1.57429e-17
C152	a_27_74##3	A#6	7.03384e-19
C153	Z#2	A#3	4.79146e-18
C154	VGND#6	A#8	6.44207e-20
C155	A#6	Z#7	8.68625e-18
C156	a_27_368##2	a_473_323##7	4.464e-18
C157	Z#4	A#1	2.7066e-19
C158	TE#3	VGND#1	1.04745e-17
C159	a_27_74##3	A#8	3.12711e-19
C160	A#6	a_27_74##8	1.10042e-17
C161	VGND#6	A#10	4.40717e-20
C162	Z#2	A#2	1.63335e-18
C163	Z#1	a_27_368##8	5.25378e-17
C164	Z#4	A#6	1.03287e-18
C165	a_27_368##2	a_473_323##8	8.28005e-18
C166	A#8	a_27_74##8	1.33769e-17
C167	a_27_368##6	a_27_368##8	4.13522e-18
C168	a_27_74##6	A#6	3.33791e-19
C169	Z#4	A#8	4.52669e-17
C170	a_27_368##6	Z#1	8.68356e-17
C171	a_27_74##6	A#8	2.44503e-18
C172	A#10	Z#4	2.08291e-17
C173	a_473_323##11	TE#3	1.45071e-17
C174	a_27_74##6	A#10	5.25812e-17
C175	Z#2	a_473_323##5	2.52033e-18
C176	a_27_368##5	A#7	1.6145e-17
C177	a_27_368##3	TE#7	3.73305e-18
C178	TE#7	a_473_323##4	2.85095e-18
C179	Z#2	A#5	3.20717e-17
C180	TE#9	TE#8	4.35303e-18
C181	a_27_74#	TE#4	2.32499e-17
C182	a_27_368##5	A#11	1.49739e-17
C183	A	A#9	2.18843e-17
C184	VPWR#1	TE#1	3.51658e-17
C185	A	A#3	1.24184e-17
C186	Z#2	A#7	3.39971e-17
C187	A	A#2	2.67366e-19
C188	TE#1	a_473_323##9	2.12469e-17
C189	a_27_74#	TE#3	8.57253e-19
C190	TE#10	TE#9	2.08332e-17
C191	VPWR#1	a_473_323##6	5.51921e-19
C192	Z#2	A#11	1.6786e-18
C193	a_27_74##3	a_473_323##5	5.19173e-18
C194	VPWR#4	TE#1	4.16407e-19
C195	VGND#4	TE#5	2.91579e-18
C196	VPWR#1	a_473_323##7	8.42796e-20
C197	a_27_368#	a_473_323##6	5.89301e-17
C198	TE#11	TE#10	3.68219e-17
C199	A#2	TE#7	5.44684e-18
C200	a_473_323##6	VPWR#4	2.11788e-17
C201	A#3	A#2	7.21575e-18
C202	TE	TE#3	5.81388e-18
C203	Z#2	A#12	3.19059e-19
C204	VGND#4	TE#4	2.81621e-18
C205	a_27_368#	a_473_323##7	2.26839e-18
C206	a_27_368##7	a_473_323##6	4.85175e-19
C207	VPWR#4	a_473_323##7	5.1046e-17
C208	TE#7	TE#11	2.08172e-17
C209	a_27_368#	a_473_323##8	2.42957e-19
C210	a_473_323##7	a_27_368##7	1.74227e-17
C211	a_27_74##7	TE#6	1.13738e-18
C212	a_27_74#	a_473_323##2	1.20755e-17
C213	VPWR#4	a_473_323##8	2.57906e-18
C214	VPWR#5	a_473_323##7	3.82362e-19
C215	a_27_368##7	a_473_323##8	5.2441e-17
C216	A#1	TE#7	2.91929e-17
C217	VGND#2	a_473_323#	1.0117e-18
C218	a_27_74##7	TE#5	1.28299e-18
C219	VPWR#4	a_473_323##5	2.01741e-19
C220	a_473_323##8	VPWR#5	2.76104e-17
C221	a_473_323#	VPWR#2	2.19891e-17
C222	a_27_368##7	a_473_323##5	2.06145e-18
C223	a_27_368##3	a_473_323##8	2.2912e-18
C224	A#6	A#1	3.06954e-17
C225	a_473_323##5	VPWR#5	3.52413e-17
C226	a_27_368##3	a_473_323##5	8.38046e-17
C227	VPWR#5	A#5	1.85493e-20
C228	A#8	A#6	2.59107e-17
C229	VGND#6	TE#6	3.81822e-18
C230	VGND#2	a_27_74##2	1.46399e-19
C231	a_27_368##3	A#5	3.79577e-17
C232	a_27_368##8	a_473_323##5	2.99099e-19
C233	VPWR#5	A#7	1.04683e-20
C234	A#5	Z#5	2.32358e-17
C235	a_27_74##5	A#4	1.37567e-18
C236	VGND#1	TE#2	1.12457e-17
C237	a_27_368##3	A#7	7.65936e-19
C238	a_27_368##8	A#5	6.70331e-19
C239	a_473_323##11	TE#2	1.64495e-17
C240	A#10	A#8	2.83e-17
C241	A#7	Z#5	2.09011e-17
C242	VPWR#5	A#11	6.56284e-21
C243	a_27_368##5	A#4	8.46999e-20
C244	a_27_368##3	A#11	3.28752e-19
C245	A#7	a_27_368##8	2.67066e-17
C246	VPWR	TE#3	4.31068e-19
C247	VPWR	a_473_323##4	5.19699e-21
C248	VPWR	a_473_323##3	9.83986e-23
C249	Z#1	A#7	1.18688e-18
C250	VPWR#5	A#12	6.10086e-21
C251	VPWR	a_473_323##2	1.0348e-18
C252	a_473_323##11	a_473_323#	4.11768e-18
C253	Z#3	A#4	3.13035e-19
C254	A#11	a_27_368##8	3.07162e-17
C255	a_27_74#	a_473_323#	2.90367e-17
C256	a_27_368##6	A#7	3.26715e-19
C257	Z#2	A#4	2.31163e-19
C258	Z#1	A#11	6.3303e-17
C259	a_27_368##8	A#12	1.28405e-18
C260	a_27_368##6	A#11	2.57779e-18
C261	TE#7	a_473_323##5	1.44706e-17
C262	A#12	Z#1	2.55582e-17
C263	a_27_368##6	A#12	6.16633e-17
C264	TE#2	VPWR#1	3.48339e-17
C265	TE#2	a_473_323##9	1.99078e-18
C266	a_473_323##6	TE#1	8.19507e-19
C267	a_473_323#	VPWR#1	1.10671e-16
C268	VGND	TE#4	7.99292e-19
C269	VGND	TE#3	2.70284e-18
C270	VGND	a_473_323##4	3.93189e-21
C271	a_473_323#	a_473_323##9	5.65198e-18
C272	VGND	a_473_323##2	6.60082e-21
C273	Z#4	A#4	6.24379e-18
C274	a_473_323##7	a_473_323##6	4.50899e-17
C275	VGND	A#3	2.09505e-19
C276	a_27_368#	a_473_323#	1.11437e-16
C277	a_27_74##6	A#4	2.07701e-19
C278	VPWR#4	a_473_323#	1.22495e-18
C279	a_473_323##8	a_473_323##7	4.71883e-17
C280	a_27_368##2	VPWR#2	2.02516e-19
C281	a_473_323##5	a_473_323##8	3.78065e-17
C282	a_27_74##3	a_473_323##4	2.8613e-19
C283	A#4	a_27_368##8	7.86909e-19
C284	TE#6	VNB	2.16028e-17
C285	A#4	Z#1	3.96371e-18
C286	A#5	a_473_323##5	4.02827e-17
C287	TE#5	VNB	1.86553e-17
C288	TE#4	VNB	2.77034e-17
C289	TE#3	VNB	9.85642e-17
C290	Z#3	A	3.48692e-17
C291	a_473_323##4	VNB	1.39378e-17
C292	a_27_368##6	A#4	9.67181e-20
C293	a_473_323##3	VNB	1.25546e-17
C294	a_473_323##2	VNB	2.33255e-17
C295	A	Z#2	3.85229e-17
C296	A#9	VNB	3.6407e-17
C297	A#3	VNB	2.84586e-17
C298	A#2	VNB	2.57074e-17
C299	A#7	A#5	4.56679e-17
C300	A#11	A#7	3.74316e-17
C301	VGND#1	TE	2.06299e-17
C302	a_473_323##11	TE	3.25809e-18
C303	Z#4	A	6.35033e-17
C304	a_27_74##6	A	2.70571e-17
C305	A#12	A#11	3.77517e-17
C306	a_473_323#	TE#1	6.93011e-17
C307	VPWR	VPWR#2	4.89823e-17
C308	a_473_323##6	a_473_323#	3.27894e-17
C309	a_473_323#	a_473_323##7	2.10025e-19
C310	a_27_74##3	A#3	5.68984e-20
C311	VPWR	a_27_368##5	2.68804e-17
C312	VGND#2	VGND#1	3.71605e-19
C313	VPWR	a_27_368##2	2.13114e-18
C314	A	Z#1	6.22233e-17
C315	VPWR	Z#2	1.00999e-17
C316	A	a_27_368##6	3.75343e-17
C317	VGND#2	TE#5	2.96873e-20
C318	VGND	VGND#2	3.1121e-17
C319	VPWR	a_27_74#	4.1195e-18
C320	a_27_74##3	A#2	8.24222e-18
C321	VGND	a_27_74##5	2.77535e-17
C322	VGND	a_27_74##2	2.90386e-18
C323	VGND	a_27_368##2	4.05818e-18
C324	VGND#2	a_473_323##11	8.10787e-18
C325	VGND	Z#3	1.03951e-17
C326	VPWR	VPWR#1	4.4887e-17
C327	VGND	VGND#1	5.49565e-17
C328	VGND	a_473_323##11	2.03262e-17
C329	VPWR	a_27_368#	1.48864e-17
C330	VGND	a_27_74#	1.74035e-17
C331	VGND#2	TE#4	5.84487e-19
C332	VGND#2	VNB	4.24944e-17
C333	VGND	VGND#4	2.22324e-17
C334	VGND	a_27_74##7	1.62045e-17
C335	VPWR	a_27_368##7	1.40893e-17
C336	VPWR#2	VNB	4.38068e-17
C337	VGND	VGND#6	2.1937e-17
C338	VGND	a_27_74##3	2.41774e-17
C339	VPWR	a_27_368##3	2.62048e-17
C340	a_473_323#	TE#2	5.04517e-17
C341	a_27_74##5	VNB	5.02545e-18
C342	VGND	Z#4	8.48383e-18
C343	a_27_368##5	VNB	4.54861e-18
C344	VGND	a_27_74##6	2.32766e-17
C345	VPWR	Z#1	8.6967e-18
C346	a_27_368##2	VNB	1.55665e-18
C347	VGND	VPWR#1	2.57872e-18
C348	VPWR	a_27_368##6	2.35446e-17
C349	a_27_74##2	a_27_368##2	7.98276e-17
C350	Z#3	VNB	6.02482e-18
C351	VGND	a_27_368#	3.19217e-18
C352	Z#2	VNB	1.69987e-18
C353	a_27_74##5	Z#3	4.43475e-17
C354	VGND#1	VNB	7.86492e-17
C355	A	A#5	3.24761e-19
C356	VGND#2	a_27_74#	1.93456e-17
C357	a_473_323##11	VNB	1.78282e-17
C358	a_27_74#	VNB	5.1494e-18
C359	VGND#4	VNB	6.89617e-18
C360	VGND	a_27_368##3	2.93508e-18
C361	A	A#7	1.40791e-19
C362	a_27_74##7	VNB	2.53572e-18
C363	VGND#6	VNB	6.43056e-18
C364	A	A#11	2.07985e-18
C365	a_27_74##3	VNB	6.7731e-18
C366	VGND#2	TE#3	5.65733e-20
C367	A	A#12	4.44321e-18
C368	Z#4	VNB	1.3522e-18
C369	VGND	TE#8	1.383e-18
C370	a_27_74##6	VNB	4.65091e-17
C371	VPWR#1	VNB	9.42769e-17
C372	VGND	TE#9	2.22284e-19
C373	VGND	TE#10	2.03205e-19
C374	a_27_368#	VNB	2.81035e-18
C375	VGND	TE#11	1.14849e-19
C376	VPWR#4	VNB	4.52371e-19
C377	VPWR	TE#1	2.74602e-18
C378	a_27_368##7	VNB	2.30479e-18
C379	VGND	TE#7	6.30748e-19
C380	VPWR	a_473_323##6	1.20486e-18
C381	VPWR#5	VNB	3.14608e-18
C382	VGND	A#1	2.07141e-18
C383	a_27_368##3	VNB	5.58684e-18
C384	VPWR	a_473_323##7	9.73106e-19
C385	VGND	A#6	1.61215e-18
C386	VGND	A#8	1.69553e-18
C387	VPWR	a_473_323##8	9.57595e-19
C388	VGND	A#10	2.36012e-18
C389	VPWR	a_473_323##5	6.76209e-19
C390	a_27_368##6	VNB	5.47798e-17
C391	TE#8	VNB	3.52304e-17
C392	VPWR	A#5	1.52077e-18
C393	TE#9	VNB	2.89104e-17
C394	TE#10	VNB	2.72816e-17
C395	VPWR	A#7	1.60355e-18
C396	A	A#4	2.25327e-17
C397	TE#11	VNB	2.65155e-17
C398	VPWR	A#11	1.68062e-18
C399	TE#7	VNB	4.20699e-17
C400	A#1	VNB	2.83256e-17
C401	VPWR	A#12	2.41732e-18
C402	A#6	VNB	2.92912e-17
C403	A#8	VNB	2.96307e-17
C404	A#10	VNB	3.78072e-17
C405	TE#1	VNB	4.4122e-17
C406	a_473_323##6	VNB	3.33554e-17
C407	a_473_323##7	VNB	2.7968e-17
C408	VPWR	TE#2	4.10421e-18
C409	a_473_323##8	VNB	3.15268e-17
C410	VPWR	a_473_323#	4.16829e-17
C411	a_473_323##5	VNB	4.56031e-17
C412	A#5	VNB	3.80525e-17
C413	A#7	VNB	3.32603e-17
C414	A#11	VNB	3.21044e-17
C415	VGND	TE#2	2.94984e-18
C416	A#12	VNB	4.10863e-17
C417	VGND	a_473_323#	5.50022e-18
C418	TE#2	VNB	1.42038e-17
C419	a_473_323#	VNB	1.00047e-16
C420	VPWR	A	7.93014e-18
C421	A#4	VNB	3.87699e-17
C422	VGND	A	8.16249e-18
C423	VGND	TE	4.04159e-18
C424	VGND#2	a_27_74##7	6.68869e-18
C425	A	VNB	4.05283e-17
C426	TE	VNB	8.31357e-18
C427	VPWR	VNB	7.0673e-17
C428	VGND	VNB	7.65688e-17
C429	VGND#3	A#10	4.43427e-18
C430	VGND#3	a_27_74##6	5.43216e-17
C431	VPWR#3	a_473_323##8	5.29268e-18
C432	VGND#3	a_27_74##5	7.08827e-17
C433	VGND#3	A#6	4.48038e-18
C434	VPWR#3	VPWR#1	4.48453e-17
C435	VPWR#3	A#12	4.50012e-18
C436	VPWR#3	a_473_323##3	1.50468e-20
C437	VGND#3	A#4	7.72861e-20
C438	VGND	VGND#3	6.95575e-17
C439	VGND#3	TE#7	2.45041e-18
C440	VGND#3	a_27_74##3	4.88652e-17
C441	VGND#3	TE#6	6.31564e-20
C442	VGND#3	A#2	2.54455e-20
C443	a_27_368##6	VPWR#3	5.4279e-17
C444	VPWR#3	A#7	4.6269e-18
C445	VPWR#3	TE#3	4.04628e-22
C446	VGND#3	a_27_74##7	1.02707e-17
C447	VGND#3	VGND#2	5.64892e-17
C448	VPWR#3	A#3	3.77089e-20
C449	VGND#3	A#9	1.31703e-20
C450	VPWR#3	a_473_323##5	4.25907e-18
C451	a_27_368##2	VPWR#3	2.02516e-19
C452	VGND#3	VGND#1	4.67384e-17
C453	VGND#3	A#8	4.43427e-18
C454	VGND#3	TE#3	1.022e-21
C455	a_27_368##3	VPWR#3	4.99166e-17
C456	VPWR#3	A#4	3.91397e-20
C457	VGND#3	VNB	3.47101e-16
C458	VPWR#3	a_473_323##7	4.63648e-19
C459	VGND#3	A#1	4.4412e-18
C460	VGND#3	a_473_323##5	1.88168e-20
C461	a_27_368##5	VPWR#3	6.56532e-17
C462	VGND#3	TE#5	3.19972e-20
C463	VPWR#3	A#11	4.52054e-18
C464	VPWR#3	a_473_323##4	2.37502e-20
C465	VPWR#3	VNB	3.42166e-16
C466	VGND#3	TE#11	2.74586e-18
C467	a_27_368##7	VPWR#3	1.15e-17
C468	VPWR#3	VPWR#2	6.07729e-17
C469	VPWR#3	A#2	2.28707e-20
C470	VGND#3	A#3	4.63365e-20
C471	VPWR#3	A#5	4.89866e-18
C472	VPWR	VPWR#3	8.444e-17
C473	VGND#3	a_27_74##2	1.46399e-19
C474	VPWR#3	A#9	5.22367e-21
*
*
.ENDS sky130_fd_sc_hs__einvp_4
*
