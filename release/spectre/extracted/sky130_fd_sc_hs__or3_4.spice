* Extracted by Quantus, converted by sky130cad/quantus.py
*
*
*
*                       LINUX           Wed Nov 18 09:06:17 2026
*
*
*
*  PROGRAM  advgen
*
*  Name           : advgen - Quantus - (64-bit)
*  Version        : 25.1.0-p047
*  Build Date     : Thu Dec 11 23:20:30 PST 2025
*
*  HSPICE LIBRARY
*
*  OPERATING_TEMPERATURE 150
*  QRC_TECH_DIR <path>/tech
*
*
*

*
.SUBCKT sky130_fd_sc_hs__or3_4 VNB VPB VGND VPWR X C A B
*
*
*  caps2d version: 10
*
*
*       TRANSISTOR CARDS
*
*
XM10 a_302_388##18 C#1 VGND#9 VNB sky130_fd_pr__nfet_01v8_lvt l=0.15 w=0.74 ad=0.2109 as=0.2664 pd=2.05 ps=2.2
XM3 VGND#9 B#3 a_302_388##17 VNB sky130_fd_pr__nfet_01v8_lvt l=0.15 w=0.74 ad=0.2664 as=0.2516 pd=2.2 ps=2.16
XM4 a_302_388##17 A#3 VGND#8 VNB sky130_fd_pr__nfet_01v8_lvt l=0.15 w=0.74 ad=0.2516 as=0.259 pd=2.16 ps=2.18
XM0 X#3 a_302_388##10 VGND#8 VNB sky130_fd_pr__nfet_01v8_lvt l=0.15 w=0.74 ad=0.2109 as=0.259 pd=2.05 ps=2.18
XM11 X#3 a_302_388##8 VGND#7 VNB sky130_fd_pr__nfet_01v8_lvt l=0.15 w=0.74 ad=0.2109 as=0.2516 pd=2.05 ps=2.16
XM12 VGND#7 a_302_388##6 X#1 VNB sky130_fd_pr__nfet_01v8_lvt l=0.15 w=0.74 ad=0.2516 as=0.2072 pd=2.16 ps=2.04
XM16 VGND#1 a_302_388# X#1 VNB sky130_fd_pr__nfet_01v8_lvt l=0.15 w=0.74 ad=0.2109 as=0.2072 pd=2.05 ps=2.04
XM7 VPWR#5 A#1 a_116_388##2 VPB sky130_fd_pr__pfet_01v8 l=0.15 w=1 ad=0.295 as=0.3 pd=2.59 ps=2.6
XM2 a_116_388##2 B#1 a_206_388##2 VPB sky130_fd_pr__pfet_01v8 l=0.15 w=1 ad=0.3 as=0.33 pd=2.6 ps=2.66
XM1 a_206_388##2 C#6 a_302_388##15 VPB sky130_fd_pr__pfet_01v8 l=0.15 w=1 ad=0.33 as=0.3 pd=2.66 ps=2.6
XM8 a_302_388##15 C#5 a_206_388# VPB sky130_fd_pr__pfet_01v8 l=0.15 w=1 ad=0.3 as=0.355 pd=2.6 ps=2.71
XM9 a_206_388# B#5 a_116_388# VPB sky130_fd_pr__pfet_01v8 l=0.15 w=1 ad=0.355 as=0.35 pd=2.71 ps=2.7
XM14 a_116_388# A#5 VPWR#7 VPB sky130_fd_pr__pfet_01v8 l=0.15 w=1 ad=0.35 as=0.4174 pd=2.7 ps=3.01
XM15 VPWR#7 a_302_388##12 X#5 VPB sky130_fd_pr__pfet_01v8 l=0.15 w=1.12 ad=0.4174 as=0.336 pd=3.01 ps=2.84
XM6 X#5 a_302_388##11 VPWR#6 VPB sky130_fd_pr__pfet_01v8 l=0.15 w=1.12 ad=0.336 as=0.336 pd=2.84 ps=2.84
XM13 VPWR#6 a_302_388##7 X#6 VPB sky130_fd_pr__pfet_01v8 l=0.15 w=1.12 ad=0.336 as=0.336 pd=2.84 ps=2.84
XM5 X#6 a_302_388##5 VPWR#1 VPB sky130_fd_pr__pfet_01v8 l=0.15 w=1.12 ad=0.336 as=0.3304 pd=2.84 ps=2.83
*
*
*       RESISTOR AND CAP/DIODE CARDS
*
Rg1	A#1	A#2	506.723053
Rg2	B#1	B#2	560.440308
Rg3	C#1	C#2	347.139496
Rg4	C#2	C#3	101.159843
Rg5	C#3	C#4	17.744709
Rg6	C#2	C#5	582.197388
Rg7	C#3	C#6	520.123291
Rg8	B#3	B#4	452.344543
Rg9	B#4	B#5	408.386017
Rg10	A#3	A#4	320.356293
Rg11	A#4	A#5	509.308777
Rg12	a_302_388#	a_302_388##2	368.862610
Rg13	a_302_388##2	a_302_388##3	66.369736
Rg14	a_302_388##3	a_302_388##4	57.428749
Rg15	a_302_388##2	a_302_388##5	471.862823
Rg16	a_302_388##3	a_302_388##6	366.112152
Rg17	a_302_388##3	a_302_388##7	470.238159
Rg18	a_302_388##4	a_302_388##8	349.977234
Rg19	a_302_388##4	a_302_388##9	90.033310
Rg20	a_302_388##9	a_302_388##10	368.862610
Rg21	a_302_388##4	a_302_388##11	451.334412
Rg22	a_302_388##9	a_302_388##12	471.862823
Rf1	C	C#4	82.084763
Rf2	a_206_388#	a_206_388##2	78.092941
Rf3	B#4	B	168.893600
Rf4	B	B#2	9.054472
Rf5	B#2	B	9.841817
Rf6	a_116_388#	a_116_388##3	148.510071
Rf9	a_116_388##2	a_116_388##3	5.000000
Rf10	A#4	A#7	346.486237
Rf11	A#7	A#2	49.490376
Rf12	A#7	A	3.920758
Rf13	a_302_388##4	a_302_388##14	64.288757
Rf14	a_302_388##14	a_302_388##15	170.014465
Rf15	a_302_388##14	a_302_388##16	83.213219
Rf16	a_302_388##16	a_302_388##17	10.866916
Rf17	a_302_388##16	a_302_388##18	80.676956
Rf18	X#1	X#2	18.781376
Rf19	X#2	X#3	89.334091
Rf20	X#2	X	45.989067
Rf21	X	X#4	42.574154
Rf22	X#4	X#5	103.578354
Rf23	X#4	X#6	21.948624
Rf24	VPWR#1	VPWR#2	112.878075
Rf25	VPWR#2	VPWR#3	62.831711
Rf26	VPWR#3	VPWR#4	40.883747
Rf27	VPWR#4	VPWR#5	221.573257
Rf28	VPWR#2	VPWR#6	42.573776
Rf29	VPWR#3	VPWR#7	31.534731
Rf30	VGND#1	VGND#2	102.193375
Rf31	VGND#2	VGND#3	60.274944
Rf32	VGND#3	VGND#4	41.979504
Rf33	VGND#4	VGND#5	31.021929
Rf35	VGND#2	VGND#7	39.841232
Rf36	VGND#3	VGND#8	31.948624
Rf37	VGND#5	VGND#9	31.948624
Re1	VPWR#4	VPWR	0.892922
Re2	VGND	VGND#4	0.892955
*
*       CAPACITOR CARDS
*
*
C1	a_302_388##14	X#1	2.53455e-18
C2	a_302_388##14	VGND#7	4.26802e-18
C3	a_302_388##16	X#3	2.03719e-17
C4	a_302_388##14	X#3	5.97479e-17
C5	a_302_388##16	VGND#8	5.83877e-17
C6	a_302_388##14	VGND#8	1.55023e-18
C7	a_302_388##16	a_302_388##17	4.53118e-18
C8	VPWR#2	a_302_388##2	4.5102e-20
C9	VPWR#2	VPWR#1	7.06672e-19
C10	X#5	a_302_388##9	1.07629e-18
C11	a_302_388##16	VGND#9	4.0752e-17
C12	X#4	VPWR#1	3.71939e-19
C13	X#6	VPWR#2	1.67068e-17
C14	a_302_388##18	a_302_388##16	2.59402e-18
C15	X#4	X#6	2.08835e-19
C16	X#4	a_302_388##2	1.45938e-18
C17	X#5	VPWR#3	5.259e-18
C18	X#4	VPWR#6	2.41648e-17
C19	X#5	VPWR#2	5.54377e-18
C20	X#5	X#4	1.5699e-18
C21	a_302_388##14	X#6	2.35532e-18
C22	a_302_388##18	A#7	1.12695e-17
C23	VPWR#7	VPWR#2	6.61587e-20
C24	X#2	a_302_388##2	1.98131e-18
C25	a_302_388##14	VPWR#6	2.37113e-18
C26	X#1	VGND#1	3.83514e-17
C27	VPWR#4	C#3	4.55545e-20
C28	VGND#7	VGND#1	1.62083e-18
C29	VPWR#4	C#2	4.0386e-20
C30	a_302_388##14	X#5	6.94125e-17
C31	a_116_388#	C#3	3.24348e-21
C32	VGND#7	X#1	2.93287e-17
C33	a_302_388##14	VPWR#7	4.19517e-17
C34	a_302_388##14	a_302_388##9	1.63037e-17
C35	a_116_388#	C#2	1.60012e-19
C36	X#3	X#1	2.36826e-18
C37	a_302_388##14	a_116_388#	2.14952e-17
C38	X#3	VGND#7	4.4543e-17
C39	a_302_388##14	a_302_388##2	8.85784e-18
C40	VGND#8	VGND#7	1.9889e-18
C41	a_302_388##9	a_302_388##4	4.30602e-18
C42	a_206_388#	C#2	8.66309e-20
C43	VGND#2	a_302_388#	6.66234e-19
C44	VGND#8	X#3	2.22855e-17
C45	a_302_388##4	a_302_388##2	4.29143e-18
C46	a_302_388##14	C#3	2.55309e-19
C47	VGND#1	VPWR#1	1.99913e-19
C48	VGND#2	a_302_388##6	7.7856e-18
C49	a_302_388##15	C#3	3.59307e-19
C50	A#4	a_302_388##9	3.47525e-17
C51	a_302_388##15	C#2	3.54517e-19
C52	VGND#2	a_302_388##8	4.94451e-18
C53	VGND#9	VGND#8	1.54682e-18
C54	A#4	C#3	1.65118e-18
C55	VGND#3	a_302_388##10	3.40213e-18
C56	A#4	C#2	1.28309e-17
C57	X#2	a_302_388#	1.97114e-17
C58	VGND#2	a_302_388##10	5.5578e-19
C59	a_206_388##2	C#3	3.01482e-19
C60	VGND#3	A#3	2.60465e-18
C61	X#2	a_302_388##6	2.16563e-17
C62	a_302_388##14	a_302_388#	6.4388e-21
C63	a_206_388##2	C#2	5.02208e-21
C64	a_302_388##18	VGND#9	4.32305e-17
C65	a_302_388##14	a_302_388##6	1.42365e-20
C66	C#2	B#4	2.46207e-17
C67	a_302_388##16	a_302_388##8	6.22094e-19
C68	a_116_388##2	C#3	1.7679e-18
C69	a_302_388##14	a_302_388##8	2.93808e-19
C70	a_302_388##16	a_302_388##10	7.38103e-18
C71	a_302_388##14	a_302_388##10	3.73397e-18
C72	A#7	C#3	3.29146e-17
C73	a_302_388##16	A#3	3.56636e-17
C74	X#6	VPWR#1	6.2273e-17
C75	a_302_388##14	A#3	1.80779e-18
C76	VPWR#5	C#3	8.90514e-20
C77	VPWR#6	VPWR#1	2.00319e-18
C78	a_302_388##16	B#3	2.01739e-17
C79	B#2	a_302_388##9	4.80982e-19
C80	a_302_388##14	B#3	5.32993e-19
C81	VPWR#6	X#6	6.23622e-17
C82	B#2	C#3	4.72427e-17
C83	a_302_388##16	C#1	4.42063e-19
C84	B#2	C#2	1.43485e-17
C85	X#5	X#6	9.27108e-19
C86	a_302_388##14	C#1	2.57895e-19
C87	VPWR#2	a_302_388##5	2.16586e-18
C88	VGND#1	a_302_388#	3.22631e-17
C89	X#5	VPWR#6	6.16751e-17
C90	A#7	B#3	1.67642e-19
C91	X#4	a_302_388##5	2.42092e-17
C92	a_302_388#	X#1	1.33201e-17
C93	VPWR#7	VPWR#6	2.66815e-18
C94	VGND#1	a_302_388##6	2.54014e-18
C95	VPWR#2	a_302_388##7	5.27282e-18
C96	VGND#7	a_302_388#	4.40306e-19
C97	A#7	C#1	2.17286e-19
C98	X#4	a_302_388##7	1.81637e-17
C99	X#1	a_302_388##6	3.16531e-17
C100	VPWR#7	X#5	5.20507e-17
C101	A#2	C#3	3.19893e-17
C102	VGND#1	a_302_388##8	3.21261e-19
C103	a_302_388##6	VGND#7	1.56333e-17
C104	VPWR#2	a_302_388##11	5.49193e-18
C105	X#1	a_302_388##8	2.6328e-18
C106	X#4	a_302_388##11	5.35548e-18
C107	X#3	a_302_388##6	3.6409e-19
C108	VPWR#3	a_302_388##12	3.33004e-18
C109	VGND#7	a_302_388##8	3.00221e-17
C110	a_116_388#	VPWR#7	5.13394e-17
C111	VPWR#2	a_302_388##12	3.95329e-19
C112	X#1	a_302_388##10	1.9269e-19
C113	X#3	a_302_388##8	2.48125e-17
C114	X#4	a_302_388##12	1.31417e-19
C115	VGND#7	a_302_388##10	1.13986e-18
C116	VPWR#3	A#5	4.40722e-18
C117	a_302_388##14	a_302_388##11	5.63533e-19
C118	VGND#8	a_302_388##8	1.4632e-18
C119	a_302_388##10	X#3	1.91692e-17
C120	a_116_388#	a_206_388#	8.14321e-17
C121	VGND#8	a_302_388##10	3.32861e-17
C122	a_302_388##14	a_302_388##12	9.84065e-18
C123	a_116_388#	a_302_388##15	7.35679e-17
C124	X#3	A#3	3.72576e-19
C125	A#3	VGND#8	1.7078e-17
C126	a_206_388#	a_302_388##15	2.38939e-18
C127	a_116_388#	a_206_388##2	5.63141e-19
C128	VGND#9	a_302_388##10	2.86953e-19
C129	a_302_388##14	A#5	2.45259e-17
C130	A#3	a_302_388##17	1.63601e-17
C131	a_116_388##2	a_116_388#	1.67078e-18
C132	VGND#8	B#3	6.86627e-19
C133	VGND#9	A#3	1.77248e-18
C134	VGND#3	VGND#2	1.31904e-18
C135	a_206_388##2	a_302_388##15	7.28883e-19
C136	a_302_388##14	B#5	4.27727e-19
C137	B#3	a_302_388##17	7.20563e-18
C138	a_302_388##18	A#3	1.9772e-19
C139	VGND#9	B#3	3.32613e-17
C140	a_116_388##2	a_302_388##15	1.6576e-17
C141	a_302_388##14	C#5	2.52556e-19
C142	a_302_388##18	B#3	9.74856e-19
C143	a_116_388##2	a_206_388##2	6.07027e-17
C144	C#1	VGND#9	2.054e-17
C145	a_302_388##18	C#1	4.52183e-17
C146	a_206_388##2	VPWR#5	1.38062e-17
C147	a_302_388##14	C#6	2.65645e-19
C148	VPWR#5	a_116_388##2	4.48951e-17
C149	a_302_388##5	VPWR#1	3.37354e-17
C150	X#6	a_302_388##5	4.9928e-17
C151	VPWR#1	a_302_388##7	1.23306e-18
C152	VPWR#4	VPWR#3	3.08552e-17
C153	VPWR#6	a_302_388##5	7.14071e-19
C154	VGND#4	VGND#3	3.06316e-17
C155	a_302_388##6	a_302_388#	3.9103e-17
C156	VPWR#4	VPWR#2	4.29927e-17
C157	X#6	a_302_388##7	4.82853e-17
C158	VGND#4	VGND#2	4.16291e-17
C159	VPWR#1	a_302_388##11	2.59902e-19
C160	a_302_388##7	VPWR#6	2.09722e-17
C161	C#2	B#3	4.17676e-18
C162	X#6	a_302_388##11	1.85252e-18
C163	X#5	a_302_388##7	4.65102e-19
C164	a_302_388##8	a_302_388##6	2.5406e-17
C165	a_302_388##14	VPWR#4	2.4603e-19
C166	VPWR#6	a_302_388##11	4.59417e-17
C167	VGND#2	a_302_388##4	8.58559e-20
C168	VPWR#3	VPWR#2	1.20361e-18
C169	X#6	a_302_388##12	7.76085e-20
C170	VGND#2	X#2	4.86456e-19
C171	X#5	a_302_388##11	5.5952e-17
C172	VGND#3	a_302_388##16	9.37125e-19
C173	VPWR#6	a_302_388##12	1.88397e-18
C174	VGND#4	a_302_388##16	1.75424e-17
C175	VPWR#7	a_302_388##11	2.63865e-18
C176	VPWR#2	a_302_388##4	9.08134e-20
C177	a_302_388##10	a_302_388##8	3.96073e-17
C178	X#5	a_302_388##12	1.50712e-17
C179	X#4	a_302_388##4	3.63167e-18
C180	C#3	C#1	2.72795e-17
C181	X#2	a_302_388##4	4.66264e-18
C182	VPWR#7	a_302_388##12	5.74043e-17
C183	VGND#3	a_302_388##14	4.97804e-19
C184	X#5	A#5	7.02277e-19
C185	a_116_388#	a_302_388##12	1.16679e-18
C186	A#3	a_302_388##10	2.71896e-17
C187	a_302_388##14	a_302_388##4	3.49477e-17
C188	a_302_388##15	a_302_388##11	2.38007e-19
C189	A#5	VPWR#7	2.38591e-17
C190	X#4	VPWR#2	2.5317e-19
C191	X#5	B#5	3.39005e-19
C192	A	C#3	1.73974e-18
C193	a_116_388#	A#5	5.24844e-17
C194	a_302_388##16	A#4	7.33282e-17
C195	a_302_388##15	a_302_388##12	2.70206e-19
C196	VPWR#7	B#5	1.35479e-18
C197	A#4	a_302_388##14	7.01786e-17
C198	a_206_388#	A#5	5.40111e-19
C199	B#3	A#3	2.77545e-17
C200	X#5	C#5	2.13622e-19
C201	a_116_388#	B#5	3.66463e-17
C202	a_302_388##15	A#5	5.03503e-19
C203	VPWR#7	C#5	7.44207e-19
C204	a_206_388#	B#5	3.61797e-17
C205	a_302_388##16	B#4	3.01848e-19
C206	X#5	C#6	1.7258e-19
C207	a_116_388#	C#5	1.39116e-17
C208	a_302_388##14	B#4	8.67988e-19
C209	C#1	B#3	2.53062e-17
C210	a_302_388##15	B#5	1.69509e-17
C211	VGND#4	VGND#1	2.78711e-17
C212	a_116_388##2	A#5	2.90971e-19
C213	VPWR#7	C#6	4.25406e-19
C214	a_206_388#	C#5	4.22576e-17
C215	C#3	C#2	7.25978e-18
C216	X#2	X#4	4.26987e-18
C217	a_302_388##14	VPWR#3	7.13976e-19
C218	a_116_388#	C#6	4.08535e-19
C219	a_302_388##15	C#5	3.81179e-17
C220	a_116_388##2	B#5	3.54e-19
C221	VPWR#7	B#1	4.53363e-19
C222	C	C#3	4.16934e-17
C223	VPWR#5	B#5	5.15194e-19
C224	a_116_388#	B#1	2.49485e-19
C225	a_302_388##15	C#6	3.12089e-17
C226	a_116_388##2	C#5	5.80898e-19
C227	VGND#7	a_302_388##4	1.36249e-18
C228	a_206_388##2	C#6	4.25005e-17
C229	VPWR#4	VPWR#1	2.59871e-17
C230	VPWR#5	C#5	4.38912e-19
C231	X#3	a_302_388##4	2.11919e-18
C232	a_116_388#	A#1	1.68734e-19
C233	a_302_388##15	B#1	2.64336e-18
C234	B#2	a_302_388##14	8.27315e-18
C235	a_116_388##2	C#6	2.01209e-17
C236	a_206_388##2	B#1	3.35907e-17
C237	VPWR#5	C#6	7.21103e-19
C238	a_302_388##15	A#1	1.26955e-18
C239	a_302_388##14	X#4	6.8162e-17
C240	a_116_388##2	B#1	3.05773e-17
C241	A#7	B#2	7.4104e-17
C242	a_302_388##7	a_302_388##5	4.68916e-17
C243	A#4	VGND#8	6.86388e-19
C244	a_206_388##2	A#1	6.83396e-19
C245	X#3	a_302_388##9	3.20107e-18
C246	X	a_302_388##9	6.85789e-20
C247	VPWR#5	B#1	6.39547e-18
C248	X	a_302_388##2	1.7696e-17
C249	A#4	a_302_388##17	1.87885e-18
C250	a_116_388#	VPWR#4	2.02414e-17
C251	a_116_388##2	A#1	3.45446e-17
C252	A#4	VGND#9	1.32278e-18
C253	a_206_388#	VPWR#4	2.9834e-17
C254	VPWR#5	A#1	3.08459e-17
C255	X#2	a_302_388##14	5.96111e-17
C256	A#7	A#2	6.3507e-17
C257	a_302_388##18	A#4	5.07766e-17
C258	VPWR#6	a_302_388##4	7.87338e-19
C259	a_302_388##11	a_302_388##7	4.81638e-17
C260	X#5	a_302_388##4	1.06193e-18
C261	a_206_388##2	VPWR#4	1.52959e-17
C262	VGND#9	B#4	3.10413e-19
C263	a_302_388##16	a_302_388##14	1.55945e-18
C264	a_302_388##12	a_302_388##11	4.87774e-17
C265	VPWR#4	VPWR#5	5.49164e-17
C266	VPWR#7	A#4	5.26874e-19
C267	A#5	a_302_388##12	3.79538e-17
C268	A#4	a_302_388##15	2.64566e-18
C269	a_116_388#	B#4	6.92253e-19
C270	a_206_388#	B#4	2.21507e-19
C271	B#5	A#5	3.3562e-17
C272	a_302_388##15	B#4	2.415e-18
C273	VGND#4	A#3	1.77853e-18
C274	C#5	B#5	3.31436e-17
C275	VGND#4	B#3	3.77837e-19
C276	B#2	a_116_388#	7.90375e-20
C277	B#2	a_206_388#	3.95187e-19
C278	A#4	a_302_388##10	2.35129e-18
C279	B#2	a_302_388##15	9.66381e-17
C280	VGND	a_302_388##9	4.97058e-20
C281	C#6	C#5	4.83897e-17
C282	VGND	a_302_388##2	4.93376e-20
C283	A#4	A#3	3.24671e-18
C284	B#2	a_206_388##2	6.63962e-19
C285	VGND	C#3	7.60968e-18
C286	B#2	a_116_388##2	1.67033e-17
C287	A#4	B#3	1.6428e-17
C288	VPWR#5	B#2	2.97288e-20
C289	A#4	C#1	4.58095e-18
C290	A#7	B	1.5923e-17
C291	B#1	C#6	3.71339e-17
C292	VPWR#4	A#5	2.95287e-18
C293	VPWR#5	A#2	1.03779e-17
C294	VPWR#4	B#5	4.29598e-18
C295	A#1	B#1	4.26457e-17
C296	VPWR#4	C#5	5.22033e-18
C297	VPWR#4	C#6	5.22033e-18
C298	A#4	a_302_388##12	2.95698e-19
C299	VGND#3	a_302_388##9	4.86332e-20
C300	B#4	A#5	6.64025e-18
C301	A#7	C	5.45802e-17
C302	VGND#2	VGND#1	9.43065e-19
C303	C#5	B#4	8.12337e-18
C304	X	X#4	4.10179e-19
C305	B#2	a_302_388##12	2.92747e-19
C306	a_302_388##14	X	2.58167e-17
C307	B#2	A#5	1.90943e-18
C308	B#2	C#5	9.05e-18
C309	VPWR	VPWR#3	1.93502e-17
C310	B#2	C#6	2.03051e-17
C311	C	VGND#9	2.58011e-18
C312	VPWR	VPWR#2	4.04161e-17
C313	VGND#2	X#1	1.36893e-17
C314	VPWR	X#4	3.66203e-18
C315	C	a_302_388##18	5.33859e-17
C316	VGND#4	A#4	9.21783e-20
C317	VPWR#4	B#4	5.27773e-20
C318	X	VGND#1	3.08626e-17
C319	VPWR	a_302_388##14	1.16369e-17
C320	A#1	B#2	4.17771e-18
C321	VGND#9	C#3	8.17732e-19
C322	VGND#2	a_302_388##9	8.84239e-22
C323	a_302_388##9	VNB	2.77769e-17
C324	A	VPWR#5	2.34617e-17
C325	a_302_388##2	VNB	3.62088e-17
C326	C#3	VNB	1.13052e-16
C327	C#2	VNB	2.65304e-17
C328	VGND	VGND#3	1.8908e-17
C329	VGND	VGND#2	3.94091e-17
C330	X	VPWR#1	2.71377e-17
C331	B#4	A#4	4.01557e-17
C332	VGND	X#4	4.07172e-18
C333	VGND	X#2	3.34361e-18
C334	VGND	a_302_388##16	2.24431e-17
C335	VGND	a_302_388##14	7.7012e-18
C336	A#4	B#2	9.64211e-17
C337	VGND#3	X#3	5.12378e-18
C338	VGND	A#7	2.81457e-17
C339	VPWR	VPWR#1	3.48772e-17
C340	B#2	B#4	2.0667e-17
C341	VPWR	X#6	1.6164e-17
C342	C	B#3	3.39948e-19
C343	VPWR	X#5	1.21597e-17
C344	X	a_302_388#	1.88679e-19
C345	C	C#1	1.82154e-18
C346	VGND	VGND#1	3.95146e-17
C347	VPWR	VPWR#7	2.21992e-17
C348	X	a_302_388##6	5.3403e-20
C349	VGND	X#1	1.31891e-17
C350	VPWR	a_116_388#	2.19075e-17
C351	X	a_302_388##8	1.3671e-20
C352	VPWR	a_206_388#	1.93788e-17
C353	VGND	X#3	1.17913e-17
C354	X	a_302_388##10	7.79517e-21
C355	VGND	VGND#8	1.57457e-17
C356	VPWR	a_302_388##15	6.0409e-18
C357	VPWR	a_206_388##2	1.89837e-17
C358	VGND#2	X#3	5.63749e-18
C359	VGND	VGND#9	1.55935e-17
C360	VPWR	a_116_388##2	7.53412e-18
C361	A#2	B#2	3.09604e-17
C362	VGND	a_302_388##18	1.71593e-17
C363	VPWR	VPWR#5	5.25865e-17
C364	VGND	X#5	1.25543e-18
C365	VGND#2	a_302_388##2	5.87174e-20
C366	C#3	a_302_388##18	1.79913e-17
C367	VGND	VPWR#5	2.71984e-18
C368	VGND	a_302_388#	3.11045e-19
C369	VPWR	a_302_388##5	1.54268e-18
C370	VGND#3	VNB	2.32865e-17
C371	VGND	a_302_388##6	3.27666e-20
C372	VPWR	a_302_388##7	8.66318e-19
C373	VGND#2	VNB	3.26722e-17
C374	VGND	a_302_388##8	6.9092e-19
C375	VPWR#3	VNB	2.35127e-17
C376	VPWR	a_302_388##11	1.65259e-18
C377	X#2	VGND#1	3.41504e-18
C378	VPWR#2	VNB	3.18261e-17
C379	VGND	a_302_388##10	6.83048e-20
C380	X#4	VNB	2.89069e-18
C381	VPWR	a_302_388##12	3.52809e-18
C382	X#2	VNB	1.12519e-18
C383	VGND	A#3	9.14812e-19
C384	a_302_388##16	VNB	2.59674e-18
C385	a_302_388##14	VNB	1.78612e-18
C386	VGND	B#3	4.38005e-19
C387	VPWR	A#5	7.7978e-18
C388	VGND	C#1	8.52298e-19
C389	A	B#4	8.19639e-20
C390	VGND#8	VGND#2	1.76209e-19
C391	VPWR	B#5	9.37897e-18
C392	A#7	VNB	4.5634e-17
C393	VPWR	C#5	9.73686e-18
C394	B	A#2	1.32254e-17
C395	VPWR	C#6	9.73686e-18
C396	C#2	a_302_388##18	3.16902e-18
C397	VPWR	B#1	9.37636e-18
C398	A	B#2	7.25826e-19
C399	VGND#1	VNB	5.23338e-17
C400	X#1	VNB	2.39239e-18
C401	VPWR	A#1	7.71134e-18
C402	VGND#7	VNB	2.18511e-19
C403	X	a_302_388##4	6.44002e-19
C404	X#3	VNB	4.84539e-18
C405	A	A#2	2.2225e-17
C406	VGND#8	VNB	8.99717e-19
C407	VGND#9	VNB	1.41035e-18
C408	VPWR	VPWR#4	3.80078e-17
C409	VPWR#1	VNB	6.61896e-17
C410	X#6	VNB	3.08937e-18
C411	VPWR#6	VNB	4.09278e-19
C412	C	A#2	9.86553e-18
C413	X#5	VNB	5.11636e-18
C414	VPWR#7	VNB	2.43487e-18
C415	a_116_388#	VNB	2.79686e-18
C416	a_206_388#	VNB	3.6669e-18
C417	VPWR	A#4	2.7601e-18
C418	a_206_388##2	VNB	3.56253e-18
C419	a_116_388##2	VNB	2.78896e-20
C420	VPWR#5	VNB	1.00646e-16
C421	a_302_388#	VNB	2.93342e-17
C422	VGND	VGND#4	8.39816e-18
C423	a_302_388##6	VNB	2.94404e-17
C424	X#2	X#1	8.3333e-19
C425	a_302_388##8	VNB	2.49478e-17
C426	VGND	a_302_388##4	1.24817e-19
C427	VPWR	B#2	8.2104e-18
C428	a_302_388##10	VNB	2.73965e-17
C429	A#3	VNB	2.6308e-17
C430	VGND	A#4	7.97273e-18
C431	A	B	2.68544e-17
C432	B#3	VNB	2.65266e-17
C433	VPWR	A#2	5.46144e-19
C434	C#1	VNB	2.63749e-17
C435	a_302_388##5	VNB	4.38596e-17
C436	a_302_388##7	VNB	3.21605e-17
C437	a_302_388##11	VNB	3.04852e-17
C438	VGND	B#2	7.24899e-18
C439	a_302_388##12	VNB	3.53289e-17
C440	A#5	VNB	3.66305e-17
C441	VGND	A#2	1.08277e-17
C442	B#5	VNB	3.21654e-17
C443	C#5	VNB	3.76131e-17
C444	C#6	VNB	3.67717e-17
C445	B#1	VNB	3.15905e-17
C446	A#1	VNB	4.62827e-17
C447	VPWR	B	9.70244e-19
C448	VPWR#4	VNB	2.6667e-16
C449	VGND#4	VNB	2.31153e-16
C450	VPWR	A	2.76558e-18
C451	a_302_388##4	VNB	6.75137e-17
C452	A#4	VNB	3.67761e-17
C453	VGND	B	1.02963e-18
C454	B#4	VNB	3.54727e-17
C455	B#2	VNB	4.13472e-17
C456	VPWR	X	2.52435e-18
C457	A#2	VNB	1.82791e-16
C458	VGND	C	1.58417e-17
C459	VGND	X	3.79167e-18
C460	B	VNB	1.03201e-18
C461	A	VNB	1.4877e-17
C462	C	VNB	6.86665e-18
C463	X	VNB	5.32583e-17
C464	VPWR	VNB	8.1025e-17
C465	VGND	VNB	6.71272e-17
C466	X#2	VGND#7	1.54417e-17
C467	VPWR#3	a_302_388##9	4.57114e-20
C468	a_116_388##3	a_116_388##2	2.96726e-18
C469	VGND#5	VNB	8.69516e-17
C470	a_116_388##3	a_206_388##2	1.65345e-17
C471	a_116_388##3	VNB	2.33309e-18
C472	VGND	VGND#5	6.45451e-17
C473	VGND#5	B#3	5.45764e-19
C474	VGND#5	B#2	4.36776e-19
C475	a_116_388##3	A#1	1.39269e-17
C476	a_116_388##3	a_302_388##15	6.20052e-18
C477	VGND#5	C#3	1.09172e-17
C478	a_116_388##3	B#1	9.86124e-18
C479	a_116_388##3	C#6	1.12982e-18
C480	B#2	a_116_388##3	1.19553e-17
C481	A#7	a_116_388##3	1.22456e-18
C482	VPWR	a_116_388##3	1.08238e-17
C483	VGND#5	a_302_388##18	1.77478e-17
C484	VGND#5	C#1	2.70908e-18
C485	VGND#5	A#2	1.01646e-17
C486	VGND#5	C#2	1.20805e-19
C487	VGND#5	A#7	2.95426e-17
C488	VGND#5	VGND#3	9.5684e-19
C489	VGND#5	C	2.73601e-17
C490	B	a_116_388##3	1.48943e-17
C491	VGND#5	a_302_388##16	1.95443e-19
C492	VGND#4	VGND#5	1.03239e-16
C493	VPWR#5	a_116_388##3	4.63401e-17
*
*
.ENDS sky130_fd_sc_hs__or3_4
*
