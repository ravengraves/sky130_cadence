* Extracted by Quantus, converted by sky130cad/quantus.py
*
*
*
*                       LINUX           Wed Nov 18 09:05:30 2026
*
*
*
*  PROGRAM  advgen
*
*  Name           : advgen - Quantus - (64-bit)
*  Version        : 25.1.0-p047
*  Build Date     : Thu Dec 11 23:20:30 PST 2025
*
*  HSPICE LIBRARY
*
*  OPERATING_TEMPERATURE 150
*  QRC_TECH_DIR <path>/tech
*
*
*

*
.SUBCKT sky130_fd_sc_hs__or2b_1 VNB VPB VGND VPWR X B_N A
*
*
*  caps2d version: 10
*
*
*       TRANSISTOR CARDS
*
*
XM0 a_27_112##8 B_N#1 VGND#7 VNB sky130_fd_pr__nfet_01v8_lvt l=0.15 w=0.55 ad=0.3685 as=0.34925 pd=2.44 ps=2.37
XM7 VGND#7 a_27_112##4 a_264_368##7 VNB sky130_fd_pr__nfet_01v8_lvt l=0.15 w=0.55 ad=0.34925 as=0.154 pd=2.37 ps=1.66
XM1 a_264_368##7 A#3 VGND#6 VNB sky130_fd_pr__nfet_01v8_lvt l=0.15 w=0.55 ad=0.154 as=0.38645 pd=1.66 ps=2.64
XM2 VGND#6 a_264_368# X#1 VNB sky130_fd_pr__nfet_01v8_lvt l=0.15 w=0.74 ad=0.38645 as=0.2109 pd=2.64 ps=2.05
XM6 a_27_112##7 B_N#4 VPWR#7 VPB sky130_fd_pr__pfet_01v8 l=0.15 w=0.84 ad=0.2478 as=0.2898 pd=2.27 ps=2.37
XM3 a_264_368##6 a_27_112# a_353_368# VPB sky130_fd_pr__pfet_01v8 l=0.15 w=1 ad=0.295 as=0.27 pd=2.59 ps=2.54
XM4 a_353_368# A#1 VPWR#6 VPB sky130_fd_pr__pfet_01v8 l=0.15 w=1 ad=0.27 as=0.4764 pd=2.54 ps=3.11
XM5 VPWR#6 a_264_368##3 X#2 VPB sky130_fd_pr__pfet_01v8 l=0.15 w=1.12 ad=0.4764 as=0.3304 pd=3.11 ps=2.83
*
*
*       RESISTOR AND CAP/DIODE CARDS
*
Rg1	B_N#1	B_N#2	429.895599
Rg2	B_N#2	B_N#3	38.752129
Rg3	B_N#2	B_N#4	530.088013
Rg4	a_27_112#	a_27_112##2	494.230865
Rg5	a_27_112##2	a_27_112##3	47.331097
Rg6	a_27_112##2	a_27_112##4	371.880157
Rg7	A#1	A#2	398.521515
Rg8	A#2	A#3	326.336823
Rg9	a_264_368#	a_264_368##2	353.846649
Rg10	a_264_368##2	a_264_368##3	456.846832
Rf1	B_N	B_N#5	0.882458
Rf2	B_N#6	B_N#3	161.115265
Rf3	B_N#5	B_N#6	3.543054
Rf4	a_27_112##3	a_27_112##6	181.117142
Rf5	a_27_112##6	a_27_112##7	85.258377
Rf6	a_27_112##6	a_27_112##8	56.952911
Rf7	A#4	A#2	160.844009
Rf8	A	A#6	0.611206
Rf9	A#4	A#6	5.905091
Rf10	a_264_368##2	a_264_368##5	221.349365
Rf11	a_264_368##5	a_264_368##6	93.841972
Rf12	a_264_368##5	a_264_368##7	25.285515
Rf13	X#1	X	86.530853
Rf14	X	X#3	9.285030
Rf15	X#3	X	0.127192
Rf16	X#2	X#3	5.000000
Rf18	VGND#2	VGND#3	57.832882
Rf19	VGND#3	VGND#4	30.441013
Rf21	VGND#2	VGND#6	33.989296
Rf22	VGND#4	VGND#7	26.415836
Rf24	VPWR#2	VPWR#3	54.032833
Rf25	VPWR#3	VPWR#4	65.720917
Rf27	VPWR#2	VPWR#6	35.727165
Rf28	VPWR#4	VPWR#7	35.274624
Re1	VPWR#3	VPWR	1.403190
Re2	VGND	VGND#3	1.403242
*
*       CAPACITOR CARDS
*
*
C1	VGND	VNB	5.65428e-17
C2	VPWR	VNB	7.28035e-17
C3	A	VNB	9.18464e-19
C4	B_N#3	VNB	6.84189e-17
C5	a_27_112##3	VNB	7.34466e-17
C6	A#2	VNB	3.1293e-17
C7	a_264_368##2	VNB	5.07421e-17
C8	VGND#3	VNB	1.67879e-16
C9	VPWR#3	VNB	1.77659e-16
C10	B_N#4	VNB	5.33049e-17
C11	a_27_112#	VNB	3.84593e-17
C12	A#1	VNB	3.36571e-17
C13	a_264_368##3	VNB	4.20447e-17
C14	B_N#1	VNB	5.45007e-17
C15	a_27_112##4	VNB	3.08216e-17
C16	A#3	VNB	3.22704e-17
C17	a_264_368#	VNB	3.3387e-17
C18	a_27_112##7	VNB	5.58621e-17
C19	VPWR	A	4.04949e-18
C20	VPWR#7	VNB	1.76556e-17
C21	a_264_368##6	VNB	1.30319e-17
C22	VPWR#6	VNB	7.19458e-18
C23	X#2	VNB	8.36693e-17
C24	a_27_112##8	VNB	2.22916e-17
C25	VGND#7	VNB	9.82746e-18
C26	VGND	B_N#3	1.48851e-18
C27	VGND#6	VNB	5.01074e-18
C28	X#1	VNB	5.02148e-17
C29	B_N#5	VNB	1.04657e-17
C30	VGND	a_27_112##3	3.79045e-18
C31	B_N#6	VNB	1.04691e-17
C32	a_27_112##6	VNB	1.08623e-17
C33	A#4	VNB	2.6804e-18
C34	VGND	a_264_368##2	4.73493e-18
C35	VGND	VGND#3	1.02188e-17
C36	a_264_368##5	VNB	5.1032e-18
C37	VPWR	a_27_112##3	7.13296e-18
C38	VPWR	a_264_368##2	3.36936e-18
C39	VPWR	VPWR#3	1.74789e-17
C40	VGND	B_N#1	7.46826e-18
C41	VGND	a_27_112##4	7.79466e-18
C42	VPWR	B_N#4	1.45261e-18
C43	VGND	A#3	9.67613e-18
C44	VPWR	a_27_112#	9.28394e-18
C45	VGND	a_264_368#	1.91856e-18
C46	VGND	a_27_112##7	3.18025e-18
C47	VPWR	A#1	7.43629e-18
C48	VPWR	a_264_368##3	4.31453e-18
C49	VGND	a_264_368##6	2.58136e-18
C50	A	a_27_112##3	1.00702e-18
C51	VPWR	B_N#1	3.28268e-19
C52	A	A#2	6.2039e-18
C53	VGND	X#2	2.35494e-18
C54	VGND	a_27_112##8	2.10796e-17
C55	A	a_264_368##2	6.33227e-18
C56	VPWR	a_27_112##7	1.66552e-17
C57	VGND	X#1	2.06619e-17
C58	VPWR	VPWR#7	2.14202e-17
C59	VGND	B_N#5	3.64266e-18
C60	VPWR	a_264_368##6	1.94496e-17
C61	VPWR	VPWR#6	2.12409e-17
C62	VGND	a_27_112##6	8.27425e-19
C63	VGND	A#4	2.81221e-18
C64	VPWR	X#2	2.4888e-17
C65	a_27_112##6	a_264_368##5	1.68004e-18
C66	A	a_27_112#	7.17378e-19
C67	VGND	a_264_368##5	1.57683e-17
C68	A	A#1	6.92827e-18
C69	A	a_264_368##3	2.00051e-18
C70	B_N#3	a_27_112##3	3.3312e-18
C71	VPWR	B_N#6	2.35633e-18
C72	VPWR	a_27_112##6	2.99284e-18
C73	a_264_368##5	A#4	4.87718e-17
C74	a_27_112##3	A#2	2.67104e-17
C75	VGND#3	B_N#3	1.12751e-20
C76	a_264_368##2	a_27_112##3	2.90188e-19
C77	a_27_112#	a_353_368#	2.45803e-17
C78	A#1	a_353_368#	2.16065e-17
C79	A#2	a_264_368##2	3.26747e-17
C80	a_264_368##6	A	1.97498e-17
C81	a_27_112##3	VPWR#3	4.41963e-19
C82	A	VPWR#6	1.55289e-17
C83	A	X#2	3.92484e-18
C84	B_N#3	a_27_112#	5.71776e-19
C85	a_27_112#	A#2	1.29942e-18
C86	a_264_368##6	a_353_368#	1.89811e-18
C87	A#2	a_264_368##3	6.66717e-19
C88	B_N#1	a_27_112##3	1.27969e-17
C89	a_27_112##7	B_N#3	1.39364e-17
C90	a_264_368##5	A	2.7259e-18
C91	a_27_112##3	A#3	1.06564e-18
C92	VPWR#3	a_27_112#	4.68311e-18
C93	VPWR#7	B_N#3	1.07436e-18
C94	a_264_368##6	B_N#3	3.86214e-19
C95	B_N#4	a_27_112#	4.98042e-18
C96	VGND#3	B_N#1	5.63755e-22
C97	a_264_368##6	a_27_112##3	3.69534e-17
C98	A#3	a_264_368##2	3.86873e-19
C99	VGND#3	a_27_112##4	4.35041e-18
C100	a_264_368##2	a_264_368#	4.12127e-18
C101	B_N#3	a_27_112##8	1.25711e-17
C102	B_N#4	a_264_368##3	3.68093e-20
C103	a_27_112#	A#1	5.47295e-17
C104	a_264_368##6	A#2	1.33516e-18
C105	A#2	VPWR#6	3.81093e-18
C106	a_27_112##3	VGND#7	6.25571e-17
C107	A#1	a_264_368##3	2.66532e-17
C108	X#2	A#2	8.06411e-19
C109	B_N#5	B_N#3	9.62405e-18
C110	B_N#6	B_N#3	1.23635e-17
C111	a_264_368##2	VPWR#6	9.22131e-18
C112	a_264_368##2	X#2	5.87522e-17
C113	a_264_368##6	VPWR#3	1.26672e-17
C114	a_27_112##6	B_N#3	1.918e-17
C115	VGND#6	A#2	1.34133e-18
C116	a_27_112##7	B_N#4	4.71229e-17
C117	X#1	A#2	1.3825e-21
C118	VPWR#7	B_N#4	2.5214e-17
C119	a_264_368##2	VGND#6	2.98602e-17
C120	a_27_112##6	a_27_112##3	4.73077e-19
C121	a_27_112##7	a_27_112#	2.53114e-19
C122	a_264_368##2	X#1	4.13955e-17
C123	a_264_368##6	B_N#4	4.67432e-18
C124	A#4	a_27_112##3	2.28055e-18
C125	VPWR#7	a_27_112#	4.52482e-18
C126	a_264_368##6	a_27_112#	7.70463e-17
C127	B_N#1	a_27_112##4	8.37704e-18
C128	VPWR#6	B_N#4	1.14802e-18
C129	VPWR#7	A#1	5.62869e-19
C130	A#4	A#2	9.45286e-18
C131	a_264_368##5	a_27_112##3	4.01576e-17
C132	a_264_368##6	A#1	9.83786e-18
C133	VPWR#7	a_264_368##3	9.97257e-19
C134	VPWR#6	a_27_112#	7.78258e-18
C135	a_27_112##4	A#3	3.09179e-17
C136	a_264_368##2	A#4	2.84695e-17
C137	X#2	a_27_112#	4.35688e-19
C138	a_264_368##6	a_264_368##3	3.65406e-18
C139	A#1	VPWR#6	3.96215e-17
C140	a_264_368##5	A#2	5.92777e-18
C141	X#2	A#1	3.85053e-18
C142	VPWR#7	B_N#1	1.9691e-18
C143	A#3	a_264_368#	1.15062e-17
C144	a_264_368##3	VPWR#6	3.83479e-17
C145	a_264_368##5	a_264_368##2	2.51926e-18
C146	X#2	a_264_368##3	5.33421e-17
C147	VGND#3	a_264_368##5	8.43571e-18
C148	a_27_112##7	VPWR#7	7.83586e-17
C149	a_27_112##8	B_N#1	3.15584e-17
C150	a_27_112##6	B_N#4	4.98588e-18
C151	B_N#1	VGND#7	3.16706e-17
C152	a_27_112##7	a_264_368##6	2.36497e-18
C153	a_27_112##8	a_27_112##4	1.07624e-19
C154	a_27_112##6	a_27_112#	1.76963e-18
C155	VPWR#7	a_264_368##6	4.20599e-17
C156	a_27_112##4	VGND#7	2.15075e-17
C157	VGND#6	B_N#1	2.99794e-19
C158	a_27_112##4	a_264_368##7	1.10962e-17
C159	VGND#7	A#3	1.60701e-18
C160	VGND#6	a_27_112##4	7.5787e-19
C161	VPWR#7	VPWR#6	2.21653e-18
C162	A#3	a_264_368##7	1.10962e-17
C163	VGND#7	a_264_368#	4.60941e-19
C164	a_27_112##8	a_27_112##7	1.95172e-18
C165	a_264_368##6	VPWR#6	2.87709e-17
C166	A#3	VGND#6	2.38304e-17
C167	X#1	A#3	1.8658e-18
C168	a_264_368##6	X#2	4.60348e-18
C169	a_264_368#	VGND#6	2.29398e-17
C170	X#1	a_264_368#	3.52377e-17
C171	a_27_112##6	B_N#1	1.55572e-17
C172	VPWR#6	X#2	9.31475e-17
C173	a_27_112##6	a_27_112##4	3.93005e-19
C174	B_N#6	a_27_112##7	2.68424e-17
C175	a_264_368##5	B_N#1	2.20189e-18
C176	a_27_112##8	VGND#7	4.18476e-17
C177	a_264_368##5	a_27_112##4	1.93429e-17
C178	a_27_112##6	VPWR#7	2.94052e-17
C179	a_264_368##5	A#3	3.88528e-17
C180	X#1	X#2	4.03994e-18
C181	a_27_112##6	a_264_368##6	8.40831e-18
C182	VGND#7	VGND#6	3.05019e-18
C183	a_264_368##5	a_264_368#	9.11934e-19
C184	a_27_112##8	B_N#5	3.21586e-17
C185	VGND#6	X#1	3.93021e-17
C186	a_27_112##6	a_27_112##8	9.83649e-19
C187	VGND#7	a_27_112##6	3.35049e-18
C188	a_27_112##8	a_264_368##5	3.04452e-19
C189	B_N#5	a_27_112##6	1.04943e-17
C190	VGND#7	a_264_368##5	6.1724e-17
C191	B_N#6	a_27_112##6	1.74775e-17
C192	a_264_368##5	a_264_368##7	3.48171e-19
C193	a_264_368##5	VGND#6	3.21402e-17
C194	a_264_368##5	X#1	2.19011e-18
C195	VGND#2	a_264_368#	1.02761e-17
C196	VGND#2	A#3	3.8835e-18
C197	VGND#4	VGND#2	1.72015e-18
C198	VGND#3	VGND#2	5.78973e-17
C199	VGND#2	a_264_368##2	4.41816e-19
C200	VGND#2	a_264_368##5	1.37447e-18
C201	VGND	VGND#2	6.41983e-17
C202	VGND#2	VNB	5.45773e-17
C203	VGND#2	X#1	2.43073e-17
C204	VGND#4	VNB	7.43794e-17
C205	VGND	VGND#4	7.96684e-17
C206	a_27_112##6	VPWR#4	5.049e-20
C207	VPWR#2	VNB	5.06262e-17
C208	VPWR#4	VNB	5.17385e-17
C209	a_264_368##2	VPWR#2	3.44148e-19
C210	VPWR#4	B_N#3	1.74453e-19
C211	VGND#4	B_N#3	1.64066e-18
C212	VGND#3	VGND#4	6.76173e-17
C213	a_27_112##3	VPWR#4	1.48219e-18
C214	VPWR#3	VPWR#2	5.77451e-17
C215	VPWR#4	VPWR#2	3.27808e-19
C216	VPWR	VPWR#2	3.86125e-17
C217	VGND#4	B_N#1	2.35402e-18
C218	VPWR	VPWR#4	3.66465e-17
C219	VGND#4	a_264_368#	1.19131e-18
C220	X#2	VPWR#2	3.02673e-17
C221	A	VPWR#2	7.35054e-19
C222	VGND#4	a_27_112##8	1.45745e-17
C223	VPWR#2	A#1	1.72649e-17
C224	VPWR#3	VPWR#4	5.45753e-17
C225	VGND#4	VGND#6	2.39328e-18
C226	a_27_112##7	VPWR#4	2.08977e-17
C227	VPWR#2	a_264_368##3	4.63558e-18
C228	VGND#4	a_27_112##6	1.52959e-19
C229	VPWR#4	B_N#4	2.55622e-18
*
*
.ENDS sky130_fd_sc_hs__or2b_1
*
