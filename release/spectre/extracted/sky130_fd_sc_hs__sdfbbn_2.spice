* Extracted by Quantus, converted by sky130cad/quantus.py
*
*
*
*                       LINUX           Wed Nov 18 09:08:59 2026
*
*
*
*  PROGRAM  advgen
*
*  Name           : advgen - Quantus - (64-bit)
*  Version        : 25.1.0-p047
*  Build Date     : Thu Dec 11 23:20:30 PST 2025
*
*  HSPICE LIBRARY
*
*  OPERATING_TEMPERATURE 150
*  QRC_TECH_DIR <path>/tech
*
*
*

*
.SUBCKT sky130_fd_sc_hs__sdfbbn_2 VNB VPB VGND SET_B VPWR Q_N Q SCD SCE CLK_N D RESET_B
*
*
*  caps2d version: 10
*
*
*       TRANSISTOR CARDS
*
*
XM27 VGND#13 SCD#3 a_119_119# VNB sky130_fd_pr__nfet_01v8_lvt l=0.15 w=0.42 ad=0.1197 as=0.1008 pd=1.41 ps=1.32
XM49 a_119_119# SCE#3 a_197_119##5 VNB sky130_fd_pr__nfet_01v8_lvt l=0.15 w=0.42 ad=0.1008 as=0.2856 pd=1.32 ps=2.2
XM46 a_197_119##5 D#1 a_363_119# VNB sky130_fd_pr__nfet_01v8_lvt l=0.15 w=0.42 ad=0.2856 as=0.1008 pd=2.2 ps=1.32
XM28 a_363_119# a_341_410##4 VGND#20 VNB sky130_fd_pr__nfet_01v8_lvt l=0.15 w=0.42 ad=0.1008 as=0.2226 pd=1.32 ps=1.9
XM16 VGND#20 SCE#2 a_341_410##8 VNB sky130_fd_pr__nfet_01v8_lvt l=0.15 w=0.42 ad=0.2226 as=0.1197 pd=1.9 ps=1.41
XM38 a_688_98##11 CLK_N#3 VGND#19 VNB sky130_fd_pr__nfet_01v8_lvt l=0.15 w=0.74 ad=0.2109 as=0.6005 pd=2.05 ps=3.48
XM17 VGND#19 a_688_98##4 a_868_368##12 VNB sky130_fd_pr__nfet_01v8_lvt l=0.15 w=0.74 ad=0.6005 as=0.2109 pd=3.48 ps=2.05
XM29 VGND#18 a_1007_366# a_1185_125# VNB sky130_fd_pr__nfet_01v8_lvt l=0.15 w=0.42 ad=0.24385 as=0.0882 pd=2.14 ps=1.26
XM30 a_1185_125# a_688_98##2 a_1154_464##5 VNB sky130_fd_pr__nfet_01v8_lvt l=0.15 w=0.42 ad=0.0882 as=0.1281 pd=1.26 ps=1.45
XM3 a_1154_464##5 a_868_368##3 a_197_119##2 VNB sky130_fd_pr__nfet_01v8_lvt l=0.15 w=0.42 ad=0.1281 as=0.1491 pd=1.45 ps=1.55
XM11 a_1473_73##2 a_1154_464# a_1007_366##14 VNB sky130_fd_pr__nfet_01v8_lvt l=0.15 w=0.55 ad=0.3531 as=0.154 pd=2.54 ps=1.66
XM24 a_1007_366##14 a_1643_257# a_1473_73# VNB sky130_fd_pr__nfet_01v8_lvt l=0.15 w=0.55 ad=0.154 as=0.25025 pd=1.66 ps=2.01
XM14 a_1473_73# SET_B#1 VGND#17 VNB sky130_fd_pr__nfet_01v8_lvt l=0.15 w=0.55 ad=0.25025 as=0.1925 pd=2.01 ps=1.8
XM31 VGND#17 a_1007_366##6 a_1902_125# VNB sky130_fd_pr__nfet_01v8_lvt l=0.15 w=0.55 ad=0.1925 as=0.216375 pd=1.8 ps=2.18
XM34 a_1902_125# a_688_98##6 a_1997_82##7 VNB sky130_fd_pr__nfet_01v8_lvt l=0.15 w=0.55 ad=0.216375 as=0.4945 pd=2.18 ps=3.3
XM12 a_1997_82##7 a_868_368##7 a_2247_82# VNB sky130_fd_pr__nfet_01v8_lvt l=0.15 w=0.42 ad=0.4945 as=0.1008 pd=3.3 ps=1.32
XM43 a_2247_82# a_2216_410##3 VGND#16 VNB sky130_fd_pr__nfet_01v8_lvt l=0.15 w=0.42 ad=0.1008 as=0.34705 pd=1.32 ps=2.79
XM18 VGND#16 SET_B#6 a_2452_74##2 VNB sky130_fd_pr__nfet_01v8_lvt l=0.15 w=0.74 ad=0.34705 as=0.2738 pd=2.79 ps=2.22
XM36 a_2452_74##2 a_1643_257##6 a_2216_410##22 VNB sky130_fd_pr__nfet_01v8_lvt l=0.15 w=0.74 ad=0.2738 as=0.2072 pd=2.22 ps=2.04
XM45 a_2216_410##22 a_1997_82# a_2452_74# VNB sky130_fd_pr__nfet_01v8_lvt l=0.15 w=0.74 ad=0.2072 as=0.30055 pd=2.04 ps=2.42
XM44 a_1643_257##11 RESET_B#3 VGND#15 VNB sky130_fd_pr__nfet_01v8_lvt l=0.15 w=0.42 ad=0.1176 as=0.37775 pd=1.4 ps=3.66
XM39 VGND#15 a_2216_410##15 Q_N#1 VNB sky130_fd_pr__nfet_01v8_lvt l=0.15 w=0.74 ad=0.37775 as=0.2072 pd=3.66 ps=2.04
XM33 Q_N#1 a_2216_410##13 VGND#14 VNB sky130_fd_pr__nfet_01v8_lvt l=0.15 w=0.74 ad=0.2072 as=0.2294 pd=2.04 ps=2.1
XM15 a_3272_94##9 a_2216_410##11 VGND#4 VNB sky130_fd_pr__nfet_01v8_lvt l=0.15 w=0.64 ad=0.1824 as=0.3235 pd=1.85 ps=2.38
XM4 Q#2 a_3272_94##5 VGND#4 VNB sky130_fd_pr__nfet_01v8_lvt l=0.15 w=0.74 ad=0.2072 as=0.3235 pd=2.04 ps=2.38
XM42 VGND#1 a_3272_94# Q#2 VNB sky130_fd_pr__nfet_01v8_lvt l=0.15 w=0.74 ad=0.2072 as=0.2072 pd=2.04 ps=2.04
XM41 a_27_464##2 SCD#1 VPWR#25 VPB sky130_fd_pr__pfet_01v8 l=0.15 w=0.64 ad=0.1888 as=0.192 pd=1.87 ps=1.88
XM19 VPWR#25 SCE#5 a_206_464# VPB sky130_fd_pr__pfet_01v8 l=0.15 w=0.64 ad=0.192 as=0.1536 pd=1.88 ps=1.76
XM37 a_206_464# D#3 a_197_119##6 VPB sky130_fd_pr__pfet_01v8 l=0.15 w=0.64 ad=0.1536 as=0.192 pd=1.76 ps=1.88
XM10 a_197_119##6 a_341_410##3 a_27_464# VPB sky130_fd_pr__pfet_01v8 l=0.15 w=0.64 ad=0.192 as=0.1888 pd=1.88 ps=1.87
XM13 VPWR#23 SCE#1 a_341_410##5 VPB sky130_fd_pr__pfet_01v8 l=0.15 w=0.64 ad=0.1888 as=0.1888 pd=1.87 ps=1.87
XM26 a_688_98##9 CLK_N#1 VPWR#20 VPB sky130_fd_pr__pfet_01v8 l=0.15 w=1.12 ad=0.3304 as=0.336 pd=2.83 ps=2.84
XM0 VPWR#20 a_688_98##8 a_868_368##9 VPB sky130_fd_pr__pfet_01v8 l=0.15 w=1.12 ad=0.336 as=0.3304 pd=2.84 ps=2.83
XM48 VPWR#18 a_1007_366##3 a_1070_464# VPB sky130_fd_pr__pfet_01v8 l=0.15 w=0.42 ad=0.1239 as=0.1134 pd=1.43 ps=1.38
XM5 a_1070_464# a_868_368# a_1154_464##7 VPB sky130_fd_pr__pfet_01v8 l=0.15 w=0.42 ad=0.1134 as=0.2266 pd=1.38 ps=2.05
XM32 a_1154_464##7 a_688_98# a_197_119# VPB sky130_fd_pr__pfet_01v8 l=0.15 w=0.64 ad=0.2266 as=0.2208 pd=2.05 ps=1.97
XM1 a_1007_366##10 a_1154_464##4 a_1592_424# VPB sky130_fd_pr__pfet_01v8 l=0.15 w=0.84 ad=0.7476 as=0.2268 pd=3.46 ps=2.22
XM7 a_1592_424# a_1643_257##3 VPWR#16 VPB sky130_fd_pr__pfet_01v8 l=0.15 w=0.84 ad=0.2268 as=0.3276 pd=2.22 ps=2.46
XM20 VPWR#16 SET_B#3 a_1007_366##13 VPB sky130_fd_pr__pfet_01v8 l=0.15 w=0.84 ad=0.3276 as=0.2478 pd=2.46 ps=2.27
XM22 VPWR#14 a_1007_366##4 a_1986_424# VPB sky130_fd_pr__pfet_01v8 l=0.15 w=0.84 ad=0.2478 as=0.2016 pd=2.27 ps=2.16
XM23 a_1986_424# a_868_368##5 a_1997_82##6 VPB sky130_fd_pr__pfet_01v8 l=0.15 w=0.84 ad=0.2016 as=0.2856 pd=2.16 ps=2.45
XM2 a_1997_82##6 a_688_98##7 a_2171_508# VPB sky130_fd_pr__pfet_01v8 l=0.15 w=0.42 ad=0.2856 as=0.1008 pd=2.45 ps=1.32
XM40 a_2171_508# a_2216_410# VPWR#11 VPB sky130_fd_pr__pfet_01v8 l=0.15 w=0.42 ad=0.1008 as=0.1239 pd=1.32 ps=1.43
XM8 a_2216_410##16 SET_B#4 VPWR#9 VPB sky130_fd_pr__pfet_01v8 l=0.15 w=1 ad=0.295 as=0.36 pd=2.59 ps=2.72
XM50 VPWR#9 a_1643_257##4 a_2556_392# VPB sky130_fd_pr__pfet_01v8 l=0.15 w=1 ad=0.36 as=0.27 pd=2.72 ps=2.54
XM35 a_2556_392# a_1997_82##3 a_2216_410##18 VPB sky130_fd_pr__pfet_01v8 l=0.15 w=1 ad=0.27 as=0.295 pd=2.54 ps=2.59
XM6 a_1643_257##7 RESET_B#1 VPWR#7 VPB sky130_fd_pr__pfet_01v8 l=0.15 w=0.64 ad=0.1888 as=1.17153 pd=1.87 ps=4.69
XM25 VPWR#7 a_2216_410##14 Q_N#2 VPB sky130_fd_pr__pfet_01v8 l=0.15 w=1.12 ad=1.17153 as=0.336 pd=4.69 ps=2.84
XM51 Q_N#2 a_2216_410##12 VPWR#5 VPB sky130_fd_pr__pfet_01v8 l=0.15 w=1.12 ad=0.336 as=0.3192 pd=2.84 ps=2.81
XM9 a_3272_94##10 a_2216_410##4 VPWR#4 VPB sky130_fd_pr__pfet_01v8 l=0.15 w=1 ad=0.29 as=0.4076 pd=2.58 ps=2.99
XM21 VPWR#4 a_3272_94##6 Q#1 VPB sky130_fd_pr__pfet_01v8 l=0.15 w=1.12 ad=0.4076 as=0.336 pd=2.99 ps=2.84
XM47 Q#1 a_3272_94##4 VPWR#1 VPB sky130_fd_pr__pfet_01v8 l=0.15 w=1.12 ad=0.336 as=0.3304 pd=2.84 ps=2.83
*
*
*       RESISTOR AND CAP/DIODE CARDS
*
Rg1	SCD#1	SCD#2	360.927948
Rg2	SCD#2	SCD#3	269.031525
Rg3	D#1	D#2	435.216949
Rg4	D#2	D#3	524.359924
Rg5	a_341_410#	a_341_410##2	269.362183
Rg6	a_341_410##2	a_341_410##3	569.597900
Rg7	a_341_410##2	a_341_410##4	515.558716
Rg8	SCE#1	SCE#2	1331.148804
Rg9	SCE#2	SCE#3	1700.009766
Rg10	SCE#3	SCE#4	249.588074
Rg11	SCE#4	SCE#5	490.031738
Rg12	CLK_N#1	CLK_N#2	450.401886
Rg13	CLK_N#2	CLK_N#3	325.136932
Rg14	a_868_368#	a_868_368##2	534.095337
Rg15	a_1007_366#	a_1007_366##2	822.922485
Rg16	a_1007_366##2	a_1007_366##3	233.787552
Rg17	a_868_368##3	a_868_368##4	440.867310
Rg18	a_1154_464#	a_1154_464##2	243.013321
Rg19	a_1154_464##2	a_1154_464##3	406.514069
Rg20	a_1154_464##2	a_1154_464##4	573.146057
Rg21	a_1643_257#	a_1643_257##2	299.307709
Rg22	a_1643_257##2	a_1643_257##3	406.344635
Rg23	SET_B#1	SET_B#2	344.428619
Rg24	SET_B#2	SET_B#3	429.790710
Rg25	a_1007_366##4	a_1007_366##5	393.470032
Rg26	a_1007_366##5	a_1007_366##6	487.685638
Rg27	a_868_368##5	a_868_368##6	604.578552
Rg28	a_688_98#	a_688_98##2	1017.414551
Rg29	a_688_98##2	a_688_98##3	342.764954
Rg30	a_688_98##3	a_688_98##4	1230.705933
Rg31	a_688_98##4	a_688_98##5	365.182068
Rg32	a_688_98##3	a_688_98##6	2341.128906
Rg33	a_688_98##6	a_688_98##7	1516.512817
Rg34	a_688_98##5	a_688_98##8	449.442902
Rg35	a_868_368##7	a_868_368##8	402.624939
Rg36	a_2216_410#	a_2216_410##2	228.275131
Rg37	a_2216_410##2	a_2216_410##3	997.407898
Rg38	SET_B#4	SET_B#5	509.830780
Rg39	SET_B#5	SET_B#6	307.937683
Rg40	a_1643_257##4	a_1643_257##5	518.009277
Rg41	a_1643_257##5	a_1643_257##6	320.356293
Rg42	a_1997_82#	a_1997_82##2	451.403168
Rg43	a_1997_82##2	a_1997_82##3	400.207520
Rg44	RESET_B#1	RESET_B#2	296.912354
Rg45	RESET_B#2	RESET_B#3	259.159424
Rg46	a_2216_410##4	a_2216_410##5	471.267975
Rg47	a_2216_410##5	a_2216_410##6	199.518890
Rg48	a_2216_410##6	a_2216_410##7	23.403116
Rg49	a_2216_410##7	a_2216_410##8	64.029663
Rg50	a_2216_410##8	a_2216_410##9	22.292738
Rg51	a_2216_410##9	a_2216_410##10	320.935852
Rg52	a_2216_410##5	a_2216_410##11	375.035156
Rg53	a_2216_410##6	a_2216_410##12	433.238647
Rg54	a_2216_410##7	a_2216_410##13	394.638336
Rg55	a_2216_410##8	a_2216_410##14	433.238647
Rg56	a_2216_410##9	a_2216_410##15	423.462036
Rg57	a_3272_94#	a_3272_94##2	322.953644
Rg58	a_3272_94##2	a_3272_94##3	81.843414
Rg59	a_3272_94##2	a_3272_94##4	507.075531
Rg60	a_3272_94##3	a_3272_94##5	302.769196
Rg61	a_3272_94##3	a_3272_94##6	485.753845
Rf1	SCD	SCD#4	0.964345
Rf2	SCD#5	SCD#2	54.375278
Rf3	SCD#4	SCD#5	10.353502
Rf4	SCD	SCD#7	0.964345
Rf5	SCD#5	SCD#7	1.081709
Rf6	SCE#6	SCE	2.286683
Rf7	SCE#4	SCE#8	82.403084
Rf8	SCE#6	SCE#8	4.276989
Rf9	SCE#9	SCE	2.286683
Rf10	SCE#8	SCE#9	5.313834
Rf11	D#2	D	161.807495
Rf12	a_27_464#	a_27_464##2	193.700104
Rf13	a_341_410##5	a_341_410##6	58.128162
Rf14	a_341_410##6	a_341_410#	166.945938
Rf15	a_341_410##6	a_341_410##8	56.553131
Rf16	CLK_N#4	CLK_N#2	162.219223
Rf17	CLK_N	CLK_N#6	1.986418
Rf18	CLK_N#4	CLK_N#6	4.798750
Rf19	a_688_98##9	a_688_98##10	92.768135
Rf20	a_688_98##10	a_688_98##11	75.815353
Rf21	a_868_368##9	a_868_368##10	63.965069
Rf22	a_868_368##10	a_868_368##11	83.186890
Rf23	a_868_368##10	a_868_368##12	24.675297
Rf24	a_868_368##11	a_868_368##2	9.791353
Rf25	a_868_368##2	a_868_368##4	197.758957
Rf26	a_1154_464##5	a_1154_464##3	87.167778
Rf27	a_1154_464##3	a_1154_464##7	124.005653
Rf28	a_197_119#	a_197_119##3	243.211578
Rf29	a_197_119##3	a_197_119##4	527.174072
Rf30	a_197_119##4	a_197_119##5	68.475601
Rf31	a_197_119##4	a_197_119##6	129.103455
Rf32	a_197_119##2	a_197_119##3	15.000000
Rf33	a_1473_73#	a_1473_73##2	116.001167
Rf34	SET_B#7	SET_B#2	176.176544
Rf35	a_1007_366##5	a_1007_366##8	216.865067
Rf36	a_1007_366##8	a_1007_366##9	67.977913
Rf37	a_1007_366##9	a_1007_366##11	86.556282
Rf38	a_1007_366##11	a_1007_366##2	348.874969
Rf39	a_1007_366##8	a_1007_366##13	20.475231
Rf40	a_1007_366##9	a_1007_366##14	105.940483
Rf41	a_1007_366##10	a_1007_366##11	7.500000
Rf42	a_868_368##8	a_868_368##6	196.554153
Rf44	SET_B#5	SET_B#10	161.629105
Rf45	SET_B#11	SET_B	11.174080
Rf46	SET_B#10	SET_B#11	9.883524
Rf47	a_1997_82##2	a_1997_82##5	284.862366
Rf48	a_1997_82##5	a_1997_82##6	111.527603
Rf49	a_1997_82##5	a_1997_82##7	141.031067
Rf50	a_2452_74#	a_2452_74##2	96.915443
Rf51	a_1643_257##7	a_1643_257##8	80.958382
Rf52	a_1643_257##8	a_1643_257##9	65.653336
Rf53	a_1643_257##9	a_1643_257##2	482.601959
Rf54	a_1643_257##8	a_1643_257##11	27.215935
Rf55	a_1643_257##9	a_1643_257##5	167.527832
Rf56	RESET_B	RESET_B#2	162.201172
Rf57	a_2216_410##16	a_2216_410##17	14.999464
Rf58	a_2216_410##17	a_2216_410##19	101.468483
Rf59	a_2216_410##17	a_2216_410##2	207.430206
Rf60	a_2216_410##19	a_2216_410##10	153.199173
Rf61	a_2216_410##10	a_2216_410##22	168.632492
Rf62	a_2216_410##18	a_2216_410##19	7.500000
Rf63	Q_N#1	Q_N	50.544498
Rf64	Q_N	Q_N#2	41.728977
Rf65	a_3272_94##3	a_3272_94##8	181.346985
Rf66	a_3272_94##8	a_3272_94##9	29.403225
Rf67	a_3272_94##8	a_3272_94##10	42.483578
Rf68	Q	Q#1	20.247894
Rf69	Q	Q#2	91.781036
Rf70	VGND#1	VGND#2	110.555344
Rf71	VGND#2	VGND#3	89.243172
Rf72	VGND#2	VGND#4	31.731567
Rf73	VGND#3	VGND#5	63.742043
Rf74	VGND#5	VGND#6	226.415070
Rf75	VGND#6	VGND#7	130.530807
Rf76	VGND#7	VGND#8	62.798893
Rf77	VGND#8	VGND#9	265.530884
Rf78	VGND#9	VGND#10	111.816940
Rf79	VGND#10	VGND#11	50.802910
Rf80	VGND#11	VGND#12	77.101089
Rf81	VGND#12	VGND#13	186.063049
Rf82	VGND#3	VGND#14	36.804161
Rf83	VGND#5	VGND#15	37.151749
Rf84	VGND#6	VGND#16	24.078712
Rf85	VGND#8	VGND#17	41.987278
Rf86	VGND#9	VGND#18	35.016190
Rf87	VGND#10	VGND#19	27.306370
Rf88	VGND#12	VGND#20	49.562149
Rf89	VPWR#1	VPWR#2	115.584740
Rf90	VPWR#2	VPWR#3	91.398163
Rf91	VPWR#2	VPWR#4	37.498695
Rf92	VPWR#3	VPWR#5	39.225067
Rf93	VPWR#3	VPWR#6	60.858223
Rf94	VPWR#6	VPWR#7	16.742468
Rf95	VPWR#6	VPWR#8	156.492279
Rf96	VPWR#8	VPWR#9	32.932804
Rf97	VPWR#8	VPWR#10	78.480217
Rf98	VPWR#10	VPWR#11	32.932804
Rf99	VPWR#10	VPWR#12	96.036865
Rf100	VPWR#12	VPWR#13	32.848190
Rf101	VPWR#13	VPWR#14	31.534731
Rf102	VPWR#13	VPWR#15	80.306480
Rf103	VPWR#15	VPWR#16	39.231567
Rf104	VPWR#15	VPWR#17	251.301987
Rf105	VPWR#17	VPWR#18	50.329590
Rf106	VPWR#17	VPWR#19	76.711304
Rf107	VPWR#19	VPWR#20	32.125244
Rf108	VPWR#19	VPWR#21	49.649803
Rf109	VPWR#21	VPWR#22	56.954857
Rf110	VPWR#22	VPWR#23	31.337896
Rf111	VPWR#22	VPWR#24	135.094360
Rf112	VPWR#24	VPWR#25	32.145462
Rf119	a_688_98##5	a_688_98##10	160.232803
Re1	a_868_368##6	a_868_368##11	26.769386
Re3	SET_B	SET_B#7	14.521620
Re4	VPWR#3	VPWR#28	3.190358
Re5	VPWR#28	VPWR	0.368763
Re6	VPWR	VPWR#21	2.910993
Re7	VGND#3	VGND#22	3.190358
Re8	VGND#22	VGND	0.368763
Re9	VGND	VGND#11	2.910993
Re15	VPWR#12	VPWR#28	0.698413
Re18	VGND#7	VGND#22	0.698413
*
*       CAPACITOR CARDS
*
*
C1	VGND#3	a_2216_410##7	6.28706e-18
C2	a_1643_257##4	a_1997_82##3	5.30693e-17
C3	a_1997_82##6	a_688_98##6	5.48089e-19
C4	a_688_98##9	VPWR#21	3.16481e-17
C5	VPWR#25	VPWR#23	1.15844e-20
C6	VGND#11	a_868_368##9	6.80503e-19
C7	a_1997_82##7	a_2216_410##3	1.43003e-18
C8	SET_B#7	VPWR#10	4.40571e-19
C9	VGND#3	a_2216_410##10	2.54062e-17
C10	a_1643_257##2	a_1643_257##3	2.53495e-18
C11	a_341_410##2	a_341_410#	9.27896e-18
C12	a_197_119##5	D#1	3.84737e-17
C13	a_1643_257##9	a_2216_410##2	1.23589e-19
C14	VGND#3	VGND#2	7.63203e-17
C15	a_2216_410##18	a_2216_410##2	3.93116e-19
C16	VGND#12	D#1	3.298e-18
C17	VGND#8	a_1007_366##5	1.36702e-19
C18	SCE#4	D#1	3.31521e-18
C19	VGND#2	Q#2	1.70847e-17
C20	a_3272_94##8	a_2216_410##5	5.73223e-17
C21	VGND#13	a_341_410##4	4.68336e-19
C22	a_341_410##5	VPWR#21	2.97565e-17
C23	a_1154_464##4	a_1643_257##2	1.1073e-17
C24	a_1643_257#	SET_B#1	1.91006e-17
C25	a_2216_410##17	VPWR#10	8.87521e-18
C26	a_27_464##2	a_206_464#	3.63199e-18
C27	SCE#3	SCE#4	1.08029e-18
C28	a_3272_94##10	VPWR#4	8.78206e-17
C29	VGND#3	a_3272_94##8	2.60121e-18
C30	a_197_119##2	a_868_368##4	5.43233e-19
C31	a_1997_82##6	SET_B#3	4.00891e-19
C32	a_1643_257##9	VGND#16	6.29121e-18
C33	VGND#5	a_2216_410##15	5.49047e-18
C34	a_3272_94##8	a_2216_410##13	4.11496e-19
C35	VPWR#21	VPWR#23	1.93599e-17
C36	VGND#3	a_2216_410##5	1.24928e-18
C37	VPWR#14	a_1007_366##4	5.52046e-17
C38	VPWR#25	a_27_464#	3.67486e-17
C39	a_1997_82##5	a_2216_410##2	7.6125e-17
C40	a_27_464#	VPWR#22	3.88082e-17
C41	VGND#20	SCD#3	5.99884e-19
C42	a_1154_464##5	a_868_368##4	3.64219e-17
C43	a_1154_464##3	a_1154_464##4	7.2953e-18
C44	VPWR#17	a_688_98#	5.437e-18
C45	a_1997_82##6	a_1997_82##5	3.33139e-18
C46	a_2216_410##17	a_2216_410#	1.59869e-18
C47	a_1007_366##9	a_688_98##6	6.19138e-20
C48	SET_B#4	a_1643_257##4	3.6897e-17
C49	VPWR#21	a_868_368##11	7.72344e-18
C50	a_197_119##5	SCE#3	4.43688e-17
C51	VPWR#21	a_27_464#	4.33026e-17
C52	a_1997_82##7	a_868_368##7	3.31234e-17
C53	a_688_98#	a_1154_464##3	2.78329e-18
C54	VPWR#10	VPWR#8	9.83158e-19
C55	VGND#13	D#1	9.74599e-19
C56	VPWR#9	VPWR#6	6.47496e-19
C57	VPWR#15	a_688_98#	1.21376e-19
C58	a_1997_82##5	a_1643_257##4	6.25078e-19
C59	VGND#11	a_868_368##11	3.12272e-17
C60	VPWR#5	VPWR#4	2.9329e-18
C61	a_2216_410##2	VPWR#11	3.67795e-17
C62	VPWR#21	a_197_119##6	1.06885e-17
C63	a_1007_366##10	a_1154_464##2	3.71615e-19
C64	a_1643_257##9	a_868_368##8	8.74658e-19
C65	a_27_464##2	a_27_464#	7.66945e-19
C66	VPWR#2	a_3272_94##2	4.24656e-20
C67	VPWR#14	SET_B#3	3.10908e-18
C68	a_197_119##4	a_868_368##9	3.4618e-18
C69	a_688_98#	a_868_368##4	1.5849e-17
C70	VGND#12	SCE#3	2.2432e-17
C71	VPWR#15	a_1154_464##3	1.2675e-19
C72	VGND#8	SET_B#2	1.16368e-19
C73	a_1007_366##8	a_688_98##6	3.67244e-19
C74	a_1154_464#	a_1643_257#	2.92266e-17
C75	VPWR#16	a_1007_366##4	1.17473e-19
C76	D#2	a_341_410##2	3.2781e-17
C77	a_2216_410##17	VPWR#8	1.05472e-17
C78	VPWR#16	VPWR#14	9.51117e-19
C79	a_197_119##5	SCD#3	5.42101e-18
C80	a_2216_410#	SET_B#4	3.03603e-18
C81	a_1997_82##6	a_2216_410##2	4.05429e-17
C82	SET_B#3	a_1007_366##13	2.86251e-17
C83	SCE#2	SCE#1	1.17915e-18
C84	VGND#5	RESET_B#3	2.33858e-18
C85	a_868_368##8	a_1997_82##5	6.4453e-17
C86	a_868_368##2	a_688_98#	2.17736e-17
C87	a_2216_410##5	a_3272_94##6	2.97493e-18
C88	a_1997_82##7	a_688_98##6	5.88128e-17
C89	VPWR#21	VPWR#25	1.80109e-17
C90	Q#2	a_3272_94##2	1.23921e-17
C91	VGND#15	VPWR#7	9.27938e-18
C92	VGND#13	SCE#3	2.47268e-17
C93	a_27_464##2	a_197_119##6	2.59849e-17
C94	a_2216_410##17	a_688_98##7	1.40133e-19
C95	CLK_N#6	a_688_98##8	4.31892e-19
C96	VGND#12	VGND#19	2.00229e-19
C97	VPWR#5	a_3272_94##10	9.29558e-17
C98	VPWR#17	a_868_368#	1.14598e-18
C99	a_197_119##4	a_197_119##2	4.02369e-18
C100	VPWR#14	a_1643_257##3	3.56273e-19
C101	VPWR#21	a_27_464##2	1.91482e-17
C102	SET_B#3	VPWR#16	1.89503e-17
C103	a_1007_366##2	a_688_98#	2.59691e-18
C104	a_197_119##2	a_1007_366##2	6.62276e-19
C105	a_1997_82##5	SET_B#4	1.475e-17
C106	VGND#19	VGND#18	8.35971e-20
C107	SCE#2	a_341_410##3	1.8445e-19
C108	a_197_119##2	a_1185_125#	6.6478e-18
C109	VGND#6	a_1997_82#	4.68869e-18
C110	a_197_119##4	a_341_410##3	1.14552e-18
C111	a_1007_366##2	a_868_368#	3.13791e-17
C112	VPWR#17	a_868_368##4	6.34667e-20
C113	a_1154_464##5	a_1007_366##2	1.80912e-20
C114	a_868_368##8	a_1997_82##6	1.82989e-17
C115	SCD#4	SCE#4	8.665e-18
C116	a_868_368##3	a_1154_464#	2.47996e-18
C117	VPWR#15	a_1154_464##2	4.29339e-20
C118	VGND#2	a_3272_94##9	4.798e-18
C119	VGND#8	a_1643_257##2	2.18962e-17
C120	a_688_98##7	a_2216_410#	3.25798e-17
C121	a_1007_366##2	a_1007_366##3	8.86459e-18
C122	VPWR#15	a_868_368##4	1.83894e-20
C123	SET_B#7	a_1997_82##7	2.39321e-18
C124	VGND#13	SCD#3	3.09358e-17
C125	a_1997_82##7	a_1007_366##6	1.98323e-18
C126	a_1154_464##2	a_1643_257#	5.78341e-18
C127	a_1643_257##9	a_1997_82##7	1.10691e-16
C128	VGND#11	SCD#4	5.29305e-18
C129	a_688_98##8	a_1007_366##2	7.08681e-18
C130	VPWR#16	a_1643_257##3	3.85265e-17
C131	SET_B#7	a_868_368##8	6.60249e-19
C132	Q#2	VGND#1	6.67702e-17
C133	VGND#17	a_688_98##6	1.36875e-18
C134	VGND#5	a_1997_82#	1.84209e-19
C135	CLK_N#6	CLK_N#1	3.1419e-18
C136	SCE#4	a_341_410##2	2.29214e-19
C137	a_2216_410##17	a_868_368##5	9.43393e-20
C138	a_27_464##2	VPWR#25	5.81044e-17
C139	VPWR#17	a_1007_366##3	2.75767e-18
C140	a_688_98##5	a_688_98##8	1.02656e-17
C141	RESET_B#2	a_2216_410##10	3.65009e-17
C142	SCE#3	a_341_410##3	5.34676e-20
C143	SCD#4	SCD#2	1.98421e-17
C144	VPWR#21	VPWR#22	7.86993e-17
C145	a_688_98##5	CLK_N#1	7.30168e-18
C146	a_1154_464##7	a_688_98##3	2.60109e-19
C147	a_868_368##5	a_688_98##7	3.62557e-17
C148	a_1473_73#	a_688_98##6	1.38426e-17
C149	VPWR#8	VPWR#6	2.46166e-19
C150	Q_N#2	VPWR#5	6.906e-17
C151	VGND#9	a_1154_464##3	8.66018e-19
C152	VGND#6	a_1643_257##6	4.90349e-18
C153	a_1997_82##3	a_2556_392#	2.27725e-17
C154	SET_B#7	a_1007_366##5	6.34493e-17
C155	VPWR#16	a_1154_464##4	4.13612e-18
C156	a_2216_410##10	a_1997_82##2	1.32709e-20
C157	SET_B#7	a_688_98##6	1.36492e-18
C158	a_688_98##2	a_868_368##3	3.02303e-17
C159	VGND#19	VGND#9	2.6458e-19
C160	CLK_N#2	a_688_98##8	2.33953e-19
C161	a_688_98##3	a_1154_464#	1.63151e-17
C162	a_868_368##10	VPWR#18	1.65716e-18
C163	VPWR#17	a_868_368##2	2.51057e-20
C164	a_688_98##5	SCE#1	1.83814e-19
C165	a_1007_366##10	a_1643_257##3	6.34147e-18
C166	a_1643_257##4	a_2556_392#	2.27725e-17
C167	VPWR#21	VPWR#19	5.52488e-17
C168	VGND#8	a_1154_464##3	2.25382e-19
C169	VGND#17	a_1007_366##6	3.28946e-17
C170	a_1007_366##5	VPWR#12	5.96622e-19
C171	VGND#4	VGND#1	1.71243e-18
C172	a_1997_82##2	RESET_B#2	8.00713e-18
C173	VGND#3	a_1643_257##8	8.26391e-18
C174	a_1007_366##5	a_1997_82##6	1.43589e-17
C175	a_688_98##5	a_868_368##12	4.66686e-18
C176	CLK_N#6	SCE#1	5.32231e-19
C177	VGND#5	Q_N#1	6.75305e-18
C178	a_341_410#	a_688_98##8	1.76259e-19
C179	VPWR#2	a_3272_94##4	2.67726e-18
C180	SCE#1	CLK_N#2	5.54311e-18
C181	a_1007_366##14	a_688_98##6	8.63552e-19
C182	VPWR#21	VPWR#17	1.36451e-16
C183	VGND#7	a_1007_366##5	5.60496e-20
C184	VPWR#19	a_688_98##8	3.3186e-18
C185	VGND#5	a_1643_257##6	2.55554e-20
C186	a_688_98##5	VGND#19	8.71856e-18
C187	VPWR#12	a_688_98##6	3.72144e-19
C188	a_1007_366##9	a_1592_424#	2.10622e-18
C189	a_197_119##2	a_197_119#	4.34868e-19
C190	a_341_410#	CLK_N#1	9.55602e-19
C191	a_1643_257##2	SET_B#7	3.22359e-17
C192	a_2216_410##11	a_3272_94##3	4.62006e-18
C193	a_1007_366##4	a_868_368##5	5.58252e-17
C194	a_688_98##11	a_688_98##5	1.15551e-18
C195	a_1473_73#	a_1007_366##6	9.95371e-19
C196	a_1007_366##10	VPWR#16	2.41448e-17
C197	a_3272_94##3	Q#2	2.63746e-17
C198	a_1007_366##10	a_1154_464##4	4.61146e-17
C199	a_1007_366##5	VPWR#14	3.49409e-17
C200	a_341_410#	SCE#1	4.48083e-17
C201	a_1997_82##2	a_1643_257##5	3.79096e-17
C202	VGND#1	a_3272_94#	2.6517e-17
C203	VPWR#17	a_688_98##8	1.76965e-18
C204	a_1997_82##5	a_688_98##7	1.78297e-19
C205	a_1997_82##6	VPWR#10	2.19357e-18
C206	a_2216_410#	a_2171_508#	9.87534e-18
C207	a_1997_82##7	a_1997_82##5	1.02556e-18
C208	SET_B#7	a_197_119##2	8.79837e-19
C209	a_1473_73##2	a_688_98##6	4.1222e-19
C210	a_1007_366#	a_688_98##2	5.37284e-17
C211	a_3272_94##3	VGND#4	4.55397e-17
C212	SET_B#1	VGND#17	1.47143e-17
C213	a_2216_410##12	a_2216_410##5	6.45914e-19
C214	VGND#7	a_1643_257##2	3.47187e-17
C215	a_1997_82##2	SET_B#5	9.01713e-19
C216	VGND#7	a_688_98##6	8.86019e-18
C217	a_688_98##7	a_2171_508#	9.87534e-18
C218	VGND#6	SET_B#6	1.13014e-17
C219	VGND#9	a_868_368##4	1.49023e-19
C220	a_688_98##11	VGND#19	7.9905e-19
C221	a_341_410##8	a_868_368##12	1.75842e-18
C222	VPWR#1	a_3272_94##4	3.15851e-17
C223	VGND#4	Q#2	6.13626e-17
C224	a_197_119#	a_1154_464##4	9.80693e-18
C225	a_2216_410##3	a_2247_82#	7.49457e-18
C226	a_1007_366##2	VPWR#17	5.28292e-17
C227	a_1007_366##14	a_1007_366##6	2.1449e-19
C228	SET_B#5	a_1643_257##5	3.53995e-17
C229	a_868_368##7	a_2247_82#	1.65812e-18
C230	a_1997_82##2	a_2216_410##2	4.54213e-19
C231	D#2	a_341_410##3	9.49318e-18
C232	VPWR#7	Q_N#2	4.66849e-17
C233	Q#2	a_3272_94#	3.86552e-17
C234	a_1007_366##10	a_688_98#	2.80482e-17
C235	a_688_98##3	a_868_368##3	1.32633e-17
C236	SET_B#3	a_1007_366##4	4.56135e-18
C237	a_2216_410##10	a_2216_410##13	7.60468e-21
C238	CLK_N#2	a_688_98##11	3.88076e-17
C239	a_688_98##4	a_688_98##2	1.20261e-19
C240	a_1154_464##7	a_1154_464##4	1.34002e-19
C241	Q#1	a_3272_94##4	4.86541e-17
C242	a_1473_73#	SET_B#1	2.27174e-17
C243	VPWR#2	a_3272_94##6	4.25137e-18
C244	a_868_368##11	a_1154_464##3	6.28753e-17
C245	a_868_368##5	a_1986_424#	1.97507e-17
C246	VPWR#19	CLK_N#1	1.83965e-18
C247	VGND#1	a_3272_94##5	1.34515e-18
C248	a_2216_410##10	a_2216_410##15	2.60591e-18
C249	a_688_98#	a_197_119#	2.01601e-17
C250	VPWR#21	a_1154_464##3	1.15458e-18
C251	a_1007_366##4	a_1986_424#	1.97507e-17
C252	a_2216_410##2	SET_B#5	4.21531e-18
C253	VPWR#1	a_3272_94##6	1.17456e-18
C254	a_197_119##4	VPWR#23	5.6324e-18
C255	VGND#17	a_1643_257#	9.04502e-19
C256	a_868_368##11	a_868_368##4	1.72094e-17
C257	SCE#4	D#3	8.05512e-19
C258	VPWR#15	VPWR#14	5.12321e-19
C259	a_3272_94##5	a_3272_94#	3.66411e-17
C260	a_868_368##3	a_1154_464##2	2.22153e-19
C261	VGND#4	a_3272_94#	1.50742e-18
C262	a_1643_257##8	RESET_B	3.65766e-17
C263	VPWR#3	VPWR#1	5.45503e-17
C264	a_688_98##4	a_1007_366#	8.68589e-18
C265	VPWR#4	a_3272_94##4	3.34438e-18
C266	a_3272_94##9	Q#2	1.24343e-18
C267	a_1643_257##2	a_1643_257##9	8.03287e-19
C268	a_2216_410##10	RESET_B#3	2.19716e-17
C269	a_1007_366##10	a_868_368#	3.73896e-19
C270	SCE	a_341_410##2	5.48425e-20
C271	a_1007_366##14	SET_B#1	7.97745e-19
C272	VPWR#21	a_868_368##4	2.31598e-18
C273	Q_N#1	a_3272_94##8	1.02663e-18
C274	a_1154_464##7	a_688_98#	5.4703e-17
C275	a_868_368##11	a_868_368##2	2.85497e-17
C276	VGND#6	a_2216_410##3	8.29046e-18
C277	a_868_368##11	VGND#9	3.88992e-18
C278	Q#2	a_3272_94##5	3.85608e-17
C279	a_1643_257##3	SET_B#3	3.04092e-17
C280	a_3272_94##6	Q#1	1.32391e-17
C281	a_2216_410##10	a_1997_82#	6.54974e-19
C282	VPWR#3	Q#1	1.83284e-17
C283	a_868_368##8	a_2216_410##2	9.63873e-18
C284	a_1643_257#	a_1473_73#	2.30757e-17
C285	SCD#2	SCE#5	9.04555e-18
C286	a_3272_94##10	a_3272_94##4	4.27278e-20
C287	a_868_368##11	a_1007_366##2	3.26236e-17
C288	VPWR#22	SCE#1	4.17506e-18
C289	a_868_368##11	a_1473_73#	1.3754e-20
C290	a_688_98##6	a_1902_125#	2.74941e-18
C291	a_197_119##4	a_868_368##12	2.97463e-17
C292	a_868_368##11	VGND#8	2.35844e-18
C293	a_1643_257##3	a_1592_424#	4.78978e-18
C294	a_3272_94##9	a_3272_94#	1.39744e-19
C295	a_197_119##2	a_868_368##10	1.78057e-17
C296	a_1643_257##2	VPWR#16	1.4686e-18
C297	VGND#1	a_2216_410##11	2.16388e-19
C298	a_1473_73##2	SET_B#1	2.23021e-19
C299	a_2216_410##10	a_1643_257##6	1.49262e-19
C300	a_1007_366##6	a_1902_125#	5.77691e-18
C301	VGND#20	a_341_410##2	4.08605e-19
C302	a_341_410##8	a_688_98##11	1.36419e-17
C303	VPWR#3	VPWR#4	2.02133e-17
C304	VPWR#21	a_1007_366##2	2.31598e-17
C305	VGND#20	a_341_410#	3.18129e-19
C306	RESET_B#3	a_2216_410##9	1.22495e-18
C307	a_1154_464##4	a_1592_424#	1.66292e-17
C308	a_1997_82##5	a_2216_410##17	5.72457e-17
C309	a_1007_366##10	a_197_119#	1.31812e-16
C310	a_1007_366##10	a_1007_366##3	2.57087e-19
C311	VPWR#2	a_2216_410##4	5.50307e-18
C312	a_2216_410##10	Q_N#1	4.71447e-18
C313	VPWR#4	a_3272_94##6	7.0817e-17
C314	VGND#3	VPWR#1	3.88056e-18
C315	a_868_368##11	a_688_98##5	2.11296e-18
C316	a_868_368##11	a_1154_464#	2.21008e-21
C317	a_1007_366##8	a_1007_366##5	5.82548e-18
C318	a_868_368##11	a_1007_366##14	2.78565e-17
C319	a_868_368#	a_1154_464##7	1.31847e-17
C320	a_3272_94##5	VGND#4	2.38082e-17
C321	VGND#6	a_2452_74#	3.04736e-17
C322	VGND#11	a_1007_366##2	3.36123e-18
C323	a_1007_366##14	a_1643_257#	3.23014e-17
C324	a_3272_94##9	VGND#4	4.06373e-17
C325	VPWR#18	a_688_98#	8.7996e-20
C326	VPWR#21	a_688_98##5	4.96473e-18
C327	a_2216_410##9	a_2216_410##7	4.30012e-18
C328	a_3272_94##10	VPWR#3	2.8462e-17
C329	CLK_N#3	a_688_98##4	7.97951e-18
C330	a_2216_410##10	VGND#15	6.08207e-17
C331	a_2216_410##11	a_3272_94##5	1.93935e-17
C332	a_1154_464##4	a_1643_257##3	4.81685e-17
C333	a_868_368##11	a_868_368##3	2.74274e-19
C334	a_868_368##11	a_1473_73##2	8.66733e-18
C335	VPWR#3	a_3272_94##4	3.8924e-18
C336	Q#2	a_2216_410##11	2.36027e-19
C337	SET_B#7	a_1643_257##9	3.31338e-19
C338	a_1997_82##2	RESET_B#3	6.17225e-19
C339	VGND#11	a_688_98##5	5.22581e-18
C340	a_3272_94##10	a_3272_94##6	1.62442e-18
C341	a_1473_73#	a_1154_464#	7.28979e-19
C342	VPWR#14	VPWR#10	4.90984e-20
C343	VPWR#21	CLK_N#2	4.64013e-20
C344	a_868_368##9	a_688_98#	1.16883e-19
C345	VPWR#3	VPWR#5	1.99592e-17
C346	VGND#6	a_868_368##7	4.04569e-18
C347	VGND#9	a_1007_366##2	1.55907e-19
C348	a_1007_366##10	a_1154_464##7	3.46356e-17
C349	VGND#2	a_3272_94##8	4.78362e-19
C350	a_868_368##11	a_688_98##2	1.61559e-17
C351	a_868_368#	a_1070_464#	2.19373e-18
C352	VPWR#19	CLK_N#2	1.0918e-21
C353	a_868_368##11	a_197_119##2	1.17715e-16
C354	VGND#3	VPWR#4	3.94068e-18
C355	a_1473_73##2	a_1643_257#	4.70718e-19
C356	VPWR#6	a_2216_410##12	1.09113e-18
C357	a_3272_94##9	a_3272_94##5	9.97915e-19
C358	SCD	a_341_410##2	2.38767e-19
C359	a_1154_464##7	a_1007_366##3	2.26263e-18
C360	VGND#11	CLK_N#2	4.48378e-18
C361	VPWR#3	a_3272_94##6	2.90117e-18
C362	VPWR#4	a_2216_410##4	2.43743e-17
C363	SCE#2	a_688_98##4	4.25609e-19
C364	a_197_119##4	VGND#19	5.23793e-17
C365	a_1007_366##3	a_1070_464#	4.29612e-18
C366	a_868_368##10	a_1154_464##5	1.66627e-19
C367	VPWR#21	a_341_410#	6.16321e-18
C368	VPWR#18	a_868_368#	1.01143e-18
C369	a_1643_257##2	a_868_368##8	6.57947e-20
C370	VPWR#2	a_2216_410##5	7.28668e-20
C371	a_2216_410##13	a_3272_94##5	1.70511e-19
C372	VPWR#5	a_3272_94##6	4.70193e-19
C373	Q_N#2	VPWR#3	2.547e-17
C374	a_868_368##11	a_1007_366#	1.79812e-17
C375	VPWR#22	a_341_410##3	4.50351e-18
C376	a_868_368##11	a_1154_464##5	3.50423e-17
C377	VPWR#20	a_688_98#	1.78285e-19
C378	a_1154_464##3	a_1007_366##10	6.48681e-18
C379	a_1007_366##14	a_1154_464#	2.68122e-17
C380	VGND#5	a_2452_74#	1.76711e-17
C381	a_2216_410##11	VGND#4	2.61763e-17
C382	VGND#11	a_341_410#	2.47399e-18
C383	SET_B#2	a_1007_366##8	3.0913e-17
C384	VPWR#3	a_2216_410##4	9.18439e-18
C385	VGND#14	VGND#4	7.61881e-18
C386	SET_B#2	a_1007_366##5	3.19856e-17
C387	a_197_119##5	D#2	3.27647e-17
C388	a_688_98#	a_1154_464##4	2.01329e-18
C389	a_197_119##4	a_197_119##6	3.09913e-18
C390	VPWR#21	D#2	2.54291e-18
C391	a_2216_410##22	a_2216_410##10	1.77897e-18
C392	VGND#8	a_688_98##6	5.77563e-17
C393	a_1643_257##8	a_2216_410##15	2.59935e-19
C394	VGND#11	VGND#12	1.30283e-16
C395	a_1154_464##3	a_197_119#	1.00258e-16
C396	a_3272_94##10	a_2216_410##4	7.82689e-17
C397	a_868_368##9	a_868_368#	9.93148e-20
C398	a_868_368##11	a_688_98##4	3.2391e-18
C399	SCE#2	CLK_N#3	1.21422e-17
C400	a_1997_82##5	VPWR#10	2.48333e-19
C401	a_1154_464##7	a_197_119#	5.58792e-17
C402	a_1643_257##5	a_1997_82#	8.02344e-18
C403	VGND#14	a_3272_94##5	6.20427e-19
C404	a_1473_73#	a_868_368##3	5.45558e-20
C405	VGND#11	D#2	1.80256e-18
C406	a_1643_257##2	a_1007_366##5	1.28805e-17
C407	a_1007_366##8	a_1997_82##6	3.50991e-18
C408	VPWR#3	a_2216_410##12	4.91567e-18
C409	VGND#12	a_197_119##5	1.15192e-17
C410	a_688_98##3	a_1007_366#	1.79541e-17
C411	VPWR#18	a_1007_366##3	1.91934e-17
C412	CLK_N#6	a_688_98##9	3.61296e-17
C413	VGND#11	VGND#10	6.02075e-17
C414	a_2216_410##13	a_2216_410##11	4.72473e-18
C415	VPWR#4	a_2216_410##12	5.91372e-19
C416	a_1154_464#	a_1473_73##2	1.22845e-17
C417	a_2216_410##18	a_1643_257##7	7.6134e-17
C418	a_868_368##11	CLK_N#3	4.01141e-19
C419	VGND#10	a_688_98##5	5.98423e-20
C420	a_1643_257##2	SET_B#2	1.16347e-16
C421	VPWR#3	a_1643_257##7	6.86308e-18
C422	a_3272_94##9	a_2216_410##11	2.40164e-17
C423	a_1007_366##10	a_868_368##4	7.99126e-19
C424	a_341_410#	VPWR#22	1.03062e-18
C425	VPWR#5	a_2216_410##4	3.55021e-18
C426	a_1643_257##9	RESET_B#3	4.39148e-19
C427	VGND#6	a_688_98##6	5.00065e-19
C428	VPWR#3	a_2216_410##14	4.59272e-18
C429	VGND#11	VGND#9	1.31044e-16
C430	a_3272_94##3	VPWR#2	4.46181e-19
C431	Q	a_3272_94##2	1.10084e-17
C432	a_197_119##4	a_688_98##11	4.94891e-17
C433	a_3272_94##8	a_3272_94##4	1.48693e-19
C434	a_1007_366##14	a_868_368##3	3.90517e-19
C435	RESET_B	a_1643_257##11	1.91305e-18
C436	a_868_368##9	a_1007_366##3	1.74516e-18
C437	a_197_119#	a_868_368##4	1.5726e-18
C438	a_1007_366##9	a_1643_257##2	6.38525e-17
C439	VPWR#6	a_2216_410##14	1.6824e-17
C440	a_197_119##5	SCE#4	4.26343e-18
C441	a_868_368#	a_688_98#	2.40696e-17
C442	VGND#4	a_2216_410##13	8.92292e-19
C443	VPWR#3	a_2216_410##18	2.15909e-17
C444	D#3	a_206_464#	2.26782e-18
C445	a_3272_94##10	a_2216_410##12	3.40601e-18
C446	VGND#11	a_1007_366#	2.23193e-18
C447	VGND#14	a_3272_94##9	4.97758e-17
C448	Q	a_2216_410##5	1.50108e-18
C449	a_2216_410##22	RESET_B#2	3.81925e-19
C450	a_197_119##2	a_1154_464#	6.66745e-18
C451	VPWR#3	RESET_B#1	5.31761e-18
C452	a_868_368##4	a_1154_464##7	2.4254e-17
C453	a_1643_257##2	a_1007_366##8	1.76985e-17
C454	SCE#5	a_206_464#	7.25679e-18
C455	VPWR#18	a_688_98##8	7.38873e-19
C456	VGND#12	a_197_119##4	3.54023e-17
C457	VGND#5	a_2216_410##22	7.45071e-18
C458	a_868_368##11	VGND#19	4.21086e-20
C459	VGND#14	a_2216_410##11	4.01127e-18
C460	SCE#2	a_341_410##4	3.12666e-17
C461	VGND#11	a_688_98##4	8.30684e-18
C462	VGND#13	SCE#4	1.36582e-19
C463	a_1643_257##8	RESET_B#3	1.96678e-17
C464	a_1007_366##10	a_868_368##2	2.03099e-19
C465	VGND#11	a_197_119##2	6.70221e-17
C466	a_1473_73##2	a_868_368##3	5.17236e-19
C467	VGND#8	a_1007_366##6	4.78944e-19
C468	VPWR#5	a_2216_410##12	7.21407e-17
C469	VPWR#22	VPWR#19	4.31494e-19
C470	VGND#6	a_2452_74##2	7.45685e-17
C471	a_1154_464##3	a_868_368##4	1.1821e-16
C472	a_688_98##8	a_868_368##9	3.31254e-17
C473	a_3272_94##9	a_2216_410##13	1.4746e-18
C474	VGND#14	a_2216_410##7	1.30632e-17
C475	a_688_98##2	a_1185_125#	1.51933e-18
C476	VGND#11	CLK_N#3	9.47289e-18
C477	a_1154_464##5	a_1154_464#	3.30501e-19
C478	a_2452_74#	a_1997_82##2	3.58607e-19
C479	VGND#11	a_1154_464##5	3.99575e-18
C480	VGND#7	a_1643_257##9	5.03588e-17
C481	a_688_98##9	a_1007_366##3	5.44793e-20
C482	a_1007_366#	a_1185_125#	4.83624e-18
C483	a_2216_410##3	SET_B#5	3.38628e-17
C484	a_2216_410##15	a_2216_410##13	3.96335e-17
C485	a_1007_366##3	a_868_368#	2.47289e-17
C486	a_688_98##8	a_688_98#	2.01199e-19
C487	a_2216_410##10	VPWR#6	3.56704e-17
C488	a_3272_94##10	a_2216_410##14	2.02539e-19
C489	a_1154_464##3	a_868_368##2	7.70012e-20
C490	a_1154_464##7	a_868_368##2	4.67124e-18
C491	Q_N#1	a_2216_410##11	3.03436e-19
C492	a_1643_257##9	a_1997_82#	1.48978e-17
C493	a_197_119##4	a_688_98##2	5.24951e-20
C494	a_197_119##4	a_341_410##8	1.07391e-16
C495	VGND#11	SCE#2	1.20647e-17
C496	a_868_368##3	a_197_119##2	2.35232e-17
C497	a_2216_410##12	Q_N#2	1.45643e-17
C498	a_688_98##4	a_688_98##3	3.09496e-19
C499	a_2216_410##22	a_1997_82##2	6.1926e-19
C500	VPWR#20	a_688_98##8	5.08398e-17
C501	Q_N#1	a_3272_94##9	1.37262e-18
C502	VPWR#22	D#2	1.94884e-20
C503	a_1007_366##9	a_1154_464##3	7.03104e-19
C504	a_3272_94##8	a_3272_94##6	2.27994e-19
C505	a_1007_366##2	a_1154_464##3	1.11141e-18
C506	a_1007_366##2	a_1007_366##10	2.37231e-18
C507	a_868_368##11	a_1592_424#	3.50238e-19
C508	VGND#13	SCD#2	8.78024e-18
C509	VPWR#6	RESET_B#1	4.84347e-18
C510	a_2216_410##13	VGND#14	2.99772e-17
C511	a_868_368##11	a_688_98##3	1.20242e-18
C512	VGND#11	a_341_410##4	2.94888e-18
C513	a_868_368##9	CLK_N#1	7.41443e-19
C514	SCE	a_197_119##4	2.89311e-18
C515	VPWR#5	a_2216_410##14	3.32333e-18
C516	VGND#10	a_197_119##4	2.86138e-18
C517	a_1473_73##2	a_688_98##2	1.38924e-19
C518	a_1643_257##9	a_1643_257##8	5.63268e-18
C519	a_2216_410##3	a_2216_410##2	8.40079e-19
C520	a_1473_73#	VGND#17	3.819e-17
C521	D#1	a_341_410##4	4.2932e-17
C522	SCE#3	SCE#2	1.6033e-19
C523	a_688_98##9	a_688_98##8	7.13766e-19
C524	a_1007_366##10	VPWR#17	6.57686e-17
C525	a_1007_366##8	a_868_368##5	3.00868e-19
C526	Q_N	a_2216_410##9	1.57226e-17
C527	a_2216_410##17	a_2216_410##18	1.99178e-18
C528	Q_N	a_2216_410##7	2.08371e-17
C529	VGND#15	a_2216_410##11	1.10456e-19
C530	a_1643_257##8	a_1997_82#	2.17587e-18
C531	a_1154_464##5	a_868_368##3	3.13999e-17
C532	a_1007_366##2	a_868_368##2	3.42856e-17
C533	a_1007_366##2	a_1154_464##7	4.42304e-17
C534	Q_N	a_2216_410##5	5.85765e-19
C535	a_868_368##9	a_868_368##2	3.89764e-19
C536	VPWR#2	VPWR#1	1.14185e-18
C537	a_868_368##11	a_1154_464##2	1.30593e-18
C538	a_688_98##8	a_1007_366##3	3.94009e-18
C539	VGND#11	D#1	5.3942e-18
C540	a_1154_464##2	a_1643_257##2	2.93819e-17
C541	a_1007_366##8	VPWR#14	5.24618e-17
C542	VGND#11	a_868_368##12	7.28495e-18
C543	VGND#8	SET_B#1	2.51753e-18
C544	VPWR#20	CLK_N#1	4.3444e-17
C545	VGND#6	VGND#16	7.34861e-18
C546	a_1643_257##9	a_2247_82#	6.34512e-19
C547	VGND#15	a_2216_410##9	2.99733e-18
C548	SCD#4	VGND#13	4.31778e-17
C549	Q_N#2	a_2216_410##14	4.78631e-17
C550	a_1007_366##9	a_688_98##3	1.78921e-20
C551	VPWR#17	a_1007_366#	4.82426e-20
C552	Q_N#1	a_2216_410##13	4.65496e-17
C553	VGND#12	a_341_410#	1.42644e-19
C554	a_197_119##2	a_688_98##2	8.60392e-18
C555	VPWR#9	a_2216_410##18	1.31254e-17
C556	VGND#11	SCE#3	1.5205e-17
C557	a_868_368##8	a_2216_410##3	3.88437e-17
C558	Q_N#1	VGND#14	7.52794e-17
C559	a_1643_257##8	a_2216_410##9	2.85381e-19
C560	VGND#11	VGND#19	1.45505e-17
C561	a_868_368##9	SCE#1	2.70525e-19
C562	a_868_368##10	a_868_368##12	8.25998e-19
C563	RESET_B#3	a_2216_410##15	2.81743e-18
C564	VPWR#8	a_1997_82##3	5.57712e-18
C565	a_688_98##5	a_1007_366##2	1.95934e-19
C566	a_197_119##4	a_1007_366#	1.2445e-19
C567	RESET_B	a_1643_257##7	3.06971e-17
C568	a_197_119##4	VGND#20	7.81262e-17
C569	a_1007_366##2	VPWR#18	7.42982e-17
C570	a_197_119##5	VGND#20	1.53642e-17
C571	VPWR#6	RESET_B#2	5.53803e-20
C572	a_1007_366##14	a_688_98##3	1.7159e-18
C573	a_688_98##9	CLK_N#1	3.70957e-17
C574	a_1643_257##9	a_1643_257##6	1.43297e-17
C575	RESET_B	a_2216_410##18	5.33301e-18
C576	SET_B#7	a_1007_366##9	1.38373e-18
C577	a_1007_366##10	VPWR#15	8.63711e-17
C578	VGND#14	a_2216_410##15	7.93195e-19
C579	VGND#11	SCD#3	4.50291e-18
C580	a_1643_257##5	a_2452_74##2	1.18959e-18
C581	a_2216_410##14	VPWR#7	1.82968e-17
C582	a_1007_366##14	VGND#17	5.74889e-19
C583	a_868_368##9	a_1007_366##2	3.60205e-17
C584	VGND#11	a_688_98##11	4.75173e-18
C585	VGND#2	a_3272_94##3	9.28958e-19
C586	SCD#4	SCE	1.59129e-17
C587	VPWR#20	SCE#1	7.92587e-19
C588	SCD	a_197_119##4	8.91963e-19
C589	CLK_N#1	a_688_98##8	4.63179e-17
C590	SCE#3	D#1	2.55632e-17
C591	a_688_98##2	a_1154_464##5	2.46793e-17
C592	SET_B#7	a_1007_366##8	2.69511e-17
C593	CLK_N#2	a_688_98##5	6.44013e-17
C594	VPWR#6	a_1997_82##3	2.09937e-18
C595	a_868_368##8	a_688_98##6	3.28344e-17
C596	VGND#15	a_2216_410##13	8.6301e-19
C597	a_341_410##5	CLK_N#1	1.24676e-18
C598	a_3272_94##8	Q	2.34595e-18
C599	a_1643_257##9	a_1997_82##5	2.90853e-17
C600	a_1007_366##8	a_1007_366##4	2.95563e-18
C601	VPWR#18	a_688_98##4	3.8736e-19
C602	Q_N#2	RESET_B#1	8.62126e-20
C603	VGND#11	a_341_410##8	9.54996e-18
C604	VPWR#19	a_688_98##4	1.04108e-20
C605	a_3272_94##8	a_3272_94##3	3.84943e-19
C606	a_1997_82#	a_2216_410##15	3.81556e-19
C607	a_868_368##10	a_868_368##3	1.34867e-20
C608	a_1643_257##8	a_1643_257##6	3.75088e-19
C609	a_341_410#	a_688_98##5	4.76413e-18
C610	a_688_98##9	a_1007_366##2	1.29388e-20
C611	a_1643_257##7	a_2216_410##14	5.15599e-19
C612	a_1007_366##8	a_1007_366##13	3.6093e-18
C613	a_197_119##2	a_1007_366#	3.27714e-17
C614	a_688_98##9	SCE#1	8.47972e-18
C615	VGND#12	a_341_410##3	7.82968e-19
C616	Q_N#1	a_2216_410##15	4.5432e-17
C617	Q#1	VPWR#2	1.64452e-17
C618	a_688_98##3	a_1154_464##3	3.80946e-18
C619	VPWR#23	CLK_N#1	6.07323e-19
C620	a_688_98##7	a_2216_410##3	2.6051e-19
C621	a_197_119##2	a_1154_464##4	1.89042e-18
C622	VGND#8	a_1643_257#	7.39421e-19
C623	a_341_410#	CLK_N#2	1.74874e-17
C624	a_1007_366##9	a_1154_464##2	4.45573e-18
C625	VGND#15	VGND#14	2.40377e-18
C626	a_688_98##5	a_868_368##9	5.43737e-17
C627	a_1007_366##14	a_1154_464##2	5.72816e-18
C628	VPWR#8	a_1997_82##2	5.00623e-20
C629	RESET_B#1	VPWR#7	1.52274e-17
C630	a_868_368##9	a_688_98##4	8.43007e-18
C631	a_1154_464##3	a_1154_464##2	7.71907e-18
C632	VPWR#19	VPWR#17	7.88059e-19
C633	VGND#12	D#2	6.71398e-19
C634	a_197_119##4	a_688_98##4	9.86612e-18
C635	a_1007_366##9	VPWR#16	1.45341e-17
C636	VPWR#17	a_688_98##4	5.51638e-20
C637	a_341_410##5	SCE#1	3.86731e-17
C638	a_1473_73#	a_1007_366##14	4.85909e-17
C639	a_688_98##5	VPWR#20	3.03322e-17
C640	SCE#1	CLK_N#1	1.83864e-17
C641	a_1007_366##9	SET_B#3	6.72638e-19
C642	a_868_368##12	a_868_368##3	8.55595e-20
C643	a_2216_410##18	a_2216_410##14	4.7539e-19
C644	VGND#5	a_2216_410##10	1.22667e-17
C645	a_1997_82#	RESET_B#3	2.05523e-18
C646	a_1643_257##9	SET_B#6	2.64958e-17
C647	VPWR#8	a_1643_257##4	5.422e-18
C648	a_1997_82##5	a_1643_257##6	6.54573e-19
C649	a_1154_464##5	a_1007_366#	2.31981e-18
C650	VPWR#21	a_341_410##2	2.4898e-18
C651	a_2216_410##15	VGND#15	2.34776e-17
C652	SET_B#5	VGND#16	6.36393e-19
C653	SCD#3	SCE#3	3.99407e-17
C654	a_341_410##2	SCE#1	7.65613e-18
C655	a_868_368##9	VPWR#18	5.79927e-17
C656	a_1643_257##7	RESET_B#1	3.87023e-17
C657	VGND#18	a_688_98##2	1.44498e-18
C658	VGND#11	a_197_119##5	2.29101e-17
C659	VPWR#23	SCE#1	5.09588e-17
C660	VGND#1	VPWR#1	1.01277e-17
C661	a_1473_73##2	a_688_98##3	1.94806e-17
C662	a_1007_366##8	SET_B#3	4.90101e-17
C663	a_197_119##2	a_688_98##4	3.54166e-17
C664	a_688_98##6	a_1007_366##5	9.12391e-18
C665	a_868_368##10	a_688_98##2	1.51722e-19
C666	Q_N	a_3272_94##8	1.40679e-17
C667	VPWR#6	a_1643_257##4	2.12991e-19
C668	SET_B#7	a_688_98##7	1.1673e-18
C669	SCE#4	D#2	6.73833e-17
C670	Q_N#1	RESET_B#3	1.03804e-18
C671	a_341_410##4	a_363_119#	9.87534e-18
C672	a_2216_410##17	VPWR#9	6.80847e-17
C673	a_1007_366##8	VPWR#16	6.05393e-17
C674	a_197_119##5	SCE	6.89583e-17
C675	VGND#15	Q_N#1	6.92872e-17
C676	D#1	a_363_119#	9.87534e-18
C677	a_27_464#	SCE#1	1.26215e-18
C678	a_3272_94##3	a_3272_94##2	3.92949e-18
C679	a_341_410##3	SCE#1	3.57966e-18
C680	VGND#13	SCE	1.45014e-18
C681	a_2216_410##18	RESET_B#1	2.93844e-17
C682	a_1473_73##2	a_1473_73#	2.44041e-18
C683	a_868_368##12	a_688_98##2	1.09583e-19
C684	CLK_N#2	a_688_98##9	3.35515e-18
C685	VGND#8	a_1154_464#	1.53234e-18
C686	VGND#11	VGND#13	9.73344e-17
C687	SCD#2	SCE#4	7.55475e-17
C688	a_1643_257##8	a_1643_257##7	2.7974e-18
C689	a_1154_464##5	a_688_98##4	1.6707e-19
C690	a_197_119##4	CLK_N#3	2.9903e-17
C691	a_197_119##5	a_197_119##4	1.77946e-18
C692	VPWR#23	a_341_410##3	2.09609e-18
C693	a_688_98##6	SET_B#2	9.88394e-19
C694	VGND#11	a_688_98##3	1.99946e-18
C695	a_2216_410##7	a_2216_410##5	9.24217e-19
C696	a_1643_257##2	a_2216_410##3	7.35167e-20
C697	a_1643_257##7	a_1997_82##3	2.27818e-18
C698	a_1007_366##9	a_1643_257##3	2.19416e-17
C699	a_197_119##6	SCE#1	3.38759e-18
C700	VGND#12	SCE#4	8.58951e-19
C701	a_688_98##3	a_868_368##4	9.62671e-19
C702	Q#2	Q	2.02699e-18
C703	RESET_B#3	VGND#15	7.08335e-18
C704	VGND#18	a_1007_366#	6.72926e-18
C705	a_1643_257##9	a_2216_410##3	2.77481e-17
C706	a_1643_257##6	a_1997_82#	3.50134e-17
C707	VGND#5	RESET_B#2	9.16228e-20
C708	a_1997_82##5	SET_B#6	2.7093e-18
C709	VPWR	VPWR#17	9.89664e-19
C710	a_1473_73##2	a_1154_464##2	2.3485e-18
C711	SET_B#2	a_1007_366##6	5.44755e-18
C712	VPWR	VPWR#15	1.48489e-16
C713	a_341_410##5	D#3	1.33471e-19
C714	VPWR	VPWR#13	5.11292e-17
C715	a_197_119##2	CLK_N#3	3.03575e-19
C716	VPWR#12	a_868_368##5	7.7303e-18
C717	VPWR	VPWR#10	7.72772e-17
C718	a_2216_410##18	a_2556_392#	4.77082e-18
C719	VPWR#8	SET_B#4	2.5632e-18
C720	a_1643_257##2	a_868_368##7	4.48605e-19
C721	a_1007_366##2	a_1070_464#	1.23229e-17
C722	VPWR	VPWR#8	9.05655e-17
C723	VGND#5	a_2216_410##9	2.98831e-20
C724	a_27_464#	a_341_410##3	5.8747e-17
C725	VPWR#22	SCE#2	1.45513e-20
C726	a_2452_74#	a_2216_410##15	1.07906e-18
C727	Q_N#1	a_1997_82#	1.72899e-19
C728	D#3	a_341_410##3	4.55194e-17
C729	a_1007_366##8	a_1643_257##3	4.52488e-18
C730	a_868_368##10	a_1007_366#	4.17984e-18
C731	a_341_410#	a_688_98##9	1.12409e-17
C732	a_2216_410##18	a_1997_82##3	7.50771e-17
C733	a_1643_257##2	a_688_98##6	4.20394e-17
C734	VGND#9	a_868_368##3	1.39079e-18
C735	VPWR#20	a_868_368##9	5.42526e-17
C736	VPWR#12	a_1007_366##4	3.10713e-18
C737	VPWR#23	D#3	8.12252e-20
C738	VGND#12	VGND#10	2.06297e-20
C739	VGND#2	a_3272_94##2	8.3927e-20
C740	a_688_98##11	a_688_98##9	1.62715e-18
C741	a_1997_82##7	a_2216_410##2	2.99828e-19
C742	a_868_368##12	a_1007_366#	7.44206e-19
C743	a_1473_73##2	a_1007_366##14	3.03962e-17
C744	VPWR#11	VPWR#9	1.47651e-18
C745	a_197_119##6	a_341_410##3	2.61031e-17
C746	RESET_B#3	a_1643_257##11	1.24378e-17
C747	SCE#3	a_119_119#	9.7209e-18
C748	a_2216_410##17	a_2216_410##16	4.31124e-18
C749	a_1643_257##2	a_1007_366##6	2.26106e-17
C750	a_2216_410##10	a_2216_410##14	4.90915e-18
C751	VPWR	a_2216_410##17	2.09873e-17
C752	SCD#3	a_119_119#	1.01349e-17
C753	a_1643_257##7	a_1643_257##4	2.46249e-19
C754	SCE#2	a_341_410##2	1.05997e-18
C755	a_197_119##2	a_688_98##3	4.07765e-17
C756	VPWR#25	SCE#1	5.45656e-20
C757	SET_B#7	a_1997_82##6	9.25702e-18
C758	VPWR	a_1643_257##9	2.73752e-18
C759	a_341_410#	VPWR#23	1.50349e-17
C760	a_341_410##5	a_341_410##2	6.14336e-19
C761	a_1007_366##9	a_1007_366##8	5.38112e-18
C762	VPWR	a_1997_82##5	4.8891e-18
C763	VGND#18	a_688_98##4	3.96047e-19
C764	a_27_464#	D#3	1.9511e-17
C765	a_2216_410##22	a_2216_410##15	5.24846e-19
C766	a_197_119##4	SCE#2	5.63101e-17
C767	a_1643_257##2	SET_B#1	2.16489e-17
C768	VGND#15	a_1997_82#	1.24682e-18
C769	a_1643_257##8	a_2216_410##18	3.37123e-18
C770	a_2216_410##10	RESET_B#1	7.85196e-18
C771	VPWR#10	a_2216_410#	4.06864e-18
C772	a_3272_94##10	VPWR#2	7.72974e-18
C773	Q#2	Q#1	1.48436e-18
C774	VGND#6	a_1997_82##2	3.00826e-20
C775	VGND#13	a_197_119##5	1.81318e-17
C776	a_868_368##10	a_868_368##2	3.58404e-19
C777	a_197_119##2	SCE#2	1.0528e-19
C778	a_1007_366##9	a_1154_464##4	1.39762e-17
C779	a_868_368##11	a_1007_366##9	8.77189e-19
C780	a_2216_410##5	a_3272_94##3	3.24003e-17
C781	SCE#5	D#3	5.27706e-17
C782	VPWR	a_1007_366##9	3.38454e-18
C783	RESET_B#2	a_2216_410##14	9.88319e-19
C784	a_2216_410##18	a_1643_257##4	1.84908e-17
C785	a_688_98##9	a_868_368##9	2.30785e-18
C786	VPWR#23	SCE#5	2.5873e-20
C787	a_1643_257##2	a_1643_257#	8.4303e-18
C788	VPWR	a_1007_366##8	2.229e-17
C789	SCE	a_27_464#	1.38607e-18
C790	VPWR#8	SET_B#5	9.46869e-20
C791	a_1643_257##9	a_868_368##7	1.89885e-17
C792	a_1997_82##5	a_2216_410##3	2.08474e-17
C793	a_197_119##6	a_341_410#	5.10935e-18
C794	SET_B#6	a_1643_257##6	2.41788e-17
C795	a_197_119##6	D#3	3.31378e-17
C796	Q	VPWR#1	3.53372e-17
C797	a_2216_410##10	a_1997_82##3	2.96003e-19
C798	Q	Q#1	1.37163e-18
C799	VPWR#9	a_1997_82##3	5.43889e-18
C800	VPWR#4	Q	2.87224e-17
C801	VPWR#25	a_341_410##3	2.65181e-19
C802	SCE	a_27_464##2	1.72718e-17
C803	a_3272_94##10	Q	2.4312e-19
C804	a_2216_410##10	a_2216_410##9	2.99448e-18
C805	a_868_368##12	a_688_98##4	3.69269e-17
C806	a_3272_94##10	a_2216_410##7	2.45495e-20
C807	a_1643_257##2	a_1154_464#	2.29924e-19
C808	a_868_368##10	a_688_98##4	1.71887e-17
C809	SET_B#7	VPWR#14	4.36816e-18
C810	VPWR#6	VPWR#5	2.17212e-18
C811	a_1997_82##7	a_868_368##8	5.64563e-17
C812	a_197_119##2	a_1007_366##14	5.22295e-17
C813	a_1007_366##8	a_1154_464##4	7.07581e-19
C814	a_1997_82##6	VPWR#12	1.75138e-17
C815	a_1643_257##2	a_1902_125#	1.51863e-17
C816	a_3272_94##3	VPWR#4	3.03869e-17
C817	a_27_464#	SCE#5	7.1624e-18
C818	RESET_B	a_2216_410##14	1.57995e-19
C819	a_197_119##2	a_1154_464##2	1.34463e-17
C820	a_27_464#	D#2	1.60092e-19
C821	a_1997_82##3	RESET_B#2	5.55418e-19
C822	VGND	a_688_98##3	5.9313e-20
C823	VGND#9	a_688_98##3	4.61102e-17
C824	VPWR#11	a_2216_410##17	2.88263e-17
C825	a_2216_410##22	RESET_B#3	5.29578e-19
C826	a_688_98##9	VPWR#20	5.52363e-17
C827	SCD#1	SCE#5	2.94428e-17
C828	SCD	a_197_119##6	7.04064e-18
C829	VGND#15	a_1643_257##6	1.96015e-19
C830	a_197_119##6	D#2	4.33976e-17
C831	a_197_119##6	SCE#5	2.02117e-18
C832	a_1997_82##2	RESET_B#1	2.39804e-19
C833	a_2216_410##18	SET_B#4	8.00168e-19
C834	a_688_98##4	VGND#19	1.07785e-17
C835	a_1154_464##3	a_1154_464#	1.74766e-19
C836	a_197_119##4	a_688_98##5	3.66713e-17
C837	a_197_119##4	a_341_410##4	2.39517e-17
C838	a_2216_410##10	a_2216_410##7	1.0014e-19
C839	VPWR#25	D#3	1.68463e-18
C840	SCD	a_27_464##2	4.73451e-17
C841	a_868_368##10	a_1007_366##2	1.94065e-17
C842	a_3272_94##8	a_3272_94##2	2.59785e-19
C843	a_197_119#	a_1007_366##9	5.20967e-17
C844	a_3272_94##6	a_3272_94##4	4.94132e-17
C845	VPWR#9	a_1643_257##4	4.28412e-17
C846	a_1007_366##9	a_688_98#	1.69369e-19
C847	a_2452_74#	a_1997_82#	3.68866e-17
C848	a_1643_257##9	a_2216_410##10	1.09203e-18
C849	a_2216_410##2	VPWR#10	2.01998e-18
C850	VPWR#23	SCE#2	3.56907e-19
C851	Q_N	a_3272_94##10	6.11285e-18
C852	a_27_464#	SCD#1	2.85329e-19
C853	a_1997_82##2	a_1997_82##3	4.46025e-18
C854	VGND#6	a_1643_257##5	9.30752e-20
C855	a_1154_464##5	a_688_98##3	1.47515e-18
C856	Q_N	VPWR#5	1.31422e-17
C857	a_1154_464##3	a_868_368##3	9.22204e-18
C858	VPWR#5	VPWR#2	1.17523e-19
C859	VPWR#10	a_688_98##7	8.47423e-18
C860	Q_N	Q_N#2	8.68101e-19
C861	a_868_368##12	CLK_N#3	1.57518e-18
C862	VPWR#7	Q_N	1.2897e-17
C863	a_197_119##2	a_1473_73##2	7.42088e-17
C864	a_2452_74#	VGND#15	5.45266e-18
C865	a_1643_257##9	a_688_98##6	3.41138e-18
C866	a_27_464##2	D#3	5.06761e-18
C867	a_2216_410##3	SET_B#6	2.24569e-17
C868	a_2216_410##10	a_1643_257##8	3.31074e-17
C869	a_1154_464##3	a_688_98##2	8.60508e-20
C870	a_868_368##10	CLK_N#3	9.301e-19
C871	a_1997_82##2	a_1643_257##4	2.10466e-17
C872	a_197_119##6	SCE#4	1.0938e-18
C873	a_197_119##6	SCD#1	2.09635e-20
C874	SCE	D#1	4.50814e-19
C875	VGND#8	a_1473_73#	3.91962e-17
C876	a_868_368##11	a_688_98#	1.20352e-17
C877	SCE	SCE#3	5.76566e-19
C878	VPWR#25	SCE#5	2.90977e-17
C879	VPWR#6	Q_N#2	2.63099e-17
C880	a_2216_410##22	a_1997_82#	4.14009e-17
C881	a_868_368##9	VPWR#19	9.95894e-18
C882	a_1997_82##2	SET_B#4	3.63675e-18
C883	CLK_N#3	VGND#19	2.61768e-17
C884	VGND#6	a_1643_257##9	9.89478e-17
C885	SET_B#4	VPWR#9	2.68553e-17
C886	VGND	VGND#9	3.66738e-17
C887	VGND	VGND#8	1.55671e-16
C888	a_2216_410##9	Q_N#2	6.10023e-20
C889	VGND	VGND#6	1.48943e-16
C890	VGND#9	a_1007_366#	1.1665e-18
C891	VPWR#5	a_2216_410##7	6.05448e-18
C892	VGND#10	VGND#9	2.72598e-20
C893	VPWR#11	a_1643_257##4	3.56513e-19
C894	a_3272_94##10	a_2216_410##5	8.65563e-19
C895	a_688_98##2	a_868_368##4	2.2725e-17
C896	a_341_410##8	a_688_98##4	4.88874e-19
C897	a_27_464##2	SCE#5	1.4101e-17
C898	VPWR#21	a_688_98#	1.77579e-18
C899	a_2216_410##4	a_3272_94##6	3.65145e-17
C900	a_197_119##4	CLK_N#2	6.1026e-19
C901	a_197_119##4	D#1	6.93807e-18
C902	a_2452_74#	a_1643_257##6	6.65808e-19
C903	VPWR#3	RESET_B	3.40173e-18
C904	a_688_98##5	a_868_368##10	3.38567e-17
C905	VGND	a_1643_257##9	6.15292e-17
C906	a_868_368##12	SCE#2	2.43631e-19
C907	VPWR	a_2216_410##18	1.62383e-17
C908	VGND	a_1643_257##8	1.2717e-18
C909	a_27_464##2	SCE#4	1.67652e-18
C910	VGND	a_1997_82##5	2.71231e-18
C911	VGND#3	RESET_B	2.77966e-18
C912	a_341_410##5	a_688_98##9	5.88523e-17
C913	VPWR	VPWR#9	1.56941e-17
C914	VPWR#3	VPWR#8	1.9671e-17
C915	VPWR#23	VPWR#20	6.27521e-19
C916	a_197_119##6	SCD#2	2.30083e-18
C917	a_197_119##6	SCE#2	7.80088e-20
C918	VGND#3	VGND#1	5.30193e-17
C919	VPWR	VPWR#11	1.86486e-18
C920	VGND#8	a_688_98##3	1.62847e-17
C921	SET_B#4	a_2216_410##16	2.12441e-17
C922	VPWR#25	SCD#1	2.8217e-17
C923	a_1997_82##2	a_2216_410##17	2.77062e-17
C924	VPWR	a_1997_82##6	2.32737e-17
C925	a_688_98##11	CLK_N#3	2.57146e-17
C926	a_2452_74##2	a_1997_82#	1.38991e-18
C927	VPWR	VPWR#14	1.21034e-17
C928	Q_N	a_2216_410##11	7.57146e-21
C929	VGND#6	SET_B#5	7.49543e-19
C930	VPWR#10	a_868_368##8	2.74359e-19
C931	Q_N	a_2216_410##13	4.16822e-20
C932	VPWR	VPWR#16	1.27742e-19
C933	a_868_368##9	VPWR#17	1.59825e-17
C934	Q_N	a_2216_410##15	5.45241e-20
C935	VPWR	a_1007_366##10	4.44365e-17
C936	Q_N	RESET_B#3	4.52274e-19
C937	a_1997_82##5	a_688_98##6	9.07025e-20
C938	a_1643_257##9	a_1007_366##6	7.63278e-20
C939	a_2216_410##10	VPWR#7	8.76122e-17
C940	VPWR	a_197_119#	1.29917e-17
C941	a_2216_410##12	a_3272_94##6	1.10217e-19
C942	VPWR#3	VPWR#6	1.48141e-16
C943	a_868_368##2	a_688_98##2	1.58173e-17
C944	CLK_N#6	a_688_98##5	2.11349e-17
C945	a_1997_82##6	VPWR#11	1.19874e-17
C946	VGND#10	a_688_98##4	7.2954e-18
C947	VPWR#9	a_2216_410#	8.05733e-19
C948	a_2216_410##2	a_1997_82##3	4.85772e-19
C949	a_868_368##11	a_688_98##8	2.10464e-19
C950	VGND#3	Q#2	2.06931e-17
C951	a_868_368##7	a_2216_410##3	3.96299e-17
C952	a_1643_257##8	RESET_B#2	6.4205e-18
C953	VGND#19	SCE#2	9.47162e-19
C954	a_27_464##2	SCD#1	2.68979e-17
C955	VPWR#21	a_1007_366##3	2.80056e-18
C956	a_1643_257##6	a_2216_410##22	1.55088e-17
C957	VPWR#11	SET_B#4	2.61589e-18
C958	a_1007_366#	a_868_368##2	1.90756e-17
C959	a_27_464#	a_341_410##2	3.55558e-18
C960	Q	a_3272_94##4	1.10269e-17
C961	a_27_464##2	SCD#2	4.49744e-18
C962	a_1643_257##7	a_2216_410##10	1.70897e-17
C963	Q	a_3272_94##6	5.97566e-18
C964	a_2216_410##10	RESET_B	3.56284e-17
C965	VPWR#15	VPWR#13	7.87344e-19
C966	a_341_410##8	CLK_N#3	2.7003e-18
C967	a_2216_410##2	a_1643_257##4	5.96964e-19
C968	VPWR#15	a_1007_366##4	3.73492e-19
C969	RESET_B	RESET_B#2	2.05098e-17
C970	VPWR#3	VPWR#2	7.38511e-17
C971	VPWR#6	VPWR#7	2.07367e-17
C972	a_868_368##10	a_868_368##11	4.17618e-18
C973	VGND#3	VGND#4	2.25155e-17
C974	RESET_B	a_1997_82##2	6.95889e-19
C975	VPWR#21	a_688_98##8	3.63908e-18
C976	VGND	a_2452_74#	9.87532e-18
C977	a_2216_410##12	a_2216_410##4	6.45493e-18
C978	VGND	a_2216_410##22	7.41448e-18
C979	VGND	a_2452_74##2	2.70565e-17
C980	a_197_119##2	a_1154_464##5	1.12831e-16
C981	a_1007_366##2	a_688_98##2	1.60404e-18
C982	a_1007_366##9	VPWR#15	1.15299e-18
C983	VGND	a_1997_82##7	1.08802e-17
C984	a_2216_410##10	a_2216_410##18	3.48312e-18
C985	VGND#9	a_688_98##4	1.05255e-17
C986	a_2216_410##2	SET_B#4	2.07978e-17
C987	a_197_119##4	a_341_410#	4.83127e-17
C988	a_197_119##4	SCE#3	9.03238e-19
C989	a_1997_82##6	a_2216_410##17	1.4826e-18
C990	VGND#9	a_1473_73##2	8.21667e-18
C991	a_688_98##11	SCE#2	5.50816e-18
C992	VGND	a_1473_73#	2.48069e-17
C993	VGND	a_1007_366##14	7.72543e-18
C994	VGND#2	a_3272_94#	2.12388e-18
C995	a_1007_366##14	a_1007_366##9	9.44585e-19
C996	VGND	a_1473_73##2	3.03333e-17
C997	VGND	a_197_119##2	2.31644e-17
C998	a_2452_74##2	a_1643_257##6	3.8326e-17
C999	VPWR#21	CLK_N#1	1.22217e-18
C1000	VGND#3	a_3272_94##9	2.07608e-17
C1001	a_1007_366##2	a_1007_366#	1.87175e-18
C1002	VPWR#13	a_1007_366##4	9.12183e-19
C1003	SCD	D#3	5.10179e-19
C1004	Q_N	a_2216_410##4	1.26958e-19
C1005	VPWR#7	a_2216_410##9	3.38587e-18
C1006	Q_N	a_2216_410##12	1.07526e-17
C1007	SCD	SCE#5	2.1113e-18
C1008	Q_N	a_2216_410##14	6.63037e-18
C1009	a_2216_410##7	Q_N#2	2.41976e-19
C1010	Q_N	RESET_B#1	2.5282e-19
C1011	a_1643_257##9	a_1997_82##2	6.62668e-17
C1012	a_2216_410##17	a_1643_257##5	3.81832e-19
C1013	VPWR#11	a_2216_410#	3.05614e-17
C1014	VGND#8	a_1154_464##2	2.78157e-19
C1015	VGND#11	a_197_119##4	1.07321e-16
C1016	VPWR#23	a_341_410##5	5.22406e-17
C1017	VGND#10	a_197_119##2	3.42781e-17
C1018	a_688_98##4	a_1007_366##2	1.00661e-17
C1019	VPWR#21	SCE	6.16283e-18
C1020	CLK_N#6	SCE#2	8.60977e-19
C1021	a_1643_257##7	RESET_B#2	3.71412e-18
C1022	a_2216_410##22	SET_B#6	7.23797e-19
C1023	CLK_N#6	CLK_N#2	6.31949e-18
C1024	VPWR#21	SCE#1	5.57847e-18
C1025	VGND#11	SCE	8.55417e-18
C1026	VGND#6	a_2216_410##2	2.33629e-20
C1027	a_1997_82##6	SET_B#4	1.42777e-19
C1028	a_1997_82##5	a_1007_366##6	4.46979e-21
C1029	VGND#17	SET_B#2	3.27312e-19
C1030	a_3272_94##2	VNB	3.87691e-17
C1031	a_341_410##8	SCE#2	2.88492e-17
C1032	a_688_98##7	a_2216_410##2	3.4991e-17
C1033	a_2216_410##9	VNB	2.92625e-17
C1034	a_2216_410##7	VNB	4.98176e-17
C1035	a_1643_257##8	a_1643_257##11	2.78338e-18
C1036	VPWR#20	VPWR#17	1.26591e-18
C1037	a_2216_410##5	VNB	4.28361e-17
C1038	a_688_98##3	VNB	1.8079e-16
C1039	a_1154_464##2	VNB	2.85311e-17
C1040	a_1643_257##8	a_1997_82##2	3.33354e-17
C1041	a_688_98##6	a_868_368##7	6.62257e-18
C1042	a_341_410##2	VNB	5.05521e-17
C1043	VGND#10	CLK_N#3	4.13751e-18
C1044	a_2216_410##18	RESET_B#2	3.54277e-19
C1045	a_868_368##11	a_1007_366##10	8.63956e-18
C1046	VPWR#21	SCD	5.55771e-18
C1047	VGND#3	Q	1.32166e-18
C1048	a_1473_73#	SET_B#2	2.69565e-19
C1049	VPWR#21	a_341_410##3	1.5694e-18
C1050	VPWR	a_1997_82##3	3.82325e-19
C1051	a_2216_410##2	a_868_368##5	5.81333e-19
C1052	a_2216_410##14	a_2216_410##12	4.74446e-17
C1053	VPWR	a_1643_257##4	1.35974e-18
C1054	VGND#3	Q_N#1	2.85763e-17
C1055	VGND#8	a_1473_73##2	4.88786e-17
C1056	Q#1	VPWR#1	6.99875e-17
C1057	a_1997_82##5	a_1997_82##2	4.47478e-18
C1058	a_2216_410##17	a_1997_82##3	4.22702e-19
C1059	VPWR#14	VPWR#11	3.85103e-19
C1060	a_1643_257##2	a_1997_82##7	5.01528e-17
C1061	a_688_98##5	a_688_98##4	4.80339e-18
C1062	a_2452_74#	a_2216_410##22	5.7073e-17
C1063	a_868_368##8	a_688_98##7	1.67902e-17
C1064	a_1997_82##5	a_2216_410##16	1.15535e-18
C1065	VPWR#22	VNB	4.20714e-17
C1066	VPWR#15	SET_B#3	8.95506e-18
C1067	VPWR#19	VNB	2.81655e-17
C1068	VPWR	SET_B#3	1.212e-19
C1069	a_197_119##6	SCE#3	3.34311e-19
C1070	VPWR#17	VNB	7.50183e-17
C1071	a_2452_74##2	SET_B#6	2.68714e-17
C1072	VPWR#15	VNB	7.15913e-17
C1073	VPWR#13	VNB	2.69223e-17
C1074	VPWR	a_1643_257##3	6.62546e-19
C1075	VGND#18	a_688_98##3	1.40805e-17
C1076	VPWR#10	VNB	3.90361e-17
C1077	SCE#2	VGND#20	1.79865e-17
C1078	a_868_368##11	a_197_119#	7.38077e-18
C1079	VPWR#8	VNB	5.79217e-17
C1080	a_197_119##4	D#2	4.74674e-17
C1081	VPWR#6	VNB	6.15259e-17
C1082	VPWR	a_1154_464##4	4.78479e-19
C1083	VPWR#11	a_688_98##7	4.3242e-18
C1084	VPWR#2	VNB	3.70927e-17
C1085	Q_N	VPWR#3	1.76091e-18
C1086	VPWR#21	D#3	1.37466e-18
C1087	VGND#12	VNB	4.63338e-17
C1088	a_197_119##6	a_341_410##2	9.48221e-18
C1089	VGND#10	VNB	3.23899e-17
C1090	VGND#3	Q_N	2.00776e-18
C1091	VGND#9	VNB	6.48403e-17
C1092	VGND#8	VNB	5.82774e-17
C1093	a_3272_94##3	Q	1.97718e-17
C1094	VGND#6	VNB	8.18611e-17
C1095	a_688_98##5	CLK_N#3	1.98944e-18
C1096	VGND#5	VNB	6.6582e-17
C1097	VGND#2	VNB	3.92516e-17
C1098	a_3272_94##8	VNB	1.12587e-18
C1099	VGND	a_1997_82#	2.5475e-18
C1100	a_688_98##9	VPWR#19	2.05691e-18
C1101	VGND	a_1643_257##6	1.4437e-18
C1102	a_1997_82##2	a_1643_257##7	2.06393e-17
C1103	a_1007_366##8	VPWR#15	9.4107e-18
C1104	a_1997_82##6	a_2216_410#	3.84479e-18
C1105	a_2216_410##17	VNB	1.04545e-17
C1106	VGND#9	a_197_119##2	1.16944e-16
C1107	VGND	a_2216_410##3	2.54577e-18
C1108	VGND#2	a_3272_94##5	4.72845e-18
C1109	a_1643_257##9	VNB	1.375e-17
C1110	a_1643_257##8	VNB	1.74218e-17
C1111	VGND	a_688_98##6	1.03288e-18
C1112	a_1997_82##5	VNB	7.34731e-18
C1113	VGND	a_1007_366##6	1.28045e-18
C1114	VGND	SET_B#1	3.63169e-18
C1115	VPWR#3	a_2216_410##9	1.83141e-20
C1116	a_2216_410##22	a_2216_410##3	1.63153e-19
C1117	VGND#12	SCE#2	3.86085e-17
C1118	a_3272_94##8	VPWR#2	2.60842e-19
C1119	a_688_98##5	SCE#2	4.29605e-19
C1120	a_868_368##11	a_1154_464##7	4.29446e-17
C1121	a_1007_366##9	VNB	1.56312e-21
C1122	a_1007_366##8	VNB	1.58128e-17
C1123	VPWR#21	SCE#5	5.97766e-19
C1124	a_1643_257##2	VGND#17	8.29584e-17
C1125	a_197_119##4	VNB	3.26006e-17
C1126	VPWR#21	a_1007_366##10	2.15394e-17
C1127	a_197_119##4	a_341_410##2	1.46112e-17
C1128	a_1643_257##9	a_1643_257##5	1.78687e-17
C1129	a_868_368##10	VNB	4.69192e-18
C1130	a_2216_410##10	Q_N	2.26156e-17
C1131	VPWR#21	CLK_N#6	3.56739e-18
C1132	a_341_410#	CLK_N#6	1.18972e-17
C1133	CLK_N#6	VNB	1.95039e-18
C1134	SCE	D#2	2.61947e-17
C1135	a_1997_82##2	a_2216_410##18	4.29654e-17
C1136	a_3272_94##8	a_2216_410##7	1.60187e-18
C1137	a_2216_410##17	SET_B#5	6.40043e-19
C1138	Q_N	RESET_B#2	3.93139e-19
C1139	a_2216_410##18	VPWR#8	2.47744e-17
C1140	a_1007_366##5	VPWR#13	4.03341e-19
C1141	SCE	SCE#4	3.05073e-17
C1142	SET_B#7	VPWR	3.00792e-17
C1143	VPWR	VPWR#12	4.81309e-17
C1144	SCD#2	SCE	1.30163e-17
C1145	SET_B#6	VGND#16	1.09784e-17
C1146	SCD#4	VNB	1.41165e-17
C1147	VGND#1	VNB	6.82401e-17
C1148	Q#2	VNB	9.27932e-18
C1149	VGND#4	VNB	5.47255e-18
C1150	a_1643_257##2	a_1473_73#	4.10944e-17
C1151	a_3272_94##9	VNB	7.86616e-18
C1152	a_197_119##2	VGND#18	1.00528e-16
C1153	VGND#14	VNB	1.28304e-17
C1154	a_27_464#	VPWR#23	5.59787e-17
C1155	Q_N#1	VNB	2.17742e-18
C1156	a_197_119##6	a_341_410##5	2.38181e-18
C1157	VGND#15	VNB	1.2407e-17
C1158	VGND#6	a_868_368##8	8.31447e-20
C1159	SCD	D#2	3.83657e-19
C1160	VPWR#4	VPWR#1	1.56532e-18
C1161	a_2452_74#	VNB	1.13922e-17
C1162	VPWR#21	SCD#1	1.87414e-18
C1163	a_2216_410##22	VNB	8.55655e-18
C1164	a_2452_74##2	VNB	4.57061e-18
C1165	SCD	SCE#4	3.97154e-18
C1166	a_1643_257##8	a_1643_257##5	1.72343e-19
C1167	a_688_98##6	a_1007_366##6	3.96187e-17
C1168	VPWR#21	a_197_119#	7.30901e-18
C1169	VGND#3	a_3272_94#	4.56475e-18
C1170	RESET_B#1	a_2216_410##14	3.58567e-18
C1171	a_1997_82##7	VNB	4.70215e-18
C1172	VGND#17	VNB	4.07186e-18
C1173	SCD	SCD#2	3.19493e-17
C1174	a_341_410##5	VPWR#22	4.28364e-18
C1175	a_1473_73#	VNB	1.09772e-17
C1176	a_1473_73##2	VNB	1.0752e-17
C1177	VPWR#11	a_868_368##5	1.43472e-18
C1178	a_197_119##2	VNB	5.01703e-17
C1179	a_1154_464##5	VNB	1.71542e-18
C1180	VPWR	a_1997_82##2	4.88165e-18
C1181	VGND#18	VNB	2.50613e-18
C1182	a_1007_366##5	a_688_98##7	8.1179e-19
C1183	VGND#19	VNB	1.85974e-18
C1184	a_688_98##11	VNB	1.87312e-18
C1185	VGND#20	a_341_410##4	2.83412e-17
C1186	VGND#10	SCE#2	4.32998e-20
C1187	a_341_410##8	VNB	2.43966e-18
C1188	SCE#2	CLK_N#2	2.50426e-17
C1189	VGND#11	a_868_368##10	2.80671e-18
C1190	VGND#3	a_2452_74#	8.10986e-18
C1191	VGND#20	VNB	3.20116e-18
C1192	a_1007_366##14	a_1643_257##2	4.33558e-17
C1193	a_197_119##5	VNB	2.72952e-18
C1194	VPWR	a_2216_410##2	4.11786e-18
C1195	a_1643_257##9	a_2216_410##22	5.30994e-17
C1196	VGND#13	VNB	7.90418e-17
C1197	a_2452_74##2	a_2216_410##3	1.405e-18
C1198	VPWR#1	VNB	7.99739e-17
C1199	VPWR	a_868_368##8	1.19606e-18
C1200	a_1997_82##6	a_688_98##7	4.7954e-17
C1201	Q#1	VNB	2.64705e-18
C1202	VPWR#4	VNB	1.80848e-18
C1203	a_3272_94##10	VNB	1.61596e-17
C1204	a_341_410#	a_688_98##4	2.10588e-19
C1205	VPWR#5	VNB	1.1922e-17
C1206	Q_N#2	VNB	2.34341e-18
C1207	VPWR#7	VNB	1.58716e-18
C1208	VPWR	a_1007_366##5	3.79428e-18
C1209	a_1643_257##7	VNB	8.43621e-18
C1210	a_1997_82##5	a_1643_257##5	9.06685e-20
C1211	a_2216_410##18	VNB	1.22959e-17
C1212	VPWR	SET_B#2	1.52081e-18
C1213	VPWR#9	VNB	9.3993e-19
C1214	VPWR#21	a_1154_464##7	9.02937e-18
C1215	VPWR#3	a_2216_410##7	1.352e-18
C1216	a_2216_410##17	a_1643_257##4	6.45133e-18
C1217	a_1997_82##2	VPWR#9	1.56124e-18
C1218	VPWR#11	VNB	4.75401e-18
C1219	VPWR	a_1643_257##2	4.82831e-18
C1220	VGND#14	VPWR#5	1.32866e-17
C1221	a_1997_82##6	VNB	8.29367e-18
C1222	a_197_119##5	SCE#2	4.53673e-19
C1223	VGND#3	a_3272_94##5	1.70896e-18
C1224	VPWR	a_1154_464##3	6.08096e-18
C1225	a_1007_366##5	a_868_368##5	7.30937e-18
C1226	VPWR#14	a_2216_410#	1.52027e-19
C1227	VPWR#14	VNB	7.6158e-18
C1228	VPWR#16	VNB	4.30384e-19
C1229	VPWR	a_868_368##4	2.2777e-19
C1230	SCE#4	a_197_119##4	2.37568e-18
C1231	a_1007_366##10	VNB	1.65478e-17
C1232	a_197_119#	VNB	5.69195e-18
C1233	a_1154_464##7	VNB	3.42951e-18
C1234	VPWR#18	VNB	2.89409e-18
C1235	a_341_410#	CLK_N#3	7.79232e-19
C1236	a_868_368##9	VNB	1.86186e-17
C1237	VPWR#13	VPWR#10	2.71109e-19
C1238	VPWR#20	VNB	3.05912e-19
C1239	a_1997_82##3	a_2216_410##14	2.07957e-19
C1240	a_688_98##9	VNB	1.0464e-17
C1241	VGND	SET_B#7	5.09666e-18
C1242	a_341_410##5	VNB	1.27658e-17
C1243	a_197_119##2	a_1007_366##9	3.04673e-17
C1244	VGND#3	a_2216_410##22	1.04649e-17
C1245	VPWR#23	VNB	1.04212e-17
C1246	a_27_464#	VNB	1.573e-17
C1247	a_197_119##6	VNB	3.82834e-18
C1248	VGND	VGND#7	6.46249e-17
C1249	VPWR#15	a_1643_257##3	8.42418e-18
C1250	a_2216_410##18	VPWR#6	2.17329e-17
C1251	VPWR#25	VNB	2.4887e-18
C1252	VGND	a_868_368##11	3.26097e-17
C1253	a_27_464##2	VNB	4.84784e-17
C1254	a_3272_94#	VNB	3.02796e-17
C1255	a_1007_366##8	VPWR#13	9.74028e-18
C1256	a_3272_94##5	VNB	2.91136e-17
C1257	a_688_98##6	SET_B#1	1.92549e-17
C1258	a_2216_410##11	VNB	4.06916e-17
C1259	a_868_368##9	a_868_368##11	5.88074e-18
C1260	a_2216_410##13	VNB	3.15836e-17
C1261	a_197_119##5	a_197_119##6	1.12697e-18
C1262	a_2216_410##15	VNB	2.96462e-17
C1263	VPWR#14	a_1997_82##6	2.38639e-17
C1264	RESET_B#3	VNB	3.09192e-17
C1265	a_1997_82#	VNB	3.81198e-17
C1266	a_1007_366##5	a_1007_366##4	4.38739e-18
C1267	a_1643_257##6	VNB	2.59965e-17
C1268	SET_B#6	VNB	2.66051e-17
C1269	VGND#2	a_2216_410##5	5.21382e-20
C1270	a_2216_410##3	VNB	5.55097e-17
C1271	a_868_368##7	VNB	2.93708e-17
C1272	VGND	a_1997_82##2	4.80984e-18
C1273	a_341_410#	SCE#2	4.93723e-17
C1274	a_688_98##6	VNB	2.00168e-16
C1275	a_1007_366##6	VNB	3.23024e-17
C1276	VGND	a_1643_257##5	3.32079e-19
C1277	SET_B#1	VNB	2.26673e-17
C1278	VGND#2	a_2216_410##11	4.91793e-18
C1279	a_1643_257#	VNB	3.05839e-17
C1280	VGND	SET_B#5	3.16953e-18
C1281	VGND#3	a_2216_410##11	9.57682e-18
C1282	a_1154_464#	VNB	2.29202e-17
C1283	a_868_368##3	VNB	2.56566e-17
C1284	VGND	a_2216_410##2	2.10447e-19
C1285	a_688_98##2	VNB	4.26697e-17
C1286	a_1007_366#	VNB	5.43911e-17
C1287	VGND	a_868_368##8	1.60435e-18
C1288	VPWR#4	Q#1	7.11292e-17
C1289	a_688_98##4	VNB	1.01457e-16
C1290	CLK_N#3	VNB	3.82853e-17
C1291	SCE#2	VNB	1.41698e-16
C1292	VGND#3	a_3272_94##2	3.32779e-19
C1293	a_2216_410##3	VGND#16	9.61612e-18
C1294	a_341_410##4	VNB	2.23632e-17
C1295	VGND	a_1007_366##5	2.47344e-18
C1296	VPWR	a_1592_424#	3.59807e-19
C1297	VPWR#15	SET_B#2	2.4511e-20
C1298	a_27_464##2	SCE#3	3.38734e-19
C1299	a_197_119##2	a_868_368##12	6.66527e-17
C1300	D#1	VNB	1.92533e-17
C1301	SCE#3	VNB	7.98314e-17
C1302	SCD#3	VNB	2.46293e-17
C1303	VPWR#11	a_1007_366##4	1.52027e-19
C1304	VGND	a_1643_257##2	2.86079e-17
C1305	a_3272_94##4	VNB	4.49041e-17
C1306	a_3272_94##6	VNB	3.60777e-17
C1307	VGND	a_1154_464##3	3.81724e-18
C1308	VGND#12	a_341_410##4	3.01807e-18
C1309	SET_B#7	VPWR#12	3.80237e-18
C1310	a_2216_410##4	VNB	4.26476e-17
C1311	a_2216_410##12	VNB	3.25831e-17
C1312	a_1643_257##9	SET_B#5	6.5073e-17
C1313	a_2216_410##14	VNB	3.65967e-17
C1314	SET_B#3	a_1007_366##5	3.94832e-19
C1315	RESET_B#1	VNB	2.92958e-17
C1316	a_1997_82##3	VNB	3.58533e-17
C1317	a_1643_257##4	VNB	3.23034e-17
C1318	SET_B#4	VNB	4.14806e-17
C1319	VGND#2	VGND#1	9.1825e-19
C1320	a_2216_410##17	a_2216_410##2	7.31577e-18
C1321	a_2216_410#	VNB	2.10781e-17
C1322	a_688_98##7	VNB	5.93372e-17
C1323	a_1997_82##3	RESET_B#1	4.71457e-18
C1324	a_1997_82##6	a_868_368##5	4.6567e-17
C1325	a_868_368##5	VNB	3.1743e-17
C1326	a_1007_366##4	VNB	2.99751e-17
C1327	SET_B#3	VNB	3.69389e-17
C1328	VGND#20	D#1	4.36278e-18
C1329	a_1643_257##3	VNB	3.18343e-17
C1330	a_1154_464##4	VNB	4.12898e-17
C1331	a_688_98#	VNB	6.65792e-17
C1332	a_868_368#	VNB	3.90844e-17
C1333	a_1007_366##3	VNB	2.24706e-17
C1334	a_688_98##8	VNB	3.66394e-17
C1335	VPWR#3	a_2216_410##5	1.4464e-18
C1336	CLK_N#1	VNB	3.23897e-17
C1337	a_1007_366##14	a_1154_464##3	5.71629e-20
C1338	a_1997_82##7	SET_B#6	1.7139e-20
C1339	VPWR#13	SET_B#2	3.28735e-20
C1340	SCE#1	VNB	7.49129e-17
C1341	VGND#3	a_2216_410##13	5.97923e-18
C1342	a_341_410##3	VNB	4.91386e-17
C1343	a_2452_74##2	a_2216_410##22	2.14081e-17
C1344	D#3	VNB	3.3553e-17
C1345	SCE#5	VNB	2.7486e-17
C1346	VPWR#9	a_1643_257##5	3.67968e-19
C1347	SCD#1	VNB	3.2351e-17
C1348	VPWR#14	a_688_98##7	3.68698e-19
C1349	a_2216_410##22	a_1643_257##8	6.05309e-17
C1350	VPWR#3	VNB	2.68407e-16
C1351	VGND#3	VNB	2.7594e-16
C1352	VGND#3	a_2216_410##9	1.63335e-18
C1353	SET_B#1	a_1007_366##6	2.44248e-17
C1354	a_688_98##6	a_1643_257#	1.71749e-17
C1355	SET_B#7	VNB	6.15509e-18
C1356	VPWR#12	VNB	2.52079e-17
C1357	VGND#7	VNB	3.83849e-17
C1358	a_197_119##5	a_341_410##4	3.64269e-18
C1359	a_868_368##11	VNB	1.06772e-17
C1360	VPWR#21	VNB	3.44366e-16
C1361	VPWR#3	a_3272_94##8	1.2253e-18
C1362	VGND#11	VNB	3.18412e-16
C1363	a_3272_94##3	VNB	3.67355e-17
C1364	a_2216_410##10	VNB	5.91134e-17
C1365	RESET_B#2	VNB	3.42646e-17
C1366	a_27_464#	a_197_119##6	1.00683e-16
C1367	a_1997_82##2	VNB	4.66933e-17
C1368	a_1643_257##5	VNB	2.65011e-17
C1369	SET_B#5	VNB	3.36584e-17
C1370	VPWR#21	a_868_368##9	2.09711e-17
C1371	a_2216_410##2	VNB	7.16506e-17
C1372	a_868_368##8	VNB	3.87457e-17
C1373	a_1473_73##2	a_1154_464##3	1.10985e-18
C1374	VGND#5	a_2216_410##13	6.03059e-19
C1375	a_1007_366##5	VNB	5.25092e-17
C1376	VPWR#3	a_3272_94##3	3.87911e-18
C1377	SET_B#2	VNB	4.52346e-17
C1378	a_3272_94##8	a_2216_410##11	8.36748e-18
C1379	a_1643_257##2	VNB	3.52855e-17
C1380	a_1643_257##9	a_2452_74##2	4.10176e-17
C1381	a_1154_464##3	VNB	6.35369e-17
C1382	VGND#3	VGND#6	2.71523e-18
C1383	a_868_368##4	VNB	5.7739e-17
C1384	VPWR#22	a_341_410##2	1.11031e-18
C1385	a_868_368##2	VNB	3.94594e-17
C1386	a_1007_366##2	VNB	6.6891e-17
C1387	SCD	SCE	1.05718e-17
C1388	a_688_98##5	VNB	2.3262e-17
C1389	CLK_N#2	VNB	2.57394e-17
C1390	a_341_410#	VNB	4.56122e-17
C1391	D#2	a_341_410##4	5.36504e-18
C1392	D#2	VNB	5.17236e-17
C1393	VGND#3	a_2216_410##15	5.89666e-18
C1394	SCE#4	VNB	5.99793e-17
C1395	SCD#2	VNB	1.12586e-16
C1396	a_1997_82##5	SET_B#5	2.90787e-17
C1397	a_197_119##4	SCD#2	4.8182e-20
C1398	a_2216_410##17	SET_B#4	3.72747e-17
C1399	a_688_98##3	a_1154_464##2	8.50483e-19
C1400	a_197_119##2	a_1154_464##3	1.26486e-16
C1401	VPWR#21	VPWR#20	2.20201e-17
C1402	VGND#3	a_3272_94##3	6.54952e-18
C1403	SET_B#7	VPWR#13	1.17645e-18
C1404	a_868_368##12	a_1154_464##5	1.07999e-18
C1405	VPWR#3	a_2216_410##10	7.89993e-18
C1406	VGND#19	a_197_119##2	1.88873e-17
C1407	a_27_464#	a_206_464#	8.12731e-18
C1408	a_1997_82##6	a_1007_366##4	7.20298e-18
C1409	VGND#3	VGND#5	1.34592e-16
C1410	SCE	VNB	1.71734e-18
C1411	SCD	VNB	1.84959e-17
C1412	a_1643_257##2	SET_B#3	1.11518e-18
C1413	Q	VNB	8.88669e-18
C1414	Q_N	VNB	1.01921e-18
C1415	VPWR	VNB	2.4836e-16
C1416	VGND	VNB	2.28976e-16
C1417	VPWR#15	a_1154_464##4	5.41649e-18
C1418	VGND#20	SCE#3	1.38708e-18
C1419	SCE#3	D#2	1.60735e-18
C1420	VPWR#14	a_868_368##5	5.83387e-18
C1421	VPWR#24	D#3	4.39885e-18
C1422	a_868_368##6	SET_B#1	3.09829e-19
C1423	a_868_368##6	a_1643_257##9	5.61671e-19
C1424	SET_B	a_1997_82##7	4.38953e-18
C1425	a_27_464##2	VPWR#24	1.83687e-17
C1426	SET_B	VPWR#9	6.78116e-19
C1427	VPWR#24	SCE#5	9.50326e-19
C1428	SET_B	a_868_368##8	2.4495e-17
C1429	a_868_368##6	VPWR#16	4.98572e-18
C1430	a_868_368##6	a_1007_366##8	7.65566e-18
C1431	a_1997_82##7	a_868_368##6	3.62873e-17
C1432	SET_B	a_2216_410##17	6.20016e-18
C1433	a_1997_82##5	a_868_368##6	3.50284e-18
C1434	SET_B	VNB	1.23288e-17
C1435	a_868_368##6	a_688_98##7	3.62365e-17
C1436	VPWR#24	SCD#1	1.77117e-18
C1437	a_868_368##6	SET_B#2	1.5794e-17
C1438	SET_B	VGND#6	2.36243e-18
C1439	SET_B	a_2216_410##2	7.51767e-18
C1440	a_868_368##6	SET_B#5	2.17488e-18
C1441	a_868_368##6	VGND#8	2.94687e-18
C1442	VPWR#12	a_868_368##6	8.02714e-19
C1443	a_868_368##6	VGND#17	7.2013e-18
C1444	SET_B	VPWR#8	1.03684e-18
C1445	a_1997_82##5	SET_B	9.16113e-17
C1446	a_868_368##6	a_1007_366##6	3.49022e-18
C1447	VPWR	a_868_368##6	3.70458e-18
C1448	SET_B	SET_B#5	9.22371e-18
C1449	SET_B	a_2452_74##2	1.37247e-18
C1450	VPWR#24	D#2	1.63558e-20
C1451	a_868_368##6	a_868_368##8	1.23368e-18
C1452	SET_B	VPWR#10	3.33446e-18
C1453	VGND	SET_B	2.4824e-17
C1454	SET_B	a_1643_257##7	6.32066e-19
C1455	SET_B	a_1643_257##8	6.70908e-19
C1456	a_868_368##6	a_1007_366##14	5.62393e-18
C1457	SET_B	a_2216_410##3	3.25345e-19
C1458	a_868_368##6	a_1007_366##9	2.47307e-18
C1459	SET_B	a_1643_257##5	2.55075e-18
C1460	a_27_464#	VPWR#24	4.3557e-17
C1461	SET_B	a_1997_82##6	7.69152e-18
C1462	VPWR#24	SCE#4	1.76266e-20
C1463	a_868_368##6	a_1643_257#	7.62036e-19
C1464	VGND	a_868_368##6	5.81706e-17
C1465	VPWR#21	VPWR#24	1.01981e-16
C1466	a_868_368##6	a_2216_410##3	2.09609e-19
C1467	SET_B	a_1643_257##9	1.9224e-17
C1468	a_1007_366##5	a_868_368##6	6.29128e-17
C1469	SET_B	a_1997_82##2	2.93308e-17
C1470	VPWR#24	VNB	6.07505e-17
C1471	VPWR#24	SCD#2	2.16634e-19
C1472	SET_B	RESET_B	1.63939e-18
C1473	SET_B	a_688_98##7	8.18498e-19
C1474	SET_B#7	a_868_368##6	1.83823e-16
C1475	a_868_368##6	a_1592_424#	1.64459e-19
C1476	a_1997_82##6	a_868_368##6	2.21675e-17
C1477	a_868_368##6	VNB	4.79471e-17
C1478	VPWR	SET_B	2.8718e-17
C1479	VPWR#24	VPWR#22	2.38833e-19
C1480	a_868_368##6	a_688_98##6	5.88739e-17
C1481	SET_B	VPWR#11	3.19826e-18
C1482	a_868_368##6	a_1643_257##2	9.8289e-17
C1483	a_868_368##6	a_2216_410##2	4.66752e-20
C1484	a_868_368##6	VGND#7	1.36769e-18
C1485	a_868_368##6	a_1473_73#	8.71258e-18
*
*
.ENDS sky130_fd_sc_hs__sdfbbn_2
*
