* Extracted by Quantus, converted by sky130cad/quantus.py
*
*
*
*                       LINUX           Wed Nov 18 09:04:16 2026
*
*
*
*  PROGRAM  advgen
*
*  Name           : advgen - Quantus - (64-bit)
*  Version        : 25.1.0-p047
*  Build Date     : Thu Dec 11 23:20:30 PST 2025
*
*  HSPICE LIBRARY
*
*  OPERATING_TEMPERATURE 150
*  QRC_TECH_DIR <path>/tech
*
*
*

*
.SUBCKT sky130_fd_sc_hs__o41ai_1 VNB VPB VGND VPWR Y B1 A4 A3 A2 A1
*
*
*  caps2d version: 10
*
*
*       TRANSISTOR CARDS
*
*
XM3 Y#1 B1#4 a_157_74##3 VNB sky130_fd_pr__nfet_01v8_lvt l=0.15 w=0.74 ad=0.2109 as=0.2923 pd=2.05 ps=2.27
XM1 a_157_74##3 A4#1 VGND#6 VNB sky130_fd_pr__nfet_01v8_lvt l=0.15 w=0.74 ad=0.2923 as=0.3219 pd=2.27 ps=2.35
XM8 VGND#6 A3#1 a_157_74##4 VNB sky130_fd_pr__nfet_01v8_lvt l=0.15 w=0.74 ad=0.3219 as=0.2072 pd=2.35 ps=2.04
XM5 a_157_74##4 A2#3 VGND#4 VNB sky130_fd_pr__nfet_01v8_lvt l=0.15 w=0.74 ad=0.2072 as=0.3108 pd=2.04 ps=2.32
XM9 VGND#4 A1#3 a_157_74# VNB sky130_fd_pr__nfet_01v8_lvt l=0.15 w=0.74 ad=0.3108 as=0.2109 pd=2.32 ps=2.05
XM2 VPWR#3 B1#1 Y#3 VPB sky130_fd_pr__pfet_01v8 l=0.15 w=1.12 ad=0.5768 as=0.392 pd=3.27 ps=2.94
XM6 Y#3 A4#3 a_260_368# VPB sky130_fd_pr__pfet_01v8 l=0.15 w=1.12 ad=0.392 as=0.3808 pd=2.94 ps=2.92
XM7 a_260_368# A3#3 a_358_368# VPB sky130_fd_pr__pfet_01v8 l=0.15 w=1.12 ad=0.3808 as=0.4704 pd=2.92 ps=3.08
XM0 a_358_368# A2#1 a_472_368# VPB sky130_fd_pr__pfet_01v8 l=0.15 w=1.12 ad=0.4704 as=0.4704 pd=3.08 ps=3.08
XM4 a_472_368# A1#1 VPWR#1 VPB sky130_fd_pr__pfet_01v8 l=0.15 w=1.12 ad=0.4704 as=0.3304 pd=3.08 ps=2.83
*
*
*       RESISTOR AND CAP/DIODE CARDS
*
Rg1	B1#1	B1#2	507.075531
Rg2	B1#2	B1#3	71.940140
Rg3	B1#2	B1#4	322.953644
Rg4	A4#1	A4#2	394.958344
Rg5	A4#2	A4#3	442.817719
Rg6	A3#1	A3#2	382.539734
Rg7	A3#2	A3#3	434.639221
Rg8	A2#1	A2#2	434.639221
Rg9	A2#2	A2#3	382.539734
Rg10	A1#1	A1#2	430.056854
Rg11	A1#2	A1#3	377.957367
Rf1	B1	B1#3	163.775864
Rf2	Y#2	Y	5.145366
Rf3	Y#2	Y#3	105.621902
Rf4	Y#1	Y#2	7.500000
Rf5	A4	A4#2	166.137894
Rf6	A3#2	A3	165.267365
Rf7	A2#2	A2	190.295792
Rf8	a_157_74#	a_157_74##2	87.519394
Rf9	a_157_74##2	a_157_74##3	91.514343
Rf10	a_157_74##2	a_157_74##4	18.149860
Rf11	A1#2	A1#5	162.448425
Rf12	A1#6	A1	2.215620
Rf13	A1#5	A1#6	4.635897
Rf14	VPWR#1	VPWR#2	148.808945
Rf15	VPWR#2	VPWR#3	113.566574
Rf17	VGND#2	VGND#3	63.894653
Rf18	VGND#2	VGND#4	35.098007
Rf20	VGND#3	VGND#6	38.595905
Re1	VPWR#2	VPWR	1.403190
Re2	VGND	VGND#3	1.403242
*
*       CAPACITOR CARDS
*
*
C1	B1#2	A4#2	3.21066e-17
C2	a_157_74#	A1#5	4.31987e-17
C3	a_157_74##2	VGND#4	2.03173e-17
C4	a_157_74##2	a_157_74##4	9.59055e-20
C5	a_157_74##2	VGND#6	2.28892e-17
C6	A1#6	VPWR#1	2.72195e-17
C7	a_157_74#	VGND#4	5.77106e-17
C8	a_157_74##4	a_157_74#	3.05636e-18
C9	a_157_74##4	VGND#4	4.52314e-17
C10	VGND#6	VGND#4	2.27042e-18
C11	VGND#6	a_157_74##4	4.20027e-17
C12	a_157_74##3	a_157_74##4	2.91109e-18
C13	a_157_74##3	VGND#6	5.37554e-17
C14	a_157_74##2	A2#3	1.8799e-17
C15	a_157_74##2	A3#1	2.23546e-17
C16	a_157_74#	A1#3	5.13427e-17
C17	A1#6	A1#1	8.75844e-18
C18	A1#3	VGND#4	2.34678e-17
C19	a_157_74#	A2#3	9.74128e-19
C20	a_157_74##3	Y#3	3.88583e-18
C21	a_157_74##4	A1#3	9.98831e-19
C22	A1#6	A2#1	7.33561e-19
C23	A2#3	VGND#4	2.44961e-17
C24	VGND#6	A1#3	3.93821e-19
C25	a_157_74##4	A2#3	3.83781e-17
C26	VGND#4	A3#1	7.61745e-19
C27	VGND#6	A2#3	7.27413e-19
C28	a_157_74##4	A3#1	3.34795e-17
C29	VGND#4	A4#1	1.91986e-19
C30	A3#1	VGND#6	2.14153e-17
C31	a_157_74##4	A4#1	6.3924e-19
C32	a_157_74##3	A3#1	6.22548e-19
C33	A4#1	VGND#6	2.46971e-17
C34	Y#3	B1#2	1.10035e-18
C35	a_157_74##3	A4#1	6.24704e-17
C36	VGND#6	B1#4	8.66681e-19
C37	a_157_74##3	B1#4	1.08595e-17
C38	VPWR#3	Y#3	9.44976e-17
C39	B1#4	Y#1	7.57841e-18
C40	VPWR#3	B1#2	3.31007e-18
C41	A2#3	A1#3	2.17069e-17
C42	A1#1	VPWR#1	4.61636e-17
C43	A4	B1#2	1.06185e-18
C44	A1#6	A1#2	8.56488e-18
C45	VPWR#1	A2#1	9.70711e-18
C46	A1#5	A1#2	1.48036e-17
C47	A3#1	A2#3	3.90759e-17
C48	A2#2	A1#6	1.54017e-17
C49	VPWR#1	A3#3	7.77026e-19
C50	A2#2	A1#5	1.59978e-17
C51	Y#3	A1#1	5.7251e-19
C52	VPWR#1	A4#3	4.49e-19
C53	a_157_74##2	A2#2	5.25517e-17
C54	A4#1	A3#1	2.06229e-17
C55	Y#3	A2#1	8.38072e-19
C56	VPWR#3	A2#1	3.41918e-19
C57	a_157_74##2	A3#2	2.26843e-18
C58	Y#3	A3#3	6.08889e-18
C59	B1#4	A4#1	2.26986e-17
C60	a_157_74#	A1#2	5.10827e-18
C61	VPWR#3	A3#3	7.49676e-19
C62	Y#3	A4#3	6.58417e-17
C63	VPWR#2	VPWR#1	3.60181e-17
C64	VPWR#3	A4#3	2.89243e-18
C65	Y#3	B1#1	3.70875e-17
C66	VGND#4	A2#2	1.00988e-18
C67	VPWR#3	B1#1	4.22745e-17
C68	Y	B1#2	2.17749e-17
C69	A1#2	VPWR#1	4.45826e-18
C70	Y#3	VPWR#2	2.09622e-17
C71	VGND#6	A3#2	1.05547e-18
C72	VPWR#2	VPWR#3	3.31078e-17
C73	A2#1	A1#1	3.37569e-17
C74	a_157_74##3	A4#2	4.61348e-17
C75	A3#3	A2#1	2.95718e-17
C76	B1#3	Y#1	4.74775e-19
C77	a_157_74#	a_472_368#	2.14385e-19
C78	A4#3	A3#3	4.11485e-17
C79	A4#2	Y#3	3.34121e-18
C80	B1#1	A4#3	3.73519e-17
C81	VPWR#2	A2#1	3.28133e-18
C82	B1#2	A4#1	3.88261e-18
C83	VPWR#2	A3#3	6.14085e-18
C84	VPWR#3	B1#3	1.33303e-17
C85	VPWR#2	A4#3	7.77731e-18
C86	VGND	B1#2	1.10845e-18
C87	A2#2	A1#1	9.05704e-19
C88	VPWR#2	B1#1	1.49922e-18
C89	A2#2	A2#1	1.94034e-18
C90	A2#2	A3#3	9.44229e-19
C91	a_157_74##2	A2	1.19902e-18
C92	a_157_74##2	A3	4.85311e-17
C93	A2#2	VPWR#2	1.06358e-18
C94	B1#1	A4#2	2.36749e-18
C95	VPWR#2	A3#2	2.12408e-19
C96	A1#1	a_472_368#	3.5639e-17
C97	A2#1	a_472_368#	3.51708e-17
C98	A2#2	A1#2	3.57226e-17
C99	VPWR#2	A4#2	1.29198e-19
C100	A2	VPWR#1	2.42375e-17
C101	A2#1	a_358_368#	2.83354e-17
C102	A3#2	A2#2	3.47567e-17
C103	A3#3	a_358_368#	2.84869e-17
C104	A3#3	a_260_368#	2.48433e-17
C105	A4#2	A3#2	2.67215e-17
C106	A4#3	a_260_368#	1.91377e-18
C107	Y#3	A3	4.21368e-17
C108	A2#2	a_472_368#	1.42267e-18
C109	B1#2	VNB	2.41966e-17
C110	Y#3	A4	2.54016e-17
C111	A2	A1#1	1.11079e-17
C112	VPWR	A1#6	4.3189e-18
C113	A2	A2#1	3.5069e-17
C114	A2#2	a_358_368#	1.15161e-19
C115	A2	A3#3	9.1662e-18
C116	Y	a_157_74##3	7.21441e-17
C117	Y	Y#1	2.89264e-18
C118	B1	VPWR#3	2.51639e-17
C119	A3	A2#1	4.94303e-18
C120	A3	A3#3	3.17309e-17
C121	A3	A4#3	1.08926e-17
C122	A4#2	a_260_368#	2.25283e-19
C123	A2	VPWR#2	1.3802e-17
C124	A3	B1#1	1.46071e-19
C125	VGND	A1#5	4.44645e-18
C126	Y	VPWR#3	7.98217e-18
C127	A4	A3#3	5.02922e-19
C128	VGND	a_157_74##2	3.96177e-18
C129	Y	A1#3	1.1017e-19
C130	A4	A4#3	4.67343e-18
C131	A3	VPWR#2	1.09899e-17
C132	VPWR	VPWR#1	4.38103e-17
C133	Y	A2#3	9.09821e-20
C134	A4	B1#1	1.33326e-18
C135	Y	A3#1	2.25251e-19
C136	Y	A4#1	1.92264e-18
C137	VGND	a_157_74#	1.72735e-17
C138	Y	B1#4	3.03467e-17
C139	VPWR	Y#3	1.85941e-17
C140	A4	VPWR#2	9.68564e-19
C141	VGND	a_157_74##4	1.62608e-17
C142	VPWR	VPWR#3	5.45375e-17
C143	A3	A2#2	4.46079e-17
C144	VGND	a_157_74##3	1.4859e-17
C145	A3	A3#2	1.47795e-17
C146	A4#2	A3	2.04818e-17
C147	A4	A3#2	1.01628e-18
C148	VPWR	A1#1	3.14266e-18
C149	VGND	VPWR#3	4.32031e-18
C150	A4	A4#2	7.95425e-18
C151	VGND	A1#3	9.94178e-19
C152	VPWR	A2#1	3.16e-18
C153	A2	a_358_368#	1.00851e-17
C154	VGND	A2#3	1.74943e-19
C155	VPWR	A3#3	3.31701e-19
C156	VGND	A3#1	4.33607e-19
C157	VPWR	A4#3	2.25069e-18
C158	VGND	A4#1	3.60677e-19
C159	Y	A1#2	1.12373e-19
C160	A3	a_358_368#	9.04639e-18
C161	VPWR	B1#1	2.72279e-18
C162	VGND	B1#4	1.42526e-18
C163	Y	A2#2	9.46956e-20
C164	B1	B1#3	2.11602e-17
C165	VPWR	VPWR#2	4.62247e-17
C166	Y	A3#2	2.39042e-19
C167	A1#6	VNB	1.11008e-17
C168	A1#5	VNB	1.54201e-17
C169	Y	A4#2	2.02887e-17
C170	a_157_74##2	VNB	1.19145e-17
C171	Y	B1#3	1.01458e-17
C172	VPWR	A2#2	4.83163e-18
C173	VPWR	A3#2	1.05717e-18
C174	a_157_74#	VNB	4.73558e-17
C175	VGND#4	VNB	3.15884e-18
C176	a_157_74##4	VNB	1.96561e-18
C177	A3	A2	6.4317e-17
C178	VGND#6	VNB	4.2634e-18
C179	a_157_74##3	VNB	6.86236e-18
C180	VPWR	B1#3	6.15463e-19
C181	VPWR#1	VNB	8.58995e-17
C182	VGND	A2#2	4.12969e-18
C183	Y#3	VNB	7.667e-18
C184	VPWR#3	VNB	8.85431e-17
C185	VGND	A4#2	3.17094e-18
C186	A4	A3	2.67534e-17
C187	A1#3	VNB	3.23525e-17
C188	A2#3	VNB	2.89901e-17
C189	VGND	B1#3	2.21037e-18
C190	A3#1	VNB	2.90851e-17
C191	A4#1	VNB	2.87909e-17
C192	B1#4	VNB	3.27124e-17
C193	A1#1	VNB	3.21838e-17
C194	A2#1	VNB	2.40507e-17
C195	A3#3	VNB	3.36486e-17
C196	A4#3	VNB	3.35149e-17
C197	B1#1	VNB	4.09932e-17
C198	VPWR	A2	1.33136e-17
C199	Y	A4	8.23072e-18
C200	VPWR#2	VNB	2.08305e-16
C201	VPWR	A3	1.53306e-17
C202	A1#2	VNB	5.13457e-17
C203	Y	B1	5.76965e-17
C204	A2#2	VNB	3.76247e-17
C205	VGND	A2	8.33504e-19
C206	VPWR	A4	5.49291e-18
C207	A3#2	VNB	2.65604e-17
C208	A4#2	VNB	2.3798e-17
C209	VGND	A3	4.2155e-18
C210	VPWR	B1	2.18566e-18
C211	B1#3	VNB	5.80459e-17
C212	VPWR	Y	1.45193e-18
C213	VGND	B1	4.20105e-18
C214	VGND	Y	2.86992e-17
C215	A3	VNB	2.33528e-18
C216	A4	VNB	1.92786e-18
C217	B1	VNB	2.17199e-17
C218	Y	VNB	4.975e-17
C219	VPWR	VNB	7.82774e-17
C220	VGND	VNB	6.62172e-17
C221	VGND	VGND#3	7.28554e-17
C222	VGND#3	A3#1	5.28599e-18
C223	VGND#2	VNB	4.91307e-17
C224	VGND#2	A4#1	9.50915e-20
C225	VGND	VGND#2	5.39994e-17
C226	VGND#3	a_157_74##4	1.08731e-17
C227	VGND#2	A3#1	6.22155e-19
C228	VGND#2	A2#3	4.86454e-18
C229	VGND#3	a_157_74##2	3.24911e-19
C230	VGND#2	A1#3	5.26185e-18
C231	VGND#3	B1#2	3.14828e-20
C232	VGND#3	A4#1	4.87756e-18
C233	VGND#3	B1	8.64536e-19
C234	VGND#3	VNB	2.29641e-16
C235	VGND#3	B1#4	4.34467e-18
C236	VGND#3	Y	3.92325e-17
C237	VGND#3	A1#3	2.19859e-19
C238	VGND#2	a_157_74##4	6.06187e-18
C239	VGND#3	a_157_74##3	1.70676e-17
C240	VGND#2	a_157_74#	2.10084e-17
C241	VGND#3	A4#2	6.2655e-20
C242	VGND#2	A1#2	1.21963e-19
C243	VGND#3	VGND#2	5.56511e-17
C244	VGND#3	A2#3	5.87633e-19
C245	VGND#2	a_157_74##2	2.25448e-19
C246	VGND#2	A1#5	6.63763e-19
C247	VGND#3	B1#3	6.64481e-19
*
*
.ENDS sky130_fd_sc_hs__o41ai_1
*
