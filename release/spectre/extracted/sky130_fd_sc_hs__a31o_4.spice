* Extracted by Quantus, converted by sky130cad/quantus.py
*
*
*
*                       LINUX           Wed Nov 18 08:12:53 2026
*
*
*
*  PROGRAM  advgen
*
*  Name           : advgen - Quantus - (64-bit)
*  Version        : 25.1.0-p047
*  Build Date     : Thu Dec 11 23:20:30 PST 2025
*
*  HSPICE LIBRARY
*
*  OPERATING_TEMPERATURE 150
*  QRC_TECH_DIR <path>/tech
*
*
*

*
.SUBCKT sky130_fd_sc_hs__a31o_4 VPB VNB VGND VPWR X A1 A2 A3 B1
*
*
*  caps2d version: 10
*
*
*       TRANSISTOR CARDS
*
*
XM1 VGND#7 a_83_274##12 X#6 VNB sky130_fd_pr__nfet_01v8_lvt l=0.15 w=0.74 ad=0.2294 as=0.2405 pd=2.1 ps=2.13
XM11 VGND#11 a_83_274##10 X#6 VNB sky130_fd_pr__nfet_01v8_lvt l=0.15 w=0.74 ad=0.2072 as=0.2405 pd=2.04 ps=2.13
XM14 X#7 a_83_274##8 VGND#11 VNB sky130_fd_pr__nfet_01v8_lvt l=0.15 w=0.74 ad=0.2257 as=0.2072 pd=2.09 ps=2.04
XM18 X#7 a_83_274##7 VGND#10 VNB sky130_fd_pr__nfet_01v8_lvt l=0.15 w=0.74 ad=0.2257 as=0.2109 pd=2.09 ps=2.05
XM5 a_83_274##19 B1#4 VGND#9 VNB sky130_fd_pr__nfet_01v8_lvt l=0.15 w=0.64 ad=0.1824 as=0.224 pd=1.85 ps=1.98
XM21 VGND#9 B1#5 a_83_274##17 VNB sky130_fd_pr__nfet_01v8_lvt l=0.15 w=0.64 ad=0.224 as=0.1792 pd=1.98 ps=1.84
XM7 a_83_274##17 A1#6 a_775_74##2 VNB sky130_fd_pr__nfet_01v8_lvt l=0.15 w=0.64 ad=0.1792 as=0.224 pd=1.84 ps=1.98
XM22 a_775_74##2 A1#4 a_83_274##13 VNB sky130_fd_pr__nfet_01v8_lvt l=0.15 w=0.64 ad=0.224 as=0.2272 pd=1.98 ps=1.99
XM19 a_775_74# A2#4 a_1000_74##3 VNB sky130_fd_pr__nfet_01v8_lvt l=0.15 w=0.64 ad=0.1792 as=0.1824 pd=1.84 ps=1.85
XM13 a_1000_74##4 A2#1 a_775_74# VNB sky130_fd_pr__nfet_01v8_lvt l=0.15 w=0.64 ad=0.1792 as=0.1792 pd=1.84 ps=1.84
XM17 a_1000_74##4 A3#7 VGND#8 VNB sky130_fd_pr__nfet_01v8_lvt l=0.15 w=0.64 ad=0.1792 as=0.1792 pd=1.84 ps=1.84
XM23 VGND#8 A3#6 a_1000_74# VNB sky130_fd_pr__nfet_01v8_lvt l=0.15 w=0.64 ad=0.1792 as=0.1824 pd=1.84 ps=1.85
XM0 VPWR#8 a_83_274##6 X#3 VPB sky130_fd_pr__pfet_01v8 l=0.15 w=1.12 ad=0.3304 as=0.336 pd=2.83 ps=2.84
XM3 X#3 a_83_274##11 VPWR#13 VPB sky130_fd_pr__pfet_01v8 l=0.15 w=1.12 ad=0.336 as=0.448 pd=2.84 ps=3.04
XM12 VPWR#13 a_83_274##9 X#1 VPB sky130_fd_pr__pfet_01v8 l=0.15 w=1.12 ad=0.448 as=0.336 pd=3.04 ps=2.84
XM15 X#1 a_83_274# VPWR#12 VPB sky130_fd_pr__pfet_01v8 l=0.15 w=1.12 ad=0.336 as=0.3864 pd=2.84 ps=2.93
XM6 a_529_392##6 B1#6 a_83_274##18 VPB sky130_fd_pr__pfet_01v8 l=0.15 w=1 ad=0.295 as=0.37 pd=2.59 ps=2.74
XM8 a_83_274##18 B1#1 a_529_392##4 VPB sky130_fd_pr__pfet_01v8 l=0.15 w=1 ad=0.37 as=0.45 pd=2.74 ps=2.9
XM10 a_529_392##4 A1#5 VPWR#11 VPB sky130_fd_pr__pfet_01v8 l=0.15 w=1 ad=0.45 as=0.4 pd=2.9 ps=2.8
XM2 VPWR#11 A1#1 a_529_392##8 VPB sky130_fd_pr__pfet_01v8 l=0.15 w=1 ad=0.4 as=0.3 pd=2.8 ps=2.6
XM9 a_529_392##8 A2#6 VPWR#10 VPB sky130_fd_pr__pfet_01v8 l=0.15 w=1 ad=0.3 as=0.41 pd=2.6 ps=2.82
XM16 VPWR#10 A2#5 a_529_392##7 VPB sky130_fd_pr__pfet_01v8 l=0.15 w=1 ad=0.41 as=0.35 pd=2.82 ps=2.7
XM20 a_529_392##7 A3#5 VPWR#9 VPB sky130_fd_pr__pfet_01v8 l=0.15 w=1 ad=0.35 as=0.35 pd=2.7 ps=2.7
XM4 VPWR#9 A3#1 a_529_392# VPB sky130_fd_pr__pfet_01v8 l=0.15 w=1 ad=0.35 as=0.295 pd=2.7 ps=2.59
*
*
*       RESISTOR AND CAP/DIODE CARDS
*
Rg1	a_83_274#	a_83_274##2	521.775696
Rg2	a_83_274##2	a_83_274##3	35.830936
Rg3	a_83_274##3	a_83_274##4	119.985504
Rg4	a_83_274##4	a_83_274##5	65.519844
Rg5	a_83_274##5	a_83_274##6	561.358704
Rg6	a_83_274##2	a_83_274##7	331.656921
Rg7	a_83_274##3	a_83_274##8	323.235077
Rg8	a_83_274##3	a_83_274##9	482.397675
Rg9	a_83_274##4	a_83_274##10	379.494690
Rg10	a_83_274##4	a_83_274##11	468.443298
Rg11	a_83_274##5	a_83_274##12	377.236847
Rg12	B1#1	B1#2	438.955444
Rg13	B1#2	B1#3	85.058899
Rg14	B1#3	B1#4	464.094940
Rg15	B1#2	B1#5	465.042297
Rg16	B1#3	B1#6	384.206177
Rg17	A1#1	A1#2	452.553894
Rg18	A1#2	A1#3	83.442154
Rg19	A1#3	A1#4	240.818573
Rg20	A1#2	A1#5	419.935150
Rg21	A1#3	A1#6	373.913513
Rg22	A2#1	A2#2	545.807434
Rg23	A2#2	A2#3	60.144505
Rg24	A2#3	A2#4	550.773743
Rg25	A2#2	A2#5	403.578156
Rg26	A2#3	A2#6	478.389740
Rg27	A3#1	A3#2	427.036713
Rg28	A3#2	A3#3	30.596949
Rg29	A3#3	A3#4	32.582375
Rg30	A3#4	A3#5	425.091339
Rg31	A3#2	A3#6	492.093811
Rg32	A3#4	A3#7	485.354462
Rf1	X#1	X#2	86.510811
Rf2	X#2	X	9.038504
Rf3	X	X#4	14.369054
Rf4	X#4	X	0.196836
Rf5	X#2	X	5.495449
Rf6	X	X#5	37.213615
Rf7	X#5	X#6	16.455505
Rf8	X#5	X#7	80.444069
Rf9	X#3	X#4	5.000000
Rf10	B1	B1#3	88.777199
Rf11	A1	A1#7	7.086109
Rf12	A1#7	A1	11.810182
Rf13	a_83_274##13	a_83_274##14	111.521080
Rf14	a_83_274##14	a_83_274##15	83.123810
Rf15	a_83_274##15	a_83_274##3	88.732300
Rf16	a_83_274##14	a_83_274##17	31.009617
Rf17	a_83_274##14	a_83_274##18	80.677399
Rf18	a_83_274##15	a_83_274##19	30.038912
Rf19	a_775_74#	a_775_74##2	135.910568
Rf20	A2#2	A2	80.510071
Rf21	a_1000_74#	a_1000_74##2	93.541145
Rf22	a_1000_74##2	a_1000_74##3	97.751144
Rf23	a_1000_74##2	a_1000_74##4	39.263618
Rf24	A3	A3#3	81.297417
Rf25	a_529_392#	a_529_392##2	87.971939
Rf26	a_529_392##2	a_529_392##3	73.731934
Rf27	a_529_392##3	a_529_392##5	83.412445
Rf28	a_529_392##5	a_529_392##6	106.755341
Rf29	a_529_392##2	a_529_392##7	18.602406
Rf30	a_529_392##3	a_529_392##8	18.602406
Rf31	a_529_392##4	a_529_392##5	5.000000
Rf32	VGND#1	VGND#2	38.326977
Rf33	VGND#2	VGND#3	224.605743
Rf34	VGND#3	VGND#4	20.064354
Rf35	VGND#4	VGND#5	72.270927
Rf36	VGND#5	VGND#6	64.600624
Rf37	VGND#6	VGND#7	99.118919
Rf38	VGND#2	VGND#8	30.353714
Rf39	VGND#4	VGND#9	30.353714
Rf40	VGND#5	VGND#10	31.141060
Rf41	VGND#6	VGND#11	33.916985
Rf42	VPWR#1	VPWR#2	39.422733
Rf43	VPWR#2	VPWR#3	73.731934
Rf44	VPWR#3	VPWR#4	73.001427
Rf45	VPWR#4	VPWR#5	76.678490
Rf46	VPWR#5	VPWR#6	82.522530
Rf47	VPWR#6	VPWR#7	73.001427
Rf48	VPWR#7	VPWR#8	120.594025
Rf49	VPWR#2	VPWR#9	32.125244
Rf50	VPWR#3	VPWR#10	32.125244
Rf51	VPWR#4	VPWR#11	32.125244
Rf52	VPWR#6	VPWR#12	38.286041
Rf53	VPWR#7	VPWR#13	34.939823
Rf55	A1#2	A1#7	80.116402
Re1	VPWR#1	VPWR	11.068454
Re2	VPWR	VPWR#5	0.790604
Re3	VGND#1	VGND	11.068454
Re4	VGND	VGND#3	0.790604
*
*       CAPACITOR CARDS
*
*
C1	a_1000_74##2	A1#4	6.27862e-21
C2	VGND#4	B1#4	1.24819e-18
C3	VGND#6	a_83_274##7	4.77481e-19
C4	VGND#4	a_83_274##15	2.42607e-19
C5	VGND#5	a_83_274##7	2.76893e-18
C6	a_529_392#	VPWR#9	7.00365e-17
C7	VPWR#5	B1#2	8.23054e-20
C8	a_1000_74##2	a_529_392##2	9.51734e-18
C9	a_83_274##14	A2#4	3.89412e-20
C10	VGND#6	a_83_274##8	3.93525e-18
C11	a_529_392##7	a_529_392#	2.03253e-18
C12	a_1000_74#	A3#6	2.56418e-17
C13	VGND#11	a_83_274##4	4.3493e-19
C14	a_83_274##14	A1#4	4.7141e-19
C15	a_529_392##7	VPWR#9	6.22435e-17
C16	VGND#8	A3#6	3.42676e-17
C17	VGND#6	a_83_274##10	3.94436e-18
C18	a_1000_74#	A3#7	8.35627e-19
C19	VGND#3	A1#3	1.96416e-19
C20	VGND#6	X#5	1.48565e-17
C21	a_1000_74##4	A3#6	7.39035e-19
C22	VGND#3	B1#2	4.83797e-20
C23	VPWR#10	VPWR#9	1.71857e-18
C24	a_83_274##14	A1#6	1.27825e-17
C25	VGND#8	A3#7	3.28132e-17
C26	a_83_274##5	X#6	5.0457e-19
C27	a_1000_74#	A2#1	1.89737e-19
C28	a_83_274##15	B1#5	4.76379e-19
C29	VGND#6	a_83_274##12	5.50038e-19
C30	VPWR#10	a_529_392##7	5.91686e-17
C31	A3#7	a_1000_74##4	1.32271e-17
C32	a_529_392#	A3#4	9.76684e-19
C33	a_83_274##4	X#6	4.99647e-19
C34	VGND#8	A2#1	2.51377e-18
C35	a_83_274##14	B1#5	1.64356e-17
C36	a_775_74#	A3#7	1.96252e-18
C37	a_529_392##8	a_529_392##7	2.04588e-18
C38	a_83_274##15	B1#4	9.39823e-18
C39	A2#1	a_1000_74##4	1.66321e-17
C40	a_1000_74##3	A3#7	1.89737e-19
C41	VGND#8	A2#4	3.07356e-19
C42	a_529_392##8	VPWR#10	6.22197e-17
C43	a_83_274##14	B1#4	1.02368e-18
C44	a_775_74#	A2#1	3.92744e-17
C45	VPWR#2	A3#1	2.22521e-18
C46	a_1000_74##4	A2#4	6.27856e-19
C47	a_83_274##15	a_83_274##7	2.64431e-19
C48	a_1000_74##3	A2#1	4.29282e-19
C49	VPWR#11	VPWR#10	1.69608e-18
C50	VGND#8	A1#4	8.62733e-20
C51	VPWR#9	A3#4	1.51598e-18
C52	a_775_74#	A2#4	4.99472e-17
C53	a_83_274##14	a_83_274##7	8.67883e-20
C54	A2#2	A3#4	3.58509e-17
C55	a_1000_74##4	A1#4	4.94333e-20
C56	VPWR#11	a_529_392##8	6.22435e-17
C57	VPWR#2	A3#5	9.73696e-19
C58	a_83_274##15	a_83_274##8	4.07052e-20
C59	X#5	B1#4	2.80049e-20
C60	a_1000_74##3	A2#4	3.72665e-17
C61	A2#3	A2#2	3.67742e-18
C62	a_775_74#	A1#4	3.93428e-19
C63	a_529_392##4	a_529_392##8	2.07064e-18
C64	a_83_274##13	A2#4	3.11435e-18
C65	VPWR#3	A2#5	2.85637e-18
C66	a_1000_74##3	A1#4	7.0956e-19
C67	X#5	a_83_274##7	3.076e-19
C68	a_83_274##15	B1#2	8.71937e-20
C69	a_83_274##15	a_83_274##10	2.41992e-20
C70	a_775_74##2	A2#4	3.93428e-19
C71	a_83_274##14	A2#3	6.80574e-20
C72	a_529_392##4	VPWR#11	7.18396e-17
C73	A1#4	a_83_274##13	2.52592e-17
C74	a_83_274##17	A2#4	2.74999e-20
C75	a_529_392##2	A3#1	1.64517e-19
C76	VPWR#3	A2#6	2.56999e-18
C77	X#5	a_83_274##8	7.01394e-19
C78	a_775_74##2	A1#4	5.19292e-17
C79	a_83_274##15	a_83_274##12	3.11006e-20
C80	a_83_274##14	A1#3	9.83352e-18
C81	VGND#9	A2#4	7.49153e-20
C82	A1#2	A2#3	2.30761e-17
C83	a_83_274##13	A1#6	4.20524e-19
C84	VGND#2	a_1000_74#	3.23873e-19
C85	VGND#7	VPWR#8	1.12128e-17
C86	a_83_274##17	A1#4	1.24027e-18
C87	a_529_392##4	a_83_274##18	8.65086e-17
C88	VPWR#4	A1#1	2.56983e-18
C89	B1#2	A1#2	1.23923e-17
C90	A1#6	a_775_74##2	1.57948e-17
C91	X#5	a_83_274##10	2.30226e-17
C92	a_529_392##2	A3#5	1.40086e-17
C93	VGND#9	A1#4	4.45705e-19
C94	a_83_274##14	B1#2	1.36282e-17
C95	a_529_392##6	a_529_392##4	2.21215e-18
C96	a_83_274##17	A1#6	3.58372e-17
C97	a_529_392##3	A2#5	1.09374e-19
C98	a_775_74##2	B1#5	6.78953e-19
C99	a_83_274##15	a_83_274##14	3.55325e-18
C100	VPWR#4	A1#5	2.56999e-18
C101	X#5	a_83_274##12	1.5967e-17
C102	VGND#9	A1#6	9.47965e-19
C103	a_529_392##6	a_83_274##18	8.2888e-17
C104	a_529_392##2	A2#5	2.00753e-17
C105	a_83_274##17	B1#5	3.12801e-17
C106	VGND#2	a_1000_74##4	1.05259e-17
C107	a_775_74##2	B1#4	3.7021e-19
C108	VPWR#12	a_83_274##18	2.86893e-18
C109	a_529_392##3	A2#6	1.94422e-17
C110	B1#5	VGND#9	1.59515e-17
C111	B1#3	B1#2	6.34121e-18
C112	a_83_274##17	B1#4	1.10783e-18
C113	a_529_392##2	A2#6	1.09374e-19
C114	VPWR#10	A2#3	1.1685e-19
C115	a_83_274##19	B1#5	5.45922e-19
C116	VPWR#12	a_529_392##6	7.7076e-17
C117	X#1	a_83_274##18	2.50513e-19
C118	VGND#9	B1#4	3.73782e-17
C119	VGND#2	a_775_74#	6.41323e-17
C120	a_529_392##3	A1#1	2.02691e-17
C121	a_83_274##17	a_83_274##7	1.49777e-20
C122	B1#4	a_83_274##19	1.40684e-17
C123	VGND#9	a_83_274##7	6.51405e-19
C124	X#1	VPWR#12	1.02733e-16
C125	VGND#10	B1#4	2.86802e-18
C126	X#5	a_83_274##15	1.89156e-19
C127	a_529_392##3	A1#5	1.08011e-19
C128	a_83_274##19	a_83_274##7	1.46179e-18
C129	a_1000_74##2	a_1000_74#	2.45062e-19
C130	VPWR#6	a_83_274#	4.67035e-18
C131	X#7	B1#4	3.87171e-19
C132	VPWR#13	VPWR#12	1.69608e-18
C133	VGND#10	a_83_274##7	4.82654e-17
C134	a_83_274##3	a_83_274##4	1.32585e-17
C135	a_775_74#	a_529_392##3	1.30766e-18
C136	a_83_274##19	a_83_274##8	7.04565e-20
C137	X#1	VPWR#13	9.76999e-17
C138	VPWR#7	a_83_274##9	2.60708e-18
C139	a_83_274##7	X#7	1.6901e-17
C140	VGND#8	a_1000_74##2	2.34232e-17
C141	VGND#10	a_83_274##8	1.9911e-18
C142	VGND#11	a_83_274##7	1.29464e-18
C143	X#7	a_83_274##8	3.56068e-17
C144	VPWR#7	a_83_274##11	2.57891e-18
C145	VGND#11	a_83_274##8	2.84726e-17
C146	X#7	a_83_274##10	4.01452e-19
C147	VGND#5	VGND#9	1.38881e-19
C148	a_83_274##13	a_529_392##3	4.53408e-18
C149	VPWR#8	VPWR#13	1.51987e-18
C150	VGND#11	a_83_274##10	2.53648e-17
C151	a_775_74#	a_1000_74##2	2.59098e-17
C152	VPWR#7	a_83_274##6	2.30519e-18
C153	X#7	a_83_274##12	1.69409e-19
C154	a_83_274##10	X#6	4.30494e-18
C155	X#5	a_83_274##5	5.43858e-18
C156	VGND#5	a_83_274##19	6.00668e-18
C157	a_775_74##2	a_529_392##3	1.10642e-18
C158	VGND#11	a_83_274##12	1.53042e-18
C159	a_529_392##4	A1#6	3.47501e-18
C160	VGND#7	a_83_274##10	2.5917e-18
C161	VGND#6	VGND#10	2.10894e-20
C162	a_1000_74##3	a_1000_74##2	2.45062e-19
C163	a_83_274##12	X#6	8.44436e-18
C164	VGND#4	a_83_274##19	8.41594e-18
C165	X#5	a_83_274##4	5.16702e-18
C166	VGND#7	a_83_274##12	3.55788e-17
C167	VGND#6	X#7	6.72018e-18
C168	a_1000_74#	A3#4	6.89845e-18
C169	a_529_392##4	A1#3	6.38362e-19
C170	A3#7	A3#6	4.05233e-17
C171	VGND#5	X#7	4.94047e-18
C172	a_529_392##4	B1#2	2.07843e-19
C173	a_529_392#	A3#1	5.38804e-17
C174	VPWR#1	VPWR#2	4.41906e-18
C175	A2#1	A3#7	4.16659e-17
C176	a_83_274##18	A2#3	2.07182e-19
C177	A3#1	VPWR#9	2.66748e-17
C178	a_529_392#	A3#5	1.89322e-18
C179	a_529_392##7	A3#1	6.26732e-19
C180	VGND#8	A3#4	8.47155e-19
C181	VPWR#9	A3#5	4.71397e-17
C182	A2#4	A2#1	4.02882e-17
C183	a_529_392#	A2#5	1.97004e-19
C184	a_83_274##18	B1#2	1.59736e-17
C185	A3#5	a_529_392##7	1.76151e-17
C186	VGND#7	VGND#6	1.17934e-18
C187	VPWR#9	A2#5	2.44393e-18
C188	VPWR#10	A3#5	7.01405e-19
C189	a_83_274##14	a_83_274##13	1.48923e-18
C190	a_529_392#	VPWR#2	3.72422e-19
C191	a_529_392##7	A2#5	4.59553e-17
C192	VPWR#7	a_83_274##5	5.88206e-20
C193	VGND#1	VGND#2	4.70358e-18
C194	A1#4	A2#4	3.04459e-18
C195	VPWR#9	A2#6	2.85443e-19
C196	A2#5	VPWR#10	2.91115e-17
C197	a_529_392##7	A2#6	4.16662e-19
C198	a_775_74##2	a_83_274##14	2.38859e-17
C199	VPWR#7	VPWR#6	8.81498e-19
C200	a_529_392##8	A2#5	4.16662e-19
C201	A2#6	VPWR#10	3.35479e-17
C202	A1#6	A1#4	2.37305e-17
C203	VPWR#7	a_83_274##4	2.66845e-20
C204	VPWR#11	A2#5	2.84722e-19
C205	VGND#8	a_1000_74#	5.85992e-17
C206	a_529_392##6	B1#2	1.10372e-18
C207	a_529_392##8	A2#6	5.05124e-17
C208	a_529_392##7	VPWR#3	8.25749e-18
C209	a_83_274##14	a_83_274##17	1.67755e-20
C210	VPWR#10	A1#1	7.67963e-19
C211	VGND#9	a_83_274##15	1.48034e-17
C212	A1#1	A2#3	2.14343e-18
C213	VPWR#11	A2#6	1.34947e-18
C214	VPWR#4	A1#3	1.50472e-20
C215	a_83_274##18	A2#5	2.35949e-19
C216	a_1000_74##4	a_1000_74#	2.00505e-18
C217	a_529_392##8	A1#1	4.30669e-17
C218	B1#5	A1#6	4.3581e-17
C219	a_529_392##7	VPWR#2	9.40881e-18
C220	VPWR#10	A1#5	2.8528e-19
C221	A1#1	VPWR#11	2.92455e-17
C222	a_83_274##18	A2#6	2.24866e-19
C223	VGND#9	a_83_274##14	1.89011e-17
C224	a_529_392##8	A1#5	4.11471e-19
C225	a_529_392##4	A1#1	5.19482e-19
C226	a_1000_74##4	VGND#8	4.94243e-17
C227	a_529_392##8	VPWR#4	8.50531e-18
C228	B1#4	B1#5	2.9781e-17
C229	A1#5	VPWR#11	3.34822e-17
C230	VPWR#3	A2#2	4.19998e-20
C231	a_83_274##18	A1#1	6.47045e-19
C232	VPWR#12	B1#2	4.05268e-20
C233	a_529_392##4	A1#5	7.76501e-17
C234	a_83_274##19	a_83_274##14	1.38109e-18
C235	a_529_392##8	VPWR#3	8.43957e-18
C236	VGND#10	a_83_274##15	1.06988e-17
C237	B1	B1#2	5.19121e-18
C238	a_775_74#	VGND#8	4.42307e-18
C239	VPWR#11	B1#1	1.30317e-18
C240	a_83_274##18	A1#5	2.18145e-18
C241	VGND#1	a_1000_74#	3.34405e-17
C242	B1	a_83_274##4	1.49677e-19
C243	a_83_274##7	B1#4	4.63132e-18
C244	a_529_392##4	B1#1	3.39408e-17
C245	a_529_392##6	A1#5	1.95378e-19
C246	VGND#2	A2#2	3.88771e-20
C247	VGND#3	a_83_274##14	1.23203e-18
C248	VPWR#11	B1#6	5.22586e-19
C249	a_83_274##18	B1#1	4.77685e-17
C250	VPWR#12	A1#5	2.96522e-19
C251	B1#2	A1#5	3.7499e-19
C252	a_775_74#	a_1000_74##4	5.02027e-17
C253	a_529_392##3	A2#2	1.5376e-18
C254	a_529_392##4	B1#6	3.74169e-19
C255	a_529_392##6	B1#1	1.46591e-18
C256	a_529_392##2	A2#2	4.27439e-18
C257	a_529_392##2	a_529_392#	5.3354e-19
C258	a_83_274##8	a_83_274##7	3.51052e-17
C259	VPWR#6	B1#3	2.39203e-19
C260	B1#6	a_83_274##18	2.32579e-17
C261	VPWR#12	B1#1	8.08925e-19
C262	VPWR#4	VPWR#3	9.5684e-19
C263	a_529_392##4	VPWR#4	1.18207e-17
C264	a_1000_74##2	A2#2	1.17455e-17
C265	A3	A3#4	3.6827e-17
C266	a_529_392##6	B1#6	4.77482e-17
C267	a_1000_74##3	a_1000_74##4	2.00505e-18
C268	a_529_392##3	A1#2	3.90084e-18
C269	a_83_274##18	a_83_274#	7.0721e-20
C270	VPWR#12	B1#6	4.89869e-18
C271	a_83_274##10	a_83_274##8	3.80054e-17
C272	a_529_392##2	VPWR#9	2.0962e-17
C273	VPWR#7	a_83_274##3	4.30395e-20
C274	VGND#5	B1#3	3.18638e-20
C275	a_529_392##6	a_83_274#	1.62796e-18
C276	X#1	B1#6	6.79103e-20
C277	a_83_274##3	VPWR#6	2.672e-19
C278	VGND#4	B1#3	4.58838e-20
C279	a_775_74#	a_1000_74##3	6.65989e-17
C280	VGND#3	a_775_74#	1.9315e-18
C281	a_83_274#	VPWR#12	4.19575e-17
C282	VPWR#13	B1#6	8.07541e-20
C283	a_1000_74##3	A2#3	7.32071e-18
C284	X#1	a_83_274#	7.11699e-17
C285	a_83_274##12	a_83_274##10	3.08966e-17
C286	a_529_392##6	VPWR#6	1.14352e-17
C287	VGND#6	a_83_274##3	7.30483e-20
C288	a_529_392##2	a_529_392##7	8.92871e-19
C289	VPWR#12	a_83_274##9	1.34947e-18
C290	VPWR#13	a_83_274#	1.2717e-18
C291	VGND#5	a_83_274##3	9.69927e-19
C292	a_529_392#	VPWR#1	3.90505e-17
C293	VGND#3	a_775_74##2	6.69877e-17
C294	a_83_274##14	A1#2	2.20385e-18
C295	a_529_392##3	VPWR#10	1.65497e-17
C296	VGND#3	a_83_274##17	1.6789e-17
C297	X#1	a_83_274##9	7.33548e-17
C298	VPWR#3	VPWR#2	9.34474e-19
C299	a_1000_74##3	A1#3	6.16259e-19
C300	A2	A3#4	4.84074e-18
C301	VPWR#12	a_83_274##11	2.8528e-19
C302	a_83_274##9	VPWR#13	3.14717e-17
C303	A2	A2#3	1.33631e-17
C304	X#5	X#7	2.27239e-18
C305	a_83_274##15	B1#3	1.63686e-17
C306	X#1	a_83_274##11	5.24626e-19
C307	a_529_392##2	VPWR#10	1.54345e-17
C308	a_83_274##13	a_1000_74##3	5.17905e-17
C309	a_775_74##2	a_775_74#	1.45922e-18
C310	a_83_274##14	B1#3	2.068e-18
C311	a_775_74#	A2#2	9.74851e-19
C312	a_83_274##11	VPWR#13	3.71984e-17
C313	VPWR#8	a_83_274##9	2.57768e-19
C314	a_1000_74##3	A2#2	1.33415e-18
C315	a_529_392##3	a_529_392##8	1.98852e-19
C316	X#1	VPWR#7	8.61946e-18
C317	a_83_274##11	X#3	2.37392e-17
C318	VPWR#13	a_83_274##4	8.65744e-19
C319	X#5	VGND#11	4.6315e-17
C320	a_83_274##13	A2#3	4.58985e-19
C321	VPWR#13	a_83_274##6	1.46384e-18
C322	VPWR#8	a_83_274##11	1.23062e-18
C323	a_83_274##15	a_83_274##3	1.06095e-17
C324	a_83_274##14	a_83_274##3	4.66459e-19
C325	X#1	VPWR#6	8.44968e-18
C326	a_83_274##6	X#3	2.44129e-17
C327	a_83_274##13	A1#2	9.94222e-18
C328	A3#5	A3#1	3.36964e-17
C329	a_529_392##3	VPWR#11	2.40359e-17
C330	VPWR#8	a_83_274##6	3.10437e-17
C331	a_83_274##13	A1#3	9.39694e-18
C332	a_775_74##2	A1#2	1.59171e-18
C333	X#5	X#6	1.71023e-17
C334	X#5	a_83_274##3	2.63933e-17
C335	a_775_74##2	a_83_274##13	8.05891e-17
C336	A1	A2#3	4.1682e-18
C337	A1	A1#3	1.42362e-18
C338	A1	B1#2	5.5829e-18
C339	a_529_392##4	VPWR#5	2.14252e-17
C340	A2#5	A3#5	3.34435e-17
C341	VGND#6	a_83_274##5	8.27432e-20
C342	VPWR#13	VPWR#6	6.02734e-20
C343	A1#3	A2#3	3.36237e-19
C344	a_529_392##4	a_529_392##3	5.43544e-19
C345	a_529_392##6	VPWR#5	2.26809e-17
C346	VGND#7	X#5	7.52372e-17
C347	a_83_274##17	a_83_274##13	1.08192e-18
C348	VGND#9	B1#3	9.97046e-19
C349	A2#6	A2#5	2.68783e-17
C350	VGND#6	a_83_274##4	9.68785e-20
C351	VPWR#10	A2#2	1.16839e-18
C352	a_83_274##17	a_775_74##2	5.45488e-17
C353	VGND#1	A3#6	1.08409e-18
C354	a_775_74##2	A1#3	4.3252e-18
C355	A1#1	A2#6	4.15271e-17
C356	VGND#6	VGND#5	1.27024e-18
C357	a_83_274##3	VGND#10	2.79408e-17
C358	VPWR#8	VPWR#7	8.13392e-19
C359	X	a_83_274##5	1.56023e-17
C360	a_83_274##3	X#7	4.1235e-17
C361	X	a_83_274##4	2.07389e-17
C362	VGND#9	a_775_74##2	3.61774e-18
C363	a_83_274##18	A2#2	7.17732e-20
C364	a_83_274##3	VGND#11	2.80622e-18
C365	VPWR#11	A1#2	1.42679e-18
C366	A1#5	A1#1	2.79386e-17
C367	a_529_392##4	A1#2	1.07039e-18
C368	a_83_274##18	A1#2	1.72067e-18
C369	VGND#9	a_83_274##17	5.36533e-17
C370	B1	VPWR#6	5.74624e-19
C371	a_529_392##3	VPWR#4	1.6661e-19
C372	B1#1	A1#5	2.14902e-17
C373	VPWR#5	A1#6	4.77105e-20
C374	a_83_274##4	a_83_274##9	1.43955e-18
C375	a_83_274##18	B1#3	9.36149e-19
C376	VGND#3	A1#4	4.48044e-18
C377	a_529_392##6	B1#3	6.35659e-18
C378	VGND#3	A1#6	5.54121e-18
C379	a_83_274##19	a_83_274##17	5.49992e-19
C380	VPWR#12	B1#3	2.24164e-19
C381	B1#6	B1#1	3.10984e-17
C382	VGND#3	B1#5	7.10385e-18
C383	VGND#5	VGND#4	8.25571e-19
C384	X#1	B1#3	1.73074e-18
C385	a_529_392##3	VPWR#3	1.6661e-19
C386	A2#4	A2#2	1.00066e-17
C387	VPWR#1	A3#1	3.30662e-18
C388	a_83_274##3	VPWR#12	1.57497e-17
C389	B1#2	A1#3	1.43356e-18
C390	a_83_274##19	VGND#9	5.18638e-17
C391	a_83_274#	B1#6	5.76972e-18
C392	a_83_274##3	X#1	6.22506e-17
C393	a_83_274##15	B1	5.43079e-17
C394	a_83_274##14	B1	2.99783e-17
C395	VPWR#13	a_83_274##3	6.7229e-19
C396	a_83_274##14	a_529_392##4	4.73233e-18
C397	A3	a_529_392##2	3.24998e-17
C398	a_83_274##9	a_83_274#	4.78176e-17
C399	a_529_392##2	VPWR#3	2.15613e-19
C400	a_1000_74##2	A3	3.29222e-17
C401	VGND#10	VGND#9	1.74943e-18
C402	a_83_274##11	a_83_274##9	3.08555e-17
C403	a_83_274##14	a_83_274##18	2.63961e-18
C404	A2	a_529_392##3	4.9316e-17
C405	VGND	B1#2	2.41376e-20
C406	VGND#10	a_83_274##19	4.55034e-17
C407	VGND	a_83_274##5	2.87134e-19
C408	A2	a_529_392##2	4.55307e-17
C409	a_529_392##2	VPWR#2	1.6661e-19
C410	a_1000_74##2	A2	4.16429e-17
C411	a_1000_74#	A3	5.24702e-17
C412	a_83_274##6	a_83_274##11	4.61064e-17
C413	VGND#9	B1#2	1.78696e-19
C414	a_83_274##3	B1#4	2.08919e-18
C415	VPWR#5	B1#1	5.3192e-18
C416	a_83_274##3	a_83_274##7	2.74789e-18
C417	X#7	a_83_274##19	1.06955e-18
C418	VPWR#5	B1#6	5.31936e-18
C419	a_83_274##3	a_83_274##8	6.85761e-19
C420	A1	a_529_392##3	3.60573e-17
C421	a_83_274##3	a_83_274##10	3.11632e-19
C422	a_83_274##15	VPWR#12	1.45805e-17
C423	a_83_274##3	a_83_274##12	2.35772e-19
C424	a_529_392##3	A2#3	3.31916e-19
C425	a_529_392##2	A3#4	3.20696e-18
C426	X	VPWR#7	1.68492e-17
C427	a_775_74#	A2	2.36322e-18
C428	a_83_274##6	a_83_274##4	3.24531e-18
C429	VGND#2	A3#6	3.73938e-18
C430	a_1000_74##3	A2	4.63903e-17
C431	a_83_274##14	A1	2.83459e-17
C432	A1#2	A1#1	1.58554e-18
C433	X#7	VGND#10	4.63426e-17
C434	A3	a_529_392#	4.93816e-17
C435	B1	a_83_274##18	3.53527e-17
C436	A3	VPWR#9	4.49549e-18
C437	A3#4	VNB	8.65342e-17
C438	B1	a_529_392##6	4.41499e-17
C439	A2#3	VNB	2.61288e-17
C440	A1#3	VNB	1.92927e-17
C441	B1#2	VNB	3.58154e-17
C442	a_83_274##5	VNB	4.26248e-17
C443	a_83_274##4	VNB	3.2241e-17
C444	X#1	B1	6.1459e-18
C445	VGND#11	VGND#10	1.51679e-18
C446	a_83_274##13	A1	5.00067e-17
C447	VPWR	VPWR#7	6.93272e-17
C448	VGND#2	A3#7	1.25128e-18
C449	VPWR	VPWR#6	6.91431e-17
C450	VPWR	VPWR#4	6.33149e-17
C451	A2#4	A2#3	1.52989e-18
C452	A2	a_529_392##7	3.46928e-19
C453	VPWR	VPWR#3	5.95215e-17
C454	a_83_274#	B1#3	3.28862e-18
C455	X#5	X	2.05251e-18
C456	VPWR	VPWR#2	4.61648e-17
C457	A2	VPWR#10	4.09414e-18
C458	VPWR	a_529_392##3	2.86435e-18
C459	X#7	VGND#11	4.03673e-17
C460	VPWR	a_529_392##2	2.86203e-18
C461	A1#3	A2#4	2.81637e-18
C462	VPWR	a_83_274##15	1.74489e-18
C463	A1	VPWR#11	4.07303e-18
C464	VGND#2	A2#1	4.70648e-18
C465	A1	a_529_392##4	3.17617e-17
C466	VPWR#4	A1#6	1.87172e-20
C467	a_83_274##18	A1	6.83179e-18
C468	VGND#7	X	4.18168e-19
C469	VGND	VGND#6	6.25991e-17
C470	VGND	VGND#5	5.49195e-17
C471	VGND	VGND#4	4.1437e-17
C472	VGND#3	A1#2	7.11583e-20
C473	VGND	VGND#2	1.01835e-16
C474	A2	A2#4	1.84232e-18
C475	VPWR#5	B1#3	1.91651e-20
C476	VGND	a_1000_74##2	4.67263e-18
C477	a_1000_74##2	A3#6	8.69453e-20
C478	VGND	a_83_274##15	3.82322e-18
C479	VGND	a_83_274##14	6.00339e-18
C480	VGND	X#5	1.72388e-17
C481	X	X#1	2.64007e-18
C482	VPWR	a_529_392#	4.9643e-19
C483	VGND#2	A2#4	4.56487e-18
C484	X	VPWR#13	9.7248e-17
C485	VGND	a_1000_74#	3.95506e-19
C486	VPWR	VPWR#9	2.18525e-17
C487	VGND	VGND#8	2.2864e-17
C488	X	X#3	8.94437e-19
C489	VPWR	a_529_392##7	1.78691e-17
C490	VGND	a_1000_74##4	1.27494e-17
C491	VPWR#7	VNB	3.62187e-17
C492	VPWR#8	X	8.76384e-17
C493	VPWR	VPWR#10	2.09063e-17
C494	VGND	a_775_74#	3.20203e-17
C495	VPWR#6	VNB	3.65212e-17
C496	VPWR#4	VNB	3.28183e-17
C497	VGND	a_1000_74##3	7.98323e-18
C498	VPWR	a_529_392##8	1.75408e-17
C499	VPWR#3	VNB	3.06172e-17
C500	VGND	a_83_274##13	9.50727e-18
C501	VPWR	VPWR#11	2.17107e-17
C502	VPWR#2	VNB	2.53853e-17
C503	VGND	a_775_74##2	3.22973e-17
C504	VGND#6	VNB	3.24693e-17
C505	VPWR	a_529_392##4	2.6505e-17
C506	B1	a_83_274#	1.15319e-18
C507	VGND#5	VNB	2.97128e-17
C508	VGND	a_83_274##17	1.73237e-17
C509	VGND#4	VNB	2.15589e-17
C510	VPWR	a_83_274##18	1.06463e-17
C511	VGND	VGND#9	2.31498e-17
C512	VGND#2	VNB	5.79451e-17
C513	VGND	a_83_274##19	1.51596e-17
C514	VPWR	a_529_392##6	2.55799e-17
C515	a_529_392##3	VNB	5.55612e-18
C516	VGND	VGND#10	2.19052e-17
C517	VPWR	VPWR#12	2.08499e-17
C518	a_529_392##2	VNB	4.41395e-18
C519	VGND	X#7	1.34463e-17
C520	a_83_274##3	B1#3	1.95479e-17
C521	VPWR	X#1	1.85832e-17
C522	VGND	VGND#11	1.52707e-17
C523	a_1000_74##2	VNB	7.3534e-18
C524	VPWR	VPWR#13	2.11965e-17
C525	a_1000_74##2	A3#7	7.917e-18
C526	VGND	VGND#7	6.28952e-17
C527	a_83_274##15	VNB	1.17816e-17
C528	VGND#7	VGND#11	1.8403e-18
C529	a_83_274##14	VNB	7.33687e-18
C530	VPWR	VPWR#8	5.44888e-17
C531	a_1000_74##2	A3#4	1.16723e-17
C532	X#5	VNB	1.02804e-17
C533	a_1000_74#	VNB	4.94405e-17
C534	VGND#8	VNB	2.58226e-18
C535	a_1000_74##4	VNB	5.09304e-18
C536	a_775_74#	VNB	8.93495e-18
C537	a_1000_74##3	VNB	7.31114e-18
C538	a_83_274##13	VNB	8.34219e-18
C539	VGND	VPWR#12	2.86817e-18
C540	a_775_74##2	VNB	7.69223e-18
C541	a_83_274##17	VNB	1.98853e-18
C542	VGND	X#1	3.91455e-18
C543	VPWR#1	A3	2.32763e-18
C544	VGND#9	VNB	1.36473e-18
C545	a_83_274##19	VNB	1.0077e-17
C546	VGND#10	VNB	7.12256e-18
C547	VGND#1	A3	4.28709e-18
C548	X#7	VNB	4.98881e-18
C549	VGND	VPWR#8	4.93889e-18
C550	VGND#11	VNB	5.29788e-20
C551	VGND	A3#6	4.52123e-20
C552	VGND	A3#7	8.93402e-19
C553	VGND#7	VNB	7.07614e-17
C554	a_529_392#	VNB	5.52694e-17
C555	VGND	A2#1	2.10267e-18
C556	VPWR#9	VNB	1.79151e-18
C557	VGND	A2#4	1.42644e-18
C558	a_529_392##7	VNB	2.77013e-18
C559	VGND	A1#4	1.45474e-18
C560	VPWR#10	VNB	3.76262e-18
C561	a_529_392##8	VNB	2.1429e-18
C562	VGND	A1#6	3.05391e-19
C563	VPWR	A3#5	5.24123e-19
C564	VPWR#11	VNB	4.4328e-18
C565	VGND	B1#5	7.82111e-19
C566	VPWR	A2#5	2.54793e-19
C567	a_529_392##4	VNB	5.96498e-18
C568	a_529_392##3	a_529_392##2	5.37044e-19
C569	a_1000_74##2	A2#1	9.69706e-18
C570	VGND	B1#4	8.24983e-19
C571	A3	A2#2	4.8148e-18
C572	VPWR	A2#6	6.69128e-20
C573	B1	B1#3	2.53074e-17
C574	a_529_392##6	VNB	1.55518e-17
C575	X	a_83_274##9	5.24626e-19
C576	VGND#2	a_1000_74##2	8.86388e-19
C577	VPWR#12	VNB	1.44802e-17
C578	VPWR	A1#1	1.49574e-19
C579	VGND	a_83_274##8	6.58989e-19
C580	X#1	VNB	3.62909e-18
C581	X	a_83_274##11	4.8891e-17
C582	VGND	a_83_274##10	5.78113e-19
C583	VPWR	A1#5	2.45455e-19
C584	B1	a_83_274##3	4.82434e-18
C585	VPWR#13	VNB	3.84178e-18
C586	VGND	a_83_274##12	3.25112e-18
C587	X	a_83_274##6	3.45768e-17
C588	VPWR	B1#1	6.28542e-19
C589	VPWR#8	VNB	8.03272e-17
C590	A2	A2#2	2.20945e-17
C591	A3#6	VNB	3.36021e-17
C592	VPWR	B1#6	1.12188e-18
C593	a_83_274##5	a_83_274##4	3.84801e-18
C594	A3#7	VNB	2.77274e-17
C595	VPWR	a_83_274#	3.14403e-18
C596	A2#1	VNB	3.05731e-17
C597	A2	A1#2	6.20207e-18
C598	A2#4	VNB	4.39612e-17
C599	VPWR	a_83_274##9	1.54314e-19
C600	A1#4	VNB	2.61679e-17
C601	A1#6	VNB	3.62414e-17
C602	VPWR	a_83_274##11	1.62771e-19
C603	B1#5	VNB	3.44079e-17
C604	VPWR	a_83_274##6	5.40906e-18
C605	B1#4	VNB	3.2709e-17
C606	a_83_274##7	VNB	2.75065e-17
C607	A1	A1#2	3.34991e-17
C608	a_83_274##8	VNB	2.26487e-17
C609	a_83_274##10	VNB	2.28523e-17
C610	a_83_274##12	VNB	2.92797e-17
C611	A3#1	VNB	3.74458e-17
C612	VPWR	VPWR#5	5.80598e-17
C613	A3#5	VNB	2.67483e-17
C614	A2#5	VNB	3.04187e-17
C615	A2#6	VNB	3.03064e-17
C616	X	B1#3	2.68963e-19
C617	A1#1	VNB	3.21658e-17
C618	A1#5	VNB	3.01525e-17
C619	X	a_83_274##3	2.96256e-17
C620	B1#1	VNB	3.17549e-17
C621	B1#6	VNB	3.81398e-17
C622	a_83_274#	VNB	3.90829e-17
C623	VPWR	B1#3	1.32423e-18
C624	a_83_274##9	VNB	3.48655e-17
C625	VGND	VGND#3	8.62386e-17
C626	a_1000_74##2	A2#4	7.67379e-20
C627	a_83_274##11	VNB	3.14785e-17
C628	VPWR	a_83_274##3	6.30843e-18
C629	a_83_274##6	VNB	4.33943e-17
C630	VPWR#1	VNB	8.97293e-17
C631	A2	A3	2.31613e-17
C632	VGND#1	VNB	9.15298e-17
C633	VPWR#5	VNB	3.13132e-17
C634	VGND	a_83_274##3	8.72946e-18
C635	VGND#3	VNB	4.93062e-17
C636	X	B1	2.38902e-18
C637	VGND#5	a_83_274##15	8.0711e-19
C638	A2#2	VNB	5.33286e-17
C639	A1	A2	2.25537e-17
C640	A1#2	VNB	6.95766e-17
C641	B1#3	VNB	5.65974e-17
C642	VPWR	B1	5.54693e-18
C643	a_83_274##3	VNB	8.97032e-17
C644	VPWR	A3	1.81741e-18
C645	VGND	B1	4.4221e-18
C646	VPWR	A2	4.3169e-18
C647	VGND	A3	2.35496e-18
C648	VPWR	A1	3.08644e-18
C649	VGND	A2	5.29083e-18
C650	B1	VNB	7.70851e-18
C651	VPWR	X	1.89916e-17
C652	VGND	A1	3.29569e-18
C653	A3	VNB	2.60324e-17
C654	A2	VNB	5.67852e-18
C655	VGND	X	3.35975e-18
C656	A1	VNB	5.48825e-18
C657	X	VNB	1.553e-17
C658	VPWR	VNB	2.9886e-16
C659	VGND	VNB	3.00986e-16
*
*
.ENDS sky130_fd_sc_hs__a31o_4
*
