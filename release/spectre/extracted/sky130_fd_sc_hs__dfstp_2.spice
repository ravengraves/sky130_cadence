* Extracted by Quantus, converted by sky130cad/quantus.py
*
*
*
*                       LINUX           Wed Nov 18 08:28:26 2026
*
*
*
*  PROGRAM  advgen
*
*  Name           : advgen - Quantus - (64-bit)
*  Version        : 25.1.0-p047
*  Build Date     : Thu Dec 11 23:20:30 PST 2025
*
*  HSPICE LIBRARY
*
*  OPERATING_TEMPERATURE 150
*  QRC_TECH_DIR <path>/tech
*
*
*

*
.SUBCKT sky130_fd_sc_hs__dfstp_2 VPB VNB VGND SET_B VPWR Q D CLK
*
*
*  caps2d version: 10
*
*
*       TRANSISTOR CARDS
*
*
XM28 a_27_74##4 D#2 VGND#15 VNB sky130_fd_pr__nfet_01v8_lvt l=0.15 w=0.42 ad=0.1197 as=0.1197 pd=1.41 ps=1.41
XM23 a_225_74##13 CLK#3 VGND#14 VNB sky130_fd_pr__nfet_01v8_lvt l=0.15 w=0.74 ad=0.2109 as=0.2072 pd=2.05 ps=2.04
XM22 VGND#14 a_225_74##8 a_398_74##10 VNB sky130_fd_pr__nfet_01v8_lvt l=0.15 w=0.74 ad=0.2072 as=0.2109 pd=2.04 ps=2.05
XM3 a_27_74##5 a_225_74##7 a_612_74##10 VNB sky130_fd_pr__nfet_01v8_lvt l=0.15 w=0.42 ad=0.18665 as=0.2919 pd=1.8 ps=2.23
XM21 a_612_74##10 a_398_74# a_781_74# VNB sky130_fd_pr__nfet_01v8_lvt l=0.15 w=0.42 ad=0.2919 as=0.1008 pd=2.23 ps=1.32
XM9 a_781_74# a_767_384# VGND#13 VNB sky130_fd_pr__nfet_01v8_lvt l=0.15 w=0.42 ad=0.1008 as=0.1197 pd=1.32 ps=1.41
XM24 a_767_384##5 a_612_74# a_1057_118# VNB sky130_fd_pr__nfet_01v8_lvt l=0.15 w=0.42 ad=0.1197 as=0.1008 pd=1.41 ps=1.32
XM15 a_1057_118# SET_B#1 VGND#12 VNB sky130_fd_pr__nfet_01v8_lvt l=0.15 w=0.42 ad=0.1008 as=0.3044 pd=1.32 ps=2.41
XM30 VGND#12 a_612_74##4 a_1278_74# VNB sky130_fd_pr__nfet_01v8_lvt l=0.15 w=0.64 ad=0.3044 as=0.1536 pd=2.41 ps=1.76
XM26 a_1278_74# a_398_74##6 a_1356_74##14 VNB sky130_fd_pr__nfet_01v8_lvt l=0.15 w=0.64 ad=0.1536 as=0.2713 pd=1.76 ps=2.31
XM7 a_1356_74##14 a_225_74# a_1489_118# VNB sky130_fd_pr__nfet_01v8_lvt l=0.15 w=0.42 ad=0.2713 as=0.1617 pd=2.31 ps=1.61
XM0 a_1489_118# a_1566_92##2 a_1596_118# VNB sky130_fd_pr__nfet_01v8_lvt l=0.15 w=0.42 ad=0.1617 as=0.1764 pd=1.61 ps=1.68
XM18 a_1596_118# SET_B#4 VGND#11 VNB sky130_fd_pr__nfet_01v8_lvt l=0.15 w=0.42 ad=0.1764 as=0.3591 pd=1.68 ps=2.55
XM32 VGND#11 a_1356_74##6 a_1566_92##7 VNB sky130_fd_pr__nfet_01v8_lvt l=0.15 w=0.42 ad=0.3591 as=0.1197 pd=2.55 ps=1.41
XM33 a_2022_94##9 a_1356_74##5 VGND#4 VNB sky130_fd_pr__nfet_01v8_lvt l=0.15 w=0.64 ad=0.1824 as=0.3107 pd=1.85 ps=2.34
XM10 Q#1 a_2022_94##5 VGND#4 VNB sky130_fd_pr__nfet_01v8_lvt l=0.15 w=0.74 ad=0.2072 as=0.3107 pd=2.04 ps=2.34
XM2 VGND#1 a_2022_94##4 Q#1 VNB sky130_fd_pr__nfet_01v8_lvt l=0.15 w=0.74 ad=0.2294 as=0.2072 pd=2.1 ps=2.04
XM31 a_27_74##6 D#3 VPWR#16 VPB sky130_fd_pr__pfet_01v8 l=0.15 w=0.42 ad=0.1239 as=0.1239 pd=1.43 ps=1.43
XM14 a_225_74##11 CLK#1 VPWR#14 VPB sky130_fd_pr__pfet_01v8 l=0.15 w=1.12 ad=0.3304 as=0.336 pd=2.83 ps=2.84
XM27 VPWR#14 a_225_74##9 a_398_74##14 VPB sky130_fd_pr__pfet_01v8 l=0.15 w=1.12 ad=0.336 as=0.3304 pd=2.84 ps=2.83
XM4 a_27_74# a_398_74##4 a_612_74##8 VPB sky130_fd_pr__pfet_01v8 l=0.15 w=0.42 ad=0.1239 as=0.147 pd=1.43 ps=1.54
XM13 a_612_74##8 a_225_74##6 a_716_456# VPB sky130_fd_pr__pfet_01v8 l=0.15 w=0.42 ad=0.147 as=0.1134 pd=1.54 ps=1.38
XM1 a_716_456# a_767_384##4 VPWR#11 VPB sky130_fd_pr__pfet_01v8 l=0.15 w=0.42 ad=0.1134 as=0.49365 pd=1.38 ps=3.15
XM8 VPWR#11 a_612_74##3 a_767_384##7 VPB sky130_fd_pr__pfet_01v8 l=0.15 w=0.42 ad=0.49365 as=0.126 pd=3.15 ps=1.44
XM12 a_767_384##7 SET_B#3 VPWR#9 VPB sky130_fd_pr__pfet_01v8 l=0.15 w=0.42 ad=0.126 as=0.489425 pd=1.44 ps=3.76
XM29 VPWR#9 a_612_74##7 a_1266_341# VPB sky130_fd_pr__pfet_01v8 l=0.15 w=1 ad=0.489425 as=0.399625 pd=3.76 ps=3.22
XM5 a_1266_341# a_225_74##2 a_1356_74##11 VPB sky130_fd_pr__pfet_01v8 l=0.15 w=1 ad=0.399625 as=0.4315 pd=3.22 ps=3.24
XM6 a_1356_74##11 a_398_74##7 a_1521_508# VPB sky130_fd_pr__pfet_01v8 l=0.15 w=0.42 ad=0.4315 as=0.1134 pd=3.24 ps=1.38
XM11 a_1521_508# a_1566_92##3 VPWR#7 VPB sky130_fd_pr__pfet_01v8 l=0.15 w=0.42 ad=0.1134 as=0.1638 pd=1.38 ps=1.62
XM19 VPWR#7 SET_B#6 a_1356_74##13 VPB sky130_fd_pr__pfet_01v8 l=0.15 w=0.42 ad=0.1638 as=0.1239 pd=1.62 ps=1.43
XM20 VPWR#5 a_1356_74##7 a_1566_92##4 VPB sky130_fd_pr__pfet_01v8 l=0.15 w=0.42 ad=0.1239 as=0.1239 pd=1.43 ps=1.43
XM16 a_2022_94##10 a_1356_74# VPWR#4 VPB sky130_fd_pr__pfet_01v8 l=0.15 w=1 ad=0.295 as=0.4204 pd=2.59 ps=3.01
XM17 Q#2 a_2022_94##6 VPWR#4 VPB sky130_fd_pr__pfet_01v8 l=0.15 w=1.12 ad=0.336 as=0.4204 pd=2.84 ps=3.01
XM25 VPWR#1 a_2022_94# Q#2 VPB sky130_fd_pr__pfet_01v8 l=0.15 w=1.12 ad=0.3304 as=0.336 pd=2.83 ps=2.84
*
*
*       RESISTOR AND CAP/DIODE CARDS
*
Rg1	D#1	D#2	311.105377
Rg2	D#1	D#3	453.390839
Rg3	CLK#1	CLK#2	478.349915
Rg4	CLK#2	CLK#3	320.356293
Rg5	a_398_74#	a_398_74##2	511.823395
Rg6	a_398_74##2	a_398_74##3	146.752594
Rg7	a_398_74##3	a_398_74##4	297.047241
Rg8	a_767_384#	a_767_384##2	308.853058
Rg9	a_767_384##2	a_767_384##3	346.612640
Rg10	a_767_384##3	a_767_384##4	404.356903
Rg11	a_612_74#	a_612_74##2	300.359375
Rg12	a_612_74##2	a_612_74##3	499.582458
Rg13	SET_B#1	SET_B#2	597.891296
Rg14	SET_B#2	SET_B#3	231.071503
Rg15	a_612_74##4	a_612_74##5	344.985535
Rg16	a_612_74##5	a_612_74##6	16.815884
Rg17	a_612_74##5	a_612_74##7	415.359894
Rg18	a_398_74##5	a_398_74##6	279.244598
Rg19	a_225_74#	a_225_74##2	1174.917358
Rg20	a_225_74##2	a_225_74##3	2174.318115
Rg21	a_225_74##3	a_225_74##4	1435.597534
Rg22	a_225_74##4	a_225_74##5	59.143440
Rg23	a_225_74##3	a_225_74##6	299.145386
Rg24	a_225_74##4	a_225_74##7	646.215393
Rg25	a_225_74##5	a_225_74##8	371.702240
Rg26	a_225_74##5	a_225_74##9	446.312561
Rg27	a_398_74##7	a_398_74##8	233.787552
Rg28	a_1566_92#	a_1566_92##2	307.893585
Rg29	a_1566_92#	a_1566_92##3	418.525909
Rg30	SET_B#4	SET_B#5	481.015625
Rg31	SET_B#5	SET_B#6	384.535614
Rg32	a_1356_74#	a_1356_74##2	357.489990
Rg33	a_1356_74##2	a_1356_74##3	551.578308
Rg34	a_1356_74##3	a_1356_74##4	18.192068
Rg35	a_1356_74##2	a_1356_74##5	509.471100
Rg36	a_1356_74##3	a_1356_74##6	560.108521
Rg37	a_1356_74##3	a_1356_74##7	337.738251
Rg38	a_2022_94#	a_2022_94##2	471.862823
Rg39	a_2022_94##2	a_2022_94##3	79.391464
Rg40	a_2022_94##2	a_2022_94##4	368.862610
Rg41	a_2022_94##3	a_2022_94##5	348.749176
Rg42	a_2022_94##3	a_2022_94##6	451.749359
Rf1	D#4	D	0.532052
Rf2	D#1	D#6	53.942986
Rf3	D#4	D#6	7.479781
Rf4	D#7	D	0.532052
Rf5	D#6	D#7	7.086109
Rf6	CLK#4	CLK#2	161.521530
Rf7	CLK	CLK#6	1.288721
Rf8	CLK#4	CLK#6	7.589135
Rf9	a_225_74##5	a_225_74##12	223.872650
Rf10	a_225_74##12	a_225_74##13	88.222649
Rf11	a_225_74##11	a_225_74##12	15.000000
Rf12	a_27_74#	a_27_74##2	37.774403
Rf13	a_27_74##2	a_27_74##3	154.010620
Rf14	a_27_74##3	a_27_74##4	136.400085
Rf15	a_27_74##2	a_27_74##5	113.600792
Rf16	a_27_74##3	a_27_74##6	39.304317
Rf17	a_398_74##3	a_398_74##10	265.101013
Rf18	a_767_384##5	a_767_384##2	191.338776
Rf19	a_767_384##7	a_767_384##3	240.757782
Rf20	SET_B#7	SET_B#2	175.088989
Rf21	a_612_74##8	a_612_74##9	110.421349
Rf22	a_612_74##9	a_612_74##10	36.860916
Rf23	a_612_74##9	a_612_74##11	126.995476
Rf24	a_612_74##11	a_612_74##6	196.069397
Rf25	a_398_74##5	a_398_74##12	168.519608
Rf26	a_398_74##12	a_398_74##13	338.762207
Rf27	a_398_74##13	a_398_74##14	186.851929
Rf28	a_398_74##12	a_398_74##8	428.633057
Rf29	a_398_74##13	a_398_74##2	195.508774
Rf30	SET_B#9	SET_B#5	81.756851
Rf31	SET_B	SET_B#12	11.418228
Rf32	SET_B#9	SET_B#12	6.956707
Rf33	a_1356_74##4	a_1356_74##9	130.395889
Rf34	a_1356_74##9	a_1356_74##10	87.532616
Rf35	a_1356_74##10	a_1356_74##12	12.771268
Rf36	a_1356_74##9	a_1356_74##13	25.548002
Rf37	a_1356_74##10	a_1356_74##11	19.023748
Rf38	a_1356_74##12	a_1356_74##14	127.064163
Rf39	a_1356_74##11	a_1356_74##12	7.500000
Rf40	a_1566_92##4	a_1566_92##5	96.836678
Rf41	a_1566_92##5	a_1566_92#	183.118378
Rf42	a_1566_92##5	a_1566_92##7	28.183121
Rf43	a_2022_94##3	a_2022_94##8	182.331177
Rf44	a_2022_94##8	a_2022_94##9	33.536789
Rf45	a_2022_94##8	a_2022_94##10	36.686043
Rf46	Q#1	Q	87.373764
Rf47	Q	Q#2	20.511347
Rf48	VPWR#1	VPWR#2	115.584740
Rf49	VPWR#2	VPWR#3	106.629196
Rf50	VPWR#2	VPWR#4	32.518913
Rf51	VPWR#3	VPWR#5	36.824379
Rf52	VPWR#3	VPWR#6	81.792023
Rf53	VPWR#6	VPWR#7	32.145462
Rf54	VPWR#6	VPWR#8	166.563416
Rf55	VPWR#8	VPWR#9	36.515656
Rf56	VPWR#8	VPWR#10	133.813263
Rf57	VPWR#10	VPWR#11	44.872284
Rf58	VPWR#10	VPWR#12	58.173187
Rf59	VPWR#12	VPWR#13	118.317268
Rf60	VPWR#13	VPWR#14	35.294842
Rf61	VPWR#13	VPWR#15	73.731934
Rf62	VPWR#15	VPWR#16	34.310661
Rf64	VGND#1	VGND#2	112.381599
Rf65	VGND#2	VGND#3	102.611412
Rf66	VGND#2	VGND#4	33.306259
Rf67	VGND#3	VGND#5	255.355652
Rf68	VGND#5	VGND#6	110.435463
Rf69	VGND#6	VGND#7	78.504745
Rf70	VGND#7	VGND#8	118.374619
Rf71	VGND#8	VGND#9	78.229668
Rf73	VGND#3	VGND#11	19.312283
Rf74	VGND#5	VGND#12	17.109503
Rf75	VGND#6	VGND#13	32.539131
Rf76	VGND#8	VGND#14	37.457504
Rf77	VGND#9	VGND#15	40.352859
Rf85	a_612_74##2	a_612_74##11	160.232803
Re2	SET_B	SET_B#7	13.698293
Re3	VPWR#3	VPWR	2.179561
Re4	VPWR	VPWR#12	1.712512
Re5	VGND#3	VGND	2.179561
Re6	VGND	VGND#7	1.712512
*
*       CAPACITOR CARDS
*
*
C1	a_1566_92##5	a_1356_74##2	2.88519e-19
C2	a_398_74##13	a_767_384##4	3.33969e-17
C3	a_1356_74##7	a_2022_94##6	3.14388e-19
C4	a_27_74#	a_612_74##8	3.98793e-17
C5	a_27_74##2	a_398_74##14	2.74666e-17
C6	a_1566_92##5	a_2022_94##10	1.5829e-17
C7	a_2022_94##2	Q#2	7.64865e-20
C8	a_398_74##14	a_225_74##3	2.40135e-17
C9	a_398_74##12	VPWR#8	4.52201e-18
C10	VGND#13	a_225_74##7	1.61075e-18
C11	a_225_74##4	a_398_74##4	2.07888e-17
C12	a_398_74##12	a_767_384##4	1.04128e-19
C13	a_398_74#	a_612_74##10	1.32943e-17
C14	a_225_74##7	a_225_74##3	2.81147e-20
C15	a_1356_74##7	a_1356_74#	3.66682e-18
C16	VGND#4	a_2022_94##8	5.08778e-18
C17	VGND#14	a_398_74##10	6.09171e-17
C18	a_225_74##13	a_27_74##5	5.51586e-19
C19	a_398_74##10	a_767_384#	3.85448e-19
C20	a_225_74##5	a_27_74##2	8.86787e-17
C21	a_612_74##8	a_398_74##14	8.13388e-18
C22	a_225_74##3	a_398_74##4	1.27441e-17
C23	VGND#8	a_225_74##8	6.02831e-18
C24	VGND#1	Q#1	7.57129e-17
C25	a_398_74##13	a_225_74##6	1.0148e-17
C26	a_27_74##2	VPWR#14	3.45384e-17
C27	a_612_74##2	a_767_384##5	3.77626e-17
C28	VGND#11	a_1356_74##2	9.13632e-20
C29	a_225_74##4	a_225_74##3	1.25579e-19
C30	VPWR#14	a_225_74##4	4.537e-19
C31	a_1356_74##10	a_1521_508#	2.12042e-18
C32	a_225_74##7	a_612_74##10	2.08236e-17
C33	a_398_74##14	VPWR#12	3.23327e-17
C34	a_398_74##14	a_27_74#	8.02511e-17
C35	VGND#13	a_612_74##2	3.71135e-18
C36	SET_B#6	a_1356_74##7	3.25227e-18
C37	a_225_74##13	a_398_74##10	2.26895e-18
C38	VGND#5	VGND#12	3.49996e-18
C39	a_27_74##3	a_225_74##11	4.91399e-17
C40	a_398_74##12	a_225_74##6	2.32314e-20
C41	a_398_74##10	a_398_74#	2.07057e-18
C42	a_27_74##3	CLK#2	4.64313e-19
C43	a_225_74##8	a_225_74##4	7.82397e-18
C44	VGND#3	a_2022_94##4	3.01081e-18
C45	VPWR#7	a_1566_92#	1.13009e-18
C46	a_225_74##7	a_27_74##5	2.50159e-17
C47	VPWR#14	a_225_74##3	5.71035e-19
C48	VGND#4	VGND#1	1.58842e-18
C49	a_612_74##9	a_767_384##4	4.46477e-19
C50	VGND#14	a_398_74#	2.03694e-20
C51	VGND#3	a_2022_94##5	1.27355e-18
C52	a_225_74##9	a_225_74##4	3.15225e-17
C53	VGND#3	VGND#5	3.77315e-17
C54	VGND#8	CLK#3	9.2411e-18
C55	a_27_74##2	a_225_74##11	2.76347e-17
C56	a_398_74##13	a_398_74##4	2.60314e-19
C57	a_767_384##2	VGND#13	3.07879e-17
C58	a_225_74##13	VGND#14	5.49634e-17
C59	a_1356_74##11	a_1566_92#	6.65708e-19
C60	a_1566_92##3	SET_B#6	2.0145e-17
C61	a_398_74##10	a_225_74##7	3.4297e-17
C62	VGND#3	a_1356_74##5	9.57682e-18
C63	VGND#3	VGND#2	8.6231e-17
C64	a_225_74##9	a_225_74##3	1.02618e-17
C65	a_27_74##3	VPWR#16	3.72343e-17
C66	a_27_74##3	D#1	3.05004e-17
C67	a_27_74##5	a_225_74##8	2.53534e-18
C68	VPWR#14	a_398_74##14	4.05779e-17
C69	a_612_74##10	a_767_384##2	8.3178e-19
C70	a_27_74##2	D#1	1.18822e-18
C71	VGND#3	a_1356_74##6	8.95072e-18
C72	a_612_74##2	a_225_74##3	2.24191e-19
C73	VGND#14	a_225_74##7	2.80066e-19
C74	VGND#4	Q#1	6.84265e-17
C75	VPWR#3	VPWR#8	2.43748e-17
C76	a_225_74##11	a_225_74##4	3.69588e-19
C77	D#7	CLK#2	7.44424e-20
C78	a_398_74##8	a_1356_74##11	6.32179e-17
C79	VGND#15	VGND#14	1.27713e-18
C80	VGND#13	a_767_384##3	1.14195e-18
C81	VGND#3	SET_B#4	4.55923e-18
C82	a_612_74##9	a_225_74##6	7.15445e-19
C83	a_1566_92##5	SET_B#9	1.06241e-17
C84	VGND#6	a_767_384##5	8.59176e-18
C85	a_225_74##8	a_398_74##10	1.53046e-17
C86	a_398_74##7	a_1566_92##3	2.66464e-17
C87	VPWR#3	VPWR#6	1.00427e-16
C88	a_398_74##13	a_225_74##9	9.08378e-20
C89	SET_B#7	VGND#5	3.98955e-18
C90	D#6	CLK#2	4.30435e-19
C91	VGND#3	a_1566_92##2	9.028e-18
C92	VGND#8	D#2	2.85197e-19
C93	a_27_74##5	CLK#3	6.35252e-20
C94	a_1356_74##9	a_1566_92##4	1.28242e-18
C95	D#4	CLK#2	4.52603e-19
C96	VPWR#3	VPWR#2	8.48458e-17
C97	VGND#14	a_225_74##8	4.37319e-17
C98	a_1356_74##11	a_398_74##5	4.22915e-18
C99	a_2022_94##9	Q#1	3.13804e-19
C100	VGND#15	a_225_74##13	3.92335e-17
C101	D#7	D#1	1.92504e-17
C102	a_398_74##10	CLK#3	4.94284e-19
C103	a_225_74##11	VPWR#14	2.22986e-19
C104	VGND#5	a_767_384##5	1.9417e-17
C105	a_398_74##12	a_1266_341#	1.08278e-17
C106	VGND#3	a_398_74##6	2.35077e-18
C107	a_225_74##2	a_398_74##7	1.02889e-17
C108	a_225_74##13	a_225_74##8	1.72339e-18
C109	VPWR#3	a_2022_94##8	1.59929e-18
C110	D#6	D#1	6.92938e-18
C111	a_398_74##12	a_1566_92##2	1.30357e-19
C112	a_1356_74##11	a_612_74##6	1.93374e-19
C113	a_767_384##2	a_225_74##3	3.30307e-19
C114	a_27_74##2	a_767_384##4	3.51773e-19
C115	CLK#3	VGND#14	1.49495e-17
C116	D#4	D#1	1.79453e-17
C117	a_1566_92##5	a_2022_94##9	4.85814e-17
C118	a_27_74##5	a_398_74##2	7.96109e-20
C119	VPWR#16	VPWR#14	1.37998e-17
C120	a_1356_74##11	a_225_74#	1.61319e-18
C121	a_27_74##6	a_398_74##14	1.6803e-22
C122	a_27_74##4	a_225_74##13	3.74563e-18
C123	VGND#15	a_225_74##8	1.7595e-19
C124	a_2022_94##9	VGND#4	5.83224e-17
C125	a_1356_74##5	a_2022_94##3	7.74694e-18
C126	a_1356_74##14	a_1356_74##11	4.18331e-18
C127	a_398_74##13	a_716_456#	6.95624e-18
C128	a_612_74##7	a_225_74##2	5.51669e-17
C129	a_225_74##13	CLK#3	5.50407e-17
C130	VPWR#9	a_612_74##6	3.27004e-19
C131	a_27_74##3	a_225_74##4	2.93415e-19
C132	a_1356_74##10	a_1356_74##13	3.08702e-18
C133	a_2022_94##10	a_1356_74##2	1.20876e-17
C134	a_398_74##3	a_612_74##10	2.51928e-17
C135	VPWR#16	a_225_74##3	7.05568e-20
C136	VGND#13	VGND#5	4.55223e-18
C137	VGND#14	D#2	5.49493e-19
C138	SET_B#7	VPWR#8	5.2767e-18
C139	SET_B#3	a_225_74##2	1.29536e-17
C140	a_1356_74##4	a_1356_74##5	3.30886e-19
C141	a_27_74##5	a_398_74##3	6.14899e-17
C142	a_27_74##4	VGND#15	3.05828e-17
C143	VGND#3	a_2022_94##8	1.59348e-18
C144	a_27_74##2	a_225_74##6	3.07491e-19
C145	VGND#15	CLK#3	1.2001e-18
C146	a_398_74##12	a_225_74#	1.89853e-17
C147	a_398_74##10	a_398_74##3	4.13395e-18
C148	SET_B#7	VPWR#6	4.16761e-19
C149	a_1566_92##5	a_1566_92##7	3.23474e-18
C150	a_225_74##13	D#2	1.92246e-18
C151	SET_B#3	a_612_74##7	8.37598e-18
C152	a_1356_74##9	a_1356_74##13	5.93909e-19
C153	VGND#8	a_225_74##4	3.61606e-19
C154	D#3	a_225_74##3	1.40658e-19
C155	a_767_384##7	SET_B#2	4.39618e-17
C156	D#7	a_225_74##11	3.63396e-17
C157	a_27_74##4	CLK#3	3.47788e-19
C158	SET_B#4	a_1356_74##4	2.16048e-19
C159	VPWR#3	a_1356_74##10	3.98346e-17
C160	a_767_384##3	a_225_74##3	4.57439e-18
C161	a_225_74##5	a_27_74##5	1.96183e-17
C162	a_1356_74##10	VPWR#7	1.49148e-17
C163	VGND#15	D#2	3.02666e-17
C164	a_27_74##6	a_225_74##4	4.60517e-20
C165	VPWR#11	VPWR#10	9.07204e-18
C166	a_1356_74##9	VPWR#3	5.42871e-18
C167	a_225_74##5	a_398_74##10	3.47628e-17
C168	VGND#3	a_1566_92##5	2.17697e-17
C169	a_27_74##2	a_398_74##4	2.74894e-18
C170	a_27_74##6	VPWR#16	3.41227e-17
C171	VGND#11	VGND#4	2.61524e-18
C172	a_398_74##12	a_398_74##6	2.49001e-17
C173	a_767_384##7	a_612_74##2	3.98179e-17
C174	a_612_74##3	SET_B#3	2.09364e-17
C175	VGND#14	a_225_74##5	2.50102e-18
C176	a_27_74##2	a_225_74##4	2.6537e-17
C177	D#2	a_27_74##4	1.36702e-17
C178	VGND#11	a_1566_92##5	9.83693e-17
C179	a_1566_92#	a_1356_74##6	1.076e-20
C180	a_1356_74##9	VPWR#7	2.67299e-17
C181	a_27_74##5	CLK#2	7.00992e-20
C182	a_27_74##3	a_225_74##9	3.29419e-19
C183	VPWR#10	VPWR#8	1.58359e-19
C184	VGND#2	a_2022_94##2	4.36225e-20
C185	a_1566_92#	SET_B#4	2.61379e-17
C186	D#6	a_225_74##11	1.47996e-17
C187	VGND#2	a_2022_94##8	3.62404e-19
C188	VPWR#3	a_2022_94#	3.88582e-18
C189	VGND#7	a_398_74#	5.06894e-18
C190	VGND#2	a_2022_94##3	4.91923e-19
C191	a_1566_92#	a_1566_92##2	1.32771e-17
C192	CLK#2	VGND#14	1.91538e-18
C193	a_767_384##4	a_612_74##3	3.0989e-18
C194	a_398_74##8	a_1356_74##6	2.87793e-19
C195	VGND#11	a_2022_94##9	7.65135e-18
C196	a_27_74##2	a_225_74##9	2.40385e-17
C197	a_225_74##4	a_398_74##2	4.66895e-19
C198	VPWR#3	a_2022_94##6	5.23454e-19
C199	VGND#7	a_225_74##7	4.47092e-18
C200	CLK#2	a_225_74##13	4.66782e-17
C201	a_398_74##12	a_612_74##4	1.28457e-17
C202	a_225_74#	a_1566_92#	1.3373e-17
C203	a_398_74##8	SET_B#4	3.19658e-18
C204	a_398_74##2	a_225_74##3	3.91109e-19
C205	a_27_74##5	D#1	5.20565e-20
C206	a_398_74##10	a_27_74##2	9.54954e-19
C207	VPWR#3	a_1356_74#	8.9595e-18
C208	a_398_74##8	a_1566_92##2	1.2682e-17
C209	a_398_74##10	D#1	2.54266e-19
C210	a_27_74##3	CLK#1	7.0991e-19
C211	a_1356_74##14	a_225_74##2	1.38292e-18
C212	VPWR#11	a_767_384##3	1.34048e-18
C213	a_225_74##6	a_767_384##4	3.39098e-17
C214	SET_B#7	a_1356_74##10	1.2405e-18
C215	a_398_74##8	a_225_74#	1.7112e-17
C216	VPWR#3	a_1356_74##7	7.96831e-18
C217	a_225_74##13	D#1	7.27926e-18
C218	a_27_74##2	CLK#1	2.53811e-17
C219	Q#2	VPWR#1	6.52426e-17
C220	a_1356_74##10	a_1356_74##11	7.8504e-18
C221	a_398_74##8	a_398_74##6	5.93132e-19
C222	VGND#8	a_398_74##10	4.04986e-17
C223	VGND#15	D#1	5.66167e-18
C224	a_398_74##4	a_767_384##4	6.46066e-19
C225	a_612_74##8	a_767_384##3	8.36138e-20
C226	a_398_74##12	SET_B#1	6.33114e-19
C227	VPWR#1	a_2022_94#	3.15894e-17
C228	VGND#3	SET_B#9	4.54823e-18
C229	a_27_74##4	D#1	1.13878e-17
C230	a_398_74##8	a_612_74##4	2.07157e-19
C231	a_398_74##5	a_225_74#	1.51381e-17
C232	a_2022_94##5	a_2022_94##4	3.8451e-17
C233	a_225_74##2	VGND#12	2.94672e-19
C234	a_398_74##4	a_225_74##6	2.50966e-17
C235	VPWR#3	a_398_74##12	1.05728e-18
C236	a_27_74##3	VPWR#13	1.81139e-18
C237	a_27_74##3	D#3	1.6969e-17
C238	a_225_74##4	a_398_74##3	5.17251e-17
C239	Q#2	a_2022_94#	4.73286e-17
C240	VPWR#4	VPWR#1	1.56532e-18
C241	a_612_74##8	a_398_74##2	1.60379e-17
C242	a_612_74##4	a_398_74##5	2.44002e-18
C243	a_612_74##6	a_225_74#	1.29808e-18
C244	a_398_74##3	a_225_74##3	1.93136e-18
C245	VPWR#1	a_2022_94##6	1.17456e-18
C246	VPWR#2	a_2022_94##3	4.57114e-20
C247	a_27_74##3	a_27_74##2	1.88192e-18
C248	a_1356_74##2	a_2022_94##6	1.29701e-18
C249	VGND#2	a_1356_74##2	1.87467e-19
C250	VPWR#3	a_225_74##2	4.05463e-18
C251	VPWR#4	a_2022_94#	2.77771e-18
C252	a_398_74##12	a_612_74#	9.92948e-20
C253	a_398_74##12	a_1356_74##10	2.6992e-18
C254	a_398_74##3	a_612_74##8	2.89612e-17
C255	a_2022_94##6	Q#2	1.96456e-17
C256	VPWR#4	Q#2	5.94329e-17
C257	VGND#3	a_225_74##2	3.93317e-20
C258	VGND#3	a_398_74##12	2.66624e-17
C259	a_1356_74##5	a_2022_94##5	2.14238e-17
C260	VPWR#3	a_1356_74##2	8.19475e-19
C261	a_2022_94##8	a_2022_94##3	2.7777e-19
C262	a_398_74##3	a_27_74#	1.63862e-17
C263	a_612_74##6	SET_B#1	2.17444e-17
C264	a_2022_94##10	a_2022_94#	2.24223e-19
C265	a_27_74##2	VPWR#13	8.69631e-19
C266	a_398_74##13	a_767_384#	3.63026e-19
C267	a_398_74##3	a_398_74##14	4.22342e-18
C268	VPWR#4	a_2022_94##6	5.71049e-17
C269	a_398_74##14	VPWR#13	3.31122e-17
C270	SET_B#7	a_225_74##2	7.10172e-18
C271	CLK#1	a_225_74##9	4.63458e-17
C272	D#7	CLK#1	4.83921e-19
C273	VPWR#2	a_2022_94#	2.71244e-18
C274	a_1356_74##4	a_1356_74#	4.11e-18
C275	Q#2	a_1356_74#	4.60724e-19
C276	VPWR#9	a_1356_74##10	9.5714e-18
C277	a_2022_94##10	Q#2	2.47845e-18
C278	SET_B#7	a_612_74##7	1.07165e-17
C279	a_225_74##5	a_225_74##4	3.93622e-18
C280	a_2022_94##10	a_2022_94##6	1.94099e-18
C281	a_1356_74##4	a_1356_74##7	3.26814e-18
C282	a_225_74##5	a_398_74##14	1.7396e-18
C283	a_27_74##4	a_27_74##3	2.16949e-19
C284	VGND#8	a_225_74##13	1.16181e-17
C285	VGND#3	a_2022_94##2	3.0339e-19
C286	SET_B#7	a_398_74##12	9.4762e-17
C287	a_1356_74#	VPWR#4	1.92306e-17
C288	VGND#1	a_2022_94##4	2.80986e-17
C289	a_225_74##5	VPWR#14	6.3748e-19
C290	a_612_74##2	SET_B#1	2.43591e-17
C291	D#3	CLK#1	4.98007e-18
C292	a_2022_94##8	a_1356_74##4	3.05071e-19
C293	a_1356_74##6	a_1356_74##5	5.00307e-18
C294	SET_B#6	a_1356_74##4	2.36356e-18
C295	a_767_384##2	a_398_74##6	8.84409e-20
C296	a_1566_92##4	a_2022_94##6	4.8935e-19
C297	a_225_74##11	a_225_74##5	2.2654e-18
C298	a_398_74##12	a_1278_74#	1.30298e-17
C299	a_2022_94##10	VPWR#4	4.21199e-17
C300	a_767_384##2	a_612_74##4	2.36255e-19
C301	VPWR#6	SET_B#5	1.52002e-19
C302	a_1356_74##4	a_1566_92##3	7.13252e-20
C303	a_2022_94##8	a_2022_94#	5.21962e-21
C304	a_2022_94##10	a_1356_74#	6.22766e-17
C305	a_612_74##2	a_767_384#	1.5886e-19
C306	a_767_384##2	SET_B#1	6.19093e-19
C307	SET_B#7	a_767_384##4	1.6293e-19
C308	VGND#3	a_1356_74##2	7.20799e-19
C309	SET_B#9	a_1356_74##2	2.67389e-19
C310	Q#1	a_2022_94##4	4.12074e-17
C311	VPWR#5	a_2022_94##6	3.35575e-19
C312	VPWR#2	a_2022_94##6	9.75834e-19
C313	a_398_74##13	VPWR#12	3.91153e-17
C314	VPWR#4	a_1356_74##7	1.11861e-18
C315	a_767_384##2	a_612_74#	1.02843e-17
C316	a_1566_92##3	SET_B#5	4.0635e-18
C317	a_225_74##11	CLK#2	4.55537e-17
C318	a_1566_92##4	a_1356_74#	3.03739e-18
C319	VGND#1	a_2022_94##5	1.23762e-18
C320	a_1566_92##5	a_1356_74##4	8.49734e-17
C321	a_1566_92##4	VPWR#4	4.78483e-18
C322	a_2022_94##10	a_1356_74##7	8.88953e-19
C323	VGND#4	a_2022_94##4	1.54118e-18
C324	SET_B#4	a_1356_74##6	4.08569e-18
C325	a_767_384##2	a_398_74#	7.45813e-19
C326	VPWR#5	a_1356_74#	3.687e-19
C327	a_225_74##11	D#1	9.36835e-18
C328	a_767_384##2	a_225_74##7	4.82152e-19
C329	Q#1	a_2022_94##5	4.03212e-17
C330	a_767_384#	a_767_384##3	2.44893e-18
C331	VPWR#12	a_398_74##4	7.33661e-19
C332	a_2022_94##8	a_2022_94##6	1.8423e-20
C333	a_1566_92##4	a_1356_74##7	1.24787e-17
C334	VPWR#16	D#1	1.37624e-18
C335	a_398_74##8	a_1566_92##3	1.82954e-17
C336	a_612_74##9	a_767_384#	1.6648e-17
C337	a_1566_92##4	a_2022_94##10	7.22946e-17
C338	VPWR#5	VPWR#4	6.78755e-19
C339	a_2022_94##9	a_2022_94##4	1.27619e-20
C340	a_1356_74##13	a_1356_74#	3.47243e-20
C341	a_225_74##2	a_1566_92#	7.82162e-18
C342	VPWR#2	a_1356_74#	9.68639e-18
C343	VGND#1	a_1356_74##5	2.43534e-19
C344	a_27_74#	a_225_74##7	2.87223e-19
C345	VGND#5	a_398_74##5	1.5453e-19
C346	VPWR#5	a_1356_74##7	1.98814e-17
C347	a_1566_92##5	SET_B#5	2.03377e-18
C348	a_2022_94##5	VGND#4	2.38928e-17
C349	a_225_74##2	a_398_74##8	3.40435e-17
C350	a_1566_92##4	SET_B#6	3.11687e-19
C351	a_1566_92##2	SET_B#4	2.85812e-17
C352	a_398_74##14	a_225_74##7	1.41513e-20
C353	Q#1	a_1356_74##5	2.10101e-19
C354	a_1356_74##13	a_1356_74##7	1.17317e-18
C355	a_225_74##7	a_398_74##2	1.35066e-18
C356	a_398_74##5	a_225_74##2	2.12711e-17
C357	a_2022_94##9	a_2022_94##5	3.86209e-20
C358	VPWR#6	a_398_74##8	2.42124e-19
C359	a_612_74##9	a_398_74#	1.33649e-17
C360	VPWR#5	SET_B#6	2.52137e-18
C361	a_398_74##3	a_398_74#	4.31846e-19
C362	VPWR#16	VPWR#13	3.69177e-19
C363	a_1356_74##9	SET_B#5	3.48146e-18
C364	VPWR#7	a_1356_74##7	1.00208e-18
C365	a_1356_74##5	VGND#4	2.68128e-17
C366	SET_B#9	a_1356_74##4	1.93554e-17
C367	a_398_74##3	a_225_74##7	4.14788e-17
C368	a_612_74##6	a_225_74##2	7.65729e-19
C369	SET_B#7	VPWR#3	1.14652e-17
C370	VPWR#5	a_1566_92##4	2.62107e-17
C371	a_1566_92#	a_1566_92##5	1.96289e-18
C372	SET_B#6	a_1356_74##13	1.61483e-17
C373	VGND#5	a_612_74##6	6.46167e-17
C374	VGND#7	a_612_74##9	9.31553e-19
C375	a_767_384##5	a_225_74##3	5.80803e-20
C376	a_612_74##8	a_612_74##10	9.05732e-19
C377	CLK	a_225_74##4	9.24784e-19
C378	VGND#2	a_2022_94##4	2.21334e-18
C379	SET_B#2	a_225_74##2	1.67433e-18
C380	a_225_74#	a_1566_92##2	2.09917e-17
C381	a_398_74##12	a_1356_74##11	6.86323e-17
C382	a_2022_94##9	a_1356_74##5	4.66482e-17
C383	VPWR#8	a_398_74##5	7.70528e-19
C384	VPWR#7	SET_B#6	2.64228e-17
C385	VPWR#6	SET_B#6	1.82654e-18
C386	SET_B#2	a_612_74##7	1.61679e-17
C387	a_612_74##9	a_225_74##7	3.92214e-18
C388	a_1566_92#	a_1356_74##10	2.29401e-17
C389	VGND#11	a_2022_94##5	8.64243e-19
C390	a_612_74##2	a_225_74##2	8.58303e-19
C391	a_1356_74##13	a_1566_92##4	1.19163e-18
C392	a_1356_74##13	a_1566_92##3	4.66801e-19
C393	a_1566_92#	a_1356_74##9	3.3653e-18
C394	SET_B#9	SET_B#5	2.34754e-17
C395	a_1566_92##5	a_1356_74#	2.03276e-19
C396	VPWR#3	a_2022_94##3	3.11826e-18
C397	a_2022_94##8	VPWR#2	2.17145e-19
C398	CLK#2	a_225_74##8	1.39546e-18
C399	a_612_74##3	SET_B#2	1.53589e-17
C400	a_27_74##3	D#7	6.01087e-17
C401	VGND#5	a_225_74##2	2.44147e-19
C402	a_1566_92##3	VPWR#7	1.12823e-17
C403	VGND#3	a_2022_94##3	5.17408e-18
C404	VPWR#8	a_1566_92##3	3.34737e-20
C405	a_1356_74##4	VPWR#3	6.06515e-18
C406	a_2022_94##9	a_1356_74##6	3.57157e-18
C407	VPWR#12	a_225_74##3	2.59655e-17
C408	VGND#5	SET_B#2	7.56461e-19
C409	VPWR#13	a_225_74##4	7.85786e-21
C410	a_398_74##6	a_225_74#	1.28741e-17
C411	a_1356_74##13	VPWR#5	2.60615e-17
C412	VGND#2	a_2022_94##5	4.75482e-18
C413	VGND#11	a_1356_74##5	2.66254e-18
C414	VGND#3	a_1356_74##4	5.27242e-18
C415	a_27_74##5	a_27_74#	2.63412e-18
C416	D#6	a_225_74##13	3.30718e-19
C417	a_398_74##8	a_1356_74##10	4.99909e-17
C418	VPWR#6	a_1566_92##3	5.91853e-18
C419	D#1	CLK#3	3.9242e-18
C420	a_398_74##13	VPWR#9	1.89668e-17
C421	a_1356_74##6	a_1566_92##7	1.27421e-17
C422	VPWR#7	a_398_74##7	2.01736e-18
C423	VPWR#3	a_1566_92#	3.10275e-18
C424	a_1566_92#	SET_B#9	7.14339e-17
C425	a_1356_74##11	a_1566_92##3	3.5808e-19
C426	VGND#11	a_398_74##12	5.12367e-18
C427	a_2022_94##9	SET_B#4	1.79139e-19
C428	VPWR#7	VPWR#5	1.65805e-18
C429	VGND#3	a_1566_92#	1.33435e-17
C430	a_767_384##3	a_612_74##3	1.37984e-17
C431	VGND#3	VGND#1	5.40187e-17
C432	VPWR#3	a_398_74##8	4.36359e-18
C433	a_1356_74##9	a_1356_74#	3.73699e-20
C434	VGND#6	a_612_74##2	3.01498e-19
C435	a_1356_74##6	VGND#11	2.12387e-17
C436	D#4	a_225_74##13	4.14421e-17
C437	a_398_74##12	VPWR#9	4.97748e-17
C438	VPWR#8	a_398_74##7	7.89298e-20
C439	a_612_74##4	a_398_74##6	4.09115e-17
C440	VGND#5	a_612_74##2	1.97715e-18
C441	VPWR#13	a_225_74##3	7.58867e-18
C442	VGND#3	a_398_74##8	7.35493e-18
C443	VGND#3	Q#1	1.98315e-17
C444	VPWR#7	a_225_74##2	7.55935e-19
C445	VGND#7	a_225_74##4	1.83207e-19
C446	VGND#2	a_1356_74##5	3.55125e-18
C447	a_398_74##7	a_1356_74##11	1.35675e-17
C448	a_767_384##7	a_398_74##13	6.93541e-17
C449	a_398_74##2	a_767_384##4	2.07915e-17
C450	VGND#3	a_398_74##5	6.5106e-19
C451	VPWR#6	a_398_74##7	5.37095e-18
C452	VPWR#7	a_1356_74##13	2.18724e-17
C453	VGND#3	VGND#4	2.22915e-17
C454	VPWR#9	a_1566_92##3	1.88542e-19
C455	a_1356_74##10	a_1356_74##7	1.28628e-19
C456	SET_B#4	a_1596_118#	1.29642e-17
C457	a_398_74##2	a_225_74##6	5.79034e-18
C458	a_27_74##3	D#6	9.44792e-18
C459	SET_B#7	a_398_74##5	1.31559e-18
C460	a_1566_92##2	a_1596_118#	1.3968e-17
C461	VGND#3	a_2022_94##9	1.76515e-17
C462	a_398_74##3	a_767_384##4	3.51879e-18
C463	VGND#11	SET_B#4	4.25899e-17
C464	SET_B#5	a_1356_74##4	2.95324e-17
C465	Q	a_2022_94##2	1.59513e-17
C466	D#4	VGND#15	2.97649e-17
C467	a_2022_94##3	a_2022_94##2	3.56897e-18
C468	a_1356_74##9	a_1356_74##7	6.26238e-19
C469	a_398_74##13	a_225_74##4	1.00902e-19
C470	a_1356_74##11	a_225_74##2	6.85868e-17
C471	Q	a_1356_74##2	6.06726e-19
C472	a_612_74##6	SET_B#7	4.13536e-17
C473	a_767_384##7	a_398_74##12	3.88864e-17
C474	a_27_74##4	D#6	4.21982e-18
C475	VGND#6	a_767_384##2	6.71763e-19
C476	VPWR#9	a_398_74##7	1.35667e-19
C477	SET_B#1	a_612_74##4	8.5896e-18
C478	a_1566_92#	a_1356_74##4	2.52263e-19
C479	VPWR#8	a_225_74##2	4.26497e-17
C480	a_398_74##13	VPWR#11	1.22958e-16
C481	a_1566_92#	SET_B#5	5.67721e-17
C482	VGND#3	VGND#11	2.1781e-16
C483	a_398_74##8	a_1356_74##4	4.72506e-19
C484	a_398_74##13	a_398_74##12	2.63161e-18
C485	a_1356_74##2	a_2022_94##3	2.17381e-17
C486	VPWR#8	a_612_74##2	4.45072e-19
C487	VPWR#6	a_225_74##2	3.1182e-19
C488	a_1356_74##10	SET_B#6	1.79446e-18
C489	a_1356_74##11	a_612_74##7	1.28801e-18
C490	a_398_74##12	a_398_74##8	2.22746e-18
C491	a_1566_92##3	a_1521_508#	8.30228e-18
C492	a_398_74##8	SET_B#5	9.79404e-20
C493	VPWR#10	a_225_74##3	3.05625e-17
C494	VGND#11	a_1566_92##2	1.01489e-17
C495	a_225_74##5	a_225_74##9	7.73984e-18
C496	VPWR#9	a_225_74##2	2.05527e-17
C497	a_27_74##4	D#4	3.69701e-17
C498	a_1566_92##2	a_1489_118#	2.78082e-18
C499	a_398_74##7	a_1521_508#	8.10422e-18
C500	VPWR#2	a_2022_94##2	4.5102e-20
C501	a_225_74#	a_1489_118#	5.26592e-18
C502	a_398_74##8	a_1566_92#	1.19601e-16
C503	CLK#1	a_225_74##5	2.17201e-18
C504	a_398_74##13	a_225_74##3	3.67688e-17
C505	a_1356_74##9	SET_B#6	1.72694e-17
C506	a_1356_74##10	VPWR#8	1.47368e-17
C507	a_612_74#	SET_B#1	3.72284e-17
C508	a_767_384#	a_612_74##4	1.67121e-19
C509	a_767_384##7	a_225_74##2	1.84906e-18
C510	VGND#6	a_767_384##3	1.9663e-19
C511	VPWR#8	a_612_74##7	3.72588e-18
C512	VGND#3	a_1356_74##14	1.14431e-17
C513	a_225_74##2	a_1266_341#	1.09167e-17
C514	VPWR#10	a_767_384##2	7.45261e-20
C515	a_612_74##7	VPWR#9	1.58781e-17
C516	VGND#11	a_225_74#	2.68389e-18
C517	VGND#2	VGND#1	8.74392e-19
C518	a_612_74##7	a_1266_341#	1.48081e-17
C519	VPWR	a_225_74##3	2.44252e-17
C520	a_1356_74##10	a_1566_92##3	3.18111e-17
C521	D#1	CLK#1	6.5815e-18
C522	a_398_74##12	a_398_74##5	2.04746e-17
C523	VPWR#12	a_398_74##2	1.31951e-19
C524	a_398_74##12	a_1356_74##14	1.20511e-16
C525	a_767_384##7	a_612_74##7	7.87031e-20
C526	VGND#7	a_398_74##2	1.12634e-19
C527	a_612_74##6	a_398_74##5	2.37741e-17
C528	VPWR#12	a_398_74##3	4.27349e-19
C529	VGND#6	a_767_384##4	1.18799e-19
C530	SET_B#3	VPWR#9	1.44133e-17
C531	a_1356_74##4	a_1356_74##2	1.29316e-18
C532	a_1356_74##10	VPWR#6	2.56032e-17
C533	a_398_74##6	a_1278_74#	1.13155e-17
C534	a_767_384#	a_612_74#	2.39452e-18
C535	SET_B#7	a_1356_74##14	2.58195e-18
C536	VPWR#11	a_612_74##7	6.46318e-20
C537	VGND#7	a_398_74##3	3.82317e-19
C538	VPWR#8	a_225_74##3	3.04162e-18
C539	a_225_74##13	a_225_74##11	2.78462e-18
C540	a_1356_74##14	a_1566_92##2	9.36003e-19
C541	a_27_74##5	a_225_74##4	2.68825e-17
C542	VGND#11	a_398_74##6	8.46046e-19
C543	VGND#1	VPWR#1	1.03343e-17
C544	a_767_384##4	a_716_456#	8.2607e-18
C545	VPWR#8	SET_B#3	6.60794e-19
C546	a_612_74##8	a_398_74##13	1.0019e-16
C547	a_612_74##6	SET_B#2	3.63248e-17
C548	a_767_384##7	SET_B#3	9.50489e-18
C549	VPWR#10	a_767_384##3	7.02633e-19
C550	Q#1	a_2022_94##3	1.91553e-17
C551	a_612_74##6	a_398_74##12	5.49188e-17
C552	VGND#2	Q#1	1.71591e-17
C553	a_1356_74##10	a_398_74##7	2.93888e-17
C554	a_767_384##2	a_398_74##5	1.63686e-19
C555	SET_B#1	a_1057_118#	9.87534e-18
C556	a_2022_94##3	VGND#4	4.15452e-17
C557	a_612_74##2	SET_B#2	5.08854e-17
C558	a_767_384##2	a_612_74##6	6.87728e-20
C559	a_612_74#	a_1057_118#	9.87534e-18
C560	a_767_384##7	a_612_74##3	2.72783e-17
C561	a_1566_92##5	a_2022_94##8	4.14313e-17
C562	a_1356_74##14	a_225_74#	4.55084e-17
C563	VPWR#2	a_1356_74##2	1.44001e-19
C564	a_398_74#	a_767_384#	5.17432e-17
C565	VPWR#10	a_612_74##3	6.12892e-19
C566	a_2022_94##9	a_2022_94##3	4.96554e-20
C567	Q	VPWR#2	1.75212e-19
C568	a_1356_74##9	VPWR#6	6.31428e-19
C569	a_2022_94##8	Q	7.78927e-19
C570	a_767_384##7	a_225_74##3	3.02586e-19
C571	a_612_74##2	a_767_384##2	6.83946e-17
C572	VGND#5	a_225_74#	1.38599e-18
C573	SET_B#2	a_398_74##13	1.0112e-18
C574	a_612_74##3	VPWR#11	3.51653e-18
C575	VPWR#8	a_612_74##3	4.8515e-19
C576	a_612_74##2	a_767_384##3	8.28269e-17
C577	a_398_74##2	SET_B#2	2.80451e-19
C578	SET_B#2	a_398_74##12	3.50433e-17
C579	SET_B#7	a_1266_341#	1.06482e-18
C580	a_767_384##7	a_767_384##4	3.80843e-19
C581	a_1356_74##10	a_225_74##2	1.93652e-17
C582	VGND#6	VGND#5	5.64475e-19
C583	a_767_384##2	a_767_384##3	9.23747e-19
C584	a_612_74##2	a_398_74##2	1.02654e-18
C585	a_398_74##10	a_225_74##4	5.93548e-18
C586	VGND#13	a_767_384##5	1.71071e-17
C587	a_398_74##6	a_1356_74##14	1.50889e-17
C588	Q#1	a_2022_94##2	7.90266e-18
C589	a_398_74##2	a_767_384##2	8.92706e-18
C590	a_767_384#	a_781_74#	9.87534e-18
C591	a_2022_94##8	a_2022_94##2	1.04333e-19
C592	a_767_384##4	VPWR#11	1.84745e-17
C593	a_225_74##7	a_398_74#	8.21745e-18
C594	VPWR	VPWR#13	1.02573e-16
C595	CLK	a_27_74##5	3.55291e-18
C596	a_398_74#	a_781_74#	9.87534e-18
C597	VPWR	VPWR#10	8.99885e-17
C598	VPWR	VPWR#8	1.01396e-16
C599	a_398_74##2	a_767_384##3	2.38743e-17
C600	VGND#14	CLK	1.79883e-17
C601	VPWR#2	VPWR#1	9.86498e-19
C602	VPWR#10	a_767_384##4	2.43491e-18
C603	a_2022_94##8	a_1356_74##5	1.24422e-17
C604	a_612_74##2	a_398_74##13	1.3812e-18
C605	a_398_74##14	a_398_74##13	1.00885e-18
C606	a_612_74##9	a_398_74##13	5.71325e-18
C607	a_398_74##3	a_767_384##3	1.48304e-18
C608	VGND#8	a_225_74##5	9.28537e-19
C609	VGND#5	a_398_74##6	7.31039e-18
C610	VGND#11	a_1356_74##4	1.93789e-18
C611	a_398_74##12	a_612_74##2	4.79034e-19
C612	a_398_74##3	a_398_74##2	4.6742e-19
C613	VGND	a_225_74##4	4.1207e-18
C614	VPWR#11	a_225_74##6	1.85243e-18
C615	a_1356_74##14	a_612_74##4	2.0556e-18
C616	a_1356_74##10	a_612_74##7	3.29144e-18
C617	a_612_74##8	a_767_384##4	1.81553e-18
C618	VPWR#11	a_225_74##3	1.88201e-17
C619	VPWR	a_398_74##13	6.56247e-17
C620	Q#1	Q	3.07101e-18
C621	VPWR	a_398_74##12	9.84327e-18
C622	VPWR#3	VPWR#1	5.46606e-17
C623	VGND#2	a_2022_94##9	1.47656e-17
C624	a_225_74##8	a_225_74##7	2.88809e-18
C625	VPWR	a_612_74##9	1.95548e-18
C626	VGND#5	a_398_74##12	1.35936e-16
C627	VPWR#3	Q#2	1.83744e-17
C628	VPWR	a_27_74##3	1.09077e-17
C629	VPWR	a_27_74##2	6.78465e-18
C630	a_2022_94##8	a_1356_74##6	2.56005e-19
C631	Q#2	VPWR#2	1.64439e-17
C632	VGND#11	SET_B#5	1.12082e-18
C633	a_398_74##13	a_767_384##2	3.60558e-19
C634	a_612_74##8	a_225_74##6	3.18737e-17
C635	CLK#2	a_225_74##5	3.98884e-17
C636	a_612_74##10	a_767_384##5	2.54155e-18
C637	a_612_74##9	a_612_74##2	3.0267e-18
C638	a_398_74##14	a_767_384##4	3.88366e-20
C639	VPWR	D#7	4.23002e-18
C640	VPWR#3	VPWR#4	2.17082e-17
C641	a_767_384##2	a_398_74##12	2.44773e-18
C642	CLK	a_225_74##11	1.06127e-17
C643	a_225_74##5	D#1	1.90557e-19
C644	VGND#3	VPWR#1	4.93889e-18
C645	VGND#5	a_612_74##4	3.60447e-17
C646	VGND#8	CLK#2	7.45638e-19
C647	VPWR#13	a_225_74##5	7.97012e-20
C648	a_767_384##5	a_398_74##12	1.39671e-18
C649	a_612_74##4	VGND#12	1.86201e-17
C650	SET_B#7	a_1278_74#	1.42889e-19
C651	a_27_74#	a_225_74##6	6.7314e-19
C652	VGND#7	a_612_74##10	1.55411e-17
C653	D#1	CLK#2	1.16207e-17
C654	a_1356_74##10	SET_B#3	7.64346e-19
C655	Q	VPWR#1	4.18206e-17
C656	VPWR#3	a_2022_94##10	1.85275e-17
C657	a_1566_92##5	a_1356_74##5	1.38251e-18
C658	Q	Q#2	7.08424e-19
C659	a_767_384##5	a_398_74##6	1.80489e-19
C660	CLK#3	a_225_74##8	3.87542e-17
C661	Q	VPWR#4	3.06297e-17
C662	a_612_74##8	a_398_74##4	1.04384e-17
C663	a_398_74##8	a_1489_118#	1.24246e-17
C664	a_2022_94##10	Q	2.54746e-17
C665	a_398_74##14	a_225_74##6	1.87264e-19
C666	D#4	CLK#3	3.11999e-19
C667	a_2022_94##2	VNB	3.8815e-17
C668	VGND#11	a_1566_92#	2.8619e-17
C669	a_612_74##10	VGND#13	1.09238e-17
C670	a_1356_74##2	VNB	3.15674e-17
C671	VGND	VGND#8	9.50971e-17
C672	a_1566_92##4	VPWR#3	3.41448e-17
C673	a_225_74##4	VNB	8.25417e-17
C674	a_2022_94##8	a_1356_74##2	2.90542e-17
C675	VGND	VGND#6	8.21626e-17
C676	a_225_74##3	VNB	1.8816e-16
C677	VGND	VGND#5	1.27901e-16
C678	VGND#7	a_398_74##10	4.47997e-17
C679	a_27_74#	a_398_74##4	2.23321e-17
C680	a_398_74##13	a_767_384##3	8.06368e-17
C681	a_612_74##9	a_767_384##2	3.28159e-17
C682	SET_B#1	VGND#12	1.23297e-17
C683	VPWR#3	VPWR#5	1.62738e-17
C684	VPWR#11	VPWR#9	1.61367e-20
C685	a_398_74##12	a_767_384##3	3.3079e-19
C686	CLK	a_225_74##8	2.33222e-18
C687	a_767_384##5	a_612_74##4	3.4537e-19
C688	a_398_74##14	a_398_74##4	6.33117e-18
C689	VPWR#13	CLK#2	2.30914e-19
C690	VGND#5	SET_B#1	2.83183e-17
C691	a_1356_74##13	VPWR#3	2.12045e-17
C692	a_398_74##13	a_225_74##2	1.07946e-17
C693	D#2	CLK#3	3.17725e-18
C694	VGND	a_398_74##12	1.31763e-17
C695	a_225_74##13	a_225_74##4	1.72608e-19
C696	a_612_74##3	a_225_74##3	1.59408e-17
C697	a_1566_92##5	a_1356_74##6	4.34611e-17
C698	a_1356_74##14	a_1566_92#	4.4519e-19
C699	a_27_74#	a_225_74##9	1.4882e-18
C700	VGND	a_612_74##9	1.09553e-17
C701	VGND#11	a_398_74##8	3.73204e-17
C702	VPWR	a_767_384##7	7.15973e-18
C703	VPWR	VPWR#11	9.41781e-18
C704	a_2022_94##9	a_2022_94##2	1.64082e-20
C705	VPWR#3	VPWR#7	1.02671e-17
C706	VPWR	a_612_74##8	1.05431e-17
C707	VGND#13	a_612_74##4	7.73388e-19
C708	VPWR	a_27_74#	1.08842e-17
C709	VPWR#13	a_225_74##9	3.70366e-18
C710	VGND#11	VGND#2	3.83529e-19
C711	VPWR	a_398_74##14	3.26742e-17
C712	a_398_74##12	a_225_74##2	2.88985e-17
C713	a_225_74##9	a_398_74##14	2.56463e-17
C714	a_612_74##8	a_225_74##4	3.33561e-19
C715	VGND#8	VNB	4.41663e-17
C716	VPWR	a_225_74##11	5.61674e-18
C717	a_398_74##13	a_398_74##2	1.16769e-19
C718	VGND#6	VNB	4.23022e-17
C719	VGND#5	VNB	7.9131e-17
C720	VGND	D#4	4.51453e-18
C721	VGND#2	VNB	4.48729e-17
C722	VPWR	a_27_74##6	1.66012e-17
C723	a_612_74##9	a_767_384##3	1.22566e-17
C724	VPWR#13	VNB	4.36074e-17
C725	a_767_384##5	SET_B#1	4.19077e-18
C726	VPWR#10	VNB	3.24487e-17
C727	VPWR#8	VNB	5.40782e-17
C728	a_2022_94##10	VPWR#2	1.25252e-17
C729	VPWR#6	VNB	5.15755e-17
C730	VPWR#2	VNB	4.40813e-17
C731	a_27_74#	CLK#1	2.46383e-19
C732	a_2022_94##8	VNB	2.99715e-19
C733	a_1566_92##5	VNB	2.79926e-17
C734	VPWR#14	a_225_74##9	3.99557e-17
C735	a_612_74##9	a_225_74##4	1.48522e-19
C736	a_1356_74##10	VNB	6.92098e-18
C737	a_1356_74##9	VNB	1.24505e-17
C738	a_398_74##10	VGND#13	2.61641e-18
C739	VGND	a_767_384##5	1.19891e-17
C740	Q	a_2022_94#	1.16211e-17
C741	a_1356_74##14	a_398_74##8	7.79555e-17
C742	VGND	VGND#13	1.8211e-17
C743	VPWR#3	a_1356_74##11	1.51736e-18
C744	SET_B#9	VNB	1.08107e-18
C745	Q	a_2022_94##6	2.0063e-17
C746	VGND	a_612_74##10	1.65007e-17
C747	VGND	a_27_74##5	8.58656e-18
C748	Q	a_1356_74#	7.90329e-18
C749	a_398_74##13	VNB	3.0567e-17
C750	a_398_74##12	VNB	1.5368e-17
C751	VGND	a_398_74##10	4.24354e-17
C752	a_398_74##13	a_612_74##7	1.12868e-19
C753	a_398_74##14	CLK#1	1.55311e-18
C754	VPWR	a_767_384#	2.48693e-19
C755	VGND	a_225_74##13	2.26709e-17
C756	a_612_74##8	a_225_74##3	8.4873e-19
C757	a_612_74##9	VNB	1.27753e-17
C758	VGND#5	a_612_74#	9.48201e-18
C759	VGND	a_27_74##4	1.56947e-17
C760	VGND#13	SET_B#1	3.49263e-19
C761	a_225_74##11	a_225_74##9	7.98959e-19
C762	a_612_74##7	a_225_74#	4.31754e-19
C763	a_1566_92##5	SET_B#4	1.1228e-18
C764	a_27_74##3	VNB	6.00043e-17
C765	D#7	VNB	3.99725e-18
C766	D#6	VNB	5.24283e-19
C767	VPWR#14	CLK#1	3.6275e-17
C768	D#4	VNB	1.24332e-18
C769	a_398_74##12	a_612_74##7	4.27851e-17
C770	a_767_384##5	a_612_74#	3.45696e-17
C771	VGND#1	VNB	6.87461e-17
C772	Q#1	VNB	7.33152e-18
C773	VGND#4	VNB	9.35045e-18
C774	VGND	a_767_384##7	1.69982e-18
C775	a_2022_94##9	VNB	1.01577e-17
C776	a_398_74##13	a_398_74##3	5.05485e-19
C777	VPWR#13	CLK#1	3.66843e-18
C778	VGND#11	VNB	1.05396e-16
C779	a_612_74##9	a_398_74##2	1.16873e-16
C780	VGND#3	a_1356_74##11	3.26523e-18
C781	a_1356_74##14	VNB	1.27828e-18
C782	VPWR	a_225_74##2	7.17546e-18
C783	a_767_384##4	a_225_74##3	1.63246e-17
C784	a_398_74##14	D#3	9.90512e-19
C785	a_767_384##5	VNB	6.68451e-18
C786	VGND	a_225_74##11	2.31809e-18
C787	VPWR	a_612_74##7	3.0237e-18
C788	VGND#13	VNB	5.49481e-18
C789	VPWR	SET_B#3	9.4041e-19
C790	a_1356_74##14	a_398_74##5	7.69399e-18
C791	a_612_74##10	VNB	1.86239e-18
C792	a_225_74##11	CLK#1	3.11351e-17
C793	a_27_74##5	VNB	6.62839e-18
C794	a_398_74##10	VNB	1.04902e-17
C795	VGND#6	a_767_384#	5.30796e-18
C796	VGND#14	VNB	4.16079e-19
C797	VPWR	a_767_384##4	3.89619e-18
C798	VPWR#3	Q	2.6375e-18
C799	a_612_74##9	a_225_74##3	3.29915e-19
C800	a_225_74##13	VNB	1.77864e-17
C801	VGND#15	VNB	2.71725e-18
C802	VGND#3	Q	3.60508e-18
C803	a_27_74##4	VNB	4.79206e-17
C804	a_27_74##6	a_225_74##9	3.65752e-20
C805	VPWR#1	VNB	7.96317e-17
C806	VGND#6	a_612_74##9	3.06189e-18
C807	Q#2	VNB	2.65392e-18
C808	VPWR#4	VNB	1.69514e-18
C809	VPWR	a_225_74##9	3.37269e-18
C810	VGND#13	a_612_74#	2.5351e-18
C811	a_2022_94##10	VNB	1.34385e-17
C812	VGND	a_398_74##6	9.96699e-20
C813	a_1566_92##4	VNB	1.97111e-17
C814	VPWR	CLK#1	4.97433e-18
C815	VGND	a_612_74##4	5.2273e-18
C816	VPWR#5	VNB	3.94574e-18
C817	VPWR#14	D#3	3.74874e-18
C818	a_1356_74##13	VNB	6.09878e-18
C819	VGND	SET_B#1	4.50258e-18
C820	VPWR	D#3	2.0336e-18
C821	VPWR#7	VNB	2.75201e-18
C822	VGND	a_612_74#	1.03592e-17
C823	a_398_74##13	SET_B#3	3.32402e-18
C824	a_27_74#	a_225_74##4	1.65549e-17
C825	a_2022_94##3	Q	6.69031e-17
C826	VGND	a_767_384#	1.62273e-18
C827	a_1356_74##11	VNB	3.10556e-18
C828	a_398_74##13	VPWR#10	2.58805e-17
C829	VGND	a_398_74#	1.42003e-18
C830	VPWR#16	CLK#1	6.83115e-18
C831	VPWR#9	VNB	3.36947e-18
C832	VGND	a_225_74##7	1.09408e-18
C833	VGND	a_225_74##8	3.04708e-18
C834	VPWR#11	VNB	5.41111e-18
C835	VGND	CLK#3	1.37144e-18
C836	a_612_74##8	VNB	5.64192e-18
C837	VGND	D#2	2.82843e-18
C838	a_27_74#	VNB	1.58602e-18
C839	SET_B#7	VPWR	2.38012e-17
C840	a_767_384##5	a_767_384#	2.10203e-18
C841	a_2022_94##3	VPWR#4	3.07116e-18
C842	a_398_74##14	VNB	1.17405e-17
C843	SET_B#7	a_1356_74##11	3.88805e-17
C844	VPWR#14	VNB	3.26713e-19
C845	VPWR	VPWR#12	6.96283e-17
C846	a_1566_92##5	a_1566_92##2	2.66002e-19
C847	a_225_74##11	VNB	8.58185e-18
C848	CLK	a_225_74##5	4.60162e-17
C849	a_27_74##2	a_612_74##8	5.94848e-18
C850	VGND#5	a_767_384#	1.07723e-18
C851	VPWR#16	VNB	6.52887e-18
C852	a_27_74##6	VNB	2.40398e-17
C853	a_2022_94##4	VNB	3.61316e-17
C854	CLK	CLK#2	5.71581e-18
C855	a_2022_94##5	VNB	3.07307e-17
C856	a_1356_74##5	VNB	4.68043e-17
C857	a_398_74##10	a_612_74##10	2.22474e-17
C858	a_1356_74##6	VNB	4.35608e-17
C859	SET_B#4	VNB	3.19427e-17
C860	a_398_74##12	SET_B#3	1.94564e-17
C861	a_1566_92##2	VNB	3.45571e-17
C862	a_27_74##6	CLK#1	3.14669e-20
C863	a_225_74#	VNB	5.52397e-17
C864	a_398_74##6	VNB	2.98945e-17
C865	VGND#8	a_398_74#	4.27227e-20
C866	a_612_74##4	VNB	2.56135e-17
C867	SET_B#1	VNB	3.33963e-17
C868	a_612_74#	VNB	2.7709e-17
C869	a_612_74##9	a_398_74##3	8.94598e-17
C870	a_1356_74##14	a_612_74##6	5.27744e-19
C871	a_767_384#	VNB	3.25298e-17
C872	a_398_74#	VNB	2.96598e-17
C873	VPWR	a_612_74##6	2.44251e-18
C874	a_225_74##7	VNB	4.76979e-17
C875	a_225_74##8	VNB	2.87037e-17
C876	VPWR	SET_B#2	2.82994e-18
C877	a_1566_92##5	a_1356_74##9	5.3485e-18
C878	CLK#3	VNB	3.43595e-17
C879	a_27_74#	a_225_74##3	1.41885e-18
C880	D#2	VNB	3.00966e-17
C881	VPWR	a_612_74##2	5.64889e-18
C882	VPWR#13	D#3	5.16015e-19
C883	VPWR#16	D#3	3.00569e-17
C884	a_2022_94#	VNB	4.15867e-17
C885	VGND#13	a_767_384#	3.27478e-17
C886	a_2022_94##6	VNB	3.12224e-17
C887	a_1356_74#	VNB	4.01472e-17
C888	VPWR	a_767_384##3	5.29782e-18
C889	a_2022_94##6	a_2022_94#	4.7465e-17
C890	a_1356_74##7	VNB	3.08382e-17
C891	SET_B#6	VNB	3.09436e-17
C892	VPWR	a_398_74##2	1.8646e-19
C893	a_1566_92##3	VNB	3.57791e-17
C894	a_398_74##7	VNB	2.16445e-17
C895	VGND	SET_B#7	2.29722e-18
C896	VPWR	a_398_74##3	6.46801e-18
C897	a_225_74##2	VNB	1.47157e-16
C898	SET_B#7	VPWR#9	5.65995e-18
C899	a_612_74##7	VNB	3.04973e-17
C900	VPWR	a_225_74##5	3.85067e-18
C901	VGND	VGND#7	7.15585e-17
C902	SET_B#3	VNB	2.37702e-17
C903	a_612_74##3	VNB	3.56494e-17
C904	VPWR	CLK#2	1.67712e-18
C905	a_767_384##4	VNB	4.01944e-17
C906	a_612_74##10	a_612_74#	2.30751e-19
C907	VGND#13	a_612_74##9	4.1488e-19
C908	a_225_74##6	VNB	2.72472e-17
C909	a_398_74##4	VNB	3.14816e-17
C910	VGND#6	a_398_74#	3.46973e-18
C911	a_225_74##9	VNB	3.28264e-17
C912	a_767_384##5	a_398_74#	1.06451e-18
C913	CLK#1	VNB	4.37081e-17
C914	a_27_74##6	D#3	1.217e-17
C915	D#3	VNB	4.61034e-17
C916	a_612_74##6	VGND#12	4.19101e-18
C917	VGND	a_398_74##5	1.50571e-19
C918	a_398_74##13	a_612_74##3	1.41881e-17
C919	VGND	a_612_74##6	4.2614e-18
C920	VPWR#3	VNB	2.84657e-16
C921	VGND	SET_B#2	2.57966e-18
C922	a_398_74##13	VPWR#8	4.06628e-17
C923	VGND#3	VNB	2.59518e-16
C924	VGND	a_612_74##2	1.2002e-17
C925	SET_B#7	VNB	3.70163e-18
C926	a_398_74##10	a_27_74##5	7.42364e-17
C927	VPWR#12	VNB	2.96407e-17
C928	VGND	a_767_384##2	2.84784e-18
C929	SET_B#7	a_767_384##7	4.4784e-18
C930	VGND#7	VNB	4.07443e-17
C931	VGND	a_767_384##3	4.58323e-18
C932	a_2022_94##3	VNB	4.25286e-17
C933	VGND	a_398_74##2	3.96236e-18
C934	a_2022_94##10	a_1356_74##4	1.29187e-18
C935	a_1356_74##4	VNB	1.17685e-16
C936	a_225_74##3	a_225_74##6	9.47163e-19
C937	a_27_74##2	a_27_74#	4.0328e-18
C938	SET_B#5	VNB	7.03048e-17
C939	VGND	a_398_74##3	5.26067e-18
C940	a_1566_92#	VNB	5.69473e-17
C941	VGND	a_225_74##5	6.87642e-18
C942	a_398_74##8	VNB	5.24558e-17
C943	VGND	CLK#2	3.67485e-18
C944	a_398_74##5	VNB	1.82369e-17
C945	a_612_74##6	VNB	5.03214e-17
C946	VGND	D#1	8.72319e-19
C947	SET_B#2	VNB	5.62403e-17
C948	a_1566_92##5	a_225_74#	2.27596e-19
C949	a_1356_74##13	VPWR#6	7.96356e-18
C950	a_612_74##2	VNB	6.53809e-17
C951	a_767_384##2	VNB	4.15903e-17
C952	a_767_384##3	VNB	5.11744e-17
C953	a_398_74##2	VNB	6.24348e-17
C954	a_398_74##3	VNB	5.47947e-17
C955	a_398_74##12	a_612_74##3	2.46931e-18
C956	a_225_74##5	VNB	3.71902e-17
C957	CLK#2	VNB	3.5912e-17
C958	a_1356_74##4	a_1566_92##4	5.74579e-17
C959	VGND#13	a_398_74#	6.17559e-18
C960	D#1	VNB	1.02434e-16
C961	a_2022_94##8	Q#1	2.94033e-19
C962	a_27_74##3	a_398_74##14	1.07059e-21
C963	a_398_74##14	a_225_74##4	5.74567e-18
C964	a_1356_74#	a_2022_94##6	3.16166e-17
C965	VGND#8	a_225_74##7	3.51569e-19
C966	VPWR	CLK	1.45115e-18
C967	a_612_74##10	a_767_384#	1.99408e-18
C968	a_1356_74##4	VPWR#5	3.62867e-17
C969	a_27_74##2	a_398_74##3	5.86645e-17
C970	a_767_384##5	a_225_74##7	3.5252e-19
C971	VGND	CLK	1.42571e-18
C972	Q	VNB	1.12463e-17
C973	VPWR	VNB	2.81482e-16
C974	VGND	VNB	3.14159e-16
C975	SET_B	a_398_74##12	1.54684e-18
C976	VGND#9	a_27_74##4	1.49729e-17
C977	SET_B	a_1356_74##9	5.09597e-17
C978	VGND#9	a_225_74##8	2.15575e-19
C979	SET_B	a_1356_74##11	6.89894e-18
C980	a_398_74##8	SET_B	4.62364e-17
C981	VGND#9	VNB	5.23843e-17
C982	SET_B	a_1356_74##10	1.65369e-17
C983	a_27_74##6	VPWR#15	1.76169e-17
C984	a_1566_92#	SET_B	5.64878e-17
C985	VGND#9	VGND#14	8.83349e-19
C986	SET_B	VPWR#6	3.94206e-18
C987	VPWR#3	SET_B	3.75622e-17
C988	VPWR#15	VPWR#13	1.34865e-18
C989	VGND#9	CLK#3	1.12127e-18
C990	VPWR#15	D#3	5.29625e-18
C991	SET_B	VPWR#7	3.74453e-18
C992	SET_B	VNB	1.2686e-17
C993	VPWR	VPWR#15	1.03226e-16
C994	SET_B	SET_B#5	1.07213e-17
C995	SET_B	a_1566_92##5	3.3502e-19
C996	SET_B	SET_B#9	1.99712e-17
C997	SET_B	a_1356_74##4	1.82532e-17
C998	VPWR#15	a_225_74##3	5.11327e-20
C999	VGND#9	a_225_74##13	1.2449e-17
C1000	SET_B	VGND#11	9.96287e-19
C1001	VGND#9	D#2	8.42255e-18
C1002	SET_B	a_1356_74#	2.76743e-21
C1003	SET_B	a_1566_92##2	1.27021e-18
C1004	VPWR#15	VNB	4.99906e-17
C1005	SET_B	a_1566_92##4	8.71052e-19
C1006	a_27_74##3	VPWR#15	3.36789e-18
C1007	SET_B	a_2022_94##10	1.97951e-18
C1008	VGND	VGND#9	9.68816e-17
C1009	SET_B	a_225_74##2	2.84033e-18
C1010	VGND#9	VGND#8	9.87704e-19
*
*
.ENDS sky130_fd_sc_hs__dfstp_2
*
