* Extracted by Quantus, converted by sky130cad/quantus.py
*
*
*
*                       LINUX           Wed Nov 18 08:15:02 2026
*
*
*
*  PROGRAM  advgen
*
*  Name           : advgen - Quantus - (64-bit)
*  Version        : 25.1.0-p047
*  Build Date     : Thu Dec 11 23:20:30 PST 2025
*
*  HSPICE LIBRARY
*
*  OPERATING_TEMPERATURE 150
*  QRC_TECH_DIR <path>/tech
*
*
*

*
.SUBCKT sky130_fd_sc_hs__a41o_2 VPB VNB VGND VPWR X A3 A2 A4 A1 B1
*
*
*  caps2d version: 10
*
*
*       TRANSISTOR CARDS
*
*
XM7 VGND#4 A4#1 a_121_74# VNB sky130_fd_pr__nfet_01v8_lvt l=0.15 w=0.74 ad=0.2109 as=0.1776 pd=2.05 ps=1.96
XM0 a_121_74# A3#3 a_199_74# VNB sky130_fd_pr__nfet_01v8_lvt l=0.15 w=0.74 ad=0.1776 as=0.3108 pd=1.96 ps=2.32
XM9 a_199_74# A2#3 a_313_74# VNB sky130_fd_pr__nfet_01v8_lvt l=0.15 w=0.74 ad=0.3108 as=0.3626 pd=2.32 ps=2.46
XM1 a_313_74# A1#3 a_441_74##7 VNB sky130_fd_pr__nfet_01v8_lvt l=0.15 w=0.74 ad=0.3626 as=0.2886 pd=2.46 ps=2.26
XM13 a_441_74##7 B1#3 VGND#5 VNB sky130_fd_pr__nfet_01v8_lvt l=0.15 w=0.74 ad=0.2886 as=0.3182 pd=2.26 ps=2.34
XM4 VGND#5 a_441_74##4 X#2 VNB sky130_fd_pr__nfet_01v8_lvt l=0.15 w=0.74 ad=0.3182 as=0.3034 pd=2.34 ps=2.3
XM11 X#2 a_441_74##5 VGND#1 VNB sky130_fd_pr__nfet_01v8_lvt l=0.15 w=0.74 ad=0.3034 as=0.5772 pd=2.3 ps=3.04
XM6 a_27_392##3 A4#4 VPWR#9 VPB sky130_fd_pr__pfet_01v8 l=0.15 w=1 ad=0.295 as=0.4 pd=2.59 ps=2.8
XM5 VPWR#9 A3#1 a_27_392##4 VPB sky130_fd_pr__pfet_01v8 l=0.15 w=1 ad=0.4 as=0.3 pd=2.8 ps=2.6
XM12 a_27_392##4 A2#1 VPWR#8 VPB sky130_fd_pr__pfet_01v8 l=0.15 w=1 ad=0.3 as=0.58 pd=2.6 ps=3.16
XM8 VPWR#8 A1#1 a_27_392# VPB sky130_fd_pr__pfet_01v8 l=0.15 w=1 ad=0.58 as=0.3 pd=3.16 ps=2.6
XM2 a_27_392# B1#1 a_441_74##9 VPB sky130_fd_pr__pfet_01v8 l=0.15 w=1 ad=0.3 as=0.345 pd=2.6 ps=2.69
XM3 VPWR#7 a_441_74##6 X#1 VPB sky130_fd_pr__pfet_01v8 l=0.15 w=1.12 ad=0.3864 as=0.336 pd=2.93 ps=2.84
XM10 X#1 a_441_74# VPWR#1 VPB sky130_fd_pr__pfet_01v8 l=0.15 w=1.12 ad=0.336 as=0.3864 pd=2.84 ps=2.93
*
*
*       RESISTOR AND CAP/DIODE CARDS
*
Rg1	A4#1	A4#2	322.141815
Rg2	A4#2	A4#3	24.690777
Rg3	A4#2	A4#4	524.422424
Rg4	A3#1	A3#2	509.830780
Rg5	A3#2	A3#3	307.937683
Rg6	A2#1	A2#2	503.220673
Rg7	A2#2	A2#3	301.327576
Rg8	A1#1	A1#2	421.194458
Rg9	A1#2	A1#3	491.066467
Rg10	B1#1	B1#2	409.090576
Rg11	B1#2	B1#3	439.925934
Rg12	a_441_74#	a_441_74##2	559.483337
Rg13	a_441_74##2	a_441_74##3	51.522579
Rg14	a_441_74##3	a_441_74##4	356.179077
Rg15	a_441_74##2	a_441_74##5	319.959229
Rg16	a_441_74##2	a_441_74##6	504.081116
Rf1	A4	A4#5	0.882458
Rf2	A4#6	A4#3	161.115265
Rf3	A4#5	A4#6	3.543054
Rf4	A3#4	A3	1.151501
Rf5	A3#5	A3	1.151501
Rf6	A3#4	A3#5	10.378571
Rf7	A3#6	A3	1.151501
Rf8	A3#5	A3#6	10.378571
Rf9	A3#2	A3#8	161.384308
Rf10	A3#6	A3#8	2.524517
Rf11	A2	A2#2	163.775864
Rf12	A1#2	A1	162.201172
Rf13	a_27_392#	a_27_392##2	93.164307
Rf14	a_27_392##2	a_27_392##3	99.351166
Rf15	a_27_392##2	a_27_392##4	21.715120
Rf16	B1#4	B1	0.818971
Rf17	B1#2	B1#6	161.051773
Rf18	B1#4	B1#6	4.724072
Rf19	a_441_74##7	a_441_74##8	84.065117
Rf20	a_441_74##8	a_441_74##9	56.783592
Rf21	X#1	X#3	137.171158
Rf22	X#3	X	4.724072
Rf23	X#2	X#3	7.500000
Rf24	VPWR#1	VPWR#2	107.655571
Rf25	VPWR#2	VPWR#3	81.792023
Rf26	VPWR#3	VPWR#4	38.655746
Rf27	VPWR#4	VPWR#5	79.539490
Rf29	VPWR#2	VPWR#7	33.011005
Rf30	VPWR#4	VPWR#8	24.362135
Rf31	VPWR#5	VPWR#9	34.939823
Rf32	VGND#1	VGND#2	94.918716
Rf33	VGND#2	VGND#3	40.518494
Rf34	VGND#3	VGND#4	182.373627
Rf35	VGND#2	VGND#5	31.141060
Rf41	a_441_74##3	a_441_74##8	80.116402
Re1	VPWR#3	VPWR	0.982218
Re2	VGND	VGND#3	0.982254
*
*       CAPACITOR CARDS
*
*
C1	a_441_74##7	B1#6	1.03324e-17
C2	VPWR#2	VPWR#1	9.5684e-19
C3	X#1	VPWR#2	1.49937e-17
C4	a_441_74##9	VPWR#2	1.24176e-17
C5	a_27_392#	VPWR#4	1.32308e-19
C6	VGND#4	a_27_392##2	2.44215e-19
C7	VPWR#8	VPWR#2	2.62194e-19
C8	a_27_392##4	VPWR#4	8.42824e-18
C9	B1#6	a_441_74##9	2.96881e-17
C10	VGND#5	VGND#1	1.62731e-18
C11	a_27_392##2	a_441_74##9	1.25077e-18
C12	a_27_392##2	a_27_392#	3.7648e-19
C13	VGND#4	A3#4	2.78329e-17
C14	VGND#2	a_441_74##4	6.04702e-18
C15	a_27_392##2	VPWR#8	3.5876e-17
C16	VGND#2	B1#3	2.36544e-18
C17	a_441_74##7	VGND#5	4.68265e-17
C18	a_27_392##2	a_27_392##4	1.96856e-19
C19	a_27_392##2	VPWR#9	3.21075e-17
C20	VGND#1	VPWR#1	9.31251e-18
C21	a_27_392##3	a_27_392##2	3.1492e-18
C22	a_441_74##7	a_27_392#	6.93828e-18
C23	A4#6	a_27_392##3	3.7308e-17
C24	X#1	VPWR#1	1.09451e-16
C25	VPWR#2	a_441_74##6	4.68498e-18
C26	VPWR#7	VPWR#1	1.69608e-18
C27	a_441_74##5	VGND#1	2.60303e-17
C28	VPWR#7	X#1	6.3943e-17
C29	a_441_74##5	X#2	7.45941e-18
C30	VGND#1	a_441_74##4	1.25923e-18
C31	VPWR#4	A1#1	7.76352e-19
C32	a_441_74##9	X#1	1.66217e-17
C33	VGND#5	a_441_74##5	2.63483e-18
C34	A3#4	A2#3	5.6291e-18
C35	a_441_74##4	X#2	1.17846e-17
C36	B1#6	a_441_74##6	1.55685e-19
C37	VGND#1	B1#3	3.11803e-19
C38	a_441_74##9	VPWR#7	5.37972e-17
C39	a_441_74##7	a_441_74##5	6.22664e-20
C40	a_441_74##4	VGND#5	2.42917e-17
C41	VPWR#4	A2#1	2.58404e-18
C42	A3#4	A3#3	1.3706e-17
C43	a_441_74##7	a_441_74##4	9.87096e-19
C44	B1#3	VGND#5	2.80233e-17
C45	A3#4	A4#1	4.68681e-18
C46	a_27_392#	a_441_74##9	8.89726e-17
C47	VPWR#8	VPWR#7	7.31124e-19
C48	a_441_74##7	B1#3	3.73079e-17
C49	VGND#4	a_27_392##3	3.75762e-18
C50	a_27_392##2	B1#1	3.34425e-19
C51	VGND#5	A1#3	2.15136e-18
C52	A1#3	a_441_74##7	3.20573e-17
C53	VGND#5	A2#3	5.17437e-19
C54	a_27_392##2	A1#1	8.32544e-19
C55	a_27_392#	VPWR#8	7.90714e-17
C56	a_441_74##7	A2#3	4.11965e-18
C57	a_27_392##4	a_27_392#	1.6789e-18
C58	VGND#5	A3#3	2.9215e-19
C59	a_27_392##2	A2#1	2.39333e-17
C60	a_441_74##7	A3#3	6.03176e-19
C61	a_27_392##4	VPWR#8	6.35173e-17
C62	VGND#4	A1#3	5.18117e-19
C63	VPWR#9	VPWR#8	1.86405e-18
C64	a_27_392##2	A3#1	1.92506e-17
C65	VPWR#3	VPWR#4	3.85969e-17
C66	a_441_74##7	A4#1	4.85946e-19
C67	VPWR#3	VPWR#2	4.94125e-17
C68	VGND#3	VGND#2	4.02166e-17
C69	VPWR#9	a_27_392##4	6.74482e-17
C70	VGND#4	A2#3	1.32547e-18
C71	a_27_392##2	A4#4	1.00981e-18
C72	VGND#4	A3#3	1.30582e-17
C73	VGND#2	a_441_74##3	1.13981e-18
C74	a_27_392##3	VPWR#9	1.00192e-16
C75	VGND#4	A4#1	4.22993e-17
C76	B1#6	VPWR#3	3.14327e-19
C77	VPWR#4	VPWR#2	1.10241e-19
C78	a_441_74##3	VPWR#2	6.44647e-19
C79	VPWR#2	B1#2	2.35682e-20
C80	VGND#3	a_27_392##2	4.59067e-19
C81	VPWR#1	a_441_74#	3.51471e-17
C82	a_441_74##4	a_441_74##5	2.21865e-17
C83	a_441_74##3	B1#6	3.78241e-17
C84	X#1	a_441_74#	6.29088e-17
C85	VPWR#1	a_441_74##6	1.43952e-18
C86	VPWR#7	a_441_74#	1.48454e-18
C87	X#1	a_441_74##6	5.79811e-17
C88	B1#6	B1#2	8.7439e-18
C89	B1#3	a_441_74##4	2.0926e-17
C90	a_441_74##9	a_441_74#	1.39066e-19
C91	VPWR#1	B1#1	1.55711e-19
C92	a_441_74##6	VPWR#7	2.93283e-17
C93	X#1	B1#1	8.60141e-19
C94	a_27_392##2	B1#2	1.12727e-19
C95	a_441_74##9	a_441_74##6	5.85488e-18
C96	VGND#3	A3#4	4.93241e-18
C97	VPWR#7	B1#1	2.88743e-18
C98	A1#3	B1#3	2.76362e-17
C99	a_27_392#	a_441_74##6	2.97692e-19
C100	B1#1	a_441_74##9	4.11889e-17
C101	a_27_392##2	A1#2	2.40548e-18
C102	VPWR#7	A1#1	4.62287e-19
C103	VPWR#8	a_441_74##6	2.69711e-19
C104	a_27_392#	B1#1	5.97115e-17
C105	a_441_74##9	A1#1	2.00034e-19
C106	A2#3	A1#3	1.746e-17
C107	VPWR#8	B1#1	1.5011e-18
C108	VGND#3	VGND#1	5.17077e-17
C109	VPWR#7	A2#1	1.43448e-19
C110	a_27_392##2	A2#2	2.63783e-17
C111	a_27_392#	A1#1	6.44664e-17
C112	a_441_74##9	A2#1	1.61969e-19
C113	A1#1	VPWR#8	3.39199e-17
C114	a_441_74##3	VGND#1	4.57849e-18
C115	a_27_392#	A2#1	5.4829e-19
C116	A3#3	A2#3	2.21242e-17
C117	VGND#3	a_441_74##7	2.16166e-17
C118	a_27_392##4	A1#1	4.4786e-19
C119	a_27_392##2	A3#2	7.03173e-17
C120	a_441_74##3	X#2	3.90372e-18
C121	A2#1	VPWR#8	3.91063e-17
C122	VPWR#9	A1#1	2.22346e-19
C123	VGND#5	a_441_74##3	3.80179e-17
C124	a_27_392##4	A2#1	5.06566e-17
C125	VPWR#8	A3#1	1.40191e-18
C126	A4#1	A3#3	4.84101e-17
C127	VPWR#3	VPWR#1	2.95983e-17
C128	VPWR#9	A2#1	1.3945e-18
C129	A3#4	A2#2	2.59985e-17
C130	VGND#5	B1#2	1.02718e-18
C131	a_27_392##4	A3#1	4.27066e-17
C132	VGND#3	VGND#4	5.47494e-17
C133	VPWR#8	A4#4	6.76402e-19
C134	a_27_392##2	VPWR#4	1.6661e-19
C135	a_441_74##7	B1#2	3.28105e-19
C136	A3#1	VPWR#9	2.93491e-17
C137	a_27_392##3	A3#1	8.94419e-19
C138	a_441_74##9	VPWR#3	1.03855e-17
C139	A4#4	VPWR#9	3.85631e-17
C140	a_441_74##7	A1#2	2.98843e-18
C141	a_27_392#	VPWR#3	1.9405e-17
C142	A4#6	A3#2	1.06435e-17
C143	a_27_392##3	A4#4	6.04513e-17
C144	X#1	a_441_74##3	2.84888e-17
C145	a_441_74##3	VPWR#7	1.59389e-17
C146	A2#2	a_441_74##7	3.82853e-17
C147	a_441_74##3	a_441_74##9	3.28794e-18
C148	A4#6	A4#3	1.28677e-17
C149	X#1	B1#2	7.39066e-19
C150	a_441_74##6	a_441_74#	4.85034e-17
C151	a_441_74##9	B1#2	4.42753e-18
C152	B1#1	a_441_74##6	5.19629e-18
C153	a_441_74##9	A1#2	6.74273e-20
C154	VGND#4	A3#2	1.64305e-19
C155	a_27_392#	A1#2	2.00074e-18
C156	VPWR#8	A1#2	6.25554e-19
C157	a_441_74##3	a_441_74##5	2.92421e-18
C158	VGND#3	B1#3	2.69122e-19
C159	A1#1	B1#1	4.18278e-17
C160	a_441_74##3	a_441_74##4	6.5933e-18
C161	A4#3	VGND#4	3.72739e-17
C162	VGND#3	A1#3	8.69981e-18
C163	VPWR#8	A2#2	1.07693e-18
C164	B1#3	a_441_74##3	2.53665e-18
C165	VGND#3	A2#3	6.25562e-18
C166	A2#1	A1#1	1.446e-17
C167	VPWR#9	A3#2	6.55123e-19
C168	A3#1	A2#1	4.68902e-17
C169	A3#4	a_199_74#	3.59768e-18
C170	A2#2	B1#3	2.49439e-18
C171	VPWR#3	B1#1	7.73615e-18
C172	A2#2	A1#3	1.852e-17
C173	a_441_74##3	a_441_74#	6.5273e-18
C174	a_27_392##3	A4#3	1.29512e-17
C175	A4#4	A3#1	3.15846e-17
C176	VPWR#3	A1#1	1.77704e-18
C177	A3#4	a_121_74#	8.61107e-21
C178	A2#2	A2#3	2.28343e-17
C179	a_441_74##3	a_441_74##6	2.94627e-19
C180	A2#2	A3#3	1.09495e-18
C181	B1#2	a_441_74##6	1.36597e-18
C182	A3#2	A2#3	8.10758e-19
C183	a_27_392##2	A1	5.78239e-18
C184	A3#2	A3#3	1.74693e-18
C185	A3#2	A4#1	1.13973e-18
C186	A2#1	A1#2	3.64899e-18
C187	a_441_74##7	B1	2.191e-17
C188	a_441_74##7	A1	2.09108e-17
C189	VPWR#3	B1#2	2.53582e-20
C190	A1#3	a_313_74#	2.32438e-18
C191	A2#3	a_313_74#	2.03838e-17
C192	B1	a_27_392#	2.40204e-17
C193	B1#2	a_441_74##3	2.33161e-17
C194	VGND#3	A1#2	5.15999e-20
C195	VGND#2	VGND#1	8.30441e-19
C196	a_441_74##3	A1#2	1.41806e-19
C197	A2#3	a_199_74#	2.12237e-18
C198	VGND#3	A2#2	1.46934e-17
C199	VGND#2	X	1.32944e-17
C200	A3#3	a_199_74#	1.86523e-17
C201	A1#2	B1#2	3.26335e-17
C202	A1	a_27_392#	3.70359e-17
C203	A2#2	a_441_74##3	1.76847e-18
C204	VGND#3	A3#2	1.43107e-20
C205	A1	VPWR#8	9.4845e-19
C206	A2#2	B1#2	1.29216e-19
C207	A3#3	a_121_74#	1.34204e-17
C208	A4#1	a_121_74#	1.71328e-18
C209	A2#2	A1#2	2.932e-17
C210	VPWR	VPWR#4	1.77087e-17
C211	VPWR	VPWR#2	2.99595e-17
C212	A3#2	A2#2	7.95679e-17
C213	VGND#4	A3	1.62472e-17
C214	VPWR	B1#6	1.93012e-18
C215	X	VGND#1	7.79204e-17
C216	VPWR	a_27_392##2	3.163e-18
C217	X	X#2	1.8762e-17
C218	A4#3	A3#2	4.11198e-17
C219	VGND#5	X	3.60198e-17
C220	a_441_74##7	X	3.30106e-19
C221	VGND	VGND#2	2.74671e-17
C222	VPWR	A4#6	1.98501e-18
C223	X	X#1	3.47411e-18
C224	A1	A2#1	1.01145e-18
C225	VGND	B1#6	1.2917e-18
C226	A2#2	a_313_74#	6.87797e-18
C227	VGND	a_27_392##2	5.49947e-18
C228	B1	VPWR#3	2.28694e-19
C229	A3	A2#3	5.48038e-18
C230	A3	A3#3	1.17927e-17
C231	VPWR	VPWR#1	4.03492e-17
C232	VGND	A3#4	1.86748e-17
C233	A3#2	a_199_74#	4.43988e-19
C234	VGND#2	a_441_74##7	4.74445e-19
C235	X	a_441_74##5	2.53376e-17
C236	VPWR	X#1	1.7312e-17
C237	A3	A4#1	5.53263e-18
C238	B1	B1#2	7.53162e-18
C239	VPWR	VPWR#7	1.67e-17
C240	X	a_441_74##4	1.37932e-17
C241	VGND#3	A1	1.13726e-18
C242	VGND#2	VNB	3.15624e-17
C243	VPWR	a_441_74##9	1.97283e-17
C244	X	B1#3	1.09779e-18
C245	VGND	VGND#1	6.33645e-17
C246	VPWR#4	VNB	2.78068e-17
C247	B1	A1#2	3.47481e-18
C248	VPWR	a_27_392#	1.73051e-17
C249	VPWR#2	VNB	3.87095e-17
C250	X	A1#3	2.69017e-20
C251	VPWR	VPWR#8	3.73397e-17
C252	VGND	VGND#5	2.20423e-17
C253	VGND	a_441_74##7	1.79709e-17
C254	VPWR	a_27_392##4	1.59949e-17
C255	A1	B1#2	4.26713e-18
C256	VPWR	VPWR#9	2.20003e-17
C257	B1#6	VNB	2.40316e-18
C258	VPWR	a_27_392##3	1.77644e-17
C259	A1	A1#2	1.7545e-17
C260	a_27_392##2	VNB	1.07995e-17
C261	VGND	VGND#4	6.07419e-17
C262	VGND	VPWR#1	5.81298e-18
C263	A2#2	A1	1.87745e-17
C264	VGND	X#1	1.29699e-18
C265	A1	A3#2	5.1739e-19
C266	A3#4	VNB	5.52713e-20
C267	A4#6	VNB	1.03969e-17
C268	A1	A4#3	3.89579e-19
C269	VGND#1	VNB	6.92644e-17
C270	VGND#5	VNB	4.46659e-18
C271	VGND	a_27_392##3	6.28925e-18
C272	a_441_74##7	VNB	8.87411e-18
C273	VPWR	a_441_74#	5.20816e-18
C274	VGND	a_441_74##4	1.37277e-18
C275	VPWR	a_441_74##6	3.37547e-18
C276	VGND	B1#3	1.51657e-18
C277	VPWR	B1#1	2.65255e-18
C278	VGND#4	VNB	8.44172e-17
C279	VGND	A1#3	1.17417e-18
C280	VPWR#1	VNB	9.2976e-17
C281	VPWR	A1#1	2.21297e-19
C282	VGND	A2#3	1.9616e-18
C283	X#1	VNB	1.09941e-17
C284	VPWR	A2#1	4.58141e-20
C285	VPWR#7	VNB	1.07316e-17
C286	VGND	A3#3	9.397e-19
C287	a_441_74##9	VNB	1.92383e-17
C288	VGND	A4#1	3.05823e-18
C289	VPWR	A3#1	2.02589e-19
C290	A3	A2#2	3.19781e-17
C291	a_27_392#	VNB	7.55658e-18
C292	X	a_441_74##3	1.03954e-16
C293	VPWR#8	VNB	6.2534e-18
C294	VPWR	A4#4	1.18236e-18
C295	a_27_392##4	VNB	2.14247e-18
C296	VPWR#9	VNB	3.9203e-18
C297	a_27_392##3	VNB	6.44677e-17
C298	VPWR	VPWR#3	1.60671e-17
C299	a_441_74##5	VNB	2.97466e-17
C300	a_441_74##4	VNB	2.99732e-17
C301	B1#3	VNB	2.98478e-17
C302	VPWR	a_441_74##3	4.96994e-18
C303	A1#3	VNB	3.49151e-17
C304	A2#3	VNB	2.61016e-17
C305	A1	B1	2.83016e-17
C306	A3#3	VNB	2.67591e-17
C307	A4#1	VNB	4.42402e-17
C308	VPWR	A2#2	3.41423e-18
C309	a_441_74#	VNB	5.5068e-17
C310	a_441_74##6	VNB	3.92959e-17
C311	VGND	VGND#3	3.36772e-17
C312	VPWR	A3#2	3.24484e-18
C313	B1#1	VNB	4.0297e-17
C314	VGND	a_441_74##3	1.28896e-17
C315	A3	a_199_74#	2.13295e-18
C316	A1#1	VNB	3.05371e-17
C317	A2#1	VNB	3.56004e-17
C318	A3#1	VNB	3.52987e-17
C319	A3	a_121_74#	1.05916e-20
C320	A4#4	VNB	4.57204e-17
C321	VGND	A2#2	1.51392e-17
C322	VGND	A3#2	3.32079e-19
C323	VPWR#3	VNB	2.21565e-16
C324	VGND#3	VNB	2.44829e-16
C325	VGND	A4#3	2.87716e-18
C326	a_441_74##3	VNB	8.9752e-17
C327	B1#2	VNB	3.71581e-17
C328	A1#2	VNB	3.58602e-17
C329	A2#2	VNB	4.3634e-17
C330	A3#2	VNB	3.61106e-17
C331	VPWR	B1	1.5183e-18
C332	A4#3	VNB	7.33573e-17
C333	VPWR	A1	1.97984e-18
C334	VGND	B1	1.07224e-18
C335	VGND	A1	4.59108e-18
C336	B1	VNB	3.16655e-19
C337	A1	VNB	2.61145e-18
C338	VGND	X	2.10543e-17
C339	A3	VNB	3.65267e-19
C340	X	VNB	2.41813e-17
C341	VPWR	VNB	6.71488e-17
C342	VGND	VNB	7.26532e-17
C343	VPWR#5	VNB	4.897e-17
C344	VPWR	VPWR#5	3.38289e-17
C345	a_27_392##2	VPWR#5	1.20253e-19
C346	VPWR#5	A4#3	1.74453e-19
C347	VPWR#5	VPWR#4	2.84532e-19
C348	VPWR#3	VPWR#5	5.49766e-17
C349	VPWR#5	A4#4	2.59457e-18
C350	VPWR#5	A3#1	2.59449e-18
C351	a_27_392##3	VPWR#5	2.09496e-17
C352	a_27_392##4	VPWR#5	8.4992e-18
C353	VPWR#5	VPWR#8	5.99824e-19
*
*
.ENDS sky130_fd_sc_hs__a41o_2
*
