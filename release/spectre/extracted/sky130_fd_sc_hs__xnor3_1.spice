* Extracted by Quantus, converted by sky130cad/quantus.py
*
*
*
*                       LINUX           Wed Nov 18 09:14:39 2026
*
*
*
*  PROGRAM  advgen
*
*  Name           : advgen - Quantus - (64-bit)
*  Version        : 25.1.0-p047
*  Build Date     : Thu Dec 11 23:20:30 PST 2025
*
*  HSPICE LIBRARY
*
*  OPERATING_TEMPERATURE 150
*  QRC_TECH_DIR <path>/tech
*
*
*

*
.SUBCKT sky130_fd_sc_hs__xnor3_1 VNB VPB VGND VPWR X C B A
*
*
*  caps2d version: 10
*
*
*       TRANSISTOR CARDS
*
*
XM10 X#2 a_81_268##3 VGND#8 VNB sky130_fd_pr__nfet_01v8_lvt l=0.15 w=0.74 ad=0.2109 as=0.3915 pd=2.05 ps=2.98
XM0 VGND#8 C#4 a_232_162##6 VNB sky130_fd_pr__nfet_01v8_lvt l=0.15 w=0.42 ad=0.3915 as=0.1575 pd=2.98 ps=1.59
XM4 a_371_74##3 C#1 a_81_268##4 VNB sky130_fd_pr__nfet_01v8_lvt l=0.15 w=0.64 ad=0.1824 as=0.224 pd=1.85 ps=1.98
XM1 a_81_268##4 a_232_162##3 a_363_394##5 VNB sky130_fd_pr__nfet_01v8_lvt l=0.15 w=0.64 ad=0.224 as=0.2272 pd=1.98 ps=1.99
XM11 VGND#7 B#6 a_786_100##8 VNB sky130_fd_pr__nfet_01v8_lvt l=0.15 w=0.74 ad=0.36 as=0.2109 pd=2.83 ps=2.05
XM16 a_897_54##10 a_786_100##3 a_371_74##6 VNB sky130_fd_pr__nfet_01v8_lvt l=0.15 w=0.64 ad=0.374625 as=0.2656 pd=2.77 ps=2.11
XM21 a_371_74##6 B#8 a_1113_383##3 VNB sky130_fd_pr__nfet_01v8_lvt l=0.15 w=0.64 ad=0.2656 as=0.2272 pd=2.11 ps=2.1
XM12 a_1113_383##3 a_786_100##2 a_363_394# VNB sky130_fd_pr__nfet_01v8_lvt l=0.15 w=0.42 ad=0.2272 as=0.1999 pd=2.1 ps=1.97
XM15 a_363_394# B#1 a_897_54##8 VNB sky130_fd_pr__nfet_01v8_lvt l=0.15 w=0.64 ad=0.1999 as=0.2208 pd=1.97 ps=1.97
XM20 a_897_54##8 A#3 VGND#4 VNB sky130_fd_pr__nfet_01v8_lvt l=0.15 w=0.64 ad=0.2208 as=0.2752 pd=1.97 ps=2.14
XM3 VGND#4 a_897_54# a_1113_383##5 VNB sky130_fd_pr__nfet_01v8_lvt l=0.15 w=0.64 ad=0.2752 as=0.1824 pd=2.14 ps=1.85
XM7 X#1 a_81_268# VPWR#7 VPB sky130_fd_pr__pfet_01v8 l=0.15 w=1.12 ad=0.3192 as=0.4808 pd=2.81 ps=3.3
XM13 VPWR#7 C#6 a_232_162##4 VPB sky130_fd_pr__pfet_01v8 l=0.15 w=0.64 ad=0.4808 as=0.1888 pd=3.3 ps=1.87
XM18 a_363_394##4 C#5 a_81_268##6 VPB sky130_fd_pr__pfet_01v8 l=0.15 w=0.84 ad=0.2478 as=0.41795 pd=2.27 ps=2.85
XM5 a_81_268##6 a_232_162# a_371_74# VPB sky130_fd_pr__pfet_01v8 l=0.15 w=0.84 ad=0.41795 as=0.2436 pd=2.85 ps=2.26
XM8 VPWR#5 B#9 a_786_100##9 VPB sky130_fd_pr__pfet_01v8 l=0.15 w=1.12 ad=0.4194 as=0.3192 pd=3.08 ps=2.81
XM14 a_897_54##4 a_786_100##5 a_363_394##6 VPB sky130_fd_pr__pfet_01v8 l=0.15 w=0.84 ad=0.36585 as=0.3054 pd=2.87 ps=2.45
XM9 a_363_394##6 B#7 a_1113_383##2 VPB sky130_fd_pr__pfet_01v8 l=0.15 w=0.64 ad=0.3054 as=0.192 pd=2.45 ps=1.88
XM19 a_1113_383##2 a_786_100# a_371_74##4 VPB sky130_fd_pr__pfet_01v8 l=0.15 w=0.64 ad=0.192 as=0.3704 pd=1.88 ps=2.65
XM2 a_371_74##4 B#2 a_897_54##5 VPB sky130_fd_pr__pfet_01v8 l=0.15 w=0.84 ad=0.3704 as=0.3716 pd=2.65 ps=2.78
XM17 a_897_54##5 A#1 VPWR#4 VPB sky130_fd_pr__pfet_01v8 l=0.15 w=1 ad=0.3716 as=0.385 pd=2.78 ps=2.77
XM6 VPWR#4 a_897_54##3 a_1113_383##6 VPB sky130_fd_pr__pfet_01v8 l=0.15 w=1 ad=0.385 as=0.3 pd=2.77 ps=2.6
*
*
*       RESISTOR AND CAP/DIODE CARDS
*
Rg1	a_81_268#	a_81_268##2	436.870972
Rg2	a_81_268##2	a_81_268##3	305.727875
Rg3	C#1	C#2	384.528778
Rg4	C#2	C#3	476.178680
Rg5	C#3	C#4	216.345963
Rg6	C#2	C#5	485.732117
Rg7	C#3	C#6	291.399933
Rg8	a_232_162#	a_232_162##2	350.619171
Rg9	a_232_162##2	a_232_162##3	482.155487
Rg10	a_786_100#	a_786_100##2	619.182251
Rg11	a_786_100##2	a_786_100##3	1463.072144
Rg12	a_786_100##3	a_786_100##4	279.244598
Rg13	a_786_100##4	a_786_100##5	363.181610
Rg14	B#1	B#2	792.427307
Rg15	B#2	B#3	973.586609
Rg16	B#3	B#4	1494.353638
Rg17	B#4	B#5	17.816948
Rg18	B#5	B#6	317.705597
Rg19	B#3	B#7	425.348724
Rg20	B#7	B#8	726.933533
Rg21	B#5	B#9	450.786560
Rg22	A#1	A#2	400.207520
Rg23	A#2	A#3	319.414948
Rg24	a_897_54#	a_897_54##2	319.414948
Rg25	a_897_54##2	a_897_54##3	400.207520
Rf1	X	X#1	95.078621
Rf2	X	X#3	3.804633
Rf3	X#3	X	9.602168
Rf4	X#2	X#3	7.500000
Rf5	C#3	C#8	160.844009
Rf6	C#9	C	0.611206
Rf7	C#8	C#9	5.905091
Rf8	a_81_268##4	a_81_268##5	211.510162
Rf9	a_81_268##5	a_81_268##6	235.010223
Rf10	a_232_162##4	a_232_162##5	48.541882
Rf11	a_232_162##5	a_232_162##6	73.157898
Rf12	a_232_162##5	a_232_162##2	229.903748
Rf13	a_371_74#	a_371_74##2	138.425781
Rf14	a_371_74##2	a_371_74##3	33.627686
Rf15	B#4	B	83.099030
Rf16	a_786_100##4	a_786_100##7	166.748093
Rf17	a_786_100##7	a_786_100##8	82.166641
Rf18	a_786_100##7	a_786_100##9	78.054047
Rf19	a_371_74##4	a_371_74##5	116.659981
Rf20	a_371_74##5	a_371_74##7	8.898544
Rf21	a_371_74##6	a_371_74##7	15.000000
Rf22	a_363_394#	a_363_394##2	239.888870
Rf23	a_363_394##2	a_363_394##3	106.299149
Rf24	a_363_394##3	a_363_394##4	106.469879
Rf25	a_363_394##2	a_363_394##5	33.719276
Rf26	a_363_394##3	a_363_394##6	138.714813
Rf27	a_1113_383#	a_1113_383##2	199.247147
Rf28	a_1113_383#	a_1113_383##3	23.146135
Rf29	A#4	A	1.358797
Rf30	A#2	A#6	161.591599
Rf31	A#4	A#6	2.937730
Rf32	a_897_54##4	a_897_54##6	199.680801
Rf33	a_897_54##6	a_897_54##7	70.383293
Rf34	a_897_54##7	a_897_54##9	70.097229
Rf35	a_897_54##9	a_897_54##10	190.189468
Rf36	a_897_54##5	a_897_54##6	7.500000
Rf37	a_897_54##8	a_897_54##9	7.500000
Rf38	a_1113_383##4	a_1113_383##5	24.748034
Rf39	a_1113_383##4	a_1113_383##6	72.151031
Rf41	VGND#2	VGND#3	302.429047
Rf42	VGND#2	VGND#4	39.106503
Rf43	VGND#3	VGND#5	187.715240
Rf45	VGND#3	VGND#7	28.360416
Rf46	VGND#5	VGND#8	24.468842
Rf48	VPWR#2	VPWR#3	302.027283
Rf49	VPWR#2	VPWR#4	37.689926
Rf50	VPWR#3	VPWR#5	33.084488
Rf51	VPWR#3	VPWR#6	195.808151
Rf52	VPWR#6	VPWR#7	38.736572
Rf60	a_897_54##2	a_897_54##7	160.232803
Rf55	a_81_268##2	a_81_268##5	160.232803
Re1	a_371_74##5	a_371_74##2	25.122730
Re2	a_1113_383##4	a_1113_383#	22.652748
Re3	VPWR#2	VPWR	4.549932
Re4	VPWR	VPWR#3	0.974985
Re5	VGND#2	VGND	4.549932
Re6	VGND	VGND#3	0.974985
*
*       CAPACITOR CARDS
*
*
C1	VPWR#5	a_897_54##4	1.01036e-17
C2	a_897_54##4	B#5	4.62181e-18
C3	a_897_54##10	a_786_100##3	4.44876e-17
C4	a_371_74##6	B#6	3.84295e-19
C5	a_897_54##4	B#3	4.49967e-17
C6	a_897_54##10	B#6	3.64594e-18
C7	a_786_100##3	VGND#7	2.62326e-18
C8	a_786_100##8	B#6	3.63347e-17
C9	a_363_394##5	a_786_100##3	4.12069e-19
C10	a_897_54##10	a_232_162##3	4.88184e-19
C11	B#6	VGND#7	1.41741e-17
C12	a_786_100##9	B#5	2.60469e-17
C13	a_786_100##8	a_232_162##3	4.15113e-19
C14	a_363_394#	a_786_100##7	8.06832e-19
C15	a_363_394##3	a_786_100##5	2.68415e-19
C16	a_363_394##5	B#6	2.13267e-18
C17	a_81_268##6	VPWR#5	1.01429e-17
C18	a_786_100##7	B#7	1.48493e-18
C19	a_363_394##2	a_371_74##6	7.50045e-20
C20	VGND#7	a_232_162##3	2.76297e-18
C21	a_81_268##4	B#6	5.35033e-19
C22	B#3	B#2	7.1576e-19
C23	a_232_162##2	B#5	3.7791e-18
C24	a_786_100##7	a_1113_383##3	1.56532e-18
C25	a_232_162##3	a_363_394##5	2.54049e-17
C26	a_363_394##3	B#9	3.91207e-17
C27	a_371_74##3	B#6	5.26991e-20
C28	a_786_100##7	a_786_100##5	8.15843e-18
C29	VGND#7	C#1	1.7636e-19
C30	a_363_394##2	a_897_54##10	5.5012e-17
C31	a_232_162##2	C#2	2.89466e-17
C32	a_81_268##4	a_232_162##3	4.25577e-17
C33	a_363_394##4	a_371_74#	8.13633e-18
C34	B#5	VPWR#5	1.60558e-18
C35	a_786_100##7	a_371_74##6	3.59425e-17
C36	a_371_74##3	a_232_162##3	7.88832e-19
C37	a_363_394##3	a_232_162#	2.17463e-17
C38	a_363_394##4	a_81_268##6	7.30534e-17
C39	a_232_162##4	a_371_74#	1.03866e-18
C40	a_897_54##5	a_786_100##2	5.25435e-19
C41	a_786_100##7	B#9	3.51297e-19
C42	a_81_268##4	C#1	3.57454e-17
C43	VPWR#5	B#3	3.07496e-18
C44	a_363_394##2	a_786_100##8	5.64774e-17
C45	a_786_100#	B#3	5.50071e-18
C46	a_1113_383##3	a_897_54##3	1.51232e-19
C47	a_371_74##4	a_786_100##2	2.69116e-18
C48	a_371_74##3	C#1	3.2287e-17
C49	a_232_162##4	a_81_268##6	1.77101e-17
C50	a_786_100##7	a_897_54##10	4.93532e-18
C51	a_363_394##3	C#5	5.06302e-19
C52	C#3	C#2	1.8336e-18
C53	a_232_162##6	C#1	5.60251e-19
C54	a_1113_383##2	a_786_100##2	6.32712e-19
C55	a_363_394##2	VGND#7	5.06114e-17
C56	a_232_162##4	a_363_394##4	4.71416e-17
C57	VPWR#7	a_81_268##6	1.78297e-17
C58	a_1113_383##3	A#1	8.11437e-19
C59	a_371_74##3	C#4	1.13204e-18
C60	a_371_74#	B#5	6.74341e-19
C61	a_81_268##4	a_81_268##3	2.87551e-18
C62	a_363_394#	B#2	2.54455e-20
C63	a_232_162##6	C#4	1.44181e-17
C64	a_371_74##3	a_81_268##3	4.52741e-19
C65	a_1113_383##3	B#2	1.66714e-17
C66	C#4	VGND#8	1.09105e-17
C67	a_1113_383##2	a_786_100##3	3.02923e-20
C68	a_232_162##6	a_81_268##3	1.97981e-18
C69	a_371_74##6	B#2	2.26438e-19
C70	a_371_74#	C#2	1.29289e-19
C71	a_81_268##2	C#2	7.12704e-20
C72	a_363_394##6	a_786_100##3	1.00083e-19
C73	a_1113_383##3	a_786_100#	8.43569e-19
C74	a_81_268##3	VGND#8	3.80058e-18
C75	a_371_74##6	a_786_100#	2.48105e-19
C76	a_232_162##5	C#5	3.55045e-19
C77	a_81_268##3	X#2	7.07065e-18
C78	X#1	VPWR#7	5.23591e-17
C79	a_1113_383##3	B#7	1.00786e-18
C80	B#5	a_786_100##5	2.50525e-17
C81	a_371_74##3	a_363_394##2	2.67324e-19
C82	a_371_74##6	B#7	2.01687e-17
C83	B#3	a_786_100##5	1.28171e-17
C84	a_1113_383##4	A#6	6.90704e-18
C85	a_232_162##5	C#6	1.38966e-18
C86	VGND#4	a_1113_383##5	3.00651e-17
C87	a_81_268##6	C#2	7.86926e-19
C88	a_371_74##6	a_786_100##5	1.01681e-18
C89	a_232_162##5	a_81_268#	1.34634e-19
C90	a_897_54##8	a_1113_383##5	2.24304e-18
C91	a_897_54##3	a_1113_383##6	2.42302e-17
C92	a_1113_383##3	B#3	2.79748e-19
C93	a_371_74#	B#6	5.27393e-19
C94	B#9	B#5	3.4402e-17
C95	VPWR#4	a_897_54##3	5.05405e-17
C96	A#3	a_897_54#	1.82514e-17
C97	a_1113_383##6	A#1	1.40814e-18
C98	B#9	B#3	1.31014e-17
C99	a_897_54##8	VGND#4	7.00897e-17
C100	a_897_54##5	a_897_54##3	2.80616e-18
C101	a_363_394##4	C#2	1.67835e-18
C102	a_371_74##6	B#5	1.11086e-19
C103	A#1	VPWR#4	2.21017e-17
C104	B#1	A#3	2.63952e-17
C105	a_897_54##5	A#1	6.85564e-17
C106	VPWR#4	B#2	5.01767e-19
C107	a_371_74##6	B#3	8.35532e-19
C108	a_897_54##5	B#2	3.94502e-17
C109	a_81_268##4	a_232_162##5	1.44376e-18
C110	a_1113_383##2	A#1	7.75674e-19
C111	a_897_54##8	a_363_394#	1.11399e-16
C112	A#6	a_897_54##5	1.83966e-17
C113	a_786_100##2	B#1	3.86585e-17
C114	B#2	a_371_74##4	2.6743e-17
C115	a_897_54##5	a_786_100#	9.52532e-19
C116	a_1113_383##2	B#2	1.77692e-17
C117	a_897_54##8	a_1113_383##3	2.4403e-18
C118	a_371_74##4	a_786_100#	2.05502e-17
C119	a_371_74##5	a_363_394##3	2.48625e-18
C120	a_363_394##6	B#2	1.49173e-19
C121	a_897_54##5	B#7	4.18489e-19
C122	B#8	a_786_100##2	3.67199e-17
C123	a_1113_383##4	a_1113_383##5	2.76819e-18
C124	a_1113_383##2	a_786_100#	4.06833e-17
C125	a_371_74##5	a_363_394##2	9.86331e-18
C126	a_897_54##4	B#2	6.45932e-19
C127	a_1113_383##4	VGND#4	8.76876e-18
C128	a_371_74##4	B#7	3.83119e-19
C129	a_363_394#	a_1113_383##3	7.97939e-17
C130	a_363_394##6	a_786_100#	3.39617e-19
C131	a_786_100##3	a_786_100##2	4.46746e-19
C132	a_897_54##5	a_786_100##5	3.79563e-19
C133	a_371_74##5	a_786_100##7	4.22248e-17
C134	a_1113_383##4	a_897_54##8	1.37533e-17
C135	a_1113_383##2	B#7	3.36103e-17
C136	a_371_74##2	a_363_394##3	6.99109e-18
C137	a_897_54##4	a_786_100#	2.16011e-18
C138	a_371_74##4	a_786_100##5	1.68573e-19
C139	a_786_100##3	B#8	3.15014e-17
C140	a_371_74##2	a_363_394##2	4.48906e-17
C141	a_363_394##6	B#7	8.66135e-18
C142	a_786_100##8	B#5	6.62741e-18
C143	a_363_394#	a_371_74##6	3.85934e-17
C144	a_1113_383##2	a_786_100##5	2.82895e-18
C145	a_897_54##4	B#7	1.51355e-18
C146	a_363_394##3	VPWR#3	3.75703e-17
C147	a_363_394##6	a_786_100##5	5.7843e-17
C148	B#6	a_786_100##3	4.11779e-18
C149	a_1113_383##2	B#9	3.96421e-19
C150	a_371_74##6	a_1113_383##3	4.24324e-17
C151	a_897_54##10	a_363_394#	7.70261e-17
C152	a_786_100##5	a_897_54##4	1.89695e-17
C153	a_363_394##6	B#9	1.80285e-19
C154	VPWR#3	a_786_100##7	3.65679e-18
C155	a_232_162##5	a_371_74##2	3.42702e-17
C156	a_897_54##4	B#9	3.74047e-18
C157	a_1113_383##3	a_897_54##10	4.75022e-19
C158	VPWR#5	a_786_100##5	5.10633e-19
C159	a_232_162##3	B#6	3.80497e-18
C160	VGND#3	a_363_394##2	3.69982e-17
C161	VGND#7	B#5	3.14574e-19
C162	a_1113_383#	a_897_54##8	2.24479e-17
C163	a_363_394##3	a_363_394##6	9.68838e-19
C164	a_786_100##9	B#9	2.61023e-17
C165	A#6	a_897_54##2	3.21879e-17
C166	a_1113_383#	a_363_394#	1.73185e-17
C167	a_897_54##4	a_232_162#	4.44143e-19
C168	VGND#3	a_786_100##7	1.86659e-18
C169	B#9	VPWR#5	3.08468e-17
C170	VPWR#3	a_232_162##5	2.69121e-18
C171	a_1113_383#	a_1113_383##3	4.5265e-17
C172	a_786_100##9	a_232_162#	4.28273e-19
C173	a_371_74#	B#9	5.70976e-19
C174	C#1	a_232_162##3	2.83344e-17
C175	a_1113_383#	a_371_74##6	2.91813e-18
C176	VPWR#5	a_232_162#	4.56284e-18
C177	a_371_74##5	a_363_394#	6.4105e-18
C178	A#6	A#2	1.06579e-17
C179	a_1113_383#	a_897_54##10	4.34735e-19
C180	a_81_268##6	B#9	2.79605e-18
C181	a_363_394##3	B#5	1.22831e-17
C182	VGND#3	a_232_162##5	1.57564e-18
C183	a_371_74##5	a_1113_383##3	5.77717e-18
C184	a_371_74#	a_232_162#	3.775e-17
C185	a_363_394##4	B#9	6.33943e-19
C186	a_1113_383##4	a_1113_383##6	2.86643e-18
C187	a_371_74##5	a_371_74##6	3.81535e-17
C188	VPWR#5	C#5	1.16222e-18
C189	a_232_162#	a_81_268##6	3.07159e-17
C190	C#4	C#1	2.59969e-18
C191	a_371_74##5	a_897_54##10	3.73094e-18
C192	a_1113_383##4	VPWR#4	5.95133e-18
C193	a_363_394##3	a_786_100##9	4.82585e-17
C194	a_786_100##7	a_363_394##6	5.21847e-17
C195	a_371_74#	C#5	2.85469e-18
C196	a_786_100##2	B#2	1.53359e-18
C197	a_363_394##4	a_232_162#	1.81058e-17
C198	a_371_74##5	a_786_100##8	1.60653e-17
C199	a_1113_383##4	a_897_54##5	4.92484e-18
C200	a_81_268##3	C#1	5.82208e-19
C201	a_81_268##6	C#5	3.55528e-17
C202	a_232_162##4	a_232_162#	6.42064e-20
C203	a_371_74#	C#6	8.97802e-20
C204	a_81_268##3	C#4	1.43296e-17
C205	a_363_394##4	C#5	7.21756e-17
C206	a_363_394##2	a_786_100##4	4.1169e-19
C207	a_786_100##7	a_897_54##4	3.34496e-18
C208	VGND#7	a_897_54##10	7.09551e-18
C209	a_363_394##3	VPWR#5	4.63268e-17
C210	a_81_268##6	C#6	2.72865e-18
C211	VPWR#3	a_1113_383##3	3.5103e-18
C212	a_363_394##2	B#5	9.3082e-18
C213	a_232_162##4	C#5	2.88474e-18
C214	B#7	a_786_100##2	4.10905e-18
C215	a_786_100##7	a_786_100##4	2.45307e-17
C216	VPWR#3	a_371_74##6	4.82158e-18
C217	a_371_74##2	VGND#7	4.87357e-18
C218	VGND#3	a_897_54##8	2.31479e-17
C219	a_363_394##4	C#6	2.45852e-18
C220	VPWR#7	C#5	2.44624e-19
C221	a_363_394##5	a_371_74##2	2.66407e-17
C222	VGND#3	a_363_394#	1.50237e-17
C223	a_81_268##6	a_81_268#	2.39316e-18
C224	C#6	a_232_162##4	1.19548e-17
C225	a_897_54##2	a_1113_383##5	7.55898e-18
C226	a_81_268##4	a_371_74##2	3.77482e-17
C227	VGND#3	a_1113_383##3	5.61553e-18
C228	a_786_100##7	a_786_100##9	2.83151e-19
C229	a_897_54##2	VGND#4	2.4091e-17
C230	a_363_394##4	a_81_268#	9.87848e-19
C231	a_363_394##3	a_371_74#	8.15681e-17
C232	C#6	VPWR#7	1.48956e-17
C233	VGND#3	a_371_74##6	3.88038e-18
C234	a_897_54##8	a_897_54##2	2.83221e-19
C235	a_232_162##4	a_81_268#	1.66561e-19
C236	a_1113_383#	a_897_54##5	8.98422e-18
C237	VGND#3	a_897_54##10	1.15082e-16
C238	a_232_162##6	a_371_74##2	2.81358e-17
C239	X#1	C#6	1.4253e-18
C240	a_363_394##5	a_786_100##8	3.34303e-19
C241	a_232_162##2	a_363_394##3	3.28435e-18
C242	a_371_74#	a_363_394##2	4.88835e-17
C243	VGND#3	a_786_100##8	2.88915e-18
C244	a_1113_383#	a_371_74##4	7.19941e-18
C245	VPWR#7	a_81_268#	4.80867e-17
C246	a_1113_383##3	a_897_54##2	2.08339e-18
C247	a_363_394##2	a_232_162##2	5.42869e-19
C248	VGND#3	VGND#7	2.19439e-17
C249	a_1113_383#	a_1113_383##2	3.54343e-18
C250	X#1	a_81_268#	3.12384e-17
C251	a_897_54##8	A#2	2.2494e-18
C252	VGND#3	a_363_394##5	3.60085e-17
C253	a_786_100##7	a_232_162##2	1.17553e-19
C254	a_81_268##4	C#2	1.49115e-18
C255	a_363_394##5	VGND#7	1.41877e-17
C256	VGND#3	a_81_268##4	8.5061e-17
C257	A#1	a_897_54##3	2.83497e-17
C258	a_1113_383##3	A#2	3.07291e-18
C259	a_1113_383#	a_897_54##4	6.41902e-19
C260	a_371_74##5	a_1113_383##2	2.18304e-18
C261	VGND#3	a_371_74##3	8.38509e-18
C262	VGND#3	a_232_162##6	7.05421e-18
C263	a_371_74##5	a_363_394##6	1.2223e-17
C264	a_363_394##4	a_363_394##3	1.27773e-18
C265	a_232_162##5	a_232_162##2	2.18641e-18
C266	a_81_268##4	VGND#7	3.34139e-18
C267	a_371_74##5	a_897_54##4	5.22753e-18
C268	B#2	A#1	3.16016e-17
C269	VPWR#3	a_897_54##5	1.66769e-17
C270	a_371_74##5	a_786_100##9	6.35892e-18
C271	a_1113_383##4	a_897_54#	7.41955e-18
C272	a_371_74##6	a_786_100##4	3.31106e-18
C273	VPWR#3	a_371_74##4	4.22433e-18
C274	a_786_100##2	B#3	3.3376e-19
C275	a_897_54##10	a_786_100##4	4.68039e-19
C276	a_1113_383##4	A#3	8.73972e-19
C277	a_81_268##4	a_363_394##5	5.74219e-17
C278	a_786_100##7	B#5	8.87087e-18
C279	a_232_162##5	C#3	4.38505e-17
C280	VPWR#3	a_1113_383##2	1.86847e-17
C281	a_786_100#	B#2	1.95351e-17
C282	a_363_394##6	VPWR#3	1.55024e-17
C283	a_897_54##2	a_1113_383##6	1.81235e-17
C284	a_371_74##2	VPWR#5	3.45531e-18
C285	VGND#3	a_371_74##4	6.19047e-19
C286	a_897_54##8	a_897_54##5	3.65341e-18
C287	a_897_54##4	VPWR#3	1.1057e-16
C288	a_897_54##2	VPWR#4	2.43532e-17
C289	B#7	B#2	1.18479e-18
C290	a_371_74##2	a_371_74#	2.05855e-17
C291	VPWR#3	a_786_100##9	3.58851e-18
C292	a_81_268##2	a_232_162##5	2.28148e-18
C293	a_786_100##7	B#3	6.07856e-19
C294	VGND#3	a_363_394##6	1.04034e-18
C295	a_371_74##2	a_81_268##6	2.58014e-18
C296	B#7	a_786_100#	4.05268e-17
C297	VPWR#3	VPWR#5	1.99888e-17
C298	a_371_74##2	a_363_394##4	7.00971e-18
C299	VPWR#3	a_371_74#	3.3323e-18
C300	a_232_162##5	a_371_74#	1.09625e-18
C301	a_81_268##4	a_371_74##3	1.00147e-16
C302	A#2	a_897_54##5	3.60499e-18
C303	a_81_268##6	VPWR#3	1.02171e-16
C304	a_1113_383#	B#1	6.42389e-18
C305	a_363_394##4	VPWR#3	1.3497e-17
C306	a_786_100##5	B#7	3.04233e-17
C307	a_1113_383##3	a_897_54##5	2.51525e-17
C308	VGND#3	a_371_74#	4.10829e-19
C309	a_363_394#	a_371_74##4	5.95247e-19
C310	a_232_162##6	C#2	1.7262e-19
C311	a_363_394##5	a_232_162##2	4.5229e-19
C312	a_1113_383#	a_786_100##2	1.37509e-18
C313	VPWR#3	a_232_162##4	8.99213e-18
C314	a_81_268##4	a_232_162##6	2.83757e-17
C315	a_81_268##4	a_232_162##2	6.77762e-19
C316	a_232_162##5	a_81_268##6	2.21082e-18
C317	B	B#5	3.36706e-17
C318	a_363_394##2	a_363_394##3	1.10693e-18
C319	VPWR#3	X#1	1.60199e-17
C320	a_1113_383##3	a_371_74##4	8.30631e-17
C321	a_371_74##5	B#8	1.63381e-18
C322	a_363_394##6	a_786_100##4	2.47868e-19
C323	a_232_162##6	a_371_74##3	1.35429e-17
C324	a_81_268##4	C#3	1.47479e-18
C325	B#5	a_786_100##3	1.7563e-20
C326	a_897_54##4	a_786_100##4	1.56698e-19
C327	a_371_74##5	a_786_100##3	2.1588e-19
C328	VGND#3	X#1	1.24388e-18
C329	a_232_162##5	a_363_394##4	1.60419e-17
C330	a_1113_383##4	a_897_54##3	2.60967e-18
C331	C#3	a_232_162##6	2.33386e-17
C332	a_232_162#	B#9	5.67311e-18
C333	a_371_74##5	B#6	1.98866e-19
C334	a_1113_383##3	a_1113_383##2	1.7174e-18
C335	a_81_268##2	a_371_74##3	1.70473e-18
C336	a_371_74##2	B#6	1.34332e-19
C337	a_897_54##2	a_897_54#	6.69091e-18
C338	a_81_268##2	a_232_162##6	2.98072e-17
C339	C#5	a_232_162#	2.11072e-17
C340	a_232_162##5	a_232_162##4	6.39845e-20
C341	a_371_74##6	a_1113_383##2	1.67375e-17
C342	VGND#3	a_786_100##2	2.05466e-18
C343	a_371_74##2	a_232_162##3	1.5821e-17
C344	a_897_54##2	A#3	1.58305e-19
C345	a_81_268##2	VGND#8	1.54612e-17
C346	C	C#2	9.42442e-20
C347	a_363_394##3	a_786_100##7	1.45596e-18
C348	a_897_54##2	B#1	5.33189e-20
C349	a_371_74##2	C#1	8.40094e-18
C350	VGND#3	a_786_100##3	1.27373e-17
C351	a_897_54##2	a_786_100##2	1.07089e-20
C352	a_371_74##2	C#4	2.11034e-19
C353	C#6	C#5	5.43441e-18
C354	VGND#3	B#6	1.21091e-17
C355	a_371_74##6	a_363_394##6	2.05401e-17
C356	B#1	A#2	1.58359e-17
C357	a_232_162##2	a_371_74#	3.78286e-17
C358	VGND#3	a_232_162##3	6.46835e-18
C359	a_81_268#	C#5	7.53128e-19
C360	a_232_162##2	a_81_268##6	2.44426e-18
C361	a_363_394##2	a_786_100##7	3.44105e-17
C362	a_232_162##2	a_363_394##4	2.64928e-17
C363	VGND#3	C#1	4.68335e-18
C364	a_81_268#	C#6	1.33642e-17
C365	a_232_162##4	a_232_162##2	4.01557e-20
C366	a_371_74##6	a_897_54##4	4.31535e-18
C367	a_81_268##6	C#3	4.21806e-19
C368	VGND#3	a_81_268##3	7.18633e-18
C369	a_786_100##4	B#8	7.47007e-18
C370	a_232_162##4	C#3	7.46705e-19
C371	a_371_74##5	B#7	1.34002e-18
C372	C#3	VPWR#7	3.10657e-19
C373	a_81_268##2	a_81_268##6	2.03548e-18
C374	VPWR#3	B#2	6.1823e-18
C375	X#1	C#3	2.67205e-20
C376	a_81_268##2	a_363_394##4	6.01264e-18
C377	a_81_268##2	a_232_162##4	4.86159e-17
C378	a_897_54##2	a_897_54##3	7.43327e-18
C379	a_81_268##2	VPWR#7	8.42792e-17
C380	VPWR#3	B#7	6.02715e-19
C381	a_897_54##2	A#1	1.23551e-18
C382	X#1	a_81_268##2	3.47058e-17
C383	VPWR#3	a_786_100##5	1.14203e-18
C384	a_897_54##2	B#2	2.828e-19
C385	a_371_74##2	B#5	5.07815e-19
C386	a_232_162##2	B#6	2.40008e-19
C387	a_363_394##2	B#8	2.33861e-19
C388	a_232_162##5	B#5	1.6742e-20
C389	a_786_100##7	a_786_100##2	1.89708e-19
C390	VPWR#3	B#9	7.63548e-18
C391	B#2	A#2	1.67971e-17
C392	C#2	a_232_162##3	4.2636e-18
C393	VPWR#3	a_232_162#	1.46055e-17
C394	a_786_100##8	a_786_100##9	5.43595e-19
C395	a_371_74##2	C#2	2.37715e-17
C396	VPWR#3	C#5	2.91484e-18
C397	a_363_394##2	a_786_100##3	1.67205e-17
C398	a_786_100##7	B#8	1.78752e-18
C399	VPWR#3	a_81_268#	4.24741e-18
C400	a_786_100##4	B#7	9.6674e-18
C401	VPWR#4	a_1113_383##6	4.97206e-17
C402	a_81_268##2	C#1	2.06495e-19
C403	a_81_268##2	C#4	2.7892e-17
C404	a_81_268##2	a_81_268##3	1.08498e-17
C405	VPWR#3	B#5	8.12945e-20
C406	a_371_74##5	a_1113_383#	2.4446e-17
C407	a_232_162##5	C#2	7.33605e-18
C408	a_363_394##2	B#6	3.23073e-17
C409	a_897_54##5	a_1113_383##6	4.46149e-18
C410	a_786_100##7	a_786_100##3	5.55953e-18
C411	a_363_394##3	B	1.61184e-17
C412	VPWR#3	B#3	5.48436e-17
C413	a_363_394##2	B	2.95414e-17
C414	B	a_786_100##7	3.9826e-17
C415	a_1113_383##4	a_897_54##2	1.1659e-16
C416	VPWR#3	C#2	1.9767e-20
C417	a_232_162##2	B#9	1.0022e-18
C418	A	a_897_54##8	1.85268e-17
C419	a_1113_383##3	A	2.28428e-17
C420	a_1113_383##4	A#2	2.43296e-18
C421	a_897_54##5	VPWR#4	7.94833e-17
C422	VGND#3	a_1113_383#	2.09876e-17
C423	a_232_162##2	C#5	1.81167e-17
C424	a_897_54#	a_1113_383##5	1.21392e-17
C425	a_363_394##2	a_232_162##3	4.52848e-19
C426	VPWR#3	a_371_74##2	1.36639e-18
C427	a_786_100##7	B#6	3.46965e-19
C428	VGND#3	a_371_74##5	4.86034e-17
C429	C#3	C#5	1.84671e-19
C430	VGND#3	a_371_74##2	5.23489e-17
C431	a_897_54##5	B#3	2.55692e-18
C432	a_363_394##5	a_371_74#	1.38696e-17
C433	a_1113_383#	A#2	1.5482e-18
C434	a_81_268##2	a_232_162#	2.27586e-19
C435	VGND#4	a_897_54#	3.57521e-17
C436	a_81_268##2	C#5	1.557e-18
C437	a_81_268#	C#3	6.00325e-20
C438	C	a_232_162##5	1.9302e-17
C439	B	a_786_100##8	3.94594e-17
C440	a_1113_383##5	A#3	8.1442e-19
C441	a_81_268##2	C#6	2.60848e-17
C442	VGND#3	B#5	3.10014e-19
C443	B	VGND#7	2.39131e-19
C444	A	a_897_54##5	1.67612e-17
C445	a_371_74##5	a_786_100##4	3.73148e-19
C446	a_81_268##2	a_81_268#	1.27913e-17
C447	a_363_394##2	C#1	1.01877e-19
C448	a_897_54##8	a_897_54#	1.97793e-18
C449	C#4	C#2	5.98279e-19
C450	VGND#3	C#2	8.2551e-20
C451	A#3	VGND#4	1.86991e-17
C452	A#2	a_897_54##2	3.16556e-17
C453	VGND#3	a_786_100##4	3.76859e-20
C454	a_371_74##2	a_232_162##2	8.31436e-17
C455	a_1113_383##2	a_897_54##5	9.83591e-17
C456	a_897_54##8	A#3	5.15231e-17
C457	VPWR#3	a_232_162##2	4.48923e-18
C458	a_371_74##2	C#3	1.68249e-18
C459	B	a_786_100##9	4.13751e-17
C460	VGND#3	a_232_162##2	5.6406e-20
C461	a_1113_383##3	a_897_54#	2.19349e-21
C462	a_371_74##4	B#3	3.36087e-19
C463	A	B#1	2.21569e-18
C464	a_371_74##2	a_81_268##2	1.49467e-18
C465	VGND#3	C#3	5.82361e-18
C466	VPWR#3	a_81_268##2	5.42367e-18
C467	a_363_394#	A#3	1.05016e-18
C468	a_371_74##4	a_1113_383##2	7.82298e-17
C469	X	a_81_268##4	2.39541e-18
C470	VGND#3	a_81_268##2	1.5364e-17
C471	a_897_54##8	B#1	2.26262e-17
C472	X	X#2	6.35742e-18
C473	C	a_81_268##6	7.91494e-19
C474	C	a_232_162##4	1.12788e-17
C475	a_1113_383##3	A#3	7.21349e-20
C476	VGND#4	a_786_100##2	3.57075e-19
C477	a_363_394##6	a_371_74##4	1.91505e-18
C478	a_363_394#	B#1	3.76614e-17
C479	B#5	VNB	1.02091e-16
C480	A	B#2	1.65727e-18
C481	B#3	VNB	1.47419e-16
C482	C#2	VNB	4.75499e-17
C483	a_1113_383##2	B#5	8.45695e-19
C484	a_897_54##8	a_786_100##2	2.43953e-17
C485	X	X#1	2.22172e-18
C486	a_81_268##2	C#3	5.93334e-17
C487	a_1113_383##3	B#1	1.24946e-17
C488	a_363_394##6	a_1113_383##2	2.97287e-17
C489	B	a_786_100##5	1.67446e-19
C490	B	B#9	5.64037e-18
C491	a_363_394#	a_786_100##2	2.43587e-17
C492	a_1113_383##2	B#3	2.35686e-18
C493	X	C#1	6.09961e-19
C494	a_1113_383##4	A	9.32091e-19
C495	a_897_54##8	A#6	1.55661e-17
C496	X	C#4	1.04779e-18
C497	X	a_81_268##3	2.62284e-17
C498	a_897_54##8	B#8	4.39733e-19
C499	a_232_162##6	a_232_162##4	2.39539e-18
C500	a_1113_383#	A	5.0256e-18
C501	a_897_54##4	a_1113_383##2	3.77068e-17
C502	C	C#5	3.09478e-20
C503	a_1113_383##3	a_786_100##2	5.04189e-17
C504	C	C#6	2.31007e-18
C505	C	a_81_268#	6.4199e-19
C506	a_371_74##5	B	3.01743e-17
C507	a_897_54##10	B#1	2.50648e-19
C508	a_363_394#	B#8	2.42356e-17
C509	a_371_74##2	B	1.09958e-17
C510	VPWR#3	B	5.97079e-18
C511	A	A#2	5.52145e-18
C512	A#6	VNB	7.33738e-20
C513	VGND#3	B	1.39948e-18
C514	a_363_394##3	VNB	1.22478e-17
C515	a_363_394##2	VNB	1.29102e-17
C516	a_371_74##6	a_786_100##2	2.87292e-18
C517	a_786_100##7	VNB	3.46718e-18
C518	a_363_394##6	a_897_54##4	5.99104e-17
C519	a_897_54##8	a_786_100##3	2.90741e-19
C520	a_232_162##5	VNB	7.77016e-18
C521	VPWR#3	C	3.54596e-18
C522	a_363_394##6	B#5	1.66221e-17
C523	B	a_786_100##4	1.3385e-18
C524	a_1113_383##5	VNB	2.7016e-17
C525	VGND#4	VNB	1.14996e-17
C526	a_897_54##8	VNB	1.84386e-17
C527	B#8	a_1113_383##3	1.39406e-17
C528	a_1113_383##3	VNB	5.97995e-18
C529	a_371_74##6	VNB	4.20315e-18
C530	a_897_54##10	VNB	1.63355e-17
C531	B	a_232_162##2	6.02906e-19
C532	a_786_100##8	VNB	3.39721e-18
C533	VGND#7	VNB	6.07064e-18
C534	a_363_394##5	VNB	7.91062e-18
C535	a_81_268##4	VNB	2.24473e-17
C536	a_371_74##3	VNB	2.10065e-18
C537	VGND#3	X	1.73427e-17
C538	a_232_162##6	VNB	2.03098e-18
C539	a_1113_383##6	VNB	4.44844e-17
C540	a_897_54##10	a_786_100##2	4.27719e-18
C541	VPWR#4	VNB	4.47144e-18
C542	a_897_54##5	VNB	1.00653e-17
C543	a_371_74##4	VNB	1.42071e-18
C544	a_1113_383##2	VNB	8.77097e-19
C545	a_363_394#	a_786_100##3	1.49277e-17
C546	C	C#3	5.39987e-18
C547	a_363_394##6	VNB	1.98306e-18
C548	a_897_54##4	VNB	1.85858e-17
C549	VPWR#5	VNB	5.4363e-18
C550	a_81_268##2	C	3.76832e-17
C551	a_786_100##9	a_363_394##6	1.41389e-17
C552	a_371_74#	VNB	1.22872e-17
C553	a_81_268##6	VNB	3.22693e-17
C554	a_363_394##4	VNB	3.7564e-19
C555	a_232_162##4	VNB	8.46548e-18
C556	VPWR#7	VNB	3.60475e-18
C557	X#1	VNB	5.95154e-17
C558	a_371_74##6	B#8	3.09417e-17
C559	a_897_54#	VNB	3.08613e-17
C560	a_363_394##6	B#3	3.85279e-18
C561	A#3	VNB	2.43611e-17
C562	B#1	VNB	3.66352e-17
C563	X	a_81_268##2	8.36442e-17
C564	a_786_100##2	VNB	9.86753e-17
C565	B#8	VNB	3.30316e-17
C566	a_786_100##3	VNB	7.17398e-17
C567	B#6	VNB	3.87772e-17
C568	a_232_162##3	VNB	4.08015e-17
C569	C#1	VNB	4.10561e-17
C570	C#4	VNB	3.12613e-17
C571	a_81_268##3	VNB	4.43317e-17
C572	a_897_54##3	VNB	3.80443e-17
C573	A#1	VNB	2.97336e-17
C574	B#2	VNB	7.765e-17
C575	a_1113_383##3	a_786_100##3	1.32607e-18
C576	a_786_100#	VNB	2.74268e-17
C577	B#7	VNB	4.03238e-17
C578	a_786_100##5	VNB	3.0671e-17
C579	B#9	VNB	4.00759e-17
C580	a_232_162#	VNB	4.37996e-17
C581	C#5	VNB	4.39294e-17
C582	C#6	VNB	2.67181e-17
C583	a_81_268#	VNB	4.13135e-17
C584	a_1113_383##4	VNB	5.48318e-17
C585	a_897_54##10	B#8	7.31589e-18
C586	B#5	a_786_100##4	2.36609e-17
C587	a_1113_383#	VNB	5.89195e-18
C588	a_371_74##5	VNB	7.95374e-18
C589	a_371_74##2	VNB	1.14109e-17
C590	VPWR#3	VNB	4.03689e-16
C591	a_363_394#	B#6	7.43601e-19
C592	VGND#3	VNB	3.81695e-16
C593	a_897_54##2	VNB	3.74557e-17
C594	A#2	VNB	2.69017e-17
C595	a_786_100##4	VNB	2.32485e-17
C596	a_232_162##2	VNB	4.12337e-17
C597	C#3	VNB	2.93369e-17
C598	a_786_100##4	B#3	6.02111e-19
C599	a_81_268##2	VNB	4.80205e-17
C600	a_371_74##6	a_786_100##3	2.55439e-17
C601	A	VNB	1.15601e-18
C602	B	VNB	6.34767e-18
C603	C	VNB	2.3617e-18
C604	X	VNB	5.49848e-17
C605	a_1113_383##3	B#6	5.70693e-19
C606	VGND#2	a_786_100##2	1.38727e-17
C607	VPWR#2	a_786_100##2	5.3462e-19
C608	VGND#2	A#2	2.75014e-20
C609	a_897_54##4	VPWR#2	3.38205e-17
C610	VPWR#2	a_897_54##2	2.23982e-18
C611	VGND#5	C#2	6.08014e-20
C612	VGND#5	VNB	8.73847e-17
C613	VPWR#2	A#6	9.03052e-19
C614	a_1113_383##4	VGND#2	3.08044e-17
C615	VGND#2	VNB	1.89661e-16
C616	VGND#2	A#3	3.48844e-18
C617	VGND#3	VGND#2	6.6019e-17
C618	VPWR#2	A#1	1.01881e-17
C619	VPWR#2	VNB	1.89066e-16
C620	VPWR#6	VNB	7.43802e-17
C621	VPWR#3	VPWR#2	6.97311e-17
C622	VPWR#6	a_81_268#	8.137e-18
C623	VGND#5	X	2.38673e-17
C624	VPWR#2	A	9.72397e-19
C625	VGND#2	a_897_54##10	2.80478e-17
C626	VPWR#6	C#6	5.69726e-19
C627	a_897_54##5	VPWR#2	9.8608e-17
C628	X#1	VPWR#6	1.85694e-17
C629	VGND#2	a_1113_383#	1.01259e-17
C630	VPWR#2	A#2	2.6739e-20
C631	VPWR#3	VPWR#6	1.36308e-16
C632	a_1113_383##6	VPWR#2	3.30024e-17
C633	VGND#2	a_897_54##8	1.12099e-16
C634	VPWR#2	B#2	1.42266e-17
C635	VGND#2	B#1	1.15177e-18
C636	VGND#2	a_897_54##2	1.17488e-18
C637	VPWR#6	C#2	1.00136e-19
C638	VGND#5	a_81_268##2	4.11121e-17
C639	VGND#2	a_1113_383##5	2.24754e-17
C640	VGND#2	a_897_54#	4.51859e-18
C641	a_81_268##2	VPWR#6	6.4574e-19
C642	VGND#5	C#3	1.57508e-19
C643	VGND#5	a_81_268##3	1.25995e-17
C644	VPWR#2	a_897_54##3	6.97596e-18
C645	VPWR#6	a_81_268##6	8.04754e-17
C646	VGND#5	VGND#8	6.48192e-18
C647	VGND#5	C#4	1.86494e-18
C648	VPWR#6	C#3	1.15415e-19
C649	VGND#5	C#1	9.94029e-19
C650	VGND#5	a_232_162##3	7.03856e-20
C651	VGND#5	a_81_268##4	6.01114e-17
C652	VGND#2	a_786_100##3	3.68676e-18
C653	VPWR#2	VPWR#4	4.08042e-20
C654	VGND#3	VGND#5	1.43711e-16
C655	VPWR#2	B#3	1.53311e-17
C656	VPWR#2	a_786_100#	3.04645e-19
*
*
.ENDS sky130_fd_sc_hs__xnor3_1
*
