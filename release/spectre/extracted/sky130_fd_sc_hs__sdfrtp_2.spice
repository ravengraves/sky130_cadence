* Extracted by Quantus, converted by sky130cad/quantus.py
*
*
*
*                       LINUX           Wed Nov 18 09:09:51 2026
*
*
*
*  PROGRAM  advgen
*
*  Name           : advgen - Quantus - (64-bit)
*  Version        : 25.1.0-p047
*  Build Date     : Thu Dec 11 23:20:30 PST 2025
*
*  HSPICE LIBRARY
*
*  OPERATING_TEMPERATURE 150
*  QRC_TECH_DIR <path>/tech
*
*
*

*
.SUBCKT sky130_fd_sc_hs__sdfrtp_2 VNB VPB VGND RESET_B VPWR Q D CLK SCE SCD
*
*
*  caps2d version: 10
*
*
*       TRANSISTOR CARDS
*
*
XM38 a_27_74##8 SCE#4 VGND#19 VNB sky130_fd_pr__nfet_01v8_lvt l=0.15 w=0.42 ad=0.1197 as=0.1197 pd=1.41 ps=1.41
XM2 a_225_81##2 a_27_74# a_312_81# VNB sky130_fd_pr__nfet_01v8_lvt l=0.15 w=0.42 ad=0.1197 as=0.1008 pd=1.41 ps=1.32
XM41 a_312_81# D#3 a_390_81##8 VNB sky130_fd_pr__nfet_01v8_lvt l=0.15 w=0.42 ad=0.1008 as=0.2667 pd=1.32 ps=2.11
XM11 a_390_81##8 SCE#6 a_547_81# VNB sky130_fd_pr__nfet_01v8_lvt l=0.15 w=0.42 ad=0.2667 as=0.1008 pd=2.11 ps=1.32
XM1 a_547_81# SCD#1 a_225_81# VNB sky130_fd_pr__nfet_01v8_lvt l=0.15 w=0.42 ad=0.1008 as=0.1659 pd=1.32 ps=1.63
XM8 a_225_81# RESET_B#3 VGND#18 VNB sky130_fd_pr__nfet_01v8_lvt l=0.15 w=0.42 ad=0.1659 as=0.1491 pd=1.63 ps=1.55
XM30 a_855_368##13 CLK#1 VGND#17 VNB sky130_fd_pr__nfet_01v8_lvt l=0.15 w=0.74 ad=0.2109 as=0.259 pd=2.05 ps=2.18
XM39 VGND#17 a_855_368##9 a_1034_368##10 VNB sky130_fd_pr__nfet_01v8_lvt l=0.15 w=0.74 ad=0.259 as=0.2109 pd=2.18 ps=2.05
XM14 a_390_81# a_855_368##8 a_1242_457##10 VNB sky130_fd_pr__nfet_01v8_lvt l=0.15 w=0.42 ad=0.1197 as=0.147 pd=1.41 ps=1.54
XM26 a_1242_457##10 a_1034_368# a_1354_138# VNB sky130_fd_pr__nfet_01v8_lvt l=0.15 w=0.42 ad=0.147 as=0.1008 pd=1.54 ps=1.32
XM9 a_1354_138# a_1383_349# a_1432_138# VNB sky130_fd_pr__nfet_01v8_lvt l=0.15 w=0.42 ad=0.1008 as=0.1008 pd=1.32 ps=1.32
XM12 a_1432_138# RESET_B#7 VGND#16 VNB sky130_fd_pr__nfet_01v8_lvt l=0.15 w=0.42 ad=0.1008 as=0.73575 pd=1.32 ps=3.69
XM36 VGND#16 a_1242_457##4 a_1383_349##5 VNB sky130_fd_pr__nfet_01v8_lvt l=0.15 w=0.74 ad=0.73575 as=0.2627 pd=3.69 ps=2.19
XM19 a_1383_349##5 a_1034_368##5 a_1824_74##7 VNB sky130_fd_pr__nfet_01v8_lvt l=0.15 w=0.74 ad=0.2627 as=0.5504 pd=2.19 ps=3.72
XM21 a_1824_74##7 a_855_368# a_2078_74# VNB sky130_fd_pr__nfet_01v8_lvt l=0.15 w=0.42 ad=0.5504 as=0.1008 pd=3.72 ps=1.32
XM20 a_2078_74# a_2082_446# VGND#15 VNB sky130_fd_pr__nfet_01v8_lvt l=0.15 w=0.42 ad=0.1008 as=0.1176 pd=1.32 ps=1.4
XM31 VGND#15 RESET_B#11 a_2242_74# VNB sky130_fd_pr__nfet_01v8_lvt l=0.15 w=0.42 ad=0.1176 as=0.0882 pd=1.4 ps=1.26
XM33 a_2242_74# a_1824_74##4 a_2082_446##4 VNB sky130_fd_pr__nfet_01v8_lvt l=0.15 w=0.42 ad=0.0882 as=0.1197 pd=1.26 ps=1.41
XM24 VGND#14 a_1824_74# a_2492_392##11 VNB sky130_fd_pr__nfet_01v8_lvt l=0.15 w=0.64 ad=0.1824 as=0.1824 pd=1.85 ps=1.85
XM16 VGND#13 a_2492_392##6 Q#2 VNB sky130_fd_pr__nfet_01v8_lvt l=0.15 w=0.74 ad=0.2109 as=0.2072 pd=2.05 ps=2.04
XM13 Q#2 a_2492_392# VGND#1 VNB sky130_fd_pr__nfet_01v8_lvt l=0.15 w=0.74 ad=0.2072 as=0.2109 pd=2.04 ps=2.05
XM28 a_27_74##9 SCE#5 VPWR#19 VPB sky130_fd_pr__pfet_01v8 l=0.15 w=0.64 ad=0.1888 as=0.6208 pd=1.87 ps=3.22
XM34 VPWR#19 SCE#1 a_340_464# VPB sky130_fd_pr__pfet_01v8 l=0.15 w=0.64 ad=0.6208 as=0.1728 pd=3.22 ps=1.82
XM18 a_340_464# D#1 a_390_81##6 VPB sky130_fd_pr__pfet_01v8 l=0.15 w=0.64 ad=0.1728 as=0.192 pd=1.82 ps=1.88
XM3 a_390_81##6 a_27_74##3 a_514_464# VPB sky130_fd_pr__pfet_01v8 l=0.15 w=0.64 ad=0.192 as=0.2496 pd=1.88 ps=2.06
XM10 a_514_464# SCD#3 VPWR#17 VPB sky130_fd_pr__pfet_01v8 l=0.15 w=0.64 ad=0.2496 as=0.2688 pd=2.06 ps=2.12
XM40 VPWR#17 RESET_B#4 a_390_81##7 VPB sky130_fd_pr__pfet_01v8 l=0.15 w=0.64 ad=0.2688 as=0.1888 pd=2.12 ps=1.87
XM22 a_855_368##12 CLK#4 VPWR#15 VPB sky130_fd_pr__pfet_01v8 l=0.15 w=1.12 ad=0.3304 as=0.336 pd=2.83 ps=2.84
XM27 VPWR#15 a_855_368##6 a_1034_368##13 VPB sky130_fd_pr__pfet_01v8 l=0.15 w=1.12 ad=0.336 as=0.3304 pd=2.84 ps=2.83
XM23 a_390_81##2 a_1034_368##3 a_1242_457##8 VPB sky130_fd_pr__pfet_01v8 l=0.15 w=0.42 ad=0.1239 as=0.126 pd=1.43 ps=1.44
XM7 a_1242_457##8 a_855_368##7 a_1332_457# VPB sky130_fd_pr__pfet_01v8 l=0.15 w=0.42 ad=0.126 as=0.1134 pd=1.44 ps=1.38
XM32 a_1332_457# a_1383_349##3 VPWR#13 VPB sky130_fd_pr__pfet_01v8 l=0.15 w=0.42 ad=0.1134 as=0.277675 pd=1.38 ps=2.32
XM17 VPWR#13 RESET_B#8 a_1242_457##9 VPB sky130_fd_pr__pfet_01v8 l=0.15 w=0.42 ad=0.277675 as=0.1239 pd=2.32 ps=1.43
XM4 VPWR#11 a_1242_457# a_1383_349##4 VPB sky130_fd_pr__pfet_01v8 l=0.15 w=1 ad=0.27685 as=0.49755 pd=2.59 ps=3.13
XM35 a_1383_349##4 a_855_368##2 a_1824_74##9 VPB sky130_fd_pr__pfet_01v8 l=0.15 w=1 ad=0.49755 as=0.44725 pd=3.13 ps=3.66
XM0 a_1824_74##9 a_1034_368##6 a_2037_508# VPB sky130_fd_pr__pfet_01v8 l=0.15 w=0.42 ad=0.44725 as=0.1008 pd=3.66 ps=1.32
XM29 a_2037_508# a_2082_446##3 VPWR#8 VPB sky130_fd_pr__pfet_01v8 l=0.15 w=0.42 ad=0.1008 as=0.294 pd=1.32 ps=2.24
XM5 VPWR#8 RESET_B#9 a_2082_446##6 VPB sky130_fd_pr__pfet_01v8 l=0.15 w=0.42 ad=0.294 as=0.126 pd=2.24 ps=1.44
XM25 a_2082_446##6 a_1824_74##6 VPWR#6 VPB sky130_fd_pr__pfet_01v8 l=0.15 w=0.42 ad=0.126 as=0.3828 pd=1.44 ps=2.87
XM6 VPWR#6 a_1824_74##5 a_2492_392##10 VPB sky130_fd_pr__pfet_01v8 l=0.15 w=1 ad=0.3828 as=0.295 pd=2.87 ps=2.59
XM15 Q#1 a_2492_392##7 VPWR#4 VPB sky130_fd_pr__pfet_01v8 l=0.15 w=1.12 ad=0.336 as=0.3304 pd=2.84 ps=2.83
XM37 VPWR#1 a_2492_392##5 Q#1 VPB sky130_fd_pr__pfet_01v8 l=0.15 w=1.12 ad=0.3864 as=0.336 pd=2.93 ps=2.84
*
*
*       RESISTOR AND CAP/DIODE CARDS
*
Rg1	a_27_74#	a_27_74##2	403.314087
Rg2	SCE#1	SCE#2	523.968933
Rg3	SCE#2	SCE#3	101.487701
Rg4	SCE#3	SCE#4	578.322266
Rg5	SCE#3	SCE#5	454.178406
Rg6	D#1	D#2	709.512146
Rg7	D#2	D#3	233.781555
Rg8	a_27_74##3	a_27_74##4	296.912354
Rg9	SCE#6	SCE#7	399.419281
Rg10	SCD#1	SCD#2	574.761475
Rg11	SCD#2	SCD#3	351.179199
Rg12	RESET_B#1	RESET_B#2	50.300888
Rg13	RESET_B#2	RESET_B#3	744.742188
Rg14	RESET_B#2	RESET_B#4	311.928345
Rg15	CLK#1	CLK#2	343.308899
Rg16	CLK#2	CLK#3	48.315460
Rg17	CLK#2	CLK#4	489.233673
Rg18	a_1034_368#	a_1034_368##2	629.802795
Rg19	a_1034_368##2	a_1034_368##3	298.746185
Rg20	a_1383_349#	a_1383_349##2	509.706146
Rg21	a_1383_349##2	a_1383_349##3	248.303986
Rg22	RESET_B#5	RESET_B#6	50.300888
Rg23	RESET_B#6	RESET_B#7	551.007507
Rg24	RESET_B#6	RESET_B#8	248.803528
Rg25	a_1242_457#	a_1242_457##2	408.064636
Rg26	a_1242_457##2	a_1242_457##3	48.064560
Rg27	a_1242_457##2	a_1242_457##4	341.183014
Rg28	a_1034_368##4	a_1034_368##5	686.927185
Rg29	a_1034_368##6	a_1034_368##7	248.303986
Rg30	a_855_368#	a_855_368##2	1380.115112
Rg31	a_855_368##2	a_855_368##3	1899.217896
Rg32	a_855_368##3	a_855_368##4	1495.336304
Rg33	a_855_368##4	a_855_368##5	183.186905
Rg34	a_855_368##5	a_855_368##6	453.555176
Rg35	a_855_368##3	a_855_368##7	296.970245
Rg36	a_855_368##4	a_855_368##8	501.901337
Rg37	a_855_368##5	a_855_368##9	324.944977
Rg38	a_2082_446#	a_2082_446##2	546.845398
Rg39	a_2082_446##2	a_2082_446##3	285.736267
Rg40	RESET_B#9	RESET_B#10	292.220825
Rg41	RESET_B#10	RESET_B#11	799.159363
Rg42	a_1824_74#	a_1824_74##2	334.579071
Rg43	a_1824_74##2	a_1824_74##3	123.561432
Rg44	a_1824_74##3	a_1824_74##4	395.132812
Rg45	a_1824_74##2	a_1824_74##5	545.776917
Rg46	a_1824_74##3	a_1824_74##6	682.040527
Rg47	a_2492_392#	a_2492_392##2	374.534637
Rg48	a_2492_392##2	a_2492_392##3	82.124687
Rg49	a_2492_392##3	a_2492_392##4	35.772793
Rg50	a_2492_392##2	a_2492_392##5	473.258270
Rg51	a_2492_392##3	a_2492_392##6	389.052795
Rg52	a_2492_392##3	a_2492_392##7	475.629547
Rf1	D	D#4	2.165378
Rf2	D#5	D#2	162.398178
Rf3	D#4	D#5	7.380112
Rf4	a_27_74##4	a_27_74##6	310.729065
Rf5	a_27_74##6	a_27_74##7	68.468300
Rf6	a_27_74##7	a_27_74##8	42.382935
Rf7	a_27_74##6	a_27_74##9	29.754587
Rf8	a_27_74##7	a_27_74##2	184.267532
Rf9	SCE#7	SCE	215.527863
Rf10	SCE	SCE#9	3.396243
Rf11	SCE#9	SCE	14.717052
Rf12	SCD	SCD#4	8.660800
Rf13	SCD#4	SCD	5.905091
Rf14	a_225_81#	a_225_81##2	189.706268
Rf15	RESET_B#1	RESET_B#13	160.920990
Rf16	RESET_B#14	RESET_B#15	0.688184
Rf17	RESET_B#13	RESET_B#14	5.117745
Rf18	CLK#3	CLK	88.614197
Rf19	a_855_368##5	a_855_368##11	166.354416
Rf20	a_855_368##11	a_855_368##12	71.135483
Rf21	a_855_368##11	a_855_368##13	83.052155
Rf22	a_390_81#	a_390_81##3	163.809052
Rf23	a_390_81##3	a_390_81##4	151.288513
Rf24	a_390_81##4	a_390_81##5	18.044025
Rf25	a_390_81##5	a_390_81##6	101.126427
Rf26	a_390_81##4	a_390_81##7	11.819120
Rf27	a_390_81##5	a_390_81##8	187.323883
Rf28	a_390_81##2	a_390_81##3	15.000000
Rf29	a_1242_457##3	a_1242_457##6	248.721649
Rf30	a_1242_457##6	a_1242_457##7	59.502655
Rf31	a_1242_457##7	a_1242_457##8	38.199654
Rf32	a_1242_457##6	a_1242_457##9	29.205271
Rf33	a_1242_457##7	a_1242_457##10	122.001526
Rf34	RESET_B#16	RESET_B#5	185.617279
Rf35	a_1383_349##4	a_1383_349##6	81.340477
Rf36	a_1383_349##6	a_1383_349##2	304.633118
Rf37	a_1383_349##5	a_1383_349##6	15.000000
Rf38	a_1034_368##7	a_1034_368##4	213.762543
Rf39	a_1034_368##4	a_1034_368##11	365.482483
Rf40	a_1034_368##11	a_1034_368##12	58.951870
Rf41	a_1034_368##12	a_1034_368##13	24.395369
Rf42	a_1034_368##12	a_1034_368##2	182.811096
Rf43	a_1034_368##10	a_1034_368##11	7.500000
Rf44	RESET_B#10	RESET_B	171.388443
Rf45	a_1824_74##7	a_1824_74##8	52.960350
Rf46	a_1824_74##8	a_1824_74##10	124.780128
Rf47	a_1824_74##10	a_1824_74##9	31.928770
Rf48	a_1824_74##8	a_1824_74##3	238.227539
Rf49	a_1824_74##9	a_1824_74##10	15.000000
Rf50	a_2082_446##4	a_2082_446##5	208.908554
Rf51	a_2082_446##5	a_2082_446##6	103.266579
Rf52	a_2492_392##4	a_2492_392##9	173.046844
Rf53	a_2492_392##9	a_2492_392##10	61.397648
Rf54	a_2492_392##9	a_2492_392##11	46.529354
Rf55	Q#1	Q	58.944824
Rf56	Q	Q#3	7.282945
Rf57	Q#3	Q	7.282945
Rf58	Q#2	Q#3	7.500000
Rf59	VPWR#1	VPWR#2	41.751957
Rf60	VPWR#2	VPWR#3	54.763340
Rf61	VPWR#3	VPWR#4	38.286041
Rf62	VPWR#3	VPWR#5	77.384460
Rf63	VPWR#5	VPWR#6	35.924004
Rf64	VPWR#5	VPWR#7	88.398598
Rf65	VPWR#7	VPWR#8	15.937577
Rf66	VPWR#7	VPWR#9	59.933441
Rf67	VPWR#9	VPWR#10	121.604546
Rf68	VPWR#10	VPWR#11	42.971458
Rf69	VPWR#10	VPWR#12	80.120956
Rf70	VPWR#12	VPWR#13	31.319780
Rf71	VPWR#12	VPWR#14	178.739136
Rf72	VPWR#14	VPWR#15	31.948624
Rf73	VPWR#14	VPWR#16	110.281715
Rf74	VPWR#16	VPWR#17	36.430706
Rf75	VPWR#16	VPWR#18	168.140366
Rf76	VPWR#18	VPWR#20	8.553795
Rf77	VPWR#20	VPWR#19	7.500000
Rf79	VPWR#19	VPWR#20	7.500000
Rf80	VGND#1	VGND#2	57.253010
Rf81	VGND#2	VGND#3	51.168163
Rf82	VGND#3	VGND#4	69.406258
Rf83	VGND#4	VGND#5	98.569107
Rf84	VGND#5	VGND#6	61.337887
Rf85	VGND#6	VGND#7	163.385269
Rf86	VGND#7	VGND#8	214.496078
Rf87	VGND#8	VGND#9	74.827690
Rf88	VGND#9	VGND#10	37.961727
Rf89	VGND#10	VGND#11	193.559280
Rf91	VGND#3	VGND#13	41.038895
Rf92	VGND#4	VGND#14	31.948624
Rf93	VGND#5	VGND#15	34.507496
Rf94	VGND#7	VGND#16	21.678009
Rf95	VGND#8	VGND#17	33.326477
Rf96	VGND#9	VGND#18	35.885353
Rf97	VGND#11	VGND#19	33.523315
Rf102	SCE#2	SCE#9	53.410934
Rf103	SCD#2	SCD#4	80.116402
Rf115	a_2082_446##2	a_2082_446##5	53.410934
Re2	RESET_B	RESET_B#16	4.743838
Re3	RESET_B#16	RESET_B#15	16.991604
Re4	VPWR#2	VPWR#23	6.363944
Re5	VPWR#23	VPWR	1.106290
Re6	VPWR	VPWR#16	2.173466
Re7	VGND#2	VGND#21	6.363944
Re8	VGND#21	VGND	1.106290
Re9	VGND	VGND#10	2.173466
Re14	VPWR#9	VPWR#23	0.698413
Re17	VGND#6	VGND#21	0.698413
*
*       CAPACITOR CARDS
*
*
C1	CLK#1	a_855_368##9	2.76359e-17
C2	a_1383_349##2	RESET_B#7	2.19602e-17
C3	RESET_B#3	VGND#18	2.03418e-17
C4	a_1824_74##5	a_2492_392##4	3.10097e-19
C5	a_390_81##2	a_855_368##7	9.9639e-18
C6	a_855_368##4	a_1034_368#	9.46278e-19
C7	RESET_B#16	a_1242_457##10	4.11165e-18
C8	RESET_B#16	a_855_368##7	1.44624e-18
C9	VPWR#13	a_855_368##6	9.29174e-19
C10	a_1383_349##2	a_1383_349#	1.10063e-17
C11	VGND#6	a_1824_74##7	2.96441e-17
C12	VPWR#15	a_1383_349##3	2.28139e-19
C13	a_855_368##13	SCD#1	6.26017e-19
C14	a_390_81#	a_390_81##2	1.14659e-18
C15	SCE#1	D#1	4.72343e-17
C16	VGND#1	a_2492_392#	2.13987e-17
C17	a_1242_457##8	a_1034_368##3	1.86538e-17
C18	VGND#1	VPWR#1	1.16636e-17
C19	a_1824_74##3	a_1824_74##5	1.01053e-17
C20	a_1034_368#	a_1383_349##2	1.24727e-17
C21	a_27_74##4	a_390_81##6	6.01702e-17
C22	a_225_81#	RESET_B#3	3.6384e-17
C23	RESET_B#16	a_390_81#	9.51651e-19
C24	a_855_368##11	CLK#2	7.86361e-18
C25	VGND#5	a_855_368#	6.5529e-19
C26	a_1034_368#	a_855_368##3	1.54461e-19
C27	a_2082_446##4	a_1824_74##5	2.85412e-18
C28	a_2492_392##10	VPWR#4	7.42616e-17
C29	VGND#2	VGND#3	1.25651e-17
C30	a_390_81##8	CLK#1	5.64332e-19
C31	a_390_81##2	a_1034_368##3	2.5754e-17
C32	VPWR#6	a_2492_392##9	1.82694e-18
C33	a_390_81##5	a_855_368##6	1.15877e-18
C34	RESET_B#16	a_1034_368##10	5.22687e-18
C35	VPWR#14	a_855_368##3	1.68552e-17
C36	a_2492_392#	Q#2	1.54402e-17
C37	VPWR#15	a_855_368##7	6.5329e-19
C38	RESET_B#10	a_1824_74##5	9.56487e-19
C39	RESET_B#3	CLK#1	4.96692e-18
C40	a_390_81#	a_1242_457##10	9.74326e-17
C41	SCE#5	SCE#1	3.13845e-18
C42	a_855_368##11	a_1034_368##10	2.65983e-17
C43	a_1034_368##13	a_390_81#	2.00531e-17
C44	a_390_81##6	SCE#7	2.34407e-18
C45	a_1034_368##13	a_1034_368##3	2.21434e-19
C46	VGND#7	a_1034_368##5	2.4425e-18
C47	VGND#1	a_2492_392##6	8.70259e-19
C48	RESET_B#10	a_1824_74##6	2.42007e-17
C49	a_855_368##8	a_1034_368##2	1.96683e-17
C50	a_225_81#	SCD#1	1.55728e-17
C51	a_2492_392##4	Q#2	2.28296e-20
C52	a_855_368##4	a_855_368##3	2.42741e-19
C53	VGND#13	VGND#1	2.12594e-18
C54	a_2082_446##2	a_1824_74##5	5.52743e-19
C55	a_390_81##2	a_855_368##6	2.63403e-17
C56	VPWR#6	VPWR#4	1.64286e-18
C57	VGND#13	a_2492_392#	7.69025e-19
C58	a_390_81##8	RESET_B#3	3.21931e-18
C59	a_855_368##11	RESET_B#2	2.6947e-19
C60	VPWR#15	a_1034_368##3	1.35665e-18
C61	a_2492_392##4	VGND#13	3.48995e-17
C62	VGND#18	a_390_81##5	2.36064e-18
C63	a_2082_446##2	a_1824_74##6	2.24634e-19
C64	a_1824_74##9	VPWR#7	2.27099e-17
C65	a_1824_74##9	a_2037_508#	2.35171e-18
C66	VGND#5	a_1034_368##5	1.15465e-19
C67	VPWR#14	RESET_B#1	3.15821e-19
C68	a_1034_368##10	a_1034_368##13	3.95948e-18
C69	a_2082_446##3	RESET_B#10	5.47837e-18
C70	a_855_368##5	a_855_368##8	4.11598e-20
C71	a_2492_392##6	Q#2	1.49333e-17
C72	a_390_81##5	CLK#4	3.00208e-17
C73	a_1034_368##13	a_855_368##6	3.05836e-17
C74	a_1034_368##10	a_1242_457##10	5.27077e-17
C75	a_1824_74##9	a_855_368#	4.55098e-19
C76	VGND#15	a_1824_74##8	1.71795e-17
C77	a_855_368##11	a_855_368##6	3.9626e-18
C78	a_1242_457##6	RESET_B#5	2.99535e-17
C79	SCD#1	RESET_B#3	2.30906e-17
C80	RESET_B#15	a_855_368##6	2.63707e-18
C81	a_855_368##11	VGND#17	2.39756e-17
C82	a_390_81##2	CLK#4	1.30713e-18
C83	a_225_81#	SCE#6	9.99207e-18
C84	VPWR#11	a_2037_508#	1.83062e-20
C85	a_390_81##5	a_855_368##9	4.00261e-19
C86	VGND#1	a_1824_74#	1.19977e-19
C87	RESET_B#16	VGND#7	2.33501e-18
C88	VPWR#16	a_1034_368##3	4.01213e-18
C89	a_1383_349##4	VPWR#10	7.79598e-18
C90	VPWR#6	a_2492_392##10	8.82668e-17
C91	VPWR#2	VPWR#1	2.09985e-17
C92	VPWR#15	a_855_368##6	3.52974e-17
C93	a_2082_446##2	a_2082_446##3	1.35201e-17
C94	VGND#10	a_855_368##7	5.70263e-19
C95	CLK#1	a_855_368##5	1.82212e-19
C96	a_390_81##8	SCD#1	2.2821e-17
C97	a_390_81##6	VPWR#17	8.8433e-18
C98	VPWR#12	a_855_368##3	4.95013e-17
C99	RESET_B#15	CLK#4	1.48825e-18
C100	a_2492_392##6	VGND#13	2.28519e-17
C101	VGND#7	a_1242_457##4	7.2259e-18
C102	a_390_81##5	a_1034_368##13	3.99826e-22
C103	VPWR#2	a_2492_392##2	4.5102e-20
C104	VPWR#3	a_2492_392##7	6.1968e-18
C105	a_1824_74##2	VGND#14	3.13933e-18
C106	a_2082_446##4	a_2492_392##4	1.69326e-18
C107	a_1034_368##13	CLK#4	2.0723e-18
C108	VGND#3	VGND#1	1.24095e-20
C109	a_2082_446##2	a_1034_368##6	4.04843e-19
C110	Q#1	VPWR#2	2.81722e-17
C111	a_225_81##2	RESET_B#3	2.24554e-19
C112	a_1242_457##3	a_855_368##3	5.74563e-20
C113	a_855_368##12	a_855_368##6	1.19017e-18
C114	a_1034_368##10	a_390_81#	9.23802e-17
C115	VPWR#7	a_1824_74##5	4.44981e-19
C116	VPWR#2	VPWR#3	1.14557e-17
C117	a_1034_368##7	a_2082_446##3	1.05552e-17
C118	a_225_81#	a_390_81##5	9.31588e-18
C119	a_2492_392##9	a_2492_392##5	4.14608e-19
C120	a_390_81##2	RESET_B#4	8.77026e-19
C121	a_2492_392##11	a_1824_74##3	8.97904e-20
C122	a_855_368##2	a_2082_446##2	8.34274e-19
C123	a_1242_457##7	a_1383_349##2	4.44854e-17
C124	a_390_81##5	RESET_B#4	3.64406e-17
C125	a_2492_392##9	a_2492_392##6	8.84699e-19
C126	VPWR#15	CLK#4	3.4973e-17
C127	a_225_81#	D#3	3.48904e-19
C128	VGND#2	VPWR#1	5.55873e-18
C129	RESET_B#15	a_390_81#	7.63651e-18
C130	a_855_368##11	CLK#4	7.64766e-19
C131	a_2492_392##11	a_2492_392##6	1.17144e-18
C132	RESET_B#3	CLK#3	5.81744e-18
C133	SCE#6	SCD#1	3.90637e-17
C134	a_1383_349##2	a_1242_457##6	4.11567e-17
C135	a_1824_74##7	a_2078_74#	8.89811e-21
C136	VPWR#16	RESET_B#4	4.87894e-18
C137	a_1242_457##3	RESET_B#6	1.4133e-17
C138	a_390_81##8	SCE#6	4.0659e-17
C139	VPWR#5	a_1824_74##5	4.59749e-18
C140	a_390_81##5	CLK#1	7.94466e-19
C141	a_1383_349##4	a_1034_368##5	9.98537e-19
C142	VGND#8	a_855_368##11	4.44979e-19
C143	a_1034_368##7	a_855_368##2	2.94453e-17
C144	a_855_368##12	CLK#4	3.20292e-17
C145	RESET_B#15	a_1034_368##10	4.27093e-18
C146	VGND#13	a_1824_74#	2.02217e-18
C147	a_225_81##2	SCD#1	2.17198e-19
C148	a_2082_446##4	a_1824_74##3	1.00233e-16
C149	a_855_368##11	a_390_81##2	4.78287e-18
C150	VPWR#16	SCD#3	4.46647e-18
C151	a_390_81##5	VPWR#15	2.42496e-17
C152	a_1034_368##7	a_1242_457#	1.21478e-19
C153	VPWR#15	RESET_B#4	2.95186e-18
C154	VGND#14	a_2492_392##6	6.47071e-19
C155	RESET_B#15	VGND#17	3.83715e-18
C156	VGND#7	RESET_B#7	3.11062e-18
C157	a_2082_446##6	VPWR#6	4.65702e-17
C158	a_1034_368##4	a_855_368##2	5.48977e-17
C159	a_225_81#	a_27_74#	2.31793e-19
C160	a_855_368##11	a_855_368##9	4.8058e-18
C161	VPWR#16	a_27_74##3	6.30869e-18
C162	VPWR#16	a_390_81#	3.57523e-19
C163	a_1242_457##9	VPWR#12	3.4263e-18
C164	VPWR#7	a_1824_74##6	1.47127e-18
C165	a_1242_457##7	a_1034_368##2	2.29828e-18
C166	a_390_81##5	SCD#3	2.30927e-17
C167	a_2492_392##9	a_2492_392##7	1.20112e-18
C168	VPWR#10	a_855_368##3	5.36867e-18
C169	D#3	a_390_81##8	1.23209e-17
C170	a_1824_74#	a_2492_392##11	2.59383e-17
C171	RESET_B#15	a_855_368##13	3.28519e-18
C172	a_1034_368##4	a_1242_457#	1.73069e-19
C173	VGND#15	a_1824_74##3	7.95356e-18
C174	VGND#2	a_2492_392##2	9.43571e-20
C175	VPWR#16	D#1	1.54686e-18
C176	a_2492_392##9	a_1824_74#	1.91572e-19
C177	a_2082_446##4	a_1824_74##2	2.22579e-17
C178	D#3	SCE#6	5.14626e-18
C179	SCD#2	RESET_B#3	2.48067e-18
C180	VPWR#17	CLK#4	7.737e-19
C181	a_1242_457##6	a_1034_368##2	1.80091e-20
C182	a_2492_392##11	VGND#13	4.90444e-17
C183	a_1242_457##3	a_855_368##2	3.68725e-18
C184	RESET_B#5	a_855_368##3	2.24544e-18
C185	a_225_81##2	SCE#6	7.554e-19
C186	a_390_81##5	RESET_B#3	1.38371e-17
C187	a_2082_446##4	a_2492_392##6	5.39404e-19
C188	VPWR#15	SCD#3	2.40619e-19
C189	RESET_B#15	VGND#18	2.88567e-18
C190	a_2082_446##4	RESET_B#10	1.25495e-19
C191	a_855_368##13	CLK#2	7.2327e-19
C192	VPWR#5	a_1824_74##6	7.72001e-18
C193	VGND#17	a_1034_368##10	4.12364e-17
C194	VPWR#16	SCE#1	8.41757e-19
C195	RESET_B#4	a_390_81##7	2.15916e-17
C196	VGND#10	a_1242_457##10	8.63901e-18
C197	a_1242_457##3	a_1242_457#	3.52836e-19
C198	a_855_368##11	a_1034_368##13	6.99427e-17
C199	VGND#9	VGND#8	1.15287e-18
C200	a_390_81##5	a_855_368##12	3.70553e-17
C201	VGND#14	a_1824_74#	3.51522e-17
C202	VPWR#12	VPWR#10	5.16303e-19
C203	a_1242_457##9	VPWR#10	2.97623e-18
C204	RESET_B#5	a_855_368##2	2.24654e-18
C205	VPWR#16	SCE#5	6.54467e-19
C206	VGND#19	SCE#6	2.62713e-19
C207	VGND#10	a_390_81#	1.23119e-17
C208	VPWR#5	a_1824_74##2	5.73947e-20
C209	a_390_81##8	a_27_74#	1.10166e-18
C210	a_855_368##11	CLK#1	7.08212e-18
C211	a_855_368##13	a_855_368##12	1.73242e-18
C212	RESET_B#4	VPWR#17	1.94539e-17
C213	a_390_81##8	a_390_81##5	2.55841e-18
C214	RESET_B#16	VPWR#12	5.4968e-18
C215	a_2492_392##11	a_1824_74##4	4.80628e-19
C216	RESET_B#5	a_1242_457#	1.06197e-17
C217	VGND#7	a_1383_349#	2.09406e-18
C218	a_390_81##5	a_27_74##3	8.64029e-19
C219	a_225_81##2	D#3	1.40808e-17
C220	VGND#10	a_1034_368##10	5.00009e-17
C221	VPWR#7	RESET_B#9	1.47221e-17
C222	a_2492_392##9	a_1824_74##5	5.2142e-18
C223	VGND#14	VGND#13	2.45642e-18
C224	a_27_74#	D#3	3.08355e-17
C225	a_2082_446##4	a_1824_74#	9.02074e-18
C226	a_2082_446##6	VPWR#8	4.07504e-19
C227	a_855_368##13	a_1034_368##10	2.46848e-18
C228	RESET_B#16	VPWR#10	6.40545e-18
C229	a_2082_446##2	a_2082_446##4	1.44407e-18
C230	RESET_B#16	VPWR#9	2.98241e-18
C231	a_1242_457##7	VPWR#12	6.81758e-18
C232	VGND#4	a_2492_392##11	9.00295e-18
C233	VGND#10	VGND#17	1.83368e-17
C234	a_1034_368##5	a_855_368##2	6.39999e-18
C235	a_1242_457##7	a_1242_457##6	2.92389e-18
C236	SCE#7	SCD#1	1.04334e-17
C237	VPWR#17	SCD#3	3.24696e-17
C238	VGND#14	a_1824_74##4	2.44402e-18
C239	VGND#19	D#3	4.14201e-19
C240	a_855_368##11	VPWR#15	1.49564e-18
C241	a_390_81##8	SCE#4	4.7568e-19
C242	a_390_81##5	a_390_81##7	2.49601e-18
C243	a_390_81##6	RESET_B#4	2.65468e-19
C244	a_390_81##6	a_514_464#	8.18396e-18
C245	VGND#5	VGND#14	2.43813e-20
C246	VGND#10	a_855_368##13	1.31741e-17
C247	a_390_81##5	a_855_368##5	5.21435e-20
C248	a_1383_349##2	a_855_368##3	1.5101e-18
C249	a_225_81##2	a_27_74#	3.52496e-17
C250	VPWR#13	VPWR#10	1.81986e-18
C251	VPWR#10	a_2082_446##3	2.39892e-19
C252	a_1034_368##10	a_1432_138#	2.74415e-19
C253	VGND#15	a_2082_446##2	5.76887e-19
C254	a_855_368##11	RESET_B#3	1.34363e-19
C255	VGND#3	a_2492_392##9	8.42772e-20
C256	a_27_74##8	D#3	1.10285e-19
C257	VGND#14	a_2492_392##11	2.98371e-17
C258	a_390_81##5	D#1	2.98427e-19
C259	a_855_368##13	VGND#17	3.45775e-17
C260	VPWR#2	a_2492_392##4	1.95596e-20
C261	a_2082_446##4	a_1824_74##4	3.99154e-17
C262	a_855_368##7	a_1383_349##2	4.94279e-18
C263	VPWR#17	a_27_74##3	3.48631e-18
C264	D#2	SCE#6	5.39376e-18
C265	SCE#4	a_27_74#	3.85297e-18
C266	VGND#7	a_1034_368#	2.99556e-18
C267	VGND#3	a_2492_392##11	5.95528e-18
C268	a_390_81##6	SCD#3	2.56371e-18
C269	VPWR#7	a_2082_446##3	2.10316e-17
C270	VGND#10	a_225_81#	1.28074e-16
C271	a_1383_349##2	RESET_B#6	3.40286e-17
C272	VGND#19	a_27_74#	3.1965e-18
C273	RESET_B#16	VPWR#16	1.22118e-17
C274	VPWR#13	RESET_B#7	5.28746e-19
C275	a_1034_368##3	a_1383_349##2	3.21814e-19
C276	VGND#2	a_2492_392##4	6.36986e-21
C277	VPWR#10	a_1034_368##5	5.47697e-19
C278	VGND#14	RESET_B#11	2.22877e-19
C279	VGND#15	a_1824_74#	3.43192e-19
C280	a_855_368##11	a_855_368##5	2.24536e-17
C281	a_1242_457##6	VPWR#12	1.10558e-18
C282	a_1034_368##2	a_855_368##7	5.67969e-18
C283	a_855_368##11	a_855_368##12	8.81787e-19
C284	a_27_74#	D#2	1.58349e-17
C285	a_225_81##2	SCE#4	2.02842e-18
C286	a_390_81##5	VPWR#17	5.96445e-17
C287	a_1824_74##9	a_2082_446##6	1.9175e-18
C288	VGND#18	RESET_B#2	1.5109e-19
C289	a_390_81##5	CLK#3	5.48235e-18
C290	VPWR#17	D#1	2.79983e-19
C291	a_27_74##8	a_27_74#	2.38168e-19
C292	VGND#8	a_855_368##8	2.06423e-18
C293	VGND#18	VGND#17	2.15298e-18
C294	VGND#5	a_2082_446##4	2.78554e-18
C295	VGND#10	a_390_81##8	1.68761e-17
C296	a_390_81##6	a_27_74##3	5.0538e-17
C297	RESET_B#6	a_1242_457#	1.41162e-18
C298	a_2082_446##4	a_2492_392##11	1.54219e-17
C299	VPWR#10	a_1034_368##6	4.36253e-19
C300	a_2082_446##4	RESET_B#11	4.331e-18
C301	a_1824_74##7	a_855_368##2	4.02945e-19
C302	a_855_368##4	a_1034_368##2	3.85641e-17
C303	a_390_81##5	SCE#1	2.43895e-19
C304	VGND#19	SCE#4	3.3786e-17
C305	a_1383_349##4	RESET_B#6	2.32374e-19
C306	VGND#14	VPWR#6	2.35957e-18
C307	VPWR#11	a_855_368##3	1.324e-19
C308	RESET_B#15	VPWR#16	5.98195e-17
C309	a_1242_457##10	a_1354_138#	4.71086e-20
C310	a_1824_74##7	a_1034_368##7	1.98368e-19
C311	SCE#4	a_27_74##2	1.56158e-17
C312	RESET_B#16	a_1824_74##9	3.43552e-17
C313	VGND#15	a_1824_74##4	5.1625e-18
C314	SCD	RESET_B#2	5.44588e-18
C315	a_1034_368##2	a_855_368##3	1.20907e-18
C316	VPWR#17	SCE#1	3.4042e-19
C317	VPWR#7	a_1034_368##6	3.71561e-18
C318	a_1383_349##5	a_855_368##2	2.3102e-18
C319	VGND#14	VGND#3	5.11342e-20
C320	a_1242_457##8	VPWR#12	7.83803e-18
C321	VGND#10	a_225_81##2	6.13177e-17
C322	a_390_81##6	D#1	3.78037e-17
C323	VGND#10	RESET_B#15	1.37492e-18
C324	a_27_74##8	SCE#4	1.23277e-17
C325	a_27_74#	SCE#2	7.84791e-18
C326	RESET_B#8	a_855_368##3	1.86836e-17
C327	a_1034_368##4	VGND#15	3.03422e-18
C328	RESET_B#16	a_1383_349##4	6.7642e-17
C329	CLK#4	a_855_368##5	7.69556e-19
C330	VGND#18	a_855_368##13	2.73222e-17
C331	VGND#10	VGND#9	6.79283e-17
C332	VGND#4	a_2082_446##4	1.64424e-17
C333	a_390_81##5	RESET_B#1	9.55627e-18
C334	VGND#10	VGND#19	1.85223e-17
C335	a_2082_446##4	VGND#14	3.68646e-17
C336	a_390_81##5	VPWR#14	7.00849e-18
C337	a_2082_446##4	VPWR#6	2.74167e-17
C338	a_2082_446##4	a_2082_446#	6.76785e-19
C339	RESET_B#16	VPWR#11	4.33714e-17
C340	a_390_81##2	VPWR#14	1.29233e-17
C341	a_1824_74##9	VPWR#9	3.29097e-17
C342	a_27_74##9	a_27_74##3	1.46532e-20
C343	VGND#10	VGND#8	1.17691e-16
C344	VGND#8	a_855_368##9	4.67408e-18
C345	VGND#10	a_27_74##8	1.68746e-17
C346	RESET_B#15	VPWR#14	8.87758e-18
C347	a_1034_368##4	a_1824_74##7	9.86224e-17
C348	a_390_81##6	SCE#1	6.71056e-18
C349	VPWR#10	a_855_368##2	5.1043e-17
C350	VGND#15	RESET_B#11	2.72716e-17
C351	a_1824_74##2	a_2492_392##6	9.22716e-19
C352	RESET_B#16	a_855_368##3	4.41124e-19
C353	a_1824_74##8	a_1824_74##4	2.42068e-20
C354	VGND#18	RESET_B#13	7.5574e-18
C355	RESET_B#16	a_1242_457##9	9.4333e-18
C356	RESET_B#16	a_1034_368##7	1.319e-17
C357	VGND#10	VGND#7	2.40243e-17
C358	a_1034_368##4	a_1383_349##5	1.75723e-16
C359	RESET_B#15	VPWR#12	9.00429e-19
C360	RESET_B#1	CLK#4	9.72166e-18
C361	a_1824_74##7	a_1824_74##4	1.31927e-19
C362	RESET_B#3	CLK#2	8.92364e-20
C363	VGND#6	a_2082_446##2	2.80523e-21
C364	VPWR#9	a_1034_368##7	4.18493e-19
C365	VPWR#7	a_855_368##2	2.03449e-18
C366	RESET_B#16	VPWR#13	4.18566e-18
C367	a_855_368##5	a_855_368##4	1.52752e-17
C368	a_1824_74##4	a_2242_74#	8.8457e-18
C369	RESET_B#16	a_1034_368##4	2.0654e-17
C370	RESET_B#13	CLK#3	1.17958e-18
C371	a_27_74##9	D#1	1.08832e-20
C372	a_390_81##2	VPWR#12	6.91221e-19
C373	a_1034_368##4	VGND#16	1.04142e-17
C374	a_390_81##6	a_390_81##5	1.789e-18
C375	a_1242_457##9	a_855_368##3	6.67301e-18
C376	RESET_B#11	a_2242_74#	8.8457e-18
C377	a_2082_446##4	a_855_368#	4.39727e-19
C378	VGND#9	CLK#1	1.04895e-18
C379	a_390_81##5	SCD#2	1.11449e-17
C380	RESET_B#16	RESET_B#6	7.99729e-19
C381	SCE#1	VPWR#19	2.16837e-17
C382	VPWR#9	a_1034_368##4	7.29874e-20
C383	a_1242_457##3	RESET_B#16	3.68251e-17
C384	VGND#15	a_2082_446#	2.51967e-17
C385	a_2492_392##7	a_2492_392##5	4.76335e-17
C386	a_1383_349##3	a_855_368##3	1.51487e-17
C387	VGND#6	a_1034_368##4	2.45572e-17
C388	a_1383_349##5	a_1242_457##3	1.00118e-16
C389	a_27_74##9	SCE#1	7.02958e-19
C390	a_2492_392##6	a_2492_392#	3.83551e-17
C391	RESET_B#16	a_1242_457##8	3.74817e-18
C392	VPWR#7	VPWR#5	9.24721e-19
C393	a_225_81#	VGND#18	5.00158e-17
C394	VPWR#16	VPWR#14	1.25012e-16
C395	RESET_B#16	RESET_B#5	2.17196e-17
C396	VGND#8	CLK#1	2.94497e-18
C397	a_1824_74##8	RESET_B#11	2.44845e-19
C398	VPWR#10	a_1242_457#	1.66245e-18
C399	a_1824_74##7	RESET_B#11	2.64283e-19
C400	a_2492_392##4	Q#1	1.20156e-18
C401	SCE#5	VPWR#19	2.31384e-17
C402	a_1383_349##4	a_1824_74##9	6.53725e-17
C403	CLK#2	a_855_368##5	3.34515e-17
C404	VPWR#1	a_2492_392##5	3.01669e-17
C405	RESET_B#16	a_390_81##2	2.94209e-17
C406	VPWR#16	VPWR#12	4.42484e-17
C407	VGND#15	VGND#14	1.74799e-18
C408	RESET_B#13	RESET_B#1	1.35634e-17
C409	RESET_B#16	a_1383_349##2	3.34476e-17
C410	a_1824_74##3	RESET_B#10	2.80139e-17
C411	a_27_74##4	SCD#3	5.78014e-18
C412	D#1	SCD#2	3.75856e-19
C413	a_2492_392##4	VPWR#4	3.88353e-17
C414	VPWR#7	a_1242_457#	2.63988e-19
C415	VGND#5	a_1824_74##8	1.60985e-18
C416	a_2492_392##9	a_2492_392##2	1.7374e-19
C417	a_27_74##4	a_390_81##5	1.66678e-18
C418	a_27_74##9	SCE#5	2.68231e-17
C419	a_1034_368##13	a_1034_368#	1.43082e-19
C420	VGND#15	a_855_368#	5.60963e-18
C421	a_2082_446##2	a_1824_74##3	1.05681e-16
C422	a_1383_349##3	RESET_B#6	5.69925e-19
C423	RESET_B#16	a_1034_368##2	2.9486e-18
C424	a_1034_368##10	a_1034_368##4	2.60546e-18
C425	a_2082_446##3	a_2037_508#	2.39305e-18
C426	VGND#9	RESET_B#3	9.06647e-19
C427	a_390_81##2	a_855_368##8	7.58544e-19
C428	a_1824_74##5	a_2492_392##7	6.76353e-18
C429	Q#1	a_2492_392##5	5.56324e-17
C430	a_2082_446#	a_2078_74#	2.39305e-18
C431	VPWR#12	RESET_B#8	2.78774e-18
C432	a_1383_349##5	RESET_B#5	9.3457e-19
C433	a_390_81##8	a_855_368##13	4.26518e-18
C434	a_27_74##4	D#1	5.3145e-17
C435	a_1034_368##6	a_2037_508#	7.48001e-18
C436	a_1824_74##7	a_2082_446#	5.54613e-18
C437	a_855_368#	a_2078_74#	7.57963e-18
C438	a_2082_446##2	RESET_B#10	1.4437e-16
C439	VPWR#11	a_1824_74##9	4.83498e-18
C440	VPWR#13	a_855_368##3	2.22087e-17
C441	CLK	CLK#2	1.25343e-17
C442	a_27_74##6	a_27_74##3	2.57082e-19
C443	VPWR#1	a_2492_392##7	1.30581e-18
C444	CLK	RESET_B#2	3.08804e-18
C445	a_27_74##4	SCE#1	1.26572e-17
C446	a_1824_74##8	a_2082_446#	1.7361e-17
C447	VGND#3	a_2492_392##4	3.65675e-19
C448	a_1824_74#	a_2492_392##6	3.81391e-18
C449	VGND#15	a_2082_446##4	1.8141e-17
C450	VPWR#4	a_2492_392##5	3.39114e-18
C451	VPWR#12	a_1034_368#	3.02323e-19
C452	a_390_81##8	a_390_81##6	3.5841e-18
C453	a_855_368##3	a_855_368##7	1.00422e-18
C454	RESET_B#15	a_1034_368##2	2.21229e-17
C455	a_1034_368##7	a_2082_446##2	2.32237e-17
C456	VGND#15	a_1034_368##5	4.92162e-19
C457	RESET_B#13	a_390_81##7	3.00342e-18
C458	a_2492_392##10	a_1824_74##3	2.4088e-20
C459	Q#1	a_2492_392##7	2.07361e-17
C460	SCE#7	a_390_81##5	2.43105e-18
C461	VPWR#16	a_1034_368##2	1.98917e-18
C462	VPWR#11	a_1383_349##4	4.6194e-17
C463	a_1383_349##2	a_1383_349##5	6.01489e-19
C464	a_2492_392##9	a_1824_74##2	1.82375e-17
C465	a_1824_74##6	a_1824_74##5	2.61761e-17
C466	a_1034_368##4	a_2082_446##2	8.84144e-19
C467	a_1824_74##7	a_855_368#	3.81417e-17
C468	VGND#5	a_1824_74##3	2.55556e-18
C469	VPWR#6	a_1824_74##3	1.78695e-18
C470	a_225_81#	a_547_81#	6.72118e-19
C471	VGND#10	a_1034_368##2	3.1157e-18
C472	VPWR#12	a_1383_349##3	2.26478e-18
C473	a_27_74##6	D#1	4.47457e-19
C474	VPWR#4	a_2492_392##7	8.00112e-17
C475	a_1242_457##7	a_855_368##4	1.74105e-19
C476	RESET_B#15	a_1242_457##8	1.18888e-18
C477	RESET_B#2	CLK#3	1.1441e-17
C478	a_1383_349##3	a_1332_457#	1.28314e-18
C479	RESET_B#15	CLK#3	6.63575e-18
C480	VGND#8	a_855_368##4	4.1981e-19
C481	VGND#4	a_1824_74##3	8.44892e-19
C482	a_2082_446##6	a_1824_74##3	2.71513e-18
C483	VGND#10	a_855_368##5	1.33552e-18
C484	a_855_368##7	a_1332_457#	6.47728e-18
C485	a_1824_74##8	a_855_368#	2.32935e-17
C486	Q#1	a_1824_74##5	3.88213e-19
C487	VPWR#5	VPWR#3	8.44973e-19
C488	SCE#2	D#1	1.61542e-17
C489	RESET_B#15	a_390_81##2	2.92613e-17
C490	a_1383_349##5	a_855_368#	2.47149e-19
C491	RESET_B#15	RESET_B#1	6.61596e-18
C492	a_1824_74##4	a_1824_74#	3.54492e-18
C493	a_225_81#	a_390_81##8	9.86142e-17
C494	RESET_B#7	a_1432_138#	6.69917e-18
C495	a_2492_392##10	a_2492_392##7	1.68703e-18
C496	a_855_368##4	a_1034_368##3	1.59582e-17
C497	VGND#10	CLK#3	2.05412e-18
C498	RESET_B#10	VPWR#6	1.20986e-17
C499	a_1034_368##4	a_1242_457##3	3.3279e-18
C500	a_1383_349#	a_1432_138#	7.05466e-18
C501	VPWR#16	RESET_B#1	1.49878e-18
C502	VGND#5	VGND#4	5.14881e-19
C503	RESET_B#9	a_1824_74##6	2.3475e-17
C504	a_1034_368##5	a_1824_74##7	2.36101e-17
C505	RESET_B#15	a_1034_368##13	3.59212e-17
C506	a_1242_457##10	a_1383_349##2	6.44755e-17
C507	VPWR#16	a_1242_457##8	9.85441e-18
C508	VPWR#4	a_1824_74##5	3.60681e-18
C509	VGND#2	a_2492_392#	1.04768e-17
C510	RESET_B#10	a_2082_446##6	2.82875e-17
C511	a_1034_368##4	RESET_B#5	5.58432e-19
C512	a_855_368##3	a_1034_368##3	1.91902e-17
C513	a_27_74##6	SCE#1	6.67027e-19
C514	VPWR#6	a_2492_392##7	4.64301e-19
C515	a_390_81#	a_1383_349##2	3.43967e-19
C516	RESET_B#16	a_1242_457##7	3.535e-17
C517	RESET_B#15	VPWR#15	1.90572e-18
C518	a_1824_74##7	a_2082_446##4	1.65832e-18
C519	RESET_B#15	a_27_74##4	4.01602e-18
C520	VPWR#16	a_390_81##2	2.35402e-17
C521	VGND#5	RESET_B#10	3.15645e-19
C522	a_1242_457##7	a_855_368##3	5.41077e-18
C523	a_1242_457##9	VPWR#11	3.16514e-17
C524	a_1242_457##3	RESET_B#5	4.11639e-17
C525	VGND#2	a_2492_392##6	4.80003e-18
C526	VGND#10	SCD#2	2.89689e-20
C527	a_1034_368##10	a_1383_349##2	4.56822e-17
C528	a_2492_392##10	a_1824_74##5	6.30803e-17
C529	a_1034_368##5	a_1383_349##5	2.10471e-17
C530	VPWR#16	a_27_74##4	1.19838e-17
C531	RESET_B#15	a_855_368##4	4.94056e-18
C532	a_1242_457##10	a_855_368##7	1.10019e-19
C533	a_2082_446##2	VPWR#6	1.5579e-18
C534	RESET_B#15	a_855_368##12	5.8548e-17
C535	RESET_B#16	a_1242_457##6	3.29535e-17
C536	VPWR#16	a_1034_368##13	3.58627e-18
C537	D#5	SCD#2	5.2411e-20
C538	SCD	a_390_81##5	8.43692e-17
C539	a_1383_349##2	a_1242_457##3	5.58249e-17
C540	a_1242_457##8	a_855_368##4	3.92857e-19
C541	VGND#2	a_1824_74#	1.57889e-20
C542	VPWR#4	a_1824_74##6	2.47802e-19
C543	SCD#3	a_514_464#	1.81643e-17
C544	VPWR#16	SCE#7	4.11261e-18
C545	a_1242_457##10	a_1034_368##2	2.28693e-18
C546	a_2082_446##3	RESET_B#9	4.76471e-18
C547	RESET_B#15	a_855_368##3	2.73801e-19
C548	RESET_B#11	a_1824_74##4	4.60885e-17
C549	a_2082_446##2	a_2082_446##6	8.72949e-18
C550	VGND#9	CLK	2.08232e-18
C551	a_27_74##6	a_27_74##4	2.44301e-19
C552	VPWR#16	VPWR#15	9.97599e-18
C553	a_27_74##3	a_514_464#	1.81643e-17
C554	a_1824_74##5	VPWR#6	2.67372e-17
C555	a_1383_349#	a_1354_138#	5.76507e-18
C556	a_1824_74##8	a_855_368##2	9.44184e-20
C557	VGND#10	SCE#7	5.9888e-18
C558	a_390_81#	a_1034_368##2	7.54132e-17
C559	VPWR#13	VPWR#11	6.35821e-18
C560	Q	a_2492_392##2	2.07524e-17
C561	a_225_81##2	a_312_81#	9.81252e-19
C562	a_1034_368#	a_1354_138#	7.57264e-18
C563	Q	a_1824_74##2	9.23831e-19
C564	VPWR#3	a_2492_392##4	2.2986e-20
C565	a_27_74##6	SCE#5	1.52175e-17
C566	VPWR#14	a_1034_368##3	3.22515e-19
C567	VPWR#16	a_855_368##12	2.69638e-18
C568	a_2492_392##10	a_1824_74##6	1.33177e-18
C569	VGND#10	a_1034_368##13	2.2741e-18
C570	a_1034_368##10	a_1034_368##2	1.08625e-18
C571	VGND#7	VGND#16	8.62914e-18
C572	a_855_368##6	a_855_368##4	2.83935e-17
C573	VGND#10	D#2	2.28458e-19
C574	a_1242_457##8	a_855_368##3	3.70228e-18
C575	a_1383_349##5	a_1242_457##4	4.85578e-17
C576	a_27_74##7	a_27_74##6	5.06307e-18
C577	a_1034_368##2	a_1383_349##2	1.67027e-17
C578	a_2082_446##6	a_1824_74##5	8.71732e-19
C579	D#1	a_340_464#	1.62684e-17
C580	VGND#5	a_2082_446##2	1.52885e-19
C581	VPWR#12	a_1034_368##3	1.90887e-18
C582	a_27_74##7	SCE#7	2.11242e-19
C583	VGND#10	a_27_74##2	7.83909e-18
C584	SCE#1	a_340_464#	1.62684e-17
C585	a_1824_74##9	a_2082_446##2	6.13245e-17
C586	a_1824_74##6	VPWR#6	2.73967e-17
C587	RESET_B#2	CLK#2	5.01974e-19
C588	a_390_81##5	a_855_368##11	5.81215e-18
C589	a_1034_368##6	a_2082_446##3	3.20974e-17
C590	VPWR#7	a_1824_74##3	8.67043e-20
C591	a_855_368##6	a_855_368##3	2.16257e-17
C592	VPWR#16	SCE#2	3.1236e-18
C593	VPWR#13	a_1242_457##9	7.75836e-18
C594	VPWR#16	VPWR#17	1.57949e-17
C595	a_1242_457##6	a_855_368##3	1.07385e-18
C596	VGND#10	a_855_368##12	3.25738e-18
C597	a_390_81#	a_855_368##5	8.66303e-21
C598	a_27_74##7	D#3	1.59115e-19
C599	a_1242_457##4	VGND#16	1.4083e-17
C600	VGND#10	SCE#2	3.70646e-18
C601	a_1383_349##4	a_2082_446##2	9.47861e-20
C602	a_1824_74##7	VGND#15	1.81054e-17
C603	VPWR#5	a_1824_74##3	6.02925e-20
C604	a_2082_446#	RESET_B#11	4.34975e-17
C605	a_2492_392##9	a_2492_392##4	7.11162e-19
C606	D#5	SCD#1	7.51224e-19
C607	a_855_368##3	a_1432_138#	3.75038e-19
C608	a_1034_368##10	a_855_368##5	2.69141e-18
C609	a_2082_446##6	a_1824_74##6	3.50389e-17
C610	a_1383_349##5	RESET_B#7	6.30776e-18
C611	a_390_81##2	a_855_368##4	2.67778e-17
C612	VGND#4	VGND#3	9.61002e-19
C613	SCD#2	RESET_B#2	4.81246e-17
C614	VPWR#16	a_855_368##3	2.56354e-18
C615	VPWR#14	a_855_368##6	3.95658e-18
C616	a_855_368##5	VGND#17	8.29e-19
C617	a_1034_368##7	a_1824_74##9	1.12495e-16
C618	VPWR#6	RESET_B#9	1.17386e-18
C619	a_27_74##7	SCE	9.26058e-18
C620	a_1242_457##7	RESET_B#6	3.10814e-19
C621	D#5	SCE#7	1.11062e-17
C622	a_390_81##6	VPWR#16	3.52393e-17
C623	a_27_74##6	SCE	3.54424e-17
C624	a_27_74##7	D#2	4.39239e-19
C625	a_855_368##2	a_1034_368##6	9.73306e-18
C626	D#5	SCE	1.42431e-17
C627	a_1383_349##4	a_1034_368##7	3.27416e-18
C628	a_390_81##5	CLK	2.23797e-17
C629	VPWR	a_855_368##3	2.3188e-18
C630	RESET_B#7	VGND#16	1.36205e-17
C631	CLK#3	RESET_B#1	9.88765e-18
C632	a_225_81##2	a_390_81##8	1.4392e-17
C633	a_27_74##7	a_27_74#	4.1776e-19
C634	CLK	a_855_368##11	3.57708e-17
C635	VPWR#7	RESET_B#10	8.43478e-19
C636	a_390_81##2	a_855_368##3	8.64872e-18
C637	a_2082_446##6	RESET_B#9	4.18988e-17
C638	D#5	SCE#6	1.00095e-18
C639	Q#1	a_2492_392##2	2.29334e-18
C640	a_1383_349##5	a_1383_349#	2.79476e-19
C641	a_1034_368##4	a_1824_74##9	1.5779e-17
C642	CLK	RESET_B#13	4.61489e-18
C643	a_27_74##7	a_390_81##8	1.81818e-21
C644	VPWR#6	a_2082_446##3	3.12908e-19
C645	a_855_368#	a_2082_446#	5.42387e-17
C646	a_2492_392##9	a_1824_74##3	1.39627e-18
C647	a_390_81##8	SCD	3.23654e-17
C648	RESET_B#9	VPWR#8	6.18196e-18
C649	a_1034_368##4	a_1383_349##4	9.18071e-18
C650	D#5	D#2	1.80528e-17
C651	VPWR#16	a_27_74##9	1.7688e-17
C652	a_855_368##13	CLK#3	3.691e-18
C653	a_1242_457#	a_855_368##2	4.09996e-17
C654	VGND#3	Q	3.56182e-18
C655	VPWR#14	CLK#4	3.25086e-18
C656	VGND#10	a_855_368##4	5.83544e-19
C657	a_1242_457##10	a_1242_457##4	2.95461e-19
C658	VPWR#16	RESET_B#2	7.99159e-19
C659	RESET_B#16	a_1034_368##5	3.22084e-18
C660	a_2082_446##6	a_2082_446##3	7.98632e-19
C661	VGND#19	a_390_81##8	2.90667e-18
C662	VGND#18	CLK#3	3.29922e-18
C663	VGND#7	a_1034_368##4	1.05734e-16
C664	a_27_74##2	a_27_74##6	3.82993e-19
C665	SCD#1	a_547_81#	7.05199e-18
C666	a_27_74##4	SCD#2	2.38493e-17
C667	a_1034_368##13	a_855_368##4	3.50369e-17
C668	a_27_74##7	SCE#4	1.68422e-17
C669	Q#1	a_1824_74##2	8.14433e-21
C670	SCE#6	a_547_81#	7.05199e-18
C671	a_27_74##4	RESET_B#2	4.80291e-19
C672	a_2492_392##9	VGND#13	7.63289e-18
C673	D#5	D#3	4.64636e-18
C674	a_390_81##5	a_855_368##4	3.96915e-19
C675	a_1383_349##5	a_1034_368#	1.59372e-19
C676	a_1242_457##6	RESET_B#6	1.06234e-17
C677	SCE#7	SCD#2	3.27786e-17
C678	a_2492_392##9	Q	2.69228e-18
C679	a_2082_446##2	VPWR#7	3.35149e-17
C680	a_2082_446##3	VPWR#8	1.35859e-17
C681	a_27_74##4	SCE#3	1.61252e-19
C682	a_1242_457##3	a_1383_349##4	3.0813e-18
C683	SCE#7	a_27_74##4	6.8659e-17
C684	a_225_81##2	SCE	1.60086e-18
C685	D#2	SCD#2	1.86501e-18
C686	a_2492_392##9	VPWR#3	4.40843e-19
C687	a_1824_74##9	RESET_B#9	4.4737e-19
C688	RESET_B#16	RESET_B#7	2.89131e-18
C689	VGND#8	CLK#2	2.69034e-20
C690	a_2492_392##9	RESET_B#10	4.11222e-19
C691	a_1034_368##5	a_855_368#	3.09317e-18
C692	a_2082_446##2	VPWR#5	4.09412e-19
C693	RESET_B#15	a_390_81##5	3.28418e-17
C694	a_27_74##7	D	7.65885e-19
C695	RESET_B#8	a_1242_457#	4.25503e-18
C696	a_2082_446##6	a_1034_368##6	1.31628e-19
C697	VPWR#11	a_1242_457##3	8.82411e-19
C698	a_27_74##4	D#2	4.19874e-19
C699	VGND#6	a_855_368#	6.73992e-18
C700	a_1034_368##13	a_855_368##3	8.74751e-21
C701	VPWR#16	a_1242_457##7	4.99044e-18
C702	a_27_74##8	a_390_81##8	7.0707e-21
C703	a_1242_457##10	RESET_B#7	6.10875e-19
C704	VGND#18	RESET_B#1	2.85853e-18
C705	a_1242_457##7	a_1332_457#	2.30893e-18
C706	a_2492_392##4	a_2492_392##2	3.54001e-18
C707	SCE#7	D#2	4.89844e-17
C708	a_1242_457##3	a_1242_457##9	1.45143e-18
C709	a_1824_74##8	a_1824_74##3	3.00307e-18
C710	CLK	a_855_368##13	3.50057e-17
C711	SCE#2	a_27_74##6	5.57203e-17
C712	a_1383_349##5	VPWR#11	6.5273e-19
C713	VGND#18	CLK	4.84356e-18
C714	a_1034_368##10	a_1242_457##4	1.18372e-18
C715	VGND#6	a_1034_368##5	2.37584e-18
C716	a_1383_349##4	RESET_B#5	6.4591e-19
C717	VGND#10	CLK#2	5.13192e-20
C718	a_27_74##4	SCE#2	1.39231e-17
C719	a_1824_74##2	a_2492_392##4	8.66465e-18
C720	RESET_B#2	CLK#4	1.74218e-18
C721	VGND#7	a_1242_457##3	1.39986e-19
C722	VPWR	VPWR#12	7.02567e-17
C723	D#3	a_312_81#	6.86229e-18
C724	RESET_B#16	a_1034_368#	4.41763e-19
C725	VPWR	VPWR#10	9.43546e-17
C726	a_390_81##5	a_855_368##3	2.62457e-19
C727	a_1824_74##9	a_2082_446##3	8.95995e-18
C728	VPWR	VPWR#7	1.04127e-16
C729	a_27_74#	a_312_81#	8.27954e-18
C730	a_27_74##2	D#2	3.41283e-18
C731	VPWR	VPWR#5	6.45514e-17
C732	VPWR	VPWR#3	4.61941e-17
C733	VPWR	a_2492_392##9	1.77904e-18
C734	VGND#19	a_225_81##2	3.0377e-17
C735	a_1383_349##3	RESET_B#8	1.10041e-17
C736	SCE#2	D#2	1.97761e-17
C737	VPWR#13	a_1034_368##13	1.21377e-20
C738	a_855_368##7	a_1242_457#	1.09047e-19
C739	a_1242_457##10	a_1383_349#	7.12229e-18
C740	RESET_B#15	a_855_368##11	2.42662e-17
C741	RESET_B#5	a_1242_457##9	3.26105e-17
C742	a_390_81##5	VPWR#16	5.70824e-17
C743	SCE#7	RESET_B#2	1.23483e-19
C744	a_27_74##2	SCE#2	6.40712e-17
C745	VGND#10	SCE#3	1.80992e-20
C746	a_2492_392##9	a_2082_446##2	2.49607e-19
C747	a_1242_457##4	a_1034_368##5	2.40381e-17
C748	a_225_81#	SCD#2	1.23698e-18
C749	Q	VGND#1	6.52324e-17
C750	a_1034_368##10	RESET_B#7	1.61782e-17
C751	a_390_81##2	RESET_B#2	7.45857e-20
C752	SCE#7	SCE#3	4.20449e-19
C753	VGND#13	Q	6.52967e-17
C754	a_1824_74##9	a_1034_368##6	3.79452e-17
C755	VPWR	a_1242_457##7	7.24441e-18
C756	a_27_74##4	a_514_464#	4.28519e-19
C757	VPWR	a_1242_457##6	3.4595e-18
C758	VGND#2	VGND#1	1.22045e-17
C759	a_27_74##7	SCE#3	2.44445e-17
C760	a_225_81##2	D	1.37924e-17
C761	VGND	a_1824_74##2	4.0561e-18
C762	a_1242_457##6	a_855_368##2	2.41916e-19
C763	a_1242_457##6	a_1383_349##4	2.57839e-18
C764	a_390_81##2	a_1242_457##8	5.3481e-17
C765	VPWR#11	a_2082_446##3	2.575e-19
C766	a_390_81##8	SCD#2	8.05718e-18
C767	VPWR#15	a_855_368##3	5.25561e-18
C768	VGND#19	a_27_74##7	4.40484e-18
C769	a_855_368##7	a_1383_349##3	3.32403e-17
C770	CLK	a_855_368##12	2.31283e-17
C771	a_1242_457##10	a_1242_457##7	2.83957e-19
C772	VPWR#10	a_1034_368##4	5.56095e-20
C773	a_1242_457##10	a_1034_368#	4.72113e-17
C774	a_1824_74##3	a_1824_74#	9.79661e-19
C775	VGND#7	RESET_B#5	6.43337e-19
C776	RESET_B	VPWR#7	7.99634e-18
C777	VPWR#13	a_1383_349##2	9.41822e-19
C778	VPWR#16	a_855_368##11	1.23561e-18
C779	D#5	a_390_81##8	1.55927e-17
C780	RESET_B	a_2492_392##9	4.85925e-19
C781	a_1383_349##5	VGND#16	1.06138e-17
C782	a_1034_368##10	a_1383_349#	8.89088e-18
C783	VGND#10	a_390_81##5	3.32379e-18
C784	a_1824_74##3	a_1824_74##2	5.54461e-18
C785	a_1824_74##9	a_855_368##2	5.93885e-17
C786	a_1034_368##13	CLK#2	9.2442e-20
C787	a_1383_349##2	a_1432_138#	8.16991e-20
C788	RESET_B	a_1824_74##8	2.89247e-18
C789	VGND#3	a_2492_392#	6.13846e-19
C790	VPWR#11	a_1034_368##6	2.27928e-19
C791	RESET_B#7	a_1242_457##4	2.89064e-18
C792	VGND#8	a_1034_368##10	5.68853e-17
C793	VPWR	a_2082_446##4	2.52957e-18
C794	a_390_81#	a_1034_368#	8.17791e-18
C795	a_1824_74##3	RESET_B#11	3.99749e-17
C796	a_27_74##8	VGND#19	3.46752e-17
C797	a_855_368##2	a_1383_349##4	3.92387e-17
C798	a_1242_457##6	a_1242_457#	1.65894e-19
C799	a_390_81##5	RESET_B#13	5.29063e-17
C800	a_1824_74##8	a_2082_446##2	9.42778e-17
C801	RESET_B#15	RESET_B#13	1.86582e-17
C802	a_1034_368##3	a_855_368##7	3.04726e-17
C803	a_1242_457##10	a_855_368##8	1.07064e-17
C804	SCE	a_27_74#	2.64346e-18
C805	VGND#9	VGND#17	4.69243e-20
C806	a_390_81##2	a_1383_349##2	5.36634e-19
C807	VGND	VGND#7	1.44614e-16
C808	a_225_81#	SCE#7	4.72365e-19
C809	VGND	VGND#5	9.21166e-17
C810	SCE#3	D#2	9.4897e-19
C811	a_1824_74##9	a_1242_457#	2.01819e-18
C812	a_390_81##5	a_340_464#	2.79171e-21
C813	VGND	VGND#4	6.97876e-17
C814	VGND	VGND#3	5.52028e-17
C815	a_390_81#	a_1242_457##7	7.95617e-18
C816	VPWR#2	a_2492_392##5	8.10088e-18
C817	Q#1	VPWR#3	4.03581e-18
C818	a_1034_368##10	a_1034_368#	1.06936e-17
C819	a_390_81##2	a_1034_368##13	5.35386e-17
C820	CLK	CLK#1	1.12539e-18
C821	a_27_74##6	SCE#3	2.57617e-17
C822	a_1242_457##7	a_1242_457##9	2.29492e-18
C823	a_1034_368##13	a_1383_349##2	1.09901e-20
C824	VPWR#11	a_855_368##2	4.38071e-18
C825	VPWR#10	a_1242_457##3	2.27791e-19
C826	CLK	RESET_B#3	1.99957e-18
C827	a_1824_74##3	a_855_368#	1.63119e-19
C828	VGND#10	a_855_368##11	4.6936e-18
C829	a_2082_446##4	a_2492_392##9	3.21233e-17
C830	VGND#7	a_1383_349##2	1.4888e-19
C831	VGND	a_2492_392##9	2.66916e-18
C832	VGND#7	a_1034_368##10	7.10202e-17
C833	a_1242_457##8	a_1034_368##2	4.90242e-19
C834	a_1242_457##7	RESET_B#8	1.10356e-18
C835	VPWR	VPWR#4	2.04215e-17
C836	a_390_81#	a_855_368##8	4.71899e-17
C837	VPWR	a_2492_392##10	1.91832e-17
C838	a_390_81##8	SCE#7	3.94156e-17
C839	VPWR#2	a_2492_392##7	2.98209e-18
C840	VGND	a_1824_74##8	4.96764e-18
C841	VPWR	VPWR#6	2.06778e-17
C842	a_1242_457#	a_1383_349##4	3.40091e-17
C843	RESET_B	VGND#15	3.7016e-18
C844	VPWR	a_2082_446##6	1.95299e-17
C845	RESET_B	a_1824_74##7	2.64246e-18
C846	VGND#10	a_1034_368#	4.70185e-19
C847	VPWR	a_1824_74##9	3.55867e-17
C848	a_1383_349#	RESET_B#7	4.45541e-17
C849	a_1034_368##2	a_390_81##2	5.35737e-17
C850	Q	a_2492_392#	2.47434e-17
C851	VPWR	a_1383_349##4	1.47632e-17
C852	VGND#3	a_2492_392##6	1.04788e-17
C853	VGND#5	a_1824_74#	7.57513e-20
C854	Q	a_2492_392##6	2.30844e-17
C855	VPWR	a_1242_457##9	1.11923e-17
C856	VPWR	VPWR#13	1.0279e-17
C857	VPWR#16	RESET_B#13	2.19319e-18
C858	SCD	D#1	2.45987e-19
C859	a_2082_446##2	RESET_B#11	3.70331e-18
C860	a_390_81##2	VPWR#15	2.18675e-17
C861	SCD#3	RESET_B#2	2.55296e-18
C862	a_1242_457##6	RESET_B#8	1.33405e-17
C863	a_225_81##2	SCE#7	1.08078e-18
C864	a_1034_368##13	a_1034_368##2	1.85919e-19
C865	D	D#3	8.03783e-19
C866	a_1034_368##7	a_1824_74##8	2.007e-17
C867	VPWR#11	a_1242_457#	4.94555e-17
C868	D	a_27_74#	9.84508e-18
C869	a_1034_368##10	a_855_368##8	8.67844e-18
C870	D	SCE#4	1.07015e-18
C871	a_390_81##5	CLK#2	2.93486e-19
C872	a_225_81##2	D#5	1.22558e-17
C873	VPWR#13	a_855_368##2	4.11961e-19
C874	VPWR#12	RESET_B#5	2.63647e-19
C875	RESET_B	VPWR#4	2.19903e-18
C876	SCE	D#1	1.81432e-18
C877	VGND#9	a_855_368##13	1.17265e-18
C878	RESET_B	a_2492_392##10	1.17489e-18
C879	a_1383_349##4	RESET_B#8	3.08559e-19
C880	VGND#10	a_855_368##9	2.08404e-18
C881	RESET_B	VPWR#6	5.35622e-18
C882	a_1242_457##7	VPWR#13	1.02614e-17
C883	D#2	a_390_81##8	3.10539e-18
C884	RESET_B	a_2082_446##6	9.45967e-18
C885	a_390_81#	a_855_368##9	7.89669e-19
C886	VGND#8	a_1034_368##2	1.72253e-20
C887	VGND#4	a_1824_74#	2.93981e-18
C888	VGND	a_2492_392##11	1.72821e-17
C889	a_390_81##2	a_855_368##5	4.44118e-19
C890	a_27_74##6	a_27_74##9	2.12367e-20
C891	VGND	VGND#14	1.36041e-17
C892	RESET_B	a_1824_74##9	2.82465e-17
C893	VGND	a_2082_446##4	2.26491e-17
C894	a_1242_457##9	a_1242_457#	8.36013e-19
C895	a_855_368#	a_2082_446##2	3.06443e-17
C896	RESET_B#5	VPWR#10	2.59125e-18
C897	VPWR#6	a_1824_74##2	1.0617e-18
C898	a_390_81#	a_855_368##4	1.28517e-17
C899	RESET_B#15	SCD	2.92501e-18
C900	CLK#4	a_855_368##6	4.88784e-17
C901	VGND	a_1824_74##7	3.3085e-17
C902	a_1242_457##7	a_1383_349##3	2.08567e-17
C903	VGND	a_1383_349##5	1.53202e-17
C904	VPWR#16	SCD	4.25286e-18
C905	a_855_368##11	a_855_368##4	1.73696e-18
C906	VGND#10	CLK#1	1.86065e-18
C907	VGND#7	a_1034_368##2	2.84537e-20
C908	a_1034_368##13	a_855_368##5	5.82923e-18
C909	SCE#3	a_27_74##2	7.33778e-18
C910	VGND	a_1242_457##10	2.96975e-18
C911	VGND#10	SCD	3.33083e-18
C912	VGND	a_1034_368##10	2.26154e-17
C913	VPWR#11	RESET_B#8	2.81661e-18
C914	a_225_81##2	D#2	5.31023e-18
C915	a_2492_392##10	VPWR#5	1.00082e-17
C916	a_1034_368#	a_1383_349#	4.7131e-17
C917	VGND#10	RESET_B#13	3.21119e-18
C918	a_1034_368##10	a_855_368##9	4.91181e-17
C919	VPWR#13	a_1242_457#	1.29469e-18
C920	a_2492_392##2	VNB	4.10031e-17
C921	a_1824_74##2	VNB	4.38549e-17
C922	VPWR#16	SCE	4.26664e-18
C923	VGND#10	RESET_B#3	5.69253e-18
C924	a_855_368##4	VNB	6.72028e-17
C925	a_855_368##3	VNB	1.77244e-16
C926	RESET_B#6	VNB	2.40705e-17
C927	CLK#2	VNB	1.93164e-17
C928	VGND#10	SCE	4.91348e-18
C929	a_1242_457##6	a_1383_349##3	1.15429e-18
C930	RESET_B#2	VNB	3.77176e-17
C931	VGND#3	a_1824_74#	8.17458e-19
C932	SCE#3	VNB	5.24914e-17
C933	a_1242_457##6	RESET_B#7	4.67117e-19
C934	VGND#5	a_1824_74##4	8.21302e-18
C935	VGND	VPWR#4	3.72084e-18
C936	a_1242_457##6	VPWR#13	2.94869e-17
C937	a_1034_368##7	a_855_368#	1.41869e-17
C938	a_2492_392##2	Q#2	3.40161e-19
C939	VGND	VPWR#6	1.2194e-18
C940	VGND#8	a_855_368##13	1.00723e-17
C941	a_1034_368##4	a_1824_74##8	6.28594e-17
C942	a_390_81##5	RESET_B#2	2.139e-17
C943	RESET_B	a_855_368#	1.56542e-18
C944	a_1242_457##9	RESET_B#8	2.81776e-17
C945	VGND	a_1824_74##9	2.8532e-18
C946	VPWR	a_2492_392##7	9.78207e-19
C947	CLK	RESET_B#15	2.555e-17
C948	VGND	a_1383_349##4	1.34247e-18
C949	VPWR	a_1824_74##5	5.33321e-18
C950	VPWR#7	VPWR#6	1.75558e-18
C951	VPWR#16	CLK	8.35173e-19
C952	VGND#10	SCD#1	4.0223e-18
C953	VPWR	a_1824_74##6	1.94003e-18
C954	a_855_368##12	a_1034_368##13	2.82613e-18
C955	VGND#10	CLK	8.3511e-18
C956	VPWR	a_2082_446##3	1.92677e-18
C957	RESET_B#4	CLK#4	4.61647e-18
C958	a_1034_368##4	a_2082_446#	4.64486e-19
C959	a_390_81#	a_855_368##3	1.34954e-19
C960	VPWR	a_855_368##2	8.38406e-18
C961	VPWR	a_1242_457#	1.81861e-18
C962	a_855_368##9	VGND#17	1.72429e-17
C963	VPWR#11	a_1383_349##3	3.34514e-19
C964	VPWR	RESET_B#8	3.16574e-18
C965	VPWR	a_1383_349##3	3.18644e-18
C966	a_2492_392##9	Q#1	3.74812e-18
C967	a_2492_392##10	VPWR#3	7.70686e-18
C968	VGND#10	SCE#6	4.60767e-18
C969	a_2082_446##2	a_1824_74##2	4.03523e-20
C970	a_27_74##2	a_225_81##2	1.01953e-17
C971	VGND#9	VNB	2.74672e-17
C972	VGND#8	VNB	6.26429e-17
C973	VPWR#2	Q	1.21347e-18
C974	VGND#7	VNB	8.98153e-17
C975	SCD	SCD#2	2.83061e-17
C976	VGND#5	VNB	3.63374e-17
C977	VGND#10	D	4.5337e-18
C978	RESET_B#8	VPWR#13	1.7914e-17
C979	VGND#4	VNB	3.78119e-17
C980	VGND#2	Q	3.15029e-17
C981	VGND#3	VNB	2.76954e-17
C982	a_1242_457##7	a_855_368##7	1.19133e-17
C983	VGND#8	a_855_368##5	6.74959e-20
C984	a_1034_368##4	a_855_368#	4.02801e-17
C985	VGND	a_1824_74#	4.40329e-18
C986	a_27_74##4	SCD	3.08273e-17
C987	RESET_B	a_2492_392##7	2.46581e-21
C988	VPWR#14	VNB	6.31754e-17
C989	VGND	a_1824_74##4	8.96279e-19
C990	VPWR#12	VNB	4.39376e-17
C991	VPWR#10	VNB	3.85016e-17
C992	VGND	RESET_B#11	7.27613e-19
C993	VPWR#7	VNB	4.15587e-17
C994	VPWR#5	VNB	3.22806e-17
C995	VGND	a_2082_446#	4.55511e-19
C996	SCE#7	SCD	2.29257e-17
C997	VPWR#3	VNB	3.06415e-17
C998	a_1034_368##10	CLK#1	2.99508e-18
C999	VGND	a_855_368#	3.99337e-19
C1000	RESET_B#7	a_855_368##3	2.21936e-19
C1001	a_27_74##2	VGND#19	3.9147e-17
C1002	a_2492_392##9	VNB	1.07765e-17
C1003	VGND	a_1034_368##5	4.76439e-18
C1004	VPWR#16	a_27_74##6	4.42899e-18
C1005	SCD	D#2	5.14038e-19
C1006	VGND	a_1242_457##4	2.20824e-18
C1007	a_855_368##12	CLK#3	4.04474e-18
C1008	VGND	RESET_B#7	6.7098e-18
C1009	SCE	SCD#2	4.88797e-19
C1010	a_1824_74##8	VNB	1.27775e-17
C1011	Q#1	VPWR#1	1.06053e-16
C1012	SCE	a_27_74##4	3.90319e-17
C1013	a_1242_457##9	a_1383_349##3	7.43326e-19
C1014	CLK	a_855_368##5	3.68864e-18
C1015	SCD	SCE#2	4.49831e-19
C1016	a_1034_368##4	a_1034_368##5	3.77915e-17
C1017	CLK	CLK#3	2.17989e-17
C1018	a_855_368##12	VPWR#15	2.40685e-19
C1019	a_1242_457##7	VNB	6.47097e-18
C1020	a_855_368##8	a_1034_368#	3.05809e-17
C1021	Q	a_2492_392##4	4.48638e-17
C1022	a_390_81##5	VNB	7.17175e-18
C1023	a_855_368##13	a_855_368##9	6.83878e-19
C1024	CLK	RESET_B#1	3.87435e-18
C1025	SCE	D#2	1.6474e-17
C1026	a_855_368##11	VNB	4.21987e-18
C1027	RESET_B#16	VPWR	7.27706e-17
C1028	a_1242_457##6	a_855_368##7	2.36034e-19
C1029	a_27_74##2	SCE	2.02873e-17
C1030	RESET_B#13	VNB	4.14375e-18
C1031	VPWR	VPWR#9	6.64914e-17
C1032	a_1034_368##10	a_855_368##4	1.01955e-17
C1033	SCE	SCE#2	3.0099e-17
C1034	a_27_74##7	VNB	3.8347e-17
C1035	a_27_74##6	VNB	4.08778e-17
C1036	SCD#3	RESET_B#4	1.75817e-17
C1037	VPWR#11	a_855_368##7	1.02846e-19
C1038	D#5	VNB	1.91572e-18
C1039	a_1034_368##4	a_1242_457##4	2.2614e-17
C1040	SCE#3	SCE#2	7.47878e-19
C1041	VGND#1	VNB	4.12989e-17
C1042	a_1242_457##3	a_855_368#	5.29456e-19
C1043	VGND#13	VNB	1.03677e-17
C1044	a_2492_392##11	VNB	1.13062e-17
C1045	a_1824_74##8	a_1242_457##3	1.32893e-19
C1046	VGND#14	VNB	3.15525e-18
C1047	VPWR	a_2492_392##4	1.90762e-18
C1048	VGND#5	RESET_B#11	3.96077e-18
C1049	a_2082_446##4	VNB	1.4139e-17
C1050	VGND#17	CLK#1	3.32425e-17
C1051	a_1383_349##3	VPWR#13	1.73124e-17
C1052	a_1824_74##7	VNB	3.62756e-18
C1053	a_1383_349##5	VNB	7.44369e-18
C1054	VPWR	RESET_B#10	1.55083e-18
C1055	a_225_81##2	SCE#2	9.64841e-18
C1056	VPWR	a_2082_446##2	9.58565e-18
C1057	a_1242_457##10	VNB	1.25868e-19
C1058	VPWR#14	a_1034_368##2	1.40128e-19
C1059	a_390_81#	VNB	4.66239e-18
C1060	a_1034_368##10	VNB	3.92517e-17
C1061	VPWR	a_1034_368##7	4.63434e-19
C1062	a_2082_446##6	VPWR#7	6.1996e-17
C1063	VGND#17	VNB	2.97074e-18
C1064	RESET_B	VPWR#9	2.64257e-18
C1065	D	D#2	4.70971e-18
C1066	a_855_368##13	VNB	3.07088e-18
C1067	VGND#10	a_27_74##7	1.08685e-18
C1068	VGND#18	VNB	1.03989e-17
C1069	a_225_81#	VNB	1.07511e-17
C1070	a_27_74##2	D	1.73828e-17
C1071	a_1034_368##4	RESET_B#7	5.89299e-20
C1072	a_390_81##8	VNB	9.65383e-18
C1073	VPWR	a_1242_457##3	6.26326e-19
C1074	a_855_368##12	RESET_B#1	3.98779e-18
C1075	VGND#10	SCE#4	1.59941e-18
C1076	a_225_81##2	VNB	1.38415e-17
C1077	a_1242_457##3	a_1034_368##5	9.32492e-18
C1078	VGND#19	VNB	5.46533e-18
C1079	VPWR	RESET_B#5	3.29611e-18
C1080	D	SCE#2	5.41466e-18
C1081	a_27_74##8	VNB	2.32987e-17
C1082	VPWR#1	VNB	5.48817e-17
C1083	Q#1	VNB	7.63199e-18
C1084	VPWR	a_1383_349##2	2.18779e-18
C1085	VGND#19	SCE#2	8.84604e-19
C1086	VPWR#4	VNB	1.20866e-17
C1087	a_2492_392##10	VNB	1.38177e-17
C1088	VPWR#6	VNB	1.04813e-17
C1089	a_1034_368##10	RESET_B#3	7.07854e-20
C1090	a_1242_457##9	a_855_368##7	1.67226e-19
C1091	a_2082_446##6	VNB	5.95785e-18
C1092	RESET_B	a_1824_74##3	5.83715e-18
C1093	RESET_B	RESET_B#10	2.27619e-17
C1094	VGND#9	a_390_81##5	6.51185e-19
C1095	a_1824_74##9	VNB	8.82188e-18
C1096	VPWR#4	VPWR#1	1.77567e-18
C1097	VPWR#12	a_1034_368##2	2.48092e-19
C1098	a_1383_349##4	VNB	4.2596e-18
C1099	VGND#9	CLK#3	5.42521e-19
C1100	VPWR#11	VNB	9.55595e-18
C1101	RESET_B	a_2082_446##2	5.98695e-17
C1102	a_1242_457##9	VNB	4.4249e-18
C1103	a_2492_392##9	VPWR#4	1.14486e-17
C1104	RESET_B#16	a_1824_74##7	2.659e-18
C1105	VPWR#13	VNB	8.48811e-18
C1106	RESET_B	a_1034_368##7	2.79489e-17
C1107	a_1242_457##7	a_1034_368##3	3.69425e-19
C1108	a_1242_457##8	VNB	6.78697e-19
C1109	a_1034_368##10	a_1383_349##5	1.26614e-17
C1110	a_390_81##2	VNB	1.42891e-17
C1111	a_1034_368##13	VNB	1.42651e-19
C1112	VGND	RESET_B#16	2.18494e-18
C1113	VPWR#15	VNB	2.18047e-19
C1114	a_855_368##12	VNB	9.94576e-19
C1115	VPWR#17	VNB	1.02548e-18
C1116	VGND	VGND#6	8.32709e-17
C1117	a_390_81##6	VNB	2.07875e-18
C1118	a_225_81#	VGND#9	3.12279e-18
C1119	a_855_368##13	CLK#1	2.47705e-17
C1120	a_27_74##9	VNB	3.03174e-17
C1121	a_2492_392#	VNB	3.15421e-17
C1122	a_2492_392##6	VNB	3.38129e-17
C1123	a_1824_74#	VNB	3.2493e-17
C1124	VGND	a_2492_392##4	4.08024e-18
C1125	a_1824_74##4	VNB	2.69824e-17
C1126	VGND#8	CLK#3	8.34289e-20
C1127	RESET_B#11	VNB	3.33405e-17
C1128	VGND	a_1824_74##3	9.07342e-18
C1129	a_2082_446#	VNB	3.83022e-17
C1130	a_855_368#	VNB	8.07548e-17
C1131	VGND	RESET_B#10	1.1033e-18
C1132	a_1034_368##5	VNB	4.34608e-17
C1133	a_1242_457##4	VNB	3.06573e-17
C1134	VGND	a_2082_446##2	7.80372e-18
C1135	a_1242_457##10	a_1242_457##8	1.73431e-19
C1136	a_27_74##3	SCD#3	2.00125e-17
C1137	RESET_B#7	VNB	4.26383e-17
C1138	a_1383_349#	VNB	2.71217e-17
C1139	VGND	a_1034_368##7	6.22633e-19
C1140	a_1034_368#	VNB	4.51675e-17
C1141	a_855_368##8	VNB	3.80762e-17
C1142	VGND	a_1034_368##4	4.87295e-17
C1143	a_855_368##9	VNB	2.87107e-17
C1144	a_1383_349##5	RESET_B#16	1.19858e-17
C1145	CLK#1	VNB	3.04456e-17
C1146	VGND	a_1242_457##3	7.60831e-18
C1147	VPWR#13	a_855_368##7	2.91527e-18
C1148	RESET_B#3	VNB	4.34161e-17
C1149	SCD#1	VNB	3.28159e-17
C1150	VGND	RESET_B#5	2.37684e-18
C1151	a_1242_457##3	RESET_B#7	2.85625e-17
C1152	RESET_B#16	a_855_368##2	6.33566e-18
C1153	SCE#6	VNB	2.53672e-17
C1154	a_855_368##9	a_855_368##8	3.34405e-18
C1155	D#3	VNB	1.9212e-17
C1156	VGND	a_1383_349##2	5.14209e-18
C1157	a_27_74#	VNB	4.27642e-17
C1158	SCE#4	VNB	4.48814e-17
C1159	a_2492_392##5	VNB	3.90203e-17
C1160	a_1242_457##6	a_1034_368##3	2.0158e-20
C1161	VGND#17	RESET_B#3	5.82016e-19
C1162	a_2492_392##7	VNB	3.96309e-17
C1163	a_1824_74##5	VNB	4.77583e-17
C1164	a_1824_74##6	VNB	5.88124e-17
C1165	VPWR#9	a_1034_368##6	6.60683e-18
C1166	RESET_B#9	VNB	2.35041e-17
C1167	a_2082_446##6	VPWR#5	7.58607e-18
C1168	a_2082_446##3	VNB	3.26093e-17
C1169	a_1034_368##6	VNB	2.39372e-17
C1170	a_855_368##2	VNB	1.47957e-16
C1171	a_1242_457#	VNB	3.47083e-17
C1172	RESET_B#8	VNB	2.57126e-17
C1173	a_1383_349##3	VNB	2.22099e-17
C1174	a_855_368##7	VNB	2.61024e-17
C1175	a_1034_368##3	VNB	2.04876e-17
C1176	a_855_368##6	VNB	3.14529e-17
C1177	CLK#4	VNB	4.65041e-17
C1178	RESET_B#4	VNB	3.01225e-17
C1179	VPWR#17	VPWR#15	4.9698e-19
C1180	SCD#3	VNB	2.65013e-17
C1181	a_1242_457##3	a_1383_349#	7.51257e-19
C1182	a_27_74##3	VNB	2.20763e-17
C1183	RESET_B	a_2242_74#	7.84094e-19
C1184	D#1	VNB	4.28234e-17
C1185	SCE#1	VNB	2.99344e-17
C1186	SCE#5	VNB	4.79806e-17
C1187	RESET_B#16	VGND#16	8.19184e-21
C1188	VGND#18	CLK#1	3.08877e-18
C1189	VPWR#2	VNB	1.15634e-16
C1190	RESET_B	a_2078_74#	3.7049e-19
C1191	RESET_B#16	a_1242_457#	1.04311e-17
C1192	VGND#2	VNB	1.18842e-16
C1193	VPWR#4	Q#1	9.11844e-17
C1194	RESET_B#16	VNB	1.27742e-17
C1195	VPWR#9	VNB	3.42319e-17
C1196	VGND#6	VNB	4.57015e-17
C1197	SCE	SCD	1.7874e-18
C1198	RESET_B#15	VNB	9.03941e-18
C1199	VPWR#16	VNB	3.43331e-16
C1200	VGND#10	VNB	3.76152e-16
C1201	a_2492_392##4	VNB	5.86698e-17
C1202	VPWR#9	a_855_368##2	3.98981e-18
C1203	a_1824_74##3	VNB	8.43367e-17
C1204	RESET_B#10	VNB	6.52126e-17
C1205	VGND#5	a_2082_446#	6.37898e-18
C1206	a_2082_446##2	VNB	7.78355e-17
C1207	a_1034_368##7	VNB	4.11363e-17
C1208	a_1034_368##4	VNB	5.96106e-17
C1209	a_1034_368##10	VGND#16	1.29846e-18
C1210	a_1242_457##3	VNB	5.04273e-17
C1211	a_390_81##2	a_1242_457##7	4.31885e-17
C1212	RESET_B#5	VNB	5.03054e-17
C1213	a_1383_349##2	VNB	4.72572e-17
C1214	VGND#13	a_1824_74##2	3.49736e-19
C1215	a_1034_368##2	VNB	5.37649e-17
C1216	VPWR#14	a_855_368##5	1.25305e-19
C1217	a_855_368##5	VNB	3.26112e-17
C1218	VPWR#7	VPWR#8	4.24046e-18
C1219	a_390_81##2	a_1383_349##3	6.47469e-19
C1220	SCD#2	VPWR#17	1.6296e-18
C1221	CLK#3	VNB	4.62002e-17
C1222	D	SCE	2.38129e-17
C1223	RESET_B#1	VNB	3.87307e-17
C1224	SCD#2	VNB	4.72313e-17
C1225	a_27_74##4	VNB	3.25743e-17
C1226	a_855_368##13	RESET_B#3	3.60739e-18
C1227	SCE#7	VNB	5.18091e-17
C1228	a_1383_349##2	a_1034_368##5	1.28129e-19
C1229	D#2	VNB	5.57834e-17
C1230	VGND#10	D#5	4.98739e-18
C1231	a_27_74##2	VNB	3.30171e-17
C1232	SCE#2	VNB	1.09231e-16
C1233	VPWR#13	a_1034_368##3	6.15718e-19
C1234	D#1	a_27_74##3	2.79483e-17
C1235	a_2492_392##9	a_2492_392##10	6.40243e-21
C1236	VPWR#14	a_855_368##4	2.1819e-19
C1237	a_1242_457##8	a_855_368##7	1.67908e-17
C1238	a_1824_74##8	a_2082_446##4	1.59746e-18
C1239	a_225_81#	CLK#1	3.77638e-19
C1240	RESET_B	VPWR	3.41127e-17
C1241	VGND#6	a_855_368##2	5.43831e-20
C1242	a_390_81##5	a_1034_368##3	5.95108e-19
C1243	SCD	VNB	3.27536e-18
C1244	SCE	VNB	6.98649e-18
C1245	CLK	VNB	1.30382e-17
C1246	D	VNB	1.75036e-18
C1247	a_2082_446##4	a_2492_392##7	1.08245e-19
C1248	Q	VNB	1.50376e-17
C1249	VPWR	VNB	2.31562e-16
C1250	RESET_B	VNB	2.78154e-18
C1251	VGND	VNB	2.56515e-16
C1252	a_27_74##6	VPWR#18	7.76887e-17
C1253	VPWR#18	SCE#5	2.30992e-17
C1254	VPWR#18	VNB	8.85696e-17
C1255	VPWR#18	SCE#1	3.71269e-17
C1256	VPWR#18	D#1	1.23059e-17
C1257	a_27_74##9	VPWR#18	7.95979e-17
C1258	VPWR#18	a_27_74##3	2.8821e-19
C1259	VPWR#18	VPWR#19	2.66087e-17
C1260	VPWR#18	SCD#3	1.62609e-19
C1261	VPWR#18	a_390_81##6	3.55289e-17
C1262	VPWR#18	VPWR#17	5.35012e-19
C1263	VPWR#16	VPWR#18	2.14071e-16
C1264	VPWR#18	SCE#2	4.91811e-18
C1265	VPWR#18	D#2	3.14055e-19
C1266	a_27_74##4	VPWR#18	2.3609e-17
C1267	VGND#11	SCE#4	1.23127e-18
C1268	VGND#10	VGND#11	1.25616e-16
C1269	VGND#11	SCE#2	3.93973e-20
C1270	VGND#11	a_225_81##2	7.319e-17
C1271	VGND#11	a_27_74#	3.88562e-18
C1272	VGND#11	a_27_74##2	2.78787e-18
C1273	VGND#11	a_27_74##7	3.31947e-19
C1274	VGND#11	VNB	7.6315e-17
C1275	VGND#11	a_27_74##8	1.76179e-17
C1276	VGND#11	D#3	3.98674e-18
C1277	VGND#11	D#2	2.04589e-19
*
*
.ENDS sky130_fd_sc_hs__sdfrtp_2
*
