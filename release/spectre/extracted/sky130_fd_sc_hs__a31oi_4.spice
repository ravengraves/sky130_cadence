* Extracted by Quantus, converted by sky130cad/quantus.py
*
*
*
*                       LINUX           Wed Nov 18 08:13:28 2026
*
*
*
*  PROGRAM  advgen
*
*  Name           : advgen - Quantus - (64-bit)
*  Version        : 25.1.0-p047
*  Build Date     : Thu Dec 11 23:20:30 PST 2025
*
*  HSPICE LIBRARY
*
*  OPERATING_TEMPERATURE 150
*  QRC_TECH_DIR <path>/tech
*
*
*

*
.SUBCKT sky130_fd_sc_hs__a31oi_4 VPB VNB VGND VPWR Y A3 A2 A1 B1
*
*
*  caps2d version: 10
*
*
*       TRANSISTOR CARDS
*
*
XM27 VGND#9 A3#12 a_30_74##5 VNB sky130_fd_pr__nfet_01v8_lvt l=0.15 w=0.74 ad=0.2072 as=0.2109 pd=2.04 ps=2.05
XM15 VGND#9 A3#10 a_30_74##8 VNB sky130_fd_pr__nfet_01v8_lvt l=0.15 w=0.74 ad=0.2072 as=0.2072 pd=2.04 ps=2.04
XM16 a_30_74##8 A3#8 VGND#8 VNB sky130_fd_pr__nfet_01v8_lvt l=0.15 w=0.74 ad=0.2072 as=0.259 pd=2.04 ps=2.18
XM24 a_30_74##7 A3#1 VGND#8 VNB sky130_fd_pr__nfet_01v8_lvt l=0.15 w=0.74 ad=0.2072 as=0.259 pd=2.04 ps=2.18
XM7 a_475_74##4 A2#7 a_30_74##7 VNB sky130_fd_pr__nfet_01v8_lvt l=0.15 w=0.74 ad=0.2146 as=0.2072 pd=2.06 ps=2.04
XM25 a_30_74##6 A2#11 a_475_74##4 VNB sky130_fd_pr__nfet_01v8_lvt l=0.15 w=0.74 ad=0.2072 as=0.2146 pd=2.04 ps=2.06
XM26 a_475_74##6 A2#10 a_30_74##6 VNB sky130_fd_pr__nfet_01v8_lvt l=0.15 w=0.74 ad=0.3108 as=0.2072 pd=2.32 ps=2.04
XM20 a_30_74# A2#8 a_475_74##6 VNB sky130_fd_pr__nfet_01v8_lvt l=0.15 w=0.74 ad=0.202325 as=0.3108 pd=2.05 ps=2.32
XM11 Y#4 A1#12 a_475_74##5 VNB sky130_fd_pr__nfet_01v8_lvt l=0.15 w=0.74 ad=0.19805 as=0.4218 pd=2.07 ps=2.62
XM22 a_475_74##5 A1#11 Y#7 VNB sky130_fd_pr__nfet_01v8_lvt l=0.15 w=0.74 ad=0.4218 as=0.259 pd=2.62 ps=2.18
XM21 a_475_74# A1#9 Y#7 VNB sky130_fd_pr__nfet_01v8_lvt l=0.15 w=0.74 ad=0.2072 as=0.259 pd=2.04 ps=2.18
XM28 Y#6 A1#1 a_475_74# VNB sky130_fd_pr__nfet_01v8_lvt l=0.15 w=0.74 ad=0.259 as=0.2072 pd=2.18 ps=2.04
XM10 VGND#7 B1#8 Y#6 VNB sky130_fd_pr__nfet_01v8_lvt l=0.15 w=0.74 ad=0.8177 as=0.259 pd=3.69 ps=2.18
XM12 Y#1 B1#1 VGND#7 VNB sky130_fd_pr__nfet_01v8_lvt l=0.15 w=0.74 ad=0.2109 as=0.8177 pd=2.05 ps=3.69
XM17 VPWR#13 A3#6 a_27_368##12 VPB sky130_fd_pr__pfet_01v8 l=0.15 w=1.12 ad=0.336 as=0.3304 pd=2.84 ps=2.83
XM0 a_27_368##16 A3#11 VPWR#13 VPB sky130_fd_pr__pfet_01v8 l=0.15 w=1.12 ad=0.336 as=0.336 pd=2.84 ps=2.84
XM3 a_27_368##16 A3#9 VPWR#11 VPB sky130_fd_pr__pfet_01v8 l=0.15 w=1.12 ad=0.336 as=0.336 pd=2.84 ps=2.84
XM23 VPWR#11 A3#7 a_27_368##15 VPB sky130_fd_pr__pfet_01v8 l=0.15 w=1.12 ad=0.336 as=0.336 pd=2.84 ps=2.84
XM5 a_27_368##15 A2#13 VPWR#9 VPB sky130_fd_pr__pfet_01v8 l=0.15 w=1.12 ad=0.336 as=0.392 pd=2.84 ps=2.94
XM1 a_27_368##14 A2#12 VPWR#9 VPB sky130_fd_pr__pfet_01v8 l=0.15 w=1.12 ad=0.336 as=0.392 pd=2.84 ps=2.94
XM4 VPWR#7 A2#9 a_27_368##14 VPB sky130_fd_pr__pfet_01v8 l=0.15 w=1.12 ad=0.392 as=0.336 pd=2.94 ps=2.84
XM13 VPWR#7 A2#1 a_27_368##7 VPB sky130_fd_pr__pfet_01v8 l=0.15 w=1.12 ad=0.392 as=0.392 pd=2.94 ps=2.94
XM9 a_27_368##7 A1#7 VPWR#6 VPB sky130_fd_pr__pfet_01v8 l=0.15 w=1.12 ad=0.392 as=0.392 pd=2.94 ps=2.94
XM18 VPWR#6 A1#13 a_27_368##5 VPB sky130_fd_pr__pfet_01v8 l=0.15 w=1.12 ad=0.392 as=0.9296 pd=2.94 ps=3.9
XM6 VPWR#5 A1#10 a_27_368##5 VPB sky130_fd_pr__pfet_01v8 l=0.15 w=1.12 ad=0.448 as=0.9296 pd=3.04 ps=3.9
XM8 a_27_368##3 A1#8 VPWR#5 VPB sky130_fd_pr__pfet_01v8 l=0.15 w=1.12 ad=0.3696 as=0.448 pd=2.9 ps=3.04
XM14 a_27_368##3 B1#10 Y#9 VPB sky130_fd_pr__pfet_01v8 l=0.15 w=1.12 ad=0.3696 as=0.3584 pd=2.9 ps=2.88
XM19 a_27_368##13 B1#9 Y#9 VPB sky130_fd_pr__pfet_01v8 l=0.15 w=1.12 ad=0.336 as=0.3584 pd=2.84 ps=2.88
XM2 Y#10 B1#6 a_27_368##13 VPB sky130_fd_pr__pfet_01v8 l=0.15 w=1.12 ad=0.336 as=0.336 pd=2.84 ps=2.84
XM29 Y#10 B1#5 a_27_368# VPB sky130_fd_pr__pfet_01v8 l=0.15 w=1.12 ad=0.336 as=0.3304 pd=2.84 ps=2.83
*
*
*       RESISTOR AND CAP/DIODE CARDS
*
Rg1	A3#1	A3#2	397.555725
Rg2	A3#2	A3#3	66.369736
Rg3	A3#3	A3#4	47.978874
Rg4	A3#4	A3#5	93.302582
Rg5	A3#5	A3#6	449.655212
Rg6	A3#2	A3#7	449.655212
Rg7	A3#3	A3#8	395.494293
Rg8	A3#3	A3#9	448.603302
Rg9	A3#4	A3#10	371.764587
Rg10	A3#4	A3#11	423.864075
Rg11	A3#5	A3#12	397.555725
Rg12	A2#1	A2#2	503.938385
Rg13	A2#2	A2#3	70.823959
Rg14	A2#3	A2#4	39.351238
Rg15	A2#4	A2#5	43.995083
Rg16	A2#5	A2#6	18.725645
Rg17	A2#6	A2#7	439.399414
Rg18	A2#2	A2#8	451.838898
Rg19	A2#3	A2#9	419.000305
Rg20	A2#4	A2#10	427.868561
Rg21	A2#5	A2#11	391.205902
Rg22	A2#5	A2#12	445.616760
Rg23	A2#6	A2#13	516.858521
Rg24	A1#1	A1#2	432.149536
Rg25	A1#2	A1#3	54.843189
Rg26	A1#3	A1#4	34.140049
Rg27	A1#4	A1#5	30.009388
Rg28	A1#5	A1#6	129.475647
Rg29	A1#6	A1#7	598.663269
Rg30	A1#2	A1#8	417.407684
Rg31	A1#3	A1#9	354.942963
Rg32	A1#4	A1#10	420.988159
Rg33	A1#5	A1#11	377.887207
Rg34	A1#6	A1#12	405.827179
Rg35	A1#6	A1#13	437.389587
Rg36	B1#1	B1#2	451.838898
Rg37	B1#2	B1#3	67.132561
Rg38	B1#3	B1#4	90.753067
Rg39	B1#2	B1#5	503.938385
Rg40	B1#3	B1#6	419.554810
Rg41	B1#4	B1#7	50.961979
Rg42	B1#7	B1#8	381.948395
Rg43	B1#4	B1#9	429.126801
Rg44	B1#7	B1#10	449.812653
Rf1	A3	A3#13	2.750425
Rf2	A3#13	A3	11.918507
Rf3	a_30_74#	a_30_74##2	92.976440
Rf4	a_30_74##2	a_30_74##3	67.785400
Rf5	a_30_74##3	a_30_74##4	65.145798
Rf6	a_30_74##4	a_30_74##5	86.158134
Rf7	a_30_74##2	a_30_74##6	25.969021
Rf8	a_30_74##3	a_30_74##7	21.341251
Rf9	a_30_74##4	a_30_74##8	28.306047
Rf10	A2	A2#14	2.139219
Rf11	A2#14	A2	12.529713
Rf12	A1	A1#14	14.363330
Rf13	A1#14	A1	0.305603
Rf14	a_475_74#	a_475_74##2	99.710838
Rf15	a_475_74##2	a_475_74##3	120.118996
Rf16	a_475_74##3	a_475_74##4	92.642258
Rf17	a_475_74##2	a_475_74##5	23.090988
Rf18	a_475_74##3	a_475_74##6	24.862514
Rf19	B1	B1#11	6.723260
Rf20	B1#11	B1	7.945672
Rf21	a_27_368#	a_27_368##2	90.961189
Rf22	a_27_368##2	a_27_368##4	79.183083
Rf23	a_27_368##4	a_27_368##6	79.763519
Rf24	a_27_368##6	a_27_368##8	67.968658
Rf25	a_27_368##8	a_27_368##9	80.723709
Rf26	a_27_368##9	a_27_368##10	56.658928
Rf27	a_27_368##10	a_27_368##11	60.993011
Rf28	a_27_368##11	a_27_368##12	84.812973
Rf29	a_27_368##2	a_27_368##13	24.845327
Rf30	a_27_368##9	a_27_368##14	15.846697
Rf31	a_27_368##10	a_27_368##15	20.068451
Rf32	a_27_368##11	a_27_368##16	20.653482
Rf33	a_27_368##3	a_27_368##4	7.500000
Rf34	a_27_368##5	a_27_368##6	3.750000
Rf35	a_27_368##7	a_27_368##8	5.000000
Rf36	Y#1	Y#2	137.558975
Rf37	Y#2	Y#3	71.780540
Rf38	Y#3	Y#5	67.030167
Rf39	Y#2	Y#6	18.149860
Rf40	Y#3	Y#7	23.090988
Rf41	Y#5	Y	6.699468
Rf42	Y	Y#8	178.170517
Rf43	Y#8	Y#9	16.378334
Rf44	Y#8	Y#10	78.883324
Rf45	Y#4	Y#5	15.000000
Rf47	VGND#2	VGND#3	320.472504
Rf48	VGND#3	VGND#4	129.640091
Rf49	VGND#4	VGND#5	62.774361
Rf51	VGND#2	VGND#7	13.953727
Rf52	VGND#4	VGND#8	38.247387
Rf53	VGND#5	VGND#9	38.247387
Rf54	VPWR#1	VPWR#2	121.969795
Rf55	VPWR#2	VPWR#3	108.065666
Rf56	VPWR#3	VPWR#4	87.891739
Rf57	VPWR#2	VPWR#5	33.916985
Rf58	VPWR#3	VPWR#6	33.916985
Rf59	VPWR#4	VPWR#7	36.213654
Rf60	VPWR#4	VPWR#8	60.607380
Rf61	VPWR#8	VPWR#9	32.125244
Rf62	VPWR#8	VPWR#10	65.696381
Rf63	VPWR#10	VPWR#11	32.715752
Rf64	VPWR#10	VPWR#12	65.696381
Rf65	VPWR#12	VPWR#13	32.715752
Rf70	B1#4	B1#11	53.410934
Rf67	A3#4	A3#13	40.058201
Rf68	A2#4	A2#14	40.058201
Rf69	A1#5	A1#14	53.410934
Re1	VPWR#1	VPWR	3.735117
Re2	VPWR	VPWR#4	1.067176
Re3	VGND#2	VGND	3.735117
Re4	VGND	VGND#3	1.067176
*
*       CAPACITOR CARDS
*
*
C1	VGND	VNB	3.10608e-16
C2	VPWR#5	B1#9	4.55432e-20
C3	a_27_368##7	VPWR#3	8.7238e-18
C4	VPWR	VNB	2.80677e-16
C5	Y	VNB	1.43009e-19
C6	A3	VNB	4.4965e-17
C7	Y#9	B1#10	4.79032e-17
C8	a_27_368##11	A3#6	1.24815e-19
C9	A2	VNB	2.29393e-17
C10	A1	VNB	1.26174e-17
C11	B1	VNB	5.3958e-17
C12	VGND	A3	1.08241e-17
C13	A1#12	A1#11	1.23257e-17
C14	VPWR	Y	8.4376e-18
C15	VGND	A2	1.21349e-17
C16	VGND#4	A3#1	5.46003e-18
C17	VPWR	A3	1.10394e-17
C18	VGND	A1	7.13268e-18
C19	Y#10	a_27_368##13	4.93338e-17
C20	VGND	B1	1.96272e-18
C21	A3#4	VNB	5.6571e-17
C22	VPWR	A2	1.19012e-17
C23	A1#5	VNB	5.06033e-17
C24	VPWR	A1	8.76346e-18
C25	A2	Y	3.82499e-17
C26	VGND#3	VNB	8.49255e-17
C27	VPWR	B1	2.56468e-18
C28	VPWR#4	VNB	3.17807e-17
C29	Y	A1	1.03526e-16
C30	VGND#4	A2#6	2.40115e-20
C31	VPWR#1	VNB	1.97899e-16
C32	A3	A2	1.60343e-17
C33	a_27_368##3	B1#9	1.53222e-18
C34	A3#6	VNB	3.78156e-17
C35	a_27_368##13	B1#10	6.18796e-19
C36	A3#11	VNB	2.67263e-17
C37	A3#9	VNB	2.64883e-17
C38	A3#7	VNB	2.84985e-17
C39	A2#13	VNB	2.84963e-17
C40	VGND	VGND#3	1.41415e-16
C41	A2#12	VNB	3.01433e-17
C42	VGND#7	a_475_74#	5.25762e-17
C43	A2#9	VNB	2.93148e-17
C44	A2#1	VNB	2.77825e-17
C45	A1#7	VNB	4.6272e-17
C46	A1#13	VNB	2.82765e-17
C47	a_27_368##11	VPWR#10	1.6661e-19
C48	A1#10	VNB	3.34288e-17
C49	A1#8	VNB	3.17518e-17
C50	B1#10	VNB	3.26018e-17
C51	B1#9	VNB	3.23095e-17
C52	A1	B1	3.19969e-17
C53	VPWR#5	B1#6	2.63595e-20
C54	B1#6	VNB	3.18489e-17
C55	VPWR	VPWR#4	6.06782e-17
C56	B1#5	VNB	3.70414e-17
C57	Y#9	B1#9	5.99049e-17
C58	A3#12	VNB	3.38759e-17
C59	Y	A1#5	5.4393e-18
C60	A3#10	VNB	2.53079e-17
C61	A3#8	VNB	2.57275e-17
C62	A3	A3#4	3.68346e-17
C63	VPWR	VPWR#1	7.07991e-18
C64	A3#1	VNB	2.70518e-17
C65	A2#7	VNB	2.72808e-17
C66	A2#11	VNB	2.89003e-17
C67	a_27_368##10	A3#11	3.9254e-19
C68	VPWR	A3#6	1.51415e-18
C69	A2#10	VNB	2.96972e-17
C70	VGND	A1#7	9.96801e-21
C71	A2#8	VNB	3.19736e-17
C72	a_27_368##13	a_27_368#	3.85757e-18
C73	VPWR	A3#11	5.83585e-19
C74	A1#12	VNB	3.61053e-17
C75	A1#11	VNB	3.01841e-17
C76	A2	A3#4	4.11227e-20
C77	VPWR	A3#9	5.30774e-19
C78	A1#9	VNB	2.84162e-17
C79	A1#1	VNB	2.65548e-17
C80	A2#2	A1#6	2.39641e-18
C81	VPWR	A3#7	9.24144e-19
C82	B1#8	VNB	3.12237e-17
C83	B1#1	VNB	3.37907e-17
C84	a_27_368##12	VNB	5.37225e-17
C85	VPWR	A2#13	9.05058e-19
C86	A2#6	VPWR#7	7.9871e-19
C87	a_27_368##3	B1#6	3.28804e-19
C88	VPWR#13	VNB	2.7893e-18
C89	VPWR	A2#12	1.29112e-19
C90	VPWR#11	VNB	4.3181e-19
C91	a_27_368##11	A3#11	1.19885e-17
C92	B1#9	a_27_368##13	2.76956e-17
C93	VPWR	A2#9	1.6669e-19
C94	A1#11	A1#9	2.5232e-17
C95	VPWR#9	VNB	1.03385e-18
C96	VGND	A3#12	1.66197e-18
C97	a_27_368##14	VNB	2.1429e-18
C98	VPWR	A2#1	5.4157e-19
C99	VPWR#7	VNB	1.05662e-18
C100	VGND	A3#10	6.36564e-19
C101	a_27_368##7	VNB	3.80241e-18
C102	VPWR	A1#7	3.24318e-20
C103	VGND	A3#8	6.36564e-19
C104	VPWR#6	VNB	7.38093e-19
C105	VPWR	A1#13	4.83039e-19
C106	A1	A1#5	3.10944e-17
C107	VGND	A3#1	2.89347e-22
C108	VPWR#5	VNB	3.48432e-18
C109	VGND#4	A2#7	5.32796e-18
C110	VGND	A2#7	1.98332e-18
C111	VPWR	A1#10	6.74906e-20
C112	a_27_368##3	VNB	3.01343e-18
C113	Y#9	VNB	1.42389e-19
C114	VGND	A2#11	1.57e-18
C115	Y	A2#13	1.52959e-19
C116	VPWR	A1#8	4.17975e-19
C117	VPWR#5	B1#5	3.11524e-20
C118	A3	A3#6	3.3886e-18
C119	VGND	A2#10	1.66361e-18
C120	B1#7	B1#3	8.81379e-19
C121	a_27_368#	VNB	5.42102e-17
C122	Y	A2#12	1.57992e-19
C123	VGND	A2#8	1.69631e-18
C124	VGND#7	Y#6	6.55113e-17
C125	a_30_74##5	VNB	4.36713e-17
C126	VGND#9	VNB	1.3093e-18
C127	A3	A3#11	2.10322e-18
C128	VGND	A1#12	1.70842e-18
C129	B1	A1#5	3.00777e-20
C130	Y	A2#9	2.75885e-19
C131	a_30_74##8	VNB	4.55126e-18
C132	Y#9	B1#6	1.73137e-18
C133	VGND	A1#11	1.66619e-18
C134	Y#4	A1#7	2.26772e-18
C135	VGND#8	VNB	3.39417e-19
C136	A3	A3#9	2.1e-18
C137	a_30_74##7	VNB	2.13503e-18
C138	VGND	A1#9	1.47244e-18
C139	Y	A2#1	3.86718e-19
C140	Y#10	B1#9	1.28708e-18
C141	a_475_74##4	VNB	2.6537e-18
C142	VGND	A1#1	1.83984e-18
C143	Y	A1#7	1.08211e-17
C144	A3	A3#7	1.59058e-18
C145	a_30_74#	VNB	4.50059e-18
C146	Y#4	VNB	5.3329e-18
C147	Y	A1#13	2.11653e-17
C148	A3	A2#13	5.05263e-19
C149	a_27_368#	Y#10	8.09572e-17
C150	Y	A1#10	1.03587e-17
C151	a_475_74#	VNB	3.50953e-18
C152	Y#6	VNB	2.64473e-18
C153	A3	A2#12	1.70675e-19
C154	a_27_368##5	VPWR#2	1.70548e-17
C155	VGND#7	VNB	1.0378e-16
C156	Y	A1#8	1.37137e-19
C157	Y#1	VNB	4.47637e-17
C158	A2	A3#9	1.73148e-19
C159	Y	B1#10	1.54208e-19
C160	a_30_74##2	VNB	1.08311e-18
C161	a_30_74##3	VNB	4.29929e-18
C162	a_30_74##4	VNB	1.2586e-18
C163	A2	A3#7	3.14227e-19
C164	B1#6	a_27_368##13	2.45592e-17
C165	a_475_74##2	VNB	1.02865e-17
C166	a_27_368#	B1#9	3.14109e-19
C167	a_475_74##3	VNB	1.00414e-17
C168	VPWR#1	B1	1.20555e-17
C169	A2	A2#13	1.58253e-18
C170	a_27_368##2	VNB	5.00195e-18
C171	a_27_368##10	A3#9	7.43993e-19
C172	A2	A2#12	1.94885e-18
C173	a_27_368##10	VNB	2.97977e-18
C174	Y#2	VNB	3.42166e-18
C175	Y#3	VNB	1.06381e-18
C176	A2	A2#1	2.07577e-18
C177	VGND	a_30_74##5	1.55586e-17
C178	VPWR	a_27_368##12	1.68245e-17
C179	A2	A1#7	1.17771e-17
C180	a_27_368##11	A3#9	1.28465e-17
C181	A1#9	A1#1	3.84487e-17
C182	VGND#4	VNB	4.24414e-17
C183	VGND	a_30_74##8	1.18512e-17
C184	VPWR	VPWR#13	2.28557e-17
C185	Y#10	B1#6	5.16368e-17
C186	a_27_368##10	A3#2	8.55302e-19
C187	VPWR#2	VNB	4.00489e-17
C188	VPWR	a_27_368##16	1.34513e-17
C189	VGND	a_30_74##7	1.53108e-17
C190	Y#6	Y#1	1.39821e-18
C191	VPWR#3	VNB	3.92571e-17
C192	VPWR	VPWR#11	2.25795e-17
C193	VPWR#8	VNB	2.72653e-17
C194	VGND	a_475_74##4	2.13309e-17
C195	VPWR#10	VNB	2.72198e-17
C196	VGND	a_30_74##6	7.76417e-18
C197	VPWR	a_27_368##15	1.41786e-17
C198	a_27_368##5	VPWR#3	1.79825e-17
C199	VPWR	VPWR#9	2.1919e-17
C200	VGND	a_30_74#	9.44083e-18
C201	VGND#4	A2#11	2.16198e-19
C202	a_475_74##3	a_30_74##6	1.87294e-17
C203	VPWR	a_27_368##14	1.72175e-17
C204	VGND	Y#4	1.15005e-17
C205	VPWR	VPWR#7	2.18983e-17
C206	VGND#7	A1#3	3.70716e-20
C207	VPWR	a_27_368##7	2.05963e-17
C208	VGND	a_475_74#	2.43158e-17
C209	a_27_368##13	B1#5	1.43272e-18
C210	VPWR	VPWR#6	1.63247e-17
C211	VGND	Y#6	8.57708e-18
C212	VGND	VGND#7	7.71845e-17
C213	a_475_74##6	a_475_74##2	1.5061e-18
C214	VPWR	a_27_368##5	3.4523e-17
C215	a_27_368#	B1#6	1.39333e-18
C216	VPWR	VPWR#5	1.63617e-17
C217	A1	A1#10	2.14965e-18
C218	VGND	a_30_74##2	2.72031e-18
C219	VPWR	a_27_368##3	1.69914e-17
C220	VGND	a_30_74##3	4.08511e-18
C221	VPWR	Y#9	4.49862e-18
C222	VGND	a_30_74##4	3.47596e-18
C223	A1	A1#8	1.20344e-18
C224	VGND	a_475_74##2	4.1382e-17
C225	VGND	a_475_74##3	4.11377e-17
C226	A3#4	A3#2	3.46257e-18
C227	VGND#3	A1#5	2.99506e-20
C228	Y#10	B1#5	4.62845e-17
C229	a_27_368##10	A3#7	2.28708e-17
C230	Y#4	a_27_368##7	1.71514e-18
C231	B1	A1#10	1.26643e-19
C232	VGND	a_27_368##10	4.26448e-18
C233	B1	A1#8	1.23939e-19
C234	VGND	Y#2	2.51736e-18
C235	a_27_368##7	Y	3.39002e-17
C236	Y#1	VGND#7	9.57187e-17
C237	VGND	Y#3	1.18485e-17
C238	a_30_74##3	A3#2	1.44106e-18
C239	A3#5	A3#4	4.03955e-18
C240	Y	VPWR#6	8.76722e-19
C241	B1	B1#10	2.11183e-18
C242	A1#1	B1#8	2.78004e-17
C243	a_27_368##11	A3#7	2.26414e-19
C244	Y	a_27_368##5	1.0175e-16
C245	B1	B1#9	2.06806e-18
C246	A3	a_27_368##12	4.37816e-17
C247	Y#3	A1#12	1.02678e-18
C248	VGND	VGND#4	1.00791e-16
C249	a_27_368#	B1#5	4.40513e-17
C250	B1	B1#6	2.06457e-18
C251	a_475_74##3	a_475_74##6	6.77996e-19
C252	a_27_368##9	A2#2	1.28646e-18
C253	a_475_74##2	Y#3	4.61316e-17
C254	B1	B1#5	5.96424e-18
C255	a_27_368##2	B1#2	4.57837e-21
C256	VGND#4	A2#10	7.27373e-20
C257	a_30_74#	a_475_74##2	4.45244e-18
C258	VGND#4	a_30_74##3	9.68101e-19
C259	A3#2	VNB	2.43428e-17
C260	A3#5	VNB	3.75497e-17
C261	A2#2	VNB	3.24225e-17
C262	Y#2	A1#11	1.82913e-20
C263	A2#6	VNB	8.96229e-17
C264	A1#3	VNB	4.22674e-17
C265	a_27_368##3	VPWR#2	1.4477e-17
C266	A1#6	VNB	4.50304e-17
C267	a_27_368##10	A2#13	2.48173e-17
C268	B1#2	VNB	3.97297e-17
C269	B1#3	VNB	3.2257e-17
C270	B1#7	VNB	6.14496e-17
C271	Y#4	Y	3.17028e-18
C272	VPWR	a_27_368##9	2.80931e-18
C273	VPWR	a_27_368##10	3.11827e-18
C274	VPWR	a_27_368##11	2.77103e-18
C275	a_27_368##11	A2#13	9.43844e-20
C276	B1#8	B1#1	2.38216e-18
C277	a_30_74##5	A3	4.48407e-17
C278	a_475_74##3	a_30_74#	3.21484e-17
C279	Y#3	A1#11	3.29192e-17
C280	A2	a_27_368##7	4.86111e-17
C281	a_27_368##2	B1#3	8.58444e-20
C282	a_475_74##2	Y#4	4.107e-17
C283	a_30_74##5	VGND#9	4.79169e-17
C284	VPWR	VPWR#2	7.65575e-17
C285	VPWR	VPWR#3	7.51821e-17
C286	VPWR	VPWR#8	5.33123e-17
C287	VGND#4	A2#8	5.09348e-20
C288	VPWR	VPWR#10	5.30402e-17
C289	a_27_368##9	A2#12	1.80223e-17
C290	VGND#4	a_30_74##4	2.91756e-19
C291	Y#2	A1#9	5.54469e-20
C292	a_27_368##10	A2#12	4.96047e-19
C293	VGND#7	B1#2	5.33923e-19
C294	a_30_74##5	A3#12	3.07273e-17
C295	a_30_74##5	a_30_74##8	1.72657e-18
C296	a_30_74##3	A3	2.07821e-17
C297	Y#3	A1#9	2.32618e-17
C298	a_475_74##2	a_475_74##5	1.6164e-17
C299	A1	Y#9	3.58538e-17
C300	a_27_368##2	B1#7	1.7422e-19
C301	a_30_74##4	A3	7.93988e-17
C302	VPWR#10	A3#9	9.78637e-19
C303	VGND#9	A3#12	2.91028e-17
C304	a_27_368##7	A1#6	2.20567e-19
C305	a_475_74##2	A1#7	9.32304e-19
C306	VPWR#4	A2#9	2.56324e-18
C307	A3#6	A3#11	4.6327e-17
C308	a_30_74#	A2	5.62416e-17
C309	VGND#3	A1#7	5.44963e-20
C310	a_27_368##9	A2#9	1.80208e-17
C311	VPWR#4	A2#1	9.78612e-19
C312	a_30_74##5	A3#10	8.48022e-19
C313	a_475_74##3	A1#7	7.06523e-19
C314	VGND#7	B1#3	2.24578e-18
C315	a_30_74##8	A3#12	6.43198e-19
C316	Y#2	A1#1	1.66729e-17
C317	VGND#9	a_30_74##8	4.15829e-17
C318	VGND	A1#6	6.04726e-20
C319	a_27_368##10	A2#9	6.34562e-19
C320	A3#11	A3#9	4.78667e-17
C321	B1	Y#9	1.02559e-16
C322	A3	a_27_368##10	1.73035e-17
C323	A3	a_27_368##11	8.28683e-17
C324	a_27_368##11	A3#5	9.05954e-19
C325	a_30_74##2	A2	8.4362e-17
C326	VGND#9	A3#10	3.28956e-17
C327	B1	Y#10	5.84291e-17
C328	a_30_74##3	A2	1.40363e-17
C329	a_475_74##2	Y#7	2.95316e-19
C330	B1	a_27_368#	3.45192e-17
C331	a_27_368##9	A2#6	5.30141e-18
C332	a_27_368##12	VPWR#13	6.84496e-17
C333	Y#3	A1#1	9.28354e-19
C334	Y#4	A1	1.65828e-17
C335	a_30_74##5	A3#8	1.87602e-19
C336	A3#9	A3#7	4.64077e-17
C337	a_30_74##2	A2#6	7.02764e-18
C338	VPWR#10	A3#7	1.49437e-18
C339	a_475_74##3	A2	3.07704e-18
C340	A3#10	a_30_74##8	1.72195e-17
C341	VGND#9	VGND#8	1.66094e-18
C342	a_27_368##9	A2#1	2.73481e-19
C343	VGND#7	B1#7	2.24588e-18
C344	a_475_74##4	A2#6	9.94204e-19
C345	a_30_74##4	A3#5	1.29716e-18
C346	Y#2	B1#8	2.67991e-17
C347	a_27_368##12	a_27_368##16	2.04939e-18
C348	VGND#9	A3#8	1.37067e-18
C349	a_27_368##10	A2#1	3.80035e-19
C350	Y#1	B1#2	1.42172e-18
C351	A2	a_27_368##9	9.16955e-17
C352	VGND#8	A3#10	1.21722e-18
C353	A3#7	A2#13	4.7209e-17
C354	A2	a_27_368##10	1.76303e-17
C355	a_475_74##2	a_475_74#	2.34971e-18
C356	A3#8	a_30_74##8	1.38193e-17
C357	VPWR#1	B1#10	5.93959e-18
C358	a_30_74##8	VGND#8	4.16102e-17
C359	A2#12	A2#6	1.15971e-19
C360	a_30_74##7	A3#10	1.45653e-19
C361	Y#3	B1#8	3.55859e-19
C362	VPWR#8	A2#13	1.49023e-18
C363	A1#6	VPWR#6	1.95914e-18
C364	VPWR#13	a_27_368##16	5.72304e-17
C365	VPWR#1	B1#9	6.0214e-18
C366	A2#13	A2#12	3.7122e-17
C367	a_27_368##9	A1#7	1.05329e-19
C368	A3#4	VPWR#13	6.13865e-19
C369	Y#1	B1	8.14862e-17
C370	VGND#8	A3#8	3.23452e-17
C371	VPWR#1	B1#6	6.09434e-18
C372	Y#1	B1#3	4.76708e-18
C373	A3#4	a_27_368##16	6.9441e-19
C374	A1#5	A1#3	2.50139e-18
C375	VPWR#1	B1#5	6.72258e-18
C376	A3#4	VPWR#11	6.47602e-19
C377	a_27_368##10	A1#7	1.00362e-19
C378	VPWR#13	VPWR#11	3.39498e-18
C379	a_30_74##8	A3#1	2.86039e-19
C380	A1#3	B1#8	6.55992e-19
C381	a_30_74##8	a_30_74##7	1.78332e-18
C382	VGND#3	A2#11	4.43427e-18
C383	A2#12	A2#9	4.67119e-17
C384	a_27_368##5	A1#3	9.59866e-19
C385	a_30_74##7	A3#8	1.14653e-18
C386	A1#6	A1#5	1.29486e-18
C387	a_475_74##6	A2#2	4.66947e-19
C388	VGND#3	A2#10	4.43427e-18
C389	a_27_368##10	A2#6	9.01308e-19
C390	Y#3	A1	9.32849e-17
C391	a_27_368##12	a_27_368##11	3.43539e-19
C392	VPWR#2	A1#3	7.81172e-20
C393	VGND#3	A2#8	4.43427e-18
C394	a_30_74##3	A2#6	1.72546e-18
C395	A3#1	VGND#8	1.60017e-17
C396	a_27_368##16	VPWR#11	5.72501e-17
C397	a_475_74##4	A3#8	4.16367e-19
C398	VPWR#8	A2#12	2.58258e-18
C399	VGND#3	A1#12	4.43427e-18
C400	A2#9	A2#1	3.78618e-17
C401	VGND#8	a_30_74##7	4.44319e-17
C402	a_30_74##7	A3#1	3.14888e-17
C403	VGND#7	a_475_74##2	3.13885e-17
C404	a_27_368##16	a_27_368##15	1.97586e-18
C405	VGND#8	A2#7	1.4093e-19
C406	Y#2	B1	1.08884e-16
C407	A2#1	A1#7	3.68637e-17
C408	a_475_74##4	A3#1	1.82195e-18
C409	A1#6	a_27_368##5	1.77266e-18
C410	a_27_368##11	VPWR#13	2.43069e-17
C411	Y	A2#2	2.40307e-18
C412	VGND#8	a_475_74##4	1.22633e-18
C413	VGND#4	a_30_74##8	5.19931e-18
C414	Y	A2#6	2.80963e-19
C415	A2#7	a_30_74##7	1.15239e-17
C416	a_27_368##11	a_27_368##10	1.22038e-18
C417	VPWR#11	a_27_368##15	5.8479e-17
C418	Y	A1#3	1.11503e-19
C419	a_30_74##6	A3#1	2.22408e-19
C420	Y	A1#6	2.20395e-17
C421	VPWR#3	VPWR#2	2.17032e-19
C422	A1#7	A1#13	3.55097e-17
C423	VPWR#8	A2#6	8.18847e-21
C424	VGND#9	A3#4	3.56005e-19
C425	A1#3	VPWR#5	2.07587e-18
C426	a_475_74##4	A2#7	3.47034e-17
C427	a_30_74##4	a_30_74##3	5.40749e-19
C428	a_30_74#	A2#2	1.52832e-18
C429	A1#5	a_27_368##5	3.70275e-18
C430	VPWR#11	VPWR#9	2.95085e-18
C431	a_30_74##7	a_475_74##4	4.51985e-17
C432	VGND#8	A3#4	5.97646e-19
C433	a_30_74##7	A2#11	3.19945e-19
C434	a_27_368##11	a_27_368##16	4.01497e-18
C435	a_30_74##6	A2#7	1.00216e-18
C436	A1#13	A1#10	6.76713e-18
C437	a_475_74##6	A2#6	8.51156e-19
C438	VPWR#3	A2#1	4.14254e-19
C439	A3#5	VPWR#13	6.2216e-19
C440	a_475_74##4	A2#11	2.93115e-17
C441	VGND#3	A2#2	2.17463e-20
C442	a_27_368##15	VPWR#9	5.60011e-17
C443	a_27_368##10	VPWR#11	1.57542e-17
C444	A3#2	A2#6	3.36599e-17
C445	a_475_74##6	A2#7	2.49178e-19
C446	a_30_74##7	a_30_74##6	1.899e-18
C447	a_30_74##7	A2#10	1.40538e-19
C448	A3	A3#2	1.14545e-17
C449	A1#10	A1#8	3.07167e-17
C450	a_27_368##2	B1#9	1.5904e-17
C451	A2#6	A2#1	1.48525e-19
C452	A2#11	a_30_74##6	2.26813e-17
C453	A3	A3#5	2.37634e-17
C454	a_27_368##14	VPWR#4	1.0665e-17
C455	VGND#3	A2#6	9.01474e-20
C456	a_27_368##15	a_27_368##14	2.81946e-18
C457	a_27_368##11	VPWR#11	1.56403e-17
C458	A3	A2#6	7.62671e-18
C459	a_475_74##4	A2#10	1.08163e-18
C460	VPWR#3	A1#7	4.29902e-18
C461	VGND#4	a_30_74##7	1.4848e-17
C462	a_475_74##6	A2#11	1.04061e-18
C463	a_27_368##7	VPWR#4	9.3776e-18
C464	a_475_74##4	a_30_74##6	3.40697e-17
C465	A1#8	B1#10	3.82762e-17
C466	a_27_368##10	a_27_368##15	1.25626e-18
C467	a_475_74##2	VPWR#6	2.16172e-20
C468	Y#4	A2#2	5.95995e-20
C469	a_27_368##3	A1#3	1.33484e-18
C470	VPWR#9	a_27_368##14	5.96943e-17
C471	a_30_74##6	A2#10	2.8684e-17
C472	VGND#3	A1#6	8.01324e-20
C473	a_27_368##2	B1#6	1.43642e-17
C474	A2#2	A1#7	8.31665e-18
C475	a_27_368##9	VPWR#9	1.68052e-17
C476	a_475_74##4	A2#8	2.62632e-19
C477	a_27_368##12	A3#6	3.70288e-17
C478	a_30_74##3	A3#4	6.87192e-19
C479	VPWR#2	A1#13	3.00432e-19
C480	A2#10	a_475_74##6	2.18148e-17
C481	B1#10	B1#9	3.95808e-17
C482	a_30_74##4	A3#4	5.73607e-18
C483	a_475_74##4	a_475_74##6	3.31591e-18
C484	VPWR#3	A1#6	6.46382e-20
C485	VPWR#13	A3#6	4.6703e-17
C486	VPWR#9	VPWR#7	1.78392e-18
C487	a_30_74##4	A3#12	1.95034e-19
C488	Y#4	A2#11	9.25461e-20
C489	a_475_74##3	a_30_74##2	6.8868e-19
C490	VPWR#3	A1#13	3.63788e-18
C491	VGND#4	a_475_74##4	1.56322e-17
C492	a_30_74##6	A2#8	8.2287e-19
C493	a_27_368##16	A3#6	7.44586e-19
C494	a_27_368##10	VPWR#9	1.58013e-17
C495	a_27_368##12	A3#11	8.62068e-19
C496	a_30_74#	A2#10	5.89166e-19
C497	A2	A3#2	6.08246e-18
C498	a_30_74##3	A3#10	4.41656e-20
C499	VPWR#13	A3#11	5.2758e-17
C500	Y#4	Y#3	2.15142e-18
C501	a_27_368##14	VPWR#7	6.22197e-17
C502	A3#2	VPWR#11	6.13865e-19
C503	a_475_74#	A1#5	2.89759e-19
C504	A2	A2#2	2.01335e-17
C505	B1#9	B1#6	4.7044e-17
C506	A2#8	a_475_74##6	1.96536e-17
C507	VPWR#4	A2#6	3.23808e-20
C508	a_27_368##9	a_27_368##14	9.84448e-19
C509	a_30_74##6	a_475_74##6	2.42499e-17
C510	A3#11	a_27_368##16	2.74584e-17
C511	Y#4	A2#10	1.72514e-19
C512	a_27_368##12	A3#9	1.93787e-19
C513	A2	A2#6	5.06442e-17
C514	Y#1	a_27_368#	3.23355e-19
C515	a_30_74##4	A3#10	1.69139e-17
C516	VGND#7	A1#5	8.17512e-20
C517	VPWR#2	A1#10	4.58852e-18
C518	VGND#3	a_475_74##4	2.80896e-17
C519	VPWR#11	A3#11	2.16505e-18
C520	VPWR#13	A3#9	2.66221e-18
C521	A2	A1#6	3.18479e-18
C522	a_30_74#	A2#8	5.61496e-17
C523	Y#3	Y#2	1.62783e-19
C524	a_27_368##3	VPWR#1	3.8607e-17
C525	a_27_368##14	a_27_368##7	2.15957e-18
C526	a_27_368##15	A3#11	1.52813e-19
C527	VPWR#3	A1#10	1.94733e-19
C528	A3#9	a_27_368##16	2.29566e-17
C529	Y#9	A1#3	6.68499e-18
C530	a_30_74##3	A3#8	1.20285e-19
C531	B1#6	B1#5	4.58142e-17
C532	VPWR#1	Y#9	1.01912e-17
C533	a_475_74##6	A1#12	6.05694e-19
C534	a_30_74##6	a_30_74#	2.82978e-18
C535	Y#2	A1#3	2.20587e-18
C536	VPWR#11	A3#9	4.54606e-17
C537	Y#3	a_475_74##5	8.67647e-19
C538	Y#4	A2#8	1.36235e-18
C539	a_27_368##11	A3#4	4.95962e-18
C540	a_27_368##9	VPWR#7	2.47641e-17
C541	Y#4	A2#6	2.6506e-20
C542	VPWR#10	VPWR#8	1.02927e-18
C543	a_30_74##4	A3#8	1.76521e-17
C544	VPWR#1	Y#10	9.22085e-18
C545	a_27_368##7	VPWR#7	7.23251e-17
C546	a_27_368##15	A3#9	3.66575e-19
C547	a_27_368##16	A3#7	3.66575e-19
C548	a_30_74#	A1#12	3.80789e-18
C549	a_27_368#	VPWR#1	7.39905e-17
C550	VPWR#2	A1#8	4.01435e-18
C551	VPWR#11	A3#7	5.25025e-17
C552	a_475_74##2	A1#5	1.22004e-18
C553	a_475_74##6	A1#11	1.49656e-19
C554	a_30_74##3	A3#1	2.37591e-17
C555	a_30_74#	a_475_74##6	3.65247e-17
C556	Y#4	A1#12	4.99844e-17
C557	A3#7	a_27_368##15	2.64826e-17
C558	VPWR#3	A1#8	1.55132e-20
C559	VPWR#7	VPWR#6	1.51967e-18
C560	a_27_368##16	A2#13	1.52813e-19
C561	VGND#4	A3#4	3.58181e-20
C562	Y#3	Y#7	1.70674e-18
C563	VPWR#9	A3#7	2.06668e-18
C564	a_27_368##9	a_27_368##7	1.37196e-18
C565	a_27_368##3	B1#7	2.41069e-19
C566	a_30_74##4	A3#1	8.67344e-20
C567	a_30_74#	A1#11	3.88733e-19
C568	VPWR#11	A2#13	2.11001e-18
C569	Y#2	a_475_74#	1.37455e-17
C570	A1#12	a_475_74##5	1.68044e-17
C571	A1	A1#3	1.60771e-17
C572	a_27_368##14	A3#7	2.24209e-19
C573	A2#13	a_27_368##15	2.43772e-17
C574	a_27_368##7	VPWR#6	5.26862e-17
C575	A1	A1#6	1.50031e-17
C576	a_30_74##3	A2#7	2.1328e-17
C577	Y#4	A1#11	6.95674e-19
C578	VPWR#2	B1#10	3.83345e-19
C579	VPWR#9	A2#13	4.88086e-17
C580	VPWR#10	A3#4	3.08101e-20
C581	Y#3	A1#3	2.08656e-18
C582	a_27_368##14	A2#13	1.54588e-18
C583	a_27_368##15	A2#12	4.6721e-19
C584	a_30_74##2	A2#11	1.66635e-17
C585	Y#3	a_475_74#	5.4563e-17
C586	a_27_368##7	a_27_368##5	2.85897e-18
C587	A1#11	a_475_74##5	1.3898e-17
C588	A3#12	A3#10	3.9603e-17
C589	VPWR#7	A2#13	2.81672e-19
C590	a_475_74#	A1#12	1.77935e-19
C591	A2#12	VPWR#9	2.68531e-17
C592	Y#2	Y#6	5.22661e-19
C593	a_30_74#	Y#4	3.8936e-17
C594	Y#3	A1#5	9.31908e-18
C595	Y#9	B1#3	3.38223e-19
C596	a_30_74##3	A2#11	1.30042e-19
C597	A1#3	B1#7	3.07256e-17
C598	VGND#3	a_475_74##2	6.81946e-17
C599	A2#6	A2#2	2.9094e-18
C600	a_27_368##14	A2#12	4.59238e-17
C601	A1#11	Y#7	1.66135e-17
C602	VGND#3	a_475_74##3	9.67904e-17
C603	a_27_368##5	VPWR#6	4.4318e-17
C604	VPWR#2	B1#9	1.44223e-19
C605	VPWR#7	A2#12	7.67963e-19
C606	VPWR#9	A2#9	7.67963e-19
C607	a_30_74##2	A2#10	1.89782e-17
C608	A3#10	A3#8	4.09573e-17
C609	a_30_74##5	a_30_74##4	5.2354e-19
C610	a_475_74#	A1#11	9.7782e-19
C611	B1#7	Y#9	4.29314e-18
C612	Y#3	Y#6	2.94262e-18
C613	a_27_368##14	A2#9	5.3223e-17
C614	B1	A1#3	1.73686e-17
C615	Y#2	VGND#7	5.04567e-17
C616	a_30_74##3	A2#10	5.71219e-20
C617	VPWR#6	VPWR#5	1.25482e-18
C618	Y#4	A1#6	6.1552e-18
C619	a_27_368##2	Y#9	2.06914e-17
C620	A1#9	Y#7	7.52576e-18
C621	A2#9	VPWR#7	2.66236e-17
C622	VPWR#9	A2#1	2.81672e-19
C623	a_27_368##16	VPWR#10	5.73776e-18
C624	B1	B1#2	2.2256e-17
C625	Y#6	A1#11	3.3065e-19
C626	B1	B1#3	1.64644e-17
C627	VPWR#2	A1#5	1.02413e-19
C628	a_27_368##7	A2#9	1.02641e-18
C629	B1	B1#7	3.52621e-17
C630	a_27_368##14	A2#1	1.43261e-18
C631	A3#8	A3#1	2.48728e-17
C632	VPWR#3	A1#5	5.60198e-20
C633	VPWR#2	B1#6	3.89057e-20
C634	a_475_74##3	A2#6	2.46347e-19
C635	a_30_74##4	VGND#9	2.25094e-17
C636	Y#4	a_475_74##5	8.10218e-19
C637	a_475_74#	A1#9	4.07034e-17
C638	VPWR#1	B1#2	1.1053e-20
C639	a_27_368##5	VPWR#5	4.4047e-17
C640	VPWR#7	A2#1	5.38669e-17
C641	VGND#7	A1#11	4.55324e-18
C642	Y#2	B1#3	1.46499e-18
C643	A1#6	A1#10	3.44989e-20
C644	VPWR#1	B1#3	2.25602e-20
C645	a_27_368##7	A2#1	3.43462e-17
C646	a_27_368##14	A1#7	1.65796e-19
C647	a_27_368##2	a_27_368##13	5.66162e-20
C648	Y#6	A1#9	1.00231e-18
C649	VPWR#1	B1#7	4.95635e-20
C650	B1#3	a_27_368##13	5.79373e-19
C651	VPWR#6	A2#1	7.51961e-19
C652	VPWR#7	A1#7	1.86275e-18
C653	a_27_368##5	a_27_368##3	2.90721e-18
C654	A3#1	A2#7	3.97628e-17
C655	a_27_368##9	VPWR#4	1.6661e-19
C656	a_475_74#	A1#1	3.78613e-17
C657	a_30_74##4	a_30_74##8	1.24483e-18
C658	VGND#7	A1#9	4.6752e-18
C659	a_30_74##3	VGND#8	1.6218e-17
C660	a_27_368##7	A1#7	7.51927e-17
C661	VPWR#2	B1#5	2.38844e-20
C662	B1#7	a_27_368##13	5.91569e-19
C663	Y#2	B1#7	8.60027e-18
C664	VGND#9	A3#5	4.08925e-19
C665	a_475_74##2	A2#10	1.3533e-19
C666	a_27_368##15	VPWR#8	6.0273e-18
C667	A1#1	Y#6	1.38136e-17
C668	VPWR#7	A1#13	2.80804e-19
C669	A1#7	VPWR#6	2.15744e-17
C670	Y#9	a_27_368##5	1.60794e-17
C671	a_27_368##3	VPWR#5	6.31187e-17
C672	a_27_368##2	Y#10	1.48251e-17
C673	A2#7	A2#11	3.48445e-17
C674	a_475_74#	B1#8	2.15733e-18
C675	a_27_368##7	A1#13	2.64214e-18
C676	a_27_368##5	A1#7	4.62654e-19
C677	a_30_74##3	a_27_368##10	1.94747e-17
C678	a_475_74##2	A1#6	1.43839e-18
C679	a_475_74##3	A2#10	1.49961e-17
C680	a_30_74##4	VGND#8	1.42084e-17
C681	B1#2	Y#10	1.39623e-18
C682	VGND#7	A1#1	5.35956e-18
C683	a_27_368##15	VPWR#10	6.07186e-18
C684	a_30_74##3	a_30_74##7	5.13056e-19
C685	VPWR#6	A1#13	4.25276e-17
C686	a_27_368##2	VPWR#1	9.64426e-17
C687	Y#9	VPWR#5	1.43251e-18
C688	a_30_74##2	a_475_74##4	1.53494e-17
C689	Y#6	B1#8	4.18375e-17
C690	a_475_74##2	A2#8	1.06288e-18
C691	a_27_368##7	A1#10	1.90702e-19
C692	a_27_368##5	A1#13	6.15452e-17
C693	A2#6	VPWR#9	1.78267e-18
C694	a_475_74#	B1#1	2.83384e-19
C695	B1#3	Y#10	1.95867e-18
C696	a_27_368##9	VPWR#8	1.74291e-19
C697	A2#11	A2#10	3.67991e-17
C698	B1#3	B1#2	8.80869e-19
C699	VPWR#6	A1#10	6.52369e-19
C700	VPWR#5	A1#13	5.87486e-19
C701	a_475_74##3	A2#8	1.78719e-17
C702	B1#8	VGND#7	3.47165e-17
C703	Y#9	a_27_368##3	1.16834e-16
C704	a_30_74##3	a_475_74##4	1.20452e-17
C705	a_27_368##7	A1#8	8.83603e-20
C706	a_30_74##2	a_30_74##6	4.99122e-19
C707	a_27_368##5	A1#10	7.93248e-17
C708	Y#6	B1#1	6.31999e-19
C709	a_475_74##2	A1#12	3.29615e-17
C710	VGND#4	A3#10	9.71076e-19
C711	Y#1	B1#8	6.27073e-19
C712	a_475_74#	Y#7	7.82987e-19
C713	VPWR#6	A1#8	2.07384e-19
C714	Y#9	A1#13	1.17552e-19
C715	A1#10	VPWR#5	3.33993e-17
C716	VPWR#4	VPWR#3	8.03217e-19
C717	a_27_368##3	a_27_368##13	3.8222e-18
C718	A2#10	A2#8	2.1663e-17
C719	VPWR#8	VPWR#4	8.03217e-19
C720	B1#1	VGND#7	3.46345e-17
C721	VGND#8	A3#2	5.00869e-19
C722	a_27_368##14	VPWR#8	6.26355e-18
C723	a_27_368##5	A1#8	5.63165e-19
C724	a_27_368##3	A1#10	8.22822e-19
C725	a_27_368##10	VPWR#8	2.66562e-19
C726	a_30_74##3	a_30_74##6	7.71851e-19
C727	a_475_74#	A1#3	8.07354e-19
C728	a_27_368#	B1#2	7.89769e-20
C729	a_30_74##2	a_475_74##6	1.84465e-17
C730	A1#8	VPWR#5	2.98778e-17
C731	Y#9	A1#10	6.03813e-18
C732	Y#9	a_27_368##13	4.63374e-17
C733	a_475_74##2	A1#11	2.56005e-17
C734	Y#1	B1#1	5.50356e-17
C735	VPWR#7	VPWR#3	1.09337e-19
C736	Y#2	Y#9	3.49514e-18
C737	a_27_368##3	A1#8	5.98957e-17
C738	VGND#4	A3#8	5.36554e-18
C739	A2#6	a_27_368##14	5.48219e-19
C740	A2#8	A1#12	3.5711e-18
C741	A2#2	VPWR#7	9.19595e-19
C742	A2#8	A1#6	8.96237e-20
C743	B1#7	B1#2	6.23031e-19
C744	VPWR#5	B1#10	8.69729e-20
C745	Y#9	A1#8	1.94918e-17
C746	a_27_368##10	VPWR#10	2.54815e-19
C747	Y#9	Y#10	3.01982e-18
C748	Y#3	Y#9	1.18756e-18
C749	a_475_74#	Y#6	4.64599e-17
C750	a_27_368##3	B1#10	4.00055e-17
C751	a_27_368##13	A1#8	2.71044e-19
C752	a_475_74##2	A1#9	7.08857e-19
C753	a_27_368##10	A3#6	2.52025e-19
C754	VGND#5	A3#8	9.71076e-19
C755	VGND#5	A3#10	5.48658e-18
C756	VGND#5	A3#12	5.38509e-18
C757	VGND#5	A3#4	3.85385e-20
C758	VGND#5	a_30_74##8	5.24871e-18
C759	VGND#5	A3	5.97387e-19
C760	VGND#5	a_30_74##5	1.7841e-17
C761	VGND#5	a_30_74##4	2.91756e-19
C762	VGND#5	VGND#4	1.68991e-18
C763	VGND	VGND#5	9.65962e-17
C764	VGND#5	VNB	4.66226e-17
C765	VGND#2	Y#2	3.79814e-18
C766	VPWR#12	A3#11	9.78637e-19
C767	VGND#2	B1#8	1.0349e-19
C768	a_27_368##16	VPWR#12	5.78018e-18
C769	VGND#2	Y#6	8.84943e-18
C770	VGND#2	Y#1	3.39165e-17
C771	VPWR#12	A3#4	2.02698e-20
C772	VPWR#12	VNB	4.58465e-17
C773	VGND#2	B1#1	7.23717e-19
C774	VGND#2	B1	1.04387e-17
C775	a_27_368##11	VPWR#12	1.6661e-19
C776	VGND#2	VNB	1.31673e-16
C777	VGND#2	VGND#7	1.68337e-16
C778	VPWR#12	VPWR#10	1.03096e-18
C779	VPWR	VPWR#12	7.57413e-17
C780	VPWR#12	A3#6	9.77087e-19
C781	a_27_368##12	VPWR#12	1.92191e-17
*
*
.ENDS sky130_fd_sc_hs__a31oi_4
*
