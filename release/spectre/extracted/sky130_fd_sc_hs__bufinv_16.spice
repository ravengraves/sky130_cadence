* Extracted by Quantus, converted by sky130cad/quantus.py
*
*
*
*                       LINUX           Wed Nov 18 08:21:22 2026
*
*
*
*  PROGRAM  advgen
*
*  Name           : advgen - Quantus - (64-bit)
*  Version        : 25.1.0-p047
*  Build Date     : Thu Dec 11 23:20:30 PST 2025
*
*  HSPICE LIBRARY
*
*  OPERATING_TEMPERATURE 150
*  QRC_TECH_DIR <path>/tech
*
*
*

*
.SUBCKT sky130_fd_sc_hs__bufinv_16 VPB VNB VGND Y VPWR A
*
*
*  caps2d version: 10
*
*
*       TRANSISTOR CARDS
*
*
XM2 VGND#27 A#7 a_27_74##24 VNB sky130_fd_pr__nfet_01v8_lvt l=0.15 w=0.74 ad=0.2516 as=0.2109 pd=2.16 ps=2.05
XM44 a_27_74##27 A#5 VGND#27 VNB sky130_fd_pr__nfet_01v8_lvt l=0.15 w=0.74 ad=0.2072 as=0.2516 pd=2.04 ps=2.16
XM43 a_27_74##27 A#1 VGND#26 VNB sky130_fd_pr__nfet_01v8_lvt l=0.15 w=0.74 ad=0.2072 as=0.2072 pd=2.04 ps=2.04
XM17 VGND#26 a_27_74##18 a_384_74##58 VNB sky130_fd_pr__nfet_01v8_lvt l=0.15 w=0.74 ad=0.2072 as=0.2072 pd=2.04 ps=2.04
XM16 VGND#25 a_27_74##16 a_384_74##58 VNB sky130_fd_pr__nfet_01v8_lvt l=0.15 w=0.74 ad=0.2072 as=0.2072 pd=2.04 ps=2.04
XM30 a_384_74##63 a_27_74##13 VGND#25 VNB sky130_fd_pr__nfet_01v8_lvt l=0.15 w=0.74 ad=0.2072 as=0.2072 pd=2.04 ps=2.04
XM21 a_384_74##63 a_27_74##12 VGND#24 VNB sky130_fd_pr__nfet_01v8_lvt l=0.15 w=0.74 ad=0.2072 as=0.259 pd=2.04 ps=2.18
XM5 VGND#24 a_27_74##9 a_384_74##62 VNB sky130_fd_pr__nfet_01v8_lvt l=0.15 w=0.74 ad=0.259 as=0.2072 pd=2.18 ps=2.04
XM45 a_384_74##62 a_27_74##8 VGND#23 VNB sky130_fd_pr__nfet_01v8_lvt l=0.15 w=0.74 ad=0.2072 as=0.259 pd=2.04 ps=2.18
XM13 VGND#23 a_384_74##23 Y#1 VNB sky130_fd_pr__nfet_01v8_lvt l=0.15 w=0.74 ad=0.259 as=0.2072 pd=2.18 ps=2.04
XM35 VGND#22 a_384_74##51 Y#1 VNB sky130_fd_pr__nfet_01v8_lvt l=0.15 w=0.74 ad=0.2072 as=0.2072 pd=2.04 ps=2.04
XM4 Y#4 a_384_74##49 VGND#22 VNB sky130_fd_pr__nfet_01v8_lvt l=0.15 w=0.74 ad=0.2072 as=0.2072 pd=2.04 ps=2.04
XM26 Y#4 a_384_74##47 VGND#21 VNB sky130_fd_pr__nfet_01v8_lvt l=0.15 w=0.74 ad=0.2072 as=0.259 pd=2.04 ps=2.18
XM31 VGND#21 a_384_74##45 Y#7 VNB sky130_fd_pr__nfet_01v8_lvt l=0.15 w=0.74 ad=0.259 as=0.2072 pd=2.18 ps=2.04
XM46 Y#7 a_384_74##43 VGND#20 VNB sky130_fd_pr__nfet_01v8_lvt l=0.15 w=0.74 ad=0.2072 as=0.259 pd=2.04 ps=2.18
XM48 VGND#20 a_384_74##41 Y#12 VNB sky130_fd_pr__nfet_01v8_lvt l=0.15 w=0.74 ad=0.259 as=0.2072 pd=2.18 ps=2.04
XM25 Y#12 a_384_74##39 VGND#19 VNB sky130_fd_pr__nfet_01v8_lvt l=0.15 w=0.74 ad=0.2072 as=0.259 pd=2.04 ps=2.18
XM9 Y#13 a_384_74##37 VGND#19 VNB sky130_fd_pr__nfet_01v8_lvt l=0.15 w=0.74 ad=0.2072 as=0.259 pd=2.04 ps=2.18
XM3 Y#13 a_384_74##35 VGND#18 VNB sky130_fd_pr__nfet_01v8_lvt l=0.15 w=0.74 ad=0.2072 as=0.259 pd=2.04 ps=2.18
XM6 Y#16 a_384_74##33 VGND#18 VNB sky130_fd_pr__nfet_01v8_lvt l=0.15 w=0.74 ad=0.2072 as=0.259 pd=2.04 ps=2.18
XM7 Y#16 a_384_74##31 VGND#17 VNB sky130_fd_pr__nfet_01v8_lvt l=0.15 w=0.74 ad=0.2072 as=0.259 pd=2.04 ps=2.18
XM47 VGND#17 a_384_74##29 Y#19 VNB sky130_fd_pr__nfet_01v8_lvt l=0.15 w=0.74 ad=0.259 as=0.2072 pd=2.18 ps=2.04
XM27 VGND#16 a_384_74##27 Y#19 VNB sky130_fd_pr__nfet_01v8_lvt l=0.15 w=0.74 ad=0.259 as=0.2072 pd=2.18 ps=2.04
XM14 VGND#16 a_384_74##25 Y#25 VNB sky130_fd_pr__nfet_01v8_lvt l=0.15 w=0.74 ad=0.259 as=0.2072 pd=2.18 ps=2.04
XM39 VGND#1 a_384_74##24 Y#25 VNB sky130_fd_pr__nfet_01v8_lvt l=0.15 w=0.74 ad=0.2627 as=0.2072 pd=2.19 ps=2.04
XM49 a_27_74##26 A#9 VPWR#26 VPB sky130_fd_pr__pfet_01v8 l=0.15 w=1.12 ad=0.3304 as=0.336 pd=2.83 ps=2.84
XM37 a_27_74##28 A#8 VPWR#26 VPB sky130_fd_pr__pfet_01v8 l=0.15 w=1.12 ad=0.336 as=0.336 pd=2.84 ps=2.84
XM22 VPWR#24 A#4 a_27_74##28 VPB sky130_fd_pr__pfet_01v8 l=0.15 w=1.12 ad=0.336 as=0.336 pd=2.84 ps=2.84
XM19 VPWR#24 a_27_74##20 a_384_74##61 VPB sky130_fd_pr__pfet_01v8 l=0.15 w=1.12 ad=0.336 as=0.3584 pd=2.84 ps=2.88
XM40 a_384_74##61 a_27_74##19 VPWR#22 VPB sky130_fd_pr__pfet_01v8 l=0.15 w=1.12 ad=0.3584 as=0.336 pd=2.88 ps=2.84
XM23 VPWR#22 a_27_74##14 a_384_74##65 VPB sky130_fd_pr__pfet_01v8 l=0.15 w=1.12 ad=0.336 as=0.336 pd=2.84 ps=2.84
XM0 a_384_74##65 a_27_74##11 VPWR#20 VPB sky130_fd_pr__pfet_01v8 l=0.15 w=1.12 ad=0.336 as=0.336 pd=2.84 ps=2.84
XM28 VPWR#20 a_27_74##10 a_384_74##64 VPB sky130_fd_pr__pfet_01v8 l=0.15 w=1.12 ad=0.336 as=0.336 pd=2.84 ps=2.84
XM42 a_384_74##64 a_27_74# VPWR#19 VPB sky130_fd_pr__pfet_01v8 l=0.15 w=1.12 ad=0.336 as=0.336 pd=2.84 ps=2.84
XM15 Y#3 a_384_74##53 VPWR#19 VPB sky130_fd_pr__pfet_01v8 l=0.15 w=1.12 ad=0.336 as=0.336 pd=2.84 ps=2.84
XM20 VPWR#18 a_384_74##52 Y#3 VPB sky130_fd_pr__pfet_01v8 l=0.15 w=1.12 ad=0.336 as=0.336 pd=2.84 ps=2.84
XM18 Y#6 a_384_74##50 VPWR#18 VPB sky130_fd_pr__pfet_01v8 l=0.15 w=1.12 ad=0.336 as=0.336 pd=2.84 ps=2.84
XM29 VPWR#17 a_384_74##48 Y#6 VPB sky130_fd_pr__pfet_01v8 l=0.15 w=1.12 ad=0.336 as=0.336 pd=2.84 ps=2.84
XM34 VPWR#17 a_384_74##46 Y#9 VPB sky130_fd_pr__pfet_01v8 l=0.15 w=1.12 ad=0.336 as=0.336 pd=2.84 ps=2.84
XM1 Y#9 a_384_74##44 VPWR#16 VPB sky130_fd_pr__pfet_01v8 l=0.15 w=1.12 ad=0.336 as=0.336 pd=2.84 ps=2.84
XM32 Y#10 a_384_74##42 VPWR#16 VPB sky130_fd_pr__pfet_01v8 l=0.15 w=1.12 ad=0.336 as=0.336 pd=2.84 ps=2.84
XM8 VPWR#15 a_384_74##40 Y#10 VPB sky130_fd_pr__pfet_01v8 l=0.15 w=1.12 ad=0.336 as=0.336 pd=2.84 ps=2.84
XM24 Y#15 a_384_74##38 VPWR#15 VPB sky130_fd_pr__pfet_01v8 l=0.15 w=1.12 ad=0.336 as=0.336 pd=2.84 ps=2.84
XM12 Y#15 a_384_74##36 VPWR#14 VPB sky130_fd_pr__pfet_01v8 l=0.15 w=1.12 ad=0.336 as=0.392 pd=2.84 ps=2.94
XM11 Y#18 a_384_74##34 VPWR#14 VPB sky130_fd_pr__pfet_01v8 l=0.15 w=1.12 ad=0.336 as=0.392 pd=2.84 ps=2.94
XM33 VPWR#13 a_384_74##32 Y#18 VPB sky130_fd_pr__pfet_01v8 l=0.15 w=1.12 ad=0.392 as=0.336 pd=2.94 ps=2.84
XM41 VPWR#13 a_384_74##30 Y#21 VPB sky130_fd_pr__pfet_01v8 l=0.15 w=1.12 ad=0.392 as=0.336 pd=2.94 ps=2.84
XM36 VPWR#12 a_384_74##28 Y#21 VPB sky130_fd_pr__pfet_01v8 l=0.15 w=1.12 ad=0.3472 as=0.336 pd=2.86 ps=2.84
XM38 VPWR#12 a_384_74##26 Y#22 VPB sky130_fd_pr__pfet_01v8 l=0.15 w=1.12 ad=0.3472 as=0.3808 pd=2.86 ps=2.92
XM10 Y#22 a_384_74# VPWR#1 VPB sky130_fd_pr__pfet_01v8 l=0.15 w=1.12 ad=0.3808 as=0.3304 pd=2.92 ps=2.83
*
*
*       RESISTOR AND CAP/DIODE CARDS
*
Rg1	A#1	A#2	397.555725
Rg2	A#2	A#3	73.670235
Rg3	A#2	A#4	449.655212
Rg4	A#3	A#5	383.404541
Rg5	A#3	A#6	64.081955
Rg6	A#6	A#7	397.555725
Rg7	A#3	A#8	429.126801
Rg8	A#6	A#9	449.655212
Rg9	a_27_74#	a_27_74##2	527.513611
Rg10	a_27_74##2	a_27_74##3	203.314056
Rg11	a_27_74##3	a_27_74##4	76.522545
Rg12	a_27_74##4	a_27_74##5	26.825764
Rg13	a_27_74##5	a_27_74##6	60.911690
Rg14	a_27_74##6	a_27_74##7	16.028849
Rg15	a_27_74##2	a_27_74##8	361.167877
Rg16	a_27_74##3	a_27_74##9	368.897400
Rg17	a_27_74##3	a_27_74##10	471.698395
Rg18	a_27_74##4	a_27_74##11	411.085419
Rg19	a_27_74##5	a_27_74##12	379.087921
Rg20	a_27_74##6	a_27_74##13	451.009796
Rg21	a_27_74##6	a_27_74##14	494.049438
Rg22	a_27_74##7	a_27_74##15	53.724728
Rg23	a_27_74##15	a_27_74##16	423.278687
Rg24	a_27_74##15	a_27_74##17	64.574753
Rg25	a_27_74##17	a_27_74##18	368.862610
Rg26	a_27_74##15	a_27_74##19	466.318329
Rg27	a_27_74##17	a_27_74##20	471.862823
Rg28	a_384_74#	a_384_74##2	474.792969
Rg29	a_384_74##2	a_384_74##3	74.244629
Rg30	a_384_74##3	a_384_74##4	50.538216
Rg31	a_384_74##4	a_384_74##5	30.850983
Rg32	a_384_74##5	a_384_74##6	76.963417
Rg33	a_384_74##6	a_384_74##7	51.295765
Rg34	a_384_74##7	a_384_74##8	32.331371
Rg35	a_384_74##8	a_384_74##9	72.553886
Rg36	a_384_74##9	a_384_74##10	49.020065
Rg37	a_384_74##10	a_384_74##11	35.039188
Rg38	a_384_74##11	a_384_74##12	73.191963
Rg39	a_384_74##12	a_384_74##13	45.965961
Rg40	a_384_74##13	a_384_74##14	32.285915
Rg41	a_384_74##14	a_384_74##15	72.553879
Rg42	a_384_74##15	a_384_74##16	47.096798
Rg43	a_384_74##16	a_384_74##17	31.144489
Rg44	a_384_74##17	a_384_74##18	73.610207
Rg45	a_384_74##18	a_384_74##19	47.719563
Rg46	a_384_74##19	a_384_74##20	105.269493
Rg47	a_384_74##20	a_384_74##21	44.198460
Rg48	a_384_74##21	a_384_74##22	91.667946
Rg49	a_384_74##22	a_384_74##23	368.862610
Rg50	a_384_74##2	a_384_74##24	377.321411
Rg51	a_384_74##3	a_384_74##25	365.868195
Rg52	a_384_74##3	a_384_74##26	468.868408
Rg53	a_384_74##5	a_384_74##27	365.821045
Rg54	a_384_74##5	a_384_74##28	469.818115
Rg55	a_384_74##6	a_384_74##29	394.814545
Rg56	a_384_74##6	a_384_74##30	437.854187
Rg57	a_384_74##8	a_384_74##31	394.814545
Rg58	a_384_74##8	a_384_74##32	437.854187
Rg59	a_384_74##9	a_384_74##33	397.730652
Rg60	a_384_74##9	a_384_74##34	440.770294
Rg61	a_384_74##11	a_384_74##35	397.730652
Rg62	a_384_74##11	a_384_74##36	440.770294
Rg63	a_384_74##12	a_384_74##37	407.645752
Rg64	a_384_74##12	a_384_74##38	450.685394
Rg65	a_384_74##14	a_384_74##39	397.730652
Rg66	a_384_74##14	a_384_74##40	440.770294
Rg67	a_384_74##15	a_384_74##41	394.814545
Rg68	a_384_74##15	a_384_74##42	437.854187
Rg69	a_384_74##17	a_384_74##43	414.365143
Rg70	a_384_74##17	a_384_74##44	457.404785
Rg71	a_384_74##18	a_384_74##45	402.070007
Rg72	a_384_74##18	a_384_74##46	445.109619
Rg73	a_384_74##19	a_384_74##47	364.316711
Rg74	a_384_74##19	a_384_74##48	447.184967
Rg75	a_384_74##20	a_384_74##49	423.278687
Rg76	a_384_74##20	a_384_74##50	466.318329
Rg77	a_384_74##21	a_384_74##51	345.146149
Rg78	a_384_74##21	a_384_74##52	446.614410
Rg79	a_384_74##22	a_384_74##53	471.862823
Rf1	A	A#10	8.404075
Rf2	A#10	A	6.264856
Rf3	a_27_74##7	a_27_74##22	65.331589
Rf4	a_27_74##22	a_27_74##23	57.768112
Rf5	a_27_74##23	a_27_74##24	90.541153
Rf6	a_27_74##22	a_27_74##25	73.351395
Rf7	a_27_74##25	a_27_74##26	81.107391
Rf8	a_27_74##23	a_27_74##27	28.306047
Rf9	a_27_74##25	a_27_74##28	18.602406
Rf10	a_384_74##54	a_384_74##55	7.034982
Rf11	a_384_74##55	a_384_74##56	23.489130
Rf12	a_384_74##56	a_384_74##57	61.669346
Rf13	a_384_74##57	a_384_74##58	84.951050
Rf14	a_384_74##55	a_384_74##59	15.120852
Rf15	a_384_74##59	a_384_74##60	57.739658
Rf16	a_384_74##60	a_384_74##61	84.453606
Rf17	a_384_74##56	a_384_74##62	23.106659
Rf18	a_384_74##57	a_384_74##63	18.783115
Rf19	a_384_74##59	a_384_74##64	25.258175
Rf20	a_384_74##60	a_384_74##65	21.948624
Rf21	Y#1	Y#2	72.407570
Rf22	Y#2	Y#3	19.762726
Rf23	a_384_74##66	a_384_74##21	179.530060
Rf24	Y#4	Y#5	81.704468
Rf25	Y#5	Y#6	19.762726
Rf26	a_384_74##68	a_384_74##19	177.884048
Rf27	Y#7	Y#8	76.132385
Rf28	Y#8	Y#9	19.762726
Rf29	a_384_74##70	a_384_74##16	177.884048
Rf30	Y#10	Y#11	19.762726
Rf31	Y#11	Y#12	73.551369
Rf32	a_384_74##13	a_384_74##73	177.884048
Rf33	Y#13	Y#14	72.779747
Rf34	Y#14	Y#15	19.369053
Rf35	a_384_74##74	a_384_74##10	177.884048
Rf36	Y#16	Y#17	72.779747
Rf37	Y#17	Y#18	19.369053
Rf38	a_384_74##7	a_384_74##77	177.884048
Rf39	Y#19	Y#20	72.492256
Rf40	Y#20	Y#21	19.762726
Rf41	a_384_74##78	a_384_74##4	168.106262
Rf42	Y#23	Y#24	13.052517
Rf43	Y#24	Y#25	57.738995
Rf44	Y#22	Y#23	5.000000
Rf45	VGND#1	VGND#2	102.675797
Rf46	VGND#2	VGND#3	67.887894
Rf47	VGND#3	VGND#4	31.387180
Rf48	VGND#4	VGND#5	36.500717
Rf49	VGND#5	VGND#6	67.887894
Rf50	VGND#6	VGND#7	67.887894
Rf51	VGND#7	VGND#8	67.887894
Rf52	VGND#8	VGND#9	65.753731
Rf53	VGND#9	VGND#10	65.023224
Rf54	VGND#10	VGND#11	68.314209
Rf55	VGND#11	VGND#12	67.787148
Rf56	VGND#12	VGND#13	59.909691
Rf57	VGND#13	VGND#14	67.157394
Rf59	VGND#2	VGND#16	32.814167
Rf60	VGND#3	VGND#17	32.814167
Rf61	VGND#5	VGND#18	32.814167
Rf62	VGND#6	VGND#19	32.814167
Rf63	VGND#7	VGND#20	32.814167
Rf64	VGND#8	VGND#21	32.814167
Rf65	VGND#9	VGND#22	40.399361
Rf66	VGND#10	VGND#23	33.306259
Rf67	VGND#11	VGND#24	39.776924
Rf68	VGND#12	VGND#25	42.655182
Rf69	VGND#13	VGND#26	38.247387
Rf70	VGND#14	VGND#27	38.247387
Rf71	VPWR#1	VPWR#2	117.680092
Rf72	VPWR#2	VPWR#3	68.774590
Rf73	VPWR#3	VPWR#4	34.926804
Rf74	VPWR#4	VPWR#5	34.935162
Rf75	VPWR#5	VPWR#6	67.905930
Rf76	VPWR#6	VPWR#7	65.941528
Rf77	VPWR#7	VPWR#8	65.941528
Rf78	VPWR#8	VPWR#9	65.941528
Rf79	VPWR#9	VPWR#10	65.941528
Rf80	VPWR#10	VPWR#11	74.098198
Rf81	VPWR#2	VPWR#12	51.822784
Rf82	VPWR#3	VPWR#13	48.124508
Rf83	VPWR#5	VPWR#14	49.906605
Rf84	VPWR#6	VPWR#15	64.157562
Rf85	VPWR#7	VPWR#16	64.157562
Rf86	VPWR#8	VPWR#17	64.157562
Rf87	VPWR#9	VPWR#18	64.157562
Rf88	VPWR#10	VPWR#19	64.157562
Rf89	VPWR#11	VPWR#20	64.369812
Rf90	VPWR#11	VPWR#21	58.903690
Rf91	VPWR#21	VPWR#22	58.622005
Rf92	VPWR#21	VPWR#23	67.402542
Rf93	VPWR#23	VPWR#24	53.143215
Rf94	VPWR#23	VPWR#25	65.941528
Rf95	VPWR#25	VPWR#26	53.143215
Rf97	A#3	A#10	53.410934
Re1	a_384_74##78	a_384_74##77	10.625852
Re2	a_384_74##77	a_384_74##74	0.838999
Re3	a_384_74##74	a_384_74##73	0.843534
Re4	a_384_74##73	a_384_74##70	0.829929
Re5	a_384_74##70	a_384_74##68	0.852604
Re6	a_384_74##68	a_384_74##66	0.807253
Re7	a_384_74##66	a_384_74##54	10.562360
Re8	Y#24	Y#27	10.639457
Re9	Y#27	Y#28	0.861674
Re10	Y#28	Y#29	0.861674
Re11	Y#29	Y	0.340135
Re12	Y	Y#30	0.476189
Re13	Y#30	Y#31	0.816323
Re14	Y#31	Y#32	0.816323
Re15	Y#32	Y#2	10.585035
Re16	VPWR#4	VPWR	2.179561
Re17	VPWR	VPWR#11	1.712512
Re18	VGND#4	VGND	2.179561
Re19	VGND	VGND#11	1.712512
Re29	Y#20	Y#27	9.777782
Re30	Y#17	Y#28	9.777782
Re31	Y#14	Y#29	9.777782
Re32	Y#11	Y#30	9.777782
Re33	Y#8	Y#31	9.777782
Re34	Y#5	Y#32	9.777782
*
*       CAPACITOR CARDS
*
*
C1	VPWR#26	a_27_74##20	1.53981e-19
C2	a_384_74##25	a_384_74##24	3.84042e-17
C3	VGND#23	VGND#22	2.53213e-18
C4	A#4	VPWR#24	2.75034e-17
C5	a_384_74##66	VGND#10	4.34119e-21
C6	VPWR#2	VPWR#1	6.90304e-19
C7	VGND#16	a_384_74##31	3.18276e-19
C8	a_384_74##77	VPWR#13	8.03027e-18
C9	A#5	a_27_74##27	1.78083e-17
C10	a_384_74##66	VGND#9	2.20193e-18
C11	Y#11	a_384_74##17	8.61968e-18
C12	a_27_74##24	A#1	1.75368e-19
C13	a_27_74##28	A#4	5.23928e-17
C14	a_384_74##29	VGND#17	1.68567e-17
C15	a_384_74##66	VGND#8	5.49884e-20
C16	a_384_74##28	a_384_74##26	4.65347e-17
C17	VGND#13	a_27_74##16	6.3656e-19
C18	Y#15	VPWR#14	5.62921e-17
C19	a_384_74##55	a_27_74##3	1.50518e-17
C20	VGND#26	A#7	1.67894e-19
C21	a_384_74##54	VPWR#10	1.65904e-18
C22	VGND#4	VGND#1	6.41676e-17
C23	a_27_74##22	a_27_74##17	1.67007e-17
C24	VPWR#26	A#4	6.54315e-19
C25	VPWR#23	a_27_74##20	6.78248e-18
C26	A#5	VGND#27	1.72349e-17
C27	Y#11	a_384_74##14	6.86952e-18
C28	a_384_74##70	VGND#20	5.81893e-18
C29	VPWR#24	A#8	6.12523e-19
C30	Y#19	a_384_74##31	1.56825e-18
C31	VGND#4	Y#25	2.04569e-17
C32	VGND#9	a_384_74##22	3.47801e-20
C33	VGND#23	Y#1	7.41228e-17
C34	VPWR#20	a_27_74##3	4.07513e-19
C35	Y#17	VPWR#13	3.22658e-17
C36	VPWR#21	a_27_74##20	2.75115e-19
C37	a_27_74##2	a_384_74##22	2.11162e-17
C38	VGND#4	VGND#16	1.7413e-17
C39	a_27_74##28	A#8	4.59447e-17
C40	Y#16	a_384_74##29	3.96575e-19
C41	a_384_74##16	a_384_74##17	2.84234e-17
C42	VGND#12	a_27_74##16	5.58443e-18
C43	a_27_74##27	A#7	1.20069e-18
C44	a_27_74##24	A#5	7.40254e-19
C45	VGND#4	Y#19	1.53286e-17
C46	Y#17	Y#18	6.89997e-19
C47	VGND#16	VPWR#12	9.12823e-20
C48	a_384_74##27	a_384_74##25	2.90078e-17
C49	VGND#1	Y#25	7.7233e-17
C50	A#8	VPWR#26	2.52415e-17
C51	a_384_74##30	a_384_74##28	4.61905e-17
C52	VPWR#23	A#2	2.01982e-20
C53	a_27_74##3	a_27_74#	4.08218e-18
C54	Y#22	VPWR#2	1.75435e-17
C55	VPWR#15	VPWR#14	1.92146e-18
C56	a_384_74##11	Y#15	1.01727e-19
C57	VGND#17	a_384_74##31	4.36691e-17
C58	VPWR#24	A#9	3.50621e-19
C59	VGND#4	VGND#17	1.70067e-17
C60	VPWR#3	a_384_74##5	1.00565e-20
C61	VPWR#9	VPWR#8	6.93111e-19
C62	Y#17	VPWR#14	3.39281e-17
C63	VGND#27	A#7	3.28471e-17
C64	VPWR#11	VPWR#23	6.18522e-17
C65	VGND#4	Y#16	2.91344e-17
C66	a_27_74##26	A#8	2.12167e-18
C67	a_384_74##55	a_27_74##2	1.72906e-17
C68	a_27_74##28	A#9	1.99344e-18
C69	a_27_74##22	a_27_74##15	3.37505e-17
C70	VPWR#22	a_27_74##15	7.87338e-19
C71	VPWR#11	VPWR#21	5.97533e-17
C72	VGND#13	a_27_74##18	8.03728e-18
C73	Y#19	a_384_74##33	1.94488e-19
C74	VGND#4	VGND#18	1.70067e-17
C75	VPWR#11	VPWR#10	5.80854e-17
C76	A#9	VPWR#26	3.08474e-17
C77	VPWR#23	A#4	5.18502e-18
C78	a_384_74##17	Y#10	1.1473e-19
C79	Y#16	a_384_74##31	1.32499e-17
C80	VGND#4	Y#13	1.53286e-17
C81	a_27_74##24	A#7	3.37619e-17
C82	VPWR#11	VPWR#9	5.81399e-17
C83	VGND#9	VGND#8	1.08661e-18
C84	VPWR#15	Y#15	5.56804e-17
C85	a_384_74##70	a_384_74##17	7.64079e-18
C86	a_384_74##32	a_384_74##30	3.89705e-17
C87	VPWR#10	a_27_74##2	3.28839e-20
C88	VPWR#11	VPWR#8	5.87722e-17
C89	VGND#4	VGND#19	1.70646e-17
C90	a_384_74##74	VPWR#14	6.51523e-18
C91	VGND#12	a_27_74##18	6.94539e-19
C92	a_27_74##26	A#9	5.81998e-17
C93	VPWR#21	A#4	7.75555e-20
C94	VGND#16	VGND#1	1.84033e-18
C95	VPWR#11	VPWR#7	3.36218e-18
C96	VGND#17	a_384_74##33	2.32609e-18
C97	a_27_74##5	a_27_74##10	1.71475e-18
C98	VGND#4	Y#12	1.5157e-17
C99	a_384_74##54	VGND#10	1.33093e-18
C100	a_384_74##29	a_384_74##27	3.94171e-17
C101	VGND#4	VGND#20	1.70646e-17
C102	VGND#18	a_384_74##31	7.30871e-19
C103	a_384_74##62	VGND#23	4.48095e-17
C104	a_384_74##61	a_27_74##17	1.79274e-18
C105	a_384_74##19	a_384_74##17	4.99616e-18
C106	VGND#13	A#1	5.36121e-18
C107	Y#16	a_384_74##33	3.73637e-17
C108	Y#21	VPWR#3	8.90011e-18
C109	Y#14	VPWR#14	3.21817e-17
C110	a_384_74##34	a_384_74##32	4.6199e-17
C111	VPWR#2	a_384_74##5	9.8432e-20
C112	Y#14	Y#15	2.32124e-18
C113	VPWR#23	A#8	5.02784e-19
C114	VGND#16	Y#25	7.32022e-17
C115	VGND#17	a_384_74##35	3.18276e-19
C116	a_384_74##61	a_27_74##15	3.58354e-18
C117	VPWR#15	Y#14	1.87659e-17
C118	a_384_74##14	Y#10	1.132e-19
C119	Y#8	VGND#20	6.99845e-19
C120	a_384_74##33	VGND#18	1.68567e-17
C121	VGND#24	VGND#23	2.17902e-18
C122	Y#10	VPWR#15	5.52661e-17
C123	a_27_74##22	a_27_74##5	1.97671e-17
C124	a_384_74##31	a_384_74##29	2.9012e-17
C125	Y#21	VPWR#2	8.06991e-18
C126	a_384_74##17	VPWR#16	1.81654e-18
C127	a_384_74##36	a_384_74##34	3.90049e-17
C128	Y#8	VGND#21	4.4085e-19
C129	Y#16	a_384_74##35	1.56825e-18
C130	VPWR#8	VPWR#7	6.93111e-19
C131	Y#2	a_384_74##60	4.22057e-19
C132	VPWR#1	a_384_74#	3.16367e-17
C133	a_384_74##59	a_384_74##53	1.07587e-18
C134	VGND#13	A#5	6.57467e-19
C135	Y#13	a_384_74##33	3.96575e-19
C136	a_384_74##59	Y#2	6.35248e-18
C137	a_384_74##73	VPWR#15	5.62228e-18
C138	Y#19	Y#25	4.74215e-18
C139	Y#19	a_384_74##11	6.62432e-20
C140	a_27_74##25	A#6	4.16739e-19
C141	VPWR#16	VPWR#15	1.87864e-18
C142	VGND#8	VGND#7	1.13178e-18
C143	a_384_74##22	a_384_74##21	3.61313e-18
C144	VGND#24	a_384_74##62	4.03546e-17
C145	VGND#18	a_384_74##35	4.36691e-17
C146	VPWR#23	A#9	2.26247e-19
C147	Y#22	a_384_74#	4.93938e-17
C148	VGND#11	VGND#13	7.47361e-17
C149	a_384_74##55	Y#2	1.88647e-17
C150	a_384_74##38	a_384_74##36	4.62064e-17
C151	VGND#11	VGND#12	6.49899e-17
C152	Y#25	a_384_74##5	9.31042e-18
C153	VPWR#4	a_384_74##11	4.00017e-19
C154	VGND#17	VPWR#13	8.82578e-20
C155	a_384_74##68	VGND#21	6.34092e-18
C156	a_384_74##60	VPWR#21	2.5317e-19
C157	VGND#11	VGND#10	5.73073e-17
C158	Y#16	a_384_74##37	1.94488e-19
C159	VPWR#4	VPWR#1	5.45469e-17
C160	VPWR#1	a_384_74##26	1.13272e-18
C161	a_384_74##33	a_384_74##31	3.94171e-17
C162	VGND#11	VGND#9	6.34357e-17
C163	Y#11	VPWR#15	1.7861e-17
C164	VPWR#12	a_384_74#	1.70866e-18
C165	a_27_74##3	a_27_74##2	7.77403e-18
C166	VPWR#4	Y#22	1.82347e-17
C167	Y#13	a_384_74##35	1.32499e-17
C168	VGND#11	VGND#8	5.60689e-17
C169	VPWR#16	Y#10	5.53247e-17
C170	VPWR#4	a_384_74##8	4.5102e-20
C171	a_384_74##55	a_384_74##53	1.47964e-18
C172	a_384_74##59	a_27_74#	9.59919e-18
C173	Y#11	Y#10	6.80733e-19
C174	a_384_74##54	a_384_74##59	3.34196e-18
C175	Y#19	VGND#16	6.33891e-17
C176	VGND#11	VGND#7	7.16434e-18
C177	a_384_74##63	a_384_74##62	2.43346e-18
C178	VGND#13	A#7	2.93259e-19
C179	a_384_74##4	VPWR#2	4.1337e-19
C180	a_384_74##26	Y#22	1.81326e-17
C181	VPWR#10	a_384_74##22	4.57114e-20
C182	a_27_74##25	A#2	1.23962e-18
C183	Y#11	VPWR#16	3.17444e-17
C184	VGND#18	a_384_74##37	2.32609e-18
C185	VPWR#4	Y#21	1.75988e-17
C186	a_384_74##40	a_384_74##38	4.872e-17
C187	VPWR#4	a_384_74##5	2.15472e-23
C188	VPWR#2	a_384_74##2	5.40171e-20
C189	a_384_74##17	Y#9	9.40911e-20
C190	a_384_74##54	a_384_74##55	4.08283e-17
C191	VGND#19	a_384_74##35	7.30871e-19
C192	VGND#4	VPWR#1	4.93889e-18
C193	VPWR#1	a_384_74##28	2.41154e-19
C194	a_27_74##22	a_27_74##3	5.51198e-18
C195	VGND#4	a_384_74##17	1.29818e-19
C196	a_384_74##26	VPWR#12	2.53621e-17
C197	Y#18	VPWR#4	3.46004e-17
C198	a_384_74##60	a_27_74##10	3.24712e-19
C199	Y#13	a_384_74##37	3.73637e-17
C200	a_27_74##23	A#6	7.01991e-19
C201	VGND#4	VPWR#12	9.23328e-19
C202	a_384_74##60	VPWR#11	2.7957e-18
C203	a_384_74##54	a_27_74##22	3.95405e-18
C204	a_384_74##35	a_384_74##33	2.9012e-17
C205	a_384_74##70	VPWR#16	5.60574e-18
C206	Y#22	a_384_74##28	1.19479e-18
C207	a_384_74##63	VGND#24	3.83514e-17
C208	VGND#17	VGND#16	1.89091e-18
C209	a_384_74##55	a_27_74#	7.72195e-18
C210	a_384_74##56	a_384_74##23	5.17804e-19
C211	a_384_74##59	a_27_74##10	1.66582e-17
C212	Y#21	a_384_74##26	1.34913e-18
C213	a_384_74##59	VPWR#11	1.58178e-18
C214	a_384_74##42	a_384_74##40	4.61937e-17
C215	VPWR#4	Y#15	1.7606e-17
C216	Y#19	a_384_74##8	1.7403e-19
C217	Y#15	VPWR#6	8.52757e-18
C218	VPWR#2	a_384_74#	2.33004e-18
C219	VGND#18	a_384_74##39	3.18276e-19
C220	VPWR#7	VPWR#6	6.93111e-19
C221	a_384_74##7	VPWR#3	3.94766e-19
C222	VGND#4	VPWR#13	3.80483e-19
C223	VGND#16	a_384_74##5	1.03046e-17
C224	VGND#4	a_384_74##11	1.22074e-19
C225	a_384_74##28	VPWR#12	3.09862e-17
C226	Y#9	VPWR#16	5.63676e-17
C227	a_384_74##37	VGND#19	1.68567e-17
C228	Y#25	a_384_74##2	8.91412e-18
C229	VPWR#13	a_384_74##26	1.71672e-19
C230	VPWR#4	Y#10	1.7606e-17
C231	VPWR#11	a_384_74##55	2.03913e-18
C232	VGND#7	VGND#6	1.13178e-18
C233	VPWR#11	a_27_74##25	4.03789e-18
C234	VGND#4	a_384_74##8	4.95174e-20
C235	a_384_74##66	VGND#22	2.8529e-18
C236	a_384_74##60	a_27_74##11	1.59835e-17
C237	Y#13	a_384_74##39	1.56825e-18
C238	Y#21	a_384_74##28	5.07731e-17
C239	a_384_74##44	a_384_74##42	4.87177e-17
C240	VGND#25	VGND#24	1.01212e-18
C241	a_27_74##23	A#2	1.85441e-18
C242	VPWR#4	Y#9	6.63242e-18
C243	Y#15	VPWR#5	8.44089e-18
C244	VPWR#11	a_27_74##22	9.8469e-18
C245	VPWR#3	a_384_74##26	8.886e-20
C246	VGND#17	Y#19	7.20319e-17
C247	VGND#11	a_384_74##60	4.63452e-18
C248	a_384_74##17	a_384_74##14	4.9905e-18
C249	Y#12	a_384_74##37	3.94856e-19
C250	a_384_74##59	VPWR#19	1.44072e-17
C251	a_384_74##55	a_27_74##10	1.06692e-18
C252	a_384_74##56	a_27_74##8	5.1654e-18
C253	a_384_74##59	a_27_74##11	3.24712e-19
C254	VGND#4	a_384_74##5	2.46652e-19
C255	a_384_74##37	a_384_74##35	3.94171e-17
C256	VGND#11	a_384_74##59	9.67999e-19
C257	VPWR#17	VPWR#16	1.87864e-18
C258	VPWR#12	a_384_74##30	3.58904e-19
C259	a_384_74##5	a_384_74##2	3.20022e-18
C260	VPWR#13	a_384_74##28	3.84499e-19
C261	VGND#11	a_384_74##57	3.51641e-18
C262	a_384_74##56	a_384_74##22	6.21364e-20
C263	a_384_74##10	VPWR#5	2.96928e-19
C264	VGND#19	a_384_74##39	4.36691e-17
C265	Y#8	a_384_74##17	6.818e-18
C266	VPWR#2	a_384_74##26	5.16913e-18
C267	VGND#11	a_384_74##56	1.75935e-18
C268	VGND#4	a_384_74##2	1.43567e-19
C269	VGND#11	a_384_74##55	3.53721e-18
C270	a_27_74##22	A#6	2.23153e-19
C271	Y#13	a_384_74##17	6.62432e-20
C272	a_384_74##46	a_384_74##44	4.62024e-17
C273	Y#21	a_384_74##30	4.54621e-17
C274	VGND#25	a_384_74##63	3.60545e-17
C275	Y#13	a_384_74##41	1.94488e-19
C276	VGND#3	a_384_74##7	2.65272e-20
C277	Y#16	a_384_74##11	8.37474e-18
C278	VGND#11	a_27_74##23	3.32931e-18
C279	a_384_74##60	a_27_74##14	1.58234e-17
C280	Y#10	VPWR#7	8.52757e-18
C281	VGND#2	a_384_74##7	2.29902e-20
C282	VPWR#17	Y#9	5.64273e-17
C283	VGND#7	a_384_74##17	1.47973e-19
C284	Y#16	Y#19	4.60578e-18
C285	Y#12	a_384_74##39	1.31731e-17
C286	Y#1	a_27_74##3	4.87082e-20
C287	VGND#11	a_27_74##22	1.31869e-17
C288	VPWR#12	a_384_74##32	1.63882e-19
C289	a_27_74##22	a_27_74##10	1.62176e-19
C290	Y#19	a_384_74##5	5.61927e-18
C291	a_384_74##30	VPWR#13	2.60111e-17
C292	a_384_74##59	a_384_74##64	2.08835e-19
C293	a_384_74##56	a_27_74##9	1.95966e-17
C294	VPWR#3	a_384_74##28	3.16545e-19
C295	Y#8	VPWR#16	2.9508e-17
C296	a_384_74##39	a_384_74##37	2.90115e-17
C297	VGND#19	a_384_74##41	2.32609e-18
C298	Y#8	Y#9	8.71405e-19
C299	a_384_74##48	a_384_74##46	4.87172e-17
C300	Y#21	a_384_74##32	1.1619e-18
C301	a_384_74##60	VPWR#20	9.1003e-18
C302	a_384_74##13	VPWR#6	4.15416e-19
C303	a_27_74##20	a_27_74##15	1.60086e-18
C304	Y#18	a_384_74##30	1.20115e-18
C305	VGND#20	a_384_74##39	7.30871e-19
C306	Y#8	VPWR#17	3.62278e-17
C307	a_27_74##22	A#2	1.09448e-17
C308	VPWR#5	a_384_74##13	3.96166e-21
C309	a_384_74##58	a_384_74##63	2.61235e-18
C310	Y#10	VPWR#6	8.44089e-18
C311	VPWR#2	a_384_74##28	7.49772e-18
C312	a_384_74##57	a_27_74##12	1.75828e-17
C313	VGND#2	VGND#1	9.5684e-19
C314	VPWR#6	VPWR#5	6.97557e-19
C315	a_384_74##56	Y#1	1.99425e-18
C316	VGND#6	VGND#5	1.13178e-18
C317	Y#1	a_27_74##2	1.62919e-18
C318	a_384_74##32	VPWR#13	3.30756e-17
C319	a_384_74##54	VGND#23	6.08097e-18
C320	Y#12	a_384_74##41	3.72809e-17
C321	a_384_74##60	a_27_74##19	3.24712e-19
C322	Y#16	VGND#17	6.33891e-17
C323	VPWR#14	a_384_74##30	1.67684e-19
C324	VPWR#5	a_384_74##30	8.34969e-20
C325	a_384_74##60	a_384_74##59	1.87999e-18
C326	a_384_74##50	a_384_74##48	4.62111e-17
C327	a_384_74##55	VPWR#19	1.64548e-17
C328	a_384_74##56	a_27_74##12	2.17519e-19
C329	a_384_74##59	VPWR#20	8.91318e-18
C330	a_384_74##55	a_384_74##22	1.14319e-17
C331	VGND#19	a_384_74##43	3.18276e-19
C332	Y#18	a_384_74##32	5.04415e-17
C333	a_384_74##68	VPWR#17	4.64742e-18
C334	Y#24	VPWR#2	2.70497e-18
C335	Y#6	VPWR#17	5.63676e-17
C336	VPWR#3	a_384_74##30	6.79183e-18
C337	a_384_74##58	VGND#25	4.05523e-17
C338	a_384_74##41	VGND#20	1.69372e-17
C339	a_384_74##41	a_384_74##39	3.94171e-17
C340	Y#13	a_384_74##14	1.7403e-19
C341	a_384_74##4	Y#25	1.45168e-17
C342	a_384_74##60	a_384_74##65	2.08835e-19
C343	A#6	A#3	3.49128e-18
C344	VGND#18	a_384_74##11	1.04259e-17
C345	a_384_74##16	VPWR#7	4.27926e-19
C346	Y#9	VPWR#8	8.52757e-18
C347	A#3	A#2	4.0818e-18
C348	VPWR#13	a_384_74##34	3.66149e-19
C349	a_384_74##4	VGND#16	3.13629e-17
C350	a_384_74##55	Y#1	1.73882e-17
C351	Y#16	a_384_74##8	5.86687e-18
C352	a_384_74##57	a_27_74##13	2.01981e-17
C353	VPWR#14	a_384_74##32	3.68828e-19
C354	VGND#6	a_384_74##17	2.29902e-20
C355	Y#19	a_384_74##4	2.2411e-17
C356	a_27_74##24	a_27_74##26	1.6024e-19
C357	Y#12	a_384_74##43	1.55327e-18
C358	VGND#6	a_384_74##13	2.65272e-20
C359	a_384_74##56	VGND#23	2.04872e-17
C360	VPWR#2	a_384_74##30	2.93322e-19
C361	a_384_74##52	a_384_74##50	4.86782e-17
C362	VGND#2	Y#25	1.50197e-17
C363	VGND#18	VGND#17	1.89091e-18
C364	VGND#5	a_384_74##13	9.72663e-21
C365	VGND#11	Y#7	1.48513e-17
C366	a_27_74##25	VPWR#23	3.13618e-19
C367	Y#7	a_384_74##41	3.91654e-19
C368	Y#5	VPWR#17	2.95091e-17
C369	Y#18	a_384_74##34	4.53491e-17
C370	VGND#11	VGND#21	1.70683e-17
C371	VPWR#18	VPWR#17	1.87864e-18
C372	a_27_74##22	a_27_74##9	3.91548e-20
C373	a_384_74##56	a_27_74##13	1.12264e-19
C374	VGND#11	Y#4	1.43662e-17
C375	Y#5	Y#6	1.08112e-18
C376	VPWR#5	a_384_74##32	3.0177e-19
C377	VGND#26	VGND#25	1.15684e-18
C378	Y#9	VPWR#7	8.39142e-18
C379	VGND#20	a_384_74##43	4.56899e-17
C380	Y#5	VPWR#18	3.70323e-17
C381	VPWR#13	a_384_74##36	1.68802e-19
C382	a_27_74##25	a_27_74##19	4.56109e-19
C383	a_384_74##34	VPWR#14	2.57038e-17
C384	VGND#11	Y#1	1.53286e-17
C385	Y#25	a_384_74##7	6.99315e-20
C386	a_384_74##78	VPWR#2	1.4603e-19
C387	a_384_74##53	a_384_74##52	4.66865e-17
C388	VGND#23	a_27_74##2	2.56228e-18
C389	VGND#4	a_384_74##24	4.91221e-18
C390	a_384_74##60	VPWR#22	1.87972e-17
C391	a_384_74##43	a_384_74##41	2.90274e-17
C392	VGND#11	VGND#23	1.76568e-17
C393	a_384_74##22	Y#3	1.1473e-19
C394	A#2	a_27_74##20	1.11938e-18
C395	VPWR#3	a_384_74##32	3.95948e-18
C396	Y#24	a_384_74#	1.55882e-17
C397	VPWR#9	a_384_74##19	1.95381e-20
C398	a_384_74##55	VGND#23	3.29658e-17
C399	a_384_74##55	VPWR#10	1.86595e-19
C400	Y#12	a_384_74##45	1.92106e-19
C401	a_384_74##19	VPWR#8	6.24985e-19
C402	Y#19	a_384_74##7	2.48274e-17
C403	VGND#11	a_384_74##62	2.31409e-17
C404	VGND#4	a_384_74##25	4.72078e-18
C405	VPWR#18	Y#6	5.64273e-17
C406	VGND#18	Y#16	7.20319e-17
C407	Y#18	a_384_74##36	1.18334e-18
C408	a_384_74##56	a_384_74##62	1.01243e-18
C409	a_384_74##7	VGND#17	4.28829e-17
C410	Y#15	a_384_74##34	1.20115e-18
C411	Y#24	a_384_74##26	1.2459e-17
C412	Y#7	a_384_74##43	1.30198e-17
C413	VGND#4	a_384_74##27	2.20249e-18
C414	Y#16	a_384_74##7	2.25458e-17
C415	VPWR#6	a_384_74##34	7.86402e-20
C416	VGND#11	a_384_74##63	2.1376e-17
C417	a_384_74##57	VGND#24	1.41383e-17
C418	VPWR#2	a_384_74##32	8.13879e-20
C419	a_384_74##66	VPWR#18	6.44015e-18
C420	a_27_74##22	a_27_74##19	1.18895e-19
C421	a_384_74##78	a_384_74#	2.34056e-18
C422	VGND#5	VGND#3	1.13178e-18
C423	VGND#26	a_384_74##58	4.15829e-17
C424	VGND#3	Y#19	5.65469e-18
C425	VGND#4	a_384_74##29	2.18464e-18
C426	a_27_74##22	a_27_74##12	5.71442e-20
C427	VPWR#5	VPWR#3	7.08743e-19
C428	a_384_74##55	a_27_74##20	2.34021e-19
C429	Y#24	a_384_74##28	1.21317e-18
C430	a_384_74##56	a_27_74##16	6.90194e-20
C431	Y#12	a_384_74##17	8.52548e-18
C432	a_384_74##36	VPWR#14	3.28668e-17
C433	a_27_74#	a_384_74##53	4.83652e-17
C434	VGND#20	a_384_74##45	2.32609e-18
C435	VPWR#15	a_384_74##34	1.54166e-19
C436	A#2	a_27_74##28	2.70455e-19
C437	VGND#11	a_384_74##58	1.26004e-17
C438	VGND#4	a_384_74##31	3.02242e-18
C439	Y#13	a_384_74##11	6.47975e-18
C440	VGND#24	a_27_74##5	8.66025e-19
C441	a_384_74##78	a_384_74##26	1.43292e-18
C442	a_27_74##3	a_384_74##62	3.082e-19
C443	Y#6	VPWR#9	8.52757e-18
C444	VPWR#5	a_384_74##34	3.21375e-18
C445	Y#24	a_384_74##30	1.07419e-19
C446	Y#20	VPWR#3	1.30691e-18
C447	a_27_74##25	a_27_74##20	4.78925e-18
C448	VGND#21	a_384_74##43	7.30871e-19
C449	VGND#4	a_384_74##33	5.26645e-18
C450	VGND#11	a_27_74##27	1.18512e-17
C451	a_384_74##78	a_384_74##28	1.0153e-18
C452	Y#15	a_384_74##36	4.93144e-17
C453	a_384_74##61	a_384_74##60	1.87999e-18
C454	a_384_74##45	a_384_74##43	3.94171e-17
C455	VGND#4	a_384_74##35	2.26597e-18
C456	Y#20	VPWR#2	1.44609e-18
C457	VGND#2	a_384_74##25	5.12874e-18
C458	Y#13	Y#16	4.60578e-18
C459	Y#2	VPWR#18	2.98206e-17
C460	Y#20	a_384_74##26	8.19202e-19
C461	VPWR#3	a_384_74##34	2.97342e-19
C462	Y#7	a_384_74##45	3.70528e-17
C463	VGND#11	a_27_74##24	1.57414e-17
C464	a_384_74##56	VGND#24	1.62977e-17
C465	VGND#13	a_27_74##17	9.84346e-20
C466	a_384_74##21	VPWR#9	5.11962e-19
C467	VGND#8	a_384_74##19	5.54123e-20
C468	VGND#4	a_384_74##37	2.26878e-18
C469	a_27_74##10	a_27_74#	4.666e-17
C470	a_384_74##10	Y#16	1.62441e-17
C471	Y#2	Y#3	8.02958e-19
C472	a_27_74##27	a_384_74##58	1.67195e-18
C473	VPWR#14	a_384_74##38	3.62944e-19
C474	VGND#7	a_384_74##19	3.33063e-20
C475	VGND#6	a_384_74##14	4.36225e-20
C476	VPWR#15	a_384_74##36	4.42492e-19
C477	Y#20	a_384_74##28	1.46086e-17
C478	a_384_74##10	VGND#18	3.10972e-17
C479	a_384_74##57	a_384_74##63	4.59562e-19
C480	a_27_74##22	a_27_74##20	3.49141e-18
C481	VGND#2	Y#19	6.96642e-18
C482	Y#6	VPWR#8	8.44089e-18
C483	VGND#4	a_384_74##39	2.35851e-18
C484	VPWR#19	Y#2	2.80954e-17
C485	a_27_74##22	a_27_74##13	9.92976e-20
C486	Y#13	a_384_74##10	2.2411e-17
C487	VGND#20	a_384_74##47	3.18276e-19
C488	Y#3	VPWR#18	5.63676e-17
C489	a_384_74##56	a_384_74##59	3.51624e-18
C490	VPWR#6	a_384_74##36	2.85183e-19
C491	a_27_74##2	a_384_74##62	5.4791e-20
C492	a_384_74##56	a_27_74##18	4.85784e-20
C493	Y#2	a_384_74##64	1.13557e-18
C494	VGND#4	a_384_74##41	1.84614e-18
C495	Y#20	a_384_74##30	9.95539e-18
C496	A#6	VPWR#26	2.86194e-19
C497	a_384_74##45	VGND#21	1.70982e-17
C498	Y#15	a_384_74##38	4.35379e-17
C499	Y#2	VPWR#20	5.30561e-19
C500	a_27_74##22	VPWR#23	2.55351e-19
C501	VGND#4	a_384_74##43	1.50559e-18
C502	a_27_74##25	A#4	2.03913e-17
C503	Y#20	a_384_74##32	5.57999e-19
C504	a_27_74##11	a_27_74##10	4.78959e-17
C505	Y#2	a_384_74##65	7.00772e-19
C506	VPWR#8	a_384_74##17	6.60847e-21
C507	VPWR#5	a_384_74##36	7.6574e-18
C508	a_27_74##23	a_27_74##16	6.89014e-20
C509	a_384_74##77	VPWR#3	2.76624e-19
C510	Y#13	VGND#18	6.33891e-17
C511	Y#7	a_384_74##47	1.52198e-18
C512	VPWR#14	a_384_74##40	1.66711e-19
C513	VPWR#11	Y#9	1.08649e-17
C514	a_384_74##38	VPWR#15	2.30125e-17
C515	a_27_74##27	VGND#26	4.16102e-17
C516	a_384_74##54	VPWR#19	1.55433e-17
C517	a_384_74##47	a_384_74##45	2.90565e-17
C518	Y#20	a_384_74##34	9.6139e-20
C519	VGND#2	a_384_74##27	3.30567e-18
C520	Y#16	a_384_74##13	6.62432e-20
C521	VPWR#19	VPWR#18	1.87864e-18
C522	Y#4	a_384_74##45	3.8523e-19
C523	VGND#9	a_384_74##21	5.54123e-20
C524	VGND#20	a_384_74##17	6.63409e-18
C525	VPWR#3	a_384_74##36	8.29084e-20
C526	a_384_74##4	VPWR#12	2.47062e-17
C527	VPWR#7	a_384_74##38	8.1728e-20
C528	VGND#8	a_384_74##21	4.0675e-20
C529	VPWR#11	Y#6	1.75339e-17
C530	VGND#24	a_27_74##3	2.44538e-19
C531	Y#12	a_384_74##14	5.55183e-18
C532	VGND#25	a_27_74##15	7.63565e-19
C533	a_27_74##22	A#4	2.53186e-18
C534	a_384_74##57	VGND#25	1.87178e-17
C535	Y#13	a_384_74##13	2.43192e-17
C536	Y#15	a_384_74##40	1.36969e-18
C537	Y#17	a_384_74##30	5.97578e-19
C538	Y#3	VPWR#10	8.52757e-18
C539	a_27_74##22	a_27_74##16	5.37847e-19
C540	Y#10	a_384_74##38	1.36162e-18
C541	a_27_74##14	a_27_74##11	4.61734e-17
C542	a_384_74##13	VGND#19	3.98127e-17
C543	a_27_74##22	VPWR#20	1.24879e-18
C544	VGND#21	a_384_74##47	4.3871e-17
C545	Y#12	a_384_74##13	2.20226e-17
C546	VPWR#11	Y#3	1.77451e-17
C547	VGND#3	VGND#2	1.13178e-18
C548	Y#17	a_384_74##32	1.21962e-17
C549	VGND#3	a_384_74##29	5.07635e-18
C550	a_384_74##78	VGND#3	3.32825e-20
C551	VPWR#6	a_384_74##38	5.74943e-18
C552	a_27_74##25	A#8	1.75424e-17
C553	a_384_74##40	VPWR#15	2.96156e-17
C554	VPWR#16	a_384_74##38	1.53981e-19
C555	VPWR#3	VPWR#2	7.19971e-19
C556	VPWR#19	Y#3	5.64273e-17
C557	VGND#12	a_27_74##17	2.4464e-20
C558	VGND#27	VGND#26	1.49731e-18
C559	VGND#11	VPWR#17	2.90767e-20
C560	a_384_74##64	VPWR#11	2.8181e-17
C561	Y#17	a_384_74##34	1.02796e-17
C562	VGND#19	VGND#18	1.89091e-18
C563	Y#7	a_384_74##49	1.87398e-19
C564	Y#17	VPWR#5	4.23303e-19
C565	a_384_74##78	VGND#2	1.02599e-18
C566	a_27_74##23	a_27_74##18	2.89389e-19
C567	VGND#6	Y#13	6.79046e-18
C568	a_384_74##47	Y#4	1.66502e-17
C569	a_27_74##19	a_27_74##14	4.78959e-17
C570	VPWR#5	a_384_74##38	2.95577e-19
C571	Y#3	VPWR#9	8.44089e-18
C572	Y#17	a_384_74##36	5.70028e-19
C573	a_384_74##49	a_384_74##47	4.03706e-17
C574	Y#17	VPWR#3	5.02005e-19
C575	VGND#11	VPWR#18	1.0862e-18
C576	a_384_74##65	VPWR#11	2.83871e-17
C577	Y#10	a_384_74##40	5.02837e-17
C578	a_384_74##7	Y#21	9.94324e-20
C579	a_384_74##58	a_27_74##17	4.00134e-18
C580	a_384_74##7	VPWR#13	2.86995e-17
C581	a_27_74##22	A#8	5.50473e-19
C582	Y#17	a_384_74##38	9.35704e-20
C583	a_27_74##22	a_27_74##18	3.8842e-18
C584	VGND#21	a_384_74##49	2.32555e-18
C585	VGND#11	VPWR#19	7.86833e-19
C586	Y#2	a_384_74##22	6.52768e-18
C587	VPWR#11	a_384_74##61	1.8869e-17
C588	a_27_74##22	a_384_74##65	2.51339e-18
C589	a_384_74##16	Y#12	2.24668e-17
C590	VPWR#15	a_384_74##42	3.44144e-19
C591	VPWR#7	a_384_74##40	2.85183e-19
C592	VPWR#16	a_384_74##40	3.44144e-19
C593	a_384_74##16	VGND#20	3.092e-17
C594	VGND#22	a_384_74##47	1.52211e-18
C595	VPWR#7	a_384_74##17	8.92889e-20
C596	VGND#27	a_27_74##27	3.22926e-17
C597	Y#7	a_384_74##16	1.57911e-17
C598	Y#14	a_384_74##34	6.05431e-19
C599	a_27_74##20	a_27_74##19	4.28391e-17
C600	VPWR#11	a_27_74##28	1.72175e-17
C601	VGND#3	a_384_74##31	2.52787e-18
C602	a_27_74##25	A#9	1.94029e-19
C603	VGND#19	Y#13	7.20319e-17
C604	Y#10	a_384_74##42	4.5295e-17
C605	VPWR#6	a_384_74##40	7.39236e-18
C606	Y#14	a_384_74##36	8.75469e-18
C607	a_27_74##23	A#1	1.59099e-17
C608	VGND#5	Y#13	6.96642e-18
C609	a_384_74##49	Y#4	2.22124e-17
C610	VPWR#11	a_27_74##26	1.92756e-17
C611	VGND#12	a_27_74##15	4.50962e-20
C612	a_384_74##58	a_27_74##15	6.87289e-19
C613	Y#7	a_384_74##17	5.08523e-18
C614	VGND#11	a_384_74##61	3.03356e-18
C615	a_384_74##74	VPWR#5	3.08387e-19
C616	Y#1	a_384_74##47	1.89499e-19
C617	Y#14	a_384_74##38	8.4949e-18
C618	a_27_74##25	a_384_74##61	2.76926e-17
C619	a_384_74##51	a_384_74##49	4.00403e-17
C620	a_384_74##64	VPWR#19	6.38643e-17
C621	VPWR#15	a_384_74##44	1.53981e-19
C622	a_384_74##42	VPWR#16	2.3798e-17
C623	VGND#5	a_384_74##33	1.83366e-18
C624	VGND#13	A#3	6.34752e-21
C625	A#4	a_27_74##20	4.75489e-17
C626	VPWR#5	a_384_74##40	8.56305e-20
C627	VGND#21	a_384_74##51	3.18252e-19
C628	a_27_74##22	A#9	4.02886e-19
C629	a_384_74##10	VPWR#14	2.62655e-17
C630	VPWR#4	a_384_74#	5.42937e-18
C631	VGND#7	Y#12	6.57927e-18
C632	VPWR#8	a_384_74##42	8.1728e-20
C633	Y#14	a_384_74##40	6.45355e-19
C634	Y#12	a_384_74##19	6.54324e-20
C635	a_27_74##22	VPWR#22	2.37113e-18
C636	a_384_74##49	VGND#22	1.36909e-17
C637	a_27_74##24	a_27_74##27	1.57583e-18
C638	VPWR#4	a_384_74##26	1.70316e-18
C639	a_27_74##22	VGND#24	2.98762e-18
C640	Y#7	a_384_74##19	2.45786e-17
C641	Y#14	a_384_74##42	9.74657e-20
C642	a_27_74##22	a_384_74##60	8.76072e-17
C643	Y#10	a_384_74##44	1.36162e-18
C644	Y#9	a_384_74##42	1.38663e-18
C645	a_384_74##19	VGND#21	3.75511e-17
C646	Y#11	a_384_74##36	8.93095e-20
C647	Y#12	Y#13	4.59692e-18
C648	VPWR#4	a_384_74##28	1.2902e-18
C649	VPWR#7	a_384_74##42	1.00598e-17
C650	Y#4	a_384_74##19	2.62479e-17
C651	Y#4	a_384_74##51	1.74735e-18
C652	A#8	A#4	4.58541e-17
C653	a_384_74##77	VGND#3	1.52165e-18
C654	a_384_74##64	VPWR#10	8.46816e-18
C655	VPWR#20	VPWR#19	1.87864e-18
C656	a_27_74##23	A#5	2.32324e-17
C657	VPWR#4	a_384_74##30	2.22588e-18
C658	Y#11	a_384_74##38	6.91286e-19
C659	Y#1	a_384_74##19	6.45435e-20
C660	Y#4	a_384_74##22	6.54588e-20
C661	Y#1	a_384_74##49	4.15947e-19
C662	a_384_74##44	VPWR#16	2.96156e-17
C663	VPWR#17	a_384_74##42	1.53981e-19
C664	Y#14	VPWR#6	1.09024e-18
C665	VPWR#6	a_384_74##42	2.85183e-19
C666	VPWR#4	a_384_74##32	5.03919e-18
C667	Y#11	a_384_74##40	1.25067e-17
C668	a_27_74##17	a_27_74##15	4.19224e-18
C669	A	a_27_74##17	2.97227e-18
C670	a_27_74##25	VPWR#24	2.34228e-17
C671	a_384_74##13	Y#15	1.26215e-19
C672	a_384_74##54	a_384_74##22	2.02365e-18
C673	a_384_74##23	a_384_74##51	3.94085e-17
C674	VGND#6	Y#12	6.96642e-18
C675	Y#24	a_384_74##5	9.29021e-18
C676	VGND#5	a_384_74##11	6.7674e-20
C677	a_27_74##24	VGND#27	5.17008e-17
C678	a_384_74##13	VPWR#15	2.3721e-17
C679	Y#14	VPWR#5	1.5001e-18
C680	VPWR#4	a_384_74##34	5.59597e-18
C681	Y#11	a_384_74##42	9.97664e-18
C682	VGND#22	a_384_74##51	3.62245e-17
C683	Y#9	a_384_74##44	5.07731e-17
C684	VGND#5	a_384_74##35	6.08799e-18
C685	A#9	A#8	4.73903e-17
C686	a_27_74##22	a_384_74##61	5.95195e-17
C687	Y#7	a_384_74##21	6.38304e-20
C688	A	A#6	2.10326e-17
C689	VPWR#4	a_384_74##36	1.60398e-18
C690	a_27_74##22	a_384_74##63	2.51339e-18
C691	A	A#2	1.24946e-17
C692	Y#11	a_384_74##44	6.53957e-19
C693	VPWR#8	a_384_74##44	2.85183e-19
C694	VPWR#20	a_384_74##64	6.12645e-17
C695	a_27_74##22	a_384_74##59	2.08766e-18
C696	Y#12	VGND#19	6.33221e-17
C697	Y#4	a_384_74##21	2.68425e-17
C698	Y#4	a_384_74##23	1.92192e-19
C699	VPWR#4	a_384_74##38	2.37987e-18
C700	VGND#8	Y#7	5.02111e-18
C701	VPWR#16	a_384_74##46	3.44144e-19
C702	a_384_74##21	VGND#22	2.60544e-17
C703	VPWR#17	a_384_74##44	3.44144e-19
C704	Y#11	a_384_74##46	1.00376e-19
C705	Y#24	a_384_74##2	8.59975e-18
C706	Y#1	a_384_74##21	2.71704e-17
C707	Y#1	a_384_74##51	1.32123e-17
C708	VPWR#4	a_384_74##40	1.43856e-18
C709	a_27_74##23	A#7	1.70136e-19
C710	VPWR#7	a_384_74##44	5.25788e-18
C711	VGND#6	a_384_74##37	4.29057e-18
C712	VGND#9	VGND#21	5.91997e-20
C713	a_27_74##25	A#3	2.63947e-18
C714	Y#9	a_384_74##46	4.56562e-17
C715	VPWR#4	a_384_74##42	1.77312e-18
C716	a_27_74##23	A#3	3.89276e-18
C717	a_27_74##25	a_27_74##28	1.36226e-18
C718	VGND#22	a_384_74##23	1.80132e-18
C719	a_27_74##22	A#3	2.49972e-19
C720	a_384_74##16	VPWR#16	2.19045e-17
C721	a_384_74##65	a_384_74##64	1.11023e-18
C722	a_27_74##8	a_384_74##23	2.81084e-17
C723	VGND#11	a_384_74##45	2.6788e-18
C724	a_384_74##73	VPWR#6	3.49607e-19
C725	VPWR#4	a_384_74##44	1.76582e-18
C726	VPWR#6	a_384_74##44	8.1728e-20
C727	VGND#23	a_384_74##51	7.26534e-19
C728	VGND#11	a_384_74##47	2.11375e-18
C729	VPWR#9	a_384_74##46	8.1728e-20
C730	a_27_74##22	VPWR#24	2.11405e-18
C731	VPWR#16	a_384_74##48	1.53981e-19
C732	a_384_74##46	VPWR#17	2.29014e-17
C733	a_27_74##22	VGND#25	2.53134e-18
C734	VGND#11	a_384_74##49	3.09331e-18
C735	VGND#20	VGND#19	1.89091e-18
C736	Y#2	a_27_74##2	2.32175e-19
C737	a_384_74##57	a_27_74##22	8.08549e-17
C738	VGND#7	Y#7	6.96642e-18
C739	a_384_74##74	VGND#6	2.60471e-20
C740	VGND#11	a_384_74##51	2.16107e-18
C741	a_384_74##65	VPWR#21	6.14458e-18
C742	a_27_74##23	a_384_74##58	8.953e-19
C743	Y#1	a_384_74##23	3.7218e-17
C744	VPWR#8	a_384_74##46	6.87632e-18
C745	VGND#11	a_384_74##23	2.18673e-18
C746	Y#9	a_384_74##48	1.38663e-18
C747	Y#6	a_384_74##46	1.38663e-18
C748	a_384_74##60	a_27_74##15	5.03722e-18
C749	Y#8	a_384_74##42	6.49805e-19
C750	a_384_74##74	VGND#5	1.48706e-18
C751	a_384_74##65	VPWR#20	6.11996e-17
C752	VGND#11	a_27_74##8	1.4393e-18
C753	a_384_74##78	a_384_74##5	2.27779e-18
C754	Y#8	a_384_74##44	1.26098e-17
C755	a_384_74##19	Y#9	9.56081e-20
C756	a_384_74##78	Y#24	2.87805e-17
C757	VGND#6	a_384_74##39	3.46772e-18
C758	VGND#11	a_27_74##9	5.42483e-18
C759	VGND#22	a_27_74##8	1.9409e-19
C760	VGND#9	Y#4	5.52595e-18
C761	a_384_74##19	VPWR#17	2.30524e-17
C762	VPWR#7	a_384_74##46	2.85183e-19
C763	a_27_74##25	VPWR#26	1.74539e-17
C764	a_384_74##48	VPWR#17	2.96156e-17
C765	VPWR#18	a_384_74##46	1.53981e-19
C766	VGND#11	a_27_74##12	5.45033e-18
C767	Y#8	a_384_74##46	9.99364e-18
C768	VGND#21	VPWR#17	2.31643e-19
C769	a_384_74##19	Y#6	8.26181e-20
C770	VGND#23	a_384_74##23	1.7085e-17
C771	a_27_74##9	a_27_74##8	3.938e-17
C772	Y#11	VPWR#7	1.88226e-18
C773	Y#20	Y#24	1.81753e-18
C774	VGND#11	a_27_74##13	8.92893e-19
C775	Y#8	a_384_74##48	1.11999e-18
C776	VGND#20	Y#12	6.49192e-17
C777	VPWR#11	a_384_74##17	2.15472e-23
C778	a_384_74##54	a_27_74##15	2.14977e-19
C779	VGND#11	a_27_74##16	8.38778e-19
C780	Y#11	VPWR#6	1.48071e-18
C781	a_27_74##22	a_384_74##58	5.3857e-17
C782	Y#6	a_384_74##48	5.07731e-17
C783	a_384_74##78	Y#20	8.79182e-17
C784	VPWR#22	VPWR#20	1.87864e-18
C785	a_384_74##56	a_27_74##22	1.10997e-17
C786	Y#8	a_384_74##50	1.02179e-19
C787	Y#1	a_27_74##8	1.47224e-18
C788	VGND#11	a_27_74##18	2.90215e-19
C789	Y#24	VGND#16	2.50533e-18
C790	VGND#7	a_384_74##41	8.41191e-18
C791	VPWR#9	a_384_74##48	2.85183e-19
C792	a_27_74##23	VGND#26	3.60143e-18
C793	Y#20	a_384_74##11	8.46615e-20
C794	VGND#11	A#1	6.7009e-19
C795	a_384_74##54	a_27_74##5	2.98577e-19
C796	a_384_74##68	a_384_74##48	9.13221e-19
C797	VPWR#6	a_384_74##14	4.5102e-20
C798	VPWR#17	a_384_74##50	3.44144e-19
C799	VGND#11	A#5	1.52482e-18
C800	VPWR#18	a_384_74##48	3.44144e-19
C801	a_384_74##21	Y#6	6.11892e-20
C802	Y#5	a_384_74##46	6.3673e-19
C803	VGND#8	Y#4	7.21478e-18
C804	VPWR#8	a_384_74##48	7.26742e-18
C805	VGND#11	A#7	1.6266e-18
C806	a_384_74##21	VPWR#18	2.37637e-17
C807	a_384_74##54	a_27_74##3	1.91526e-18
C808	a_384_74##77	Y#20	6.90805e-17
C809	VGND#23	a_27_74##8	4.13929e-17
C810	a_384_74##21	Y#3	9.02541e-20
C811	Y#5	a_384_74##48	1.45442e-17
C812	a_27_74##26	a_27_74##25	6.21728e-19
C813	VGND#27	A#3	8.39499e-19
C814	Y#6	a_384_74##50	4.56587e-17
C815	VPWR#22	a_384_74##65	6.12645e-17
C816	a_27_74##12	a_27_74##9	2.38372e-17
C817	Y#5	a_384_74##50	9.92792e-18
C818	Y#17	Y#20	7.97528e-19
C819	Y#7	Y#12	4.5326e-18
C820	VPWR#7	a_384_74##48	8.1728e-20
C821	VPWR#23	a_27_74##17	5.18063e-20
C822	Y#5	a_384_74##52	1.14879e-18
C823	Y#22	VPWR#1	5.6597e-17
C824	Y#1	a_27_74##9	1.46125e-19
C825	a_384_74##70	VPWR#7	3.86408e-19
C826	a_27_74##22	VGND#26	2.47832e-17
C827	a_384_74##61	VPWR#23	8.72375e-18
C828	VPWR#10	a_384_74##50	8.1728e-20
C829	VGND#10	Y#1	5.65469e-18
C830	a_27_74##23	a_27_74##25	1.37791e-18
C831	a_384_74##77	Y#17	8.71017e-17
C832	a_27_74##22	a_384_74##55	1.88808e-17
C833	a_384_74##78	VGND#16	5.2418e-18
C834	a_384_74##50	VPWR#18	2.28704e-17
C835	Y#1	a_384_74##22	7.88178e-18
C836	VPWR#17	a_384_74##52	1.53981e-19
C837	a_27_74##8	a_384_74##62	8.38915e-18
C838	Y#5	a_384_74##53	1.5156e-19
C839	a_384_74##73	VGND#7	4.34119e-21
C840	a_27_74##23	a_27_74##27	1.44528e-18
C841	Y#20	a_384_74##5	5.01407e-18
C842	VGND#7	a_384_74##43	1.5232e-18
C843	VGND#12	a_384_74##57	3.16169e-19
C844	a_384_74##66	a_384_74##52	8.6863e-19
C845	VGND#11	a_384_74##22	4.74935e-23
C846	a_384_74##4	a_384_74##26	1.6031e-18
C847	VPWR#9	a_384_74##50	6.5528e-18
C848	a_384_74##73	VGND#6	1.90002e-18
C849	a_384_74##61	a_384_74##65	1.11023e-18
C850	a_384_74##60	a_27_74##5	8.00999e-18
C851	Y#6	a_384_74##52	1.38663e-18
C852	Y#3	a_384_74##50	1.38663e-18
C853	VGND#23	a_27_74##9	2.36312e-18
C854	a_384_74##4	a_384_74##28	4.56813e-18
C855	Y#2	a_384_74##50	6.52254e-19
C856	a_384_74##74	Y#17	7.17247e-17
C857	VGND#24	a_27_74##8	3.36063e-19
C858	Y#2	a_384_74##52	1.41805e-17
C859	a_384_74##61	VPWR#21	9.20617e-18
C860	VPWR#8	a_384_74##50	2.85183e-19
C861	Y#7	VGND#20	6.82393e-17
C862	VPWR#12	VPWR#1	1.95513e-18
C863	a_27_74##13	a_27_74##12	3.91909e-17
C864	Y#14	Y#17	7.89671e-19
C865	a_384_74##52	VPWR#18	2.96156e-17
C866	VPWR#19	a_384_74##50	1.53981e-19
C867	Y#2	a_384_74##53	1.00951e-17
C868	VGND#8	a_384_74##45	5.13483e-18
C869	VGND#9	Y#1	6.96642e-18
C870	a_384_74##7	a_384_74##28	1.39655e-18
C871	VPWR#11	a_384_74##46	2.2258e-18
C872	Y#24	VPWR#4	1.45282e-17
C873	VPWR#11	a_27_74##5	6.982e-20
C874	Y#2	a_27_74#	1.13443e-18
C875	a_384_74##62	a_27_74##9	3.11688e-17
C876	a_384_74##74	Y#14	8.11672e-17
C877	a_384_74##61	VPWR#22	6.23134e-17
C878	a_27_74##22	a_27_74##25	6.7825e-19
C879	VPWR#11	a_384_74##48	9.96939e-19
C880	Y#2	a_27_74##10	4.15475e-21
C881	Y#3	a_384_74##52	5.07731e-17
C882	a_384_74##54	a_384_74##53	1.7105e-18
C883	a_27_74##23	VGND#27	2.09281e-17
C884	VPWR#11	a_384_74##50	2.27338e-18
C885	VPWR#4	VPWR#7	5.41654e-17
C886	VPWR#11	a_27_74##3	3.68078e-20
C887	VPWR#10	a_384_74##52	2.85183e-19
C888	Y#2	a_27_74##11	4.3694e-19
C889	a_384_74##54	a_27_74#	3.08325e-18
C890	VGND#23	a_27_74##12	3.1607e-19
C891	Y#20	VPWR#4	1.66346e-17
C892	VPWR#11	a_384_74##52	1.25295e-18
C893	VGND#4	a_384_74##78	8.97988e-18
C894	VPWR#4	VPWR#6	5.74931e-17
C895	a_384_74##54	a_27_74##10	2.76239e-19
C896	a_384_74##73	Y#14	4.38355e-17
C897	a_384_74##77	a_384_74##8	3.23719e-18
C898	VGND#9	a_384_74##47	3.07897e-19
C899	a_27_74##9	VGND#24	1.70759e-17
C900	VPWR#19	a_384_74##52	3.44144e-19
C901	VPWR#18	a_384_74##53	3.44144e-19
C902	VPWR#11	a_384_74##53	2.05831e-18
C903	a_384_74##77	VPWR#4	1.04572e-19
C904	Y#20	VGND#17	4.65342e-19
C905	VPWR#12	Y#22	5.5015e-17
C906	A	a_27_74##25	6.96163e-17
C907	VGND#4	Y#20	9.30071e-19
C908	A#3	a_27_74##28	2.74109e-19
C909	VPWR#4	VPWR#5	5.06056e-17
C910	VPWR#9	a_384_74##52	7.36636e-18
C911	a_27_74##23	A	6.73989e-17
C912	VPWR#11	a_27_74#	1.09487e-18
C913	VPWR#21	a_27_74##17	3.96166e-21
C914	VGND#21	VGND#20	1.89091e-18
C915	A#3	VPWR#26	9.49831e-19
C916	Y#11	Y#14	7.51726e-19
C917	A	a_27_74##22	4.53498e-17
C918	VPWR#24	VPWR#22	1.82348e-18
C919	Y#17	VPWR#4	1.82653e-17
C920	a_27_74##15	a_27_74##5	6.13118e-18
C921	a_27_74##16	a_27_74##13	3.6224e-17
C922	a_384_74##57	a_27_74##15	3.94924e-18
C923	VPWR#11	a_27_74##10	6.03502e-18
C924	VGND#4	a_384_74##77	1.30674e-17
C925	VPWR#4	VPWR#3	5.16463e-17
C926	Y#3	a_384_74##53	4.56801e-17
C927	a_384_74##62	a_27_74##12	1.18611e-18
C928	VGND#10	a_27_74##3	4.82766e-20
C929	a_384_74##73	Y#11	6.6413e-17
C930	A#1	a_27_74##17	1.01864e-18
C931	VPWR#11	a_27_74##11	5.96854e-18
C932	a_384_74##74	VPWR#4	9.01193e-20
C933	VPWR#8	a_384_74##52	8.1728e-20
C934	VGND#4	Y#17	7.63987e-19
C935	a_384_74##11	a_384_74##8	4.98862e-18
C936	a_384_74##63	a_27_74##9	4.06489e-19
C937	VGND#13	A#2	4.2656e-20
C938	VPWR#4	VPWR#2	7.22807e-17
C939	VGND#8	a_384_74##47	3.46772e-18
C940	VGND#23	VGND#9	6.26714e-20
C941	VPWR#11	a_27_74##14	1.22965e-18
C942	Y#14	VPWR#4	1.23509e-17
C943	VGND#4	a_384_74##74	1.30598e-17
C944	a_384_74##53	VPWR#19	2.29282e-17
C945	a_27_74##24	a_27_74##23	4.77832e-19
C946	VPWR#18	a_27_74#	1.53981e-19
C947	VPWR#11	a_27_74##19	4.70403e-19
C948	VGND#11	a_27_74##17	3.35068e-19
C949	a_384_74##70	Y#11	6.85446e-17
C950	VGND#24	a_27_74##12	3.18612e-17
C951	VGND#10	a_384_74##62	6.96642e-18
C952	VPWR#11	a_27_74##20	4.02037e-18
C953	VPWR#24	a_384_74##61	4.8045e-17
C954	VGND#11	a_27_74##15	1.34e-19
C955	a_384_74##70	VGND#7	2.13201e-18
C956	a_384_74##56	a_27_74##17	1.74882e-20
C957	a_384_74##77	VGND#17	6.3751e-18
C958	VPWR#11	A#4	7.49657e-19
C959	VPWR#10	a_384_74##53	6.59465e-18
C960	a_384_74##64	a_384_74##53	1.5569e-18
C961	a_27_74##28	VPWR#23	8.43957e-18
C962	a_384_74##60	a_27_74##3	1.00122e-19
C963	Y#11	VPWR#4	1.39423e-17
C964	Y#3	a_27_74#	1.38663e-18
C965	VGND#4	a_384_74##73	1.24223e-17
C966	VGND#21	Y#7	6.16409e-17
C967	Y	VPWR#6	4.89526e-20
C968	a_384_74##5	Y#22	1.45324e-19
C969	VGND#9	a_384_74##49	7.15374e-18
C970	VPWR#11	A#8	7.58606e-19
C971	VGND#11	a_27_74##5	1.27204e-19
C972	VGND#12	VGND#24	1.0526e-18
C973	VPWR#23	VPWR#21	6.66735e-19
C974	a_384_74##62	a_27_74##13	1.92637e-19
C975	a_27_74##18	a_27_74##16	4.05933e-17
C976	VGND#4	Y#11	8.47029e-19
C977	Y#17	a_384_74##11	8.63265e-18
C978	VPWR#11	A#9	1.15213e-18
C979	a_27_74##12	a_384_74##63	1.21249e-17
C980	VPWR#9	a_384_74##53	2.85183e-19
C981	VPWR#20	a_384_74##53	1.53981e-19
C982	a_27_74#	VPWR#19	2.96706e-17
C983	VPWR#21	a_27_74##15	4.39607e-20
C984	VGND#11	a_27_74##3	5.99678e-19
C985	VGND#4	a_384_74##70	1.10109e-17
C986	Y#8	Y#11	7.69206e-19
C987	VGND#10	a_27_74##2	1.34428e-20
C988	a_27_74##28	a_384_74##61	2.27313e-18
C989	a_27_74##24	A	4.5893e-17
C990	VGND#11	a_27_74##2	1.13984e-21
C991	Y#21	VPWR#12	5.69237e-17
C992	a_384_74##70	Y#8	8.80557e-17
C993	VGND#24	a_27_74##13	1.28093e-18
C994	a_384_74##64	a_27_74#	5.58305e-17
C995	a_384_74##22	VNB	2.04622e-17
C996	Y#17	a_384_74##8	6.94545e-18
C997	a_384_74##17	VNB	4.85421e-17
C998	a_384_74##14	VNB	1.82634e-17
C999	Y#8	VPWR#4	6.35459e-18
C1000	VGND#25	a_27_74##12	1.52743e-19
C1001	a_384_74##11	VNB	4.95126e-17
C1002	a_384_74##8	VNB	1.84922e-17
C1003	a_384_74##5	VNB	4.44478e-17
C1004	Y#4	Y#7	4.40657e-18
C1005	Y#8	VPWR#8	1.3614e-18
C1006	a_384_74##2	VNB	4.15128e-17
C1007	a_384_74##56	a_27_74##15	6.5262e-20
C1008	a_27_74##17	VNB	2.9735e-17
C1009	VGND#4	Y#8	1.09616e-18
C1010	VPWR#5	a_384_74##11	4.05308e-20
C1011	a_27_74##15	VNB	6.04613e-17
C1012	VPWR#20	a_27_74#	3.44144e-19
C1013	VPWR#19	a_27_74##10	3.44144e-19
C1014	a_27_74##5	VNB	4.15728e-17
C1015	a_384_74##4	a_384_74##5	2.25002e-17
C1016	a_384_74##19	a_384_74##48	6.83317e-18
C1017	a_27_74##3	VNB	2.6766e-17
C1018	a_384_74##4	Y#24	2.76865e-17
C1019	a_27_74##2	VNB	2.24879e-17
C1020	a_27_74#	a_384_74##22	4.09434e-18
C1021	VGND#10	a_384_74##55	2.94412e-19
C1022	A#6	VNB	3.63363e-17
C1023	Y#8	VPWR#7	6.92416e-19
C1024	a_27_74##28	VPWR#24	5.20507e-17
C1025	A#2	VNB	2.6668e-17
C1026	A#1	a_27_74##18	3.90138e-17
C1027	a_384_74##63	a_27_74##13	3.09991e-17
C1028	a_384_74##78	a_384_74##4	2.91454e-17
C1029	VPWR#10	a_27_74#	5.16556e-18
C1030	VGND#13	VGND#12	1.62068e-18
C1031	VGND#9	a_384_74##51	6.36843e-18
C1032	VGND#1	a_384_74##24	2.74598e-17
C1033	VGND#12	a_384_74##63	5.36914e-18
C1034	a_384_74##57	a_27_74##5	2.56384e-18
C1035	Y#20	a_384_74##4	2.74403e-17
C1036	Y#24	a_384_74##7	9.30684e-20
C1037	a_384_74##68	Y#8	6.48331e-17
C1038	a_384_74##64	a_27_74##10	4.82766e-17
C1039	VPWR#13	VPWR#12	2.0066e-18
C1040	Y#17	VGND#18	9.45019e-19
C1041	VGND#13	a_27_74##23	2.91756e-19
C1042	a_384_74##21	a_384_74##48	1.40032e-18
C1043	VGND#24	a_27_74##16	1.68102e-19
C1044	Y	VGND#19	8.95281e-19
C1045	Y#5	Y#8	7.22631e-19
C1046	VPWR#9	a_27_74#	8.1728e-20
C1047	Y#20	a_384_74##7	2.91889e-17
C1048	a_384_74##21	a_384_74##52	5.97347e-18
C1049	a_27_74##13	VGND#25	1.42294e-17
C1050	a_384_74##55	a_27_74##17	2.86219e-19
C1051	a_384_74##2	Y#22	1.43795e-19
C1052	a_27_74##10	VPWR#20	2.42267e-17
C1053	a_384_74##59	a_27_74##3	2.33087e-18
C1054	a_384_74##21	a_384_74##53	1.42591e-19
C1055	a_384_74##68	Y#5	8.97166e-17
C1056	a_384_74##77	a_384_74##7	3.00221e-17
C1057	VPWR#19	a_27_74##11	1.53981e-19
C1058	A	a_27_74##26	4.47687e-17
C1059	VPWR#26	VPWR#24	1.87864e-18
C1060	Y#4	VGND#21	6.29203e-17
C1061	a_384_74##5	VPWR#12	1.945e-18
C1062	Y#17	a_384_74##7	2.78811e-17
C1063	Y#25	a_384_74##24	4.0209e-17
C1064	VGND#10	a_384_74##23	5.07635e-18
C1065	a_384_74##74	a_384_74##11	6.41011e-18
C1066	a_384_74##63	a_27_74##16	1.37094e-18
C1067	a_384_74##65	a_27_74##10	1.68814e-18
C1068	a_384_74##64	a_27_74##11	1.68814e-18
C1069	VGND#11	a_384_74##70	1.88154e-18
C1070	a_384_74##66	Y#5	6.20658e-17
C1071	a_384_74##10	Y#17	2.38267e-17
C1072	A#5	A#1	4.10297e-17
C1073	VPWR#21	a_27_74##10	8.1728e-20
C1074	a_384_74##58	a_27_74##13	3.85933e-19
C1075	VPWR#13	Y#21	6.13215e-17
C1076	a_384_74##68	VPWR#8	3.24444e-19
C1077	a_384_74##74	a_384_74##10	2.69233e-17
C1078	VGND#4	VGND#7	4.86096e-17
C1079	Y#2	Y#5	9.23007e-19
C1080	VGND#2	a_384_74##5	9.96243e-20
C1081	VGND#1	a_384_74##25	1.37281e-18
C1082	Y#8	VPWR#11	9.77682e-18
C1083	a_384_74##7	a_384_74##11	1.84574e-19
C1084	Y#14	a_384_74##10	2.68969e-17
C1085	Y#17	a_384_74##13	7.96764e-20
C1086	a_384_74##74	VGND#18	7.69431e-18
C1087	VPWR#22	a_27_74##10	1.53981e-19
C1088	a_27_74##11	VPWR#20	2.88136e-17
C1089	VPWR#23	VNB	2.65647e-17
C1090	a_384_74##66	Y#2	8.72214e-17
C1091	VPWR#4	a_384_74##4	1.20297e-18
C1092	VPWR#21	VNB	2.52707e-17
C1093	VGND#4	VGND#6	5.55577e-17
C1094	VGND#9	a_384_74##23	4.32095e-19
C1095	VPWR#10	VNB	2.67185e-17
C1096	Y	VPWR#15	2.52424e-17
C1097	VPWR#26	a_27_74##28	5.21059e-17
C1098	VPWR#9	VNB	2.68822e-17
C1099	VPWR#8	VNB	2.66964e-17
C1100	VPWR#10	a_27_74##10	2.85183e-19
C1101	VPWR#7	VNB	2.69339e-17
C1102	VGND#25	a_27_74##16	2.7334e-17
C1103	VPWR#6	VNB	2.69862e-17
C1104	VGND#16	a_384_74##24	1.465e-18
C1105	VGND#4	a_384_74##4	2.93096e-18
C1106	VPWR#5	VNB	2.21093e-17
C1107	VGND#23	VPWR#19	3.81273e-19
C1108	VPWR#3	VNB	2.20506e-17
C1109	Y#14	a_384_74##13	3.10217e-17
C1110	a_384_74##7	a_384_74##8	1.1969e-17
C1111	VPWR#2	VNB	3.36826e-17
C1112	Y#5	VPWR#11	1.54544e-17
C1113	VPWR#4	a_384_74##7	1.33007e-18
C1114	VGND#4	VGND#5	4.60611e-17
C1115	VGND#11	a_384_74##68	1.21993e-17
C1116	VGND#13	a_27_74##22	5.36453e-19
C1117	VGND#13	VNB	2.73108e-17
C1118	VGND#12	VNB	2.5594e-17
C1119	a_384_74##73	a_384_74##13	3.08946e-17
C1120	VGND#10	VNB	2.93114e-17
C1121	a_384_74##55	a_27_74##15	1.94571e-18
C1122	VGND#9	VNB	2.73718e-17
C1123	a_384_74##65	a_27_74##11	5.57945e-17
C1124	a_384_74##54	Y#2	4.01953e-17
C1125	VGND#8	VNB	2.98185e-17
C1126	VGND#4	a_384_74##7	3.09432e-18
C1127	VGND#22	VGND#21	2.49656e-18
C1128	VGND#7	VNB	2.97389e-17
C1129	VGND#11	Y#5	1.34528e-18
C1130	VGND#6	VNB	2.95312e-17
C1131	Y#11	a_384_74##13	2.56467e-17
C1132	VGND#5	VNB	2.41027e-17
C1133	VPWR#4	a_384_74##10	8.64108e-19
C1134	VGND#4	VGND#3	4.49515e-17
C1135	VGND#3	VNB	2.30898e-17
C1136	a_384_74##7	a_384_74##5	3.54928e-18
C1137	VGND#2	VNB	3.52717e-17
C1138	VGND#13	a_384_74##58	5.24724e-18
C1139	Y#2	VPWR#11	1.26939e-17
C1140	Y#25	a_384_74##25	3.85294e-17
C1141	a_384_74##63	a_27_74##18	2.06596e-19
C1142	Y#14	a_384_74##17	8.72376e-20
C1143	VGND#11	a_384_74##66	1.15525e-17
C1144	VPWR#21	a_27_74##5	2.09747e-20
C1145	VGND#4	a_384_74##10	2.91224e-18
C1146	a_384_74##16	Y#11	2.4973e-17
C1147	VGND#4	VGND#2	6.53782e-17
C1148	VPWR#4	a_384_74##13	1.07592e-18
C1149	Y#24	VPWR#1	3.75605e-17
C1150	a_384_74##58	a_27_74##16	2.39019e-17
C1151	a_384_74##54	VPWR#11	1.01068e-17
C1152	VGND#27	A#6	3.11931e-19
C1153	VGND#11	Y#2	1.01311e-18
C1154	VPWR#22	a_27_74##11	6.12523e-19
C1155	a_384_74##60	VNB	1.55961e-18
C1156	a_384_74##56	a_27_74##5	1.44249e-18
C1157	A#7	A#5	2.6283e-17
C1158	a_384_74##59	VNB	1.06203e-18
C1159	VPWR#20	a_27_74##14	3.44144e-19
C1160	a_384_74##57	VNB	1.03121e-18
C1161	VGND#10	a_27_74##8	1.92313e-18
C1162	a_384_74##56	VNB	1.03081e-18
C1163	a_384_74##70	a_384_74##16	2.72899e-17
C1164	a_27_74##26	a_27_74##28	2.36849e-18
C1165	VGND#4	a_384_74##13	2.94909e-18
C1166	a_384_74##55	VNB	1.77614e-19
C1167	a_27_74##23	VNB	1.14536e-18
C1168	VGND#11	a_384_74##54	1.02239e-17
C1169	a_27_74##22	VNB	6.43871e-18
C1170	VPWR#4	a_384_74##16	1.24533e-18
C1171	Y#11	a_384_74##19	9.37317e-20
C1172	VGND#1	a_384_74##27	2.86953e-19
C1173	VGND#1	VNB	7.23286e-17
C1174	Y#25	VNB	1.0442e-17
C1175	Y#5	VPWR#9	1.28393e-18
C1176	Y#24	Y#22	1.67442e-18
C1177	VGND#16	VNB	9.07195e-19
C1178	Y#19	VNB	3.21247e-18
C1179	VGND#4	a_384_74##16	1.75652e-18
C1180	VGND#17	VNB	8.97376e-19
C1181	Y#16	VNB	3.21901e-18
C1182	VGND#25	a_27_74##18	1.00988e-18
C1183	VGND#18	VNB	9.01595e-19
C1184	a_384_74##65	a_27_74##14	4.82521e-17
C1185	Y#13	VNB	3.21158e-18
C1186	VGND#19	VNB	8.97376e-19
C1187	Y#8	a_384_74##16	2.50754e-17
C1188	VPWR#21	a_27_74##11	5.02784e-19
C1189	Y#12	VNB	3.23931e-18
C1190	Y#5	VPWR#8	1.16637e-18
C1191	VGND#20	VNB	8.97376e-19
C1192	Y#7	VNB	3.30354e-18
C1193	VGND#21	VNB	8.98256e-19
C1194	a_384_74##25	VGND#16	1.69896e-17
C1195	VGND#26	a_27_74##16	1.2119e-18
C1196	Y#4	VNB	8.74152e-18
C1197	VGND#22	VNB	3.80878e-19
C1198	Y#24	VPWR#12	3.87573e-17
C1199	Y#1	VNB	3.21199e-18
C1200	VGND#23	VNB	1.55631e-18
C1201	a_384_74##62	VNB	2.3242e-18
C1202	Y#8	a_384_74##19	2.74261e-17
C1203	VGND#9	a_27_74##8	1.09503e-19
C1204	a_384_74##5	Y#21	1.20861e-19
C1205	VGND#24	VNB	4.56457e-19
C1206	VGND#22	Y#4	5.28051e-17
C1207	a_384_74##63	VNB	2.11272e-18
C1208	VGND#25	VNB	1.94671e-19
C1209	VGND#12	a_384_74##58	5.51402e-18
C1210	a_384_74##58	VNB	4.80275e-18
C1211	a_384_74##68	a_384_74##19	3.28664e-17
C1212	VGND#26	VNB	3.01253e-20
C1213	a_27_74##14	VPWR#22	2.43297e-17
C1214	a_27_74##27	VNB	4.55126e-18
C1215	Y#18	VPWR#13	5.64141e-17
C1216	a_27_74##26	VPWR#26	5.2514e-17
C1217	VGND#27	VNB	1.66926e-18
C1218	VPWR#20	a_27_74##19	1.53981e-19
C1219	VPWR#10	a_27_74##11	8.1728e-20
C1220	a_27_74##24	VNB	4.65845e-17
C1221	VPWR#1	VNB	8.06335e-17
C1222	Y#8	a_384_74##21	9.89198e-20
C1223	Y#5	a_384_74##19	3.17431e-17
C1224	Y#14	a_384_74##11	7.96277e-18
C1225	Y#22	VNB	2.88281e-18
C1226	VPWR#12	VNB	2.9502e-18
C1227	Y#21	VNB	2.14956e-18
C1228	a_384_74##4	a_384_74##7	2.01947e-19
C1229	a_27_74##18	a_384_74##58	1.99113e-17
C1230	Y#25	a_384_74##27	1.99631e-18
C1231	VPWR#13	VNB	3.00866e-18
C1232	Y#18	VNB	2.14318e-18
C1233	VGND#1	VPWR#1	1.12128e-17
C1234	VPWR#14	VNB	3.00641e-18
C1235	Y#15	VNB	2.14892e-18
C1236	VPWR#15	VNB	2.92383e-18
C1237	Y#5	a_384_74##21	2.5507e-17
C1238	Y#10	VNB	2.14892e-18
C1239	a_27_74##27	a_27_74##16	1.28671e-19
C1240	VPWR#16	VNB	2.92383e-18
C1241	Y#9	VNB	2.15195e-18
C1242	a_384_74##61	a_27_74##14	2.01285e-18
C1243	VPWR#17	VNB	2.92383e-18
C1244	a_384_74##11	Y#18	1.1473e-19
C1245	Y#6	VNB	2.14892e-18
C1246	a_384_74##66	a_384_74##21	2.80095e-17
C1247	a_384_74##65	a_27_74##19	1.68814e-18
C1248	VPWR#18	VNB	2.92383e-18
C1249	A	a_27_74##20	2.60666e-19
C1250	Y#3	VNB	2.15006e-18
C1251	a_384_74##10	a_384_74##11	2.76829e-17
C1252	VPWR#19	VNB	2.92383e-18
C1253	Y#19	a_384_74##25	3.96575e-19
C1254	A	A#4	1.70045e-18
C1255	a_384_74##64	VNB	2.28176e-18
C1256	Y#2	a_384_74##21	3.19567e-17
C1257	VPWR#20	VNB	2.92383e-18
C1258	a_384_74##65	VNB	2.17062e-18
C1259	A	A#8	2.05823e-18
C1260	VPWR#11	a_384_74##19	1.70447e-18
C1261	VPWR#22	VNB	2.92383e-18
C1262	Y	a_384_74##38	1.54342e-18
C1263	a_384_74##61	VNB	3.07049e-18
C1264	A	A#9	3.34096e-18
C1265	VPWR#24	VNB	2.92383e-18
C1266	a_27_74##28	VNB	2.1429e-18
C1267	VGND#11	a_384_74##19	2.94874e-18
C1268	VPWR#26	VNB	2.82484e-18
C1269	a_27_74##26	VNB	4.93569e-17
C1270	a_384_74##24	VNB	3.2205e-17
C1271	VPWR#11	a_384_74##21	1.31775e-18
C1272	a_384_74##10	a_384_74##13	1.67609e-19
C1273	VGND#26	a_27_74##18	2.99835e-17
C1274	a_384_74##78	VPWR#12	6.27469e-18
C1275	VPWR#24	a_27_74##14	1.5047e-19
C1276	a_384_74##25	VNB	2.78739e-17
C1277	a_384_74##68	VGND#8	2.08874e-18
C1278	a_384_74##27	VNB	2.64485e-17
C1279	a_27_74##19	VPWR#22	2.88151e-17
C1280	VPWR#23	a_27_74##14	7.75555e-20
C1281	a_384_74##29	VNB	2.77832e-17
C1282	a_384_74##31	VNB	2.66155e-17
C1283	VGND#11	a_384_74##21	1.07037e-18
C1284	a_384_74##33	VNB	2.76606e-17
C1285	a_384_74##35	VNB	2.91225e-17
C1286	a_384_74##37	VNB	2.71445e-17
C1287	VGND#16	a_384_74##27	4.36691e-17
C1288	a_384_74##39	VNB	2.67621e-17
C1289	VGND#2	a_384_74##2	3.77275e-20
C1290	a_384_74##41	VNB	3.04715e-17
C1291	VPWR#14	VPWR#13	1.98598e-18
C1292	a_384_74##66	VPWR#9	3.16795e-19
C1293	Y#1	Y#4	4.71378e-18
C1294	a_384_74##43	VNB	2.51508e-17
C1295	a_384_74##45	VNB	2.76284e-17
C1296	a_384_74##47	VNB	2.79254e-17
C1297	a_384_74##49	VNB	2.87866e-17
C1298	a_384_74##51	VNB	2.63413e-17
C1299	a_384_74##23	VNB	2.81805e-17
C1300	a_27_74##8	VNB	2.59396e-17
C1301	a_27_74##9	VNB	2.62064e-17
C1302	a_384_74##73	VGND#19	7.59442e-18
C1303	a_384_74##61	a_27_74##19	7.39102e-17
C1304	VPWR#21	a_27_74##14	5.1817e-18
C1305	a_384_74##58	A#1	7.66775e-19
C1306	a_27_74##12	VNB	2.50343e-17
C1307	a_27_74##24	A#6	2.51133e-19
C1308	a_27_74##13	VNB	2.64424e-17
C1309	a_27_74##16	VNB	2.47486e-17
C1310	a_27_74##18	VNB	2.72138e-17
C1311	a_384_74##16	a_384_74##19	2.27696e-19
C1312	a_384_74##55	a_27_74##5	2.27784e-18
C1313	A#1	VNB	2.49755e-17
C1314	A#5	VNB	2.68349e-17
C1315	a_27_74##27	a_27_74##18	5.40425e-19
C1316	A#7	VNB	3.43005e-17
C1317	Y#25	a_384_74##29	2.05321e-19
C1318	VGND#26	VGND#12	4.31886e-19
C1319	a_384_74#	VNB	3.97036e-17
C1320	a_384_74##26	VNB	3.37914e-17
C1321	a_384_74##28	VNB	3.74481e-17
C1322	a_384_74##30	VNB	3.32382e-17
C1323	VGND#12	a_27_74##12	5.27848e-19
C1324	a_384_74##32	VNB	3.48031e-17
C1325	a_384_74##21	a_384_74##19	4.06976e-18
C1326	a_384_74##34	VNB	3.30794e-17
C1327	a_384_74##36	VNB	3.51409e-17
C1328	VPWR#24	a_27_74##19	1.1593e-18
C1329	a_384_74##38	VNB	3.31989e-17
C1330	a_384_74##40	VNB	3.46841e-17
C1331	VPWR#22	a_27_74##20	3.33993e-19
C1332	a_384_74##42	VNB	3.60368e-17
C1333	a_384_74##44	VNB	3.29616e-17
C1334	Y#19	a_384_74##27	1.32499e-17
C1335	a_384_74##46	VNB	3.3439e-17
C1336	a_384_74##73	Y	4.46043e-17
C1337	a_384_74##48	VNB	3.80461e-17
C1338	a_384_74##56	a_27_74##3	1.73814e-18
C1339	a_384_74##50	VNB	3.31615e-17
C1340	Y#20	VPWR#12	3.13872e-17
C1341	a_384_74##73	a_384_74##14	3.31627e-18
C1342	a_384_74##52	VNB	3.73334e-17
C1343	VGND#26	A#1	2.82147e-17
C1344	a_384_74##53	VNB	3.43252e-17
C1345	VPWR#10	VPWR#9	6.93111e-19
C1346	a_27_74#	VNB	3.79642e-17
C1347	VPWR#11	A	8.88582e-18
C1348	VGND#13	a_27_74##27	6.6813e-18
C1349	Y	VPWR#4	5.44658e-18
C1350	a_27_74##10	VNB	3.37642e-17
C1351	a_27_74##11	VNB	3.2013e-17
C1352	VGND#11	A	8.07605e-18
C1353	a_27_74##14	VNB	3.2113e-17
C1354	a_27_74##19	VNB	3.46803e-17
C1355	VPWR#14	Y#18	5.76348e-17
C1356	a_27_74##20	VNB	3.69145e-17
C1357	a_27_74##28	a_27_74##19	1.6201e-19
C1358	VGND#10	a_384_74##22	2.65272e-20
C1359	A#4	VNB	3.33678e-17
C1360	A#8	VNB	3.17581e-17
C1361	a_27_74##20	a_384_74##61	4.5769e-17
C1362	A#9	VNB	4.38433e-17
C1363	Y#20	Y#21	7.31017e-19
C1364	Y#24	VNB	9.84082e-18
C1365	Y#1	VGND#22	6.23381e-17
C1366	a_384_74##78	VNB	2.20634e-18
C1367	Y#20	VNB	8.62921e-19
C1368	VGND#16	a_384_74##29	2.32609e-18
C1369	a_384_74##13	a_384_74##17	1.9491e-19
C1370	a_384_74##77	VNB	1.0756e-18
C1371	Y#17	VNB	1.00482e-18
C1372	a_384_74##74	VNB	9.43758e-19
C1373	Y#14	VNB	1.93978e-18
C1374	a_384_74##58	A#5	1.97573e-19
C1375	a_384_74##73	VNB	9.0631e-19
C1376	Y#11	VNB	9.36937e-19
C1377	a_384_74##8	Y#18	1.132e-19
C1378	a_384_74##70	VNB	1.11117e-18
C1379	VPWR#4	VNB	2.47262e-16
C1380	Y#2	VPWR#10	6.58881e-19
C1381	VGND#4	VNB	2.34543e-16
C1382	Y#20	VPWR#13	4.03997e-17
C1383	VPWR#23	a_27_74##19	2.75115e-19
C1384	A#1	a_27_74##27	1.39055e-17
C1385	Y#8	VNB	7.23241e-19
C1386	a_27_74##20	VPWR#24	2.03714e-17
C1387	Y	a_384_74##13	1.58643e-18
C1388	a_384_74##68	VNB	1.09226e-18
C1389	A	A#3	1.97901e-17
C1390	a_384_74##13	a_384_74##14	1.22394e-17
C1391	Y#5	VNB	4.54383e-19
C1392	VGND#17	a_384_74##27	7.30871e-19
C1393	a_384_74##66	VNB	1.05453e-18
C1394	VPWR#22	A#4	1.5047e-19
C1395	Y#2	VNB	9.08048e-19
C1396	a_384_74##54	VNB	8.35835e-19
C1397	Y#2	VPWR#9	1.46131e-18
C1398	VPWR#11	VNB	3.19388e-16
C1399	a_384_74##26	a_384_74#	3.92179e-17
C1400	VGND#11	VNB	3.05234e-16
C1401	a_384_74##4	VNB	1.05561e-18
C1402	VPWR#20	a_27_74##5	3.76942e-19
C1403	a_384_74##11	VPWR#14	2.42205e-18
C1404	a_384_74##7	VNB	3.22381e-17
C1405	a_384_74##10	VNB	9.26762e-19
C1406	a_384_74##13	VNB	3.06229e-17
C1407	a_384_74##16	VNB	6.14689e-19
C1408	a_384_74##13	a_384_74##11	4.98485e-18
C1409	a_384_74##19	VNB	4.63772e-17
C1410	a_384_74##21	VNB	4.43055e-17
C1411	a_27_74##28	a_27_74##20	1.6677e-18
C1412	VPWR#21	a_27_74##19	7.34342e-18
C1413	VGND#10	VGND#9	1.11424e-18
C1414	A#3	VNB	3.13446e-17
C1415	VGND#26	A#5	1.22621e-18
C1416	a_384_74##61	A#4	2.14303e-18
C1417	Y#19	a_384_74##29	3.73637e-17
C1418	A	VNB	3.57561e-17
C1419	a_27_74##5	a_27_74##3	4.00188e-18
C1420	VGND#12	a_27_74##13	5.81537e-18
C1421	VGND#27	A#1	2.28999e-18
C1422	a_384_74##56	a_27_74##2	2.00472e-19
C1423	A#2	a_27_74##17	2.49153e-17
C1424	VGND#14	VGND#13	1.60811e-18
C1425	VPWR#25	VNB	4.64004e-17
C1426	a_27_74##25	VPWR#25	3.13618e-19
C1427	VPWR#25	A#3	2.04712e-20
C1428	VGND#11	VGND#14	9.85802e-17
C1429	VPWR#25	A#4	5.30308e-19
C1430	VPWR#25	A#9	7.70872e-18
C1431	VGND#14	A#3	2.26697e-20
C1432	VGND#14	A#1	8.69739e-19
C1433	a_27_74##28	VPWR#25	8.48902e-18
C1434	VGND#14	A#5	5.85993e-18
C1435	VGND#14	A#7	5.41481e-18
C1436	VPWR#25	a_27_74##20	8.1728e-20
C1437	VPWR#25	VPWR#23	6.93668e-19
C1438	VGND#14	a_27_74##27	3.76672e-18
C1439	VGND#14	VNB	4.73644e-17
C1440	a_27_74##26	VPWR#25	2.1222e-17
C1441	VGND#14	a_27_74##23	6.89606e-19
C1442	VPWR#25	A#8	5.25568e-18
C1443	VGND#14	a_27_74##24	1.7841e-17
C1444	VPWR#11	VPWR#25	8.81222e-17
*
*
.ENDS sky130_fd_sc_hs__bufinv_16
*
