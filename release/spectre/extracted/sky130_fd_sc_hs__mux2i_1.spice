* Extracted by Quantus, converted by sky130cad/quantus.py
*
*
*
*                       LINUX           Wed Nov 18 08:43:27 2026
*
*
*
*  PROGRAM  advgen
*
*  Name           : advgen - Quantus - (64-bit)
*  Version        : 25.1.0-p047
*  Build Date     : Thu Dec 11 23:20:30 PST 2025
*
*  HSPICE LIBRARY
*
*  OPERATING_TEMPERATURE 150
*  QRC_TECH_DIR <path>/tech
*
*
*

*
.SUBCKT sky130_fd_sc_hs__mux2i_1 VPB VNB VGND VPWR Y S A1 A0
*
*
*  caps2d version: 10
*
*
*       TRANSISTOR CARDS
*
*
XM9 VGND#3 S#6 a_114_74##6 VNB sky130_fd_pr__nfet_01v8_lvt l=0.15 w=0.55 ad=0.15675 as=0.15675 pd=1.67 ps=1.67
XM8 a_225_74##2 S#1 VGND#1 VNB sky130_fd_pr__nfet_01v8_lvt l=0.15 w=0.74 ad=0.2109 as=0.3108 pd=2.05 ps=2.32
XM1 VGND#1 a_114_74# a_426_74# VNB sky130_fd_pr__nfet_01v8_lvt l=0.15 w=0.74 ad=0.3108 as=0.1776 pd=2.32 ps=1.96
XM0 a_426_74# A0#3 Y#2 VNB sky130_fd_pr__nfet_01v8_lvt l=0.15 w=0.74 ad=0.1776 as=0.5217 pd=1.96 ps=2.89
XM5 Y#2 A1#3 a_225_74# VNB sky130_fd_pr__nfet_01v8_lvt l=0.15 w=0.74 ad=0.5217 as=0.2109 pd=2.89 ps=2.05
XM2 VPWR#3 S#7 a_114_74##7 VPB sky130_fd_pr__pfet_01v8 l=0.15 w=0.84 ad=0.2394 as=0.231 pd=2.25 ps=2.23
XM4 a_223_368##2 S#5 VPWR#1 VPB sky130_fd_pr__pfet_01v8 l=0.15 w=1.12 ad=0.3136 as=0.336 pd=2.8 ps=2.84
XM7 VPWR#1 a_114_74##3 a_399_368##2 VPB sky130_fd_pr__pfet_01v8 l=0.15 w=1.12 ad=0.336 as=0.308 pd=2.84 ps=2.79
XM3 a_223_368# A0#1 Y#1 VPB sky130_fd_pr__pfet_01v8 l=0.15 w=1.12 ad=0.3136 as=0.336 pd=2.8 ps=2.84
XM6 Y#1 A1#4 a_399_368# VPB sky130_fd_pr__pfet_01v8 l=0.15 w=1.12 ad=0.336 as=0.3192 pd=2.84 ps=2.81
*
*
*       RESISTOR AND CAP/DIODE CARDS
*
Rg1	S#1	S#2	277.445038
Rg2	S#2	S#3	492.623352
Rg3	S#3	S#4	47.460377
Rg4	S#2	S#5	575.182312
Rg5	S#3	S#6	323.402100
Rg6	S#4	S#7	452.756500
Rg7	a_114_74#	a_114_74##2	382.539734
Rg8	a_114_74##2	a_114_74##3	434.639221
Rg9	A0#1	A0#2	462.532532
Rg10	A0#2	A0#3	423.399261
Rg11	A1#1	A1#2	24.707481
Rg12	A1#2	A1#3	320.354431
Rg13	A1#2	A1#4	506.680298
Rf1	S	S#8	1.431188
Rf2	S#9	S#4	81.547592
Rf3	S#8	S#9	6.953845
Rf4	S	S#11	1.431188
Rf5	S#9	S#11	4.481367
Rf6	a_114_74##2	a_114_74##5	234.286774
Rf7	a_114_74##5	a_114_74##6	66.807083
Rf8	a_114_74##5	a_114_74##7	76.236839
Rf9	a_223_368#	a_223_368##2	137.968719
Rf10	A0#4	A0#2	161.149612
Rf11	A0	A0#6	0.916808
Rf12	A0#4	A0#6	5.739682
Rf13	Y#1	Y#3	104.406075
Rf14	Y#3	Y	9.152890
Rf15	Y#2	Y#3	7.500000
Rf16	a_225_74#	a_225_74##2	231.205795
Rf17	A1#5	A1	0.705966
Rf18	A1#1	A1#7	160.938766
Rf19	A1#5	A1#7	3.543054
Rf20	a_399_368#	a_399_368##2	142.734314
Rf21	VGND#1	VGND#2	41.745289
Rf22	VGND#2	VGND#3	168.743118
Rf23	VPWR#1	VPWR#2	35.032631
Rf24	VPWR#2	VPWR#3	169.842712
Re1	VPWR#2	VPWR	1.227783
Re2	VGND	VGND#2	1.227829
*
*       CAPACITOR CARDS
*
*
C1	VGND	VNB	7.26313e-17
C2	VPWR	VNB	6.53168e-17
C3	Y	VNB	7.28532e-18
C4	S	VNB	1.33591e-17
C5	A1	VNB	9.9739e-18
C6	VGND	Y	1.24461e-17
C7	A0	VNB	1.44475e-18
C8	VGND	A1	4.61642e-18
C9	a_399_368#	A1#2	5.04909e-18
C10	a_114_74##6	S#8	6.67319e-18
C11	VPWR	S	5.2376e-18
C12	a_225_74##2	a_225_74#	1.6614e-18
C13	a_114_74##2	VNB	3.53156e-17
C14	VPWR	A0	3.19809e-18
C15	A0#2	VNB	4.67829e-17
C16	Y	A1	2.02285e-17
C17	VGND#2	VNB	2.80896e-16
C18	VPWR#2	VNB	2.74481e-16
C19	S#7	VNB	5.03586e-17
C20	S#5	VNB	4.39786e-17
C21	a_114_74##3	VNB	3.61444e-17
C22	VGND	a_114_74##2	3.67842e-18
C23	A0#1	VNB	3.5934e-17
C24	VGND	A0#2	6.87085e-20
C25	A1#4	VNB	4.32178e-17
C26	S#6	VNB	3.59969e-17
C27	VGND	VGND#2	9.84024e-17
C28	S#1	VNB	2.78727e-17
C29	a_114_74#	VNB	2.78633e-17
C30	A0#3	VNB	3.45753e-17
C31	A1#3	VNB	3.58877e-17
C32	VPWR	a_114_74##2	4.47565e-18
C33	VPWR#3	VNB	7.65225e-17
C34	a_114_74##7	VNB	1.46208e-17
C35	a_223_368##2	VNB	1.32829e-17
C36	VPWR#1	VNB	1.20207e-19
C37	a_399_368##2	VNB	1.39295e-17
C38	VGND#1	a_225_74#	2.23665e-17
C39	a_223_368#	VNB	7.16888e-18
C40	Y#1	VNB	7.74245e-18
C41	a_399_368#	VNB	6.37345e-17
C42	VPWR	VPWR#2	6.91481e-17
C43	Y	a_114_74##2	1.91352e-19
C44	VGND#3	VNB	6.28464e-17
C45	VGND	S#6	1.35087e-18
C46	a_114_74##6	VNB	9.54483e-18
C47	Y	A0#2	1.20662e-17
C48	a_225_74##2	VNB	1.63563e-17
C49	VGND	S#1	2.73459e-19
C50	VPWR	S#7	2.94307e-18
C51	VGND#1	VNB	2.14683e-18
C52	VGND	a_114_74#	3.47683e-19
C53	VPWR	S#5	1.12962e-18
C54	VGND	A0#3	4.48475e-18
C55	a_225_74#	VNB	4.18245e-17
C56	S#8	VNB	1.18433e-17
C57	VPWR	a_114_74##3	7.58492e-19
C58	VGND	A1#3	2.64636e-18
C59	S#9	VNB	6.03786e-18
C60	VPWR	A0#1	1.49638e-18
C61	VPWR	A1#4	2.20998e-18
C62	VGND	a_223_368##2	2.73168e-18
C63	a_114_74##5	VNB	1.48136e-17
C64	A0#4	VNB	4.4193e-18
C65	A0#4	Y#1	1.00523e-17
C66	A1#7	VNB	1.05728e-17
C67	A1	A0#2	1.11902e-19
C68	VGND	a_399_368#	4.28312e-18
C69	VGND	VGND#3	4.05098e-17
C70	VGND	a_114_74##6	1.76491e-17
C71	a_114_74##2	A0	6.42021e-18
C72	A0#4	A1#2	1.01464e-18
C73	VGND	a_225_74##2	1.85505e-17
C74	S#3	S#2	1.45778e-18
C75	VGND#3	S#3	6.70428e-18
C76	VPWR	VPWR#3	4.0593e-17
C77	VGND#2	A1	1.07038e-18
C78	A0	A0#2	7.19957e-18
C79	VPWR	a_114_74##7	1.90643e-17
C80	S	S#5	6.30828e-19
C81	VPWR	a_223_368##2	1.61078e-17
C82	VGND	a_225_74#	4.8231e-17
C83	VPWR	VPWR#1	2.15676e-17
C84	VGND	S#8	4.91087e-18
C85	VPWR	a_399_368##2	2.60961e-17
C86	Y	a_114_74#	3.12172e-18
C87	VPWR	a_223_368#	1.1749e-17
C88	Y	A0#3	1.86821e-17
C89	VPWR	Y#1	7.03422e-18
C90	VGND	a_114_74##5	2.66601e-18
C91	VPWR	a_399_368#	3.14056e-17
C92	Y	A1#3	1.65717e-17
C93	VGND	A0#4	4.01191e-18
C94	a_225_74#	Y#2	5.35228e-18
C95	A0	S#5	2.20053e-19
C96	Y	a_223_368#	1.93277e-18
C97	A0	a_114_74##3	1.05915e-18
C98	S	VPWR#3	2.444e-17
C99	A0	A0#1	5.31887e-18
C100	A0	A1#4	4.19872e-19
C101	VPWR	a_114_74##5	3.17717e-18
C102	a_225_74##2	Y	3.51494e-17
C103	A1	A0#3	3.09632e-19
C104	Y	Y#2	1.19951e-17
C105	a_225_74#	Y	9.61543e-17
C106	VPWR	A1#7	2.15635e-18
C107	Y	A0#4	3.09852e-17
C108	a_114_74##2	A0#2	2.89084e-17
C109	a_114_74##6	S#3	9.39218e-19
C110	a_114_74##5	a_225_74##2	3.33027e-17
C111	Y	A1#7	1.03617e-17
C112	S#2	VNB	5.30866e-17
C113	A0	a_399_368##2	2.32043e-19
C114	S#3	VNB	9.97055e-17
C115	A1#2	VNB	6.34448e-17
C116	A0	a_223_368#	2.7856e-17
C117	Y#1	A1#7	1.36382e-17
C118	A0	Y#1	2.25867e-17
C119	S	a_114_74##5	2.8975e-17
C120	A0	a_399_368#	9.81543e-19
C121	VPWR#2	a_114_74##2	5.52077e-20
C122	VGND#2	A0#2	2.2024e-19
C123	a_225_74#	A1	3.45831e-17
C124	a_114_74#	a_426_74#	1.31401e-17
C125	S#3	S#1	6.13514e-19
C126	VPWR#2	A0#2	8.7591e-20
C127	A0#3	a_426_74#	2.66794e-18
C128	A1#7	a_399_368#	2.04427e-17
C129	S#5	a_114_74##2	1.28551e-17
C130	a_114_74##2	S#2	4.49115e-17
C131	a_225_74##2	S#2	1.22539e-17
C132	a_114_74##2	S#3	7.01023e-19
C133	a_114_74##5	A0	1.78745e-18
C134	a_225_74##2	S#3	3.02057e-19
C135	A0#2	A1#4	2.82339e-18
C136	VGND	S#2	1.59024e-18
C137	VGND	S#3	3.00639e-18
C138	VGND	A1#2	6.4202e-19
C139	S#2	a_114_74#	2.72721e-18
C140	VPWR#2	S#5	1.84742e-18
C141	a_225_74##2	A1#2	6.64312e-19
C142	a_225_74##2	a_426_74#	5.18898e-20
C143	VPWR#2	a_114_74##3	4.08078e-18
C144	a_114_74##2	A0#3	4.72532e-19
C145	VPWR#2	A0#1	4.45075e-18
C146	S#7	S#5	6.82833e-18
C147	a_225_74#	a_426_74#	6.32864e-19
C148	VPWR#2	A1#4	4.47264e-18
C149	VGND#2	S#6	7.29451e-19
C150	VGND#2	S#1	6.14839e-18
C151	S#8	a_114_74##5	2.127e-17
C152	S#5	a_114_74##3	4.6833e-17
C153	A0#2	A1#2	2.16041e-17
C154	a_114_74##2	a_223_368##2	2.11488e-17
C155	VGND#2	a_114_74#	5.81502e-18
C156	VGND#2	A0#3	6.33519e-18
C157	a_114_74##2	a_399_368##2	1.79223e-18
C158	VPWR	S#2	9.36027e-19
C159	VPWR	S#3	4.67513e-19
C160	a_114_74##3	A0#1	6.37871e-18
C161	S#9	a_114_74##5	1.65088e-17
C162	a_114_74##2	a_223_368#	2.0159e-17
C163	VGND#2	A1#3	5.65706e-18
C164	a_399_368##2	A0#2	5.00001e-19
C165	A0#2	a_223_368#	8.27789e-18
C166	A0#1	A1#4	5.02427e-17
C167	VPWR#2	VPWR#3	3.49564e-17
C168	Y#1	A0#2	3.58246e-18
C169	A0#3	A1#2	7.66855e-19
C170	a_114_74##7	VPWR#2	1.00803e-17
C171	a_225_74##2	a_114_74##2	7.43196e-17
C172	a_223_368##2	VPWR#2	1.79448e-17
C173	VGND#1	a_114_74##2	8.57569e-19
C174	VPWR#3	S#7	3.08102e-17
C175	a_399_368##2	VPWR#2	5.95168e-17
C176	Y	S#2	8.06041e-19
C177	a_114_74##7	S#7	5.73354e-17
C178	Y	A1#2	5.29766e-18
C179	VPWR#3	S#5	9.4636e-19
C180	a_223_368#	VPWR#2	4.57158e-19
C181	a_223_368##2	S#7	3.88276e-18
C182	VGND#2	VGND#3	3.43726e-17
C183	a_114_74##7	S#5	1.59249e-18
C184	VPWR#1	S#7	1.16882e-18
C185	VGND#2	a_114_74##6	6.7304e-18
C186	a_225_74#	A0#2	1.19192e-18
C187	a_399_368#	VPWR#2	6.87763e-17
C188	a_223_368##2	S#5	7.46129e-17
C189	S#6	S#1	4.35135e-18
C190	VGND#2	a_225_74##2	1.79908e-17
C191	VGND#2	S#2	7.72139e-19
C192	VPWR#1	S#5	4.61904e-17
C193	a_223_368#	S#7	1.24959e-19
C194	VGND#2	S#3	2.71111e-19
C195	a_223_368##2	a_114_74##3	7.13709e-18
C196	a_114_74##5	a_114_74##2	3.93666e-18
C197	VGND#2	A1#2	6.1905e-19
C198	VPWR#1	a_114_74##3	5.00283e-17
C199	a_114_74##2	A0#4	1.26612e-17
C200	S#1	a_114_74#	2.03107e-17
C201	a_223_368#	S#5	2.03333e-19
C202	a_223_368##2	A0#1	3.52028e-19
C203	A1#7	A1#2	1.49683e-17
C204	a_114_74##3	a_399_368##2	2.52074e-17
C205	VGND#2	a_225_74#	7.43609e-17
C206	S	S#3	1.76234e-17
C207	Y#1	S#5	1.41416e-19
C208	VPWR#1	A0#1	1.03336e-18
C209	a_114_74##5	A0#2	1.09336e-19
C210	a_223_368##2	A1#4	1.23179e-19
C211	a_223_368#	a_114_74##3	2.18563e-17
C212	A0#4	A0#2	1.35427e-17
C213	a_399_368##2	A0#1	1.0367e-17
C214	a_114_74#	A0#3	4.9529e-17
C215	VPWR#3	S#3	5.88004e-18
C216	Y#1	a_114_74##3	3.51824e-19
C217	VPWR#1	A1#4	9.02653e-20
C218	a_223_368#	A0#1	7.46049e-17
C219	a_399_368#	a_114_74##3	3.12702e-19
C220	a_399_368##2	A1#4	3.49079e-19
C221	VPWR#2	S#2	7.48225e-19
C222	A0#1	Y#1	2.78003e-17
C223	VPWR#2	S#3	1.44132e-19
C224	a_223_368#	A1#4	1.87437e-18
C225	A0#3	A1#3	5.41269e-18
C226	a_399_368#	A0#1	1.93584e-17
C227	A1#7	A0#2	7.64048e-19
C228	VGND#2	a_114_74##5	7.06987e-19
C229	VPWR#2	A1#2	1.07228e-19
C230	A1#4	Y#1	2.83486e-17
C231	a_399_368#	A1#4	6.07103e-17
C232	A1	A1#2	8.61261e-18
C233	A1#2	a_225_74#	6.87746e-18
C234	a_114_74##7	S#3	9.84882e-19
C235	VPWR#3	a_114_74##7	7.63374e-17
C236	S#9	S#5	1.27957e-20
C237	S#6	VGND#3	2.58368e-17
C238	a_114_74##5	S#7	1.97718e-18
C239	S#8	S#3	1.78011e-17
C240	a_114_74##6	S#6	4.01701e-17
C241	VPWR#3	VPWR#1	5.87781e-19
C242	VGND#3	S#1	1.24698e-18
C243	a_114_74##7	a_223_368##2	8.38893e-17
C244	A0	S#3	1.50664e-19
C245	a_223_368##2	S#2	3.91508e-18
C246	A0	A1#2	7.05684e-20
C247	a_225_74##2	S#6	2.8944e-18
C248	a_114_74##6	S#1	1.42756e-18
C249	a_114_74##5	S#5	3.35895e-18
C250	a_223_368##2	S#3	4.52035e-19
C251	VGND#3	a_114_74#	2.36509e-19
C252	VGND#1	S#6	3.98544e-19
C253	a_225_74##2	S#1	6.20882e-17
C254	a_223_368##2	VPWR#1	8.53651e-17
C255	a_114_74##5	a_114_74##3	1.46142e-19
C256	S#9	S#2	1.70183e-19
C257	S#1	VGND#1	2.38629e-17
C258	a_225_74##2	a_114_74#	2.80523e-17
C259	a_114_74#	VGND#1	2.0173e-17
C260	S#9	S#3	8.80885e-18
C261	a_114_74##5	A0#1	9.38425e-20
C262	a_223_368##2	a_223_368#	1.41504e-18
C263	VPWR#1	a_399_368##2	5.82936e-17
C264	a_225_74##2	A0#3	8.8532e-18
C265	VGND#3	VPWR#3	2.29677e-19
C266	VGND#1	A0#3	5.04893e-19
C267	a_223_368##2	Y#1	1.96916e-21
C268	a_223_368#	VPWR#1	8.33334e-18
C269	a_225_74##2	A1#3	1.26774e-18
C270	a_223_368#	a_399_368##2	1.03222e-16
C271	VGND#1	A1#3	2.60577e-19
C272	a_225_74#	a_114_74#	8.82634e-18
C273	A0#3	Y#2	2.19689e-17
C274	a_114_74##6	a_114_74##7	1.50906e-18
C275	S#3	S#5	2.76701e-18
C276	a_225_74#	A0#3	2.3548e-17
C277	A1#3	Y#2	1.1629e-17
C278	a_399_368##2	a_399_368#	1.58081e-18
C279	a_223_368#	Y#1	5.90794e-17
C280	a_225_74#	A1#3	3.75746e-17
C281	a_114_74##5	S#1	2.64988e-19
C282	a_399_368#	Y#1	1.0475e-16
C283	a_114_74##5	a_114_74#	1.89628e-19
C284	a_225_74##2	a_223_368#	5.71746e-18
C285	a_114_74##5	A0#3	1.12697e-19
C286	VGND#3	a_114_74##6	4.87542e-17
C287	VGND#3	a_225_74##2	1.82271e-18
C288	a_225_74#	a_223_368#	1.04943e-18
C289	VGND#3	VGND#1	6.26025e-19
C290	a_114_74##6	a_225_74##2	5.14564e-17
C291	a_225_74#	Y#1	3.0386e-19
C292	a_114_74##5	a_223_368##2	2.52588e-17
C293	Y#1	A1#2	3.41658e-18
C294	a_114_74##5	S#2	9.31804e-18
C295	a_225_74##2	VGND#1	1.01412e-16
C296	a_114_74##5	S#3	3.88257e-17
C297	VGND#3	S#8	2.4096e-17
*
*
.ENDS sky130_fd_sc_hs__mux2i_1
*
