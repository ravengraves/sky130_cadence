* Extracted by Quantus, converted by sky130cad/quantus.py
*
*
*
*                       LINUX           Wed Nov 18 08:42:38 2026
*
*
*
*  PROGRAM  advgen
*
*  Name           : advgen - Quantus - (64-bit)
*  Version        : 25.1.0-p047
*  Build Date     : Thu Dec 11 23:20:30 PST 2025
*
*  HSPICE LIBRARY
*
*  OPERATING_TEMPERATURE 150
*  QRC_TECH_DIR <path>/tech
*
*
*

*
.SUBCKT sky130_fd_sc_hs__maj3_2 VPB VNB VGND VPWR X A B C
*
*
*  caps2d version: 10
*
*
*       TRANSISTOR CARDS
*
*
XM6 VGND#5 a_87_264##4 X#3 VNB sky130_fd_pr__nfet_01v8_lvt l=0.15 w=0.74 ad=0.2109 as=0.2072 pd=2.05 ps=2.04
XM13 X#3 a_87_264##5 VGND#7 VNB sky130_fd_pr__nfet_01v8_lvt l=0.15 w=0.74 ad=0.2072 as=0.6623 pd=2.04 ps=3.27
XM7 VGND#7 A#6 a_413_74# VNB sky130_fd_pr__nfet_01v8_lvt l=0.15 w=0.74 ad=0.6623 as=0.1776 pd=3.27 ps=1.96
XM3 a_413_74# B#5 a_87_264##13 VNB sky130_fd_pr__nfet_01v8_lvt l=0.15 w=0.74 ad=0.1776 as=0.2072 pd=1.96 ps=2.04
XM1 a_87_264##13 B#6 a_577_74# VNB sky130_fd_pr__nfet_01v8_lvt l=0.15 w=0.74 ad=0.2072 as=0.2442 pd=2.04 ps=2.14
XM11 a_577_74# C#3 VGND#6 VNB sky130_fd_pr__nfet_01v8_lvt l=0.15 w=0.74 ad=0.2442 as=0.333 pd=2.14 ps=2.38
XM8 VGND#6 A#1 a_793_74# VNB sky130_fd_pr__nfet_01v8_lvt l=0.15 w=0.74 ad=0.333 as=0.1776 pd=2.38 ps=1.96
XM4 a_793_74# C#6 a_87_264##14 VNB sky130_fd_pr__nfet_01v8_lvt l=0.15 w=0.74 ad=0.1776 as=0.2109 pd=1.96 ps=2.05
XM5 X#1 a_87_264##6 VPWR#5 VPB sky130_fd_pr__pfet_01v8 l=0.15 w=1.12 ad=0.336 as=0.3304 pd=2.84 ps=2.83
XM14 VPWR#7 a_87_264# X#1 VPB sky130_fd_pr__pfet_01v8 l=0.15 w=1.12 ad=0.8064 as=0.336 pd=3.77 ps=2.84
XM15 VPWR#7 A#3 a_393_368# VPB sky130_fd_pr__pfet_01v8 l=0.15 w=1 ad=0.8064 as=0.373375 pd=3.77 ps=2.92
XM0 a_393_368# B#7 a_87_264##11 VPB sky130_fd_pr__pfet_01v8 l=0.15 w=1 ad=0.373375 as=0.3 pd=2.92 ps=2.6
XM10 a_87_264##11 B#1 a_584_347# VPB sky130_fd_pr__pfet_01v8 l=0.15 w=1 ad=0.3 as=0.31 pd=2.6 ps=2.62
XM12 a_584_347# C#1 VPWR#6 VPB sky130_fd_pr__pfet_01v8 l=0.15 w=1 ad=0.31 as=0.4368 pd=2.62 ps=3.05
XM2 VPWR#6 A#2 a_790_368# VPB sky130_fd_pr__pfet_01v8 l=0.15 w=1 ad=0.4368 as=0.27 pd=3.05 ps=2.54
XM9 a_790_368# C#4 a_87_264##7 VPB sky130_fd_pr__pfet_01v8 l=0.15 w=1 ad=0.27 as=0.295 pd=2.54 ps=2.59
*
*
*       RESISTOR AND CAP/DIODE CARDS
*
Rg1	a_87_264#	a_87_264##2	441.658081
Rg2	a_87_264##2	a_87_264##3	81.860123
Rg3	a_87_264##3	a_87_264##4	380.339874
Rg4	a_87_264##2	a_87_264##5	359.443329
Rg5	a_87_264##3	a_87_264##6	462.979767
Rg6	B#1	B#2	416.835754
Rg7	B#2	B#3	22.722054
Rg8	B#3	B#4	30.613651
Rg9	B#4	B#5	337.300201
Rg10	B#2	B#6	338.168213
Rg11	B#4	B#7	415.223511
Rg12	C#1	C#2	400.207520
Rg13	C#2	C#3	322.284241
Rg14	A#1	A#2	901.461060
Rg15	A#2	A#3	1900.636475
Rg16	A#3	A#4	442.543427
Rg17	A#4	A#5	47.363594
Rg18	A#4	A#6	392.465759
Rg19	C#4	C#5	422.415131
Rg20	C#5	C#6	353.846649
Rf1	X	X#2	0.181173
Rf2	X#2	X	13.225628
Rf3	X	X#3	87.171745
Rf4	X#1	X#2	5.000000
Rf5	A#7	A	0.882458
Rf6	A#5	A#9	161.115265
Rf7	A#7	A#9	3.543054
Rf8	B	B#3	85.186874
Rf9	C#5	C#8	198.197983
Rf10	C#8	C	6.935383
Rf11	a_87_264##7	a_87_264##8	142.732986
Rf12	a_87_264##8	a_87_264##9	8.165758
Rf13	a_87_264##9	a_87_264##2	236.311371
Rf14	a_87_264##8	a_87_264##11	13.152990
Rf15	a_87_264##9	a_87_264##12	69.282181
Rf16	a_87_264##12	a_87_264##13	12.647680
Rf17	a_87_264##12	a_87_264##14	144.166733
Rf19	VGND#2	VGND#3	86.867325
Rf20	VGND#3	VGND#4	70.563454
Rf21	VGND#4	VGND#5	127.176811
Rf22	VGND#2	VGND#6	27.696468
Rf23	VGND#4	VGND#7	14.695254
Rf25	VPWR#2	VPWR#3	91.288589
Rf26	VPWR#3	VPWR#4	70.721878
Rf27	VPWR#4	VPWR#5	134.190903
Rf28	VPWR#2	VPWR#6	35.077789
Rf29	VPWR#4	VPWR#8	13.392073
Rf30	VPWR#8	VPWR#7	8.411336
Rf31	VPWR#7	VPWR#8	7.500000
Rf35	C#2	C#8	160.232803
Re1	VPWR#3	VPWR	0.982218
Re2	VGND	VGND#3	0.982254
*
*       CAPACITOR CARDS
*
*
C1	B#6	a_87_264##13	1.4937e-17
C2	VGND	VNB	6.58207e-17
C3	VPWR	VNB	5.7082e-17
C4	X	VNB	1.082e-17
C5	A	VNB	2.87297e-18
C6	B	VNB	1.86804e-18
C7	VGND	X	6.9076e-19
C8	C	VNB	7.60651e-18
C9	VGND	A	3.14256e-18
C10	VPWR	X	1.80401e-17
C11	VGND#6	B#5	3.50244e-19
C12	VPWR#6	VPWR#7	5.53779e-22
C13	a_87_264##12	B#5	3.88948e-17
C14	VGND	C	4.88353e-18
C15	VPWR	B	4.25171e-18
C16	VPWR	C	4.40142e-18
C17	a_87_264##2	VNB	3.54857e-17
C18	A#5	VNB	5.0724e-17
C19	B#3	VNB	9.31999e-22
C20	C#2	VNB	3.09901e-17
C21	C#5	VNB	7.25762e-17
C22	VGND#3	VNB	2.27999e-16
C23	VPWR#3	VNB	2.25811e-16
C24	a_87_264##6	VNB	4.08603e-17
C25	VGND	a_87_264##2	6.52995e-18
C26	a_87_264#	VNB	3.8749e-17
C27	VGND#5	VPWR#5	1.03343e-17
C28	A#3	VNB	9.20079e-17
C29	VGND	A#5	3.68521e-19
C30	B#7	VNB	2.3389e-17
C31	B	C	2.02722e-17
C32	VGND	B#3	4.8856e-18
C33	B#1	VNB	2.14088e-17
C34	C#1	VNB	2.20612e-17
C35	A#2	VNB	1.01244e-16
C36	VGND	C#5	3.41807e-18
C37	C#4	VNB	4.12467e-17
C38	VGND	VGND#3	1.92545e-17
C39	a_87_264##4	VNB	3.45088e-17
C40	VPWR	a_87_264##2	4.72483e-18
C41	a_87_264##5	VNB	3.21545e-17
C42	A#6	VNB	2.81417e-17
C43	B#5	VNB	2.81571e-17
C44	B#6	VNB	2.4374e-17
C45	VGND#6	B#6	4.05522e-18
C46	C#3	VNB	2.46715e-17
C47	A#1	VNB	3.45307e-17
C48	C#6	VNB	3.02971e-17
C49	a_87_264##8	a_393_368#	4.86496e-18
C50	VPWR#5	VNB	8.17241e-17
C51	VPWR	C#5	3.17808e-18
C52	X	a_87_264##2	4.86359e-17
C53	VPWR#7	VNB	7.49394e-18
C54	B	a_393_368#	1.85165e-19
C55	a_87_264##11	VNB	7.20449e-19
C56	VPWR	VPWR#3	2.72817e-17
C57	a_87_264##12	B#4	7.65775e-18
C58	VPWR#6	VNB	4.99352e-18
C59	B	a_584_347#	3.20751e-19
C60	VPWR	a_87_264##6	4.06141e-18
C61	a_87_264##7	VNB	5.40728e-17
C62	VGND#5	VNB	6.95625e-17
C63	VGND	a_87_264##4	4.53631e-18
C64	a_87_264##2	A	4.39649e-18
C65	X#3	VNB	9.58613e-18
C66	VPWR	a_87_264#	2.92415e-18
C67	VGND	a_87_264##5	1.18304e-18
C68	VGND#7	VNB	5.1912e-17
C69	A	A#5	1.07016e-17
C70	VGND	A#6	2.22826e-18
C71	VPWR	A#3	1.32268e-17
C72	VGND	B#5	5.93043e-19
C73	C	a_584_347#	2.62778e-19
C74	VPWR	B#7	4.38359e-18
C75	VGND	B#6	1.68003e-19
C76	VGND#6	VNB	1.12353e-18
C77	VPWR#4	a_87_264##3	2.05092e-20
C78	VPWR	B#1	4.70463e-18
C79	VGND	C#3	4.69961e-19
C80	a_87_264##14	VNB	4.13418e-17
C81	a_87_264##11	VPWR#6	1.54795e-17
C82	a_87_264##3	VNB	3.8748e-17
C83	VGND	A#1	4.39041e-19
C84	VPWR	C#1	4.38252e-18
C85	VGND	C#6	1.82124e-18
C86	B#4	VNB	4.30497e-17
C87	VPWR	A#2	1.65242e-17
C88	X	a_87_264##6	2.11886e-17
C89	VGND	VPWR#5	4.09786e-18
C90	B	A#5	1.55596e-18
C91	VPWR	C#4	9.28394e-18
C92	X	a_87_264#	2.1111e-17
C93	VGND#6	C#3	3.71704e-17
C94	X	A#3	1.30475e-18
C95	X	B#7	1.4151e-19
C96	B	C#2	9.13457e-19
C97	a_87_264##8	VPWR#4	1.83276e-19
C98	VGND	a_87_264##7	4.60073e-18
C99	B#3	C	1.8029e-17
C100	VGND	VGND#5	3.21764e-17
C101	a_87_264##14	B#6	1.99545e-19
C102	VGND	X#3	1.67589e-17
C103	VGND	VGND#7	7.98851e-17
C104	C	C#2	2.28429e-17
C105	a_87_264##8	a_87_264#	4.84511e-19
C106	VPWR	VPWR#5	3.45753e-17
C107	C	C#5	3.65369e-19
C108	VGND	VGND#6	2.87074e-17
C109	VPWR	VPWR#7	4.16358e-17
C110	VGND	a_87_264##14	2.36187e-17
C111	VPWR	a_87_264##11	2.60332e-17
C112	B	A#3	1.03852e-18
C113	VGND#6	A#1	3.80118e-17
C114	a_87_264##12	B#6	4.13292e-17
C115	B	B#7	4.93974e-18
C116	VPWR	a_87_264##7	2.10292e-17
C117	B	B#1	4.55117e-18
C118	A	a_87_264##4	4.30839e-19
C119	B#3	a_577_74#	4.74225e-19
C120	VPWR#5	X	6.51124e-17
C121	A	a_87_264##5	1.56022e-18
C122	B	C#1	1.83613e-18
C123	a_87_264##11	a_87_264##7	1.39339e-18
C124	a_87_264##14	C#3	4.18946e-19
C125	X	X#1	4.90344e-19
C126	X	VPWR#7	4.08446e-17
C127	VPWR#4	a_87_264##6	2.52624e-18
C128	C	B#1	1.90962e-18
C129	C	C#1	5.4329e-18
C130	C	A#2	1.19041e-17
C131	VGND#6	C#6	6.05409e-18
C132	a_87_264##8	a_584_347#	6.17708e-18
C133	C	C#4	1.02698e-18
C134	X#3	X	3.16284e-18
C135	a_87_264##14	A#1	2.29274e-17
C136	X	a_87_264##3	1.31192e-17
C137	a_87_264##2	A#5	3.24219e-17
C138	a_87_264##7	VPWR#6	4.07481e-17
C139	X#3	A	3.73624e-18
C140	VGND#7	A	3.48601e-17
C141	C	A#1	8.19447e-18
C142	B	a_87_264##11	2.99788e-19
C143	A#9	VNB	3.47794e-18
C144	a_87_264##14	C#6	4.55711e-17
C145	a_87_264##8	A#3	2.20064e-17
C146	a_87_264##8	VNB	1.54791e-18
C147	a_87_264##12	VNB	5.03252e-18
C148	B#3	A#5	2.90068e-18
C149	A#3	a_393_368#	2.26597e-17
C150	VPWR#4	VNB	4.47807e-17
C151	A#6	a_413_74#	1.30639e-17
C152	A	a_87_264##3	9.5318e-20
C153	a_87_264##12	C#3	2.26275e-17
C154	B#7	a_393_368#	1.86793e-17
C155	B#5	a_413_74#	1.24371e-17
C156	B#3	C#2	3.1439e-18
C157	A#9	a_87_264##12	7.06555e-18
C158	C	VPWR#6	8.41711e-19
C159	VPWR#4	a_87_264#	6.76419e-18
C160	C	a_87_264##7	2.57668e-17
C161	B#1	a_584_347#	2.46707e-17
C162	a_87_264##12	A#3	1.74837e-19
C163	VPWR#3	A#5	1.89417e-19
C164	B#6	a_577_74#	1.96901e-17
C165	C#1	a_584_347#	2.46725e-17
C166	a_87_264##2	a_87_264##6	4.7468e-19
C167	C#3	a_577_74#	1.96901e-17
C168	B	B#4	1.12864e-17
C169	a_87_264##2	a_87_264#	5.13662e-18
C170	C	VGND#6	1.8969e-18
C171	a_87_264##2	A#3	6.37215e-19
C172	A#2	a_790_368#	2.3859e-17
C173	a_87_264##14	C	3.26533e-17
C174	A#1	a_793_74#	1.6058e-17
C175	C#4	a_790_368#	2.4664e-17
C176	X#3	a_87_264##12	3.59897e-18
C177	A#5	A#3	1.51866e-19
C178	a_87_264##3	X#1	1.10031e-19
C179	C#6	a_793_74#	1.67661e-17
C180	VGND#7	a_87_264##8	9.07592e-20
C181	C	B#4	5.24611e-18
C182	a_87_264##8	B#7	1.65851e-17
C183	VGND	a_87_264##8	1.43467e-18
C184	A#5	B#7	2.94527e-18
C185	VGND	a_87_264##12	3.85737e-17
C186	a_87_264##12	A#1	5.64776e-19
C187	VGND#5	X#3	7.52942e-17
C188	VPWR#4	A#3	8.20865e-18
C189	a_87_264##11	a_393_368#	6.08707e-18
C190	VGND#5	VGND#7	2.86754e-18
C191	C#2	A#2	1.1742e-17
C192	VPWR#3	A#3	2.27326e-17
C193	a_87_264##5	A#5	4.00167e-19
C194	VPWR#3	B#7	3.36534e-18
C195	VPWR	A#9	2.69182e-18
C196	a_87_264##6	a_87_264#	4.69848e-17
C197	C#5	A#2	1.90462e-17
C198	VGND#7	a_87_264##12	7.74698e-17
C199	a_87_264##2	A#9	2.61946e-17
C200	a_87_264##8	B#1	1.66759e-17
C201	A#5	B#5	6.19233e-19
C202	VPWR#3	B#1	3.61961e-18
C203	VGND#7	X#3	7.54349e-17
C204	VPWR	a_87_264##8	9.83537e-18
C205	a_87_264#	A#3	9.57012e-18
C206	a_87_264##12	C#6	2.87893e-19
C207	VPWR	VPWR#4	4.05958e-17
C208	a_87_264##14	a_793_74#	3.54916e-18
C209	VPWR#3	A#2	3.12139e-18
C210	a_87_264##2	VPWR#7	4.21218e-17
C211	a_87_264##7	a_790_368#	5.27805e-18
C212	a_87_264##2	a_87_264##8	4.73833e-18
C213	A#3	B#7	5.45106e-17
C214	B#1	A#3	1.5087e-17
C215	VPWR#7	A#5	1.784e-18
C216	VGND#3	A#6	1.49969e-18
C217	C#2	A#1	1.4487e-17
C218	B#7	B#1	4.13399e-17
C219	VGND#3	B#5	5.31202e-18
C220	A#9	A#5	9.99581e-18
C221	a_87_264##8	C#1	2.39401e-17
C222	X	a_87_264##8	2.34278e-18
C223	VGND#3	B#6	5.45667e-18
C224	A#3	A#2	1.27166e-19
C225	C#5	A#1	1.80234e-17
C226	a_87_264##14	a_87_264##7	4.90788e-18
C227	B#1	C#1	4.43105e-17
C228	X	VPWR#4	1.67156e-17
C229	X#3	a_87_264##2	1.94268e-17
C230	B#1	A#2	8.81135e-18
C231	a_87_264##2	VGND#7	2.77854e-17
C232	a_87_264##2	VPWR#4	2.79356e-19
C233	a_87_264##8	A#5	1.05387e-17
C234	C#1	A#2	4.85572e-17
C235	VGND#7	VGND#6	6.29528e-19
C236	X#3	A#5	9.71908e-19
C237	A#5	VGND#7	1.13825e-17
C238	VPWR#6	C#2	8.69486e-19
C239	VPWR#3	VPWR#5	2.62279e-17
C240	a_87_264##12	A#5	5.53319e-18
C241	A#2	C#4	6.08813e-17
C242	a_87_264##12	a_87_264##13	6.27501e-19
C243	a_87_264##8	A#2	3.4984e-18
C244	a_87_264##3	a_87_264##2	3.6739e-18
C245	A	a_87_264##12	2.01084e-17
C246	X#3	a_87_264##3	1.10631e-17
C247	B#3	a_87_264##13	3.00342e-18
C248	C#5	a_87_264##7	4.90733e-17
C249	VPWR#5	a_87_264##6	3.23395e-17
C250	a_87_264##11	VPWR#3	1.56234e-17
C251	X#1	a_87_264##6	3.60701e-17
C252	VPWR#4	A#5	2.56314e-20
C253	a_87_264##8	VPWR#7	2.64057e-17
C254	a_87_264##8	B#3	5.7661e-18
C255	VGND#7	a_87_264##3	5.35053e-20
C256	VPWR#5	a_87_264#	1.25964e-18
C257	a_87_264##12	A#2	3.31719e-19
C258	VPWR#7	a_87_264##6	1.06653e-18
C259	A#5	B#4	2.77139e-17
C260	X#1	a_87_264#	4.01464e-17
C261	VGND#3	VGND#5	2.61962e-17
C262	VPWR#5	VPWR#4	1.27237e-18
C263	VPWR#5	A#3	2.36195e-19
C264	VGND#6	C#2	6.09365e-19
C265	a_87_264##12	B#3	8.58351e-17
C266	a_87_264#	VPWR#7	4.23582e-17
C267	VGND#3	VGND#7	6.16701e-17
C268	a_87_264##8	C#4	1.33907e-19
C269	a_87_264##8	B	9.43439e-17
C270	B#3	B#4	1.92135e-17
C271	A#3	VPWR#7	4.30211e-17
C272	a_87_264##4	a_87_264##5	3.89036e-17
C273	VPWR#7	B#7	2.70417e-18
C274	a_87_264##12	a_87_264##8	7.83827e-18
C275	C#5	a_87_264##14	5.85516e-17
C276	B#4	C#2	2.80025e-17
C277	a_87_264##11	A#3	2.61974e-17
C278	a_87_264##8	C#2	7.01267e-19
C279	a_87_264##5	A#6	3.9209e-18
C280	a_87_264##14	VGND#6	3.59596e-17
C281	VPWR#7	B#1	9.13841e-19
C282	a_87_264##11	B#7	5.1178e-17
C283	VPWR#6	A#3	1.71644e-18
C284	a_87_264##12	C#2	1.70917e-18
C285	VPWR#7	C#1	5.98366e-19
C286	A#6	B#5	4.55811e-17
C287	a_87_264##11	B#1	4.47751e-17
C288	a_87_264##12	VGND#6	2.69227e-17
C289	C	a_87_264##8	3.75008e-17
C290	VPWR#6	B#7	8.15464e-19
C291	a_87_264##12	C	3.41172e-17
C292	VGND#3	B#4	1.40448e-19
C293	VPWR#7	A#2	1.25883e-18
C294	a_87_264##11	C#1	3.67059e-18
C295	VPWR#6	B#1	3.40305e-18
C296	a_87_264##7	B#7	2.64567e-19
C297	B#5	B#6	3.76006e-17
C298	a_87_264##8	a_87_264##11	7.57224e-19
C299	VPWR#3	B#4	2.88149e-19
C300	a_87_264##11	A#2	1.91507e-18
C301	C#1	VPWR#6	2.79932e-17
C302	a_87_264##7	B#1	5.42145e-19
C303	a_87_264##11	C#4	2.33508e-19
C304	B#6	C#3	3.10128e-17
C305	VPWR#6	A#2	5.08309e-17
C306	a_87_264##7	C#1	6.14432e-19
C307	VPWR#6	C#4	7.739e-18
C308	a_87_264##7	A#2	3.10119e-17
C309	C#3	A#1	1.91162e-17
C310	a_87_264##7	C#4	5.91869e-17
C311	A#1	C#6	5.19411e-17
C312	VGND#3	a_87_264##12	3.30749e-17
C313	B#4	A#3	4.41177e-19
C314	a_87_264##12	a_87_264##14	1.78937e-18
C315	a_87_264##12	a_413_74#	2.28256e-18
C316	VGND#5	a_87_264##4	2.67462e-17
C317	a_87_264##8	VPWR#6	1.31958e-17
C318	a_87_264##8	VPWR#3	7.14971e-19
C319	X#3	a_87_264##4	3.95183e-17
C320	a_87_264##12	a_87_264##5	7.48516e-19
C321	VGND#5	a_87_264##5	1.3865e-18
C322	VGND#7	a_87_264##4	3.47555e-18
C323	VPWR#5	X#1	4.23606e-17
C324	X#3	a_87_264##5	4.81519e-17
C325	a_87_264##14	A#2	1.10292e-19
C326	a_87_264##11	VPWR#4	1.97587e-18
C327	VGND#5	A#6	1.50788e-19
C328	VPWR#5	VPWR#7	1.50149e-18
C329	a_87_264##5	VGND#7	4.04492e-17
C330	a_87_264##12	a_577_74#	8.95139e-18
C331	X#3	A#6	8.01462e-19
C332	X#1	VPWR#7	4.47272e-17
C333	A#6	VGND#7	2.91974e-17
C334	a_87_264##12	A#6	2.34814e-17
C335	VPWR#3	VPWR#4	6.03149e-17
C336	VGND#7	B#5	6.94747e-19
C337	A#9	a_87_264##8	2.8984e-17
C338	a_87_264##8	B#4	3.08698e-18
C339	VGND#7	B#6	3.682e-19
C340	VPWR#7	a_87_264##11	5.23703e-17
C341	B#5	a_87_264##13	1.4937e-17
C342	VGND#6	A#6	3.9255e-19
C343	VGND#7	C#3	2.1251e-19
C344	VGND#2	a_87_264##12	3.41134e-18
C345	VPWR#2	C#1	4.07936e-18
C346	VGND#7	VGND#2	1.7654e-19
C347	VGND#3	VGND#2	8.04845e-17
C348	VPWR#2	A#2	4.48276e-17
C349	VPWR#2	VNB	6.01427e-17
C350	VGND#2	C#5	1.14951e-19
C351	VPWR#2	C#4	5.11186e-18
C352	VPWR	VPWR#2	7.74844e-17
C353	VPWR#2	C#5	1.20789e-19
C354	a_87_264##7	VPWR#2	1.59972e-17
C355	VGND#2	C#6	7.07627e-18
C356	a_87_264##8	VPWR#2	2.37739e-18
C357	VGND#2	A#1	3.73099e-18
C358	VGND#2	C#3	3.686e-18
C359	VPWR#3	VPWR#2	7.64027e-17
C360	VGND#2	B#4	2.55192e-19
C361	VGND	VGND#2	5.25768e-17
C362	VGND#2	VNB	7.21353e-17
C363	VGND#2	a_87_264##14	2.39736e-17
*
*
.ENDS sky130_fd_sc_hs__maj3_2
*
