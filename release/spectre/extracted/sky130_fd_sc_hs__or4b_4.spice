* Extracted by Quantus, converted by sky130cad/quantus.py
*
*
*
*                       LINUX           Wed Nov 18 09:08:00 2026
*
*
*
*  PROGRAM  advgen
*
*  Name           : advgen - Quantus - (64-bit)
*  Version        : 25.1.0-p047
*  Build Date     : Thu Dec 11 23:20:30 PST 2025
*
*  HSPICE LIBRARY
*
*  OPERATING_TEMPERATURE 150
*  QRC_TECH_DIR <path>/tech
*
*
*

*
.SUBCKT sky130_fd_sc_hs__or4b_4 VNB VPB VGND C VPWR X B D_N A
*
*
*  caps2d version: 10
*
*
*       TRANSISTOR CARDS
*
*
XM19 a_27_74##18 B#3 VGND#12 VNB sky130_fd_pr__nfet_01v8_lvt l=0.15 w=0.74 ad=0.2109 as=0.3108 pd=2.05 ps=2.32
XM7 VGND#12 A#3 a_27_74##16 VNB sky130_fd_pr__nfet_01v8_lvt l=0.15 w=0.74 ad=0.3108 as=0.8177 pd=2.32 ps=3.69
XM6 a_27_74##16 C#3 VGND#11 VNB sky130_fd_pr__nfet_01v8_lvt l=0.15 w=0.74 ad=0.8177 as=0.3108 pd=3.69 ps=2.32
XM17 VGND#11 a_563_48##4 a_27_74##14 VNB sky130_fd_pr__nfet_01v8_lvt l=0.15 w=0.74 ad=0.3108 as=0.2109 pd=2.32 ps=2.05
XM1 a_563_48##7 D_N#3 VGND#10 VNB sky130_fd_pr__nfet_01v8_lvt l=0.15 w=0.64 ad=0.32135 as=0.27 pd=2.98 ps=2.23
XM14 X#2 a_27_74##6 VGND#10 VNB sky130_fd_pr__nfet_01v8_lvt l=0.15 w=0.74 ad=0.2997 as=0.27 pd=2.29 ps=2.23
XM21 VGND#9 a_27_74##10 X#2 VNB sky130_fd_pr__nfet_01v8_lvt l=0.15 w=0.74 ad=0.259 as=0.2997 pd=2.18 ps=2.29
XM3 VGND#9 a_27_74##8 X#5 VNB sky130_fd_pr__nfet_01v8_lvt l=0.15 w=0.74 ad=0.259 as=0.2072 pd=2.18 ps=2.04
XM4 X#5 a_27_74# VGND#1 VNB sky130_fd_pr__nfet_01v8_lvt l=0.15 w=0.74 ad=0.2072 as=0.2109 pd=2.04 ps=2.05
XM8 a_27_392# B#1 a_116_392##2 VPB sky130_fd_pr__pfet_01v8 l=0.15 w=1 ad=0.295 as=0.3 pd=2.59 ps=2.6
XM10 VPWR#10 A#4 a_116_392##2 VPB sky130_fd_pr__pfet_01v8 l=0.15 w=1 ad=0.3 as=0.3 pd=2.6 ps=2.6
XM20 a_116_392# A#1 VPWR#10 VPB sky130_fd_pr__pfet_01v8 l=0.15 w=1 ad=0.35 as=0.3 pd=2.7 ps=2.6
XM13 a_116_392# B#4 a_27_392##2 VPB sky130_fd_pr__pfet_01v8 l=0.15 w=1 ad=0.35 as=0.35 pd=2.7 ps=2.7
XM15 a_27_392##2 C#1 a_496_392##2 VPB sky130_fd_pr__pfet_01v8 l=0.15 w=1 ad=0.35 as=0.35 pd=2.7 ps=2.7
XM12 a_27_74##19 a_563_48##6 a_496_392##2 VPB sky130_fd_pr__pfet_01v8 l=0.15 w=1 ad=0.3 as=0.35 pd=2.6 ps=2.7
XM2 a_496_392# a_563_48##5 a_27_74##19 VPB sky130_fd_pr__pfet_01v8 l=0.15 w=1 ad=0.3 as=0.3 pd=2.6 ps=2.6
XM5 a_496_392# C#5 a_27_392##4 VPB sky130_fd_pr__pfet_01v8 l=0.15 w=1 ad=0.3 as=0.295 pd=2.6 ps=2.59
XM16 a_563_48##9 D_N#1 VPWR#9 VPB sky130_fd_pr__pfet_01v8 l=0.15 w=1 ad=0.295 as=0.4204 pd=2.59 ps=3.01
XM18 VPWR#9 a_27_74##12 X#3 VPB sky130_fd_pr__pfet_01v8 l=0.15 w=1.12 ad=0.4204 as=0.336 pd=3.01 ps=2.84
XM9 X#3 a_27_74##11 VPWR#8 VPB sky130_fd_pr__pfet_01v8 l=0.15 w=1.12 ad=0.336 as=0.336 pd=2.84 ps=2.84
XM11 X#4 a_27_74##9 VPWR#8 VPB sky130_fd_pr__pfet_01v8 l=0.15 w=1.12 ad=0.336 as=0.336 pd=2.84 ps=2.84
XM0 VPWR#1 a_27_74##7 X#4 VPB sky130_fd_pr__pfet_01v8 l=0.15 w=1.12 ad=0.3248 as=0.336 pd=2.82 ps=2.84
*
*
*       RESISTOR AND CAP/DIODE CARDS
*
Rg1	B#1	B#2	509.830780
Rg2	B#2	B#3	307.937683
Rg3	A#1	A#2	438.772827
Rg4	A#2	A#3	453.364960
Rg5	A#2	A#4	436.062531
Rg6	B#4	B#5	509.830780
Rg7	C#1	C#2	511.579926
Rg8	C#2	C#3	440.886749
Rg9	a_563_48#	a_563_48##2	609.362854
Rg10	a_563_48##2	a_563_48##3	65.513748
Rg11	a_563_48##3	a_563_48##4	466.419159
Rg12	a_563_48##2	a_563_48##5	410.569672
Rg13	a_563_48##3	a_563_48##6	415.223511
Rg14	C#4	C#5	560.348511
Rg15	D_N#1	D_N#2	449.596100
Rg16	D_N#2	D_N#3	271.212860
Rg17	a_27_74#	a_27_74##2	429.203064
Rg18	a_27_74##2	a_27_74##3	65.657387
Rg19	a_27_74##3	a_27_74##4	105.417610
Rg20	a_27_74##4	a_27_74##5	45.668800
Rg21	a_27_74##5	a_27_74##6	420.584869
Rg22	a_27_74##2	a_27_74##7	518.505249
Rg23	a_27_74##3	a_27_74##8	410.074219
Rg24	a_27_74##3	a_27_74##9	441.636597
Rg25	a_27_74##4	a_27_74##10	354.816742
Rg26	a_27_74##4	a_27_74##11	437.456635
Rg27	a_27_74##5	a_27_74##12	393.081268
Rf1	A#2	A	162.201172
Rf2	a_116_392#	a_116_392##2	101.881073
Rf3	B#5	B	248.934143
Rf4	B	B#7	5.679396
Rf5	B#7	B	8.668551
Rf6	C#6	C#2	161.469666
Rf7	C	C#9	11.014644
Rf8	C#6	C#9	5.092223
Rf9	a_496_392#	a_496_392##2	71.395279
Rf10	a_27_392#	a_27_392##3	164.009262
Rf11	a_27_392##3	a_27_392##4	129.255432
Rf12	a_27_392##2	a_27_392##3	5.000000
Rf13	C#10	C#11	0.984182
Rf14	C#4	C#13	161.216980
Rf15	C#10	C#13	1.968364
Rf16	a_563_48##7	a_563_48#	191.648422
Rf17	a_563_48##9	a_563_48##2	261.398804
Rf18	D_N	D_N#4	1.588424
Rf19	D_N#5	D_N#2	161.821228
Rf20	D_N#4	D_N#5	3.176847
Rf21	a_27_74##4	a_27_74##15	250.268661
Rf22	a_27_74##15	a_27_74##17	82.156845
Rf23	a_27_74##17	a_27_74##18	88.014877
Rf24	a_27_74##15	a_27_74##19	95.952812
Rf25	a_27_74##14	a_27_74##15	7.500000
Rf26	a_27_74##16	a_27_74##17	2.500000
Rf27	X	X#1	43.700375
Rf28	X#1	X#2	77.580963
Rf29	X	X#3	55.502209
Rf30	X	X#4	24.218163
Rf31	X#1	X#5	24.129911
Rf32	VPWR#1	VPWR#2	35.961449
Rf33	VPWR#2	VPWR#3	69.738693
Rf34	VPWR#3	VPWR#4	68.675751
Rf35	VPWR#4	VPWR#5	126.044922
Rf36	VPWR#5	VPWR#6	159.225540
Rf38	VPWR#3	VPWR#8	32.518913
Rf39	VPWR#4	VPWR#9	48.259808
Rf40	VPWR#6	VPWR#10	32.342297
Rf41	VGND#1	VGND#2	36.772179
Rf42	VGND#2	VGND#3	72.331985
Rf43	VGND#3	VGND#4	73.001427
Rf44	VGND#4	VGND#5	119.047775
Rf45	VGND#5	VGND#6	59.315514
Rf46	VGND#6	VGND#7	129.054199
Rf48	VGND#3	VGND#9	34.507496
Rf49	VGND#4	VGND#10	33.326477
Rf50	VGND#6	VGND#11	30.809536
Rf51	VGND#7	VGND#12	31.948624
Rf54	B#2	B#7	160.232803
Re1	C#11	C	12.051637
Re3	VPWR#2	VPWR	11.068454
Re4	VPWR	VPWR#5	0.790604
Re5	VGND#2	VGND	11.068454
Re6	VGND	VGND#5	0.790604
*
*       CAPACITOR CARDS
*
*
C1	C#13	a_563_48##3	1.61346e-19
C2	VGND#10	a_27_74##10	1.28222e-18
C3	VGND#10	VGND#3	4.81949e-20
C4	a_27_74##6	X#2	2.42013e-17
C5	VGND#4	a_563_48##7	2.24541e-17
C6	a_27_392##4	a_496_392#	7.60611e-17
C7	a_27_74##19	a_563_48##9	1.98104e-18
C8	VPWR#4	a_563_48##5	5.45308e-20
C9	VPWR#9	a_27_74##5	3.10714e-18
C10	VGND#10	a_27_74##6	3.87046e-17
C11	VGND#6	a_27_74##14	4.18807e-18
C12	X#1	VGND#1	2.09474e-17
C13	X#2	D_N#3	9.08671e-19
C14	a_27_74##18	a_27_392#	2.17393e-19
C15	a_27_392##4	a_27_74##19	1.76625e-17
C16	a_563_48##7	a_27_74##6	6.76809e-19
C17	D_N#3	VGND#10	1.72207e-17
C18	VPWR#4	a_563_48##6	4.78293e-20
C19	a_496_392#	a_27_74##19	4.18138e-19
C20	X#1	X#5	1.65623e-19
C21	C#10	a_563_48##3	3.5599e-20
C22	a_27_74##14	a_27_74##6	4.64624e-19
C23	a_563_48##2	a_27_74##5	5.33046e-19
C24	D_N#3	a_563_48##7	1.74279e-17
C25	a_27_74##5	a_27_74##11	1.13983e-18
C26	VGND#10	a_563_48##4	6.98629e-19
C27	a_27_392##2	a_27_392##4	1.85824e-18
C28	a_563_48##9	a_27_74##5	1.1583e-18
C29	a_27_74##14	D_N#3	8.82475e-19
C30	a_563_48##3	a_563_48##2	4.75286e-18
C31	a_27_74##11	a_27_74##3	1.12419e-18
C32	X#1	VGND#9	1.93921e-17
C33	VGND#6	a_27_74##16	2.7922e-17
C34	a_496_392##2	a_27_74##19	3.91056e-19
C35	a_27_392##2	a_496_392#	1.13299e-18
C36	a_563_48##9	a_27_74##3	3.18531e-19
C37	a_27_74##14	a_563_48##4	5.21865e-17
C38	a_27_392##2	a_27_74##19	3.35977e-17
C39	X#2	X#1	2.10373e-19
C40	a_563_48##4	VGND#11	1.96402e-17
C41	a_563_48##9	a_27_74##2	1.21795e-19
C42	VGND#12	VGND#6	1.43771e-20
C43	a_27_74##14	C#3	3.29221e-18
C44	a_27_392##2	a_496_392##2	8.31168e-17
C45	a_27_74##16	a_563_48##4	4.32843e-19
C46	C#2	a_563_48##3	2.38425e-17
C47	VGND#11	C#3	3.02678e-17
C48	a_27_74##14	A#3	4.91022e-19
C49	a_27_74##16	C#3	3.37636e-17
C50	VGND#11	A#3	4.86173e-19
C51	a_27_392##2	a_116_392#	1.10608e-16
C52	VGND#12	C#3	5.79142e-19
C53	a_27_74##16	A#3	6.27253e-17
C54	D_N#1	a_27_74##5	2.91712e-18
C55	VGND#11	B#3	2.90893e-19
C56	A#3	VGND#12	2.52445e-17
C57	a_27_74##16	B#3	7.96289e-19
C58	a_116_392#	VPWR#10	5.55399e-17
C59	a_27_74##18	A#3	9.09312e-19
C60	VGND#4	a_27_74##5	7.24153e-20
C61	B#3	VGND#12	2.75588e-17
C62	a_116_392##2	a_116_392#	2.30457e-18
C63	a_27_392#	a_27_392##2	9.8276e-19
C64	a_27_74##18	B#3	4.18527e-17
C65	a_116_392##2	VPWR#10	3.86126e-17
C66	a_27_392#	a_116_392#	1.14431e-17
C67	a_27_392#	VPWR#10	1.29141e-18
C68	VGND#3	a_27_74##5	7.97229e-20
C69	a_27_392#	a_116_392##2	9.36421e-17
C70	VGND#3	VGND#2	1.15214e-18
C71	VPWR#3	VPWR#2	1.22366e-18
C72	VPWR#1	a_27_74##7	3.75346e-17
C73	VGND#4	VGND#3	1.22054e-18
C74	VGND#3	a_27_74##3	2.40274e-20
C75	a_27_74##7	X#4	2.55436e-17
C76	C#11	VGND#4	6.95704e-19
C77	a_27_74##19	a_563_48##3	1.37766e-17
C78	VPWR#1	a_27_74##9	2.47203e-18
C79	VPWR#8	a_27_74##7	2.56658e-18
C80	a_27_74##9	X#4	2.81168e-17
C81	X#3	a_27_74##7	1.96665e-19
C82	VGND#2	X#1	4.22993e-19
C83	VPWR#8	a_27_74##9	5.16471e-17
C84	a_27_74##8	a_27_74#	3.97491e-17
C85	X#4	a_27_74##11	8.49649e-19
C86	X#3	a_27_74##9	4.6213e-19
C87	X#4	VPWR#3	6.76774e-18
C88	a_563_48##9	a_27_74##7	1.22995e-19
C89	VPWR#8	a_27_74##11	4.51478e-17
C90	VPWR#4	VPWR#8	2.85251e-19
C91	a_496_392##2	a_563_48##3	1.74911e-19
C92	X#4	a_27_74##12	1.84274e-19
C93	X#3	a_27_74##11	3.87731e-17
C94	a_27_74##10	a_27_74##8	2.38066e-17
C95	VPWR#8	a_27_74##12	1.98995e-18
C96	VPWR#9	a_27_74##11	6.51081e-19
C97	X#3	a_27_74##12	5.61313e-17
C98	X#3	VPWR#4	6.51514e-18
C99	a_563_48##9	a_27_74##11	1.99992e-19
C100	a_27_74##12	VPWR#9	2.78389e-17
C101	a_27_74##6	a_27_74##10	2.36588e-17
C102	C#11	D_N#5	3.14746e-18
C103	X#3	D_N#1	1.704e-18
C104	X#3	VPWR#3	8.8485e-18
C105	a_563_48##9	a_27_74##12	1.49853e-18
C106	C#11	D_N#4	3.60033e-18
C107	a_27_392##2	a_563_48##3	2.36448e-19
C108	VPWR#8	C#5	6.6229e-20
C109	D_N#1	VPWR#9	3.41556e-17
C110	a_27_392##4	a_27_74##12	4.8935e-19
C111	VGND#4	a_27_74##4	2.02208e-18
C112	a_563_48##9	D_N#1	8.30864e-17
C113	VPWR#4	a_27_74##5	9.57098e-21
C114	D_N#3	a_27_74##6	2.45637e-17
C115	a_27_74##14	C#13	1.21255e-18
C116	a_496_392#	a_27_74##12	5.5847e-20
C117	VPWR#9	C#5	1.13593e-18
C118	C#1	a_563_48##3	5.33318e-18
C119	a_27_392##4	D_N#1	3.15752e-18
C120	C#11	C#13	1.09884e-17
C121	a_563_48##9	C#5	1.80084e-18
C122	a_563_48##9	VPWR#4	1.24103e-17
C123	a_496_392#	D_N#1	3.41919e-19
C124	C#11	C#10	1.07801e-17
C125	a_27_74##14	C#10	3.2683e-17
C126	a_27_74##4	VPWR#4	3.35332e-19
C127	VPWR#9	a_563_48##5	2.05897e-19
C128	VGND#4	D_N#2	1.20233e-19
C129	a_27_392##4	C#5	4.06596e-17
C130	a_27_74##19	D_N#1	4.1079e-19
C131	a_563_48##9	a_563_48##5	7.63671e-20
C132	a_496_392#	C#5	3.56716e-17
C133	VPWR#9	a_563_48##6	2.21919e-19
C134	X#1	a_27_74##4	3.66997e-17
C135	a_27_392##4	a_563_48##5	1.89317e-17
C136	a_27_74##19	C#5	3.29952e-18
C137	VPWR#3	a_27_74##5	4.21123e-20
C138	VPWR#4	D_N#2	1.64316e-19
C139	VGND#4	C#4	1.21762e-19
C140	a_496_392#	a_563_48##5	4.23088e-17
C141	C#3	a_563_48##4	1.7583e-17
C142	a_27_392##4	a_563_48##6	4.02559e-19
C143	VGND#2	VGND#1	1.79974e-17
C144	a_27_74##3	X#5	9.11613e-20
C145	a_27_74##19	a_563_48##5	3.08579e-17
C146	VGND#3	X#1	2.36517e-19
C147	a_27_392##2	C#5	2.64175e-19
C148	VGND#2	X#5	6.96642e-18
C149	X#5	VGND#1	4.56044e-17
C150	D_N#5	a_27_74##4	2.6784e-17
C151	VPWR#3	a_27_74##3	4.11451e-20
C152	a_27_392##4	C#1	2.41319e-19
C153	a_27_74##19	a_563_48##6	3.0536e-17
C154	A#3	C#3	1.963e-18
C155	a_27_74##4	D_N#4	5.45129e-17
C156	a_27_74##2	X#5	1.60919e-19
C157	a_27_392##2	a_563_48##5	4.39228e-19
C158	VGND#9	a_27_74##5	7.58268e-19
C159	a_496_392##2	a_563_48##6	4.63688e-17
C160	VPWR#4	VPWR#3	9.86498e-19
C161	VGND#9	VGND#1	2.81164e-18
C162	a_27_74##19	C#1	4.17315e-18
C163	D_N#5	D_N#2	1.36037e-17
C164	a_27_392##2	a_563_48##6	1.99079e-17
C165	VPWR#3	a_27_74##2	3.96212e-21
C166	VPWR#10	a_563_48##5	2.01492e-19
C167	C#1	a_496_392##2	2.35035e-17
C168	D_N#4	D_N#2	9.14095e-18
C169	B#3	A#3	2.04611e-17
C170	VGND#9	a_27_74##3	6.60793e-19
C171	a_27_74##19	B#4	8.91487e-19
C172	VGND#9	X#5	4.20273e-17
C173	a_27_392##2	C#1	7.08255e-17
C174	C#11	a_563_48##7	4.88323e-18
C175	VPWR#10	a_563_48##6	3.00126e-19
C176	D_N#5	C#4	2.27137e-18
C177	a_116_392#	C#1	1.10782e-18
C178	C#11	a_27_74##14	1.92578e-17
C179	VPWR#2	VPWR#1	2.15106e-17
C180	a_27_74##19	A#1	2.38914e-19
C181	D_N#4	C#4	9.95524e-19
C182	C#13	D_N#2	2.03097e-18
C183	a_27_392##2	B#4	3.52468e-17
C184	VPWR#10	C#1	6.75611e-19
C185	X#2	X#5	2.28935e-18
C186	X#4	VPWR#2	6.71311e-18
C187	C#10	D_N#2	1.2615e-18
C188	X#2	a_27_74##5	6.36249e-18
C189	a_116_392#	B#4	4.93843e-17
C190	a_27_74##19	A#4	1.54511e-19
C191	X#1	a_27_74##5	1.76357e-18
C192	a_27_392##2	A#1	1.66021e-17
C193	VPWR#10	B#4	1.92392e-18
C194	D_N#5	a_563_48##9	3.52821e-17
C195	a_27_392#	C#1	9.41804e-20
C196	C#13	C#4	1.05882e-17
C197	a_116_392#	A#1	3.2385e-17
C198	X#2	VGND#9	5.38561e-17
C199	VGND#6	B#5	3.85389e-19
C200	a_116_392##2	B#4	1.63346e-19
C201	C#10	C#4	6.78607e-18
C202	a_27_392##2	A#4	2.07637e-19
C203	VPWR#10	A#1	3.82679e-17
C204	a_27_392#	B#4	1.50535e-19
C205	a_116_392#	A#4	4.6642e-19
C206	X#1	a_27_74##3	9.08456e-18
C207	a_563_48##2	D_N#5	1.80498e-18
C208	a_116_392##2	A#1	3.78208e-19
C209	VGND#10	VGND#9	2.59146e-18
C210	a_27_392##2	B#1	3.28747e-19
C211	a_27_74##9	a_27_74##7	4.79384e-17
C212	VGND#5	a_563_48##7	1.59086e-17
C213	a_27_74##4	VGND#9	4.1058e-18
C214	VPWR#10	A#4	3.4904e-17
C215	a_27_392#	A#1	2.31366e-19
C216	a_27_74##4	X#2	9.96215e-17
C217	VGND#5	a_27_74##14	1.52719e-17
C218	a_116_392#	B#1	2.00227e-19
C219	a_116_392##2	A#4	4.82747e-17
C220	a_27_74##4	VGND#10	3.84787e-17
C221	VPWR#10	B#1	2.51629e-18
C222	VGND#10	X#2	3.69709e-17
C223	a_27_392#	A#4	1.7041e-17
C224	X#1	a_27_74##2	1.26114e-17
C225	a_27_74##4	a_563_48##7	3.36331e-17
C226	a_27_74##11	a_27_74##9	4.61376e-17
C227	a_563_48##2	C#13	1.98094e-17
C228	C#11	a_563_48##9	5.28773e-18
C229	B#1	a_116_392##2	1.99235e-17
C230	C#10	a_563_48##2	1.04508e-18
C231	C#11	a_27_392##4	7.17869e-18
C232	VGND#10	D_N#2	7.26142e-19
C233	a_27_392#	B#1	5.64016e-17
C234	C#11	a_496_392#	1.50234e-18
C235	D_N#2	a_563_48##7	1.26602e-18
C236	a_27_74##12	a_27_74##11	4.64079e-17
C237	a_563_48##9	VPWR#5	4.32722e-20
C238	a_563_48##7	VGND#10	2.24137e-17
C239	C#13	a_563_48##9	1.27506e-17
C240	a_563_48##7	C#4	1.85856e-18
C241	VGND#3	a_27_74#	5.26594e-19
C242	a_27_392##4	VPWR#5	2.20091e-17
C243	a_27_74##14	C#4	1.19352e-17
C244	D_N#1	a_27_74##12	3.21928e-17
C245	X#2	a_563_48#	1.27927e-19
C246	a_496_392#	VPWR#5	3.02824e-17
C247	a_27_74##4	VPWR#8	2.35532e-18
C248	VGND#10	a_563_48#	4.83518e-19
C249	C#5	a_27_74##12	3.44903e-19
C250	a_27_74##14	VGND#10	6.92176e-20
C251	a_27_74##4	X#3	5.88181e-17
C252	a_27_74##14	a_563_48#	1.04749e-16
C253	a_27_74##4	VPWR#9	3.13282e-17
C254	VGND#2	a_27_74#	3.42739e-18
C255	a_496_392##2	VPWR#5	3.14165e-17
C256	C#5	D_N#1	6.82434e-18
C257	VGND#11	a_563_48#	1.58626e-18
C258	VGND#3	a_27_74##8	4.49993e-18
C259	a_27_74##4	a_563_48##9	4.28144e-18
C260	a_27_392##2	VPWR#5	5.42454e-18
C261	a_563_48##7	a_27_74##14	3.72791e-17
C262	D_N#5	VPWR#4	3.27757e-19
C263	a_27_74##14	a_563_48##2	2.4339e-17
C264	VPWR#2	a_27_74##2	4.51072e-20
C265	VGND#1	VPWR#1	2.16595e-19
C266	a_563_48##9	D_N#2	4.9693e-18
C267	a_563_48##5	C#5	4.33455e-17
C268	C#11	a_27_74##10	1.28223e-19
C269	VGND#3	a_27_74##10	3.86552e-18
C270	C#11	a_27_74##6	1.62832e-18
C271	a_27_74##14	C#2	4.17361e-18
C272	a_563_48##9	C#4	2.96383e-18
C273	a_563_48##6	a_563_48##5	4.2227e-17
C274	C#2	VGND#11	1.73995e-18
C275	a_27_392##4	C#4	1.0977e-18
C276	VGND#4	a_27_74##6	4.22521e-18
C277	a_27_74##16	C#2	1.65348e-17
C278	a_27_74##14	VGND#11	4.8958e-17
C279	B#5	a_27_74##14	3.94266e-18
C280	a_27_74##6	a_27_74##5	6.05841e-19
C281	VGND#2	a_27_74##3	6.14033e-21
C282	VGND#3	a_27_74##6	3.66595e-19
C283	a_27_392##4	a_563_48#	3.03182e-19
C284	C#1	a_563_48##6	3.31119e-17
C285	X#1	a_27_74#	5.59496e-18
C286	VPWR#2	a_27_74##7	1.47913e-18
C287	VGND#2	a_27_74##2	1.50238e-19
C288	B#5	a_27_74##16	9.19861e-17
C289	a_496_392#	a_563_48#	1.7574e-19
C290	a_27_74##16	a_27_74##14	2.90912e-18
C291	VGND#4	D_N#3	4.85507e-18
C292	a_27_74##14	a_563_48##3	7.49952e-18
C293	a_563_48##2	a_27_392##4	2.65158e-17
C294	B#4	C#1	3.91377e-17
C295	a_27_74##4	a_27_74##10	4.03717e-19
C296	a_496_392#	a_563_48##2	1.70247e-19
C297	a_27_74##16	A#2	1.98641e-18
C298	a_27_74##16	VGND#11	3.86457e-17
C299	a_27_74##19	a_563_48##2	4.31572e-17
C300	VGND#6	a_563_48##4	6.8373e-18
C301	X#1	a_27_74##8	1.88106e-17
C302	a_27_74##4	a_27_74##6	8.8984e-18
C303	VGND#12	A#2	4.51375e-19
C304	X	a_27_74##5	1.92729e-18
C305	X	a_27_74##3	8.54448e-18
C306	X	a_27_74##2	1.00577e-17
C307	a_27_74##4	D_N#3	3.03983e-17
C308	C#11	a_27_74##5	8.10448e-19
C309	a_27_392##2	a_563_48##2	4.09844e-20
C310	A#1	B#4	3.43142e-17
C311	a_27_74##4	a_563_48##4	1.0436e-19
C312	D_N#2	a_27_74##6	4.77008e-18
C313	a_27_74##5	a_27_74##3	3.78588e-18
C314	a_27_74##19	C#2	8.40782e-19
C315	VGND#12	VGND#11	1.01615e-18
C316	B#2	VGND#12	1.73177e-19
C317	a_496_392##2	C#2	1.74592e-19
C318	B#2	a_27_74##18	3.02943e-17
C319	X#1	a_27_74##10	4.32947e-20
C320	C#2	a_27_392##2	2.26984e-17
C321	VGND#6	C#3	4.11539e-18
C322	A#4	A#1	4.21492e-17
C323	D_N#5	a_27_74##5	2.53841e-18
C324	a_27_74##16	VGND#12	4.04115e-17
C325	B#5	a_27_392##2	2.35438e-17
C326	a_563_48#	D_N#3	2.93307e-18
C327	B#1	A#4	4.39489e-17
C328	a_116_392#	B#5	4.70277e-19
C329	a_27_74##19	A#2	2.66542e-19
C330	X#1	a_27_74##6	4.7811e-20
C331	a_563_48##4	a_563_48#	2.5758e-17
C332	VGND#6	A#3	2.12156e-19
C333	a_27_74##18	a_27_74##16	3.02213e-18
C334	VPWR#5	C#5	5.29191e-18
C335	a_563_48#	C#3	2.02261e-19
C336	a_563_48##2	D_N#3	1.10888e-18
C337	a_116_392#	A#2	5.18701e-19
C338	VPWR#5	a_563_48##5	5.31936e-18
C339	a_563_48##4	a_563_48##2	7.73423e-18
C340	VPWR#10	A#2	5.97759e-19
C341	a_116_392##2	A#2	1.88957e-19
C342	VPWR#5	a_563_48##6	5.33467e-18
C343	a_27_74##18	VGND#12	4.74104e-17
C344	a_27_392#	A#2	2.60342e-18
C345	C#2	a_563_48##4	7.90228e-18
C346	VPWR#5	C#1	5.58583e-18
C347	D_N#4	a_27_74##5	5.23068e-19
C348	VGND#6	B#3	7.15213e-20
C349	A#3	C#2	3.16628e-19
C350	B#2	a_27_392#	1.70052e-17
C351	B#5	a_563_48##4	6.97849e-19
C352	C#4	D_N#1	8.50406e-20
C353	B#5	C#3	2.91738e-18
C354	A#3	B#5	2.08148e-18
C355	a_27_74##3	a_27_74##2	5.95763e-18
C356	a_563_48##2	C#5	2.92409e-17
C357	a_563_48##2	a_563_48##5	1.43233e-18
C358	B#2	A#3	3.76522e-18
C359	VPWR#5	a_563_48##3	2.27556e-20
C360	B#2	B#3	4.31211e-18
C361	a_563_48##2	a_563_48##6	3.23103e-19
C362	D_N#4	a_27_74##6	5.06377e-20
C363	a_27_74##14	a_563_48##9	1.93043e-18
C364	C#11	VGND#5	3.36189e-18
C365	C#2	C#1	3.16786e-18
C366	VGND	a_27_74##3	1.09596e-19
C367	VGND	a_27_74##2	3.29515e-21
C368	X#4	VPWR#1	5.84992e-17
C369	C#11	a_27_74##4	3.05573e-18
C370	C#2	B#4	1.67981e-18
C371	X	VPWR#3	1.75212e-19
C372	X#1	X	5.21068e-18
C373	C#11	D_N#2	1.28205e-20
C374	C#11	C#4	2.41288e-18
C375	VPWR#8	VPWR#1	2.06271e-18
C376	A#2	B#4	5.08711e-18
C377	C#11	a_563_48#	2.6097e-18
C378	VGND#5	a_563_48##3	3.34569e-20
C379	A#2	A#1	1.42896e-19
C380	VPWR#5	C#4	1.75114e-19
C381	VPWR	VPWR#4	9.86179e-17
C382	VPWR	VPWR#3	5.54393e-17
C383	C#11	a_563_48##2	2.36907e-17
C384	VPWR	X#1	9.66058e-19
C385	A	a_27_392##2	1.29255e-17
C386	a_27_74##4	D_N#2	1.37067e-17
C387	VGND#5	C#4	3.29143e-19
C388	B#1	A#2	6.49251e-18
C389	VPWR#8	X#4	5.8479e-17
C390	a_27_74##16	B	3.5299e-17
C391	A	VPWR#10	2.42499e-18
C392	B	VGND#12	2.06338e-18
C393	a_27_74##4	C#4	4.29459e-19
C394	VGND#5	a_563_48#	2.47826e-17
C395	VPWR	D_N#5	3.69646e-18
C396	a_27_74##18	B	3.45143e-17
C397	VGND#1	X	1.09532e-17
C398	VPWR#5	a_563_48##2	2.24522e-20
C399	A	a_27_392#	2.81186e-17
C400	C#4	D_N#2	2.04903e-17
C401	a_27_74##14	a_27_74##19	7.95907e-19
C402	VGND#5	a_563_48##2	4.21694e-20
C403	VPWR	C#13	2.15237e-18
C404	VPWR#5	C#2	5.45167e-20
C405	a_27_74##4	a_27_74##5	3.99992e-17
C406	a_563_48##2	a_27_74##4	3.47773e-18
C407	X#3	X#4	2.42846e-18
C408	a_563_48#	C#4	3.41308e-18
C409	a_563_48##2	D_N#2	2.86485e-19
C410	a_27_74##4	a_27_74##3	8.23228e-18
C411	X	VPWR#1	3.32164e-17
C412	X	X#4	8.90826e-19
C413	a_563_48##2	C#4	5.6222e-17
C414	X	VPWR#8	2.24638e-17
C415	a_563_48##2	a_563_48#	1.82479e-18
C416	X#3	VPWR#8	6.84984e-17
C417	a_563_48##9	X	2.00834e-18
C418	B	a_27_392#	2.11051e-17
C419	VGND	VGND#6	9.15309e-17
C420	VGND	VGND#4	8.30507e-17
C421	VGND	VGND#3	7.82572e-17
C422	VPWR	X#4	1.63711e-17
C423	VPWR	VPWR#8	2.15404e-17
C424	VPWR	X#3	1.70143e-17
C425	a_27_74##14	a_27_392##2	3.49205e-19
C426	VGND	X#1	3.47108e-18
C427	a_27_74##3	X#4	1.14613e-19
C428	VPWR	a_563_48##9	1.94663e-17
C429	VPWR#3	a_27_74##9	9.67868e-19
C430	VPWR#9	VPWR#8	2.35578e-18
C431	VGND#3	VGND#1	6.17332e-20
C432	VPWR	a_27_392##4	2.28991e-17
C433	B	A#3	1.75532e-17
C434	B#5	C#2	7.40747e-17
C435	VPWR	a_496_392#	1.89443e-17
C436	VGND	D_N#4	2.96629e-18
C437	VPWR	a_27_74##19	4.47188e-18
C438	a_27_74##5	VNB	7.8553e-17
C439	A	C#1	2.42106e-19
C440	a_27_74##3	VNB	2.85826e-17
C441	a_27_74##2	VNB	3.94841e-17
C442	VPWR	a_496_392##2	1.76071e-17
C443	a_563_48##3	VNB	2.49559e-17
C444	VPWR	a_27_392##2	3.03069e-17
C445	A	B#4	1.02205e-18
C446	C#2	A#2	1.16046e-18
C447	VGND	C#10	2.31474e-18
C448	VGND#1	a_27_74#	3.96896e-17
C449	VPWR	a_116_392#	1.88544e-17
C450	C#13	D_N#5	8.89421e-18
C451	C#10	a_563_48##4	3.89865e-19
C452	VPWR	VPWR#10	1.81173e-17
C453	VPWR	a_116_392##2	1.32918e-17
C454	A#2	B#5	3.62403e-17
C455	D_N#2	a_27_74##5	2.69867e-17
C456	VPWR	a_27_392#	2.21237e-17
C457	A	B#1	1.28682e-18
C458	a_27_74##2	X#4	1.38399e-19
C459	VPWR#4	a_27_74##11	5.16438e-19
C460	B#5	B#2	1.01501e-19
C461	VPWR#9	X#3	8.74276e-17
C462	VGND	X#5	1.74862e-17
C463	X	a_27_74##7	1.89169e-17
C464	VGND	X#2	1.8509e-17
C465	VGND	VGND#10	1.62302e-17
C466	X	a_27_74##9	1.85183e-17
C467	B#2	A#2	2.39216e-17
C468	VGND	a_563_48##7	2.37506e-17
C469	X	a_27_74##11	9.51954e-19
C470	a_27_74#	X#5	9.60835e-18
C471	VGND	a_27_74##14	2.88235e-17
C472	VGND	a_27_74##16	4.57424e-17
C473	VGND	VGND#12	1.60698e-17
C474	X	D_N#1	3.14056e-19
C475	VPWR#3	a_27_74##11	9.76995e-19
C476	VGND	a_27_74##18	1.87534e-17
C477	VPWR#8	a_27_74##5	4.18784e-19
C478	VGND#3	X#5	6.79046e-18
C479	a_27_74##16	a_27_392##2	4.51976e-18
C480	VGND#1	a_27_74##8	2.98973e-18
C481	VPWR	a_27_74##9	4.95419e-19
C482	C#13	D_N#4	8.71162e-19
C483	VGND	a_563_48##9	4.89622e-18
C484	VPWR	a_27_74##11	4.16381e-19
C485	VPWR	a_27_74##12	1.95489e-18
C486	VPWR	D_N#1	8.96655e-18
C487	VGND#9	a_27_74#	7.99633e-19
C488	VPWR	C#5	2.60823e-18
C489	VPWR	a_563_48##5	7.15197e-19
C490	VPWR	a_563_48##6	5.97858e-19
C491	VPWR#4	a_27_74##12	7.81199e-18
C492	VGND	a_27_392#	3.96839e-18
C493	VPWR	C#1	2.15615e-19
C494	X#5	a_27_74##8	3.13171e-17
C495	VGND	a_27_74#	5.31182e-19
C496	X	VPWR#2	3.58829e-18
C497	VGND#6	VNB	4.36986e-17
C498	VPWR	B#4	1.64672e-18
C499	VPWR#8	a_27_74##3	2.39132e-19
C500	VGND#4	VNB	4.45292e-17
C501	VGND#3	VNB	3.05921e-17
C502	VGND	a_27_74##10	4.59896e-19
C503	VPWR	A#1	6.15822e-19
C504	VGND#2	X	3.70794e-18
C505	VGND	a_27_74##6	5.54624e-19
C506	VPWR#4	VNB	4.36414e-17
C507	VPWR#3	VNB	2.88728e-17
C508	VGND	D_N#3	7.26518e-18
C509	VPWR	A#4	1.08196e-18
C510	X#1	VNB	8.40669e-18
C511	A	C#2	4.83973e-18
C512	VPWR	B#1	1.18452e-18
C513	VGND	C#3	5.9715e-19
C514	VGND#1	a_27_74##10	3.1607e-19
C515	VGND	A#3	1.74952e-19
C516	a_563_48##9	VPWR#9	7.71275e-17
C517	D_N#5	VNB	2.67118e-18
C518	B#5	A	1.66452e-17
C519	D_N#4	VNB	2.87651e-18
C520	VGND	B#3	1.03823e-18
C521	VPWR	VPWR#2	9.81608e-18
C522	C#13	VNB	4.12591e-18
C523	A	A#2	2.63006e-17
C524	C#10	VNB	5.38185e-18
C525	a_27_74##4	X	3.24099e-17
C526	A	B#2	2.93242e-18
C527	C#10	D_N#4	6.41909e-18
C528	a_27_74##8	VGND#9	1.7405e-17
C529	VGND#1	VNB	4.20428e-17
C530	VPWR	VPWR#5	1.08735e-16
C531	X#5	VNB	2.3242e-18
C532	VGND#9	VNB	5.61793e-19
C533	X#2	VNB	6.32129e-18
C534	VGND#10	VNB	1.9237e-18
C535	a_563_48##7	VNB	8.13787e-18
C536	B	B#5	2.57514e-18
C537	a_27_74##14	VNB	1.10178e-17
C538	VPWR	a_27_74##4	8.58513e-18
C539	VGND#11	VNB	2.62498e-18
C540	VGND#4	X#2	9.19913e-18
C541	a_27_74##16	VNB	7.97373e-18
C542	VGND#12	VNB	4.73091e-18
C543	B	A#2	8.38176e-18
C544	a_27_74##18	VNB	3.29344e-17
C545	X#5	a_27_74##10	1.15769e-18
C546	VPWR#1	VNB	3.28149e-17
C547	X#4	VNB	5.30487e-18
C548	VPWR#8	VNB	1.08161e-19
C549	B	B#2	9.47516e-18
C550	X#3	VNB	2.75613e-18
C551	VPWR#9	VNB	8.35921e-18
C552	a_563_48##9	VNB	1.88261e-17
C553	a_27_392##4	VNB	1.1503e-17
C554	a_496_392#	VNB	3.17871e-18
C555	VPWR	a_563_48##2	5.58764e-18
C556	a_27_392##4	VPWR#9	4.65132e-18
C557	a_27_74##19	VNB	3.43937e-19
C558	VPWR#4	D_N#1	6.87727e-18
C559	a_496_392##2	VNB	3.28387e-18
C560	a_27_392##2	VNB	9.77633e-18
C561	VGND	VGND#2	1.08605e-17
C562	VPWR	C#2	2.3069e-18
C563	a_116_392#	VNB	2.70163e-18
C564	VPWR#10	VNB	2.08869e-19
C565	VGND	C#11	2.2511e-17
C566	a_116_392##2	VNB	4.48044e-18
C567	VPWR	B#5	3.47392e-18
C568	X#2	a_27_74##8	4.20524e-19
C569	a_27_392#	VNB	5.27221e-17
C570	a_27_74#	VNB	2.6805e-17
C571	a_27_74##8	VNB	2.63278e-17
C572	a_27_74##10	VNB	2.52272e-17
C573	a_27_74##6	VNB	3.32348e-17
C574	VGND	VGND#5	6.28302e-17
C575	D_N#3	VNB	2.56699e-17
C576	VPWR	B#2	1.72737e-18
C577	a_563_48##4	VNB	3.666e-17
C578	VGND	a_27_74##4	1.77646e-17
C579	C#3	VNB	2.48212e-17
C580	X#3	a_27_74##5	3.98775e-18
C581	A#3	VNB	3.4044e-17
C582	VGND	D_N#2	5.31327e-19
C583	B#3	VNB	3.76243e-17
C584	a_27_74##7	VNB	3.98366e-17
C585	a_27_74##9	VNB	2.73788e-17
C586	VGND	a_563_48#	2.20288e-17
C587	VGND#9	a_27_74##10	3.28478e-17
C588	a_27_74##11	VNB	2.82889e-17
C589	a_27_74##12	VNB	3.52835e-17
C590	VGND	a_563_48##2	2.43992e-18
C591	D_N#1	VNB	4.98409e-17
C592	a_27_74##3	a_27_74##7	1.27674e-18
C593	C#5	VNB	4.14282e-17
C594	VGND	C#2	2.87329e-18
C595	B	A	3.55414e-17
C596	a_563_48##5	VNB	3.28768e-17
C597	a_563_48##6	VNB	3.01246e-17
C598	VGND	B#5	5.84534e-18
C599	C#1	VNB	3.52897e-17
C600	B#4	VNB	3.52272e-17
C601	A#1	VNB	2.66878e-17
C602	VGND#3	X#2	9.38626e-18
C603	A#4	VNB	2.75116e-17
C604	VGND	B#2	2.2019e-18
C605	B#1	VNB	4.98398e-17
C606	VPWR#2	VNB	9.19309e-17
C607	X#5	a_27_74##6	1.76227e-19
C608	a_563_48##9	a_27_392##4	7.72216e-17
C609	VGND#2	VNB	9.52691e-17
C610	VPWR	A	1.70829e-18
C611	C#11	VNB	1.03227e-17
C612	VPWR#5	VNB	5.7816e-17
C613	VGND#5	VNB	3.52307e-17
C614	a_27_74##4	VNB	1.68922e-18
C615	D_N#2	VNB	4.05508e-17
C616	VPWR	B	4.29914e-18
C617	C#4	VNB	6.0381e-17
C618	a_563_48#	VNB	7.23731e-17
C619	a_563_48##2	VNB	4.61888e-17
C620	VPWR	X	1.96479e-18
C621	C#2	VNB	3.23959e-17
C622	VGND	A	1.82546e-18
C623	B#5	VNB	4.061e-17
C624	A#2	VNB	6.303e-17
C625	X#2	a_27_74##10	2.77149e-17
C626	B#2	VNB	5.16141e-17
C627	VGND	B	5.32489e-18
C628	VGND	X	8.41548e-19
C629	VPWR#4	C#5	4.58455e-19
C630	A	VNB	2.66389e-18
C631	B	VNB	2.78379e-17
C632	X	VNB	3.0464e-17
C633	VPWR	VNB	3.12652e-16
C634	VGND#9	a_27_74##6	1.18715e-18
C635	VGND	VNB	2.94175e-16
C636	C	VGND#11	1.97403e-18
C637	VGND#7	A#2	1.16539e-19
C638	VGND#7	a_27_74##16	2.69173e-17
C639	C	B	1.2426e-18
C640	VGND#7	B#2	1.3723e-19
C641	C	a_27_392##2	1.30008e-17
C642	a_27_74##14	C	8.43981e-17
C643	VGND#7	VGND#6	2.76261e-19
C644	VGND#7	a_27_74##18	2.09665e-17
C645	VPWR#6	B#4	4.53348e-18
C646	a_116_392##2	VPWR#6	1.4171e-17
C647	VPWR#6	C#2	4.37679e-20
C648	C	a_496_392##2	2.42952e-18
C649	C	VNB	4.72966e-18
C650	C	a_27_74##19	2.9447e-17
C651	VPWR#6	A#1	9.50782e-19
C652	VGND#7	A#3	2.74048e-18
C653	a_27_392#	VPWR#6	2.38409e-17
C654	VPWR#6	B#5	7.17325e-20
C655	VGND#7	B#3	2.71104e-18
C656	C	VGND#5	1.41544e-18
C657	C	a_496_392#	7.3236e-19
C658	VGND	C	2.42557e-17
C659	C	B#5	6.97453e-18
C660	VPWR#6	A#4	1.7912e-18
C661	C	VGND#6	4.03792e-19
C662	C	a_563_48##3	9.02495e-18
C663	VPWR#6	VNB	8.02263e-17
C664	C	a_27_392##4	1.07909e-18
C665	a_27_392##2	VPWR#6	1.92927e-17
C666	C	C#2	2.9883e-17
C667	C	a_563_48##4	8.28866e-19
C668	VPWR#6	B#1	5.80812e-18
C669	VGND	VGND#7	1.03933e-16
C670	VPWR#6	B#2	9.46869e-20
C671	VPWR	C	2.98977e-18
C672	C	a_563_48##2	7.37474e-18
C673	a_116_392#	VPWR#6	2.04602e-17
C674	C	a_27_74##16	1.39831e-18
C675	VPWR	VPWR#6	1.42832e-16
C676	VGND#7	VNB	6.3126e-17
*
*
.ENDS sky130_fd_sc_hs__or4b_4
*
