* Extracted by Quantus, converted by sky130cad/quantus.py
*
*
*
*                       LINUX           Wed Nov 18 09:12:46 2026
*
*
*
*  PROGRAM  advgen
*
*  Name           : advgen - Quantus - (64-bit)
*  Version        : 25.1.0-p047
*  Build Date     : Thu Dec 11 23:20:30 PST 2025
*
*  HSPICE LIBRARY
*
*  OPERATING_TEMPERATURE 150
*  QRC_TECH_DIR <path>/tech
*
*
*

*
.SUBCKT sky130_fd_sc_hs__sedfxtp_1 VNB VPB VGND VPWR Q D SCE SCD CLK DE
*
*
*  caps2d version: 10
*
*
*       TRANSISTOR CARDS
*
*
XM24 a_27_74##6 D#1 a_143_74# VNB sky130_fd_pr__nfet_01v8_lvt l=0.15 w=0.42 ad=0.1806 as=0.1008 pd=1.7 ps=1.32
XM13 a_143_74# DE#5 VGND#21 VNB sky130_fd_pr__nfet_01v8_lvt l=0.15 w=0.42 ad=0.1008 as=0.1197 pd=1.32 ps=1.41
XM25 a_159_404##9 DE#7 VGND#20 VNB sky130_fd_pr__nfet_01v8_lvt l=0.15 w=0.42 ad=0.1197 as=0.1176 pd=1.41 ps=1.4
XM34 VGND#20 a_159_404##3 a_505_111# VNB sky130_fd_pr__nfet_01v8_lvt l=0.15 w=0.42 ad=0.1176 as=0.1008 pd=1.4 ps=1.32
XM19 a_505_111# a_547_301##3 a_27_74# VNB sky130_fd_pr__nfet_01v8_lvt l=0.15 w=0.42 ad=0.1008 as=0.1176 pd=1.32 ps=1.4
XM20 a_27_74# a_639_85##2 a_669_111##7 VNB sky130_fd_pr__nfet_01v8_lvt l=0.15 w=0.42 ad=0.1176 as=0.1491 pd=1.4 ps=1.55
XM4 a_639_85##10 SCE#2 VGND#19 VNB sky130_fd_pr__nfet_01v8_lvt l=0.15 w=0.42 ad=0.1176 as=0.1176 pd=1.4 ps=1.4
XM22 VGND#19 SCD#3 a_1026_125# VNB sky130_fd_pr__nfet_01v8_lvt l=0.15 w=0.42 ad=0.1176 as=0.0882 pd=1.4 ps=1.26
XM12 a_1026_125# SCE#1 a_669_111##9 VNB sky130_fd_pr__nfet_01v8_lvt l=0.15 w=0.42 ad=0.0882 as=0.1176 pd=1.26 ps=1.4
XM21 VGND#18 CLK#3 a_1295_74##16 VNB sky130_fd_pr__nfet_01v8_lvt l=0.15 w=0.74 ad=0.2109 as=0.2072 pd=2.05 ps=2.04
XM15 VGND#17 a_1295_74##9 a_1492_74##16 VNB sky130_fd_pr__nfet_01v8_lvt l=0.15 w=0.74 ad=0.2109 as=0.2072 pd=2.05 ps=2.04
XM35 a_669_111##8 a_1295_74# a_1688_97##4 VNB sky130_fd_pr__nfet_01v8_lvt l=0.15 w=0.42 ad=0.1176 as=0.2226 pd=1.4 ps=1.9
XM16 a_1688_97##4 a_1492_74##4 a_1824_97# VNB sky130_fd_pr__nfet_01v8_lvt l=0.15 w=0.42 ad=0.2226 as=0.1806 pd=1.9 ps=1.7
XM1 a_1824_97# a_1910_71##3 VGND#16 VNB sky130_fd_pr__nfet_01v8_lvt l=0.15 w=0.42 ad=0.1806 as=0.3413 pd=1.7 ps=2.49
XM27 VGND#16 a_1688_97# a_1910_71##11 VNB sky130_fd_pr__nfet_01v8_lvt l=0.15 w=0.64 ad=0.3413 as=0.1824 pd=2.49 ps=1.85
XM2 VGND#8 a_1910_71##4 a_2313_74# VNB sky130_fd_pr__nfet_01v8_lvt l=0.15 w=0.64 ad=0.1824 as=0.1344 pd=1.85 ps=1.7
XM18 a_2313_74# a_1492_74##5 a_2385_74##9 VNB sky130_fd_pr__nfet_01v8_lvt l=0.15 w=0.64 ad=0.1344 as=0.2139 pd=1.7 ps=2
XM36 a_2385_74##9 a_1295_74##10 a_2487_74# VNB sky130_fd_pr__nfet_01v8_lvt l=0.15 w=0.42 ad=0.2139 as=0.1008 pd=2 ps=1.32
XM33 a_2487_74# a_547_301##4 VGND#6 VNB sky130_fd_pr__nfet_01v8_lvt l=0.15 w=0.42 ad=0.1008 as=0.4095 pd=1.32 ps=2.79
XM10 VGND#6 a_2385_74##5 a_547_301##9 VNB sky130_fd_pr__nfet_01v8_lvt l=0.15 w=0.42 ad=0.4095 as=0.1197 pd=2.79 ps=1.41
XM28 Q#3 a_2385_74##4 VGND#1 VNB sky130_fd_pr__nfet_01v8_lvt l=0.15 w=0.74 ad=0.2109 as=0.2109 pd=2.05 ps=2.05
XM9 a_27_74##4 D#3 a_114_464# VPB sky130_fd_pr__pfet_01v8 l=0.15 w=0.64 ad=0.1824 as=0.1536 pd=1.85 ps=1.76
XM23 a_114_464# a_159_404# VPWR#20 VPB sky130_fd_pr__pfet_01v8 l=0.15 w=0.64 ad=0.1536 as=0.1888 pd=1.76 ps=1.87
XM29 a_159_404##8 DE#6 VPWR#19 VPB sky130_fd_pr__pfet_01v8 l=0.15 w=0.64 ad=0.1888 as=0.3392 pd=1.87 ps=2.34
XM31 VPWR#19 DE#1 a_554_463# VPB sky130_fd_pr__pfet_01v8 l=0.15 w=0.64 ad=0.3392 as=0.1536 pd=2.34 ps=1.76
XM0 a_554_463# a_547_301# a_27_74##5 VPB sky130_fd_pr__pfet_01v8 l=0.15 w=0.64 ad=0.1536 as=0.192 pd=1.76 ps=1.88
XM5 a_27_74##5 SCE#5 a_669_111##5 VPB sky130_fd_pr__pfet_01v8 l=0.15 w=0.64 ad=0.192 as=0.176 pd=1.88 ps=1.83
XM7 a_639_85##9 SCE#4 VPWR#18 VPB sky130_fd_pr__pfet_01v8 l=0.15 w=0.64 ad=0.1792 as=0.3392 pd=1.84 ps=2.34
XM32 VPWR#18 SCD#1 a_1053_455# VPB sky130_fd_pr__pfet_01v8 l=0.15 w=0.64 ad=0.3392 as=0.1536 pd=2.34 ps=1.76
XM3 a_1053_455# a_639_85##4 a_669_111##10 VPB sky130_fd_pr__pfet_01v8 l=0.15 w=0.64 ad=0.1536 as=0.176 pd=1.76 ps=1.83
XM14 VPWR#17 CLK#1 a_1295_74##14 VPB sky130_fd_pr__pfet_01v8 l=0.15 w=1.12 ad=0.308 as=0.308 pd=2.79 ps=2.79
XM30 VPWR#16 a_1295_74##8 a_1492_74##17 VPB sky130_fd_pr__pfet_01v8 l=0.15 w=1.12 ad=0.308 as=0.308 pd=2.79 ps=2.79
XM40 a_669_111# a_1492_74# a_1688_97##6 VPB sky130_fd_pr__pfet_01v8 l=0.15 w=0.42 ad=0.1176 as=0.147 pd=1.4 ps=1.54
XM11 a_1688_97##6 a_1295_74##7 a_1890_508# VPB sky130_fd_pr__pfet_01v8 l=0.15 w=0.42 ad=0.147 as=0.1176 pd=1.54 ps=1.4
XM37 a_1890_508# a_1910_71# VPWR#15 VPB sky130_fd_pr__pfet_01v8 l=0.15 w=0.42 ad=0.1176 as=0.28945 pd=1.4 ps=2.68
XM41 VPWR#15 a_1688_97##3 a_1910_71##8 VPB sky130_fd_pr__pfet_01v8 l=0.15 w=0.84 ad=0.28945 as=0.231 pd=2.68 ps=2.23
XM6 VPWR#14 a_1910_71##7 a_2274_392# VPB sky130_fd_pr__pfet_01v8 l=0.15 w=1 ad=0.275 as=0.785 pd=2.55 ps=3.57
XM17 a_2274_392# a_1295_74##12 a_2385_74##10 VPB sky130_fd_pr__pfet_01v8 l=0.15 w=1 ad=0.785 as=0.3328 pd=3.57 ps=2.77
XM38 a_2385_74##10 a_1492_74##7 a_2568_508# VPB sky130_fd_pr__pfet_01v8 l=0.15 w=0.42 ad=0.3328 as=0.1134 pd=2.77 ps=1.38
XM26 a_2568_508# a_547_301##6 VPWR#13 VPB sky130_fd_pr__pfet_01v8 l=0.15 w=0.42 ad=0.1134 as=0.2935 pd=1.38 ps=2.4
XM39 VPWR#13 a_2385_74##6 a_547_301##13 VPB sky130_fd_pr__pfet_01v8 l=0.15 w=0.64 ad=0.2935 as=0.176 pd=2.4 ps=1.83
XM8 Q#1 a_2385_74# VPWR#1 VPB sky130_fd_pr__pfet_01v8 l=0.15 w=1.12 ad=0.308 as=0.3192 pd=2.79 ps=2.81
*
*
*       RESISTOR AND CAP/DIODE CARDS
*
Rg1	D#1	D#2	367.776825
Rg2	D#2	D#3	494.234833
Rg3	a_159_404#	a_159_404##2	454.208282
Rg4	a_159_404##3	a_159_404##4	497.400696
Rg5	DE#1	DE#2	587.980652
Rg6	DE#2	DE#3	426.292847
Rg7	DE#3	DE#4	56.207062
Rg8	DE#4	DE#5	591.009338
Rg9	DE#2	DE#6	234.008942
Rg10	DE#4	DE#7	306.947662
Rg11	a_547_301#	a_547_301##2	456.825958
Rg12	a_547_301##2	a_547_301##3	477.391693
Rg13	a_639_85#	a_639_85##2	501.096832
Rg15	SCD#1	SCD#2	458.738525
Rg16	SCD#2	SCD#3	365.323883
Rg17	SCE#1	SCE#2	1097.454712
Rg18	SCE#2	SCE#3	252.692917
Rg19	SCE#3	SCE#4	574.178406
Rg20	SCE#4	SCE#5	999.329224
Rg21	a_639_85##4	a_639_85##5	360.062225
Rg22	CLK#1	CLK#2	465.147736
Rg23	CLK#2	CLK#3	307.355530
Rg24	a_1492_74#	a_1492_74##2	472.082581
Rg25	a_1492_74##3	a_1492_74##4	211.981689
Rg26	a_1295_74#	a_1295_74##2	535.286499
Rg27	a_1295_74##2	a_1295_74##3	230.579941
Rg28	a_1295_74##3	a_1295_74##4	323.416168
Rg29	a_1295_74##4	a_1295_74##5	14.466387
Rg30	a_1295_74##2	a_1295_74##6	603.248718
Rg31	a_1295_74##6	a_1295_74##7	289.032745
Rg32	a_1295_74##3	a_1295_74##8	371.735809
Rg33	a_1295_74##4	a_1295_74##9	562.963623
Rg34	a_1910_71#	a_1910_71##2	646.387329
Rg35	a_1910_71##2	a_1910_71##3	319.089874
Rg36	a_1688_97#	a_1688_97##2	497.312164
Rg37	a_1688_97##2	a_1688_97##3	354.298584
Rg38	a_1910_71##4	a_1910_71##5	338.070862
Rg39	a_1910_71##5	a_1910_71##6	37.328922
Rg40	a_1910_71##5	a_1910_71##7	505.445740
Rg41	a_1492_74##5	a_1492_74##6	480.096283
Rg42	a_1295_74##10	a_1295_74##11	529.242615
Rg43	a_1295_74##11	a_1295_74##12	435.940521
Rg44	a_1492_74##7	a_1492_74##8	593.549866
Rg45	a_547_301##4	a_547_301##5	1184.660522
Rg46	a_547_301##5	a_547_301##6	245.891434
Rg47	a_2385_74#	a_2385_74##2	484.847717
Rg48	a_2385_74##2	a_2385_74##3	131.539062
Rg49	a_2385_74##2	a_2385_74##4	337.235657
Rg50	a_2385_74##3	a_2385_74##5	307.930420
Rg51	a_2385_74##3	a_2385_74##6	579.709839
Rf1	D#4	D	1.391894
Rf2	D#2	D#6	81.508293
Rf3	D#4	D#6	5.161376
Rf4	D#7	D	1.391894
Rf5	D#6	D#7	7.570019
Rf6	DE	DE#3	167.318909
Rf7	a_159_404##4	a_159_404##6	198.539154
Rf8	a_159_404##6	a_159_404##2	51.274906
Rf9	a_159_404##6	a_159_404##8	44.937363
Rf10	a_159_404##2	a_159_404##9	91.626060
Rf11	a_547_301##2	a_547_301##8	170.468292
Rf12	a_27_74#	a_27_74##2	121.804634
Rf13	a_27_74##2	a_27_74##3	274.576874
Rf14	a_27_74##3	a_27_74##4	17.971626
Rf15	a_27_74##2	a_27_74##5	21.310108
Rf16	a_27_74##3	a_27_74##6	139.484406
Rf17	SCE#3	SCE	162.201172
Rf18	SCD	SCD#4	0.880183
Rf19	SCD#5	SCD#2	161.112991
Rf20	SCD#4	SCD#5	10.465661
Rf21	a_639_85##5	a_639_85##7	193.063843
Rf22	a_639_85##7	a_639_85##8	41.957123
Rf23	a_639_85##7	a_639_85##9	46.810741
Rf24	a_639_85##8	a_639_85##10	36.461548
Rf25	CLK#2	CLK	163.775864
Rf26	a_1295_74##5	a_1295_74##15	178.404373
Rf27	a_1295_74##15	a_1295_74##16	95.099060
Rf28	a_1295_74##14	a_1295_74##15	15.000000
Rf29	a_669_111#	a_669_111##2	93.722176
Rf30	a_669_111##2	a_669_111##3	119.020882
Rf31	a_669_111##3	a_669_111##4	14.815279
Rf32	a_669_111##4	a_669_111##6	200.924866
Rf33	a_669_111##6	a_669_111##7	139.328842
Rf34	a_669_111##2	a_669_111##8	132.625778
Rf35	a_669_111##3	a_669_111##9	131.242706
Rf36	a_669_111##4	a_669_111##10	11.055597
Rf37	a_669_111##5	a_669_111##6	7.500000
Rf38	a_1688_97##4	a_1688_97##5	83.216507
Rf39	a_1688_97##5	a_1688_97##6	80.244347
Rf40	a_1688_97##5	a_1688_97##2	252.741272
Rf41	a_1910_71##8	a_1910_71##9	81.127708
Rf42	a_1910_71##9	a_1910_71##2	228.341736
Rf43	a_1910_71##9	a_1910_71##11	62.379623
Rf44	a_1910_71##9	a_1910_71##6	101.921631
Rf45	a_1295_74##11	a_1295_74##6	597.495178
Rf46	a_1492_74##8	a_1492_74##10	235.462997
Rf47	a_1492_74##10	a_1492_74##11	250.909088
Rf48	a_1492_74##11	a_1492_74##12	87.048958
Rf49	a_1492_74##12	a_1492_74##2	122.825584
Rf50	a_1492_74##10	a_1492_74##6	179.775497
Rf51	a_1492_74##11	a_1492_74##3	173.052750
Rf52	a_1492_74##12	a_1492_74##16	84.807930
Rf53	a_1492_74##2	a_1492_74##17	26.830551
Rf54	a_2385_74##3	a_2385_74##8	226.347321
Rf55	a_2385_74##8	a_2385_74##9	155.549606
Rf56	a_2385_74##8	a_2385_74##10	65.528854
Rf57	a_547_301##9	a_547_301##10	86.974144
Rf58	a_547_301##10	a_547_301##11	28.201635
Rf59	a_547_301##11	a_547_301##5	192.065430
Rf60	a_547_301##11	a_547_301##13	24.144201
Rf61	Q	Q#2	0.191323
Rf62	Q#2	Q	13.966559
Rf63	Q	Q#4	7.078941
Rf64	Q#4	Q	7.078941
Rf65	Q#1	Q#2	5.000000
Rf66	Q#3	Q#4	7.500000
Rf67	VPWR#1	VPWR#2	100.268669
Rf68	VPWR#2	VPWR#3	61.479885
Rf69	VPWR#3	VPWR#4	181.623413
Rf70	VPWR#4	VPWR#5	73.135536
Rf71	VPWR#5	VPWR#6	177.232498
Rf72	VPWR#6	VPWR#7	98.569107
Rf73	VPWR#7	VPWR#8	96.434937
Rf74	VPWR#8	VPWR#9	120.200882
Rf75	VPWR#9	VPWR#10	62.125736
Rf76	VPWR#10	VPWR#11	105.258347
Rf78	VPWR#3	VPWR#13	27.459908
Rf79	VPWR#4	VPWR#14	31.948624
Rf80	VPWR#5	VPWR#15	35.446526
Rf81	VPWR#6	VPWR#16	33.129639
Rf82	VPWR#7	VPWR#17	34.310661
Rf83	VPWR#8	VPWR#18	39.585419
Rf84	VPWR#10	VPWR#19	37.794724
Rf85	VPWR#11	VPWR#20	37.538910
Rf86	VGND#1	VGND#2	92.317253
Rf87	VGND#2	VGND#3	82.387344
Rf88	VGND#3	VGND#4	143.782578
Rf89	VGND#4	VGND#5	90.250175
Rf90	VGND#3	VGND#7	6.050352
Rf91	VGND#7	VGND#6	15.000000
Rf92	VGND#4	VGND#8	37.027283
Rf93	VGND#5	VGND#9	214.963074
Rf94	VGND#9	VGND#10	74.511719
Rf95	VGND#10	VGND#11	92.831688
Rf96	VGND#11	VGND#12	111.069572
Rf97	VGND#12	VGND#13	82.157272
Rf98	VGND#13	VGND#14	72.270927
Rf100	VGND#5	VGND#16	41.644516
Rf101	VGND#9	VGND#17	33.326477
Rf102	VGND#10	VGND#18	43.629364
Rf103	VGND#11	VGND#19	51.864471
Rf104	VGND#13	VGND#20	41.790440
Rf105	VGND#14	VGND#21	34.507496
Rf106	VGND#6	VGND#7	15.000000
Rf115	a_639_85#	a_639_85##8	32.046562
Re1	a_547_301##10	a_547_301##8	39.119308
Re2	VPWR#2	VPWR#22	4.103880
Re3	VPWR#22	VPWR	0.921908
Re4	VPWR	VPWR#9	2.357848
Re5	VGND#2	VGND#23	4.103880
Re6	VGND#23	VGND	0.921908
Re7	VGND	VGND#12	2.357848
Re11	VPWR#5	VPWR#22	0.698413
Re14	VGND#5	VGND#23	0.698413
*
*       CAPACITOR CARDS
*
*
C1	a_547_301##10	VPWR#15	2.34344e-18
C2	a_639_85##9	a_547_301#	1.49488e-20
C3	DE#7	a_159_404##3	3.37955e-17
C4	a_547_301##10	a_1688_97##5	4.82231e-17
C5	a_159_404##6	SCE#5	9.09117e-20
C6	a_27_74##6	DE#5	5.49882e-18
C7	VGND#8	a_1910_71##4	4.35015e-17
C8	a_547_301##8	DE#1	8.63965e-18
C9	a_27_74##2	a_639_85##2	4.28415e-19
C10	a_639_85##5	a_669_111##4	1.33892e-16
C11	SCE#5	a_27_74##5	6.58839e-18
C12	VPWR#9	a_547_301#	1.58247e-17
C13	VGND#20	a_27_74#	1.91755e-17
C14	a_1688_97##2	a_1910_71##7	1.94205e-18
C15	VGND#12	SCE#5	1.73785e-19
C16	VPWR#6	a_1295_74##8	9.55127e-19
C17	a_639_85##5	SCE#2	9.35398e-20
C18	VGND#13	DE#7	3.30294e-18
C19	SCE#1	SCD#2	6.4545e-19
C20	a_547_301##10	VPWR#2	1.84148e-17
C21	a_669_111##5	a_547_301#	2.0631e-18
C22	a_27_74##2	a_669_111##5	6.28529e-17
C23	VGND#8	a_1910_71##6	1.744e-18
C24	a_1492_74##10	a_1688_97#	2.38716e-18
C25	VPWR#9	DE#1	4.51793e-18
C26	a_159_404##2	VPWR#20	1.52588e-18
C27	a_1910_71##11	a_1910_71##4	4.21956e-19
C28	VGND#4	VGND#3	1.64415e-20
C29	VGND#2	a_547_301##10	1.95053e-17
C30	a_547_301##10	a_1688_97##6	1.83122e-18
C31	a_1295_74##5	a_1295_74##2	1.3337e-18
C32	a_27_74##5	a_547_301#	2.9905e-17
C33	a_27_74##2	DE#1	2.65878e-17
C34	a_27_74##6	D#1	2.93745e-17
C35	VPWR#9	DE#6	4.43763e-18
C36	VGND#12	a_159_404##9	1.46454e-17
C37	VGND#12	DE#1	9.62486e-20
C38	a_27_74##6	a_27_74##3	1.33309e-18
C39	VPWR#19	SCE#5	4.02351e-19
C40	VGND#5	a_1492_74##12	3.64919e-17
C41	VGND#8	a_1688_97#	4.82736e-19
C42	a_1910_71##2	a_1688_97##3	5.10232e-18
C43	a_159_404##6	a_547_301#	3.78026e-19
C44	DE#5	DE#7	3.64421e-18
C45	a_159_404##9	a_27_74#	2.94737e-18
C46	VGND#18	a_669_111##4	7.32795e-19
C47	a_669_111##5	DE#1	3.75866e-19
C48	a_1492_74##11	a_1910_71##3	3.38285e-17
C49	a_547_301##10	VPWR#5	5.17978e-18
C50	VGND#5	a_1295_74##2	4.47275e-20
C51	VPWR#7	CLK#1	3.55177e-18
C52	a_547_301##10	a_669_111#	3.25028e-18
C53	a_159_404##9	a_159_404##6	2.76474e-18
C54	SCE#3	SCD#3	6.91452e-18
C55	VGND#3	VGND#1	1.14372e-18
C56	a_1295_74##6	a_1910_71##7	3.41337e-19
C57	VPWR#9	a_159_404#	6.48702e-19
C58	a_669_111##4	SCD#2	5.29495e-19
C59	a_1295_74##16	a_1295_74##2	2.50808e-19
C60	VGND#5	a_1492_74##11	4.73793e-17
C61	a_27_74##2	a_27_74##5	2.73037e-18
C62	a_1295_74##6	a_1688_97##3	3.15742e-17
C63	a_547_301##10	VGND#5	5.51363e-18
C64	a_27_74##3	DE#6	2.32331e-18
C65	a_27_74##5	DE#1	2.8275e-18
C66	a_1688_97##6	VPWR#15	8.92753e-18
C67	VPWR#9	D#3	1.43042e-18
C68	a_1688_97#	a_1910_71##11	9.81351e-18
C69	VPWR#19	a_547_301#	2.6482e-18
C70	VGND#13	DE#5	1.09254e-18
C71	a_1492_74##12	a_1492_74##4	4.42914e-18
C72	VGND#5	a_1492_74##10	1.50875e-17
C73	a_1295_74##6	a_1910_71#	5.1807e-17
C74	SCD#4	CLK#2	2.9162e-19
C75	a_639_85##7	a_639_85##5	1.42853e-18
C76	a_27_74##2	DE#6	3.34991e-17
C77	VGND#12	a_27_74##6	2.16779e-17
C78	VPWR#8	a_639_85##4	3.72621e-18
C79	a_1295_74##6	a_1295_74##7	3.87546e-18
C80	D#1	DE#5	4.20041e-17
C81	VPWR#3	a_2385_74##3	3.02084e-21
C82	a_27_74##5	DE#6	3.79243e-19
C83	a_547_301##8	a_1492_74##12	1.17753e-18
C84	a_1688_97#	VGND#16	2.17947e-17
C85	a_669_111##2	VPWR#7	1.45314e-18
C86	a_669_111##9	a_669_111##4	1.00859e-18
C87	a_1492_74##12	a_1492_74##11	3.09956e-18
C88	a_1492_74##11	a_1492_74##4	1.43692e-17
C89	VPWR#19	DE#1	3.05441e-17
C90	a_1688_97##5	a_1688_97##6	2.07873e-18
C91	a_547_301##8	a_1295_74##3	9.47614e-19
C92	a_669_111##4	SCE#3	4.49027e-19
C93	VPWR#7	a_639_85##4	1.42067e-18
C94	a_27_74##3	a_159_404#	2.77371e-17
C95	a_1295_74##8	a_1295_74##6	7.99352e-19
C96	SCD#5	a_639_85##5	5.20039e-17
C97	a_547_301##8	a_1295_74##2	1.99245e-18
C98	a_159_404##9	VGND#20	3.83381e-17
C99	a_1492_74##12	a_1295_74#	4.00199e-17
C100	SCD#4	a_639_85##5	4.01191e-18
C101	VGND#16	a_1910_71##2	2.06158e-18
C102	a_27_74##2	a_159_404#	1.00991e-19
C103	a_1492_74##2	a_1295_74##7	6.49796e-19
C104	a_639_85##7	SCD#2	7.68434e-19
C105	a_1688_97##6	VPWR#5	2.13552e-17
C106	a_1910_71##9	a_1910_71##4	2.63669e-19
C107	DE#6	VPWR#19	2.29074e-17
C108	a_547_301##10	a_2385_74##3	8.95466e-17
C109	VPWR#1	a_2385_74#	3.15902e-17
C110	VGND#11	SCD#4	1.58402e-18
C111	a_1910_71##3	VGND#16	1.21769e-17
C112	a_159_404##3	a_547_301##2	3.45448e-19
C113	VPWR#8	SCD#1	3.64923e-18
C114	DE#7	DE#2	7.71918e-19
C115	a_669_111##2	VPWR#6	6.18428e-18
C116	VPWR#2	a_2385_74##3	1.62321e-18
C117	a_2385_74##10	VPWR#3	2.58542e-17
C118	a_547_301##10	a_547_301##5	1.02455e-17
C119	DE#6	a_159_404##8	9.208e-18
C120	a_547_301##5	VPWR#3	2.22665e-18
C121	VGND#3	a_1295_74##11	5.24515e-20
C122	a_1492_74##10	a_2385_74##9	4.44808e-17
C123	a_1688_97##5	a_669_111#	2.13783e-18
C124	a_1492_74##11	a_1295_74#	5.151e-19
C125	a_2385_74#	Q#1	3.15727e-17
C126	a_1295_74##8	a_1492_74##2	1.13979e-17
C127	a_27_74##2	VPWR#19	6.48815e-17
C128	a_547_301##11	a_547_301##13	3.35464e-19
C129	VGND#21	VGND#20	5.13642e-18
C130	a_27_74##3	D#3	4.38511e-17
C131	VGND#2	a_2385_74##3	6.20848e-18
C132	VPWR#2	a_547_301##5	2.43067e-18
C133	SCD#5	SCD#2	1.32596e-17
C134	a_547_301##10	a_1492_74##8	2.45593e-17
C135	a_669_111#	a_1688_97##6	2.9785e-17
C136	VGND#3	a_547_301##9	3.08783e-17
C137	a_1492_74##2	CLK#1	1.88755e-20
C138	VGND#13	DE#4	5.87832e-19
C139	a_2385_74##3	a_547_301##11	2.57267e-18
C140	VPWR#20	DE#6	4.8684e-19
C141	VPWR#1	a_2385_74##6	9.66653e-19
C142	a_2385_74##8	a_2385_74##2	1.13381e-20
C143	a_27_74##3	a_159_404##8	5.15509e-17
C144	a_547_301##8	VPWR#9	7.72099e-17
C145	DE#7	a_159_404##4	4.31273e-18
C146	a_1295_74##5	a_1295_74##8	1.31129e-17
C147	SCD#4	SCD#2	8.01839e-18
C148	a_1910_71##9	a_1910_71##7	6.76942e-20
C149	a_547_301##13	a_2385_74#	2.14249e-18
C150	VGND#4	a_1492_74##10	3.094e-17
C151	VPWR#13	a_2385_74##3	8.33173e-19
C152	a_159_404##8	a_159_404#	4.29846e-19
C153	a_639_85##7	SCE#3	5.37336e-18
C154	VGND#16	a_1492_74##4	1.96237e-18
C155	a_1492_74##12	a_1295_74##9	3.94709e-19
C156	a_2385_74##8	a_2385_74##3	4.66634e-17
C157	a_159_404##6	a_159_404#	3.33219e-19
C158	a_547_301##10	a_1295_74##11	4.98539e-17
C159	a_1910_71##9	a_1688_97#	7.41411e-18
C160	CLK#1	a_1295_74##5	1.43082e-17
C161	VGND#3	a_2385_74##4	1.14887e-18
C162	VGND#13	DE#1	5.49479e-19
C163	VGND#12	a_547_301##8	8.23101e-17
C164	a_2385_74##5	a_2385_74##4	3.3107e-18
C165	VGND#4	a_1492_74##6	1.72446e-19
C166	VGND#21	a_159_404##9	3.1677e-17
C167	VPWR#20	a_159_404#	3.43126e-17
C168	a_547_301##10	a_1492_74##6	3.43559e-17
C169	VPWR#8	SCE#4	1.32764e-17
C170	a_547_301##13	a_547_301##5	1.11878e-19
C171	VPWR#13	a_2385_74#	1.22128e-18
C172	VGND#9	a_1295_74##3	1.17325e-19
C173	a_27_74##2	a_159_404##8	4.88713e-17
C174	VGND#13	a_159_404##9	4.52736e-18
C175	a_547_301##11	VPWR#3	2.49924e-19
C176	a_159_404##2	a_547_301##3	8.36935e-20
C177	VPWR#1	a_547_301##6	2.16419e-19
C178	a_1492_74##11	a_1492_74##10	3.09956e-18
C179	VPWR#3	a_1492_74##8	3.94737e-19
C180	a_2385_74##10	a_2385_74##3	1.11545e-19
C181	SCD#5	SCE#3	4.61397e-18
C182	a_547_301##11	VPWR#13	1.0198e-17
C183	a_547_301##13	a_2385_74##6	4.0858e-17
C184	a_159_404##2	a_159_404##3	6.05721e-20
C185	a_547_301##8	a_669_111#	7.40314e-19
C186	a_159_404##6	DE#7	1.05676e-18
C187	a_547_301##5	VPWR#13	2.7075e-17
C188	a_547_301##10	a_1910_71##6	2.94624e-17
C189	VPWR#7	SCE#4	1.24256e-19
C190	a_27_74##3	VPWR#20	7.56409e-17
C191	a_547_301##11	a_547_301##5	2.65786e-19
C192	SCD#4	SCE#3	1.95634e-18
C193	VGND#3	VGND#6	9.11835e-18
C194	VPWR#20	D#3	4.69187e-18
C195	a_639_85##5	CLK#1	7.15211e-18
C196	VGND#13	DE#2	6.99155e-19
C197	a_159_404##6	D#3	5.34382e-19
C198	a_547_301##8	a_1492_74##17	1.42744e-17
C199	a_2385_74##6	a_2385_74#	6.24723e-18
C200	a_159_404##2	DE#5	2.9527e-17
C201	a_1688_97##4	a_1492_74##4	6.11928e-18
C202	a_669_111#	a_1492_74##17	4.86298e-18
C203	a_547_301##10	a_1688_97##2	4.6662e-17
C204	a_669_111##2	a_1688_97##6	1.14686e-17
C205	a_2385_74##6	VPWR#13	2.10935e-17
C206	VPWR#9	DE#2	1.78452e-22
C207	a_2385_74##8	a_547_301##5	7.95873e-17
C208	a_1688_97##4	a_1492_74##3	4.30576e-18
C209	VPWR#10	SCE#5	1.19009e-18
C210	a_2385_74##10	a_547_301##5	3.06116e-17
C211	a_547_301##8	VPWR#16	3.8167e-18
C212	a_2385_74##10	a_2385_74#	1.0649e-19
C213	VGND#3	a_2385_74##5	1.49648e-17
C214	a_1295_74##11	VPWR#4	1.16582e-17
C215	a_547_301##4	a_2385_74##5	7.04278e-18
C216	a_547_301##13	a_547_301##6	1.57733e-18
C217	a_639_85##5	SCD#1	1.60809e-17
C218	a_547_301##10	a_1910_71##2	1.64239e-17
C219	VGND#4	a_1910_71##6	4.69744e-19
C220	D#2	DE#5	2.16922e-17
C221	a_1492_74##10	VGND#8	6.37595e-17
C222	a_2385_74##8	VPWR#3	5.81685e-19
C223	a_547_301##8	a_1295_74##14	3.98117e-17
C224	D#3	a_27_74##4	6.65453e-18
C225	VGND#9	a_1295_74##2	1.95099e-20
C226	a_1295_74##11	VPWR#3	3.42828e-19
C227	VGND#21	VGND#13	2.98863e-18
C228	a_547_301##5	a_2385_74##3	2.61684e-17
C229	VPWR#16	a_669_111#	2.6707e-17
C230	a_547_301##10	a_1295_74##6	2.35185e-17
C231	a_1492_74##16	a_669_111##8	5.18871e-17
C232	a_1492_74##11	a_1910_71##11	3.67057e-17
C233	a_1688_97##5	a_1688_97##3	1.17391e-19
C234	a_27_74##6	a_159_404##9	3.76408e-19
C235	a_547_301##6	VPWR#13	2.28854e-17
C236	a_1295_74#	a_1688_97##4	1.50285e-17
C237	a_2385_74##3	a_2385_74##2	4.03298e-19
C238	a_547_301##6	a_2385_74##6	1.09387e-17
C239	a_547_301##8	VPWR#17	3.28827e-18
C240	a_639_85##7	a_547_301##2	1.41086e-19
C241	VGND#4	a_547_301##4	8.65929e-20
C242	a_547_301##11	a_1492_74##8	1.29668e-19
C243	a_1492_74##2	a_1688_97##4	9.37269e-18
C244	a_2385_74##10	a_1492_74##8	4.55244e-17
C245	SCE#4	SCD#2	1.80736e-18
C246	a_2385_74##10	a_2385_74##6	2.55945e-18
C247	a_547_301##8	a_669_111##4	3.90047e-17
C248	a_547_301##10	a_1492_74##3	1.40491e-18
C249	a_547_301##13	a_1492_74##7	3.51668e-19
C250	VGND#5	a_1688_97##2	1.26143e-20
C251	VPWR#5	a_1910_71##2	1.05099e-19
C252	a_669_111##8	a_1492_74##2	4.30008e-17
C253	a_1492_74##8	a_2385_74##8	5.08463e-17
C254	VGND#12	DE#4	1.86542e-18
C255	VPWR#9	a_1295_74##14	1.75667e-18
C256	a_1492_74##8	a_547_301##5	3.8277e-17
C257	VPWR#10	a_547_301#	7.8712e-19
C258	VGND#4	a_2385_74##9	1.11175e-17
C259	a_1295_74#	a_669_111##8	2.66035e-17
C260	a_547_301##10	a_1492_74##2	3.47105e-17
C261	a_1295_74##10	a_547_301##4	4.68028e-17
C262	VGND#3	a_547_301##4	2.98747e-17
C263	VPWR#4	a_1492_74##6	1.86535e-19
C264	a_669_111##4	a_669_111##2	1.17504e-18
C265	a_1295_74##6	VPWR#5	7.18464e-18
C266	a_27_74##6	VGND#21	1.23301e-17
C267	VPWR#13	a_1492_74##7	2.97201e-18
C268	VGND#12	DE#2	7.42399e-19
C269	a_1295_74##11	a_547_301##5	2.62145e-19
C270	a_1492_74##10	a_1910_71##11	5.64085e-17
C271	a_1295_74##11	a_2385_74##10	7.5418e-17
C272	a_27_74##3	a_27_74##4	3.23292e-18
C273	a_547_301##8	a_669_111##2	4.35198e-17
C274	VPWR#8	a_547_301#	1.8874e-19
C275	a_2385_74##10	a_547_301##6	6.35365e-18
C276	VGND#5	a_1295_74##6	1.59542e-19
C277	a_1492_74##7	a_547_301##6	2.6688e-17
C278	a_1492_74##11	VGND#16	8.2751e-17
C279	a_547_301##8	VPWR#18	1.64743e-18
C280	a_2385_74##10	a_547_301##11	1.01594e-18
C281	a_547_301##4	a_2487_74#	8.30758e-18
C282	a_1492_74##8	a_1295_74##11	9.88825e-17
C283	VGND#12	a_1295_74##14	5.99451e-19
C284	a_1492_74##16	a_1295_74#	1.94951e-18
C285	a_1295_74##10	a_2487_74#	8.30758e-18
C286	a_669_111##8	a_1295_74##5	5.41666e-19
C287	VPWR#9	a_669_111##4	3.17827e-17
C288	VGND#5	a_1492_74##3	5.43228e-19
C289	a_669_111##2	a_1492_74##17	5.67859e-17
C290	VGND#4	a_1295_74##10	1.38176e-19
C291	a_547_301##10	a_2385_74##4	1.21396e-19
C292	a_547_301##2	SCE#4	4.43317e-19
C293	a_1492_74##6	a_1492_74##8	1.09374e-18
C294	a_547_301##8	a_639_85##9	2.38691e-18
C295	a_669_111##8	a_1295_74##9	3.5679e-18
C296	a_1295_74##11	VPWR#14	1.9707e-17
C297	VPWR#13	a_1295_74##12	8.47106e-19
C298	VGND#3	a_2385_74##9	4.59738e-17
C299	a_1492_74##16	a_1295_74##5	5.48092e-19
C300	a_1295_74##11	a_2385_74##8	1.08632e-18
C301	a_547_301##6	a_2568_508#	1.06762e-17
C302	a_27_74##2	a_547_301##2	1.21012e-17
C303	VGND#17	a_1492_74##16	4.13232e-17
C304	a_1295_74##16	a_669_111##8	4.56413e-18
C305	a_2385_74##10	a_1492_74##7	4.815e-17
C306	a_1492_74##6	a_1295_74##11	8.51228e-17
C307	VGND#17	a_1295_74#	2.58215e-19
C308	a_547_301##8	a_669_111##5	1.77703e-17
C309	VPWR#10	DE#1	7.02999e-18
C310	VGND#17	a_1295_74##5	4.2589e-18
C311	a_1492_74##7	a_2568_508#	1.06762e-17
C312	a_1910_71##8	a_1295_74##11	7.31103e-18
C313	a_159_404##4	SCE#4	1.9417e-19
C314	VPWR#14	a_547_301##6	2.1639e-19
C315	a_1492_74##5	a_1295_74##10	2.66151e-17
C316	VPWR#4	a_1910_71##6	2.57835e-19
C317	VGND#3	a_1295_74##10	8.94676e-18
C318	a_1295_74##12	a_1492_74##7	2.96157e-17
C319	a_1910_71##6	a_1295_74##11	4.4601e-18
C320	a_669_111##8	a_1492_74##17	2.21861e-17
C321	a_1492_74##16	a_1295_74##9	2.12083e-17
C322	a_1295_74##16	a_1295_74##5	5.22287e-19
C323	a_547_301##2	DE#1	4.53801e-18
C324	VPWR#9	a_639_85##9	6.07896e-18
C325	a_547_301##10	a_547_301##4	8.2874e-19
C326	a_669_111##4	a_1295_74##14	4.45905e-17
C327	a_669_111##8	CLK#2	4.94409e-19
C328	a_159_404##4	a_547_301#	3.05037e-19
C329	VPWR#13	a_1910_71##7	4.8328e-19
C330	a_547_301##8	a_1295_74##5	1.86144e-17
C331	a_1688_97##5	a_1295_74##2	1.41068e-17
C332	a_1910_71##6	a_1492_74##6	5.32353e-17
C333	a_1295_74##16	a_1295_74#	5.95494e-19
C334	a_1295_74##11	a_1688_97##2	1.73679e-19
C335	a_669_111##8	CLK#3	5.73216e-20
C336	a_669_111##5	VPWR#9	9.50303e-17
C337	a_669_111##2	VPWR#16	5.30858e-17
C338	a_2385_74##10	a_1295_74##12	2.25186e-17
C339	a_1295_74##12	a_2274_392#	3.36506e-17
C340	a_159_404##4	DE#1	1.07653e-17
C341	a_1492_74##12	a_1688_97##4	6.68205e-17
C342	a_1688_97##5	a_1295_74#	2.19849e-19
C343	a_1910_71##8	a_1492_74##6	3.32024e-18
C344	a_1295_74##16	a_1492_74##16	1.75612e-17
C345	a_1492_74##10	a_1492_74##8	1.31959e-18
C346	a_1492_74##5	a_2313_74#	1.02147e-17
C347	a_1492_74##6	a_1688_97##2	7.002e-19
C348	a_547_301##8	a_639_85##7	6.13069e-17
C349	VGND#17	a_1295_74##9	3.91557e-17
C350	VGND#2	a_2385_74##4	9.80661e-18
C351	a_547_301##8	CLK#2	2.07027e-17
C352	VGND#4	a_1492_74##5	5.59965e-18
C353	VPWR#14	a_1492_74##7	7.7403e-19
C354	a_1910_71##7	a_2274_392#	1.93009e-17
C355	a_159_404##4	a_27_74##2	4.10898e-17
C356	VPWR#17	VPWR#16	6.74409e-18
C357	a_1910_71##4	a_2313_74#	1.25705e-17
C358	a_27_74##5	VPWR#9	3.01715e-17
C359	a_547_301##8	VPWR#19	2.10471e-18
C360	VPWR#9	CLK#2	2.8782e-18
C361	a_1688_97##2	a_1910_71##6	2.01352e-17
C362	CLK#2	a_1295_74##16	9.00184e-18
C363	a_1492_74##16	CLK#3	7.35161e-19
C364	a_1910_71##7	a_1295_74##12	8.94454e-18
C365	a_547_301##8	a_639_85##5	4.97696e-17
C366	VPWR#14	a_1910_71##6	7.21225e-19
C367	VPWR#10	DE#6	6.14426e-18
C368	a_1910_71##4	a_1492_74##5	5.18992e-17
C369	a_639_85##2	SCE#5	1.47105e-18
C370	a_1295_74##16	a_1295_74##9	1.07567e-17
C371	a_1910_71##2	a_1910_71##6	2.46144e-20
C372	a_1688_97##6	VPWR#6	1.06624e-18
C373	a_669_111##4	VPWR#17	6.65054e-17
C374	a_2385_74##10	a_1910_71##7	3.14926e-18
C375	VPWR#9	a_639_85##5	4.82896e-18
C376	VGND#3	a_1492_74##5	1.07551e-18
C377	a_547_301##8	SCD#2	3.15986e-20
C378	a_1688_97##4	a_1492_74##11	5.40424e-17
C379	VPWR#14	a_1295_74##12	2.73816e-18
C380	a_27_74##3	a_27_74##2	3.10847e-18
C381	a_669_111##9	CLK#2	2.17843e-17
C382	a_1295_74##16	VGND#17	3.19361e-17
C383	VGND#12	a_639_85##5	4.11052e-18
C384	a_27_74##3	DE#3	6.72016e-19
C385	a_1688_97##2	a_1910_71##2	1.06045e-16
C386	a_1910_71#	a_1890_508#	9.15884e-18
C387	a_1910_71##6	a_1295_74##6	3.62129e-18
C388	VGND#17	CLK#3	2.52256e-18
C389	a_669_111##2	a_1295_74##14	1.67366e-17
C390	a_547_301##8	SCD#5	3.41229e-17
C391	a_547_301##8	SCE#3	5.52457e-18
C392	a_1295_74##7	a_1890_508#	1.03857e-17
C393	VPWR#9	a_639_85##7	4.81432e-18
C394	a_1492_74##12	a_669_111##8	5.41536e-17
C395	VGND#18	a_1295_74##9	9.33298e-20
C396	a_1492_74##10	a_1295_74##11	2.49299e-17
C397	a_1688_97##2	a_1295_74##6	2.25403e-17
C398	VPWR#9	a_159_404##8	6.24073e-18
C399	a_1295_74##14	a_669_111##8	2.75579e-19
C400	a_1688_97##3	a_1910_71##7	6.34134e-18
C401	a_1910_71##8	a_1295_74##12	1.02465e-18
C402	D#3	a_159_404##2	1.28574e-17
C403	VGND#4	a_1910_71##4	6.89015e-18
C404	a_669_111##2	a_1295_74##7	9.79818e-20
C405	a_2385_74##10	a_1688_97##3	7.12749e-19
C406	a_1295_74##6	a_1910_71##2	2.05332e-17
C407	a_1688_97##2	a_1910_71##8	1.68422e-17
C408	a_1295_74##16	CLK#3	5.19993e-17
C409	VGND#8	VGND#3	1.24314e-18
C410	a_27_74##3	DE#4	3.86476e-19
C411	VPWR#14	a_1910_71##7	4.3854e-17
C412	a_1910_71##3	a_1824_97#	1.40884e-18
C413	SCE#4	a_639_85##10	7.33783e-19
C414	VPWR#10	a_159_404#	1.44216e-19
C415	a_669_111##9	a_639_85##5	6.1129e-17
C416	a_1688_97#	a_1910_71##4	3.53252e-18
C417	VGND#19	a_639_85##7	1.93764e-18
C418	a_669_111##4	a_669_111##10	1.79535e-18
C419	VGND#18	VGND#17	5.49498e-19
C420	a_669_111##9	a_1295_74##9	8.26435e-19
C421	a_1492_74##3	a_1910_71##2	2.51638e-17
C422	DE#3	a_159_404##6	2.8405e-17
C423	VPWR#15	a_1688_97##2	3.39274e-19
C424	a_27_74##3	a_143_74#	3.01954e-18
C425	a_547_301##8	a_547_301##2	2.19005e-17
C426	a_1910_71#	a_1910_71##7	3.75207e-19
C427	a_1492_74##4	a_1824_97#	1.07802e-17
C428	a_547_301##10	a_547_301##9	7.16916e-19
C429	a_1688_97##5	a_1295_74##8	1.02822e-19
C430	VGND#17	SCE#1	9.17817e-20
C431	a_669_111#	VPWR#6	4.1992e-17
C432	a_27_74##3	a_159_404##2	6.40928e-17
C433	VGND#3	a_1910_71##4	3.45912e-19
C434	a_1492_74##3	a_1295_74##6	1.95573e-17
C435	a_1492_74##2	a_1910_71##2	1.91988e-19
C436	a_669_111##2	VPWR#17	1.6842e-20
C437	CLK#3	VGND#18	1.22161e-17
C438	a_1910_71##8	a_1910_71##7	6.57037e-18
C439	VGND#10	CLK	1.05736e-18
C440	VGND#1	VPWR#1	9.92097e-18
C441	VPWR#9	SCD#5	1.08975e-18
C442	a_547_301##8	a_159_404##4	4.90056e-17
C443	VGND#12	a_639_85##7	2.80777e-18
C444	VGND#12	a_547_301##2	1.07878e-19
C445	VGND#19	a_639_85##5	1.00063e-18
C446	a_1910_71##8	a_1910_71##2	6.6665e-19
C447	a_1910_71#	a_1688_97##3	3.21722e-17
C448	a_639_85##4	a_1053_455#	1.41674e-17
C449	DE#2	a_547_301##2	7.83064e-19
C450	a_1492_74##16	a_1492_74##12	2.62773e-18
C451	a_1295_74##6	a_1492_74##2	2.26211e-17
C452	VPWR#9	a_159_404##4	3.36001e-18
C453	a_1492_74##10	a_1492_74##6	4.0726e-18
C454	VPWR#14	a_1688_97##3	4.83906e-18
C455	a_1295_74##16	SCE#1	1.29162e-18
C456	SCD#1	a_1053_455#	1.41674e-17
C457	a_547_301##8	a_27_74##2	5.39667e-17
C458	DE#3	a_547_301##8	5.27219e-18
C459	a_669_111##2	a_1492_74#	1.93424e-18
C460	VPWR#15	a_1910_71##7	2.20634e-18
C461	a_27_74##3	DE#2	6.52136e-19
C462	VGND#12	a_159_404##4	4.17169e-18
C463	a_1492_74##2	a_1492_74##3	5.59156e-19
C464	a_669_111##9	SCD#2	7.76035e-19
C465	a_669_111##9	CLK#3	6.372e-18
C466	VGND#18	a_1295_74##16	5.39632e-17
C467	VGND#4	a_1688_97#	7.25249e-19
C468	VGND#17	a_1295_74##14	9.0695e-19
C469	VPWR#9	DE#3	3.09286e-18
C470	a_669_111##4	a_1295_74##8	7.72997e-19
C471	a_1295_74##6	VPWR#14	2.4281e-17
C472	a_547_301##8	a_159_404##2	2.02615e-18
C473	a_639_85##10	a_639_85##7	1.9336e-18
C474	a_1910_71##8	a_1688_97##3	3.89862e-17
C475	VGND#12	DE#3	1.98077e-18
C476	a_547_301##10	a_2385_74##9	8.64102e-18
C477	a_1910_71##3	a_1688_97#	9.24023e-18
C478	VGND#18	SCE#1	3.64222e-18
C479	a_1492_74##11	a_1910_71##9	1.3497e-17
C480	a_669_111##7	SCE#5	2.89017e-19
C481	a_27_74##3	D#2	1.37617e-17
C482	VGND#2	VGND#1	4.89414e-17
C483	a_1295_74##6	a_1910_71##8	5.3821e-17
C484	VPWR#9	a_159_404##2	7.2904e-18
C485	VGND#5	a_1910_71##4	1.07693e-19
C486	SCD#4	a_669_111##9	1.80804e-17
C487	a_1295_74##6	VPWR#4	4.18121e-18
C488	VPWR#14	a_1910_71#	2.00114e-18
C489	a_1492_74##2	a_1295_74##5	1.26039e-19
C490	VPWR#9	a_27_74##3	4.70903e-17
C491	a_2385_74##8	a_547_301##11	1.40271e-17
C492	a_1295_74##7	a_1910_71#	2.91229e-17
C493	a_1492_74##11	a_1910_71##6	3.47229e-19
C494	VGND#12	a_159_404##2	6.03238e-18
C495	a_1295_74##16	SCD#3	2.73001e-21
C496	a_1295_74##6	VPWR#15	4.05505e-17
C497	a_1688_97##3	VPWR#15	2.25403e-17
C498	a_547_301##10	VGND#9	4.68188e-19
C499	a_547_301#	a_554_463#	1.41968e-17
C500	a_1295_74##16	a_1295_74##14	1.81504e-18
C501	VGND#5	a_1688_97#	6.43354e-18
C502	a_27_74##2	VPWR#9	2.49089e-17
C503	a_669_111##9	SCE#3	2.41374e-20
C504	a_1688_97##6	a_1910_71##7	6.02166e-19
C505	a_669_111##9	SCE#1	4.39581e-17
C506	VGND#12	SCD#4	5.35888e-18
C507	a_669_111##9	a_1295_74##16	7.11667e-18
C508	a_1492_74##10	a_1910_71##6	9.14645e-17
C509	DE#1	a_554_463#	1.41968e-17
C510	a_1910_71##8	a_1910_71#	2.61758e-18
C511	a_669_111##2	a_1295_74##8	2.42586e-17
C512	DE#4	a_159_404##4	2.02134e-18
C513	VPWR#18	VPWR#17	1.82964e-18
C514	CLK#2	a_1295_74##5	6.7885e-18
C515	a_547_301##10	VGND#8	2.43227e-18
C516	a_639_85##7	a_669_111##4	3.16678e-17
C517	VPWR#7	VPWR#16	1.01355e-19
C518	VGND#2	a_547_301##9	3.48563e-17
C519	VPWR#13	VPWR#1	5.03831e-19
C520	VGND#19	CLK#3	5.15097e-19
C521	VGND#5	a_1910_71##3	4.60306e-18
C522	a_669_111##4	CLK#1	4.39247e-17
C523	VGND#18	SCD#3	2.94863e-19
C524	a_1688_97##6	a_1295_74##6	5.62059e-17
C525	a_2385_74##3	a_2385_74##4	1.67488e-18
C526	a_159_404##4	DE#2	3.53518e-17
C527	a_669_111##7	a_639_85##7	1.1309e-17
C528	a_159_404##6	a_27_74##3	4.40909e-18
C529	a_669_111##4	VPWR#18	4.47913e-17
C530	VPWR#15	a_1910_71#	2.44858e-17
C531	a_547_301##10	VGND#4	3.42561e-18
C532	a_1492_74##10	a_1910_71##9	3.29685e-18
C533	a_1492_74#	a_1295_74##7	1.88825e-17
C534	a_27_74##2	DE#2	5.14255e-18
C535	a_1492_74##4	a_1910_71##3	1.31863e-17
C536	VGND#5	a_1492_74##4	3.21523e-18
C537	a_1492_74##12	a_1688_97##5	2.78827e-19
C538	a_639_85##5	CLK#2	7.52024e-18
C539	a_1910_71##9	a_1492_74##6	1.31096e-18
C540	a_639_85##10	SCE#3	3.04467e-18
C541	VGND#9	a_1295_74##5	1.26651e-20
C542	a_1688_97##6	a_1688_97##3	1.09005e-18
C543	D	DE#4	1.16649e-19
C544	a_159_404#	a_114_464#	1.40434e-17
C545	DE#4	DE#2	1.66845e-19
C546	a_1295_74##9	a_1295_74##2	7.44827e-19
C547	a_2385_74##8	a_2385_74##4	3.3179e-19
C548	a_669_111##9	SCD#3	3.65916e-18
C549	a_669_111##9	VGND#18	4.18157e-17
C550	a_1492_74##11	a_1688_97##2	9.07015e-19
C551	a_547_301##10	VGND#16	1.56058e-18
C552	D#3	a_114_464#	1.46614e-17
C553	SCD#2	CLK#2	4.91665e-19
C554	a_547_301##10	VGND#3	1.07698e-17
C555	a_669_111##4	SCE#1	1.81698e-18
C556	a_547_301##4	a_2385_74##3	2.02589e-17
C557	VPWR#9	a_159_404##6	1.37287e-18
C558	SCE#1	a_1026_125#	8.8457e-18
C559	VGND#19	SCE#1	5.29044e-18
C560	a_2385_74##9	a_547_301##9	9.06919e-19
C561	VGND#11	SCE	1.33173e-18
C562	a_639_85##5	SCD#2	5.67344e-17
C563	SCD#3	a_1026_125#	8.8457e-18
C564	a_669_111##2	CLK#1	1.27428e-18
C565	VGND#18	SCE#2	2.49526e-19
C566	VPWR#15	a_1295_74##7	3.24145e-18
C567	VPWR#8	VPWR#7	7.21472e-19
C568	a_669_111##9	a_1295_74##14	1.91396e-19
C569	a_639_85##5	SCE#3	1.52649e-19
C570	a_669_111##4	a_639_85##4	3.56633e-17
C571	a_669_111##2	a_1295_74##3	1.44257e-17
C572	a_1688_97##6	a_1910_71#	3.96472e-18
C573	a_159_404##6	a_27_74##2	1.95438e-18
C574	a_1295_74##8	a_1492_74#	4.856e-18
C575	a_639_85##9	a_669_111##4	3.39794e-17
C576	a_547_301##4	a_547_301##5	1.14357e-18
C577	SCE#3	SCD#2	3.27801e-17
C578	VGND#19	SCD#4	1.71651e-17
C579	DE#3	DE#4	4.27489e-18
C580	a_669_111##9	SCE#2	1.17469e-19
C581	VPWR#3	a_2385_74##6	2.56012e-18
C582	VGND#10	CLK#2	8.46656e-20
C583	a_1295_74#	a_1492_74##4	9.32469e-18
C584	a_27_74#	DE#4	6.31072e-19
C585	a_1688_97##5	a_1492_74##11	2.54509e-17
C586	a_1688_97##6	a_1492_74##2	3.14787e-17
C587	a_1910_71##9	a_1910_71##6	1.3808e-17
C588	a_1295_74##11	a_2274_392#	1.29108e-17
C589	VPWR#13	a_547_301##13	3.2122e-17
C590	VPWR#6	a_1492_74##2	5.47026e-19
C591	VGND#9	a_1295_74#	3.27853e-18
C592	VGND#19	SCD#3	2.92052e-17
C593	a_1492_74##6	a_2274_392#	4.32177e-18
C594	VPWR#8	VPWR#17	6.53097e-19
C595	VGND#11	VGND#10	1.7052e-18
C596	VGND#9	CLK#2	7.38635e-20
C597	VPWR#15	a_1492_74#	8.3317e-19
C598	a_2385_74##8	a_2385_74##5	1.84469e-18
C599	a_1492_74##11	a_1910_71##2	7.52071e-17
C600	a_1492_74##2	a_669_111#	1.98777e-17
C601	Q	a_2385_74##2	4.63675e-17
C602	a_1688_97##6	a_1295_74##7	2.97967e-17
C603	a_547_301##4	a_1492_74##8	3.52671e-17
C604	a_669_111##2	a_639_85##4	1.26294e-19
C605	a_669_111##4	a_1053_455#	2.30527e-18
C606	CLK#1	a_1295_74##8	2.38445e-18
C607	VGND#20	DE#1	1.46828e-19
C608	a_1688_97##5	a_1910_71##6	2.31812e-19
C609	a_669_111##4	SCD#1	2.39534e-17
C610	a_639_85##10	SCD#3	1.17573e-18
C611	a_669_111##2	a_1295_74##2	4.94076e-19
C612	a_547_301##8	SCE#1	2.2923e-18
C613	a_669_111##7	a_547_301##2	7.412e-19
C614	VGND#10	a_1295_74##9	5.00952e-19
C615	VGND#19	VGND#18	3.43311e-18
C616	a_669_111#	a_1295_74##7	7.2959e-19
C617	VGND#1	a_2385_74##4	2.5566e-17
C618	VPWR#15	a_1295_74##8	3.89229e-19
C619	SCE#2	VGND#19	1.0729e-17
C620	VGND#11	a_639_85##5	4.90355e-20
C621	VPWR#16	a_1910_71#	2.33139e-19
C622	a_1295_74##11	a_547_301##4	9.02997e-19
C623	a_27_74#	a_547_301##2	2.00728e-17
C624	a_1295_74##16	CLK	4.10132e-17
C625	a_1688_97##6	a_1492_74#	1.74559e-17
C626	a_1295_74##9	a_1295_74#	5.82961e-18
C627	a_1910_71##9	a_1688_97##2	4.7508e-17
C628	a_1492_74##12	a_1295_74##6	7.83078e-20
C629	VPWR#3	a_547_301##6	8.60927e-18
C630	a_159_404#	DE#2	4.6406e-19
C631	a_547_301##11	a_2385_74#	1.02408e-18
C632	a_669_111##9	CLK	2.47405e-17
C633	a_1295_74##6	a_1890_508#	2.93397e-18
C634	a_159_404##4	a_547_301##2	4.34457e-17
C635	VGND#9	a_1492_74##16	4.38825e-17
C636	VPWR#19	DE#2	4.23615e-19
C637	VGND#10	a_639_85##5	1.41885e-19
C638	VPWR#6	a_1295_74##5	1.76533e-18
C639	a_27_74##2	VPWR#10	3.69892e-17
C640	SCE	a_639_85##7	9.10845e-18
C641	a_669_111##4	SCE#2	1.6783e-19
C642	a_547_301##10	VPWR#6	1.79351e-18
C643	VGND#9	a_1295_74##9	4.74786e-18
C644	a_1492_74##12	a_1295_74##3	7.03533e-20
C645	a_639_85##4	CLK#1	5.72179e-18
C646	a_159_404##2	DE#4	2.00502e-17
C647	a_1492_74##11	a_1295_74##6	5.16844e-18
C648	a_2385_74##8	a_547_301##4	2.33502e-17
C649	a_547_301##8	SCE#2	9.48785e-20
C650	DE#3	a_547_301##2	2.72786e-19
C651	SCE	SCD#5	7.0888e-18
C652	VPWR#16	a_1295_74##5	5.28007e-19
C653	SCE	SCD#4	1.96805e-17
C654	a_669_111#	a_1492_74#	1.99692e-17
C655	VGND#11	CLK#3	4.93471e-19
C656	a_639_85##10	SCE#2	2.82158e-17
C657	a_2385_74##4	Q#3	2.0459e-17
C658	a_2385_74##10	a_547_301##13	3.3603e-18
C659	a_159_404##2	DE#2	1.13017e-17
C660	a_1492_74##5	a_1295_74##11	4.0488e-18
C661	VGND#19	a_669_111##9	1.56439e-17
C662	VGND#10	VGND#17	8.94732e-19
C663	DE#3	a_159_404##4	5.71474e-17
C664	a_2385_74##8	a_2385_74#	1.73624e-19
C665	VGND#2	VGND#3	5.19359e-17
C666	a_547_301##10	a_2385_74#	2.61625e-18
C667	a_159_404##2	a_547_301##2	1.2041e-19
C668	a_1688_97##5	a_1688_97##2	2.08795e-18
C669	a_547_301##10	VPWR#4	6.76837e-18
C670	VPWR#16	a_1295_74##7	3.50345e-19
C671	a_669_111##5	VPWR#18	3.7808e-17
C672	a_1295_74##14	a_1295_74##5	4.66908e-18
C673	a_547_301##8	a_639_85##2	8.80603e-19
C674	a_669_111##4	SCE#4	1.27023e-17
C675	a_547_301##3	a_505_111#	9.87534e-18
C676	a_1688_97##6	a_1295_74##8	1.43286e-18
C677	a_27_74#	a_159_404##4	1.13294e-18
C678	VGND#12	SCE#1	3.90767e-18
C679	a_159_404##2	a_159_404##4	3.4746e-18
C680	VGND#1	a_2385_74##5	1.00051e-18
C681	a_159_404##3	a_505_111#	9.87534e-18
C682	VPWR#7	VPWR#6	6.36506e-19
C683	a_547_301##10	VPWR#3	5.65029e-18
C684	a_159_404##2	DE#3	6.975e-17
C685	VGND#10	CLK#3	9.6811e-18
C686	a_547_301##9	a_547_301##11	1.35652e-19
C687	VPWR#2	a_2385_74#	9.91092e-18
C688	VGND#12	SCD#3	2.0988e-18
C689	a_547_301##9	a_2385_74##4	2.65708e-18
C690	a_1910_71##2	a_1910_71##9	2.78064e-18
C691	CLK#3	a_1295_74##9	4.53332e-18
C692	SCD#1	a_639_85##4	4.89501e-17
C693	a_669_111#	a_1295_74##8	7.17492e-18
C694	VGND#20	a_159_404##4	1.85399e-17
C695	a_1492_74##12	a_1492_74##3	2.84798e-19
C696	D#2	DE#3	1.47849e-18
C697	VPWR#9	a_639_85##2	4.00723e-19
C698	VGND#11	SCD#2	8.69009e-19
C699	a_2385_74##10	VPWR#13	1.25754e-17
C700	a_547_301##11	a_2385_74##6	3.45737e-17
C701	VPWR#3	a_1492_74##7	3.34669e-18
C702	a_159_404##6	DE#4	3.39444e-19
C703	a_669_111##5	a_639_85##9	9.63263e-17
C704	VPWR#16	a_1492_74#	1.48827e-18
C705	CLK#2	a_1295_74##14	2.39491e-17
C706	D#2	a_159_404##2	6.7114e-17
C707	VGND#12	SCE#2	3.25809e-18
C708	a_1492_74##12	a_1295_74##2	1.02717e-18
C709	a_1492_74##11	a_1492_74##3	1.68599e-17
C710	a_547_301##11	Q	4.27713e-17
C711	a_639_85##7	a_639_85##4	3.56904e-20
C712	a_2385_74##8	a_1295_74##10	1.45945e-20
C713	a_27_74##3	D	3.46411e-17
C714	DE#3	a_27_74#	4.44475e-18
C715	a_1492_74##17	a_1295_74##8	3.03085e-17
C716	VPWR#17	CLK#2	3.359e-19
C717	VGND#10	VGND#9	1.07576e-18
C718	DE#2	a_159_404##8	1.07164e-18
C719	a_1688_97##5	a_1910_71##2	1.00754e-17
C720	a_1910_71##6	a_1492_74##5	1.04555e-17
C721	a_1688_97##2	a_1295_74##2	1.53141e-20
C722	VGND#12	a_639_85##2	1.33288e-17
C723	VGND#11	SCE#1	1.6951e-17
C724	a_639_85##2	a_669_111##7	1.44694e-17
C725	VGND#10	a_1295_74##16	9.4407e-18
C726	D#2	DE#4	7.29053e-19
C727	SCE	a_639_85##10	2.56031e-17
C728	DE#5	a_143_74#	9.7209e-18
C729	SCE#4	SCD#1	1.75224e-17
C730	a_2385_74##8	a_547_301##9	6.75999e-18
C731	VPWR#4	a_1295_74##12	3.75921e-18
C732	a_547_301##9	a_2385_74##5	3.34889e-17
C733	VPWR#16	a_1295_74##8	4.25426e-17
C734	a_1295_74##14	a_639_85##5	1.97894e-18
C735	VGND#12	a_547_301##3	1.00033e-17
C736	D#1	a_143_74#	1.01349e-17
C737	a_547_301##10	a_2385_74##2	3.64119e-18
C738	VPWR#2	VPWR#3	4.24878e-17
C739	VPWR#9	DE#7	4.83101e-21
C740	a_159_404##9	DE#3	2.68266e-17
C741	SCE#1	CLK#3	6.02085e-18
C742	VGND#11	VGND#18	1.28851e-18
C743	VGND#10	SCE#1	2.19193e-18
C744	a_1688_97#	a_1910_71##6	1.08061e-17
C745	a_159_404##6	DE#2	3.06511e-17
C746	VGND#13	a_547_301##8	5.17473e-18
C747	a_27_74#	a_639_85##2	4.26174e-17
C748	a_1492_74##12	a_1492_74##2	8.34031e-19
C749	VPWR#7	a_639_85##5	1.26228e-19
C750	VGND#12	a_159_404##3	4.3422e-18
C751	a_159_404##2	a_27_74#	1.58314e-18
C752	a_1492_74##3	a_1824_97#	1.11038e-18
C753	VPWR	VPWR#7	1.42827e-17
C754	VPWR	VPWR#6	1.1259e-16
C755	VPWR	VPWR#4	1.08667e-16
C756	VPWR#3	a_1295_74##12	2.83358e-18
C757	VGND#11	SCE#3	2.41489e-19
C758	VPWR	VPWR#3	6.56916e-17
C759	a_639_85##7	SCD#1	9.15209e-20
C760	a_639_85##5	a_669_111##10	1.46861e-18
C761	a_2385_74##5	VGND#6	7.41184e-18
C762	a_27_74##5	a_669_111##5	4.12939e-17
C763	a_547_301##8	VGND#11	5.77819e-18
C764	VPWR	a_2385_74##8	1.7663e-18
C765	a_2385_74##8	a_1492_74##5	4.5433e-20
C766	VGND#9	a_1295_74##16	1.10782e-17
C767	VGND#12	DE#7	3.91574e-18
C768	VPWR#16	CLK#1	3.34348e-18
C769	VGND#5	VGND#4	5.42778e-19
C770	VGND#20	DE#2	3.02959e-20
C771	a_1688_97##5	a_1295_74##6	7.54971e-17
C772	a_547_301##10	a_547_301##11	4.39339e-18
C773	SCE#5	SCE#4	4.89192e-18
C774	VGND#9	SCE#1	4.05481e-20
C775	VGND#8	a_2385_74##9	1.31968e-17
C776	a_27_74##2	a_554_463#	1.84083e-18
C777	VPWR#17	a_1295_74##8	1.67866e-18
C778	Q	VGND#1	7.05199e-17
C779	Q	Q#3	2.332e-18
C780	a_547_301##9	a_547_301##4	1.26767e-18
C781	a_547_301##9	a_2385_74##3	1.58784e-17
C782	a_547_301##9	Q	6.45346e-17
C783	CLK	a_1295_74##9	1.57366e-19
C784	a_547_301##8	VGND#10	3.80754e-18
C785	a_159_404##9	a_159_404##2	3.95227e-18
C786	VGND#11	SCD#3	2.51976e-18
C787	VGND#12	DE#5	9.94202e-19
C788	a_639_85##10	VGND#19	3.52172e-17
C789	a_27_74##6	D	3.82246e-17
C790	VPWR	a_1688_97##5	2.80314e-18
C791	a_669_111#	a_1295_74##2	2.228e-18
C792	a_1295_74##14	CLK#1	3.90326e-17
C793	a_547_301##10	a_2385_74##8	4.96491e-17
C794	a_27_74#	a_547_301##3	3.135e-17
C795	VPWR	a_669_111##4	1.88635e-18
C796	VGND#21	a_159_404##2	2.84466e-17
C797	a_547_301#	SCE#4	3.00158e-19
C798	VPWR	a_669_111##2	1.42816e-17
C799	VPWR#4	a_1910_71##7	3.95562e-18
C800	a_1295_74##2	a_1910_71##2	1.70329e-18
C801	a_27_74##2	a_669_111##7	2.42306e-18
C802	SCE#1	SCD#3	5.92021e-17
C803	a_1910_71##9	a_1492_74##3	2.14484e-19
C804	a_547_301##8	VGND#9	5.48335e-18
C805	VGND#12	D#1	1.80462e-18
C806	a_639_85##7	a_639_85##9	1.74764e-17
C807	VGND#20	a_639_85##2	4.5193e-19
C808	VPWR#16	a_639_85##4	2.74078e-19
C809	a_1492_74##10	a_2313_74#	2.7559e-18
C810	a_1910_71##2	a_1688_97#	6.60585e-18
C811	a_159_404##9	DE#4	2.40487e-17
C812	VGND	VGND#9	1.0039e-16
C813	VGND	VGND#4	9.43841e-17
C814	a_547_301##8	a_669_111##8	2.0377e-17
C815	VGND	VGND#3	1.01509e-16
C816	a_547_301##10	a_1295_74##2	1.53093e-18
C817	VGND#11	a_669_111##9	7.55093e-19
C818	a_547_301##4	VGND#6	1.68522e-17
C819	VPWR#6	a_1295_74##3	2.73388e-20
C820	a_639_85##7	SCE#4	3.14874e-17
C821	VPWR#17	CLK#1	3.0849e-17
C822	a_547_301#	SCE#5	4.5621e-17
C823	a_27_74##6	a_159_404##2	5.63019e-18
C824	VPWR#2	a_2385_74##2	1.79739e-18
C825	a_27_74##3	a_114_464#	2.78569e-18
C826	VPWR#18	SCD#2	5.04061e-19
C827	a_2385_74##9	a_2385_74##5	3.12839e-19
C828	a_1295_74##14	a_639_85##4	2.57419e-19
C829	a_547_301##8	a_1492_74##16	8.55978e-18
C830	VGND	a_2385_74##8	2.01956e-18
C831	a_1688_97##5	a_1492_74##3	5.7348e-18
C832	SCE#2	SCE#1	2.30992e-18
C833	a_547_301##9	a_1295_74##10	1.16175e-19
C834	Q	VPWR#1	9.11844e-17
C835	VPWR#10	DE#2	2.48323e-19
C836	Q	Q#1	4.22911e-18
C837	a_1492_74##17	a_1295_74##3	2.31526e-18
C838	VPWR#19	a_669_111##5	1.89623e-18
C839	a_547_301##13	Q	4.57879e-17
C840	VGND	a_1492_74##12	3.82377e-17
C841	VPWR#2	a_547_301##11	8.66278e-19
C842	a_27_74#	a_159_404##3	3.91067e-18
C843	a_639_85##7	SCE#2	7.05205e-20
C844	VGND	a_1492_74##11	3.08878e-17
C845	VGND	a_1492_74##10	3.49987e-17
C846	SCD#4	SCE#1	1.88904e-18
C847	VPWR#5	a_1688_97##3	4.5157e-18
C848	VGND	a_1910_71##9	2.10154e-18
C849	VPWR	a_669_111##8	5.05768e-19
C850	a_547_301##8	VGND#17	8.67702e-18
C851	VGND	a_1688_97##5	2.06334e-18
C852	VGND#20	a_547_301##3	3.97676e-18
C853	VPWR#14	a_2385_74##10	6.41783e-18
C854	SCE	SCD#3	9.54153e-19
C855	VPWR#5	VPWR#4	8.77876e-19
C856	VPWR#17	a_639_85##4	3.25385e-18
C857	VGND	a_669_111##2	1.21252e-18
C858	a_27_74#	a_27_74##2	1.29287e-18
C859	VGND#11	SCE#2	2.53343e-17
C860	VPWR#2	a_2385_74##8	1.66954e-18
C861	a_669_111##8	a_1295_74##3	7.07771e-18
C862	VGND#10	a_669_111##9	7.98336e-18
C863	a_669_111##5	a_639_85##7	3.57826e-17
C864	SCE#2	SCD#3	2.93574e-17
C865	a_27_74##6	D#2	2.94478e-17
C866	DE#1	a_547_301#	5.21166e-17
C867	VPWR#5	a_1910_71#	3.92957e-18
C868	a_2385_74##3	a_2385_74#	1.96258e-18
C869	a_547_301##8	a_1295_74##16	4.95481e-18
C870	a_1492_74##10	a_547_301##4	3.81537e-19
C871	VPWR#8	SCE#3	1.47225e-20
C872	VPWR#19	a_27_74##5	1.20038e-17
C873	a_639_85##7	SCE#5	9.97181e-19
C874	VPWR#10	a_669_111##5	1.97613e-18
C875	a_1492_74##17	a_1295_74##2	7.22089e-18
C876	a_639_85##4	a_669_111##10	2.11001e-17
C877	a_159_404##9	a_547_301##3	4.34019e-19
C878	VPWR	VPWR#13	1.65383e-18
C879	a_2385_74##9	a_547_301##4	2.70806e-17
C880	VPWR#6	a_1295_74##2	9.62556e-20
C881	a_27_74#	DE#7	9.49089e-19
C882	VPWR	a_2385_74##10	2.48453e-17
C883	a_547_301##9	a_1492_74##5	9.26342e-20
C884	VPWR#5	a_1295_74##7	4.5537e-18
C885	VGND#3	a_2385_74##8	2.30925e-17
C886	a_2385_74##9	a_547_301##5	1.59301e-19
C887	VGND#10	SCE#2	1.72345e-20
C888	a_547_301##8	VGND#18	5.49861e-18
C889	VPWR#18	CLK#1	4.2206e-19
C890	VPWR	VPWR#14	1.54095e-17
C891	Q	a_2385_74##4	2.54257e-17
C892	a_1492_74##3	a_1910_71##3	5.76324e-18
C893	VPWR	a_1910_71##8	4.41016e-18
C894	VGND	a_2385_74##9	2.92123e-17
C895	Q	a_2385_74##5	9.90096e-19
C896	VGND#12	VGND#13	9.11473e-17
C897	VPWR	VPWR#15	9.25227e-18
C898	VPWR#17	SCD#1	3.59814e-19
C899	a_1492_74##2	a_1688_97##5	7.4264e-17
C900	VGND	a_1910_71##11	3.01255e-18
C901	a_547_301##10	a_1492_74##12	2.12839e-18
C902	VPWR	a_1688_97##6	2.29628e-17
C903	VGND#21	DE#4	4.67069e-18
C904	VPWR	a_669_111#	3.42873e-17
C905	VGND#20	a_159_404##3	4.09552e-17
C906	D	DE#5	3.24952e-18
C907	VGND	a_1688_97##4	6.28362e-18
C908	VPWR	a_1492_74##17	2.88777e-18
C909	VGND	a_669_111##8	4.08778e-18
C910	VPWR	VPWR#16	1.36612e-17
C911	VGND	a_1492_74##16	2.71573e-17
C912	VPWR	a_1295_74##14	2.20856e-18
C913	SCD#4	SCD#3	2.70116e-18
C914	VGND	VGND#17	7.12137e-18
C915	VGND	a_1295_74##16	9.4821e-18
C916	VPWR#5	a_1492_74#	1.80781e-18
C917	DE#6	DE#1	1.19331e-17
C918	a_547_301##8	a_669_111##9	2.06566e-17
C919	VGND#2	a_2385_74##2	1.92584e-18
C920	a_669_111##8	a_1295_74##2	9.23097e-18
C921	VGND#12	VGND#11	1.00233e-16
C922	a_669_111##5	VPWR#8	4.33047e-17
C923	a_547_301##5	a_2385_74##6	1.43979e-17
C924	VGND#12	CLK	4.52453e-18
C925	a_547_301##10	a_1492_74##11	1.79693e-17
C926	a_547_301##8	VPWR#10	1.68339e-18
C927	a_1295_74#	a_1492_74##3	5.41452e-18
C928	a_2385_74##2	VNB	6.03191e-17
C929	a_1295_74##3	VNB	2.45808e-17
C930	a_1295_74##3	VPWR#16	1.34001e-18
C931	a_1295_74##2	VNB	5.11329e-17
C932	VGND#2	a_2385_74##8	9.92985e-19
C933	DE#4	VNB	4.09602e-17
C934	a_2385_74##9	a_2385_74##8	8.90726e-19
C935	DE#2	VNB	3.97263e-17
C936	a_159_404##9	a_159_404##3	6.58902e-19
C937	VPWR#18	a_639_85##4	3.11337e-18
C938	VGND	a_2385_74##10	3.96489e-19
C939	VGND#12	VGND#10	8.32047e-17
C940	a_1492_74##11	a_1824_97#	9.47316e-19
C941	Q	a_2385_74#	3.71669e-17
C942	VPWR#17	SCE#4	2.52948e-19
C943	a_639_85##7	a_547_301#	1.17962e-19
C944	Q	a_2385_74##6	1.78363e-18
C945	a_2385_74##9	a_1295_74##10	2.6454e-17
C946	a_547_301##8	VPWR#8	3.50813e-18
C947	a_1492_74##10	a_1295_74##10	2.05488e-19
C948	a_547_301##10	a_1492_74##10	1.17448e-17
C949	VGND	a_1492_74##17	9.50392e-19
C950	a_2385_74##9	a_1492_74##8	6.55144e-17
C951	VGND	a_1295_74##14	2.60094e-19
C952	VPWR#3	VPWR#1	4.62048e-19
C953	VGND#20	DE#7	2.78054e-17
C954	a_547_301##8	VGND#19	8.99197e-18
C955	a_1492_74##16	a_1295_74##3	4.05689e-18
C956	a_547_301##8	SCE	1.71224e-17
C957	VGND#12	VGND#9	7.11992e-18
C958	a_1492_74##7	a_547_301##5	3.21473e-17
C959	VPWR#9	SCE	2.17834e-18
C960	a_639_85##9	a_639_85##4	3.79211e-20
C961	VGND#8	a_547_301##4	1.16679e-19
C962	a_159_404#	DE#6	3.73681e-18
C963	VGND#12	SCE	4.11527e-18
C964	a_1492_74##2	a_1295_74#	2.85107e-18
C965	VGND#13	VNB	4.00244e-17
C966	a_1492_74##12	a_1492_74##17	6.5486e-19
C967	VGND#11	VNB	4.09007e-17
C968	VGND#10	VNB	3.83346e-17
C969	CLK	a_1295_74##5	2.09821e-20
C970	a_669_111##2	a_1492_74##2	7.38156e-18
C971	VGND#9	VNB	6.23356e-17
C972	a_547_301##8	VPWR#7	3.9474e-18
C973	VGND#4	VNB	4.53547e-17
C974	VGND#3	VNB	6.50643e-17
C975	CLK	CLK#2	1.07579e-17
C976	VPWR#10	VNB	3.73311e-17
C977	VPWR#8	VNB	4.61978e-17
C978	VPWR#2	VPWR#1	5.04676e-17
C979	VPWR#7	VNB	4.58159e-17
C980	a_1910_71##9	a_1910_71##8	1.93263e-18
C981	VPWR#6	VNB	6.10438e-17
C982	SCD#4	SCE#2	2.92598e-19
C983	VPWR#4	VNB	5.89658e-17
C984	VPWR#3	VNB	5.5446e-17
C985	a_669_111##5	a_547_301##2	1.19976e-18
C986	CLK	SCD#2	6.81544e-20
C987	a_547_301##11	VNB	6.06199e-18
C988	a_547_301##8	a_639_85##10	4.84757e-18
C989	VPWR#18	SCD#1	3.36846e-17
C990	a_2385_74##8	VNB	8.01429e-18
C991	a_1492_74##10	a_2385_74##8	3.59008e-19
C992	a_1492_74##2	a_1295_74##9	1.57302e-19
C993	VGND#12	a_1295_74##16	1.54006e-17
C994	VPWR#9	D	4.89144e-18
C995	a_1492_74##12	VNB	1.11746e-17
C996	VGND	a_1910_71##3	7.44129e-18
C997	a_1492_74##11	VNB	8.18149e-18
C998	a_1492_74##10	VNB	2.21985e-17
C999	VPWR	a_1688_97##3	7.24448e-18
C1000	VGND#12	D	8.9202e-18
C1001	VGND#20	a_27_74##2	1.28102e-18
C1002	a_1295_74##2	a_1492_74##3	1.89001e-18
C1003	DE#7	a_159_404##9	9.99462e-18
C1004	VGND	a_1295_74##9	2.66134e-18
C1005	VGND#13	a_547_301##3	3.01751e-18
C1006	a_1910_71##9	VNB	6.89357e-18
C1007	a_547_301##8	VPWR#6	4.47832e-18
C1008	a_27_74#	a_669_111##7	9.05419e-17
C1009	a_1688_97##5	VNB	8.64712e-18
C1010	a_547_301##10	Q	6.53181e-17
C1011	a_669_111##4	VNB	2.17169e-17
C1012	Q	VPWR#2	4.25787e-17
C1013	a_547_301##10	VPWR#13	4.23077e-18
C1014	a_669_111##2	VNB	1.65963e-17
C1015	a_27_74##2	SCE#4	1.36908e-19
C1016	VGND#2	Q	4.26831e-17
C1017	a_639_85##7	VNB	5.04451e-18
C1018	SCD#5	VNB	1.40435e-18
C1019	SCD#4	VNB	3.62613e-18
C1020	a_547_301##3	a_639_85##2	3.50979e-17
C1021	a_547_301##8	a_669_111##7	2.02808e-17
C1022	a_27_74##3	VNB	9.15999e-17
C1023	a_27_74##2	VNB	1.5865e-17
C1024	a_669_111##4	a_1295_74##5	9.71094e-20
C1025	a_2385_74##9	a_1492_74##5	3.4654e-17
C1026	VPWR#9	VPWR#10	8.30847e-17
C1027	a_159_404##6	VNB	2.2234e-18
C1028	a_639_85##9	SCD#1	9.72409e-20
C1029	VGND#20	DE#5	1.64919e-18
C1030	VPWR#8	SCE#1	1.6986e-19
C1031	Q	a_2385_74##3	7.90283e-19
C1032	SCE	SCD#2	2.85586e-18
C1033	a_2385_74##9	a_1295_74##11	8.05484e-19
C1034	VGND#1	VNB	6.57884e-17
C1035	a_1295_74##12	a_1492_74##8	6.49091e-18
C1036	a_547_301##9	VNB	1.14628e-17
C1037	SCE	SCE#3	2.1554e-17
C1038	a_547_301##8	CLK#1	1.32052e-18
C1039	D#3	a_159_404#	4.54968e-17
C1040	a_2385_74##9	VNB	3.64896e-18
C1041	a_547_301##10	VPWR	8.3825e-17
C1042	VGND#8	VNB	6.30906e-19
C1043	a_1910_71##11	VNB	2.96355e-19
C1044	VGND#16	VNB	3.01305e-18
C1045	a_1688_97##4	VNB	6.50465e-18
C1046	a_669_111##8	VNB	1.69016e-17
C1047	a_547_301##13	VPWR#2	3.26198e-17
C1048	a_1492_74##16	VNB	1.54474e-17
C1049	VPWR	VPWR#5	1.03773e-16
C1050	a_1492_74##10	a_1492_74##5	1.08613e-17
C1051	VGND#17	VNB	6.32189e-18
C1052	VPWR#10	a_547_301##2	1.28693e-19
C1053	VGND#21	DE#7	2.58746e-18
C1054	a_1295_74##16	VNB	1.79174e-17
C1055	VGND#18	VNB	3.65727e-18
C1056	a_1295_74##11	a_1492_74##7	1.0247e-18
C1057	VGND#8	a_1295_74##10	2.2846e-19
C1058	a_669_111##9	VNB	2.12191e-17
C1059	a_547_301##8	a_27_74#	6.64283e-17
C1060	SCE#4	VPWR#18	2.27347e-17
C1061	VGND#2	VPWR#1	3.82176e-18
C1062	a_547_301##8	VPWR	2.67458e-17
C1063	VGND#12	a_669_111##9	1.75912e-17
C1064	VGND#19	VNB	3.29902e-18
C1065	a_639_85##10	VNB	4.48587e-18
C1066	a_669_111##7	VNB	1.58268e-17
C1067	VPWR#9	VPWR#8	9.76066e-17
C1068	a_27_74#	VNB	8.80965e-18
C1069	VGND#20	VNB	2.58708e-18
C1070	a_159_404##9	VNB	1.09025e-17
C1071	VGND#21	VNB	7.59795e-18
C1072	a_27_74##6	VNB	5.3456e-17
C1073	VPWR	a_547_301##5	3.0087e-18
C1074	VPWR#1	VNB	7.81602e-17
C1075	a_547_301##13	VNB	7.94628e-18
C1076	VPWR	a_1492_74##8	2.39505e-18
C1077	a_669_111##5	SCD#1	6.30327e-19
C1078	VPWR#13	VNB	4.71865e-18
C1079	VPWR	a_1295_74##11	2.32457e-17
C1080	a_2385_74##10	VNB	7.91032e-18
C1081	a_1295_74##5	a_669_111##2	7.80136e-17
C1082	VPWR#14	VNB	3.64247e-18
C1083	VPWR	a_1492_74##6	2.76249e-18
C1084	D	DE#3	3.84089e-20
C1085	a_669_111##8	a_669_111##2	9.45319e-19
C1086	a_1910_71##8	VNB	4.85861e-18
C1087	VPWR#15	VNB	2.22093e-18
C1088	VGND	a_547_301##10	8.16541e-17
C1089	VPWR	a_1910_71##6	2.61069e-18
C1090	a_1688_97##6	VNB	4.54404e-18
C1091	D	a_159_404##2	5.99492e-17
C1092	a_159_404##9	DE#5	9.32723e-19
C1093	VPWR#9	CLK#1	4.6794e-18
C1094	a_669_111#	VNB	9.54687e-18
C1095	VPWR	a_1688_97##2	3.25192e-18
C1096	a_547_301##10	a_2385_74##10	2.02265e-17
C1097	a_1492_74##17	VNB	2.44147e-18
C1098	a_2385_74##9	a_2487_74#	2.12975e-18
C1099	a_1295_74##11	a_1295_74##12	2.5091e-17
C1100	VPWR#16	VNB	5.04981e-18
C1101	D	D#2	2.45334e-17
C1102	a_1295_74##14	VNB	8.76438e-18
C1103	VPWR#15	VPWR#14	8.72243e-18
C1104	VPWR#2	VPWR#13	1.20802e-17
C1105	VPWR#17	VNB	4.12663e-18
C1106	VGND	VGND#5	1.31367e-16
C1107	VPWR	a_1295_74##6	2.4883e-17
C1108	a_669_111##4	VPWR#8	4.3261e-18
C1109	VPWR#18	VNB	5.37477e-19
C1110	VGND	a_547_301##8	2.50969e-17
C1111	a_639_85##9	VNB	7.63731e-18
C1112	a_669_111##5	VNB	1.71699e-17
C1113	VPWR#9	VPWR#7	8.47727e-17
C1114	a_27_74##5	VNB	2.64423e-18
C1115	VPWR	a_1492_74##2	1.28692e-18
C1116	VPWR#19	VNB	3.26483e-19
C1117	SCE#4	a_639_85##9	1.59148e-17
C1118	VPWR	a_1295_74##5	1.83692e-18
C1119	a_159_404##8	VNB	3.93659e-19
C1120	VPWR#20	VNB	1.14508e-18
C1121	a_2385_74##4	VNB	3.32525e-17
C1122	VGND	a_1492_74##8	3.45331e-18
C1123	a_2385_74##5	VNB	2.75323e-17
C1124	CLK#2	a_1295_74##9	2.70386e-18
C1125	a_547_301##4	VNB	5.5929e-17
C1126	VGND	a_1295_74##11	2.38313e-18
C1127	a_1295_74##10	VNB	2.89477e-17
C1128	a_1492_74##5	VNB	2.82723e-17
C1129	a_1492_74##11	a_1910_71##4	1.38207e-19
C1130	a_1910_71##4	VNB	2.5302e-17
C1131	a_1688_97#	VNB	4.61262e-17
C1132	VGND	a_1910_71##6	3.92038e-18
C1133	VGND#11	a_639_85##10	7.24905e-18
C1134	a_1910_71##3	VNB	3.0446e-17
C1135	a_1492_74##4	VNB	2.31866e-17
C1136	VGND	a_1688_97##2	1.07145e-18
C1137	a_27_74##2	SCE#5	4.44214e-18
C1138	a_1295_74#	VNB	4.9936e-17
C1139	a_1295_74##9	VNB	5.02322e-17
C1140	VGND	a_1910_71##2	2.4878e-18
C1141	CLK#3	VNB	3.74476e-17
C1142	a_1295_74##11	a_1910_71##7	4.15676e-17
C1143	VPWR#9	a_639_85##4	1.00207e-17
C1144	SCE#1	VNB	7.37146e-17
C1145	VGND	a_1295_74##6	1.12229e-19
C1146	SCD#3	VNB	1.78698e-17
C1147	SCE#2	VNB	5.90428e-17
C1148	a_2385_74##9	a_1910_71##4	5.6525e-18
C1149	a_639_85##2	VNB	4.84684e-17
C1150	a_547_301##3	VNB	2.81196e-17
C1151	a_159_404##3	VNB	2.53704e-17
C1152	DE#7	VNB	3.33412e-17
C1153	VGND	a_1295_74##5	9.9178e-19
C1154	DE#5	VNB	3.65303e-17
C1155	D#1	VNB	3.01091e-17
C1156	a_1688_97##5	a_1910_71##8	1.3069e-18
C1157	a_159_404##3	a_547_301##3	4.70415e-17
C1158	a_2385_74#	VNB	4.56915e-17
C1159	a_2385_74##6	VNB	4.31338e-17
C1160	a_547_301##6	VNB	2.41445e-17
C1161	a_1492_74##7	VNB	3.78992e-17
C1162	a_1295_74##12	VNB	3.29198e-17
C1163	VGND#21	DE#5	3.39218e-17
C1164	a_1910_71##7	VNB	4.66179e-17
C1165	CLK#2	a_669_111##4	3.92157e-18
C1166	VGND#13	a_159_404##3	3.14427e-18
C1167	a_1688_97##3	VNB	3.99097e-17
C1168	VPWR#6	a_1492_74#	2.12345e-18
C1169	VGND#9	a_1492_74##12	3.39852e-17
C1170	a_1910_71#	VNB	4.22574e-17
C1171	a_1295_74##7	VNB	2.19004e-17
C1172	a_1492_74#	VNB	2.1282e-17
C1173	a_669_111##5	SCE#4	3.38704e-17
C1174	a_1295_74##8	VNB	3.41672e-17
C1175	CLK#1	VNB	5.11592e-17
C1176	a_639_85##4	VNB	3.60853e-17
C1177	a_1295_74##14	a_1295_74##2	8.4472e-20
C1178	a_639_85##7	SCD#5	1.18973e-18
C1179	SCD#1	VNB	3.27366e-17
C1180	SCE#4	VNB	7.29227e-17
C1181	SCE#5	VNB	6.68245e-17
C1182	a_1295_74##11	a_1688_97##3	7.2175e-19
C1183	a_547_301#	VNB	3.6062e-17
C1184	VGND#8	a_1492_74##5	2.65553e-18
C1185	DE#1	VNB	4.20521e-17
C1186	DE#6	VNB	2.87329e-17
C1187	VPWR#9	SCD#1	4.37787e-18
C1188	a_159_404#	VNB	2.79742e-17
C1189	D#3	VNB	3.73059e-17
C1190	a_547_301##10	VNB	2.01616e-17
C1191	VPWR#2	VNB	1.43955e-16
C1192	SCE#1	CLK#2	4.9762e-19
C1193	VGND#2	VNB	1.46082e-16
C1194	VGND#12	a_639_85##10	1.08232e-17
C1195	a_1492_74##2	a_1295_74##2	4.5698e-17
C1196	a_27_74##6	DE#7	4.66718e-20
C1197	VPWR#5	VNB	5.309e-17
C1198	a_547_301##10	VPWR#14	3.2324e-18
C1199	a_2385_74##2	Q#3	1.26645e-18
C1200	VGND#5	VNB	6.98405e-17
C1201	a_547_301##10	a_1910_71##9	3.62875e-17
C1202	a_547_301##8	VNB	2.2407e-17
C1203	VPWR#9	VNB	3.16722e-16
C1204	VGND#12	VNB	3.19366e-16
C1205	a_1910_71##7	a_1492_74##6	1.11476e-17
C1206	a_2385_74##3	VNB	8.85029e-17
C1207	a_159_404##9	D#1	1.75792e-19
C1208	a_547_301##5	VNB	6.78088e-17
C1209	a_639_85##9	SCE#5	3.39323e-18
C1210	a_1492_74##8	VNB	4.27686e-17
C1211	a_1295_74##11	VNB	4.8034e-17
C1212	a_1492_74##10	a_1910_71##4	1.80962e-17
C1213	a_1492_74##6	VNB	2.93082e-17
C1214	a_1910_71##6	VNB	9.22823e-17
C1215	a_1688_97##2	VNB	4.23745e-17
C1216	a_1910_71##2	VNB	6.43485e-17
C1217	a_1295_74##6	VNB	6.76977e-17
C1218	a_1492_74##3	VNB	3.10519e-17
C1219	a_1492_74##2	VNB	4.75796e-17
C1220	a_1295_74##5	VNB	6.95141e-17
C1221	a_547_301##8	SCE#5	1.67577e-18
C1222	CLK#2	VNB	2.83021e-17
C1223	a_639_85##5	VNB	6.19323e-17
C1224	SCD#2	VNB	5.14766e-17
C1225	SCE#3	VNB	3.30291e-17
C1226	SCD#3	CLK#2	2.14424e-19
C1227	VGND#3	a_2385_74##3	1.15479e-17
C1228	a_547_301##2	VNB	7.71132e-17
C1229	a_159_404##4	VNB	5.25074e-17
C1230	DE#3	VNB	3.0433e-17
C1231	a_669_111##2	CLK#2	1.0941e-18
C1232	a_159_404##2	VNB	6.29704e-17
C1233	a_1492_74##16	a_669_111##2	8.08313e-18
C1234	D#2	VNB	9.17369e-17
C1235	VGND#12	a_669_111##7	2.8951e-17
C1236	a_547_301##13	VPWR#3	5.03713e-18
C1237	a_547_301##10	a_1910_71##8	5.3468e-18
C1238	a_669_111##4	VPWR#7	1.90031e-17
C1239	a_669_111##5	SCE#5	6.39811e-17
C1240	a_639_85##5	SCE#1	2.26934e-18
C1241	a_2385_74##9	a_1688_97#	3.25553e-19
C1242	a_27_74##2	a_547_301#	2.11087e-17
C1243	VGND#21	D#1	6.42367e-18
C1244	CLK	VNB	1.61528e-18
C1245	VPWR#7	a_1295_74##8	1.11689e-19
C1246	VPWR#9	SCE#5	1.35506e-17
C1247	SCE	VNB	1.19715e-18
C1248	D	VNB	8.41734e-18
C1249	Q	VNB	4.32696e-17
C1250	VPWR	VNB	2.14468e-16
C1251	VGND#12	a_27_74#	2.68024e-17
C1252	VGND	VNB	2.17781e-16
C1253	a_1492_74##11	a_1688_97#	3.9377e-17
C1254	DE#3	a_639_85#	7.41838e-20
C1255	VPWR#11	DE#3	2.29668e-20
C1256	a_639_85#	a_669_111##9	1.6685e-18
C1257	a_159_404##4	a_639_85#	4.43726e-19
C1258	VPWR#11	a_159_404##2	1.03647e-19
C1259	VGND#14	D	1.8652e-18
C1260	a_639_85#	VNB	1.57226e-16
C1261	a_547_301##2	a_639_85#	8.18771e-18
C1262	VPWR#11	D#2	1.45914e-19
C1263	VGND#12	VGND#14	1.3583e-16
C1264	VPWR#11	DE#4	2.08993e-20
C1265	a_27_74##2	a_639_85#	5.66963e-19
C1266	VGND#14	D#1	8.55628e-18
C1267	VPWR#9	VPWR#11	1.25727e-16
C1268	VGND#14	VNB	6.634e-17
C1269	VGND#11	a_639_85#	1.54796e-17
C1270	VPWR#11	VPWR#10	5.53051e-19
C1271	a_639_85#	SCE#3	4.71954e-17
C1272	VPWR#11	DE#2	1.52422e-19
C1273	VGND#14	a_27_74##6	1.85797e-17
C1274	a_639_85#	a_159_404##3	2.21458e-19
C1275	VGND#13	a_639_85#	3.0165e-18
C1276	a_669_111##5	a_639_85#	1.17711e-17
C1277	VPWR#11	DE#1	2.25396e-19
C1278	VGND#14	DE#5	7.04139e-18
C1279	a_639_85#	a_547_301##3	3.5749e-19
C1280	VGND#14	DE#4	6.91535e-19
C1281	VPWR#11	DE#6	8.967e-19
C1282	a_639_85##5	a_639_85#	1.77733e-19
C1283	VGND#20	a_639_85#	2.82782e-18
C1284	a_639_85##2	a_639_85#	1.55873e-17
C1285	VPWR#11	a_159_404#	7.19749e-18
C1286	SCD#5	a_639_85#	1.61349e-18
C1287	VGND#12	a_639_85#	5.34464e-17
C1288	a_639_85#	SCE#2	3.15344e-17
C1289	a_639_85#	SCE	2.99342e-17
C1290	a_27_74##3	VPWR#11	6.16253e-17
C1291	VPWR#11	D#3	7.14354e-18
C1292	a_27_74#	a_639_85#	7.17867e-19
C1293	VGND#14	D#2	2.37278e-19
C1294	VPWR#9	a_639_85#	1.05744e-20
C1295	a_639_85#	SCD#3	3.6645e-19
C1296	a_669_111##7	a_639_85#	1.18536e-16
C1297	a_639_85#	SCE#5	1.81718e-18
C1298	a_547_301##8	a_639_85#	2.36686e-18
C1299	a_639_85#	SCE#1	5.16799e-19
C1300	VGND#14	VGND#13	1.41197e-18
C1301	VGND#14	a_159_404##2	2.01652e-18
C1302	VPWR#11	VNB	6.62699e-17
C1303	a_639_85#	SCE#4	7.06235e-18
C1304	a_639_85##7	a_639_85#	1.88244e-17
C1305	VGND#14	a_159_404##9	4.2682e-18
C1306	a_639_85#	VGND#19	4.81434e-18
*
*
.ENDS sky130_fd_sc_hs__sedfxtp_1
*
