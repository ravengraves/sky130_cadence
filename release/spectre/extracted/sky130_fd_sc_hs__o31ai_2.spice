* Extracted by Quantus, converted by sky130cad/quantus.py
*
*
*
*                       LINUX           Wed Nov 18 09:02:33 2026
*
*
*
*  PROGRAM  advgen
*
*  Name           : advgen - Quantus - (64-bit)
*  Version        : 25.1.0-p047
*  Build Date     : Thu Dec 11 23:20:30 PST 2025
*
*  HSPICE LIBRARY
*
*  OPERATING_TEMPERATURE 150
*  QRC_TECH_DIR <path>/tech
*
*
*

*
.SUBCKT sky130_fd_sc_hs__o31ai_2 VNB VPB VGND VPWR Y B1 A1 A2 A3
*
*
*  caps2d version: 10
*
*
*       TRANSISTOR CARDS
*
*
XM3 VGND#9 A1#5 a_27_74##8 VNB sky130_fd_pr__nfet_01v8_lvt l=0.15 w=0.74 ad=0.3108 as=0.2109 pd=2.32 ps=2.05
XM14 a_27_74##7 A1#1 VGND#9 VNB sky130_fd_pr__nfet_01v8_lvt l=0.15 w=0.74 ad=0.2072 as=0.3108 pd=2.04 ps=2.32
XM8 a_27_74##7 A2#7 VGND#8 VNB sky130_fd_pr__nfet_01v8_lvt l=0.15 w=0.74 ad=0.2072 as=0.3108 pd=2.04 ps=2.32
XM11 VGND#8 A2#1 a_27_74##4 VNB sky130_fd_pr__nfet_01v8_lvt l=0.15 w=0.74 ad=0.3108 as=0.2072 pd=2.32 ps=2.04
XM0 a_27_74##4 A3#4 VGND#7 VNB sky130_fd_pr__nfet_01v8_lvt l=0.15 w=0.74 ad=0.2072 as=0.64 pd=2.04 ps=3.29
XM12 VGND#7 A3#1 a_27_74##2 VNB sky130_fd_pr__nfet_01v8_lvt l=0.15 w=0.74 ad=0.64 as=0.2072 pd=3.29 ps=2.04
XM1 a_27_74##2 B1#5 Y#7 VNB sky130_fd_pr__nfet_01v8_lvt l=0.15 w=0.74 ad=0.2072 as=0.2442 pd=2.04 ps=2.14
XM4 Y#7 B1#6 a_27_74# VNB sky130_fd_pr__nfet_01v8_lvt l=0.15 w=0.74 ad=0.2442 as=0.2257 pd=2.14 ps=2.09
XM5 VPWR#7 A1#6 a_28_368##3 VPB sky130_fd_pr__pfet_01v8 l=0.15 w=1.12 ad=0.336 as=0.3304 pd=2.84 ps=2.83
XM10 a_28_368##4 A1#4 VPWR#7 VPB sky130_fd_pr__pfet_01v8 l=0.15 w=1.12 ad=0.336 as=0.336 pd=2.84 ps=2.84
XM15 a_28_368##4 A2#5 a_297_368##2 VPB sky130_fd_pr__pfet_01v8 l=0.15 w=1.12 ad=0.336 as=0.336 pd=2.84 ps=2.84
XM7 a_297_368##2 A2#6 a_28_368# VPB sky130_fd_pr__pfet_01v8 l=0.15 w=1.12 ad=0.336 as=0.3304 pd=2.84 ps=2.83
XM2 Y#4 A3#6 a_297_368# VPB sky130_fd_pr__pfet_01v8 l=0.15 w=1.12 ad=0.3304 as=0.336 pd=2.83 ps=2.84
XM9 a_297_368# A3#5 Y#5 VPB sky130_fd_pr__pfet_01v8 l=0.15 w=1.12 ad=0.336 as=0.392 pd=2.84 ps=2.94
XM13 Y#5 B1#8 VPWR#6 VPB sky130_fd_pr__pfet_01v8 l=0.15 w=1.12 ad=0.392 as=0.336 pd=2.94 ps=2.84
XM6 VPWR#6 B1#7 Y#1 VPB sky130_fd_pr__pfet_01v8 l=0.15 w=1.12 ad=0.336 as=0.3304 pd=2.84 ps=2.83
*
*
*       RESISTOR AND CAP/DIODE CARDS
*
Rg1	A1#1	A1#2	399.154449
Rg2	A1#2	A1#3	56.190357
Rg3	A1#2	A1#4	449.655212
Rg4	A1#3	A1#5	402.789612
Rg5	A1#3	A1#6	451.603058
Rg6	A2#1	A2#2	450.191284
Rg7	A2#2	A2#3	21.995068
Rg8	A2#3	A2#4	27.140614
Rg9	A2#4	A2#5	491.063538
Rg10	A2#2	A2#6	397.986786
Rg11	A2#4	A2#7	451.951538
Rg12	A3#1	A3#2	377.027313
Rg13	A3#2	A3#3	69.421532
Rg14	A3#3	A3#4	558.858765
Rg15	A3#2	A3#5	429.126801
Rg16	A3#3	A3#6	416.207306
Rg17	B1#1	B1#2	202.236023
Rg18	B1#2	B1#3	42.816685
Rg19	B1#3	B1#4	14.234964
Rg20	B1#4	B1#5	369.531891
Rg21	B1#2	B1#6	372.760712
Rg22	B1#2	B1#7	453.553314
Rg23	B1#4	B1#8	457.323822
Rf1	A1	A1#7	4.125637
Rf2	A1#7	A1	10.543295
Rf3	a_28_368#	a_28_368##2	78.344398
Rf4	a_28_368##2	a_28_368##3	90.294769
Rf5	a_28_368##2	a_28_368##4	18.602406
Rf6	A2#8	A2	1.409262
Rf7	A2#3	A2#10	161.642059
Rf8	A2#8	A2#10	1.528014
Rf9	A2#11	A2	1.409262
Rf10	A2#10	A2#11	13.140918
Rf11	a_297_368#	a_297_368##2	151.642776
Rf12	A3#7	A3	2.241867
Rf13	A3#2	A3#9	162.474670
Rf14	A3#7	A3#9	4.889644
Rf15	a_27_74#	a_27_74##3	94.034966
Rf16	a_27_74##3	a_27_74##5	89.082848
Rf17	a_27_74##5	a_27_74##6	80.222198
Rf18	a_27_74##6	a_27_74##7	18.149860
Rf19	a_27_74##6	a_27_74##8	87.959900
Rf20	a_27_74##2	a_27_74##3	15.000000
Rf21	a_27_74##4	a_27_74##5	7.500000
Rf22	Y#1	Y#2	93.168167
Rf23	Y#2	Y#3	71.544403
Rf24	Y#3	Y#4	19.934891
Rf25	Y#2	Y	11.240370
Rf26	Y	Y#6	2.362036
Rf27	Y#6	Y	12.203854
Rf28	Y#3	Y#7	171.533188
Rf29	Y#5	Y#6	5.000000
Rf30	B1	B1#1	6.925657
Rf31	B1#1	B1#3	100.528336
Rf33	VPWR#2	VPWR#3	122.092361
Rf34	VPWR#3	VPWR#4	124.583908
Rf36	VPWR#2	VPWR#6	56.795742
Rf37	VPWR#4	VPWR#7	38.736572
Rf39	VGND#2	VGND#3	38.882378
Rf40	VGND#3	VGND#4	45.266777
Rf41	VGND#4	VGND#5	73.001427
Rf43	VGND#2	VGND#7	20.414762
Rf44	VGND#4	VGND#8	37.656876
Rf45	VGND#5	VGND#9	37.656876
Rf46	A1#3	A1#7	160.232803
Re1	VPWR#3	VPWR	0.982218
Re2	VGND	VGND#3	0.982254
*
*       CAPACITOR CARDS
*
*
C1	Y#7	Y#2	7.72388e-18
C2	a_27_74##2	Y#3	4.91572e-18
C3	VGND#9	A1#2	1.66381e-18
C4	Y#3	VGND#7	1.05375e-18
C5	B1#2	Y#1	6.42013e-18
C6	a_27_74##4	Y#3	5.05196e-17
C7	A1#4	A2#4	2.32005e-19
C8	VPWR#6	B1#4	1.30154e-18
C9	Y#7	A3#9	2.67374e-17
C10	a_27_74##6	VGND#8	2.21088e-17
C11	a_27_74##6	a_27_74##7	9.59055e-20
C12	a_27_74##6	VGND#9	1.92877e-17
C13	Y#2	Y#1	2.96995e-18
C14	Y#3	A3#3	3.03243e-17
C15	Y#2	B1#4	4.16358e-18
C16	Y#2	VPWR#6	1.991e-17
C17	VPWR#3	A3#3	2.27366e-19
C18	Y#3	A2#4	2.22596e-19
C19	VPWR#3	A2#4	1.24391e-20
C20	A3#3	a_297_368#	2.18298e-18
C21	a_27_74##4	A2#10	6.62012e-18
C22	Y#2	Y#5	5.0742e-18
C23	Y#3	a_297_368#	8.43208e-17
C24	a_27_74#	Y#7	5.75874e-17
C25	Y#2	a_297_368#	1.24082e-17
C26	Y#3	A1#2	6.1192e-19
C27	a_27_74##2	a_27_74#	2.85412e-18
C28	Y#3	Y#4	8.63287e-18
C29	Y#7	a_27_74##2	9.04279e-17
C30	a_28_368#	Y#3	5.56703e-17
C31	Y#7	VGND#7	1.27695e-19
C32	a_27_74##2	VGND#7	2.15652e-18
C33	a_27_74##4	Y#7	3.87276e-19
C34	a_27_74##6	A2#4	3.522e-18
C35	VGND#4	A3#1	8.76857e-20
C36	a_27_74##4	a_27_74##2	1.72913e-18
C37	VGND#4	A3#4	8.35471e-19
C38	a_27_74##4	VGND#7	2.62199e-18
C39	B1#3	B1#4	1.91487e-17
C40	Y#3	VPWR#7	4.47515e-21
C41	B1#3	B1#2	1.09388e-17
C42	a_27_74##6	A1#2	8.787e-18
C43	VGND#4	A2#1	4.03656e-18
C44	a_27_74##4	VGND#8	5.31845e-17
C45	A2#4	a_297_368##2	8.36207e-19
C46	VGND#4	A2#7	5.55201e-18
C47	a_27_74##7	a_27_74##4	3.52595e-18
C48	A3#2	B1#4	2.85142e-17
C49	a_27_74##7	VGND#8	4.39572e-17
C50	A3#3	A3#2	8.81427e-19
C51	VGND#4	A1#1	4.868e-19
C52	A2#10	a_28_368#	1.79648e-17
C53	VGND#9	VGND#8	1.50261e-18
C54	VGND#4	A1#5	2.22173e-19
C55	VGND#9	a_27_74##7	4.39851e-17
C56	a_28_368##2	a_28_368#	6.21728e-19
C57	A3#9	B1#4	5.82457e-18
C58	a_27_74##8	a_27_74##7	3.44654e-18
C59	A2#3	A3#3	8.18913e-18
C60	Y#3	A3#4	7.32164e-18
C61	a_28_368##2	a_297_368##2	1.24785e-17
C62	A2#4	A2#3	1.469e-18
C63	A3#9	B1#2	1.43782e-19
C64	a_27_74##8	VGND#9	5.38591e-17
C65	Y#3	A2#1	4.25805e-19
C66	a_28_368##2	a_28_368##4	1.26689e-18
C67	a_28_368##2	VPWR#7	2.36653e-17
C68	Y#3	A2#7	1.91893e-19
C69	A1#2	VPWR#7	1.11989e-19
C70	a_28_368##3	a_28_368##2	5.34827e-19
C71	A1#3	A1#2	5.75408e-18
C72	a_27_74##6	A2#7	2.66144e-17
C73	Y#1	VPWR#6	5.89851e-17
C74	a_27_74##6	A1#1	1.3225e-17
C75	a_27_74#	B1#6	4.89472e-17
C76	B1#6	Y#7	2.25059e-17
C77	a_297_368#	VPWR#6	2.65692e-18
C78	a_27_74#	B1#5	1.90154e-18
C79	a_27_74##2	B1#6	8.79501e-19
C80	Y#7	B1#5	4.07595e-17
C81	Y#3	B1#7	1.06373e-19
C82	a_27_74#	A3#1	3.5866e-19
C83	B1#4	B1#2	2.62164e-18
C84	Y#2	B1#7	1.00656e-18
C85	a_27_74##2	B1#5	2.86749e-17
C86	Y#7	A3#1	1.91925e-17
C87	Y#3	B1#8	3.75351e-19
C88	a_27_74##2	A3#1	4.63542e-17
C89	a_297_368#	Y#4	8.50466e-19
C90	Y#2	B1#8	2.12722e-17
C91	Y#7	A3#4	6.50163e-20
C92	a_27_74##4	B1#5	4.65791e-20
C93	A3#1	VGND#7	2.01938e-17
C94	Y#3	A3#5	1.05678e-18
C95	a_27_74##2	A3#4	7.06611e-19
C96	a_27_74##8	a_28_368##3	1.6024e-19
C97	a_27_74##4	A3#1	6.69628e-19
C98	Y#2	A3#5	1.82017e-17
C99	A3#9	B1#7	6.05399e-19
C100	A3#4	VGND#7	1.88511e-17
C101	a_297_368##2	a_297_368#	1.23225e-18
C102	A3#1	B1#4	1.24762e-18
C103	VGND#8	A3#1	8.69737e-20
C104	Y#3	A3#6	3.82376e-17
C105	a_27_74##4	A3#4	6.36841e-17
C106	Y#2	A3#6	5.88287e-19
C107	A3#9	B1#8	1.04966e-18
C108	VGND#8	A3#4	4.62717e-19
C109	a_28_368#	a_297_368##2	7.89962e-17
C110	a_27_74##4	A2#1	5.28809e-17
C111	Y#3	A2#6	4.27878e-18
C112	A2#1	VGND#8	2.03907e-17
C113	A3#9	A3#5	2.06411e-18
C114	a_28_368##4	a_28_368#	2.36849e-18
C115	Y#2	A2#6	2.37331e-20
C116	a_27_74##4	A2#7	1.04811e-18
C117	a_27_74##7	A2#1	7.09677e-19
C118	a_28_368##4	a_297_368##2	5.3059e-17
C119	A2#7	VGND#8	2.33355e-17
C120	Y#3	A2#5	9.66683e-19
C121	VGND#9	A2#1	1.24714e-19
C122	a_27_74##7	A2#7	3.83764e-17
C123	VPWR#7	a_297_368##2	2.58007e-18
C124	VGND#8	A1#1	2.70797e-19
C125	VGND#9	A2#7	4.87445e-19
C126	Y#3	A1#4	6.37375e-19
C127	VPWR#7	a_28_368##4	5.30395e-17
C128	a_27_74##7	A1#1	3.33797e-17
C129	VGND#4	a_27_74##6	2.25448e-19
C130	VGND#8	A1#5	1.71095e-19
C131	A1#1	VGND#9	2.06944e-17
C132	a_28_368##3	a_28_368##4	2.03743e-18
C133	a_27_74##7	A1#5	1.12634e-18
C134	VGND#3	VGND#4	3.42638e-17
C135	Y#3	A1#6	3.39568e-19
C136	a_27_74##8	A1#1	1.09848e-18
C137	a_28_368##3	VPWR#7	5.21257e-17
C138	A1#5	VGND#9	2.54628e-17
C139	A3	A3#3	5.5745e-18
C140	a_27_74##8	A1#5	5.22862e-17
C141	a_28_368##2	A2#6	1.59203e-19
C142	A2#4	A2#1	6.6105e-19
C143	a_28_368##2	A2#5	2.438e-17
C144	B1#5	B1#6	3.00853e-17
C145	Y#1	B1#7	5.72003e-17
C146	a_28_368##2	A2#4	1.14303e-18
C147	A2	A3#3	7.90883e-18
C148	A2	A2#4	7.24181e-18
C149	a_28_368##2	A1#4	1.75137e-17
C150	B1#7	VPWR#6	2.67637e-17
C151	A2	A1#2	1.40278e-18
C152	Y#1	B1#8	2.29165e-18
C153	A3#1	B1#5	3.65791e-17
C154	B1#8	VPWR#6	2.90747e-17
C155	a_28_368##2	A1#6	4.29174e-18
C156	a_297_368#	B1#7	5.79324e-19
C157	B1#8	Y#5	2.60309e-17
C158	VPWR#6	A3#5	6.06286e-19
C159	a_28_368##2	A1#2	7.58826e-19
C160	a_297_368#	B1#8	1.7884e-18
C161	A3#4	A3#1	7.27676e-18
C162	A3#5	Y#5	4.27931e-18
C163	a_27_74#	B1#4	4.49013e-19
C164	A1#2	A2#7	3.59236e-18
C165	A1	A2#4	1.41984e-17
C166	a_297_368#	A3#5	5.3627e-17
C167	B1#3	Y#2	4.38456e-17
C168	A1	A1#2	1.89372e-17
C169	A2#1	A3#4	3.93002e-17
C170	B1#2	a_27_74#	6.27952e-18
C171	a_297_368#	A3#6	6.09701e-17
C172	Y#3	A3#2	1.61908e-18
C173	A3#6	Y#4	3.80516e-17
C174	Y#2	A3#2	5.66349e-19
C175	a_297_368#	A2#6	4.00382e-19
C176	A2#7	A2#1	2.16505e-17
C177	A3#9	B1#3	2.44453e-17
C178	a_28_368#	A3#6	1.431e-18
C179	a_297_368##2	A3#6	3.01602e-19
C180	Y#3	A2#3	2.47999e-18
C181	Y#7	B1#4	4.9782e-18
C182	a_297_368#	A2#5	1.16698e-19
C183	a_28_368#	A2#6	6.75032e-17
C184	B1	B1#2	2.0104e-17
C185	A3#9	A3#2	1.21793e-17
C186	A1#1	A2#7	3.619e-17
C187	a_27_74##6	A2#3	2.79575e-18
C188	a_297_368##2	A2#6	3.87622e-17
C189	a_28_368#	A2#5	1.37187e-18
C190	a_28_368##4	A2#6	1.86078e-18
C191	VGND#3	a_27_74##4	1.58069e-17
C192	A2#5	a_297_368##2	3.02825e-17
C193	VGND#4	A2#4	4.97431e-20
C194	VPWR#7	A2#6	2.71272e-19
C195	A1#5	A1#1	2.02466e-17
C196	a_27_74##6	A1#3	9.00497e-19
C197	a_28_368##4	A2#5	5.10715e-17
C198	a_27_74#	B1#3	2.97065e-18
C199	Y#7	A3#3	9.72574e-19
C200	a_297_368##2	A1#4	6.21446e-19
C201	Y#7	B1#3	5.6855e-17
C202	VPWR#7	A2#5	6.87375e-19
C203	Y#3	Y#2	3.80104e-18
C204	a_28_368##4	A1#4	4.59893e-17
C205	A1#2	A2#4	2.7346e-17
C206	A2#10	A2#3	1.068e-17
C207	A1#5	A1#2	5.62293e-18
C208	a_297_368##2	A1#6	3.46167e-19
C209	a_27_74##2	B1#4	7.82462e-20
C210	A1#4	VPWR#7	2.25963e-17
C211	Y#7	A3#2	2.72837e-18
C212	a_297_368#	VPWR#3	6.43433e-17
C213	a_28_368##4	A1#6	2.07075e-18
C214	a_28_368##2	A2#3	1.65736e-19
C215	a_28_368##3	A1#4	7.46456e-19
C216	a_27_74##2	A3#2	6.86747e-19
C217	VPWR#7	A1#6	4.37911e-17
C218	a_28_368##3	A1#6	3.52059e-17
C219	a_297_368##2	VPWR#3	5.45184e-17
C220	A1#3	a_28_368##2	3.15221e-18
C221	B1#3	Y#1	1.42634e-17
C222	a_27_74##2	A3#3	3.64521e-19
C223	B1#8	B1#7	4.69872e-17
C224	a_27_74##4	A2#3	8.68883e-19
C225	B1#3	VPWR#6	2.54187e-18
C226	VGND#8	A2#3	1.37144e-18
C227	B1#3	Y#5	1.58867e-19
C228	VPWR	B1#2	6.51024e-19
C229	A3#5	B1#8	3.70118e-17
C230	A3#2	a_297_368#	1.1315e-18
C231	VGND#9	A1#3	1.46606e-18
C232	A3#6	A3#5	4.60844e-17
C233	a_27_74##8	A1#3	1.42624e-17
C234	Y#3	A3	5.33148e-17
C235	VGND#3	A3#4	2.85337e-18
C236	A3	Y#2	4.69542e-18
C237	a_28_368#	A2#3	1.99613e-18
C238	A2#6	A3#6	4.83041e-18
C239	VGND#3	A2#1	1.4917e-18
C240	A2#3	a_297_368##2	1.54099e-18
C241	A2#5	A2#6	4.91444e-17
C242	VGND	A3#3	9.974e-19
C243	A2	Y#3	2.34599e-17
C244	a_27_74##6	A2	1.84522e-17
C245	A1#3	VPWR#7	1.12404e-18
C246	A3#4	A3#2	1.19046e-18
C247	A1#3	a_28_368##3	8.74798e-18
C248	A1#4	A2#5	4.7786e-17
C249	A3#9	Y#2	1.80559e-17
C250	A2#3	A3#4	5.28884e-18
C251	Y#7	A3	1.6257e-17
C252	VPWR#3	A3#6	4.4526e-18
C253	a_27_74##6	A1	5.91666e-17
C254	A1#6	A1#4	4.68327e-17
C255	a_27_74##4	A3#3	7.71148e-19
C256	VPWR#3	A2#6	4.42463e-18
C257	A2	a_28_368##2	1.59992e-17
C258	Y#3	B1	1.13318e-18
C259	a_27_74##4	A2	3.00623e-17
C260	A1	a_28_368##2	6.0349e-17
C261	Y#3	Y	1.52544e-18
C262	A2#3	A3#6	3.23301e-20
C263	a_27_74#	B1	2.99168e-17
C264	a_27_74##8	A1	4.02454e-17
C265	A2	a_28_368#	3.3386e-17
C266	A2	a_297_368##2	1.72974e-18
C267	VGND#4	a_27_74##4	1.74998e-18
C268	VPWR	Y#3	8.71908e-18
C269	VPWR#3	A3#2	2.18032e-20
C270	VPWR	Y#2	3.21664e-18
C271	A1#3	A1#6	1.75021e-18
C272	B1	Y#1	2.91866e-17
C273	VPWR#3	A2#3	1.66508e-19
C274	VGND#8	A2#4	1.12274e-19
C275	VGND	VGND#4	4.12768e-17
C276	VPWR	A3#9	1.57536e-18
C277	B1#4	VNB	3.75898e-17
C278	B1#2	VNB	5.18597e-17
C279	A3#3	VNB	3.86197e-17
C280	A2#4	VNB	2.74726e-17
C281	A1	a_28_368##3	2.98382e-17
C282	A1#2	VNB	3.71746e-17
C283	VPWR	A2#10	1.08151e-18
C284	B1#3	A3#2	5.1164e-18
C285	VPWR	a_28_368##2	4.27867e-18
C286	VGND	Y#3	4.14713e-18
C287	Y	VPWR#6	5.5124e-17
C288	VGND	Y#2	1.33915e-18
C289	Y	Y#5	4.38663e-18
C290	VGND	a_27_74##6	3.52673e-18
C291	a_297_368#	Y	6.29362e-17
C292	A3	A3#6	1.33179e-18
C293	VGND	A3#9	1.54925e-18
C294	B1	A3#4	1.63842e-19
C295	VGND	A2#10	1.31628e-18
C296	VPWR	Y#1	1.74322e-17
C297	A2	A3#6	4.90113e-19
C298	a_27_74##6	A2#10	1.3324e-17
C299	VGND	a_27_74#	2.41108e-17
C300	VPWR	a_297_368#	3.04382e-17
C301	VGND	Y#7	1.18908e-17
C302	VGND	a_27_74##2	2.27963e-17
C303	VPWR	a_28_368#	8.66923e-18
C304	VGND#4	a_27_74##7	8.43305e-18
C305	VGND	a_27_74##4	2.11007e-17
C306	A2	A1#4	1.55608e-19
C307	VPWR	a_297_368##2	2.50137e-17
C308	VPWR	a_28_368##4	1.58676e-17
C309	VGND	a_27_74##7	1.60454e-17
C310	VGND	a_27_74##8	1.68582e-17
C311	VPWR	a_28_368##3	1.50947e-17
C312	A1	A1#4	2.04598e-18
C313	A1	A1#6	1.62276e-18
C314	Y	B1#7	1.35839e-18
C315	Y	B1#8	2.90044e-17
C316	A3	A3#2	5.69401e-18
C317	Y	A3#5	1.35079e-17
C318	VGND#4	VNB	2.80415e-17
C319	Y	A3#6	2.99515e-19
C320	VGND	B1#6	2.19307e-18
C321	Y	A2#6	4.37893e-20
C322	VGND	B1#5	1.51613e-18
C323	VPWR	B1#7	1.14236e-18
C324	VGND	A3#1	4.43105e-19
C325	VPWR	B1#8	1.07343e-18
C326	Y#3	VNB	1.2065e-17
C327	VGND	A3#4	2.52631e-18
C328	A2	A2#3	1.33207e-17
C329	a_27_74##6	VNB	2.63691e-18
C330	VGND	A2#1	1.52708e-19
C331	VPWR	A3#5	1.95691e-18
C332	VGND	A2#7	1.59549e-19
C333	VPWR	A3#6	1.54305e-18
C334	A3#9	VNB	3.15271e-18
C335	VGND	A1#1	2.35585e-19
C336	VPWR	A2#6	1.60526e-18
C337	VGND	A1#5	1.14572e-18
C338	VPWR	A2#5	4.64153e-19
C339	A2#10	VNB	4.15573e-18
C340	VPWR	A1#4	6.45251e-19
C341	A1	A1#3	1.75396e-17
C342	a_27_74#	VNB	4.03457e-17
C343	VPWR	A1#6	3.27704e-18
C344	Y#7	VNB	2.48215e-18
C345	a_27_74##2	VNB	2.43263e-18
C346	a_27_74##4	VNB	9.18127e-18
C347	VGND#8	VNB	2.25126e-18
C348	VPWR	VPWR#3	2.96103e-17
C349	a_27_74##7	VNB	1.96561e-18
C350	VGND#9	VNB	2.24672e-18
C351	a_27_74##6	a_28_368##2	5.39489e-18
C352	a_27_74##8	VNB	4.66865e-17
C353	Y#1	VNB	5.23102e-17
C354	VPWR#6	VNB	2.82484e-18
C355	a_297_368#	VNB	9.92403e-18
C356	VPWR	B1#3	3.2472e-18
C357	a_28_368#	VNB	8.83325e-18
C358	a_297_368##2	VNB	8.50927e-18
C359	a_28_368##4	VNB	2.15003e-18
C360	VPWR#7	VNB	2.60465e-18
C361	a_28_368##3	VNB	4.98224e-17
C362	VGND	VGND#3	8.98943e-18
C363	B1#6	VNB	3.2811e-17
C364	B1#5	VNB	2.80884e-17
C365	VPWR	A1#3	6.46074e-19
C366	A3#1	VNB	2.81646e-17
C367	A3#4	VNB	3.5887e-17
C368	VGND	B1#3	3.76279e-18
C369	A1	A2	2.97377e-17
C370	A2#1	VNB	2.95882e-17
C371	A2#7	VNB	2.90762e-17
C372	A1#1	VNB	2.53908e-17
C373	A1#5	VNB	3.63847e-17
C374	B1#7	VNB	3.99841e-17
C375	VGND	A1#3	7.23345e-19
C376	B1#8	VNB	3.45386e-17
C377	A3#5	VNB	3.00209e-17
C378	A3#6	VNB	3.52383e-17
C379	A2#6	VNB	3.59565e-17
C380	A2#5	VNB	3.21405e-17
C381	VPWR	A3	1.53094e-18
C382	A1#4	VNB	3.10077e-17
C383	A1#6	VNB	4.05933e-17
C384	VPWR	A2	4.24997e-18
C385	VPWR#3	VNB	2.54595e-16
C386	VGND#3	VNB	2.1424e-16
C387	VGND	A3	1.54881e-18
C388	VPWR	A1	6.34023e-18
C389	B1#3	VNB	6.71154e-19
C390	VGND	A2	3.31227e-18
C391	VPWR	B1	3.25844e-18
C392	A3#2	VNB	3.10674e-17
C393	A2#3	VNB	3.86238e-17
C394	VGND	A1	6.48615e-18
C395	A1#3	VNB	4.53741e-17
C396	VPWR	Y	1.65129e-17
C397	VGND	B1	4.46652e-18
C398	A3	VNB	5.20248e-18
C399	A2	VNB	1.01981e-17
C400	A1	VNB	3.32401e-17
C401	B1	VNB	2.76495e-17
C402	Y	VNB	2.13225e-18
C403	VPWR	VNB	7.86563e-17
C404	VGND	VNB	6.59896e-17
C405	Y#7	Y#3	2.48453e-19
C406	VGND#8	VGND#2	1.59005e-18
C407	VPWR#4	A1#2	6.74602e-20
C408	VGND#2	VNB	8.06339e-17
C409	VGND#2	VGND#7	1.48775e-17
C410	VPWR#4	a_297_368##2	3.59642e-18
C411	Y#1	VPWR#2	2.10991e-17
C412	VPWR#2	B1#7	7.95062e-18
C413	VGND#2	A2#1	1.20086e-18
C414	VGND#5	VNB	5.14603e-17
C415	VGND	VGND#2	7.41247e-17
C416	VGND#2	B1#2	2.93628e-19
C417	VPWR#2	A3#5	4.6846e-18
C418	VPWR#4	A3#6	9.03715e-20
C419	VGND#2	A3#1	1.15365e-17
C420	VGND#5	a_27_74##8	2.10084e-17
C421	VPWR#4	A2#5	6.09997e-18
C422	VPWR#2	A2#6	8.15893e-20
C423	VPWR#4	A1#6	6.29768e-18
C424	B1	VPWR#2	4.39289e-19
C425	VGND#2	A3#2	1.03707e-18
C426	VPWR#3	VPWR#4	6.65122e-17
C427	VGND#5	A1#1	5.65012e-18
C428	VGND	VGND#5	5.53236e-17
C429	VGND#2	B1#6	4.72194e-18
C430	VPWR	VPWR#2	5.53429e-17
C431	VPWR#2	B1#4	2.2837e-20
C432	VGND#5	a_27_74##7	8.10386e-18
C433	VGND#4	VGND#2	1.36542e-18
C434	a_28_368##2	VPWR#4	7.70776e-19
C435	VPWR	VPWR#4	6.09587e-17
C436	VGND#5	A2#1	1.63365e-19
C437	Y#2	VPWR#2	7.71518e-19
C438	VGND#2	a_27_74##4	4.59527e-17
C439	VGND#5	VGND#4	1.35535e-18
C440	VGND#2	A2#7	3.36782e-19
C441	a_28_368##4	VPWR#4	1.66935e-17
C442	a_28_368##3	VPWR#4	1.81912e-17
C443	VGND#2	a_27_74##2	9.53652e-17
C444	VGND#2	A3#3	1.43255e-18
C445	VPWR#2	B1#8	5.0867e-18
C446	VGND#3	VGND#5	5.53144e-17
C447	VGND#2	A3#4	9.679e-18
C448	a_297_368#	VPWR#2	5.2875e-18
C449	VGND#5	A1#5	6.24323e-18
C450	VGND#2	a_27_74#	5.76606e-17
C451	VGND#2	B1#4	5.68087e-20
C452	VPWR#2	A3#6	1.90284e-19
C453	VPWR#4	A2#6	2.23082e-19
C454	VPWR#4	A1#4	5.087e-18
C455	VGND#2	B1#5	4.96733e-18
C456	Y	VPWR#2	1.75377e-17
C457	VGND#2	B1	8.30064e-19
C458	VPWR#2	B1#2	4.19437e-19
C459	VGND#5	A2#7	8.77242e-19
C460	VPWR#3	VPWR#2	6.63718e-17
C461	VPWR#2	VNB	5.76896e-17
C462	VGND#3	VGND#2	9.48959e-17
C463	VGND#5	a_27_74##6	2.25448e-19
C464	VPWR#4	VNB	5.78879e-17
C465	VPWR#4	A2#4	1.15177e-21
*
*
.ENDS sky130_fd_sc_hs__o31ai_2
*
