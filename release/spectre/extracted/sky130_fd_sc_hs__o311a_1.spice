* Extracted by Quantus, converted by sky130cad/quantus.py
*
*
*
*                       LINUX           Wed Nov 18 09:00:25 2026
*
*
*
*  PROGRAM  advgen
*
*  Name           : advgen - Quantus - (64-bit)
*  Version        : 25.1.0-p047
*  Build Date     : Thu Dec 11 23:20:30 PST 2025
*
*  HSPICE LIBRARY
*
*  OPERATING_TEMPERATURE 150
*  QRC_TECH_DIR <path>/tech
*
*
*

*
.SUBCKT sky130_fd_sc_hs__o311a_1 VNB VPB VGND VPWR X A3 A1 C1 B1 A2
*
*
*  caps2d version: 10
*
*
*       TRANSISTOR CARDS
*
*
XM10 a_31_387##9 C1#1 a_131_74# VNB sky130_fd_pr__nfet_01v8_lvt l=0.15 w=0.64 ad=0.1824 as=0.1536 pd=1.85 ps=1.76
XM0 a_131_74# B1#3 a_209_74##2 VNB sky130_fd_pr__nfet_01v8_lvt l=0.15 w=0.64 ad=0.1536 as=0.2496 pd=1.76 ps=2.06
XM2 a_209_74##2 A2#2 VGND#5 VNB sky130_fd_pr__nfet_01v8_lvt l=0.15 w=0.64 ad=0.2496 as=0.3648 pd=2.06 ps=2.42
XM3 VGND#5 A3#1 a_209_74# VNB sky130_fd_pr__nfet_01v8_lvt l=0.15 w=0.64 ad=0.3648 as=0.5952 pd=2.42 ps=3.14
XM1 a_209_74# A1#1 VGND#3 VNB sky130_fd_pr__nfet_01v8_lvt l=0.15 w=0.64 ad=0.5952 as=0.2554 pd=3.14 ps=2.2
XM8 VGND#3 a_31_387# X#1 VNB sky130_fd_pr__nfet_01v8_lvt l=0.15 w=0.74 ad=0.2554 as=0.2109 pd=2.2 ps=2.05
XM11 a_31_387##8 C1#4 VPWR#7 VPB sky130_fd_pr__pfet_01v8 l=0.15 w=1 ad=0.295 as=0.4 pd=2.59 ps=2.8
XM4 VPWR#7 B1#1 a_31_387##5 VPB sky130_fd_pr__pfet_01v8 l=0.15 w=1 ad=0.4 as=0.3 pd=2.8 ps=2.6
XM6 a_31_387##5 A3#3 a_320_387# VPB sky130_fd_pr__pfet_01v8 l=0.15 w=1 ad=0.3 as=0.93 pd=2.6 ps=3.86
XM9 a_320_387# A2#3 a_536_387# VPB sky130_fd_pr__pfet_01v8 l=0.15 w=1 ad=0.93 as=0.42 pd=3.86 ps=2.84
XM7 a_536_387# A1#3 VPWR#6 VPB sky130_fd_pr__pfet_01v8 l=0.15 w=1 ad=0.42 as=0.5038 pd=2.84 ps=3.18
XM5 VPWR#6 a_31_387##3 X#3 VPB sky130_fd_pr__pfet_01v8 l=0.15 w=1.12 ad=0.5038 as=0.3304 pd=3.18 ps=2.83
*
*
*       RESISTOR AND CAP/DIODE CARDS
*
Rg1	C1#1	C1#2	302.415039
Rg2	C1#2	C1#3	32.565670
Rg3	C1#2	C1#4	548.786133
Rg4	B1#1	B1#2	533.757141
Rg5	B1#2	B1#3	290.721832
Rg6	A2#1	A2#2	450.954651
Rg7	A3#1	A3#2	298.599518
Rg8	A3#2	A3#3	817.094238
Rg9	A2#3	A2#4	400.207520
Rg10	A1#1	A1#2	279.244598
Rg11	A1#2	A1#3	542.457581
Rg12	a_31_387#	a_31_387##2	394.958344
Rg13	a_31_387##2	a_31_387##3	442.817719
Rf1	C1	C1#3	161.413818
Rf2	B1	B1#2	165.744217
Rf3	A3	A3#2	160.626480
Rf4	A2#4	A2#1	327.447296
Rf5	A2#1	A2	0.372219
Rf6	a_209_74#	a_209_74##2	70.940216
Rf7	A1#2	A1	164.169525
Rf8	a_31_387##2	a_31_387##6	426.747864
Rf9	a_31_387##6	a_31_387##7	67.453918
Rf10	a_31_387##7	a_31_387##8	53.170792
Rf11	a_31_387##7	a_31_387##9	82.219131
Rf12	a_31_387##5	a_31_387##6	5.000000
Rf13	X#2	X	6.615660
Rf14	X	X#3	97.922653
Rf15	X#2	X	6.615660
Rf16	X#1	X#2	7.500000
Rf18	VGND#2	VGND#4	23.837896
Rf19	VGND#4	VGND#5	135.805908
Rf20	VGND#2	VGND#6	99.689392
Rf21	VGND#3	VGND#4	7.500000
Rf23	VPWR#2	VPWR#3	99.324142
Rf24	VPWR#3	VPWR#4	99.324142
Rf26	VPWR#2	VPWR#6	35.530331
Rf27	VPWR#4	VPWR#7	36.317677
Re1	VPWR#3	VPWR	1.091357
Re2	VGND	VGND#6	1.091398
*
*       CAPACITOR CARDS
*
*
C1	VGND	VNB	7.91466e-17
C2	VPWR	VNB	8.29311e-17
C3	X	VNB	1.50902e-17
C4	A3	VNB	3.74314e-18
C5	A1	VNB	1.38286e-18
C6	C1	VNB	2.08739e-17
C7	X#1	a_31_387#	2.61919e-17
C8	VGND	X	2.03143e-17
C9	C1#3	VNB	7.09195e-17
C10	VPWR#6	X#3	8.9049e-17
C11	B1#2	VNB	3.41828e-17
C12	VGND	A3	3.94314e-18
C13	A2#1	VNB	2.62768e-17
C14	A3#2	VNB	3.3742e-17
C15	A2#4	VNB	2.19745e-17
C16	VGND	A1	1.67738e-18
C17	A1#2	VNB	4.32999e-17
C18	a_31_387##2	VNB	5.05364e-17
C19	VGND#6	VNB	2.84543e-16
C20	VGND	C1	4.75483e-18
C21	VPWR	A3	4.24437e-18
C22	VPWR#3	VNB	2.27609e-16
C23	C1#4	VNB	5.32947e-17
C24	B1#1	VNB	3.98415e-17
C25	A3#3	VNB	4.65592e-17
C26	A2#3	VNB	3.35306e-17
C27	A1#3	VNB	4.50383e-17
C28	a_31_387##3	VNB	4.0238e-17
C29	VPWR	C1	1.92e-18
C30	C1#1	VNB	2.80457e-17
C31	B1#3	VNB	2.70213e-17
C32	A2#2	VNB	2.77068e-17
C33	A3#1	VNB	2.63234e-17
C34	A1#1	VNB	2.57768e-17
C35	a_31_387#	VNB	3.27834e-17
C36	a_31_387##8	VNB	6.09306e-17
C37	VPWR#7	VNB	5.5205e-18
C38	a_31_387##5	VNB	1.11993e-17
C39	A3	A1	8.82679e-18
C40	VPWR#6	VNB	6.06365e-18
C41	X#3	VNB	6.12305e-17
C42	a_31_387##9	VNB	3.56526e-17
C43	a_209_74##2	VNB	1.00453e-17
C44	a_209_74#	VNB	9.43128e-18
C45	VGND	C1#3	1.91573e-18
C46	VGND#3	VNB	7.62418e-19
C47	X#1	VNB	4.56939e-17
C48	VGND	B1#2	4.85291e-18
C49	VGND	A2#1	5.46101e-18
C50	a_31_387##7	VNB	7.55007e-18
C51	VGND	A2#4	4.9527e-18
C52	VGND	A1#2	1.223e-18
C53	VPWR	C1#3	7.1635e-19
C54	VGND	a_31_387##2	6.5718e-18
C55	VGND	VGND#6	6.15086e-17
C56	VPWR	A2#1	7.00412e-18
C57	VPWR	A3#2	1.45589e-18
C58	A3	a_320_387#	5.5437e-18
C59	VPWR	A2#4	1.09329e-17
C60	VPWR	a_31_387##2	1.40136e-17
C61	VPWR	VPWR#3	3.00174e-17
C62	VGND	C1#1	1.05188e-18
C63	A3	C1#3	2.55615e-19
C64	VGND	B1#3	1.09602e-18
C65	VGND	A2#2	1.2862e-18
C66	VPWR	C1#4	7.85841e-18
C67	A3	B1#2	1.75623e-19
C68	VGND	A3#1	1.15912e-18
C69	VPWR	B1#1	8.16374e-18
C70	VGND	A1#1	4.09753e-19
C71	A2#1	A3	9.27254e-17
C72	VPWR	A3#3	1.56356e-17
C73	VGND	a_31_387#	2.03527e-18
C74	A3	A3#2	3.54413e-17
C75	VGND	a_31_387##8	2.73833e-18
C76	VPWR	A2#3	9.35753e-18
C77	VPWR	A1#3	9.7813e-18
C78	A3	A2#4	8.74048e-17
C79	VPWR	a_31_387##3	2.27025e-18
C80	A3	A1#2	2.20405e-18
C81	C1	C1#3	2.02747e-17
C82	A1	A3#2	3.11649e-18
C83	VGND	a_31_387##9	2.04265e-17
C84	A2#4	A1	1.12006e-17
C85	VGND	a_209_74##2	2.79868e-17
C86	VGND	VGND#5	1.02895e-17
C87	VGND	a_209_74#	4.07842e-17
C88	A1	A1#2	1.00758e-17
C89	VGND	VGND#3	6.47421e-18
C90	VPWR	a_31_387##8	1.61503e-17
C91	A1	a_31_387##2	1.68904e-17
C92	VPWR	VPWR#7	2.12438e-17
C93	VPWR	a_31_387##5	4.58568e-17
C94	A3	A3#3	6.33655e-19
C95	VPWR	VPWR#6	2.24512e-17
C96	A3	A2#3	3.2116e-18
C97	VPWR	X#3	2.01819e-17
C98	VGND	a_31_387##7	4.73858e-18
C99	X	A1#1	6.54558e-19
C100	VGND#6	C1	1.16972e-18
C101	X	a_31_387#	1.0839e-17
C102	VPWR	a_31_387##7	3.32383e-18
C103	a_31_387##9	a_209_74##2	2.92676e-17
C104	VGND#3	X	2.04007e-17
C105	X	X#1	1.05516e-18
C106	A2#1	a_320_387#	7.32389e-18
C107	A3#2	a_320_387#	1.33709e-18
C108	a_31_387##9	A3	1.32233e-18
C109	A2#4	a_320_387#	1.41561e-17
C110	VGND#5	A3	4.22823e-17
C111	C1#3	B1#2	3.07428e-17
C112	A2#4	a_536_387#	4.14185e-18
C113	C1	a_31_387##8	2.73735e-17
C114	A2#1	C1#3	9.91612e-20
C115	B1#2	A2#1	6.21686e-17
C116	a_31_387##9	a_209_74#	2.97168e-20
C117	a_31_387##2	a_536_387#	3.86594e-18
C118	A1	a_209_74#	1.96808e-18
C119	B1#2	A3#2	1.27697e-18
C120	VGND#3	A1	2.35869e-17
C121	C1	a_31_387##9	4.41805e-17
C122	A2#1	A3#2	3.55399e-17
C123	X#1	X#3	2.82204e-18
C124	a_209_74##2	VGND#5	4.6584e-17
C125	A2#1	A2#4	2.41344e-18
C126	A3#3	a_320_387#	1.64993e-17
C127	C1#1	a_131_74#	1.24742e-17
C128	VGND#6	C1#3	8.82297e-19
C129	B1#3	a_131_74#	9.95235e-18
C130	A3#2	A2#4	2.56902e-17
C131	A2#3	a_320_387#	3.37469e-17
C132	VGND#6	B1#2	1.39577e-18
C133	A3#2	A1#2	4.28784e-18
C134	a_209_74##2	a_209_74#	7.44193e-19
C135	A2#3	a_536_387#	1.78735e-17
C136	VGND#6	A2#1	1.47006e-19
C137	A2#4	A1#2	2.23442e-17
C138	A1#3	a_536_387#	2.53739e-17
C139	VGND#6	A3#2	1.88208e-19
C140	A2#4	a_31_387##2	9.14272e-17
C141	a_31_387##7	VPWR#7	3.75377e-17
C142	C1	a_31_387##7	1.70587e-17
C143	a_209_74#	VGND#5	6.94982e-17
C144	VPWR#3	A3#2	2.61401e-19
C145	VGND#6	A2#4	1.14599e-19
C146	a_31_387##2	A1#2	6.98493e-17
C147	VPWR#3	A2#4	1.33184e-20
C148	A2#1	A3#3	4.64999e-17
C149	a_31_387##9	a_131_74#	1.64175e-18
C150	A2#1	A2#3	7.67948e-19
C151	a_31_387##5	a_320_387#	1.06017e-17
C152	VGND#3	a_209_74#	8.42528e-17
C153	A3#2	A2#3	1.1643e-19
C154	A2#4	A3#3	6.01421e-19
C155	A2#4	A2#3	1.84263e-17
C156	a_31_387##5	a_536_387#	2.49842e-19
C157	A2#4	A1#3	1.38104e-17
C158	a_31_387##2	A3#3	4.42916e-19
C159	a_31_387##8	C1#3	8.78621e-18
C160	a_31_387##2	A2#3	7.31085e-18
C161	VGND#6	A3#3	3.87934e-20
C162	VGND#3	X#1	3.34561e-17
C163	a_31_387##2	A1#3	4.12269e-17
C164	A2#2	A3#2	7.27353e-19
C165	VPWR#3	A3#3	2.75581e-18
C166	a_31_387##2	a_31_387##3	5.02768e-18
C167	VPWR#7	B1#2	5.4541e-19
C168	VPWR#3	A2#3	5.18893e-18
C169	C1#4	B1#1	3.13097e-17
C170	A3#2	A1#1	2.50547e-19
C171	A2#1	a_31_387##5	7.78971e-17
C172	a_31_387##9	C1#3	1.14492e-17
C173	B1#1	A3#3	5.18435e-17
C174	VGND#6	C1#1	5.45178e-18
C175	VGND#6	B1#3	8.61498e-18
C176	a_31_387##5	A3#2	1.62169e-18
C177	a_31_387##9	B1#2	2.10907e-17
C178	A1#2	a_31_387#	7.4523e-18
C179	a_31_387##9	a_31_387##7	1.42018e-18
C180	VGND#6	A2#2	4.68182e-18
C181	A3#3	A2#3	4.08019e-18
C182	B1#2	a_209_74##2	3.4764e-17
C183	A2#4	a_31_387##5	4.39985e-17
C184	VGND#6	A3#1	4.66629e-18
C185	a_31_387##9	A2#1	2.45029e-20
C186	A2#3	A1#3	2.32834e-17
C187	a_209_74##2	A2#1	5.86639e-18
C188	a_31_387##9	A3#2	1.08431e-19
C189	A2#1	VGND#5	2.77627e-17
C190	a_31_387##5	a_31_387##2	2.15694e-18
C191	a_209_74##2	a_31_387##7	7.01944e-18
C192	VPWR#6	A1#2	1.4243e-18
C193	A1#3	a_31_387##3	2.84285e-17
C194	VGND#5	A3#2	3.55545e-18
C195	a_209_74#	A3#2	9.61511e-19
C196	a_31_387##2	VPWR#6	1.33555e-16
C197	VGND#5	A2#4	1.00082e-17
C198	a_31_387##5	VPWR#3	4.98985e-17
C199	a_31_387##7	C1#3	1.11177e-17
C200	a_31_387##2	X#3	2.99344e-17
C201	X#1	A3#2	1.76993e-19
C202	a_209_74#	A2#4	1.31779e-18
C203	a_31_387##8	C1#4	5.11819e-17
C204	VGND#3	A2#4	1.02978e-17
C205	C1#4	VPWR#7	3.91682e-17
C206	a_31_387##7	B1#2	7.0354e-17
C207	a_31_387##8	B1#1	1.19201e-18
C208	a_209_74#	A1#2	7.67942e-19
C209	VGND#6	a_31_387##9	2.34398e-17
C210	a_31_387##5	C1#4	1.18678e-18
C211	VGND#3	A1#2	1.86865e-17
C212	B1#1	VPWR#7	2.891e-17
C213	A1#2	X#1	7.62318e-18
C214	a_31_387##5	B1#1	5.00183e-17
C215	VGND#6	a_209_74##2	5.76924e-17
C216	A2#1	a_31_387##7	3.23976e-17
C217	VPWR#7	A3#3	1.84761e-18
C218	C1#1	B1#3	4.53074e-17
C219	VGND#3	a_31_387##2	1.37194e-17
C220	a_31_387##5	A3#3	7.40763e-17
C221	X#1	a_31_387##2	3.72366e-17
C222	VGND#6	a_209_74#	5.86196e-17
C223	VPWR#7	A2#3	6.88897e-19
C224	a_31_387##7	A3#2	2.92522e-19
C225	a_31_387##5	A2#3	2.58934e-17
C226	B1#3	A2#2	2.15333e-17
C227	a_31_387##5	A1#3	2.67727e-19
C228	VPWR#6	A3#3	6.84396e-19
C229	A2#2	A3#1	9.73886e-18
C230	VPWR#6	A2#3	1.70806e-18
C231	A1#3	VPWR#6	3.48262e-17
C232	A3#1	A1#1	3.07413e-18
C233	a_209_74##2	A3#3	1.8805e-19
C234	X#3	A1#3	4.74352e-19
C235	a_31_387##3	VPWR#6	3.64642e-17
C236	VGND#5	A3#3	1.97913e-19
C237	X#3	a_31_387##3	4.65346e-17
C238	a_209_74#	A3#3	6.8382e-21
C239	A1#1	a_31_387#	2.40991e-17
C240	VGND#6	a_31_387##7	4.19417e-19
C241	a_31_387##9	C1#1	3.86716e-17
C242	a_31_387##8	VPWR#7	8.6428e-17
C243	a_31_387##9	B1#3	9.19875e-18
C244	a_209_74##2	C1#1	6.37001e-18
C245	a_31_387##7	C1#4	8.33258e-18
C246	a_31_387##8	a_31_387##5	3.40256e-18
C247	a_31_387##9	A2#2	2.66774e-18
C248	B1#3	a_209_74##2	3.33744e-17
C249	VPWR#7	a_31_387##5	8.82147e-17
C250	a_31_387##7	B1#1	8.45398e-18
C251	a_31_387##9	A3#1	3.09521e-19
C252	a_209_74##2	A2#2	5.43403e-17
C253	a_31_387##7	A3#3	6.56703e-18
C254	VGND#5	A2#2	2.85782e-17
C255	a_209_74##2	A3#1	1.34693e-18
C256	VGND#5	A3#1	3.86015e-17
C257	a_209_74##2	A1#1	4.06248e-19
C258	VGND#3	A2#2	7.82484e-20
C259	a_31_387##9	a_31_387##8	1.8567e-18
C260	a_209_74#	A3#1	5.15432e-17
C261	VGND#3	A3#1	4.71685e-19
C262	A1#1	a_209_74#	2.10186e-17
C263	X#1	A3#1	4.82487e-19
C264	VGND#3	A1#1	5.03845e-17
C265	X#1	A1#1	2.13269e-18
C266	a_31_387#	VGND#3	1.75861e-17
C267	VGND#2	A2#2	1.1015e-19
C268	VGND#2	A1#2	1.60867e-19
C269	VGND	VGND#2	6.22571e-17
C270	VPWR#3	VPWR#2	6.45662e-17
C271	VGND#2	A2#4	3.82439e-20
C272	a_31_387##5	VPWR#2	2.07663e-18
C273	VGND#2	a_31_387#	8.66731e-18
C274	a_31_387##2	VPWR#2	1.44181e-17
C275	VPWR#2	a_31_387##3	4.59925e-18
C276	VPWR	VPWR#2	4.16242e-17
C277	a_31_387##5	VPWR#4	1.63933e-17
C278	VGND#2	VGND#3	9.64948e-19
C279	VPWR#4	C1#3	9.53521e-19
C280	VPWR#2	A1#3	2.77688e-18
C281	VPWR#4	A3#3	2.52246e-18
C282	VGND#2	A1#1	7.68332e-18
C283	VGND#2	VNB	5.84983e-17
C284	VGND#6	VGND#2	6.4859e-17
C285	VPWR	VPWR#4	4.37196e-17
C286	VPWR#2	A2#4	3.52197e-20
C287	VPWR#4	B1#1	3.48936e-18
C288	a_31_387##8	VPWR#4	1.90226e-17
C289	VGND#2	X	2.25956e-17
C290	VPWR#4	C1#4	6.98929e-18
C291	VGND#2	a_209_74#	3.01774e-17
C292	VGND#2	A3#1	6.88172e-19
C293	VPWR#2	VNB	5.69212e-17
C294	VGND#2	a_31_387##2	4.52662e-19
C295	VPWR#4	VNB	5.71994e-17
C296	VPWR#3	VPWR#4	6.46063e-17
C297	a_31_387##7	VPWR#4	4.168e-19
C298	X#3	VPWR#2	2.33307e-17
*
*
.ENDS sky130_fd_sc_hs__o311a_1
*
