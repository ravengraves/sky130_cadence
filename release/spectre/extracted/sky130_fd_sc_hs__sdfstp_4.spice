* Extracted by Quantus, converted by sky130cad/quantus.py
*
*
*
*                       LINUX           Wed Nov 18 09:11:01 2026
*
*
*
*  PROGRAM  advgen
*
*  Name           : advgen - Quantus - (64-bit)
*  Version        : 25.1.0-p047
*  Build Date     : Thu Dec 11 23:20:30 PST 2025
*
*  HSPICE LIBRARY
*
*  OPERATING_TEMPERATURE 150
*  QRC_TECH_DIR <path>/tech
*
*
*

*
.SUBCKT sky130_fd_sc_hs__sdfstp_4 VNB VPB VGND SET_B VPWR Q SCD CLK SCE D
*
*
*  caps2d version: 10
*
*
*       TRANSISTOR CARDS
*
*
XM47 a_27_74##9 SCE#4 VGND#22 VNB sky130_fd_pr__nfet_01v8_lvt l=0.15 w=0.42 ad=0.1197 as=0.1638 pd=1.41 ps=1.62
XM4 VGND#22 a_27_74# a_222_74# VNB sky130_fd_pr__nfet_01v8_lvt l=0.15 w=0.42 ad=0.1638 as=0.1008 pd=1.62 ps=1.32
XM2 a_222_74# D#1 a_288_464##6 VNB sky130_fd_pr__nfet_01v8_lvt l=0.15 w=0.42 ad=0.1008 as=0.1827 pd=1.32 ps=1.71
XM48 a_288_464##6 SCE#6 a_417_74# VNB sky130_fd_pr__nfet_01v8_lvt l=0.15 w=0.42 ad=0.1827 as=0.1008 pd=1.71 ps=1.32
XM42 a_417_74# SCD#3 VGND#21 VNB sky130_fd_pr__nfet_01v8_lvt l=0.15 w=0.42 ad=0.1008 as=0.1197 pd=1.32 ps=1.41
XM33 a_616_74##15 CLK#3 VGND#20 VNB sky130_fd_pr__nfet_01v8_lvt l=0.15 w=0.74 ad=0.2109 as=0.259 pd=2.05 ps=2.18
XM26 VGND#20 a_616_74##10 a_803_74##13 VNB sky130_fd_pr__nfet_01v8_lvt l=0.15 w=0.74 ad=0.259 as=0.2109 pd=2.18 ps=2.05
XM37 a_288_464##5 a_616_74##9 a_1017_81##13 VNB sky130_fd_pr__nfet_01v8_lvt l=0.15 w=0.42 ad=0.1765 as=0.2226 pd=1.73 ps=1.9
XM49 a_1017_81##13 a_803_74# a_1153_81# VNB sky130_fd_pr__nfet_01v8_lvt l=0.15 w=0.42 ad=0.2226 as=0.1008 pd=1.9 ps=1.32
XM43 a_1153_81# a_1201_55# VGND#19 VNB sky130_fd_pr__nfet_01v8_lvt l=0.15 w=0.42 ad=0.1008 as=0.2084 pd=1.32 ps=1.95
XM34 a_1201_55##5 a_1017_81# a_1445_74# VNB sky130_fd_pr__nfet_01v8_lvt l=0.15 w=0.42 ad=0.1197 as=0.1008 pd=1.41 ps=1.32
XM17 a_1445_74# SET_B#1 VGND#18 VNB sky130_fd_pr__nfet_01v8_lvt l=0.15 w=0.42 ad=0.1008 as=0.344 pd=1.32 ps=2.52
XM21 a_1677_74##2 a_1017_81##8 VGND#18 VNB sky130_fd_pr__nfet_01v8_lvt l=0.15 w=0.64 ad=0.1792 as=0.344 pd=1.84 ps=2.52
XM12 VGND#17 a_1017_81##4 a_1677_74##2 VNB sky130_fd_pr__nfet_01v8_lvt l=0.15 w=0.64 ad=0.1824 as=0.1792 pd=1.85 ps=1.84
XM29 a_1677_74# a_803_74##10 a_1823_524##19 VNB sky130_fd_pr__nfet_01v8_lvt l=0.15 w=0.64 ad=0.1792 as=0.1824 pd=1.84 ps=1.85
XM13 a_1823_524##17 a_803_74##7 a_1677_74# VNB sky130_fd_pr__nfet_01v8_lvt l=0.15 w=0.64 ad=0.2139 as=0.1792 pd=2 ps=1.84
XM7 a_1823_524##17 a_616_74# a_2149_74# VNB sky130_fd_pr__nfet_01v8_lvt l=0.15 w=0.42 ad=0.2139 as=0.1008 pd=2 ps=1.32
XM35 a_2149_74# a_2191_180##3 a_2227_74# VNB sky130_fd_pr__nfet_01v8_lvt l=0.15 w=0.42 ad=0.1008 as=0.1638 pd=1.32 ps=1.62
XM8 a_2227_74# SET_B#4 VGND#16 VNB sky130_fd_pr__nfet_01v8_lvt l=0.15 w=0.42 ad=0.1638 as=0.2184 pd=1.62 ps=1.88
XM28 VGND#16 a_1823_524##9 a_2191_180##7 VNB sky130_fd_pr__nfet_01v8_lvt l=0.15 w=0.42 ad=0.2184 as=0.1197 pd=1.88 ps=1.41
XM16 a_2580_74##16 a_1823_524##6 VGND#15 VNB sky130_fd_pr__nfet_01v8_lvt l=0.15 w=0.74 ad=0.2109 as=0.259 pd=2.05 ps=2.18
XM44 Q#4 a_2580_74##12 VGND#15 VNB sky130_fd_pr__nfet_01v8_lvt l=0.15 w=0.74 ad=0.3219 as=0.259 pd=2.35 ps=2.18
XM19 Q#4 a_2580_74##10 VGND#14 VNB sky130_fd_pr__nfet_01v8_lvt l=0.15 w=0.74 ad=0.3219 as=0.259 pd=2.35 ps=2.18
XM9 VGND#14 a_2580_74##7 Q#6 VNB sky130_fd_pr__nfet_01v8_lvt l=0.15 w=0.74 ad=0.259 as=0.2072 pd=2.18 ps=2.04
XM6 VGND#1 a_2580_74##6 Q#6 VNB sky130_fd_pr__nfet_01v8_lvt l=0.15 w=0.74 ad=0.25955 as=0.2072 pd=2.19 ps=2.04
XM10 a_27_74##7 SCE#5 VPWR#24 VPB sky130_fd_pr__pfet_01v8 l=0.15 w=0.64 ad=0.1824 as=0.192 pd=1.85 ps=1.88
XM36 VPWR#24 SCE#1 a_204_464# VPB sky130_fd_pr__pfet_01v8 l=0.15 w=0.64 ad=0.192 as=0.1728 pd=1.88 ps=1.82
XM45 a_204_464# D#3 a_288_464##4 VPB sky130_fd_pr__pfet_01v8 l=0.15 w=0.64 ad=0.1728 as=0.3072 pd=1.82 ps=2.24
XM39 a_288_464##4 a_27_74##3 a_414_464# VPB sky130_fd_pr__pfet_01v8 l=0.15 w=0.64 ad=0.3072 as=0.1728 pd=2.24 ps=1.82
XM0 a_414_464# SCD#4 VPWR#23 VPB sky130_fd_pr__pfet_01v8 l=0.15 w=0.64 ad=0.1728 as=0.2954 pd=1.82 ps=2.4
XM11 a_616_74##13 CLK#1 VPWR#22 VPB sky130_fd_pr__pfet_01v8 l=0.15 w=1.12 ad=0.3304 as=0.336 pd=2.83 ps=2.84
XM32 VPWR#22 a_616_74##11 a_803_74##18 VPB sky130_fd_pr__pfet_01v8 l=0.15 w=1.12 ad=0.336 as=0.3256 pd=2.84 ps=2.93
XM20 a_288_464# a_803_74##6 a_1017_81##14 VPB sky130_fd_pr__pfet_01v8 l=0.15 w=0.42 ad=0.1239 as=0.19495 pd=1.43 ps=1.99
XM40 a_1017_81##14 a_616_74##8 a_1140_495# VPB sky130_fd_pr__pfet_01v8 l=0.15 w=0.42 ad=0.19495 as=0.18235 pd=1.99 ps=1.93
XM41 a_1140_495# a_1201_55##4 VPWR#21 VPB sky130_fd_pr__pfet_01v8 l=0.15 w=0.42 ad=0.18235 as=0.31385 pd=1.93 ps=2.48
XM23 VPWR#21 a_1017_81##3 a_1201_55##7 VPB sky130_fd_pr__pfet_01v8 l=0.15 w=0.42 ad=0.31385 as=0.1386 pd=2.48 ps=1.5
XM22 a_1201_55##7 SET_B#3 VPWR#20 VPB sky130_fd_pr__pfet_01v8 l=0.15 w=0.42 ad=0.1386 as=0.3339 pd=1.5 ps=2.74
XM46 VPWR#20 a_1017_81##7 a_1620_373##2 VPB sky130_fd_pr__pfet_01v8 l=0.15 w=0.84 ad=0.3339 as=0.252 pd=2.74 ps=2.28
XM24 a_1620_373##2 a_1017_81##9 VPWR#19 VPB sky130_fd_pr__pfet_01v8 l=0.15 w=0.84 ad=0.252 as=0.23175 pd=2.28 ps=2.27
XM1 a_1823_524##15 a_616_74##7 a_1620_373# VPB sky130_fd_pr__pfet_01v8 l=0.15 w=0.84 ad=0.2328 as=0.252 pd=2.27 ps=2.28
XM27 a_1620_373# a_616_74##2 a_1823_524##13 VPB sky130_fd_pr__pfet_01v8 l=0.15 w=0.84 ad=0.252 as=0.2604 pd=2.28 ps=2.39
XM25 a_1823_524##13 a_803_74##11 a_2103_508# VPB sky130_fd_pr__pfet_01v8 l=0.15 w=0.42 ad=0.2604 as=0.1995 pd=2.39 ps=1.79
XM3 a_2103_508# a_2191_180# VPWR#18 VPB sky130_fd_pr__pfet_01v8 l=0.15 w=0.42 ad=0.1995 as=0.126 pd=1.79 ps=1.44
XM30 VPWR#18 SET_B#6 a_1823_524##16 VPB sky130_fd_pr__pfet_01v8 l=0.15 w=0.42 ad=0.126 as=0.1239 pd=1.44 ps=1.43
XM14 a_2191_180##6 a_1823_524##8 VPWR#17 VPB sky130_fd_pr__pfet_01v8 l=0.15 w=0.42 ad=0.1239 as=0.2604 pd=1.43 ps=2.39
XM31 a_2580_74##14 a_1823_524##7 VPWR#17 VPB sky130_fd_pr__pfet_01v8 l=0.15 w=0.84 ad=0.252 as=0.2604 pd=2.28 ps=2.39
XM5 VPWR#16 a_1823_524# a_2580_74##14 VPB sky130_fd_pr__pfet_01v8 l=0.15 w=0.84 ad=0.3724 as=0.252 pd=2.95 ps=2.28
XM18 Q#5 a_2580_74##13 VPWR#16 VPB sky130_fd_pr__pfet_01v8 l=0.15 w=1.12 ad=0.336 as=0.3724 pd=2.84 ps=2.95
XM50 VPWR#15 a_2580_74##9 Q#5 VPB sky130_fd_pr__pfet_01v8 l=0.15 w=1.12 ad=0.336 as=0.336 pd=2.84 ps=2.84
XM38 VPWR#15 a_2580_74##8 Q#1 VPB sky130_fd_pr__pfet_01v8 l=0.15 w=1.12 ad=0.336 as=0.336 pd=2.84 ps=2.84
XM15 Q#1 a_2580_74# VPWR#1 VPB sky130_fd_pr__pfet_01v8 l=0.15 w=1.12 ad=0.336 as=0.3304 pd=2.84 ps=2.83
*
*
*       RESISTOR AND CAP/DIODE CARDS
*
Rg1	SCE#1	SCE#2	330.998413
Rg2	SCE#2	SCE#3	9.268713
Rg3	SCE#3	SCE#4	613.204407
Rg4	SCE#3	SCE#5	365.598572
Rg5	a_27_74#	a_27_74##2	221.858398
Rg6	D#1	D#2	756.491394
Rg7	D#2	D#3	309.532410
Rg8	SCE#6	SCE#7	412.833405
Rg9	a_27_74##3	a_27_74##4	296.912354
Rg10	SCD#1	SCD#2	64.182579
Rg11	SCD#2	SCD#3	445.989441
Rg12	SCD#2	SCD#4	434.217255
Rg13	CLK#1	CLK#2	500.238068
Rg14	CLK#2	CLK#3	320.356293
Rg15	a_803_74#	a_803_74##2	567.919922
Rg16	a_803_74##2	a_803_74##3	242.759598
Rg17	a_803_74##3	a_803_74##4	36.543846
Rg18	a_803_74##2	a_803_74##5	55.486282
Rg19	a_803_74##3	a_803_74##6	388.057404
Rg20	a_1201_55#	a_1201_55##2	242.973175
Rg21	a_1201_55##2	a_1201_55##3	387.360199
Rg22	a_1201_55##3	a_1201_55##4	240.449829
Rg23	a_1017_81#	a_1017_81##2	442.223602
Rg24	a_1017_81##2	a_1017_81##3	434.563446
Rg25	SET_B#1	SET_B#2	553.551208
Rg26	SET_B#2	SET_B#3	395.100281
Rg27	a_1017_81##4	a_1017_81##5	372.009277
Rg28	a_1017_81##5	a_1017_81##6	54.508873
Rg29	a_1017_81##6	a_1017_81##7	463.281677
Rg30	a_1017_81##5	a_1017_81##8	264.676239
Rg31	a_1017_81##5	a_1017_81##9	487.970764
Rg32	a_803_74##7	a_803_74##8	444.515137
Rg33	a_803_74##8	a_803_74##9	373.703888
Rg34	a_803_74##8	a_803_74##10	234.008942
Rg35	a_616_74#	a_616_74##2	1372.746826
Rg36	a_616_74##2	a_616_74##3	518.726318
Rg37	a_616_74##3	a_616_74##4	2171.220703
Rg38	a_616_74##4	a_616_74##5	1462.737183
Rg39	a_616_74##5	a_616_74##6	64.065247
Rg40	a_616_74##3	a_616_74##7	305.272156
Rg41	a_616_74##4	a_616_74##8	213.631027
Rg42	a_616_74##5	a_616_74##9	689.255066
Rg43	a_616_74##6	a_616_74##10	402.235901
Rg44	a_616_74##6	a_616_74##11	450.385345
Rg45	a_803_74##11	a_803_74##12	333.544495
Rg46	a_2191_180#	a_2191_180##2	734.932800
Rg47	a_2191_180##2	a_2191_180##3	216.119781
Rg48	SET_B#4	SET_B#5	567.385803
Rg49	SET_B#5	SET_B#6	363.225250
Rg50	a_1823_524#	a_1823_524##2	380.536285
Rg51	a_1823_524##2	a_1823_524##3	94.530968
Rg52	a_1823_524##3	a_1823_524##4	280.908173
Rg53	a_1823_524##4	a_1823_524##5	27.342104
Rg54	a_1823_524##2	a_1823_524##6	667.274719
Rg55	a_1823_524##3	a_1823_524##7	291.996490
Rg56	a_1823_524##4	a_1823_524##8	374.806763
Rg57	a_1823_524##5	a_1823_524##9	517.227539
Rg58	a_2580_74#	a_2580_74##2	518.509094
Rg59	a_2580_74##2	a_2580_74##3	203.551437
Rg60	a_2580_74##3	a_2580_74##4	76.542564
Rg61	a_2580_74##4	a_2580_74##5	45.827671
Rg62	a_2580_74##2	a_2580_74##6	369.280487
Rg63	a_2580_74##3	a_2580_74##7	379.241852
Rg64	a_2580_74##3	a_2580_74##8	462.367249
Rg65	a_2580_74##4	a_2580_74##9	414.808441
Rg66	a_2580_74##5	a_2580_74##10	401.921875
Rg67	a_2580_74##5	a_2580_74##11	36.535618
Rg68	a_2580_74##11	a_2580_74##12	402.851532
Rg69	a_2580_74##11	a_2580_74##13	432.879364
Rf1	D#4	D	0.701255
Rf2	D#2	D#6	160.934052
Rf3	D#4	D#6	8.267126
Rf4	a_27_74##4	a_27_74##6	291.453735
Rf5	a_27_74##6	a_27_74##7	19.525269
Rf6	a_27_74##6	a_27_74##8	67.204483
Rf7	a_27_74##8	a_27_74##9	34.326897
Rf8	a_27_74##8	a_27_74##2	181.964966
Rf9	SCE#7	SCE	241.756149
Rf10	SCE	SCE#2	86.021492
Rf11	SCD	SCD#1	2.759685
Rf12	SCD#1	SCD	14.258374
Rf13	CLK#4	CLK#2	161.821228
Rf14	CLK	CLK#6	1.588424
Rf15	CLK#4	CLK#6	3.882813
Rf16	a_616_74##6	a_616_74##14	210.681000
Rf17	a_616_74##14	a_616_74##15	93.932152
Rf18	a_616_74##13	a_616_74##14	15.000000
Rf19	a_288_464#	a_288_464##2	23.291517
Rf20	a_288_464##2	a_288_464##3	163.861893
Rf21	a_288_464##3	a_288_464##4	56.811401
Rf22	a_288_464##2	a_288_464##5	113.963249
Rf23	a_288_464##3	a_288_464##6	175.154999
Rf24	a_803_74##13	a_803_74##4	330.031097
Rf25	a_1201_55##5	a_1201_55##2	238.064011
Rf26	a_1201_55##7	a_1201_55##3	265.173981
Rf27	SET_B#2	SET_B#8	161.138672
Rf28	SET_B#9	SET_B#10	0.905865
Rf29	SET_B#8	SET_B#9	3.149382
Rf30	a_1017_81##6	a_1017_81##11	253.489639
Rf31	a_1017_81##11	a_1017_81##12	85.505188
Rf32	a_1017_81##12	a_1017_81##13	50.785542
Rf33	a_1017_81##12	a_1017_81##14	84.567307
Rf34	a_1620_373#	a_1620_373##2	127.488098
Rf35	a_1677_74#	a_1677_74##2	181.719498
Rf36	a_803_74##12	a_803_74##16	255.164948
Rf37	a_803_74##16	a_803_74##17	344.753906
Rf38	a_803_74##17	a_803_74##18	166.168274
Rf39	a_803_74##16	a_803_74##9	165.961761
Rf40	a_803_74##17	a_803_74##5	189.468689
Rf41	SET_B#11	SET_B	11.020545
Rf42	SET_B#5	SET_B#14	81.359161
Rf43	SET_B#11	SET_B#14	4.586240
Rf44	a_1823_524##5	a_1823_524##11	147.650772
Rf45	a_1823_524##11	a_1823_524##12	52.669868
Rf46	a_1823_524##12	a_1823_524##14	66.506042
Rf47	a_1823_524##14	a_1823_524##15	72.371323
Rf48	a_1823_524##11	a_1823_524##16	25.649860
Rf49	a_1823_524##12	a_1823_524##18	128.458618
Rf50	a_1823_524##18	a_1823_524##19	84.160286
Rf51	a_1823_524##13	a_1823_524##14	15.000000
Rf52	a_1823_524##17	a_1823_524##18	7.500000
Rf53	a_2191_180##2	a_2191_180##5	246.221542
Rf54	a_2191_180##5	a_2191_180##6	140.380829
Rf55	a_2191_180##5	a_2191_180##7	29.207432
Rf56	a_2580_74##14	a_2580_74##15	77.249771
Rf57	a_2580_74##15	a_2580_74##16	41.302010
Rf58	a_2580_74##15	a_2580_74##5	90.203362
Rf59	Q#1	Q#2	35.291424
Rf60	Q#2	Q	53.031364
Rf61	Q	Q#3	56.312622
Rf62	Q#3	Q#4	78.822159
Rf63	Q#2	Q#5	51.736492
Rf64	Q#3	Q#6	20.278393
Rf65	VPWR#1	VPWR#2	100.628624
Rf66	VPWR#2	VPWR#3	69.336914
Rf67	VPWR#3	VPWR#4	62.831711
Rf68	VPWR#4	VPWR#5	116.581177
Rf69	VPWR#5	VPWR#6	85.501900
Rf70	VPWR#6	VPWR#7	100.785156
Rf71	VPWR#7	VPWR#8	65.818954
Rf72	VPWR#8	VPWR#9	102.401550
Rf73	VPWR#9	VPWR#10	194.687851
Rf74	VPWR#10	VPWR#11	27.369404
Rf75	VPWR#11	VPWR#12	46.362534
Rf76	VPWR#12	VPWR#13	146.417175
Rf78	VPWR#2	VPWR#15	36.016815
Rf79	VPWR#3	VPWR#16	35.274624
Rf80	VPWR#4	VPWR#17	40.352859
Rf81	VPWR#5	VPWR#18	37.027283
Rf82	VPWR#7	VPWR#19	42.380951
Rf83	VPWR#8	VPWR#20	70.139786
Rf84	VPWR#9	VPWR#21	38.050537
Rf85	VPWR#10	VPWR#22	33.326477
Rf86	VPWR#12	VPWR#23	24.862514
Rf87	VPWR#13	VPWR#24	33.326477
Rf88	VGND#1	VGND#2	96.886703
Rf89	VGND#2	VGND#3	81.755501
Rf90	VGND#3	VGND#4	120.080757
Rf91	VGND#4	VGND#5	132.889130
Rf92	VGND#5	VGND#6	82.157272
Rf93	VGND#6	VGND#7	75.240959
Rf94	VGND#7	VGND#8	113.227211
Rf95	VGND#8	VGND#9	193.534744
Rf96	VGND#9	VGND#10	26.638899
Rf97	VGND#10	VGND#11	54.398087
Rf98	VGND#11	VGND#12	133.998596
Rf100	VGND#2	VGND#14	40.564270
Rf101	VGND#3	VGND#15	33.306259
Rf102	VGND#4	VGND#16	26.375343
Rf103	VGND#6	VGND#17	31.141060
Rf104	VGND#7	VGND#18	13.162715
Rf105	VGND#8	VGND#19	27.224552
Rf106	VGND#9	VGND#20	32.518913
Rf107	VGND#11	VGND#21	33.129639
Rf108	VGND#12	VGND#22	33.129639
Rf122	a_1017_81##2	a_1017_81##11	80.116402
Re2	SET_B	SET_B#10	16.991604
Re3	VPWR#2	VPWR#26	3.707182
Re4	VPWR#26	VPWR	0.829717
Re5	VPWR	VPWR#11	2.450039
Re6	VGND#2	VGND#24	3.707182
Re7	VGND#24	VGND	0.829717
Re8	VGND	VGND#10	2.450039
Re12	VPWR#6	VPWR#26	0.698413
Re15	VGND#5	VGND#24	0.698413
*
*       CAPACITOR CARDS
*
*
C1	VGND#8	a_803_74##13	1.33125e-17
C2	VPWR#11	a_1201_55##4	3.79581e-18
C3	a_1823_524##17	a_803_74##9	1.74724e-18
C4	a_1620_373#	a_1823_524##12	3.07616e-18
C5	a_803_74##4	a_616_74##10	1.0699e-19
C6	VGND#11	VGND#9	7.73092e-19
C7	VPWR#10	a_616_74##4	1.6711e-17
C8	VPWR#16	VPWR#15	2.00842e-18
C9	a_803_74##12	a_2191_180#	2.72835e-17
C10	VGND#6	a_1017_81##4	1.25383e-18
C11	VPWR#15	a_1823_524#	3.0551e-19
C12	VGND#10	VGND#22	1.82904e-17
C13	a_1677_74#	a_803_74##9	8.86605e-18
C14	VPWR#10	a_803_74##6	2.87062e-19
C15	a_2580_74##15	a_2580_74##12	9.85056e-20
C16	a_616_74##2	a_2191_180##2	8.62892e-19
C17	a_1201_55##5	SET_B#1	5.21709e-18
C18	VGND#4	SET_B#5	1.33129e-19
C19	a_2580_74##13	VPWR#16	2.14613e-17
C20	a_1823_524##9	a_1823_524##6	4.07576e-18
C21	VPWR#23	a_27_74##3	9.69135e-19
C22	a_288_464##2	a_803_74##4	5.94625e-17
C23	a_27_74##6	a_27_74##3	1.84516e-19
C24	a_1823_524##19	a_803_74##9	2.54402e-18
C25	VGND#10	a_27_74##9	2.00265e-17
C26	a_1823_524##3	a_1823_524#	1.34872e-18
C27	Q#3	Q#2	3.35754e-17
C28	a_1201_55##7	a_616_74##4	1.30786e-18
C29	a_2580_74##15	VPWR#3	1.70833e-19
C30	VPWR#9	a_803_74##6	4.40597e-19
C31	a_2580_74##6	VGND#1	2.88336e-17
C32	Q#5	a_1823_524#	1.46065e-18
C33	SET_B#10	a_803_74##17	6.29834e-19
C34	a_803_74##12	a_616_74##2	4.278e-17
C35	VGND#17	a_803_74##9	1.1402e-18
C36	VGND#11	a_616_74##15	2.1718e-18
C37	a_2580_74##14	a_2580_74##13	1.70139e-19
C38	a_803_74##18	VPWR#10	6.80521e-17
C39	VGND#19	SET_B#1	7.19374e-19
C40	VPWR#11	a_616_74##11	1.21506e-18
C41	a_1823_524##17	a_1017_81##6	5.28573e-19
C42	VGND#7	a_1017_81##8	3.60797e-17
C43	a_616_74##5	a_803_74##6	2.32279e-17
C44	VPWR#16	Q#5	7.60867e-17
C45	a_803_74##12	a_616_74##7	1.3192e-19
C46	a_803_74##16	a_616_74##2	1.62918e-17
C47	a_2580_74##5	VPWR#3	2.71822e-19
C48	SET_B#8	a_803_74##17	1.43648e-18
C49	SET_B#10	a_803_74##16	1.13028e-16
C50	a_1677_74##2	a_803_74##9	1.21349e-17
C51	VPWR#23	D#3	4.47202e-19
C52	CLK#2	a_616_74##10	5.45505e-18
C53	a_288_464##4	a_27_74##3	2.88867e-17
C54	VPWR#16	a_1823_524#	4.62155e-17
C55	a_803_74##9	a_616_74##2	9.52964e-18
C56	VPWR#11	CLK#1	4.81016e-18
C57	a_1201_55##5	a_1017_81#	4.34622e-17
C58	VPWR#24	SCD#4	5.06351e-19
C59	a_803_74##12	a_1017_81##9	2.10275e-19
C60	a_2580_74##6	Q#6	1.5442e-17
C61	a_803_74##5	a_803_74##2	1.66457e-17
C62	a_803_74##13	a_1017_81##13	1.86748e-17
C63	a_803_74##6	a_616_74##4	1.02202e-17
C64	VGND#5	a_803_74##8	1.18947e-19
C65	VPWR#24	SCE#3	7.99368e-19
C66	a_1823_524##6	a_2580_74##11	9.18061e-18
C67	VGND#3	Q#4	8.8287e-18
C68	a_288_464##3	VPWR#12	1.69026e-17
C69	a_288_464##2	a_1017_81##14	6.30148e-17
C70	a_616_74##6	a_288_464##2	8.50257e-17
C71	a_2580_74##15	a_1823_524##6	1.42251e-17
C72	a_803_74##4	a_616_74##5	4.14233e-17
C73	a_27_74##6	D#3	3.06924e-19
C74	Q#5	a_1823_524##7	3.42037e-20
C75	SET_B#10	a_1620_373#	4.1815e-18
C76	VPWR#10	a_616_74##11	4.0059e-18
C77	a_803_74##18	VPWR#9	1.00173e-17
C78	a_1823_524##17	VGND#16	9.90853e-18
C79	a_1017_81##6	a_616_74##2	8.44262e-19
C80	SET_B#4	a_1823_524##9	1.41739e-17
C81	Q#3	a_2580_74##5	2.97612e-17
C82	a_2103_508#	VPWR#6	5.81451e-18
C83	VGND#4	a_2191_180##2	7.7336e-18
C84	a_1823_524#	a_2580_74##14	1.75792e-17
C85	VGND#1	a_2580_74##7	1.36469e-18
C86	VPWR#9	a_616_74##4	6.4731e-17
C87	VPWR#5	a_1823_524##5	1.74503e-19
C88	a_1017_81##9	a_803_74##9	4.84239e-18
C89	a_803_74##4	a_616_74##4	1.57006e-18
C90	a_803_74##17	a_616_74##7	1.24218e-19
C91	a_2580_74##14	Q#5	1.23555e-18
C92	VPWR#23	SCE#1	2.08897e-19
C93	a_803_74##2	a_616_74##8	1.05286e-17
C94	VGND#19	a_1017_81#	2.93252e-18
C95	a_288_464##4	D#3	3.20576e-17
C96	VPWR#11	a_27_74##3	1.64381e-18
C97	SET_B#10	a_1823_524##15	1.32057e-18
C98	VPWR#24	a_27_74##3	5.3358e-19
C99	a_1823_524##12	SET_B#11	9.9285e-18
C100	a_2580_74##5	Q#2	1.38807e-17
C101	a_2580_74##8	a_2580_74#	4.81504e-17
C102	a_1823_524##13	VPWR#6	4.88959e-17
C103	VPWR#16	a_1823_524##7	2.43706e-18
C104	VGND#14	a_2580_74##6	5.8969e-19
C105	VPWR#4	a_1823_524##5	3.99856e-19
C106	a_1677_74##2	a_1017_81##6	4.7925e-17
C107	a_2580_74##14	a_1823_524##3	4.68922e-19
C108	a_1201_55##5	a_1201_55#	1.46009e-18
C109	D#4	a_27_74##6	1.46571e-17
C110	a_2191_180##5	a_1823_524##6	1.31465e-18
C111	VPWR#17	a_1823_524#	1.33053e-18
C112	a_1017_81##12	a_803_74#	2.739e-18
C113	SET_B#8	a_803_74##16	7.78645e-18
C114	VPWR#11	D#3	1.46773e-18
C115	a_803_74##16	a_616_74##7	3.41707e-18
C116	SET_B#10	VPWR#19	2.56194e-18
C117	a_616_74##4	VPWR#21	9.86791e-19
C118	a_803_74##13	a_288_464##5	9.02955e-17
C119	VGND#7	SET_B#1	3.05514e-17
C120	a_1017_81##6	VGND#18	1.26032e-18
C121	a_2580_74##5	VPWR#15	1.72302e-18
C122	a_2580_74##7	Q#6	1.4935e-17
C123	VPWR#11	a_616_74##4	1.96983e-17
C124	a_288_464##3	CLK#2	3.15935e-19
C125	a_1823_524##7	a_2580_74##14	2.22532e-17
C126	VPWR#11	SCE#1	7.51774e-19
C127	a_288_464##4	SCE#1	1.93882e-18
C128	a_27_74##6	SCE#1	1.91555e-17
C129	SET_B#10	a_1620_373##2	1.01588e-17
C130	a_288_464##2	a_288_464#	3.62541e-18
C131	a_616_74##5	a_616_74##4	6.28502e-20
C132	a_288_464##5	a_616_74##5	2.67335e-17
C133	a_2580_74##14	VPWR#16	6.56214e-17
C134	a_616_74##11	a_616_74##5	3.5074e-17
C135	a_2580_74##5	Q#5	5.38287e-17
C136	VPWR#24	D#3	4.20405e-18
C137	a_2191_180##6	a_1823_524#	1.10367e-18
C138	a_1823_524##15	VPWR#6	1.88371e-17
C139	VGND#1	a_2580_74##10	2.84905e-19
C140	a_1201_55#	VGND#19	1.68045e-17
C141	SET_B#8	a_1017_81#	6.4736e-19
C142	VPWR#11	SCE#5	1.8489e-18
C143	a_1823_524##2	a_2580_74##14	9.39875e-19
C144	a_2191_180##3	SET_B#4	2.07563e-17
C145	Q#2	VPWR#1	2.35333e-17
C146	SET_B#2	a_1017_81##7	8.615e-18
C147	SET_B#10	VPWR#20	3.99489e-18
C148	a_2580_74##5	VPWR#16	1.14488e-17
C149	a_803_74##4	a_803_74##2	1.32453e-17
C150	VPWR#17	a_1823_524##7	3.62007e-17
C151	Q#3	a_2580_74##11	2.18891e-18
C152	a_1017_81##13	a_1017_81#	4.16563e-19
C153	a_2580_74##9	a_2580_74##8	4.61753e-17
C154	a_616_74##11	a_616_74##4	6.73929e-18
C155	a_2580_74##7	VGND#14	1.67496e-17
C156	VPWR#5	SET_B#5	1.86531e-19
C157	a_1017_81##12	a_803_74##2	3.83082e-17
C158	a_1201_55##5	a_803_74#	1.63033e-19
C159	VGND#8	a_1017_81#	5.311e-19
C160	a_2580_74##15	Q#3	4.00348e-19
C161	a_616_74##6	a_616_74##5	6.86745e-18
C162	a_2580_74##5	a_2580_74##11	4.27897e-17
C163	VPWR#24	SCE#1	3.06472e-17
C164	a_2580_74##14	a_1823_524##8	6.00903e-19
C165	a_1017_81##12	a_616_74##9	1.33906e-18
C166	VGND#7	a_803_74##16	4.21599e-19
C167	VPWR#8	a_616_74##4	9.25485e-18
C168	a_803_74##16	a_1017_81##9	2.95516e-17
C169	a_2191_180##5	a_1823_524##9	1.67663e-17
C170	a_803_74##6	a_803_74##2	6.55291e-18
C171	VPWR#17	VPWR#16	1.73069e-18
C172	SET_B#10	SET_B#8	1.69087e-17
C173	a_1017_81##3	SET_B#2	3.30853e-18
C174	a_2191_180##6	a_1823_524##7	5.04963e-18
C175	a_27_74##6	SCE#5	2.83593e-17
C176	VGND#19	a_803_74#	2.80568e-18
C177	VGND#7	a_1017_81#	1.52938e-17
C178	D#1	SCE#7	1.48908e-17
C179	Q#4	a_2580_74##7	4.24687e-19
C180	a_288_464##2	a_803_74##18	8.88324e-17
C181	VGND#10	a_616_74##5	2.28308e-18
C182	VPWR#17	a_1823_524##3	2.5076e-18
C183	VPWR#17	a_1823_524##8	7.08701e-18
C184	a_1201_55##3	a_1017_81##7	1.053e-19
C185	a_2580_74##5	a_2580_74##3	5.42982e-18
C186	VPWR#12	SCD#4	5.25138e-18
C187	a_2580_74##15	a_1823_524##5	5.91216e-18
C188	a_1017_81##13	a_1201_55#	4.50823e-18
C189	a_288_464##2	VPWR#10	5.25419e-19
C190	a_1677_74##2	a_1017_81##2	1.46369e-19
C191	VPWR#24	SCE#5	2.78058e-17
C192	a_2580_74##13	a_2580_74##9	4.6369e-17
C193	VPWR#11	a_803_74##2	6.87495e-19
C194	VGND#14	a_2580_74##10	3.19973e-17
C195	VGND#20	a_803_74##13	6.19391e-17
C196	a_2580_74##14	a_1823_524##5	7.49161e-19
C197	a_616_74##15	a_288_464##5	5.80913e-19
C198	a_288_464##3	VPWR#22	7.22905e-18
C199	VGND#6	a_803_74##9	1.05359e-18
C200	a_2580_74##5	a_2580_74##2	5.93335e-19
C201	a_803_74##17	a_1017_81##7	2.42847e-19
C202	a_803_74##13	a_1017_81#	5.81796e-19
C203	a_616_74#	a_2191_180##3	3.53967e-17
C204	VGND#3	a_2580_74##16	2.08036e-17
C205	a_2191_180##5	a_1823_524##5	1.04707e-16
C206	Q#2	Q#1	5.99305e-18
C207	VPWR#2	a_2580_74##5	7.03142e-18
C208	VPWR#17	a_2580_74##14	3.95314e-17
C209	a_803_74##13	a_616_74##5	4.99395e-18
C210	Q#5	VPWR#3	7.13378e-18
C211	a_2191_180##6	a_1823_524##8	4.06624e-17
C212	VPWR#11	a_803_74##17	3.3644e-17
C213	a_1201_55##3	a_1017_81##3	1.47485e-17
C214	a_1017_81##14	a_803_74##18	1.27292e-17
C215	SCE#5	a_27_74##7	1.77301e-18
C216	a_1823_524##5	VPWR#17	4.09806e-18
C217	a_2580_74##15	Q#2	6.08764e-19
C218	VPWR#18	a_1823_524##7	9.95025e-20
C219	VGND#8	a_1201_55#	5.51851e-18
C220	VGND#2	a_2580_74##5	7.17484e-18
C221	VGND#4	a_2191_180##7	2.37179e-17
C222	a_27_74##2	SCE#6	9.37937e-19
C223	VGND#19	a_616_74##9	6.13139e-19
C224	a_2580_74##11	a_2580_74##3	3.83764e-18
C225	a_803_74##16	a_1017_81##7	2.58961e-17
C226	VPWR#17	SET_B#6	1.79555e-19
C227	a_1823_524##12	VPWR#5	1.10905e-18
C228	Q#2	a_2580_74#	1.27965e-17
C229	a_27_74##4	a_288_464##3	7.6245e-17
C230	VPWR#11	SCE#3	1.89428e-19
C231	a_2191_180##6	a_1823_524##5	4.60333e-17
C232	Q#2	a_2580_74##11	1.40919e-18
C233	a_2191_180##5	SET_B#4	2.05714e-19
C234	VPWR#8	a_616_74##3	3.70871e-17
C235	Q#4	a_2580_74##10	2.78985e-17
C236	a_1201_55##5	a_1017_81##2	5.613e-17
C237	VPWR#4	VPWR#16	2.22668e-19
C238	a_1823_524##16	a_1823_524##8	1.06045e-18
C239	a_27_74##2	D#1	3.73607e-17
C240	a_1017_81##13	a_803_74#	3.51874e-17
C241	a_288_464##2	VPWR#22	3.95856e-17
C242	a_616_74##6	SCD#2	5.14166e-19
C243	VPWR#23	VPWR#10	1.56727e-18
C244	VGND#8	a_1017_81##12	2.02347e-18
C245	a_616_74##15	a_803_74##13	2.25397e-18
C246	a_1823_524#	a_2580_74##13	2.9979e-17
C247	VGND#11	a_288_464##6	1.43257e-17
C248	VGND#7	a_1201_55#	3.9516e-19
C249	VGND#14	a_2580_74##12	3.67223e-19
C250	a_2191_180##6	a_2580_74##14	1.56186e-17
C251	a_803_74##13	a_1201_55#	3.52947e-19
C252	a_2191_180##6	SET_B#6	1.14755e-18
C253	a_803_74##6	a_1201_55##3	8.32726e-19
C254	SCE#4	a_27_74##2	1.6276e-17
C255	VPWR#12	a_27_74##3	6.19516e-18
C256	VGND#7	a_1017_81##6	6.6629e-17
C257	a_288_464##3	a_616_74##13	4.39412e-17
C258	VPWR#18	a_1823_524##8	4.34396e-19
C259	VPWR#11	a_1017_81##12	3.91044e-18
C260	VGND#15	a_2580_74##10	1.34281e-18
C261	a_803_74##17	SET_B#3	7.98645e-18
C262	a_616_74##10	a_616_74##5	8.91848e-18
C263	a_1823_524##12	a_1823_524##5	4.01892e-18
C264	a_803_74##7	a_616_74#	3.01277e-17
C265	SET_B#8	a_616_74##4	4.77165e-20
C266	VPWR#17	a_2191_180#	6.23956e-20
C267	a_2191_180##5	SET_B#5	6.11036e-19
C268	Q#2	VPWR#15	2.08251e-17
C269	VGND#6	a_1017_81##6	9.54707e-20
C270	a_2191_180##6	SET_B#5	3.12272e-19
C271	a_1823_524##17	a_1677_74#	6.59252e-17
C272	VGND#8	VGND#7	2.80883e-20
C273	a_1017_81##14	a_616_74##4	1.05246e-18
C274	a_1823_524##16	SET_B#6	2.90833e-17
C275	Q#3	a_2580_74##3	1.05156e-17
C276	VGND#10	a_803_74##2	9.5296e-20
C277	VPWR#5	a_803_74##12	1.61379e-19
C278	a_803_74##5	a_616_74##8	1.86797e-18
C279	a_2580_74##15	a_2580_74#	1.41649e-19
C280	a_2580_74##12	Q#4	2.52461e-17
C281	a_1823_524##11	a_1823_524##5	1.03575e-18
C282	VPWR#4	a_1823_524##2	4.66604e-20
C283	a_616_74##9	a_1017_81##13	2.068e-17
C284	a_803_74##16	a_1823_524##13	2.93648e-19
C285	SCE#7	a_288_464##3	9.73262e-18
C286	a_803_74##16	SET_B#3	1.81208e-17
C287	VGND#8	a_803_74#	5.31495e-18
C288	a_616_74##15	VGND#20	5.79346e-17
C289	a_2191_180##6	VPWR#17	4.77701e-17
C290	a_803_74##5	a_803_74##6	3.91824e-19
C291	Q#2	a_2580_74##8	2.12627e-17
C292	a_616_74##13	a_288_464##2	2.01474e-17
C293	a_1823_524##11	VPWR#5	1.5852e-18
C294	a_2191_180##5	a_2191_180##3	7.88941e-20
C295	VGND#10	SCD#2	3.00666e-18
C296	a_803_74##13	a_803_74#	1.96338e-18
C297	a_1823_524##7	a_1823_524#	3.79322e-17
C298	a_2580_74##16	a_2580_74##10	4.15105e-20
C299	SET_B#6	VPWR#18	1.09888e-17
C300	a_2580_74##14	VPWR#4	5.28636e-18
C301	a_1201_55##2	VGND#18	3.7645e-21
C302	VPWR#9	VPWR#8	3.09436e-19
C303	a_616_74##9	a_288_464##5	2.35034e-17
C304	VPWR#7	a_616_74##3	3.98746e-17
C305	VGND#15	a_2580_74##12	4.89682e-17
C306	a_1823_524##16	a_2191_180#	1.27549e-18
C307	a_288_464##3	VPWR#23	4.86656e-17
C308	VGND#3	a_2580_74##11	8.13259e-20
C309	VGND#10	a_1017_81##12	8.13276e-18
C310	SCD#2	CLK#2	1.33025e-17
C311	a_1823_524##19	a_1823_524##17	3.22697e-18
C312	VPWR#11	a_1017_81##14	8.21574e-18
C313	VPWR#22	a_803_74##18	4.26235e-17
C314	a_803_74##17	a_1017_81##3	2.43928e-17
C315	a_1823_524##17	a_1823_524##12	2.25454e-18
C316	VGND#7	SET_B#2	6.18034e-19
C317	a_803_74##10	a_803_74##7	3.30203e-17
C318	a_1823_524##12	SET_B#5	2.6524e-17
C319	VGND#9	a_616_74##9	2.61376e-18
C320	VPWR#7	a_803_74##9	5.92583e-19
C321	a_2191_180##2	a_2191_180##5	2.54252e-18
C322	Q#4	a_1823_524##6	3.70086e-19
C323	VGND#2	a_2580_74##6	7.44931e-19
C324	a_1823_524##5	a_1823_524##2	5.37928e-18
C325	VGND#21	VGND#20	1.36207e-18
C326	Q#5	Q#2	3.21515e-19
C327	VPWR#6	a_803_74##12	4.57517e-20
C328	VPWR#18	a_2191_180#	2.02884e-17
C329	a_1201_55##2	VGND#19	3.6305e-17
C330	Q#3	a_2580_74##2	1.48047e-17
C331	a_288_464##4	VPWR#12	9.10901e-18
C332	a_803_74##13	a_616_74##9	3.08738e-17
C333	a_2580_74##14	VPWR#3	5.22349e-18
C334	SET_B#10	a_803_74##9	1.54053e-18
C335	VGND#16	VGND#3	2.47612e-19
C336	VPWR#18	a_2191_180##2	2.92603e-19
C337	D#2	a_288_464##3	2.3523e-18
C338	a_803_74##16	a_1823_524##12	1.13153e-19
C339	SET_B#11	a_1823_524##5	2.51153e-17
C340	a_1823_524##11	SET_B#5	5.31445e-17
C341	a_2580_74##15	a_2580_74##8	9.66214e-20
C342	a_803_74##16	a_1620_373#	8.00079e-17
C343	a_1823_524##8	a_1823_524##7	2.54167e-17
C344	a_803_74##16	a_1017_81##3	1.36649e-18
C345	a_1823_524##13	SET_B#6	2.10733e-19
C346	a_616_74##6	a_616_74##11	1.18512e-17
C347	VPWR#3	a_2580_74##13	4.77828e-18
C348	a_2580_74##16	a_2580_74##12	1.29192e-18
C349	a_27_74##8	a_288_464##6	3.17069e-19
C350	SCD#2	CLK#1	8.43286e-18
C351	VGND#2	a_2580_74##7	5.33822e-18
C352	VGND#5	a_803_74##12	2.447e-19
C353	VPWR#11	a_803_74##18	3.47846e-17
C354	a_1823_524##16	a_803_74##11	2.81981e-19
C355	a_1823_524##11	VPWR#4	1.19713e-18
C356	a_288_464##5	a_616_74##10	1.69145e-18
C357	SET_B#4	a_2227_74#	1.26474e-17
C358	SET_B#10	a_1017_81##6	4.69262e-17
C359	Q#2	a_2580_74##9	5.37648e-20
C360	a_2191_180##5	a_616_74#	1.2908e-19
C361	VGND#8	a_616_74##9	1.4446e-18
C362	CLK#1	a_616_74##6	3.88626e-18
C363	Q#2	a_2580_74##3	7.19101e-18
C364	a_2191_180#	a_2103_508#	1.4412e-17
C365	a_27_74##6	a_27_74##4	1.08053e-18
C366	a_1017_81##13	a_1201_55##2	2.13375e-17
C367	a_2191_180##3	a_2227_74#	1.26474e-17
C368	VGND#15	a_1823_524##6	1.8382e-17
C369	VPWR#3	a_1823_524##2	4.0622e-20
C370	a_1823_524##19	a_1677_74#	7.68747e-17
C371	VGND#20	a_616_74##9	1.69868e-19
C372	VGND#2	a_2580_74##10	5.18435e-18
C373	SCE	SCD#2	3.13782e-19
C374	VPWR#11	VPWR#22	1.83426e-17
C375	a_1823_524##16	a_2191_180##6	2.7991e-17
C376	VPWR#18	VPWR#17	6.44873e-19
C377	SCE	SCE#3	4.30113e-17
C378	SET_B#10	SET_B#2	1.30612e-17
C379	VGND#9	a_616_74##5	5.24875e-19
C380	a_616_74##15	a_616_74##5	2.13099e-19
C381	VPWR#18	a_803_74##11	7.52307e-19
C382	VGND#21	a_616_74##15	3.16537e-17
C383	SET_B#5	a_1823_524##5	9.45645e-17
C384	VGND#8	a_1017_81##2	6.77409e-19
C385	VPWR#8	a_1017_81##6	9.20883e-20
C386	a_803_74##17	a_1201_55##4	2.97931e-17
C387	a_616_74##10	a_803_74##13	1.58434e-17
C388	a_1823_524##13	a_2191_180#	1.56777e-18
C389	VPWR#11	a_616_74##13	5.86645e-18
C390	VGND#2	a_2580_74##12	9.66257e-19
C391	VPWR#4	a_1823_524#	8.972e-19
C392	a_1017_81##4	a_803_74##10	3.54326e-18
C393	a_1823_524##12	a_2191_180##2	4.09278e-17
C394	a_1017_81##2	SET_B#10	1.24511e-17
C395	SET_B#6	a_1823_524##8	3.32898e-18
C396	VGND#7	a_1017_81##2	2.53074e-18
C397	a_1823_524##5	a_2191_180##2	6.27263e-19
C398	a_2103_508#	a_803_74##12	8.08813e-19
C399	VPWR#7	a_1017_81##6	2.99945e-19
C400	a_2580_74##16	a_1823_524##6	5.57029e-17
C401	a_288_464##5	a_803_74##2	1.05607e-19
C402	VGND#9	a_616_74##10	3.80187e-18
C403	a_803_74##11	a_2103_508#	1.6657e-17
C404	a_2580_74##15	a_2580_74##11	6.93448e-19
C405	a_288_464##5	CLK#3	6.9987e-20
C406	VPWR#11	VPWR#23	2.20968e-17
C407	a_27_74##8	SCE#7	2.37583e-18
C408	a_803_74##18	a_616_74##5	1.62202e-17
C409	SET_B#11	SET_B#5	1.52286e-17
C410	a_288_464##3	VPWR#11	3.44527e-17
C411	D#4	a_27_74##4	9.64102e-18
C412	a_2191_180##2	a_1823_524##11	4.44728e-19
C413	a_1620_373#	a_2191_180#	2.17111e-19
C414	a_2191_180##5	a_2580_74##15	4.51759e-17
C415	a_2191_180##2	SET_B#5	4.72201e-17
C416	a_1823_524##13	a_803_74##12	3.74776e-17
C417	VGND#7	VGND#6	1.41063e-18
C418	VPWR#3	a_1823_524#	1.88893e-18
C419	VGND#16	a_2580_74##12	2.65001e-19
C420	VGND#20	a_616_74##10	5.07316e-17
C421	VPWR#9	a_803_74##2	8.93625e-20
C422	VGND#15	a_1823_524##9	5.47033e-19
C423	a_2580_74##15	Q#5	6.87001e-18
C424	a_2191_180##5	a_803_74##7	5.50214e-20
C425	VGND#10	a_616_74##13	2.68793e-18
C426	Q#2	a_2580_74##13	2.94785e-19
C427	a_288_464##2	VPWR#11	1.97285e-17
C428	Q#2	a_2580_74##2	2.73256e-18
C429	a_1823_524##13	a_803_74##11	4.54346e-17
C430	a_1620_373#	a_803_74##12	3.59578e-18
C431	VGND#2	VGND#1	7.0313e-17
C432	a_2191_180##3	a_2149_74#	9.87534e-18
C433	VPWR#5	a_1823_524##7	5.03618e-20
C434	VPWR#23	VPWR#22	5.88882e-18
C435	a_2191_180##7	a_1823_524##6	8.93381e-19
C436	a_27_74##4	SCD#4	3.72196e-18
C437	a_803_74##13	CLK#3	5.18202e-19
C438	a_2191_180##6	VPWR#4	2.59506e-17
C439	VPWR#11	a_1017_81##2	2.83341e-18
C440	CLK	a_616_74##5	1.04153e-18
C441	VPWR#8	VPWR#7	2.69386e-18
C442	a_616_74#	a_2149_74#	9.87534e-18
C443	VPWR#11	a_288_464##4	1.64415e-17
C444	a_803_74##12	a_2191_180##2	1.23915e-17
C445	a_803_74##18	a_616_74##4	1.91935e-17
C446	a_27_74##4	a_27_74##3	8.0849e-18
C447	a_616_74##15	a_616_74##10	1.51216e-18
C448	a_2191_180#	SET_B#6	2.75885e-17
C449	SET_B#10	a_803_74##5	1.29474e-18
C450	a_803_74##17	a_616_74##8	2.79985e-17
C451	a_288_464##5	SCD#2	5.90657e-20
C452	VGND#10	a_1017_81##2	3.5537e-18
C453	a_2580_74##16	a_1823_524##9	1.09237e-18
C454	a_1620_373#	a_803_74##11	6.06747e-19
C455	VPWR#11	a_1201_55##3	3.98666e-18
C456	VPWR#8	SET_B#2	7.34035e-19
C457	a_1017_81##8	a_1017_81##4	3.38649e-17
C458	VPWR#18	a_1823_524##16	2.69723e-17
C459	a_27_74##4	D#3	2.05949e-17
C460	VPWR#4	a_1823_524##7	6.01013e-18
C461	a_803_74##12	a_1823_524##12	5.76295e-17
C462	a_1823_524##16	VPWR#5	2.07296e-17
C463	a_803_74##4	a_1017_81##13	4.97244e-17
C464	a_803_74##8	a_616_74##3	1.93966e-19
C465	VGND#22	a_27_74##8	3.18658e-18
C466	a_27_74##8	D#2	2.5837e-19
C467	a_1017_81##14	a_803_74##2	2.27908e-18
C468	SCE#7	D#4	3.68827e-18
C469	CLK#3	VGND#20	1.90001e-17
C470	VGND#10	a_1201_55##3	2.85103e-18
C471	VGND#16	a_1823_524##6	1.02897e-18
C472	a_27_74##4	SCE#1	2.02673e-19
C473	a_1620_373#	a_803_74##9	2.69779e-18
C474	a_1823_524##13	a_616_74##2	3.58344e-17
C475	a_803_74##16	VPWR#19	7.30467e-19
C476	VGND#17	a_1823_524##19	5.03894e-17
C477	a_1677_74##2	a_1677_74#	1.10136e-18
C478	VGND#15	SET_B#4	1.46576e-19
C479	a_2191_180##2	SET_B#11	1.34921e-17
C480	a_288_464##6	a_616_74##15	9.93797e-18
C481	a_27_74##6	D#2	4.6974e-20
C482	a_288_464##5	a_803_74##4	8.28222e-17
C483	VPWR#11	VPWR#24	1.62172e-17
C484	VGND#9	CLK#3	2.46237e-18
C485	VGND#21	a_616_74##10	3.95761e-19
C486	a_1823_524##15	a_803_74##11	1.96362e-19
C487	a_2580_74##15	a_2580_74##13	1.61728e-18
C488	a_27_74##4	SCE#5	1.20121e-19
C489	VGND#10	a_1201_55##2	8.28481e-18
C490	a_1823_524##15	a_803_74##9	6.68057e-19
C491	VGND#10	a_288_464##2	7.99573e-19
C492	VGND#2	Q#4	2.82657e-17
C493	a_2191_180##7	a_1823_524##9	3.14556e-17
C494	a_803_74##13	a_803_74##4	3.55116e-18
C495	a_2580_74##3	a_2580_74##2	8.71174e-18
C496	VPWR#11	a_803_74##5	1.75915e-18
C497	a_2580_74##15	VPWR#16	7.67707e-18
C498	a_27_74##4	SCD#2	3.39088e-17
C499	VGND#1	Q#3	7.04323e-17
C500	a_616_74##15	CLK#3	5.59443e-17
C501	a_1620_373#	a_616_74##2	3.67256e-17
C502	VPWR#22	a_616_74##5	4.64975e-19
C503	a_803_74##11	a_2191_180#	1.49277e-17
C504	a_27_74##4	SCE#3	9.22267e-20
C505	VGND#10	a_803_74##5	2.5006e-18
C506	VPWR#5	a_1823_524##8	3.43366e-19
C507	VGND#2	VGND#15	2.0911e-17
C508	VGND#4	a_1823_524##17	8.48043e-20
C509	VPWR#11	a_803_74##4	2.92868e-18
C510	a_1017_81##6	a_803_74##9	9.89123e-18
C511	VPWR#9	a_1017_81##2	3.13317e-19
C512	VGND#20	SCD#3	4.36231e-19
C513	a_1823_524##13	a_616_74##7	7.78991e-19
C514	a_803_74##17	a_803_74##6	1.28128e-18
C515	VGND#10	a_803_74##4	3.87676e-18
C516	D#4	D#2	4.98055e-18
C517	a_1823_524##15	a_616_74##2	4.59876e-19
C518	SET_B#1	a_1017_81##8	9.39035e-18
C519	VGND#11	SCD#3	3.7711e-18
C520	a_288_464##6	VGND#21	1.52534e-17
C521	a_1823_524##9	VGND#16	1.67276e-17
C522	a_616_74##6	a_288_464##5	1.87072e-17
C523	VPWR#11	a_616_74##6	4.89731e-18
C524	VGND#21	CLK#3	2.54108e-18
C525	a_1823_524##12	a_803_74##9	1.16822e-20
C526	a_288_464##2	a_1017_81##12	1.77854e-17
C527	SCD	a_616_74##5	1.56777e-19
C528	VGND#6	a_1677_74#	5.79829e-19
C529	VGND#14	VGND#1	1.69044e-18
C530	VPWR#4	a_1823_524##8	5.77066e-18
C531	VGND#8	a_1201_55##2	2.27383e-18
C532	a_27_74##6	a_27_74##2	6.77259e-19
C533	a_616_74##15	a_616_74##13	2.40073e-18
C534	VPWR#22	a_616_74##4	4.20805e-19
C535	a_803_74##16	a_1620_373##2	7.62673e-17
C536	a_803_74##16	a_2191_180##2	3.57333e-20
C537	a_803_74##13	a_616_74##6	2.54813e-17
C538	a_1017_81##6	SET_B#2	4.07225e-17
C539	VGND#10	a_616_74##6	6.22037e-18
C540	a_803_74##13	SCD#2	3.95258e-19
C541	a_1620_373#	a_616_74##7	4.8678e-17
C542	a_2580_74##15	a_2580_74##3	6.70201e-20
C543	a_2191_180##7	SET_B#4	1.64686e-18
C544	VPWR#11	CLK#2	1.85667e-18
C545	a_616_74##15	SCD#3	2.31584e-18
C546	VPWR#19	a_1017_81##6	1.80069e-20
C547	a_2103_508#	VPWR#18	2.96622e-17
C548	a_1823_524##13	a_1823_524##16	1.60925e-18
C549	SCD	SCD#2	4.32047e-17
C550	a_616_74##2	a_803_74##11	2.7373e-17
C551	a_2580_74##15	a_1823_524#	7.56096e-20
C552	VGND#20	a_616_74##6	5.34598e-18
C553	a_1017_81##2	a_1017_81##6	4.48913e-18
C554	VGND#10	CLK#2	4.08734e-18
C555	a_616_74##5	a_803_74##2	9.03156e-19
C556	a_1823_524##13	a_1017_81##9	6.68634e-20
C557	a_288_464##3	a_616_74##5	1.56349e-19
C558	SCD#2	CLK#3	3.28246e-18
C559	a_1201_55##4	a_1140_495#	2.43314e-18
C560	a_1620_373##2	a_1017_81##6	4.31532e-19
C561	a_803_74##17	VPWR#20	1.46566e-17
C562	Q#3	Q#6	4.68449e-19
C563	a_1823_524##15	a_616_74##7	2.56566e-17
C564	a_1823_524##17	a_803_74##8	7.86996e-20
C565	a_1017_81##2	SET_B#2	4.43384e-17
C566	a_616_74##8	a_1140_495#	8.13709e-18
C567	VGND#21	SCD#3	4.08202e-17
C568	a_2580_74##2	VGND#1	1.79574e-18
C569	SET_B#1	a_1445_74#	9.87534e-18
C570	a_1677_74##2	VGND#17	8.73741e-17
C571	VPWR#5	SET_B#6	5.58056e-18
C572	VGND#16	SET_B#4	3.55274e-17
C573	VPWR#18	VPWR#4	3.38558e-19
C574	D#4	a_27_74##2	7.84396e-19
C575	VPWR#11	a_27_74##4	1.2407e-17
C576	SCE#7	SCD#2	3.63066e-17
C577	a_803_74##17	a_616_74##11	1.07666e-19
C578	a_1017_81#	a_1445_74#	9.87534e-18
C579	a_1620_373#	a_1017_81##9	8.74946e-19
C580	a_1201_55##3	SET_B#2	2.15392e-19
C581	a_1201_55##2	a_1017_81##6	1.70234e-19
C582	a_1823_524##2	a_2580_74##11	7.99188e-18
C583	a_1017_81#	SET_B#1	4.61713e-17
C584	a_288_464##6	CLK#3	1.09239e-18
C585	a_1823_524##13	VPWR#18	2.4569e-18
C586	VPWR#19	a_616_74##7	2.94176e-18
C587	VGND#10	a_27_74##4	2.93038e-18
C588	SCE#7	SCE#3	9.29453e-19
C589	VGND#14	a_2580_74##11	8.34386e-19
C590	a_803_74##17	VPWR#9	7.28583e-17
C591	a_616_74##15	SCE#6	2.04538e-19
C592	a_803_74##17	a_1140_495#	4.95398e-18
C593	VPWR#11	SCE#7	5.27333e-18
C594	a_2191_180##7	a_2191_180##3	4.57929e-19
C595	a_1017_81##2	a_1201_55##3	8.34807e-17
C596	VGND#11	SCE#6	5.69096e-18
C597	a_616_74##7	a_616_74##2	4.39534e-17
C598	CLK#2	VGND#20	3.58474e-18
C599	VGND#3	a_2580_74##15	2.43307e-19
C600	a_803_74##16	VPWR#20	6.43328e-17
C601	a_1677_74#	a_616_74##3	9.4311e-21
C602	VPWR#4	SET_B#6	2.41969e-19
C603	VGND#6	a_1823_524##19	1.74771e-17
C604	a_1823_524##15	a_1017_81##9	5.97189e-19
C605	a_2103_508#	VPWR#5	1.5837e-17
C606	VGND#4	a_2191_180##5	2.6997e-19
C607	Q	a_2580_74##3	1.28049e-19
C608	VGND#10	SCE#7	8.1464e-18
C609	Q	a_2580_74##2	1.13952e-17
C610	a_2580_74##3	Q#6	2.02349e-19
C611	a_1017_81##2	a_1201_55##2	7.61003e-17
C612	a_616_74##15	CLK#2	3.1095e-17
C613	a_1620_373##2	a_616_74##7	3.67576e-19
C614	VPWR#11	D#2	2.16883e-18
C615	VGND#22	VGND#21	9.2858e-19
C616	VGND#5	a_616_74#	6.20098e-18
C617	VGND#21	VPWR#23	5.16584e-20
C618	VPWR#11	a_27_74##6	2.57219e-17
C619	VGND#21	SCE#6	3.5432e-18
C620	a_1620_373#	a_1017_81##7	1.18622e-19
C621	a_1017_81##9	a_616_74##2	4.69896e-19
C622	a_1201_55##7	a_803_74##17	6.22851e-17
C623	VGND#10	D#2	2.20422e-18
C624	a_1201_55##2	a_1201_55##3	2.70116e-18
C625	a_803_74##5	a_1017_81##2	1.0705e-18
C626	VGND#7	VGND#17	2.54936e-18
C627	VGND#2	VGND#3	4.14006e-17
C628	a_1823_524##17	a_1823_524##9	4.07898e-19
C629	SCD#4	a_414_464#	1.26272e-17
C630	a_2580_74##15	VPWR#17	5.83575e-18
C631	VPWR#19	a_1017_81##9	4.48031e-17
C632	VGND#16	a_2191_180##3	3.62174e-18
C633	a_1823_524##13	a_2103_508#	4.00337e-17
C634	a_1201_55##7	SET_B#2	2.21914e-18
C635	Q#3	VGND#14	6.17828e-17
C636	a_288_464##6	SCD#3	1.33063e-17
C637	a_27_74##3	a_414_464#	5.89735e-18
C638	VGND#5	a_803_74##7	4.42881e-18
C639	VPWR#20	a_616_74##7	9.09983e-20
C640	Q#2	a_1823_524##2	8.19542e-20
C641	SCE	a_288_464##3	2.05029e-18
C642	a_803_74##5	a_1201_55##3	3.01729e-17
C643	VGND#10	a_27_74##2	5.95525e-18
C644	a_803_74##2	a_616_74##4	8.64486e-19
C645	a_288_464##2	a_616_74##5	4.28551e-17
C646	VPWR#5	a_2191_180#	8.14292e-18
C647	a_1017_81##9	a_616_74##7	4.72178e-18
C648	a_1201_55#	a_1017_81#	3.89471e-18
C649	a_2191_180##7	a_616_74#	2.81126e-19
C650	a_1201_55#	a_1153_81#	8.24968e-18
C651	a_1677_74#	a_803_74##8	1.4316e-17
C652	a_1620_373##2	a_1017_81##9	3.06689e-17
C653	VGND#5	a_803_74##10	4.45364e-18
C654	a_803_74#	a_1153_81#	8.58214e-18
C655	a_803_74##17	VPWR#8	4.30756e-17
C656	VPWR#9	a_1201_55##2	2.65713e-19
C657	VGND#10	a_27_74##8	6.4441e-19
C658	a_803_74##8	a_616_74##2	8.15544e-18
C659	VPWR#24	VPWR#23	8.97128e-19
C660	a_803_74##12	a_803_74##8	3.85943e-19
C661	a_2580_74##2	Q#6	4.51395e-20
C662	a_1201_55##7	a_803_74##16	6.37647e-17
C663	D#3	a_204_464#	1.52812e-17
C664	a_803_74##16	a_803_74##9	2.69574e-17
C665	D#2	SCD#2	2.84325e-18
C666	VGND#21	D#1	5.46502e-19
C667	a_1017_81##2	a_1201_55##7	2.08082e-17
C668	VPWR#19	a_1017_81##7	1.53069e-18
C669	a_27_74##8	SCE	4.39154e-17
C670	VPWR#4	a_2191_180#	5.43857e-20
C671	a_27_74##6	SCE	7.37758e-17
C672	SCE#1	a_204_464#	1.52812e-17
C673	a_1823_524##13	VPWR#5	6.04266e-19
C674	VPWR#20	a_1017_81##9	1.22008e-18
C675	SCE#3	D#2	4.41236e-17
C676	VGND#3	a_1823_524##3	7.92994e-19
C677	a_1823_524##17	SET_B#4	1.93333e-18
C678	a_803_74##5	a_803_74##4	4.20717e-19
C679	a_288_464##6	SCE#6	4.09946e-17
C680	VGND#8	a_803_74##4	3.95232e-19
C681	Q#4	a_2580_74##11	8.03321e-18
C682	VGND#16	a_616_74#	1.3742e-18
C683	a_1823_524##5	a_1823_524##6	5.23662e-18
C684	SCE	D#4	3.25417e-17
C685	a_803_74##17	VPWR#21	8.9107e-17
C686	VPWR#11	D#4	1.62786e-18
C687	VPWR#2	a_2580_74##11	2.74835e-20
C688	VPWR#7	a_803_74##11	6.56507e-20
C689	VGND#22	SCD#3	2.16132e-19
C690	a_1620_373##2	a_1017_81##7	3.5145e-17
C691	Q#4	VGND#14	5.40926e-17
C692	a_1017_81##7	a_1017_81##9	4.20706e-17
C693	a_2191_180##6	a_2580_74##15	5.26451e-18
C694	VGND#7	a_1677_74##2	5.58637e-17
C695	VGND#14	a_2580_74##3	2.69694e-19
C696	Q#4	Q#3	2.5966e-18
C697	a_2191_180##7	a_803_74##7	2.9362e-19
C698	VPWR	a_1823_524##3	3.31795e-18
C699	a_1620_373#	VPWR#7	1.00399e-18
C700	VPWR	a_1823_524##2	1.85741e-19
C701	a_288_464##2	a_616_74##4	1.00633e-18
C702	VPWR	a_616_74##4	4.01218e-18
C703	a_1201_55##7	a_1201_55##3	7.22497e-20
C704	VGND#22	a_288_464##6	1.14008e-17
C705	VGND#4	VGND#3	1.25298e-19
C706	VPWR#19	SET_B#3	4.04276e-19
C707	a_803_74#	a_1201_55#	3.33686e-17
C708	a_616_74##15	SCD#2	5.02109e-18
C709	a_1823_524##13	a_1620_373#	5.29467e-17
C710	VPWR#23	a_616_74##4	5.09991e-20
C711	VGND#21	a_27_74#	2.2331e-19
C712	a_27_74##8	SCE#3	2.66375e-17
C713	SET_B#10	VGND#7	1.18953e-17
C714	VPWR#5	a_803_74##11	5.93265e-19
C715	a_1017_81##7	VPWR#20	1.25774e-17
C716	SET_B#4	a_1823_524##5	7.688e-19
C717	VPWR#5	VPWR#4	2.52742e-19
C718	VPWR#21	a_1201_55##3	3.7667e-19
C719	a_288_464##6	D#1	3.65846e-17
C720	a_803_74##16	VPWR#8	6.8667e-19
C721	VPWR#2	a_2580_74##3	3.74368e-20
C722	a_1017_81##6	a_803_74##16	2.90355e-17
C723	CLK#2	a_616_74##6	3.26829e-17
C724	a_1823_524##17	a_2191_180##3	3.26641e-18
C725	SCE#6	SCD#2	3.90354e-18
C726	a_1620_373##2	SET_B#3	1.11934e-18
C727	SET_B#10	VGND#6	1.79272e-18
C728	VPWR#24	a_288_464##4	9.32402e-18
C729	VGND#16	a_803_74##7	8.76544e-19
C730	a_803_74##9	a_616_74##3	1.64246e-18
C731	VGND#22	SCE#6	5.06104e-19
C732	VGND#3	a_2580_74##12	3.83219e-18
C733	a_2191_180##5	a_2191_180##6	2.85249e-18
C734	a_1823_524##19	a_803_74##8	3.41467e-18
C735	VGND#9	a_616_74##6	5.74122e-19
C736	a_288_464##6	a_27_74##4	1.95005e-18
C737	SET_B#3	a_1017_81##7	1.33602e-17
C738	SET_B#10	a_1677_74#	4.7271e-18
C739	VGND#10	D#4	1.8613e-18
C740	VPWR#2	VPWR#3	5.15541e-17
C741	a_2580_74##15	a_1823_524##3	5.81291e-18
C742	VPWR#2	a_2580_74##2	3.3546e-20
C743	VGND#15	VGND#14	1.71986e-18
C744	a_803_74##8	a_616_74##7	2.85596e-18
C745	VGND#6	a_1677_74##2	5.7036e-18
C746	a_1017_81##14	a_1201_55##3	3.09916e-20
C747	a_27_74##2	SCD#2	6.76034e-19
C748	a_2191_180##2	a_1823_524##6	2.44849e-19
C749	a_1823_524##15	a_1823_524##13	2.50653e-18
C750	a_27_74##9	a_288_464##6	5.66194e-20
C751	Q#3	Q	4.7706e-18
C752	SET_B#3	VPWR#20	1.5062e-17
C753	a_288_464##3	SCD	6.86718e-17
C754	SCD	a_288_464##2	1.88434e-18
C755	SET_B#10	a_1823_524##19	2.1225e-18
C756	VGND#21	SCE#4	3.0867e-19
C757	SCE#3	a_27_74##2	2.49763e-17
C758	a_803_74##17	a_616_74##5	1.83873e-19
C759	a_288_464##3	a_414_464#	2.61753e-18
C760	a_27_74##9	SCE#6	6.8516e-21
C761	a_616_74##9	a_803_74#	1.51851e-17
C762	VGND#7	VGND#18	6.14667e-18
C763	a_288_464##6	a_27_74#	3.02723e-18
C764	VPWR#7	a_1823_524##15	3.36638e-17
C765	a_1201_55##5	a_1677_74##2	1.25983e-18
C766	SET_B#10	VGND#17	4.53522e-18
C767	SET_B#3	a_1201_55##7	1.28982e-17
C768	a_288_464##3	a_803_74##6	1.10831e-19
C769	VGND#2	a_2580_74##11	8.33338e-20
C770	a_1823_524##17	a_616_74#	4.75921e-17
C771	VPWR#2	Q#3	1.138e-18
C772	VGND#22	D#1	4.21164e-18
C773	a_2191_180##2	SET_B#4	4.3176e-17
C774	VPWR#5	a_616_74##2	7.32545e-19
C775	VGND#16	a_803_74##10	5.09975e-20
C776	a_288_464##6	SCE#7	8.03241e-17
C777	a_1017_81##3	SET_B#3	2.58482e-17
C778	a_1823_524##13	a_616_74##3	1.30816e-18
C779	a_803_74##16	a_1823_524##17	5.22678e-18
C780	a_803_74##16	SET_B#2	1.41632e-17
C781	VPWR#19	a_1017_81##4	1.5486e-19
C782	a_1620_373#	a_1823_524##15	4.64953e-17
C783	SCD#3	a_417_74#	9.87534e-18
C784	VPWR#9	a_803_74##4	9.0057e-20
C785	SET_B#10	a_1677_74##2	1.80463e-17
C786	VPWR#2	a_2580_74#	8.86478e-19
C787	VGND#21	SCD#2	7.57858e-18
C788	a_288_464##5	a_288_464##2	2.11694e-18
C789	SCE#6	a_417_74#	9.87534e-18
C790	VGND#15	Q#4	6.4074e-17
C791	a_27_74##6	SCE#3	1.57206e-17
C792	a_288_464##2	a_803_74##6	2.94419e-17
C793	SCE#7	a_27_74##4	4.80696e-17
C794	Q#2	VPWR#2	3.75139e-18
C795	CLK	a_288_464##5	4.58218e-18
C796	VPWR#8	VPWR#19	1.61306e-18
C797	VGND#10	a_1201_55#	8.865e-18
C798	VPWR#2	a_1823_524##2	2.68866e-19
C799	VPWR#8	a_616_74##7	6.46394e-20
C800	VGND#20	CLK	1.74921e-17
C801	VGND#3	a_1823_524##6	5.55788e-18
C802	VGND#11	SCD#2	7.94547e-19
C803	a_27_74##9	D#1	1.01081e-20
C804	VPWR	VPWR#9	2.07766e-17
C805	a_1017_81##9	a_616_74##3	1.77024e-17
C806	a_2580_74##15	a_1823_524##2	3.53851e-17
C807	VPWR	VPWR#8	7.62196e-17
C808	D#2	a_27_74##4	8.62261e-17
C809	VGND#9	CLK#2	5.93153e-20
C810	a_1017_81##14	a_803_74##17	6.37975e-17
C811	VPWR	VPWR#7	7.83556e-17
C812	a_616_74#	a_2191_180##2	5.59128e-17
C813	VPWR#2	a_2580_74##8	2.88004e-18
C814	VPWR	VPWR#5	8.8498e-17
C815	VGND#2	a_2580_74##3	2.90145e-19
C816	a_288_464##6	SCE#4	1.73808e-18
C817	VPWR	VPWR#4	7.99893e-17
C818	a_1201_55##7	a_1017_81##3	2.18965e-17
C819	VGND#10	a_803_74#	1.23446e-17
C820	a_2191_180##5	a_1823_524##11	1.21816e-18
C821	VPWR	VPWR#3	6.09928e-18
C822	a_1017_81##6	a_616_74##3	4.4964e-19
C823	SCE#7	D#2	7.32573e-17
C824	a_1620_373##2	a_1017_81##4	4.94275e-19
C825	a_2191_180##2	a_2227_74#	1.42267e-18
C826	a_803_74##17	a_616_74##4	2.9493e-17
C827	VGND#5	a_1823_524##17	5.03768e-17
C828	a_27_74#	VGND#22	1.88584e-17
C829	a_1017_81##14	a_803_74##5	1.10045e-17
C830	VGND#17	a_2191_180##3	3.04211e-20
C831	a_1823_524##13	a_803_74##8	7.37366e-20
C832	VPWR	a_2580_74##15	2.41613e-18
C833	VPWR#7	a_616_74##7	1.20335e-19
C834	a_616_74##10	a_616_74##9	3.30408e-18
C835	a_2191_180##2	a_803_74##7	2.25556e-18
C836	a_1823_524##17	a_803_74##7	5.07344e-17
C837	a_2580_74##3	a_2580_74#	4.08654e-18
C838	a_1201_55##4	a_1017_81##3	7.58262e-18
C839	a_288_464##6	D#2	6.62786e-19
C840	a_27_74##2	SCE#7	5.13402e-19
C841	VPWR#2	a_2580_74##9	1.46379e-18
C842	VGND#2	a_2580_74##2	1.47461e-20
C843	a_2580_74##16	Q#3	6.36917e-20
C844	VPWR#19	a_1620_373#	4.28243e-18
C845	VGND#10	a_616_74##9	1.73531e-21
C846	VPWR	a_1823_524##12	7.96991e-18
C847	a_288_464##3	a_616_74##11	4.68809e-19
C848	a_1823_524##11	a_1823_524##8	1.61001e-18
C849	VPWR#2	a_2580_74##15	1.85973e-18
C850	VPWR	a_1823_524##11	7.7654e-18
C851	a_803_74##17	a_1017_81##2	5.96931e-19
C852	a_1017_81##3	VPWR#21	1.45178e-17
C853	a_27_74##9	VGND#22	3.68106e-17
C854	SCE#3	D#1	9.00494e-19
C855	VGND#4	a_1823_524##9	2.71617e-18
C856	a_2580_74##5	VGND#14	3.3828e-18
C857	a_616_74#	a_803_74##12	2.93162e-17
C858	VGND#1	VPWR#1	3.32361e-19
C859	a_616_74##13	SCD#2	1.18203e-17
C860	VGND#2	Q#3	3.52838e-17
C861	a_803_74##17	a_803_74##16	6.42281e-19
C862	VGND#1	Q	3.19112e-17
C863	a_1677_74#	a_803_74##16	2.12255e-17
C864	VPWR	a_803_74##17	2.8571e-17
C865	VGND#10	a_616_74##10	1.57924e-18
C866	a_2580_74##16	Q#4	1.2142e-18
C867	VPWR#2	a_2580_74##13	3.06558e-18
C868	VPWR#10	a_616_74##6	2.57368e-20
C869	a_803_74##16	a_1017_81##2	2.26712e-19
C870	VPWR	a_803_74##16	7.32658e-18
C871	a_27_74##9	a_27_74#	9.5846e-19
C872	SCD	a_616_74##15	2.74368e-17
C873	a_803_74##13	a_288_464##2	1.86544e-18
C874	a_1201_55##7	a_1201_55##4	3.51214e-19
C875	VGND#21	SCD	1.44194e-17
C876	a_288_464##2	a_616_74##11	2.24076e-17
C877	VPWR#4	VPWR#3	1.20296e-18
C878	D#1	a_222_74#	9.87534e-18
C879	a_2580_74##16	a_2580_74##11	1.591e-20
C880	VGND#5	a_1823_524##19	2.69171e-17
C881	VGND#6	a_803_74##8	1.19129e-19
C882	a_1677_74##2	a_616_74##3	7.71383e-20
C883	VPWR#15	a_2580_74##11	3.02037e-19
C884	a_803_74##12	a_803_74##7	1.0454e-18
C885	a_288_464##6	SCD	3.99956e-17
C886	a_1677_74#	a_803_74##7	1.86714e-17
C887	a_2580_74##5	Q#4	6.09873e-17
C888	a_27_74#	a_222_74#	9.87534e-18
C889	a_1017_81##14	a_803_74##4	1.63956e-19
C890	a_2580_74##11	a_2580_74##8	1.12838e-18
C891	VGND#8	a_1201_55##5	1.72565e-17
C892	VPWR	SET_B#8	1.43512e-18
C893	VGND#2	Q#2	2.87436e-18
C894	VGND#10	CLK#3	6.25033e-18
C895	SET_B	VGND#4	4.15065e-18
C896	a_1620_373##2	VPWR#8	2.46373e-18
C897	SCE#4	VGND#22	2.05025e-17
C898	VPWR#2	a_1823_524#	5.59202e-18
C899	SCE	VPWR#24	2.44767e-18
C900	a_1620_373#	a_616_74##3	1.9754e-18
C901	VPWR#20	a_616_74##8	5.41167e-20
C902	VPWR#19	a_1823_524##15	3.0042e-17
C903	a_1620_373##2	a_1620_373#	1.36006e-18
C904	a_616_74##8	a_1201_55##4	1.6212e-17
C905	SET_B#10	VPWR#8	1.84513e-18
C906	VGND	a_1823_524##3	1.04902e-18
C907	VGND#17	a_616_74#	6.7413e-20
C908	a_27_74##2	a_288_464##6	1.35684e-17
C909	a_1201_55##4	VPWR#21	1.2693e-17
C910	a_803_74##9	a_616_74#	3.38853e-19
C911	VGND#15	a_2580_74##5	3.82421e-18
C912	a_1017_81##12	a_1017_81##2	3.5189e-18
C913	a_1823_524##17	a_803_74##10	1.80422e-18
C914	SET_B	VPWR#5	4.10009e-18
C915	VGND#10	SCD#3	2.48576e-18
C916	CLK#3	a_616_74##10	2.83485e-17
C917	a_803_74##4	a_803_74##18	1.50939e-18
C918	SET_B#8	SET_B#2	8.7534e-18
C919	VGND#4	a_1823_524##12	1.9081e-19
C920	SET_B#2	a_616_74##4	2.1781e-19
C921	CLK	a_616_74##13	8.36921e-18
C922	SET_B#10	VPWR#7	2.17037e-18
C923	SET_B	a_2580_74##15	3.01449e-18
C924	a_1823_524##19	a_803_74##7	1.24369e-18
C925	SET_B	a_2191_180##5	5.24231e-18
C926	a_288_464##3	CLK#1	1.652e-17
C927	a_1017_81##7	a_616_74##3	1.92507e-17
C928	a_803_74##6	a_1201_55##4	4.04514e-19
C929	VPWR#7	a_1017_81##9	4.31264e-19
C930	a_2191_180##5	a_1823_524##2	1.77478e-18
C931	a_27_74##2	VGND#22	4.11833e-17
C932	a_27_74##9	SCE#4	2.17744e-17
C933	a_1201_55##3	a_803_74##17	7.24173e-17
C934	VGND#10	SCE#6	1.69724e-19
C935	SET_B	a_1823_524##12	3.90799e-17
C936	a_1823_524##11	SET_B#6	1.19892e-17
C937	SET_B	a_1823_524##11	8.29309e-18
C938	a_27_74##4	a_204_464#	1.27643e-18
C939	a_2580_74##16	VGND#15	6.98644e-17
C940	VGND#2	a_2580_74##15	2.30418e-18
C941	VGND#8	a_803_74##2	1.96082e-19
C942	SET_B#2	a_616_74##3	4.66669e-19
C943	SET_B	SET_B#11	2.29475e-17
C944	a_1620_373##2	VPWR#7	3.33599e-18
C945	a_803_74##10	a_1677_74#	1.64537e-17
C946	a_1620_373#	a_803_74##8	7.92562e-19
C947	VGND#7	a_1201_55##5	2.44001e-17
C948	a_1201_55##3	a_803_74##16	3.2261e-18
C949	SET_B	a_803_74##16	9.87171e-18
C950	Q	VPWR#1	3.30657e-17
C951	VGND#4	SET_B#4	3.68152e-18
C952	a_288_464##2	CLK#1	9.51529e-18
C953	VPWR#21	a_616_74##8	2.42701e-18
C954	VGND#10	D#1	1.46745e-18
C955	a_803_74##6	a_616_74##8	1.55795e-17
C956	VPWR	a_1823_524##17	3.2238e-18
C957	a_1017_81##14	a_1201_55##4	2.13558e-19
C958	a_27_74##6	a_204_464#	3.63355e-18
C959	a_1017_81##4	a_803_74##9	9.03641e-18
C960	VGND#15	a_2580_74##15	2.7487e-17
C961	VGND#17	a_803_74##7	1.94187e-19
C962	a_616_74##6	a_803_74##18	3.92786e-19
C963	a_1017_81##12	a_1017_81##14	2.01519e-18
C964	SCD	a_616_74##13	6.87333e-17
C965	SCD#2	VPWR#23	2.00412e-18
C966	VGND#10	a_27_74#	6.02291e-19
C967	a_1201_55##7	a_803_74##6	1.34203e-19
C968	VGND	VGND#8	1.66414e-17
C969	a_803_74##18	a_803_74##17	1.20525e-18
C970	SET_B#8	a_1201_55##7	1.61334e-17
C971	VGND	VGND#7	1.26171e-16
C972	VGND	VGND#6	6.15057e-17
C973	a_616_74##6	VPWR#22	1.05606e-18
C974	VGND	VGND#4	1.08161e-16
C975	a_1823_524##12	a_2191_180#	3.28305e-17
C976	a_1017_81##12	a_1201_55##3	1.15548e-17
C977	Q#3	a_2580_74##6	2.51826e-17
C978	VGND	VGND#3	3.65975e-17
C979	VPWR#8	a_1017_81##7	2.62974e-18
C980	a_1823_524##19	a_803_74##10	5.72402e-17
C981	VGND#11	a_27_74##4	9.39802e-20
C982	SCD#3	CLK#3	3.24716e-18
C983	a_2580_74##16	a_1823_524##5	4.95028e-19
C984	VPWR#15	a_2580_74##3	3.44743e-19
C985	a_1823_524##11	a_2191_180##6	4.0157e-17
C986	a_1017_81##2	SET_B#8	4.66647e-17
C987	Q#5	a_2580_74##11	3.28426e-18
C988	VGND#10	SCE#4	1.03639e-18
C989	VGND#10	VGND#11	8.30276e-17
C990	a_616_74##13	a_616_74##6	5.17962e-18
C991	a_1823_524##17	a_616_74##2	1.57598e-17
C992	a_1620_373##2	VPWR#19	5.87474e-17
C993	a_288_464##3	SCD#4	3.6407e-17
C994	a_1677_74##2	a_803_74##7	1.74634e-19
C995	a_1823_524##15	a_616_74##3	1.86772e-17
C996	SET_B#3	a_616_74##4	1.63342e-17
C997	VGND	a_2580_74##15	1.27771e-18
C998	a_616_74##8	a_1017_81##14	1.30838e-17
C999	CLK	a_616_74##10	1.80135e-19
C1000	VGND	a_2191_180##5	3.72269e-18
C1001	a_1677_74#	a_1017_81##4	3.26909e-19
C1002	a_803_74##17	a_1201_55##2	1.20694e-18
C1003	a_2580_74##16	a_2580_74##3	8.35395e-21
C1004	a_288_464##6	SCD#2	1.3851e-17
C1005	a_1823_524##11	a_2191_180#	1.7761e-19
C1006	VGND	a_1823_524##12	1.11982e-18
C1007	VPWR#2	VPWR#1	6.74037e-17
C1008	SET_B	VGND#16	2.82121e-18
C1009	VGND#10	VGND#9	8.74313e-17
C1010	VGND#19	a_1201_55##5	2.15579e-17
C1011	VPWR	a_2580_74##14	1.32968e-17
C1012	a_1017_81##4	a_616_74##3	3.40777e-19
C1013	a_288_464##3	SCD#2	2.3399e-17
C1014	VGND	SET_B#11	3.22465e-18
C1015	a_1201_55##2	a_1153_81#	1.5787e-21
C1016	SET_B	a_1823_524##17	3.34493e-17
C1017	VPWR	a_2191_180##6	2.19175e-17
C1018	a_803_74##16	a_616_74##3	2.06467e-18
C1019	SET_B	a_1677_74#	1.09808e-17
C1020	VPWR	a_1823_524##16	1.42536e-17
C1021	a_1017_81##12	a_803_74##17	5.14567e-18
C1022	SET_B	a_1823_524##19	1.4444e-18
C1023	a_803_74##16	a_1017_81##4	1.80519e-18
C1024	VGND#17	a_803_74##10	2.14262e-18
C1025	VGND	a_803_74##16	8.45003e-18
C1026	a_1677_74#	a_616_74##2	6.25853e-18
C1027	VPWR	a_2103_508#	2.0144e-17
C1028	a_1017_81##2	a_616_74##4	1.04158e-18
C1029	a_2580_74##7	a_2580_74##6	3.88454e-17
C1030	VGND#16	a_1823_524##5	8.29185e-19
C1031	VPWR	a_1823_524##13	3.09949e-17
C1032	a_27_74##8	SCE#6	3.8369e-20
C1033	VPWR	a_1620_373#	5.90706e-18
C1034	a_27_74##6	VPWR#24	6.27402e-17
C1035	VPWR	a_1823_524##15	2.50567e-17
C1036	a_1017_81##6	SET_B#1	1.09696e-17
C1037	a_288_464##3	VGND#21	4.37559e-20
C1038	VGND#10	VGND#8	9.70411e-17
C1039	VGND#19	VGND#7	1.26017e-18
C1040	VGND	SET_B#8	1.60445e-18
C1041	Q#1	VPWR#2	2.32083e-17
C1042	VGND#4	a_2191_180##3	8.3743e-18
C1043	VPWR	a_1620_373##2	1.27063e-17
C1044	a_616_74##13	CLK#2	3.8528e-17
C1045	VPWR	a_1201_55##7	6.92711e-18
C1046	SCD	CLK#3	2.00367e-19
C1047	a_1823_524##19	a_1017_81##4	1.28743e-18
C1048	VPWR#20	VPWR#19	4.44405e-18
C1049	a_288_464##2	a_803_74##2	8.82444e-19
C1050	a_1823_524##15	a_803_74##8	5.10705e-20
C1051	a_803_74##6	a_1017_81##14	1.81158e-17
C1052	a_1017_81##12	a_1201_55##2	2.5613e-17
C1053	a_1201_55##7	a_1017_81#	1.52639e-18
C1054	SCE#6	SCD#3	3.94736e-17
C1055	CLK#1	a_616_74##11	4.63846e-17
C1056	VPWR#2	VPWR#15	2.15552e-17
C1057	a_803_74##18	a_616_74##8	1.84263e-19
C1058	a_2191_180##7	a_2580_74##16	4.16439e-17
C1059	a_1677_74##2	a_803_74##10	6.40718e-19
C1060	VGND#16	VGND#15	6.6317e-19
C1061	Q#3	a_2580_74##7	3.68124e-17
C1062	VPWR#8	SET_B#3	7.54489e-19
C1063	a_1677_74#	a_1017_81##8	9.23416e-20
C1064	a_288_464##3	a_27_74##3	1.48637e-17
C1065	VPWR#1	a_2580_74#	5.10408e-17
C1066	VGND	VGND#15	1.16991e-18
C1067	VGND	a_2580_74##16	2.09546e-17
C1068	SET_B	VPWR#18	3.26119e-18
C1069	VGND	a_2191_180##7	2.16131e-17
C1070	VGND#11	SCE#7	1.70646e-19
C1071	VGND	VGND#16	2.91764e-17
C1072	SET_B	a_2103_508#	2.43978e-18
C1073	a_803_74##6	a_288_464#	4.91709e-18
C1074	SET_B	a_1823_524##13	6.91599e-18
C1075	Q#1	VPWR#1	5.46134e-17
C1076	a_1017_81##12	a_616_74##5	2.8986e-19
C1077	SET_B	a_1620_373#	4.26787e-18
C1078	VGND	a_1823_524##17	3.21989e-17
C1079	Q#5	VPWR#2	2.5329e-17
C1080	SET_B	a_1823_524##15	1.21344e-19
C1081	VGND	a_1677_74#	8.18807e-18
C1082	VGND	a_1823_524##19	2.67945e-17
C1083	VGND#17	a_1017_81##4	4.46124e-17
C1084	a_803_74##5	a_803_74##17	1.55132e-18
C1085	VGND	VGND#17	1.73883e-17
C1086	a_1823_524##17	a_1823_524##5	1.50038e-19
C1087	VGND	a_1677_74##2	1.67653e-17
C1088	a_1677_74#	a_616_74##7	5.977e-19
C1089	a_1017_81#	SET_B#2	1.6865e-18
C1090	a_288_464##3	SCE#3	3.76393e-19
C1091	VGND#16	SET_B#5	6.79193e-19
C1092	VGND	a_1201_55##5	1.36149e-17
C1093	VPWR#11	VPWR#12	7.66947e-17
C1094	VPWR#20	a_1620_373##2	3.28955e-17
C1095	a_803_74##16	a_803_74##8	2.1393e-18
C1096	a_1823_524##12	VPWR#18	1.88576e-17
C1097	Q	a_2580_74#	7.60275e-18
C1098	a_27_74##8	D#1	4.33686e-19
C1099	a_1677_74##2	a_803_74##16	3.66073e-17
C1100	a_27_74##6	a_27_74##7	6.94333e-18
C1101	VPWR#16	a_2580_74##11	3.45895e-18
C1102	a_2580_74#	Q#1	1.63361e-17
C1103	VPWR#2	VPWR#16	1.83309e-17
C1104	a_803_74##18	a_803_74##6	5.23585e-18
C1105	a_2191_180##5	a_2580_74##16	3.83942e-17
C1106	a_2580_74##13	a_2580_74##11	1.13844e-18
C1107	VGND#10	a_1201_55##5	2.45953e-18
C1108	a_1017_81##3	a_616_74##4	1.63246e-17
C1109	a_1017_81##2	SET_B#1	1.95706e-18
C1110	SCD#4	CLK#1	3.58873e-18
C1111	a_2580_74##11	VNB	7.71321e-17
C1112	a_2580_74##10	a_2580_74##7	2.39745e-17
C1113	a_1017_81##2	a_803_74##2	3.92834e-19
C1114	VPWR#11	VPWR#10	9.58117e-17
C1115	a_2580_74##3	VNB	2.84876e-17
C1116	a_2580_74##2	VNB	2.55433e-17
C1117	VPWR#12	a_27_74##4	1.28377e-19
C1118	a_1823_524##3	VNB	1.61747e-17
C1119	a_1823_524##2	VNB	3.60881e-17
C1120	a_616_74##5	VNB	1.01928e-16
C1121	a_616_74##4	VNB	1.7963e-16
C1122	a_616_74##3	VNB	1.24472e-16
C1123	a_803_74##8	VNB	2.01144e-17
C1124	a_803_74##2	VNB	6.59059e-17
C1125	SCD	a_616_74##11	3.0975e-19
C1126	VPWR#11	SCE	5.70926e-18
C1127	a_288_464##2	SCD#2	3.37249e-19
C1128	SCD#2	VNB	1.08897e-16
C1129	SCE#3	VNB	1.05568e-16
C1130	a_1677_74##2	a_1017_81##4	2.45216e-17
C1131	SCD	CLK#1	4.67433e-19
C1132	a_288_464##3	a_288_464##2	1.19063e-18
C1133	VPWR#1	a_2580_74##8	3.33975e-18
C1134	VGND#10	SCE	6.50179e-18
C1135	VPWR#9	a_1017_81##3	9.97365e-19
C1136	a_1017_81##2	a_1017_81#	6.48962e-18
C1137	VGND#10	VGND#19	2.25597e-17
C1138	D#1	SCE#6	1.78974e-17
C1139	VPWR#6	a_803_74##11	5.47914e-18
C1140	SET_B	a_616_74#	4.01207e-18
C1141	a_1017_81##12	a_803_74##5	4.78711e-17
C1142	SET_B	a_803_74##7	4.93079e-19
C1143	VPWR#15	VPWR#1	2.06271e-18
C1144	a_1201_55##3	a_616_74##4	1.74052e-18
C1145	VPWR#11	VPWR#9	1.16728e-16
C1146	a_1017_81##13	a_1201_55##5	1.60623e-18
C1147	VPWR#15	a_2580_74#	2.69297e-18
C1148	a_27_74##8	a_27_74##6	1.33716e-18
C1149	a_1823_524##12	a_616_74##2	4.3648e-19
C1150	a_288_464##3	D#3	2.63573e-19
C1151	VPWR	a_1823_524##7	5.39956e-18
C1152	VPWR#11	CLK	1.60342e-18
C1153	VPWR	a_1823_524##8	6.62854e-20
C1154	VGND#17	a_1017_81##8	2.42313e-18
C1155	VGND#10	CLK	1.39661e-18
C1156	a_1823_524##12	a_1823_524##11	1.67638e-18
C1157	Q#3	a_2580_74##10	1.2604e-18
C1158	a_1823_524##11	VPWR#18	5.19977e-18
C1159	a_1823_524##17	SET_B#5	2.68342e-19
C1160	VPWR#6	a_616_74##2	6.84294e-18
C1161	a_616_74##11	a_803_74##18	2.30401e-17
C1162	VGND#11	VNB	4.50073e-17
C1163	VGND#9	VNB	5.02814e-17
C1164	VGND#8	VNB	6.28167e-17
C1165	VGND#8	a_1017_81##13	1.55071e-17
C1166	VGND#7	VNB	4.70607e-17
C1167	a_2191_180##5	SET_B#11	3.44062e-18
C1168	VGND#6	VNB	3.31981e-17
C1169	VGND#16	a_2191_180##2	1.57518e-17
C1170	VGND#4	VNB	5.86653e-17
C1171	a_1017_81##12	a_616_74##4	2.81579e-19
C1172	VGND#3	VNB	4.15479e-17
C1173	a_2580_74##8	Q#1	2.64796e-17
C1174	VGND#15	a_1823_524##2	1.23399e-18
C1175	VPWR#12	VNB	4.03522e-17
C1176	VPWR	a_1017_81##9	2.05091e-18
C1177	VPWR#10	VNB	4.65055e-17
C1178	VPWR#9	VNB	5.11024e-17
C1179	a_27_74##3	SCD#4	3.47395e-17
C1180	VPWR#8	VNB	2.87274e-17
C1181	VPWR	a_1017_81##7	3.8621e-18
C1182	VPWR#7	VNB	3.10671e-17
C1183	a_803_74##17	a_803_74##4	7.31236e-20
C1184	VPWR#5	VNB	4.33993e-17
C1185	VPWR#4	VNB	3.81827e-17
C1186	VPWR#3	VNB	2.81042e-17
C1187	VPWR#11	SCD	5.72699e-18
C1188	Q#3	VNB	6.96332e-18
C1189	VGND	a_1823_524##6	3.49029e-21
C1190	SET_B#10	a_1017_81##9	4.01741e-18
C1191	Q#2	VNB	1.83236e-18
C1192	VGND	a_1823_524##9	7.77456e-20
C1193	VGND#10	SCD	4.11065e-18
C1194	a_27_74##8	a_27_74#	2.62629e-19
C1195	a_2580_74##15	VNB	1.01204e-17
C1196	VGND#10	a_1017_81##13	1.76753e-17
C1197	a_2191_180##5	VNB	1.46905e-17
C1198	VPWR#2	Q	2.5293e-18
C1199	a_1201_55##2	a_1017_81##8	8.12994e-20
C1200	Q#5	a_2580_74#	1.95135e-19
C1201	a_1823_524##12	VNB	7.34333e-18
C1202	VGND#2	Q	3.16944e-18
C1203	a_1823_524##11	VNB	1.05765e-17
C1204	a_27_74##4	a_288_464##4	5.54869e-17
C1205	SET_B#10	a_616_74##4	1.13107e-19
C1206	SET_B#11	VNB	1.63928e-18
C1207	a_803_74##17	VNB	1.94206e-17
C1208	VPWR#22	a_616_74##11	4.05636e-17
C1209	a_1823_524##12	a_2103_508#	3.907e-17
C1210	a_803_74##16	VNB	2.59144e-17
C1211	a_288_464##6	a_288_464##3	9.93934e-19
C1212	a_1017_81##12	VNB	1.10238e-17
C1213	VGND	a_1017_81#	6.16572e-19
C1214	VGND#5	a_616_74##2	2.24978e-20
C1215	SET_B#8	VNB	2.92903e-18
C1216	SET_B	a_616_74##2	6.85526e-18
C1217	a_1017_81##8	a_1677_74##2	1.63603e-17
C1218	a_1201_55##2	SET_B#1	3.11517e-19
C1219	a_288_464##3	VNB	7.74718e-18
C1220	a_288_464##2	VNB	1.41172e-18
C1221	SET_B#10	a_1017_81##7	4.84718e-18
C1222	VPWR#15	Q#1	4.9919e-17
C1223	VGND#10	a_288_464##5	1.0924e-17
C1224	a_2580_74##5	Q	1.30169e-18
C1225	VGND#16	a_2191_180##7	3.2531e-17
C1226	VPWR#15	a_2580_74##8	5.10155e-17
C1227	a_1017_81##13	VGND#19	7.59245e-18
C1228	CLK	a_616_74##6	2.88547e-17
C1229	a_27_74##8	VNB	4.34106e-17
C1230	a_27_74##6	VNB	5.90988e-17
C1231	CLK	CLK#2	6.75204e-18
C1232	SCE	D#2	2.24076e-18
C1233	SET_B#10	a_616_74##3	4.25208e-19
C1234	a_2580_74##12	a_2580_74##10	2.11893e-17
C1235	a_27_74#	D#1	3.46628e-17
C1236	D#4	VNB	8.28415e-19
C1237	VGND#1	VNB	6.82692e-17
C1238	SET_B#10	VPWR	4.25364e-17
C1239	a_1823_524##5	a_1823_524##7	7.17434e-18
C1240	VGND#14	VNB	4.09641e-19
C1241	a_27_74##2	SCE	5.64757e-17
C1242	VPWR#12	SCE#7	4.3777e-20
C1243	Q#4	VNB	5.97446e-18
C1244	VPWR	VPWR#6	6.83895e-17
C1245	VGND#15	VNB	3.90165e-18
C1246	a_1201_55##2	a_1017_81#	5.00793e-18
C1247	a_2580_74##16	VNB	9.1828e-18
C1248	a_2191_180##7	VNB	8.78619e-18
C1249	VGND#16	VNB	3.84028e-18
C1250	VGND#3	a_2580_74##5	5.47921e-19
C1251	a_1823_524##17	VNB	1.47052e-17
C1252	a_1677_74#	VNB	7.40355e-18
C1253	a_1823_524##19	VNB	1.11598e-17
C1254	VGND#17	VNB	7.03554e-18
C1255	a_1017_81##12	a_803_74##4	7.92275e-17
C1256	VGND#10	a_803_74##13	4.1375e-17
C1257	a_1677_74##2	VNB	1.47897e-17
C1258	D#3	a_27_74##3	1.47839e-17
C1259	VPWR#9	a_1201_55##4	3.14869e-18
C1260	a_1201_55##5	VNB	8.68698e-18
C1261	SCD	CLK#2	9.379e-19
C1262	a_1823_524##17	a_2191_180##2	2.19228e-17
C1263	Q#1	a_2580_74##9	3.20735e-19
C1264	VGND#19	VNB	6.39445e-18
C1265	VPWR	a_1823_524##5	3.50859e-18
C1266	a_1017_81##13	VNB	4.6564e-18
C1267	a_288_464##3	SCE#1	1.17957e-19
C1268	a_1620_373##2	a_616_74##3	4.25738e-18
C1269	a_288_464##5	VNB	6.51227e-18
C1270	VPWR	SET_B#5	3.25552e-18
C1271	a_803_74##17	a_1017_81#	7.00422e-20
C1272	a_803_74##13	VNB	1.4112e-17
C1273	a_1201_55##4	a_616_74##4	1.6209e-17
C1274	VGND#20	VNB	8.49121e-19
C1275	a_616_74##15	VNB	1.21909e-17
C1276	VGND#21	VNB	5.0872e-18
C1277	a_288_464##4	SCE#7	2.79127e-19
C1278	a_803_74##2	a_1201_55##3	4.03864e-17
C1279	a_1201_55##2	a_1201_55#	7.59608e-18
C1280	a_288_464##6	VNB	2.7099e-18
C1281	VPWR	a_803_74##12	3.19172e-18
C1282	VGND#22	VNB	4.16334e-18
C1283	D#4	SCE#3	9.77527e-18
C1284	a_27_74##9	VNB	2.33852e-17
C1285	a_803_74##17	a_803_74##2	4.2975e-19
C1286	VPWR#1	VNB	7.43874e-17
C1287	Q#1	VNB	4.69346e-18
C1288	SET_B	VPWR#6	1.83551e-18
C1289	a_1017_81##8	VGND#18	1.70301e-17
C1290	VPWR#22	CLK#1	3.7058e-17
C1291	VPWR#15	VNB	1.1667e-19
C1292	VPWR	a_1017_81##6	1.89551e-18
C1293	Q#5	a_2580_74##8	4.58847e-19
C1294	Q#5	VNB	2.69373e-18
C1295	SET_B	VGND#5	3.82362e-18
C1296	VPWR#16	VNB	1.92634e-18
C1297	a_2580_74##14	VNB	6.46176e-18
C1298	VPWR#17	VNB	3.90342e-18
C1299	a_2191_180##6	VNB	8.11983e-18
C1300	a_1823_524##16	VNB	6.07152e-18
C1301	VPWR	a_1017_81##2	1.41447e-18
C1302	VPWR#18	VNB	4.38795e-19
C1303	a_2103_508#	VNB	6.21386e-18
C1304	VGND#10	VGND#20	1.95356e-17
C1305	a_1823_524##13	VNB	3.99258e-18
C1306	VPWR	a_1201_55##3	3.00857e-19
C1307	Q#3	a_2580_74##12	2.62153e-19
C1308	a_1620_373#	VNB	2.25863e-18
C1309	a_1823_524##15	VNB	7.91755e-18
C1310	SET_B	a_1823_524##5	1.11267e-17
C1311	VPWR#19	VNB	6.53764e-18
C1312	a_1620_373##2	VNB	3.26853e-18
C1313	VPWR#20	VNB	4.71293e-18
C1314	SET_B	SET_B#5	1.35808e-17
C1315	a_1201_55##7	VNB	5.41179e-18
C1316	a_27_74##8	SCE#4	1.96305e-17
C1317	a_803_74#	a_1201_55##2	2.30743e-17
C1318	VPWR#21	VNB	4.11019e-18
C1319	SET_B	a_2191_180##2	1.86539e-17
C1320	a_1017_81##14	VNB	6.47242e-18
C1321	SET_B	a_803_74##12	2.87849e-17
C1322	a_803_74##18	VNB	1.51823e-17
C1323	a_616_74##13	VNB	4.12206e-18
C1324	a_1201_55##5	a_1017_81##4	1.11123e-19
C1325	a_1201_55##2	a_616_74##4	2.23165e-19
C1326	VPWR#23	VNB	5.54383e-18
C1327	Q#5	Q#1	1.918e-18
C1328	VGND	SET_B#10	4.03924e-17
C1329	VPWR#24	VNB	2.02219e-18
C1330	VPWR#15	a_2580_74##9	4.49275e-17
C1331	a_2580_74##6	VNB	3.38759e-17
C1332	a_1677_74##2	SET_B#1	7.83986e-19
C1333	a_2580_74##7	VNB	2.65744e-17
C1334	VGND	VGND#5	7.43955e-17
C1335	a_2580_74##10	VNB	2.56033e-17
C1336	a_2580_74##12	VNB	3.14623e-17
C1337	a_1823_524##6	VNB	4.65927e-17
C1338	a_1823_524##9	VNB	3.57334e-17
C1339	a_616_74##13	CLK#1	4.06579e-17
C1340	SET_B#4	VNB	3.15151e-17
C1341	SET_B#5	a_1823_524##8	3.22487e-19
C1342	VGND#10	a_616_74##15	3.82613e-17
C1343	a_2191_180##3	VNB	1.93305e-17
C1344	a_616_74#	VNB	5.61913e-17
C1345	a_803_74##7	VNB	3.47734e-17
C1346	VGND	a_1823_524##5	5.14247e-18
C1347	a_803_74##10	VNB	2.89048e-17
C1348	a_1017_81##4	VNB	3.70841e-17
C1349	a_1017_81##8	VNB	2.6444e-17
C1350	SET_B#1	VNB	3.1604e-17
C1351	VGND	a_2191_180##2	1.1522e-17
C1352	a_1017_81#	VNB	4.59415e-17
C1353	a_1201_55#	VNB	2.78632e-17
C1354	VGND	a_803_74##12	3.31738e-18
C1355	a_803_74#	VNB	4.10257e-17
C1356	a_616_74##9	VNB	4.67584e-17
C1357	VPWR#10	a_616_74##5	9.44127e-20
C1358	a_616_74##10	VNB	3.1098e-17
C1359	Q#5	a_1823_524##3	6.25439e-20
C1360	CLK#3	VNB	3.4081e-17
C1361	VGND	a_1017_81##6	5.85814e-18
C1362	SCE#1	D#3	3.55014e-17
C1363	SCD#3	VNB	2.4743e-17
C1364	SCE#6	VNB	2.52962e-17
C1365	VGND	SET_B#2	4.81599e-21
C1366	D#1	VNB	4.02861e-17
C1367	D#2	a_288_464##4	1.4105e-18
C1368	a_27_74#	VNB	2.12242e-17
C1369	VGND	a_1017_81##2	6.56194e-18
C1370	SCE#4	VNB	4.57621e-17
C1371	a_2580_74#	VNB	4.18155e-17
C1372	a_2580_74##8	VNB	3.13986e-17
C1373	a_803_74##7	a_616_74##2	1.74249e-17
C1374	a_2580_74##9	VNB	2.7673e-17
C1375	SCE#4	a_27_74#	1.66017e-17
C1376	Q#1	a_2580_74##13	1.37978e-19
C1377	a_2580_74##13	VNB	3.51505e-17
C1378	a_1823_524#	VNB	2.6702e-17
C1379	VGND#16	a_2191_180##5	2.8412e-17
C1380	a_1823_524##7	VNB	2.54987e-17
C1381	a_1823_524##8	VNB	3.42351e-17
C1382	VPWR#22	SCD#4	1.34255e-18
C1383	SET_B#6	VNB	2.8857e-17
C1384	a_2191_180#	VNB	4.73622e-17
C1385	VGND#10	VGND#21	1.65451e-17
C1386	a_803_74##11	VNB	2.94776e-17
C1387	a_616_74##2	VNB	7.93355e-17
C1388	VGND#4	a_1823_524##5	4.96771e-19
C1389	a_616_74##7	VNB	2.89933e-17
C1390	a_1017_81##9	VNB	3.35769e-17
C1391	VGND#22	SCE#3	1.4071e-18
C1392	VGND#9	a_803_74##13	7.39518e-17
C1393	a_1017_81##7	VNB	3.23675e-17
C1394	a_1823_524##17	a_803_74##12	4.49066e-17
C1395	VPWR#23	CLK#1	4.55242e-18
C1396	SET_B#3	VNB	3.33432e-17
C1397	a_1017_81##3	VNB	3.40153e-17
C1398	a_1201_55##4	VNB	1.86761e-17
C1399	a_616_74##8	VNB	2.48538e-17
C1400	Q#5	a_2580_74##9	3.87522e-17
C1401	a_803_74##6	VNB	3.45481e-17
C1402	a_616_74##11	VNB	3.31246e-17
C1403	CLK#1	VNB	4.21948e-17
C1404	SCD#4	VNB	3.45299e-17
C1405	a_1823_524##6	a_2580_74##12	2.99792e-17
C1406	a_27_74##3	VNB	2.62291e-17
C1407	D#3	VNB	2.55149e-17
C1408	SCE#1	VNB	2.16697e-17
C1409	SCE#5	VNB	2.97239e-17
C1410	SET_B#1	VGND#18	1.27737e-17
C1411	VPWR#2	VNB	1.6333e-16
C1412	SET_B#10	a_803_74##2	7.9683e-19
C1413	VGND#2	VNB	1.67703e-16
C1414	a_288_464##3	SCE#5	1.1985e-19
C1415	SET_B#10	VNB	2.2515e-17
C1416	VPWR#6	VNB	3.37184e-17
C1417	VGND#5	VNB	4.18144e-17
C1418	a_2191_180#	SET_B#5	2.46617e-17
C1419	VPWR#11	VNB	3.02795e-16
C1420	VGND#10	VNB	3.35591e-16
C1421	a_1823_524##5	VNB	1.08019e-16
C1422	VGND#3	a_1823_524##5	1.34223e-19
C1423	SET_B#5	VNB	8.58269e-17
C1424	a_2191_180##2	VNB	6.45396e-17
C1425	a_1677_74#	a_803_74##12	2.78982e-18
C1426	a_803_74##12	VNB	5.23239e-17
C1427	a_803_74##9	VNB	6.83737e-17
C1428	a_616_74##5	a_616_74##8	1.06361e-19
C1429	Q#5	VPWR#15	6.99586e-17
C1430	a_1017_81##6	VNB	6.20425e-17
C1431	SET_B#2	VNB	6.16853e-17
C1432	a_1017_81##2	VNB	7.3858e-17
C1433	a_1017_81#	a_616_74##4	5.05452e-20
C1434	a_1201_55##3	VNB	4.49166e-17
C1435	a_1201_55##2	VNB	4.16284e-17
C1436	a_1823_524##2	a_2580_74##13	1.20497e-17
C1437	VPWR#15	a_2580_74##13	1.98339e-18
C1438	a_803_74##5	VNB	1.47849e-19
C1439	a_803_74##4	VNB	5.59376e-17
C1440	a_1201_55##5	a_1017_81##8	2.16246e-19
C1441	a_616_74##6	VNB	3.667e-17
C1442	CLK#2	VNB	3.7089e-17
C1443	a_27_74##6	SCD#4	8.43468e-20
C1444	a_27_74##4	VNB	3.01554e-17
C1445	VPWR#6	a_616_74##3	7.25488e-18
C1446	SCE#7	VNB	4.6188e-17
C1447	D#2	VNB	4.92949e-17
C1448	a_27_74##2	VNB	3.10196e-17
C1449	VGND#11	VGND#20	1.70446e-19
C1450	a_1677_74##2	a_1017_81#	3.22822e-19
C1451	SCE#5	SCE#1	2.86049e-17
C1452	a_803_74##4	a_803_74#	7.81475e-19
C1453	VPWR#16	a_2580_74##9	7.34099e-19
C1454	VGND#7	a_1017_81##4	2.80234e-18
C1455	VGND#10	a_288_464##6	2.87908e-17
C1456	Q#5	a_1823_524##2	2.85455e-18
C1457	a_803_74##13	VGND#19	4.23794e-18
C1458	VPWR#3	a_2580_74##11	1.29892e-20
C1459	Q#3	a_1823_524##6	1.19098e-19
C1460	SET_B	VPWR	3.77352e-17
C1461	SCD#4	VPWR#23	2.36207e-17
C1462	a_616_74##4	a_616_74##8	4.39006e-19
C1463	a_2580_74##12	a_2580_74##11	1.01838e-18
C1464	a_803_74##2	a_1201_55##2	1.41977e-17
C1465	SCE	VNB	7.39675e-18
C1466	VGND	SET_B	3.85208e-17
C1467	VPWR#8	a_616_74##8	6.84029e-20
C1468	CLK	VNB	2.3183e-19
C1469	VPWR#6	a_803_74##8	2.16097e-19
C1470	a_803_74##4	a_616_74##9	4.11536e-17
C1471	SCD	VNB	8.23727e-18
C1472	Q	VNB	3.01027e-17
C1473	VPWR	VNB	2.32275e-16
C1474	SET_B	VNB	2.1559e-17
C1475	VGND	VNB	2.35315e-16
C1476	Q#5	a_2580_74##13	5.61175e-17
C1477	VPWR#13	D#2	1.28191e-19
C1478	VPWR#13	SCE#7	5.87253e-20
C1479	VPWR#13	VNB	6.49946e-17
C1480	a_27_74##4	VPWR#13	2.16033e-18
C1481	VPWR#11	VPWR#13	1.1596e-16
C1482	VPWR#13	SCE#5	1.78221e-18
C1483	VPWR#13	SCE#1	3.9289e-18
C1484	a_288_464##4	VPWR#13	1.11634e-17
C1485	VPWR#13	D#3	7.58497e-18
C1486	VPWR#13	VPWR#23	3.13163e-19
C1487	a_27_74##6	VPWR#13	2.05709e-17
C1488	VPWR#13	a_27_74##2	9.0437e-20
C1489	VGND#10	VGND#12	1.12583e-16
C1490	VGND#12	SCE	6.16343e-19
C1491	VGND#12	D#2	3.44662e-19
C1492	VGND#12	SCE#4	2.72043e-18
C1493	VGND#12	VGND#11	3.02189e-19
C1494	VGND#12	SCE#7	7.74565e-19
C1495	VGND#12	a_27_74#	4.79858e-18
C1496	VGND#12	a_288_464##6	8.81801e-18
C1497	VGND#12	VNB	6.45482e-17
C1498	VGND#12	a_27_74##9	2.13573e-17
C1499	VGND#12	a_27_74##8	2.67487e-19
C1500	VGND#12	a_27_74##2	1.80843e-18
C1501	VGND#12	D#1	7.73139e-18
*
*
.ENDS sky130_fd_sc_hs__sdfstp_4
*
