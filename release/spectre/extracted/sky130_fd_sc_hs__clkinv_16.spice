* Extracted by Quantus, converted by sky130cad/quantus.py
*
*
*
*                       LINUX           Wed Nov 18 08:24:20 2026
*
*
*
*  PROGRAM  advgen
*
*  Name           : advgen - Quantus - (64-bit)
*  Version        : 25.1.0-p047
*  Build Date     : Thu Dec 11 23:20:30 PST 2025
*
*  HSPICE LIBRARY
*
*  OPERATING_TEMPERATURE 150
*  QRC_TECH_DIR <path>/tech
*
*
*

*
.SUBCKT sky130_fd_sc_hs__clkinv_16 VPB VNB VGND A Y VPWR
*
*
*  caps2d version: 10
*
*
*       TRANSISTOR CARDS
*
*
XM25 Y#3 A#72 VGND#13 VNB sky130_fd_pr__nfet_01v8_lvt l=0.15 w=0.42 ad=0.1176 as=0.1197 pd=1.4 ps=1.41
XM10 VGND#20 A#69 Y#3 VNB sky130_fd_pr__nfet_01v8_lvt l=0.15 w=0.42 ad=0.1176 as=0.1176 pd=1.4 ps=1.4
XM18 Y#6 A#65 VGND#20 VNB sky130_fd_pr__nfet_01v8_lvt l=0.15 w=0.42 ad=0.1176 as=0.1176 pd=1.4 ps=1.4
XM22 VGND#19 A#62 Y#6 VNB sky130_fd_pr__nfet_01v8_lvt l=0.15 w=0.42 ad=0.147 as=0.1176 pd=1.54 ps=1.4
XM27 VGND#19 A#58 Y#10 VNB sky130_fd_pr__nfet_01v8_lvt l=0.15 w=0.42 ad=0.147 as=0.1176 pd=1.54 ps=1.4
XM23 VGND#18 A#55 Y#10 VNB sky130_fd_pr__nfet_01v8_lvt l=0.15 w=0.42 ad=0.147 as=0.1176 pd=1.54 ps=1.4
XM38 Y#14 A#51 VGND#18 VNB sky130_fd_pr__nfet_01v8_lvt l=0.15 w=0.42 ad=0.1176 as=0.147 pd=1.4 ps=1.54
XM39 Y#14 A#48 VGND#17 VNB sky130_fd_pr__nfet_01v8_lvt l=0.15 w=0.42 ad=0.1176 as=0.1764 pd=1.4 ps=1.68
XM30 Y#15 A#43 VGND#17 VNB sky130_fd_pr__nfet_01v8_lvt l=0.15 w=0.42 ad=0.1176 as=0.1764 pd=1.4 ps=1.68
XM31 Y#15 A#39 VGND#16 VNB sky130_fd_pr__nfet_01v8_lvt l=0.15 w=0.42 ad=0.1176 as=0.1764 pd=1.4 ps=1.68
XM20 Y#18 A#37 VGND#16 VNB sky130_fd_pr__nfet_01v8_lvt l=0.15 w=0.42 ad=0.1176 as=0.1764 pd=1.4 ps=1.68
XM5 VGND#15 A#35 Y#18 VNB sky130_fd_pr__nfet_01v8_lvt l=0.15 w=0.42 ad=0.1176 as=0.1176 pd=1.4 ps=1.4
XM4 Y#21 A#33 VGND#15 VNB sky130_fd_pr__nfet_01v8_lvt l=0.15 w=0.42 ad=0.1176 as=0.1176 pd=1.4 ps=1.4
XM8 VGND#14 A#31 Y#21 VNB sky130_fd_pr__nfet_01v8_lvt l=0.15 w=0.42 ad=0.1176 as=0.1176 pd=1.4 ps=1.4
XM13 VGND#14 A#29 Y#27 VNB sky130_fd_pr__nfet_01v8_lvt l=0.15 w=0.42 ad=0.1176 as=0.1176 pd=1.4 ps=1.4
XM29 VGND#3 A#27 Y#27 VNB sky130_fd_pr__nfet_01v8_lvt l=0.15 w=0.42 ad=0.71835 as=0.1176 pd=5.57 ps=1.4
XM1 VPWR#15 A#74 Y#1 VPB sky130_fd_pr__pfet_01v8 l=0.15 w=1.12 ad=0.3304 as=0.336 pd=2.83 ps=2.84
XM32 Y#1 A#73 VPWR#26 VPB sky130_fd_pr__pfet_01v8 l=0.15 w=1.12 ad=0.336 as=0.336 pd=2.84 ps=2.84
XM17 Y#4 A#70 VPWR#26 VPB sky130_fd_pr__pfet_01v8 l=0.15 w=1.12 ad=0.336 as=0.336 pd=2.84 ps=2.84
XM19 VPWR#25 A#66 Y#4 VPB sky130_fd_pr__pfet_01v8 l=0.15 w=1.12 ad=0.336 as=0.336 pd=2.84 ps=2.84
XM15 VPWR#25 A#63 Y#7 VPB sky130_fd_pr__pfet_01v8 l=0.15 w=1.12 ad=0.336 as=0.336 pd=2.84 ps=2.84
XM16 Y#7 A#59 VPWR#24 VPB sky130_fd_pr__pfet_01v8 l=0.15 w=1.12 ad=0.336 as=0.336 pd=2.84 ps=2.84
XM26 Y#11 A#56 VPWR#24 VPB sky130_fd_pr__pfet_01v8 l=0.15 w=1.12 ad=0.336 as=0.336 pd=2.84 ps=2.84
XM28 Y#11 A#52 VPWR#23 VPB sky130_fd_pr__pfet_01v8 l=0.15 w=1.12 ad=0.336 as=0.336 pd=2.84 ps=2.84
XM21 VPWR#23 A#49 Y#17 VPB sky130_fd_pr__pfet_01v8 l=0.15 w=1.12 ad=0.336 as=0.336 pd=2.84 ps=2.84
XM24 Y#17 A#44 VPWR#22 VPB sky130_fd_pr__pfet_01v8 l=0.15 w=1.12 ad=0.336 as=0.336 pd=2.84 ps=2.84
XM6 Y#20 A#40 VPWR#22 VPB sky130_fd_pr__pfet_01v8 l=0.15 w=1.12 ad=0.336 as=0.336 pd=2.84 ps=2.84
XM34 Y#20 A#36 VPWR#21 VPB sky130_fd_pr__pfet_01v8 l=0.15 w=1.12 ad=0.336 as=0.392 pd=2.84 ps=2.94
XM33 Y#23 A#34 VPWR#21 VPB sky130_fd_pr__pfet_01v8 l=0.15 w=1.12 ad=0.336 as=0.392 pd=2.84 ps=2.94
XM36 Y#23 A#32 VPWR#20 VPB sky130_fd_pr__pfet_01v8 l=0.15 w=1.12 ad=0.336 as=0.392 pd=2.84 ps=2.94
XM37 VPWR#20 A#30 Y#24 VPB sky130_fd_pr__pfet_01v8 l=0.15 w=1.12 ad=0.392 as=0.4032 pd=2.94 ps=2.96
XM35 Y#24 A#28 VPWR#19 VPB sky130_fd_pr__pfet_01v8 l=0.15 w=1.12 ad=0.4032 as=0.336 pd=2.96 ps=2.84
XM12 VPWR#19 A#26 Y#28 VPB sky130_fd_pr__pfet_01v8 l=0.15 w=1.12 ad=0.336 as=0.336 pd=2.84 ps=2.84
XM7 VPWR#18 A#25 Y#28 VPB sky130_fd_pr__pfet_01v8 l=0.15 w=1.12 ad=0.336 as=0.336 pd=2.84 ps=2.84
XM9 VPWR#18 A#24 Y#30 VPB sky130_fd_pr__pfet_01v8 l=0.15 w=1.12 ad=0.336 as=0.336 pd=2.84 ps=2.84
XM11 VPWR#17 A#23 Y#30 VPB sky130_fd_pr__pfet_01v8 l=0.15 w=1.12 ad=0.336 as=0.336 pd=2.84 ps=2.84
XM3 Y#32 A#22 VPWR#17 VPB sky130_fd_pr__pfet_01v8 l=0.15 w=1.12 ad=0.336 as=0.336 pd=2.84 ps=2.84
XM2 VPWR#16 A#21 Y#32 VPB sky130_fd_pr__pfet_01v8 l=0.15 w=1.12 ad=0.336 as=0.336 pd=2.84 ps=2.84
XM14 VPWR#16 A#20 Y#34 VPB sky130_fd_pr__pfet_01v8 l=0.15 w=1.12 ad=0.336 as=0.336 pd=2.84 ps=2.84
XM0 VPWR#1 A#1 Y#34 VPB sky130_fd_pr__pfet_01v8 l=0.15 w=1.12 ad=0.3304 as=0.336 pd=2.83 ps=2.84
*
*
*       RESISTOR AND CAP/DIODE CARDS
*
Rg1	A#1	A#2	497.728577
Rg2	A#2	A#3	73.465096
Rg3	A#3	A#4	73.465096
Rg4	A#4	A#5	73.424057
Rg5	A#5	A#6	74.922478
Rg6	A#6	A#7	73.465096
Rg7	A#7	A#8	73.465096
Rg8	A#8	A#9	75.808647
Rg9	A#9	A#10	75.397446
Rg10	A#10	A#11	31.934380
Rg11	A#11	A#12	29.242865
Rg12	A#12	A#13	23.795013
Rg13	A#13	A#14	44.919460
Rg14	A#14	A#15	23.575155
Rg15	A#15	A#16	27.563437
Rg16	A#16	A#17	45.683620
Rg17	A#17	A#18	36.801712
Rg18	A#18	A#19	44.923103
Rg19	A#2	A#20	420.988159
Rg20	A#3	A#21	420.988159
Rg21	A#4	A#22	420.988159
Rg22	A#5	A#23	431.374420
Rg23	A#6	A#24	420.988159
Rg24	A#7	A#25	420.988159
Rg25	A#8	A#26	420.988159
Rg26	A#9	A#27	501.069458
Rg27	A#9	A#28	458.029816
Rg28	A#10	A#29	487.111786
Rg29	A#10	A#30	444.072144
Rg30	A#12	A#31	460.034943
Rg31	A#13	A#32	406.715515
Rg32	A#14	A#33	443.419525
Rg33	A#15	A#34	396.302673
Rg34	A#16	A#35	452.745636
Rg35	A#17	A#36	420.988159
Rg36	A#18	A#37	429.545044
Rg37	A#19	A#38	40.953987
Rg38	A#38	A#39	474.280792
Rg39	A#19	A#40	431.374420
Rg40	A#38	A#41	23.896481
Rg41	A#41	A#42	45.415306
Rg42	A#42	A#43	450.413574
Rg43	A#41	A#44	414.808441
Rg44	A#42	A#45	23.687782
Rg45	A#45	A#46	23.711906
Rg46	A#46	A#47	44.296150
Rg47	A#47	A#48	478.864655
Rg48	A#45	A#49	400.745392
Rg49	A#47	A#50	67.952133
Rg50	A#50	A#51	478.864655
Rg51	A#47	A#52	435.824982
Rg52	A#50	A#53	31.875059
Rg53	A#53	A#54	41.717842
Rg54	A#54	A#55	493.272003
Rg55	A#50	A#56	435.824982
Rg56	A#54	A#57	68.720062
Rg57	A#57	A#58	482.539917
Rg58	A#54	A#59	450.232361
Rg59	A#57	A#60	42.319065
Rg60	A#60	A#61	32.004574
Rg61	A#61	A#62	524.321228
Rg62	A#57	A#63	439.500244
Rg63	A#61	A#64	69.817749
Rg64	A#64	A#65	501.069458
Rg65	A#61	A#66	481.281555
Rg66	A#64	A#67	40.708923
Rg67	A#67	A#68	28.385496
Rg68	A#68	A#69	487.111786
Rg69	A#64	A#70	458.029816
Rg70	A#68	A#71	56.957760
Rg71	A#71	A#72	520.151001
Rg72	A#68	A#73	444.072144
Rg73	A#71	A#74	514.864258
Rf1	Y#1	Y#2	29.087254
Rf2	Y#2	Y#3	112.629433
Rf3	A#67	A#76	167.934540
Rf4	Y#4	Y#5	19.369053
Rf5	Y#5	Y#6	90.527290
Rf6	A#60	A#78	177.490372
Rf7	Y#8	Y#9	14.369054
Rf8	Y#9	Y#10	75.694885
Rf9	Y#7	Y#8	5.000000
Rf10	A#53	A#80	177.490372
Rf11	Y#12	Y#13	18.000223
Rf12	Y#13	Y#14	84.566788
Rf13	Y#11	Y#12	5.000000
Rf14	A#46	A#82	177.490372
Rf15	Y#15	Y#16	83.430237
Rf16	Y#16	Y#17	19.369053
Rf17	A#19	A#84	177.490372
Rf18	Y#18	Y#19	111.285194
Rf19	Y#19	Y#20	19.369053
Rf20	A#16	A#86	177.490372
Rf21	Y#21	Y#22	93.923309
Rf22	Y#22	Y#23	20.018257
Rf23	A#11	A#88	177.490372
Rf24	Y#25	Y#26	19.030769
Rf25	Y#26	Y#27	89.298203
Rf26	Y#24	Y#25	5.000000
Rf27	Y#28	Y#29	41.441216
Rf28	Y#30	Y#31	41.441216
Rf29	Y#32	Y#33	41.441216
Rf30	Y#34	Y#35	31.663431
Rf31	A#5	A#90	16.785089
Rf32	VPWR#1	VPWR#2	100.350525
Rf33	VPWR#2	VPWR#3	65.696381
Rf34	VPWR#3	VPWR#4	23.351625
Rf35	VPWR#4	VPWR#5	45.324123
Rf36	VPWR#5	VPWR#6	62.831711
Rf37	VPWR#6	VPWR#7	72.118324
Rf38	VPWR#7	VPWR#8	68.157890
Rf39	VPWR#8	VPWR#9	68.798325
Rf40	VPWR#9	VPWR#10	65.941528
Rf41	VPWR#10	VPWR#11	38.084301
Rf42	VPWR#11	VPWR#12	27.857231
Rf43	VPWR#12	VPWR#13	65.941528
Rf44	VPWR#13	VPWR#14	68.798325
Rf45	VPWR#14	VPWR#15	99.042503
Rf46	VPWR#2	VPWR#16	38.286041
Rf47	VPWR#3	VPWR#17	38.286041
Rf48	VPWR#5	VPWR#18	48.259808
Rf49	VPWR#6	VPWR#19	38.286041
Rf50	VPWR#7	VPWR#20	43.246067
Rf51	VPWR#8	VPWR#21	48.259808
Rf52	VPWR#9	VPWR#22	67.810089
Rf53	VPWR#10	VPWR#23	67.810089
Rf54	VPWR#12	VPWR#24	67.810089
Rf55	VPWR#13	VPWR#25	67.810089
Rf56	VPWR#14	VPWR#26	48.259808
Rf58	VGND#2	VGND#4	7.822790
Rf59	VGND#4	VGND#5	85.478607
Rf60	VGND#5	VGND#6	64.088837
Rf61	VGND#6	VGND#7	66.645599
Rf62	VGND#7	VGND#8	72.642242
Rf63	VGND#8	VGND#9	41.614250
Rf64	VGND#9	VGND#10	28.522509
Rf65	VGND#10	VGND#11	69.074753
Rf66	VGND#11	VGND#12	66.308029
Rf67	VGND#12	VGND#13	94.774017
Rf68	VGND#5	VGND#14	36.302452
Rf69	VGND#6	VGND#15	38.771423
Rf70	VGND#7	VGND#16	36.302452
Rf71	VGND#8	VGND#17	35.688515
Rf72	VGND#10	VGND#18	41.887741
Rf73	VGND#11	VGND#19	39.171638
Rf74	VGND#12	VGND#20	38.771423
Rf75	VGND#3	VGND#4	2.500000
Re1	A#90	A#88	3.408406
Re2	A#88	A	0.680269
Re3	A	A#86	0.181405
Re4	A#86	A#84	0.761902
Re5	A#84	A#82	0.897955
Re6	A#82	A#80	0.843534
Re7	A#80	A#78	0.879815
Re8	A#78	A#76	10.594106
Re9	Y#35	Y#33	10.594106
Re10	Y#33	Y#31	0.816323
Re11	Y#31	Y#29	0.816323
Re12	Y#29	Y#40	0.843534
Re13	Y#40	Y#41	0.888885
Re14	Y#41	Y	0.385486
Re15	Y	Y#42	0.476189
Re16	Y#42	Y#43	0.816323
Re17	Y#43	Y#44	0.789112
Re18	Y#44	Y#45	0.843534
Re19	Y#45	Y#46	0.816323
Re20	Y#46	Y#2	10.603176
Re21	VPWR#4	VPWR	2.268450
Re22	VPWR	VPWR#11	1.620321
Re23	VGND#2	VGND	2.268450
Re24	VGND	VGND#9	1.620321
Re37	Y#26	Y#40	9.777782
Re38	Y#22	Y#41	9.777782
Re39	Y#19	Y#42	9.777782
Re40	Y#16	Y#43	9.777782
Re41	Y#13	Y#44	9.777782
Re42	Y#9	Y#45	9.777782
Re43	Y#5	Y#46	9.777782
*
*       CAPACITOR CARDS
*
*
C1	Y#33	VPWR#16	9.67782e-17
C2	VPWR#24	A#63	3.44144e-19
C3	VPWR#8	A#44	8.74044e-20
C4	VGND#20	A#68	2.59368e-18
C5	VPWR#25	A#59	3.44144e-19
C6	Y#10	A#54	6.91128e-18
C7	VPWR#8	A#15	1.91679e-20
C8	A#86	A#15	7.13431e-18
C9	VGND#3	VPWR#19	7.07591e-19
C10	VGND#19	A#51	1.80094e-19
C11	VPWR#7	VPWR#6	9.22463e-19
C12	Y#22	A#9	2.02988e-19
C13	VPWR#4	VPWR#7	2.71652e-17
C14	Y#33	Y#32	2.74039e-17
C15	Y#3	A#71	8.64095e-18
C16	A#63	Y#7	2.37318e-17
C17	Y#10	A#55	3.35052e-17
C18	A#21	A#20	4.66635e-17
C19	VPWR#4	VPWR#6	5.6637e-17
C20	A#2	A#1	1.07265e-18
C21	VGND#15	A#15	1.27041e-18
C22	VGND#5	A#27	7.99992e-19
C23	VPWR#15	VPWR#14	1.41623e-19
C24	Y#6	A#61	4.80333e-18
C25	VPWR#5	VPWR#17	2.85135e-19
C26	Y#33	VPWR#17	9.66297e-17
C27	VGND#20	Y#6	3.95284e-17
C28	Y#18	A#17	4.08188e-18
C29	VPWR#24	A#66	1.53981e-19
C30	VPWR#12	A#49	8.1728e-20
C31	A#63	VPWR#25	2.34806e-17
C32	VPWR#24	VPWR#23	1.87864e-18
C33	VGND#10	Y#10	7.34722e-18
C34	VGND#18	A#58	3.18433e-19
C35	VPWR#4	VPWR#5	5.809e-17
C36	Y#19	A#17	1.1916e-17
C37	A#88	VGND#3	2.42916e-19
C38	VGND#19	A#55	4.01266e-19
C39	VPWR#4	VPWR#3	4.06313e-17
C40	Y#4	A#63	1.36969e-18
C41	VPWR#10	A#49	5.14502e-18
C42	VPWR#7	A#15	1.62596e-20
C43	VGND#3	A#9	1.30186e-18
C44	Y#3	A#68	5.62063e-18
C45	A#88	Y#27	3.0239e-17
C46	VGND#5	A#9	1.79677e-20
C47	VPWR#4	VPWR#2	6.09076e-17
C48	Y#10	A#58	2.7283e-17
C49	Y#21	A#13	2.8916e-18
C50	A#66	VPWR#25	2.78589e-17
C51	Y#31	VPWR#17	9.67782e-17
C52	VPWR#26	A#63	1.72497e-19
C53	A#22	A#21	4.754e-17
C54	VGND#14	A#88	1.43032e-17
C55	VPWR#9	A#49	2.85183e-19
C56	Y#3	Y#6	7.18169e-18
C57	VGND#10	A#54	3.16446e-20
C58	Y#6	A#55	4.11923e-19
C59	Y#18	A#15	2.3964e-19
C60	Y#19	A#13	3.65156e-20
C61	VGND#18	A#62	1.44119e-19
C62	Y#31	Y#30	2.74039e-17
C63	A#88	Y#21	1.83061e-17
C64	Y#4	A#66	5.11892e-17
C65	A#88	VGND#5	2.88859e-18
C66	VPWR#14	A#68	3.16553e-20
C67	Y#10	A#47	1.6347e-19
C68	Y#16	A#47	3.84434e-19
C69	A#58	VGND#19	1.06843e-17
C70	Y#31	VPWR#18	7.06167e-17
C71	VPWR#25	A#70	3.44144e-19
C72	VPWR#26	A#66	3.71489e-19
C73	A#5	VPWR#6	3.62687e-19
C74	VGND#3	A#8	6.18214e-18
C75	Y#27	A#9	4.1846e-18
C76	Y#10	A#62	1.84425e-18
C77	A#5	VPWR#5	6.93502e-19
C78	Y#6	A#54	1.41487e-19
C79	Y#3	VGND#20	4.63198e-17
C80	A#5	VPWR#3	3.62687e-19
C81	Y#4	A#70	4.54089e-17
C82	A#23	A#22	4.66635e-17
C83	Y#6	A#58	1.68593e-18
C84	A#90	VPWR#16	5.79366e-18
C85	A#5	VPWR#2	1.1133e-18
C86	VGND#5	A#29	7.94617e-18
C87	VPWR#12	A#52	2.85183e-19
C88	VGND#19	VGND#10	3.30395e-19
C89	VPWR#25	A#73	1.53981e-19
C90	A#62	VGND#19	1.34782e-17
C91	VPWR#26	A#70	1.89174e-17
C92	Y#29	VPWR#18	9.54492e-17
C93	VGND#5	A#11	4.82713e-20
C94	Y#3	A#61	1.38659e-19
C95	Y#22	VGND#15	5.43868e-19
C96	A#82	A#47	8.47635e-18
C97	VGND#12	Y#6	6.81973e-18
C98	VGND#20	A#58	1.86671e-19
C99	VPWR#10	A#52	4.11912e-18
C100	A#90	VPWR#17	4.26709e-18
C101	A#4	A#3	1.08601e-18
C102	Y#29	Y#28	2.74039e-17
C103	Y#16	A#17	4.24199e-20
C104	VGND#3	A#7	5.82825e-18
C105	Y#4	A#73	1.36969e-18
C106	Y#10	A#65	4.57945e-19
C107	VGND#13	VGND#20	2.88697e-18
C108	Y#13	A#61	1.92969e-19
C109	A#62	Y#6	1.56181e-17
C110	Y#29	VPWR#19	9.77828e-17
C111	VPWR#9	A#52	8.1728e-20
C112	A#24	A#23	4.77253e-17
C113	VPWR#26	A#73	4.98453e-17
C114	VPWR#25	VPWR#24	1.87864e-18
C115	VPWR#4	VPWR#1	6.40649e-17
C116	A#90	VPWR#18	3.58299e-18
C117	A#86	Y#21	1.85571e-17
C118	VGND#19	A#65	9.77194e-19
C119	A#73	Y#1	1.70469e-17
C120	VGND#6	A#31	4.20163e-19
C121	VGND#20	A#62	9.88086e-19
C122	VGND#11	Y#6	6.5736e-18
C123	A#11	VPWR#7	2.55965e-19
C124	VGND#15	A#86	2.07411e-17
C125	VPWR#6	VPWR#5	1.20296e-18
C126	VPWR#6	A#11	6.52127e-21
C127	Y#13	A#47	1.29943e-17
C128	VGND#3	A#6	5.82825e-18
C129	VGND#13	Y#3	4.13858e-17
C130	A#86	Y#18	2.58819e-17
C131	VPWR#4	VPWR#16	1.55653e-17
C132	VPWR#26	A#74	2.8063e-18
C133	VPWR#15	A#73	3.0391e-18
C134	A#90	VPWR#19	4.10299e-18
C135	VPWR#13	A#56	8.1728e-20
C136	A#65	Y#6	1.75836e-17
C137	Y#21	A#9	2.29914e-19
C138	A#25	A#24	4.68222e-17
C139	Y#3	A#62	4.03691e-19
C140	A#80	A#61	1.8092e-22
C141	A#74	Y#1	2.48908e-17
C142	VGND#5	A#31	7.27543e-18
C143	VGND#19	A#69	1.8342e-19
C144	VPWR#12	A#56	2.76491e-18
C145	VPWR#4	VPWR#17	1.5341e-17
C146	A#9	A#26	2.85791e-19
C147	VGND#20	A#65	7.96442e-18
C148	VPWR#15	A#74	5.56111e-17
C149	A#80	A#54	8.63078e-18
C150	VPWR#7	A#13	3.80408e-21
C151	VPWR#10	A#56	2.85183e-19
C152	Y#26	VPWR#19	1.09162e-16
C153	A#3	A#2	1.08601e-18
C154	Y#19	Y#18	3.54031e-19
C155	VGND#3	A#4	6.09189e-18
C156	Y#6	A#69	1.81218e-18
C157	A#80	A#47	2.77949e-19
C158	A#86	VGND#7	2.27162e-19
C159	Y#26	Y#24	2.83737e-17
C160	Y#9	A#68	2.21798e-19
C161	A#26	A#25	4.75314e-17
C162	Y#3	A#65	1.76789e-18
C163	VGND#6	A#86	2.06661e-18
C164	Y#26	VPWR#20	8.27168e-17
C165	Y#4	VPWR#25	5.56214e-17
C166	Y#9	A#61	1.39968e-17
C167	VGND#20	A#69	2.46368e-17
C168	A#16	VPWR#8	2.34227e-19
C169	Y#22	VPWR#8	1.17369e-18
C170	A#86	VGND#5	3.09759e-20
C171	VPWR#14	A#61	6.43325e-21
C172	VPWR#4	VPWR#19	1.56389e-17
C173	VGND#6	A#33	2.30721e-18
C174	Y#22	VPWR#7	1.12565e-18
C175	Y#6	A#72	7.01766e-19
C176	Y#9	A#54	1.23275e-17
C177	A#84	Y#18	2.21114e-17
C178	VGND#3	A#3	9.21189e-19
C179	VPWR#13	A#59	2.85183e-19
C180	A#69	Y#3	1.39117e-17
C181	A#28	A#26	4.65788e-17
C182	VGND#16	A#84	1.65866e-17
C183	VPWR#4	VPWR#20	5.37361e-18
C184	VPWR#26	VPWR#25	1.94092e-18
C185	Y#9	A#47	2.13381e-19
C186	VGND#12	VGND#11	1.93683e-18
C187	A#78	A#68	2.49579e-19
C188	A#84	Y#15	2.08282e-17
C189	VGND#5	A#33	4.53098e-19
C190	VGND#20	A#72	1.66276e-18
C191	VPWR#12	A#59	1.00568e-17
C192	VPWR#7	VPWR#19	3.1233e-19
C193	VGND#13	A#69	2.13505e-18
C194	A#78	A#61	2.20713e-17
C195	VPWR#10	A#59	8.1728e-20
C196	VPWR#13	A#61	7.75645e-20
C197	VPWR#26	Y#4	5.66781e-17
C198	A#72	Y#3	1.80295e-17
C199	VGND#3	A#2	6.51353e-19
C200	VGND#12	Y#3	1.03635e-17
C201	A#30	A#28	3.67525e-17
C202	A#78	A#54	2.40023e-19
C203	VGND#7	A#35	3.50412e-19
C204	A#36	A#17	2.18508e-19
C205	Y#5	A#71	3.91142e-20
C206	A#19	VPWR#9	3.18742e-19
C207	VGND#13	A#72	3.32416e-17
C208	Y#5	A#68	1.07578e-17
C209	VPWR#5	VPWR#3	9.84578e-19
C210	VPWR#14	A#63	8.74044e-20
C211	A#88	VPWR#20	6.62644e-18
C212	VGND#6	A#35	4.55154e-18
C213	Y#5	A#61	1.12662e-17
C214	A#32	A#30	3.80582e-17
C215	VPWR#13	A#63	9.56153e-18
C216	VPWR#19	VPWR#5	6.61283e-20
C217	A#82	Y#15	2.80442e-17
C218	Y#1	VPWR#26	5.46023e-17
C219	VPWR#16	VPWR#1	2.06271e-18
C220	VGND#5	A#35	1.79201e-19
C221	VPWR#12	A#63	2.85183e-19
C222	VGND#8	A#46	4.29079e-20
C223	VGND#17	A#82	1.80964e-17
C224	VGND#7	A#46	4.7108e-20
C225	Y#22	VPWR#20	5.40516e-17
C226	A#76	A#71	4.75956e-19
C227	A#82	Y#14	2.95112e-17
C228	A#76	A#68	1.90942e-17
C229	Y#22	Y#23	2.15534e-18
C230	A#34	A#32	4.70481e-17
C231	A#84	VGND#8	1.85438e-20
C232	VPWR#15	VPWR#26	2.66815e-18
C233	VGND#3	Y#27	4.16627e-17
C234	VGND#13	VGND#12	2.46552e-18
C235	VPWR#21	Y#22	2.81256e-17
C236	A#76	A#61	2.65002e-19
C237	VGND#7	A#37	4.82038e-18
C238	A#84	VGND#7	2.46166e-18
C239	Y#19	VPWR#9	1.7048e-18
C240	A#46	VPWR#10	3.7999e-19
C241	VPWR#9	A#46	3.99361e-20
C242	VPWR#8	A#46	2.55131e-20
C243	Y#19	VPWR#8	9.75554e-19
C244	VPWR#14	VPWR#13	6.99578e-19
C245	VPWR#8	VPWR#20	4.42235e-20
C246	VPWR#15	Y#1	6.09904e-17
C247	VPWR#14	A#66	3.00302e-19
C248	A#36	A#34	3.81778e-17
C249	VPWR#1	A#1	5.56386e-17
C250	VGND#6	A#37	5.02058e-19
C251	Y#2	A#71	1.16488e-17
C252	A#86	VPWR#21	4.87642e-18
C253	VGND#14	VGND#3	3.54836e-18
C254	Y#2	A#68	8.67625e-18
C255	VPWR#13	A#66	7.40145e-18
C256	VPWR#2	A#20	4.2123e-18
C257	A#1	Y#34	6.26508e-18
C258	VPWR#12	A#66	8.1728e-20
C259	VGND#11	VGND#10	1.76189e-18
C260	A#80	Y#14	2.96862e-17
C261	A#40	A#36	4.5523e-17
C262	Y#19	VPWR#21	3.38605e-17
C263	VPWR#1	A#20	3.16746e-18
C264	VGND#18	A#80	1.33042e-17
C265	VPWR#13	A#54	2.41247e-21
C266	VPWR#16	A#1	3.26202e-18
C267	Y#19	Y#20	4.50375e-19
C268	A#80	Y#10	3.10758e-17
C269	VGND#14	Y#27	4.71851e-17
C270	Y#19	VPWR#22	3.5565e-17
C271	A#20	Y#34	1.25302e-17
C272	A#53	VPWR#12	2.82521e-19
C273	VPWR#11	A#68	4.75714e-20
C274	VGND#7	A#39	9.03144e-18
C275	A#44	A#40	4.78268e-17
C276	VPWR#11	A#61	1.42762e-19
C277	VPWR#3	VPWR#2	1.22166e-18
C278	Y#23	VPWR#8	8.40339e-18
C279	VPWR#14	A#70	9.39682e-18
C280	VPWR#16	A#20	6.50658e-17
C281	VPWR#17	VPWR#16	2.06267e-18
C282	VPWR#6	A#9	2.78774e-20
C283	VPWR#11	A#54	4.79373e-23
C284	VGND#6	A#39	2.06892e-19
C285	A#84	VPWR#22	6.21278e-18
C286	Y#35	A#1	2.05805e-17
C287	VPWR#12	A#54	1.98359e-20
C288	Y#21	Y#27	6.85381e-18
C289	VPWR#13	A#70	2.85183e-19
C290	VGND#10	A#43	2.15287e-19
C291	VPWR#11	A#47	2.01073e-20
C292	VPWR#2	A#21	4.2123e-18
C293	Y#35	A#20	1.82772e-17
C294	VGND#9	A#71	8.09535e-20
C295	A#49	A#44	4.61838e-17
C296	Y#23	VPWR#7	8.58074e-18
C297	A#29	A#27	3.42353e-17
C298	VGND#9	A#68	4.05981e-22
C299	VPWR#16	A#21	5.69866e-17
C300	Y#16	VPWR#22	4.96386e-17
C301	VGND#8	A#43	2.75565e-18
C302	VGND#9	A#61	4.05981e-22
C303	A#78	Y#10	3.12818e-17
C304	Y#16	Y#17	3.36677e-19
C305	VPWR#11	A#17	2.8903e-19
C306	Y#21	VGND#14	4.24541e-17
C307	VGND#19	A#78	1.55334e-17
C308	Y#16	VPWR#10	1.13247e-18
C309	Y#16	VPWR#23	3.5428e-17
C310	Y#33	A#21	1.82772e-17
C311	A#82	VGND#8	1.71794e-18
C312	A#21	Y#32	6.26508e-18
C313	A#60	VPWR#13	3.54963e-19
C314	A#52	A#49	4.78192e-17
C315	VPWR#11	A#15	4.79373e-23
C316	A#78	Y#6	2.88029e-17
C317	Y#16	VPWR#9	1.52778e-18
C318	VGND#9	A#47	4.23715e-20
C319	VGND#7	A#43	3.74908e-19
C320	Y#33	A#22	1.82772e-17
C321	VPWR#16	A#22	2.65268e-18
C322	VPWR#3	A#22	4.2123e-18
C323	VPWR#13	VPWR#12	6.93111e-19
C324	VPWR#17	A#21	2.65268e-18
C325	A#31	A#29	3.44313e-17
C326	VPWR#14	A#73	6.35729e-18
C327	VPWR#6	A#8	2.0379e-20
C328	A#82	VPWR#23	2.89889e-18
C329	A#56	A#52	4.73065e-17
C330	A#22	Y#32	1.25302e-17
C331	VGND#15	VGND#14	2.65029e-18
C332	A#90	A#1	5.56723e-18
C333	VPWR#13	A#73	8.1728e-20
C334	VGND#9	A#17	1.55667e-19
C335	VGND#10	A#48	4.75574e-19
C336	Y#31	A#23	1.84716e-17
C337	VGND#9	A#15	1.21794e-20
C338	VPWR#17	A#22	6.50658e-17
C339	Y#31	A#24	1.97552e-17
C340	VGND#9	A#13	4.01921e-20
C341	Y#13	VPWR#23	9.37141e-17
C342	VGND#10	VGND#8	1.35918e-18
C343	A#59	A#56	4.7822e-17
C344	Y#20	VPWR#9	8.5101e-18
C345	VGND#8	A#48	2.78278e-18
C346	Y#13	Y#11	4.95029e-18
C347	Y#31	A#25	3.20172e-18
C348	A#17	A#15	8.48067e-18
C349	Y#13	VPWR#24	7.32467e-17
C350	VGND#15	Y#21	4.42221e-17
C351	VPWR#5	A#23	2.93116e-19
C352	A#33	A#31	3.40962e-17
C353	A#76	Y#6	2.88303e-17
C354	VPWR#4	A#1	4.20854e-18
C355	VPWR#18	VPWR#17	2.35578e-18
C356	VGND#20	A#76	1.37925e-17
C357	VPWR#17	A#23	5.74759e-17
C358	Y#29	A#25	1.82772e-17
C359	VGND#5	VGND#3	2.03755e-18
C360	Y#3	A#76	3.19038e-17
C361	VGND#7	A#48	1.72056e-19
C362	VPWR#4	A#20	1.1331e-18
C363	A#63	A#59	4.62127e-17
C364	Y#20	VPWR#8	8.4779e-18
C365	A#74	A#68	2.32984e-19
C366	VGND#11	A#51	1.90211e-19
C367	Y#29	A#26	1.82772e-17
C368	VPWR#4	A#21	1.20262e-18
C369	A#80	VPWR#24	2.89889e-18
C370	Y#26	A#23	1.53004e-19
C371	VPWR#14	A#74	6.52765e-19
C372	A#23	Y#30	6.26508e-18
C373	VPWR#4	A#22	1.20262e-18
C374	Y#18	Y#21	7.35653e-18
C375	Y#26	A#24	1.94181e-19
C376	A#5	A#9	6.06737e-18
C377	Y#2	VGND#20	6.04319e-19
C378	VPWR#17	A#24	2.68538e-18
C379	A#5	A#8	1.37964e-17
C380	VPWR#4	A#23	6.04685e-18
C381	VGND#10	A#51	3.04758e-18
C382	Y#2	Y#3	2.53363e-18
C383	A#66	A#63	4.78193e-17
C384	Y#26	A#25	3.54932e-19
C385	A#5	A#7	1.29751e-17
C386	A#35	A#33	3.48488e-17
C387	VPWR#18	A#23	3.60255e-18
C388	VGND#9	Y#21	1.4182e-17
C389	A#5	A#6	1.48231e-17
C390	Y#9	VPWR#24	9.47965e-17
C391	VPWR#4	A#24	3.07205e-18
C392	A#5	A#4	1.40626e-17
C393	Y#26	A#26	7.70233e-19
C394	Y#9	Y#7	1.20428e-18
C395	VGND#9	Y#18	1.53918e-17
C396	A#24	Y#30	1.25302e-17
C397	A#5	A#3	1.29134e-17
C398	A#11	A#13	1.33044e-17
C399	VPWR#5	A#7	2.01073e-20
C400	VPWR#4	A#25	1.20273e-18
C401	Y#13	VPWR#12	2.83269e-19
C402	Y#9	VPWR#25	9.37659e-17
C403	A#5	A#2	1.50541e-17
C404	Y#26	A#28	2.20034e-17
C405	VGND#9	Y#15	1.52193e-17
C406	VGND#3	A#5	5.82825e-18
C407	VPWR#5	A#24	5.84566e-18
C408	Y#18	VGND#15	4.17168e-17
C409	A#70	A#66	4.62005e-17
C410	VPWR#17	A#25	3.06214e-19
C411	Y#13	VPWR#10	6.17194e-19
C412	A#80	VGND#10	1.88793e-18
C413	VPWR#4	A#26	1.20454e-18
C414	A#27	VGND#3	1.85056e-17
C415	A#11	A#9	9.22692e-18
C416	VPWR#18	A#24	1.93664e-17
C417	Y#26	A#30	2.19762e-17
C418	VGND#9	Y#14	3.01344e-17
C419	VPWR#4	A#28	1.49726e-18
C420	VGND#5	Y#27	7.67327e-18
C421	Y#26	A#32	1.43691e-18
C422	VGND#9	Y#10	1.6485e-17
C423	A#16	A#17	1.00933e-17
C424	A#78	VPWR#25	2.89889e-18
C425	A#37	A#35	3.33085e-17
C426	VPWR#12	VPWR#10	6.93111e-19
C427	A#16	A#15	5.62302e-18
C428	VPWR#4	A#30	1.16971e-18
C429	VGND#11	A#55	4.23809e-19
C430	A#73	A#70	4.67384e-17
C431	A#27	Y#27	2.21789e-17
C432	VGND#9	Y#6	1.53587e-17
C433	VGND#16	VGND#15	2.51964e-18
C434	Y#17	VPWR#10	8.52757e-18
C435	VPWR#18	A#25	5.08592e-17
C436	A#71	A#68	9.24815e-18
C437	VGND#9	Y#3	1.42069e-17
C438	VGND#3	A#29	1.88171e-18
C439	Y#27	A#11	3.30815e-18
C440	VGND#9	VGND#13	5.54592e-17
C441	VGND#14	A#11	2.9126e-18
C442	A#15	A#13	9.52352e-18
C443	Y#5	VPWR#25	4.02551e-17
C444	VGND#10	A#55	9.33426e-18
C445	Y#21	A#11	2.98966e-19
C446	VGND#6	VGND#14	2.00563e-19
C447	VGND#14	A#27	2.07861e-18
C448	Y#5	Y#4	5.03183e-19
C449	A#74	A#73	4.81397e-17
C450	A#25	Y#28	6.26508e-18
C451	VPWR#19	VPWR#18	2.66815e-18
C452	Y#5	VPWR#26	4.03069e-17
C453	Y#17	VPWR#9	8.4779e-18
C454	VGND#8	VGND#7	1.37848e-18
C455	A#29	Y#27	1.74271e-17
C456	VPWR#18	A#26	2.15714e-18
C457	A#39	A#37	2.00848e-17
C458	VPWR#11	VPWR#20	6.52709e-18
C459	VPWR#5	A#25	7.24527e-18
C460	VGND#16	Y#18	4.72174e-17
C461	VPWR#19	A#25	2.64756e-18
C462	Y#22	A#30	3.98846e-19
C463	VPWR#11	Y#23	1.75595e-17
C464	Y#21	A#27	6.3935e-19
C465	A#46	A#47	9.7838e-18
C466	VGND#12	A#58	1.89782e-19
C467	Y#22	A#32	8.79196e-18
C468	A#26	Y#28	1.25302e-17
C469	A#76	VPWR#26	4.86481e-18
C470	VPWR#11	Y#20	1.87385e-17
C471	VGND#14	A#29	2.90329e-17
C472	A#5	VPWR#16	4.04403e-17
C473	Y#22	A#34	1.2674e-17
C474	VPWR#11	Y#17	1.77995e-17
C475	VGND#9	VPWR#20	1.0936e-18
C476	A#5	VPWR#17	4.18326e-17
C477	A#46	A#17	9.27615e-18
C478	VPWR#19	A#26	6.53696e-17
C479	Y#22	A#36	5.15576e-19
C480	Y#27	A#31	1.95503e-18
C481	VGND#11	A#58	1.02589e-17
C482	Y#15	Y#18	6.61833e-18
C483	A#5	VPWR#18	3.38391e-17
C484	Y#2	VPWR#26	4.31109e-17
C485	Y#21	A#29	8.30111e-19
C486	A#43	A#39	3.33771e-17
C487	Y#2	Y#1	6.28143e-18
C488	VGND#7	A#17	3.26287e-20
C489	A#53	A#54	9.30631e-18
C490	A#5	VPWR#19	3.01722e-17
C491	VGND#9	VPWR#22	1.43241e-18
C492	VPWR#15	Y#2	3.8611e-17
C493	A#53	A#47	9.50124e-18
C494	VGND#10	A#58	4.58544e-19
C495	Y#19	A#34	4.51256e-19
C496	VPWR#6	A#26	4.2123e-18
C497	VGND#14	A#31	2.23735e-17
C498	VGND#6	Y#21	5.7616e-18
C499	VPWR#11	Y#4	1.80852e-17
C500	VPWR#19	A#28	5.66176e-17
C501	Y#19	A#36	1.20792e-17
C502	Y#9	VPWR#13	1.06023e-17
C503	Y#27	A#33	4.53683e-19
C504	Y#9	VPWR#12	1.01427e-17
C505	VPWR#11	Y#1	1.4242e-17
C506	Y#15	VGND#16	3.10707e-17
C507	Y#19	A#40	1.30252e-17
C508	VPWR#5	A#26	3.95329e-19
C509	VPWR#11	VPWR#15	6.3251e-17
C510	A#78	VGND#11	3.93634e-18
C511	A#28	Y#24	6.83442e-18
C512	A#31	Y#21	1.39984e-17
C513	Y#19	A#44	6.68799e-19
C514	A#60	A#61	1.62508e-17
C515	A#11	Y#24	3.35677e-19
C516	A#78	VGND#10	2.93456e-20
C517	VGND#6	A#17	7.78177e-20
C518	A#11	VPWR#20	2.38968e-17
C519	VGND#12	A#62	4.36925e-19
C520	Y#21	A#46	1.75525e-19
C521	A#48	A#43	1.96356e-17
C522	VPWR#19	A#30	2.42144e-18
C523	VGND#14	A#33	1.16851e-18
C524	A#90	Y#35	2.81889e-17
C525	VGND#5	Y#21	6.07152e-18
C526	Y#16	A#36	1.7861e-19
C527	VPWR#20	A#28	2.30661e-18
C528	Y#18	A#46	4.36165e-18
C529	VPWR#10	VPWR#9	6.93111e-19
C530	VGND#16	A#46	4.86094e-18
C531	VGND#9	VPWR#15	6.02544e-18
C532	A#68	A#61	9.50553e-18
C533	VPWR#3	A#4	2.0379e-20
C534	VPWR#20	VPWR#19	1.46112e-18
C535	Y#15	A#46	8.203e-18
C536	Y#16	A#40	1.17288e-18
C537	A#90	Y#33	4.15868e-17
C538	VGND#15	A#31	1.20291e-18
C539	VGND#17	A#46	4.1933e-18
C540	VGND#17	VGND#16	2.50833e-18
C541	A#30	Y#24	1.37684e-17
C542	VGND#11	A#62	1.13727e-17
C543	Y#14	A#46	4.1494e-19
C544	Y#16	A#44	1.43648e-17
C545	A#90	Y#31	4.09836e-17
C546	Y#21	A#33	1.71147e-17
C547	VGND#9	A#31	4.524e-18
C548	Y#35	VPWR#4	2.64731e-17
C549	VGND#12	A#71	5.76574e-20
C550	Y#16	A#49	1.34615e-17
C551	VPWR#19	A#32	2.77397e-19
C552	VGND#9	A#33	6.7314e-18
C553	A#67	A#68	1.55488e-17
C554	A#30	VPWR#20	3.23152e-17
C555	A#90	Y#29	4.15857e-17
C556	A#16	VPWR#21	2.54556e-17
C557	VGND#9	A#35	4.524e-18
C558	Y#33	VPWR#4	3.09814e-17
C559	VPWR#6	A#28	4.60001e-18
C560	Y#16	A#52	7.06017e-19
C561	Y#18	A#31	1.56773e-19
C562	VGND#14	A#35	2.13539e-19
C563	VGND#10	A#62	2.07532e-19
C564	VGND#9	A#37	8.87321e-18
C565	A#51	A#48	3.33366e-17
C566	VGND#9	A#39	8.18608e-18
C567	Y#31	VPWR#4	4.34999e-17
C568	VGND#15	A#33	1.02527e-17
C569	Y#23	A#30	1.06766e-18
C570	VGND#9	A#43	8.18608e-18
C571	Y#13	A#44	3.62962e-20
C572	VGND#17	Y#15	4.74567e-17
C573	Y#14	A#53	5.51338e-18
C574	VGND#7	VGND#6	1.81361e-18
C575	A#90	Y#26	2.40544e-17
C576	VGND#9	A#48	1.1114e-17
C577	Y#29	VPWR#4	3.08461e-17
C578	VGND#18	A#53	5.52277e-18
C579	Y#13	A#49	1.95325e-18
C580	Y#10	A#53	5.31391e-19
C581	Y#35	VPWR#2	1.26249e-17
C582	VGND#9	A#51	1.4634e-17
C583	Y#21	A#35	2.10144e-18
C584	A#32	VPWR#20	3.74812e-17
C585	Y#13	A#52	3.99499e-17
C586	VGND#9	A#55	9.08364e-18
C587	VPWR#21	A#30	1.77028e-19
C588	A#19	VPWR#22	1.10995e-17
C589	VGND#6	A#15	1.60904e-20
C590	VGND#9	A#58	9.08364e-18
C591	Y#18	A#33	4.95809e-19
C592	Y#13	A#56	2.28229e-17
C593	VGND#12	A#65	8.49701e-18
C594	VPWR#8	A#30	9.02394e-20
C595	VGND#9	A#62	6.89104e-18
C596	Y#26	VPWR#4	3.5161e-17
C597	A#32	Y#23	1.61528e-17
C598	VGND#7	Y#18	6.1996e-18
C599	Y#13	A#59	3.66735e-18
C600	VGND#9	A#65	6.89104e-18
C601	VGND#15	A#35	2.39696e-17
C602	Y#14	Y#15	7.65575e-18
C603	A#55	A#51	2.57238e-17
C604	VGND#9	A#69	5.06382e-18
C605	Y#13	A#63	3.30389e-20
C606	VPWR#7	A#30	3.9832e-18
C607	VGND#9	A#72	5.46859e-18
C608	VPWR#20	A#34	2.3042e-18
C609	VGND#11	A#65	4.2765e-19
C610	A#46	Y#20	2.31756e-19
C611	Y#9	A#52	3.66238e-20
C612	VPWR#21	A#32	4.05029e-19
C613	A#88	Y#26	4.35065e-17
C614	Y#21	A#37	5.14215e-19
C615	VPWR#22	A#46	5.14742e-18
C616	Y#23	VPWR#20	6.24143e-17
C617	A#46	Y#17	4.47559e-19
C618	Y#9	A#56	2.03785e-18
C619	VGND#12	A#68	7.18707e-20
C620	A#46	VPWR#23	1.98075e-17
C621	Y#22	Y#26	4.37783e-18
C622	Y#23	A#34	4.49795e-17
C623	Y#18	A#35	1.0489e-17
C624	Y#9	A#59	4.10282e-17
C625	Y#5	VPWR#14	1.95992e-18
C626	Y#9	A#63	3.35847e-17
C627	VGND#6	Y#18	6.74395e-18
C628	Y#22	VPWR#4	7.93856e-20
C629	Y#5	VPWR#13	1.68069e-18
C630	Y#33	VPWR#3	6.75818e-18
C631	VPWR#2	A#3	2.01073e-20
C632	Y#14	VGND#17	4.76726e-17
C633	VGND#15	A#37	1.12793e-18
C634	VPWR#20	A#36	2.80367e-19
C635	A#5	A#1	9.68677e-18
C636	Y#9	A#66	2.01695e-18
C637	A#34	VPWR#21	2.7419e-17
C638	VPWR#21	VPWR#20	2.22678e-18
C639	A#58	A#55	3.23831e-17
C640	Y#9	A#70	3.8112e-20
C641	Y#33	VPWR#2	6.59427e-18
C642	VGND#16	A#35	4.17557e-19
C643	A#76	VGND#12	1.81837e-18
C644	A#88	Y#22	3.0411e-17
C645	A#53	Y#11	2.39747e-19
C646	VPWR#11	A#32	1.93078e-18
C647	Y#23	A#36	1.07893e-18
C648	A#76	VGND#11	3.01337e-20
C649	A#53	VPWR#24	1.94484e-17
C650	Y#20	A#34	1.22308e-18
C651	VPWR#11	A#34	1.91929e-18
C652	Y#5	A#63	6.44426e-19
C653	Y#18	A#37	2.75689e-17
C654	VPWR#8	A#32	3.36474e-19
C655	VGND#11	A#68	1.6895e-20
C656	VPWR#11	A#36	2.53151e-18
C657	Y#5	A#66	1.45032e-17
C658	VGND#12	A#69	7.76536e-18
C659	VPWR#11	A#40	1.5582e-18
C660	A#36	VPWR#21	3.25084e-17
C661	VPWR#9	VPWR#8	6.99578e-19
C662	VPWR#16	A#3	1.87972e-18
C663	A#86	Y#22	3.92708e-17
C664	VGND#18	VGND#17	1.82554e-18
C665	Y#5	A#70	1.13479e-17
C666	VPWR#22	A#34	1.54166e-19
C667	VGND#15	A#39	2.11464e-19
C668	VPWR#21	Y#23	6.52537e-17
C669	VPWR#11	A#44	2.28509e-18
C670	Y#5	A#73	5.41776e-19
C671	VPWR#7	A#32	1.84729e-18
C672	Y#35	A#2	3.67028e-18
C673	VPWR#11	A#49	1.65427e-18
C674	Y#19	Y#22	2.53461e-18
C675	A#37	VGND#16	1.34019e-17
C676	Y#20	A#36	5.26289e-17
C677	VPWR#11	A#52	4.66536e-18
C678	VGND#11	A#69	1.86477e-19
C679	A#62	A#58	2.57097e-17
C680	A#60	VPWR#25	1.36671e-17
C681	A#86	Y#19	2.26918e-17
C682	VPWR#11	A#56	6.61601e-18
C683	Y#33	A#4	1.77594e-18
C684	Y#31	VPWR#5	1.0389e-18
C685	Y#18	A#39	1.16779e-18
C686	VPWR#11	A#59	1.74589e-18
C687	VPWR#21	A#40	3.71489e-19
C688	VPWR#22	A#36	3.44144e-19
C689	VPWR#11	A#63	1.83016e-18
C690	VPWR#16	A#2	1.85466e-18
C691	Y	A#17	6.68204e-19
C692	A#61	A#54	9.47948e-18
C693	Y#2	A#73	1.00198e-17
C694	Y#33	A#3	1.75226e-18
C695	VGND#18	Y#14	3.52389e-17
C696	A#84	Y#19	4.08833e-17
C697	Y#15	A#37	1.69023e-18
C698	VPWR#11	A#66	1.50858e-18
C699	VGND#16	VGND#6	1.90675e-19
C700	VPWR#2	A#2	4.21166e-20
C701	Y#2	A#74	1.52422e-17
C702	VPWR#11	A#70	1.83054e-18
C703	VGND#8	Y#15	7.61572e-18
C704	Y#20	A#40	4.5563e-17
C705	VPWR#17	A#4	1.85466e-18
C706	Y#16	Y#19	3.65811e-18
C707	VPWR#11	A#73	1.60099e-18
C708	VPWR#9	A#34	7.86402e-20
C709	A#39	VGND#16	1.71576e-17
C710	VGND#13	VPWR#15	8.46125e-18
C711	VGND#12	VNB	3.4278e-17
C712	VGND#6	VGND#5	1.97243e-18
C713	A#67	VPWR#26	1.81849e-17
C714	Y#31	A#6	1.77594e-18
C715	VGND#11	VNB	3.18077e-17
C716	VGND#10	VNB	2.41105e-17
C717	A#15	Y#23	4.31576e-19
C718	VGND#8	VNB	2.74964e-17
C719	VPWR#11	A#74	4.16209e-18
C720	A#84	Y#16	2.79844e-17
C721	VGND#7	VNB	3.17457e-17
C722	VGND#6	VNB	2.83779e-17
C723	VGND#5	VNB	2.9997e-17
C724	VPWR#21	A#44	1.72497e-19
C725	VPWR#14	VNB	3.1367e-17
C726	A#40	VPWR#22	2.20294e-17
C727	VPWR#13	VNB	2.73569e-17
C728	VGND#17	A#37	3.82458e-19
C729	Y#20	VPWR#21	5.77178e-17
C730	VPWR#12	VNB	1.94987e-17
C731	VPWR#18	A#7	1.87972e-18
C732	A#65	A#62	3.41975e-17
C733	VPWR#10	VNB	2.08582e-17
C734	Y#18	A#43	3.72699e-19
C735	VPWR#9	VNB	2.66702e-17
C736	VPWR#8	VNB	2.92828e-17
C737	VPWR#7	VNB	3.00201e-17
C738	VPWR#21	A#17	4.8551e-18
C739	VPWR#6	VNB	2.94445e-17
C740	VPWR#8	A#34	5.68853e-18
C741	VPWR#5	VNB	2.2278e-17
C742	VPWR#3	VNB	2.02792e-17
C743	Y#29	A#8	1.77594e-18
C744	VPWR#2	VNB	3.11572e-17
C745	VGND#6	A#13	1.70025e-20
C746	A#82	Y#16	4.09333e-17
C747	VPWR#20	A#13	8.51274e-19
C748	Y#10	Y#14	7.59931e-18
C749	Y#20	A#44	1.3947e-18
C750	Y#15	A#39	1.30262e-17
C751	VGND#12	A#72	4.32747e-18
C752	Y#17	A#40	1.3713e-18
C753	Y#13	Y#16	4.0738e-18
C754	VGND#7	Y#15	5.1481e-18
C755	Y#29	A#7	1.75226e-18
C756	VPWR#19	A#9	1.06517e-18
C757	Y#4	VPWR#14	8.52757e-18
C758	VPWR#2	VPWR#1	1.22366e-18
C759	VGND#10	VGND#17	9.91659e-19
C760	VGND#16	A#43	2.18049e-18
C761	A#82	Y#13	2.92891e-17
C762	Y#29	VPWR#6	6.64682e-18
C763	A#44	VPWR#22	2.88105e-17
C764	A#5	Y#35	3.05862e-17
C765	A#61	Y#7	2.07781e-19
C766	VPWR#22	VPWR#21	1.94092e-18
C767	A#9	A#8	1.08601e-18
C768	VPWR#23	A#40	1.53981e-19
C769	VPWR#18	A#6	1.85466e-18
C770	A#46	A#40	1.43373e-19
C771	A#5	Y#33	4.07538e-17
C772	VGND#17	A#39	8.30444e-19
C773	A#90	A#9	1.16168e-17
C774	Y#29	VPWR#5	6.59427e-18
C775	A#5	Y#31	4.37011e-17
C776	A#80	Y#13	3.10709e-17
C777	Y#17	A#44	5.217e-17
C778	A#69	A#65	3.47559e-17
C779	A#5	Y#29	4.03279e-17
C780	Y#26	A#13	1.3762e-19
C781	Y#10	VGND#18	3.97564e-17
C782	A#90	A#8	9.37078e-18
C783	Y#15	A#43	2.79062e-17
C784	A#90	A#5	1.05718e-16
C785	Y#9	Y#13	4.09437e-18
C786	Y#4	VPWR#13	8.44243e-18
C787	Y#2	VPWR#14	2.02123e-18
C788	VGND#5	A#13	6.51227e-20
C789	A#47	Y#11	2.36551e-19
C790	VPWR#19	A#8	2.6692e-18
C791	Y	VPWR#21	3.51449e-17
C792	A#13	Y#23	4.47528e-20
C793	Y#26	A#5	2.08693e-17
C794	Y#22	VPWR#11	1.62439e-17
C795	A#80	Y#9	3.28911e-17
C796	VPWR#22	A#49	3.44144e-19
C797	A#90	A#7	8.73828e-18
C798	VPWR#22	Y#20	5.6783e-17
C799	A#5	VPWR#4	1.12465e-17
C800	VGND#9	A#88	1.04402e-17
C801	VPWR#23	A#44	3.44144e-19
C802	A#9	Y#24	3.3245e-19
C803	A#90	A#11	2.68958e-19
C804	VGND#16	A#48	2.07086e-19
C805	VPWR#9	A#36	2.85183e-19
C806	VGND#9	Y#22	8.17421e-19
C807	Y#26	A#11	4.33943e-17
C808	Y#19	VPWR#11	1.60318e-17
C809	A#68	Y#4	1.59832e-19
C810	VPWR#4	A#11	7.68665e-19
C811	VGND#9	A#86	2.57333e-17
C812	A#90	A#6	8.73828e-18
C813	A#78	Y#9	2.9841e-17
C814	A#43	VGND#17	1.56856e-17
C815	Y#17	A#49	4.52163e-17
C816	VGND#9	Y#19	2.76579e-19
C817	VPWR#25	A#61	6.14042e-18
C818	Y#16	VPWR#11	1.7256e-17
C819	Y#26	A#9	1.35914e-17
C820	Y#5	Y#9	4.01867e-18
C821	A#88	A#11	2.44222e-17
C822	VGND#9	A#84	2.21968e-17
C823	VPWR#8	A#36	4.59393e-18
C824	A#90	A#4	7.97217e-18
C825	VGND#19	VGND#18	1.76998e-18
C826	Y#22	A#11	2.15595e-17
C827	A#54	Y#7	2.68547e-19
C828	A#78	Y#5	3.63215e-17
C829	Y#15	A#48	1.20805e-18
C830	VGND#9	Y#16	9.51757e-19
C831	VPWR#22	A#52	1.53981e-19
C832	A#72	A#69	3.41391e-17
C833	VPWR#8	VPWR#7	1.2742e-18
C834	Y#26	A#8	1.50972e-19
C835	A#49	VPWR#23	2.20294e-17
C836	A#71	VNB	5.70466e-17
C837	Y#13	VPWR#11	4.87492e-17
C838	A#68	VNB	7.14847e-17
C839	VGND#11	A#61	6.91889e-20
C840	VGND#9	A#82	2.34995e-17
C841	A#61	VNB	7.73699e-17
C842	Y#10	A#68	1.57294e-19
C843	A#90	A#3	4.69145e-18
C844	A#54	VNB	2.60161e-17
C845	A#16	Y#22	2.98768e-17
C846	A#47	VNB	2.80488e-17
C847	Y#14	A#43	1.20805e-18
C848	VGND#17	VGND#7	3.80789e-19
C849	A#86	A#16	9.7189e-18
C850	A#76	Y#5	2.79269e-17
C851	Y#26	A#7	8.42964e-20
C852	Y#9	VPWR#11	3.59669e-17
C853	A#17	VNB	4.12313e-17
C854	Y#17	A#52	1.3713e-18
C855	A#15	VNB	2.70957e-17
C856	VGND#9	A#80	2.74627e-17
C857	Y#19	A#16	2.69808e-17
C858	A#13	VNB	2.77518e-17
C859	A#90	A#2	5.53702e-18
C860	Y#2	Y#5	2.35628e-18
C861	A#9	VNB	3.86953e-17
C862	A#8	VNB	3.44712e-17
C863	A#7	VNB	3.18593e-17
C864	A#48	VGND#17	1.84099e-17
C865	A#6	VNB	3.18783e-17
C866	A#4	VNB	3.321e-17
C867	Y#26	A#6	4.61179e-20
C868	Y#2	A#76	1.75727e-17
C869	A#3	VNB	3.87049e-17
C870	Y#5	VPWR#11	1.76241e-17
C871	A#19	Y#19	3.03408e-17
C872	A#2	VNB	4.70497e-17
C873	VGND#9	A#78	2.52279e-17
C874	A#8	A#7	1.08601e-18
C875	VGND#3	VNB	1.56832e-16
C876	Y#27	VNB	1.48031e-17
C877	VPWR#26	A#68	6.14042e-18
C878	VGND#3	A#90	1.42146e-16
C879	A#84	A#19	9.78899e-18
C880	Y#21	VNB	9.46209e-18
C881	VGND#15	VNB	1.43067e-18
C882	A#86	A#46	7.98029e-19
C883	A#52	VPWR#23	2.97457e-17
C884	VGND#19	Y#10	3.8994e-17
C885	Y#17	VPWR#22	5.56925e-17
C886	Y#18	VNB	2.08697e-18
C887	VGND#9	Y#5	1.43335e-18
C888	VGND#16	VNB	5.38537e-18
C889	VGND#18	A#43	1.48133e-19
C890	Y#15	VNB	4.1149e-18
C891	Y#16	A#19	1.78913e-17
C892	VPWR#24	A#49	1.53981e-19
C893	VGND#17	VNB	5.74558e-18
C894	Y#19	A#46	1.0825e-17
C895	Y#14	VNB	4.61105e-18
C896	A#61	Y#4	2.8453e-19
C897	VGND#18	VNB	3.16557e-18
C898	Y#2	VPWR#11	1.49461e-17
C899	VGND#9	A#76	1.88241e-17
C900	Y#10	VNB	4.51986e-18
C901	VPWR#10	A#40	8.1728e-20
C902	VGND#19	VNB	3.1724e-18
C903	A#84	A#46	2.26666e-17
C904	Y#15	A#47	4.1494e-19
C905	Y#6	VNB	1.43534e-17
C906	Y#27	A#15	1.5583e-19
C907	VPWR#11	VPWR#14	6.87287e-17
C908	A#90	Y#27	1.32127e-17
C909	Y#3	VNB	1.81654e-17
C910	VGND#13	VNB	5.82548e-17
C911	Y	A#34	1.57489e-20
C912	Y#16	A#46	6.08745e-17
C913	VPWR#1	VNB	8.85394e-17
C914	VPWR#16	VNB	4.21811e-19
C915	A#82	A#46	2.28312e-17
C916	Y#14	A#48	3.35919e-17
C917	VPWR#11	VPWR#13	5.86419e-17
C918	A#52	Y#11	2.37944e-17
C919	VPWR#17	VNB	3.1908e-19
C920	VPWR#18	VNB	6.47003e-19
C921	A#71	Y#1	2.63722e-19
C922	Y#13	A#46	2.9654e-17
C923	VGND#10	A#61	7.50888e-21
C924	VPWR#19	VNB	4.62703e-19
C925	VPWR#11	VPWR#12	4.23847e-17
C926	VPWR#20	VNB	5.41993e-18
C927	Y#23	VNB	3.02114e-18
C928	VPWR#9	A#40	7.17767e-18
C929	VPWR#21	VNB	5.21642e-18
C930	Y#20	VNB	2.16219e-18
C931	VPWR#22	VNB	3.67071e-18
C932	Y#14	A#54	3.21051e-19
C933	Y#17	VNB	2.16168e-18
C934	Y#13	A#53	4.19735e-17
C935	VPWR#11	VPWR#10	4.6368e-17
C936	VPWR#23	VNB	4.30359e-18
C937	VGND#17	A#51	8.30444e-19
C938	VPWR#23	A#56	3.44144e-19
C939	VPWR#24	VNB	4.21863e-18
C940	VPWR#23	VPWR#22	1.87864e-18
C941	A#80	A#53	2.61846e-17
C942	VPWR#24	A#52	3.47059e-18
C943	VPWR#25	VNB	4.30359e-18
C944	Y#4	VNB	2.15554e-18
C945	VPWR#11	VPWR#9	5.90067e-17
C946	VPWR#26	VNB	5.96044e-19
C947	Y#6	A#71	2.41041e-19
C948	Y#9	A#53	3.02564e-17
C949	A#88	A#15	6.73837e-19
C950	VPWR#4	A#6	2.0379e-20
C951	Y#1	VNB	3.01433e-18
C952	VPWR#11	A#16	7.68617e-19
C953	VPWR#15	VNB	7.35165e-17
C954	A#27	VNB	4.74151e-17
C955	Y#6	Y#10	7.38343e-18
C956	A#29	VNB	3.20983e-17
C957	Y#26	VGND#3	3.80296e-19
C958	A#31	VNB	3.01459e-17
C959	VPWR#11	VPWR#8	6.49838e-17
C960	VGND#18	A#48	8.66328e-19
C961	A#33	VNB	3.18029e-17
C962	VGND#9	VGND#12	7.89227e-17
C963	VPWR#8	A#40	3.00302e-19
C964	A#35	VNB	2.7366e-17
C965	VPWR#11	A#19	1.04595e-18
C966	A#37	VNB	3.3498e-17
C967	A#60	Y#9	2.89008e-17
C968	A#39	VNB	3.65331e-17
C969	A#43	VNB	3.35478e-17
C970	A#48	VNB	3.41082e-17
C971	VPWR#11	VPWR#7	2.94376e-17
C972	A#78	A#60	9.7189e-18
C973	A#51	VNB	3.53467e-17
C974	A#68	Y#1	2.12576e-19
C975	VGND#9	VGND#11	7.4905e-17
C976	A#55	VNB	3.40368e-17
C977	VPWR#11	A#46	1.20133e-18
C978	Y#10	A#61	6.54274e-18
C979	A#58	VNB	3.72631e-17
C980	A#62	VNB	3.57811e-17
C981	Y#5	A#60	3.21031e-17
C982	A#65	VNB	3.34031e-17
C983	A#69	VNB	3.09228e-17
C984	VGND#9	A#46	1.04669e-19
C985	VGND#9	VGND#10	5.60677e-17
C986	Y#26	VPWR#7	6.9849e-18
C987	A#72	VNB	4.28647e-17
C988	VPWR#11	A#53	1.233e-18
C989	A#51	Y#14	2.16891e-17
C990	A#1	VNB	8.11247e-17
C991	A#20	VNB	3.1427e-17
C992	VGND#17	A#47	3.28736e-20
C993	A#21	VNB	3.14417e-17
C994	A#67	Y#5	2.84935e-17
C995	A#88	A#13	9.99629e-18
C996	VGND#9	A#53	4.29079e-20
C997	A#22	VNB	3.15339e-17
C998	VGND#9	VGND#8	6.80291e-17
C999	A#23	VNB	3.24625e-17
C1000	Y#35	VPWR#1	8.99852e-17
C1001	Y#21	A#17	6.4202e-19
C1002	A#24	VNB	3.37714e-17
C1003	A#86	Y	1.49349e-17
C1004	A#76	A#67	1.20443e-17
C1005	VPWR#11	A#60	1.16481e-18
C1006	VPWR#23	A#59	1.53981e-19
C1007	A#25	VNB	3.13574e-17
C1008	A#26	VNB	3.14852e-17
C1009	VPWR#23	Y#17	5.57515e-17
C1010	A#56	VPWR#24	2.49583e-17
C1011	A#28	VNB	3.14113e-17
C1012	Y#2	A#67	3.01276e-17
C1013	Y#1	VPWR#14	1.15066e-17
C1014	A#30	VNB	3.26137e-17
C1015	VGND#9	VGND#7	7.37084e-17
C1016	Y#26	VPWR#6	1.02392e-17
C1017	A#32	VNB	3.04005e-17
C1018	Y#10	A#48	4.75925e-19
C1019	A#34	VNB	3.24773e-17
C1020	A#36	VNB	3.29249e-17
C1021	A#40	VNB	3.57584e-17
C1022	A#19	A#46	1.59887e-17
C1023	VGND#17	A#55	3.76868e-19
C1024	A#44	VNB	3.38878e-17
C1025	VGND#9	VGND#6	6.51455e-17
C1026	A#49	VNB	3.21466e-17
C1027	Y#22	A#17	7.19775e-20
C1028	A#52	VNB	3.38806e-17
C1029	A#56	VNB	3.47842e-17
C1030	Y#6	A#68	6.42682e-18
C1031	A#59	VNB	3.65879e-17
C1032	Y#35	Y#34	2.88707e-17
C1033	A#63	VNB	3.59982e-17
C1034	A#66	VNB	3.45834e-17
C1035	Y#6	VGND#19	3.85323e-17
C1036	VGND#9	VGND#5	2.95821e-17
C1037	A#70	VNB	3.42717e-17
C1038	A#73	VNB	2.97369e-17
C1039	A#74	VNB	4.21428e-17
C1040	A#51	VGND#18	1.02377e-17
C1041	Y#35	VNB	1.47062e-17
C1042	Y#33	VNB	5.22547e-18
C1043	Y#22	A#15	1.3043e-17
C1044	A#7	A#6	1.08601e-18
C1045	Y#31	VNB	5.23342e-18
C1046	Y#29	VNB	5.22618e-18
C1047	A#90	VNB	7.24632e-17
C1048	Y	VPWR#11	6.61763e-18
C1049	Y#26	VNB	5.68903e-18
C1050	VPWR#4	VNB	2.28611e-16
C1051	Y#35	VPWR#16	9.66297e-17
C1052	A#88	VNB	1.84597e-18
C1053	VPWR#10	A#44	2.85183e-19
C1054	A#88	A#9	2.66657e-19
C1055	A#86	VNB	1.71145e-18
C1056	Y#27	A#13	6.71512e-19
C1057	A#84	VNB	4.398e-18
C1058	Y	A#16	4.19084e-18
C1059	A#59	VPWR#24	2.78713e-17
C1060	Y#14	A#55	1.69321e-18
C1061	A#82	VNB	5.42634e-18
C1062	VPWR#25	A#56	1.53981e-19
C1063	Y#13	VNB	3.44972e-18
C1064	A#80	VNB	1.81213e-18
C1065	Y#9	VNB	3.62656e-18
C1066	VGND#19	A#61	3.26028e-18
C1067	A#78	VNB	4.09672e-18
C1068	Y#5	VNB	9.7086e-19
C1069	A#20	A#1	4.75499e-17
C1070	A#76	VNB	1.13982e-18
C1071	Y#21	A#15	4.19086e-18
C1072	Y#2	VNB	2.13196e-17
C1073	Y#22	A#13	1.43528e-17
C1074	VPWR#11	VNB	2.94351e-16
C1075	VGND#9	VNB	2.90922e-16
C1076	Y#10	A#51	1.96187e-18
C1077	Y#14	A#47	7.01741e-18
C1078	A#5	VNB	4.47371e-17
C1079	A#11	VNB	4.65256e-17
C1080	VPWR#9	A#44	6.5604e-18
C1081	VGND#15	A#17	1.29619e-18
C1082	A#16	VNB	6.03425e-19
C1083	A#19	VNB	2.96935e-19
C1084	A#59	Y#7	2.27776e-17
C1085	A#46	VNB	1.20953e-16
C1086	A#53	VNB	4.67358e-17
C1087	A#60	VNB	4.84651e-19
C1088	A#67	VNB	4.84651e-19
C1089	VGND#20	VGND#19	2.31658e-18
C1090	A#86	A#17	1.12136e-17
C1091	A#55	VGND#18	1.46373e-17
C1092	VPWR#14	A#71	2.24169e-20
C1093	VGND#11	Y#10	7.44117e-18
C1094	VGND#2	A#1	4.6171e-18
C1095	VGND#2	VGND#5	4.29548e-17
C1096	VGND#2	A#11	3.65383e-20
C1097	VGND#2	A#27	9.08364e-18
C1098	VGND#2	A#88	1.45728e-17
C1099	VGND#2	Y#27	1.47869e-17
C1100	VGND#2	A#2	4.39574e-19
C1101	VGND#2	VPWR#19	3.86645e-19
C1102	VGND#2	A#90	1.32375e-16
C1103	VGND#2	A#9	2.80127e-20
C1104	VGND#2	VNB	2.54805e-16
C1105	VGND#2	A#29	4.73382e-18
C1106	VGND#2	VPWR#1	1.0905e-17
C1107	VGND#2	VGND#3	3.23665e-16
*
*
.ENDS sky130_fd_sc_hs__clkinv_16
*
