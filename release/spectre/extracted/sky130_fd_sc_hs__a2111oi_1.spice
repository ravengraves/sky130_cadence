* Extracted by Quantus, converted by sky130cad/quantus.py
*
*
*
*                       LINUX           Wed Nov 18 08:02:02 2026
*
*
*
*  PROGRAM  advgen
*
*  Name           : advgen - Quantus - (64-bit)
*  Version        : 25.1.0-p047
*  Build Date     : Thu Dec 11 23:20:30 PST 2025
*
*  HSPICE LIBRARY
*
*  OPERATING_TEMPERATURE 150
*  QRC_TECH_DIR <path>/tech
*
*
*

*
.SUBCKT sky130_fd_sc_hs__a2111oi_1 VPB VNB VGND VPWR Y A2 D1 C1 B1 A1
*
*
*  caps2d version: 10
*
*
*       TRANSISTOR CARDS
*
*
XM9 VGND#8 D1#1 Y#3 VNB sky130_fd_pr__nfet_01v8_lvt l=0.15 w=0.74 ad=0.1961 as=0.2072 pd=2.01 ps=2.04
XM2 Y#3 C1#1 VGND#7 VNB sky130_fd_pr__nfet_01v8_lvt l=0.15 w=0.74 ad=0.2072 as=0.37 pd=2.04 ps=2.48
XM0 VGND#7 B1#1 Y#1 VNB sky130_fd_pr__nfet_01v8_lvt l=0.15 w=0.74 ad=0.37 as=0.2072 pd=2.48 ps=2.04
XM3 Y#1 A1#1 a_461_74# VNB sky130_fd_pr__nfet_01v8_lvt l=0.15 w=0.74 ad=0.2072 as=0.2368 pd=2.04 ps=2.12
XM5 a_461_74# A2#3 VGND#4 VNB sky130_fd_pr__nfet_01v8_lvt l=0.15 w=0.74 ad=0.2368 as=0.2109 pd=2.12 ps=2.05
XM4 Y#4 D1#3 a_156_368# VPB sky130_fd_pr__pfet_01v8 l=0.15 w=1.12 ad=0.308 as=0.2688 pd=2.79 ps=2.72
XM6 a_156_368# C1#3 a_234_368# VPB sky130_fd_pr__pfet_01v8 l=0.15 w=1.12 ad=0.2688 as=0.4368 pd=2.72 ps=3.02
XM8 a_234_368# B1#3 a_342_368##2 VPB sky130_fd_pr__pfet_01v8 l=0.15 w=1.12 ad=0.4368 as=0.4368 pd=3.02 ps=3.02
XM1 a_342_368##2 A1#3 VPWR#4 VPB sky130_fd_pr__pfet_01v8 l=0.15 w=1.12 ad=0.4368 as=0.4368 pd=3.02 ps=3.02
XM7 VPWR#4 A2#1 a_342_368# VPB sky130_fd_pr__pfet_01v8 l=0.15 w=1.12 ad=0.4368 as=0.308 pd=3.02 ps=2.79
*
*
*       RESISTOR AND CAP/DIODE CARDS
*
Rg1	D1#1	D1#2	382.539734
Rg2	D1#2	D1#3	434.639221
Rg3	C1#1	C1#2	382.539734
Rg4	C1#2	C1#3	434.639221
Rg5	B1#1	B1#2	382.539734
Rg6	B1#2	B1#3	434.639221
Rg7	A1#1	A1#2	382.539734
Rg8	A1#2	A1#3	434.639221
Rg9	A2#1	A2#2	492.059540
Rg10	A2#2	A2#3	307.937683
Rf1	D1#2	D1#5	161.608017
Rf2	D1#6	D1	1.375212
Rf3	D1#5	D1#6	5.294745
Rf4	C1#2	C1	166.137894
Rf5	B1#2	B1	166.137894
Rf6	Y#1	Y#2	90.498764
Rf7	Y#2	Y	119.210602
Rf8	Y#2	Y#3	21.341251
Rf9	Y	Y#5	3.143177
Rf10	Y#5	Y	3.131334
Rf11	Y#4	Y#5	5.000000
Rf12	A1#4	A1#2	161.608017
Rf13	A1	A1#6	1.375212
Rf14	A1#4	A1#6	5.294745
Rf15	a_342_368#	a_342_368##2	100.537308
Rf16	A2#4	A2#2	161.213211
Rf17	A2	A2#6	0.980415
Rf18	A2#4	A2#6	11.648439
Rf20	VGND#2	VGND#3	90.192825
Rf21	VGND#2	VGND#4	32.026825
Rf22	VGND#3	VGND#5	88.804871
Rf24	VGND#3	VGND#7	36.707130
Rf25	VGND#5	VGND#8	38.247387
Rf27	VPWR#2	VPWR#3	54.012489
Rf28	VPWR#2	VPWR#4	29.844635
Re1	VPWR#3	VPWR	1.403190
Re2	VGND	VGND#3	1.403242
*
*       CAPACITOR CARDS
*
*
C1	A1#4	A2#4	2.12999e-17
C2	VGND#4	A2#6	2.08919e-17
C3	VGND#4	A2#4	2.07361e-17
C4	Y#2	D1#5	3.13031e-17
C5	Y#1	A1#4	2.78837e-17
C6	A2#6	a_342_368#	1.58065e-17
C7	Y#2	Y#1	5.30578e-19
C8	A2#4	a_342_368#	2.02029e-17
C9	Y#2	VGND#7	2.52031e-17
C10	Y#2	Y#3	1.26383e-18
C11	Y#2	VGND#8	3.67316e-17
C12	Y#1	VGND#4	2.08891e-17
C13	VGND#7	VGND#4	1.13489e-18
C14	Y#1	VGND#7	5.95213e-17
C15	Y#3	Y#1	1.74978e-18
C16	Y#3	VGND#7	4.49499e-17
C17	VGND#8	VGND#7	1.50444e-18
C18	VGND#8	Y#3	4.2284e-17
C19	Y#1	a_342_368##2	5.44817e-18
C20	Y#2	B1#1	2.03126e-19
C21	Y#2	C1#1	2.32133e-17
C22	VGND#4	A2#3	3.76962e-17
C23	Y#2	D1#1	1.67899e-17
C24	a_342_368#	VPWR#4	9.03131e-17
C25	a_342_368##2	a_342_368#	2.4705e-18
C26	VGND#4	A1#1	7.92786e-18
C27	Y#1	A2#3	8.44206e-18
C28	a_342_368##2	VPWR#4	7.89732e-17
C29	VGND#4	B1#1	2.98044e-19
C30	VGND#7	A2#3	2.81255e-19
C31	Y#1	A1#1	5.06384e-17
C32	VGND#4	C1#1	1.58234e-19
C33	VGND#7	A1#1	3.21883e-19
C34	Y#1	B1#1	5.53616e-17
C35	B1#1	VGND#7	2.26658e-17
C36	Y#1	C1#1	5.64885e-19
C37	Y#3	B1#1	6.69885e-19
C38	C1#1	VGND#7	2.59833e-17
C39	VGND#8	B1#1	1.17947e-19
C40	Y#3	C1#1	3.63442e-17
C41	VGND#7	D1#1	6.00131e-19
C42	VGND#8	C1#1	1.41262e-18
C43	D1#1	Y#3	1.25806e-17
C44	VGND#8	D1#1	2.60118e-17
C45	D1#6	C1#3	6.81321e-19
C46	D1#6	D1#3	1.63428e-18
C47	A2#4	A2#2	2.78559e-17
C48	VGND#3	A1#4	4.16233e-19
C49	A1#1	A2#3	3.559e-17
C50	a_342_368#	A2#1	6.14416e-17
C51	VGND#3	Y#2	2.25448e-19
C52	A2#4	A1#2	5.01318e-18
C53	A2#1	VPWR#4	3.11845e-17
C54	A1#4	A2#2	3.81188e-18
C55	a_342_368#	A1#3	1.36114e-18
C56	a_342_368##2	A2#1	8.14832e-19
C57	B1#1	A1#1	3.83383e-17
C58	VPWR#4	A1#3	5.25611e-17
C59	a_342_368#	B1#3	4.52539e-19
C60	A2#4	B1#2	8.31368e-19
C61	A1#4	A1#2	1.056e-17
C62	a_342_368##2	A1#3	3.47577e-17
C63	VPWR#4	B1#3	1.37093e-18
C64	a_342_368#	C1#3	1.386e-19
C65	Y#2	A1#2	5.56819e-20
C66	C1#1	B1#1	1.62284e-17
C67	a_342_368##2	B1#3	5.64067e-17
C68	A1#4	B1#2	3.18236e-18
C69	A2#4	C1#2	4.50218e-19
C70	VPWR#4	C1#3	6.39242e-19
C71	VGND#3	VGND#4	2.47823e-20
C72	a_342_368#	D1#3	1.48153e-19
C73	a_342_368##2	C1#3	5.13712e-18
C74	Y#2	B1#2	9.64682e-20
C75	VPWR#4	D1#3	4.19693e-19
C76	D1#1	C1#1	3.99185e-17
C77	VGND#3	Y#1	1.7006e-17
C78	A2#2	VGND#4	4.65144e-18
C79	A2#4	D1#2	3.72231e-19
C80	Y#2	C1#2	3.53652e-18
C81	VGND#3	Y#3	6.70407e-18
C82	Y#1	A2#2	1.13855e-18
C83	Y#2	D1#2	3.91732e-18
C84	D1#6	C1#2	1.54428e-18
C85	Y#1	A1#2	1.55555e-18
C86	D1#3	Y#4	9.90917e-18
C87	a_342_368##2	VPWR#3	1.79859e-17
C88	D1#5	C1#2	2.35005e-18
C89	a_342_368#	A2#2	2.71701e-18
C90	Y#1	B1#2	2.85383e-18
C91	D1#6	D1#2	5.6736e-18
C92	VGND#7	B1#2	8.57569e-19
C93	D1#5	D1#2	9.15877e-18
C94	A1#3	A2#1	3.13122e-17
C95	A1#2	VPWR#4	1.318e-18
C96	VGND#7	C1#2	6.47359e-19
C97	a_342_368##2	A1#2	1.91773e-18
C98	VGND#3	A2#3	2.61505e-19
C99	B1#3	A1#3	3.19202e-17
C100	VGND#3	A1#1	5.19363e-18
C101	B1#2	a_342_368##2	3.78182e-18
C102	VGND#3	B1#1	5.45539e-18
C103	VGND#8	D1#2	9.7991e-19
C104	A1#1	A2#2	2.0912e-18
C105	VGND#3	C1#1	5.39918e-18
C106	C1#3	B1#3	3.24864e-17
C107	VGND#3	D1#1	7.64815e-19
C108	D1#3	C1#3	6.24552e-17
C109	VPWR#3	B1#3	7.77731e-18
C110	D1#2	Y#4	5.29945e-19
C111	VPWR#3	C1#3	5.33885e-18
C112	A1#2	A2#1	2.0245e-18
C113	VPWR#3	D1#3	5.32105e-18
C114	B1	A1#4	2.06777e-17
C115	Y#2	C1	4.27339e-17
C116	D1#6	C1	1.57694e-17
C117	Y#1	B1	3.49535e-17
C118	VGND#3	A1#2	3.69778e-20
C119	VPWR#3	B1#2	6.67361e-20
C120	D1#5	C1	2.06777e-17
C121	A1	a_342_368##2	3.86319e-17
C122	A2#3	a_461_74#	2.11762e-17
C123	A1#2	A2#2	3.36242e-17
C124	VPWR#3	C1#2	1.34211e-19
C125	A1#1	a_461_74#	2.06918e-17
C126	VGND#3	C1#2	3.69778e-20
C127	VPWR#3	D1#2	4.50366e-20
C128	B1	a_342_368##2	3.05486e-17
C129	B1#2	A1#2	3.51669e-17
C130	B1#3	a_234_368#	3.19637e-18
C131	C1#3	a_234_368#	2.73923e-17
C132	C1#2	B1#2	2.88857e-17
C133	C1#3	a_156_368#	1.99472e-17
C134	D1#3	a_156_368#	2.09406e-17
C135	A1	A2#1	2.88782e-18
C136	Y#2	Y	9.15312e-18
C137	A1	A1#3	2.06063e-18
C138	D1#2	C1#2	3.46472e-17
C139	VPWR	A2#6	3.88015e-18
C140	Y	D1#6	6.04482e-17
C141	A1	B1#3	5.78516e-19
C142	VPWR	A2#4	1.7085e-18
C143	Y	D1#5	2.04747e-17
C144	B1	A1#3	5.64345e-19
C145	B1	B1#3	4.68264e-18
C146	B1	C1#3	3.88406e-19
C147	C1#2	a_234_368#	5.15778e-19
C148	VPWR	D1#6	2.72921e-18
C149	C1	B1#3	8.02098e-19
C150	VGND	A2#6	3.95345e-18
C151	Y	a_342_368##2	5.0689e-17
C152	C1	C1#3	1.46664e-18
C153	VGND	A2#4	3.05416e-18
C154	A1	A2#2	1.94556e-18
C155	B1	VPWR#3	6.3307e-19
C156	C1	D1#3	6.79484e-19
C157	VGND	A1#4	5.96119e-18
C158	A1	A1#2	6.35752e-18
C159	Y	Y#4	6.32033e-18
C160	VGND	Y#2	9.9911e-18
C161	A1	B1#2	1.93158e-18
C162	C1	VPWR#3	5.03242e-19
C163	VPWR	a_342_368#	1.78946e-17
C164	VPWR	VPWR#4	2.55527e-17
C165	B1	A1#2	2.55187e-18
C166	VPWR	a_342_368##2	1.88553e-17
C167	VGND	D1#5	3.05888e-18
C168	B1	B1#2	1.52901e-17
C169	VGND	VGND#4	2.22442e-17
C170	A2#6	VNB	3.19636e-17
C171	VGND	Y#1	1.71906e-17
C172	B1	C1#2	3.55808e-18
C173	VGND	Y#3	1.38184e-17
C174	C1	B1#2	3.01451e-18
C175	Y	A1#3	1.05442e-19
C176	A1#4	VNB	1.58783e-18
C177	VGND	a_342_368#	2.99882e-18
C178	Y	B1#3	1.44879e-17
C179	C1	C1#2	1.46307e-17
C180	Y#2	VNB	3.2805e-17
C181	Y	C1#3	5.01448e-17
C182	C1	D1#2	4.54393e-18
C183	D1#6	VNB	3.45385e-18
C184	Y	D1#3	5.72223e-17
C185	VPWR	A2#1	6.56349e-19
C186	D1#5	VNB	5.62134e-18
C187	VGND#4	VNB	3.29606e-17
C188	VGND	A2#3	4.07812e-19
C189	VPWR	A1#3	7.284e-19
C190	Y	VPWR#3	6.30128e-17
C191	VGND	A1#1	1.30163e-18
C192	Y#1	VNB	6.02296e-18
C193	VPWR	B1#3	2.25688e-18
C194	VGND#7	VNB	2.7989e-18
C195	VGND	B1#1	3.03553e-19
C196	VPWR	C1#3	4.15066e-19
C197	Y#3	VNB	2.32929e-18
C198	VGND	C1#1	9.94105e-20
C199	VGND#8	VNB	2.43773e-17
C200	VPWR	D1#3	1.40055e-18
C201	VGND	D1#1	6.67961e-19
C202	a_342_368#	VNB	5.59598e-17
C203	VPWR#4	VNB	2.68651e-18
C204	Y	A1#2	3.61571e-21
C205	a_342_368##2	VNB	3.08962e-18
C206	VPWR	VPWR#3	5.39476e-17
C207	Y	B1#2	6.26417e-21
C208	B1	A1	1.63245e-17
C209	Y	C1#2	2.39715e-18
C210	A2#3	VNB	2.33999e-17
C211	A1#1	VNB	2.60943e-17
C212	Y	D1#2	1.30461e-17
C213	B1#1	VNB	2.95521e-17
C214	C1#1	VNB	2.94773e-17
C215	D1#1	VNB	3.56168e-17
C216	C1	B1	3.02588e-17
C217	VGND	VGND#3	5.87735e-17
C218	A2#1	VNB	4.45841e-17
C219	A1#3	VNB	2.83607e-17
C220	B1#3	VNB	3.42466e-17
C221	VGND	A1#2	1.18618e-18
C222	C1#3	VNB	3.36501e-17
C223	Y	a_156_368#	3.45077e-18
C224	D1#3	VNB	4.09239e-17
C225	VPWR#3	VNB	2.24103e-16
C226	VGND#3	VNB	1.95717e-16
C227	A2#2	VNB	4.62112e-17
C228	A1#2	VNB	3.33155e-17
C229	B1#2	VNB	2.68613e-17
C230	VPWR	A1	2.73316e-18
C231	C1#2	VNB	2.88831e-17
C232	C1	Y	3.44548e-17
C233	D1#2	VNB	4.33252e-17
C234	VPWR	B1	4.74347e-18
C235	VPWR	C1	3.63782e-18
C236	VGND	B1	2.64412e-18
C237	VGND	C1	2.59275e-18
C238	A1	VNB	5.36511e-18
C239	B1	VNB	3.34581e-18
C240	VPWR	Y	4.47936e-17
C241	C1	VNB	2.19947e-18
C242	Y	VNB	9.41842e-17
C243	VPWR	VNB	7.43259e-17
C244	VGND	VNB	6.55978e-17
C245	VPWR#3	VPWR#2	5.81464e-17
C246	A2#6	VPWR#2	8.47227e-19
C247	VGND#2	A1#2	1.69171e-19
C248	VGND#3	VGND#5	4.40415e-17
C249	VGND#5	B1#1	1.97963e-19
C250	VGND#2	VNB	4.49088e-17
C251	VGND#5	VGND#7	5.44463e-19
C252	a_342_368#	VPWR#2	2.09846e-17
C253	VGND#2	A2#6	1.40796e-18
C254	VGND#5	VNB	4.32989e-17
C255	VPWR#2	VNB	5.29295e-17
C256	VGND#5	C1#1	1.06002e-18
C257	VGND#5	Y#3	6.99235e-18
C258	VGND#3	VGND#2	4.75617e-17
C259	VPWR#2	A2#2	9.46869e-20
C260	a_342_368##2	VPWR#2	4.38265e-18
C261	VGND#2	A2#3	3.75761e-18
C262	VGND#5	D1#1	6.91011e-18
C263	VGND#2	A1#4	1.04965e-18
C264	VGND#5	Y#2	3.06729e-18
C265	VPWR#2	A2#1	2.58793e-18
C266	VGND#2	A2#4	7.32415e-19
C267	VGND	VGND#2	3.32358e-17
C268	VGND#2	A1#1	2.79566e-18
C269	VGND	VGND#5	5.09951e-17
C270	VPWR	VPWR#2	3.64823e-17
C271	VPWR#2	A1#3	9.77087e-19
*
*
.ENDS sky130_fd_sc_hs__a2111oi_1
*
