* Extracted by Quantus, converted by sky130cad/quantus.py
*
*
*
*                       LINUX           Wed Nov 18 08:55:03 2026
*
*
*
*  PROGRAM  advgen
*
*  Name           : advgen - Quantus - (64-bit)
*  Version        : 25.1.0-p047
*  Build Date     : Thu Dec 11 23:20:30 PST 2025
*
*  HSPICE LIBRARY
*
*  OPERATING_TEMPERATURE 150
*  QRC_TECH_DIR <path>/tech
*
*
*

*
.SUBCKT sky130_fd_sc_hs__o21a_4 VNB VPB VGND VPWR X A2 A1 B1
*
*
*  caps2d version: 10
*
*
*       TRANSISTOR CARDS
*
*
XM9 VGND#11 A1#4 a_27_125##5 VNB sky130_fd_pr__nfet_01v8_lvt l=0.15 w=0.64 ad=0.2272 as=0.1824 pd=1.99 ps=1.85
XM3 a_27_125##6 A2#4 VGND#11 VNB sky130_fd_pr__nfet_01v8_lvt l=0.15 w=0.64 ad=0.1792 as=0.2272 pd=1.84 ps=1.99
XM18 VGND#10 A2#5 a_27_125##6 VNB sky130_fd_pr__nfet_01v8_lvt l=0.15 w=0.64 ad=0.2752 as=0.1792 pd=2.14 ps=1.84
XM14 a_27_125##2 A1#3 VGND#10 VNB sky130_fd_pr__nfet_01v8_lvt l=0.15 w=0.64 ad=0.1792 as=0.2752 pd=1.84 ps=2.14
XM12 a_216_387##18 B1#5 a_27_125##2 VNB sky130_fd_pr__nfet_01v8_lvt l=0.15 w=0.64 ad=0.1792 as=0.1792 pd=1.84 ps=1.84
XM13 a_27_125# B1#3 a_216_387##18 VNB sky130_fd_pr__nfet_01v8_lvt l=0.15 w=0.64 ad=0.2336 as=0.1792 pd=2.01 ps=1.84
XM2 VGND#9 a_216_387##11 X#5 VNB sky130_fd_pr__nfet_01v8_lvt l=0.15 w=0.74 ad=0.2109 as=0.2072 pd=2.05 ps=2.04
XM7 X#5 a_216_387##9 VGND#8 VNB sky130_fd_pr__nfet_01v8_lvt l=0.15 w=0.74 ad=0.2072 as=0.2331 pd=2.04 ps=2.11
XM8 X#1 a_216_387##7 VGND#8 VNB sky130_fd_pr__nfet_01v8_lvt l=0.15 w=0.74 ad=0.2072 as=0.2331 pd=2.04 ps=2.11
XM10 VGND#1 a_216_387# X#1 VNB sky130_fd_pr__nfet_01v8_lvt l=0.15 w=0.74 ad=0.2109 as=0.2072 pd=2.05 ps=2.04
XM0 VPWR#6 A1#5 a_116_387##2 VPB sky130_fd_pr__pfet_01v8 l=0.15 w=1 ad=0.295 as=0.35 pd=2.59 ps=2.7
XM5 a_116_387##2 A2#6 a_216_387##16 VPB sky130_fd_pr__pfet_01v8 l=0.15 w=1 ad=0.35 as=0.3 pd=2.7 ps=2.6
XM17 a_216_387##16 A2#1 a_116_387# VPB sky130_fd_pr__pfet_01v8 l=0.15 w=1 ad=0.3 as=0.35 pd=2.6 ps=2.7
XM1 a_116_387# A1#1 VPWR#9 VPB sky130_fd_pr__pfet_01v8 l=0.15 w=1 ad=0.35 as=0.37 pd=2.7 ps=2.78
XM6 VPWR#9 B1#6 a_216_387##14 VPB sky130_fd_pr__pfet_01v8 l=0.15 w=0.84 ad=0.37 as=0.3192 pd=2.78 ps=2.44
XM19 a_216_387##14 B1#1 VPWR#8 VPB sky130_fd_pr__pfet_01v8 l=0.15 w=0.84 ad=0.3192 as=0.5614 pd=2.44 ps=3.4
XM4 VPWR#8 a_216_387##13 X#4 VPB sky130_fd_pr__pfet_01v8 l=0.15 w=1.12 ad=0.5614 as=0.336 pd=3.4 ps=2.84
XM11 VPWR#7 a_216_387##12 X#4 VPB sky130_fd_pr__pfet_01v8 l=0.15 w=1.12 ad=0.448 as=0.336 pd=3.04 ps=2.84
XM15 X#6 a_216_387##8 VPWR#7 VPB sky130_fd_pr__pfet_01v8 l=0.15 w=1.12 ad=0.336 as=0.448 pd=2.84 ps=3.04
XM16 X#6 a_216_387##6 VPWR#1 VPB sky130_fd_pr__pfet_01v8 l=0.15 w=1.12 ad=0.336 as=0.3864 pd=2.84 ps=2.93
*
*
*       RESISTOR AND CAP/DIODE CARDS
*
Rg1	A2#1	A2#2	416.208282
Rg2	A2#2	A2#3	32.959415
Rg3	A2#3	A2#4	304.732208
Rg4	A2#2	A2#5	336.150360
Rg5	A2#3	A2#6	385.524780
Rg6	A1#1	A1#2	408.386017
Rg7	A1#2	A1#3	331.833557
Rg8	A1#3	A1#4	1639.754272
Rg9	A1#4	A1#5	786.144897
Rg10	B1#1	B1#2	380.771210
Rg11	B1#2	B1#3	314.637177
Rg12	B1#2	B1#4	38.488548
Rg13	B1#4	B1#5	331.108124
Rg14	B1#4	B1#6	369.327576
Rg15	a_216_387#	a_216_387##2	336.783966
Rg16	a_216_387##2	a_216_387##3	39.386524
Rg17	a_216_387##3	a_216_387##4	77.627602
Rg18	a_216_387##4	a_216_387##5	40.261318
Rg19	a_216_387##2	a_216_387##6	444.332916
Rg20	a_216_387##3	a_216_387##7	340.844513
Rg21	a_216_387##3	a_216_387##8	438.393311
Rg22	a_216_387##4	a_216_387##9	296.149994
Rg23	a_216_387##5	a_216_387##10	32.326767
Rg24	a_216_387##10	a_216_387##11	296.149994
Rg25	a_216_387##5	a_216_387##12	486.547119
Rg26	a_216_387##10	a_216_387##13	505.324677
Rf1	A2#3	A2	81.210030
Rf2	a_116_387#	a_116_387##2	115.510460
Rf3	A1#2	A1#7	160.988663
Rf4	A1#8	A1	0.755859
Rf5	A1#7	A1#8	7.761615
Rf6	B1	B1#7	16.470037
Rf7	B1#7	B1	6.781780
Rf8	a_27_125#	a_27_125##3	111.282867
Rf9	a_27_125##3	a_27_125##4	73.751663
Rf10	a_27_125##4	a_27_125##5	81.860588
Rf11	a_27_125##4	a_27_125##6	15.969168
Rf12	a_27_125##2	a_27_125##3	7.500000
Rf13	a_216_387##14	a_216_387##15	17.459919
Rf14	a_216_387##15	a_216_387##16	122.615204
Rf15	a_216_387##15	a_216_387##17	89.902412
Rf16	a_216_387##17	a_216_387##18	77.463036
Rf17	a_216_387##17	a_216_387##5	62.626343
Rf18	X#1	X#2	20.747131
Rf19	X#2	X#3	60.563652
Rf20	X#3	X#4	101.970322
Rf21	X#2	X#5	76.199287
Rf22	X#3	X#6	39.521107
Rf23	X#3	X	38.057014
Rf24	VPWR#1	VPWR#2	105.096703
Rf25	VPWR#2	VPWR#3	80.631317
Rf26	VPWR#3	VPWR#4	36.095047
Rf27	VPWR#4	VPWR#5	47.458290
Rf28	VPWR#5	VPWR#6	177.232346
Rf29	VPWR#2	VPWR#7	34.939823
Rf30	VPWR#3	VPWR#8	36.453156
Rf31	VPWR#5	VPWR#9	46.120842
Rf32	VGND#1	VGND#2	93.708946
Rf33	VGND#2	VGND#3	67.013947
Rf34	VGND#3	VGND#4	58.838467
Rf35	VGND#4	VGND#5	84.348793
Rf36	VGND#5	VGND#6	68.798134
Rf38	VGND#2	VGND#8	29.859245
Rf39	VGND#3	VGND#9	37.457504
Rf40	VGND#5	VGND#10	41.987278
Rf41	VGND#6	VGND#11	41.603920
Rf44	B1#2	B1#7	80.116402
Re1	VPWR#4	VPWR	0.818510
Re2	VGND	VGND#4	0.818540
*
*       CAPACITOR CARDS
*
*
C1	a_216_387##17	a_216_387##3	8.09879e-20
C2	VPWR#8	a_216_387##10	9.34184e-19
C3	X#4	B1#4	6.10605e-19
C4	X#1	VGND#1	3.90902e-17
C5	VPWR#2	VPWR#1	8.81498e-19
C6	a_27_125##4	VGND#10	1.72874e-17
C7	VGND#8	VGND#1	2.3372e-18
C8	a_216_387##10	a_216_387##3	3.81248e-18
C9	X#3	VPWR#1	1.5041e-17
C10	X#6	VPWR#2	1.49934e-17
C11	a_216_387##17	B1#4	9.16563e-18
C12	VGND#8	X#1	2.80586e-17
C13	a_27_125##4	a_27_125##6	3.15115e-19
C14	VPWR#3	VPWR#7	1.69444e-18
C15	X#3	X#6	1.76891e-19
C16	X#5	X#1	3.46101e-18
C17	a_27_125##4	VGND#11	1.54302e-17
C18	VPWR#3	X#4	1.35563e-17
C19	X#3	VPWR#7	1.78621e-17
C20	X#5	VGND#8	4.48923e-17
C21	X#4	VPWR#2	9.31272e-18
C22	a_27_125##2	A1#7	2.88343e-17
C23	a_216_387##15	B1#4	4.42225e-18
C24	VPWR#3	VPWR#8	6.18724e-19
C25	X#4	X#3	2.64007e-18
C26	VGND#9	VGND#8	2.17894e-18
C27	a_216_387##14	VPWR#5	5.67052e-19
C28	B1#4	a_216_387##14	8.55321e-19
C29	VGND#9	X#5	5.55851e-17
C30	VPWR#5	VPWR#9	2.81304e-20
C31	B1#4	a_216_387##10	1.13295e-17
C32	VPWR#9	VPWR#3	2.18614e-19
C33	a_216_387##17	X#4	3.04863e-17
C34	a_116_387#	VPWR#5	6.74934e-17
C35	a_27_125#	VGND#9	5.20397e-17
C36	a_216_387##17	VPWR#8	2.21499e-17
C37	a_216_387##16	VPWR#5	2.78301e-19
C38	a_216_387##15	VPWR#8	2.49087e-17
C39	a_216_387##18	a_27_125#	5.90058e-17
C40	a_116_387##2	VPWR#5	6.66912e-18
C41	a_216_387##15	a_216_387##14	2.96357e-18
C42	a_27_125##2	a_27_125#	2.82811e-18
C43	VGND#1	VPWR#1	3.45202e-19
C44	VPWR#6	VPWR#5	2.95662e-19
C45	a_216_387##15	VPWR#9	4.25453e-17
C46	a_27_125##2	a_216_387##18	6.66282e-17
C47	VGND#2	a_216_387##7	1.23732e-18
C48	VGND#3	a_216_387##9	4.8707e-19
C49	a_27_125##2	VGND#10	7.0698e-17
C50	VGND#2	a_216_387##9	1.23132e-18
C51	VPWR#4	B1#4	8.55919e-20
C52	VGND#5	a_216_387##11	8.41536e-20
C53	a_27_125##6	a_27_125##2	3.24494e-18
C54	a_27_125##4	a_216_387##16	5.60533e-18
C55	VGND#3	a_216_387##11	7.06162e-18
C56	a_27_125##6	VGND#10	2.95789e-17
C57	X#2	a_216_387#	5.39448e-18
C58	a_27_125##4	a_116_387##2	1.50616e-18
C59	VGND#4	a_216_387##3	1.778e-20
C60	VGND#11	VGND#10	6.80248e-18
C61	X#2	a_216_387##7	1.34708e-17
C62	VGND#4	B1#4	5.94401e-20
C63	VGND#11	a_27_125##6	2.96096e-17
C64	X#2	a_216_387##9	2.46723e-19
C65	a_27_125##5	a_27_125##6	3.15335e-18
C66	VGND#5	A1#3	2.96422e-17
C67	A1#7	a_216_387##16	2.03252e-17
C68	a_216_387##5	a_216_387##10	3.25715e-17
C69	VGND#3	A1#3	2.19618e-19
C70	a_27_125##5	VGND#11	5.03481e-17
C71	a_216_387##5	a_216_387##3	1.56676e-17
C72	X#2	a_216_387##11	1.63951e-19
C73	VGND#5	A2#5	2.53272e-18
C74	X#2	B1#3	1.06601e-19
C75	VGND#5	VGND#3	1.77939e-19
C76	VGND#5	A1#4	2.29383e-19
C77	X#6	VPWR#1	8.16273e-17
C78	VGND#1	a_216_387#	4.20017e-17
C79	VPWR#7	VPWR#1	1.74025e-18
C80	a_216_387#	X#1	1.08277e-17
C81	VGND#1	a_216_387##7	2.96979e-18
C82	VPWR#7	X#6	7.97694e-17
C83	VGND#3	VGND#2	1.21232e-18
C84	VGND#8	a_216_387#	2.19123e-18
C85	a_216_387##7	X#1	1.72395e-17
C86	a_27_125##2	a_216_387##16	1.81182e-18
C87	X#5	a_216_387#	2.9269e-19
C88	A1#2	B1#4	2.48432e-17
C89	a_27_125##4	A1#3	4.39666e-19
C90	VGND#8	a_216_387##7	3.29681e-17
C91	X#1	a_216_387##9	6.16411e-19
C92	X#4	VPWR#7	9.77868e-17
C93	X#5	a_216_387##7	6.64216e-19
C94	VGND#8	a_216_387##9	2.99857e-17
C95	a_27_125##4	A2#5	1.91393e-17
C96	X#1	a_216_387##11	2.60857e-19
C97	a_216_387##3	X#1	8.04837e-19
C98	X#5	a_216_387##9	2.67401e-17
C99	VGND#8	a_216_387##11	2.05613e-18
C100	VPWR#8	X#4	4.837e-17
C101	a_27_125##4	A2#4	1.72409e-17
C102	a_216_387##10	VGND#8	5.15063e-19
C103	VGND#9	a_216_387##9	3.25853e-19
C104	a_216_387##18	a_216_387##7	5.62463e-20
C105	X#5	a_216_387##11	3.53849e-17
C106	A1#7	A1#3	1.93704e-19
C107	a_216_387##14	X#4	2.45192e-18
C108	X#3	a_216_387##6	6.53911e-18
C109	a_216_387##11	VGND#9	2.34935e-17
C110	a_27_125##5	a_116_387##2	6.27566e-18
C111	a_27_125##4	A1#4	1.9618e-19
C112	VPWR#3	a_216_387##8	2.98515e-19
C113	a_216_387##18	a_216_387##9	7.21997e-20
C114	a_216_387##14	VPWR#8	3.46122e-17
C115	a_27_125#	a_216_387##11	1.38918e-18
C116	VPWR#2	a_216_387##8	2.57891e-18
C117	a_27_125##5	VPWR#6	1.37496e-17
C118	VGND#9	B1#3	8.70845e-19
C119	a_216_387##3	VGND#8	1.46116e-18
C120	VPWR#9	VPWR#8	3.03525e-18
C121	X#3	a_216_387##8	1.44618e-17
C122	a_216_387##18	a_216_387##11	2.28176e-19
C123	B1#3	a_216_387##10	4.03033e-18
C124	VPWR#3	a_216_387##12	1.21256e-18
C125	B1#3	a_27_125#	3.01031e-17
C126	a_216_387##10	X#5	4.02887e-18
C127	a_27_125##2	a_216_387##11	7.08825e-20
C128	VPWR#9	a_216_387##14	4.65146e-17
C129	VPWR#2	a_216_387##12	2.59958e-18
C130	a_216_387##18	B1#3	4.8021e-17
C131	VPWR#5	a_216_387##13	6.69807e-19
C132	X#3	a_216_387##12	5.24626e-19
C133	a_27_125#	B1#5	4.30415e-19
C134	a_27_125##2	B1#3	1.99155e-18
C135	VPWR#3	a_216_387##13	1.1905e-17
C136	VGND#9	A1#3	2.18141e-19
C137	a_216_387##18	B1#5	1.41975e-17
C138	a_116_387#	VPWR#9	5.47463e-17
C139	a_216_387##16	a_216_387##14	1.76225e-18
C140	VPWR#5	VPWR#3	4.38906e-18
C141	VGND#2	X#3	1.3705e-19
C142	a_27_125##2	B1#5	5.08586e-17
C143	X#5	a_216_387##3	7.78597e-19
C144	a_216_387##18	A1#3	1.09966e-18
C145	VPWR#3	B1#1	3.13536e-19
C146	a_216_387##10	VGND#9	9.1731e-18
C147	a_27_125##2	A1#3	6.25647e-17
C148	a_116_387#	a_216_387##16	9.72842e-17
C149	VGND#2	X#2	3.91263e-19
C150	VPWR#5	B1#6	1.77598e-18
C151	a_216_387##18	A2#5	6.76369e-19
C152	a_216_387##17	a_216_387##13	7.27737e-18
C153	A1#3	VGND#10	2.21194e-17
C154	a_27_125##2	A2#5	7.04544e-19
C155	a_116_387##2	a_116_387#	2.3755e-18
C156	a_27_125##6	A1#3	2.55403e-18
C157	a_216_387##18	A2#4	3.27381e-19
C158	VPWR#3	VPWR#2	8.39939e-19
C159	A2#5	VGND#10	2.31449e-17
C160	a_216_387##17	B1#1	1.40236e-18
C161	VPWR#5	A1#1	1.07263e-17
C162	a_116_387##2	a_216_387##16	7.26934e-17
C163	VGND#11	A1#3	1.36563e-18
C164	VGND#3	a_216_387##17	1.34338e-18
C165	VPWR#3	A1#1	7.168e-19
C166	a_216_387##15	B1#1	2.27859e-17
C167	a_27_125##6	A2#5	3.07144e-17
C168	a_216_387##18	A1#4	5.27374e-19
C169	VGND#10	A2#4	7.80655e-19
C170	VGND#11	A2#5	2.37629e-18
C171	a_216_387##17	B1#6	4.06035e-19
C172	a_27_125##2	A1#4	1.37754e-19
C173	VPWR#5	A2#1	4.13025e-18
C174	A2#4	a_27_125##6	1.14186e-17
C175	VPWR#6	a_116_387##2	1.35604e-16
C176	a_27_125##5	A2#5	2.5657e-19
C177	a_216_387##15	B1#6	1.90568e-17
C178	VGND#5	a_27_125##4	2.64514e-19
C179	VGND#10	A1#4	1.00018e-18
C180	VGND#11	A2#4	3.46565e-17
C181	a_27_125##6	A1#4	4.78126e-18
C182	X#3	VPWR#2	1.20253e-19
C183	a_216_387##17	A1#1	1.86596e-19
C184	a_27_125##5	A2#4	1.74117e-18
C185	a_216_387##15	A1#1	1.30533e-17
C186	A1#4	VGND#11	2.31147e-17
C187	a_27_125##5	A1#4	4.82221e-17
C188	a_216_387##17	A2#1	1.22309e-19
C189	VGND#3	a_216_387##10	4.59291e-19
C190	a_216_387##7	a_216_387#	3.85156e-17
C191	X#2	X#3	2.15782e-18
C192	a_27_125#	B1#4	1.20812e-18
C193	a_216_387##17	VPWR#3	2.10356e-19
C194	a_216_387##15	VPWR#5	3.92194e-19
C195	a_116_387#	A1#3	4.63292e-19
C196	a_216_387##6	VPWR#1	3.31887e-17
C197	a_216_387##9	a_216_387##7	3.20212e-17
C198	a_216_387##16	A1#3	3.6961e-19
C199	B1	a_216_387##10	2.72927e-18
C200	X#6	a_216_387##6	5.05192e-17
C201	a_216_387##15	VPWR#3	8.14122e-20
C202	VPWR#1	a_216_387##8	1.34947e-18
C203	VPWR#4	VPWR#5	5.95438e-17
C204	VPWR#7	a_216_387##6	1.4381e-18
C205	B1	B1#4	3.43927e-17
C206	VGND#4	VGND#5	4.38488e-17
C207	VPWR#4	VPWR#3	3.66732e-17
C208	a_216_387##11	a_216_387##9	3.82172e-17
C209	X#6	a_216_387##8	4.85724e-17
C210	VGND#4	VGND#3	3.43647e-17
C211	VGND#2	a_216_387##10	9.27752e-20
C212	VPWR#4	VPWR#2	4.6002e-17
C213	VGND#4	VGND#2	4.30416e-17
C214	VPWR#1	a_216_387##12	2.8528e-19
C215	a_216_387##8	VPWR#7	3.14557e-17
C216	a_216_387##17	X#3	3.90494e-19
C217	a_216_387##18	B1#4	4.42958e-18
C218	X#4	a_216_387##8	5.24626e-19
C219	B1#3	a_216_387##11	4.17299e-18
C220	a_216_387##12	VPWR#7	3.71984e-17
C221	VGND#3	a_216_387##5	5.82003e-19
C222	a_116_387##2	A1#4	7.37455e-19
C223	X#4	a_216_387##12	8.30023e-17
C224	a_216_387##15	VPWR#4	4.42679e-19
C225	A1	a_216_387##10	7.48044e-19
C226	VPWR#7	a_216_387##13	1.29522e-18
C227	B1#5	B1#3	3.48298e-17
C228	A1#3	a_216_387##11	4.31399e-19
C229	A1	B1#4	1.02758e-17
C230	a_216_387##5	VPWR#3	7.81953e-20
C231	X#4	a_216_387##13	6.04989e-17
C232	VGND#2	a_216_387##3	1.32384e-19
C233	a_216_387##13	VPWR#8	2.4762e-17
C234	a_216_387##5	X#3	5.17321e-17
C235	X#2	a_216_387##5	3.00749e-17
C236	X#4	B1#1	1.12147e-18
C237	a_216_387##14	a_216_387##13	1.38206e-18
C238	a_27_125##2	B1#4	1.06126e-19
C239	A1#3	B1#5	3.74988e-17
C240	B1#1	VPWR#8	3.47488e-17
C241	VPWR#9	a_216_387##13	2.17754e-19
C242	X#4	B1#6	2.03381e-19
C243	B1#1	a_216_387##14	1.78395e-17
C244	a_116_387#	a_216_387##13	2.57947e-19
C245	VPWR#8	B1#6	1.74748e-18
C246	VPWR#9	B1#1	8.55497e-19
C247	A1#3	A2#5	3.64518e-17
C248	VPWR#5	A1#2	1.37274e-20
C249	X#4	A1#1	6.04273e-20
C250	a_216_387##14	B1#6	4.04912e-17
C251	VGND#5	A2#3	6.27929e-20
C252	a_216_387##17	a_216_387##15	3.35021e-18
C253	VGND#4	VGND#1	2.6963e-17
C254	VPWR#8	A1#1	2.9276e-19
C255	B1#6	VPWR#9	2.55838e-17
C256	a_216_387##14	A1#1	1.07179e-18
C257	A2#4	A2#5	3.4814e-17
C258	A1#4	A1#3	3.97847e-19
C259	VPWR#5	A2#3	3.21383e-20
C260	A1#1	VPWR#9	2.81701e-17
C261	a_216_387##16	B1#6	2.82245e-19
C262	a_216_387##17	A1#2	5.51344e-19
C263	VGND#2	VGND#1	1.51553e-18
C264	a_216_387##14	A2#1	2.44352e-19
C265	a_216_387##15	A1#2	1.31704e-18
C266	a_116_387#	A1#1	5.33472e-17
C267	VGND#4	a_27_125#	4.45591e-17
C268	a_216_387##16	A1#1	9.67787e-18
C269	A1#4	A2#4	4.30536e-17
C270	X#5	a_216_387##5	5.67515e-17
C271	a_116_387#	A2#1	2.77322e-17
C272	a_116_387##2	A1#1	1.82138e-19
C273	VGND#4	a_27_125##2	1.97242e-17
C274	a_216_387##17	A2#3	3.09642e-20
C275	VGND#9	a_216_387##5	1.15493e-17
C276	a_216_387##16	A2#1	5.78725e-17
C277	VGND#2	X#1	1.05552e-17
C278	a_27_125##4	A2#3	7.66399e-17
C279	A1#7	A1#2	1.39185e-17
C280	a_116_387#	A2#6	4.6642e-19
C281	a_116_387##2	A2#1	4.08201e-19
C282	VPWR#4	VPWR#1	2.95983e-17
C283	VGND#3	VGND#8	5.93901e-20
C284	a_216_387##16	A2#6	4.29107e-17
C285	VPWR#3	a_216_387##10	3.11929e-20
C286	a_116_387##2	A2#6	3.15768e-17
C287	a_116_387#	A1#5	2.00195e-19
C288	A2#3	A1#7	2.3199e-17
C289	a_216_387##16	A1#5	1.77055e-18
C290	VPWR#6	A2#6	5.65869e-18
C291	VGND#3	X#5	5.94046e-18
C292	A1#5	a_116_387##2	3.37545e-17
C293	a_216_387##14	VPWR#4	8.73412e-18
C294	VPWR#6	A1#5	5.16506e-17
C295	VGND#5	VGND#9	1.60891e-19
C296	a_216_387##8	a_216_387##6	4.61442e-17
C297	a_27_125##2	A1#2	2.70142e-18
C298	VGND#2	X#5	8.13091e-18
C299	VGND#10	A1#2	4.29787e-19
C300	a_216_387##5	X#4	5.76438e-17
C301	a_216_387##12	a_216_387##8	3.09229e-17
C302	VPWR#4	VPWR#6	4.81957e-17
C303	VPWR#2	a_216_387##10	4.62695e-20
C304	VGND#1	X#3	1.75828e-18
C305	VGND#11	A2#3	2.91146e-19
C306	a_216_387##13	a_216_387##12	4.79218e-17
C307	VGND#3	a_27_125#	6.341e-18
C308	B1#1	a_216_387##13	1.49117e-17
C309	X#2	VGND#1	2.64926e-17
C310	A1#2	VPWR#9	7.37167e-19
C311	VGND	a_216_387##10	8.86766e-19
C312	A1#2	a_116_387#	6.15627e-19
C313	VGND#4	B1#3	1.11752e-18
C314	a_216_387##16	A1#2	1.23996e-18
C315	a_216_387##17	B1	4.58238e-17
C316	A1#7	a_216_387##15	8.36689e-18
C317	B1#6	B1#1	2.48335e-17
C318	B1	a_216_387##15	7.53602e-17
C319	VGND#4	B1#5	1.11953e-18
C320	A1#1	a_216_387##13	2.82185e-19
C321	VPWR#2	a_216_387##3	4.52154e-20
C322	VGND#5	a_27_125##2	3.05334e-17
C323	a_116_387#	A2#3	2.38557e-19
C324	X#2	X#1	2.11664e-18
C325	X#3	a_216_387##10	1.26844e-18
C326	A2#3	a_216_387##16	5.70157e-17
C327	a_216_387##12	a_216_387##3	1.54238e-18
C328	A2#3	a_116_387##2	2.24356e-17
C329	A1#1	B1#6	2.72444e-17
C330	VPWR#6	A2#3	1.53424e-20
C331	A1	a_216_387##17	2.88592e-18
C332	A1	a_216_387##15	2.65871e-17
C333	A2#1	A1#1	3.06444e-17
C334	X#2	VGND#8	1.87828e-17
C335	A1#3	A1#2	5.55756e-19
C336	a_216_387##18	B1	4.70542e-17
C337	a_27_125##2	B1	2.83618e-18
C338	A2#6	A2#1	4.14784e-17
C339	VPWR#4	B1#1	1.70485e-18
C340	a_216_387##13	a_216_387##10	5.14424e-19
C341	A1#3	A2#3	1.90298e-19
C342	X#3	a_216_387##3	5.04894e-17
C343	VGND#5	a_27_125##6	2.52258e-18
C344	A1#5	A2#6	3.425e-17
C345	a_27_125##2	A1	2.72547e-17
C346	A1#4	A2#3	2.09898e-17
C347	X#2	VGND#9	4.71779e-20
C348	VPWR	VPWR#5	5.36367e-17
C349	VPWR	VPWR#3	5.45591e-17
C350	VPWR	VPWR#2	2.58849e-17
C351	VGND#1	X	1.43478e-17
C352	B1#4	a_216_387##13	3.95582e-18
C353	VPWR	X#3	1.33935e-18
C354	a_216_387##3	X#6	8.68916e-19
C355	VPWR	a_216_387##17	2.74592e-18
C356	VPWR	a_216_387##15	4.70817e-18
C357	a_216_387##10	VNB	7.67843e-17
C358	a_216_387##3	VNB	7.61724e-17
C359	B1#4	VNB	5.98158e-17
C360	VGND	VGND#5	4.64686e-17
C361	VPWR	A1#7	1.21666e-18
C362	VGND	VGND#3	4.01955e-17
C363	VGND	VGND#2	2.39228e-17
C364	X#3	B1#4	9.43534e-20
C365	X	VPWR#1	2.97846e-17
C366	VGND	X#3	2.87066e-18
C367	X#2	a_216_387##3	9.21582e-18
C368	VPWR#7	a_216_387##10	1.02039e-18
C369	VGND	X#2	2.14588e-18
C370	A1#5	A2#3	1.89744e-17
C371	VGND	a_216_387##17	6.02052e-18
C372	VGND	a_27_125##4	2.67219e-18
C373	VGND#9	a_216_387##17	2.92519e-17
C374	VGND	A1#7	1.31476e-18
C375	VPWR	VPWR#1	4.05356e-17
C376	VGND	VGND#1	4.02831e-17
C377	VPWR	X#6	1.7185e-17
C378	VGND	X#1	1.42168e-17
C379	VPWR	VPWR#7	2.10908e-17
C380	VGND	VGND#8	1.84937e-17
C381	VPWR	X#4	1.71794e-17
C382	VGND	X#5	1.50076e-17
C383	B1	a_216_387##13	5.18946e-19
C384	VGND	a_27_125#	2.40016e-17
C385	VPWR	a_216_387##14	1.34281e-17
C386	VGND	a_216_387##18	7.04365e-18
C387	VGND	a_27_125##2	2.235e-17
C388	VPWR	a_116_387#	2.39902e-17
C389	VGND	a_27_125##6	1.06049e-17
C390	VPWR	a_216_387##16	1.02864e-17
C391	VPWR	a_116_387##2	2.14187e-17
C392	VGND	a_27_125##5	1.45446e-17
C393	VPWR	VPWR#6	4.91723e-17
C394	A2#3	A1#2	2.80817e-17
C395	a_216_387##17	a_27_125#	3.22812e-17
C396	VPWR#7	a_216_387##3	2.62103e-19
C397	VGND	X#4	3.22654e-18
C398	VGND	VPWR#6	4.17372e-18
C399	VGND#5	VNB	3.03329e-17
C400	VGND#3	VNB	2.78477e-17
C401	VGND	a_216_387#	5.09439e-19
C402	VGND#2	VNB	3.34651e-17
C403	VGND	a_216_387##7	5.50006e-19
C404	VPWR#5	VNB	5.05001e-17
C405	VPWR#3	VNB	3.38517e-17
C406	VGND	a_216_387##9	5.62765e-19
C407	VPWR#2	VNB	3.50627e-17
C408	X#3	VNB	5.37882e-18
C409	VGND	a_216_387##11	1.65934e-18
C410	X#2	VNB	3.66368e-18
C411	VPWR	a_216_387##6	2.25281e-19
C412	a_216_387##17	VNB	1.22342e-17
C413	VPWR	a_216_387##8	1.95051e-19
C414	a_27_125##4	VNB	3.40048e-18
C415	VGND	A1#3	5.17747e-18
C416	VPWR	a_216_387##12	2.47148e-19
C417	VGND	A2#5	3.87829e-18
C418	VPWR	a_216_387##13	2.46926e-18
C419	B1	A1#2	2.58325e-18
C420	A1#7	VNB	8.75559e-19
C421	VGND	A2#4	2.58553e-18
C422	X#4	a_216_387##10	4.64243e-18
C423	VPWR	B1#1	6.74691e-18
C424	VGND#1	VNB	6.67032e-17
C425	VGND	A1#4	6.81979e-18
C426	X#1	VNB	4.78176e-18
C427	VPWR	B1#6	5.27646e-18
C428	X#5	VNB	2.10043e-18
C429	VGND#9	VNB	9.31556e-18
C430	VPWR	A1#1	2.72928e-18
C431	A1	A1#2	5.43395e-18
C432	a_27_125#	VNB	1.99725e-17
C433	a_216_387##18	VNB	5.18079e-19
C434	a_27_125##2	VNB	7.96098e-18
C435	a_216_387##17	a_216_387##10	2.08568e-17
C436	VGND#10	VNB	7.77384e-18
C437	a_27_125##6	VNB	6.14913e-19
C438	VGND#11	VNB	5.11699e-18
C439	a_27_125##5	VNB	4.29715e-17
C440	VPWR	A1#5	3.0383e-18
C441	VPWR#1	VNB	7.70948e-17
C442	X#6	VNB	2.37737e-18
C443	VPWR#7	VNB	3.80492e-18
C444	X#4	VNB	3.61837e-18
C445	VPWR#8	VNB	2.72052e-18
C446	VPWR	VPWR#4	1.09898e-17
C447	a_216_387##14	VNB	3.79896e-18
C448	VPWR#9	VNB	1.96244e-18
C449	a_116_387#	VNB	5.13528e-18
C450	a_116_387##2	VNB	5.29841e-18
C451	VPWR	a_216_387##5	4.53341e-18
C452	VPWR#6	VNB	9.48202e-17
C453	a_216_387#	VNB	2.634e-17
C454	a_216_387##7	VNB	2.23688e-17
C455	a_216_387##9	VNB	2.2408e-17
C456	a_216_387##11	VNB	2.87642e-17
C457	B1#3	VNB	2.61587e-17
C458	B1#5	VNB	2.73127e-17
C459	VGND	VGND#4	1.53685e-17
C460	A1	B1	3.17201e-17
C461	A1#3	VNB	7.57333e-17
C462	VPWR	A2#3	3.35037e-18
C463	A2#5	VNB	2.39892e-17
C464	VGND	a_216_387##5	6.57498e-18
C465	A2#4	VNB	2.00407e-17
C466	A1#4	VNB	1.14605e-16
C467	a_216_387##6	VNB	3.60994e-17
C468	a_216_387##8	VNB	3.10958e-17
C469	a_216_387##12	VNB	3.51605e-17
C470	VGND	A2#3	3.33735e-18
C471	a_216_387##13	VNB	4.07223e-17
C472	B1#1	VNB	3.55736e-17
C473	B1#6	VNB	3.02698e-17
C474	A1#1	VNB	3.14454e-17
C475	A2#1	VNB	2.84203e-17
C476	VPWR	B1	3.33325e-18
C477	A2#6	VNB	2.76008e-17
C478	A1#5	VNB	6.07537e-17
C479	VPWR	A1	1.19838e-18
C480	VPWR#4	VNB	2.47097e-16
C481	VGND#4	VNB	2.62558e-16
C482	VGND	B1	4.3699e-18
C483	a_216_387##5	VNB	8.34288e-18
C484	VGND	A1	1.24195e-18
C485	A1#2	VNB	2.67732e-17
C486	VPWR	X	1.35214e-18
C487	A2#3	VNB	5.23978e-17
C488	VGND	X	2.07313e-18
C489	B1	VNB	4.0483e-18
C490	A1	VNB	6.34059e-19
C491	X	VNB	2.0301e-17
C492	VPWR	VNB	7.40384e-17
C493	VGND	VNB	6.95526e-17
C494	a_27_125##2	a_216_387##15	3.43158e-18
C495	VGND#6	A1#3	3.93202e-19
C496	VGND#6	A2#4	8.32199e-19
C497	VGND#4	VGND#6	5.43055e-17
C498	VGND#6	VGND#5	3.02378e-18
C499	VGND#6	a_27_125##6	2.54514e-18
C500	VGND#6	a_27_125##5	9.33693e-18
C501	VGND#6	A2#3	1.99649e-19
C502	VGND#6	a_27_125##4	2.64514e-19
C503	VGND#6	A1#4	2.61079e-17
C504	VGND	VGND#6	5.54264e-17
C505	VGND#6	VGND#10	4.29123e-19
C506	VGND#6	VNB	4.53457e-17
*
*
.ENDS sky130_fd_sc_hs__o21a_4
*
