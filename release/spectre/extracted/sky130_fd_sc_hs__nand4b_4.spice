* Extracted by Quantus, converted by sky130cad/quantus.py
*
*
*
*                       LINUX           Wed Nov 18 08:48:01 2026
*
*
*
*  PROGRAM  advgen
*
*  Name           : advgen - Quantus - (64-bit)
*  Version        : 25.1.0-p047
*  Build Date     : Thu Dec 11 23:20:30 PST 2025
*
*  HSPICE LIBRARY
*
*  OPERATING_TEMPERATURE 150
*  QRC_TECH_DIR <path>/tech
*
*
*

*
.SUBCKT sky130_fd_sc_hs__nand4b_4 VPB VNB VGND VPWR Y A_N D C B
*
*
*  caps2d version: 10
*
*
*       TRANSISTOR CARDS
*
*
XM24 a_27_158##12 A_N#5 VGND#10 VNB sky130_fd_pr__nfet_01v8_lvt l=0.15 w=0.74 ad=0.1962 as=0.19515 pd=2.05 ps=2.05
XM25 a_225_74##7 a_27_158##5 Y#7 VNB sky130_fd_pr__nfet_01v8_lvt l=0.15 w=0.74 ad=0.1962 as=0.2072 pd=2.05 ps=2.04
XM6 Y#7 a_27_158##8 a_225_74##8 VNB sky130_fd_pr__nfet_01v8_lvt l=0.15 w=0.74 ad=0.2072 as=0.2072 pd=2.04 ps=2.04
XM23 a_225_74##8 a_27_158##7 Y#5 VNB sky130_fd_pr__nfet_01v8_lvt l=0.15 w=0.74 ad=0.2072 as=0.2072 pd=2.04 ps=2.04
XM19 Y#5 a_27_158##6 a_225_74##4 VNB sky130_fd_pr__nfet_01v8_lvt l=0.15 w=0.74 ad=0.2072 as=0.2072 pd=2.04 ps=2.04
XM7 a_656_74##3 B#6 a_225_74##4 VNB sky130_fd_pr__nfet_01v8_lvt l=0.15 w=0.74 ad=0.2072 as=0.2072 pd=2.04 ps=2.04
XM26 a_225_74##2 B#10 a_656_74##3 VNB sky130_fd_pr__nfet_01v8_lvt l=0.15 w=0.74 ad=0.2072 as=0.2072 pd=2.04 ps=2.04
XM4 a_225_74##2 B#9 a_656_74# VNB sky130_fd_pr__nfet_01v8_lvt l=0.15 w=0.74 ad=0.2072 as=0.2072 pd=2.04 ps=2.04
XM11 a_656_74# B#7 a_225_74# VNB sky130_fd_pr__nfet_01v8_lvt l=0.15 w=0.74 ad=0.2072 as=0.19515 pd=2.04 ps=2.05
XM13 a_1025_158##6 C#8 a_656_74##4 VNB sky130_fd_pr__nfet_01v8_lvt l=0.15 w=0.74 ad=0.1962 as=0.2072 pd=2.05 ps=2.04
XM14 a_1025_158##4 C#7 a_656_74##4 VNB sky130_fd_pr__nfet_01v8_lvt l=0.15 w=0.74 ad=0.2072 as=0.2072 pd=2.04 ps=2.04
XM8 a_656_74##6 C#5 a_1025_158##4 VNB sky130_fd_pr__nfet_01v8_lvt l=0.15 w=0.74 ad=0.2183 as=0.2072 pd=2.07 ps=2.04
XM12 a_656_74##6 C#1 a_1025_158##8 VNB sky130_fd_pr__nfet_01v8_lvt l=0.15 w=0.74 ad=0.2183 as=0.2072 pd=2.07 ps=2.04
XM20 VGND#9 D#5 a_1025_158##8 VNB sky130_fd_pr__nfet_01v8_lvt l=0.15 w=0.74 ad=0.2072 as=0.2072 pd=2.04 ps=2.04
XM21 a_1025_158##7 D#9 VGND#9 VNB sky130_fd_pr__nfet_01v8_lvt l=0.15 w=0.74 ad=0.2072 as=0.2072 pd=2.04 ps=2.04
XM9 a_1025_158##7 D#7 VGND#8 VNB sky130_fd_pr__nfet_01v8_lvt l=0.15 w=0.74 ad=0.2072 as=0.2923 pd=2.04 ps=2.27
XM15 VGND#8 D#1 a_1025_158# VNB sky130_fd_pr__nfet_01v8_lvt l=0.15 w=0.74 ad=0.2923 as=0.2109 pd=2.27 ps=2.05
XM0 VPWR#12 A_N#4 a_27_158##13 VPB sky130_fd_pr__pfet_01v8 l=0.15 w=0.84 ad=0.2898 as=0.252 pd=2.37 ps=2.28
XM16 a_27_158##13 A_N#1 VPWR#11 VPB sky130_fd_pr__pfet_01v8 l=0.15 w=0.84 ad=0.252 as=0.406 pd=2.28 ps=3.01
XM1 VPWR#11 a_27_158##9 Y#8 VPB sky130_fd_pr__pfet_01v8 l=0.15 w=1.12 ad=0.406 as=0.7952 pd=3.01 ps=3.66
XM3 Y#8 a_27_158# VPWR#10 VPB sky130_fd_pr__pfet_01v8 l=0.15 w=1.12 ad=0.7952 as=1.4672 pd=3.66 ps=4.86
XM5 Y#9 B#8 VPWR#10 VPB sky130_fd_pr__pfet_01v8 l=0.15 w=1.12 ad=0.336 as=1.4672 pd=2.84 ps=4.86
XM17 VPWR#9 B#1 Y#9 VPB sky130_fd_pr__pfet_01v8 l=0.15 w=1.12 ad=1.2264 as=0.336 pd=4.43 ps=2.84
XM18 VPWR#9 C#9 Y#2 VPB sky130_fd_pr__pfet_01v8 l=0.15 w=1.12 ad=1.2264 as=0.7616 pd=4.43 ps=3.6
XM22 Y#2 C#4 VPWR#8 VPB sky130_fd_pr__pfet_01v8 l=0.15 w=1.12 ad=0.7616 as=1.3104 pd=3.6 ps=4.58
XM2 VPWR#8 D#8 Y#1 VPB sky130_fd_pr__pfet_01v8 l=0.15 w=1.12 ad=1.3104 as=0.3584 pd=4.58 ps=2.88
XM10 Y#1 D#6 VPWR#1 VPB sky130_fd_pr__pfet_01v8 l=0.15 w=1.12 ad=0.3584 as=0.3864 pd=2.88 ps=2.93
*
*
*       RESISTOR AND CAP/DIODE CARDS
*
Rg1	A_N#1	A_N#2	520.417480
Rg2	A_N#2	A_N#3	13.420451
Rg3	A_N#2	A_N#4	359.578186
Rg4	A_N#3	A_N#5	341.940796
Rg5	a_27_158#	a_27_158##2	488.976654
Rg6	a_27_158##2	a_27_158##3	41.785271
Rg7	a_27_158##3	a_27_158##4	49.558250
Rg8	a_27_158##4	a_27_158##5	500.003571
Rg9	a_27_158##2	a_27_158##6	336.104004
Rg10	a_27_158##3	a_27_158##7	300.089050
Rg11	a_27_158##4	a_27_158##8	322.990906
Rg12	a_27_158##4	a_27_158##9	469.777618
Rg13	B#1	B#2	467.117920
Rg14	B#2	B#3	44.712490
Rg15	B#3	B#4	29.841619
Rg16	B#4	B#5	76.032433
Rg17	B#5	B#6	458.737000
Rg18	B#2	B#7	369.474335
Rg19	B#3	B#8	419.123199
Rg20	B#4	B#9	370.752045
Rg21	B#5	B#10	377.027313
Rg22	C#1	C#2	397.555725
Rg23	C#2	C#3	89.849564
Rg24	C#2	C#4	449.655212
Rg25	C#3	C#5	377.027313
Rg26	C#3	C#6	43.647682
Rg27	C#6	C#7	394.805237
Rg28	C#6	C#8	465.569550
Rg29	C#6	C#9	448.030548
Rg30	D#1	D#2	334.647186
Rg31	D#2	D#3	74.307770
Rg32	D#3	D#4	226.261963
Rg33	D#4	D#5	539.202332
Rg34	D#2	D#6	437.647369
Rg35	D#3	D#7	365.868195
Rg36	D#3	D#8	468.868408
Rg37	D#4	D#9	328.696167
Rf1	A_N#6	A_N	1.879015
Rf2	A_N#3	A_N#8	81.995415
Rf3	A_N#6	A_N#8	7.146308
Rf4	A_N#9	A_N	1.879015
Rf5	A_N#8	A_N#9	6.046876
Rf6	a_27_158##3	a_27_158##11	107.483124
Rf7	a_27_158##11	a_27_158##12	86.942238
Rf8	a_27_158##11	a_27_158##13	35.160492
Rf9	B#5	B	55.406132
Rf10	a_225_74#	a_225_74##3	77.823425
Rf11	a_225_74##3	a_225_74##5	72.669952
Rf12	a_225_74##5	a_225_74##6	82.564590
Rf13	a_225_74##6	a_225_74##7	75.872559
Rf14	a_225_74##6	a_225_74##8	20.399406
Rf15	a_225_74##2	a_225_74##3	15.000000
Rf16	a_225_74##4	a_225_74##5	15.000000
Rf17	a_656_74##2	a_656_74##3	58.999928
Rf18	a_656_74##2	a_656_74##5	70.832367
Rf19	a_656_74##5	a_656_74##6	51.104279
Rf20	a_656_74#	a_656_74##2	15.000000
Rf21	a_656_74##4	a_656_74##5	15.000000
Rf22	C	C#10	5.806452
Rf23	C#10	C	8.862479
Rf24	Y#1	Y#3	150.950500
Rf25	Y#3	Y#4	124.645248
Rf26	Y#4	Y	37.568871
Rf27	Y	Y#6	138.626007
Rf28	Y#6	Y#7	53.863026
Rf29	Y#4	Y#8	138.291107
Rf30	Y#4	Y#9	25.395393
Rf31	Y#2	Y#3	2.500000
Rf32	Y#5	Y#6	15.000000
Rf33	a_1025_158#	a_1025_158##2	83.831841
Rf34	a_1025_158##2	a_1025_158##3	60.710083
Rf35	a_1025_158##3	a_1025_158##5	63.158970
Rf36	a_1025_158##5	a_1025_158##6	66.312012
Rf37	a_1025_158##2	a_1025_158##7	23.096294
Rf38	a_1025_158##3	a_1025_158##8	24.916723
Rf39	a_1025_158##4	a_1025_158##5	15.000000
Rf40	D#10	D	1.113320
Rf41	D#11	D	1.113320
Rf42	D#10	D#11	13.193184
Rf43	D#2	D#13	54.524254
Rf44	D#11	D#13	3.023438
Rf45	D#14	D	1.113320
Rf46	D#13	D#14	10.169745
Rf47	VPWR#1	VPWR#2	104.902000
Rf48	VPWR#2	VPWR#3	198.374756
Rf49	VPWR#3	VPWR#4	150.124893
Rf50	VPWR#4	VPWR#5	124.599609
Rf51	VPWR#5	VPWR#6	75.558197
Rf53	VPWR#2	VPWR#8	10.763660
Rf54	VPWR#3	VPWR#9	10.281279
Rf55	VPWR#4	VPWR#10	9.909842
Rf56	VPWR#5	VPWR#11	37.695530
Rf57	VPWR#6	VPWR#12	43.738586
Rf59	VGND#2	VGND#3	28.990618
Rf60	VGND#3	VGND#4	35.404957
Rf61	VGND#4	VGND#5	297.656250
Rf62	VGND#5	VGND#6	193.559280
Rf64	VGND#2	VGND#8	33.487690
Rf65	VGND#4	VGND#9	35.885353
Rf66	VGND#6	VGND#10	31.948624
Rf70	C#3	C#10	40.058201
Re1	VPWR#2	VPWR	3.246228
Re2	VPWR	VPWR#4	1.159367
Re3	VGND#3	VGND	3.246228
Re4	VGND	VGND#5	1.159367
*
*       CAPACITOR CARDS
*
*
C1	a_1025_158##2	VGND#9	1.39923e-17
C2	a_1025_158##8	D#9	4.45011e-19
C3	C#2	D#3	8.10105e-19
C4	a_1025_158##3	a_1025_158##8	1.88668e-18
C5	VGND#9	D#5	2.76049e-17
C6	Y#1	VPWR#1	8.99742e-17
C7	Y#1	D#4	3.84856e-18
C8	a_1025_158##7	C#1	1.94842e-19
C9	VGND#10	A_N#2	3.36728e-18
C10	D#5	a_1025_158##8	1.38466e-17
C11	VGND#5	B#4	1.25897e-20
C12	Y#5	Y#8	6.61852e-18
C13	VGND#5	B#3	1.64709e-19
C14	VGND#9	C#1	1.50272e-18
C15	VPWR#8	VPWR#1	3.07901e-18
C16	D#3	Y#1	6.01028e-19
C17	a_1025_158##3	a_656_74##6	1.34084e-17
C18	a_656_74##6	D#5	1.53954e-18
C19	a_225_74##6	B#6	1.89459e-19
C20	VGND#5	a_27_158##4	2.67194e-20
C21	C#1	a_1025_158##8	1.69424e-17
C22	Y#1	VPWR#8	1.28567e-16
C23	a_1025_158##4	D#5	2.17236e-19
C24	VGND#9	C#5	3.44067e-19
C25	C#6	C#2	3.2614e-18
C26	a_656_74##6	C#1	3.65239e-17
C27	D#3	D#2	3.15944e-18
C28	a_1025_158##4	a_1025_158##3	1.52928e-18
C29	a_225_74##6	a_27_158##6	4.33532e-19
C30	Y#2	Y#1	1.04638e-18
C31	a_1025_158##8	C#5	1.91297e-19
C32	VPWR#8	D#4	2.07298e-18
C33	a_27_158##12	A_N#2	7.53525e-18
C34	a_1025_158##4	C#1	4.96306e-19
C35	VGND#9	C#7	1.82013e-19
C36	a_656_74##6	C#5	4.09493e-17
C37	Y#2	VPWR#8	1.56264e-16
C38	VPWR#8	D#3	3.42587e-19
C39	a_225_74##6	a_27_158##7	1.9346e-17
C40	a_1025_158##8	C#7	8.1054e-20
C41	a_1025_158##4	C#5	3.10673e-17
C42	VGND#9	C#8	1.45165e-19
C43	VGND#8	D#3	2.80847e-19
C44	a_656_74##6	C#7	5.94406e-19
C45	VPWR#8	C#6	5.05563e-20
C46	a_656_74##4	C#5	9.51658e-19
C47	a_225_74##6	a_27_158##8	2.42426e-17
C48	a_1025_158##4	C#7	3.89272e-17
C49	Y#2	VPWR#9	3.40241e-18
C50	VPWR#8	C#2	1.95158e-20
C51	Y#2	D#4	6.21183e-19
C52	VGND#4	a_1025_158##3	1.07206e-18
C53	a_656_74##6	C#8	1.3547e-19
C54	VPWR#3	C#4	9.63445e-19
C55	a_656_74##4	C#7	3.51987e-17
C56	a_225_74#	C#5	1.46086e-19
C57	Y#9	Y#2	8.74596e-19
C58	a_1025_158##4	C#8	1.55851e-18
C59	a_225_74##6	a_27_158##5	2.27377e-18
C60	a_1025_158##6	C#7	1.10168e-18
C61	a_656_74##6	B#7	2.9932e-20
C62	a_656_74##4	C#8	3.89234e-17
C63	a_225_74#	C#7	1.97701e-19
C64	VPWR#3	C#9	3.84949e-17
C65	VGND#4	a_1025_158##2	3.55691e-19
C66	C#6	Y#2	1.16907e-17
C67	a_1025_158##6	C#8	5.04829e-17
C68	a_656_74##4	B#7	8.4592e-19
C69	C#2	Y#2	1.40068e-18
C70	a_225_74#	C#8	1.51277e-18
C71	VPWR#10	Y#9	6.87678e-17
C72	B#5	B#4	1.97476e-18
C73	a_27_158##11	a_27_158##5	1.39186e-17
C74	a_1025_158##6	B#7	2.52388e-18
C75	VGND#9	D#4	8.31749e-19
C76	VPWR#3	B#1	3.06216e-17
C77	a_1025_158##3	D#4	1.49674e-18
C78	a_656_74##4	B#9	2.81179e-19
C79	a_225_74#	B#7	3.44608e-17
C80	Y#8	Y#9	7.42317e-19
C81	a_1025_158##6	B#9	4.57372e-19
C82	a_27_158##11	A_N#5	7.44072e-19
C83	a_656_74#	B#7	3.7063e-17
C84	a_225_74#	Y#4	3.59402e-18
C85	C#6	VPWR#9	9.1918e-19
C86	a_656_74##4	B#10	2.21077e-19
C87	Y#8	VPWR#10	1.44111e-16
C88	VPWR#3	B#8	2.25145e-18
C89	a_1025_158##6	B#10	2.93312e-19
C90	Y#4	C#4	1.81197e-19
C91	a_656_74#	B#9	3.31193e-17
C92	VPWR#11	VPWR#10	1.217e-18
C93	a_656_74#	Y#4	6.04044e-19
C94	a_27_158##3	B#3	2.59478e-19
C95	a_225_74##2	B#9	2.62455e-17
C96	a_1025_158##2	D#4	2.57107e-18
C97	a_225_74##4	B#7	6.27228e-19
C98	a_1025_158##6	B#6	2.07041e-19
C99	VPWR#11	Y#8	9.77864e-17
C100	a_27_158##3	a_27_158##4	1.90585e-17
C101	Y#4	C#9	5.89273e-19
C102	Y#5	B#7	2.63003e-19
C103	a_225_74##2	B#10	2.62345e-17
C104	a_225_74##4	B#9	8.66025e-19
C105	B#4	B#3	1.27621e-18
C106	VPWR#5	a_27_158##9	4.21069e-18
C107	VPWR#8	D#5	1.12921e-18
C108	a_1025_158##2	D#3	1.64185e-18
C109	a_656_74##3	B#10	3.31193e-17
C110	a_1025_158##3	C#2	1.27015e-18
C111	Y#5	B#9	3.13253e-19
C112	a_27_158##13	VPWR#11	6.42399e-17
C113	Y#4	B#1	2.04307e-17
C114	a_225_74##4	B#10	1.51849e-18
C115	Y#2	D#5	8.993e-19
C116	a_656_74##3	B#6	2.49421e-17
C117	VPWR#12	VPWR#11	7.06476e-18
C118	Y#5	B#10	3.64935e-18
C119	VPWR#5	A_N#1	3.57688e-18
C120	a_225_74##4	B#6	2.75623e-17
C121	Y#4	B#8	2.39094e-17
C122	VPWR#12	a_27_158##13	7.27591e-17
C123	A_N#3	A_N#2	1.18353e-17
C124	B#3	Y#9	2.48606e-19
C125	a_656_74##3	a_27_158##6	7.93185e-19
C126	Y#5	B#6	1.35889e-17
C127	A_N#2	a_27_158##5	3.9723e-18
C128	a_225_74##4	a_27_158##6	3.22071e-17
C129	a_1025_158#	VGND#8	5.53122e-17
C130	Y#4	a_27_158#	4.3907e-19
C131	a_656_74##6	C#6	6.48961e-19
C132	Y#5	a_27_158##6	3.21261e-17
C133	a_225_74##4	a_27_158##7	4.01452e-19
C134	B#4	VPWR#10	2.05313e-18
C135	Y#2	C#8	2.92199e-18
C136	Y#5	a_27_158##7	3.64699e-17
C137	a_656_74##6	C#2	4.24218e-19
C138	a_1025_158##7	a_1025_158#	2.5805e-18
C139	a_225_74##4	a_27_158##8	1.69348e-19
C140	VPWR#10	B#3	1.92797e-20
C141	a_27_158##7	a_225_74##8	9.2161e-18
C142	C#8	VPWR#9	8.46084e-19
C143	D#7	D#1	1.83661e-17
C144	Y#5	a_27_158##8	1.2972e-18
C145	VPWR#3	VPWR#8	1.70735e-18
C146	a_1025_158##7	VGND#8	3.92657e-17
C147	VGND#10	a_27_158##6	3.87439e-20
C148	Y#4	VPWR#3	5.73347e-17
C149	a_27_158##8	a_225_74##8	1.44891e-17
C150	a_1025_158##4	C#6	4.95231e-18
C151	VGND#3	VGND#4	8.30634e-17
C152	Y#5	a_27_158##5	6.09343e-19
C153	Y#7	a_27_158##8	3.22785e-17
C154	D#9	D#7	4.00793e-17
C155	VGND#10	a_27_158##7	6.74911e-20
C156	VGND#9	VGND#8	2.1736e-18
C157	a_225_74##7	a_27_158##8	1.60728e-18
C158	Y#4	C#6	2.17825e-20
C159	Y#2	VPWR#3	1.22318e-16
C160	a_1025_158##4	C#2	1.93989e-19
C161	a_27_158##12	a_27_158##7	2.34842e-19
C162	Y#5	A_N#5	4.2873e-19
C163	Y#7	a_27_158##5	2.83973e-17
C164	a_225_74##6	a_225_74##4	2.27239e-18
C165	VGND#10	a_27_158##8	1.89435e-19
C166	D#5	D#9	3.88881e-17
C167	a_225_74##7	a_27_158##5	5.37571e-17
C168	VGND#9	a_1025_158##7	3.90121e-17
C169	a_27_158##12	a_27_158##8	3.38736e-19
C170	Y#7	A_N#5	1.34515e-18
C171	VGND#10	a_27_158##5	2.07481e-18
C172	VPWR#3	VPWR#9	2.40396e-17
C173	a_656_74##4	C#6	1.23358e-18
C174	a_225_74##6	Y#5	4.7131e-17
C175	a_225_74##7	A_N#5	4.42145e-18
C176	a_27_158##12	a_27_158##5	1.13371e-18
C177	Y#8	a_27_158##4	7.26569e-19
C178	a_1025_158##8	a_1025_158##7	2.44957e-18
C179	C#1	D#5	4.11184e-17
C180	VGND#10	A_N#5	4.27763e-17
C181	a_27_158##11	A_N#1	1.30285e-17
C182	Y#4	B#4	2.84696e-18
C183	a_27_158##12	A_N#5	3.68168e-17
C184	C#2	D#8	8.71358e-20
C185	Y#9	VPWR#3	7.16165e-17
C186	a_225_74##6	a_225_74##8	2.13484e-18
C187	a_1025_158##8	VGND#9	3.89481e-17
C188	C#5	C#1	3.58715e-17
C189	VGND#3	a_1025_158##3	3.18699e-18
C190	VPWR#5	VPWR#10	5.90029e-19
C191	VGND#3	a_1025_158##2	3.76013e-18
C192	Y#4	B#3	6.2024e-18
C193	a_656_74##6	VGND#9	1.67431e-18
C194	a_1025_158##6	C#6	1.36086e-18
C195	a_225_74##6	Y#7	2.34107e-17
C196	VPWR#10	VPWR#3	3.1485e-18
C197	VPWR#11	a_27_158##4	6.80814e-19
C198	a_1025_158##2	Y#1	4.91922e-18
C199	C#7	C#5	3.78446e-17
C200	D#6	VPWR#1	3.43185e-17
C201	Y#8	VPWR#5	1.63911e-17
C202	a_656_74##6	a_1025_158##8	4.02054e-17
C203	Y#1	D#6	5.60437e-17
C204	a_27_158##11	Y#5	2.88967e-18
C205	a_225_74##7	a_225_74##6	6.69423e-18
C206	VPWR#1	D#8	1.31103e-18
C207	VPWR#8	D#6	4.25091e-18
C208	C#8	C#7	4.11236e-17
C209	Y#1	D#8	3.67514e-17
C210	a_1025_158##4	a_1025_158##8	1.07049e-18
C211	Y#2	D#6	3.49435e-19
C212	VPWR#11	a_27_158##5	1.26867e-18
C213	VPWR#8	D#8	7.70313e-17
C214	a_27_158##13	a_27_158##4	7.96947e-20
C215	Y#1	C#4	3.06837e-19
C216	Y#2	D#8	5.6953e-19
C217	B#7	C#8	4.06134e-18
C218	a_656_74##6	a_1025_158##4	3.92553e-17
C219	VPWR#8	C#4	6.97392e-17
C220	a_27_158##11	Y#7	2.41696e-17
C221	a_1025_158##2	D#2	1.06178e-18
C222	Y#2	C#4	5.2304e-17
C223	a_27_158##13	VPWR#5	2.93396e-18
C224	a_656_74##4	a_656_74##6	1.69485e-18
C225	VPWR#8	C#9	9.63876e-19
C226	B#9	B#7	4.0236e-17
C227	a_27_158##13	A_N#2	9.44515e-19
C228	VGND#5	a_225_74##6	3.85989e-17
C229	Y#2	C#9	5.92902e-17
C230	Y#4	Y#2	1.96122e-19
C231	VGND#4	D#7	7.23729e-19
C232	VGND#3	a_1025_158#	1.83724e-17
C233	a_27_158##11	a_225_74##7	2.7191e-17
C234	C#9	VPWR#9	3.82544e-17
C235	a_1025_158##4	a_656_74##4	2.59357e-17
C236	B	B#4	1.47658e-17
C237	B#10	B#9	4.0236e-17
C238	Y#2	B#1	5.53476e-19
C239	B	B#3	7.75632e-19
C240	Y#9	C#9	4.18902e-19
C241	a_27_158##3	VPWR#5	4.09934e-19
C242	VGND#3	a_1025_158##7	2.42319e-17
C243	a_225_74#	B#3	2.75801e-18
C244	B	a_27_158##4	6.83403e-20
C245	B#1	VPWR#9	3.82544e-17
C246	B#1	C#6	1.26655e-19
C247	Y#4	VPWR#9	8.74908e-18
C248	VGND#3	a_1025_158##8	1.24822e-17
C249	Y#2	B#8	3.20873e-19
C250	a_1025_158##6	a_1025_158##4	3.76358e-18
C251	B#1	Y#9	2.43705e-17
C252	a_225_74#	a_656_74##6	1.5679e-18
C253	VGND#4	D#9	4.79639e-18
C254	VGND#3	a_656_74##6	4.58883e-18
C255	a_225_74##7	A_N#1	9.17039e-19
C256	B#6	B#10	4.0236e-17
C257	A_N#2	a_27_158##4	8.24807e-19
C258	VPWR#10	B#1	2.30635e-18
C259	A_N#2	VPWR#12	9.41306e-18
C260	a_27_158##11	VPWR#5	1.9442e-19
C261	Y#4	B#5	6.63403e-18
C262	VGND#4	C#6	1.62185e-19
C263	B#8	Y#9	2.88944e-17
C264	Y#8	B#1	1.74758e-19
C265	a_656_74#	B#4	9.82675e-20
C266	B#3	B#1	1.4229e-18
C267	a_656_74##4	a_1025_158##6	4.68501e-17
C268	C	D#4	1.09807e-17
C269	Y#4	Y#9	1.406e-18
C270	VPWR#10	B#8	7.79039e-17
C271	C	D#3	1.77169e-18
C272	C	C#6	4.0556e-17
C273	a_27_158##6	B#6	3.6975e-17
C274	C	C#2	1.9295e-17
C275	Y#9	a_27_158#	4.28247e-19
C276	Y#8	B#8	7.71349e-19
C277	VGND#4	D#5	4.11716e-18
C278	C	B#3	9.7982e-18
C279	a_656_74#	B#3	1.20289e-18
C280	Y#4	a_27_158##3	5.20327e-20
C281	VPWR#10	a_27_158#	7.33001e-17
C282	a_1025_158#	D#2	2.79625e-17
C283	a_656_74##4	a_225_74#	4.0313e-21
C284	VGND#4	C#2	3.7053e-20
C285	D#2	VGND#8	1.73509e-18
C286	Y#8	a_27_158#	5.14511e-17
C287	Y#4	VPWR#10	6.60268e-17
C288	a_27_158##7	a_27_158##6	3.61531e-17
C289	VPWR#10	a_27_158##9	8.65639e-19
C290	VPWR#11	a_27_158#	1.97324e-18
C291	a_27_158##11	B#5	1.33364e-19
C292	VGND#5	a_656_74##4	1.90416e-17
C293	a_225_74#	a_1025_158##6	1.77581e-17
C294	a_225_74##6	a_27_158##3	8.93733e-19
C295	a_27_158##9	Y#8	4.49218e-17
C296	a_27_158##13	a_27_158#	4.13286e-19
C297	VGND#4	C#1	5.83457e-18
C298	a_225_74##2	B#4	1.46929e-19
C299	VPWR#11	a_27_158##9	6.66779e-17
C300	a_27_158##8	a_27_158##7	3.46177e-17
C301	VGND#5	a_656_74#	5.43277e-17
C302	D	D#4	8.97493e-18
C303	Y#8	Y#4	4.96412e-19
C304	D	D#3	1.80408e-17
C305	a_27_158##13	a_27_158##9	2.20847e-18
C306	VPWR#2	VPWR#1	6.44566e-17
C307	a_27_158##11	a_27_158##3	3.76016e-21
C308	D	C#2	1.24693e-18
C309	a_656_74##4	a_225_74##2	9.64006e-22
C310	VGND#5	a_656_74##3	2.89125e-17
C311	VPWR#2	Y#1	1.98349e-17
C312	A_N#1	VPWR#11	1.86358e-17
C313	VPWR#12	a_27_158##9	1.54138e-18
C314	D#5	D#4	1.84431e-18
C315	a_225_74##2	B#3	4.92377e-19
C316	VGND#5	a_225_74##4	3.95402e-17
C317	VPWR#2	VPWR#8	1.91607e-16
C318	a_27_158##13	A_N#1	5.04642e-17
C319	a_27_158##5	a_27_158##8	3.46275e-17
C320	VGND#4	C#5	5.51273e-18
C321	VPWR#2	Y#2	3.67298e-18
C322	VPWR#12	A_N#1	1.50665e-18
C323	VPWR#11	A_N#4	1.40435e-18
C324	a_225_74#	a_656_74#	5.68748e-17
C325	a_27_158##13	A_N#4	4.42377e-17
C326	A_N#5	a_27_158##5	4.10121e-18
C327	A_N#4	VPWR#12	2.4972e-17
C328	a_1025_158##6	a_656_74##3	1.41992e-20
C329	VGND#4	C#7	5.23657e-18
C330	C#2	D#5	1.49341e-17
C331	a_656_74#	B#5	1.2717e-19
C332	a_225_74##2	B#5	9.46394e-19
C333	a_656_74#	a_225_74##2	3.5054e-17
C334	a_656_74##3	B#5	6.90763e-19
C335	A_N	A_N#2	3.05338e-17
C336	D#2	VPWR#1	1.70741e-17
C337	a_225_74##4	B#5	2.94882e-19
C338	Y#5	B#5	5.49161e-18
C339	D#2	Y#1	1.33947e-17
C340	D#2	VPWR#8	1.13722e-19
C341	VGND#4	C#8	5.26625e-18
C342	a_225_74##4	a_225_74#	3.64033e-20
C343	VGND#3	D#1	5.69488e-19
C344	a_225_74##4	a_27_158##3	4.61512e-20
C345	a_1025_158##3	D#7	6.79809e-21
C346	VGND#3	D#7	1.67329e-18
C347	Y#5	a_27_158##3	8.87586e-17
C348	D#8	D#6	4.34207e-17
C349	a_225_74##6	a_27_158##4	8.8333e-19
C350	VGND#3	D#9	2.14179e-18
C351	a_225_74##2	a_656_74##3	3.65389e-17
C352	Y#7	a_27_158##3	2.31462e-17
C353	a_1025_158##2	D#7	1.7386e-17
C354	Y	C#6	3.3641e-19
C355	VGND#3	D#5	6.67524e-19
C356	Y	B#4	6.31334e-18
C357	Y	B#3	2.10717e-17
C358	VGND#3	C#1	1.97626e-18
C359	C#4	D#8	2.31767e-18
C360	a_1025_158##3	D#9	1.63307e-20
C361	VGND#4	a_1025_158##8	1.09914e-17
C362	C#9	C#4	1.14005e-17
C363	a_1025_158##2	D#9	1.76639e-17
C364	B#5	VPWR#10	7.76464e-18
C365	a_27_158##12	A_N#3	1.98808e-17
C366	Y#8	B#5	7.97461e-18
C367	a_27_158##5	A_N#1	6.13627e-18
C368	a_225_74##4	a_656_74##3	4.15715e-17
C369	a_225_74##2	Y#5	1.5334e-17
C370	a_1025_158##3	D#5	1.43339e-17
C371	B#1	C#9	2.62155e-18
C372	B	Y#4	6.60525e-17
C373	VPWR#10	a_27_158##3	8.46474e-20
C374	a_27_158##3	Y#8	9.85877e-17
C375	VGND#4	a_656_74##6	3.08427e-17
C376	VPWR#3	C#8	1.25743e-18
C377	a_27_158##3	VPWR#11	3.11044e-17
C378	A_N#1	a_27_158##4	7.85023e-18
C379	VPWR	B#3	3.44268e-23
C380	VGND#5	B#7	5.16608e-18
C381	a_27_158##11	VPWR#11	1.07938e-17
C382	Y#5	a_656_74##3	2.24562e-19
C383	a_27_158##13	a_27_158##3	3.38415e-20
C384	B#8	B#1	4.74848e-17
C385	VPWR	A_N#2	6.44061e-21
C386	VGND#5	B#9	5.17014e-18
C387	a_1025_158##3	C	7.10125e-17
C388	a_1025_158##2	C	9.36639e-18
C389	VGND#5	B#10	5.17014e-18
C390	a_1025_158##3	C#1	1.77912e-17
C391	Y#4	C	5.19179e-17
C392	VGND#5	B#6	4.81385e-18
C393	a_225_74##4	Y#5	8.34133e-17
C394	a_27_158#	B#8	1.93625e-18
C395	A_N#3	VPWR#12	1.77865e-17
C396	VGND#5	a_27_158##6	4.43427e-18
C397	VGND#5	a_27_158##7	4.47052e-18
C398	VPWR#2	D#6	1.75176e-18
C399	VPWR#2	D#8	7.05683e-19
C400	a_27_158##9	a_27_158#	1.0313e-17
C401	a_1025_158##2	D	4.57738e-17
C402	a_1025_158##3	C#5	2.73282e-19
C403	Y#5	a_27_158##4	7.06557e-19
C404	VPWR#2	C#4	6.78855e-19
C405	B#6	B#5	3.87332e-18
C406	A_N#1	a_27_158##9	2.71464e-17
C407	VGND#4	a_656_74##4	3.45461e-17
C408	Y#5	a_225_74##8	6.51731e-19
C409	a_27_158##3	B#6	7.66698e-18
C410	a_1025_158##4	C	7.11634e-17
C411	A_N#4	A_N#1	3.67109e-17
C412	Y#5	B	4.53189e-17
C413	D#2	D#6	6.4287e-18
C414	a_1025_158##3	C#7	1.15791e-19
C415	a_656_74##4	C	2.85961e-18
C416	a_1025_158##6	C	4.29915e-17
C417	D	a_1025_158#	4.09681e-17
C418	a_656_74#	C	3.43153e-18
C419	D	VGND#8	3.77799e-18
C420	D	a_1025_158##7	2.21219e-18
C421	Y#5	A_N#2	1.20881e-20
C422	a_27_158##3	a_27_158##5	8.41775e-19
C423	C#8	C#6	3.20043e-18
C424	A_N	a_27_158##11	4.33888e-17
C425	VPWR#3	C#6	1.32397e-18
C426	Y	Y#4	7.13347e-18
C427	D#4	VNB	2.218e-17
C428	D#3	VNB	2.80418e-17
C429	C#6	VNB	5.92309e-17
C430	C#2	VNB	2.85562e-17
C431	B#4	VNB	1.3633e-17
C432	B	Y#8	3.86111e-17
C433	B#3	VNB	4.05893e-17
C434	C	Y#1	9.69517e-18
C435	a_27_158##4	VNB	3.49374e-17
C436	A_N#2	VNB	1.05716e-16
C437	VPWR	VPWR#5	7.03796e-17
C438	D#4	D#3	1.84431e-18
C439	VPWR	VPWR#3	1.88042e-16
C440	C	Y#2	1.81648e-16
C441	D	VPWR#1	3.5233e-17
C442	D	Y#1	6.32819e-17
C443	B#3	C#8	6.60381e-18
C444	VPWR	Y#4	8.32529e-18
C445	VPWR#2	D#2	1.92449e-18
C446	VGND	VGND#4	7.44279e-17
C447	A_N	VGND#10	3.032e-18
C448	VGND#3	D#2	2.55883e-18
C449	a_225_74##7	Y#7	7.91465e-18
C450	Y	a_1025_158##6	5.41081e-18
C451	A_N	a_27_158##12	4.32035e-17
C452	Y#4	C#8	4.67872e-19
C453	VPWR	a_27_158##11	1.14981e-18
C454	Y	a_225_74#	3.22541e-17
C455	C	D#5	9.44316e-18
C456	Y	a_656_74#	9.82984e-20
C457	Y	a_225_74##2	5.34192e-17
C458	a_27_158##11	a_27_158##4	8.85497e-21
C459	Y#7	a_27_158##4	4.12099e-18
C460	C	C#8	1.66426e-17
C461	VGND	a_1025_158##3	5.91156e-19
C462	VGND	Y#4	1.11099e-18
C463	A_N	a_27_158##13	1.01764e-17
C464	A_N	VPWR#12	2.3102e-17
C465	VGND#5	B#5	1.05161e-19
C466	VGND	a_225_74##6	2.46835e-17
C467	VGND#3	D#4	9.40948e-19
C468	VGND	a_27_158##11	9.79651e-18
C469	VGND#5	a_27_158##3	1.75932e-19
C470	a_1025_158#	D#1	4.61469e-17
C471	VGND#4	VNB	7.21185e-17
C472	VGND#3	D#3	4.42493e-20
C473	VPWR#5	VNB	3.66085e-17
C474	VPWR#3	VNB	6.19692e-17
C475	VGND#10	a_225_74##7	2.82709e-17
C476	a_27_158##12	Y#7	1.7783e-18
C477	VGND	a_656_74##6	1.73087e-17
C478	VGND	a_1025_158##4	6.36573e-18
C479	VPWR	VPWR#8	1.71261e-17
C480	B	B#1	6.93552e-19
C481	VGND	a_656_74##4	3.21023e-17
C482	a_1025_158##3	VNB	1.82701e-18
C483	C	D#8	4.15036e-19
C484	a_27_158##3	B#5	2.13249e-17
C485	VPWR	Y#2	3.02972e-17
C486	VGND	a_1025_158##6	6.37373e-18
C487	a_1025_158##2	VNB	6.93321e-19
C488	VGND	a_225_74#	7.94316e-18
C489	B	B#8	1.98539e-18
C490	D#1	VGND#8	1.97433e-17
C491	Y#4	VNB	4.88823e-19
C492	C	C#4	2.17906e-18
C493	VGND	a_656_74#	3.07902e-17
C494	VPWR	Y#9	1.5264e-17
C495	VPWR#3	B#3	1.90227e-20
C496	VGND	a_225_74##2	8.15685e-18
C497	VPWR	VPWR#10	2.18557e-16
C498	B	a_27_158#	1.0943e-19
C499	VGND	a_656_74##3	1.83735e-17
C500	Y	C#5	1.34172e-19
C501	C	C#9	2.18039e-18
C502	VPWR	Y#8	3.39403e-17
C503	VGND	a_225_74##4	2.07579e-17
C504	a_225_74##6	VNB	4.80967e-18
C505	Y	C#7	1.9715e-19
C506	VGND	Y#5	1.42057e-17
C507	VPWR	VPWR#11	2.10201e-17
C508	B	a_27_158##9	5.39889e-19
C509	C	B#1	1.63684e-18
C510	Y	C#8	2.92761e-18
C511	VPWR	a_27_158##13	1.46344e-17
C512	VGND	Y#7	5.86464e-18
C513	D	D#8	3.16064e-18
C514	a_27_158##11	VNB	1.21759e-17
C515	Y	B#7	9.23819e-18
C516	B	A_N#1	3.20804e-19
C517	a_1025_158#	D#7	9.94863e-19
C518	VGND	a_225_74##7	2.08428e-17
C519	VGND	VGND#10	1.61925e-17
C520	Y	B#9	7.73089e-18
C521	D	C#4	8.198e-20
C522	VPWR#5	a_27_158##4	9.53206e-21
C523	VGND	a_27_158##12	1.25988e-17
C524	Y	B#10	4.63431e-18
C525	a_27_158##11	A_N#2	2.37042e-17
C526	a_1025_158#	VNB	4.09599e-17
C527	VGND#8	VNB	1.39936e-18
C528	a_1025_158##7	D#1	8.5643e-19
C529	a_1025_158##7	VNB	4.63176e-18
C530	VGND#9	VNB	4.25909e-20
C531	a_1025_158##8	VNB	4.60013e-18
C532	a_656_74##6	VNB	3.32038e-18
C533	a_1025_158##4	VNB	6.84401e-19
C534	a_225_74##7	a_27_158##4	2.54394e-19
C535	a_656_74##4	VNB	9.49587e-18
C536	a_1025_158##6	VNB	5.08005e-18
C537	a_225_74#	VNB	4.30897e-18
C538	a_656_74#	VNB	9.8252e-18
C539	VGND#8	D#7	3.35406e-17
C540	a_656_74##3	VNB	2.98097e-18
C541	VPWR#2	C	6.19013e-18
C542	a_225_74##4	VNB	4.14713e-18
C543	Y#5	VNB	4.76899e-18
C544	VGND#3	C	4.78065e-18
C545	Y#7	VNB	2.79809e-19
C546	a_225_74##7	VNB	1.06231e-17
C547	VGND#10	VNB	1.3266e-17
C548	a_27_158##12	VNB	2.70967e-17
C549	VPWR#1	VNB	6.91887e-17
C550	VGND	C#5	7.48561e-19
C551	VPWR#2	D	6.47543e-18
C552	a_27_158##12	VGND#10	1.86447e-17
C553	VPWR	a_27_158##5	2.35303e-19
C554	Y#1	VNB	2.56975e-18
C555	VGND	C#7	9.91427e-19
C556	VPWR#8	VNB	7.0746e-17
C557	a_1025_158##2	VGND#8	1.81252e-17
C558	a_1025_158#	D#9	2.14887e-19
C559	VGND	C#8	9.58565e-19
C560	VGND#3	D	8.01699e-18
C561	Y#2	VNB	7.29376e-18
C562	VGND	B#7	9.62214e-19
C563	B	B#5	3.18502e-17
C564	Y#9	VNB	4.9799e-18
C565	VGND	B#9	9.31307e-19
C566	VPWR#10	VNB	7.10988e-17
C567	VGND	B#10	9.31307e-19
C568	Y#8	VNB	6.22253e-18
C569	a_27_158##3	B	2.27266e-17
C570	VPWR#11	VNB	5.97996e-18
C571	VGND	B#6	1.62164e-18
C572	a_1025_158##3	a_1025_158##7	8.98924e-20
C573	a_27_158##13	VNB	7.55063e-18
C574	D#7	a_1025_158##7	1.48068e-17
C575	VGND	a_27_158##6	1.6542e-18
C576	VPWR#12	VNB	4.7718e-17
C577	VGND	a_27_158##7	1.63902e-18
C578	VPWR	C#9	7.73592e-19
C579	D	D#2	2.54956e-17
C580	D#1	VNB	3.20659e-17
C581	D#7	VNB	2.50032e-17
C582	VGND	a_27_158##8	1.51207e-18
C583	VPWR	B#1	5.65349e-19
C584	D#9	VNB	2.48358e-17
C585	VGND	a_27_158##5	1.9986e-18
C586	D#5	VNB	3.74089e-17
C587	VPWR	B#8	8.99356e-19
C588	VGND	A_N#5	6.61233e-19
C589	C#1	VNB	2.78315e-17
C590	VPWR	a_27_158#	6.48997e-19
C591	C#5	VNB	2.94787e-17
C592	C#7	VNB	2.97998e-17
C593	VPWR	a_27_158##9	2.96456e-18
C594	C#8	VNB	5.28285e-17
C595	B#7	VNB	3.5098e-17
C596	VPWR	A_N#1	8.09582e-18
C597	VGND#8	D#9	1.40291e-18
C598	B#9	VNB	2.90407e-17
C599	VPWR	A_N#4	8.25674e-18
C600	B#10	VNB	2.86948e-17
C601	B#6	VNB	3.12052e-17
C602	a_27_158##6	VNB	2.6085e-17
C603	a_27_158##7	VNB	2.60522e-17
C604	a_27_158##8	VNB	2.49624e-17
C605	a_27_158##5	VNB	4.55691e-17
C606	VGND#9	D#7	1.43206e-18
C607	A_N#5	VNB	5.45433e-17
C608	Y	B#5	5.49456e-18
C609	D#6	VNB	4.12706e-17
C610	D#8	VNB	3.0881e-17
C611	Y	a_27_158##3	1.65547e-19
C612	C#4	VNB	3.08372e-17
C613	a_225_74##7	A_N#2	6.07295e-19
C614	C#9	VNB	3.07392e-17
C615	B#1	VNB	3.22795e-17
C616	B#8	VNB	3.27529e-17
C617	a_27_158#	VNB	3.34064e-17
C618	VPWR	a_27_158##3	4.86481e-18
C619	a_27_158##9	VNB	3.66307e-17
C620	VGND	VGND#5	1.8174e-16
C621	a_1025_158##2	a_1025_158##7	6.17484e-19
C622	D#9	a_1025_158##7	1.78876e-17
C623	A_N#1	VNB	4.23519e-17
C624	VPWR	A_N#3	2.04194e-18
C625	A_N#4	VNB	3.75815e-17
C626	VPWR#2	VNB	1.26114e-16
C627	C	D	3.49907e-17
C628	VGND#3	VNB	1.42995e-16
C629	VGND	a_27_158##3	5.5428e-18
C630	VGND	A_N#3	1.60472e-18
C631	a_1025_158##3	VGND#9	1.39481e-17
C632	VGND#5	VNB	1.03357e-16
C633	a_1025_158##8	D#7	1.85248e-19
C634	D#2	VNB	7.01398e-17
C635	Y	B	5.60211e-17
C636	B#5	VNB	4.55749e-17
C637	Y	C	2.54762e-17
C638	a_27_158##3	VNB	5.45852e-17
C639	VPWR	B	4.7651e-18
C640	A_N#3	VNB	2.06409e-18
C641	VPWR	C	1.18598e-17
C642	VGND	B	5.195e-18
C643	VPWR#5	A_N#2	1.61933e-20
C644	VGND	C	1.0861e-17
C645	VPWR	A_N	8.71298e-18
C646	VGND#9	D#9	3.18615e-17
C647	B	VNB	1.37884e-17
C648	VGND	A_N	4.66772e-18
C649	C	VNB	4.0302e-17
C650	D	VNB	3.20822e-17
C651	VGND	Y	8.29094e-18
C652	A_N	VNB	3.06017e-17
C653	Y	VNB	2.84134e-18
C654	VPWR	VNB	2.94245e-16
C655	VGND	VNB	3.18497e-16
C656	a_1025_158##7	D#5	4.65868e-19
C657	VPWR#6	VPWR#5	8.89837e-19
C658	VGND#6	A_N#5	2.7976e-18
C659	VGND#6	A_N#2	9.85927e-19
C660	VPWR#6	A_N#2	6.01145e-19
C661	VPWR#6	VNB	5.735e-17
C662	VGND#2	a_1025_158#	2.10217e-17
C663	VPWR	VPWR#6	1.03319e-16
C664	VGND#6	a_27_158##5	4.47355e-18
C665	VGND#2	D#2	3.08151e-19
C666	A_N	VPWR#6	1.71349e-18
C667	VGND#6	a_225_74##6	2.59097e-17
C668	VGND#2	VNB	4.38997e-17
C669	VGND#6	a_27_158##8	4.43427e-18
C670	VGND#6	a_27_158##4	9.20616e-20
C671	VGND#6	A_N#1	2.71808e-20
C672	A_N#3	VPWR#6	3.43739e-19
C673	VGND#6	VNB	7.81353e-17
C674	a_27_158##13	VPWR#6	3.78151e-18
C675	VGND#3	VGND#2	9.37957e-17
C676	VGND#2	D#9	8.40931e-19
C677	VPWR#6	VPWR#11	2.26689e-18
C678	VGND#4	VGND#2	1.16035e-18
C679	VGND#6	a_27_158##12	6.61867e-18
C680	VGND#6	a_27_158##11	2.5832e-18
C681	VGND#2	D#7	3.83201e-18
C682	VGND	VGND#6	1.29031e-16
C683	VPWR#6	A_N#4	2.36466e-18
C684	VGND#2	D#1	5.75611e-18
C685	VGND#9	VGND#2	4.31523e-19
C686	VPWR#6	a_27_158##9	1.17573e-18
C687	VGND#2	D	5.01029e-19
C688	VGND#6	a_225_74##7	4.41146e-17
*
*
.ENDS sky130_fd_sc_hs__nand4b_4
*
