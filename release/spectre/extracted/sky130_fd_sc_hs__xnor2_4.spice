* Extracted by Quantus, converted by sky130cad/quantus.py
*
*
*
*                       LINUX           Wed Nov 18 09:14:11 2026
*
*
*
*  PROGRAM  advgen
*
*  Name           : advgen - Quantus - (64-bit)
*  Version        : 25.1.0-p047
*  Build Date     : Thu Dec 11 23:20:30 PST 2025
*
*  HSPICE LIBRARY
*
*  OPERATING_TEMPERATURE 150
*  QRC_TECH_DIR <path>/tech
*
*
*

*
.SUBCKT sky130_fd_sc_hs__xnor2_4 VNB VPB VGND A VPWR Y B
*
*
*  caps2d version: 10
*
*
*       TRANSISTOR CARDS
*
*
XM22 VGND#14 A#5 a_27_74##4 VNB sky130_fd_pr__nfet_01v8_lvt l=0.15 w=0.64 ad=0.224 as=0.1824 pd=1.98 ps=1.85
XM28 a_27_74##2 A#1 VGND#14 VNB sky130_fd_pr__nfet_01v8_lvt l=0.15 w=0.64 ad=0.1792 as=0.224 pd=1.84 ps=1.98
XM23 a_116_368##13 B#6 a_27_74##2 VNB sky130_fd_pr__nfet_01v8_lvt l=0.15 w=0.64 ad=0.224 as=0.1792 pd=1.98 ps=1.84
XM1 a_27_74# B#1 a_116_368##13 VNB sky130_fd_pr__nfet_01v8_lvt l=0.15 w=0.64 ad=0.1824 as=0.224 pd=1.85 ps=1.98
XM2 a_511_74##5 a_116_368##10 Y#6 VNB sky130_fd_pr__nfet_01v8_lvt l=0.15 w=0.74 ad=0.2109 as=0.259 pd=2.05 ps=2.18
XM8 Y#6 a_116_368##9 a_511_74# VNB sky130_fd_pr__nfet_01v8_lvt l=0.15 w=0.74 ad=0.259 as=0.3293 pd=2.18 ps=2.37
XM7 a_511_74# a_116_368##7 Y#1 VNB sky130_fd_pr__nfet_01v8_lvt l=0.15 w=0.74 ad=0.3293 as=0.2072 pd=2.37 ps=2.04
XM3 Y#1 a_116_368# a_511_74##3 VNB sky130_fd_pr__nfet_01v8_lvt l=0.15 w=0.74 ad=0.2072 as=0.259 pd=2.04 ps=2.18
XM16 VGND#13 A#16 a_511_74##3 VNB sky130_fd_pr__nfet_01v8_lvt l=0.15 w=0.74 ad=0.3778 as=0.259 pd=2.72 ps=2.18
XM4 a_511_74##6 A#21 VGND#13 VNB sky130_fd_pr__nfet_01v8_lvt l=0.15 w=0.74 ad=0.2072 as=0.3778 pd=2.04 ps=2.72
XM17 VGND#12 A#19 a_511_74##6 VNB sky130_fd_pr__nfet_01v8_lvt l=0.15 w=0.74 ad=0.3778 as=0.2072 pd=2.72 ps=2.04
XM13 a_511_74##8 A#17 VGND#12 VNB sky130_fd_pr__nfet_01v8_lvt l=0.15 w=0.74 ad=0.2072 as=0.3778 pd=2.04 ps=2.72
XM11 VGND#11 B#13 a_511_74##8 VNB sky130_fd_pr__nfet_01v8_lvt l=0.15 w=0.74 ad=0.41 as=0.2072 pd=2.79 ps=2.04
XM9 a_511_74##10 B#17 VGND#11 VNB sky130_fd_pr__nfet_01v8_lvt l=0.15 w=0.74 ad=0.2072 as=0.41 pd=2.04 ps=2.79
XM25 a_511_74##10 B#16 VGND#10 VNB sky130_fd_pr__nfet_01v8_lvt l=0.15 w=0.74 ad=0.2072 as=0.3778 pd=2.04 ps=2.72
XM20 VGND#10 B#7 a_511_74##12 VNB sky130_fd_pr__nfet_01v8_lvt l=0.15 w=0.74 ad=0.3778 as=0.2109 pd=2.72 ps=2.05
XM0 VPWR#12 A#7 a_116_368##17 VPB sky130_fd_pr__pfet_01v8 l=0.15 w=0.84 ad=0.2478 as=0.252 pd=2.27 ps=2.28
XM18 a_116_368##17 A#6 VPWR#11 VPB sky130_fd_pr__pfet_01v8 l=0.15 w=0.84 ad=0.252 as=0.252 pd=2.28 ps=2.28
XM5 VPWR#11 B#4 a_116_368##15 VPB sky130_fd_pr__pfet_01v8 l=0.15 w=0.84 ad=0.252 as=0.252 pd=2.28 ps=2.28
XM21 a_116_368##15 B#5 VPWR#9 VPB sky130_fd_pr__pfet_01v8 l=0.15 w=0.84 ad=0.252 as=0.5829 pd=2.28 ps=3.67
XM6 Y#8 a_116_368##6 VPWR#9 VPB sky130_fd_pr__pfet_01v8 l=0.15 w=1.12 ad=0.336 as=0.5829 pd=2.84 ps=3.67
XM19 VPWR#7 a_116_368##11 Y#8 VPB sky130_fd_pr__pfet_01v8 l=0.15 w=1.12 ad=0.49375 as=0.336 pd=3.47 ps=2.84
XM10 VPWR#6 A#22 a_950_368##8 VPB sky130_fd_pr__pfet_01v8 l=0.15 w=1.12 ad=0.601325 as=0.3304 pd=3.66 ps=2.83
XM15 a_950_368##6 A#20 VPWR#6 VPB sky130_fd_pr__pfet_01v8 l=0.15 w=1.12 ad=0.336 as=0.601325 pd=2.84 ps=3.66
XM24 a_950_368##6 A#18 VPWR#5 VPB sky130_fd_pr__pfet_01v8 l=0.15 w=1.12 ad=0.336 as=0.59455 pd=2.84 ps=3.65
XM29 VPWR#5 A#8 a_950_368##3 VPB sky130_fd_pr__pfet_01v8 l=0.15 w=1.12 ad=0.59455 as=0.336 pd=3.65 ps=2.84
XM14 Y#4 B#19 a_950_368##3 VPB sky130_fd_pr__pfet_01v8 l=0.15 w=1.12 ad=0.336 as=0.336 pd=2.84 ps=2.84
XM26 a_950_368##5 B#18 Y#4 VPB sky130_fd_pr__pfet_01v8 l=0.15 w=1.12 ad=0.336 as=0.336 pd=2.84 ps=2.84
XM27 a_950_368##5 B#15 Y#7 VPB sky130_fd_pr__pfet_01v8 l=0.15 w=1.12 ad=0.336 as=0.336 pd=2.84 ps=2.84
XM12 Y#7 B#14 a_950_368# VPB sky130_fd_pr__pfet_01v8 l=0.15 w=1.12 ad=0.336 as=0.3304 pd=2.84 ps=2.83
*
*
*       RESISTOR AND CAP/DIODE CARDS
*
Rg1	A#1	A#2	407.934967
Rg2	A#2	A#3	46.351898
Rg3	A#3	A#4	22.738758
Rg4	A#4	A#5	409.032959
Rg5	A#2	A#6	382.026611
Rg6	A#4	A#7	382.639130
Rg7	B#1	B#2	396.550110
Rg8	B#2	B#3	58.569527
Rg9	B#3	B#4	369.872162
Rg10	B#2	B#5	339.615845
Rg11	B#3	B#6	427.016815
Rg12	a_116_368#	a_116_368##2	581.184998
Rg13	a_116_368##2	a_116_368##3	112.622421
Rg14	a_116_368##3	a_116_368##4	31.342407
Rg15	a_116_368##4	a_116_368##5	55.460026
Rg16	a_116_368##5	a_116_368##6	507.466217
Rg17	a_116_368##2	a_116_368##7	400.621063
Rg18	a_116_368##2	a_116_368##8	602.194580
Rg19	a_116_368##3	a_116_368##9	370.752045
Rg20	a_116_368##5	a_116_368##10	394.377136
Rg21	a_116_368##5	a_116_368##11	447.198364
Rg22	A#8	A#9	508.253876
Rg23	A#9	A#10	75.388161
Rg24	A#10	A#11	108.959763
Rg25	A#11	A#12	58.189354
Rg26	A#12	A#13	36.978279
Rg27	A#13	A#14	36.264217
Rg28	A#14	A#15	37.519978
Rg29	A#15	A#16	404.634918
Rg30	A#9	A#17	409.259399
Rg31	A#10	A#18	394.914215
Rg32	A#11	A#19	362.477966
Rg33	A#12	A#20	417.693329
Rg34	A#13	A#21	370.752045
Rg35	A#15	A#22	419.554810
Rg36	B#7	B#8	372.132263
Rg37	B#8	B#9	206.232513
Rg38	B#9	B#10	25.871120
Rg39	B#10	B#11	64.866600
Rg40	B#11	B#12	54.166744
Rg41	B#12	B#13	425.027893
Rg42	B#8	B#14	503.403320
Rg43	B#9	B#15	416.207306
Rg44	B#10	B#16	379.512695
Rg45	B#11	B#17	382.421600
Rg46	B#11	B#18	434.521118
Rg47	B#12	B#19	449.259979
Rf1	A#23	A#3	178.288925
Rf2	a_27_74#	a_27_74##3	65.580032
Rf3	a_27_74##3	a_27_74##4	99.977646
Rf4	a_27_74##2	a_27_74##3	7.500000
Rf5	a_116_368##4	a_116_368##13	154.860123
Rf6	a_116_368##8	a_116_368##16	227.240372
Rf7	a_116_368##16	a_116_368##17	79.996193
Rf8	a_116_368##15	a_116_368##16	7.500000
Rf9	A#14	A	77.208542
Rf11	B	B#20	8.537777
Rf12	B#20	B	6.640493
Rf13	B	B#2	458.865753
Rf14	Y#1	Y#2	20.924774
Rf15	Y#2	Y#3	366.239441
Rf16	Y#3	Y	62.197594
Rf17	Y	Y#5	11.952142
Rf18	Y#2	Y#6	92.562088
Rf19	Y#3	Y#7	20.503279
Rf20	Y#5	Y#8	362.209320
Rf21	Y#4	Y#5	7.500000
Rf22	a_950_368#	a_950_368##2	95.370132
Rf23	a_950_368##2	a_950_368##4	73.138298
Rf24	a_950_368##2	a_950_368##5	28.853926
Rf25	a_950_368##4	a_950_368##7	73.375099
Rf26	a_950_368##7	a_950_368##8	83.917130
Rf27	a_950_368##3	a_950_368##4	15.000000
Rf28	a_950_368##6	a_950_368##7	15.000000
Rf29	a_511_74#	a_511_74##2	21.712120
Rf30	a_511_74##2	a_511_74##4	78.349442
Rf31	a_511_74##2	a_511_74##5	91.523170
Rf32	a_511_74##4	a_511_74##7	68.109215
Rf33	a_511_74##7	a_511_74##9	59.296253
Rf34	a_511_74##9	a_511_74##11	61.853020
Rf35	a_511_74##11	a_511_74##12	65.178619
Rf36	a_511_74##3	a_511_74##4	15.000000
Rf37	a_511_74##6	a_511_74##7	15.000000
Rf38	a_511_74##8	a_511_74##9	15.000000
Rf39	a_511_74##10	a_511_74##11	15.000000
Rf41	VGND#2	VGND#3	29.926170
Rf42	VGND#3	VGND#4	45.796490
Rf43	VGND#4	VGND#5	75.722664
Rf44	VGND#5	VGND#6	74.462440
Rf45	VGND#6	VGND#7	136.945145
Rf46	VGND#7	VGND#8	193.559280
Rf48	VGND#2	VGND#10	24.862514
Rf49	VGND#4	VGND#11	23.958794
Rf50	VGND#5	VGND#12	24.862514
Rf51	VGND#6	VGND#13	24.862514
Rf52	VGND#8	VGND#14	34.507496
Rf53	VPWR#1	VPWR#2	103.341919
Rf54	VPWR#2	VPWR#3	78.294701
Rf55	VPWR#3	VPWR#4	151.369736
Rf56	VPWR#2	VPWR#5	22.697315
Rf57	VPWR#3	VPWR#6	22.587963
Rf58	VPWR#4	VPWR#7	26.195217
Rf59	VPWR#4	VPWR#8	88.945282
Rf60	VPWR#8	VPWR#9	22.481674
Rf61	VPWR#8	VPWR#10	72.387810
Rf62	VPWR#10	VPWR#11	70.870285
Rf63	VPWR#10	VPWR#12	126.726852
Rf68	B#11	B#20	53.410934
Re1	A	A#23	25.122730
Re2	VPWR#1	VPWR	3.246228
Re3	VPWR	VPWR#4	1.159367
Re4	VGND#3	VGND	3.246228
Re5	VGND	VGND#7	1.159367
*
*       CAPACITOR CARDS
*
*
C1	A#9	B#12	1.73876e-17
C2	Y#8	a_950_368##8	2.926e-17
C3	a_511_74##12	VGND#10	3.29478e-17
C4	Y#8	a_116_368##2	3.77412e-19
C5	a_511_74##3	a_116_368#	2.90958e-17
C6	VPWR#3	A#20	1.08914e-17
C7	a_950_368##3	VPWR#2	2.96221e-17
C8	Y#3	B#14	2.61376e-17
C9	VGND#13	a_116_368##7	1.86568e-19
C10	Y#8	VPWR#7	3.92451e-18
C11	a_116_368#	Y#1	1.44708e-17
C12	a_950_368##2	B#15	1.58662e-17
C13	VPWR#2	A#20	1.16681e-18
C14	Y#2	a_511_74#	6.10151e-19
C15	a_511_74##10	a_511_74##12	2.5798e-18
C16	a_511_74##3	a_116_368##7	4.63657e-19
C17	VGND#13	a_116_368##9	6.45371e-20
C18	VGND#7	a_116_368##5	3.04244e-20
C19	Y#3	B#15	3.52335e-17
C20	a_116_368##7	Y#1	1.44708e-17
C21	B#11	B#12	2.56944e-17
C22	VPWR#3	A#22	1.14707e-17
C23	VPWR#2	VPWR#5	6.05526e-18
C24	B#11	B#10	2.01089e-17
C25	a_950_368##2	B#18	1.57515e-17
C26	A#15	A#12	3.63839e-18
C27	a_511_74##10	VGND#10	3.33056e-17
C28	Y#2	A#15	4.80988e-18
C29	a_116_368##15	VPWR#7	2.00783e-18
C30	Y#6	Y#2	2.56098e-18
C31	a_511_74##3	a_116_368##9	2.03038e-19
C32	VGND#7	a_116_368##2	5.24929e-20
C33	VPWR#2	A#22	2.5196e-19
C34	a_116_368##7	a_511_74#	1.12959e-17
C35	a_511_74##3	a_116_368##2	1.82972e-19
C36	B#11	B#8	3.20981e-19
C37	a_950_368##6	VPWR#3	3.06869e-17
C38	VPWR#10	a_116_368##11	1.16372e-19
C39	a_116_368##15	Y#8	3.07754e-17
C40	VPWR#8	a_116_368##11	1.89902e-18
C41	Y#6	a_116_368##7	8.67876e-19
C42	Y#3	B#18	1.61738e-18
C43	a_116_368##15	a_116_368##5	3.23373e-19
C44	a_950_368##6	VPWR#2	3.04936e-17
C45	a_116_368##9	a_511_74#	1.40654e-17
C46	a_511_74##5	a_116_368##7	2.0216e-19
C47	a_116_368##15	VPWR#9	3.02819e-18
C48	a_116_368##13	a_116_368#	1.18678e-19
C49	Y#6	a_116_368##9	4.7522e-17
C50	VPWR#3	VPWR#6	6.15985e-18
C51	VPWR#10	a_116_368##6	1.24848e-18
C52	Y#3	B#19	1.2456e-19
C53	a_511_74##10	VGND#11	1.04424e-18
C54	a_950_368##3	B#13	2.74918e-19
C55	VPWR#8	a_116_368##6	1.44705e-17
C56	a_511_74##5	a_116_368##9	9.72106e-19
C57	Y#2	A#12	2.65898e-18
C58	a_116_368##13	a_116_368##7	1.13923e-19
C59	a_116_368##10	Y#6	1.78653e-17
C60	VPWR#3	A#15	7.02569e-19
C61	a_116_368##15	VPWR#11	4.9927e-17
C62	A#14	A#15	1.95912e-17
C63	a_511_74##8	a_511_74##10	2.45333e-18
C64	a_950_368##8	VPWR#3	3.88387e-17
C65	Y#3	A#8	7.57933e-20
C66	a_116_368##15	B#3	2.65938e-19
C67	a_511_74##5	a_116_368##10	6.41327e-17
C68	a_116_368##13	a_116_368##9	1.0167e-18
C69	A#14	A#12	1.24969e-17
C70	Y#3	A#9	9.80595e-19
C71	VPWR#8	B#5	3.25327e-18
C72	Y#6	B#1	5.99126e-19
C73	a_116_368##17	a_116_368##15	3.01982e-18
C74	a_27_74#	a_116_368##10	5.80139e-19
C75	A#14	A#10	2.95843e-18
C76	VPWR#8	VPWR#7	2.22202e-18
C77	A#14	A#9	4.34237e-19
C78	a_511_74##8	VGND#11	1.00748e-18
C79	a_511_74##5	B#1	5.17551e-18
C80	a_116_368##13	a_116_368##10	5.35644e-18
C81	a_116_368##17	VPWR#11	4.4715e-17
C82	Y#3	A#18	9.2901e-20
C83	a_27_74#	B#1	3.80211e-17
C84	VPWR#10	B#4	1.99689e-18
C85	Y#2	A#10	5.58945e-18
C86	a_27_74##2	a_116_368##10	1.88982e-19
C87	VPWR#12	VPWR#11	5.11037e-18
C88	a_511_74##5	B#6	6.27388e-19
C89	a_116_368##13	B#1	3.60233e-17
C90	VGND#14	a_116_368##10	1.51403e-19
C91	VPWR#3	A#12	3.57101e-20
C92	VPWR#12	a_116_368##17	6.62353e-17
C93	a_27_74##2	B#1	1.38663e-18
C94	Y#2	A#9	6.2793e-19
C95	Y#8	VPWR#3	2.72713e-18
C96	a_511_74##5	A#1	3.07152e-19
C97	VPWR#10	A#6	2.14825e-18
C98	B#6	a_116_368##13	1.69706e-17
C99	a_511_74##8	VGND#12	3.34235e-17
C100	VGND#14	B#1	4.54552e-19
C101	A#8	B#12	1.1829e-18
C102	a_116_368##8	a_116_368##5	9.96557e-20
C103	a_27_74##2	B#6	5.63918e-17
C104	VPWR#8	VPWR#9	4.38645e-18
C105	a_511_74##5	A#5	2.46773e-19
C106	a_950_368##2	Y#7	3.27575e-19
C107	a_116_368##2	a_116_368##8	2.20434e-18
C108	a_116_368##13	A#1	1.11321e-19
C109	VGND#14	B#6	9.58192e-19
C110	a_511_74##6	a_511_74##8	2.5798e-18
C111	a_116_368##15	VPWR#10	4.34013e-18
C112	Y#3	a_950_368#	7.48063e-17
C113	a_27_74##2	A#1	4.86505e-17
C114	VPWR#10	A#7	5.26218e-18
C115	a_511_74##5	a_116_368##5	1.74469e-18
C116	a_116_368##4	A#15	1.88501e-19
C117	a_116_368##13	A#5	9.4617e-20
C118	A#1	VGND#14	1.56846e-17
C119	VPWR#2	A#12	4.71373e-20
C120	a_116_368##15	VPWR#8	5.30355e-17
C121	a_950_368##2	a_950_368##5	5.47123e-20
C122	a_511_74##6	VGND#12	3.32688e-17
C123	a_27_74##2	A#5	1.88792e-18
C124	B#16	B#7	2.08871e-17
C125	a_116_368##17	A#4	2.88555e-18
C126	B#12	B#17	7.80007e-18
C127	a_27_74##4	A#1	7.39424e-19
C128	Y#3	Y#7	1.47747e-18
C129	a_116_368##4	a_116_368##5	2.27159e-17
C130	VGND#14	A#5	3.14393e-17
C131	VPWR#8	a_116_368##5	2.20085e-20
C132	VGND#13	VGND#12	3.03882e-18
C133	a_116_368##4	a_116_368##2	2.39124e-17
C134	a_950_368##2	Y#4	3.1255e-19
C135	a_27_74##4	A#5	3.48381e-17
C136	A#12	A#10	6.04167e-18
C137	Y#2	a_116_368##2	8.58075e-18
C138	a_116_368##4	B#3	1.33362e-19
C139	VGND#4	B#12	1.43121e-18
C140	a_116_368##4	A#4	1.32589e-19
C141	Y#8	a_116_368#	2.00587e-19
C142	B#17	B#16	3.90328e-17
C143	Y#3	a_950_368##5	4.48535e-17
C144	A#10	A#8	7.39195e-19
C145	a_511_74##6	VGND#13	3.33912e-17
C146	a_116_368##17	VPWR#10	6.6489e-18
C147	VPWR#2	A#10	6.10697e-20
C148	VPWR#10	B#3	6.91496e-21
C149	B#13	B#17	1.60258e-17
C150	a_511_74##3	a_511_74##6	2.5798e-18
C151	B#2	a_116_368##5	2.93537e-18
C152	VPWR#1	VPWR#2	8.60431e-18
C153	B#2	a_116_368##2	2.97714e-17
C154	a_950_368#	B#14	4.26498e-17
C155	VPWR#12	VPWR#10	4.48846e-18
C156	B#2	B#3	1.39239e-17
C157	A#12	A#9	3.20973e-18
C158	B#2	A#4	1.46419e-18
C159	B#14	Y#7	2.25276e-17
C160	a_511_74##3	VGND#13	4.27786e-17
C161	a_116_368##13	a_116_368##5	5.65614e-19
C162	VPWR#2	A#9	3.78948e-19
C163	A#17	B#13	4.19855e-17
C164	VPWR#10	A#4	6.28795e-20
C165	a_950_368#	B#15	1.30694e-18
C166	a_950_368##5	B#14	1.29161e-18
C167	VGND#6	A#12	5.00344e-20
C168	B#15	Y#7	2.24764e-17
C169	a_950_368#	B#18	3.00902e-19
C170	B#15	a_950_368##5	2.38548e-17
C171	Y#3	VPWR#5	3.6113e-21
C172	VGND#3	VGND#5	5.56597e-18
C173	A#19	A#17	2.02245e-17
C174	VGND#3	VGND#4	6.88111e-17
C175	a_116_368##13	a_116_368##2	6.60751e-20
C176	a_511_74##3	Y#1	1.43305e-19
C177	A#3	A#4	2.65627e-17
C178	B#18	a_950_368##5	2.73733e-17
C179	a_116_368##2	A#15	1.92413e-18
C180	a_950_368##3	B#15	3.32899e-19
C181	A#20	A#10	2.39927e-19
C182	A#23	VPWR#10	1.28207e-18
C183	B#18	Y#4	2.32419e-17
C184	A#21	A#19	3.9033e-17
C185	a_116_368##13	B#3	3.13501e-19
C186	A#23	VPWR#8	4.49496e-18
C187	a_950_368##5	B#19	6.2318e-19
C188	a_950_368##3	B#18	9.91649e-19
C189	VGND#5	A#12	3.87179e-20
C190	a_950_368#	B#8	5.67685e-20
C191	B#19	Y#4	2.32419e-17
C192	a_950_368##2	VPWR#1	9.04657e-17
C193	a_116_368##13	A#4	1.52545e-18
C194	a_950_368##5	A#8	2.68812e-19
C195	a_950_368##3	B#19	4.17857e-17
C196	A#16	A#21	2.02245e-17
C197	a_511_74##12	a_950_368#	1.0345e-17
C198	VPWR#1	Y#3	9.82733e-18
C199	A#9	B#13	8.12141e-18
C200	a_950_368##3	A#8	5.25619e-17
C201	A#12	A#17	1.27568e-18
C202	a_116_368#	A#16	2.57111e-17
C203	a_511_74##5	a_116_368##6	5.35761e-19
C204	A#8	VPWR#5	2.29011e-17
C205	a_27_74##2	B#3	4.40426e-20
C206	VGND#3	Y#3	1.37654e-17
C207	a_950_368##3	A#18	7.58655e-19
C208	a_950_368##6	A#8	8.6941e-19
C209	a_511_74##2	Y#2	5.00658e-17
C210	VGND#3	Y#2	4.11372e-19
C211	VGND#4	B#7	3.86917e-19
C212	Y#6	a_511_74#	6.89876e-19
C213	A#18	VPWR#5	2.7542e-17
C214	a_27_74##2	A#4	1.70157e-18
C215	a_116_368##7	a_116_368#	3.84562e-17
C216	a_511_74##12	B#10	1.72303e-19
C217	a_950_368##6	A#18	4.78943e-17
C218	a_116_368##2	A#22	1.8505e-18
C219	B#10	a_950_368##5	9.88784e-19
C220	VGND#4	B#16	7.49747e-19
C221	a_950_368##6	A#20	4.74241e-17
C222	VGND#5	A#9	2.14231e-20
C223	a_116_368##9	a_116_368##7	1.96057e-17
C224	A#20	VPWR#6	2.9062e-17
C225	VPWR#10	VPWR#8	3.57098e-18
C226	a_511_74##5	Y#6	4.08584e-17
C227	a_950_368##6	A#22	9.33532e-19
C228	a_950_368##8	A#20	6.58389e-19
C229	Y#3	a_950_368##2	1.59961e-17
C230	B#12	Y#4	1.00842e-19
C231	VGND#3	a_511_74##12	2.03626e-17
C232	A#22	VPWR#6	2.9062e-17
C233	VGND#14	A#4	1.34243e-18
C234	VGND#4	B#17	9.34264e-18
C235	a_511_74##12	B#8	3.49566e-19
C236	VGND#4	B#11	1.00301e-19
C237	a_116_368##10	a_116_368##9	2.85376e-17
C238	VGND#3	VGND#10	2.2208e-17
C239	a_950_368##8	A#22	5.32555e-17
C240	VGND#10	B#10	6.43397e-19
C241	a_116_368##11	a_116_368##2	2.56441e-18
C242	VGND#3	a_511_74##10	3.45832e-17
C243	VGND#6	a_116_368##2	1.57085e-20
C244	VGND#7	a_511_74##2	7.2877e-17
C245	VPWR#7	A#22	1.20102e-18
C246	VGND#3	a_511_74##8	1.3868e-17
C247	a_950_368##8	a_116_368##11	2.74002e-19
C248	Y#8	A#22	7.08205e-18
C249	VGND#4	A#9	5.51173e-20
C250	B#1	a_116_368##10	4.7886e-18
C251	a_27_74#	a_511_74##5	2.34172e-17
C252	VGND#4	VGND#10	3.07162e-18
C253	a_116_368##13	Y#6	1.21198e-17
C254	VGND#4	B#13	1.11345e-17
C255	a_116_368##11	VPWR#7	3.70455e-17
C256	a_511_74##10	B#12	5.70044e-19
C257	a_116_368##8	VPWR#3	1.21475e-17
C258	Y#8	a_116_368##11	3.83542e-17
C259	a_116_368##6	a_116_368##5	1.08601e-18
C260	VGND#5	A#17	2.92317e-18
C261	a_950_368##3	B#12	4.75132e-20
C262	a_27_74##4	A#4	2.11684e-18
C263	a_116_368##13	a_511_74##5	8.29535e-18
C264	VPWR#7	a_116_368##6	2.02634e-18
C265	B#6	B#1	2.85837e-17
C266	VGND#10	B#8	3.46031e-19
C267	a_950_368##2	B#11	6.94551e-20
C268	Y#8	a_116_368##6	3.056e-17
C269	A#16	A#15	2.27176e-19
C270	a_116_368##15	a_116_368##11	1.19735e-18
C271	VGND#4	a_511_74##10	3.99159e-17
C272	VGND#4	A#17	7.49747e-19
C273	a_511_74##10	B#10	5.24714e-19
C274	a_116_368##6	VPWR#9	2.0579e-17
C275	VPWR#11	a_116_368##11	1.12372e-19
C276	B#11	Y#3	1.544e-16
C277	a_27_74#	a_116_368##13	3.14031e-17
C278	a_27_74##2	a_511_74##5	1.53474e-18
C279	A#1	B#6	3.66626e-17
C280	a_116_368##15	a_116_368##6	1.70008e-17
C281	Y#8	B#5	1.91057e-18
C282	VGND#5	A#19	2.91084e-18
C283	B#5	VPWR#9	2.2148e-17
C284	VPWR#11	a_116_368##6	4.7162e-19
C285	VGND#4	VGND#11	1.27531e-17
C286	a_116_368##15	B#5	6.1011e-17
C287	VGND#4	A#19	2.88628e-19
C288	a_116_368##17	a_116_368##6	1.55427e-19
C289	VGND#14	a_511_74##5	1.35342e-18
C290	a_950_368#	VPWR#1	7.50952e-17
C291	VGND#6	A#21	2.91947e-18
C292	VPWR#10	B#2	1.95348e-20
C293	VGND#5	a_511_74##8	8.90389e-18
C294	A#5	A#1	2.4144e-17
C295	VPWR#8	B#2	5.84843e-19
C296	Y#2	A#14	6.31622e-17
C297	VPWR#12	a_116_368##6	4.80156e-19
C298	a_116_368##17	B#5	2.57927e-19
C299	a_116_368##15	B#4	5.65701e-17
C300	a_27_74##2	a_116_368##13	5.4504e-17
C301	VGND#3	a_950_368#	4.44236e-18
C302	a_116_368#	A#15	1.41193e-17
C303	VPWR#3	VPWR#2	1.87587e-18
C304	B#4	VPWR#11	1.91934e-17
C305	A#23	a_511_74##5	3.42571e-18
C306	a_950_368##3	VPWR#1	6.66256e-17
C307	VGND#4	a_511_74##8	4.29466e-17
C308	A#23	a_27_74#	2.31289e-18
C309	a_116_368##17	B#4	1.93563e-18
C310	a_116_368##15	A#6	1.90173e-18
C311	VGND#6	A#16	2.62408e-18
C312	Y#2	a_116_368##8	3.56971e-19
C313	a_511_74##2	a_116_368##4	8.52252e-19
C314	A#3	VPWR#10	2.82528e-19
C315	A#23	a_116_368##13	8.54513e-18
C316	a_511_74##10	B#11	6.32966e-19
C317	VPWR#12	B#4	3.44995e-19
C318	A#6	VPWR#11	2.37967e-17
C319	a_27_74##2	A#23	4.36995e-17
C320	VGND#6	a_511_74##6	8.95252e-18
C321	VGND#7	a_511_74##3	2.04083e-18
C322	Y#3	B#7	7.38482e-18
C323	a_116_368##17	A#6	6.30242e-17
C324	B	A#15	6.33374e-18
C325	VPWR#12	A#6	1.37475e-18
C326	VPWR#11	A#7	1.40734e-18
C327	a_511_74##8	B#12	8.28135e-19
C328	B	A#12	5.71682e-18
C329	VGND#12	VGND#4	3.0654e-18
C330	a_27_74##2	VGND#14	5.63984e-17
C331	Y#2	a_116_368##4	3.7884e-17
C332	a_116_368##17	A#7	4.35836e-17
C333	B	A#10	9.78869e-18
C334	VGND#6	a_116_368#	4.46415e-18
C335	B	A#9	2.86774e-17
C336	VGND#7	a_511_74##5	5.40088e-17
C337	VGND#5	a_511_74##6	8.90389e-18
C338	VPWR#12	A#7	2.40507e-17
C339	B	a_116_368##2	1.53183e-18
C340	VGND#7	a_27_74#	1.18118e-17
C341	B#15	B#14	4.56502e-17
C342	Y#3	B#16	1.71842e-17
C343	VGND#7	a_116_368##13	2.39971e-18
C344	a_27_74##4	a_27_74##2	2.49329e-18
C345	a_116_368##5	a_116_368##2	2.7078e-19
C346	Y#2	B#2	1.29884e-18
C347	B#18	B#15	4.69396e-17
C348	Y#3	B#17	1.69464e-17
C349	a_27_74##4	VGND#14	5.64716e-17
C350	Y	B#12	5.15804e-19
C351	Y	B#10	6.52118e-19
C352	VGND#6	a_511_74##3	4.6803e-17
C353	Y	A#15	1.01056e-18
C354	a_511_74##3	a_116_368##8	2.36446e-19
C355	A#23	VPWR#7	7.16202e-19
C356	Y	A#12	3.6214e-19
C357	B#19	B#18	4.59036e-17
C358	Y	A#10	1.08196e-19
C359	Y	A#9	9.40115e-19
C360	A#23	Y#8	1.08223e-18
C361	VGND#3	B#7	8.98574e-19
C362	a_950_368##3	A#9	2.57937e-19
C363	a_116_368##2	a_116_368#	3.20043e-18
C364	Y#3	B#13	1.51172e-17
C365	VPWR#1	B#13	6.4093e-20
C366	B#11	a_950_368##5	1.39295e-19
C367	VGND#3	B#16	2.87999e-18
C368	A#23	a_116_368##15	3.3465e-17
C369	A#6	B#3	6.50863e-19
C370	A#8	B#19	4.67128e-17
C371	B#11	Y#4	4.45539e-19
C372	A#23	VPWR#11	3.11026e-18
C373	VGND#3	B#17	1.94827e-18
C374	a_950_368##3	B#11	4.36441e-20
C375	a_950_368##6	A#15	3.28746e-19
C376	A#23	a_116_368##17	1.93426e-17
C377	VGND#3	B#13	1.63143e-19
C378	Y#6	a_116_368##4	6.53614e-17
C379	a_511_74##5	a_116_368##4	9.83567e-18
C380	A#18	A#8	2.43007e-17
C381	Y#3	A#17	3.11133e-20
C382	A#10	VPWR#5	7.55047e-20
C383	a_116_368##13	a_116_368##4	1.51052e-19
C384	a_511_74##2	A#16	1.96008e-19
C385	Y#2	A#17	1.29271e-17
C386	A#20	A#18	4.85111e-17
C387	a_27_74#	B#2	1.55911e-18
C388	a_950_368##6	A#12	2.69193e-19
C389	A#9	VPWR#5	1.46131e-18
C390	a_950_368#	Y#7	3.01818e-19
C391	a_116_368##13	B#2	7.02742e-17
C392	a_27_74##2	B#2	1.764e-18
C393	A#22	A#20	2.29709e-17
C394	a_116_368##8	a_950_368##8	3.27792e-17
C395	Y#2	A#19	1.97224e-17
C396	A#15	VPWR#6	1.31718e-18
C397	a_511_74##2	a_116_368#	4.27927e-19
C398	a_511_74##12	B#7	5.67227e-17
C399	a_116_368##8	VPWR#7	9.79918e-17
C400	a_950_368##5	a_950_368#	3.51463e-18
C401	VPWR#1	B#12	7.90256e-21
C402	a_116_368##8	Y#8	1.89561e-16
C403	a_27_74##2	A#3	1.86671e-17
C404	a_116_368##11	A#22	1.1989e-19
C405	VPWR#1	B#10	4.23145e-20
C406	a_27_74##4	A#3	2.40741e-17
C407	a_950_368##6	A#10	7.23046e-20
C408	B#10	B#8	6.56553e-18
C409	B#7	VGND#10	2.42946e-17
C410	B#11	B#13	3.9025e-20
C411	a_116_368##4	VPWR#7	6.47555e-18
C412	a_116_368##4	Y#8	5.96507e-18
C413	VPWR#1	B#8	2.25616e-20
C414	Y#2	A#21	1.80374e-17
C415	VPWR#1	B#14	6.73822e-18
C416	a_511_74##12	B#16	2.21004e-18
C417	a_511_74##12	Y#3	3.73668e-17
C418	a_116_368##6	a_116_368##11	4.84038e-17
C419	a_511_74##2	a_116_368##7	2.39457e-17
C420	VPWR#1	B#15	6.09434e-18
C421	a_511_74##10	B#7	8.85392e-19
C422	a_950_368##6	A#9	2.01159e-19
C423	B#2	VPWR#7	2.89854e-18
C424	VGND#7	a_116_368##7	4.43427e-18
C425	VPWR#1	B#18	6.03748e-18
C426	B#2	Y#8	1.30778e-16
C427	B#16	VGND#10	2.54661e-17
C428	VGND#7	a_116_368##9	4.47052e-18
C429	B#2	VPWR#9	8.58911e-18
C430	B#5	a_116_368##6	1.89435e-17
C431	VPWR#1	B#19	5.93932e-18
C432	VGND#7	a_116_368##10	4.43427e-18
C433	a_511_74##8	A#10	3.50738e-19
C434	B#2	a_116_368##15	5.90492e-17
C435	a_511_74##12	B#17	4.20905e-19
C436	Y#2	A#16	1.94975e-17
C437	VPWR#1	A#8	2.4423e-18
C438	A#15	a_950_368##8	1.5243e-18
C439	Y#3	VGND#10	2.3095e-19
C440	a_511_74##10	B#16	4.37367e-17
C441	a_116_368##17	B#2	2.94028e-18
C442	a_511_74##2	a_116_368##9	2.35786e-17
C443	B#4	B#5	3.601e-17
C444	a_511_74##6	A#15	5.6771e-19
C445	VGND#10	B#17	1.34754e-18
C446	VGND#3	B#10	7.481e-21
C447	a_116_368#	a_116_368##8	1.22683e-18
C448	a_511_74##8	A#9	8.70751e-19
C449	A#3	a_116_368##17	4.01048e-17
C450	a_511_74##12	B#13	2.51874e-19
C451	A#6	B#4	3.71639e-17
C452	Y#3	B	2.70217e-17
C453	VGND	A#12	9.36428e-19
C454	Y#2	a_116_368#	2.70449e-17
C455	a_950_368##3	a_950_368##5	3.97785e-18
C456	Y#2	B	4.74127e-17
C457	VGND#3	B#8	5.44036e-19
C458	a_511_74##10	B#17	4.17351e-17
C459	VGND	A#10	2.09319e-19
C460	Y#3	a_511_74##10	8.04672e-17
C461	a_116_368##4	a_116_368#	3.15474e-20
C462	a_511_74##2	a_116_368##10	6.82544e-19
C463	VGND#10	B#13	2.72949e-19
C464	B#11	B#14	2.76809e-19
C465	A#7	A#6	3.61642e-17
C466	B#11	B#15	1.26464e-18
C467	B#17	VGND#11	1.6802e-17
C468	a_950_368##3	Y#4	3.16843e-19
C469	VPWR	VPWR#10	7.47693e-17
C470	a_950_368##2	B#10	5.95474e-20
C471	B#11	B#18	1.82823e-18
C472	Y	a_950_368##2	1.55898e-17
C473	VPWR	VPWR#8	8.21786e-17
C474	VGND#12	A#10	9.64314e-19
C475	VPWR	VPWR#3	1.01528e-16
C476	VPWR	VPWR#2	4.7319e-17
C477	Y	Y#3	2.84827e-18
C478	a_511_74##10	B#13	5.66928e-19
C479	B#11	B#19	2.06018e-18
C480	Y#2	a_116_368##7	2.75705e-17
C481	B#2	a_116_368##10	3.60717e-19
C482	Y#3	VGND#11	6.30018e-19
C483	a_511_74##6	A#12	7.89133e-19
C484	a_511_74##8	B#17	5.66928e-19
C485	A#23	a_116_368##6	3.85012e-19
C486	A#23	B#5	6.99456e-19
C487	VGND#13	A#15	1.41014e-18
C488	B#13	VGND#11	1.77164e-17
C489	A#14	A#8	3.23744e-19
C490	A#23	B#4	1.91681e-18
C491	VGND#12	A#9	9.31329e-20
C492	VGND#12	B#17	2.72949e-19
C493	VPWR#2	B#14	5.12532e-20
C494	VGND#7	a_116_368##6	3.44838e-19
C495	A#23	A#6	2.28624e-18
C496	A#14	A#20	2.03654e-18
C497	Y#2	a_116_368##9	1.27322e-18
C498	a_511_74##2	a_511_74##3	2.46682e-18
C499	a_511_74##8	B#13	4.40615e-17
C500	A#14	A#22	5.50422e-19
C501	A#23	A#7	1.2697e-18
C502	a_950_368##3	VPWR#5	1.53671e-18
C503	Y#3	a_511_74##8	4.4056e-17
C504	a_116_368##8	A#22	1.44647e-17
C505	A#4	B#3	3.21832e-17
C506	VGND#12	B#13	7.39855e-19
C507	B	VPWR#5	2.79903e-18
C508	a_116_368##8	a_116_368##11	2.44964e-17
C509	a_27_74##2	a_116_368##15	8.18704e-19
C510	B	a_950_368##6	4.66755e-19
C511	B	VPWR#6	3.74484e-18
C512	a_116_368##8	a_116_368##6	8.37826e-19
C513	a_950_368##6	a_950_368##3	2.75124e-18
C514	B	a_950_368##8	1.39823e-18
C515	a_511_74##6	A#10	5.1348e-19
C516	a_950_368##2	B#8	1.19095e-21
C517	a_511_74##8	A#17	4.21843e-17
C518	B	Y#8	6.90008e-17
C519	VPWR#2	B#15	7.20463e-20
C520	Y#2	a_511_74##8	3.76778e-17
C521	Y	a_950_368##5	4.70156e-17
C522	a_116_368##4	a_116_368##6	1.35438e-17
C523	a_511_74##2	Y#1	2.11675e-19
C524	Y#8	A#15	5.97281e-19
C525	Y	Y#4	1.59748e-18
C526	Y	a_950_368##3	8.40443e-17
C527	B#2	a_116_368##11	2.16028e-17
C528	Y	VPWR#5	2.48325e-18
C529	VPWR#1	B#11	7.03381e-18
C530	Y	a_950_368##6	8.69427e-17
C531	B#2	a_116_368##6	5.0597e-17
C532	VGND	VGND#6	7.71511e-17
C533	Y	VPWR#6	2.63499e-18
C534	VGND	VGND#5	4.78458e-17
C535	A#17	VGND#12	2.39932e-17
C536	a_950_368##6	VPWR#5	1.54961e-18
C537	VGND#3	B#11	5.8783e-18
C538	Y	a_950_368##8	2.98093e-17
C539	a_511_74##3	A#15	6.45445e-19
C540	B#2	B#5	9.12641e-18
C541	A#23	VGND#7	3.60684e-18
C542	B#2	B#4	1.55195e-18
C543	B	B#13	6.35542e-18
C544	a_511_74##8	A#19	5.56888e-19
C545	VGND	a_511_74##2	3.6961e-17
C546	B#2	A#6	2.7289e-19
C547	B#12	VNB	3.74974e-17
C548	VPWR	a_950_368##3	1.96143e-18
C549	B#10	VNB	2.98755e-17
C550	Y#3	B#12	7.23547e-18
C551	B#8	VNB	3.583e-17
C552	A#15	VNB	5.87518e-17
C553	a_511_74##6	A#17	5.56888e-19
C554	A#12	VNB	2.82794e-17
C555	VPWR	a_950_368##6	2.0802e-17
C556	Y#2	VGND#12	3.17381e-20
C557	VGND	Y#2	1.97311e-17
C558	A#10	VNB	2.33545e-17
C559	A#9	VNB	2.74614e-17
C560	a_116_368##5	VNB	2.12473e-17
C561	B	a_116_368#	1.35874e-18
C562	a_116_368##2	VNB	6.80066e-17
C563	VPWR	a_950_368##8	1.52856e-17
C564	B#3	VNB	2.29065e-17
C565	a_511_74##2	a_511_74#	1.53661e-17
C566	A#4	VNB	8.3675e-17
C567	VPWR#2	B#18	2.01984e-19
C568	VPWR	VPWR#7	1.00802e-16
C569	VPWR	Y#8	1.12327e-17
C570	Y	B#13	1.42417e-18
C571	A#23	a_116_368##8	1.12339e-19
C572	A#19	VGND#12	2.48665e-17
C573	VPWR	a_116_368##15	2.95293e-17
C574	VPWR	a_116_368##17	1.51756e-17
C575	VGND#13	A#17	2.81896e-19
C576	A#23	a_116_368##4	2.78978e-17
C577	VGND	a_511_74##8	7.21989e-18
C578	VPWR	VPWR#12	4.94759e-17
C579	VGND	VGND#12	2.1341e-17
C580	VGND	a_511_74##6	2.09333e-17
C581	VGND	VGND#13	2.0442e-17
C582	VGND	a_511_74##3	2.7479e-17
C583	A#23	B#2	9.27863e-17
C584	a_950_368##6	VPWR#6	1.56246e-18
C585	a_511_74##6	A#19	4.37575e-17
C586	VGND	Y#6	4.27283e-18
C587	B	B#14	8.75421e-20
C588	VGND#7	a_116_368##4	7.89995e-20
C589	VGND	a_511_74##5	2.92487e-17
C590	VGND	a_27_74#	2.20809e-17
C591	B	B#15	6.18306e-20
C592	VPWR#7	a_116_368##5	3.56593e-20
C593	Y#3	B#10	1.50223e-17
C594	VGND	a_116_368##13	9.94845e-18
C595	VGND	a_27_74##2	2.58832e-17
C596	B	B#18	1.06967e-19
C597	Y#2	a_511_74##6	7.99831e-17
C598	VGND#7	B#2	6.98227e-20
C599	VGND	a_27_74##4	1.67729e-17
C600	B	B#19	1.02559e-18
C601	A#4	B#6	8.13667e-19
C602	B	A#8	9.92629e-18
C603	VGND#12	A#21	7.39855e-19
C604	a_511_74##2	Y#6	5.54696e-17
C605	B	A#18	2.10337e-17
C606	Y	B#15	1.79993e-18
C607	B	A#20	1.44733e-17
C608	a_116_368##4	a_116_368##8	3.75035e-18
C609	VGND#13	A#19	1.25129e-18
C610	VPWR#2	B#19	4.62676e-19
C611	Y	B#18	3.69548e-17
C612	B	A#22	1.6824e-17
C613	Y	B#19	3.68474e-17
C614	a_950_368##8	a_950_368##6	2.31223e-18
C615	B#2	a_116_368##8	6.91858e-19
C616	Y	A#8	2.75695e-17
C617	Y	A#18	1.56057e-17
C618	VPWR#10	VNB	4.42717e-17
C619	VPWR#8	VNB	3.68498e-17
C620	B#2	a_116_368##4	1.10015e-16
C621	VPWR#3	VNB	5.52327e-17
C622	Y	A#20	1.44838e-17
C623	VPWR#2	VNB	2.85753e-17
C624	a_511_74##6	A#21	4.21843e-17
C625	A#23	a_116_368##5	5.37654e-20
C626	VGND#6	VNB	4.41521e-17
C627	VGND	VPWR#12	4.87476e-18
C628	Y	A#22	9.85496e-18
C629	VGND#5	VNB	2.95392e-17
C630	VGND#4	VNB	3.0403e-17
C631	a_511_74##2	VNB	5.84751e-18
C632	VGND	A#17	1.91323e-19
C633	VPWR	A#18	7.18128e-20
C634	VGND	A#19	1.74345e-18
C635	a_950_368##2	VNB	4.48754e-18
C636	VGND	A#21	1.87852e-19
C637	Y#3	VNB	1.79198e-17
C638	Y#2	VGND#13	5.13092e-19
C639	VGND#12	A#16	2.81896e-19
C640	Y#2	VNB	3.45011e-18
C641	VGND	A#16	5.56292e-19
C642	VPWR#1	B	3.46643e-18
C643	VPWR	A#22	1.06709e-18
C644	a_27_74##4	VPWR#12	1.04249e-17
C645	VGND#3	B	2.67466e-18
C646	a_950_368##8	VPWR#6	1.57536e-18
C647	VPWR#3	A#8	2.54623e-19
C648	A#21	VGND#13	2.41231e-17
C649	a_511_74##12	VNB	4.35081e-17
C650	VGND#10	VNB	5.54242e-18
C651	VPWR	B#5	4.95338e-18
C652	a_511_74##10	VNB	1.94498e-18
C653	a_511_74##5	a_511_74##2	2.5966e-18
C654	VPWR#1	Y	1.41317e-17
C655	a_511_74##2	a_116_368##2	1.12709e-18
C656	a_511_74##8	VNB	1.94126e-18
C657	VPWR	B#4	3.54968e-18
C658	VGND#12	VNB	5.08941e-18
C659	a_511_74##6	VNB	1.93806e-18
C660	A#23	B#3	9.17877e-18
C661	VGND#13	VNB	4.72592e-18
C662	VGND	A#5	1.61909e-18
C663	VPWR	A#6	7.55098e-18
C664	a_511_74##3	VNB	3.62085e-18
C665	VPWR	A#7	7.74036e-18
C666	Y#6	VNB	8.42998e-19
C667	a_511_74##5	VNB	6.72357e-18
C668	a_27_74#	VNB	6.31763e-18
C669	a_116_368##13	VNB	1.07532e-17
C670	a_27_74##2	VNB	5.31284e-18
C671	a_511_74##6	A#16	5.56888e-19
C672	VGND#14	VNB	3.06117e-18
C673	VPWR#2	A#8	7.82416e-18
C674	a_27_74##4	VNB	4.41275e-17
C675	A#23	A#4	1.15603e-17
C676	a_950_368#	VNB	5.24184e-17
C677	A#14	B	7.33457e-17
C678	a_950_368##3	VNB	3.16372e-18
C679	B	a_116_368##8	1.01297e-18
C680	a_950_368##6	VNB	2.09779e-18
C681	a_511_74##3	A#21	9.21122e-19
C682	B#11	Y	6.31794e-17
C683	A#23	VPWR	3.41218e-17
C684	a_950_368##8	VNB	4.55853e-18
C685	VPWR#7	VNB	5.70869e-17
C686	Y#8	VNB	1.57833e-17
C687	VGND	a_116_368##6	2.38099e-19
C688	a_116_368##15	VNB	2.37887e-18
C689	VPWR#11	VNB	6.71471e-18
C690	a_116_368##17	VNB	3.48846e-18
C691	VPWR#12	VNB	8.29339e-17
C692	B#7	VNB	3.50892e-17
C693	Y#8	a_116_368##5	6.38572e-19
C694	B#16	VNB	2.87995e-17
C695	B#17	VNB	2.7889e-17
C696	Y#3	B#8	1.20647e-17
C697	B#13	VNB	4.18925e-17
C698	VPWR	A#14	4.68787e-18
C699	A#17	VNB	3.13493e-17
C700	A#19	VNB	2.94868e-17
C701	A#21	VNB	2.9184e-17
C702	VPWR	a_116_368##8	6.24849e-17
C703	Y#2	a_511_74##3	9.85176e-17
C704	A#16	VGND#13	2.42983e-17
C705	A#16	VNB	2.9451e-17
C706	a_116_368#	VNB	4.46836e-17
C707	a_116_368##7	VNB	2.99641e-17
C708	a_116_368##9	VNB	3.01402e-17
C709	a_116_368##10	VNB	3.3174e-17
C710	B#1	VNB	3.75591e-17
C711	VPWR	B#2	9.79233e-18
C712	B#6	VNB	3.06661e-17
C713	VGND	A#23	3.24653e-17
C714	A#1	VNB	2.68416e-17
C715	A#5	VNB	3.37254e-17
C716	VPWR	A#3	3.31391e-18
C717	B#14	VNB	4.66407e-17
C718	VGND	VGND#7	1.17568e-16
C719	B#15	VNB	3.32099e-17
C720	B#18	VNB	3.22827e-17
C721	B#19	VNB	3.18721e-17
C722	A#8	VNB	3.40825e-17
C723	VGND	A#14	4.02561e-18
C724	A#18	VNB	3.59521e-17
C725	A#20	VNB	3.49283e-17
C726	A#22	VNB	4.3968e-17
C727	VPWR#3	A#18	1.22078e-18
C728	a_116_368##11	VNB	3.95223e-17
C729	VGND	a_116_368##4	1.12424e-18
C730	a_116_368##6	VNB	6.16708e-17
C731	VPWR#7	a_950_368##8	2.58598e-18
C732	B#5	VNB	2.93909e-17
C733	VGND	B#2	4.18217e-18
C734	B#4	VNB	2.59509e-17
C735	A#6	VNB	3.32399e-17
C736	VGND	A#3	2.53818e-18
C737	B	Y	1.38921e-16
C738	A#7	VNB	3.79446e-17
C739	a_511_74##3	A#16	5.05036e-17
C740	VPWR#1	VNB	2.24338e-16
C741	VGND#3	VNB	1.49825e-16
C742	VPWR	B	1.30323e-17
C743	A#23	VNB	1.09358e-17
C744	VPWR	Y	1.13925e-17
C745	B#10	B#14	4.15546e-18
C746	VGND#7	VNB	7.06565e-17
C747	B#11	VNB	3.40629e-17
C748	A#14	VNB	1.10433e-17
C749	a_116_368##8	VNB	1.37236e-16
C750	a_116_368##4	VNB	6.51745e-17
C751	VGND	B	2.06291e-18
C752	VPWR#2	A#18	1.08083e-17
C753	B#2	VNB	6.37252e-17
C754	A#3	VNB	1.66096e-17
C755	VGND#13	a_116_368#	4.4773e-19
C756	B	VNB	1.74357e-17
C757	VPWR	VNB	2.84189e-16
C758	VGND	VNB	2.7227e-16
C759	VGND#8	a_27_74##4	1.78524e-17
C760	A	B#2	2.99556e-17
C761	VGND#2	B#16	2.80673e-19
C762	A	B	8.13559e-17
C763	VGND#2	B#7	2.92449e-18
C764	A	VPWR#3	2.34266e-18
C765	VGND#2	VNB	3.97307e-17
C766	VGND#8	B#6	5.81907e-18
C767	A	a_116_368##4	7.90498e-17
C768	A	A#12	1.53416e-18
C769	A	a_116_368##6	2.02674e-19
C770	A	a_511_74##3	1.40118e-18
C771	A	VNB	1.33261e-17
C772	A	a_116_368##8	2.78852e-18
C773	VGND#8	B#1	5.58218e-18
C774	VGND#3	VGND#2	6.16548e-17
C775	A	a_116_368##11	3.11634e-19
C776	VGND#8	VNB	7.35045e-17
C777	VGND#8	a_27_74##2	3.10432e-17
C778	A	a_511_74##2	2.03519e-18
C779	A	a_116_368##2	5.18104e-18
C780	A	A#15	2.0843e-17
C781	VGND#8	B#2	1.02915e-19
C782	A	A#22	3.23112e-18
C783	VGND#8	a_116_368##10	6.8853e-20
C784	VGND#8	B#3	6.80091e-21
C785	A	Y#8	5.38293e-18
C786	A	Y#2	7.7592e-17
C787	VGND	A	3.29817e-17
C788	A#23	VGND#8	4.1176e-18
C789	A	A#20	2.24074e-20
C790	A	a_116_368##5	2.95219e-19
C791	A	a_116_368#	1.71515e-17
C792	VGND	VGND#8	1.48659e-16
C793	VGND#8	a_27_74#	1.52912e-17
C794	A	VPWR#7	5.14044e-18
C795	A	a_511_74##5	8.92266e-19
C796	A	VGND#6	9.63836e-19
C797	A	VGND#7	1.96355e-18
C798	A	VPWR	3.37799e-17
C799	VGND#8	A#5	3.86159e-18
C800	A	Y#6	2.72424e-18
C801	VGND#2	a_511_74##10	1.47727e-19
C802	A	A#10	4.48149e-21
C803	VGND#2	a_511_74##12	2.13792e-17
C804	VGND#8	A#1	4.43217e-18
*
*
.ENDS sky130_fd_sc_hs__xnor2_4
*
