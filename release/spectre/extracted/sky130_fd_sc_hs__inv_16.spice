* Extracted by Quantus, converted by sky130cad/quantus.py
*
*
*
*                       LINUX           Wed Nov 18 08:41:46 2026
*
*
*
*  PROGRAM  advgen
*
*  Name           : advgen - Quantus - (64-bit)
*  Version        : 25.1.0-p047
*  Build Date     : Thu Dec 11 23:20:30 PST 2025
*
*  HSPICE LIBRARY
*
*  OPERATING_TEMPERATURE 150
*  QRC_TECH_DIR <path>/tech
*
*
*

*
.SUBCKT sky130_fd_sc_hs__inv_16 VPB VNB VGND A Y VPWR
*
*
*  caps2d version: 10
*
*
*       TRANSISTOR CARDS
*
*
XM5 VGND#11 A#55 Y#4 VNB sky130_fd_pr__nfet_01v8_lvt l=0.15 w=0.74 ad=0.1961 as=0.2072 pd=2.01 ps=2.04
XM16 VGND#18 A#53 Y#4 VNB sky130_fd_pr__nfet_01v8_lvt l=0.15 w=0.74 ad=0.259 as=0.2072 pd=2.18 ps=2.04
XM25 VGND#18 A#51 Y#5 VNB sky130_fd_pr__nfet_01v8_lvt l=0.15 w=0.74 ad=0.259 as=0.2072 pd=2.18 ps=2.04
XM22 Y#5 A#49 VGND#17 VNB sky130_fd_pr__nfet_01v8_lvt l=0.15 w=0.74 ad=0.2072 as=0.259 pd=2.04 ps=2.18
XM20 Y#8 A#47 VGND#17 VNB sky130_fd_pr__nfet_01v8_lvt l=0.15 w=0.74 ad=0.2072 as=0.259 pd=2.04 ps=2.18
XM19 Y#8 A#45 VGND#16 VNB sky130_fd_pr__nfet_01v8_lvt l=0.15 w=0.74 ad=0.2072 as=0.259 pd=2.04 ps=2.18
XM18 VGND#16 A#43 Y#14 VNB sky130_fd_pr__nfet_01v8_lvt l=0.15 w=0.74 ad=0.259 as=0.2072 pd=2.18 ps=2.04
XM7 VGND#15 A#41 Y#14 VNB sky130_fd_pr__nfet_01v8_lvt l=0.15 w=0.74 ad=0.2072 as=0.2072 pd=2.04 ps=2.04
XM9 VGND#15 A#39 Y#17 VNB sky130_fd_pr__nfet_01v8_lvt l=0.15 w=0.74 ad=0.2072 as=0.2072 pd=2.04 ps=2.04
XM15 Y#17 A#37 VGND#14 VNB sky130_fd_pr__nfet_01v8_lvt l=0.15 w=0.74 ad=0.2072 as=0.259 pd=2.04 ps=2.18
XM11 VGND#14 A#35 Y#21 VNB sky130_fd_pr__nfet_01v8_lvt l=0.15 w=0.74 ad=0.259 as=0.2072 pd=2.18 ps=2.04
XM26 Y#21 A#33 VGND#13 VNB sky130_fd_pr__nfet_01v8_lvt l=0.15 w=0.74 ad=0.2072 as=0.3108 pd=2.04 ps=2.32
XM13 VGND#13 A#31 Y#25 VNB sky130_fd_pr__nfet_01v8_lvt l=0.15 w=0.74 ad=0.3108 as=0.2072 pd=2.32 ps=2.04
XM27 Y#25 A#29 VGND#12 VNB sky130_fd_pr__nfet_01v8_lvt l=0.15 w=0.74 ad=0.2072 as=0.3256 pd=2.04 ps=2.36
XM14 Y#29 A#27 VGND#12 VNB sky130_fd_pr__nfet_01v8_lvt l=0.15 w=0.74 ad=0.2072 as=0.3256 pd=2.04 ps=2.36
XM1 Y#29 A#26 VGND#1 VNB sky130_fd_pr__nfet_01v8_lvt l=0.15 w=0.74 ad=0.2072 as=0.1961 pd=2.04 ps=2.01
XM2 Y#1 A#25 VPWR#11 VPB sky130_fd_pr__pfet_01v8 l=0.15 w=1.12 ad=0.336 as=0.3304 pd=2.84 ps=2.83
XM24 Y#1 A#54 VPWR#18 VPB sky130_fd_pr__pfet_01v8 l=0.15 w=1.12 ad=0.336 as=0.392 pd=2.84 ps=2.94
XM8 VPWR#18 A#52 Y#7 VPB sky130_fd_pr__pfet_01v8 l=0.15 w=1.12 ad=0.392 as=0.336 pd=2.94 ps=2.84
XM29 VPWR#17 A#50 Y#7 VPB sky130_fd_pr__pfet_01v8 l=0.15 w=1.12 ad=0.392 as=0.336 pd=2.94 ps=2.84
XM23 Y#10 A#48 VPWR#17 VPB sky130_fd_pr__pfet_01v8 l=0.15 w=1.12 ad=0.336 as=0.392 pd=2.84 ps=2.94
XM17 VPWR#16 A#46 Y#10 VPB sky130_fd_pr__pfet_01v8 l=0.15 w=1.12 ad=0.392 as=0.336 pd=2.94 ps=2.84
XM30 Y#11 A#44 VPWR#16 VPB sky130_fd_pr__pfet_01v8 l=0.15 w=1.12 ad=0.336 as=0.392 pd=2.84 ps=2.94
XM3 Y#11 A#42 VPWR#15 VPB sky130_fd_pr__pfet_01v8 l=0.15 w=1.12 ad=0.336 as=0.336 pd=2.84 ps=2.84
XM4 VPWR#15 A#40 Y#15 VPB sky130_fd_pr__pfet_01v8 l=0.15 w=1.12 ad=0.336 as=0.336 pd=2.84 ps=2.84
XM6 Y#15 A#38 VPWR#14 VPB sky130_fd_pr__pfet_01v8 l=0.15 w=1.12 ad=0.336 as=0.3584 pd=2.84 ps=2.88
XM28 VPWR#14 A#36 Y#18 VPB sky130_fd_pr__pfet_01v8 l=0.15 w=1.12 ad=0.3584 as=0.3696 pd=2.88 ps=2.9
XM31 Y#18 A#34 VPWR#13 VPB sky130_fd_pr__pfet_01v8 l=0.15 w=1.12 ad=0.3696 as=0.448 pd=2.9 ps=3.04
XM12 VPWR#13 A#32 Y#22 VPB sky130_fd_pr__pfet_01v8 l=0.15 w=1.12 ad=0.448 as=0.336 pd=3.04 ps=2.84
XM21 VPWR#12 A#30 Y#22 VPB sky130_fd_pr__pfet_01v8 l=0.15 w=1.12 ad=0.448 as=0.336 pd=3.04 ps=2.84
XM10 Y#26 A#28 VPWR#12 VPB sky130_fd_pr__pfet_01v8 l=0.15 w=1.12 ad=0.336 as=0.448 pd=2.84 ps=3.04
XM0 VPWR#1 A#1 Y#26 VPB sky130_fd_pr__pfet_01v8 l=0.15 w=1.12 ad=0.3304 as=0.336 pd=2.83 ps=2.84
*
*
*       RESISTOR AND CAP/DIODE CARDS
*
Rg1	A#1	A#2	454.195099
Rg2	A#2	A#3	66.369736
Rg3	A#3	A#4	50.538216
Rg4	A#4	A#5	48.569492
Rg5	A#5	A#6	79.420471
Rg6	A#6	A#7	49.553852
Rg7	A#7	A#8	49.553852
Rg8	A#8	A#9	86.547852
Rg9	A#9	A#10	39.148533
Rg10	A#10	A#11	44.922104
Rg11	A#11	A#12	76.403893
Rg12	A#12	A#13	36.607841
Rg13	A#13	A#14	38.936245
Rg14	A#14	A#15	76.473511
Rg15	A#15	A#16	43.647682
Rg16	A#16	A#17	45.616405
Rg17	A#17	A#18	76.473511
Rg18	A#18	A#19	41.889332
Rg19	A#19	A#20	44.638168
Rg20	A#20	A#21	75.544083
Rg21	A#21	A#22	41.938141
Rg22	A#22	A#23	45.467094
Rg23	A#23	A#24	68.614349
Rg24	A#24	A#25	454.195099
Rg25	A#2	A#26	414.404694
Rg26	A#3	A#27	396.457733
Rg27	A#3	A#28	449.042694
Rg28	A#5	A#29	417.745880
Rg29	A#5	A#30	453.421906
Rg30	A#6	A#31	403.227753
Rg31	A#6	A#32	451.050659
Rg32	A#8	A#33	417.745880
Rg33	A#8	A#34	453.421906
Rg34	A#9	A#35	424.485199
Rg35	A#9	A#36	438.831757
Rg36	A#11	A#37	447.709076
Rg37	A#11	A#38	462.055603
Rg38	A#12	A#39	430.496918
Rg39	A#12	A#40	444.843445
Rg40	A#14	A#41	420.034637
Rg41	A#14	A#42	434.381195
Rg42	A#15	A#43	394.561310
Rg43	A#15	A#44	446.660797
Rg44	A#17	A#45	394.561310
Rg45	A#17	A#46	446.660797
Rg46	A#18	A#47	420.034637
Rg47	A#18	A#48	434.381195
Rg48	A#20	A#49	420.034637
Rg49	A#20	A#50	434.381195
Rg50	A#21	A#51	430.496918
Rg51	A#21	A#52	444.843445
Rg52	A#23	A#53	430.496918
Rg53	A#23	A#54	444.843445
Rg54	A#24	A#55	414.404694
Rf1	Y#2	Y#3	14.795434
Rf2	Y#3	Y#4	61.289906
Rf3	Y#1	Y#2	5.000000
Rf4	A#56	A#22	166.499054
Rf5	Y#5	Y#6	64.850838
Rf6	Y#6	Y#7	20.156399
Rf7	A#58	A#19	176.685074
Rf8	Y#8	Y#9	61.369957
Rf9	Y#9	Y#10	19.369053
Rf10	A#60	A#16	177.027939
Rf11	Y#12	Y#13	15.980967
Rf12	Y#13	Y#14	64.199600
Rf13	Y#11	Y#12	5.000000
Rf14	A#62	A#13	176.909805
Rf15	Y#15	Y#16	21.241243
Rf16	Y#16	Y#17	71.993828
Rf17	A#64	A#10	176.182480
Rf18	Y#19	Y#20	15.018257
Rf19	Y#20	Y#21	62.692558
Rf20	Y#18	Y#19	5.000000
Rf21	A#66	A#7	175.831802
Rf22	Y#23	Y#24	14.369054
Rf23	Y#24	Y#25	60.120262
Rf24	Y#22	Y#23	5.000000
Rf25	A#68	A#4	166.313126
Rf26	Y#27	Y#28	16.788086
Rf27	Y#28	Y#29	64.478485
Rf28	Y#26	Y#27	5.000000
Rf29	VPWR#1	VPWR#2	70.106575
Rf30	VPWR#2	VPWR#3	37.231220
Rf31	VPWR#3	VPWR#4	73.001427
Rf32	VPWR#4	VPWR#5	71.387817
Rf33	VPWR#5	VPWR#6	67.257133
Rf34	VPWR#6	VPWR#7	49.171654
Rf35	VPWR#7	VPWR#8	17.564936
Rf36	VPWR#8	VPWR#9	69.463600
Rf37	VPWR#9	VPWR#10	70.893623
Rf38	VPWR#10	VPWR#11	118.428871
Rf39	VPWR#3	VPWR#12	35.924004
Rf40	VPWR#4	VPWR#13	35.924004
Rf41	VPWR#5	VPWR#14	40.532070
Rf42	VPWR#6	VPWR#15	47.582428
Rf43	VPWR#8	VPWR#16	45.190044
Rf44	VPWR#9	VPWR#17	45.190044
Rf45	VPWR#10	VPWR#18	39.953350
Rf46	VGND#1	VGND#2	61.792046
Rf47	VGND#2	VGND#3	41.243309
Rf48	VGND#3	VGND#4	73.732315
Rf49	VGND#4	VGND#5	70.865265
Rf50	VGND#5	VGND#6	63.968670
Rf51	VGND#6	VGND#7	48.238071
Rf52	VGND#7	VGND#8	18.279488
Rf53	VGND#8	VGND#9	69.058800
Rf54	VGND#9	VGND#10	67.240417
Rf55	VGND#10	VGND#11	108.241165
Rf56	VGND#3	VGND#12	32.870350
Rf57	VGND#4	VGND#13	34.376072
Rf58	VGND#5	VGND#14	40.197906
Rf59	VGND#6	VGND#15	39.828037
Rf60	VGND#8	VGND#16	38.701569
Rf61	VGND#9	VGND#17	37.650959
Rf62	VGND#10	VGND#18	39.828037
Re1	A#68	A#66	10.680273
Re2	A#66	A#64	0.902491
Re3	A#64	A	0.775507
Re4	A	A#62	0.049886
Re5	A#62	A#60	0.829929
Re6	A#60	A#58	0.852604
Re7	A#58	A#56	10.630386
Re8	Y#28	Y#31	10.684808
Re9	Y#31	Y#32	0.907026
Re10	Y#32	Y#33	0.861674
Re11	Y#33	Y	0.362810
Re12	Y	Y#34	0.453513
Re13	Y#34	Y#35	0.861674
Re14	Y#35	Y#36	0.861674
Re15	Y#36	Y#3	10.639457
Re16	VPWR#2	VPWR	4.549932
Re17	VPWR	VPWR#7	0.974985
Re18	VGND#2	VGND	4.549932
Re19	VGND	VGND#7	0.974985
Re28	Y#24	Y#31	9.777782
Re29	Y#20	Y#32	9.777782
Re30	Y#16	Y#33	9.777782
Re31	Y#13	Y#34	9.777782
Re32	Y#9	Y#35	9.777782
Re33	Y#6	Y#36	9.777782
*
*       CAPACITOR CARDS
*
*
C1	VGND#17	A#43	2.14151e-19
C2	VGND#18	VGND#17	2.40247e-18
C3	A	VNB	1.6845e-18
C4	A#52	VPWR#18	3.06663e-17
C5	VPWR#17	A#54	1.71283e-19
C6	A#22	VNB	5.68528e-18
C7	A#19	VNB	5.63482e-18
C8	VPWR#5	VPWR#4	9.4479e-19
C9	A#16	VNB	6.05962e-18
C10	A	Y	4.68302e-17
C11	A#13	VNB	4.82038e-18
C12	A#10	VNB	5.86422e-18
C13	Y#17	A#14	7.07702e-18
C14	VGND#2	VPWR#1	5.35857e-18
C15	A#7	VNB	4.44397e-17
C16	A#4	VNB	4.52579e-17
C17	A#45	VGND#16	2.61375e-17
C18	VGND#7	VNB	2.81332e-16
C19	VPWR#7	VNB	2.82306e-16
C20	Y#3	VNB	1.02283e-17
C21	A#56	VNB	3.42092e-18
C22	Y#6	VNB	3.33763e-18
C23	A#58	VNB	1.87938e-18
C24	Y#20	VGND#13	1.11869e-18
C25	Y#9	VNB	1.23871e-18
C26	A#60	VNB	2.18557e-18
C27	A	A#13	2.17821e-17
C28	VPWR#2	VPWR#12	1.47495e-17
C29	Y#13	VNB	3.75736e-18
C30	A#52	Y#7	2.16123e-17
C31	Y#16	VNB	1.91696e-18
C32	A#64	VNB	1.83233e-18
C33	Y#21	A#11	8.43188e-18
C34	Y#20	VNB	6.7843e-18
C35	Y	A#13	2.60959e-18
C36	A#66	VNB	2.06455e-18
C37	Y#24	VNB	3.47856e-18
C38	A#68	VNB	3.66783e-18
C39	VGND#7	A	1.23284e-17
C40	VGND#4	VGND#3	1.25336e-18
C41	VGND#2	VNB	1.33462e-16
C42	Y#8	A#43	1.6239e-18
C43	VPWR#2	VNB	1.28982e-16
C44	Y#28	VNB	1.97618e-17
C45	A#25	VNB	3.80655e-17
C46	A#54	VNB	3.12585e-17
C47	Y#25	A#8	2.29847e-20
C48	A#52	VNB	3.63075e-17
C49	A#50	VNB	3.64398e-17
C50	A#48	VNB	3.66567e-17
C51	A#46	VNB	3.80759e-17
C52	Y	VPWR#7	5.84738e-18
C53	VPWR#18	A#50	7.72434e-19
C54	A#44	VNB	3.75223e-17
C55	A#42	VNB	3.66281e-17
C56	Y#29	A#5	3.80784e-20
C57	VPWR#17	A#52	3.70183e-19
C58	A#40	VNB	3.53606e-17
C59	Y#14	A#45	1.62207e-18
C60	A#38	VNB	3.18088e-17
C61	VGND#10	A#20	4.88653e-21
C62	A#36	VNB	3.03346e-17
C63	A	Y#13	5.67772e-17
C64	A#34	VNB	3.74922e-17
C65	A#32	VNB	3.26462e-17
C66	Y#5	VGND#17	6.51803e-17
C67	A#30	VNB	3.33765e-17
C68	VGND#6	A#43	2.96136e-19
C69	A#28	VNB	3.32946e-17
C70	VPWR#17	Y#10	6.55337e-17
C71	A	Y#16	4.93997e-17
C72	A#1	VNB	3.92623e-17
C73	A#55	VNB	3.55131e-17
C74	A#53	VNB	3.20883e-17
C75	A#51	VNB	3.27977e-17
C76	VPWR#2	VPWR#1	2.67324e-17
C77	A#49	VNB	3.52757e-17
C78	A#47	VNB	3.33179e-17
C79	A#45	VNB	3.41603e-17
C80	A#43	VNB	3.36422e-17
C81	VPWR#5	A#11	3.82912e-20
C82	A#41	VNB	3.2672e-17
C83	A#50	Y#7	2.37337e-17
C84	A#39	VNB	2.96134e-17
C85	VGND#7	A#22	5.16563e-19
C86	A#43	VGND#16	2.18781e-17
C87	Y#16	A#11	7.73637e-18
C88	A#37	VNB	3.03182e-17
C89	A#35	VNB	2.76691e-17
C90	Y#8	A#23	1.15919e-19
C91	A#33	VNB	2.90737e-17
C92	Y#28	VPWR#12	1.06825e-16
C93	A#31	VNB	2.9325e-17
C94	A#29	VNB	3.08248e-17
C95	A#27	VNB	3.19721e-17
C96	A#26	VNB	3.5485e-17
C97	VGND#7	A#19	5.56298e-19
C98	VPWR#11	VNB	8.22521e-17
C99	Y#3	A#22	2.49102e-17
C100	A#66	VGND#13	7.37531e-18
C101	VPWR#18	VNB	3.34724e-18
C102	VGND#15	A#45	2.09507e-19
C103	A#56	A#22	2.44998e-17
C104	VPWR#17	VNB	3.0111e-18
C105	Y#10	VNB	2.16168e-18
C106	VPWR#9	A#54	8.34499e-20
C107	VPWR#16	VNB	3.0111e-18
C108	VGND#7	A#16	7.05307e-19
C109	VPWR#18	A#48	2.81831e-19
C110	VPWR#15	VNB	3.24742e-18
C111	A#22	Y#6	2.35117e-17
C112	Y#15	VNB	4.54866e-18
C113	VPWR#14	VNB	3.29395e-18
C114	A#50	VPWR#17	3.33457e-17
C115	VPWR#13	VNB	3.94218e-18
C116	Y#28	Y#26	6.86544e-18
C117	VPWR#12	VNB	3.74405e-18
C118	VGND#7	A#13	5.16563e-19
C119	A#66	Y#25	2.42176e-18
C120	VPWR#1	VNB	5.83524e-17
C121	VGND#11	VNB	7.05486e-17
C122	VPWR#17	VPWR#16	2.09124e-18
C123	VPWR#3	A#28	1.98845e-18
C124	Y#6	A#19	2.31484e-17
C125	Y#16	A#14	5.71312e-18
C126	Y#4	VNB	1.26049e-17
C127	VGND#18	VNB	5.51383e-18
C128	Y#5	VNB	4.11737e-18
C129	A#55	A#53	3.95082e-17
C130	VGND#17	VNB	5.7863e-18
C131	Y#14	A#43	3.86094e-17
C132	A#58	A#19	2.24475e-17
C133	Y#8	VNB	2.79724e-18
C134	VGND#7	A#10	6.75505e-19
C135	VGND#16	VNB	6.0753e-18
C136	Y#5	Y#8	5.66786e-18
C137	VPWR#10	A#54	2.74074e-18
C138	Y#14	VNB	5.26434e-18
C139	VGND#15	VNB	9.53786e-19
C140	Y#17	VNB	3.43385e-18
C141	A#19	Y#9	2.26949e-17
C142	VGND#14	VNB	4.92159e-18
C143	Y#21	VNB	3.24093e-18
C144	Y#28	VPWR#1	9.5687e-17
C145	VGND#13	VNB	6.24579e-18
C146	VGND#7	A#7	7.62752e-19
C147	Y#10	A#50	1.09555e-18
C148	Y#25	VNB	3.2822e-18
C149	VGND#12	VNB	5.91129e-18
C150	Y#29	VNB	1.19326e-17
C151	VGND#1	VNB	4.81778e-17
C152	A#2	VNB	4.41538e-17
C153	A#5	VNB	1.75609e-17
C154	VPWR#7	A#7	2.8202e-20
C155	Y#9	A#16	2.23664e-17
C156	VGND#16	A#41	9.51847e-19
C157	A#8	VNB	2.04984e-17
C158	Y#17	A#17	1.12879e-19
C159	VGND#9	A#43	6.89486e-20
C160	Y	A#40	7.92591e-19
C161	A#11	VNB	5.79259e-17
C162	VPWR#4	A#7	2.04712e-20
C163	A#60	A#16	2.15383e-17
C164	A#14	VNB	5.29273e-17
C165	A#17	VNB	5.6816e-17
C166	VPWR#6	A#11	5.10103e-21
C167	A#20	VNB	5.87035e-17
C168	A#64	A#11	5.27919e-18
C169	A#48	VPWR#17	2.76958e-17
C170	A#16	Y#13	2.85696e-17
C171	A#23	VNB	5.67591e-17
C172	VPWR#16	A#50	1.71283e-19
C173	A#24	VNB	4.09536e-17
C174	VGND#15	A#43	1.63023e-18
C175	Y#16	VPWR#5	1.01445e-18
C176	Y#10	VPWR#16	5.66693e-17
C177	Y#13	A#13	2.53304e-17
C178	Y#24	Y#25	2.55264e-19
C179	Y#16	VPWR#6	1.34819e-18
C180	A#23	Y#1	1.48557e-19
C181	Y#10	A#48	4.50431e-17
C182	VGND#7	A#56	1.00856e-17
C183	Y#14	A#41	1.86407e-17
C184	Y#3	VPWR#7	3.33788e-17
C185	VGND#17	Y#8	6.55015e-17
C186	A#13	Y#16	2.35993e-17
C187	Y#20	A#8	6.7404e-18
C188	A#53	A#51	3.05458e-17
C189	Y#24	VGND#12	2.63714e-20
C190	VGND#3	A#7	2.85129e-20
C191	Y#17	A#43	1.9132e-19
C192	Y#16	A#10	2.53284e-17
C193	VGND#7	A#58	1.30878e-17
C194	VPWR#17	A#46	4.09291e-19
C195	VGND#16	A#39	2.86029e-19
C196	Y#6	VPWR#7	3.47423e-17
C197	A	VPWR#15	6.35695e-18
C198	A#56	Y#3	3.9068e-17
C199	VPWR#16	A#48	3.70183e-19
C200	VGND#4	A#7	3.78687e-20
C201	A#64	A#10	2.3823e-17
C202	VGND#6	A#41	1.1323e-17
C203	VGND#4	A#8	2.10828e-20
C204	Y#3	Y#6	1.83766e-18
C205	A#10	Y#20	1.81437e-17
C206	VGND#15	A#41	1.46615e-17
C207	A#23	A#20	3.75752e-18
C208	VGND#7	A#60	1.36445e-17
C209	VGND#5	Y#17	7.11333e-18
C210	Y#9	VPWR#7	1.67071e-17
C211	A#24	Y#1	3.27464e-19
C212	Y#20	A#11	6.46127e-18
C213	Y#10	A#46	5.21697e-17
C214	A#56	Y#6	8.21676e-17
C215	Y#20	A#7	2.3158e-17
C216	A#60	VPWR#7	2.00324e-19
C217	A#20	Y#7	2.04615e-19
C218	Y#14	A#39	1.83506e-18
C219	VGND#17	VGND#16	1.37816e-18
C220	A#66	A#7	2.46147e-17
C221	VPWR#9	A#52	2.99535e-19
C222	Y#13	VPWR#7	4.77235e-17
C223	A	VGND#15	3.21183e-18
C224	VPWR#17	A#44	1.78501e-19
C225	Y#24	A#7	2.53474e-17
C226	A#58	Y#6	7.77153e-17
C227	Y	VPWR#15	2.99694e-17
C228	A#46	VPWR#16	3.33312e-17
C229	VGND#12	VPWR#12	2.33682e-19
C230	A#23	VPWR#18	8.10112e-18
C231	Y#17	A#41	4.21155e-19
C232	A#66	A#8	2.94254e-18
C233	VGND#7	A#64	1.34454e-17
C234	A#51	A#49	4.04819e-17
C235	A#68	VGND#12	2.81155e-18
C236	Y#6	Y#9	1.90747e-18
C237	Y#16	VPWR#7	1.52057e-17
C238	A#16	A#46	1.26155e-18
C239	VPWR#10	A#52	8.39941e-18
C240	Y#24	A#4	1.97577e-17
C241	A#16	A#44	1.26944e-18
C242	Y#10	A#44	1.20257e-18
C243	A#58	Y#9	8.17079e-17
C244	A#68	A#4	2.45549e-17
C245	VGND#7	A#66	1.36049e-17
C246	VGND#15	A#39	4.53143e-17
C247	VGND#6	Y#17	6.89192e-18
C248	VPWR#3	VNB	2.51797e-17
C249	VPWR#4	VNB	3.12055e-17
C250	VPWR#5	VNB	3.0417e-17
C251	Y#20	VPWR#7	3.79841e-17
C252	VPWR#6	VNB	2.58627e-17
C253	VGND#2	A#4	7.73157e-19
C254	VPWR#8	VNB	1.98713e-17
C255	Y#24	A#5	5.71239e-18
C256	VPWR#9	VNB	3.01849e-17
C257	A#17	Y#10	2.60556e-19
C258	VPWR#10	VNB	3.66735e-17
C259	A	A#14	6.00128e-18
C260	Y#10	VPWR#8	7.73283e-18
C261	VGND#3	VNB	2.68525e-17
C262	VGND#4	VNB	3.18312e-17
C263	VGND#5	VNB	2.89825e-17
C264	VGND#6	VNB	2.55897e-17
C265	VPWR#2	A#4	5.65071e-20
C266	VGND#8	VNB	2.11388e-17
C267	VGND#7	A#68	3.08967e-18
C268	VPWR#6	VPWR#5	1.28575e-18
C269	A#13	A#44	8.23893e-20
C270	VGND#9	VNB	3.09954e-17
C271	Y#8	VGND#16	6.53119e-17
C272	VGND#10	VNB	3.50591e-17
C273	Y#14	A#37	2.14995e-19
C274	A#44	VPWR#16	2.76997e-17
C275	A#64	VPWR#5	2.10845e-19
C276	VPWR#15	A#46	1.97554e-19
C277	A#60	Y#9	7.9869e-17
C278	Y#28	A#4	3.63811e-17
C279	Y#24	VPWR#7	3.23977e-17
C280	VPWR#16	VPWR#15	2.17087e-18
C281	A#20	VPWR#17	4.23089e-18
C282	Y#17	A#39	1.39411e-17
C283	Y#9	Y#13	2.07648e-18
C284	VGND#5	A#39	2.63417e-19
C285	VGND#2	VGND#12	1.51054e-17
C286	Y#24	A#8	1.48196e-20
C287	A#44	Y#11	2.37541e-17
C288	A#23	Y#7	2.71714e-19
C289	A#49	A#47	2.99835e-17
C290	VGND#5	VGND#4	1.23326e-18
C291	A#60	Y#13	7.92926e-17
C292	A#14	Y#11	2.12576e-19
C293	Y#10	VPWR#9	9.27264e-18
C294	VGND#15	A#37	1.89607e-18
C295	VGND#2	Y#29	3.58698e-17
C296	VPWR#16	A#42	4.0617e-19
C297	VPWR#15	A#44	1.82019e-18
C298	A#68	A#5	1.93143e-18
C299	VGND#14	A#39	4.47806e-19
C300	VGND#10	A#23	8.23128e-20
C301	Y#8	Y#14	5.93944e-18
C302	VGND#6	A#39	9.18776e-18
C303	VPWR#8	A#50	8.34499e-20
C304	Y	A#14	8.01499e-19
C305	A#17	VPWR#16	3.02141e-18
C306	A#10	A#34	7.27459e-20
C307	VGND#2	VGND#1	2.33481e-17
C308	VPWR#7	A#25	5.42908e-18
C309	A#22	VPWR#18	3.01942e-17
C310	Y#13	Y#16	1.79336e-18
C311	VPWR#7	A#54	1.56975e-18
C312	Y#17	A#37	4.46299e-17
C313	A#11	Y#15	3.00514e-19
C314	VGND#2	A#2	3.00282e-19
C315	A#20	Y#10	2.15773e-19
C316	VPWR#9	A#50	1.02864e-17
C317	VPWR#7	A#52	1.66946e-18
C318	Y#3	A#25	3.24668e-17
C319	A#7	A#34	1.41701e-18
C320	VPWR#16	A#40	1.76958e-19
C321	VPWR#7	A#50	1.70737e-18
C322	VGND#15	A#35	2.19458e-19
C323	A#7	A#32	1.36704e-18
C324	Y#3	A#54	4.22466e-17
C325	A#47	A#45	3.9564e-17
C326	A#42	VPWR#15	3.2271e-17
C327	A#64	VGND#4	7.9342e-20
C328	VGND#11	VPWR#11	1.18328e-17
C329	A#14	VPWR#15	2.79271e-18
C330	VPWR#7	A#48	1.70768e-18
C331	Y#3	A#52	1.66359e-18
C332	A#56	A#25	1.96679e-18
C333	VGND#16	Y#14	7.38873e-17
C334	A#37	VGND#14	2.40381e-17
C335	A#8	Y#18	3.56455e-19
C336	VPWR#7	A#46	1.6848e-18
C337	A#64	VGND#5	1.74831e-18
C338	Y#3	A#50	1.35074e-19
C339	Y#20	VPWR#4	9.5384e-18
C340	A#19	VPWR#17	2.82148e-17
C341	A#64	Y#16	7.68167e-17
C342	Y#15	A#42	1.25354e-18
C343	VPWR#7	A#44	1.00961e-17
C344	VPWR#6	A#14	1.50122e-20
C345	A#17	Y#11	2.63722e-19
C346	Y#17	A#35	1.34539e-18
C347	VPWR#7	A#42	2.0631e-18
C348	A#4	A#30	1.36024e-18
C349	Y#20	VPWR#5	1.03576e-17
C350	Y#16	Y#20	1.14147e-18
C351	A#24	A#23	3.48142e-18
C352	VGND#4	Y#21	8.20065e-18
C353	Y#6	A#54	1.73617e-18
C354	VPWR#2	A#2	1.98672e-20
C355	A#4	A#28	1.44964e-18
C356	A#11	VPWR#14	3.25821e-18
C357	A#5	Y#22	2.36551e-19
C358	VPWR#7	A#40	2.30867e-18
C359	Y#4	A#22	1.93751e-17
C360	Y#28	VGND#12	1.75946e-19
C361	A#40	VPWR#15	2.65483e-17
C362	VPWR#15	Y#15	6.01513e-17
C363	VGND#18	A#22	2.53284e-17
C364	VPWR#14	A#42	2.13129e-19
C365	Y#21	A#37	1.77432e-18
C366	A#64	Y#20	8.0809e-17
C367	Y#6	A#52	3.12698e-17
C368	VPWR#7	A#38	1.82704e-18
C369	A#22	Y#5	2.07525e-17
C370	VGND#5	A#37	5.52831e-18
C371	VPWR#7	A#36	1.94801e-18
C372	Y#28	Y#29	2.05209e-18
C373	Y#6	A#50	4.03532e-17
C374	VGND#16	VGND#15	2.5954e-18
C375	A#45	A#43	2.99224e-17
C376	A#2	Y#26	2.36551e-19
C377	A#40	Y#15	2.62042e-17
C378	A#35	VGND#14	2.00455e-17
C379	A#14	Y#15	1.75815e-19
C380	VPWR#7	A#34	1.07769e-18
C381	VGND#7	VGND#3	1.55952e-17
C382	A#16	VPWR#16	2.14828e-17
C383	Y#6	A#48	1.85105e-18
C384	VGND#1	VPWR#1	1.32411e-17
C385	VGND#7	VGND#4	6.03852e-17
C386	VPWR#7	A#32	2.45374e-18
C387	A#66	Y#20	8.28215e-17
C388	VGND#13	A#37	2.13008e-19
C389	Y#6	A#46	1.36393e-19
C390	VPWR#15	A#38	1.77792e-18
C391	VPWR#8	A#48	2.99535e-19
C392	VGND#4	A#11	1.20149e-20
C393	VGND#7	VGND#5	5.49307e-17
C394	VPWR#7	A#30	1.04285e-18
C395	VGND#6	A#37	3.3607e-19
C396	VGND#10	A#24	2.60702e-20
C397	VPWR#15	VPWR#14	1.38613e-18
C398	VPWR#14	A#40	1.83028e-18
C399	VGND#5	Y#21	6.80671e-18
C400	VGND#7	A#55	3.4977e-18
C401	VGND#7	VGND#6	4.99306e-17
C402	Y#20	Y#24	1.6565e-18
C403	Y#28	A#2	7.36919e-18
C404	Y#5	A#19	2.06846e-17
C405	Y#21	A#35	3.89346e-17
C406	VGND#7	A#53	4.9864e-18
C407	A#11	Y#18	2.15773e-19
C408	VGND#7	VGND#8	4.1506e-17
C409	Y#9	A#50	6.52395e-19
C410	VGND#17	A#19	2.04003e-17
C411	VPWR#9	A#48	1.03716e-17
C412	A#38	Y#15	2.32439e-17
C413	VGND#7	A#51	2.26089e-18
C414	A#19	Y#8	2.15695e-17
C415	VGND#7	VGND#9	5.90696e-17
C416	A#66	Y#24	8.49543e-17
C417	Y#9	A#48	9.72015e-18
C418	Y#14	VGND#15	6.49747e-17
C419	VGND#7	A#49	2.49673e-18
C420	VGND#7	VGND#10	7.77682e-17
C421	VGND#14	A#33	4.73941e-19
C422	A#13	VPWR#15	2.19778e-17
C423	VGND#7	A#47	2.17115e-18
C424	Y#9	A#46	1.26692e-17
C425	VPWR#15	A#36	1.9937e-19
C426	A#43	A#41	4.0462e-17
C427	VPWR#7	VPWR#3	1.28684e-17
C428	Y#15	VPWR#14	6.37185e-17
C429	A#38	VPWR#14	3.40411e-17
C430	Y#28	A#5	2.42587e-20
C431	VGND#7	A#45	2.10069e-18
C432	VGND#13	A#35	4.676e-19
C433	Y#9	A#44	9.21334e-19
C434	VPWR#7	VPWR#4	5.85855e-17
C435	A#66	VPWR#4	1.88289e-19
C436	A	VPWR#6	6.01553e-19
C437	VGND#7	A#43	1.04896e-17
C438	A#68	Y#24	8.42634e-17
C439	VGND#5	A#11	6.07548e-20
C440	VPWR#7	VPWR#5	5.7468e-17
C441	A#60	A#46	1.54291e-19
C442	VPWR#8	VPWR#6	1.27351e-18
C443	VGND#7	A#41	2.40973e-18
C444	Y#15	A#36	1.18659e-18
C445	Y#21	A#33	4.57263e-17
C446	A	VGND#5	6.22237e-20
C447	VPWR#7	VPWR#6	5.04974e-17
C448	A	VGND#6	2.73091e-18
C449	VGND#7	A#39	2.47933e-18
C450	Y#8	A#16	2.14901e-17
C451	A#60	A#44	1.52646e-19
C452	VPWR#7	VPWR#8	4.8694e-17
C453	VGND#16	A#16	1.96624e-17
C454	Y#14	Y#17	5.60157e-18
C455	A#22	A#20	1.07537e-19
C456	VGND#7	A#37	2.42192e-18
C457	A#16	Y#14	1.77527e-17
C458	Y#13	A#46	1.99411e-18
C459	VGND#14	A#31	2.12635e-19
C460	VPWR#7	VPWR#9	6.77827e-17
C461	A#22	A#23	2.416e-17
C462	Y#24	VPWR#2	5.14312e-18
C463	VGND#7	A#35	2.63452e-18
C464	VGND#2	A#68	6.89448e-18
C465	A#36	VPWR#14	3.08702e-17
C466	VGND#5	A#35	3.42587e-18
C467	A#10	VPWR#14	3.0197e-17
C468	VPWR#7	VPWR#10	6.99592e-17
C469	VPWR#13	A#38	2.67687e-19
C470	Y#13	A#44	3.26402e-17
C471	VPWR#6	A#46	6.48333e-20
C472	VGND#7	A#33	1.22365e-18
C473	VGND#6	VGND#5	1.07678e-18
C474	A#33	VGND#13	2.56843e-17
C475	Y#24	Y#28	2.09811e-18
C476	VGND#7	A#31	1.56225e-18
C477	A#41	A#39	4.04025e-17
C478	Y#13	A#42	2.30658e-17
C479	VGND#7	A#29	5.43299e-19
C480	A#36	Y#18	1.28527e-17
C481	VPWR#8	A#46	1.03077e-17
C482	Y#21	A#31	2.65637e-19
C483	Y#13	A#40	2.20586e-18
C484	A#68	Y#28	3.8164e-17
C485	VGND#6	A#35	7.90443e-20
C486	VGND#15	Y#17	6.13827e-17
C487	VPWR#14	A#34	2.10823e-18
C488	Y#14	A#13	1.73173e-17
C489	Y#13	A#38	2.52038e-19
C490	Y#25	A#33	1.03069e-18
C491	VGND#7	VPWR#11	5.14661e-18
C492	VPWR#13	A#36	1.97023e-18
C493	VGND#15	A#13	1.89115e-17
C494	VPWR#9	A#46	3.40035e-19
C495	Y#16	A#44	2.43578e-19
C496	A#19	A#20	2.28876e-17
C497	VGND#3	Y#25	8.20065e-18
C498	A#66	VGND#3	7.33764e-20
C499	A#13	Y#17	1.87395e-17
C500	A#7	VPWR#13	3.47362e-17
C501	Y#24	VPWR#3	9.01703e-18
C502	VGND#7	VPWR#18	1.56558e-18
C503	Y#16	A#42	9.13519e-19
C504	A#31	VGND#13	2.27342e-17
C505	A#7	Y#22	2.39747e-19
C506	A#34	Y#18	6.37502e-18
C507	Y#28	VPWR#2	4.74954e-17
C508	A#66	VGND#4	1.36327e-18
C509	Y#16	A#40	9.75719e-18
C510	Y#24	VPWR#4	9.47069e-18
C511	VGND#12	A#33	2.8639e-19
C512	A#39	A#37	4.05194e-17
C513	VPWR#14	VPWR#13	1.45046e-18
C514	Y	VPWR#6	4.80003e-19
C515	VPWR#14	A#32	2.8391e-19
C516	VPWR#7	VPWR#11	5.4864e-17
C517	VGND#4	A#33	3.61796e-18
C518	VPWR#8	VPWR#15	2.16006e-20
C519	VGND#15	VGND#14	2.74875e-18
C520	Y#16	A#38	8.54945e-18
C521	A#34	VPWR#13	3.82892e-17
C522	Y#25	A#31	4.07477e-17
C523	VPWR#7	VPWR#18	1.23071e-17
C524	A#16	A#17	1.89882e-17
C525	VGND#4	Y#25	7.64783e-18
C526	Y#16	A#36	6.36784e-19
C527	Y#17	A#10	1.36802e-17
C528	A#11	A#8	3.372e-18
C529	VGND#14	A#10	2.02877e-17
C530	VGND#13	A#29	7.63722e-19
C531	A#4	VPWR#12	3.58227e-17
C532	Y#16	A#34	1.27763e-19
C533	A#10	Y#21	2.2023e-17
C534	VPWR#11	Y#3	9.48743e-17
C535	Y#15	VPWR#5	8.42018e-18
C536	VPWR#6	A#44	2.72058e-19
C537	Y#20	A#40	1.36194e-19
C538	Y#3	VPWR#10	1.92359e-17
C539	A#4	Y#26	2.39747e-19
C540	VPWR#7	Y#10	1.73455e-17
C541	VGND#7	VPWR#14	8.37824e-19
C542	Y#3	Y#1	8.94437e-19
C543	VGND#12	A#31	7.4197e-19
C544	A#32	VPWR#13	3.14992e-17
C545	Y#20	A#38	1.63964e-18
C546	Y#3	VPWR#18	1.0872e-16
C547	VPWR#12	A#34	2.8528e-19
C548	Y#17	VGND#14	7.30982e-17
C549	VGND#7	VPWR#13	7.93728e-19
C550	VPWR#8	A#44	1.94182e-18
C551	A#37	A#35	3.00057e-17
C552	VPWR#8	A#17	1.6104e-20
C553	A#13	A#14	2.13046e-17
C554	Y#25	A#29	4.55544e-17
C555	Y#20	A#36	2.14066e-17
C556	VPWR#7	VPWR#15	9.73541e-18
C557	A#32	Y#22	2.37311e-17
C558	VPWR#7	Y#15	1.67012e-17
C559	A#13	A#17	1.95675e-20
C560	Y#15	VPWR#6	8.00952e-18
C561	Y#20	A#34	2.62925e-17
C562	VPWR#9	A#44	9.12873e-20
C563	VGND#11	VGND#10	1.31503e-18
C564	VGND#13	A#27	2.86078e-19
C565	VPWR#7	VPWR#14	1.1883e-17
C566	Y#21	A#7	1.79597e-17
C567	A#25	A#54	4.59792e-17
C568	A#56	VPWR#18	6.49822e-18
C569	VGND#13	A#7	2.70106e-17
C570	VPWR#13	A#30	7.67963e-19
C571	A#68	VPWR#3	5.13115e-20
C572	Y#20	A#32	1.77919e-18
C573	A#10	A#8	1.72771e-20
C574	Y#25	A#7	3.14747e-17
C575	VGND#7	VGND#11	5.8355e-17
C576	VPWR#12	A#32	7.67963e-19
C577	A#29	VGND#12	2.80247e-17
C578	VPWR#7	VPWR#13	1.52401e-17
C579	Y#17	Y#21	6.10744e-18
C580	A#66	A#34	2.36139e-19
C581	VGND#7	Y#4	2.22264e-17
C582	A#10	A#11	2.28468e-17
C583	Y#24	A#36	2.31476e-19
C584	A#30	Y#22	2.37311e-17
C585	Y#25	A#27	2.82965e-19
C586	VGND#4	A#31	2.96979e-18
C587	A#66	A#32	1.99034e-19
C588	VPWR#9	A#17	5.8684e-21
C589	VGND#5	A#14	6.80091e-22
C590	VGND#7	Y#5	1.73236e-17
C591	A#10	A#14	1.13038e-19
C592	VPWR#9	VPWR#8	7.4289e-19
C593	A#35	A#33	3.95845e-17
C594	Y#6	VPWR#18	9.9518e-17
C595	A#54	A#52	3.87841e-17
C596	Y#24	A#34	6.37043e-19
C597	VGND#7	VGND#17	1.28219e-17
C598	VPWR#13	A#28	2.8528e-19
C599	Y#29	A#29	2.89856e-19
C600	Y#6	Y#7	1.56109e-18
C601	VGND#7	Y#8	1.73301e-17
C602	A#7	A#5	3.48457e-18
C603	A#30	VPWR#12	3.79656e-17
C604	Y#24	A#32	3.33667e-17
C605	VGND#7	VGND#16	1.27231e-17
C606	Y#6	VPWR#17	8.70269e-17
C607	Y#25	A#4	1.79922e-17
C608	A#27	VGND#12	2.32089e-17
C609	VPWR#6	A#42	1.13188e-17
C610	A#8	A#7	2.63322e-18
C611	VGND#7	Y#14	3.06498e-17
C612	A#56	VPWR#10	2.29549e-19
C613	VGND#14	Y#21	6.21549e-17
C614	VGND#12	A#4	3.29356e-17
C615	Y#24	A#30	4.26012e-17
C616	VGND#7	VGND#15	1.17275e-17
C617	VGND#8	VGND#6	1.2974e-18
C618	Y#29	A#4	2.65938e-17
C619	VPWR#13	VPWR#12	1.69573e-18
C620	A#52	A#50	4.62023e-17
C621	VGND#1	A#29	2.87353e-19
C622	Y#25	A#26	1.49466e-19
C623	VGND#7	Y#17	1.55162e-17
C624	VPWR#8	A#42	3.33909e-19
C625	Y#24	A#28	6.34156e-19
C626	VGND#7	VGND#14	1.18048e-17
C627	A#4	A#2	3.48087e-18
C628	VGND#6	A#14	7.18905e-20
C629	A#28	VPWR#12	3.14434e-17
C630	A#68	A#30	1.98548e-19
C631	A#58	VPWR#17	6.5767e-18
C632	VGND#7	Y#21	1.87796e-17
C633	Y#29	A#27	3.92091e-17
C634	A#33	A#31	2.26631e-17
C635	VPWR#1	A#30	2.97439e-19
C636	VGND#7	VGND#13	1.4282e-17
C637	A#5	A#4	2.53223e-18
C638	VGND#10	Y#4	1.5754e-17
C639	VGND#7	Y#25	2.07505e-17
C640	VGND#3	A#29	3.18918e-18
C641	A#68	VGND#3	3.98282e-19
C642	VGND#12	A#26	1.4681e-18
C643	VGND#14	VGND#13	1.36628e-18
C644	Y#3	VGND#18	1.3196e-19
C645	A#25	A#23	2.31808e-19
C646	A#50	A#48	3.88393e-17
C647	A#28	Y#26	2.37785e-17
C648	VGND#10	A#55	2.38074e-18
C649	A#68	A#1	2.07992e-18
C650	A#56	VGND#10	1.44939e-18
C651	VGND#1	A#27	1.37281e-18
C652	Y#9	VPWR#17	3.53378e-17
C653	VPWR#12	A#1	1.38323e-18
C654	Y#9	Y#10	9.78918e-19
C655	VPWR#2	A#30	1.33993e-18
C656	VPWR#1	A#28	3.00157e-18
C657	Y#29	A#26	4.10911e-17
C658	Y#9	VPWR#16	3.26013e-17
C659	A#48	A#46	4.6154e-17
C660	A#14	A#11	3.7649e-18
C661	A#56	VGND#18	3.21183e-18
C662	VPWR#2	A#28	3.84079e-18
C663	Y#21	VGND#13	7.11033e-17
C664	A#31	A#29	3.95886e-17
C665	Y#6	VPWR#9	9.37232e-18
C666	Y#28	A#30	6.715e-19
C667	VPWR#6	A#40	9.70557e-18
C668	VPWR#2	A#1	1.05467e-17
C669	Y#6	VPWR#10	1.10161e-17
C670	VGND#1	A#26	2.35502e-17
C671	Y#28	A#28	3.35439e-17
C672	VGND#7	A#11	3.38567e-20
C673	VPWR#1	A#1	3.16259e-17
C674	VPWR#3	A#5	1.98672e-20
C675	A#60	VPWR#16	6.5767e-18
C676	VPWR#8	A#40	9.24815e-20
C677	A#46	A#44	3.77098e-17
C678	VGND#7	A#14	8.76319e-20
C679	Y#28	A#1	2.59974e-17
C680	VGND#9	A#53	7.28951e-20
C681	Y#21	Y#25	7.23304e-18
C682	VGND#7	A#17	3.1003e-19
C683	VGND#3	VGND#1	1.20807e-18
C684	VPWR#2	VPWR#3	3.534e-17
C685	VGND#3	A#27	3.7918e-18
C686	VGND#2	VGND#3	3.57132e-17
C687	VPWR#7	A#8	4.79373e-23
C688	Y#13	VPWR#16	1.03861e-16
C689	VGND#7	A#20	5.04686e-20
C690	A#29	A#27	2.15638e-17
C691	VGND#10	A#53	7.85173e-18
C692	A#44	A#42	4.71394e-17
C693	Y#13	Y#11	5.60966e-18
C694	VPWR#7	A#11	4.79373e-23
C695	VPWR#12	VPWR#1	1.82759e-18
C696	Y#13	VPWR#15	6.93146e-17
C697	VGND#7	A#24	2.87134e-19
C698	VPWR#9	A#20	2.58027e-19
C699	VPWR#10	VPWR#9	1.14868e-18
C700	VPWR#7	A#14	1.81511e-20
C701	VPWR#5	A#38	4.80651e-18
C702	VGND#13	Y#25	6.97724e-17
C703	A#58	VGND#17	3.36121e-18
C704	VPWR#7	A#17	2.25662e-20
C705	A#58	VPWR#9	5.70871e-19
C706	A#42	A#40	4.83326e-17
C707	VPWR#5	VPWR#13	3.19889e-19
C708	VPWR#7	A#20	3.88826e-19
C709	VGND#9	Y#5	8.20821e-18
C710	VGND#11	A#55	2.69106e-17
C711	A#27	A#26	3.95102e-17
C712	VGND#9	VGND#8	1.2261e-18
C713	VPWR#7	A#23	1.59805e-20
C714	VGND#13	VGND#12	1.4681e-18
C715	VPWR#10	A#20	1.0918e-21
C716	VGND#9	A#51	2.97496e-19
C717	A#40	A#38	4.81418e-17
C718	Y#4	A#55	4.00074e-17
C719	VPWR#15	Y#16	1.66279e-17
C720	Y#28	VPWR#3	5.18157e-19
C721	VGND#10	Y#5	7.63903e-18
C722	Y#16	Y#15	1.93628e-18
C723	VGND#11	A#53	1.37221e-18
C724	A#44	A#14	2.32005e-19
C725	A#58	VGND#9	2.81281e-18
C726	VGND#10	A#51	8.96384e-18
C727	VGND#18	A#55	8.28545e-19
C728	Y#16	VPWR#14	3.32657e-17
C729	Y#25	VGND#12	7.16867e-17
C730	Y#3	A#23	8.69267e-18
C731	Y#4	A#53	4.48279e-17
C732	A#38	A#36	4.42115e-17
C733	A#20	A#46	2.31942e-19
C734	VPWR#5	A#36	1.6823e-18
C735	Y#3	A#24	9.93067e-18
C736	VGND#8	A#17	1.25015e-19
C737	Y#5	A#55	1.0048e-19
C738	Y#9	VPWR#8	1.88218e-18
C739	A#60	VGND#16	3.28652e-18
C740	A#17	A#14	3.47805e-18
C741	VGND#11	A#51	2.75937e-19
C742	Y#9	VPWR#9	1.78138e-18
C743	A#64	VPWR#14	9.72929e-18
C744	A#53	VGND#18	2.39331e-17
C745	VGND#2	A#27	7.01675e-18
C746	Y#25	Y#29	4.58658e-18
C747	Y#4	A#51	1.4927e-18
C748	VPWR#11	VPWR#10	1.17344e-18
C749	A#36	A#34	4.16348e-17
C750	VGND#2	A#26	9.81794e-18
C751	Y#5	A#53	1.31651e-18
C752	A#56	A#23	2.88752e-18
C753	VGND#9	A#17	7.481e-21
C754	Y#20	VPWR#14	1.04272e-16
C755	VGND#9	A#49	1.13333e-17
C756	A#51	VGND#18	1.96299e-17
C757	Y#20	Y#18	2.14096e-17
C758	VGND#17	A#53	2.16873e-19
C759	VGND#10	VGND#17	2.34368e-20
C760	VGND#11	Y#4	7.48333e-17
C761	VPWR#4	A#34	7.58691e-18
C762	VPWR#4	A#8	1.98672e-20
C763	Y#20	VPWR#13	9.672e-17
C764	A#34	A#32	3.07375e-17
C765	VGND#12	Y#29	6.82353e-17
C766	Y#6	A#20	7.58554e-18
C767	VPWR#4	VPWR#3	9.53351e-19
C768	VGND#10	A#49	3.0652e-19
C769	Y#5	A#51	3.81665e-17
C770	VPWR#11	VPWR#18	9.74136e-19
C771	VGND#8	Y#8	8.0569e-18
C772	Y#14	A#11	1.26847e-19
C773	Y#6	A#23	7.128e-18
C774	VGND#18	A#49	4.24401e-19
C775	A#60	VPWR#8	2.39445e-19
C776	VGND#17	A#51	1.70207e-18
C777	Y#17	A#8	8.20705e-20
C778	VGND#11	VGND#18	2.32212e-18
C779	Y#4	A#23	8.71373e-18
C780	A#66	VPWR#13	1.04337e-17
C781	Y#21	A#5	1.79167e-19
C782	A#32	A#30	4.54843e-17
C783	Y#25	A#2	2.85591e-19
C784	Y#5	A#49	1.59629e-17
C785	VGND#12	VGND#1	1.51782e-18
C786	VPWR#5	A#8	9.79935e-21
C787	A#58	A#20	6.45113e-18
C788	Y#8	A#51	1.96473e-19
C789	VGND#9	Y#8	8.10658e-18
C790	VGND#18	A#47	1.90843e-19
C791	Y#5	A#20	8.08396e-18
C792	VGND#10	VGND#9	1.35217e-18
C793	VPWR#10	A#23	3.55414e-20
C794	A#49	VGND#17	2.52507e-17
C795	Y#24	VPWR#13	1.07777e-16
C796	Y#4	VGND#18	6.71074e-17
C797	Y#4	A#24	1.25617e-17
C798	VGND#16	VGND#6	7.69522e-20
C799	VGND#9	A#47	9.46922e-18
C800	Y#8	A#17	1.02161e-17
C801	Y#24	Y#22	8.94437e-19
C802	Y#5	A#47	1.55631e-18
C803	Y#9	A#17	6.68363e-18
C804	A#30	A#28	3.0679e-17
C805	VGND#3	A#5	4.08055e-21
C806	VGND#18	A#23	4.14315e-18
C807	Y#29	VGND#1	7.52794e-17
C808	VPWR#4	A#32	2.71346e-18
C809	A#60	VGND#8	1.60236e-18
C810	Y#8	A#49	1.62888e-18
C811	Y#16	VGND#14	7.15045e-19
C812	Y#24	VPWR#12	1.04943e-16
C813	VPWR#11	A#25	3.0752e-17
C814	Y#14	A#14	5.88443e-18
C815	A#11	A#34	2.02319e-19
C816	Y#9	A#20	6.05423e-18
C817	VGND#10	A#47	8.22764e-20
C818	A#47	VGND#17	2.02291e-17
C819	VGND#17	A#20	5.81804e-18
C820	Y#4	Y#5	3.71472e-18
C821	Y#13	VPWR#6	3.94324e-18
C822	A#25	Y#1	2.44129e-17
C823	Y#17	A#11	7.29895e-18
C824	VGND#16	A#49	2.80057e-19
C825	VPWR#18	VPWR#9	6.08442e-20
C826	Y#21	A#8	9.75278e-18
C827	VPWR#11	A#54	1.11723e-18
C828	A#28	A#1	4.63642e-17
C829	VPWR#18	A#25	1.36899e-18
C830	A#20	A#17	3.47781e-18
C831	VGND#6	A#45	7.29467e-20
C832	Y#25	A#5	9.9587e-18
C833	VGND#16	A#17	7.75738e-18
C834	A#68	VPWR#12	8.78082e-18
C835	Y#8	A#47	3.87914e-17
C836	VPWR#18	VPWR#17	2.1234e-18
C837	Y#29	A#2	8.11636e-18
C838	A#60	A#17	4.91009e-18
C839	A#64	VGND#14	5.68779e-18
C840	Y#5	A#23	8.15002e-18
C841	A#54	Y#1	2.37392e-17
C842	VGND#15	A#14	4.93144e-18
C843	VGND#17	A#45	4.79762e-19
C844	VGND#18	Y#5	6.49574e-17
C845	VPWR#3	VPWR#1	1.42682e-18
C846	VGND#8	A#45	8.39941e-18
C847	VGND#9	VGND#16	4.98442e-20
C848	VPWR#11	A#52	2.28306e-19
C849	VGND#16	A#47	7.49976e-19
C850	A#54	VPWR#18	3.70986e-17
C851	Y#8	A#20	8.50554e-18
C852	VGND#14	A#11	8.35296e-18
C853	VPWR#10	A#24	2.75679e-20
C854	Y#13	A#14	6.90696e-18
C855	VPWR#3	A#30	2.98155e-18
C856	VGND#2	VPWR#12	2.02421e-18
C857	VPWR#10	A#25	2.42018e-18
C858	VGND#13	A#8	1.84864e-18
C859	Y#8	A#45	4.66179e-17
C860	VGND#9	A#20	9.44988e-20
C861	VGND#6	Y#14	3.11688e-18
C862	Y#5	A#24	1.85259e-19
C863	VGND#1	A#2	2.84635e-18
C864	VGND#9	A#45	2.76092e-19
C865	Y#14	A#17	8.35453e-18
C866	Y#13	A#17	7.93983e-18
*
*
.ENDS sky130_fd_sc_hs__inv_16
*
