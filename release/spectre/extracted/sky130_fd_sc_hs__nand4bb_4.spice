* Extracted by Quantus, converted by sky130cad/quantus.py
*
*
*
*                       LINUX           Wed Nov 18 08:48:32 2026
*
*
*
*  PROGRAM  advgen
*
*  Name           : advgen - Quantus - (64-bit)
*  Version        : 25.1.0-p047
*  Build Date     : Thu Dec 11 23:20:30 PST 2025
*
*  HSPICE LIBRARY
*
*  OPERATING_TEMPERATURE 150
*  QRC_TECH_DIR <path>/tech
*
*
*

*
.SUBCKT sky130_fd_sc_hs__nand4bb_4 VPB VNB VGND VPWR Y D C A_N B_N
*
*
*  caps2d version: 10
*
*
*       TRANSISTOR CARDS
*
*
XM10 a_27_114##15 A_N#4 VGND#9 VNB sky130_fd_pr__nfet_01v8_lvt l=0.15 w=0.74 ad=0.2109 as=0.4387 pd=2.05 ps=3.14
XM13 VGND#9 B_N#4 a_232_114##15 VNB sky130_fd_pr__nfet_01v8_lvt l=0.15 w=0.74 ad=0.4387 as=0.2368 pd=3.14 ps=2.12
XM15 Y#8 a_27_114##7 a_374_74##7 VNB sky130_fd_pr__nfet_01v8_lvt l=0.15 w=0.74 ad=0.2849 as=0.2109 pd=2.25 ps=2.05
XM4 Y#8 a_27_114##12 a_374_74##8 VNB sky130_fd_pr__nfet_01v8_lvt l=0.15 w=0.74 ad=0.2849 as=0.2146 pd=2.25 ps=2.06
XM11 a_374_74##8 a_27_114##10 Y#6 VNB sky130_fd_pr__nfet_01v8_lvt l=0.15 w=0.74 ad=0.2146 as=0.2072 pd=2.06 ps=2.04
XM5 a_374_74##4 a_27_114##8 Y#6 VNB sky130_fd_pr__nfet_01v8_lvt l=0.15 w=0.74 ad=0.2072 as=0.2072 pd=2.04 ps=2.04
XM9 a_828_74##5 a_232_114##6 a_374_74##4 VNB sky130_fd_pr__nfet_01v8_lvt l=0.15 w=0.74 ad=0.2072 as=0.2072 pd=2.04 ps=2.04
XM36 a_374_74##2 a_232_114##11 a_828_74##5 VNB sky130_fd_pr__nfet_01v8_lvt l=0.15 w=0.74 ad=0.2072 as=0.2072 pd=2.04 ps=2.04
XM18 a_374_74##2 a_232_114##9 a_828_74##3 VNB sky130_fd_pr__nfet_01v8_lvt l=0.15 w=0.74 ad=0.2072 as=0.3314 pd=2.04 ps=2.4
XM24 a_828_74##3 a_232_114##7 a_374_74# VNB sky130_fd_pr__nfet_01v8_lvt l=0.15 w=0.74 ad=0.3314 as=0.2109 pd=2.4 ps=2.05
XM22 a_1229_74##5 C#12 a_828_74##6 VNB sky130_fd_pr__nfet_01v8_lvt l=0.15 w=0.74 ad=0.2109 as=0.2072 pd=2.05 ps=2.04
XM26 a_828_74##6 C#9 a_1229_74##8 VNB sky130_fd_pr__nfet_01v8_lvt l=0.15 w=0.74 ad=0.2072 as=0.2072 pd=2.04 ps=2.04
XM16 a_1229_74##8 C#7 a_828_74# VNB sky130_fd_pr__nfet_01v8_lvt l=0.15 w=0.74 ad=0.2072 as=0.2072 pd=2.04 ps=2.04
XM30 a_828_74# C#1 a_1229_74##7 VNB sky130_fd_pr__nfet_01v8_lvt l=0.15 w=0.74 ad=0.2072 as=0.2072 pd=2.04 ps=2.04
XM35 VGND#8 D#6 a_1229_74##7 VNB sky130_fd_pr__nfet_01v8_lvt l=0.15 w=0.74 ad=0.2072 as=0.2072 pd=2.04 ps=2.04
XM34 VGND#8 D#10 a_1229_74##6 VNB sky130_fd_pr__nfet_01v8_lvt l=0.15 w=0.74 ad=0.2072 as=0.2072 pd=2.04 ps=2.04
XM8 a_1229_74##6 D#8 VGND#7 VNB sky130_fd_pr__nfet_01v8_lvt l=0.15 w=0.74 ad=0.2072 as=0.259 pd=2.04 ps=2.18
XM0 a_1229_74# D#1 VGND#7 VNB sky130_fd_pr__nfet_01v8_lvt l=0.15 w=0.74 ad=0.2109 as=0.259 pd=2.05 ps=2.18
XM19 a_27_114##17 A_N#5 VPWR#12 VPB sky130_fd_pr__pfet_01v8 l=0.15 w=0.84 ad=0.252 as=0.2478 pd=2.28 ps=2.27
XM31 VPWR#21 A_N#1 a_27_114##17 VPB sky130_fd_pr__pfet_01v8 l=0.15 w=0.84 ad=0.252 as=0.252 pd=2.28 ps=2.28
XM20 a_232_114##16 B_N#5 VPWR#21 VPB sky130_fd_pr__pfet_01v8 l=0.15 w=0.84 ad=0.252 as=0.252 pd=2.28 ps=2.28
XM37 VPWR#20 B_N#1 a_232_114##16 VPB sky130_fd_pr__pfet_01v8 l=0.15 w=0.84 ad=0.553 as=0.252 pd=3.38 ps=2.28
XM3 Y#14 a_27_114##13 VPWR#20 VPB sky130_fd_pr__pfet_01v8 l=0.15 w=1.12 ad=0.392 as=0.553 pd=2.94 ps=3.38
XM27 Y#14 a_27_114##11 VPWR#19 VPB sky130_fd_pr__pfet_01v8 l=0.15 w=1.12 ad=0.392 as=0.336 pd=2.94 ps=2.84
XM6 VPWR#19 a_27_114##9 Y#18 VPB sky130_fd_pr__pfet_01v8 l=0.15 w=1.12 ad=0.336 as=0.336 pd=2.84 ps=2.84
XM33 VPWR#18 a_27_114# Y#18 VPB sky130_fd_pr__pfet_01v8 l=0.15 w=1.12 ad=0.336 as=0.336 pd=2.84 ps=2.84
XM21 VPWR#18 a_232_114##12 Y#17 VPB sky130_fd_pr__pfet_01v8 l=0.15 w=1.12 ad=0.336 as=0.336 pd=2.84 ps=2.84
XM12 VPWR#17 a_232_114##10 Y#17 VPB sky130_fd_pr__pfet_01v8 l=0.15 w=1.12 ad=0.392 as=0.336 pd=2.94 ps=2.84
XM28 Y#16 a_232_114##8 VPWR#17 VPB sky130_fd_pr__pfet_01v8 l=0.15 w=1.12 ad=0.336 as=0.392 pd=2.84 ps=2.94
XM2 Y#16 a_232_114# VPWR#16 VPB sky130_fd_pr__pfet_01v8 l=0.15 w=1.12 ad=0.336 as=0.336 pd=2.84 ps=2.84
XM7 Y#11 C#14 VPWR#16 VPB sky130_fd_pr__pfet_01v8 l=0.15 w=1.12 ad=0.336 as=0.336 pd=2.84 ps=2.84
XM1 VPWR#15 C#13 Y#11 VPB sky130_fd_pr__pfet_01v8 l=0.15 w=1.12 ad=0.448 as=0.336 pd=3.04 ps=2.84
XM23 Y#10 C#8 VPWR#15 VPB sky130_fd_pr__pfet_01v8 l=0.15 w=1.12 ad=0.336 as=0.448 pd=2.84 ps=3.04
XM25 VPWR#14 C#6 Y#10 VPB sky130_fd_pr__pfet_01v8 l=0.15 w=1.12 ad=0.392 as=0.336 pd=2.94 ps=2.84
XM14 Y#9 D#12 VPWR#14 VPB sky130_fd_pr__pfet_01v8 l=0.15 w=1.12 ad=0.336 as=0.392 pd=2.84 ps=2.94
XM17 Y#9 D#11 VPWR#13 VPB sky130_fd_pr__pfet_01v8 l=0.15 w=1.12 ad=0.336 as=0.336 pd=2.84 ps=2.84
XM29 VPWR#13 D#9 Y#1 VPB sky130_fd_pr__pfet_01v8 l=0.15 w=1.12 ad=0.336 as=0.336 pd=2.84 ps=2.84
XM32 VPWR#1 D#7 Y#1 VPB sky130_fd_pr__pfet_01v8 l=0.15 w=1.12 ad=0.3304 as=0.336 pd=2.83 ps=2.84
*
*
*       RESISTOR AND CAP/DIODE CARDS
*
Rg1	A_N#1	A_N#2	397.752228
Rg2	A_N#2	A_N#3	64.799530
Rg3	A_N#3	A_N#4	350.019196
Rg4	A_N#2	A_N#5	311.294403
Rg5	B_N#1	B_N#2	382.646179
Rg6	B_N#2	B_N#3	30.924026
Rg7	B_N#3	B_N#4	495.761597
Rg8	B_N#3	B_N#5	338.266205
Rg9	a_27_114#	a_27_114##2	554.793091
Rg10	a_27_114##2	a_27_114##3	22.761639
Rg11	a_27_114##3	a_27_114##4	42.444702
Rg12	a_27_114##4	a_27_114##5	16.948502
Rg13	a_27_114##5	a_27_114##6	44.551685
Rg14	a_27_114##6	a_27_114##7	369.888580
Rg15	a_27_114##2	a_27_114##8	376.847687
Rg16	a_27_114##3	a_27_114##9	400.575531
Rg17	a_27_114##4	a_27_114##10	310.239136
Rg18	a_27_114##5	a_27_114##11	396.253265
Rg19	a_27_114##6	a_27_114##12	320.693634
Rg20	a_27_114##6	a_27_114##13	437.450958
Rg21	a_232_114#	a_232_114##2	566.329346
Rg22	a_232_114##2	a_232_114##3	18.984928
Rg23	a_232_114##3	a_232_114##4	60.836979
Rg24	a_232_114##4	a_232_114##5	43.359482
Rg25	a_232_114##5	a_232_114##6	418.607971
Rg26	a_232_114##2	a_232_114##7	283.086792
Rg27	a_232_114##3	a_232_114##8	395.156311
Rg28	a_232_114##4	a_232_114##9	318.046356
Rg29	a_232_114##4	a_232_114##10	427.135651
Rg30	a_232_114##5	a_232_114##11	399.039703
Rg31	a_232_114##5	a_232_114##12	508.073486
Rg32	C#1	C#2	391.999054
Rg33	C#2	C#3	60.176399
Rg34	C#3	C#4	26.440405
Rg35	C#4	C#5	52.224861
Rg36	C#2	C#6	465.531921
Rg37	C#3	C#7	398.499390
Rg38	C#4	C#8	414.808441
Rg39	C#5	C#9	368.104980
Rg40	C#5	C#10	37.519978
Rg41	C#10	C#11	36.378445
Rg42	C#11	C#12	353.536194
Rg43	C#10	C#13	432.879364
Rg44	C#11	C#14	478.954651
Rg45	D#1	D#2	352.961426
Rg46	D#2	D#3	75.654991
Rg47	D#3	D#4	69.569275
Rg48	D#4	D#5	62.445145
Rg49	D#5	D#6	423.145813
Rg50	D#2	D#7	483.133362
Rg51	D#3	D#8	351.534241
Rg52	D#3	D#9	454.534424
Rg53	D#4	D#10	399.893494
Rg54	D#4	D#11	442.933136
Rg55	D#5	D#12	526.145996
Rf1	A_N#3	A_N#7	161.061707
Rf2	A_N#8	A_N	0.828910
Rf3	A_N#7	A_N#8	4.527236
Rf4	B_N#6	B_N	0.984182
Rf5	B_N#2	B_N#8	161.216980
Rf6	B_N#6	B_N#8	1.968364
Rf7	a_27_114##6	a_27_114##16	243.595108
Rf8	a_27_114##16	a_27_114##17	146.783569
Rf9	a_27_114##15	a_27_114##16	7.500000
Rf10	a_232_114##4	a_232_114##14	295.173492
Rf11	a_232_114##14	a_232_114##15	110.958626
Rf12	a_232_114##14	a_232_114##16	22.242716
Rf13	a_374_74#	a_374_74##3	86.834549
Rf14	a_374_74##3	a_374_74##5	70.629868
Rf15	a_374_74##5	a_374_74##6	69.695610
Rf16	a_374_74##6	a_374_74##7	99.503815
Rf17	a_374_74##6	a_374_74##8	18.957424
Rf18	a_374_74##2	a_374_74##3	15.000000
Rf19	a_374_74##4	a_374_74##5	15.000000
Rf20	C	C#5	42.450871
Rf21	a_828_74#	a_828_74##2	80.265083
Rf22	a_828_74##2	a_828_74##4	106.874252
Rf23	a_828_74##4	a_828_74##5	52.546246
Rf24	a_828_74##2	a_828_74##6	21.122623
Rf25	a_828_74##3	a_828_74##4	15.000000
Rf26	Y#1	Y#2	80.666893
Rf27	Y#2	Y#3	69.240715
Rf28	Y#3	Y#4	72.785042
Rf29	Y#4	Y#5	65.267540
Rf30	Y#5	Y#7	228.033600
Rf31	Y#7	Y#8	72.527618
Rf32	Y#2	Y#9	18.602406
Rf33	Y#3	Y#10	16.043533
Rf34	Y#4	Y#11	16.043533
Rf35	Y#5	Y#12	66.563393
Rf36	Y#12	Y#13	61.685928
Rf37	Y#13	Y	72.551239
Rf38	Y	Y#15	2.391325
Rf39	Y#15	Y	8.668552
Rf40	Y#5	Y#16	39.626461
Rf41	Y#12	Y#17	15.121450
Rf42	Y#13	Y#18	19.132584
Rf43	Y#6	Y#7	15.000000
Rf44	Y#14	Y#15	5.000000
Rf45	D	D#13	7.558595
Rf46	D#13	D	5.634589
Rf47	a_1229_74#	a_1229_74##2	80.560066
Rf48	a_1229_74##2	a_1229_74##3	62.951744
Rf49	a_1229_74##3	a_1229_74##4	62.951744
Rf50	a_1229_74##4	a_1229_74##5	85.983727
Rf51	a_1229_74##2	a_1229_74##6	24.653522
Rf52	a_1229_74##3	a_1229_74##7	24.825697
Rf53	a_1229_74##4	a_1229_74##8	24.848473
Rf54	VPWR#1	VPWR#2	112.381737
Rf55	VPWR#2	VPWR#3	36.623291
Rf56	VPWR#3	VPWR#4	29.983519
Rf57	VPWR#4	VPWR#5	72.328270
Rf58	VPWR#5	VPWR#6	72.328270
Rf59	VPWR#6	VPWR#7	62.831711
Rf60	VPWR#7	VPWR#8	69.348907
Rf61	VPWR#8	VPWR#9	62.104916
Rf62	VPWR#9	VPWR#10	88.549194
Rf63	VPWR#10	VPWR#11	72.270927
Rf64	VPWR#11	VPWR#12	95.155869
Rf65	VPWR#2	VPWR#13	53.143215
Rf66	VPWR#4	VPWR#14	38.736572
Rf67	VPWR#5	VPWR#15	31.534731
Rf68	VPWR#6	VPWR#16	42.062149
Rf69	VPWR#7	VPWR#17	33.503098
Rf70	VPWR#8	VPWR#18	30.353714
Rf71	VPWR#9	VPWR#19	33.851616
Rf72	VPWR#10	VPWR#20	30.353714
Rf73	VPWR#11	VPWR#21	30.353714
Rf75	VGND#2	VGND#3	67.218452
Rf76	VGND#3	VGND#4	369.087616
Rf77	VGND#4	VGND#5	187.715240
Rf79	VGND#2	VGND#7	34.113823
Rf80	VGND#3	VGND#8	37.611725
Rf81	VGND#5	VGND#9	24.468842
Rf87	D#3	D#13	32.046562
Re1	VPWR#3	VPWR	2.687498
Re2	VPWR	VPWR#9	1.343749
Re3	VGND#3	VGND	2.687498
Re4	VGND	VGND#4	1.343749
*
*       CAPACITOR CARDS
*
*
C1	D#7	VPWR#1	3.3634e-17
C2	a_27_114##6	a_27_114##5	2.22413e-17
C3	a_1229_74##4	C#9	1.64991e-17
C4	a_232_114##14	VPWR#21	2.54842e-17
C5	Y#1	D#7	5.53575e-17
C6	D#6	D#10	3.88835e-17
C7	a_27_114##6	a_27_114##3	6.50609e-20
C8	a_232_114##14	a_27_114##9	2.67413e-19
C9	Y#6	a_232_114##5	1.14291e-17
C10	VPWR#1	D#9	1.23306e-18
C11	a_1229_74##3	C#9	1.15097e-19
C12	VPWR#13	D#7	6.79311e-19
C13	a_27_114##6	B_N#3	1.23614e-17
C14	VPWR#18	a_232_114##5	9.63441e-20
C15	C#11	C#10	2.4725e-18
C16	Y#5	Y#4	4.40581e-18
C17	Y#1	D#9	6.36382e-17
C18	a_232_114##5	a_232_114##10	2.54126e-19
C19	a_27_114##17	a_232_114##14	1.93572e-17
C20	VPWR#1	D#11	2.59902e-19
C21	D#9	VPWR#13	2.47104e-17
C22	a_27_114##15	a_374_74##7	1.38506e-18
C23	C#1	D#6	4.02686e-17
C24	a_232_114##14	a_27_114##11	3.33413e-18
C25	a_232_114##10	a_232_114##3	1.73624e-19
C26	Y#1	D#11	1.77076e-18
C27	Y#9	D#9	1.66337e-18
C28	a_828_74##3	a_828_74##2	2.88709e-18
C29	D#11	VPWR#13	2.84561e-17
C30	Y#5	C#11	5.43616e-18
C31	a_27_114##15	a_232_114##15	4.13228e-17
C32	VPWR#14	D#9	1.78306e-19
C33	C#7	C#1	3.86944e-17
C34	Y#9	D#11	5.23881e-17
C35	a_232_114##14	a_27_114##13	1.66058e-17
C36	a_374_74##4	a_27_114##3	4.47644e-19
C37	VPWR#13	D#12	3.42982e-19
C38	VPWR#14	D#11	4.09291e-19
C39	a_27_114##15	VGND#9	3.4411e-18
C40	VPWR#2	VPWR#1	7.0017e-19
C41	Y#6	a_27_114##5	6.68925e-18
C42	Y#5	C#7	1.72422e-19
C43	Y#4	Y#3	1.93895e-18
C44	Y#9	D#12	4.55969e-17
C45	Y#5	C#10	4.58262e-19
C46	C#9	C#7	3.96618e-17
C47	a_232_114##14	B_N#1	1.89915e-17
C48	VPWR#13	C#6	1.53123e-19
C49	D#12	VPWR#14	2.81567e-17
C50	VPWR#8	VPWR#7	9.07129e-19
C51	a_27_114##7	VPWR#20	3.35623e-18
C52	Y#12	a_232_114##5	6.43693e-18
C53	VPWR#3	VPWR#5	5.05937e-17
C54	Y#9	C#6	1.39732e-18
C55	Y#10	D#12	1.6508e-18
C56	Y#4	C#11	2.8351e-18
C57	a_1229_74#	D#2	7.92431e-18
C58	VPWR#3	VPWR#4	5.71927e-17
C59	Y#1	VPWR#2	1.71045e-17
C60	Y#5	C#9	2.51875e-19
C61	A_N#3	B_N#3	1.23568e-17
C62	C#6	VPWR#14	3.18165e-17
C63	VPWR#15	D#12	2.81749e-19
C64	VPWR#3	VPWR#2	6.29214e-17
C65	a_232_114##14	B_N#5	1.20205e-17
C66	C#12	C#9	3.8795e-17
C67	Y#6	a_27_114##3	1.59269e-17
C68	Y#2	D#5	1.22891e-18
C69	Y#10	C#6	5.33771e-17
C70	a_27_114##5	a_374_74##8	5.78825e-19
C71	a_27_114#	a_232_114##5	9.86911e-18
C72	Y#12	a_232_114##3	4.52595e-19
C73	VPWR#14	C#8	3.70183e-19
C74	VPWR#15	C#6	7.692e-19
C75	Y#4	C#10	2.98207e-18
C76	a_27_114##3	a_232_114##6	5.86377e-18
C77	Y#5	C#12	1.77294e-18
C78	a_828_74##2	Y#5	9.05644e-19
C79	Y#10	C#8	4.65296e-17
C80	Y#13	a_27_114##5	1.18469e-18
C81	VPWR#10	VPWR#9	6.25795e-19
C82	a_232_114##14	A_N#1	6.87967e-18
C83	a_232_114##7	C#12	3.9994e-18
C84	VPWR#9	VPWR#8	1.02927e-18
C85	Y#2	D#4	9.90574e-19
C86	a_828_74##2	C#7	1.37198e-18
C87	VPWR#14	C#13	1.72643e-19
C88	C#8	VPWR#15	3.19778e-17
C89	VGND#3	a_1229_74##4	2.70862e-18
C90	a_27_114##3	Y#18	9.45519e-19
C91	Y#1	VPWR#1	7.81108e-17
C92	VGND#3	a_1229_74##3	5.5396e-18
C93	VGND#7	D#2	5.08055e-19
C94	Y#10	C#13	5.78631e-19
C95	Y#11	C#8	5.78631e-19
C96	a_27_114##5	a_27_114##8	2.27358e-18
C97	a_1229_74#	VGND#7	5.49723e-17
C98	VGND#3	a_1229_74##2	3.48634e-18
C99	VPWR#7	VPWR#6	1.20296e-18
C100	a_27_114##5	VPWR#19	1.30946e-18
C101	a_374_74##4	a_27_114#	4.17442e-19
C102	Y#5	a_232_114##7	6.51768e-18
C103	a_828_74##2	Y#4	1.30688e-18
C104	C#13	VPWR#15	3.62253e-17
C105	VPWR#16	C#8	1.72643e-19
C106	a_27_114##17	A_N#7	2.90435e-17
C107	a_232_114##9	a_232_114##7	1.84861e-17
C108	a_232_114##14	A_N#5	1.02747e-18
C109	VPWR#3	Y#4	1.18221e-18
C110	a_374_74##6	a_374_74##4	3.11773e-18
C111	VPWR#13	VPWR#1	1.94092e-18
C112	Y#8	a_27_114##5	2.2339e-18
C113	Y#6	a_27_114#	3.41176e-18
C114	a_828_74##2	C#9	2.70621e-17
C115	Y#11	C#13	5.40643e-17
C116	VPWR#3	Y#3	2.88381e-18
C117	Y#3	C#10	5.21699e-18
C118	Y#2	VPWR#3	3.40953e-18
C119	a_1229_74##6	a_1229_74#	2.43064e-18
C120	VPWR#15	C#14	7.692e-19
C121	VPWR#16	C#13	3.70183e-19
C122	B_N#8	B_N#3	1.04085e-17
C123	Y#1	VPWR#13	5.25377e-17
C124	Y#11	C#14	4.63571e-17
C125	Y#10	VPWR#5	9.23714e-18
C126	Y#5	a_232_114##9	5.49408e-18
C127	a_232_114##11	a_232_114##9	3.62136e-17
C128	Y#5	a_232_114##5	7.8038e-18
C129	a_27_114##3	VPWR#19	8.76256e-20
C130	Y#13	a_27_114##3	2.30356e-18
C131	a_374_74##6	Y#6	4.17664e-17
C132	C#14	VPWR#16	2.11055e-17
C133	VPWR#15	a_232_114#	2.84892e-19
C134	a_828_74##2	C#12	2.96356e-17
C135	VGND#3	Y#3	9.24646e-19
C136	Y#13	VPWR#9	1.9613e-19
C137	a_1229_74##6	VGND#7	3.77032e-17
C138	VPWR#6	VPWR#15	2.24131e-19
C139	VGND#8	D#5	4.88023e-19
C140	Y#9	Y#1	2.36849e-18
C141	B_N#8	A_N#2	2.95747e-20
C142	Y#11	a_232_114#	1.43586e-18
C143	Y#10	VPWR#4	7.68868e-18
C144	a_27_114##5	Y#14	2.31466e-19
C145	Y#13	a_232_114##6	3.32183e-19
C146	VPWR#16	a_232_114#	4.56093e-17
C147	a_232_114##6	a_232_114##11	3.62051e-17
C148	VGND#3	a_828_74##2	1.01389e-16
C149	VPWR#6	VPWR#5	8.80709e-19
C150	a_374_74##6	a_374_74##8	9.09394e-19
C151	Y#5	a_232_114##3	3.6267e-17
C152	Y#12	a_232_114##6	9.81547e-20
C153	a_232_114#	Y#16	1.94592e-17
C154	Y#9	VPWR#13	5.20507e-17
C155	VGND#8	VGND#7	3.32188e-18
C156	a_828_74##2	a_232_114##7	4.86424e-19
C157	a_1229_74#	D#1	4.54155e-17
C158	VGND#8	D#4	2.92021e-19
C159	VPWR#2	D#3	8.53585e-20
C160	D#2	VPWR#1	5.0152e-18
C161	VPWR#17	a_232_114#	2.28833e-18
C162	VPWR#16	a_232_114##8	1.85163e-18
C163	Y#11	VPWR#6	7.75241e-18
C164	VPWR#15	VPWR#4	2.24131e-19
C165	a_27_114##8	a_232_114##6	3.95308e-17
C166	a_232_114##8	Y#16	2.5529e-17
C167	D#1	VGND#7	1.97337e-17
C168	VPWR#14	VPWR#13	2.02693e-18
C169	a_1229_74##2	D#3	3.84307e-18
C170	a_374_74##6	Y#8	4.81056e-17
C171	VGND#8	a_1229_74##6	3.76784e-17
C172	VPWR#17	a_232_114##8	5.92941e-17
C173	Y#11	VPWR#5	9.17044e-18
C174	a_1229_74#	D#8	1.64366e-18
C175	a_828_74##2	a_232_114##9	1.50647e-19
C176	A_N#2	B_N#3	1.94911e-19
C177	a_1229_74##6	D#1	7.28521e-19
C178	Y#17	a_232_114##8	1.01922e-18
C179	Y#16	a_232_114##10	8.14394e-20
C180	VPWR#14	Y#9	6.12484e-17
C181	a_232_114##3	C#11	1.55517e-17
C182	a_27_114##10	a_27_114##8	3.77484e-17
C183	VGND#7	D#8	3.27022e-17
C184	VPWR#18	a_232_114##8	3.03503e-19
C185	a_232_114##10	VPWR#17	2.57613e-17
C186	a_1229_74##7	a_1229_74##6	2.21128e-18
C187	a_374_74##7	a_374_74##6	2.27537e-18
C188	a_1229_74#	D#10	2.03445e-19
C189	Y#17	a_232_114##10	5.08554e-17
C190	Y#16	VPWR#7	5.28917e-18
C191	D#8	a_1229_74##6	1.44203e-17
C192	a_828_74##2	a_232_114##11	3.40317e-20
C193	Y#10	Y#9	2.207e-18
C194	VPWR#5	VPWR#4	8.80709e-19
C195	VGND#4	a_374_74##6	7.18212e-17
C196	D#2	Y#1	1.19129e-18
C197	VPWR#18	a_232_114##10	1.86547e-18
C198	VPWR#17	a_232_114##12	7.45976e-19
C199	a_27_114##12	a_27_114##10	3.54675e-17
C200	Y#2	D#3	1.76856e-18
C201	a_27_114##13	a_27_114##5	6.20316e-19
C202	VGND#7	D#10	1.72203e-18
C203	Y#18	a_232_114##10	1.7978e-19
C204	a_232_114##12	Y#17	2.09249e-17
C205	VGND#8	D#8	1.41514e-18
C206	Y#16	VPWR#6	5.1988e-18
C207	a_1229_74##7	VGND#8	3.77032e-17
C208	VPWR#10	a_27_114##6	2.94517e-20
C209	a_828_74##2	C#11	4.70077e-19
C210	Y#10	VPWR#14	5.29637e-17
C211	VGND#3	a_1229_74#	1.82622e-17
C212	VPWR#18	a_232_114##12	4.80099e-17
C213	D#10	a_1229_74##6	1.75546e-17
C214	Y#18	a_232_114##12	4.31265e-19
C215	a_1229_74##7	D#8	1.70178e-19
C216	Y#17	a_27_114#	6.04151e-19
C217	a_27_114##7	a_27_114##12	2.46343e-17
C218	VGND#3	a_1229_74##6	1.70086e-17
C219	VPWR#18	a_27_114#	4.23287e-17
C220	VPWR#15	VPWR#14	2.15425e-18
C221	B_N#3	a_27_114##13	3.75069e-18
C222	VGND#8	D#10	3.26582e-17
C223	a_232_114##4	Y#13	7.53991e-17
C224	a_828_74#	VGND#8	3.94097e-18
C225	a_232_114##4	Y#12	8.24894e-17
C226	VGND#3	a_1229_74##7	2.30567e-17
C227	Y#17	VPWR#8	7.97908e-18
C228	a_27_114#	Y#18	2.32259e-17
C229	a_828_74##2	C#10	1.00759e-18
C230	Y#17	a_27_114##9	2.57104e-19
C231	VPWR#17	VPWR#6	6.61283e-20
C232	a_1229_74##6	D#6	4.0342e-19
C233	VGND#3	a_828_74#	6.56765e-17
C234	a_232_114##4	Y#5	9.18279e-17
C235	a_1229_74##7	D#10	4.0342e-19
C236	VPWR#19	a_27_114#	2.17383e-18
C237	Y#2	Y#1	6.21728e-19
C238	a_27_114##15	A_N#1	1.32963e-18
C239	VGND#3	a_1229_74##8	5.82063e-18
C240	VPWR#18	a_27_114##9	1.80532e-18
C241	B_N#4	a_27_114##7	5.09257e-18
C242	VPWR#15	Y#10	6.22435e-17
C243	Y#5	a_27_114##3	3.52701e-19
C244	Y#14	a_27_114#	2.17333e-19
C245	Y#17	VPWR#7	7.2069e-18
C246	VGND#8	D#6	2.83751e-17
C247	a_27_114##9	Y#18	2.72298e-17
C248	a_828_74#	a_1229_74##7	4.03165e-17
C249	B_N#3	a_27_114##7	1.26441e-17
C250	VPWR#4	VPWR#2	7.35961e-19
C251	D#5	Y#9	1.43007e-19
C252	a_232_114##15	B_N#3	2.3208e-17
C253	VGND#3	a_1229_74##5	2.22695e-19
C254	VPWR#19	a_27_114##9	4.85806e-17
C255	a_1229_74##6	C#1	1.70178e-19
C256	Y#11	Y#10	2.91184e-18
C257	D#6	a_1229_74##7	1.41238e-17
C258	VGND#3	a_828_74##3	5.02918e-18
C259	A_N#4	B_N#4	2.29162e-17
C260	Y#14	a_27_114##9	4.83874e-19
C261	Y#18	a_27_114##11	4.31265e-19
C262	a_374_74##6	a_27_114##8	8.45501e-19
C263	Y#2	VPWR#13	1.61599e-17
C264	a_232_114##15	a_232_114##14	1.69425e-18
C265	D#4	Y#9	1.15272e-19
C266	B_N#3	B_N#1	3.68648e-18
C267	VGND#8	C#1	1.4563e-18
C268	a_1229_74##8	a_1229_74##7	1.77981e-18
C269	VPWR#19	a_27_114##11	4.27931e-17
C270	a_828_74#	D#6	1.86149e-18
C271	VPWR#6	C#11	1.54016e-20
C272	Y#11	VPWR#15	6.22197e-17
C273	VPWR#18	VPWR#7	1.52601e-19
C274	a_1229_74#	D#3	4.08191e-19
C275	Y#14	a_27_114##11	2.81243e-17
C276	Y#18	a_27_114##13	1.80324e-19
C277	VGND#7	D#3	6.23157e-19
C278	C#1	a_1229_74##7	1.72358e-17
C279	VPWR#20	a_27_114##11	5.06688e-19
C280	VPWR#2	D#7	2.36601e-18
C281	VPWR#19	a_27_114##13	2.17602e-18
C282	a_1229_74##8	D#6	2.51532e-19
C283	a_374_74##6	a_27_114##10	2.34813e-17
C284	Y#18	VPWR#8	6.94149e-18
C285	a_828_74#	a_1229_74##8	2.96079e-17
C286	VGND#8	C#7	5.53356e-20
C287	Y#14	a_27_114##13	4.69108e-17
C288	Y#2	Y#9	9.91418e-19
C289	VPWR#16	VPWR#15	2.15425e-18
C290	a_374_74##6	a_27_114##6	5.56463e-19
C291	a_828_74#	C#1	3.63683e-17
C292	a_27_114##13	VPWR#20	2.53748e-17
C293	a_828_74#	C#10	1.12368e-18
C294	VPWR#19	B_N#1	2.17263e-19
C295	VPWR#3	VPWR#1	5.70114e-17
C296	Y#3	VPWR#14	1.41164e-17
C297	VGND#4	a_828_74##3	7.85542e-17
C298	VPWR#4	D#9	9.43017e-20
C299	a_1229_74##7	C#7	3.24704e-19
C300	a_232_114##14	a_27_114##6	9.43792e-17
C301	a_232_114##16	a_27_114##13	3.62637e-19
C302	VPWR#3	Y#1	1.89605e-17
C303	Y#14	B_N#1	2.24042e-18
C304	a_1229_74##8	C#1	5.96275e-19
C305	VPWR#16	Y#11	5.96469e-17
C306	VGND#4	a_828_74##5	5.09751e-17
C307	VPWR#21	a_27_114##13	2.6853e-19
C308	Y#13	VPWR#8	1.9613e-19
C309	VPWR#2	D#9	7.3564e-18
C310	VGND#8	C#9	2.9643e-20
C311	B_N#1	VPWR#20	3.29363e-17
C312	a_374_74##6	a_27_114##12	2.30251e-17
C313	VPWR#21	B_N#3	3.98204e-18
C314	a_27_114##15	a_232_114##14	5.22885e-19
C315	VGND#4	a_374_74##4	3.99149e-17
C316	a_828_74#	C#7	3.90999e-17
C317	Y#9	VPWR#3	3.39468e-17
C318	Y#2	VPWR#14	1.68625e-17
C319	a_232_114##16	B_N#1	4.23929e-17
C320	VPWR#5	C#11	3.11882e-20
C321	D#9	D#7	4.68943e-17
C322	a_1229_74##7	C#9	1.36973e-19
C323	VPWR#21	B_N#1	2.43748e-18
C324	Y#3	Y#10	2.68731e-19
C325	VPWR#3	Y#10	1.72489e-17
C326	VPWR#20	B_N#5	1.10021e-18
C327	C#7	a_1229_74##8	1.56858e-17
C328	VPWR#8	a_232_114##5	2.90106e-20
C329	VPWR#4	D#11	3.40035e-19
C330	a_27_114##17	B_N#1	1.61107e-19
C331	D#4	D#9	1.39165e-18
C332	VPWR#3	VPWR#15	2.09062e-17
C333	B_N	B_N#3	8.699e-18
C334	B_N#5	a_232_114##16	1.35698e-17
C335	VGND#8	C#12	2.34148e-20
C336	VGND#4	a_374_74##7	2.32572e-17
C337	Y#4	VPWR#15	1.7239e-17
C338	a_27_114##15	B_N#3	1.91654e-18
C339	a_828_74#	C#9	1.03181e-18
C340	a_374_74##6	a_27_114##7	8.6899e-19
C341	VPWR#21	B_N#5	4.3461e-17
C342	D#11	D#9	4.844e-17
C343	VPWR#2	D#11	4.39599e-18
C344	Y#12	VPWR#8	2.99964e-19
C345	Y#16	VPWR#16	5.82681e-17
C346	Y#10	Y#2	8.69008e-19
C347	a_1229_74##2	VGND#7	1.53162e-17
C348	a_27_114##17	B_N#5	1.30863e-18
C349	a_232_114##16	A_N#1	3.06655e-19
C350	VPWR#5	C#10	2.64084e-20
C351	C#9	a_1229_74##8	1.77473e-17
C352	Y#3	VPWR#15	1.64411e-17
C353	a_232_114##14	A_N#3	7.92483e-19
C354	a_1229_74##5	a_1229_74##8	3.39744e-18
C355	a_1229_74##5	C#7	2.8326e-19
C356	VPWR#21	A_N#1	4.38043e-17
C357	a_27_114##15	A_N#2	3.18092e-19
C358	B_N#3	A_N#1	1.29799e-17
C359	VPWR#17	VPWR#16	2.66815e-18
C360	a_27_114##17	B_N#3	1.41962e-18
C361	D#12	D#11	4.67323e-17
C362	VPWR#4	D#12	2.89254e-18
C363	a_27_114##15	VPWR#21	1.80436e-18
C364	A_N#1	a_27_114##17	1.7292e-17
C365	a_232_114##15	B_N#8	6.49633e-18
C366	Y#4	Y#11	2.68731e-19
C367	C#9	a_828_74##6	1.44708e-17
C368	a_232_114##16	A_N#5	1.9797e-19
C369	a_374_74##6	B_N#4	6.56529e-20
C370	VPWR#12	A_N#1	2.64683e-18
C371	Y#12	Y#16	6.82691e-19
C372	Y#12	VPWR#7	1.44335e-19
C373	VPWR#21	A_N#5	2.57999e-18
C374	VPWR#2	D#12	2.84497e-19
C375	a_232_114##6	a_27_114#	7.40627e-18
C376	B_N#8	A_N#3	1.39808e-19
C377	a_232_114##14	a_27_114##7	7.70325e-18
C378	a_1229_74##8	C#12	1.06387e-18
C379	a_27_114##17	A_N#2	1.85688e-17
C380	Y#5	VPWR#16	1.41537e-17
C381	VPWR#17	Y#16	5.76466e-17
C382	a_1229_74##2	a_1229_74##6	5.7327e-19
C383	VPWR#7	a_232_114##5	1.35383e-20
C384	a_27_114##17	A_N#5	3.02048e-17
C385	a_1229_74##5	C#9	6.48173e-19
C386	D#3	Y#1	1.42143e-18
C387	C#6	D#12	3.8366e-17
C388	A_N	B_N#3	4.26464e-18
C389	a_27_114##15	a_27_114##17	2.45212e-18
C390	a_232_114##16	VPWR#11	8.9587e-18
C391	A_N	A_N#2	3.04941e-18
C392	Y#6	a_232_114##4	8.49343e-17
C393	a_1229_74##3	VGND#8	1.35458e-17
C394	VPWR#12	A_N#5	4.26581e-17
C395	D#3	VPWR#13	1.41517e-18
C396	C#12	a_828_74##6	1.44708e-17
C397	VPWR#2	D#2	4.5102e-20
C398	A_N#7	A_N#3	1.15625e-17
C399	VPWR#4	C#6	5.32943e-18
C400	Y#4	VPWR#16	1.68206e-17
C401	Y#3	D#7	1.51071e-19
C402	a_1229_74##8	a_232_114##7	8.50078e-20
C403	a_232_114##16	VPWR#10	6.21094e-18
C404	Y#12	VPWR#17	2.65109e-17
C405	C#8	C#6	4.54562e-17
C406	VPWR#4	C#10	1.61339e-20
C407	a_1229_74##5	C#12	3.08881e-17
C408	C	D#5	5.49174e-18
C409	VPWR#2	C#6	7.81181e-20
C410	Y#6	a_27_114##6	2.59024e-17
C411	Y#5	Y#16	4.27956e-18
C412	a_232_114##5	a_232_114##3	9.06163e-19
C413	VPWR#6	C#8	8.3258e-20
C414	C	C#11	2.00815e-17
C415	Y#18	VPWR#9	6.99281e-18
C416	a_1229_74##2	VGND#8	1.47003e-17
C417	C	C#10	4.95133e-17
C418	a_27_114##6	a_374_74##8	7.74393e-20
C419	VPWR#7	a_232_114##3	1.88691e-20
C420	Y#13	Y#17	8.05539e-19
C421	Y#17	VPWR#17	6.19134e-17
C422	VPWR#3	D#5	5.02826e-20
C423	a_27_114##6	Y#8	7.29242e-17
C424	a_1229_74##3	a_1229_74##7	1.48378e-18
C425	a_374_74#	C#12	7.26476e-19
C426	VPWR#5	C#8	2.56349e-18
C427	a_27_114##6	a_374_74##7	7.28178e-17
C428	C	a_232_114##3	8.36697e-18
C429	Y#14	VPWR#9	1.9613e-19
C430	VPWR#3	D#4	4.05308e-20
C431	C#13	C#8	3.0328e-17
C432	a_1229_74##4	a_828_74#	1.49519e-17
C433	a_232_114##15	a_27_114##6	3.90335e-17
C434	a_1229_74##5	C#11	4.49339e-18
C435	a_374_74#	a_1229_74##5	2.97483e-17
C436	a_1229_74##5	a_232_114##7	2.85204e-18
C437	VPWR#4	C#8	2.99535e-19
C438	Y#3	D#9	4.16204e-19
C439	a_828_74##3	C#12	6.08215e-19
C440	Y#12	Y#17	9.84312e-19
C441	a_1229_74##3	D#5	1.07522e-18
C442	VPWR#18	VPWR#17	1.77565e-18
C443	a_27_114##15	a_27_114##6	2.63539e-18
C444	B_N#8	a_27_114##7	4.61721e-19
C445	D#12	D#4	1.39165e-18
C446	Y#5	VPWR#17	1.38951e-17
C447	C#1	D#5	4.33956e-19
C448	Y#5	VPWR#7	2.71689e-19
C449	Y#2	D#9	1.07385e-19
C450	VGND#3	D#1	5.76099e-19
C451	VPWR#3	C#10	6.23724e-21
C452	a_374_74#	a_232_114##7	4.53685e-17
C453	VPWR#6	C#13	2.99535e-19
C454	C#14	C#13	4.63533e-17
C455	Y#13	VPWR#18	1.67868e-17
C456	VGND#3	D#8	1.17803e-18
C457	a_1229_74##3	a_828_74#	1.38166e-17
C458	a_1229_74##5	C#10	1.24427e-18
C459	a_1229_74##5	a_232_114##9	5.76432e-19
C460	VPWR#18	Y#17	5.23478e-17
C461	VPWR#5	C#13	2.57993e-18
C462	VGND#3	D#10	4.64391e-18
C463	a_27_114##17	VPWR#11	1.05092e-17
C464	a_828_74##3	a_232_114##7	3.66338e-17
C465	a_1229_74##4	a_1229_74##8	2.00975e-19
C466	D	D#5	1.56473e-17
C467	VGND#3	D#6	4.83046e-18
C468	Y#3	D#11	6.74354e-19
C469	D	D#4	1.92136e-17
C470	D	D#2	3.12907e-17
C471	a_232_114#	C#14	4.92634e-17
C472	VPWR#4	C#13	8.3258e-20
C473	Y#12	VPWR#18	1.67132e-17
C474	VGND#3	C#1	7.75314e-18
C475	D	C#10	8.58055e-18
C476	VPWR#6	a_232_114##3	1.86175e-20
C477	VPWR#11	B_N#3	5.12601e-20
C478	a_374_74#	a_232_114##9	9.47398e-19
C479	a_232_114##4	VPWR#17	3.19768e-18
C480	a_232_114##15	A_N#3	2.3918e-18
C481	Y#2	D#11	1.83482e-17
C482	C#10	D#12	4.25468e-19
C483	Y#18	Y#17	2.36923e-18
C484	VGND#3	C#7	6.07009e-18
C485	Y#5	VPWR#6	2.60402e-19
C486	a_232_114##4	Y#17	2.49066e-18
C487	C#10	VPWR#15	1.89459e-18
C488	a_374_74#	a_828_74##3	6.07323e-17
C489	A_N#7	VGND#9	5.2738e-19
C490	VGND#3	D#4	2.06322e-20
C491	VPWR#6	C#14	5.26749e-18
C492	a_1229_74##5	a_232_114##11	3.00069e-19
C493	a_232_114##4	VPWR#18	9.145e-19
C494	VGND#3	C#9	6.06655e-18
C495	a_27_114##15	A_N#3	7.83881e-18
C496	Y#13	Y#18	2.97442e-18
C497	a_828_74##3	a_232_114##9	4.20241e-17
C498	a_232_114##8	a_232_114#	4.70146e-17
C499	a_232_114##4	Y#18	4.95493e-19
C500	VGND#3	C#12	4.49134e-18
C501	a_1229_74##8	a_1229_74##3	1.50048e-18
C502	a_232_114##4	VPWR#19	4.41372e-19
C503	a_1229_74##2	D#5	2.51801e-19
C504	VGND#3	C#11	5.8125e-20
C505	Y#18	VPWR#18	5.26701e-17
C506	VPWR#12	VPWR#11	1.03096e-18
C507	Y#3	D#12	5.11237e-19
C508	a_374_74#	a_232_114##11	3.41481e-19
C509	a_232_114##4	Y#14	1.49726e-17
C510	a_1229_74##4	a_828_74##6	2.26521e-20
C511	a_374_74##2	a_232_114##9	2.73753e-17
C512	VGND#3	C#10	1.40933e-19
C513	a_374_74##4	a_232_114##7	1.58528e-19
C514	VPWR#8	a_27_114##3	2.72529e-20
C515	a_232_114##10	a_232_114##8	3.75065e-17
C516	VPWR#11	A_N#2	2.96916e-19
C517	Y#2	D#12	2.25274e-17
C518	a_1229_74##5	a_232_114##6	3.00986e-19
C519	a_27_114##15	A_N#7	2.98115e-17
C520	Y#4	VPWR#6	2.60402e-19
C521	VPWR#19	VPWR#18	1.76661e-18
C522	a_27_114##6	Y#14	3.88238e-18
C523	Y#13	VPWR#19	2.08334e-17
C524	a_1229_74##4	C#10	5.63007e-18
C525	VPWR#6	a_232_114#	4.8914e-18
C526	Y#6	a_232_114##7	3.0784e-19
C527	a_27_114##6	VPWR#20	4.21783e-19
C528	a_374_74#	a_232_114##6	2.12649e-19
C529	VPWR#10	B_N#3	1.23879e-20
C530	VGND#4	a_232_114##7	4.47052e-18
C531	a_374_74##2	a_232_114##11	2.61238e-17
C532	a_232_114##12	a_232_114##10	4.70395e-17
C533	a_1229_74##2	D#4	1.59758e-18
C534	Y#3	C#6	2.48406e-17
C535	a_374_74##4	a_232_114##9	2.47521e-19
C536	VGND#4	a_232_114##9	4.47052e-18
C537	a_828_74##3	a_374_74##2	3.60531e-17
C538	C#10	C#6	1.11945e-18
C539	VPWR#19	Y#18	5.26519e-17
C540	VGND#3	a_232_114##3	1.94252e-20
C541	a_374_74##6	a_27_114##5	8.63487e-19
C542	A_N	VPWR#11	3.96368e-19
C543	VGND#4	a_232_114##11	4.47052e-18
C544	a_828_74##5	a_232_114##11	3.46224e-17
C545	Y#2	C#6	1.5561e-19
C546	VGND#4	a_232_114##6	4.58765e-18
C547	a_27_114#	a_232_114##12	4.70758e-17
C548	VPWR#7	a_232_114##8	1.83828e-18
C549	Y#6	a_232_114##9	3.45919e-19
C550	Y#4	VPWR#5	1.6661e-19
C551	a_374_74#	a_27_114##8	1.48148e-19
C552	VGND#4	a_27_114##8	4.47785e-18
C553	Y#4	C#8	9.80236e-19
C554	Y#14	Y#13	2.4829e-20
C555	Y#14	Y#18	2.4829e-18
C556	VPWR#3	D#7	2.46177e-18
C557	VPWR#6	a_232_114##8	3.95329e-19
C558	a_374_74##4	a_232_114##11	4.80762e-19
C559	VGND#4	a_27_114##10	4.47785e-18
C560	D#5	D#4	3.8854e-18
C561	a_374_74##4	a_374_74#	1.53278e-18
C562	a_1229_74#	VPWR#1	3.06501e-19
C563	VGND#4	a_27_114##12	4.47785e-18
C564	VPWR#3	D#9	1.59023e-19
C565	Y#3	C#8	2.42802e-17
C566	a_27_114##9	a_27_114#	4.77635e-17
C567	a_828_74##5	a_232_114##6	2.61554e-17
C568	VGND#4	a_27_114##7	4.49429e-18
C569	VPWR#3	D#11	3.0747e-18
C570	Y#6	a_232_114##11	5.54297e-18
C571	Y#14	VPWR#19	3.76531e-17
C572	a_27_114##17	A_N#3	2.85423e-18
C573	Y#5	C#13	1.61534e-19
C574	VPWR#3	D#12	1.82856e-18
C575	a_1229_74##3	C#10	1.82058e-18
C576	a_374_74##4	a_232_114##6	2.91873e-17
C577	a_27_114##11	a_27_114##9	4.67337e-17
C578	VPWR#7	a_232_114##10	2.58544e-18
C579	VPWR#3	C#6	7.74316e-19
C580	Y#3	VPWR#5	1.6661e-19
C581	a_374_74##2	a_828_74##5	3.95307e-17
C582	Y#4	C#13	2.35461e-17
C583	a_1229_74##5	a_232_114##3	6.15603e-19
C584	a_232_114##4	a_232_114##6	5.53911e-18
C585	VPWR#3	C#8	1.82746e-19
C586	a_1229_74##4	C	7.30238e-17
C587	a_828_74##5	a_27_114##8	8.74999e-19
C588	VPWR#20	VPWR#19	1.07072e-18
C589	VPWR	a_232_114##3	4.79373e-23
C590	a_1229_74##3	C	4.15464e-18
C591	Y#6	a_232_114##6	1.41277e-17
C592	Y#3	C#13	1.15963e-18
C593	VPWR#3	C#13	4.35747e-19
C594	A_N	a_232_114##14	5.41601e-18
C595	a_374_74##6	a_27_114##3	9.3761e-19
C596	a_27_114##13	a_27_114##11	3.77441e-17
C597	VPWR	B_N#3	1.56804e-18
C598	VPWR	A_N#2	4.24336e-19
C599	a_27_114##6	a_232_114##6	1.22468e-18
C600	a_232_114##14	B_N#8	5.91266e-17
C601	VPWR#9	a_27_114##5	1.15366e-21
C602	a_374_74##4	a_27_114##8	4.11482e-17
C603	a_27_114##6	a_27_114##8	1.88129e-19
C604	Y#5	C	1.603e-17
C605	Y#5	C#14	1.39497e-18
C606	C	Y#4	7.25727e-17
C607	Y#6	a_828_74##3	1.40984e-19
C608	VPWR#8	a_232_114##12	1.47206e-18
C609	VPWR#20	Y#14	2.58239e-17
C610	C	Y#3	5.59492e-17
C611	a_27_114##6	a_27_114##10	5.40796e-20
C612	B_N#1	a_27_114##13	1.4762e-17
C613	Y#3	VPWR#4	3.13618e-19
C614	VPWR#9	a_27_114##3	1.96535e-20
C615	a_27_114##6	a_27_114##12	1.12082e-19
C616	Y#4	C#14	2.14111e-17
C617	Y#6	a_27_114##8	2.09177e-17
C618	Y#12	a_232_114#	3.08414e-19
C619	a_27_114##6	a_27_114##7	1.68408e-17
C620	D	VPWR#2	2.29085e-20
C621	a_27_114##6	B_N#4	3.36574e-18
C622	a_1229_74##3	D	2.14523e-17
C623	a_232_114##16	Y#14	1.65241e-18
C624	a_1229_74##2	D	7.41701e-17
C625	a_374_74##4	a_27_114##10	1.18057e-18
C626	a_27_114##6	A_N#4	9.1086e-19
C627	B_N#5	B_N#1	3.62254e-17
C628	a_374_74##4	a_828_74##5	4.58359e-17
C629	Y#6	a_374_74##2	3.97215e-17
C630	a_27_114##3	a_232_114##5	1.38324e-18
C631	a_232_114##15	B_N	1.31759e-17
C632	Y#5	a_232_114#	1.87998e-17
C633	VGND#4	a_232_114##5	2.77053e-19
C634	a_374_74#	a_232_114##3	6.75221e-18
C635	Y#6	a_27_114##10	3.01455e-17
C636	a_27_114##15	B_N	1.87778e-18
C637	D	Y#2	6.93997e-17
C638	VPWR#8	a_27_114#	9.75709e-19
C639	a_232_114##16	VPWR#20	4.40967e-17
C640	A_N#1	B_N#5	3.64257e-17
C641	VGND#4	a_232_114##3	2.32177e-19
C642	Y#8	a_27_114##8	2.01308e-19
C643	C#13	C#10	6.14936e-19
C644	Y	VPWR#10	1.03368e-17
C645	Y#2	VPWR#4	1.56809e-19
C646	Y#4	a_232_114#	7.46381e-19
C647	A_N#3	B_N#4	6.01687e-18
C648	Y#12	a_232_114##8	7.48003e-19
C649	a_27_114##10	a_374_74##8	1.48488e-17
C650	D#4	D#3	3.8854e-18
C651	Y#6	a_828_74##5	2.24562e-19
C652	C	a_828_74#	1.73882e-18
C653	VGND#4	a_27_114##5	1.40386e-19
C654	C	a_1229_74##8	2.61046e-18
C655	VPWR#9	a_27_114##9	9.62502e-19
C656	A_N#5	A_N#1	3.79627e-17
C657	A_N	a_232_114##15	1.78959e-17
C658	C	a_828_74##6	3.29702e-18
C659	D#3	D#2	3.50209e-18
C660	VGND#4	a_27_114#	1.18307e-20
C661	A_N	VGND#9	1.72818e-18
C662	C	a_1229_74##5	4.84407e-17
C663	VPWR#21	VPWR#20	1.70488e-18
C664	a_27_114##15	A_N	5.03195e-18
C665	VPWR#9	a_27_114##11	9.62502e-19
C666	Y#6	a_27_114##12	6.12953e-19
C667	a_232_114##4	a_232_114#	2.14344e-19
C668	VGND#4	a_27_114##3	9.42011e-20
C669	Y#8	a_27_114##10	4.64624e-19
C670	a_232_114##5	a_828_74##3	9.12832e-19
C671	Y#5	a_232_114##8	1.81969e-17
C672	a_232_114##4	a_232_114##8	4.34107e-20
C673	D	a_1229_74#	5.86166e-17
C674	D	VGND#7	3.64108e-18
C675	Y#13	a_232_114##10	6.11251e-20
C676	D	a_1229_74##6	2.51339e-18
C677	a_232_114##4	a_232_114##10	3.98135e-19
C678	a_27_114##12	a_374_74##8	1.48488e-17
C679	D	VGND#8	2.51339e-18
C680	a_374_74##4	Y#6	8.07307e-17
C681	VPWR#21	a_232_114##16	5.31887e-17
C682	Y#2	VPWR#2	4.70427e-19
C683	Y#4	a_232_114##8	3.258e-19
C684	VPWR	VPWR#11	6.22824e-17
C685	a_232_114##4	a_232_114##12	2.17254e-18
C686	VPWR	VPWR#10	6.3935e-17
C687	Y#12	a_232_114##10	2.50287e-17
C688	VPWR	VPWR#8	5.4053e-17
C689	VPWR	VPWR#7	5.49662e-17
C690	VPWR	VPWR#6	6.91183e-17
C691	a_232_114##4	a_27_114#	2.00982e-17
C692	VPWR	VPWR#5	1.01879e-17
C693	Y#6	a_27_114##7	3.00525e-19
C694	Y#8	a_27_114##12	2.66079e-17
C695	a_232_114##4	a_27_114##9	6.3116e-18
C696	D#5	VNB	2.72499e-17
C697	a_232_114##3	a_828_74##3	4.29118e-18
C698	D#4	VNB	2.395e-17
C699	D#2	VNB	5.91836e-17
C700	C#11	VNB	3.56918e-17
C701	C#10	VNB	9.3049e-17
C702	a_27_114##17	a_232_114##16	1.49671e-18
C703	a_232_114##4	a_27_114##11	3.71048e-18
C704	a_232_114##14	a_27_114##5	1.85643e-18
C705	C	Y#10	2.39191e-18
C706	VPWR	Y#13	2.74942e-18
C707	a_232_114##5	VNB	5.65421e-17
C708	VPWR	Y#12	2.64342e-18
C709	a_232_114##3	VNB	5.07505e-17
C710	C	VPWR#15	7.90375e-19
C711	a_27_114##5	VNB	2.66914e-17
C712	C#14	C#10	1.78819e-18
C713	VPWR	Y#5	3.23884e-18
C714	C	Y#11	2.88487e-18
C715	Y#5	a_232_114##10	1.08946e-18
C716	a_27_114##3	VNB	3.22221e-17
C717	VPWR	Y#4	1.58964e-18
C718	a_374_74##7	a_27_114##12	1.27558e-18
C719	B_N#3	VNB	7.24216e-17
C720	A_N#2	VNB	1.63841e-17
C721	Y#13	a_232_114##12	1.4663e-19
C722	a_1229_74##3	Y#3	8.0498e-18
C723	A_N	a_27_114##17	1.32225e-17
C724	D	VPWR#1	3.36642e-17
C725	D	Y#1	5.28414e-17
C726	a_232_114##14	VPWR#11	1.93187e-19
C727	a_27_114##7	Y#8	2.45888e-17
C728	a_27_114##17	VPWR#21	4.95273e-17
C729	VPWR	a_232_114##14	9.73061e-18
C730	Y#12	a_232_114##12	2.12564e-17
C731	VPWR	B_N#8	1.98745e-18
C732	a_232_114##5	a_374_74##2	6.55209e-18
C733	VGND#3	D#3	2.59377e-20
C734	VPWR	A_N#7	1.21691e-18
C735	Y#6	a_374_74##8	2.46536e-19
C736	a_374_74##7	a_27_114##7	3.67537e-17
C737	C#10	D#5	3.79429e-17
C738	a_232_114##14	Y#18	9.20133e-20
C739	VPWR#12	VPWR#21	2.06271e-18
C740	VGND	Y#5	1.07699e-17
C741	a_1229_74##2	D#8	1.73806e-17
C742	B_N	a_27_114##7	4.91917e-18
C743	Y#5	a_232_114##12	2.76208e-20
C744	VGND	Y#4	1.88092e-18
C745	Y#5	a_1229_74##5	1.04385e-17
C746	Y#8	B_N#4	2.52437e-19
C747	VGND	a_828_74##2	2.21453e-17
C748	a_232_114##15	a_27_114##7	1.95841e-18
C749	Y#13	a_27_114#	1.28613e-17
C750	VGND	a_374_74##6	2.77365e-17
C751	a_1229_74##3	Y#2	6.62329e-18
C752	a_232_114##14	VPWR#10	7.15606e-19
C753	VPWR#10	a_27_114##13	6.36936e-18
C754	VGND	a_232_114##14	3.96333e-18
C755	a_232_114#	C#11	1.31464e-18
C756	a_374_74##2	a_232_114##3	8.15763e-19
C757	a_27_114##17	VPWR#12	8.75385e-17
C758	VPWR#9	a_27_114##6	5.14372e-20
C759	a_232_114##3	Y#16	4.79525e-19
C760	Y#12	a_27_114#	1.13624e-18
C761	a_374_74##7	B_N#4	2.13687e-18
C762	A_N	B_N#4	1.40758e-18
C763	Y#8	Y#6	2.35868e-18
C764	a_232_114##3	C#12	4.6819e-19
C765	Y	VPWR#19	2.70111e-17
C766	VGND#4	a_27_114##6	1.92972e-19
C767	VGND	A_N#7	1.41546e-18
C768	VPWR#11	VNB	3.26635e-17
C769	Y	Y#14	9.46178e-19
C770	VPWR#10	VNB	3.2684e-17
C771	VPWR#8	VNB	2.81265e-17
C772	VPWR#20	Y	2.47208e-17
C773	VPWR#7	VNB	2.81694e-17
C774	VPWR#6	VNB	2.68185e-17
C775	VPWR#5	VNB	3.16871e-17
C776	VPWR#4	VNB	2.12313e-17
C777	VPWR#2	VNB	2.61578e-17
C778	a_1229_74##4	VNB	6.52661e-19
C779	a_1229_74##3	VNB	5.61274e-18
C780	a_1229_74##5	Y#4	4.39712e-18
C781	a_1229_74##2	VNB	7.39464e-19
C782	a_232_114##15	B_N#4	3.5886e-17
C783	VGND	a_1229_74##5	8.22356e-18
C784	VPWR	Y#11	1.71871e-17
C785	VGND	a_374_74#	1.01576e-17
C786	VGND	a_828_74##3	3.2907e-17
C787	VPWR	Y#16	1.25791e-17
C788	a_27_114##15	a_27_114##7	7.55623e-19
C789	VGND	a_374_74##2	8.76728e-18
C790	VPWR	VPWR#17	2.18985e-17
C791	Y#5	VNB	8.04056e-18
C792	VGND	a_828_74##5	2.14517e-17
C793	Y#4	VNB	3.00374e-18
C794	Y#5	a_27_114#	1.64805e-19
C795	VGND	a_374_74##4	2.14268e-17
C796	VPWR	Y#17	1.60519e-17
C797	a_27_114##6	a_232_114##4	2.28859e-17
C798	Y#3	VNB	4.70409e-19
C799	a_1229_74##2	D#10	1.66266e-17
C800	VGND	Y#6	1.4602e-17
C801	VPWR	VPWR#18	2.25739e-17
C802	Y#5	a_374_74#	4.54786e-17
C803	a_828_74##2	a_828_74#	3.22697e-18
C804	VPWR	Y#18	1.43507e-17
C805	a_828_74##2	VNB	1.23449e-17
C806	VGND	Y#8	8.75849e-18
C807	VPWR	VPWR#19	2.23143e-17
C808	VGND	a_374_74##7	1.99059e-17
C809	a_374_74##6	VNB	5.58957e-18
C810	VGND	a_232_114##15	4.09519e-18
C811	VPWR	Y#14	9.38888e-19
C812	a_374_74##7	A_N#4	6.46543e-19
C813	Y#8	a_374_74##8	3.90552e-19
C814	VPWR	VPWR#20	2.21631e-17
C815	Y#13	a_27_114##9	1.21059e-17
C816	a_232_114##14	VNB	9.40496e-18
C817	VGND	a_27_114##15	3.41725e-17
C818	C	D#12	1.82779e-19
C819	B_N#4	VGND#9	2.24038e-17
C820	VPWR	a_232_114##16	1.56169e-17
C821	VPWR	VPWR#21	2.06295e-17
C822	C	C#6	3.04536e-19
C823	VPWR	a_27_114##17	1.60691e-17
C824	B_N#8	VNB	4.45403e-19
C825	a_232_114##5	a_828_74##5	2.39771e-18
C826	VPWR	VPWR#12	6.73823e-17
C827	VPWR#10	B_N#1	5.61957e-18
C828	a_828_74##2	a_1229_74##4	1.62137e-17
C829	D	D#7	6.66138e-18
C830	C	C#13	2.52248e-18
C831	A_N#7	VNB	9.76916e-19
C832	a_1229_74#	VNB	4.121e-17
C833	D	D#9	3.06086e-18
C834	VGND#7	VNB	1.65568e-18
C835	Y#12	a_27_114##9	5.70196e-19
C836	C	C#14	1.04557e-18
C837	a_1229_74##6	VNB	4.54209e-18
C838	VGND#8	VNB	5.194e-20
C839	VPWR#17	a_232_114##5	6.16791e-19
C840	a_1229_74##7	VNB	4.55271e-18
C841	C	a_232_114#	2.31336e-19
C842	a_232_114##15	A_N#4	3.60587e-18
C843	a_828_74#	VNB	2.98282e-18
C844	D	D#12	2.09075e-18
C845	a_1229_74##3	D#6	1.62964e-17
C846	D	C#6	7.56181e-19
C847	a_27_114##15	B_N#4	3.63906e-17
C848	a_1229_74##5	VNB	7.89984e-18
C849	a_232_114##14	Y#14	5.49186e-17
C850	a_374_74#	VNB	3.23869e-18
C851	a_828_74##3	VNB	6.72074e-18
C852	a_828_74##5	VNB	3.42896e-18
C853	D	C#13	1.52339e-19
C854	a_374_74##4	VNB	2.66049e-18
C855	Y#6	VNB	1.58394e-18
C856	a_27_114##5	a_27_114##3	1.79348e-18
C857	a_374_74##7	VNB	7.80148e-18
C858	a_232_114##15	VNB	2.86704e-18
C859	a_27_114##15	VNB	5.72615e-17
C860	A_N#4	VGND#9	2.26614e-17
C861	VPWR#1	VNB	7.26685e-17
C862	Y#1	VNB	2.19739e-18
C863	VPWR#13	VNB	2.92383e-18
C864	Y#9	VNB	2.15003e-18
C865	VPWR#14	VNB	3.0111e-18
C866	a_828_74##2	a_1229_74##8	2.96879e-17
C867	Y#5	a_828_74##3	5.5546e-19
C868	Y#10	VNB	2.13854e-18
C869	Y#12	Y#5	3.23141e-18
C870	VPWR#15	VNB	3.72837e-18
C871	a_232_114##4	a_232_114##5	3.54653e-17
C872	Y#11	VNB	2.1322e-18
C873	VPWR#16	VNB	4.09278e-19
C874	VGND	C#12	1.5837e-18
C875	VPWR#17	a_232_114##3	5.17723e-19
C876	Y#16	VNB	4.67858e-18
C877	VGND	a_232_114##7	1.68294e-18
C878	VPWR#17	VNB	1.06367e-18
C879	Y#17	VNB	2.4633e-18
C880	VGND	a_232_114##9	1.39787e-18
C881	a_232_114##3	a_232_114#	3.56794e-18
C882	VPWR#18	VNB	4.75222e-19
C883	VGND	a_232_114##11	1.38636e-18
C884	Y#13	a_27_114##11	4.31265e-21
C885	Y#18	VNB	5.05501e-18
C886	a_232_114##4	a_232_114##3	1.25681e-17
C887	VPWR#11	B_N#5	9.61318e-19
C888	VGND	a_232_114##6	2.47608e-18
C889	VPWR#19	VNB	2.76719e-19
C890	VGND	a_27_114##8	1.54207e-18
C891	VPWR#20	VNB	4.47911e-18
C892	a_27_114##15	A_N#4	5.42863e-17
C893	VGND	a_27_114##10	1.58782e-18
C894	a_232_114##16	VNB	2.42111e-18
C895	VGND	a_27_114##12	1.59552e-18
C896	VPWR#3	C	5.86249e-18
C897	VPWR#21	VNB	4.51258e-19
C898	a_27_114##17	VNB	2.75762e-17
C899	VGND	a_27_114##7	2.71492e-18
C900	VPWR#12	VNB	6.20221e-17
C901	VGND	B_N#4	8.16786e-18
C902	VPWR	C#14	8.98435e-19
C903	VGND#3	C	5.90256e-18
C904	D#1	VNB	3.19456e-17
C905	Y	a_27_114##11	6.10543e-18
C906	VGND	A_N#4	9.05532e-18
C907	D#8	VNB	2.48613e-17
C908	VPWR	a_232_114#	1.24496e-18
C909	D#10	VNB	2.45695e-17
C910	Y	a_27_114##13	1.3335e-17
C911	Y#12	a_27_114##11	3.13951e-19
C912	D#8	D#1	2.34953e-17
C913	VPWR	a_232_114##8	1.1767e-18
C914	a_27_114##6	B_N	2.66644e-17
C915	D#6	VNB	2.46107e-17
C916	C#1	VNB	2.71542e-17
C917	a_232_114##14	B_N#3	1.62842e-17
C918	VPWR	a_232_114##10	1.50106e-19
C919	C#7	VNB	2.84036e-17
C920	VPWR#3	D	1.23737e-17
C921	a_232_114##4	a_27_114##5	6.69239e-18
C922	C#9	VNB	2.86092e-17
C923	VPWR	a_232_114##12	8.84461e-19
C924	a_232_114##14	VPWR#20	2.35417e-17
C925	C#12	VNB	3.06944e-17
C926	VPWR	a_27_114#	5.09458e-19
C927	VGND#3	D	1.14225e-17
C928	a_232_114##7	VNB	3.069e-17
C929	a_374_74##7	Y#8	4.58463e-17
C930	a_1229_74##3	C#1	2.34601e-17
C931	a_232_114##9	VNB	2.63324e-17
C932	VPWR	a_27_114##9	5.47495e-19
C933	a_232_114##11	VNB	2.5449e-17
C934	a_232_114##6	VNB	3.47533e-17
C935	VPWR	a_27_114##11	4.75502e-19
C936	a_27_114##8	VNB	2.84618e-17
C937	VPWR	a_27_114##13	4.87962e-20
C938	a_27_114##10	VNB	2.68747e-17
C939	a_27_114##12	VNB	2.6905e-17
C940	VPWR	B_N#1	8.08652e-20
C941	D	D#3	2.27341e-17
C942	a_27_114##7	VNB	5.38742e-17
C943	A_N	A_N#3	6.336e-18
C944	B_N#4	VNB	3.7649e-17
C945	VPWR	B_N#5	5.4183e-19
C946	A_N#4	VNB	3.60746e-17
C947	VPWR	A_N#1	4.18727e-18
C948	Y	VPWR#9	1.28437e-17
C949	D#7	VNB	4.21668e-17
C950	a_232_114##4	a_27_114##3	1.56337e-17
C951	VGND	a_27_114#	4.36229e-19
C952	VPWR	A_N#5	5.45009e-19
C953	D#9	VNB	3.57365e-17
C954	D#11	VNB	3.30858e-17
C955	D#12	VNB	3.28548e-17
C956	C#6	VNB	3.3516e-17
C957	C#8	VNB	3.09195e-17
C958	a_828_74##2	a_828_74##6	9.5229e-19
C959	C#13	VNB	3.47532e-17
C960	C#14	VNB	3.24348e-17
C961	VPWR	VPWR#9	5.8688e-17
C962	a_374_74##4	a_232_114##5	6.29183e-19
C963	Y#5	a_374_74##2	3.41817e-17
C964	a_232_114#	VNB	3.27892e-17
C965	a_232_114##8	VNB	2.74357e-17
C966	a_232_114##10	VNB	3.00832e-17
C967	a_232_114##12	VNB	2.78604e-17
C968	a_27_114#	VNB	4.00826e-17
C969	a_27_114##9	VNB	2.71911e-17
C970	VGND	VGND#3	4.17772e-17
C971	VPWR	a_232_114##4	8.93605e-18
C972	a_27_114##11	VNB	2.72568e-17
C973	a_1229_74##4	C#7	1.67732e-17
C974	VPWR#11	VPWR#10	8.2274e-19
C975	a_27_114##13	VNB	3.92375e-17
C976	VPWR	a_27_114##6	5.29677e-18
C977	B_N#1	VNB	3.41255e-17
C978	Y#13	a_27_114##13	1.80324e-21
C979	VGND	VGND#4	1.98187e-16
C980	B_N#5	VNB	2.30143e-17
C981	A_N#1	VNB	3.43463e-17
C982	A_N#5	VNB	3.71635e-17
C983	VGND	a_232_114##4	9.7161e-18
C984	VPWR#3	VNB	1.81524e-16
C985	VPWR#11	A_N#1	4.64135e-18
C986	VGND	a_27_114##6	1.63943e-17
C987	VGND#3	VNB	2.66256e-16
C988	VPWR#9	VNB	3.11275e-17
C989	VGND#4	VNB	1.16549e-16
C990	a_232_114##14	A_N#2	1.80057e-19
C991	D#3	VNB	3.26036e-17
C992	a_232_114##14	a_232_114##16	7.19633e-19
C993	Y#12	a_27_114##13	2.55806e-19
C994	D#10	D#8	4.00972e-17
C995	a_232_114##4	VNB	3.45433e-18
C996	a_27_114##6	VNB	5.51571e-17
C997	C	D	1.39186e-17
C998	A_N#3	VNB	3.41879e-17
C999	VPWR	A_N	2.03117e-18
C1000	VGND	B_N	2.54811e-18
C1001	VPWR	C	2.7731e-18
C1002	a_1229_74##3	C#7	2.70786e-19
C1003	VGND	A_N	2.087e-18
C1004	VGND	C	3.34463e-18
C1005	a_232_114##14	a_27_114#	1.85084e-19
C1006	B_N	VNB	2.1607e-18
C1007	VPWR	Y	2.15269e-17
C1008	A_N	VNB	2.14337e-18
C1009	VPWR#18	a_232_114##6	5.81602e-19
C1010	C	VNB	5.85868e-18
C1011	a_27_114##6	a_232_114##5	1.13317e-18
C1012	D	VNB	3.36787e-17
C1013	Y	VNB	2.50872e-18
C1014	VPWR	VNB	2.85206e-16
C1015	VGND	VNB	3.21453e-16
C1016	a_828_74##2	a_1229_74##5	6.58242e-17
C1017	VGND#5	A_N#1	2.70606e-19
C1018	VGND#5	A_N#4	8.85612e-18
C1019	VGND#5	a_27_114##15	6.81529e-17
C1020	VGND#5	B_N#4	9.35164e-18
C1021	VGND#2	VNB	4.67596e-17
C1022	VGND#5	VGND#9	6.90574e-18
C1023	VGND#2	a_1229_74##2	3.16169e-19
C1024	VGND#5	a_27_114##7	2.06468e-18
C1025	VGND#5	VNB	9.48035e-17
C1026	VGND#2	a_1229_74##6	5.19785e-18
C1027	VGND#5	a_27_114##12	5.30826e-20
C1028	VGND#2	D#2	1.99838e-19
C1029	VGND	VGND#5	1.47137e-16
C1030	VGND#5	a_374_74##7	3.04646e-17
C1031	VGND#2	D#10	5.39633e-19
C1032	VGND#2	a_1229_74#	2.10217e-17
C1033	VGND#2	D#8	4.00948e-18
C1034	VGND#2	D#3	4.65699e-20
C1035	VGND#2	D#1	4.64383e-18
C1036	VGND#5	A_N#2	4.71185e-20
C1037	VGND#5	B_N#3	4.98659e-19
C1038	VGND#3	VGND#2	9.83635e-17
C1039	VGND#5	A_N#3	6.73596e-19
C1040	VGND#5	a_27_114##6	4.56552e-18
*
*
.ENDS sky130_fd_sc_hs__nand4bb_4
*
