* Extracted by Quantus, converted by sky130cad/quantus.py
*
*
*
*                       LINUX           Wed Nov 18 09:05:34 2026
*
*
*
*  PROGRAM  advgen
*
*  Name           : advgen - Quantus - (64-bit)
*  Version        : 25.1.0-p047
*  Build Date     : Thu Dec 11 23:20:30 PST 2025
*
*  HSPICE LIBRARY
*
*  OPERATING_TEMPERATURE 150
*  QRC_TECH_DIR <path>/tech
*
*
*

*
.SUBCKT sky130_fd_sc_hs__or2b_2 VNB VPB VGND VPWR X B_N A
*
*
*  caps2d version: 10
*
*
*       TRANSISTOR CARDS
*
*
XM7 a_27_368##7 B_N#3 VGND#6 VNB sky130_fd_pr__nfet_01v8_lvt l=0.15 w=0.55 ad=0.15675 as=0.25215 pd=1.67 ps=2.2
XM3 VGND#6 a_187_48##5 X#2 VNB sky130_fd_pr__nfet_01v8_lvt l=0.15 w=0.74 ad=0.25215 as=0.2109 pd=2.2 ps=2.05
XM5 X#2 a_187_48##6 VGND#5 VNB sky130_fd_pr__nfet_01v8_lvt l=0.15 w=0.74 ad=0.2109 as=0.4698 pd=2.05 ps=2.87
XM1 VGND#5 A#1 a_187_48##11 VNB sky130_fd_pr__nfet_01v8_lvt l=0.15 w=0.64 ad=0.4698 as=0.2208 pd=2.87 ps=1.97
XM9 a_187_48##11 a_27_368# VGND#1 VNB sky130_fd_pr__nfet_01v8_lvt l=0.15 w=0.64 ad=0.2208 as=0.2336 pd=1.97 ps=2.01
XM0 a_27_368##6 B_N#1 VPWR#7 VPB sky130_fd_pr__pfet_01v8 l=0.15 w=0.84 ad=0.2478 as=0.406 pd=2.27 ps=3.01
XM6 VPWR#7 a_187_48##7 X#1 VPB sky130_fd_pr__pfet_01v8 l=0.15 w=1.12 ad=0.406 as=0.5768 pd=3.01 ps=3.27
XM8 X#1 a_187_48# VPWR#6 VPB sky130_fd_pr__pfet_01v8 l=0.15 w=1.12 ad=0.5768 as=0.4554 pd=3.27 ps=3.08
XM2 VPWR#6 A#3 a_470_368# VPB sky130_fd_pr__pfet_01v8 l=0.15 w=1 ad=0.4554 as=0.27 pd=3.08 ps=2.54
XM4 a_470_368# a_27_368##3 a_187_48##8 VPB sky130_fd_pr__pfet_01v8 l=0.15 w=1 ad=0.27 as=0.415 pd=2.54 ps=2.83
*
*
*       RESISTOR AND CAP/DIODE CARDS
*
Rg1	B_N#1	B_N#2	349.716187
Rg2	B_N#2	B_N#3	323.440491
Rg3	a_187_48#	a_187_48##2	456.728729
Rg4	a_187_48##2	a_187_48##3	29.636181
Rg5	a_187_48##3	a_187_48##4	74.741219
Rg6	a_187_48##4	a_187_48##5	366.112152
Rg7	a_187_48##3	a_187_48##6	342.058960
Rg8	a_187_48##4	a_187_48##7	470.238159
Rg9	A#1	A#2	411.232849
Rg10	A#2	A#3	400.207520
Rg11	a_27_368#	a_27_368##2	394.016998
Rg12	a_27_368##2	a_27_368##3	413.532104
Rf1	B_N#4	B_N#2	162.448425
Rf2	B_N	B_N#6	2.215620
Rf3	B_N#4	B_N#6	4.635897
Rf4	X#1	X	91.364090
Rf5	X	X#3	7.282945
Rf6	X#3	X	7.282945
Rf7	X#2	X#3	7.500000
Rf8	A#4	A#2	160.844009
Rf9	A	A#6	0.611206
Rf10	A#4	A#6	5.905091
Rf11	a_27_368##2	a_27_368##5	344.835449
Rf12	a_27_368##5	a_27_368##6	21.352009
Rf13	a_27_368##5	a_27_368##7	118.871323
Rf14	a_187_48##8	a_187_48##9	121.901344
Rf15	a_187_48##9	a_187_48##2	241.930603
Rf16	a_187_48##9	a_187_48##11	18.937206
Rf17	VGND#1	VGND#2	139.734940
Rf18	VGND#2	VGND#3	68.481133
Rf20	VGND#2	VGND#5	20.274899
Rf21	VGND#3	VGND#6	45.213318
Rf23	VPWR#2	VPWR#3	18.238092
Rf24	VPWR#3	VPWR#4	63.164146
Rf26	VPWR#2	VPWR#6	33.326477
Rf27	VPWR#4	VPWR#7	33.326477
Re1	VPWR#3	VPWR	1.403190
Re2	VGND	VGND#2	1.403242
*
*       CAPACITOR CARDS
*
*
C1	VGND	VNB	5.66975e-17
C2	VPWR	VNB	6.0893e-17
C3	X	VNB	2.44483e-18
C4	B_N	VNB	1.09545e-17
C5	A	VNB	1.81483e-18
C6	B_N#2	VNB	5.68096e-17
C7	a_187_48##2	VNB	6.06756e-18
C8	A#2	VNB	3.19277e-17
C9	a_27_368##2	VNB	6.02161e-17
C10	VGND	X	1.68636e-17
C11	VGND#2	VNB	1.53024e-16
C12	VPWR#3	VNB	2.02701e-16
C13	B_N#1	VNB	4.47066e-17
C14	a_187_48##7	VNB	3.64304e-17
C15	a_187_48#	VNB	3.73471e-17
C16	A#3	VNB	3.26526e-17
C17	a_27_368##3	VNB	3.89646e-17
C18	VPWR	B_N	2.95296e-18
C19	B_N#3	VNB	3.9044e-17
C20	a_187_48##5	VNB	3.0513e-17
C21	a_187_48##6	VNB	2.84379e-17
C22	A#1	VNB	3.02428e-17
C23	VPWR	A	3.84326e-18
C24	a_27_368#	VNB	3.68313e-17
C25	a_27_368##6	VNB	4.43033e-17
C26	VPWR#7	VNB	1.0814e-17
C27	X#1	VNB	1.39519e-18
C28	VPWR#6	VNB	5.09848e-18
C29	a_187_48##8	VNB	6.80649e-17
C30	a_27_368##7	VNB	4.05381e-17
C31	VGND#6	VNB	5.08883e-18
C32	VGND#5	VNB	5.33721e-17
C33	VGND	a_187_48##2	5.47295e-18
C34	a_187_48##3	A#2	2.71693e-17
C35	a_187_48##11	VNB	6.60569e-18
C36	a_187_48##9	VGND#5	1.99106e-17
C37	VGND#1	VNB	5.36123e-17
C38	B_N#4	VNB	1.36577e-17
C39	VGND	a_27_368##2	3.84501e-18
C40	A#4	VNB	2.05561e-18
C41	a_27_368##5	VNB	6.21853e-18
C42	a_187_48##9	VNB	2.74409e-17
C43	VPWR	a_187_48##2	2.60872e-18
C44	VPWR	a_27_368##2	1.30566e-17
C45	X	B_N#2	4.14483e-19
C46	X	a_187_48##2	2.66383e-17
C47	VPWR	VPWR#3	4.13535e-17
C48	X	A#2	4.84598e-20
C49	B_N	B_N#2	8.82255e-18
C50	VGND	B_N#3	7.79466e-18
C51	VPWR	B_N#1	6.46555e-18
C52	VGND	a_187_48##5	4.83438e-18
C53	VPWR	a_187_48##7	3.96549e-19
C54	VGND	a_187_48##6	4.57445e-18
C55	VPWR	a_187_48#	4.00075e-19
C56	VGND	A#1	3.92693e-19
C57	VGND	a_27_368#	1.51271e-18
C58	VPWR	A#3	9.00216e-18
C59	a_187_48##2	A	3.85593e-18
C60	a_187_48##9	a_187_48##11	1.6497e-18
C61	VPWR	a_27_368##3	9.03749e-18
C62	VGND	X#1	2.39617e-18
C63	A	A#2	7.1365e-18
C64	A	a_27_368##2	2.87605e-17
C65	VGND	a_187_48##8	8.86841e-19
C66	VGND	a_27_368##7	1.58897e-17
C67	B_N	B_N#1	2.94218e-18
C68	VGND	VGND#5	8.14429e-17
C69	VPWR	a_27_368##6	1.38094e-17
C70	VGND	a_187_48##11	1.536e-17
C71	B_N	a_187_48##7	1.9639e-19
C72	VGND	VGND#1	4.01984e-17
C73	VPWR	VPWR#7	1.83979e-17
C74	X	B_N#3	2.21861e-18
C75	VGND	B_N#4	3.62949e-18
C76	VPWR	X#1	5.01285e-18
C77	X	a_187_48##5	2.26321e-17
C78	VPWR	VPWR#6	1.83832e-17
C79	X	a_187_48##6	3.00186e-17
C80	VGND	A#4	2.67002e-18
C81	VPWR	a_187_48##8	1.76364e-17
C82	A	a_187_48##7	3.35613e-19
C83	X	A#1	1.13708e-18
C84	a_187_48##3	VNB	3.83453e-17
C85	a_187_48##9	VGND#1	3.42622e-17
C86	a_187_48##4	VNB	2.54408e-17
C87	X	a_27_368#	4.55944e-19
C88	A	a_187_48#	1.68188e-18
C89	a_27_368##2	a_470_368#	4.03265e-18
C90	B_N#4	a_27_368##5	1.36927e-17
C91	VGND	a_187_48##9	8.3912e-18
C92	A	A#3	3.86025e-18
C93	B_N#4	a_187_48##4	1.0157e-18
C94	X	X#1	2.98442e-18
C95	A	a_27_368##3	8.40059e-19
C96	B_N	a_27_368##6	3.90037e-17
C97	a_27_368##7	X	4.28282e-17
C98	a_187_48##2	A#2	4.00788e-18
C99	VGND#6	X	4.05571e-17
C100	X	X#2	2.43446e-19
C101	VGND#5	X	5.29808e-17
C102	a_187_48##2	a_27_368##2	1.92276e-18
C103	X	a_187_48##11	2.74914e-18
C104	VPWR	a_27_368##5	1.41848e-17
C105	A#2	a_27_368##2	3.87332e-17
C106	A#3	a_470_368#	1.23961e-17
C107	X#1	A	5.03166e-18
C108	a_27_368##3	a_470_368#	2.08515e-17
C109	B_N#2	a_187_48##7	8.17361e-19
C110	a_27_368##2	VPWR#3	4.39571e-18
C111	a_27_368##2	B_N#1	7.43892e-20
C112	a_187_48#	A#2	6.49064e-19
C113	B_N	a_27_368##5	1.74734e-17
C114	a_27_368##2	a_187_48##7	1.26664e-19
C115	a_27_368##2	a_187_48#	1.10487e-18
C116	A#2	a_27_368##3	7.58305e-19
C117	a_27_368##2	A#3	3.37724e-17
C118	a_187_48##2	a_187_48##5	2.23909e-19
C119	VGND#2	a_187_48##4	4.03694e-21
C120	a_27_368##2	a_27_368##3	1.60348e-17
C121	a_187_48##2	a_187_48##6	3.26929e-18
C122	VPWR#3	a_187_48#	4.0022e-18
C123	B_N#2	a_27_368##6	3.92965e-18
C124	VPWR#3	A#3	6.65434e-18
C125	a_187_48##6	A#2	2.7632e-19
C126	B_N#1	a_187_48##7	2.66372e-17
C127	X#1	B_N#2	5.81501e-19
C128	VPWR#3	a_27_368##3	3.55018e-18
C129	a_187_48##9	A#4	2.34947e-17
C130	a_187_48##2	X#1	3.84918e-17
C131	a_187_48##7	a_187_48#	2.1943e-17
C132	A#1	a_27_368##2	6.1062e-19
C133	VGND	a_187_48##3	1.53929e-18
C134	VGND	a_187_48##4	2.52825e-19
C135	a_27_368##7	B_N#2	8.13215e-18
C136	X#1	A#2	3.29853e-19
C137	A#2	VPWR#6	1.20327e-18
C138	a_187_48#	A#3	2.86788e-17
C139	VPWR#3	a_187_48##3	4.26368e-19
C140	X#1	a_27_368##2	8.14246e-18
C141	a_27_368##2	VPWR#6	1.18762e-17
C142	B_N#4	B_N#2	1.4649e-17
C143	A#3	a_27_368##3	5.217e-17
C144	a_187_48##2	VGND#5	3.96323e-17
C145	a_27_368##2	a_187_48##8	9.10172e-17
C146	VGND#5	A#2	1.0026e-18
C147	a_27_368##6	B_N#1	5.20803e-17
C148	VGND#5	a_27_368##2	6.19627e-20
C149	B_N#1	VPWR#7	2.60661e-17
C150	a_187_48##2	A#4	1.67197e-17
C151	a_27_368##6	a_187_48##7	1.32861e-18
C152	a_27_368##5	B_N#2	3.63735e-18
C153	X#1	B_N#1	1.10012e-18
C154	VGND#1	a_27_368##2	4.62971e-19
C155	VPWR#7	a_187_48##7	3.91055e-17
C156	VGND#2	VGND#5	6.52673e-17
C157	a_27_368##6	a_187_48#	4.19195e-19
C158	X#1	a_187_48##7	4.48453e-17
C159	A#4	A#2	1.0159e-17
C160	X#1	a_187_48##3	7.06133e-18
C161	B_N#3	a_187_48##5	2.48104e-17
C162	a_187_48##2	a_27_368##5	6.23657e-18
C163	VPWR#7	a_187_48#	4.56205e-18
C164	VGND#2	VGND#1	2.57523e-17
C165	VPWR#6	a_187_48##7	4.91984e-18
C166	a_27_368##6	A#3	2.32022e-19
C167	a_187_48##2	a_187_48##9	1.14175e-18
C168	X#1	a_187_48#	5.23248e-17
C169	X#1	a_187_48##4	1.37293e-17
C170	A#4	a_187_48##3	3.17816e-18
C171	A#4	a_27_368##2	2.36776e-17
C172	VPWR#6	a_187_48#	4.88355e-17
C173	a_187_48##8	a_187_48##7	3.38877e-19
C174	a_187_48##5	a_187_48##6	3.84775e-17
C175	X#1	A#3	2.12429e-18
C176	X	a_187_48##3	7.88477e-19
C177	a_187_48##9	A#2	2.90221e-18
C178	X	a_187_48##4	7.56713e-18
C179	A#3	VPWR#6	3.10665e-17
C180	a_187_48##8	a_187_48#	1.22606e-18
C181	X#1	a_27_368##3	7.35806e-19
C182	a_27_368##5	a_27_368##2	9.95048e-19
C183	a_187_48##6	A#1	7.68731e-18
C184	VPWR#6	a_27_368##3	4.73858e-18
C185	a_187_48##9	a_27_368##2	6.59523e-17
C186	a_187_48##8	A#3	3.54386e-18
C187	a_187_48##8	a_27_368##3	2.34985e-17
C188	A#1	a_27_368#	2.721e-17
C189	a_187_48##4	a_187_48##3	2.38102e-18
C190	a_27_368##5	VPWR#3	3.77758e-18
C191	B_N	a_187_48##4	3.1427e-19
C192	a_27_368##7	B_N#3	3.98916e-17
C193	B_N#3	VGND#6	2.1293e-17
C194	a_27_368##6	VPWR#7	9.73867e-18
C195	a_27_368##7	a_187_48##5	5.8125e-18
C196	a_27_368##5	B_N#1	2.22537e-18
C197	a_187_48##5	VGND#6	1.67914e-17
C198	a_187_48##5	X#2	1.51241e-17
C199	A	a_187_48##3	1.03467e-18
C200	VGND#6	a_187_48##6	1.01876e-19
C201	a_27_368##5	a_187_48##7	2.93105e-17
C202	A	a_187_48##4	1.4199e-19
C203	VGND#5	a_187_48##5	1.39937e-18
C204	VPWR#7	VPWR#6	7.8742e-18
C205	a_187_48##6	X#2	1.51241e-17
C206	VGND#6	A#1	2.65811e-20
C207	a_27_368##5	a_187_48#	2.72639e-17
C208	a_187_48##6	VGND#5	2.74266e-17
C209	a_27_368##7	a_27_368##6	7.99277e-19
C210	a_187_48##11	a_187_48##6	1.29115e-18
C211	VGND#5	A#1	5.16411e-17
C212	a_27_368##5	A#3	2.15835e-19
C213	A#1	a_187_48##11	1.37275e-17
C214	a_187_48##8	X#1	1.47677e-19
C215	VGND#5	a_27_368#	6.58648e-18
C216	VGND#1	A#1	1.17971e-18
C217	a_27_368##5	a_27_368##3	2.97332e-19
C218	a_27_368##7	X#1	1.86871e-18
C219	VPWR#6	a_187_48##8	8.4918e-18
C220	a_187_48##11	a_27_368#	3.64958e-17
C221	a_27_368#	VGND#1	1.99029e-17
C222	a_27_368##7	a_187_48##4	2.86108e-18
C223	a_27_368##5	a_187_48##3	9.77878e-19
C224	a_27_368##5	a_187_48##4	5.45346e-18
C225	a_27_368##7	VGND#6	5.46847e-17
C226	a_187_48##9	a_187_48##3	2.67932e-20
C227	a_187_48##9	A#1	1.92484e-17
C228	VGND#6	VGND#5	3.2674e-19
C229	a_187_48##9	a_27_368#	2.53934e-17
C230	a_27_368##7	B_N#4	4.71918e-17
C231	a_187_48##4	X#2	1.94052e-19
C232	a_27_368##5	VPWR#7	5.06432e-17
C233	VGND#5	a_187_48##11	6.18137e-17
C234	VGND#5	VGND#1	2.66787e-18
C235	a_27_368##5	X#1	1.19311e-16
C236	B_N#3	a_187_48##4	7.65506e-19
C237	a_187_48##11	VGND#1	4.05633e-17
C238	a_187_48##3	VGND#5	1.81237e-18
C239	a_27_368##5	VPWR#6	3.15678e-17
C240	VGND#5	a_187_48##4	1.6805e-20
C241	B_N#2	a_187_48##4	1.85466e-17
C242	a_187_48##9	a_187_48##8	3.29127e-18
C243	a_27_368##7	a_27_368##5	1.78419e-18
C244	a_187_48##2	a_187_48##3	2.71708e-17
C245	a_187_48##2	a_187_48##4	1.00022e-19
C246	VGND#3	a_27_368##7	1.12792e-17
C247	VPWR#4	a_187_48##3	5.83956e-20
C248	VGND#3	a_187_48##4	4.34612e-20
C249	a_27_368##2	VPWR#2	5.37681e-19
C250	VGND#3	A#1	2.21776e-19
C251	VGND#3	a_187_48##5	1.00241e-17
C252	VPWR#2	VNB	2.88799e-17
C253	VPWR#4	VNB	5.24381e-17
C254	VPWR#3	VPWR#2	2.89964e-17
C255	VGND#2	VGND#3	5.28929e-17
C256	a_27_368##5	VPWR#4	2.11439e-18
C257	VGND#3	B_N#2	1.51451e-19
C258	a_27_368##6	VPWR#4	9.16398e-18
C259	a_187_48##8	VPWR#2	1.90208e-17
C260	VGND#3	VGND#5	2.56438e-18
C261	VPWR#4	a_187_48##7	4.00809e-18
C262	VGND#3	a_187_48##6	1.2547e-18
C263	VPWR#2	a_27_368##3	2.77577e-18
C264	VPWR#4	a_187_48##4	1.01264e-19
C265	VGND#3	B_N#3	2.2136e-18
C266	VPWR#3	VPWR#4	5.6251e-17
C267	VPWR#4	B_N#2	8.74503e-20
C268	VPWR	VPWR#2	1.91963e-17
C269	VPWR#4	B_N#1	3.29586e-18
C270	VGND#3	X	7.13541e-18
C271	VGND	VGND#3	5.15375e-17
C272	VPWR	VPWR#4	4.02941e-17
C273	VGND#3	VNB	5.4267e-17
*
*
.ENDS sky130_fd_sc_hs__or2b_2
*
