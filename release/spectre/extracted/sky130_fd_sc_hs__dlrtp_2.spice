* Extracted by Quantus, converted by sky130cad/quantus.py
*
*
*
*                       LINUX           Wed Nov 18 08:32:29 2026
*
*
*
*  PROGRAM  advgen
*
*  Name           : advgen - Quantus - (64-bit)
*  Version        : 25.1.0-p047
*  Build Date     : Thu Dec 11 23:20:30 PST 2025
*
*  HSPICE LIBRARY
*
*  OPERATING_TEMPERATURE 150
*  QRC_TECH_DIR <path>/tech
*
*
*

*
.SUBCKT sky130_fd_sc_hs__dlrtp_2 VPB VNB VGND VPWR Q GATE RESET_B D
*
*
*  caps2d version: 10
*
*
*       TRANSISTOR CARDS
*
*
XM18 a_27_392##7 D#1 VGND#12 VNB sky130_fd_pr__nfet_01v8_lvt l=0.15 w=0.55 ad=0.15675 as=0.30395 pd=1.67 ps=2.34
XM0 VGND#12 GATE#3 a_235_74##10 VNB sky130_fd_pr__nfet_01v8_lvt l=0.15 w=0.74 ad=0.30395 as=0.2109 pd=2.34 ps=2.05
XM19 a_347_98##8 a_235_74# VGND#11 VNB sky130_fd_pr__nfet_01v8_lvt l=0.15 w=0.74 ad=0.2701 as=0.3827 pd=2.21 ps=2.98
XM2 VGND#11 a_27_392# a_568_74# VNB sky130_fd_pr__nfet_01v8_lvt l=0.15 w=0.64 ad=0.3827 as=0.1536 pd=2.98 ps=1.76
XM1 a_568_74# a_347_98# a_646_74##8 VNB sky130_fd_pr__nfet_01v8_lvt l=0.15 w=0.64 ad=0.1536 as=0.321575 pd=1.76 ps=2.36
XM16 a_646_74##8 a_235_74##5 a_784_81# VNB sky130_fd_pr__nfet_01v8_lvt l=0.15 w=0.42 ad=0.321575 as=0.1008 pd=2.36 ps=1.32
XM12 a_784_81# a_832_55##2 VGND#10 VNB sky130_fd_pr__nfet_01v8_lvt l=0.15 w=0.42 ad=0.1008 as=0.1197 pd=1.32 ps=1.41
XM10 a_832_55##16 a_646_74# a_1060_74# VNB sky130_fd_pr__nfet_01v8_lvt l=0.15 w=0.74 ad=0.2109 as=0.1776 pd=2.05 ps=1.96
XM21 a_1060_74# RESET_B#3 VGND#9 VNB sky130_fd_pr__nfet_01v8_lvt l=0.15 w=0.74 ad=0.1776 as=0.3256 pd=1.96 ps=2.36
XM4 VGND#9 a_832_55##10 Q#2 VNB sky130_fd_pr__nfet_01v8_lvt l=0.15 w=0.74 ad=0.3256 as=0.2146 pd=2.36 ps=2.06
XM5 Q#2 a_832_55##9 VGND#1 VNB sky130_fd_pr__nfet_01v8_lvt l=0.15 w=0.74 ad=0.2146 as=0.2553 pd=2.06 ps=2.17
XM9 a_27_392##6 D#3 VPWR#12 VPB sky130_fd_pr__pfet_01v8 l=0.15 w=0.84 ad=0.2478 as=0.4789 pd=2.27 ps=3.2
XM6 VPWR#12 GATE#1 a_235_74##12 VPB sky130_fd_pr__pfet_01v8 l=0.15 w=0.84 ad=0.4789 as=0.2478 pd=3.2 ps=2.27
XM7 a_347_98##9 a_235_74##4 VPWR#11 VPB sky130_fd_pr__pfet_01v8 l=0.15 w=0.84 ad=0.2478 as=0.48765 pd=2.27 ps=3.19
XM8 VPWR#11 a_27_392##3 a_565_392# VPB sky130_fd_pr__pfet_01v8 l=0.15 w=1 ad=0.48765 as=0.27 pd=3.19 ps=2.54
XM11 a_565_392# a_235_74##7 a_646_74##7 VPB sky130_fd_pr__pfet_01v8 l=0.15 w=1 ad=0.27 as=0.3328 pd=2.54 ps=2.77
XM13 a_646_74##7 a_347_98##4 a_756_508# VPB sky130_fd_pr__pfet_01v8 l=0.15 w=0.42 ad=0.3328 as=0.2247 pd=2.77 ps=1.91
XM20 a_756_508# a_832_55##3 VPWR#10 VPB sky130_fd_pr__pfet_01v8 l=0.15 w=0.42 ad=0.2247 as=0.4606 pd=1.91 ps=3.55
XM3 VPWR#10 a_646_74##4 a_832_55##13 VPB sky130_fd_pr__pfet_01v8 l=0.15 w=1.12 ad=0.4606 as=0.336 pd=3.55 ps=2.84
XM17 a_832_55##13 RESET_B#1 VPWR#9 VPB sky130_fd_pr__pfet_01v8 l=0.15 w=1.12 ad=0.336 as=0.448 pd=2.84 ps=3.04
XM14 VPWR#9 a_832_55##8 Q#1 VPB sky130_fd_pr__pfet_01v8 l=0.15 w=1.12 ad=0.448 as=0.3528 pd=3.04 ps=2.87
XM15 Q#1 a_832_55##4 VPWR#1 VPB sky130_fd_pr__pfet_01v8 l=0.15 w=1.12 ad=0.3528 as=0.3696 pd=2.87 ps=2.9
*
*
*       RESISTOR AND CAP/DIODE CARDS
*
Rg1	D#1	D#2	380.826691
Rg2	D#2	D#3	358.599243
Rg3	GATE#1	GATE#2	463.921814
Rg4	GATE#2	GATE#3	307.937683
Rg5	a_235_74#	a_235_74##2	367.764618
Rg6	a_235_74##2	a_235_74##3	78.835838
Rg7	a_235_74##2	a_235_74##4	390.909668
Rg8	a_27_392#	a_27_392##2	462.880432
Rg9	a_27_392##2	a_27_392##3	413.532104
Rg10	a_347_98#	a_347_98##2	439.477417
Rg11	a_347_98##3	a_347_98##4	260.013794
Rg12	a_235_74##5	a_235_74##6	402.624939
Rg13	a_235_74##6	a_235_74##7	785.612732
Rg14	a_832_55#	a_832_55##2	838.800354
Rg15	a_832_55#	a_832_55##3	233.787552
Rg16	a_646_74#	a_646_74##2	394.805237
Rg17	a_646_74##2	a_646_74##3	70.960945
Rg18	a_646_74##2	a_646_74##4	448.030548
Rg19	RESET_B#1	RESET_B#2	492.059540
Rg20	RESET_B#2	RESET_B#3	307.937683
Rg21	a_832_55##4	a_832_55##5	526.145996
Rg22	a_832_55##5	a_832_55##6	36.503117
Rg23	a_832_55##6	a_832_55##7	19.785671
Rg24	a_832_55##7	a_832_55##8	472.529877
Rg25	a_832_55##5	a_832_55##9	423.145813
Rg26	a_832_55##7	a_832_55##10	364.385956
Rf1	D#4	D	0.839094
Rf2	D#2	D#6	161.071899
Rf3	D#4	D#6	5.708254
Rf4	GATE#4	GATE	0.794212
Rf5	GATE#2	GATE#6	161.027008
Rf6	GATE#4	GATE#6	4.438411
Rf7	a_27_392##2	a_27_392##5	354.522064
Rf8	a_27_392##5	a_27_392##6	17.431206
Rf9	a_27_392##5	a_27_392##7	112.875275
Rf10	a_347_98##3	a_347_98##2	365.112579
Rf11	a_347_98##2	a_347_98##7	76.363083
Rf12	a_347_98##7	a_347_98##8	26.034916
Rf13	a_347_98##7	a_347_98##9	83.450409
Rf14	a_235_74##6	a_235_74##9	426.565735
Rf15	a_235_74##9	a_235_74##10	12.569075
Rf16	a_235_74##9	a_235_74##11	47.865971
Rf17	a_235_74##11	a_235_74##12	53.900059
Rf18	a_235_74##11	a_235_74##3	164.190231
Rf19	a_646_74##3	a_646_74##6	255.306747
Rf20	a_646_74##6	a_646_74##7	63.101585
Rf21	a_646_74##6	a_646_74##8	91.472618
Rf22	RESET_B	RESET_B#4	1.456682
Rf23	RESET_B#5	RESET_B#2	161.689484
Rf24	RESET_B#4	RESET_B#5	5.471237
Rf25	a_832_55##6	a_832_55##12	147.962524
Rf26	a_832_55##12	a_832_55##14	16.906263
Rf27	a_832_55##14	a_832_55#	200.828995
Rf28	a_832_55##12	a_832_55##16	67.800888
Rf29	a_832_55##13	a_832_55##14	5.000000
Rf30	Q#1	Q	93.744492
Rf31	Q	Q#2	60.875946
Rf32	VPWR#1	VPWR#2	37.953194
Rf33	VPWR#2	VPWR#3	77.445518
Rf34	VPWR#3	VPWR#4	84.162567
Rf35	VPWR#4	VPWR#5	102.814972
Rf36	VPWR#5	VPWR#6	66.816673
Rf37	VPWR#6	VPWR#7	119.023247
Rf39	VPWR#3	VPWR#9	34.939823
Rf40	VPWR#4	VPWR#10	24.019943
Rf41	VPWR#6	VPWR#11	26.830879
Rf42	VPWR#7	VPWR#12	26.830879
Rf43	VGND#1	VGND#2	39.744942
Rf44	VGND#2	VGND#3	77.445518
Rf45	VGND#3	VGND#4	107.335167
Rf46	VGND#4	VGND#5	79.600510
Rf47	VGND#5	VGND#6	64.990410
Rf48	VGND#6	VGND#7	120.849503
Rf50	VGND#3	VGND#9	32.125244
Rf51	VGND#4	VGND#10	35.885353
Rf52	VGND#6	VGND#11	24.468842
Rf53	VGND#7	VGND#12	31.141060
Re1	VPWR#2	VPWR	11.068454
Re2	VPWR	VPWR#5	0.790604
Re3	VGND#2	VGND	11.068454
Re4	VGND	VGND#5	0.790604
*
*       CAPACITOR CARDS
*
*
C1	VGND#3	RESET_B#5	4.5647e-19
C2	a_646_74##8	a_646_74##6	2.50336e-18
C3	a_347_98##9	VPWR#11	2.15676e-18
C4	a_646_74##8	a_235_74#	4.99995e-19
C5	a_347_98##8	a_347_98#	4.10253e-19
C6	a_27_392#	VGND#11	1.44596e-17
C7	VGND#3	VGND#2	9.5684e-19
C8	VGND#3	RESET_B#4	1.48213e-18
C9	VGND#4	a_646_74##6	4.60383e-19
C10	a_347_98##8	a_27_392#	1.38936e-18
C11	a_646_74##8	GATE#3	1.65906e-19
C12	a_235_74#	VGND#11	1.65452e-17
C13	VPWR#3	VPWR#2	8.81498e-19
C14	a_832_55##12	a_646_74##2	1.67255e-17
C15	a_235_74##12	a_347_98##9	3.04672e-17
C16	VPWR#12	VPWR#11	3.43792e-18
C17	a_832_55##12	VPWR#3	1.20253e-19
C18	a_347_98##8	a_235_74#	4.06457e-17
C19	Q#1	VPWR#3	8.02985e-18
C20	Q#2	a_832_55##7	4.23671e-18
C21	VGND#12	a_27_392#	4.8457e-19
C22	VPWR#4	VPWR#9	1.947e-18
C23	a_235_74##11	GATE#1	1.51092e-18
C24	a_347_98##8	GATE#3	7.97626e-19
C25	a_27_392##6	a_347_98##9	2.93922e-17
C26	GATE#3	a_235_74##10	1.96024e-17
C27	a_27_392##7	a_235_74#	1.6474e-19
C28	a_235_74##9	a_646_74##8	1.93494e-17
C29	a_27_392##6	a_235_74##12	7.09309e-17
C30	GATE#3	VGND#12	2.74864e-17
C31	a_832_55##13	VPWR#4	5.78336e-17
C32	VGND#9	a_832_55##7	1.73606e-18
C33	a_27_392##6	VPWR#12	5.31902e-17
C34	a_27_392##7	GATE#3	3.8441e-18
C35	a_832_55##13	VPWR#3	8.44968e-18
C36	VGND#3	a_832_55##6	4.42946e-19
C37	D#1	VGND#12	2.40235e-17
C38	VPWR#4	VPWR#10	1.04937e-17
C39	a_347_98##9	a_235_74##2	6.62838e-18
C40	VGND#6	a_235_74##9	7.93485e-17
C41	a_27_392##7	D#1	3.95298e-17
C42	a_832_55##12	Q#1	7.66446e-19
C43	RESET_B#5	a_832_55##7	5.13156e-18
C44	a_235_74##9	VGND#11	4.69091e-18
C45	a_235_74##11	a_347_98##8	3.68415e-17
C46	a_832_55##6	VPWR#3	5.42231e-19
C47	a_832_55##12	VPWR#9	1.04312e-17
C48	a_646_74##6	VPWR#4	1.02977e-18
C49	a_235_74##9	a_347_98##8	9.90989e-17
C50	VGND#4	a_646_74##3	1.78146e-18
C51	a_832_55##10	a_832_55##9	3.53123e-17
C52	a_235_74##12	a_235_74##2	9.38725e-20
C53	a_832_55##4	VPWR#1	2.90972e-17
C54	a_832_55##12	a_832_55##13	1.22985e-19
C55	a_832_55##12	a_832_55##6	2.31602e-18
C56	Q#1	a_832_55##4	4.49785e-17
C57	a_235_74##9	a_235_74##10	5.13936e-18
C58	VPWR#1	a_832_55##8	2.53525e-18
C59	RESET_B#3	a_832_55##10	2.051e-17
C60	VPWR#9	a_832_55##4	1.37677e-18
C61	a_646_74##3	VPWR#4	2.10152e-18
C62	Q#1	a_832_55##8	4.8299e-17
C63	RESET_B#5	a_832_55##6	2.1986e-17
C64	a_832_55##12	VPWR#10	3.48885e-19
C65	a_832_55##12	RESET_B#2	2.55605e-18
C66	VPWR#1	RESET_B#1	2.8528e-19
C67	a_646_74##8	a_235_74##7	3.1473e-19
C68	VGND#12	a_235_74##9	6.13998e-17
C69	a_832_55##8	VPWR#9	3.14717e-17
C70	Q#2	VGND#1	4.32931e-17
C71	Q#1	RESET_B#1	2.12589e-19
C72	a_646_74#	RESET_B#3	5.11387e-17
C73	VGND#4	a_235_74##6	2.14672e-17
C74	VGND#5	a_235_74##9	1.87727e-17
C75	a_832_55#	VPWR#4	3.15622e-17
C76	RESET_B#4	a_646_74##2	4.10825e-18
C77	RESET_B#5	RESET_B#2	1.31098e-17
C78	RESET_B#1	VPWR#9	3.71773e-17
C79	RESET_B#5	a_832_55##12	1.9668e-17
C80	a_646_74##3	a_832_55##12	4.68021e-17
C81	a_27_392##7	a_235_74##9	5.16903e-18
C82	VGND#9	VGND#1	1.91447e-18
C83	RESET_B#4	RESET_B#2	5.40091e-18
C84	a_832_55##16	a_646_74##2	7.33167e-18
C85	a_832_55##13	RESET_B#1	5.90557e-17
C86	VPWR#9	a_646_74##4	1.2717e-18
C87	a_832_55##2	a_646_74#	7.27983e-18
C88	VPWR#4	a_235_74##6	2.85239e-19
C89	VGND#9	Q#2	5.99976e-17
C90	a_832_55##13	a_646_74##4	6.70024e-17
C91	a_832_55##12	RESET_B#4	2.84897e-17
C92	a_832_55##12	a_832_55#	2.02407e-19
C93	a_27_392##6	a_235_74##2	3.02178e-19
C94	VPWR#9	a_832_55##3	1.79849e-19
C95	a_646_74##6	a_832_55##13	4.52533e-19
C96	GATE#1	a_235_74##2	7.42756e-19
C97	a_646_74##4	VPWR#10	1.47986e-17
C98	a_646_74##6	a_646_74##3	1.89638e-18
C99	a_235_74##5	a_832_55##2	3.94359e-17
C100	a_347_98#	a_646_74#	3.20204e-20
C101	a_832_55##13	a_832_55##3	1.11868e-18
C102	a_347_98##3	VPWR#6	5.64554e-18
C103	a_347_98##3	VPWR#4	3.20795e-17
C104	a_832_55##3	VPWR#10	1.31109e-17
C105	a_832_55##13	a_347_98##4	2.98709e-19
C106	VGND#2	Q#2	9.13111e-18
C107	a_646_74##6	a_832_55#	4.519e-19
C108	a_832_55##16	Q#2	4.09237e-18
C109	a_347_98#	a_235_74##5	1.14327e-17
C110	VGND#6	a_27_392##2	5.81047e-19
C111	VGND#9	VGND#2	3.83323e-19
C112	a_832_55##13	a_235_74##7	7.27253e-20
C113	a_832_55##16	VGND#9	2.45003e-17
C114	a_646_74##6	a_235_74##6	8.66867e-17
C115	a_347_98##4	a_646_74##7	1.10502e-17
C116	a_27_392#	a_347_98#	4.33534e-17
C117	VPWR#11	a_832_55##3	6.90416e-20
C118	VGND#4	a_832_55##10	4.62759e-20
C119	a_27_392##6	VPWR#6	6.30951e-18
C120	VGND#6	a_235_74##3	1.6076e-19
C121	a_27_392##2	VPWR#6	2.69109e-18
C122	a_646_74##7	a_235_74##7	3.08407e-17
C123	VGND#10	VGND#9	1.22996e-18
C124	a_646_74##6	a_646_74##7	2.5391e-18
C125	VPWR#11	a_347_98##4	2.28826e-19
C126	VGND#3	a_832_55##10	4.75482e-18
C127	a_646_74##6	a_347_98##3	5.37388e-17
C128	a_235_74##9	a_235_74##6	1.6314e-18
C129	a_235_74#	a_27_392#	2.04996e-17
C130	a_646_74##7	a_27_392##3	1.1651e-18
C131	a_832_55##6	Q#2	4.20724e-17
C132	VGND#4	RESET_B#3	1.02904e-19
C133	VPWR#11	a_235_74##7	2.07583e-18
C134	VPWR#6	a_235_74##3	1.35146e-19
C135	a_832_55##6	VGND#9	8.68472e-18
C136	GATE#3	a_27_392#	2.8293e-19
C137	a_347_98##2	a_646_74##6	7.07347e-17
C138	VGND#3	RESET_B#3	6.29114e-18
C139	a_27_392##3	VPWR#11	3.32566e-17
C140	VPWR#2	a_832_55##7	5.42442e-20
C141	GATE#3	a_235_74#	3.48617e-18
C142	a_27_392##7	GATE#6	9.06924e-18
C143	VGND#10	a_832_55##16	4.34582e-17
C144	RESET_B#2	VGND#9	5.28288e-18
C145	VPWR#2	VPWR#1	2.12198e-17
C146	a_347_98##9	a_27_392##3	2.25932e-18
C147	VGND#4	a_646_74#	3.15249e-18
C148	a_235_74##4	VPWR#11	2.55825e-17
C149	Q#1	VPWR#2	9.76454e-18
C150	a_235_74##9	a_347_98##2	1.76497e-17
C151	a_646_74##6	a_27_392##2	1.20854e-19
C152	a_832_55##16	RESET_B#2	1.8561e-18
C153	a_347_98##9	a_235_74##4	4.5998e-17
C154	VGND#3	a_646_74#	1.4029e-18
C155	VPWR#9	VPWR#2	7.53417e-20
C156	D#1	GATE#3	1.8387e-17
C157	VPWR#12	a_27_392##3	1.20189e-18
C158	VPWR#11	GATE#1	1.06387e-18
C159	a_235_74##12	a_235_74##4	1.00002e-18
C160	VGND#2	Q#1	8.33969e-19
C161	a_27_392##6	a_27_392##3	2.33788e-19
C162	a_347_98##9	GATE#1	6.81505e-19
C163	VGND#4	a_832_55##2	4.07473e-18
C164	VPWR#12	a_235_74##4	1.93715e-18
C165	a_832_55##16	a_646_74##3	2.33037e-17
C166	a_235_74##9	a_27_392##2	6.92e-19
C167	VPWR#11	D#3	8.36528e-19
C168	VGND#2	a_832_55##7	5.24649e-20
C169	a_235_74##12	GATE#1	4.05934e-17
C170	VGND#10	a_646_74##3	8.51788e-18
C171	a_27_392##6	a_235_74##4	1.06025e-18
C172	GATE#1	VPWR#12	1.77678e-17
C173	a_235_74##11	a_235_74##2	4.43307e-19
C174	a_235_74##11	a_235_74##3	2.21408e-17
C175	a_235_74##12	D#3	2.04006e-18
C176	a_27_392##6	GATE#1	4.08231e-17
C177	a_235_74##9	a_235_74##3	1.37112e-18
C178	VGND#4	a_235_74##5	1.73439e-18
C179	VGND#10	a_832_55#	1.53212e-18
C180	D#3	VPWR#12	3.12957e-17
C181	a_27_392##6	D#3	5.72683e-17
C182	a_235_74##6	a_832_55##16	1.02402e-17
C183	VGND#6	a_347_98#	7.19306e-19
C184	a_235_74##11	a_347_98##9	2.54321e-17
C185	a_832_55##6	Q#1	4.96823e-17
C186	a_235_74##11	GATE#2	8.43517e-18
C187	a_235_74##6	VGND#10	4.89547e-17
C188	a_235_74##9	GATE#2	4.47918e-18
C189	a_832_55##6	VPWR#9	3.03898e-17
C190	a_832_55##8	a_832_55##4	4.43828e-17
C191	VGND#4	a_347_98#	3.59933e-19
C192	a_832_55##2	a_646_74##2	6.52703e-19
C193	a_235_74##6	a_646_74##8	9.59861e-17
C194	a_235_74##9	a_235_74##2	2.15712e-19
C195	a_235_74##11	D#2	1.31496e-18
C196	VPWR#9	RESET_B#2	6.81241e-19
C197	RESET_B#5	a_832_55##9	2.99564e-19
C198	VGND#1	VPWR#1	1.74799e-19
C199	GATE#6	a_235_74##3	1.8418e-18
C200	VGND#6	a_27_392#	9.07321e-18
C201	RESET_B#1	a_832_55##8	3.17079e-17
C202	a_235_74##9	a_235_74##12	2.13812e-18
C203	VGND#4	a_27_392#	2.24461e-20
C204	VGND#2	a_832_55##9	5.82867e-18
C205	GATE#6	GATE#2	1.26685e-17
C206	a_646_74##3	a_832_55##13	1.19814e-17
C207	RESET_B#5	a_832_55##10	1.68764e-18
C208	a_646_74##4	RESET_B#1	4.54884e-17
C209	a_347_98##2	a_646_74##8	3.75561e-17
C210	a_646_74##3	VPWR#10	1.05274e-18
C211	VGND#2	a_832_55##10	7.50515e-19
C212	VGND#6	a_235_74#	9.15763e-18
C213	VGND#2	RESET_B#3	1.27258e-19
C214	Q#2	Q#1	2.25576e-18
C215	a_832_55##13	a_832_55#	6.20795e-20
C216	a_347_98##8	a_235_74##2	1.39605e-17
C217	GATE#6	D#2	6.55643e-19
C218	a_347_98##8	a_646_74##8	2.27978e-18
C219	a_832_55#	VPWR#10	1.42267e-18
C220	a_27_392##6	a_235_74##11	1.14909e-17
C221	a_347_98##8	a_347_98##2	2.72746e-18
C222	a_832_55##3	a_646_74##4	7.59961e-18
C223	VGND#6	GATE#3	1.41638e-18
C224	a_347_98##8	a_27_392##2	2.96294e-17
C225	a_347_98##4	a_832_55##3	8.19989e-18
C226	a_347_98##3	a_832_55##13	2.81339e-18
C227	a_832_55##6	a_832_55##7	2.92344e-17
C228	a_235_74##6	a_646_74##7	2.47601e-19
C229	VGND#6	a_235_74##2	3.50651e-20
C230	a_347_98##8	VGND#11	1.60132e-18
C231	a_347_98##8	a_235_74##3	5.5419e-18
C232	VGND#3	Q#2	8.48034e-18
C233	VGND#6	VGND#4	2.75028e-19
C234	RESET_B#2	a_832_55##10	5.87879e-19
C235	VGND#3	a_832_55##7	7.95815e-20
C236	a_832_55##6	a_646_74##2	1.58148e-19
C237	VGND#5	a_235_74##5	2.28563e-18
C238	RESET_B#4	a_646_74#	9.12392e-20
C239	a_235_74##7	a_347_98##4	1.63598e-17
C240	a_347_98##3	a_646_74##7	9.04124e-17
C241	VGND#4	VGND#9	1.71401e-19
C242	a_235_74##9	a_235_74##11	2.64918e-18
C243	VGND#5	a_347_98#	4.44586e-18
C244	VGND#4	a_646_74##2	1.85727e-20
C245	a_646_74#	RESET_B#2	5.3885e-18
C246	a_347_98##8	GATE#2	8.01835e-19
C247	VPWR#11	a_347_98##3	1.93438e-17
C248	GATE#2	a_235_74##10	2.79279e-19
C249	a_347_98##2	a_646_74##7	4.20225e-17
C250	VPWR#2	a_832_55##4	1.1973e-18
C251	a_27_392##3	a_235_74##7	4.96516e-17
C252	a_27_392##7	GATE#2	5.00095e-18
C253	RESET_B#2	a_832_55##7	3.44049e-17
C254	a_832_55##2	a_646_74##3	1.83476e-17
C255	a_646_74##6	a_832_55##2	2.8666e-18
C256	a_235_74##4	a_27_392##3	2.14644e-17
C257	a_832_55##16	a_832_55##13	2.01596e-18
C258	GATE#6	a_235_74##12	5.99547e-18
C259	a_646_74##2	RESET_B#2	2.71478e-17
C260	a_27_392##2	VPWR#11	4.77873e-17
C261	a_27_392##7	D#2	3.30832e-17
C262	a_27_392##2	a_347_98##9	5.98984e-17
C263	a_235_74##6	a_646_74#	7.42742e-19
C264	VGND#4	VGND#3	4.24874e-19
C265	a_235_74##6	a_832_55##2	4.57053e-17
C266	GATE#1	a_235_74##4	5.67675e-18
C267	VGND#4	a_832_55##16	1.72233e-17
C268	a_235_74##6	a_235_74##5	1.72905e-17
C269	a_832_55##6	a_832_55##4	8.74055e-19
C270	a_347_98##9	a_235_74##3	4.86959e-18
C271	a_27_392##6	a_27_392##2	1.01345e-18
C272	a_347_98#	a_235_74##6	1.37033e-18
C273	a_832_55##6	a_832_55##8	8.09156e-18
C274	D#3	GATE#1	1.89839e-17
C275	a_235_74##6	a_27_392#	1.17558e-19
C276	VGND#3	a_832_55##16	4.23493e-18
C277	VPWR#5	a_347_98##4	4.61092e-18
C278	a_27_392##6	a_235_74##3	3.03976e-18
C279	a_235_74##12	GATE#2	2.84418e-18
C280	a_27_392##6	GATE#6	1.94312e-17
C281	a_646_74##3	a_646_74##2	2.62131e-19
C282	VPWR#5	a_235_74##7	4.49919e-18
C283	a_235_74##9	a_832_55##2	1.83143e-19
C284	a_27_392##6	GATE#2	4.93518e-18
C285	VGND#5	a_235_74##7	1.25195e-20
C286	a_27_392##7	VGND#12	6.29083e-17
C287	a_235_74##12	D#2	1.14419e-19
C288	a_347_98##2	a_27_392#	2.24432e-17
C289	a_235_74##9	a_568_74#	6.95764e-19
C290	a_646_74##3	a_646_74##4	1.80352e-18
C291	a_347_98##2	a_235_74#	1.9949e-20
C292	D#2	a_27_392##6	5.99888e-17
C293	a_235_74##9	a_235_74##5	6.83153e-19
C294	a_832_55#	a_646_74##4	1.28993e-17
C295	a_235_74#	a_27_392##2	2.11684e-18
C296	Q#1	a_832_55##7	3.51593e-18
C297	a_832_55#	a_646_74##2	2.34215e-19
C298	a_235_74##9	a_347_98#	2.3944e-17
C299	a_235_74##7	a_832_55#	8.9319e-19
C300	a_347_98##3	a_646_74##4	4.08055e-19
C301	Q	a_832_55##7	1.17158e-17
C302	GATE#2	a_235_74#	1.32394e-18
C303	a_347_98##3	a_832_55##3	1.02559e-17
C304	a_646_74##8	a_646_74##7	7.23795e-20
C305	a_235_74##6	a_235_74##7	7.91379e-20
C306	VPWR#4	a_832_55##8	3.44074e-19
C307	a_347_98##3	a_347_98##4	2.13996e-17
C308	VPWR#2	a_832_55##6	5.08181e-19
C309	D#1	GATE#2	3.73733e-18
C310	a_347_98##3	a_235_74##7	3.1501e-17
C311	VGND#2	a_832_55##6	3.93894e-19
C312	VPWR#3	a_832_55##8	3.56039e-18
C313	a_235_74##9	a_27_392#	2.95891e-17
C314	a_347_98##3	a_27_392##3	7.65213e-18
C315	a_347_98##2	a_235_74##7	5.4803e-17
C316	a_347_98##3	a_235_74##4	1.02393e-18
C317	Q#1	VPWR#1	7.96311e-17
C318	a_235_74##11	a_235_74#	7.77987e-20
C319	a_347_98##2	a_27_392##3	9.06479e-18
C320	a_347_98##3	GATE#1	2.51534e-19
C321	VPWR#4	RESET_B#1	8.50705e-19
C322	a_27_392##2	a_235_74##7	1.78425e-17
C323	a_235_74##6	a_646_74##2	1.64915e-19
C324	a_832_55##12	a_832_55##4	1.47286e-19
C325	a_832_55##9	VGND#1	1.72864e-17
C326	a_347_98##2	a_235_74##4	1.17191e-19
C327	RESET_B#3	a_1060_74#	1.73994e-17
C328	VGND#6	VGND#11	7.67149e-18
C329	a_27_392##2	a_27_392##3	2.23695e-17
C330	a_646_74#	a_1060_74#	1.73994e-17
C331	a_235_74##9	a_235_74#	1.6129e-17
C332	a_347_98##2	GATE#1	3.97491e-20
C333	VPWR#3	RESET_B#1	2.6036e-18
C334	VPWR#9	VPWR#1	1.68363e-18
C335	a_27_392##2	a_235_74##4	3.12506e-17
C336	a_832_55##6	RESET_B#2	4.21879e-18
C337	Q#2	a_832_55##9	5.55058e-17
C338	a_27_392##2	GATE#1	2.04965e-19
C339	GATE#6	a_235_74##11	1.93405e-17
C340	VPWR#5	a_235_74##6	2.25573e-20
C341	VGND#1	a_832_55##10	6.26141e-19
C342	a_27_392##2	D#3	1.39857e-19
C343	VGND#9	a_832_55##12	6.76981e-19
C344	VPWR#4	a_646_74##4	1.8859e-17
C345	VPWR#9	Q#1	7.99818e-17
C346	a_832_55##12	a_832_55##8	2.83893e-19
C347	VGND#5	a_235_74##6	4.62398e-17
C348	a_347_98##3	VPWR#5	7.05778e-17
C349	VGND#9	a_832_55##9	1.44152e-18
C350	a_235_74##9	GATE#3	3.03047e-17
C351	Q#2	a_832_55##10	4.26754e-17
C352	a_832_55##2	a_784_81#	1.91076e-18
C353	VPWR#5	a_347_98##2	3.40121e-20
C354	VPWR#6	a_235_74##2	6.0336e-21
C355	a_646_74##3	a_832_55#	9.58782e-17
C356	a_235_74##5	a_784_81#	3.96008e-18
C357	VGND#1	RESET_B#3	1.58029e-19
C358	VGND#5	a_347_98##2	1.26084e-19
C359	a_347_98##4	a_756_508#	1.2049e-17
C360	D#2	GATE#1	3.01141e-18
C361	VPWR#3	a_832_55##7	4.57114e-20
C362	a_235_74##6	a_646_74##3	1.35417e-17
C363	a_832_55##10	VGND#9	2.39698e-17
C364	a_832_55##12	RESET_B#1	2.11999e-17
C365	VPWR#4	a_832_55##3	2.4485e-17
C366	VGND	a_832_55##7	1.04935e-19
C367	a_235_74##6	a_832_55#	1.737e-17
C368	a_235_74##9	D#1	2.20577e-18
C369	Q#2	RESET_B#3	2.10931e-18
C370	a_235_74##7	a_565_392#	1.58196e-17
C371	a_832_55##13	VPWR#9	8.36048e-17
C372	a_347_98##3	a_832_55#	5.68234e-17
C373	a_27_392##3	a_565_392#	2.80259e-18
C374	a_235_74##6	a_347_98##3	2.64359e-17
C375	GATE	a_235_74##11	9.76061e-18
C376	a_347_98##2	a_832_55#	6.68973e-20
C377	a_646_74##3	a_27_392##2	1.79973e-20
C378	a_235_74##9	GATE	2.04468e-17
C379	a_347_98#	a_568_74#	6.62657e-18
C380	RESET_B#3	VGND#9	3.09721e-17
C381	a_347_98##8	a_347_98##9	2.54733e-18
C382	a_27_392#	a_568_74#	1.14708e-17
C383	a_347_98##2	a_235_74##6	1.53783e-17
C384	Q#2	a_646_74#	5.12082e-19
C385	a_27_392##7	D	1.51466e-17
C386	a_832_55##16	a_832_55##10	2.69791e-18
C387	a_832_55##12	a_646_74##4	7.67036e-18
C388	a_347_98##2	a_347_98##3	3.34383e-18
C389	a_27_392##2	a_235_74##6	1.15694e-18
C390	VPWR#4	a_347_98##4	2.67406e-18
C391	RESET_B#5	Q	3.39308e-18
C392	VGND#9	RESET_B#5	1.89808e-17
C393	VGND#12	VGND#6	7.88359e-19
C394	VGND#9	a_646_74#	4.31472e-18
C395	a_347_98##2	a_27_392##2	1.3108e-16
C396	VGND#10	a_832_55##10	1.12252e-19
C397	a_832_55##13	VPWR#10	2.24381e-18
C398	a_347_98##2	a_235_74##2	3.1586e-19
C399	a_832_55##16	RESET_B#3	6.98056e-18
C400	a_832_55##7	VNB	6.48485e-17
C401	VPWR	VPWR#6	7.45439e-17
C402	VPWR	VPWR#4	1.24489e-16
C403	a_646_74##2	VNB	1.96514e-17
C404	a_235_74##2	VNB	2.40706e-17
C405	VPWR	VPWR#3	5.96213e-17
C406	VPWR	a_832_55##12	7.25597e-19
C407	D	a_27_392##6	1.82008e-17
C408	VPWR#4	a_235_74##7	1.23824e-19
C409	VPWR	RESET_B#5	1.60476e-18
C410	VGND#9	a_832_55##2	2.81376e-19
C411	VPWR	RESET_B#4	1.25002e-18
C412	VGND#10	RESET_B#3	1.57571e-19
C413	Q	VGND#1	3.27591e-17
C414	VPWR	a_646_74##6	5.40217e-18
C415	a_27_392##7	GATE	2.1578e-17
C416	GATE#2	a_235_74##3	2.43863e-17
C417	VPWR	a_235_74##11	1.85852e-18
C418	a_347_98##3	a_756_508#	3.88795e-18
C419	a_832_55##16	a_646_74#	5.53573e-17
C420	VGND	VGND#6	9.04825e-17
C421	VGND	VGND#4	9.6748e-17
C422	VGND	VGND#3	7.74857e-17
C423	a_347_98##3	a_565_392#	5.59674e-18
C424	D#2	GATE#2	1.44394e-17
C425	VPWR#6	a_27_392##3	4.50917e-18
C426	VPWR	GATE#6	3.54104e-18
C427	a_347_98##2	a_565_392#	1.28949e-17
C428	VGND#10	a_646_74#	1.72256e-18
C429	VGND	a_832_55##12	4.13653e-18
C430	Q	VPWR#1	3.11455e-17
C431	Q	Q#1	5.0452e-19
C432	VPWR#4	a_27_392##3	5.86533e-20
C433	VGND	RESET_B#5	2.26586e-18
C434	VGND	RESET_B#4	4.18138e-18
C435	VGND	a_646_74##6	4.79427e-18
C436	a_832_55##16	a_832_55##2	7.90882e-18
C437	a_235_74##6	a_784_81#	6.27397e-18
C438	VGND	a_235_74##11	1.98896e-18
C439	VGND	a_235_74##9	5.5188e-17
C440	a_235_74##2	a_27_392##2	3.16455e-17
C441	VPWR#4	VPWR#3	9.11746e-19
C442	VGND#6	VNB	4.63306e-17
C443	VGND#10	a_832_55##2	4.42626e-17
C444	VPWR	Q#1	1.75305e-17
C445	VGND#4	VNB	4.56828e-17
C446	Q	a_832_55##9	7.14297e-19
C447	RESET_B#1	a_832_55##7	1.16658e-18
C448	VGND#3	VNB	3.92243e-17
C449	VPWR	VPWR#9	2.12223e-17
C450	Q	a_832_55##10	1.68981e-19
C451	VPWR#6	a_235_74##4	5.66474e-18
C452	VPWR	a_832_55##13	2.2163e-17
C453	GATE	D#1	1.58443e-19
C454	VPWR#6	VNB	4.01471e-17
C455	VGND#12	a_27_392##6	1.75003e-18
C456	VGND	Q#2	1.68394e-17
C457	VPWR#4	VNB	5.00783e-17
C458	VGND#3	a_832_55##12	4.40519e-19
C459	VPWR#3	VNB	3.0342e-17
C460	VGND	VGND#9	1.92585e-17
C461	VPWR	a_646_74##7	1.05814e-17
C462	a_832_55##16	RESET_B#4	2.74157e-17
C463	a_832_55##16	a_235_74##5	3.91019e-19
C464	VGND	a_832_55##16	2.16135e-17
C465	a_832_55##12	VNB	4.41731e-18
C466	VPWR	VPWR#11	2.18008e-17
C467	VGND	a_646_74##8	1.0605e-17
C468	RESET_B#5	VNB	1.07402e-18
C469	VPWR	a_347_98##9	5.12792e-18
C470	VPWR	a_235_74##12	5.17171e-18
C471	a_646_74##6	VNB	1.04808e-17
C472	VPWR	VPWR#12	2.18413e-17
C473	VGND	a_347_98##8	9.33233e-18
C474	a_235_74##11	VNB	5.95257e-18
C475	VPWR	a_27_392##6	4.29931e-17
C476	a_235_74##9	VNB	1.37715e-17
C477	VGND	VGND#12	2.05139e-17
C478	VGND	a_27_392##7	1.82654e-17
C479	VGND	Q#1	1.81488e-18
C480	a_27_392##7	a_27_392##6	1.96972e-18
C481	VGND#10	a_235_74##5	2.85274e-18
C482	a_646_74##2	RESET_B#1	2.25834e-18
C483	VGND#1	VNB	2.38893e-17
C484	Q#2	VNB	4.94254e-18
C485	VGND#9	VNB	4.26056e-18
C486	VGND	a_347_98##9	5.9781e-19
C487	VGND	a_235_74##12	1.8416e-18
C488	a_832_55##16	VNB	8.26023e-18
C489	a_646_74##8	a_832_55##2	1.51377e-18
C490	VGND#10	VNB	1.02627e-17
C491	a_646_74##8	VNB	3.21535e-18
C492	VPWR	a_832_55##4	1.09116e-19
C493	VGND	a_832_55##10	1.23544e-18
C494	VPWR	a_832_55##8	2.45229e-18
C495	a_347_98##8	VNB	7.10348e-18
C496	VGND	RESET_B#3	1.85477e-18
C497	VPWR	RESET_B#1	2.35083e-19
C498	VGND	a_646_74#	1.39184e-18
C499	VGND#12	VNB	1.03491e-17
C500	VGND	a_832_55##2	5.69455e-18
C501	a_27_392##7	VNB	4.16561e-17
C502	VPWR#1	VNB	4.06623e-17
C503	VGND	a_235_74##5	1.73531e-21
C504	VPWR	a_832_55##3	9.8456e-19
C505	Q#1	VNB	6.08855e-18
C506	VGND	a_347_98#	1.83817e-18
C507	VPWR#9	VNB	3.851e-18
C508	VPWR	a_347_98##4	1.06989e-18
C509	VPWR#2	Q	3.27223e-18
C510	VGND	a_27_392#	5.61135e-19
C511	a_832_55##13	VNB	2.52499e-18
C512	VPWR	a_235_74##7	1.44651e-18
C513	VGND	a_235_74#	8.71368e-18
C514	VGND#2	Q	4.63286e-18
C515	VGND	GATE#3	1.6724e-18
C516	VPWR	a_27_392##3	1.01288e-18
C517	a_646_74##7	VNB	3.0092e-19
C518	VGND	D#1	8.70362e-18
C519	VPWR	a_235_74##4	8.10029e-18
C520	VGND#10	a_347_98#	5.21958e-21
C521	VPWR#11	VNB	7.873e-18
C522	VPWR	GATE#1	8.46748e-18
C523	a_347_98##9	VNB	2.43062e-18
C524	D	D#2	9.82369e-18
C525	a_235_74##12	VNB	6.79102e-18
C526	a_832_55##6	Q	3.31439e-17
C527	VPWR	D#3	8.07299e-18
C528	VPWR#12	VNB	1.50542e-17
C529	a_27_392##6	VNB	6.33327e-17
C530	Q	RESET_B#2	2.45581e-19
C531	a_832_55##9	VNB	3.39513e-17
C532	VPWR	VPWR#2	1.29919e-17
C533	a_832_55##10	VNB	3.03202e-17
C534	RESET_B#3	VNB	2.5764e-17
C535	a_646_74#	VNB	2.89488e-17
C536	a_235_74##5	a_646_74##8	1.55854e-17
C537	a_832_55##2	VNB	6.82113e-17
C538	VPWR	VPWR#5	5.36534e-17
C539	VGND	a_235_74##7	1.7758e-19
C540	a_235_74##5	VNB	2.94183e-17
C541	a_347_98#	VNB	2.80475e-17
C542	a_27_392#	VNB	2.99055e-17
C543	VPWR	a_832_55##6	5.64407e-18
C544	GATE	GATE#2	8.06698e-18
C545	a_235_74#	VNB	3.68876e-17
C546	GATE#3	VNB	3.9779e-17
C547	D#1	VNB	4.19543e-17
C548	GATE	D#2	1.61129e-19
C549	VPWR	a_646_74##3	6.25106e-18
C550	a_832_55##4	VNB	3.68156e-17
C551	VPWR	a_832_55#	5.42445e-18
C552	a_832_55##8	VNB	3.39133e-17
C553	VGND	VGND#2	1.29963e-17
C554	RESET_B#1	VNB	3.41649e-17
C555	VPWR	a_235_74##6	2.19858e-18
C556	a_646_74##4	VNB	3.56348e-17
C557	VPWR	a_347_98##3	4.55495e-17
C558	a_832_55##3	VNB	2.53504e-17
C559	VGND	VGND#5	4.70853e-17
C560	a_347_98##4	VNB	2.29685e-17
C561	VPWR	a_347_98##2	3.95038e-18
C562	VGND	a_832_55##6	5.61261e-18
C563	a_646_74##6	a_235_74##7	9.1797e-18
C564	a_235_74##7	VNB	4.62293e-17
C565	a_27_392##3	VNB	3.28397e-17
C566	VGND	RESET_B#2	1.43901e-19
C567	VPWR	a_27_392##2	1.28023e-17
C568	a_235_74##4	VNB	3.43862e-17
C569	VGND	a_646_74##3	1.16165e-17
C570	GATE#1	VNB	4.27555e-17
C571	VGND	a_832_55#	3.00395e-19
C572	D#3	VNB	4.34354e-17
C573	VGND	a_235_74##6	3.22121e-17
C574	VPWR#2	VNB	9.39755e-17
C575	VPWR	D#2	9.37098e-19
C576	VGND#2	VNB	9.61358e-17
C577	VGND	a_347_98##2	9.68892e-18
C578	VPWR#5	VNB	3.04065e-17
C579	VGND#5	VNB	2.86071e-17
C580	VGND	a_27_392##2	3.65544e-18
C581	a_832_55##6	VNB	3.40006e-18
C582	VGND	a_235_74##3	5.58554e-20
C583	RESET_B#2	VNB	2.99715e-17
C584	VGND	GATE#2	6.95037e-19
C585	a_646_74##8	a_347_98#	3.11721e-17
C586	a_646_74##3	VNB	4.61731e-17
C587	a_832_55#	VNB	5.46057e-17
C588	VGND	D#2	1.02336e-18
C589	a_235_74##6	VNB	6.91479e-17
C590	a_347_98##3	VNB	4.55651e-17
C591	a_347_98##2	VNB	3.76407e-17
C592	a_27_392##2	VNB	3.77833e-17
C593	a_235_74##3	VNB	4.31538e-17
C594	GATE#2	VNB	4.25655e-17
C595	D#2	VNB	6.9823e-17
C596	VPWR	D	1.07083e-18
C597	VGND	D	2.3027e-18
C598	VGND	GATE	5.28259e-18
C599	D	VNB	1.95321e-17
C600	a_832_55##12	a_832_55##7	2.94009e-19
C601	GATE	VNB	5.16784e-19
C602	Q	VNB	5.2014e-17
C603	VPWR	VNB	2.99973e-16
C604	GATE#2	a_235_74##2	3.05483e-19
C605	VGND	VNB	3.1603e-16
C606	a_646_74##8	a_27_392#	2.11947e-18
C607	a_347_98##8	a_235_74##5	2.61681e-19
C608	VGND#7	GATE#2	1.27013e-19
C609	VGND#7	a_27_392##7	1.12905e-17
C610	VGND#7	a_235_74##3	4.63861e-20
C611	VPWR#7	a_235_74##3	6.61128e-20
C612	VGND#7	D	5.8296e-19
C613	VPWR#7	GATE#2	8.28556e-20
C614	VPWR#7	D#2	7.83095e-20
C615	VGND#7	VNB	6.30532e-17
C616	VGND#7	VGND#6	3.2171e-19
C617	VGND	VGND#7	1.06673e-16
C618	VGND#7	a_235_74##9	2.47221e-17
C619	VPWR#7	GATE#1	5.68846e-18
C620	VPWR#7	D#3	3.97962e-18
C621	VGND#7	D#1	2.24148e-18
C622	VPWR	VPWR#7	1.00286e-16
C623	VPWR#7	VNB	6.03871e-17
C624	VGND#7	GATE#3	7.46402e-18
C625	VGND#7	D#2	1.10463e-19
C626	a_27_392##6	VPWR#7	2.12065e-17
C627	VGND#7	GATE	1.08315e-18
*
*
.ENDS sky130_fd_sc_hs__dlrtp_2
*
