* Extracted by Quantus, converted by sky130cad/quantus.py
*
*
*
*                       LINUX           Wed Nov 18 08:29:53 2026
*
*
*
*  PROGRAM  advgen
*
*  Name           : advgen - Quantus - (64-bit)
*  Version        : 25.1.0-p047
*  Build Date     : Thu Dec 11 23:20:30 PST 2025
*
*  HSPICE LIBRARY
*
*  OPERATING_TEMPERATURE 150
*  QRC_TECH_DIR <path>/tech
*
*
*
*
.SUBCKT sky130_fd_sc_hs__diode_2 VPB VNB VGND VPWR DIODE
*
*
*  caps2d version: 10
*
*
*       RESISTOR AND CAP/DIODE CARDS
*
Rf1	DIODE	DIODE#1	1.163829
Rf2	DIODE#1	DIODE	1.163829
Rf3	DIODE	DIODE#3	2.430066
Rf4	DIODE#1	DIODE#3	3.992251
Rf5	DIODE	DIODE#4	1.163829
Rf6	DIODE#4	DIODE	1.163829
Rf7	DIODE#3	DIODE#4	2.430066
Rf8	DIODE	DIODE#5	1.163829
Rf9	DIODE#5	DIODE	1.163829
Rf10	DIODE#4	DIODE#5	6.422318
Rf11	DIODE	DIODE#6	1.163829
Rf12	DIODE#6	DIODE	1.163829
Rf13	DIODE#5	DIODE#6	6.422318
Rf14	DIODE	DIODE#7	1.163829
Rf15	DIODE#7	DIODE	1.163829
Rf16	DIODE#6	DIODE#7	6.422318
Rf17	DIODE	DIODE#8	1.163829
Rf18	DIODE#8	DIODE	1.163829
Rf19	DIODE#7	DIODE#8	6.422318
Rf20	DIODE	DIODE#9	1.163829
Rf21	DIODE#9	DIODE	1.163829
Rf22	DIODE#8	DIODE#9	6.422318
*
*       CAPACITOR CARDS
*
*
C1	DIODE	VNB	4.09227e-17
C2	DIODE#4	VNB	8.57424e-17
C3	DIODE#5	VNB	3.73846e-17
C4	DIODE#7	VNB	4.09227e-17
C5	DIODE#8	VNB	4.09227e-17
C6	DIODE#9	VNB	6.47067e-17
C7	DIODE#5	DIODE#3	4.05795e-18
C8	VGND	VNB	1.71004e-16
C9	VPWR	VNB	1.68738e-16
C10	VGND	DIODE#4	1.10528e-16
C11	DIODE#4	DIODE#3	2.30632e-17
C12	VPWR	DIODE#9	1.10528e-16
*
*
.ENDS sky130_fd_sc_hs__diode_2
*
