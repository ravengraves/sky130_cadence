* Extracted by Quantus, converted by sky130cad/quantus.py
*
*
*
*                       LINUX           Wed Nov 18 08:46:27 2026
*
*
*
*  PROGRAM  advgen
*
*  Name           : advgen - Quantus - (64-bit)
*  Version        : 25.1.0-p047
*  Build Date     : Thu Dec 11 23:20:30 PST 2025
*
*  HSPICE LIBRARY
*
*  OPERATING_TEMPERATURE 150
*  QRC_TECH_DIR <path>/tech
*
*
*

*
.SUBCKT sky130_fd_sc_hs__nand3b_2 VPB VNB VGND VPWR Y B C A_N
*
*
*  caps2d version: 10
*
*
*       TRANSISTOR CARDS
*
*
XM9 a_27_94##10 A_N#3 VGND#6 VNB sky130_fd_pr__nfet_01v8_lvt l=0.15 w=0.64 ad=0.1728 as=0.233 pd=1.82 ps=2.13
XM5 VGND#6 C#4 a_206_74##2 VNB sky130_fd_pr__nfet_01v8_lvt l=0.15 w=0.74 ad=0.233 as=0.2072 pd=2.13 ps=2.04
XM10 a_206_74##2 C#5 VGND#5 VNB sky130_fd_pr__nfet_01v8_lvt l=0.15 w=0.74 ad=0.2072 as=0.19445 pd=2.04 ps=2.05
XM0 Y#4 a_27_94##7 a_403_54##4 VNB sky130_fd_pr__nfet_01v8_lvt l=0.15 w=0.74 ad=0.2072 as=0.24845 pd=2.04 ps=2.6
XM11 a_403_54##2 a_27_94# Y#4 VNB sky130_fd_pr__nfet_01v8_lvt l=0.15 w=0.74 ad=0.3632 as=0.2072 pd=2.76 ps=2.04
XM4 a_206_74# B#7 a_403_54##2 VNB sky130_fd_pr__nfet_01v8_lvt l=0.15 w=0.74 ad=0.2072 as=0.3632 pd=2.04 ps=2.76
XM2 a_403_54# B#1 a_206_74# VNB sky130_fd_pr__nfet_01v8_lvt l=0.15 w=0.74 ad=0.1998 as=0.2072 pd=2.02 ps=2.04
XM13 a_27_94##11 A_N#1 VPWR#7 VPB sky130_fd_pr__pfet_01v8 l=0.15 w=1 ad=0.295 as=0.3868 pd=2.59 ps=2.95
XM1 Y#3 C#6 VPWR#7 VPB sky130_fd_pr__pfet_01v8 l=0.15 w=1.12 ad=0.3864 as=0.3868 pd=2.93 ps=2.95
XM7 VPWR#5 C#1 Y#3 VPB sky130_fd_pr__pfet_01v8 l=0.15 w=1.12 ad=0.392 as=0.3864 pd=2.94 ps=2.93
XM3 VPWR#5 a_27_94##5 Y#5 VPB sky130_fd_pr__pfet_01v8 l=0.15 w=1.12 ad=0.392 as=0.336 pd=2.94 ps=2.84
XM12 Y#5 a_27_94##6 VPWR#4 VPB sky130_fd_pr__pfet_01v8 l=0.15 w=1.12 ad=0.336 as=0.5712 pd=2.84 ps=3.26
XM8 VPWR#4 B#5 Y#1 VPB sky130_fd_pr__pfet_01v8 l=0.15 w=1.12 ad=0.5712 as=0.4032 pd=3.26 ps=2.96
XM6 Y#1 B#6 VPWR#1 VPB sky130_fd_pr__pfet_01v8 l=0.15 w=1.12 ad=0.4032 as=0.3304 pd=2.96 ps=2.83
*
*
*       RESISTOR AND CAP/DIODE CARDS
*
Rg1	A_N#1	A_N#2	465.340149
Rg2	A_N#2	A_N#3	405.317871
Rg3	C#1	C#2	457.698181
Rg4	C#2	C#3	29.283751
Rg5	C#3	C#4	385.845764
Rg6	C#2	C#5	300.089050
Rg7	C#3	C#6	421.875183
Rg8	a_27_94#	a_27_94##2	361.756409
Rg9	a_27_94##2	a_27_94##3	44.946861
Rg10	a_27_94##3	a_27_94##4	39.606800
Rg11	a_27_94##4	a_27_94##5	444.624207
Rg12	a_27_94##2	a_27_94##6	416.819550
Rg13	a_27_94##3	a_27_94##7	295.292725
Rg14	B#1	B#2	322.141815
Rg15	B#2	B#3	28.628225
Rg16	B#3	B#4	25.808643
Rg17	B#4	B#5	459.650940
Rg18	B#2	B#6	449.230865
Rg19	B#4	B#7	321.599609
Rf1	A_N#4	A_N	0.772649
Rf2	A_N#2	A_N#6	161.005447
Rf3	A_N#4	A_N#6	5.708254
Rf4	C#7	C	1.409262
Rf5	C#2	C#9	81.525665
Rf6	C#7	C#9	9.119370
Rf7	C#10	C	1.409262
Rf8	C#9	C#10	8.747149
Rf9	a_27_94##4	a_27_94##9	270.177612
Rf10	a_27_94##9	a_27_94##10	64.316849
Rf11	a_27_94##9	a_27_94##11	92.791382
Rf12	Y#1	Y#2	82.739563
Rf13	Y#2	Y#3	92.100349
Rf14	Y#2	Y	16.486036
Rf15	Y	Y#4	41.232979
Rf16	Y#2	Y#5	26.454836
Rf17	a_206_74#	a_206_74##2	164.578812
Rf18	B	B#8	0.611206
Rf19	B#8	B	14.057726
Rf20	a_403_54#	a_403_54##3	92.306343
Rf21	a_403_54##3	a_403_54##4	87.319992
Rf22	a_403_54##2	a_403_54##3	15.000000
Rf23	VPWR#1	VPWR#2	112.880684
Rf24	VPWR#2	VPWR#3	58.050613
Rf25	VPWR#2	VPWR#4	32.420494
Rf26	VPWR#3	VPWR#5	35.918396
Rf27	VPWR#3	VPWR#6	90.838676
Rf28	VPWR#6	VPWR#7	39.332726
Rf30	VGND#1	VGND#2	40.883747
Rf31	VGND#2	VGND#3	67.549004
Rf33	VGND#2	VGND#5	31.161278
Rf34	VGND#3	VGND#6	43.501350
Rf38	B#3	B#8	80.116402
Re1	VPWR#3	VPWR	1.091357
Re2	VGND	VGND#1	1.091398
*
*       CAPACITOR CARDS
*
*
C1	Y#2	VPWR#2	3.3379e-19
C2	a_403_54#	B#4	2.8162e-19
C3	a_206_74#	B#4	5.27241e-18
C4	a_27_94##3	B#4	1.79019e-17
C5	a_206_74#	a_27_94##3	4.69404e-19
C6	a_403_54##2	B#4	1.05975e-18
C7	a_403_54##2	a_27_94##3	1.67015e-19
C8	Y#4	B#4	6.87724e-19
C9	Y#4	a_27_94##3	4.9005e-18
C10	a_27_94##9	C#9	1.4339e-17
C11	Y#4	C#3	1.12057e-19
C12	a_403_54##4	a_27_94##3	1.34962e-19
C13	a_27_94##9	A_N#6	2.97177e-17
C14	C#3	a_27_94##3	6.50417e-19
C15	VGND#2	a_206_74##2	9.62679e-18
C16	a_206_74#	Y#2	3.40326e-18
C17	C#3	VGND#5	2.7179e-18
C18	VPWR#3	a_27_94##3	4.16466e-20
C19	C#3	a_206_74##2	9.40006e-18
C20	VPWR#3	C#3	2.83113e-20
C21	VPWR#2	VPWR#1	8.0943e-19
C22	VGND#1	B#4	1.22821e-19
C23	a_27_94##9	a_206_74##2	3.77582e-17
C24	VGND#1	a_27_94##3	5.74338e-20
C25	Y#1	VPWR#2	1.39342e-17
C26	a_27_94##9	VGND#6	2.7683e-17
C27	VPWR#1	B#4	9.28026e-21
C28	a_403_54#	a_206_74#	6.40642e-17
C29	Y#5	VPWR#2	2.36423e-18
C30	Y#2	Y#1	8.86386e-19
C31	a_206_74#	a_403_54##2	8.38953e-17
C32	Y#2	VPWR#4	3.49501e-17
C33	a_206_74#	Y#4	5.49834e-17
C34	a_403_54#	a_403_54##4	4.56868e-21
C35	B#4	Y#1	4.18984e-18
C36	a_27_94##4	a_27_94##3	7.84672e-18
C37	Y#2	Y#5	9.97376e-19
C38	a_403_54##2	Y#4	5.12161e-19
C39	a_27_94##4	C#3	4.46933e-17
C40	a_206_74#	a_403_54##4	4.25765e-17
C41	Y#2	VPWR#5	2.26611e-17
C42	a_27_94##10	A_N#6	1.52383e-17
C43	VGND#2	C#3	1.10596e-19
C44	Y#3	Y#2	9.84164e-19
C45	a_403_54##4	Y#4	5.15846e-19
C46	a_206_74##2	a_206_74#	2.4106e-18
C47	a_206_74##2	a_403_54##2	1.06313e-20
C48	a_27_94##9	VPWR#7	3.97483e-18
C49	a_27_94##3	VPWR#4	1.26318e-18
C50	VGND#5	a_403_54##4	1.79044e-17
C51	a_403_54#	VPWR#1	3.27709e-19
C52	a_27_94##11	Y#2	6.22931e-19
C53	a_206_74##2	a_403_54##4	1.1837e-17
C54	a_27_94##9	a_27_94##11	2.72195e-18
C55	C#9	Y#3	2.26804e-17
C56	VPWR#2	B#4	5.17216e-20
C57	a_206_74##2	VGND#5	6.05873e-17
C58	A_N#2	C#3	1.06827e-17
C59	VGND#2	C#5	1.21411e-18
C60	VGND#6	a_206_74##2	4.53624e-17
C61	a_27_94##10	a_206_74##2	9.05769e-19
C62	a_27_94##10	VGND#6	3.96164e-17
C63	A_N#6	a_27_94##11	3.2193e-17
C64	a_27_94##9	C#5	7.43583e-18
C65	a_27_94##9	C#4	2.25036e-17
C66	a_403_54#	B#1	2.72418e-17
C67	Y#1	VPWR#1	9.00885e-17
C68	a_206_74#	B#1	3.32019e-17
C69	a_27_94##9	A_N#3	6.03119e-18
C70	a_403_54#	B#7	8.18037e-19
C71	VPWR#4	VPWR#1	1.38032e-18
C72	a_206_74#	B#7	4.34861e-17
C73	Y#1	VPWR#4	4.57788e-17
C74	VPWR#2	B#5	5.68243e-18
C75	a_403_54#	a_27_94#	4.91016e-19
C76	C#3	Y#3	3.93193e-18
C77	Y#4	B#1	5.82029e-19
C78	a_403_54##2	B#7	2.54539e-17
C79	a_206_74#	a_27_94#	1.93334e-17
C80	Y#5	Y#1	1.29715e-18
C81	Y#2	B#6	4.18862e-19
C82	Y#4	B#7	9.49996e-19
C83	a_403_54#	a_27_94##7	3.25142e-19
C84	VPWR#2	a_27_94##6	5.68243e-18
C85	a_403_54##2	a_27_94#	1.77928e-17
C86	VGND#5	B#1	2.02576e-19
C87	Y#5	VPWR#4	5.18219e-17
C88	a_206_74#	a_27_94##7	1.9968e-17
C89	Y#4	a_27_94#	2.50493e-17
C90	Y#2	B#5	9.51516e-19
C91	VPWR#5	VPWR#4	1.61955e-18
C92	VGND#5	B#7	2.43928e-19
C93	a_206_74#	C#5	4.31357e-19
C94	Y#4	a_27_94##7	1.98188e-17
C95	a_206_74##2	B#7	3.48661e-19
C96	VPWR#7	C#3	1.77891e-19
C97	VPWR#5	Y#5	5.29637e-17
C98	VGND#5	a_27_94#	3.93511e-19
C99	Y#2	a_27_94##6	2.20003e-17
C100	a_403_54##4	a_27_94##7	2.73086e-17
C101	a_206_74#	C#4	2.2468e-19
C102	Y#3	Y#5	1.44024e-18
C103	Y#4	C#5	7.54472e-19
C104	a_206_74##2	a_27_94#	4.31477e-19
C105	VGND#5	a_27_94##7	1.50305e-18
C106	Y#2	a_27_94##5	1.99416e-17
C107	a_403_54##4	C#5	1.0136e-18
C108	Y#3	VPWR#5	7.50939e-17
C109	a_206_74##2	a_27_94##7	2.36334e-18
C110	Y#4	C#4	2.21403e-19
C111	VGND#5	C#5	3.68079e-17
C112	VPWR#7	VPWR#5	1.15886e-18
C113	Y#2	C#1	4.26838e-19
C114	a_206_74##2	C#5	3.32392e-17
C115	Y#4	A_N#3	2.45466e-19
C116	Y#2	a_27_94##3	5.26097e-18
C117	VGND#5	C#4	1.94608e-18
C118	a_27_94##11	C#3	1.36618e-19
C119	a_27_94##10	a_27_94##7	4.19843e-19
C120	VPWR#7	Y#3	6.20691e-17
C121	a_206_74##2	C#4	3.2985e-17
C122	a_27_94##11	Y#3	1.37843e-17
C123	Y#2	C#6	9.24901e-20
C124	a_27_94##10	C#5	5.9512e-19
C125	C#4	VGND#6	1.44331e-17
C126	a_206_74##2	A_N#3	2.19953e-18
C127	a_27_94##11	VPWR#7	6.40587e-17
C128	a_27_94##10	C#4	8.06704e-19
C129	VGND#6	A_N#3	3.02423e-17
C130	Y#2	A_N#1	8.9232e-20
C131	a_27_94##10	A_N#3	2.86149e-17
C132	a_27_94##9	a_27_94##3	8.4139e-21
C133	VPWR#3	VPWR#2	4.45629e-17
C134	VGND#1	VGND#2	3.19432e-17
C135	C	a_27_94##3	6.37853e-20
C136	C	C#3	2.03181e-17
C137	B#7	B#1	3.74857e-17
C138	Y#2	VPWR#3	3.13618e-19
C139	VPWR#1	B#6	5.18133e-17
C140	a_27_94##9	C#3	1.30476e-17
C141	B#6	Y#1	2.4416e-17
C142	a_27_94#	B#7	2.19923e-17
C143	VPWR#1	B#5	3.10644e-18
C144	VPWR#7	C#4	1.12785e-18
C145	VPWR#4	B#6	1.17046e-18
C146	B	B#4	4.38792e-17
C147	Y#1	B#5	7.48693e-17
C148	B	a_27_94##3	8.51158e-18
C149	a_27_94#	B#4	1.61592e-18
C150	VPWR#1	a_27_94##6	2.56286e-19
C151	B#5	VPWR#4	3.10712e-17
C152	a_27_94##7	a_27_94#	3.7379e-17
C153	Y#1	a_27_94##6	1.53417e-18
C154	Y#5	B#5	3.20563e-19
C155	a_27_94##6	VPWR#4	3.97904e-17
C156	a_27_94##3	a_27_94#	1.8956e-18
C157	VPWR#5	B#5	2.96361e-19
C158	Y#5	a_27_94##6	5.04819e-17
C159	a_27_94##4	Y#2	2.32484e-17
C160	C#5	a_27_94##7	3.72376e-18
C161	VPWR#4	a_27_94##5	1.10784e-18
C162	a_27_94##9	a_27_94##4	1.72301e-18
C163	VPWR#5	a_27_94##6	2.17246e-18
C164	a_27_94##5	Y#5	1.55305e-17
C165	Y#3	a_27_94##6	2.06633e-19
C166	Y	B#4	6.40899e-19
C167	VGND#1	a_403_54#	3.58333e-17
C168	VPWR#5	a_27_94##5	5.62283e-17
C169	Y	a_27_94##3	1.78419e-17
C170	C#4	C#5	3.66103e-17
C171	Y#5	C#1	3.84815e-19
C172	Y	C#3	5.33826e-20
C173	a_27_94##4	C#9	4.72625e-18
C174	Y#3	a_27_94##5	1.56948e-18
C175	VGND#1	a_403_54##2	4.91124e-17
C176	a_27_94##11	a_27_94##6	4.62869e-20
C177	C#1	VPWR#5	2.66483e-17
C178	VPWR#7	a_27_94##5	2.42545e-19
C179	Y#3	C#1	7.42752e-17
C180	A_N#3	C#4	3.43605e-17
C181	Y#2	A_N#2	9.83694e-20
C182	VGND#1	a_403_54##4	3.4263e-17
C183	a_27_94##11	a_27_94##5	8.00098e-20
C184	VPWR#5	C#6	7.23591e-19
C185	a_27_94##9	A_N#2	1.12114e-17
C186	VPWR#7	C#1	1.16157e-18
C187	Y#3	C#6	5.59987e-17
C188	VGND#1	a_206_74##2	2.30881e-18
C189	a_27_94##11	C#1	1.48547e-19
C190	VPWR#5	A_N#1	3.97426e-19
C191	VPWR#3	VPWR#1	3.13035e-17
C192	a_206_74#	a_27_94##4	1.08639e-17
C193	C#6	VPWR#7	2.47543e-17
C194	Y#3	A_N#1	3.47709e-18
C195	C#3	a_27_94##7	2.9366e-18
C196	a_27_94##11	C#6	7.63331e-18
C197	a_27_94##4	Y#4	2.22003e-17
C198	A_N#1	VPWR#7	3.3751e-17
C199	a_27_94##4	a_403_54##4	3.48402e-18
C200	Y#5	VPWR#3	1.13823e-17
C201	A_N#6	A_N#2	1.12771e-17
C202	a_27_94##11	A_N#1	5.37515e-17
C203	a_27_94##4	VGND#5	9.97341e-19
C204	a_206_74##2	a_27_94##4	5.98531e-17
C205	Y#3	VPWR#3	1.00898e-17
C206	B#5	B#6	3.59603e-17
C207	a_27_94##6	B#5	2.19931e-17
C208	a_27_94##4	Y#5	6.15446e-19
C209	VGND#6	A_N#2	9.05556e-19
C210	VGND#1	B#1	3.59493e-18
C211	a_27_94##4	VPWR#5	7.57015e-19
C212	a_27_94##10	A_N#2	3.59471e-18
C213	VGND	C#3	3.95858e-19
C214	VGND#1	B#7	3.59493e-18
C215	a_27_94##4	Y#3	2.81269e-18
C216	a_27_94##5	a_27_94##6	4.65623e-17
C217	VGND#1	a_27_94#	3.59493e-18
C218	VGND#1	a_27_94##7	3.59493e-18
C219	C#1	a_27_94##5	3.73206e-17
C220	a_27_94##4	a_27_94#	8.78932e-20
C221	C#9	C#3	9.84643e-18
C222	VGND#1	A_N#3	3.49357e-20
C223	a_27_94##4	a_27_94##7	2.55967e-18
C224	C#6	C#1	3.68235e-17
C225	a_27_94##11	A_N#2	8.54798e-18
C226	a_27_94##9	C	4.84945e-17
C227	B#4	VNB	5.33163e-17
C228	a_27_94##3	VNB	2.75031e-17
C229	A_N#1	C#6	3.75193e-17
C230	C#3	VNB	5.99691e-17
C231	VPWR#3	a_27_94##5	1.83922e-18
C232	VPWR#3	C#1	2.57866e-18
C233	B	Y#2	1.46732e-17
C234	A_N#2	C#4	4.79671e-18
C235	a_27_94##10	A_N	1.51075e-17
C236	a_403_54#	B	3.32337e-17
C237	B	a_206_74#	8.07752e-17
C238	B	a_403_54##2	5.27352e-19
C239	Y#4	B	7.1465e-18
C240	VPWR	VPWR#2	2.69252e-17
C241	A_N	a_27_94##11	8.41177e-18
C242	VPWR	Y#2	4.80277e-18
C243	A_N#2	C#6	5.24842e-18
C244	C	Y#3	2.44902e-17
C245	B	VPWR#1	3.90803e-17
C246	B	Y#1	4.5676e-17
C247	a_27_94##11	C	1.07566e-17
C248	VGND#1	a_27_94##4	1.31189e-19
C249	VPWR	C#9	9.65954e-19
C250	VGND	VGND#2	1.84783e-17
C251	VPWR	A_N#6	1.22298e-18
C252	VGND	a_27_94##9	6.35007e-18
C253	VGND	C#9	9.37446e-19
C254	a_27_94##4	A_N#2	5.03813e-20
C255	VGND	A_N#6	1.32255e-18
C256	a_27_94##11	Y	2.39255e-19
C257	VPWR	VPWR#1	4.50755e-17
C258	VPWR	Y#1	1.78602e-17
C259	VGND	a_403_54#	2.03607e-17
C260	VGND#2	VNB	2.53505e-17
C261	VPWR	VPWR#4	2.15062e-17
C262	VGND	a_206_74#	2.15485e-17
C263	VGND	a_403_54##2	2.36439e-17
C264	VPWR	Y#5	1.4791e-17
C265	C	a_27_94##6	2.6857e-19
C266	VPWR#2	VNB	3.35666e-17
C267	VGND	Y#4	4.45913e-18
C268	VPWR	VPWR#5	2.1886e-17
C269	VGND	a_403_54##4	1.80298e-17
C270	C	a_27_94##5	1.10581e-18
C271	VPWR	Y#3	1.81803e-17
C272	B	B#6	3.53009e-18
C273	VGND	VGND#5	1.63686e-17
C274	Y#2	VNB	6.3026e-19
C275	VPWR	VPWR#7	1.24144e-17
C276	VGND	a_206_74##2	2.26756e-17
C277	C	C#1	1.96867e-18
C278	a_27_94##9	VNB	6.42738e-18
C279	B	B#5	2.04969e-18
C280	VPWR	a_27_94##11	1.83668e-17
C281	VGND	a_27_94##10	1.32464e-17
C282	C	C#6	5.04977e-18
C283	B	a_27_94##6	4.78766e-19
C284	C#9	VNB	1.81719e-18
C285	A_N#6	VNB	1.36901e-18
C286	a_403_54#	VNB	4.638e-17
C287	Y	B#5	9.74414e-21
C288	a_206_74#	VNB	4.30105e-20
C289	a_403_54##2	VNB	4.71987e-18
C290	Y	a_27_94##6	1.3937e-18
C291	Y#4	VNB	1.06915e-18
C292	a_403_54##4	VNB	4.75931e-18
C293	Y	a_27_94##5	1.12295e-18
C294	VGND#5	VNB	6.35232e-18
C295	a_206_74##2	VNB	9.70137e-18
C296	Y	C#1	2.21959e-19
C297	VGND#6	VNB	2.48708e-18
C298	VPWR	B#6	7.4275e-19
C299	a_27_94##10	VNB	4.75809e-17
C300	VPWR	B#5	1.49173e-19
C301	VPWR#1	VNB	7.81381e-17
C302	a_27_94##4	C	4.47596e-17
C303	Y#1	VNB	2.76915e-18
C304	A_N	A_N#2	9.95299e-18
C305	VPWR	a_27_94##6	1.04349e-19
C306	VGND	C#5	5.07485e-19
C307	VPWR#4	VNB	4.15373e-18
C308	Y#5	VNB	2.41966e-18
C309	VGND	C#4	2.86786e-18
C310	VPWR	a_27_94##5	1.10974e-18
C311	VPWR#5	VNB	1.08735e-18
C312	VGND	A_N#3	3.90274e-18
C313	VPWR	C#1	1.53888e-19
C314	Y#3	VNB	2.46884e-18
C315	C	A_N#2	2.6954e-18
C316	VPWR#7	VNB	2.95184e-18
C317	VPWR	C#6	2.12338e-18
C318	a_27_94##11	VNB	5.0768e-17
C319	B#1	VNB	2.82103e-17
C320	VPWR	A_N#1	1.72709e-18
C321	B#7	VNB	2.48377e-17
C322	a_27_94#	VNB	2.73392e-17
C323	a_27_94##7	VNB	2.70535e-17
C324	a_27_94##4	Y	2.359e-17
C325	VPWR	VPWR#3	2.57269e-17
C326	C#5	VNB	2.45523e-17
C327	C#4	VNB	3.55155e-17
C328	A_N#3	VNB	4.10993e-17
C329	Y	A_N#2	7.76558e-20
C330	B#6	VNB	3.59754e-17
C331	VPWR	a_27_94##4	2.5636e-18
C332	B#5	VNB	3.52244e-17
C333	a_27_94##6	VNB	3.67389e-17
C334	a_27_94##5	VNB	3.16865e-17
C335	VGND	VGND#1	5.56901e-17
C336	VPWR	A_N#2	1.35097e-18
C337	C#1	VNB	2.99068e-17
C338	C#6	VNB	3.88434e-17
C339	VGND	a_27_94##4	6.40024e-18
C340	A_N#1	VNB	4.33801e-17
C341	VPWR#3	VNB	2.18904e-16
C342	VGND#1	VNB	2.7192e-16
C343	a_27_94##4	VNB	2.38818e-17
C344	C	Y	2.63685e-18
C345	VPWR	A_N	3.74333e-18
C346	A_N#2	VNB	6.91797e-17
C347	Y	B	2.77228e-17
C348	VPWR	C	4.56094e-18
C349	VGND	A_N	1.72764e-18
C350	VPWR	B	7.76608e-18
C351	VGND	C	2.95536e-18
C352	VGND	B	7.50415e-18
C353	A_N	VNB	2.19884e-17
C354	C	VNB	2.92295e-18
C355	B	VNB	3.24844e-17
C356	Y	VNB	7.60096e-19
C357	VPWR	VNB	6.24262e-17
C358	VGND	VNB	7.78665e-17
C359	VGND#3	A_N#3	6.8188e-18
C360	VGND#3	a_206_74##2	9.42715e-18
C361	VPWR#6	VPWR#5	2.8191e-19
C362	a_27_94##11	VPWR#6	2.10971e-17
C363	VGND#3	a_27_94##10	1.31793e-17
C364	VGND#3	a_27_94##9	6.73531e-19
C365	VGND#3	VNB	4.86518e-17
C366	VGND#3	C#3	7.97166e-20
C367	VPWR#6	A_N#2	2.75675e-19
C368	VGND#3	C#4	1.00691e-17
C369	VGND#1	VGND#3	4.91598e-17
C370	VGND#3	VGND#5	1.38964e-18
C371	C	VPWR#6	7.5051e-19
C372	VPWR#6	C#3	2.45002e-20
C373	VPWR#6	A_N#1	3.2884e-18
C374	VPWR	VPWR#6	4.50238e-17
C375	VGND#3	VGND#2	9.11291e-19
C376	VGND	VGND#3	5.35639e-17
C377	A_N	VPWR#6	9.73414e-19
C378	VGND#3	A_N#2	7.92589e-20
C379	Y#3	VPWR#6	9.23085e-18
C380	VPWR#6	C#6	7.77731e-18
C381	VGND#3	C#5	1.14752e-18
C382	VPWR#3	VPWR#6	6.2229e-17
C383	VPWR#6	VNB	5.57102e-17
*
*
.ENDS sky130_fd_sc_hs__nand3b_2
*
