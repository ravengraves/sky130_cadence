* Extracted by Quantus, converted by sky130cad/quantus.py
*
*
*
*                       LINUX           Wed Nov 18 08:08:25 2026
*
*
*
*  PROGRAM  advgen
*
*  Name           : advgen - Quantus - (64-bit)
*  Version        : 25.1.0-p047
*  Build Date     : Thu Dec 11 23:20:30 PST 2025
*
*  HSPICE LIBRARY
*
*  OPERATING_TEMPERATURE 150
*  QRC_TECH_DIR <path>/tech
*
*
*

*
.SUBCKT sky130_fd_sc_hs__a222oi_2 VPB VNB VGND VPWR Y C2 C1 B2 B1 A1 A2
*
*
*  caps2d version: 10
*
*
*       TRANSISTOR CARDS
*
*
XM1 VGND#6 C2#1 a_137_74##2 VNB sky130_fd_pr__nfet_01v8_lvt l=0.15 w=0.64 ad=0.264125 as=0.1792 pd=2.13 ps=1.84
XM18 Y#12 C1#5 a_137_74##2 VNB sky130_fd_pr__nfet_01v8_lvt l=0.15 w=0.64 ad=0.1792 as=0.1792 pd=1.84 ps=1.84
XM21 a_137_74# C1#1 Y#12 VNB sky130_fd_pr__nfet_01v8_lvt l=0.15 w=0.64 ad=0.1792 as=0.1792 pd=1.84 ps=1.84
XM5 a_137_74# C2#4 VGND#9 VNB sky130_fd_pr__nfet_01v8_lvt l=0.15 w=0.64 ad=0.1792 as=0.1824 pd=1.84 ps=1.85
XM22 a_593_74##2 B1#3 Y#9 VNB sky130_fd_pr__nfet_01v8_lvt l=0.15 w=0.64 ad=0.1792 as=0.1824 pd=1.84 ps=1.85
XM16 VGND#8 B2#5 a_593_74##2 VNB sky130_fd_pr__nfet_01v8_lvt l=0.15 w=0.64 ad=0.3865 as=0.1792 pd=2.66 ps=1.84
XM17 a_593_74# B2#1 VGND#8 VNB sky130_fd_pr__nfet_01v8_lvt l=0.15 w=0.64 ad=0.1792 as=0.3865 pd=1.84 ps=2.66
XM19 Y#8 B1#4 a_593_74# VNB sky130_fd_pr__nfet_01v8_lvt l=0.15 w=0.64 ad=0.1792 as=0.1792 pd=1.84 ps=1.84
XM8 a_981_74##2 A1#3 Y#8 VNB sky130_fd_pr__nfet_01v8_lvt l=0.15 w=0.64 ad=0.224 as=0.1792 pd=1.98 ps=1.84
XM11 a_981_74##2 A2#5 VGND#7 VNB sky130_fd_pr__nfet_01v8_lvt l=0.15 w=0.64 ad=0.224 as=0.1856 pd=1.98 ps=1.86
XM2 VGND#7 A2#1 a_981_74# VNB sky130_fd_pr__nfet_01v8_lvt l=0.15 w=0.64 ad=0.1856 as=0.1792 pd=1.86 ps=1.84
XM7 Y#1 A1#6 a_981_74# VNB sky130_fd_pr__nfet_01v8_lvt l=0.15 w=0.64 ad=0.1824 as=0.1792 pd=1.85 ps=1.84
XM10 Y#6 C2#3 a_116_392##3 VPB sky130_fd_pr__pfet_01v8 l=0.15 w=1 ad=0.295 as=0.3 pd=2.59 ps=2.6
XM20 Y#11 C1#6 a_116_392##3 VPB sky130_fd_pr__pfet_01v8 l=0.15 w=1 ad=0.33 as=0.3 pd=2.66 ps=2.6
XM23 a_116_392# C1#4 Y#11 VPB sky130_fd_pr__pfet_01v8 l=0.15 w=1 ad=0.3 as=0.33 pd=2.6 ps=2.66
XM12 a_116_392# C2#6 Y#10 VPB sky130_fd_pr__pfet_01v8 l=0.15 w=1 ad=0.3 as=0.345 pd=2.6 ps=2.69
XM6 a_515_392##8 B1#1 a_116_392##6 VPB sky130_fd_pr__pfet_01v8 l=0.15 w=1 ad=0.295 as=0.3 pd=2.59 ps=2.6
XM9 a_515_392##6 B2#7 a_116_392##6 VPB sky130_fd_pr__pfet_01v8 l=0.15 w=1 ad=0.3 as=0.3 pd=2.6 ps=2.6
XM15 a_116_392##4 B2#6 a_515_392##6 VPB sky130_fd_pr__pfet_01v8 l=0.15 w=1 ad=0.39 as=0.3 pd=2.78 ps=2.6
XM13 a_116_392##4 B1#6 a_515_392##3 VPB sky130_fd_pr__pfet_01v8 l=0.15 w=1 ad=0.39 as=0.3 pd=2.78 ps=2.6
XM4 VPWR#6 A1#1 a_515_392##3 VPB sky130_fd_pr__pfet_01v8 l=0.15 w=1 ad=0.33 as=0.3 pd=2.66 ps=2.6
XM14 a_515_392# A2#6 VPWR#6 VPB sky130_fd_pr__pfet_01v8 l=0.15 w=1 ad=0.3 as=0.33 pd=2.6 ps=2.66
XM0 VPWR#5 A2#4 a_515_392# VPB sky130_fd_pr__pfet_01v8 l=0.15 w=1 ad=0.3 as=0.3 pd=2.6 ps=2.6
XM3 a_515_392##5 A1#4 VPWR#5 VPB sky130_fd_pr__pfet_01v8 l=0.15 w=1 ad=0.295 as=0.3 pd=2.59 ps=2.6
*
*
*       RESISTOR AND CAP/DIODE CARDS
*
Rg1	C2#1	C2#2	330.196350
Rg2	C2#2	C2#3	550.720947
Rg3	C1#1	C1#2	318.360809
Rg4	C1#2	C1#3	34.534397
Rg5	C1#2	C1#4	548.239563
Rg6	C1#3	C1#5	331.921783
Rg7	C1#3	C1#6	631.204407
Rg8	C2#4	C2#5	330.870117
Rg9	C2#5	C2#6	450.032837
Rg10	B1#1	B1#2	397.001862
Rg11	B1#2	B1#3	476.890656
Rg12	B2#1	B2#2	362.711029
Rg13	B2#2	B2#3	36.503117
Rg14	B2#3	B2#4	16.832588
Rg15	B2#4	B2#5	369.680267
Rg16	B2#2	B2#6	507.445770
Rg17	B2#4	B2#7	508.285065
Rg18	B1#4	B1#5	468.619049
Rg19	B1#5	B1#6	409.090576
Rg20	A1#1	A1#2	409.090576
Rg21	A1#2	A1#3	468.619049
Rg22	A2#1	A2#2	483.635010
Rg23	A2#2	A2#3	40.440567
Rg24	A2#2	A2#4	424.106537
Rg25	A2#3	A2#5	488.868927
Rg26	A2#3	A2#6	426.054413
Rg27	A1#4	A1#5	409.090576
Rg28	A1#5	A1#6	468.619049
Rf1	C1	C1#3	161.610657
Rf2	a_137_74#	a_137_74##2	81.317993
Rf3	C2#5	C2#8	191.129791
Rf4	C2#8	C2	1.119708
Rf5	B2	B2#3	169.680954
Rf6	a_593_74#	a_593_74##2	95.598289
Rf7	a_116_392#	a_116_392##2	18.247265
Rf8	a_116_392##2	a_116_392##3	82.944786
Rf9	a_116_392##2	a_116_392##5	115.414215
Rf10	a_116_392##5	a_116_392##6	15.102172
Rf11	a_116_392##4	a_116_392##5	15.000000
Rf12	B1#5	B1	279.145142
Rf13	B1	B1#2	171.367172
Rf14	A2#3	A2#8	161.216980
Rf15	A2#9	A2	0.984182
Rf16	A2#8	A2#9	1.968364
Rf17	a_981_74#	a_981_74##2	90.732346
Rf18	A1#5	A1	171.760849
Rf19	A1	A1#2	278.467773
Rf20	Y#1	Y#2	166.699661
Rf21	Y#2	Y#3	124.775551
Rf22	Y#3	Y#4	78.747757
Rf23	Y#4	Y#5	63.046497
Rf24	Y#5	Y	66.755066
Rf25	Y	Y#7	2.529711
Rf26	Y#2	Y#8	22.755106
Rf27	Y#3	Y#9	19.884722
Rf28	Y#4	Y#10	15.952114
Rf29	Y#5	Y#11	15.170200
Rf30	Y	Y#12	167.432297
Rf31	Y#7	Y	14.488348
Rf32	Y#6	Y#7	5.000000
Rf33	a_515_392#	a_515_392##2	14.364655
Rf34	a_515_392##2	a_515_392##4	55.310020
Rf35	a_515_392##2	a_515_392##5	57.800014
Rf36	a_515_392##4	a_515_392##7	65.203857
Rf37	a_515_392##7	a_515_392##9	61.905823
Rf39	a_515_392##3	a_515_392##4	5.000000
Rf40	a_515_392##6	a_515_392##7	15.000000
Rf41	a_515_392##8	a_515_392##9	7.500000
Rf43	VPWR#2	VPWR#3	66.776268
Rf44	VPWR#3	VPWR#4	125.241196
Rf45	VPWR#2	VPWR#5	33.916985
Rf46	VPWR#3	VPWR#6	32.411579
Rf48	VGND#2	VGND#3	139.084137
Rf49	VGND#3	VGND#4	20.766855
Rf50	VGND#4	VGND#5	90.923332
Rf51	VGND#5	VGND#6	159.203339
Rf52	VGND#2	VGND#7	31.948624
Rf53	VGND#3	VGND#8	23.072811
Rf54	VGND#5	VGND#9	31.141060
Rf57	C2#2	C2#8	160.232803
Re1	VPWR#4	VPWR	0.701577
Re2	VGND	VGND#4	0.701602
*
*       CAPACITOR CARDS
*
*
C1	B1#2	B2#4	4.03083e-17
C2	a_116_392##6	VPWR#6	4.34965e-19
C3	a_981_74##2	B1#4	1.16867e-18
C4	VGND#7	B2#1	1.5247e-19
C5	a_515_392##6	a_116_392##4	6.54751e-19
C6	a_515_392##3	a_116_392##6	4.9387e-17
C7	Y#8	B1#4	2.88053e-17
C8	a_515_392##2	A1#1	4.227e-19
C9	B1#4	a_593_74#	1.27241e-17
C10	VGND#7	B2#5	1.19394e-19
C11	a_116_392##6	a_116_392##4	2.06231e-18
C12	a_515_392##8	a_515_392##3	1.72957e-18
C13	Y#2	Y#1	1.95246e-18
C14	Y#8	B2#1	1.33932e-18
C15	VGND#5	a_137_74##2	7.50669e-18
C16	a_515_392##2	B1#6	1.77647e-19
C17	a_515_392##6	a_116_392##6	7.3788e-17
C18	a_593_74#	B2#1	3.92939e-17
C19	Y#8	B2#5	2.51807e-19
C20	a_981_74#	Y#2	1.63377e-18
C21	B2#1	VGND#8	1.63599e-17
C22	a_593_74#	B2#5	5.56144e-19
C23	VGND#6	VGND#5	2.59241e-19
C24	a_593_74##2	B2#1	5.56144e-19
C25	Y#8	B1#3	1.18367e-19
C26	a_116_392##6	a_515_392##8	1.98967e-17
C27	B2#5	VGND#8	1.66492e-17
C28	a_593_74##2	B2#5	4.04028e-17
C29	VGND#9	B2#1	1.52959e-19
C30	Y#2	a_981_74##2	6.55974e-17
C31	a_116_392#	a_116_392##6	1.96948e-18
C32	B1#3	a_593_74##2	1.31442e-17
C33	Y#3	Y#8	9.82283e-19
C34	VGND#9	B2#5	4.97493e-19
C35	B1#3	Y#9	2.17368e-17
C36	Y#2	Y#8	7.23637e-19
C37	Y#4	B2#7	2.39693e-19
C38	VGND#9	B1#3	3.15678e-18
C39	Y#1	A2#8	1.12857e-17
C40	a_515_392##6	B2#4	1.01926e-18
C41	VGND#9	C2#4	4.91896e-17
C42	Y#2	a_593_74#	5.25934e-17
C43	Y#4	B1#1	3.34063e-18
C44	Y#12	B1#3	4.20047e-19
C45	Y#3	VGND#8	1.70777e-19
C46	C2#4	a_137_74#	1.42432e-17
C47	Y#11	a_116_392#	5.20682e-17
C48	VGND#9	C1#1	3.4084e-18
C49	Y#12	C2#4	2.05159e-18
C50	Y#2	VGND#8	1.66998e-19
C51	Y#4	C2#6	2.99385e-17
C52	a_116_392##3	a_116_392#	3.26056e-18
C53	a_137_74#	C1#1	3.76655e-17
C54	Y#3	a_593_74##2	8.75643e-17
C55	a_116_392##6	B2#4	5.34641e-19
C56	VGND#9	C1#5	3.34575e-19
C57	Y#12	C1#1	2.78067e-17
C58	Y#11	a_116_392##3	6.23712e-17
C59	VGND#6	C2#4	3.27425e-19
C60	a_137_74#	C1#5	9.3531e-19
C61	Y#4	C1#4	5.87968e-19
C62	VGND#9	C2#1	4.18527e-19
C63	Y#3	Y#9	2.51816e-18
C64	Y#12	C1#5	3.01848e-17
C65	VGND#9	Y#4	3.10424e-18
C66	VGND#6	C1#1	3.03246e-19
C67	a_137_74#	C2#1	6.41296e-19
C68	a_137_74##2	C1#5	3.20044e-17
C69	Y#4	C1#6	2.72057e-19
C70	Y#12	C2#1	2.35571e-17
C71	VGND#4	VGND#5	6.84469e-17
C72	VPWR#4	VPWR#3	5.49295e-17
C73	VGND#9	Y#3	5.1041e-17
C74	VGND#6	C1#5	4.91315e-18
C75	VGND#4	VGND#3	4.73607e-17
C76	a_137_74##2	C2#1	2.47232e-17
C77	C2#1	VGND#6	2.04004e-17
C78	Y#4	C2#3	4.28975e-20
C79	a_515_392##2	VPWR#3	7.0201e-18
C80	a_515_392##2	a_515_392##5	2.3763e-18
C81	a_116_392##2	C2#6	2.14952e-17
C82	a_515_392##3	VPWR#3	1.73413e-17
C83	A2#1	A1#6	4.05515e-17
C84	Y#12	Y#3	3.49402e-18
C85	a_515_392##2	VPWR#5	4.79515e-17
C86	a_116_392##2	C1#4	1.65574e-17
C87	a_515_392##5	A1#4	4.3804e-17
C88	VGND#5	Y#3	1.62611e-17
C89	A2#5	A2#1	3.84929e-17
C90	VPWR#5	A1#4	3.00474e-17
C91	VPWR#3	A2#3	2.23749e-20
C92	a_515_392##5	A2#4	3.16738e-18
C93	a_515_392##2	a_515_392#	1.46893e-17
C94	VPWR#5	A2#4	3.18252e-17
C95	a_515_392##5	A2#6	4.20876e-19
C96	A1#3	A2#5	2.98454e-17
C97	A2#4	a_515_392#	1.31551e-17
C98	VGND#4	Y#3	6.73266e-18
C99	a_515_392##3	A1#4	3.51975e-19
C100	VPWR#5	A2#6	1.39789e-18
C101	a_981_74#	Y#1	9.8093e-17
C102	VPWR#6	A2#4	2.01311e-18
C103	a_515_392##2	VPWR#6	4.95707e-17
C104	a_515_392##5	A1#1	1.37098e-19
C105	VGND#3	B1#5	6.34037e-20
C106	A2#6	a_515_392#	1.57915e-17
C107	a_515_392##2	A2#3	6.72999e-19
C108	VGND#3	Y#2	6.79775e-19
C109	a_515_392##3	A2#4	3.93598e-19
C110	a_116_392##6	VPWR#3	1.04409e-17
C111	B1#4	A1#3	4.11104e-17
C112	VPWR#6	A2#6	3.68459e-17
C113	VPWR#3	B1#5	1.90932e-20
C114	a_515_392##3	A2#6	2.17105e-18
C115	a_515_392##3	a_515_392##2	2.21891e-18
C116	A1#2	a_515_392##2	3.36303e-17
C117	VPWR#6	A1#1	3.37795e-17
C118	a_116_392##2	VPWR#4	8.97786e-17
C119	B2#1	B1#4	3.43687e-17
C120	a_981_74#	VGND#7	3.89908e-17
C121	A2#9	A1#5	1.11701e-18
C122	a_515_392##3	A1#1	5.98345e-17
C123	Y#2	A2#3	1.2316e-17
C124	VPWR#6	B1#6	1.39702e-18
C125	VGND#5	B1#2	4.93888e-20
C126	A2#8	A1#5	1.37132e-18
C127	a_515_392##3	B1#6	4.67529e-17
C128	a_981_74##2	a_981_74#	2.43091e-18
C129	B2#5	B2#1	1.36258e-17
C130	A2#9	A2#3	8.31542e-18
C131	VPWR#6	B2#6	3.28571e-19
C132	B1#6	a_116_392##4	1.98023e-17
C133	Y#2	A1#2	6.65716e-17
C134	a_116_392##6	A1#1	9.71816e-19
C135	a_515_392##3	B2#6	1.67111e-18
C136	A2#8	A2#3	1.15944e-17
C137	a_981_74##2	VGND#7	4.21378e-17
C138	a_515_392##8	A1#1	7.61144e-20
C139	VPWR#6	B2#7	1.05038e-19
C140	VGND#5	C2#5	1.08025e-18
C141	B2#6	a_116_392##4	2.31283e-17
C142	a_116_392##6	B1#6	1.79322e-17
C143	Y#3	B1#5	1.51518e-20
C144	B1#3	B2#5	3.72239e-17
C145	A1#2	A2#9	3.11243e-17
C146	a_515_392##3	B2#7	4.75922e-19
C147	a_515_392##6	B2#6	3.37458e-17
C148	Y#2	B1#5	3.63062e-17
C149	a_515_392##8	B1#6	2.46026e-19
C150	VPWR#6	B1#1	4.29089e-20
C151	Y#12	C1#6	1.99495e-20
C152	A1#2	A2#8	1.59852e-17
C153	a_116_392##6	B2#6	2.55581e-17
C154	a_515_392##3	B1#1	4.25234e-19
C155	a_137_74##2	C1#6	1.82738e-19
C156	a_515_392##6	B2#7	3.21562e-17
C157	VGND#5	C1#3	1.61726e-19
C158	a_515_392##8	B2#6	3.87092e-19
C159	C2#4	B1#3	5.02073e-18
C160	Y#3	B2#3	2.64949e-17
C161	Y#1	A1#5	8.11825e-18
C162	VGND#6	C1#6	6.33844e-20
C163	a_116_392##6	B2#7	4.25266e-17
C164	Y#2	B2#3	1.12613e-17
C165	Y#8	a_981_74##2	4.28859e-17
C166	a_593_74#	B2#4	9.36677e-19
C167	Y#2	a_515_392##3	8.3732e-18
C168	A2#9	a_515_392#	2.37112e-18
C169	a_515_392##8	B2#7	1.3796e-18
C170	Y#4	B1#2	2.13772e-17
C171	a_116_392##6	B1#1	4.6251e-17
C172	C1#1	C2#4	3.64484e-17
C173	Y#1	A2#3	1.33628e-17
C174	Y#3	B1#2	6.07292e-17
C175	a_515_392##8	B1#1	3.77604e-17
C176	Y#2	B1#2	2.49002e-20
C177	a_981_74#	A2#3	3.88621e-19
C178	VGND#4	a_593_74##2	1.82779e-17
C179	a_116_392##6	C2#6	4.34244e-19
C180	VGND#7	A2#3	7.55869e-19
C181	a_981_74##2	A2#3	3.45948e-19
C182	C2#5	Y#4	6.61043e-17
C183	a_515_392##8	C2#6	7.84685e-19
C184	C1#5	C1#1	3.4847e-17
C185	a_116_392#	B1#1	4.35874e-19
C186	a_593_74#	Y#8	3.44356e-17
C187	C2#5	Y#3	4.65424e-17
C188	C2#6	Y#10	2.489e-17
C189	Y#4	a_116_392##6	1.32908e-17
C190	Y#11	B1#1	6.25388e-20
C191	a_116_392#	C2#6	3.86522e-17
C192	a_981_74##2	A1#2	5.49458e-19
C193	C2#1	C1#5	3.47991e-17
C194	Y#3	a_116_392##6	1.51867e-18
C195	Y#11	C2#6	7.54479e-19
C196	Y#3	C1#3	4.01051e-21
C197	VGND#4	VGND#6	4.73034e-17
C198	a_116_392#	C1#4	3.39753e-17
C199	Y#4	a_515_392##8	6.20841e-17
C200	Y#11	C1#4	3.78589e-17
C201	a_593_74#	VGND#8	1.18514e-18
C202	a_116_392#	C1#6	1.60201e-18
C203	a_116_392##3	C1#4	1.20919e-18
C204	Y#3	a_515_392##8	2.44158e-18
C205	a_593_74#	B1#5	6.97857e-19
C206	a_515_392##5	A1#5	3.17409e-18
C207	Y#3	C2#2	4.54997e-21
C208	Y#11	C1#6	4.28571e-17
C209	Y#4	Y#10	1.28485e-17
C210	a_593_74##2	B2#4	6.31316e-19
C211	VGND#3	A2#5	1.61069e-19
C212	Y#3	B2#4	4.84538e-18
C213	a_593_74##2	a_593_74#	2.23585e-18
C214	a_116_392##3	C1#6	5.53933e-17
C215	a_116_392##6	VPWR#4	1.05049e-16
C216	Y#11	C2#3	9.01597e-19
C217	a_116_392##3	C2#3	4.50246e-17
C218	a_116_392##2	C1#3	1.1295e-19
C219	a_593_74##2	VGND#8	1.63183e-18
C220	Y#4	a_116_392#	5.30706e-17
C221	C2#3	Y#6	1.84378e-18
C222	VGND#3	A1#3	3.11416e-19
C223	A2#4	A1#4	4.17473e-17
C224	B2	B2#4	1.33536e-17
C225	a_593_74##2	B1#2	2.55956e-19
C226	a_116_392##3	VPWR#4	4.64231e-17
C227	A1#2	VPWR#6	2.12035e-18
C228	Y#2	B2#4	1.70055e-17
C229	Y#11	Y#4	2.57878e-18
C230	A2#6	A2#4	4.31325e-17
C231	Y#1	a_515_392##5	5.11983e-18
C232	A1#2	a_515_392##3	5.06568e-17
C233	VGND#3	B1#4	7.06426e-18
C234	B1#5	a_515_392##3	4.18739e-17
C235	A1#1	A2#6	3.69941e-17
C236	C2#5	VGND#9	2.58702e-17
C237	B1#5	a_116_392##4	1.7239e-18
C238	a_137_74#	C2#5	6.0322e-18
C239	Y#12	C2#5	3.33344e-18
C240	B1#5	a_515_392##6	3.27921e-17
C241	VGND#3	B2#1	1.01347e-17
C242	a_116_392##6	B1#5	4.7144e-19
C243	B1#6	A1#1	4.36013e-17
C244	a_137_74#	C1#3	3.12183e-19
C245	C1#3	Y#12	4.12887e-17
C246	a_137_74##2	C1#3	2.64417e-19
C247	B2#6	B1#6	2.78314e-17
C248	VGND#3	B2#5	7.17159e-18
C249	B1#2	a_515_392##6	4.12506e-17
C250	VGND#4	B2#5	4.8721e-18
C251	Y#12	C2#2	4.59259e-17
C252	B1#2	a_116_392##6	1.72306e-18
C253	C2#2	a_137_74##2	4.94689e-19
C254	VGND#4	B1#3	5.46057e-18
C255	B1#2	a_515_392##8	4.5575e-17
C256	B2#7	B2#6	4.74418e-17
C257	C2#2	VGND#6	1.62592e-18
C258	Y#3	Y#2	2.16049e-18
C259	a_137_74#	VGND#9	4.99186e-17
C260	VPWR#4	B2#4	1.60025e-19
C261	B2#4	B1#4	9.01276e-18
C262	VGND#3	B1#3	1.48715e-18
C263	B1#1	B2#7	4.2058e-17
C264	Y#2	A1#6	5.1942e-19
C265	Y#12	VGND#9	2.77997e-18
C266	C2#5	Y#11	3.32641e-17
C267	VGND#5	C2#4	3.72507e-18
C268	C2#6	B1#1	4.20067e-18
C269	a_116_392##2	Y#10	1.37368e-18
C270	VGND#3	C2#4	3.99032e-19
C271	Y#11	C1#3	5.29431e-19
C272	a_137_74#	Y#12	2.80578e-17
C273	Y#2	A2#1	2.82268e-19
C274	A1	a_515_392##2	3.84579e-17
C275	C1#4	C2#6	4.47045e-17
C276	C2#2	Y#11	4.4094e-17
C277	VGND#5	C1#1	5.32667e-18
C278	a_116_392##2	a_116_392#	8.70479e-20
C279	a_116_392##3	C2#2	5.46276e-19
C280	VGND#6	VGND#9	3.55323e-19
C281	VPWR#4	B2#6	5.33641e-18
C282	C1#6	C1#4	4.46745e-17
C283	A1#2	A1#4	2.88169e-20
C284	VPWR#4	B2#7	3.87805e-18
C285	Y#2	A2#5	8.9715e-18
C286	A2#9	A1	2.28856e-17
C287	A1#2	A2#4	3.88134e-20
C288	VPWR#4	B1#1	4.46113e-18
C289	Y#12	a_137_74##2	4.62694e-17
C290	A2#8	A1	1.19153e-17
C291	C2#5	B1#3	1.1018e-18
C292	a_116_392##2	Y#11	1.90904e-17
C293	A1#2	A2#6	1.31814e-17
C294	C2#3	C1#6	5.13843e-17
C295	C2#5	C2#4	4.62924e-18
C296	VGND#5	C1#5	1.94115e-18
C297	VPWR#4	C2#6	4.47472e-18
C298	A1#2	A1#1	5.38794e-18
C299	B1#5	A2#6	1.64305e-19
C300	VPWR#4	C1#4	4.45054e-18
C301	A1#2	B1#6	6.79137e-19
C302	Y#2	A1#3	1.33619e-17
C303	Y#12	VGND#6	4.53838e-17
C304	C1#3	C2#4	5.25198e-18
C305	B1#5	A1#1	6.79137e-19
C306	VPWR#4	C1#6	4.49062e-18
C307	A1#2	B2#6	2.04506e-19
C308	B2#5	B2#4	4.86312e-18
C309	Y#1	A1	6.68372e-17
C310	B1#5	B1#6	5.5636e-18
C311	Y#3	B1#4	2.97906e-19
C312	VPWR#4	C2#3	5.1146e-18
C313	B1#5	B2#6	2.46298e-17
C314	VGND#3	VGND#7	3.32462e-19
C315	VGND#6	a_137_74##2	4.51693e-17
C316	B1#5	B2#7	2.80376e-19
C317	Y#2	B1#4	2.18423e-17
C318	B1#5	B1#1	1.42931e-21
C319	B1#2	B1#6	2.05841e-20
C320	B1#2	B2#6	3.48953e-19
C321	Y#3	B2#1	2.59168e-19
C322	B1#2	B2#7	2.08992e-17
C323	B1#2	B1#1	5.91299e-18
C324	A1	a_515_392##5	5.20903e-17
C325	Y#2	B2#1	8.97199e-18
C326	A1	VPWR#5	6.27626e-19
C327	C2#6	B1#2	7.77729e-19
C328	VGND	B2#4	1.12881e-18
C329	A1	a_515_392#	5.56428e-19
C330	B1#3	B2#4	5.61174e-18
C331	Y#2	A2#8	2.90036e-17
C332	C2#5	C2#6	4.03593e-18
C333	Y#3	B2#5	1.80166e-17
C334	A2#3	A1#5	3.05721e-17
C335	VPWR#4	B1#5	2.98332e-20
C336	C2#5	C1#4	1.31622e-17
C337	A1#2	A1#5	2.33155e-19
C338	Y#2	B2#5	5.07015e-20
C339	A1#2	A2#3	3.80233e-17
C340	VGND#3	Y#8	1.10447e-17
C341	C1#6	C1#3	3.47617e-18
C342	VPWR#4	B1#2	3.21614e-20
C343	B1#5	A2#3	3.67553e-20
C344	VGND#4	B1#2	2.59731e-20
C345	C2#2	C1#6	2.43649e-17
C346	Y#3	B1#3	4.25801e-17
C347	B1#5	A1#2	7.41474e-17
C348	B2#3	A2#3	6.18983e-19
C349	a_515_392##5	VPWR#5	4.70557e-17
C350	C2#2	C2#3	4.03548e-18
C351	VPWR#4	C1#3	3.70043e-20
C352	B2#3	A1#2	4.76889e-19
C353	B2#4	VNB	8.23872e-17
C354	Y#2	B1#3	1.69059e-19
C355	B2#3	B1#5	5.22817e-18
C356	VPWR#4	C2#2	5.26018e-20
C357	VPWR	VPWR#3	3.44227e-17
C358	VGND#3	a_593_74#	4.4815e-17
C359	B1#2	B1#5	1.97231e-18
C360	VPWR	a_515_392##2	1.61245e-17
C361	Y#4	a_116_392##2	3.89495e-17
C362	Y#3	C2#4	2.53728e-18
C363	B1#2	B2#3	6.30111e-18
C364	VPWR	Y#4	1.24558e-17
C365	B2#3	C2#5	1.3295e-19
C366	VPWR	A2#9	1.74545e-18
C367	Y#1	A1#6	2.87259e-17
C368	A1	A1#4	6.24399e-18
C369	C2#5	B1#2	1.1081e-17
C370	VGND	VGND#5	4.13422e-17
C371	A1	A2#4	1.54901e-17
C372	VGND	VGND#3	4.10276e-17
C373	VPWR	a_116_392##2	3.49956e-17
C374	A1	A2#6	9.61361e-20
C375	Y#12	Y	2.4003e-18
C376	A1	A1#1	1.94395e-20
C377	VGND#3	VGND#8	1.04809e-17
C378	C2#5	C1#3	7.47117e-17
C379	a_981_74#	A1#6	3.385e-17
C380	Y#3	C1#1	2.82014e-19
C381	C2#2	C2#5	1.91907e-18
C382	VGND	Y#3	2.6405e-17
C383	VPWR#6	VPWR#5	2.05254e-18
C384	VGND	Y#2	1.06734e-17
C385	a_515_392##3	a_515_392##5	1.0694e-18
C386	Y#1	A2#1	9.0645e-18
C387	C2#2	C1#3	9.7279e-17
C388	VGND	A2#8	2.08719e-18
C389	B2#4	B1#5	4.20249e-17
C390	VGND#5	VGND#3	4.08889e-19
C391	VGND#7	A1#6	2.21293e-18
C392	Y	Y#11	2.31853e-18
C393	VPWR	a_515_392##5	1.67082e-17
C394	Y	a_116_392##3	6.44606e-17
C395	VPWR	VPWR#5	1.58351e-17
C396	VGND#5	VNB	5.5255e-17
C397	VGND#3	B2#4	1.64048e-18
C398	VGND#3	VNB	3.9694e-17
C399	Y	Y#6	1.2233e-17
C400	B2	B2#6	1.77457e-18
C401	VGND	Y#1	1.83646e-17
C402	VPWR	VPWR#6	1.79017e-17
C403	a_981_74#	A2#1	2.41434e-17
C404	VGND	a_981_74#	1.5091e-17
C405	VPWR#3	VNB	4.1973e-17
C406	VPWR	a_515_392##3	1.79942e-17
C407	VGND	VGND#7	1.59537e-17
C408	B2	B2#7	1.61235e-18
C409	VGND	a_981_74##2	1.72511e-17
C410	VGND	Y#8	1.46303e-17
C411	VPWR	a_515_392##6	6.08608e-18
C412	a_593_74##2	VGND#3	2.76396e-17
C413	VGND	a_593_74#	1.5104e-17
C414	Y#3	C1#5	1.14968e-19
C415	VPWR	a_116_392##6	5.62929e-17
C416	a_515_392##2	VNB	4.79186e-18
C417	VPWR	a_515_392##8	1.81481e-18
C418	VGND	a_593_74##2	1.6469e-17
C419	a_981_74##2	A1#6	2.01308e-19
C420	Y#1	A2#5	3.13193e-19
C421	Y#4	VNB	1.44825e-17
C422	A1	A1#5	2.36438e-17
C423	VGND	VGND#9	1.9728e-17
C424	Y#3	VNB	2.71895e-17
C425	VGND	a_137_74#	1.80568e-17
C426	Y#2	VNB	8.65871e-18
C427	VPWR	Y#11	8.96365e-18
C428	VGND	Y#12	1.33173e-17
C429	A1	A2#3	1.17329e-17
C430	VPWR	a_116_392##3	2.03661e-17
C431	VGND	a_137_74##2	1.79403e-17
C432	A2#9	VNB	4.42433e-19
C433	Y	C2#4	2.87634e-19
C434	VGND	VGND#6	5.18244e-17
C435	A2#8	VNB	2.76172e-18
C436	Y	C1#1	1.22352e-19
C437	A1#2	A1	2.01282e-18
C438	VGND#7	A2#1	2.74503e-17
C439	Y	C1#5	2.22713e-19
C440	a_116_392##2	VNB	7.97098e-18
C441	Y	C2#1	1.10757e-18
C442	VPWR#3	A2#6	9.50272e-19
C443	Y#1	VNB	5.16091e-17
C444	a_981_74#	A2#5	4.2752e-19
C445	a_981_74#	VNB	4.24095e-18
C446	VGND#7	VNB	2.87809e-19
C447	a_981_74##2	VNB	2.63982e-18
C448	Y#8	VNB	2.23639e-18
C449	a_593_74#	VNB	2.10917e-18
C450	a_593_74##2	VNB	2.10917e-18
C451	a_515_392##2	A1#4	8.88856e-19
C452	VGND#9	VNB	7.68397e-18
C453	a_981_74##2	A2#1	4.64624e-19
C454	VGND	A1#6	2.35492e-18
C455	a_137_74#	VNB	3.5985e-18
C456	Y#1	A1#3	1.86984e-19
C457	Y#12	VNB	1.29861e-17
C458	VGND	A2#1	7.73833e-19
C459	B2	B1#5	2.12809e-17
C460	a_137_74##2	VNB	3.01574e-18
C461	Y#3	C2#1	1.30432e-19
C462	VGND	A2#5	5.65669e-19
C463	VGND#6	VNB	6.44822e-17
C464	VPWR	A1#4	1.50847e-18
C465	VGND	A1#3	1.60235e-18
C466	a_515_392##5	VNB	5.67852e-17
C467	VPWR	A2#4	4.01139e-19
C468	VPWR#5	VNB	1.77236e-18
C469	VGND	B1#4	1.34456e-19
C470	Y	C2#6	4.64851e-20
C471	VGND	B2#1	3.34707e-19
C472	VPWR	A2#6	3.98643e-19
C473	Y	C1#4	2.54301e-19
C474	B1#2	B2	5.19788e-17
C475	VGND	B2#5	1.082e-18
C476	a_515_392##3	VNB	8.09511e-18
C477	VPWR	A1#1	8.75284e-19
C478	VGND#7	A2#5	2.52249e-17
C479	VGND	B1#3	2.35491e-19
C480	Y	C1#6	1.66722e-18
C481	a_515_392##3	VPWR#6	4.66854e-17
C482	VPWR	B1#6	1.69057e-18
C483	VGND	C2#4	6.47544e-19
C484	a_116_392##6	VNB	1.23501e-17
C485	Y	C2#3	3.9028e-17
C486	VPWR	B2#6	8.26775e-19
C487	VGND	C1#1	1.18604e-18
C488	VGND	C1#5	7.84553e-19
C489	VPWR	B2#7	5.36828e-19
C490	B2#3	B2#4	1.52079e-17
C491	VGND	C2#1	1.52943e-18
C492	VPWR	B1#1	1.66505e-18
C493	Y	VPWR#4	1.98064e-17
C494	a_116_392##3	VNB	7.89428e-18
C495	VPWR	C2#6	1.64365e-18
C496	A1#6	VNB	3.42995e-17
C497	VPWR	C1#4	1.61874e-18
C498	a_981_74#	A1#3	1.86731e-19
C499	A2#1	VNB	2.69964e-17
C500	VPWR	C1#6	1.61431e-18
C501	A2#5	VNB	2.74266e-17
C502	A1#3	VNB	3.04697e-17
C503	VPWR	C2#3	3.4644e-18
C504	B1#4	VNB	3.09863e-17
C505	VPWR#3	A1#1	1.45637e-18
C506	B2#1	VNB	2.48101e-17
C507	B2#5	VNB	3.0412e-17
C508	VPWR	VPWR#4	8.60914e-17
C509	B1#3	VNB	3.56895e-17
C510	C2#4	VNB	2.99543e-17
C511	a_981_74##2	A2#5	2.53413e-17
C512	C1#1	VNB	2.59199e-17
C513	C1#5	VNB	2.62113e-17
C514	Y#1	B1#4	1.26003e-19
C515	C2#1	VNB	3.45356e-17
C516	A1#4	VNB	3.53412e-17
C517	Y	C2#5	1.18249e-18
C518	VPWR	A1#2	4.37174e-18
C519	a_515_392##2	A2#4	2.07181e-17
C520	A2#4	VNB	2.55715e-17
C521	A2#6	VNB	2.56458e-17
C522	VPWR	B1#5	4.47642e-18
C523	Y	C1#3	1.70766e-19
C524	A1#1	VNB	2.95112e-17
C525	B1#6	VNB	3.2055e-17
C526	Y	C2#2	7.05663e-17
C527	VGND#7	A1#3	2.08351e-18
C528	VGND	VGND#4	1.44576e-17
C529	B2#6	VNB	3.58893e-17
C530	VPWR	B1#2	5.59976e-18
C531	B2#7	VNB	3.51638e-17
C532	B1#1	VNB	3.62381e-17
C533	VPWR	C2#5	4.46771e-18
C534	C2#6	VNB	3.47499e-17
C535	VGND	A1#2	2.96063e-18
C536	C1#4	VNB	3.73335e-17
C537	C1#6	VNB	4.35708e-17
C538	VGND	B1#5	3.10648e-18
C539	VPWR	C2#2	4.17947e-18
C540	C2#3	VNB	4.46913e-17
C541	VGND	B2#3	3.15062e-18
C542	VGND#9	VGND#3	7.90102e-19
C543	VGND	B1#2	4.08544e-18
C544	VPWR#4	VNB	4.03467e-16
C545	VGND#4	VNB	2.86865e-16
C546	VGND	C2#5	7.5907e-18
C547	A1#5	VNB	6.04525e-17
C548	VGND	C1#3	3.5141e-18
C549	A2#3	VNB	6.63062e-17
C550	VGND	C2#2	4.8881e-18
C551	A1#2	VNB	4.19738e-17
C552	B1#5	VNB	4.07692e-17
C553	B2#3	VNB	4.56317e-18
C554	B1#2	VNB	5.16224e-17
C555	C2#5	VNB	4.38996e-17
C556	a_981_74##2	A1#3	3.45226e-17
C557	a_515_392##3	a_116_392##4	6.03561e-19
C558	C1#3	VNB	5.3596e-17
C559	C2#2	VNB	5.34998e-17
C560	VPWR	A1	4.89516e-18
C561	VGND#5	a_137_74#	2.45616e-17
C562	VPWR	B2	2.64025e-18
C563	VGND	A1	3.57826e-18
C564	VPWR#3	B1#6	4.95479e-18
C565	A1	VNB	1.9481e-17
C566	VGND#7	B1#4	3.00353e-19
C567	VPWR	Y	1.70461e-17
C568	B2	VNB	1.39445e-18
C569	VGND	Y	9.91436e-19
C570	a_515_392##2	A2#6	2.09348e-17
C571	Y	VNB	9.1374e-17
C572	VPWR	VNB	9.49548e-17
C573	VGND	VNB	8.6505e-17
C574	A1#3	Y#8	8.35469e-18
C575	VGND#3	VGND#2	2.31461e-19
C576	VGND#2	VNB	7.57904e-17
C577	VGND	VGND#2	5.31075e-17
C578	VGND#2	Y#8	9.23801e-18
C579	VGND#2	a_981_74##2	2.04557e-17
C580	VGND#2	a_981_74#	1.81842e-17
C581	VGND#2	Y#1	1.86766e-17
C582	VGND#2	A1#3	4.57166e-18
C583	VGND#2	A2#5	9.52262e-19
C584	VGND#2	A2#1	1.37238e-18
C585	VGND#2	A1#6	4.57027e-18
C586	VGND#2	Y#2	5.79561e-19
C587	VGND#2	A1#2	6.81018e-20
C588	VGND#2	A1#5	6.31243e-20
C589	VGND#4	VGND#2	8.86702e-17
C590	a_515_392##9	B2#6	5.87807e-20
C591	a_515_392##9	B2#7	1.18601e-19
C592	VPWR#3	VPWR#2	1.56487e-18
C593	a_515_392##9	a_515_392##3	2.45959e-19
C594	a_515_392##9	B1#1	3.57548e-18
C595	VPWR	a_515_392##9	3.80658e-18
C596	a_515_392##5	VPWR#2	2.04921e-17
C597	a_515_392##9	C2#6	1.97538e-19
C598	VPWR#2	A1#4	4.14379e-18
C599	VPWR	VPWR#2	3.3707e-17
C600	Y#4	a_515_392##9	1.20122e-17
C601	a_515_392##9	a_116_392##6	3.06629e-17
C602	a_515_392##2	VPWR#2	6.97074e-18
C603	VPWR#6	VPWR#2	2.0056e-20
C604	VPWR#4	VPWR#2	5.09241e-17
C605	VPWR#2	A2#4	3.64036e-18
C606	a_515_392##9	A1#1	2.16532e-20
C607	VPWR#2	A2#6	5.1309e-19
C608	VPWR#2	VNB	4.60553e-17
C609	a_515_392##9	a_515_392##8	2.70584e-18
C610	VPWR#2	A1#5	4.9071e-20
C611	a_515_392##9	B1#6	3.73679e-20
C612	VPWR#2	A2#3	2.20765e-20
*
*
.ENDS sky130_fd_sc_hs__a222oi_2
*
