* Extracted by Quantus, converted by sky130cad/quantus.py
*
*
*
*                       LINUX           Wed Nov 18 08:12:34 2026
*
*
*
*  PROGRAM  advgen
*
*  Name           : advgen - Quantus - (64-bit)
*  Version        : 25.1.0-p047
*  Build Date     : Thu Dec 11 23:20:30 PST 2025
*
*  HSPICE LIBRARY
*
*  OPERATING_TEMPERATURE 150
*  QRC_TECH_DIR <path>/tech
*
*
*

*
.SUBCKT sky130_fd_sc_hs__a31o_1 VPB VNB VGND VPWR X B1 A3 A2 A1
*
*
*  caps2d version: 10
*
*
*       TRANSISTOR CARDS
*
*
XM5 X#3 a_81_270# VGND#5 VNB sky130_fd_pr__nfet_01v8_lvt l=0.15 w=0.74 ad=0.1961 as=0.4131 pd=2.01 ps=2.66
XM0 VGND#5 A3#1 a_265_120# VNB sky130_fd_pr__nfet_01v8_lvt l=0.15 w=0.64 ad=0.4131 as=0.1344 pd=2.66 ps=1.7
XM1 a_265_120# A2#3 a_337_120# VNB sky130_fd_pr__nfet_01v8_lvt l=0.15 w=0.64 ad=0.1344 as=0.25125 pd=1.7 ps=2.09
XM7 a_337_120# A1#3 a_81_270##7 VNB sky130_fd_pr__nfet_01v8_lvt l=0.15 w=0.64 ad=0.25125 as=0.2816 pd=2.09 ps=2.16
XM2 a_81_270##7 B1#2 VGND#1 VNB sky130_fd_pr__nfet_01v8_lvt l=0.15 w=0.64 ad=0.2816 as=0.1696 pd=2.16 ps=1.81
XM3 X#1 a_81_270##3 VPWR#5 VPB sky130_fd_pr__pfet_01v8 l=0.15 w=1.12 ad=0.308 as=0.5618 pd=2.79 ps=3.3
XM9 VPWR#5 A3#3 a_250_392##2 VPB sky130_fd_pr__pfet_01v8 l=0.15 w=1 ad=0.5618 as=0.3 pd=3.3 ps=2.6
XM6 a_250_392##2 A2#1 VPWR#3 VPB sky130_fd_pr__pfet_01v8 l=0.15 w=1 ad=0.3 as=0.48 pd=2.6 ps=2.96
XM8 VPWR#3 A1#1 a_250_392# VPB sky130_fd_pr__pfet_01v8 l=0.15 w=1 ad=0.48 as=0.3 pd=2.96 ps=2.6
XM4 a_250_392# B1#1 a_81_270##4 VPB sky130_fd_pr__pfet_01v8 l=0.15 w=1 ad=0.3 as=0.275 pd=2.6 ps=2.55
*
*
*       RESISTOR AND CAP/DIODE CARDS
*
Rg1	a_81_270#	a_81_270##2	305.727875
Rg2	a_81_270##2	a_81_270##3	432.429443
Rg3	A3#1	A3#2	348.108032
Rg4	A3#2	A3#3	400.207520
Rg5	A2#1	A2#2	400.207520
Rg6	A2#2	A2#3	348.108032
Rg7	A1#1	A1#2	400.207520
Rg8	A1#2	A1#3	339.500092
Rg9	B1#1	B1#2	811.008728
Rg10	B1#2	B1#3	279.244598
Rf1	X	X#2	13.399889
Rf2	X#2	X	0.372219
Rf3	X	X#3	82.689217
Rf4	X#1	X#2	5.000000
Rf5	A3#2	A3	161.903809
Rf6	A2#2	A2	161.413818
Rf7	A1	A1#2	163.574814
Rf8	a_250_392#	a_250_392##2	108.439644
Rf9	B1#4	B1	1.159035
Rf10	B1#5	B1	1.159035
Rf11	B1#4	B1#5	16.310976
Rf12	B1#3	B1#7	161.391846
Rf13	B1#7	B1	1.159035
Rf14	B1#5	B1#7	16.310976
Rf15	a_81_270##4	a_81_270##5	100.361786
Rf16	a_81_270##5	a_81_270##2	293.609741
Rf17	a_81_270##5	a_81_270##7	22.697315
Rf18	VGND#1	VGND#2	173.987152
Rf19	VGND#2	VGND#3	56.212154
Rf21	VGND#3	VGND#6	12.367956
Rf22	VGND#6	VGND#5	21.178089
Rf23	VGND#5	VGND#6	15.000000
Rf25	VPWR#2	VPWR#3	30.406815
Rf26	VPWR#2	VPWR#4	61.662327
Rf27	VPWR#4	VPWR#5	27.066298
Re1	VPWR#2	VPWR	1.403190
Re2	VGND	VGND#2	1.403242
*
*       CAPACITOR CARDS
*
*
C1	VGND	VNB	6.46912e-17
C2	VPWR	VNB	6.7812e-17
C3	X	VNB	4.63231e-17
C4	B1	VNB	1.96713e-17
C5	A3	VNB	3.63027e-19
C6	VGND	X	8.36962e-19
C7	A2	VNB	3.56322e-19
C8	A1	VNB	9.06505e-19
C9	VGND	B1	4.39015e-17
C10	VPWR	X	1.72954e-17
C11	VGND	A3	1.90062e-18
C12	VGND	A2	1.73795e-18
C13	VGND	A1	1.95056e-18
C14	VPWR	A3	2.33183e-18
C15	a_81_270##2	VNB	4.28074e-17
C16	A3#2	VNB	3.12359e-17
C17	VPWR	A2	1.67708e-18
C18	A2#2	VNB	2.89e-17
C19	X	A3	3.15897e-18
C20	A1#2	VNB	3.0064e-17
C21	VPWR	A1	1.8821e-18
C22	B1#3	VNB	5.5318e-17
C23	VGND#2	VNB	1.96403e-16
C24	VGND	a_81_270##2	9.67394e-18
C25	a_81_270##3	VNB	4.30596e-17
C26	A3#3	VNB	3.33068e-17
C27	A2#1	VNB	2.95189e-17
C28	A1#1	VNB	2.90763e-17
C29	B1#1	VNB	5.09659e-17
C30	A3	A2	2.21746e-17
C31	VGND	B1#3	4.45621e-18
C32	a_81_270#	VNB	3.73665e-17
C33	A3#1	VNB	2.54845e-17
C34	VGND	VGND#2	2.59857e-17
C35	VPWR	a_81_270##2	3.65897e-18
C36	A2#3	VNB	2.5389e-17
C37	A1#3	VNB	2.97855e-17
C38	B1#2	VNB	3.83471e-17
C39	X#1	VNB	1.99637e-17
C40	VPWR#5	VNB	5.50625e-18
C41	a_250_392##2	VNB	2.1393e-18
C42	B1	a_337_120#	2.22072e-18
C43	A2	A1	2.53893e-17
C44	a_81_270##5	a_250_392#	1.17818e-17
C45	VPWR#3	VNB	6.2017e-18
C46	X	a_81_270##2	3.19091e-17
C47	a_250_392#	VNB	2.19377e-18
C48	a_81_270##4	VNB	6.56186e-17
C49	X#3	VNB	4.92062e-17
C50	X	A3#2	3.37965e-19
C51	VGND#5	VNB	8.29962e-18
C52	X	A2#2	7.13936e-20
C53	VGND	a_81_270#	7.56852e-18
C54	VGND#1	VNB	6.92965e-17
C55	VGND	A3#1	3.57897e-18
C56	X	A1#2	4.85447e-20
C57	VPWR	a_81_270##3	4.1073e-18
C58	VGND	A2#3	1.38202e-18
C59	VPWR	A3#3	1.82484e-18
C60	VGND	B1#2	1.55008e-19
C61	VPWR	A2#1	9.21646e-20
C62	B1	A2#2	1.71683e-18
C63	VPWR	A1#1	2.81693e-19
C64	a_81_270##2	A3	5.92265e-17
C65	a_81_270##5	VNB	3.06134e-17
C66	VPWR	B1#1	6.09074e-18
C67	B1	A1#2	5.27411e-19
C68	A3	A3#2	1.53096e-17
C69	B1	B1#3	1.93756e-17
C70	X	a_81_270##3	2.70801e-17
C71	A3	A2#2	4.2456e-18
C72	a_81_270##2	A2	7.12347e-18
C73	VGND#2	B1	8.79266e-17
C74	VGND	X#3	1.72832e-17
C75	X	A3#3	9.98592e-19
C76	X	A2#1	3.85799e-19
C77	A2	A3#2	3.38026e-18
C78	X	A1#1	2.48769e-19
C79	VGND	VGND#1	3.46843e-17
C80	A2	A2#2	1.49209e-17
C81	VPWR	VPWR#5	3.07195e-17
C82	VPWR	a_250_392##2	1.7287e-17
C83	A2	A1#2	3.02222e-18
C84	VPWR	VPWR#3	2.83652e-17
C85	VPWR	a_250_392#	1.75004e-17
C86	A1	A2#2	3.72596e-18
C87	VPWR	a_81_270##4	1.51123e-17
C88	A3	a_81_270##3	1.03879e-18
C89	A1	A1#2	1.50069e-17
C90	VGND	a_81_270##5	1.4619e-17
C91	a_81_270##2	a_265_120#	2.12395e-18
C92	X	X#1	4.34516e-18
C93	B1	a_81_270#	5.0662e-19
C94	X	VPWR#5	4.72755e-17
C95	B1	A3#1	2.08992e-18
C96	B1	A2#3	1.53774e-17
C97	B1	A1#3	1.77739e-17
C98	B1	B1#2	5.53369e-18
C99	X#3	X	3.79618e-18
C100	VGND#5	a_81_270##5	5.53024e-18
C101	a_81_270##2	A3#2	3.08329e-17
C102	A1	B1#1	3.74517e-18
C103	A3	VPWR#5	1.68378e-17
C104	VGND#5	B1	1.85886e-17
C105	A3	a_250_392##2	2.30178e-17
C106	a_81_270##2	A2#2	7.08439e-19
C107	B1	a_81_270##7	2.11804e-18
C108	B1	VGND#1	5.10174e-17
C109	a_81_270##2	A1#2	2.06462e-19
C110	A3#2	A2#2	3.49927e-17
C111	A2	a_250_392##2	4.18591e-17
C112	A2	VPWR#3	1.42267e-18
C113	A1	B1#2	2.75714e-18
C114	VGND#2	a_81_270##2	7.64276e-19
C115	A2#2	A1#2	2.91854e-17
C116	B1	a_81_270##5	6.54702e-17
C117	A3#1	a_265_120#	1.29433e-17
C118	A1	VPWR#3	4.79284e-19
C119	VGND#2	A2#2	3.45065e-20
C120	A2#3	a_265_120#	1.29433e-17
C121	A1	a_250_392#	3.92668e-17
C122	A1	a_81_270##4	9.97508e-18
C123	VGND#2	A1#2	3.28584e-20
C124	a_81_270##3	A3#2	2.98843e-18
C125	A2#3	a_337_120#	1.59276e-17
C126	VGND#2	B1#3	6.0382e-18
C127	A1#3	a_337_120#	1.59276e-17
C128	a_81_270##5	a_81_270##7	1.39299e-17
C129	a_81_270##5	A2	3.3744e-17
C130	a_81_270##2	a_81_270#	3.1328e-18
C131	a_81_270##2	A3#1	2.12412e-17
C132	a_81_270##5	VGND#1	5.52476e-17
C133	a_81_270##2	A2#3	4.97967e-18
C134	a_81_270##2	A1#3	3.52756e-20
C135	A1#2	B1#1	1.85028e-17
C136	a_81_270##5	A1	4.171e-17
C137	a_81_270##2	B1#2	1.19319e-19
C138	a_81_270##2	VPWR#5	2.70483e-17
C139	a_81_270##2	a_250_392##2	6.74471e-18
C140	A2#2	A1#3	2.56232e-19
C141	a_81_270#	B1#3	1.8242e-19
C142	a_81_270##3	A3#3	1.93295e-17
C143	VPWR#5	A3#2	2.05388e-18
C144	A2#3	B1#3	6.169e-19
C145	A1#2	B1#2	9.12618e-18
C146	VGND#2	A3#1	3.22243e-20
C147	A3#3	A2#1	4.09382e-17
C148	X#3	a_81_270##2	4.07908e-17
C149	A1#3	B1#3	8.34454e-18
C150	a_250_392##2	A2#2	2.36783e-18
C151	a_81_270##2	VGND#5	5.94351e-17
C152	VGND#2	A2#3	2.60446e-18
C153	a_81_270##4	A3#2	3.76752e-20
C154	VPWR#3	A2#2	8.88921e-19
C155	VGND#2	A1#3	1.1252e-18
C156	a_81_270##5	a_337_120#	1.3204e-18
C157	A2#1	A1#1	2.05131e-17
C158	VGND#5	A3#2	1.113e-18
C159	a_81_270##4	A2#2	8.32156e-20
C160	VPWR#3	A1#2	4.91098e-19
C161	a_250_392#	A1#2	1.5455e-18
C162	A1#1	B1#1	4.11392e-17
C163	a_81_270##4	A1#2	2.315e-18
C164	a_250_392#	B1#3	6.00253e-19
C165	VGND#5	B1#3	4.52401e-19
C166	X#1	a_81_270##3	2.45282e-17
C167	a_81_270##3	VPWR#5	4.37439e-17
C168	a_81_270##5	a_81_270##2	5.20285e-19
C169	A3#3	VPWR#5	3.13037e-17
C170	VPWR#3	a_81_270##3	5.02889e-19
C171	VGND#1	B1#3	1.42789e-17
C172	a_250_392##2	A3#3	5.07287e-17
C173	a_81_270##5	A3#2	2.38636e-19
C174	a_81_270#	A3#1	1.11919e-17
C175	VPWR#5	A2#1	1.38735e-18
C176	VPWR#3	A3#3	1.37278e-18
C177	a_250_392##2	A2#1	7.08684e-17
C178	VGND#2	VGND#1	2.87791e-17
C179	VPWR#5	A1#1	2.94815e-19
C180	a_81_270##5	A2#2	4.08092e-18
C181	A2#1	VPWR#3	3.64865e-17
C182	A3#1	A2#3	5.38193e-17
C183	a_81_270##4	A3#3	2.05568e-19
C184	a_250_392##2	A1#1	5.55913e-19
C185	a_250_392#	A2#1	5.55913e-19
C186	A1#1	VPWR#3	3.19658e-17
C187	a_81_270##5	A1#2	5.17724e-18
C188	a_81_270##4	A2#1	4.30911e-19
C189	a_250_392#	A1#1	6.37868e-17
C190	A2#3	A1#3	2.29596e-17
C191	VPWR#3	B1#1	1.56017e-18
C192	a_81_270##4	A1#1	7.52864e-19
C193	a_250_392#	B1#1	5.18902e-17
C194	a_81_270##5	B1#3	3.85192e-18
C195	a_81_270##4	B1#1	3.32107e-17
C196	A1#3	B1#2	1.66763e-17
C197	VGND#2	a_81_270##5	1.48682e-19
C198	X#3	a_81_270#	3.18092e-17
C199	a_81_270#	VGND#5	2.66782e-17
C200	X#1	VPWR#5	4.3599e-17
C201	X#3	A3#1	2.30095e-18
C202	VGND#5	A3#1	4.72384e-17
C203	X#3	A2#3	3.22387e-19
C204	VPWR#5	a_250_392##2	9.01444e-17
C205	VGND#5	A2#3	4.5123e-18
C206	X#3	A1#3	2.55835e-19
C207	a_81_270##4	B1#2	3.20168e-18
C208	VPWR#5	VPWR#3	2.19754e-18
C209	VGND#5	A1#3	1.51918e-18
C210	a_250_392##2	VPWR#3	8.1859e-17
C211	VGND#1	A3#1	2.26817e-19
C212	VGND#5	B1#2	8.59086e-19
C213	a_250_392##2	a_250_392#	2.36331e-18
C214	VGND#1	A2#3	2.5083e-19
C215	a_250_392#	VPWR#3	8.32233e-17
C216	A1#3	a_81_270##7	1.25366e-17
C217	VGND#1	A1#3	1.42076e-18
C218	B1#2	a_81_270##7	1.03394e-17
C219	a_250_392#	a_81_270##4	7.58187e-17
C220	VGND#1	B1#2	1.91118e-17
C221	a_81_270##5	a_81_270#	4.43391e-19
C222	a_81_270##5	A3#1	9.62341e-19
C223	X#3	VGND#5	5.32153e-17
C224	a_81_270##5	A2#3	1.65837e-17
C225	a_81_270##5	A1#3	2.69622e-17
C226	a_81_270##5	B1#2	3.61306e-17
C227	a_81_270##5	a_250_392##2	2.09477e-18
C228	a_250_392##2	VPWR#2	1.20717e-17
C229	a_250_392##2	VPWR#4	5.02668e-18
C230	VGND#3	a_81_270#	3.69601e-18
C231	VPWR#4	VNB	4.9087e-17
C232	VPWR#2	A1#1	2.5803e-18
C233	X	VPWR#4	2.1838e-17
C234	VGND#3	a_81_270##2	9.595e-19
C235	a_250_392#	VPWR#2	1.95453e-17
C236	VPWR#4	a_81_270##3	4.62136e-18
C237	VGND#3	X#3	1.45732e-17
C238	VGND	VGND#3	7.87133e-17
C239	VGND#3	B1#3	7.94578e-19
C240	VPWR	VPWR#4	3.5171e-17
C241	VPWR#5	VPWR#2	1.77228e-19
C242	A3	VPWR#4	3.19641e-19
C243	VPWR#2	A2#1	2.57463e-18
C244	VGND#3	A3#1	2.35545e-18
C245	VPWR#2	B1#1	5.88865e-18
C246	VGND#3	VNB	5.96953e-17
C247	a_81_270##4	VPWR#2	2.0851e-17
C248	VPWR#2	VNB	2.25819e-16
C249	a_81_270##2	VPWR#4	2.70337e-19
C250	VPWR#2	VPWR#4	5.84407e-17
C251	VPWR#4	A3#3	4.57827e-18
C252	VGND#2	VGND#3	6.10629e-17
C253	VGND#3	B1	3.92745e-18
C254	VPWR	VPWR#2	4.80615e-17
*
*
.ENDS sky130_fd_sc_hs__a31o_1
*
