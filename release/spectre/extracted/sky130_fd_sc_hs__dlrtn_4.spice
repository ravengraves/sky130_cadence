* Extracted by Quantus, converted by sky130cad/quantus.py
*
*
*
*                       LINUX           Wed Nov 18 08:31:57 2026
*
*
*
*  PROGRAM  advgen
*
*  Name           : advgen - Quantus - (64-bit)
*  Version        : 25.1.0-p047
*  Build Date     : Thu Dec 11 23:20:30 PST 2025
*
*  HSPICE LIBRARY
*
*  OPERATING_TEMPERATURE 150
*  QRC_TECH_DIR <path>/tech
*
*
*

*
.SUBCKT sky130_fd_sc_hs__dlrtn_4 VPB VNB VGND VPWR Q RESET_B D GATE_N
*
*
*  caps2d version: 10
*
*
*       TRANSISTOR CARDS
*
*
XM8 a_27_136##5 D#3 VGND#16 VNB sky130_fd_pr__nfet_01v8_lvt l=0.15 w=0.55 ad=0.15675 as=0.40125 pd=1.67 ps=2.98
XM0 VGND#16 GATE_N#3 a_232_98##13 VNB sky130_fd_pr__nfet_01v8_lvt l=0.15 w=0.74 ad=0.40125 as=0.2886 pd=2.98 ps=2.26
XM25 a_348_392##9 a_232_98# VGND#15 VNB sky130_fd_pr__nfet_01v8_lvt l=0.15 w=0.74 ad=0.2109 as=0.78525 pd=2.05 ps=3.95
XM5 VGND#15 a_27_136# a_666_74# VNB sky130_fd_pr__nfet_01v8_lvt l=0.15 w=0.64 ad=0.78525 as=0.1536 pd=3.95 ps=1.76
XM2 a_666_74# a_232_98##7 a_639_392##9 VNB sky130_fd_pr__nfet_01v8_lvt l=0.15 w=0.64 ad=0.1536 as=0.1915 pd=1.76 ps=1.93
XM6 a_639_392##9 a_348_392##3 a_839_74# VNB sky130_fd_pr__nfet_01v8_lvt l=0.15 w=0.42 ad=0.1915 as=0.1155 pd=1.93 ps=1.39
XM9 a_839_74# a_888_406# VGND#14 VNB sky130_fd_pr__nfet_01v8_lvt l=0.15 w=0.42 ad=0.1155 as=0.1197 pd=1.39 ps=1.41
XM14 a_1035_74##4 a_639_392##7 a_888_406##23 VNB sky130_fd_pr__nfet_01v8_lvt l=0.15 w=0.64 ad=0.1824 as=0.1792 pd=1.85 ps=1.84
XM11 a_888_406##23 a_639_392# a_1035_74##2 VNB sky130_fd_pr__nfet_01v8_lvt l=0.15 w=0.64 ad=0.1792 as=0.1792 pd=1.84 ps=1.84
XM26 VGND#13 RESET_B#7 a_1035_74##2 VNB sky130_fd_pr__nfet_01v8_lvt l=0.15 w=0.64 ad=0.1792 as=0.1792 pd=1.84 ps=1.84
XM17 a_1035_74# RESET_B#6 VGND#13 VNB sky130_fd_pr__nfet_01v8_lvt l=0.15 w=0.64 ad=0.1824 as=0.1792 pd=1.85 ps=1.84
XM23 VGND#12 a_888_406##14 Q#3 VNB sky130_fd_pr__nfet_01v8_lvt l=0.15 w=0.74 ad=0.2109 as=0.2072 pd=2.05 ps=2.04
XM16 Q#3 a_888_406##10 VGND#11 VNB sky130_fd_pr__nfet_01v8_lvt l=0.15 w=0.74 ad=0.2072 as=0.2072 pd=2.04 ps=2.04
XM10 VGND#11 a_888_406##8 Q#1 VNB sky130_fd_pr__nfet_01v8_lvt l=0.15 w=0.74 ad=0.2072 as=0.2072 pd=2.04 ps=2.04
XM18 Q#1 a_888_406##4 VGND#1 VNB sky130_fd_pr__nfet_01v8_lvt l=0.15 w=0.74 ad=0.2072 as=0.2109 pd=2.04 ps=2.05
XM22 a_27_136##7 D#1 VPWR#15 VPB sky130_fd_pr__pfet_01v8 l=0.15 w=0.84 ad=0.2478 as=0.336 pd=2.27 ps=2.48
XM7 VPWR#15 GATE_N#1 a_232_98##11 VPB sky130_fd_pr__pfet_01v8 l=0.15 w=0.84 ad=0.336 as=0.2478 pd=2.48 ps=2.27
XM20 a_348_392##8 a_232_98##4 VPWR#14 VPB sky130_fd_pr__pfet_01v8 l=0.15 w=0.84 ad=0.2478 as=0.5165 pd=2.27 ps=3.36
XM1 VPWR#14 a_27_136##3 a_561_392# VPB sky130_fd_pr__pfet_01v8 l=0.15 w=1 ad=0.5165 as=0.24 pd=3.36 ps=2.48
XM24 a_561_392# a_348_392# a_639_392##11 VPB sky130_fd_pr__pfet_01v8 l=0.15 w=1 ad=0.24 as=0.3371 pd=2.48 ps=2.78
XM21 a_639_392##11 a_232_98##8 a_747_504# VPB sky130_fd_pr__pfet_01v8 l=0.15 w=0.42 ad=0.3371 as=0.3024 pd=2.78 ps=2.28
XM13 a_747_504# a_888_406##3 VPWR#13 VPB sky130_fd_pr__pfet_01v8 l=0.15 w=0.42 ad=0.3024 as=0.4263 pd=2.28 ps=3.18
XM28 VPWR#13 a_639_392##8 a_888_406##24 VPB sky130_fd_pr__pfet_01v8 l=0.15 w=0.84 ad=0.4263 as=0.252 pd=3.18 ps=2.28
XM15 a_888_406##24 a_639_392##6 VPWR#12 VPB sky130_fd_pr__pfet_01v8 l=0.15 w=0.84 ad=0.252 as=0.294 pd=2.28 ps=2.38
XM19 VPWR#12 RESET_B#5 a_888_406##17 VPB sky130_fd_pr__pfet_01v8 l=0.15 w=0.84 ad=0.294 as=0.3108 pd=2.38 ps=2.42
XM3 a_888_406##17 RESET_B#1 VPWR#11 VPB sky130_fd_pr__pfet_01v8 l=0.15 w=0.84 ad=0.3108 as=0.4412 pd=2.42 ps=3.11
XM27 Q#5 a_888_406##16 VPWR#11 VPB sky130_fd_pr__pfet_01v8 l=0.15 w=1.12 ad=0.336 as=0.4412 pd=2.84 ps=3.11
XM12 VPWR#10 a_888_406##15 Q#5 VPB sky130_fd_pr__pfet_01v8 l=0.15 w=1.12 ad=0.392 as=0.336 pd=2.94 ps=2.84
XM29 Q#6 a_888_406##11 VPWR#10 VPB sky130_fd_pr__pfet_01v8 l=0.15 w=1.12 ad=0.448 as=0.392 pd=3.04 ps=2.94
XM4 VPWR#1 a_888_406##7 Q#6 VPB sky130_fd_pr__pfet_01v8 l=0.15 w=1.12 ad=0.3304 as=0.448 pd=2.83 ps=3.04
*
*
*       RESISTOR AND CAP/DIODE CARDS
*
Rg1	D#1	D#2	367.040985
Rg2	D#2	D#3	315.963470
Rg3	GATE_N#1	GATE_N#2	367.623138
Rg4	GATE_N#2	GATE_N#3	371.062500
Rg5	a_232_98#	a_232_98##2	380.521820
Rg6	a_232_98##2	a_232_98##3	239.068634
Rg7	a_232_98##2	a_232_98##4	394.074310
Rg8	a_27_136#	a_27_136##2	590.508362
Rg9	a_27_136##2	a_27_136##3	457.627838
Rg10	a_348_392#	a_348_392##2	571.544128
Rg11	a_232_98##5	a_232_98##6	56.207058
Rg12	a_232_98##6	a_232_98##7	816.474976
Rg13	a_232_98##6	a_232_98##8	248.803528
Rg14	a_348_392##3	a_348_392##4	382.539764
Rg15	a_888_406#	a_888_406##2	826.912720
Rg16	a_888_406##2	a_888_406##3	233.787552
Rg17	a_639_392#	a_639_392##2	392.212280
Rg18	a_639_392##2	a_639_392##3	28.735073
Rg19	a_639_392##3	a_639_392##4	10.557396
Rg20	a_639_392##4	a_639_392##5	112.157692
Rg21	a_639_392##2	a_639_392##6	412.019958
Rg22	a_639_392##3	a_639_392##7	303.228851
Rg23	a_639_392##4	a_639_392##8	416.904755
Rg24	RESET_B#1	RESET_B#2	551.549377
Rg25	RESET_B#2	RESET_B#3	20.253447
Rg26	RESET_B#3	RESET_B#4	24.170124
Rg27	RESET_B#4	RESET_B#5	628.496277
Rg28	RESET_B#2	RESET_B#6	346.544617
Rg29	RESET_B#4	RESET_B#7	400.316589
Rg30	a_888_406##4	a_888_406##5	407.617157
Rg31	a_888_406##5	a_888_406##6	74.826576
Rg32	a_888_406##5	a_888_406##7	438.414917
Rg33	a_888_406##6	a_888_406##8	348.334229
Rg34	a_888_406##6	a_888_406##9	53.356316
Rg35	a_888_406##9	a_888_406##10	342.058960
Rg36	a_888_406##6	a_888_406##11	451.334412
Rg37	a_888_406##9	a_888_406##12	49.103977
Rg38	a_888_406##12	a_888_406##13	28.588913
Rg39	a_888_406##13	a_888_406##14	353.161041
Rg40	a_888_406##12	a_888_406##15	396.976593
Rg41	a_888_406##13	a_888_406##16	584.405579
Rf1	D#2	D#5	161.093033
Rf2	D#6	D	0.860229
Rf3	D#5	D#6	5.117745
Rf4	GATE_N#2	GATE_N#5	161.261444
Rf5	GATE_N#6	GATE_N	1.028648
Rf6	GATE_N#5	GATE_N#6	2.755709
Rf7	a_27_136##2	a_27_136##6	358.289581
Rf8	a_27_136##6	a_27_136##7	91.592400
Rf9	a_27_136##5	a_27_136##6	15.000000
Rf10	a_232_98##5	a_232_98##10	355.174561
Rf11	a_232_98##10	a_232_98##11	11.530245
Rf12	a_232_98##10	a_232_98##3	26.981524
Rf13	a_232_98##3	a_232_98##13	46.519672
Rf14	a_348_392##4	a_348_392##2	200.349548
Rf15	a_348_392##2	a_348_392##7	89.698494
Rf16	a_348_392##7	a_348_392##8	21.677826
Rf17	a_348_392##7	a_348_392##9	76.827965
Rf18	a_639_392##9	a_639_392##5	119.163879
Rf19	a_639_392##5	a_639_392##11	171.165894
Rf20	a_1035_74#	a_1035_74##3	72.364853
Rf21	a_1035_74##3	a_1035_74##4	85.803810
Rf22	a_1035_74##2	a_1035_74##3	7.500000
Rf23	RESET_B	RESET_B#8	12.007017
Rf24	RESET_B#8	RESET_B	6.889272
Rf25	a_888_406##17	a_888_406##18	36.257790
Rf26	a_888_406##18	a_888_406##19	64.173325
Rf27	a_888_406##19	a_888_406##20	19.774260
Rf28	a_888_406##20	a_888_406##2	196.231674
Rf29	a_888_406##18	a_888_406##6	149.522522
Rf30	a_888_406##19	a_888_406##23	78.301468
Rf31	a_888_406##20	a_888_406##24	20.106098
Rf32	Q#2	Q#3	85.178810
Rf33	Q#2	Q	18.928499
Rf34	Q	Q#4	54.339165
Rf35	Q#4	Q#5	88.292534
Rf36	Q#4	Q#6	15.649860
Rf37	Q#1	Q#2	7.500000
Rf38	VGND#1	VGND#2	91.681602
Rf39	VGND#2	VGND#3	21.890615
Rf40	VGND#3	VGND#4	40.883747
Rf41	VGND#4	VGND#5	72.270927
Rf42	VGND#5	VGND#6	135.094360
Rf43	VGND#6	VGND#7	102.246162
Rf44	VGND#7	VGND#8	47.114872
Rf45	VGND#8	VGND#9	140.960220
Rf47	VGND#2	VGND#11	36.279022
Rf48	VGND#4	VGND#12	31.534733
Rf49	VGND#5	VGND#13	31.948624
Rf50	VGND#6	VGND#14	31.948624
Rf51	VGND#8	VGND#15	11.448893
Rf52	VGND#9	VGND#16	24.468842
Rf53	VPWR#1	VPWR#2	109.104454
Rf54	VPWR#2	VPWR#3	70.213516
Rf55	VPWR#3	VPWR#4	77.019211
Rf56	VPWR#4	VPWR#5	87.716057
Rf57	VPWR#5	VPWR#6	116.595528
Rf58	VPWR#6	VPWR#7	68.642937
Rf59	VPWR#7	VPWR#8	117.562233
Rf61	VPWR#2	VPWR#10	34.835796
Rf62	VPWR#3	VPWR#11	36.061970
Rf63	VPWR#4	VPWR#12	36.061970
Rf64	VPWR#5	VPWR#13	15.738539
Rf65	VPWR#7	VPWR#14	23.681496
Rf66	VPWR#8	VPWR#15	41.179714
Rf75	RESET_B#3	RESET_B#8	80.116402
Re1	VPWR#2	VPWR	2.920302
Re2	VPWR	VPWR#6	1.251558
Re3	VGND#3	VGND	2.920302
Re4	VGND	VGND#7	1.251558
*
*       CAPACITOR CARDS
*
*
C1	a_888_406##6	Q#6	3.93607e-18
C2	a_888_406##18	Q#6	2.13854e-24
C3	VGND	VNB	3.01404e-16
C4	VPWR	VNB	2.95329e-16
C5	Q	VNB	6.24523e-17
C6	RESET_B	VNB	9.5201e-18
C7	D	VNB	2.04752e-18
C8	VGND#8	a_232_98##7	3.26619e-18
C9	GATE_N	VNB	1.35379e-18
C10	VGND	RESET_B	2.38329e-18
C11	a_27_136##7	GATE_N#1	3.97501e-20
C12	VGND	D	1.90393e-18
C13	VGND	GATE_N	1.01589e-18
C14	a_232_98##11	D#1	2.58647e-20
C15	VGND#14	a_888_406##2	2.79999e-19
C16	VPWR	D	1.27756e-18
C17	RESET_B	Q	1.08246e-18
C18	VPWR	GATE_N	7.87604e-19
C19	a_639_392##9	a_27_136#	7.25141e-18
C20	D#2	VNB	4.20477e-17
C21	VPWR#10	a_888_406##13	2.39285e-20
C22	GATE_N#2	VNB	3.61994e-17
C23	a_232_98##3	VNB	4.64551e-17
C24	a_27_136##2	VNB	5.1018e-17
C25	a_348_392##2	VNB	3.37273e-17
C26	a_888_406##9	a_888_406##5	3.61838e-18
C27	a_232_98##5	VNB	3.1405e-17
C28	a_348_392##4	VNB	4.64972e-17
C29	a_348_392##8	VPWR#14	9.94719e-19
C30	a_888_406##2	VNB	6.91411e-17
C31	VGND#5	a_1035_74##2	3.55908e-17
C32	a_639_392##5	VNB	1.50392e-16
C33	GATE_N#1	VPWR#15	2.53852e-17
C34	RESET_B#3	VNB	5.46259e-17
C35	a_888_406##6	VNB	7.56467e-18
C36	a_639_392##9	a_639_392##5	6.59381e-18
C37	VGND#7	VNB	2.68278e-17
C38	VPWR#6	VNB	3.49862e-17
C39	Q#3	VGND#11	4.82069e-17
C40	VGND#3	VNB	1.60532e-16
C41	VGND	a_232_98##3	1.88322e-18
C42	VPWR#2	VNB	1.87713e-16
C43	VGND	a_27_136##2	2.50127e-17
C44	D#1	VNB	3.95987e-17
C45	VGND	a_348_392##2	1.2322e-17
C46	GATE_N#1	VNB	3.60188e-17
C47	a_232_98##4	VNB	3.5373e-17
C48	a_27_136##3	VNB	3.60521e-17
C49	VGND	a_348_392##4	5.62136e-18
C50	VGND#8	VGND#6	2.69764e-19
C51	a_348_392#	VNB	3.41978e-17
C52	VPWR	D#2	4.63624e-21
C53	a_232_98##8	VNB	2.61395e-17
C54	a_888_406##3	VNB	2.54949e-17
C55	VPWR	GATE_N#2	4.63624e-20
C56	VGND	a_639_392##5	1.22004e-17
C57	a_888_406##20	a_232_98##8	2.75355e-19
C58	a_639_392##8	VNB	3.81764e-17
C59	a_27_136##7	a_232_98##4	3.46655e-20
C60	a_639_392##6	VNB	3.30789e-17
C61	VPWR	a_232_98##3	1.70308e-18
C62	VGND#13	VGND#4	6.15133e-20
C63	RESET_B#5	VNB	3.77457e-17
C64	VGND#6	a_348_392##3	5.64583e-18
C65	RESET_B#1	VNB	4.55946e-17
C66	VPWR	a_27_136##2	3.54699e-18
C67	VGND	VGND#7	5.16497e-17
C68	a_888_406##16	VNB	4.05304e-17
C69	a_232_98##11	GATE_N#1	5.89341e-17
C70	a_888_406##15	VNB	2.9138e-17
C71	VPWR	a_348_392##2	7.94308e-18
C72	a_888_406##11	VNB	2.77327e-17
C73	a_888_406##7	VNB	3.5345e-17
C74	VPWR	a_232_98##5	3.32495e-17
C75	D#3	VNB	3.46892e-17
C76	VPWR	a_348_392##4	3.42519e-18
C77	a_232_98##13	a_348_392##9	2.62076e-17
C78	GATE_N#3	VNB	3.43518e-17
C79	a_232_98#	VNB	3.49654e-17
C80	VPWR	a_888_406##2	6.64828e-18
C81	a_27_136#	VNB	3.48443e-17
C82	a_232_98##7	VNB	4.12026e-17
C83	VPWR	a_639_392##5	9.81794e-18
C84	a_348_392##3	VNB	2.45526e-17
C85	a_888_406#	VNB	4.66136e-17
C86	VGND#14	a_639_392##5	3.46887e-17
C87	a_639_392##7	VNB	3.10562e-17
C88	a_232_98##11	a_639_392##11	4.72591e-20
C89	a_639_392#	VNB	2.51653e-17
C90	RESET_B#7	VNB	2.03374e-17
C91	a_232_98##7	a_639_392##9	1.77481e-17
C92	RESET_B#6	VNB	2.37297e-17
C93	VPWR#15	a_232_98##4	1.19445e-18
C94	a_888_406##14	VNB	2.85896e-17
C95	VPWR	VPWR#6	6.85903e-17
C96	a_888_406##10	VNB	2.55932e-17
C97	a_888_406##8	VNB	2.45105e-17
C98	a_348_392##8	GATE_N#1	6.48333e-19
C99	a_888_406##4	VNB	3.24352e-17
C100	a_27_136##7	VNB	5.7139e-17
C101	VPWR#15	VNB	1.61861e-17
C102	a_232_98##11	VNB	1.87525e-17
C103	a_639_392##11	a_232_98##6	3.43806e-17
C104	D	D#2	4.32979e-18
C105	a_348_392##8	VNB	4.77368e-18
C106	VGND#14	a_27_136#	2.24287e-19
C107	VPWR	D#1	8.33394e-18
C108	a_639_392##5	a_1035_74##4	3.47607e-17
C109	a_639_392##11	VNB	3.93889e-18
C110	D	GATE_N#2	3.4008e-18
C111	VGND#8	a_348_392##3	9.65779e-19
C112	VPWR	GATE_N#1	8.12451e-18
C113	a_888_406##6	Q	3.44799e-17
C114	VPWR	a_232_98##4	8.10029e-18
C115	VPWR#12	VNB	4.51231e-18
C116	VPWR	a_27_136##3	5.1952e-19
C117	a_888_406##17	VNB	7.2776e-18
C118	VGND	D#3	8.49235e-18
C119	VPWR#11	VNB	5.64169e-18
C120	VGND	GATE_N#3	9.47289e-18
C121	VPWR	a_348_392#	2.08345e-18
C122	Q#5	VNB	2.1411e-18
C123	VPWR#10	VNB	9.57318e-19
C124	VGND	a_232_98#	9.48942e-18
C125	a_232_98##11	a_232_98##4	1.37794e-17
C126	Q#3	Q#1	2.61382e-18
C127	Q#6	VNB	5.49529e-18
C128	VPWR	a_232_98##8	1.0411e-17
C129	VGND	a_27_136#	2.71678e-18
C130	VGND#3	Q	6.20337e-18
C131	VPWR#1	VNB	7.28779e-17
C132	a_27_136##5	VNB	5.58491e-17
C133	GATE_N	GATE_N#2	3.43811e-18
C134	VGND	a_232_98##7	1.41349e-18
C135	VPWR	a_888_406##3	4.06638e-18
C136	RESET_B	a_639_392##5	6.58047e-18
C137	VPWR#2	Q	4.71486e-18
C138	VGND	a_348_392##3	6.41893e-20
C139	a_232_98##13	VNB	3.87533e-18
C140	VPWR	a_639_392##8	8.79255e-18
C141	a_888_406##23	a_639_392##5	1.94825e-17
C142	a_348_392##9	VNB	3.09968e-18
C143	VGND	a_888_406#	5.86504e-19
C144	RESET_B	RESET_B#3	2.77172e-17
C145	a_888_406##16	a_888_406##13	5.21869e-18
C146	GATE_N	a_232_98##3	3.53386e-17
C147	VPWR	a_639_392##6	8.79255e-18
C148	VGND	a_639_392##7	1.59466e-18
C149	a_639_392##9	VNB	6.63546e-18
C150	VGND	a_639_392#	1.33384e-18
C151	VPWR	RESET_B#5	4.80309e-18
C152	RESET_B	a_888_406##6	4.51164e-17
C153	a_232_98##5	a_232_98##6	4.11248e-19
C154	VGND	RESET_B#7	7.22591e-19
C155	VGND#14	VNB	3.8374e-18
C156	a_1035_74##4	VNB	8.44822e-18
C157	a_888_406##23	VNB	2.34756e-18
C158	a_1035_74##2	VNB	2.64724e-18
C159	VGND#13	VNB	8.10325e-20
C160	a_348_392##8	a_639_392##11	5.38265e-18
C161	VPWR#2	a_888_406##17	8.61959e-18
C162	VPWR#15	a_27_136##3	6.7381e-19
C163	a_1035_74#	VNB	9.73917e-18
C164	VGND#12	VNB	6.612e-18
C165	Q#3	VNB	4.88457e-18
C166	VGND#3	RESET_B	7.70485e-18
C167	VGND#11	VNB	4.05133e-20
C168	a_348_392##8	a_232_98##4	4.68651e-17
C169	a_1035_74##2	a_639_392##5	2.23607e-19
C170	Q#1	VNB	5.39447e-18
C171	VGND#1	VNB	4.80535e-17
C172	D#5	VNB	1.30925e-18
C173	a_888_406##20	a_888_406##3	1.33854e-18
C174	VGND	a_348_392##8	2.02505e-18
C175	a_639_392##9	a_348_392##3	3.83534e-17
C176	VPWR#1	a_888_406##5	7.34611e-19
C177	VGND#4	a_1035_74#	5.78799e-18
C178	VGND	a_639_392##11	3.19525e-18
C179	VGND#6	a_888_406#	3.78301e-18
C180	VPWR#2	VPWR#11	2.08863e-17
C181	a_232_98##11	a_27_136##3	2.61537e-17
C182	VGND#14	a_232_98##7	4.53769e-19
C183	a_232_98##4	VPWR#14	2.20997e-17
C184	a_888_406##18	VNB	4.76567e-18
C185	a_888_406##19	VNB	2.38036e-18
C186	a_888_406##20	VNB	3.25724e-18
C187	Q	a_888_406##11	7.37117e-19
C188	VGND#12	VGND#2	7.63531e-20
C189	Q	a_888_406##7	3.03011e-18
C190	Q#4	VNB	1.51413e-18
C191	VGND	a_27_136##5	3.44092e-17
C192	VGND#2	VNB	2.38094e-17
C193	VGND#4	VNB	2.71707e-17
C194	VGND	a_232_98##13	7.03676e-18
C195	VGND#5	VNB	4.46122e-17
C196	VGND	a_348_392##9	5.77472e-18
C197	Q#5	VPWR#2	2.65866e-17
C198	VGND#6	VNB	5.34576e-17
C199	VGND#8	VNB	5.48558e-17
C200	Q#1	VGND#11	5.89706e-17
C201	VPWR	a_27_136##7	1.8223e-17
C202	VPWR#3	VNB	3.14491e-17
C203	VGND	a_639_392##9	2.29059e-17
C204	a_348_392##8	a_27_136##3	1.29593e-17
C205	VPWR#4	VNB	3.19623e-17
C206	VPWR#5	VNB	5.85497e-17
C207	VPWR#7	VNB	5.15974e-17
C208	VGND	VGND#14	1.82433e-17
C209	VPWR	a_232_98##11	4.23952e-17
C210	VGND	a_1035_74##4	2.47761e-17
C211	VGND#8	a_888_406#	5.29334e-19
C212	VPWR	a_348_392##8	1.0482e-17
C213	VGND	a_888_406##23	7.11307e-18
C214	VGND	a_1035_74##2	2.13743e-17
C215	VGND	VGND#13	1.03747e-17
C216	VGND	a_1035_74#	5.23536e-19
C217	VPWR	a_639_392##11	7.00796e-18
C218	VPWR#2	VPWR#10	2.15991e-17
C219	a_1035_74##2	RESET_B#3	1.21858e-18
C220	D#3	GATE_N#3	2.0631e-17
C221	a_888_406##20	a_232_98##6	1.60759e-19
C222	a_232_98##11	a_348_392#	2.65395e-19
C223	a_639_392##9	a_888_406#	1.63876e-17
C224	VPWR	VPWR#12	2.12256e-17
C225	VGND	D#5	1.74967e-18
C226	a_27_136##3	VPWR#14	1.70453e-17
C227	VPWR	a_888_406##17	9.55539e-18
C228	Q#3	a_639_392##5	9.88412e-20
C229	Q	a_888_406##14	1.86931e-20
C230	a_639_392##11	a_232_98##4	9.98464e-19
C231	VGND#5	a_1035_74#	9.06505e-18
C232	VGND	GATE_N#5	2.51584e-18
C233	Q	a_888_406##10	1.38421e-20
C234	Q	a_888_406##8	5.52771e-20
C235	VGND#13	RESET_B#3	8.67494e-19
C236	VPWR#7	a_232_98##4	4.64912e-18
C237	VGND#14	a_348_392##3	3.17046e-18
C238	a_888_406##20	a_639_392##8	4.20202e-17
C239	Q#6	VPWR#2	3.41621e-17
C240	Q	a_888_406##4	1.15012e-17
C241	VGND#7	a_639_392##9	1.24832e-17
C242	a_348_392##8	a_348_392#	6.41189e-19
C243	VGND#6	a_639_392##7	4.48047e-18
C244	a_1035_74#	RESET_B#3	3.25386e-18
C245	VGND	a_888_406##18	2.7613e-18
C246	VGND	a_888_406##19	3.74162e-18
C247	VPWR#2	VPWR#1	7.50824e-17
C248	VGND#11	VGND#1	2.76823e-18
C249	a_232_98##11	a_232_98##8	2.6049e-19
C250	Q#4	VPWR#10	2.28989e-17
C251	RESET_B	a_888_406##14	1.59668e-18
C252	a_1035_74##4	a_348_392##3	1.95044e-19
C253	RESET_B	a_888_406##10	2.78491e-19
C254	a_348_392##4	a_232_98##6	1.2275e-19
C255	a_639_392##11	a_27_136##3	2.04352e-18
C256	VGND	VGND#5	5.50311e-17
C257	RESET_B	a_888_406##8	1.22803e-20
C258	a_639_392##9	a_639_392##7	2.85945e-19
C259	VGND	VGND#6	9.82335e-17
C260	VGND	VGND#8	1.28635e-16
C261	RESET_B	a_888_406##4	1.60299e-20
C262	GATE_N#3	a_232_98#	4.55876e-18
C263	a_232_98##2	VNB	2.29799e-17
C264	a_348_392##2	a_561_392#	1.73165e-18
C265	a_232_98##6	VNB	4.13024e-17
C266	VPWR	D#5	2.06149e-18
C267	Q#3	RESET_B#3	4.97352e-19
C268	Q	VPWR#1	3.62393e-17
C269	RESET_B#4	VNB	2.87601e-17
C270	VGND#14	a_888_406#	2.91582e-17
C271	a_888_406##5	VNB	3.75336e-17
C272	D#2	GATE_N#2	2.45823e-17
C273	a_888_406##9	VNB	4.88377e-17
C274	VGND#5	a_639_392#	4.40374e-18
C275	VPWR	GATE_N#5	2.50745e-18
C276	a_232_98##5	a_561_392#	3.72689e-18
C277	VPWR#5	a_27_136##3	6.48328e-19
C278	a_888_406##13	VNB	4.87228e-17
C279	Q#1	Q#4	9.41497e-19
C280	VPWR#5	VPWR#13	1.30033e-17
C281	a_232_98##3	D#2	2.53556e-19
C282	VGND#8	a_232_98##3	1.45256e-19
C283	a_348_392##9	a_232_98##2	1.18436e-17
C284	a_232_98##5	a_747_504#	8.54323e-18
C285	a_888_406##20	a_639_392##6	3.65872e-17
C286	a_639_392##9	a_348_392##9	4.56574e-21
C287	a_639_392##11	a_348_392#	3.00363e-17
C288	GATE_N#2	a_232_98##3	2.95849e-17
C289	VPWR#7	a_27_136##3	1.63913e-17
C290	VGND#1	Q#1	2.66062e-17
C291	D	VPWR#15	2.39452e-17
C292	a_1035_74##4	a_888_406#	2.15204e-18
C293	VPWR	a_888_406##18	1.32785e-18
C294	VGND#12	a_888_406##6	6.16676e-18
C295	a_888_406##18	RESET_B#5	2.01107e-18
C296	VPWR	a_888_406##19	2.18114e-18
C297	VPWR	a_888_406##20	2.06123e-17
C298	a_888_406##18	RESET_B#4	1.67272e-17
C299	Q#4	Q#6	9.02732e-18
C300	a_27_136##2	a_232_98##3	3.41006e-18
C301	Q	VGND#1	3.24809e-17
C302	VGND#14	a_639_392##7	1.74417e-18
C303	a_232_98#	a_27_136#	3.57109e-18
C304	a_888_406##6	Q#3	4.20359e-17
C305	a_888_406##19	RESET_B#5	2.66224e-19
C306	a_232_98##8	a_639_392##11	1.02124e-17
C307	a_888_406##23	a_888_406#	5.04291e-19
C308	a_232_98##2	a_27_136##3	9.519e-19
C309	a_888_406##6	VGND#11	3.12094e-18
C310	VPWR	VPWR#4	6.20234e-17
C311	VPWR	VPWR#5	1.42822e-16
C312	VPWR	VPWR#7	9.18634e-17
C313	GATE_N	a_232_98##11	1.39583e-17
C314	a_27_136##2	a_348_392##2	8.47479e-17
C315	VGND#5	RESET_B#7	1.21626e-18
C316	VPWR#5	a_348_392#	1.24941e-18
C317	a_888_406##23	RESET_B	5.93018e-18
C318	a_1035_74##4	a_639_392##7	5.79945e-17
C319	a_1035_74##2	RESET_B	2.49226e-17
C320	a_888_406##6	Q#1	5.95854e-17
C321	a_888_406##20	RESET_B#5	2.93035e-18
C322	a_232_98##5	a_27_136##2	1.7138e-19
C323	RESET_B	VGND#13	2.78907e-18
C324	VGND#8	a_27_136##2	7.7151e-17
C325	VPWR#7	a_232_98##3	9.55877e-20
C326	RESET_B	a_1035_74#	6.07974e-17
C327	a_27_136##5	D	5.89861e-18
C328	VGND#12	RESET_B	2.09274e-17
C329	a_232_98##6	a_888_406##2	4.27751e-18
C330	a_232_98##5	a_888_406##20	2.75126e-18
C331	RESET_B	Q#3	2.84571e-18
C332	a_27_136##2	a_348_392##4	1.70438e-19
C333	a_348_392##2	a_232_98##5	1.01123e-17
C334	a_888_406##13	a_888_406##11	1.34886e-18
C335	a_888_406##18	RESET_B#1	2.77008e-18
C336	VPWR#7	a_348_392#	2.2335e-18
C337	VGND#14	a_639_392#	1.86105e-19
C338	a_27_136#	a_232_98##7	5.8274e-17
C339	Q#4	VPWR#1	1.32854e-17
C340	a_639_392##7	a_888_406##23	1.67592e-17
C341	Q	Q#4	2.89691e-19
C342	VGND#2	Q#1	1.13172e-17
C343	a_27_136##2	a_639_392##5	4.54575e-19
C344	a_348_392##2	a_888_406##2	1.00385e-19
C345	a_888_406##19	RESET_B#1	1.08663e-19
C346	a_348_392##4	a_232_98##5	9.79631e-18
C347	VGND#13	a_888_406#	3.70136e-20
C348	a_27_136#	a_666_74#	1.50481e-17
C349	a_1035_74##4	a_639_392#	1.25999e-18
C350	a_27_136##3	a_561_392#	1.89205e-17
C351	a_232_98##7	a_666_74#	1.50481e-17
C352	a_348_392##2	a_639_392##5	5.29203e-19
C353	a_232_98##5	a_888_406##2	5.89388e-17
C354	a_348_392#	a_561_392#	1.89205e-17
C355	a_639_392##11	a_639_392##8	4.08196e-20
C356	a_888_406##13	a_888_406##9	3.94071e-18
C357	VGND#5	RESET_B#6	9.40368e-19
C358	a_1035_74##2	a_639_392##7	1.22695e-18
C359	VGND#2	a_888_406##14	7.17035e-19
C360	a_232_98##13	GATE_N	1.06448e-17
C361	a_888_406##3	VPWR#13	1.36871e-17
C362	VGND#14	RESET_B#7	2.59328e-20
C363	a_888_406##20	RESET_B#1	4.02692e-19
C364	a_888_406##17	VPWR#3	7.27946e-18
C365	VPWR#5	a_232_98##8	3.46935e-18
C366	a_888_406##19	RESET_B#4	2.04806e-18
C367	a_639_392##5	a_232_98##5	2.28672e-17
C368	a_348_392##4	a_888_406##2	1.4425e-17
C369	VGND#3	VGND#13	5.36597e-18
C370	VGND#8	a_348_392##2	8.08148e-18
C371	a_27_136##5	a_27_136##7	3.12481e-18
C372	VPWR#5	VPWR#12	3.24317e-18
C373	VPWR#7	a_27_136##2	3.15949e-19
C374	RESET_B	a_888_406##18	8.41265e-17
C375	a_639_392#	a_888_406##23	1.43049e-17
C376	a_888_406##18	a_888_406##16	8.9052e-19
C377	a_888_406##19	RESET_B	8.06383e-18
C378	a_348_392##4	a_639_392##5	4.18638e-17
C379	a_232_98##7	a_348_392##3	2.65989e-17
C380	VPWR#6	a_27_136##2	2.58644e-20
C381	a_232_98##8	a_747_504#	1.23982e-17
C382	VPWR#7	a_232_98##8	1.7621e-18
C383	D	GATE_N#5	2.83807e-17
C384	VGND#3	a_1035_74#	1.58009e-17
C385	VGND#7	a_348_392##2	2.52125e-18
C386	VGND#13	a_639_392##7	1.14963e-19
C387	VGND#4	a_888_406##14	3.78885e-18
C388	a_639_392##5	a_888_406##2	1.25158e-16
C389	a_888_406##3	a_747_504#	7.43026e-18
C390	VGND#2	VGND#1	1.15097e-18
C391	a_639_392##8	VPWR#13	9.41936e-18
C392	VPWR#6	a_348_392##2	4.92195e-20
C393	a_888_406##17	VPWR#4	9.81747e-18
C394	VGND#4	RESET_B	1.44113e-18
C395	VGND#7	a_232_98##5	5.59763e-20
C396	VGND#3	VGND#12	2.15172e-17
C397	VPWR#12	a_888_406##3	1.74204e-19
C398	a_1035_74##2	a_639_392#	4.6574e-17
C399	a_348_392#	a_232_98##6	1.76329e-17
C400	a_27_136##5	VPWR#15	5.04543e-18
C401	a_639_392##5	a_232_98##6	1.08819e-19
C402	GATE_N#2	a_232_98##4	1.43746e-19
C403	a_348_392##3	a_839_74#	9.10064e-18
C404	a_232_98##5	VPWR#6	2.31165e-17
C405	VGND#7	a_348_392##4	4.90138e-19
C406	VGND#3	Q#3	2.54394e-17
C407	a_888_406##19	a_888_406##2	1.19764e-20
C408	a_639_392##8	a_888_406##24	1.77983e-17
C409	a_888_406#	a_839_74#	9.10064e-18
C410	VGND#2	a_888_406##10	3.4588e-18
C411	a_888_406##23	RESET_B#7	8.52214e-19
C412	a_888_406##20	a_888_406##2	5.44345e-19
C413	VPWR#5	a_888_406##3	2.60277e-17
C414	a_888_406##6	a_639_392##5	6.65272e-19
C415	VGND#13	a_639_392#	1.12753e-18
C416	a_888_406##18	a_888_406##15	5.53612e-19
C417	a_348_392##3	a_888_406#	3.32836e-17
C418	VPWR#12	a_639_392##8	1.39041e-18
C419	a_888_406##6	RESET_B#3	1.57556e-18
C420	VGND#3	Q#1	1.56583e-17
C421	a_1035_74##2	RESET_B#7	2.65061e-17
C422	VPWR#7	a_888_406##3	9.6649e-19
C423	Q#4	RESET_B#1	3.35629e-19
C424	a_639_392##6	a_888_406##24	1.77983e-17
C425	a_888_406##18	a_639_392##5	5.79153e-19
C426	a_1035_74#	a_639_392#	1.94223e-19
C427	a_639_392##9	VGND#14	1.02865e-17
C428	VGND#3	VGND#1	5.9273e-17
C429	a_888_406##23	RESET_B#6	5.21325e-19
C430	GATE_N#3	a_232_98##2	8.5758e-20
C431	a_888_406##19	a_639_392##5	8.71523e-17
C432	VPWR#12	a_639_392##6	1.78477e-17
C433	a_639_392##5	RESET_B#4	3.81108e-17
C434	a_348_392##2	a_27_136##3	1.26654e-17
C435	VGND#13	RESET_B#7	2.44726e-17
C436	VGND#2	a_888_406##8	4.50572e-18
C437	VGND#6	a_348_392##4	2.76497e-19
C438	a_232_98##5	a_232_98##4	3.35944e-19
C439	a_888_406##20	a_639_392##5	1.54207e-17
C440	a_348_392##2	a_348_392#	1.01823e-17
C441	a_888_406##18	a_888_406##11	3.6009e-19
C442	a_888_406#	a_639_392##7	4.37201e-18
C443	Q#5	VPWR#3	8.48858e-18
C444	VPWR#7	a_232_98##2	6.10282e-21
C445	a_232_98##5	VPWR#5	1.63504e-17
C446	a_1035_74##2	RESET_B#6	4.33069e-19
C447	a_888_406##17	a_639_392##6	1.11755e-18
C448	VPWR#5	a_639_392##8	1.65118e-17
C449	a_232_98##5	a_27_136##3	4.99238e-19
C450	VGND#3	a_888_406##6	1.08967e-17
C451	a_232_98##5	VPWR#7	1.4014e-18
C452	a_639_392##9	a_1035_74##4	1.65961e-18
C453	a_1035_74#	RESET_B#7	4.51683e-19
C454	a_232_98##5	a_348_392#	2.17434e-17
C455	a_888_406##23	a_888_406##14	2.84035e-19
C456	Q#4	a_888_406##16	5.67843e-19
C457	VPWR#12	RESET_B#5	5.57846e-17
C458	a_232_98##13	a_232_98##11	3.16988e-18
C459	VPWR#2	a_888_406##6	1.06464e-17
C460	a_888_406##18	RESET_B#3	2.60475e-17
C461	Q#3	a_639_392#	2.12344e-19
C462	a_232_98##5	a_232_98##8	1.45248e-17
C463	VGND#13	RESET_B#6	2.73556e-17
C464	a_232_98##5	a_888_406##3	7.25691e-18
C465	Q	a_888_406##5	1.58801e-17
C466	RESET_B#5	a_888_406##17	2.96793e-17
C467	Q	a_888_406##9	6.22005e-19
C468	Q	a_888_406##13	3.04814e-19
C469	VPWR#4	a_639_392##6	4.00991e-18
C470	a_1035_74##2	a_888_406##14	6.33968e-20
C471	VGND#2	a_888_406##4	8.12685e-19
C472	a_232_98##5	a_639_392##8	5.07257e-19
C473	a_639_392##7	a_639_392#	3.37449e-17
C474	a_888_406##18	a_888_406##7	2.71397e-19
C475	VPWR#12	RESET_B#1	2.03949e-18
C476	VPWR#12	a_888_406##17	7.83586e-17
C477	VPWR#11	RESET_B#5	1.81463e-18
C478	a_1035_74#	RESET_B#6	3.03732e-17
C479	VPWR#3	VPWR#10	1.35121e-19
C480	VPWR#5	a_348_392##4	3.60631e-19
C481	VPWR#5	a_639_392##6	1.64835e-18
C482	Q#3	RESET_B#7	2.70044e-19
C483	a_888_406##17	RESET_B#1	2.48507e-17
C484	VGND#13	a_888_406##14	5.58073e-19
C485	Q#4	a_888_406##15	1.00108e-18
C486	RESET_B#4	RESET_B#3	6.63588e-18
C487	a_232_98##3	D#3	9.62269e-20
C488	VPWR#4	VPWR#3	9.87363e-19
C489	a_639_392##9	a_232_98##6	8.56243e-20
C490	VGND#12	RESET_B#6	2.89666e-18
C491	VPWR#12	a_888_406##16	5.62548e-19
C492	a_888_406##2	a_639_392##8	1.0691e-17
C493	VPWR#12	VPWR#11	2.77005e-18
C494	a_232_98##3	GATE_N#3	2.65419e-19
C495	a_348_392##9	a_348_392##8	2.65967e-18
C496	a_232_98##11	a_561_392#	5.35081e-19
C497	RESET_B#1	VPWR#11	2.96895e-17
C498	VGND#14	a_1035_74##4	3.38671e-17
C499	VGND#5	a_639_392##5	1.30055e-19
C500	a_888_406##19	a_888_406##13	1.35996e-18
C501	a_232_98##3	a_232_98#	5.1378e-21
C502	a_1035_74#	a_888_406##14	1.11856e-18
C503	Q#4	RESET_B#3	7.54222e-20
C504	a_27_136##2	D#3	3.30267e-19
C505	a_639_392#	RESET_B#7	3.35372e-17
C506	VPWR#4	RESET_B#5	1.92289e-18
C507	VGND#12	a_888_406##13	2.52987e-18
C508	a_888_406##17	a_888_406##16	1.52923e-18
C509	VGND#6	a_639_392##5	1.31807e-18
C510	Q#3	a_888_406##9	1.13305e-18
C511	a_27_136##2	GATE_N#3	5.61136e-19
C512	Q#3	RESET_B#6	7.86707e-19
C513	Q#5	RESET_B#1	1.1526e-18
C514	a_888_406##2	VPWR#5	4.1988e-17
C515	a_27_136##2	a_232_98#	4.22475e-17
C516	a_888_406##17	VPWR#11	6.1243e-17
C517	VPWR#5	RESET_B#5	5.05234e-19
C518	VGND#8	a_27_136##5	1.6559e-18
C519	RESET_B	RESET_B#4	1.12307e-17
C520	a_888_406##16	VPWR#11	2.90007e-17
C521	VGND#12	a_888_406##14	5.52223e-17
C522	Q#4	a_888_406##11	1.8182e-17
C523	RESET_B#3	a_888_406##13	1.2858e-17
C524	a_639_392##5	RESET_B#5	4.42062e-18
C525	RESET_B	a_888_406##5	8.81646e-20
C526	a_27_136##2	a_27_136#	7.33726e-18
C527	RESET_B	a_888_406##9	1.47993e-19
C528	VPWR#10	RESET_B#1	3.35732e-19
C529	a_27_136##5	D#5	3.30431e-17
C530	RESET_B	a_888_406##13	1.37134e-17
C531	VPWR#6	a_348_392#	6.9322e-18
C532	a_27_136##2	a_232_98##7	4.24359e-18
C533	VPWR#3	RESET_B#1	9.16194e-18
C534	Q#5	a_888_406##16	5.26927e-17
C535	a_27_136##7	a_232_98##2	1.73327e-20
C536	a_27_136##2	a_348_392##3	7.36627e-19
C537	VGND#5	RESET_B#3	1.31797e-19
C538	VPWR#6	a_232_98##8	7.55521e-18
C539	a_888_406##14	Q#3	2.25912e-17
C540	a_348_392##2	a_27_136#	3.66822e-17
C541	a_888_406##6	Q#4	7.44655e-17
C542	a_888_406##17	Q#5	3.35403e-18
C543	RESET_B#7	RESET_B#6	3.36089e-17
C544	D#1	GATE_N#1	2.42732e-17
C545	VPWR#11	a_888_406##15	7.67963e-19
C546	a_27_136##2	a_888_406#	9.2621e-20
C547	a_27_136##7	D#2	3.99522e-18
C548	a_348_392##2	a_232_98##7	2.25757e-17
C549	VPWR#10	a_888_406##16	7.67963e-19
C550	VPWR#4	a_639_392##5	2.24341e-20
C551	VGND#12	a_888_406##10	2.02447e-18
C552	VPWR#15	D#2	4.07266e-18
C553	RESET_B#3	a_888_406##16	5.73564e-18
C554	a_1035_74##4	a_888_406##23	4.94501e-17
C555	a_232_98##5	a_27_136#	7.18165e-20
C556	a_639_392##5	VPWR#5	3.57615e-18
C557	a_232_98##11	D#2	1.03459e-19
C558	Q#5	a_888_406##15	7.28699e-17
C559	Q#4	a_888_406##7	1.65774e-17
C560	a_888_406##6	a_888_406##5	1.19638e-17
C561	VGND#11	a_888_406##14	1.47992e-18
C562	VPWR#11	Q#5	8.055e-17
C563	GATE_N#1	a_232_98##4	5.17227e-18
C564	VGND#7	a_232_98##6	1.41117e-20
C565	a_27_136##7	GATE_N#2	2.2525e-19
C566	a_888_406##6	a_888_406##16	9.60097e-18
C567	VGND#4	a_888_406##6	4.055e-19
C568	VPWR#11	a_888_406##11	2.81672e-19
C569	a_888_406##6	a_888_406##9	2.84039e-17
C570	Q#3	a_888_406##13	2.63353e-18
C571	a_1035_74##4	a_888_406##19	1.35466e-18
C572	Q#3	a_888_406##10	2.46905e-17
C573	VPWR#5	VPWR#4	1.15405e-18
C574	VPWR#3	a_888_406##16	4.6113e-18
C575	VGND#11	a_888_406##9	9.23073e-19
C576	a_888_406##15	VPWR#10	2.6699e-17
C577	GATE_N#1	a_27_136##3	5.55785e-19
C578	Q#1	a_888_406##14	2.68339e-19
C579	a_888_406##18	VPWR#3	2.76358e-19
C580	RESET_B#6	a_888_406##14	4.31976e-18
C581	a_232_98##11	GATE_N#2	4.39242e-18
C582	VGND#14	VGND#13	1.16777e-20
C583	a_348_392##4	a_232_98##7	4.82374e-17
C584	VPWR#3	RESET_B#3	3.99304e-20
C585	a_1035_74##4	a_1035_74##2	3.1466e-18
C586	Q#5	a_888_406##11	1.58431e-18
C587	a_348_392##8	GATE_N#2	2.26797e-20
C588	a_888_406##6	a_888_406##11	5.08413e-19
C589	a_888_406##6	a_888_406##13	2.86709e-17
C590	a_27_136##7	a_232_98##3	8.3149e-19
C591	Q#6	a_888_406##15	5.01611e-19
C592	VPWR#11	VPWR#10	1.60753e-18
C593	a_232_98##4	a_27_136##3	2.11992e-17
C594	VGND#11	a_888_406##10	2.76241e-17
C595	VPWR#4	RESET_B#3	1.01223e-19
C596	a_888_406##6	a_888_406##7	2.39447e-19
C597	VGND#3	a_888_406##18	2.75572e-18
C598	a_348_392##4	a_888_406#	2.9349e-17
C599	VPWR#10	a_888_406##11	5.65601e-17
C600	a_1035_74##4	a_888_406##20	4.36352e-18
C601	Q#3	a_888_406##8	4.20518e-19
C602	a_232_98##3	a_232_98##11	3.3817e-18
C603	VPWR#5	a_888_406##16	4.26321e-20
C604	a_27_136##5	GATE_N#5	6.42972e-18
C605	Q#1	a_888_406##5	2.77688e-18
C606	a_232_98##3	a_348_392##8	3.28466e-17
C607	a_639_392##5	a_27_136#	4.15643e-19
C608	Q#5	a_888_406##7	2.31946e-19
C609	Q#1	a_888_406##10	5.70536e-19
C610	a_1035_74##2	a_888_406##23	3.79616e-17
C611	a_888_406##11	Q#6	2.96694e-17
C612	a_27_136##3	a_348_392#	5.94243e-17
C613	Q#5	VPWR#10	7.00593e-17
C614	VPWR#2	RESET_B#1	9.36784e-18
C615	a_1035_74##2	a_888_406##18	4.30733e-18
C616	a_888_406##18	VPWR#4	1.05068e-19
C617	a_639_392##5	a_232_98##7	1.47225e-19
C618	a_888_406##14	a_888_406##10	4.06834e-17
C619	VGND#11	a_888_406##8	3.19906e-17
C620	a_232_98##11	a_27_136##2	1.13404e-18
C621	a_888_406##6	VPWR#3	3.13907e-19
C622	VPWR#10	a_888_406##7	1.33219e-18
C623	VPWR#2	a_888_406##16	1.85511e-18
C624	VPWR#1	a_888_406##11	1.53766e-18
C625	a_27_136##2	a_348_392##8	2.57314e-17
C626	Q#3	a_888_406##4	1.75875e-19
C627	VPWR#2	a_888_406##18	1.98238e-18
C628	a_639_392##5	a_888_406#	3.40279e-17
C629	VPWR#2	a_888_406##15	2.72566e-18
C630	Q#1	a_888_406##9	2.31538e-18
C631	a_348_392#	a_232_98##8	1.9952e-17
C632	a_888_406##7	Q#6	2.4911e-17
C633	Q#5	Q#6	2.98529e-18
C634	Q#1	a_888_406##8	3.46875e-17
C635	a_639_392##5	a_639_392##7	1.49406e-18
C636	a_348_392##2	a_232_98##11	4.58045e-18
C637	a_1035_74##2	a_888_406##19	4.55354e-18
C638	VPWR#2	a_888_406##11	1.44494e-18
C639	a_348_392##8	a_348_392##2	4.17254e-18
C640	a_27_136##5	D#2	8.59296e-18
C641	a_639_392##5	a_639_392#	2.27036e-19
C642	VGND#11	a_888_406##4	1.86283e-18
C643	VPWR#1	a_888_406##7	4.31465e-17
C644	VGND#3	Q#4	3.52782e-18
C645	VPWR#2	a_888_406##7	5.30982e-19
C646	a_888_406##10	a_888_406##8	3.8883e-17
C647	a_888_406##19	VPWR#4	2.6885e-19
C648	VGND#7	a_27_136#	5.79323e-18
C649	VPWR#3	a_888_406##13	4.24194e-20
C650	VGND#1	a_888_406##8	2.04153e-18
C651	a_232_98##11	a_232_98##2	5.67087e-20
C652	a_232_98##8	a_888_406##3	7.06784e-18
C653	VPWR#10	Q#6	6.13703e-17
C654	VGND#7	a_232_98##7	8.51745e-18
C655	a_232_98##13	GATE_N#5	8.2926e-18
C656	a_888_406##23	a_1035_74#	9.11258e-20
C657	a_1035_74##2	VGND#13	4.3118e-17
C658	Q#1	a_888_406##4	2.52969e-17
C659	a_348_392##2	a_639_392##11	8.20533e-17
C660	VGND#4	VGND#2	1.46421e-18
C661	VPWR#6	a_27_136#	2.10747e-20
C662	a_27_136##5	GATE_N#2	8.34647e-19
C663	VGND#3	VGND#2	6.5988e-17
C664	a_888_406##20	VPWR#13	7.46128e-19
C665	VGND#8	VGND#15	1.8086e-17
C666	a_232_98##11	a_232_98##6	2.21351e-20
C667	VGND#3	VGND#4	5.11612e-17
C668	GATE_N#2	a_232_98##2	2.19647e-19
C669	VPWR#10	VPWR#1	1.59316e-18
C670	a_888_406##3	a_639_392##8	5.73832e-18
C671	a_232_98##13	GATE_N#2	3.42292e-18
C672	VGND#1	a_888_406##4	2.6438e-17
C673	a_232_98##5	a_639_392##11	1.13098e-16
C674	Q#4	VPWR#2	2.5853e-18
C675	RESET_B#3	a_888_406##14	1.32045e-18
C676	a_348_392##9	GATE_N#2	1.35448e-20
C677	VGND#3	VGND#5	2.55035e-17
C678	a_888_406##8	a_888_406##4	4.00443e-17
C679	a_888_406##23	VGND#12	3.70557e-19
C680	a_1035_74##2	a_1035_74#	2.38898e-18
C681	a_888_406##20	VPWR#4	7.84712e-18
C682	a_27_136##5	a_232_98##3	3.05801e-18
C683	a_888_406##18	VPWR#12	1.12385e-17
C684	Q#4	a_888_406##5	3.21634e-19
C685	Q#6	VPWR#1	7.21835e-17
C686	a_232_98##3	a_232_98##13	1.44159e-19
C687	a_639_392##8	a_639_392##6	3.87188e-17
C688	a_888_406##20	a_888_406##24	6.70828e-19
C689	a_348_392##4	a_639_392##11	3.67447e-17
C690	a_27_136##5	D#3	4.68305e-17
C691	a_232_98##3	a_348_392##9	3.08148e-17
C692	a_348_392##8	a_232_98##2	7.38178e-18
C693	a_1035_74#	VGND#13	3.95625e-17
C694	a_888_406##19	VPWR#12	1.16541e-17
C695	VGND#6	a_639_392##9	5.7436e-18
C696	a_27_136##2	VGND#16	3.19937e-20
C697	a_888_406##20	VPWR#5	5.51101e-17
C698	D#3	VGND#16	1.48663e-17
C699	a_639_392##11	a_888_406##2	6.93161e-19
C700	a_639_392##6	RESET_B#5	3.21349e-17
C701	a_27_136##7	D#5	2.48104e-17
C702	a_348_392##8	a_232_98##6	8.77124e-20
C703	a_27_136##5	GATE_N#3	3.56216e-17
C704	Q#4	a_888_406##9	8.00039e-18
C705	a_27_136##2	a_348_392##9	8.24829e-17
C706	a_232_98##3	a_232_98##2	3.72614e-19
C707	VPWR#15	VPWR#7	2.96305e-18
C708	VGND#3	a_888_406##5	2.63257e-20
C709	a_232_98##13	D#3	3.70416e-18
C710	VGND#5	VGND#4	9.76523e-19
C711	a_888_406##20	VPWR#12	8.03795e-17
C712	a_27_136##2	VGND#15	1.29472e-17
C713	a_888_406##2	VPWR#13	2.01001e-18
C714	Q#3	a_1035_74##2	3.32819e-21
C715	VGND#13	VGND#12	1.88584e-18
C716	a_639_392##11	a_639_392##5	8.16392e-20
C717	VGND#8	a_639_392##9	5.8372e-18
C718	VGND#3	a_888_406##9	1.59071e-19
C719	VGND#3	RESET_B#6	5.4946e-19
C720	GATE_N#3	VGND#16	1.80297e-17
C721	D#5	D#2	1.10658e-17
C722	RESET_B#5	RESET_B#1	3.30191e-17
C723	a_27_136##2	a_639_392##9	1.29035e-17
C724	a_27_136##5	a_232_98#	5.08294e-19
C725	VGND#8	GATE_N#3	1.98901e-18
C726	VGND#3	a_888_406##14	2.26215e-19
C727	D#5	VPWR#15	9.40884e-18
C728	a_27_136##7	VPWR#15	7.71311e-17
C729	a_232_98##13	GATE_N#3	3.96517e-17
C730	a_888_406##18	VPWR#11	1.67765e-17
C731	VGND#3	a_888_406##13	1.06766e-19
C732	VGND#3	a_888_406##10	3.47995e-18
C733	GATE_N#5	D#2	2.98487e-18
C734	Q#5	a_888_406##9	4.05224e-19
C735	a_1035_74#	VGND#12	4.40055e-17
C736	VPWR#2	VPWR#3	6.50565e-17
C737	a_888_406##20	a_888_406##17	3.8876e-18
C738	VGND#3	a_888_406##8	4.77801e-19
C739	a_232_98##11	VPWR#7	6.23252e-17
C740	a_348_392##9	GATE_N#3	5.52767e-19
C741	VPWR#12	a_639_392##5	5.50753e-19
C742	RESET_B#1	a_888_406##16	3.10298e-17
C743	a_27_136##7	a_232_98##11	3.70746e-19
C744	VPWR#2	VPWR#4	9.14658e-19
C745	VGND#3	a_888_406##4	2.78034e-18
C746	a_888_406##17	a_639_392##5	5.76802e-20
C747	a_232_98##13	a_232_98#	6.47309e-19
C748	VGND#8	a_232_98##2	4.10633e-20
C749	a_232_98##2	a_27_136##2	3.35008e-17
C750	VGND#8	a_232_98#	1.44191e-17
C751	a_27_136##5	VGND#16	3.81382e-18
C752	VPWR#2	a_888_406##5	7.00909e-21
C753	a_888_406##19	a_888_406##18	1.29205e-18
C754	GATE_N#5	GATE_N#2	1.34229e-17
C755	VPWR#15	a_232_98##11	7.98764e-17
C756	a_348_392##9	a_232_98#	3.7228e-17
C757	a_639_392##9	a_232_98##5	3.39643e-19
C758	VGND#5	a_1035_74##4	7.76242e-18
C759	a_888_406##16	a_888_406##15	4.68502e-17
C760	VPWR#2	a_888_406##9	1.32389e-19
C761	VGND#6	VGND#5	2.37879e-19
C762	a_888_406##13	Q#5	2.21351e-18
C763	VGND#2	a_888_406##5	8.51319e-20
C764	a_232_98#	VGND#15	1.53611e-17
C765	a_27_136##5	a_232_98##2	8.48405e-20
C766	a_27_136##5	a_232_98##13	6.25755e-17
C767	VGND#8	VGND#14	1.10563e-18
C768	VPWR#2	a_888_406##13	4.15483e-20
C769	VGND#12	Q#3	5.22483e-17
C770	a_348_392##9	a_27_136#	1.06338e-19
C771	VPWR#10	a_888_406##9	7.9313e-19
C772	a_639_392##9	a_348_392##4	6.51555e-17
C773	VGND#8	a_27_136#	1.36943e-17
C774	a_888_406##20	a_888_406##18	6.33359e-19
C775	VGND#6	a_1035_74##4	3.92093e-17
C776	a_888_406##15	a_888_406##11	3.81136e-17
C777	a_888_406##6	VPWR#11	7.54513e-18
C778	a_232_98##11	a_348_392##8	1.14513e-16
C779	a_27_136#	VGND#15	9.46331e-18
C780	GATE_N#5	a_232_98##11	9.02702e-18
C781	a_888_406##6	Q#5	4.55744e-17
C782	a_639_392##9	a_232_98#	2.1486e-18
C783	a_27_136##7	D#1	4.01672e-17
C784	a_348_392##2	a_232_98##2	4.33821e-19
C785	VGND#2	a_888_406##9	7.39587e-21
C786	VPWR#7	VPWR#14	8.44802e-18
C787	VGND#12	VGND#11	2.76823e-18
C788	a_888_406##6	VPWR#10	3.14569e-18
C789	a_888_406##23	RESET_B#4	1.0091e-18
C790	a_348_392##2	a_232_98##6	2.61564e-17
C791	a_232_98##11	VPWR#14	3.71987e-18
C792	D#1	VPWR#15	3.28747e-17
C793	a_888_406##11	a_888_406##7	3.03021e-17
C794	VPWR#8	VPWR#7	4.97038e-19
C795	VPWR#8	a_232_98##3	5.64047e-20
C796	VGND#9	D#2	5.96151e-19
C797	D#5	VPWR#8	3.20595e-19
C798	VPWR#8	a_27_136##3	2.91731e-19
C799	VGND#9	a_232_98#	1.7584e-18
C800	VPWR	VPWR#8	1.28606e-16
C801	VPWR#8	GATE_N#2	5.04117e-20
C802	a_27_136##7	VPWR#8	1.43731e-17
C803	VGND#9	a_232_98##3	7.9209e-20
C804	VGND#9	VGND#16	8.0289e-18
C805	VPWR#8	GATE_N#1	3.56669e-18
C806	VGND	VGND#9	1.21148e-16
C807	VPWR#8	VNB	6.47793e-17
C808	VGND#9	GATE_N#3	1.47229e-17
C809	GATE_N#5	VPWR#8	5.87757e-19
C810	VGND#9	VGND#8	3.04695e-18
C811	VPWR#8	D#1	3.57764e-18
C812	VGND#9	GATE_N#2	6.02474e-20
C813	VGND#9	a_27_136##5	6.55783e-17
C814	VGND#9	VNB	7.94046e-17
C815	VGND#9	D#3	2.54627e-18
C816	a_232_98##11	VPWR#8	1.40372e-17
*
*
.ENDS sky130_fd_sc_hs__dlrtn_4
*
