* Extracted by Quantus, converted by sky130cad/quantus.py
*
*
*
*                       LINUX           Wed Nov 18 08:19:42 2026
*
*
*
*  PROGRAM  advgen
*
*  Name           : advgen - Quantus - (64-bit)
*  Version        : 25.1.0-p047
*  Build Date     : Thu Dec 11 23:20:30 PST 2025
*
*  HSPICE LIBRARY
*
*  OPERATING_TEMPERATURE 150
*  QRC_TECH_DIR <path>/tech
*
*
*

*
.SUBCKT sky130_fd_sc_hs__and4bb_4 VPB VNB VGND VPWR X D B_N A_N C
*
*
*  caps2d version: 10
*
*
*       TRANSISTOR CARDS
*
*
XM24 a_27_74##8 B_N#3 VGND#11 VNB sky130_fd_pr__nfet_01v8_lvt l=0.15 w=0.64 ad=0.1824 as=0.1792 pd=1.85 ps=1.84
XM4 VGND#11 A_N#3 a_200_74##11 VNB sky130_fd_pr__nfet_01v8_lvt l=0.15 w=0.64 ad=0.1792 as=0.1915 pd=1.84 ps=1.99
XM20 a_412_140##4 a_200_74##6 a_472_388##21 VNB sky130_fd_pr__nfet_01v8_lvt l=0.15 w=0.64 ad=0.2272 as=0.1792 pd=1.99 ps=1.84
XM19 a_472_388##21 a_200_74##3 a_412_140##2 VNB sky130_fd_pr__nfet_01v8_lvt l=0.15 w=0.64 ad=0.1792 as=0.1792 pd=1.84 ps=1.84
XM2 a_685_140# a_27_74##4 a_412_140##2 VNB sky130_fd_pr__nfet_01v8_lvt l=0.15 w=0.64 ad=0.1792 as=0.1792 pd=1.84 ps=1.84
XM25 a_412_140# a_27_74##2 a_685_140# VNB sky130_fd_pr__nfet_01v8_lvt l=0.15 w=0.64 ad=0.1824 as=0.1792 pd=1.85 ps=1.84
XM3 a_685_140##2 C#5 a_882_137##4 VNB sky130_fd_pr__nfet_01v8_lvt l=0.15 w=0.64 ad=0.1792 as=0.2272 pd=1.84 ps=1.99
XM16 a_882_137##2 C#1 a_685_140##2 VNB sky130_fd_pr__nfet_01v8_lvt l=0.15 w=0.64 ad=0.1824 as=0.1792 pd=1.85 ps=1.84
XM9 VGND#10 D#6 a_882_137# VNB sky130_fd_pr__nfet_01v8_lvt l=0.15 w=0.64 ad=0.1824 as=0.1792 pd=1.85 ps=1.84
XM17 a_882_137# D#5 VGND#9 VNB sky130_fd_pr__nfet_01v8_lvt l=0.15 w=0.64 ad=0.1792 as=0.249 pd=1.84 ps=2.18
XM1 VGND#9 a_472_388##8 X#6 VNB sky130_fd_pr__nfet_01v8_lvt l=0.15 w=0.74 ad=0.249 as=0.2072 pd=2.18 ps=2.04
XM6 VGND#8 a_472_388##13 X#6 VNB sky130_fd_pr__nfet_01v8_lvt l=0.15 w=0.74 ad=0.2812 as=0.2072 pd=2.24 ps=2.04
XM26 X#4 a_472_388##10 VGND#8 VNB sky130_fd_pr__nfet_01v8_lvt l=0.15 w=0.74 ad=0.2368 as=0.2812 pd=2.12 ps=2.24
XM15 X#4 a_472_388# VGND#1 VNB sky130_fd_pr__nfet_01v8_lvt l=0.15 w=0.74 ad=0.2368 as=0.2146 pd=2.12 ps=2.06
XM8 a_27_74##9 B_N#1 VPWR#15 VPB sky130_fd_pr__pfet_01v8 l=0.15 w=1 ad=0.295 as=0.4 pd=2.59 ps=2.8
XM7 VPWR#15 A_N#1 a_200_74##13 VPB sky130_fd_pr__pfet_01v8 l=0.15 w=1 ad=0.4 as=0.295 pd=2.8 ps=2.59
XM5 a_472_388##24 a_200_74##9 VPWR#13 VPB sky130_fd_pr__pfet_01v8 l=0.15 w=1 ad=0.47 as=0.32 pd=2.94 ps=2.64
XM12 VPWR#11 a_200_74# a_472_388##24 VPB sky130_fd_pr__pfet_01v8 l=0.15 w=1 ad=0.32 as=0.47 pd=2.64 ps=2.94
XM0 a_472_388##23 a_27_74##5 VPWR#11 VPB sky130_fd_pr__pfet_01v8 l=0.15 w=1 ad=0.33 as=0.32 pd=2.66 ps=2.64
XM18 VPWR#10 a_27_74# a_472_388##23 VPB sky130_fd_pr__pfet_01v8 l=0.15 w=1 ad=0.4 as=0.33 pd=2.8 ps=2.66
XM13 a_472_388##22 C#4 VPWR#10 VPB sky130_fd_pr__pfet_01v8 l=0.15 w=1 ad=0.3 as=0.4 pd=2.6 ps=2.8
XM22 VPWR#9 C#6 a_472_388##22 VPB sky130_fd_pr__pfet_01v8 l=0.15 w=1 ad=1.22 as=0.3 pd=4.44 ps=2.6
XM11 VPWR#9 D#4 a_472_388##16 VPB sky130_fd_pr__pfet_01v8 l=0.15 w=1 ad=1.22 as=0.3725 pd=4.44 ps=2.91
XM27 a_472_388##16 D#1 VPWR#8 VPB sky130_fd_pr__pfet_01v8 l=0.15 w=1 ad=0.3725 as=0.4204 pd=2.91 ps=3.01
XM23 VPWR#8 a_472_388##14 X#1 VPB sky130_fd_pr__pfet_01v8 l=0.15 w=1.12 ad=0.4204 as=0.336 pd=3.01 ps=2.84
XM14 X#1 a_472_388##12 VPWR#7 VPB sky130_fd_pr__pfet_01v8 l=0.15 w=1.12 ad=0.336 as=0.336 pd=2.84 ps=2.84
XM21 VPWR#7 a_472_388##11 X#2 VPB sky130_fd_pr__pfet_01v8 l=0.15 w=1.12 ad=0.336 as=0.336 pd=2.84 ps=2.84
XM10 X#2 a_472_388##9 VPWR#1 VPB sky130_fd_pr__pfet_01v8 l=0.15 w=1.12 ad=0.336 as=0.3304 pd=2.84 ps=2.83
*
*
*       RESISTOR AND CAP/DIODE CARDS
*
Rg1	B_N#1	B_N#2	415.725189
Rg2	B_N#2	B_N#3	468.619049
Rg3	A_N#1	A_N#2	400.662323
Rg4	A_N#2	A_N#3	532.219543
Rg5	a_200_74#	a_200_74##2	419.487793
Rg6	a_200_74##2	a_200_74##3	281.308990
Rg7	a_200_74##3	a_200_74##4	1142.365234
Rg8	a_200_74##2	a_200_74##5	55.151772
Rg9	a_200_74##5	a_200_74##6	251.647827
Rg10	a_200_74##5	a_200_74##7	30.591166
Rg11	a_200_74##7	a_200_74##8	30.522003
Rg12	a_200_74##7	a_200_74##9	386.556458
Rg13	a_27_74#	a_27_74##2	744.416443
Rg14	a_27_74##2	a_27_74##3	451.389313
Rg15	a_27_74##3	a_27_74##4	276.601471
Rg16	a_27_74##4	a_27_74##5	753.330933
Rg17	C#1	C#2	275.597229
Rg18	C#2	C#3	79.514244
Rg19	C#3	C#4	473.034515
Rg20	C#3	C#5	299.874084
Rg21	C#3	C#6	412.229095
Rg22	D#1	D#2	410.742188
Rg23	D#2	D#3	75.524414
Rg24	D#3	D#4	461.605743
Rg25	D#2	D#5	375.343536
Rg26	D#3	D#6	373.466827
Rg27	a_472_388#	a_472_388##2	382.352509
Rg28	a_472_388##2	a_472_388##3	65.304848
Rg29	a_472_388##3	a_472_388##4	46.247734
Rg30	a_472_388##4	a_472_388##5	24.572433
Rg31	a_472_388##5	a_472_388##6	26.421368
Rg32	a_472_388##6	a_472_388##7	59.578423
Rg33	a_472_388##7	a_472_388##8	395.797760
Rg34	a_472_388##2	a_472_388##9	468.946686
Rg35	a_472_388##3	a_472_388##10	405.827179
Rg36	a_472_388##3	a_472_388##11	437.389587
Rg37	a_472_388##5	a_472_388##12	410.441040
Rg38	a_472_388##6	a_472_388##13	390.565155
Rg39	a_472_388##7	a_472_388##14	466.045135
Rf1	B_N	B_N#4	12.400690
Rf2	B_N#4	B_N	6.495599
Rf3	A_N#2	A_N	162.201172
Rf4	a_200_74##4	a_200_74##11	185.984848
Rf5	a_200_74##8	a_200_74##13	253.900177
Rf6	a_27_74##3	a_27_74##7	275.545227
Rf7	a_27_74##7	a_27_74##8	126.705254
Rf8	a_27_74##7	a_27_74##9	162.554596
Rf9	a_412_140#	a_412_140##3	88.321518
Rf10	a_412_140##3	a_412_140##4	105.442574
Rf11	a_412_140##2	a_412_140##3	15.000000
Rf12	a_685_140#	a_685_140##2	131.647919
Rf13	C	C#2	88.777199
Rf14	a_882_137#	a_882_137##3	79.897934
Rf15	a_882_137##3	a_882_137##4	77.996964
Rf16	a_882_137##2	a_882_137##3	7.500000
Rf17	D#7	D	1.944086
Rf18	D#2	D#9	162.176895
Rf19	D#7	D#9	7.028863
Rf20	a_472_388##4	a_472_388##17	146.310394
Rf21	a_472_388##17	a_472_388##18	129.828506
Rf22	a_472_388##18	a_472_388##19	80.003426
Rf23	a_472_388##19	a_472_388##20	67.070908
Rf24	a_472_388##20	a_472_388##21	40.278862
Rf25	a_472_388##17	a_472_388##16	39.801380
Rf26	a_472_388##18	a_472_388##22	20.927776
Rf27	a_472_388##19	a_472_388##23	31.593605
Rf28	a_472_388##20	a_472_388##24	35.307396
Rf29	a_472_388##16	a_472_388##17	15.000000
Rf30	X#1	X#3	64.205048
Rf31	X#3	X	19.523184
Rf32	X	X#5	16.521385
Rf33	X#5	X#6	84.273590
Rf34	X#2	X#3	15.000000
Rf35	X#4	X#5	15.000000
Rf36	VPWR#1	VPWR#2	97.420372
Rf37	VPWR#2	VPWR#3	65.319138
Rf38	VPWR#3	VPWR#4	108.579460
Rf39	VPWR#4	VPWR#5	105.657433
Rf40	VPWR#5	VPWR#6	56.224350
Rf41	VPWR#2	VPWR#7	35.623142
Rf42	VPWR#3	VPWR#8	31.534731
Rf43	VPWR#4	VPWR#9	9.913984
Rf44	VPWR#5	VPWR#10	36.416096
Rf45	VPWR#6	VPWR#11	39.913998
Rf46	VPWR#6	VPWR#12	98.006340
Rf47	VPWR#12	VPWR#13	34.230385
Rf48	VPWR#12	VPWR#14	93.270050
Rf49	VPWR#14	VPWR#15	31.534731
Rf51	VGND#1	VGND#2	96.029976
Rf52	VGND#2	VGND#3	75.436630
Rf53	VGND#3	VGND#4	65.753731
Rf54	VGND#4	VGND#5	193.251373
Rf55	VGND#5	VGND#6	193.559280
Rf57	VGND#2	VGND#8	40.564270
Rf58	VGND#3	VGND#9	35.274624
Rf59	VGND#4	VGND#10	43.678436
Rf60	VGND#6	VGND#11	30.353714
Rf61	B_N#2	B_N#4	160.232803
Re1	VPWR#2	VPWR	3.246228
Re2	VPWR	VPWR#6	1.159367
Re3	VGND#2	VGND	3.246228
Re4	VGND	VGND#5	1.159367
*
*       CAPACITOR CARDS
*
*
C1	VPWR#13	VPWR#11	2.29393e-18
C2	X#6	VGND#8	5.6611e-17
C3	a_200_74##8	a_200_74##2	2.52525e-20
C4	a_472_388##20	C#4	4.19463e-19
C5	a_412_140#	a_200_74##3	3.76002e-19
C6	VPWR#4	VPWR#8	6.23088e-18
C7	a_412_140##2	a_27_74##4	2.57362e-17
C8	a_472_388##19	C#4	4.32872e-20
C9	VPWR#13	a_472_388##24	2.68403e-17
C10	a_685_140#	a_200_74##3	9.11897e-19
C11	VGND#9	VGND#8	1.69044e-18
C12	a_472_388##21	a_27_74##4	1.06443e-18
C13	D#7	D#3	9.5197e-18
C14	a_472_388##18	C#4	2.37892e-17
C15	VPWR#12	a_200_74#	6.32482e-19
C16	a_412_140##2	a_200_74##3	2.97296e-17
C17	a_200_74##13	a_472_388##24	1.98876e-17
C18	a_472_388##20	a_27_74#	2.33692e-19
C19	a_472_388##16	VPWR#4	1.16673e-16
C20	a_412_140##4	a_27_74##4	1.71493e-19
C21	a_472_388##19	a_27_74#	1.05452e-17
C22	a_200_74##4	a_200_74##7	8.17443e-19
C23	a_472_388##21	a_200_74##3	2.22383e-17
C24	VGND#9	X#6	6.93594e-17
C25	a_200_74##13	VPWR#13	5.15511e-17
C26	D#7	C#3	4.21242e-21
C27	a_472_388##18	a_27_74#	9.41649e-19
C28	a_412_140##2	a_200_74##6	7.09908e-19
C29	a_472_388##16	VPWR#3	5.17468e-18
C30	a_412_140##4	a_200_74##3	4.95663e-19
C31	VGND#3	a_472_388##7	4.20716e-20
C32	VPWR#12	a_200_74##9	1.05469e-17
C33	a_472_388##20	a_27_74##5	4.78614e-19
C34	VPWR#15	VPWR#13	1.53365e-18
C35	a_472_388##21	a_200_74##6	1.94414e-17
C36	VPWR#4	VPWR#9	3.49968e-17
C37	a_200_74##11	a_200_74##3	1.65625e-19
C38	D#3	D#1	2.87282e-18
C39	a_27_74##7	a_472_388##21	1.87554e-18
C40	a_882_137#	X#6	7.56808e-19
C41	a_472_388##19	a_27_74##5	8.90869e-18
C42	a_412_140##2	A_N#3	4.54007e-20
C43	a_412_140##4	a_200_74##6	2.18408e-17
C44	a_472_388##20	a_472_388##19	2.01506e-19
C45	a_472_388##22	VPWR#5	7.87334e-18
C46	VPWR#15	a_200_74##13	6.13896e-17
C47	VPWR#12	A_N#1	8.79861e-19
C48	a_200_74##11	a_200_74##6	5.25596e-19
C49	a_472_388##20	a_200_74#	3.53057e-18
C50	a_882_137#	VGND#9	5.85583e-17
C51	A_N#2	a_200_74##7	4.24622e-19
C52	a_27_74##7	a_412_140##4	6.50967e-17
C53	a_472_388##22	VPWR#4	7.24907e-17
C54	a_27_74##9	a_200_74##13	1.24629e-17
C55	a_412_140##4	A_N#3	3.40929e-19
C56	A_N#3	a_200_74##11	2.32276e-17
C57	a_27_74##9	VPWR#15	1.02325e-16
C58	a_27_74##8	a_200_74##6	3.4271e-19
C59	VGND#10	VGND#9	3.01064e-18
C60	a_472_388##20	a_200_74##9	3.13141e-18
C61	VPWR#12	B_N#1	1.18807e-19
C62	a_200_74##11	a_27_74##7	1.12266e-16
C63	VGND#11	A_N#3	3.89605e-17
C64	VPWR#10	VPWR#4	3.47587e-18
C65	C#3	D#4	4.54178e-19
C66	a_412_140##2	a_200_74##7	1.42233e-19
C67	a_472_388##19	a_472_388##18	2.18467e-19
C68	a_27_74##8	A_N#3	3.21356e-18
C69	a_472_388##23	VPWR#5	3.18888e-18
C70	a_882_137#	VGND#10	4.40595e-17
C71	VGND#11	B_N#3	3.36814e-17
C72	VGND#11	a_27_74##7	9.07326e-18
C73	VPWR#12	VPWR#11	4.68625e-19
C74	a_27_74##8	B_N#3	2.64213e-17
C75	a_882_137##2	a_882_137#	2.63461e-18
C76	VGND#4	D#3	1.83755e-20
C77	a_472_388##18	a_472_388##16	8.45317e-20
C78	a_27_74##8	a_27_74##7	1.16335e-18
C79	a_472_388##10	a_472_388#	3.46513e-17
C80	a_412_140##2	a_200_74##2	1.56928e-19
C81	a_472_388##24	VPWR#12	8.61398e-18
C82	a_882_137##2	VGND#10	3.37564e-17
C83	a_472_388##21	a_200_74##7	3.20948e-18
C84	VGND#2	VGND#3	6.80817e-17
C85	a_472_388##18	VPWR#9	3.96636e-18
C86	VGND#4	C#3	6.85715e-20
C87	VPWR#2	VPWR#3	4.94947e-17
C88	a_472_388##13	a_472_388##10	2.55707e-17
C89	VPWR#1	a_472_388##9	4.61574e-17
C90	a_27_74##7	a_200_74##9	5.21572e-19
C91	VGND#3	D#3	1.90646e-20
C92	X#2	a_472_388##9	4.89823e-17
C93	a_472_388##18	a_472_388##22	2.00989e-19
C94	VPWR#1	a_472_388##11	7.7852e-18
C95	a_472_388##21	a_200_74##2	2.9764e-18
C96	VPWR#7	a_472_388##9	8.1833e-18
C97	a_882_137##2	a_685_140##2	3.78511e-17
C98	a_472_388##19	VPWR#10	2.70474e-17
C99	a_472_388##8	a_472_388##13	3.77259e-17
C100	C#4	C#3	8.81379e-19
C101	a_412_140##4	a_200_74##7	6.44782e-18
C102	X#2	a_472_388##11	5.24252e-17
C103	D#9	a_472_388##16	2.34734e-17
C104	a_27_74##7	A_N#1	1.99986e-19
C105	X#1	a_472_388##9	5.25152e-19
C106	a_472_388##20	a_472_388##23	2.19822e-18
C107	VPWR#12	VPWR#6	9.60724e-19
C108	a_200_74##13	VPWR#12	6.21794e-18
C109	a_685_140##2	C#4	2.81487e-18
C110	VPWR#7	a_472_388##11	5.1465e-17
C111	a_472_388##18	VPWR#10	3.52625e-17
C112	VPWR#6	VPWR#5	1.10349e-18
C113	D#7	a_472_388##16	2.27747e-17
C114	a_882_137##4	C#4	6.15933e-18
C115	X#1	a_472_388##11	7.4003e-19
C116	D#5	a_472_388##8	2.82137e-17
C117	a_27_74##7	B_N#1	6.43035e-20
C118	VPWR#7	a_472_388##12	4.50199e-17
C119	a_472_388##20	VPWR#11	2.30062e-17
C120	a_685_140##2	a_882_137##4	6.54964e-17
C121	VPWR#15	VPWR#12	1.65751e-19
C122	a_472_388##23	a_472_388##18	2.39211e-18
C123	X#1	a_472_388##12	6.27348e-17
C124	VPWR#2	D#9	1.68382e-18
C125	a_27_74##7	a_200_74##7	3.82421e-19
C126	VGND#3	a_472_388##4	4.31924e-19
C127	VPWR#7	a_472_388##14	2.08363e-18
C128	a_472_388##19	VPWR#11	1.90294e-17
C129	VPWR#8	a_472_388##12	2.13205e-18
C130	a_472_388##20	VPWR#6	2.07425e-19
C131	D#6	D#5	3.6006e-17
C132	D#5	a_472_388##7	6.12259e-19
C133	a_472_388##21	C#4	7.64442e-19
C134	a_685_140#	a_882_137##2	6.15232e-22
C135	X#1	a_472_388##14	1.70417e-17
C136	a_472_388##19	VPWR#6	1.01478e-19
C137	a_472_388##20	a_472_388##24	2.61415e-18
C138	a_472_388##16	a_472_388##12	2.63062e-19
C139	VGND#2	D#9	1.25971e-18
C140	VPWR#8	a_472_388##14	5.75839e-17
C141	VGND#3	D#2	3.51432e-20
C142	X#1	D#1	1.0097e-18
C143	a_412_140#	a_882_137##4	2.10521e-17
C144	a_472_388##16	a_472_388##14	2.0584e-18
C145	C#1	D#6	3.91235e-18
C146	VGND#3	a_472_388##10	1.17575e-19
C147	a_472_388##4	VPWR#3	3.08454e-19
C148	D#1	VPWR#8	2.23372e-17
C149	a_472_388##16	D#1	6.87754e-17
C150	a_412_140##2	a_685_140##2	1.10649e-22
C151	VGND#4	C#2	1.84647e-19
C152	VPWR#8	D#4	2.52024e-18
C153	VPWR#4	D#2	1.38963e-20
C154	C#5	C#1	3.41984e-17
C155	VGND#3	a_472_388##13	3.85251e-19
C156	VPWR#3	D#2	1.98066e-20
C157	a_472_388##16	D#4	3.77921e-17
C158	a_472_388##22	D#1	8.68092e-20
C159	X#4	X#2	2.19066e-18
C160	a_412_140#	a_685_140#	6.60172e-17
C161	D#4	VPWR#9	3.42118e-17
C162	a_200_74##2	a_27_74##5	9.56198e-18
C163	VGND#4	a_472_388##8	8.64843e-19
C164	a_472_388##16	C#6	4.22865e-19
C165	a_472_388##22	D#4	2.93079e-19
C166	VPWR#3	a_472_388##7	9.57098e-21
C167	VPWR#4	C#2	3.85045e-18
C168	a_412_140##2	a_412_140#	2.96977e-18
C169	C#6	VPWR#9	3.72334e-17
C170	VGND#3	a_472_388##8	7.35575e-18
C171	VPWR#10	D#4	1.13048e-19
C172	VGND#2	VGND#1	6.08309e-17
C173	VGND#3	X#6	8.48119e-18
C174	D#9	a_472_388##4	3.75731e-17
C175	a_472_388##22	C#6	5.02166e-17
C176	VGND#2	X#4	1.6993e-17
C177	VGND#5	a_27_74##7	2.06599e-17
C178	VGND#4	VGND#9	1.85469e-18
C179	VPWR#10	C#6	1.44897e-18
C180	a_412_140##2	a_685_140#	3.61473e-17
C181	VPWR#3	a_472_388##6	1.01795e-20
C182	VGND#2	X#6	2.66246e-17
C183	a_472_388##22	C#4	4.23458e-17
C184	VGND#3	D#5	3.19035e-18
C185	D#9	D#2	1.2739e-17
C186	VGND#9	VGND#2	3.5061e-19
C187	a_472_388##18	C#2	8.44369e-17
C188	C#4	VPWR#10	2.84777e-17
C189	D#7	D#2	4.38174e-18
C190	VGND#4	a_882_137#	4.77693e-18
C191	a_200_74##3	a_27_74##4	3.06635e-17
C192	a_472_388##23	C#4	5.47964e-19
C193	VPWR#12	a_200_74##7	4.6154e-20
C194	VGND#4	D#6	2.62985e-18
C195	X#2	a_472_388##2	1.5209e-18
C196	a_472_388##20	a_27_74##3	2.20537e-19
C197	a_27_74#	VPWR#10	3.48334e-17
C198	VPWR#11	C#4	3.79276e-19
C199	a_472_388##19	a_27_74##3	5.58119e-18
C200	a_412_140##2	a_472_388##21	4.63055e-17
C201	a_472_388##23	a_27_74#	6.32032e-17
C202	D#7	C#2	1.09699e-18
C203	VGND#3	a_882_137#	5.14736e-18
C204	VPWR#5	C#3	2.34985e-20
C205	a_200_74##3	a_200_74##6	4.04961e-17
C206	VPWR#10	a_27_74##5	7.99038e-19
C207	VPWR#11	a_27_74#	2.81088e-18
C208	X#1	a_472_388##7	6.77617e-19
C209	VGND#4	C#1	2.80748e-18
C210	a_200_74##8	a_472_388##20	4.24804e-17
C211	a_27_74##5	a_472_388##23	4.32363e-17
C212	a_412_140##4	a_412_140##2	2.23443e-18
C213	a_472_388##4	X#4	6.58692e-17
C214	C#1	D#3	2.2928e-18
C215	VPWR#10	a_200_74#	3.58726e-19
C216	VPWR#4	D#3	3.43222e-20
C217	a_472_388##4	VGND#8	5.16456e-18
C218	VPWR#11	a_27_74##5	2.24068e-17
C219	A_N#3	a_200_74##6	1.31064e-18
C220	a_472_388##4	X#6	5.86295e-17
C221	X#1	a_472_388##6	2.22891e-18
C222	a_472_388##23	a_200_74#	1.84939e-18
C223	VGND#9	a_472_388##4	1.07348e-17
C224	VGND#4	VGND#3	1.57622e-18
C225	a_412_140##4	a_472_388##21	3.4705e-17
C226	VGND#5	a_685_140##2	5.86415e-18
C227	VPWR#11	a_200_74#	5.30417e-17
C228	VGND#4	a_882_137##2	8.56304e-18
C229	VGND#4	C#5	2.95841e-18
C230	a_27_74##7	a_27_74##3	6.23758e-20
C231	a_472_388##23	a_200_74##9	1.89991e-19
C232	a_200_74#	a_472_388##24	2.36795e-17
C233	VPWR#2	VPWR#1	6.85247e-17
C234	B_N#3	A_N#3	4.06402e-17
C235	VPWR#4	C#3	3.73698e-19
C236	a_472_388##4	a_882_137##2	4.77841e-19
C237	X#2	VPWR#2	1.18744e-17
C238	VPWR#11	a_200_74##9	2.70998e-18
C239	VPWR#13	a_200_74#	1.21789e-18
C240	VGND#9	D#2	3.04495e-18
C241	VGND#5	a_685_140#	8.56282e-18
C242	VGND#9	a_472_388##16	3.69742e-18
C243	VPWR#2	VPWR#7	2.25901e-17
C244	a_882_137#	D#2	1.43297e-18
C245	a_200_74##9	a_472_388##24	3.16227e-17
C246	a_200_74##13	a_200_74#	1.40231e-19
C247	X#1	VPWR#2	1.90021e-17
C248	VGND#4	a_685_140##2	9.25241e-18
C249	VPWR#11	A_N#1	4.41489e-20
C250	a_27_74##7	a_200_74##8	6.1601e-17
C251	VPWR#13	a_200_74##9	4.65247e-17
C252	VGND#2	X#2	6.07898e-19
C253	a_882_137##2	D#2	5.61343e-19
C254	a_882_137#	a_472_388##16	5.19296e-18
C255	VPWR#2	VPWR#8	2.19707e-17
C256	a_472_388##24	A_N#1	2.55906e-19
C257	a_200_74##13	a_200_74##9	9.74674e-18
C258	a_27_74##7	a_200_74##13	4.51112e-17
C259	VPWR#2	a_472_388##16	1.86484e-18
C260	VPWR#13	A_N#1	2.22637e-18
C261	VPWR#15	a_200_74##9	6.15719e-19
C262	VGND#8	a_472_388##6	2.30947e-19
C263	a_200_74##13	A_N#1	5.64495e-17
C264	C	D#3	1.3174e-17
C265	a_27_74##7	a_200_74##4	2.96267e-17
C266	a_27_74##9	a_200_74##9	3.15831e-19
C267	C#2	a_882_137##2	7.29649e-17
C268	C#2	a_685_140##2	2.76004e-18
C269	VPWR#13	B_N#1	2.407e-19
C270	A_N#1	VPWR#15	3.13528e-17
C271	a_882_137##4	C#2	1.48823e-17
C272	a_27_74##9	A_N#1	2.39256e-17
C273	VGND#10	a_27_74##3	2.06449e-18
C274	X#4	a_472_388##2	1.9643e-18
C275	a_412_140#	C#2	6.64184e-21
C276	VGND#11	a_200_74##11	6.16042e-17
C277	a_882_137##2	a_27_74##3	5.49119e-19
C278	a_472_388##11	a_472_388##9	4.96404e-17
C279	B_N#1	VPWR#15	3.68962e-17
C280	a_27_74##7	A_N#2	2.34991e-17
C281	X#6	a_472_388##7	2.29913e-18
C282	a_685_140##2	a_27_74##3	7.15938e-19
C283	a_27_74##9	B_N#1	5.48174e-17
C284	a_472_388##4	X#2	7.15621e-17
C285	a_882_137##4	a_27_74##3	9.93194e-19
C286	a_27_74##7	a_27_74##9	3.25416e-18
C287	a_412_140#	a_27_74##3	4.42731e-17
C288	a_472_388##4	VPWR#7	3.47521e-18
C289	a_472_388##12	a_472_388##11	4.6461e-17
C290	a_685_140#	a_27_74##3	7.23057e-17
C291	a_472_388##4	X#1	8.31785e-17
C292	X#6	a_472_388##6	1.25193e-18
C293	a_27_74##7	B_N#2	1.15656e-18
C294	a_27_74##3	a_412_140##2	5.89261e-17
C295	a_472_388##23	VPWR#6	1.32342e-17
C296	a_472_388##4	VPWR#8	1.70787e-17
C297	a_472_388##21	a_27_74##3	2.12468e-19
C298	VPWR#2	a_472_388##6	1.9315e-20
C299	a_27_74##8	VGND#11	7.96373e-17
C300	a_27_74##3	a_412_140##4	2.06672e-17
C301	a_472_388##24	VPWR#6	8.52836e-18
C302	a_472_388##14	a_472_388##12	4.72758e-17
C303	a_200_74##8	a_472_388##21	2.3155e-18
C304	D#2	a_472_388##16	2.03846e-18
C305	VPWR#2	a_472_388##2	8.70486e-20
C306	a_412_140##4	a_200_74##8	3.28562e-17
C307	VGND#2	a_472_388#	1.61982e-18
C308	D#1	a_472_388##14	3.07471e-17
C309	VGND#2	a_472_388##10	3.78117e-18
C310	C#2	a_472_388##16	2.19767e-17
C311	D#4	a_472_388##14	9.87379e-19
C312	VGND#2	a_472_388##13	5.45962e-18
C313	C#2	VPWR#9	1.02627e-17
C314	VGND#2	a_472_388##7	2.31394e-20
C315	a_412_140##4	a_200_74##4	2.47866e-18
C316	VGND#2	a_472_388##8	1.75272e-18
C317	D#3	a_472_388##16	2.01644e-18
C318	a_200_74##11	a_200_74##4	2.25917e-17
C319	D#4	D#1	3.90324e-17
C320	VGND#2	a_472_388##6	1.81918e-20
C321	VGND#11	a_200_74##4	1.56984e-18
C322	VGND#2	D#5	1.24855e-18
C323	a_472_388##21	A_N#2	5.65101e-20
C324	a_200_74##2	a_27_74##4	1.42988e-17
C325	a_412_140##4	A_N#2	9.06036e-20
C326	a_200_74##11	A_N#2	1.55666e-18
C327	C#6	D#4	1.98413e-18
C328	VGND#2	a_472_388##2	1.50673e-19
C329	X#2	VPWR#1	6.13242e-19
C330	a_27_74##8	A_N#2	4.55856e-18
C331	C#4	C#6	4.10486e-17
C332	a_200_74##3	a_200_74##7	2.81415e-19
C333	a_472_388##20	a_27_74##4	3.71388e-19
C334	VGND#1	a_472_388#	3.01018e-17
C335	VPWR#7	VPWR#1	1.85622e-17
C336	a_27_74##8	B_N#2	2.16265e-17
C337	D#7	C#1	8.60098e-19
C338	a_472_388##19	a_27_74##4	4.34796e-18
C339	a_200_74##8	a_472_388##24	2.22122e-17
C340	a_27_74#	C#4	3.39963e-17
C341	X#4	a_472_388#	3.99091e-17
C342	a_200_74##8	VPWR#13	4.68164e-18
C343	a_200_74##3	a_200_74##2	4.07048e-19
C344	X#2	VPWR#7	3.40671e-17
C345	VGND#1	a_472_388##10	4.38372e-18
C346	VPWR#2	a_472_388##9	1.44698e-18
C347	VGND#5	a_200_74##3	9.99836e-18
C348	VGND#8	a_472_388#	4.56936e-18
C349	a_27_74##9	a_200_74##8	1.09576e-18
C350	a_27_74##5	a_27_74#	4.49193e-17
C351	D#7	C#5	3.41206e-19
C352	VPWR#2	a_472_388##11	4.55792e-18
C353	a_200_74##13	a_200_74##4	9.22912e-19
C354	X#4	a_472_388##10	4.435e-17
C355	X	a_472_388##7	1.01032e-19
C356	VPWR#2	a_472_388##12	2.9593e-18
C357	X	a_472_388##6	1.51493e-19
C358	X#6	a_472_388#	1.93317e-19
C359	VGND#1	a_472_388##13	9.94842e-19
C360	X	a_472_388##2	1.6159e-17
C361	VPWR#6	a_200_74##7	2.71155e-20
C362	a_200_74#	a_27_74##5	3.79256e-17
C363	VPWR#2	a_472_388##14	3.51651e-18
C364	a_472_388##10	VGND#8	2.33053e-17
C365	a_200_74##13	A_N#2	9.21422e-19
C366	a_27_74##3	C#1	4.89123e-19
C367	VPWR#2	D#1	6.19982e-18
C368	VPWR#15	A_N#2	6.50998e-19
C369	X#1	VPWR#7	5.22465e-17
C370	C#2	a_27_74##4	4.04896e-19
C371	X#4	a_472_388##13	5.00936e-19
C372	a_27_74##3	C#5	6.3177e-18
C373	a_27_74##9	A_N#2	3.80767e-18
C374	VPWR#6	a_200_74##2	1.871e-20
C375	a_200_74##7	a_200_74##2	4.51277e-19
C376	a_200_74##9	a_200_74#	2.13971e-17
C377	X#6	a_472_388##10	1.2253e-18
C378	a_27_74##4	a_27_74##3	4.67582e-17
C379	a_472_388##4	a_472_388##9	1.14404e-18
C380	C#3	a_472_388##22	4.94809e-19
C381	a_472_388##13	VGND#8	2.30944e-17
C382	VPWR#8	VPWR#7	2.06267e-18
C383	B_N#2	a_27_74##9	1.69123e-17
C384	a_27_74##3	a_200_74##3	5.16192e-17
C385	a_472_388##20	a_200_74##7	1.6643e-17
C386	VGND#9	a_472_388##10	1.69228e-19
C387	a_882_137##2	a_472_388##7	3.73738e-19
C388	VGND#9	D#9	1.39839e-17
C389	a_27_74##3	a_200_74##6	9.43147e-18
C390	A_N#1	a_200_74##9	4.13772e-18
C391	a_472_388##4	a_472_388##12	6.36286e-19
C392	VPWR#5	VPWR#4	1.18121e-18
C393	X#6	a_472_388##13	5.84843e-17
C394	C	D#7	2.3658e-17
C395	a_882_137#	D#3	1.54536e-18
C396	a_472_388##4	a_472_388##14	8.17678e-18
C397	VGND#5	C#3	5.65122e-20
C398	VPWR#8	X#1	5.20507e-17
C399	a_472_388##4	D#1	1.52587e-18
C400	VGND#8	a_472_388##8	3.04646e-19
C401	B_N#1	A_N#1	3.12827e-17
C402	VPWR	C#3	5.51279e-23
C403	D#2	a_472_388##14	4.90633e-19
C404	a_685_140##2	a_472_388##18	2.59052e-18
C405	VPWR	a_200_74##7	5.51279e-23
C406	a_200_74##4	a_200_74##3	7.28201e-19
C407	a_472_388##4	a_472_388##7	1.48407e-17
C408	a_882_137##2	a_472_388##6	6.73225e-20
C409	a_472_388##4	D#4	8.03876e-19
C410	VGND#9	a_472_388##13	3.67832e-19
C411	VGND#5	C#4	1.57994e-19
C412	a_200_74##4	a_200_74##6	7.84911e-18
C413	a_472_388##4	a_472_388##6	1.59383e-17
C414	VPWR#6	a_27_74##5	1.92999e-18
C415	X#6	a_472_388##8	4.0202e-17
C416	a_472_388##16	X#1	3.03342e-18
C417	A_N#3	a_200_74##4	1.60704e-17
C418	VPWR#6	a_200_74#	8.05006e-18
C419	A_N#2	a_200_74##6	4.06335e-19
C420	VGND#8	D#5	1.74096e-19
C421	A_N	a_27_74##7	7.80494e-17
C422	VGND#9	a_472_388##8	1.53863e-17
C423	a_882_137#	C	5.45951e-18
C424	a_472_388##4	a_472_388##2	1.44984e-17
C425	a_882_137##4	a_472_388##18	3.13853e-17
C426	a_472_388##16	VPWR#8	6.05068e-17
C427	a_472_388##19	a_200_74##7	3.22651e-21
C428	a_882_137#	D#7	2.52546e-17
C429	a_882_137##2	C	1.51809e-17
C430	a_27_74##7	a_27_74##4	8.23807e-20
C431	X#6	D#5	1.62834e-18
C432	a_412_140#	a_472_388##19	6.79426e-17
C433	a_472_388##20	a_200_74##2	1.97348e-17
C434	a_882_137#	a_472_388##8	1.07113e-19
C435	a_27_74##3	C#4	1.1453e-17
C436	VPWR#4	VPWR#3	9.4068e-19
C437	VGND#9	D#5	4.18613e-17
C438	a_472_388##18	C#3	1.43462e-17
C439	D#2	a_472_388##7	2.84666e-17
C440	VGND#10	a_472_388##8	1.23991e-19
C441	X#6	D#6	2.08416e-19
C442	a_27_74##7	a_200_74##3	1.59879e-19
C443	a_882_137#	D#5	1.04913e-17
C444	a_685_140#	a_472_388##19	1.70908e-18
C445	a_472_388##16	VPWR#9	5.84199e-18
C446	VPWR#2	a_472_388##4	1.00362e-17
C447	a_200_74##8	a_200_74#	2.16937e-19
C448	a_412_140##2	a_472_388##20	9.52969e-18
C449	VGND#9	D#6	2.98198e-18
C450	C	a_472_388##16	3.52215e-17
C451	VGND#2	a_472_388##4	1.02937e-17
C452	a_200_74##8	a_200_74##9	1.40386e-17
C453	VGND#10	D#5	1.34733e-18
C454	a_200_74##8	A_N#1	9.93812e-19
C455	a_472_388##22	a_472_388##16	9.12857e-19
C456	a_685_140#	a_472_388##18	1.24421e-18
C457	D#3	D#2	3.92772e-18
C458	a_27_74##7	a_200_74##6	1.89069e-18
C459	a_882_137#	D#6	4.79627e-17
C460	a_200_74##8	B_N#1	3.24101e-19
C461	a_472_388##19	a_200_74##2	4.23326e-20
C462	a_472_388##23	a_200_74##7	3.54916e-20
C463	a_882_137##2	D#3	2.14215e-18
C464	a_412_140##2	a_472_388##19	2.88375e-17
C465	a_882_137##2	D#5	2.93239e-20
C466	A_N#2	a_200_74##9	3.6138e-19
C467	D#9	a_472_388##7	4.40607e-18
C468	VPWR#4	a_472_388##14	1.00825e-18
C469	a_472_388##7	VNB	2.7215e-17
C470	a_27_74##8	B_N	4.76641e-17
C471	a_472_388##6	VNB	2.51766e-17
C472	a_472_388##21	a_472_388##20	3.82759e-18
C473	a_472_388##4	D#2	6.09154e-18
C474	D#6	VGND#10	1.69754e-17
C475	a_472_388##2	VNB	3.67429e-17
C476	D#3	VNB	3.08731e-17
C477	C#3	VNB	2.80016e-17
C478	a_200_74##7	VNB	2.59898e-17
C479	VPWR	VPWR#12	9.04547e-17
C480	a_200_74##2	VNB	2.27647e-17
C481	VPWR	VPWR#5	5.43595e-17
C482	VPWR	VPWR#4	1.95154e-16
C483	VPWR#3	a_472_388##14	3.33354e-18
C484	VGND#5	a_27_74##3	1.0135e-16
C485	VPWR	VPWR#3	8.72204e-18
C486	a_882_137#	C#1	6.0273e-19
C487	X	VGND#1	3.33549e-17
C488	A_N	a_200_74##13	2.05497e-18
C489	a_27_74##7	A_N#3	1.48931e-17
C490	VPWR	a_472_388##20	1.4404e-18
C491	a_882_137##2	C#3	1.24143e-19
C492	VPWR	a_472_388##19	2.08363e-18
C493	a_882_137##2	D#6	1.54803e-18
C494	VPWR	a_472_388##18	3.98343e-18
C495	A_N	a_27_74##9	2.45877e-17
C496	VPWR	D#9	4.42814e-19
C497	VGND#5	a_200_74##4	5.99857e-18
C498	VPWR	D#7	2.10427e-18
C499	VGND#10	C#1	3.00276e-18
C500	a_472_388##23	a_200_74##2	8.71553e-20
C501	C#2	a_27_74##3	1.13017e-18
C502	VPWR#4	D#1	1.64309e-18
C503	VPWR	a_27_74##7	4.46385e-18
C504	a_412_140##4	a_472_388##20	1.58587e-18
C505	VGND	VGND#4	1.22173e-16
C506	VGND	VGND#3	1.2709e-17
C507	B_N	a_27_74##9	5.78845e-17
C508	VPWR#3	D#1	4.67738e-18
C509	a_27_74##8	a_27_74##9	5.173e-19
C510	a_882_137##2	C#1	3.87173e-17
C511	VPWR#10	a_472_388##22	6.65984e-17
C512	C#2	D#3	9.36488e-18
C513	a_27_74##7	B_N#3	3.53736e-19
C514	X	VPWR#1	3.40937e-17
C515	X	X#2	1.24469e-19
C516	VGND	a_472_388##20	2.41406e-18
C517	a_27_74##3	a_200_74##4	1.84943e-18
C518	VGND	a_472_388##19	5.70061e-18
C519	VGND	a_472_388##18	3.93724e-18
C520	C#2	C#3	1.22915e-17
C521	VGND#10	C#5	8.14905e-19
C522	a_200_74##4	a_200_74##8	2.09124e-18
C523	VGND	D#9	1.01285e-18
C524	VGND	D#7	2.64215e-18
C525	a_685_140##2	C#1	2.45064e-17
C526	C	D#1	1.2869e-19
C527	A_N#2	a_200_74##8	7.20769e-18
C528	VGND	a_27_74##7	2.82196e-17
C529	VPWR#4	D#4	4.00633e-17
C530	a_882_137##2	C#5	1.37142e-18
C531	VGND#4	VNB	6.1988e-17
C532	C#2	a_200_74##2	8.2293e-19
C533	VGND#3	VNB	3.18737e-17
C534	VGND#1	X#4	1.0932e-18
C535	X	a_472_388#	1.18927e-17
C536	a_882_137##4	C#1	9.26219e-19
C537	VGND	a_882_137#	1.43337e-17
C538	VPWR#12	VNB	3.95828e-17
C539	VPWR	a_472_388##16	1.91281e-17
C540	a_685_140##2	C#3	8.94595e-19
C541	VPWR#5	VNB	2.77611e-17
C542	a_472_388##19	VPWR#5	1.01478e-19
C543	VPWR#4	VNB	6.63757e-17
C544	VGND	a_882_137##2	1.59372e-17
C545	VPWR#3	VNB	2.96345e-17
C546	B_N#2	A_N#2	3.01649e-17
C547	VGND	a_685_140##2	2.075e-17
C548	VPWR	a_472_388##22	1.70073e-17
C549	VGND	a_882_137##4	5.32812e-18
C550	VPWR	VPWR#10	2.12126e-17
C551	VGND	a_412_140#	3.93536e-18
C552	a_472_388##20	VNB	2.62931e-18
C553	VPWR	a_472_388##23	1.7786e-17
C554	X	D#5	1.85845e-20
C555	VGND	a_685_140#	1.45076e-17
C556	a_472_388##19	VNB	4.88229e-18
C557	VPWR	VPWR#11	2.12329e-17
C558	a_472_388##18	VNB	1.82918e-18
C559	VGND	a_412_140##2	8.51367e-18
C560	a_472_388##23	VPWR#10	9.06751e-17
C561	a_685_140##2	C#5	3.64378e-17
C562	VGND	a_472_388##21	4.29946e-18
C563	VPWR	a_472_388##24	1.83954e-17
C564	VGND	a_412_140##4	7.64183e-18
C565	D#9	VNB	1.78794e-18
C566	VGND	a_200_74##11	2.85626e-17
C567	VPWR	a_200_74##13	2.70915e-17
C568	D#7	VNB	4.62658e-18
C569	VGND	VGND#11	2.32381e-17
C570	VPWR	VPWR#15	2.16434e-17
C571	VGND	a_27_74##8	1.69645e-17
C572	VPWR	a_27_74##9	2.12255e-17
C573	a_412_140#	C#1	1.83758e-19
C574	a_27_74##7	VNB	4.01078e-17
C575	VGND#1	VNB	4.72673e-17
C576	X#4	VNB	8.62068e-19
C577	VGND#8	VNB	3.3137e-18
C578	VPWR#4	C#6	1.90171e-17
C579	X#6	VNB	2.4841e-18
C580	a_882_137##4	C#5	2.83368e-17
C581	VGND#9	VNB	5.03473e-18
C582	VGND#8	VGND#1	9.50307e-18
C583	a_882_137#	VNB	3.52625e-18
C584	X	a_472_388##9	9.27246e-18
C585	VGND#10	VNB	1.33176e-17
C586	a_882_137##2	VNB	1.38016e-17
C587	VPWR#11	VPWR#10	3.00815e-18
C588	a_685_140##2	VNB	6.40852e-18
C589	a_882_137##4	VNB	3.9934e-18
C590	a_412_140#	VNB	6.74166e-18
C591	a_200_74##7	a_472_388##24	8.193e-19
C592	a_685_140#	C#1	5.26054e-19
C593	a_685_140#	VNB	3.99719e-18
C594	X	a_472_388##14	8.15817e-21
C595	a_412_140##2	VNB	1.96813e-18
C596	C	D#2	3.25798e-20
C597	a_412_140##4	VNB	1.71351e-18
C598	a_200_74##11	VNB	1.2194e-17
C599	VGND#11	VNB	2.5051e-18
C600	a_472_388##18	VPWR#5	1.01478e-19
C601	a_27_74##8	VNB	4.92533e-17
C602	VPWR#1	VNB	6.36263e-17
C603	X#2	VNB	6.45632e-19
C604	a_472_388##18	D#1	1.13267e-19
C605	VGND	D#5	3.03927e-18
C606	VPWR#7	VNB	4.6438e-19
C607	a_412_140#	C#5	1.06259e-18
C608	X#1	VNB	4.99136e-18
C609	VGND	D#6	8.86823e-18
C610	VPWR#8	VNB	1.24014e-18
C611	a_27_74##3	a_200_74##7	1.44197e-19
C612	VGND	C#1	9.50297e-18
C613	a_472_388##16	VNB	7.48135e-19
C614	VGND	C#5	1.05128e-17
C615	a_472_388##22	VNB	2.22744e-18
C616	VPWR#10	VNB	9.23838e-18
C617	a_882_137##2	a_27_74##4	3.49299e-19
C618	VPWR	D#1	3.08214e-18
C619	a_472_388##23	VNB	3.95539e-18
C620	VGND	a_200_74##3	6.84095e-18
C621	VPWR#11	VNB	3.5588e-18
C622	VPWR	D#4	4.84229e-18
C623	a_412_140##2	C#1	1.94162e-20
C624	VPWR#5	C#4	3.51002e-18
C625	a_472_388##24	VNB	5.78854e-18
C626	VPWR#11	a_472_388##23	9.06782e-17
C627	VPWR	C#6	9.00565e-18
C628	VPWR#13	VNB	1.19299e-18
C629	A_N	a_200_74##8	9.45055e-19
C630	VGND	A_N#3	1.07869e-18
C631	a_200_74##13	VNB	1.81302e-17
C632	VPWR	C#4	9.9972e-18
C633	VGND	B_N#3	1.66768e-18
C634	VPWR#15	VNB	4.07772e-18
C635	VGND#3	D#9	3.2488e-19
C636	a_27_74##9	VNB	5.1226e-17
C637	VPWR	a_27_74#	9.4e-18
C638	a_472_388#	VNB	2.96872e-17
C639	VPWR	a_27_74##5	7.35052e-18
C640	a_472_388##10	VNB	2.40004e-17
C641	VPWR#2	X	4.10021e-18
C642	X#4	VGND#8	2.53371e-17
C643	a_472_388##13	VNB	2.9063e-17
C644	A_N	A_N#2	1.64308e-17
C645	VPWR	a_200_74#	4.78517e-18
C646	a_27_74##3	a_200_74##2	1.25525e-19
C647	a_472_388##8	VNB	3.15348e-17
C648	VGND#2	X	6.57987e-18
C649	D#5	VNB	2.77382e-17
C650	VPWR	a_200_74##9	4.78629e-18
C651	D#9	a_472_388##14	5.40664e-19
C652	a_685_140#	C#5	1.33283e-18
C653	D#6	VNB	3.26165e-17
C654	A_N	B_N#2	9.83582e-19
C655	VPWR	A_N#1	1.65948e-18
C656	C#1	VNB	3.11366e-17
C657	C#5	VNB	3.02846e-17
C658	VPWR#4	C#4	7.07833e-19
C659	VPWR	B_N#1	1.03498e-18
C660	B_N	A_N#2	9.96427e-18
C661	a_882_137##4	C#3	4.9766e-18
C662	a_685_140##2	a_27_74##4	2.2973e-19
C663	a_27_74##4	VNB	2.25927e-17
C664	a_472_388##4	X	3.02127e-17
C665	a_200_74##3	VNB	6.62904e-17
C666	a_200_74##6	VNB	2.17872e-17
C667	X	D#2	2.41328e-19
C668	B_N	B_N#2	1.68132e-17
C669	A_N#3	VNB	3.55505e-17
C670	B_N#3	VNB	3.60697e-17
C671	VPWR	VPWR#6	6.81486e-17
C672	a_472_388##9	VNB	3.2581e-17
C673	a_472_388##11	VNB	2.65598e-17
C674	a_472_388##12	VNB	2.90264e-17
C675	VPWR#3	VPWR#7	1.73149e-19
C676	a_472_388##14	VNB	3.49018e-17
C677	a_472_388##18	VPWR#4	5.15056e-17
C678	D#1	VNB	3.63054e-17
C679	a_200_74##2	a_472_388##24	2.05618e-19
C680	D#4	VNB	3.80154e-17
C681	VPWR	C#2	3.53719e-18
C682	C#6	VNB	3.63753e-17
C683	a_472_388##18	D#4	6.58822e-19
C684	a_412_140##2	C#5	3.2766e-20
C685	C#4	VNB	6.39676e-17
C686	a_27_74#	VNB	4.55672e-17
C687	a_27_74##5	VNB	4.44752e-17
C688	VGND	VGND#5	1.52177e-16
C689	a_200_74#	VNB	3.18706e-17
C690	a_200_74##9	VNB	4.06783e-17
C691	A_N#1	VNB	3.78451e-17
C692	B_N#1	VNB	3.98025e-17
C693	VGND	C#2	3.48025e-18
C694	VPWR	B_N#2	5.00611e-19
C695	VGND	a_27_74##3	5.34341e-17
C696	VPWR#2	VNB	1.62993e-16
C697	VGND#2	VNB	1.66167e-16
C698	VGND	a_200_74##8	4.47273e-18
C699	a_472_388##14	a_472_388##6	1.02649e-18
C700	X#6	X#4	2.83618e-18
C701	VPWR#6	VNB	3.52975e-17
C702	VGND	a_200_74##4	9.68975e-18
C703	VGND#5	VNB	7.97833e-17
C704	VPWR#5	a_27_74#	3.50157e-18
C705	a_472_388##4	VNB	5.44022e-17
C706	D#2	VNB	2.7039e-17
C707	VGND	B_N#2	5.37291e-19
C708	B_N	A_N	2.91932e-17
C709	C#2	VNB	3.54751e-17
C710	a_27_74##3	VNB	1.05437e-16
C711	a_685_140##2	a_200_74##3	1.80407e-19
C712	a_200_74##8	VNB	2.49025e-17
C713	VGND#3	D#7	1.73167e-19
C714	D#9	D#1	2.91415e-18
C715	a_472_388##24	VPWR#11	6.93031e-17
C716	a_200_74##4	VNB	9.48331e-17
C717	A_N#2	VNB	6.58461e-17
C718	B_N#2	VNB	6.49569e-17
C719	a_412_140#	a_27_74##4	9.82428e-19
C720	VPWR	C	1.58313e-18
C721	VPWR	A_N	1.71242e-18
C722	VPWR#4	a_27_74#	3.87744e-19
C723	VGND	C	2.34486e-18
C724	VPWR	B_N	2.80662e-18
C725	a_412_140#	D#3	6.79575e-19
C726	VGND	A_N	2.01908e-18
C727	VGND	B_N	2.98926e-18
C728	C	VNB	2.31597e-18
C729	A_N	VNB	5.06522e-18
C730	B_N	VNB	2.02546e-17
C731	X	VNB	6.91687e-17
C732	a_200_74##8	a_200_74##7	7.59017e-18
C733	a_472_388##7	a_472_388##6	4.12739e-18
C734	VPWR	VNB	2.95946e-16
C735	VGND	VNB	2.94312e-16
C736	X#1	VPWR#3	5.25841e-18
C737	a_472_388##18	C#6	2.47755e-17
C738	a_685_140#	a_27_74##4	2.66055e-17
C739	VPWR#14	VPWR#12	5.82112e-19
C740	VGND#6	a_200_74##11	5.36377e-17
C741	VGND#6	a_200_74##4	1.52681e-17
C742	a_27_74##9	VPWR#14	2.14697e-17
C743	VPWR#14	B_N#1	2.58249e-18
C744	VPWR#14	VNB	5.34442e-17
C745	VPWR#14	A_N#1	4.51724e-18
C746	VPWR#14	B_N#2	5.63847e-20
C747	a_200_74##13	VPWR#14	1.51522e-17
C748	VPWR#14	A_N#2	6.1158e-20
C749	VPWR	VPWR#14	9.2306e-17
C750	VGND#6	a_27_74##7	2.22396e-17
C751	VGND#6	B_N#3	1.24646e-18
C752	VGND#6	VNB	7.26722e-17
C753	VGND#6	a_27_74##8	1.78091e-17
C754	VGND#6	A_N#3	3.73938e-18
C755	VGND#6	B_N#2	6.44191e-20
C756	VGND	VGND#6	1.28463e-16
C757	VGND#6	A_N#2	6.1776e-20
*
*
.ENDS sky130_fd_sc_hs__and4bb_4
*
