* Extracted by Quantus, converted by sky130cad/quantus.py
*
*
*
*                       LINUX           Wed Nov 18 08:59:06 2026
*
*
*
*  PROGRAM  advgen
*
*  Name           : advgen - Quantus - (64-bit)
*  Version        : 25.1.0-p047
*  Build Date     : Thu Dec 11 23:20:30 PST 2025
*
*  HSPICE LIBRARY
*
*  OPERATING_TEMPERATURE 150
*  QRC_TECH_DIR <path>/tech
*
*
*

*
.SUBCKT sky130_fd_sc_hs__o22ai_4 VNB VPB VGND VPWR Y B1 A2 A1 B2
*
*
*  caps2d version: 10
*
*
*       TRANSISTOR CARDS
*
*
XM0 a_27_74##13 A1#5 VGND#10 VNB sky130_fd_pr__nfet_01v8_lvt l=0.15 w=0.74 ad=0.2109 as=0.259 pd=2.05 ps=2.18
XM23 VGND#10 A1#7 a_27_74##16 VNB sky130_fd_pr__nfet_01v8_lvt l=0.15 w=0.74 ad=0.259 as=0.2072 pd=2.18 ps=2.04
XM30 a_27_74##16 A1#6 VGND#9 VNB sky130_fd_pr__nfet_01v8_lvt l=0.15 w=0.74 ad=0.2072 as=0.259 pd=2.04 ps=2.18
XM21 a_27_74##15 A2#12 VGND#9 VNB sky130_fd_pr__nfet_01v8_lvt l=0.15 w=0.74 ad=0.2072 as=0.259 pd=2.04 ps=2.18
XM1 a_27_74##15 A2#10 VGND#8 VNB sky130_fd_pr__nfet_01v8_lvt l=0.15 w=0.74 ad=0.2072 as=0.259 pd=2.04 ps=2.18
XM24 VGND#8 A2#8 a_27_74##14 VNB sky130_fd_pr__nfet_01v8_lvt l=0.15 w=0.74 ad=0.259 as=0.2368 pd=2.18 ps=2.12
XM16 VGND#7 A2#1 a_27_74##14 VNB sky130_fd_pr__nfet_01v8_lvt l=0.15 w=0.74 ad=0.2812 as=0.2368 pd=2.24 ps=2.12
XM2 VGND#7 A1#10 a_27_74##8 VNB sky130_fd_pr__nfet_01v8_lvt l=0.15 w=0.74 ad=0.2812 as=0.2146 pd=2.24 ps=2.06
XM11 a_27_74##8 B1#7 Y#13 VNB sky130_fd_pr__nfet_01v8_lvt l=0.15 w=0.74 ad=0.2146 as=0.2516 pd=2.06 ps=2.16
XM3 Y#13 B1#5 a_27_74##6 VNB sky130_fd_pr__nfet_01v8_lvt l=0.15 w=0.74 ad=0.2516 as=0.2146 pd=2.16 ps=2.06
XM27 Y#11 B1#1 a_27_74##6 VNB sky130_fd_pr__nfet_01v8_lvt l=0.15 w=0.74 ad=0.2072 as=0.2146 pd=2.04 ps=2.06
XM9 Y#11 B2#10 a_27_74##4 VNB sky130_fd_pr__nfet_01v8_lvt l=0.15 w=0.74 ad=0.2072 as=0.2072 pd=2.04 ps=2.04
XM19 a_27_74##4 B2#7 Y#9 VNB sky130_fd_pr__nfet_01v8_lvt l=0.15 w=0.74 ad=0.2072 as=0.259 pd=2.04 ps=2.18
XM5 a_27_74##2 B2#5 Y#9 VNB sky130_fd_pr__nfet_01v8_lvt l=0.15 w=0.74 ad=0.259 as=0.259 pd=2.18 ps=2.18
XM10 Y#7 B2#1 a_27_74##2 VNB sky130_fd_pr__nfet_01v8_lvt l=0.15 w=0.74 ad=0.259 as=0.259 pd=2.18 ps=2.18
XM31 a_27_74# B1#10 Y#7 VNB sky130_fd_pr__nfet_01v8_lvt l=0.15 w=0.74 ad=0.2991 as=0.259 pd=2.41 ps=2.18
XM20 VPWR#7 A1#9 a_117_368##6 VPB sky130_fd_pr__pfet_01v8 l=0.15 w=1.12 ad=0.3304 as=0.336 pd=2.83 ps=2.84
XM25 VPWR#10 A1#8 a_117_368##6 VPB sky130_fd_pr__pfet_01v8 l=0.15 w=1.12 ad=0.392 as=0.336 pd=2.94 ps=2.84
XM13 a_117_368##4 A1#1 VPWR#10 VPB sky130_fd_pr__pfet_01v8 l=0.15 w=1.12 ad=0.336 as=0.392 pd=2.84 ps=2.94
XM12 Y#6 A2#6 a_117_368##4 VPB sky130_fd_pr__pfet_01v8 l=0.15 w=1.12 ad=0.392 as=0.336 pd=2.94 ps=2.84
XM15 Y#6 A2#11 a_117_368##2 VPB sky130_fd_pr__pfet_01v8 l=0.15 w=1.12 ad=0.392 as=0.336 pd=2.94 ps=2.84
XM29 a_117_368##2 A2#9 Y#4 VPB sky130_fd_pr__pfet_01v8 l=0.15 w=1.12 ad=0.336 as=0.336 pd=2.84 ps=2.84
XM7 a_117_368# A2#7 Y#4 VPB sky130_fd_pr__pfet_01v8 l=0.15 w=1.12 ad=0.336 as=0.336 pd=2.84 ps=2.84
XM4 a_117_368# A1#12 VPWR#9 VPB sky130_fd_pr__pfet_01v8 l=0.15 w=1.12 ad=0.336 as=0.448 pd=2.84 ps=3.04
XM14 a_877_368##5 B1#9 VPWR#9 VPB sky130_fd_pr__pfet_01v8 l=0.15 w=1.12 ad=0.336 as=0.448 pd=2.84 ps=3.04
XM18 VPWR#8 B1#8 a_877_368##5 VPB sky130_fd_pr__pfet_01v8 l=0.15 w=1.12 ad=0.336 as=0.336 pd=2.84 ps=2.84
XM6 a_877_368##3 B1#4 VPWR#8 VPB sky130_fd_pr__pfet_01v8 l=0.15 w=1.12 ad=0.392 as=0.336 pd=2.94 ps=2.84
XM26 a_877_368##3 B2#12 Y#15 VPB sky130_fd_pr__pfet_01v8 l=0.15 w=1.12 ad=0.392 as=0.336 pd=2.94 ps=2.84
XM8 Y#15 B2#11 a_877_368##6 VPB sky130_fd_pr__pfet_01v8 l=0.15 w=1.12 ad=0.336 as=0.336 pd=2.84 ps=2.84
XM17 Y#1 B2#8 a_877_368##6 VPB sky130_fd_pr__pfet_01v8 l=0.15 w=1.12 ad=0.3472 as=0.336 pd=2.86 ps=2.84
XM22 a_877_368# B2#4 Y#1 VPB sky130_fd_pr__pfet_01v8 l=0.15 w=1.12 ad=0.3808 as=0.3472 pd=2.92 ps=2.86
XM28 VPWR#1 B1#12 a_877_368# VPB sky130_fd_pr__pfet_01v8 l=0.15 w=1.12 ad=0.3864 as=0.3808 pd=2.93 ps=2.92
*
*
*       RESISTOR AND CAP/DIODE CARDS
*
Rg1	A1#1	A1#2	464.992432
Rg2	A1#2	A1#3	58.552822
Rg3	A1#3	A1#4	81.860123
Rg4	A1#4	A1#5	380.339874
Rg5	A1#2	A1#6	384.944061
Rg6	A1#3	A1#7	359.018188
Rg7	A1#3	A1#8	441.658081
Rg8	A1#4	A1#9	462.979767
Rg9	A2#1	A2#2	322.953644
Rg10	A2#2	A2#3	62.524544
Rg11	A2#3	A2#4	44.471581
Rg12	A2#4	A2#5	102.328880
Rg13	A2#5	A2#6	516.620850
Rg14	A2#2	A2#7	507.075531
Rg15	A2#3	A2#8	362.264893
Rg16	A2#3	A2#9	451.213501
Rg17	A2#4	A2#10	305.141052
Rg18	A2#4	A2#11	481.552399
Rg19	A2#5	A2#12	329.212952
Rg20	A1#10	A1#11	425.400726
Rg21	A1#11	A1#12	446.743103
Rg22	B1#1	B1#2	368.862610
Rg23	B1#2	B1#3	64.065247
Rg24	B1#2	B1#4	471.862823
Rg25	B1#3	B1#5	353.203918
Rg26	B1#3	B1#6	73.686935
Rg27	B1#6	B1#7	368.862610
Rg28	B1#3	B1#8	451.721924
Rg29	B1#6	B1#9	471.862823
Rg30	B2#1	B2#2	397.555725
Rg31	B2#2	B2#3	91.168007
Rg32	B2#2	B2#4	449.655212
Rg33	B2#3	B2#5	383.404541
Rg34	B2#3	B2#6	58.413109
Rg35	B2#6	B2#7	413.013641
Rg36	B2#3	B2#8	429.126801
Rg37	B2#6	B2#9	66.386436
Rg38	B2#9	B2#10	394.232941
Rg39	B2#6	B2#11	452.720551
Rg40	B2#9	B2#12	449.668243
Rg41	B1#10	B1#11	320.356293
Rg42	B1#11	B1#12	500.238068
Rf1	A2	A2#4	40.957573
Rf2	a_117_368#	a_117_368##3	51.481895
Rf3	a_117_368##3	a_117_368##5	44.980499
Rf4	a_117_368##5	a_117_368##6	88.469833
Rf5	a_117_368##2	a_117_368##3	15.000000
Rf6	a_117_368##4	a_117_368##5	7.500000
Rf7	A1#11	A1#14	232.883606
Rf8	A1#14	A1#3	185.442581
Rf9	A1#14	A1	2.734193
Rf10	B2	B2#3	40.058201
Rf11	a_877_368#	a_877_368##2	83.989441
Rf12	a_877_368##2	a_877_368##4	84.138283
Rf13	a_877_368##4	a_877_368##5	89.859291
Rf14	a_877_368##2	a_877_368##6	28.306047
Rf15	a_877_368##3	a_877_368##4	7.500000
Rf16	B1#11	B1	312.417053
Rf17	B1	B1#3	85.749374
Rf18	a_27_74#	a_27_74##3	83.427094
Rf19	a_27_74##3	a_27_74##5	67.696587
Rf20	a_27_74##5	a_27_74##7	34.550537
Rf21	a_27_74##7	a_27_74##9	44.697857
Rf22	a_27_74##9	a_27_74##10	69.690117
Rf23	a_27_74##10	a_27_74##11	68.002594
Rf24	a_27_74##11	a_27_74##12	68.569008
Rf25	a_27_74##12	a_27_74##13	85.211128
Rf26	a_27_74##10	a_27_74##14	13.666845
Rf27	a_27_74##11	a_27_74##15	13.666845
Rf28	a_27_74##12	a_27_74##16	13.076361
Rf29	a_27_74##2	a_27_74##3	15.000000
Rf30	a_27_74##4	a_27_74##5	15.000000
Rf31	a_27_74##6	a_27_74##7	15.000000
Rf32	a_27_74##8	a_27_74##9	7.500000
Rf33	Y#1	Y#2	16.278900
Rf34	Y#2	Y#3	65.430122
Rf35	Y#3	Y#5	232.709702
Rf36	Y#5	Y#6	73.734558
Rf37	Y#2	Y#8	204.366104
Rf38	Y#8	Y#10	67.696587
Rf39	Y#10	Y#12	65.260002
Rf40	Y#12	Y	28.622444
Rf41	Y	Y#14	16.172312
Rf42	Y#14	Y	0.344092
Rf43	Y#3	Y#15	14.311552
Rf44	Y#4	Y#5	15.000000
Rf45	Y#7	Y#8	15.000000
Rf46	Y#9	Y#10	15.000000
Rf47	Y#11	Y#12	15.000000
Rf48	Y#13	Y#14	15.000000
Rf49	VPWR#1	VPWR#2	56.733246
Rf50	VPWR#2	VPWR#3	176.449768
Rf51	VPWR#3	VPWR#4	72.328270
Rf52	VPWR#4	VPWR#5	49.284554
Rf53	VPWR#5	VPWR#6	158.860306
Rf54	VPWR#6	VPWR#7	116.990257
Rf55	VPWR#3	VPWR#8	40.097046
Rf56	VPWR#4	VPWR#9	33.326477
Rf57	VPWR#6	VPWR#10	30.747387
Rf58	VGND#1	VGND#2	300.785431
Rf59	VGND#2	VGND#3	52.571827
Rf60	VGND#3	VGND#4	67.887894
Rf61	VGND#4	VGND#5	67.887894
Rf63	VGND#2	VGND#7	36.824379
Rf64	VGND#3	VGND#8	33.326477
Rf65	VGND#4	VGND#9	33.326477
Rf66	VGND#5	VGND#10	36.082184
Re1	VPWR#2	VPWR	4.549932
Re2	VPWR	VPWR#5	0.974985
Re3	VGND#1	VGND	4.549932
Re4	VGND	VGND#2	0.974985
*
*       CAPACITOR CARDS
*
*
C1	VGND#2	A2#2	9.19969e-20
C2	Y#6	Y#4	8.82228e-19
C3	Y#7	a_27_74##2	4.28197e-17
C4	A2#1	VGND#7	2.53683e-17
C5	VGND#8	A1#10	3.02236e-19
C6	VPWR#4	B1#9	4.56421e-18
C7	Y#3	B1#4	1.64178e-17
C8	a_27_74##8	A2#8	7.65688e-19
C9	a_117_368##2	Y#6	4.24214e-17
C10	B1#11	B2#6	8.37276e-18
C11	A2#1	a_27_74##14	8.61211e-18
C12	a_117_368##4	A2#5	1.97934e-19
C13	VPWR#3	B1#9	4.19594e-19
C14	Y#2	Y#1	6.76235e-19
C15	Y#9	Y#7	2.27577e-18
C16	B1#11	B2#2	4.08137e-17
C17	a_877_368##5	VPWR#4	8.76492e-18
C18	VGND#7	A2#8	1.32888e-18
C19	VGND#8	A2#1	1.49832e-18
C20	Y#3	a_877_368##6	4.33106e-17
C21	B1#11	B1#2	3.99513e-19
C22	a_27_74##8	A2#10	3.46244e-19
C23	A2#8	a_27_74##14	1.13844e-17
C24	VPWR#4	A1#12	4.45854e-18
C25	a_877_368##5	VPWR#3	8.14065e-18
C26	Y#3	B1#8	1.47873e-17
C27	a_27_74##2	Y#9	4.51562e-17
C28	a_117_368##4	Y#6	6.00766e-17
C29	a_877_368##2	B2#8	1.59206e-17
C30	VPWR#3	A1#12	1.3925e-19
C31	Y#2	a_877_368##6	4.25032e-17
C32	VGND#8	A2#8	3.56687e-17
C33	a_27_74##8	A2#12	2.32201e-19
C34	Y#3	Y#15	1.30266e-20
C35	B2#3	B2#9	5.6378e-18
C36	a_27_74##4	a_27_74##2	2.80175e-18
C37	B2#3	B2#6	2.34459e-17
C38	Y#3	B1#9	1.49247e-19
C39	VPWR#9	VPWR#3	8.16037e-20
C40	A2#10	VGND#8	2.02914e-17
C41	a_877_368##2	B2#9	8.58444e-20
C42	B2#3	B2#2	1.02386e-17
C43	a_877_368##2	B2#11	1.57259e-17
C44	VGND#9	A2#8	3.18276e-19
C45	a_27_74##12	a_27_74##11	2.42159e-18
C46	a_117_368##4	VPWR#10	7.05946e-17
C47	a_117_368##4	A1#2	2.25002e-19
C48	A2#10	a_27_74##15	1.49812e-17
C49	a_117_368#	VPWR#4	2.39404e-18
C50	Y#3	a_877_368##3	9.39336e-17
C51	VGND#4	A2#5	8.07251e-20
C52	Y#9	a_27_74##4	4.33102e-17
C53	VGND#8	A2#12	7.30871e-19
C54	a_117_368##6	a_117_368##4	2.54741e-18
C55	VGND#9	A2#10	1.61711e-18
C56	B2#9	B2#6	3.06076e-18
C57	a_877_368##2	B2#6	1.45753e-19
C58	Y#3	A1#12	1.08656e-19
C59	A2#2	a_27_74##14	4.39158e-19
C60	A2#12	a_27_74##15	5.46871e-18
C61	a_117_368##6	VPWR#10	7.21584e-17
C62	Y#4	VPWR#4	1.33197e-18
C63	VGND#9	A2#12	3.56687e-17
C64	Y#3	VPWR#8	8.47881e-19
C65	a_877_368##2	VPWR#3	2.99066e-17
C66	VPWR#7	VPWR#10	1.85043e-18
C67	B1#3	B1#6	2.17396e-17
C68	a_117_368##2	VPWR#6	6.17399e-18
C69	VPWR#10	A1#2	7.43193e-20
C70	a_27_74##11	a_27_74##10	2.42159e-18
C71	B1#3	B1#2	2.14233e-17
C72	a_27_74##4	Y#11	3.75216e-17
C73	A1#6	VGND#9	2.02696e-17
C74	VGND#10	A2#12	1.76464e-19
C75	VPWR#7	a_117_368##6	8.59557e-17
C76	Y#3	a_877_368##5	5.1663e-17
C77	A1#6	a_27_74##16	1.49687e-17
C78	VPWR#6	A2#6	5.3494e-18
C79	VGND#9	A1#7	7.26534e-19
C80	Y#9	Y#13	4.31894e-20
C81	VGND#10	A1#6	1.61244e-18
C82	A2#5	a_27_74##15	5.58558e-19
C83	a_117_368##6	A1#4	1.45204e-18
C84	A1#11	B2#9	3.07021e-19
C85	A1#7	a_27_74##16	2.62275e-18
C86	a_27_74##13	A1#6	2.02452e-19
C87	VGND#10	A1#7	3.70938e-17
C88	a_27_74##6	Y#11	1.98831e-17
C89	A1#11	B1#6	3.54372e-17
C90	A1#11	B1#2	4.20942e-20
C91	VPWR#6	A1#1	2.57728e-18
C92	A1#11	A2#5	1.60895e-19
C93	a_27_74##13	A1#7	1.66555e-18
C94	a_117_368##4	VPWR#6	3.06622e-17
C95	VPWR#3	B2#9	1.13558e-20
C96	A2#2	A1#11	3.50905e-17
C97	A1#5	VGND#10	1.89423e-17
C98	B2#6	B2#2	2.12792e-18
C99	B2#1	B1#10	2.52902e-17
C100	A1#11	A1#2	4.05852e-19
C101	a_27_74##13	A1#5	5.72922e-17
C102	VPWR#6	A1#8	1.48376e-18
C103	VPWR#3	B2#6	1.09861e-20
C104	a_27_74##6	Y#13	2.38216e-19
C105	a_877_368##2	Y#1	2.46063e-19
C106	B2#5	B2#1	2.74805e-17
C107	VPWR#4	B1#6	4.57114e-20
C108	Y#4	Y#3	1.02972e-18
C109	B1#4	B2#9	1.16538e-18
C110	A2#5	A2#4	4.07881e-18
C111	VPWR#6	A2#5	5.7386e-20
C112	A2#4	A2#2	4.80129e-18
C113	VPWR#6	A1#9	3.0357e-18
C114	B1#2	B2#9	2.59947e-17
C115	a_117_368##6	VPWR#6	1.5429e-17
C116	a_877_368##2	a_877_368##6	5.47123e-20
C117	B2#7	B2#5	2.75603e-17
C118	B1#12	VPWR#1	2.50906e-17
C119	a_27_74##8	Y#13	1.58734e-18
C120	a_877_368#	B1#12	5.1995e-17
C121	Y#3	a_877_368##2	2.55837e-17
C122	a_877_368##2	Y#15	7.86096e-19
C123	VPWR#1	B2#4	4.61824e-19
C124	VPWR#7	VPWR#6	9.07052e-19
C125	B2#10	B2#7	3.98545e-17
C126	a_877_368#	B2#4	3.84074e-17
C127	A1#3	A2#5	7.13646e-18
C128	a_877_368##6	B1#12	3.93614e-19
C129	A1#3	A2#2	1.95509e-19
C130	VPWR#1	B2#8	1.8922e-19
C131	B2#4	Y#1	2.37323e-17
C132	A1#3	A1#4	2.23955e-17
C133	Y#2	a_877_368##2	1.43922e-17
C134	A1#3	A1#2	1.81984e-17
C135	a_877_368#	B2#8	7.80102e-19
C136	a_877_368##6	B2#4	6.1146e-19
C137	a_27_74##8	VGND#7	5.81899e-17
C138	B1#1	B2#10	3.91991e-17
C139	VPWR#1	B2#11	6.57738e-20
C140	B2#8	Y#1	2.37323e-17
C141	a_877_368#	B2#11	3.28804e-19
C142	B2#8	a_877_368##6	2.39003e-17
C143	VPWR#6	A1#4	2.05092e-20
C144	VPWR#1	B2#12	3.66478e-20
C145	B1#5	B1#1	3.68521e-17
C146	B2#11	a_877_368##6	2.73382e-17
C147	a_877_368##3	B2#8	3.00902e-19
C148	VGND#4	VGND#3	1.44368e-18
C149	B2#11	Y#15	2.32329e-17
C150	Y#2	VPWR#2	1.75184e-17
C151	a_877_368##6	B2#12	6.2318e-19
C152	a_877_368##3	B2#11	6.72697e-19
C153	B1#7	B1#5	3.0312e-17
C154	VGND#10	A1#4	5.40133e-19
C155	B2#12	Y#15	2.32329e-17
C156	VGND#8	VGND#7	1.87259e-18
C157	a_877_368##6	B1#4	2.69851e-19
C158	a_877_368##3	B2#12	3.84808e-17
C159	a_877_368#	B2#6	2.17473e-20
C160	VGND#3	VGND#2	1.44687e-18
C161	VPWR#8	B2#12	7.30289e-19
C162	A1#10	B1#7	3.60987e-17
C163	a_877_368##3	B1#4	4.42457e-17
C164	a_877_368##5	B2#12	2.1004e-19
C165	a_877_368#	B2#2	9.04228e-20
C166	B1#2	B2#10	1.10686e-18
C167	VPWR#8	B1#4	3.90238e-17
C168	a_877_368##3	B1#8	4.35308e-19
C169	A2#1	A1#10	2.50441e-17
C170	a_877_368##5	B1#4	1.4023e-18
C171	a_27_74##13	A1#4	1.5068e-18
C172	B1#8	VPWR#8	2.27214e-17
C173	VPWR#9	B1#4	2.84892e-19
C174	Y#4	B2#12	1.03103e-19
C175	a_877_368##2	VPWR#2	4.46932e-17
C176	a_877_368##5	B1#8	6.17731e-17
C177	B2#6	Y#1	2.92383e-19
C178	A2#8	A2#1	3.225e-17
C179	VPWR#8	B1#9	2.50123e-19
C180	VPWR#9	B1#8	1.36503e-18
C181	Y#4	B1#4	1.7598e-19
C182	a_877_368##5	B1#9	4.65033e-17
C183	B2#2	Y#1	2.88728e-19
C184	VGND#9	VGND#8	1.88328e-18
C185	B1#9	VPWR#9	2.97035e-17
C186	VPWR#8	A1#12	1.16651e-19
C187	Y#4	B1#8	7.68591e-19
C188	VGND#2	a_27_74##10	1.09074e-17
C189	A2#10	A2#8	2.78636e-17
C190	a_877_368##5	A1#12	1.3628e-18
C191	B1#11	Y#2	2.08021e-17
C192	A1#12	VPWR#9	2.33924e-17
C193	Y#4	B1#9	2.71617e-17
C194	a_117_368#	A1#12	3.92468e-17
C195	a_877_368##5	A2#7	4.31468e-19
C196	B2#6	a_877_368##6	1.56267e-18
C197	A2#12	A2#10	3.82503e-17
C198	Y#4	A1#12	2.86095e-17
C199	VPWR#9	A2#7	1.29477e-18
C200	VPWR#4	B1#3	8.5328e-21
C201	Y#6	B1#9	9.68001e-20
C202	Y#3	B2#9	1.42231e-18
C203	VPWR#3	B1#3	3.59597e-20
C204	VGND#1	a_27_74#	7.77803e-17
C205	a_117_368#	A2#7	4.51593e-17
C206	a_877_368##5	A2#9	2.68693e-19
C207	VGND#1	Y#7	1.91652e-17
C208	Y#4	A2#7	3.2066e-17
C209	Y#6	A1#12	1.37382e-19
C210	VPWR#9	A2#9	6.40889e-19
C211	VGND#1	a_27_74##2	8.73415e-17
C212	A1#6	A2#12	2.78636e-17
C213	VGND#1	Y#9	1.61153e-18
C214	a_117_368##4	A1#12	1.89349e-19
C215	a_877_368##5	A2#11	1.83577e-19
C216	VGND#1	a_27_74##4	6.5664e-17
C217	B2	B2#9	3.53418e-18
C218	Y#3	B2#6	1.60971e-18
C219	B1#3	Y#3	6.48915e-17
C220	Y#6	A2#7	2.32882e-19
C221	Y#4	A2#9	3.52912e-17
C222	B2	B2#6	9.25087e-18
C223	VPWR#9	A2#11	3.36126e-19
C224	B2	B2#2	4.89248e-18
C225	B2	B1#6	4.32317e-20
C226	VGND#10	VGND#9	2.24931e-18
C227	a_117_368##2	A2#9	4.53348e-17
C228	a_117_368##4	A2#7	2.75436e-19
C229	B2	B1#2	1.06102e-18
C230	A1#7	A1#6	3.86354e-17
C231	VGND#1	a_27_74##6	9.89057e-18
C232	VGND#4	A2#4	1.13015e-20
C233	Y#6	A2#9	7.91693e-19
C234	VGND#3	A2#4	7.58816e-20
C235	VPWR#10	A2#7	2.17619e-19
C236	Y#4	A2#11	9.78435e-20
C237	VPWR#9	A2#6	2.21794e-19
C238	a_117_368##4	A2#9	4.55812e-19
C239	VPWR#6	A2#4	5.25245e-20
C240	a_117_368##2	A2#11	4.10262e-17
C241	Y#7	Y#2	1.53025e-18
C242	A1#5	A1#7	2.3813e-17
C243	VPWR#10	A2#9	3.27368e-19
C244	Y#6	A2#11	4.92957e-17
C245	a_117_368##4	A2#11	1.55021e-18
C246	a_117_368##6	A2#9	2.93925e-20
C247	VGND#4	A1#3	2.35423e-20
C248	B1#11	a_27_74#	1.13988e-18
C249	a_27_74##10	A1#11	2.88612e-18
C250	VPWR#10	A2#11	7.07089e-19
C251	A2#6	Y#6	2.56297e-17
C252	B1#11	Y#7	1.27521e-16
C253	Y#2	B2#6	2.7149e-18
C254	VGND#2	a_27_74##6	5.08843e-17
C255	Y#7	B2#2	1.10771e-18
C256	A1#3	VPWR#6	3.12381e-19
C257	VPWR#2	VPWR#1	2.96388e-17
C258	a_117_368##6	A2#11	4.41047e-20
C259	a_117_368##4	A2#6	6.54661e-17
C260	Y#3	B1#6	9.13777e-19
C261	B1#11	Y#9	2.85573e-17
C262	a_877_368#	VPWR#2	7.51645e-17
C263	A1	A2#5	1.34403e-18
C264	VPWR#10	A2#6	1.29477e-18
C265	VGND#2	a_27_74##8	5.01768e-17
C266	VGND#3	A2#8	1.22302e-18
C267	A1	A2#2	1.45962e-18
C268	a_27_74##13	VGND#10	5.58262e-17
C269	A1#10	B1#6	1.20594e-18
C270	VPWR#4	VPWR#3	1.12342e-18
C271	a_27_74##11	A2#4	3.09803e-18
C272	a_117_368##6	A2#6	7.34123e-20
C273	a_117_368##4	A1#1	5.99998e-17
C274	B2#3	Y#7	2.20059e-18
C275	a_27_74##10	A2#4	3.11971e-18
C276	A1#1	VPWR#10	2.68022e-17
C277	Y#2	B2#2	1.61722e-18
C278	a_27_74##2	B2#6	5.30517e-19
C279	Y#3	B1#2	4.08154e-19
C280	a_117_368##6	A1#1	8.95656e-19
C281	a_117_368##4	A1#8	1.37074e-18
C282	a_27_74##12	A1#3	6.96387e-17
C283	VPWR#10	A1#8	4.60659e-17
C284	B2#4	B1#12	3.57647e-17
C285	VGND#3	A2#10	2.71574e-18
C286	a_27_74##11	A1#3	3.8196e-18
C287	a_117_368##6	A1#8	4.10915e-17
C288	a_117_368##4	A1#9	1.98864e-19
C289	a_27_74##2	B2#2	3.30494e-19
C290	VPWR#7	A1#8	1.17456e-18
C291	A2	B1#6	2.18995e-19
C292	VPWR#10	A1#9	2.66217e-18
C293	A2	B1#2	6.15517e-20
C294	Y#9	B2#9	1.91535e-19
C295	A2	A2#5	1.56066e-17
C296	Y#11	B1#3	4.4379e-18
C297	a_877_368##3	B1#2	2.99517e-20
C298	A2	A2#2	1.1722e-17
C299	a_117_368##6	A1#9	5.58694e-17
C300	B2#8	B2#4	4.38024e-17
C301	VGND#4	A2#12	1.23778e-18
C302	A2#2	A1#10	2.60185e-18
C303	A2	A1#4	1.96221e-19
C304	B1#3	a_27_74##6	3.06219e-18
C305	A2	A1#2	3.94449e-18
C306	VPWR#7	A1#9	3.23867e-17
C307	B1#3	Y#13	3.48621e-18
C308	a_27_74##8	B1#3	4.10119e-18
C309	VPWR#1	B1#11	4.35356e-19
C310	A1#2	A2#6	2.35935e-18
C311	Y#9	B2#6	1.68647e-18
C312	B2#11	B2#8	4.70895e-17
C313	a_877_368#	B1#11	3.28969e-19
C314	a_117_368#	VPWR#5	2.555e-17
C315	a_877_368#	VPWR#1	7.03034e-17
C316	VGND#4	A1#6	2.71574e-18
C317	a_27_74##8	A1#11	2.39345e-17
C318	B1	B2#9	2.26228e-17
C319	VGND#7	A1#11	6.0436e-19
C320	a_117_368##2	VPWR#5	3.31458e-17
C321	B1	B2#6	1.03205e-17
C322	B2#12	B2#11	4.55455e-17
C323	Y#9	B2#2	1.18656e-19
C324	B1	B1#6	1.55111e-19
C325	B1	B1#2	1.28463e-18
C326	a_27_74##4	B2#9	4.17646e-19
C327	B1	A2#2	4.82279e-19
C328	VPWR#8	B1#2	1.0988e-19
C329	a_27_74##8	Y#4	1.03648e-17
C330	VGND#1	B1#10	6.74759e-18
C331	B1#4	B2#12	3.63647e-17
C332	A2#4	a_27_74##14	4.74775e-19
C333	VGND#1	B2#1	6.08997e-18
C334	a_877_368#	Y#1	2.23005e-19
C335	a_27_74##10	A1#10	4.62761e-19
C336	A2#4	VGND#8	2.82359e-18
C337	a_27_74##4	B2#6	3.42604e-19
C338	a_27_74##12	A2#1	2.97347e-19
C339	VGND#1	B2#5	4.43427e-18
C340	A2#4	a_27_74##15	3.29549e-19
C341	VGND#1	B2#7	4.43427e-18
C342	B1#8	B1#4	4.77416e-17
C343	a_27_74##11	A2#1	1.91128e-19
C344	B1#3	VPWR#8	3.87563e-18
C345	VGND#1	B2#10	4.43427e-18
C346	a_27_74#	B1#10	2.69043e-17
C347	a_877_368##5	B1#6	3.28377e-19
C348	VGND#4	a_27_74##12	7.00275e-18
C349	a_877_368##6	a_877_368#	3.78151e-18
C350	B1#3	a_877_368##5	3.23009e-18
C351	Y	B1#6	1.78203e-18
C352	a_27_74##10	A2#1	3.24446e-17
C353	B1#9	B1#8	4.66545e-17
C354	Y	B1#2	1.09058e-18
C355	a_27_74##12	A2#8	4.32717e-19
C356	Y#7	B1#10	4.5241e-17
C357	Y#11	B2#9	4.01605e-19
C358	A1#3	a_27_74##16	2.5292e-18
C359	B1#3	Y#4	8.84695e-18
C360	a_877_368##5	B1#2	7.82071e-20
C361	B1#11	B1#10	4.19454e-18
C362	A1#3	VGND#10	4.24402e-18
C363	a_27_74#	B2#1	1.25e-18
C364	a_27_74##13	A1#3	2.41571e-17
C365	B1#11	B2#1	1.23783e-17
C366	A1#11	VPWR#9	1.33001e-18
C367	a_27_74##11	A2#8	1.0331e-18
C368	A1#2	A2#5	2.3522e-17
C369	A1#11	a_117_368#	1.88853e-18
C370	A1#12	B1#9	3.1449e-17
C371	a_27_74##2	B1#10	1.68498e-18
C372	B2	Y#3	4.84631e-17
C373	B1#11	B2#5	8.43482e-18
C374	VGND#2	B1#1	4.48038e-18
C375	B2	Y#2	6.88539e-17
C376	VGND#4	a_27_74##11	7.34874e-18
C377	A1#11	Y#4	2.61176e-17
C378	VGND#2	B1#5	4.46238e-18
C379	Y#7	B2#1	3.07125e-17
C380	a_27_74##10	A2#8	2.06955e-17
C381	a_27_74##12	A2#10	8.97522e-19
C382	VGND#2	B1#7	4.43427e-18
C383	Y#9	B1#10	7.51868e-19
C384	A2#7	A1#12	4.60406e-17
C385	VGND#2	A1#10	2.44515e-18
C386	Y#4	A2#4	2.67169e-19
C387	a_27_74##2	B2#1	3.83889e-17
C388	VGND#2	A2#1	9.56465e-19
C389	a_27_74##11	A2#10	3.2884e-17
C390	a_117_368##2	A2#4	5.65494e-19
C391	Y#6	A2#4	6.92465e-19
C392	VGND#3	a_27_74##11	6.9896e-18
C393	Y#7	B2#5	1.51674e-18
C394	a_117_368##4	A2#4	3.98846e-20
C395	A2#9	A2#7	4.61903e-17
C396	VPWR#2	B1#12	5.79921e-18
C397	a_27_74##11	A2#5	1.68129e-18
C398	a_27_74##10	A2#10	4.04506e-19
C399	Y#9	B2#1	1.567e-18
C400	a_27_74##10	A1	3.91468e-18
C401	a_27_74##12	A2#12	2.40588e-18
C402	VPWR#2	B2#4	5.94061e-18
C403	a_27_74##2	B2#5	3.18052e-17
C404	a_877_368##3	a_877_368##6	3.51463e-18
C405	VPWR#2	B2#8	4.60467e-18
C406	A1#3	a_117_368##4	4.97502e-17
C407	A2#11	A2#9	4.61961e-17
C408	a_27_74##4	B2#1	3.44525e-19
C409	a_27_74##11	A2#12	2.52219e-17
C410	A1#3	VPWR#10	4.51072e-18
C411	B2	Y#7	1.26131e-18
C412	Y#7	B2#7	1.9737e-19
C413	A1#3	a_117_368##6	5.18583e-17
C414	Y#9	B2#5	3.61371e-17
C415	VGND#3	a_27_74##10	4.14547e-18
C416	a_27_74##10	a_27_74##8	2.51693e-18
C417	a_27_74##11	A2	7.00394e-17
C418	A2#6	A2#11	3.19814e-17
C419	a_27_74##10	A2	5.05054e-17
C420	a_27_74##12	A1#6	4.31388e-17
C421	a_27_74##2	B2#7	7.16139e-19
C422	a_27_74##4	B2#5	7.86036e-19
C423	A1#1	A2#6	4.63871e-17
C424	a_27_74##11	A1#6	4.04506e-19
C425	Y#9	B2#7	2.8887e-17
C426	VGND	B1#6	4.97058e-20
C427	VGND	B1#2	3.44259e-20
C428	VGND	A2#5	3.54218e-19
C429	B1	Y#3	2.33032e-17
C430	VGND	A2#2	3.18796e-19
C431	a_27_74##10	VGND#7	4.96535e-17
C432	A1#8	A1#1	3.80354e-17
C433	a_27_74##12	A1#7	2.64595e-17
C434	a_27_74##4	B2#7	3.40557e-17
C435	a_877_368##3	VPWR#8	5.51666e-17
C436	VPWR#2	B2#6	4.22436e-20
C437	B2	a_877_368##6	8.69412e-19
C438	B2	Y#15	2.35532e-18
C439	Y#9	B2#10	1.47854e-18
C440	VPWR#5	A2#7	5.3494e-18
C441	A1#9	A1#8	4.72662e-17
C442	VPWR#2	B2#2	1.19615e-20
C443	VPWR#5	A2#9	5.30839e-18
C444	A1#6	A2#5	2.14291e-18
C445	a_877_368##5	a_877_368##3	2.70417e-18
C446	VPWR#5	A2#11	5.35905e-18
C447	a_27_74##10	a_27_74##14	1.4853e-17
C448	a_27_74##4	B2#10	3.46224e-17
C449	a_27_74##6	B1#2	2.08116e-19
C450	a_27_74##11	VGND#8	4.74423e-17
C451	a_27_74##12	A1#5	7.41499e-19
C452	A1#11	B2#12	2.28704e-19
C453	B1	Y#9	4.92733e-17
C454	VPWR#3	B2#4	3.93943e-20
C455	Y#9	B1#1	8.30727e-19
C456	A1#11	B1#4	4.00896e-19
C457	B1	Y#11	3.96832e-17
C458	VPWR	VPWR#6	1.05184e-16
C459	Y#11	B2#10	2.59126e-17
C460	VPWR	VPWR#4	5.90648e-17
C461	A1#11	B1#8	6.63955e-19
C462	A1	a_117_368#	7.44663e-20
C463	a_877_368##5	VPWR#8	5.27032e-17
C464	VPWR	VPWR#3	1.10891e-16
C465	A1	Y#4	5.97774e-17
C466	A1#11	B1#9	2.68615e-18
C467	A1	a_117_368##2	1.53913e-18
C468	a_117_368#	A2#2	1.46471e-19
C469	A1	Y#6	6.26322e-17
C470	a_27_74##10	A2#2	2.01113e-18
C471	A1#11	A1#12	6.4945e-18
C472	VPWR	Y#3	1.51741e-17
C473	A1	a_117_368##4	1.06352e-18
C474	VPWR	Y#2	9.32145e-19
C475	a_27_74##10	VGND#8	4.25766e-17
C476	VGND#1	B2#9	2.89501e-20
C477	A2#7	A1#11	2.98394e-18
C478	a_117_368##6	A1	3.55165e-19
C479	Y#9	B1#5	5.12046e-19
C480	VGND#1	B2#6	7.36763e-20
C481	VPWR#9	VPWR#8	1.45557e-18
C482	a_27_74##11	a_27_74##15	2.96381e-18
C483	a_27_74##8	B2#7	1.82069e-19
C484	Y	a_27_74##6	5.22139e-17
C485	A2#4	A2#7	2.59382e-18
C486	Y#11	B1#1	2.25729e-17
C487	Y	Y#13	1.14472e-18
C488	a_27_74##8	Y	5.7401e-17
C489	VPWR#3	B2#8	6.98256e-20
C490	VGND#1	B2#2	2.16685e-20
C491	VPWR	a_877_368##2	2.58972e-17
C492	Y#3	B1#12	5.21622e-19
C493	VGND	VGND#4	5.63993e-17
C494	a_27_74##12	VGND#9	4.9819e-17
C495	VGND	VGND#3	5.26506e-17
C496	A2#11	A2#4	2.59382e-18
C497	VPWR#2	B1#11	3.52164e-18
C498	VGND#1	B1#11	9.09572e-18
C499	a_27_74##6	B1#1	3.55774e-17
C500	VPWR#9	a_877_368##5	3.08031e-17
C501	Y#2	B1#12	3.29489e-17
C502	VGND	Y#3	6.17088e-18
C503	VGND	a_27_74##12	1.80543e-17
C504	Y#9	B1#7	3.57326e-19
C505	VGND#1	B2#3	3.61113e-18
C506	a_27_74##8	B2#10	2.58111e-19
C507	VGND	a_27_74##11	1.78475e-17
C508	A1#3	A2#6	7.83235e-18
C509	VGND	a_27_74##10	1.82221e-17
C510	A2	B1#1	1.97328e-19
C511	A1#3	A1#1	5.10219e-18
C512	A2	B1#5	2.90369e-19
C513	a_27_74##11	VGND#9	4.50975e-17
C514	B2	B1#12	2.30391e-18
C515	A2	B1#7	4.54519e-19
C516	A1#3	A1#8	2.7544e-18
C517	B2#9	VNB	2.96226e-17
C518	B2#6	VNB	5.57165e-17
C519	B2#2	VNB	2.63659e-17
C520	A2	A1#10	1.07467e-18
C521	B2	B2#4	2.07554e-18
C522	B1#6	VNB	2.60725e-17
C523	B1#2	VNB	2.15666e-17
C524	A2#5	VNB	2.76125e-17
C525	A2#2	VNB	2.72932e-17
C526	B2	B2#8	2.03199e-18
C527	A1#3	A1#9	7.672e-19
C528	A1#4	VNB	4.4562e-17
C529	A1#2	VNB	2.04204e-17
C530	B1	B2#7	8.10938e-18
C531	VPWR#3	B2#11	4.68233e-18
C532	a_27_74##13	VPWR#7	1.39693e-17
C533	VGND#7	B2#10	3.99847e-20
C534	a_27_74##12	a_27_74##16	2.52842e-18
C535	Y#3	B2#4	6.28036e-19
C536	B2	B2#11	1.75967e-18
C537	B1#11	B2#3	7.05088e-17
C538	B1	B2#10	8.77794e-18
C539	VGND#2	B1#3	5.68047e-20
C540	Y#4	A2#2	2.26689e-19
C541	a_27_74##6	B1#5	3.62762e-17
C542	B1	B1#1	3.2854e-18
C543	B2	B2#12	7.0783e-19
C544	B1	B1#5	5.52487e-19
C545	VGND	a_27_74##2	7.30637e-18
C546	A2	A1#6	1.26148e-18
C547	B2	B1#4	5.61992e-19
C548	B1	B1#7	3.42158e-19
C549	VGND	Y#9	8.75892e-18
C550	a_27_74##8	B1#1	4.18858e-19
C551	VGND	a_27_74##4	2.61796e-17
C552	A2	A1#7	6.52052e-19
C553	VPWR#5	A2#4	1.2338e-19
C554	VPWR	a_877_368##3	2.12736e-17
C555	B1	A1#10	2.68817e-19
C556	B2	B1#8	3.58178e-19
C557	VGND	Y#11	6.40547e-18
C558	VGND	a_27_74##6	2.55757e-17
C559	A2	A1#5	5.35149e-19
C560	B1	A2#1	1.11841e-19
C561	Y	B2#1	2.62558e-19
C562	Y#2	B2#4	3.45673e-17
C563	VPWR	a_877_368##5	1.83862e-17
C564	B2	B1#9	3.24238e-19
C565	VGND	a_27_74##8	2.93465e-17
C566	Y	B2#5	3.75645e-19
C567	VGND#2	A2#4	2.74465e-20
C568	VPWR	VPWR#9	1.61609e-17
C569	VGND	VGND#7	1.62666e-17
C570	VPWR	a_117_368#	1.92538e-17
C571	Y	B2#7	6.08192e-19
C572	VPWR	Y#4	1.48685e-17
C573	VGND	VGND#8	1.61196e-17
C574	Y	B2#10	1.71492e-18
C575	a_117_368#	VPWR#9	3.22325e-17
C576	B1#5	Y#13	1.6359e-17
C577	Y#4	a_877_368##5	2.83981e-17
C578	VPWR	a_117_368##2	2.48729e-17
C579	a_27_74##8	B1#6	3.33758e-19
C580	Y	B1#1	1.21353e-17
C581	VGND	VGND#9	1.61086e-17
C582	VPWR	Y#6	6.23916e-18
C583	Y	B1#5	2.42213e-17
C584	VPWR	a_117_368##4	2.55927e-17
C585	Y	B1#7	9.17504e-18
C586	A1	B1#9	7.92016e-19
C587	A1#11	B1#3	2.21609e-17
C588	VPWR	VPWR#10	2.22944e-17
C589	VGND	a_27_74##13	1.87695e-17
C590	VPWR	a_117_368##6	1.76688e-17
C591	VGND#7	B1#1	6.94399e-20
C592	A1	A1#12	2.03492e-18
C593	VPWR	VPWR#7	5.57175e-17
C594	A1	A2#7	2.84274e-17
C595	A1	A2#9	1.70943e-17
C596	A1#11	A2#4	7.14474e-19
C597	a_27_74##12	VGND#10	5.72876e-17
C598	A1	A2#11	1.98331e-17
C599	Y#3	B2#8	2.44254e-18
C600	a_27_74##8	B1#5	1.45027e-18
C601	VPWR#3	B2#12	5.06449e-18
C602	A1	A2#6	1.15991e-17
C603	VGND	Y#4	3.82463e-18
C604	Y#4	VPWR#9	4.95952e-17
C605	A1#3	A1#11	6.17411e-19
C606	A1	A1#1	9.35861e-20
C607	VGND#4	VNB	2.95207e-17
C608	VGND#3	VNB	2.73361e-17
C609	A1	A1#8	6.17003e-20
C610	VPWR#6	VNB	5.48556e-17
C611	VPWR#2	B2	2.15036e-18
C612	A1#3	A2#4	7.83841e-19
C613	VPWR#4	VNB	2.78492e-17
C614	VPWR#3	VNB	5.19819e-17
C615	VGND	VPWR#7	4.87476e-18
C616	B1#7	Y#13	8.67324e-18
C617	Y#2	B2#8	2.97474e-17
C618	VGND	B2#5	1.66549e-18
C619	Y#2	VNB	2.30822e-17
C620	a_27_74##12	VNB	2.76926e-18
C621	VGND	B2#7	1.61774e-18
C622	a_27_74##11	VNB	2.0942e-18
C623	VGND#7	B1#5	2.34279e-19
C624	a_27_74##10	VNB	4.88955e-18
C625	VGND	B2#10	1.40154e-18
C626	VGND	B1#1	1.38862e-18
C627	VGND	B1#5	1.29951e-18
C628	VGND	B1#7	1.1976e-18
C629	a_877_368##2	VNB	5.4627e-18
C630	VGND	A1#10	4.60486e-19
C631	B2	B1#11	9.05267e-19
C632	VGND	A2#1	1.90532e-19
C633	VPWR	B2#8	1.43241e-18
C634	VGND	A2#8	6.63755e-19
C635	VPWR#5	A2#2	4.76304e-20
C636	a_117_368#	Y#4	6.09607e-17
C637	VPWR	B2#11	1.5594e-18
C638	VGND	A2#10	1.27386e-19
C639	VPWR	B2#12	1.46136e-18
C640	a_27_74##8	B1#7	6.02238e-17
C641	a_27_74#	VNB	2.44503e-17
C642	VGND	A2#12	6.37594e-19
C643	a_117_368##2	A2#2	1.78141e-20
C644	Y#7	VNB	4.91449e-17
C645	a_27_74##2	VNB	4.90362e-18
C646	VGND	A1#6	3.88473e-20
C647	VPWR	B1#4	6.61018e-19
C648	B2	B1#3	4.7757e-20
C649	Y#9	VNB	3.13437e-19
C650	a_27_74##4	VNB	4.81521e-18
C651	VGND	A1#7	7.4344e-19
C652	VPWR	B1#8	5.6915e-19
C653	a_27_74#	Y#7	6.77473e-17
C654	a_27_74##6	VNB	4.07277e-18
C655	VGND	A1#5	7.44673e-19
C656	VPWR	B1#9	1.55837e-18
C657	B2	A1#11	2.10516e-19
C658	a_27_74##8	VNB	7.08072e-18
C659	VGND#7	VNB	3.61969e-18
C660	VPWR	A1#12	1.18251e-18
C661	VGND#8	VNB	4.4291e-19
C662	a_27_74##13	a_27_74##12	3.21785e-18
C663	VPWR	A2#7	5.36426e-19
C664	VGND#9	VNB	4.51266e-19
C665	Y#3	B2#11	4.10867e-17
C666	VPWR	A2#9	6.93505e-19
C667	VGND#10	VNB	1.28376e-18
C668	a_27_74##13	VNB	4.36012e-17
C669	VPWR#1	VNB	3.92067e-17
C670	VPWR	A2#11	6.16639e-19
C671	VPWR#3	B1#4	4.20547e-18
C672	a_877_368#	VNB	4.00588e-18
C673	VPWR	A2#6	5.01158e-19
C674	A2	B1#3	3.18682e-18
C675	A1	A2#4	1.57379e-17
C676	a_877_368##3	VNB	3.21581e-18
C677	B1	B1#11	5.77425e-19
C678	VPWR#8	VNB	3.00137e-19
C679	a_877_368##5	VNB	2.10164e-18
C680	A2	A1#11	1.41136e-17
C681	VPWR	A1#8	6.99117e-19
C682	Y#3	Y#2	3.01982e-18
C683	VPWR#9	VNB	3.77186e-18
C684	VGND#7	B1#7	5.10317e-19
C685	B1	B2#3	8.07999e-17
C686	a_117_368#	VNB	3.15425e-18
C687	VPWR	A1#9	4.47011e-18
C688	a_117_368##2	VNB	4.21429e-18
C689	A2	A2#4	3.88466e-17
C690	Y#2	VPWR#1	5.37195e-17
C691	B1	B1#3	2.53845e-19
C692	a_117_368##4	VNB	3.53901e-18
C693	VPWR#10	VNB	2.29042e-18
C694	a_117_368##6	VNB	2.83623e-18
C695	VPWR	VPWR#2	2.17431e-17
C696	A1#3	A2	2.04932e-17
C697	B1	A1#11	8.22908e-20
C698	Y#2	B2#11	1.82864e-18
C699	VPWR#7	VNB	8.23238e-17
C700	B1#10	VNB	3.10869e-17
C701	B2#1	VNB	2.74807e-17
C702	Y#6	A2#5	4.03787e-19
C703	B2#5	VNB	2.85927e-17
C704	B2#7	VNB	2.8699e-17
C705	VPWR	VPWR#5	7.74539e-17
C706	B2#10	VNB	2.78373e-17
C707	Y	B1#3	7.72006e-17
C708	B1#1	VNB	2.85917e-17
C709	B1#5	VNB	2.83512e-17
C710	B1#7	VNB	2.9006e-17
C711	a_27_74##8	A1#10	5.82799e-17
C712	A1#10	VNB	2.82827e-17
C713	A2#1	VNB	2.33964e-17
C714	A2#8	VNB	2.28748e-17
C715	A2#10	VNB	2.40881e-17
C716	A2#12	VNB	2.21385e-17
C717	VGND	VGND#1	7.17764e-17
C718	A1#6	VNB	2.61549e-17
C719	VPWR	B1#3	6.6017e-18
C720	A1#7	VNB	2.49146e-17
C721	A1#5	VNB	3.48495e-17
C722	VPWR	A1#11	5.26718e-18
C723	VGND	VGND#2	1.27435e-16
C724	B1#12	VNB	4.51612e-17
C725	a_27_74##2	a_27_74#	2.18779e-18
C726	B2#4	VNB	3.19762e-17
C727	VGND	B1#11	1.01189e-18
C728	VGND#2	B1#6	2.75421e-20
C729	B2#8	VNB	3.1641e-17
C730	B2#11	VNB	3.38457e-17
C731	VGND	B2#3	4.58821e-18
C732	VPWR	A1#3	8.71392e-18
C733	B2#12	VNB	3.11635e-17
C734	B1#4	VNB	2.92598e-17
C735	VGND	B1#3	6.68235e-18
C736	A2	A1	1.11242e-16
C737	B1#8	VNB	3.1012e-17
C738	B1#9	VNB	3.43815e-17
C739	VGND	A1#11	3.87923e-18
C740	A1#12	VNB	3.21051e-17
C741	A2#7	VNB	3.49961e-17
C742	VGND	A2#4	6.28737e-19
C743	A2#9	VNB	3.2443e-17
C744	a_877_368##3	VPWR#3	4.22989e-17
C745	Y#4	a_117_368##2	3.36432e-17
C746	A2#11	VNB	3.64805e-17
C747	VGND	A1#3	8.24661e-18
C748	VGND#2	B1#2	1.63704e-20
C749	A2#6	VNB	3.60553e-17
C750	A1#1	VNB	3.11954e-17
C751	A1#8	VNB	2.85277e-17
C752	A1#9	VNB	4.05926e-17
C753	A1#10	VGND#7	2.22984e-17
C754	VPWR	B2	3.32407e-18
C755	VPWR#2	VNB	1.64241e-16
C756	VGND#1	VNB	2.08317e-16
C757	VPWR	A1	8.09121e-18
C758	Y#3	B2#12	3.55015e-17
C759	VPWR#5	VNB	4.1083e-17
C760	VGND#2	VNB	7.14591e-17
C761	Y	B1	6.02736e-18
C762	B1#11	VNB	4.71648e-17
C763	VPWR	A2	7.44738e-18
C764	B2#3	VNB	1.80707e-18
C765	B1#3	VNB	3.117e-17
C766	VGND	A1	6.51119e-18
C767	VPWR	B1	2.43729e-18
C768	A1#11	VNB	3.50162e-17
C769	A2#4	VNB	5.8759e-17
C770	VGND	A2	8.25245e-18
C771	VPWR#3	B1#8	5.84197e-18
C772	A1#3	VNB	5.60626e-17
C773	VGND	B1	9.1149e-18
C774	VGND	Y	9.96494e-18
C775	B2	VNB	3.41052e-18
C776	A1	VNB	3.10253e-18
C777	a_27_74##8	A2#1	2.37989e-18
C778	A2	VNB	1.0964e-17
C779	Y#2	a_877_368#	9.638e-17
C780	B1	VNB	5.42965e-18
C781	VPWR	VNB	3.00173e-16
C782	VGND	VNB	3.00119e-16
C783	B2#2	B1#12	2.81781e-18
C784	VGND#5	VNB	4.88757e-17
C785	VGND#5	A1#3	6.15311e-20
C786	VGND	VGND#5	1.01171e-16
C787	VGND#5	A1#5	5.27975e-18
C788	VGND#5	a_27_74##12	7.2826e-18
C789	VGND#5	A1#6	8.20355e-19
C790	VGND#5	VGND#4	1.44687e-18
C791	VGND#5	VGND#9	6.17332e-20
C792	VGND#5	A1#7	4.75132e-18
C793	VGND#5	A2#12	1.39606e-19
C794	VGND#5	a_27_74##13	2.10276e-17
*
*
.ENDS sky130_fd_sc_hs__o22ai_4
*
