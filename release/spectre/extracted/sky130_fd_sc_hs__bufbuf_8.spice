* Extracted by Quantus, converted by sky130cad/quantus.py
*
*
*
*                       LINUX           Wed Nov 18 08:20:56 2026
*
*
*
*  PROGRAM  advgen
*
*  Name           : advgen - Quantus - (64-bit)
*  Version        : 25.1.0-p047
*  Build Date     : Thu Dec 11 23:20:30 PST 2025
*
*  HSPICE LIBRARY
*
*  OPERATING_TEMPERATURE 150
*  QRC_TECH_DIR <path>/tech
*
*
*

*
.SUBCKT sky130_fd_sc_hs__bufbuf_8 VPB VNB VGND VPWR X A
*
*
*  caps2d version: 10
*
*
*       TRANSISTOR CARDS
*
*
XM19 a_27_112##6 A#3 VGND#15 VNB sky130_fd_pr__nfet_01v8_lvt l=0.15 w=0.55 ad=0.15675 as=0.30395 pd=1.67 ps=2.34
XM20 VGND#15 a_27_112# a_221_368##13 VNB sky130_fd_pr__nfet_01v8_lvt l=0.15 w=0.74 ad=0.30395 as=0.2109 pd=2.34 ps=2.05
XM11 a_334_368##33 a_221_368##8 VGND#14 VNB sky130_fd_pr__nfet_01v8_lvt l=0.15 w=0.74 ad=0.2109 as=0.2072 pd=2.05 ps=2.04
XM6 VGND#14 a_221_368##6 a_334_368##29 VNB sky130_fd_pr__nfet_01v8_lvt l=0.15 w=0.74 ad=0.2072 as=0.2072 pd=2.04 ps=2.04
XM22 a_334_368##29 a_221_368##5 VGND#13 VNB sky130_fd_pr__nfet_01v8_lvt l=0.15 w=0.74 ad=0.2072 as=0.259 pd=2.04 ps=2.18
XM8 VGND#13 a_334_368##12 X#7 VNB sky130_fd_pr__nfet_01v8_lvt l=0.15 w=0.74 ad=0.259 as=0.2072 pd=2.18 ps=2.04
XM7 VGND#9 a_334_368##25 X#7 VNB sky130_fd_pr__nfet_01v8_lvt l=0.15 w=0.74 ad=0.259 as=0.2072 pd=2.18 ps=2.04
XM12 X#5 a_334_368##22 VGND#9 VNB sky130_fd_pr__nfet_01v8_lvt l=0.15 w=0.74 ad=0.2072 as=0.259 pd=2.04 ps=2.18
XM2 X#5 a_334_368##20 VGND#8 VNB sky130_fd_pr__nfet_01v8_lvt l=0.15 w=0.74 ad=0.2072 as=0.2072 pd=2.04 ps=2.04
XM13 X#3 a_334_368##19 VGND#8 VNB sky130_fd_pr__nfet_01v8_lvt l=0.15 w=0.74 ad=0.2516 as=0.2072 pd=2.16 ps=2.04
XM21 VGND#7 a_334_368##16 X#3 VNB sky130_fd_pr__nfet_01v8_lvt l=0.15 w=0.74 ad=0.259 as=0.2516 pd=2.18 ps=2.16
XM10 VGND#7 a_334_368##14 X#12 VNB sky130_fd_pr__nfet_01v8_lvt l=0.15 w=0.74 ad=0.259 as=0.2072 pd=2.18 ps=2.04
XM3 X#12 a_334_368##13 VGND#1 VNB sky130_fd_pr__nfet_01v8_lvt l=0.15 w=0.74 ad=0.2072 as=0.25955 pd=2.04 ps=2.19
XM0 a_27_112##4 A#1 VPWR#14 VPB sky130_fd_pr__pfet_01v8 l=0.15 w=0.84 ad=0.2478 as=0.3892 pd=2.27 ps=2.99
XM23 VPWR#14 a_27_112##3 a_221_368##12 VPB sky130_fd_pr__pfet_01v8 l=0.15 w=1.12 ad=0.3892 as=0.3304 pd=2.99 ps=2.83
XM4 a_334_368##32 a_221_368##9 VPWR#12 VPB sky130_fd_pr__pfet_01v8 l=0.15 w=1.12 ad=0.3304 as=0.336 pd=2.83 ps=2.84
XM16 VPWR#12 a_221_368##7 a_334_368##34 VPB sky130_fd_pr__pfet_01v8 l=0.15 w=1.12 ad=0.336 as=0.336 pd=2.84 ps=2.84
XM24 a_334_368##34 a_221_368# VPWR#10 VPB sky130_fd_pr__pfet_01v8 l=0.15 w=1.12 ad=0.336 as=0.392 pd=2.84 ps=2.94
XM5 X#11 a_334_368##26 VPWR#10 VPB sky130_fd_pr__pfet_01v8 l=0.15 w=1.12 ad=0.392 as=0.392 pd=2.94 ps=2.94
XM17 VPWR#9 a_334_368##24 X#11 VPB sky130_fd_pr__pfet_01v8 l=0.15 w=1.12 ad=0.336 as=0.392 pd=2.84 ps=2.94
XM15 X#15 a_334_368##23 VPWR#9 VPB sky130_fd_pr__pfet_01v8 l=0.15 w=1.12 ad=0.336 as=0.336 pd=2.84 ps=2.84
XM9 VPWR#8 a_334_368##21 X#15 VPB sky130_fd_pr__pfet_01v8 l=0.15 w=1.12 ad=0.3416 as=0.336 pd=2.85 ps=2.84
XM25 X#14 a_334_368##18 VPWR#8 VPB sky130_fd_pr__pfet_01v8 l=0.15 w=1.12 ad=0.336 as=0.3416 pd=2.84 ps=2.85
XM14 VPWR#7 a_334_368##17 X#14 VPB sky130_fd_pr__pfet_01v8 l=0.15 w=1.12 ad=0.336 as=0.336 pd=2.84 ps=2.84
XM18 X#13 a_334_368##15 VPWR#7 VPB sky130_fd_pr__pfet_01v8 l=0.15 w=1.12 ad=0.336 as=0.336 pd=2.84 ps=2.84
XM1 VPWR#1 a_334_368# X#13 VPB sky130_fd_pr__pfet_01v8 l=0.15 w=1.12 ad=0.3136 as=0.336 pd=2.8 ps=2.84
*
*
*       RESISTOR AND CAP/DIODE CARDS
*
Rg1	A#1	A#2	359.776581
Rg2	A#2	A#3	328.022858
Rg3	a_27_112#	a_27_112##2	352.702850
Rg4	a_27_112##2	a_27_112##3	455.703033
Rg5	a_221_368#	a_221_368##2	471.862823
Rg6	a_221_368##2	a_221_368##3	63.189835
Rg7	a_221_368##3	a_221_368##4	80.177322
Rg8	a_221_368##2	a_221_368##5	368.862610
Rg9	a_221_368##3	a_221_368##6	394.814545
Rg10	a_221_368##3	a_221_368##7	437.854187
Rg11	a_221_368##4	a_221_368##8	336.569885
Rg12	a_221_368##4	a_221_368##9	439.074646
Rg13	a_334_368#	a_334_368##2	471.862823
Rg14	a_334_368##2	a_334_368##3	62.936840
Rg15	a_334_368##3	a_334_368##4	78.247475
Rg16	a_334_368##4	a_334_368##5	68.019966
Rg17	a_334_368##5	a_334_368##6	8.507745
Rg18	a_334_368##6	a_334_368##7	97.063522
Rg19	a_334_368##7	a_334_368##8	52.265877
Rg20	a_334_368##8	a_334_368##9	68.555359
Rg21	a_334_368##9	a_334_368##10	26.818237
Rg22	a_334_368##10	a_334_368##11	54.878704
Rg23	a_334_368##11	a_334_368##12	368.862610
Rg24	a_334_368##2	a_334_368##13	368.862610
Rg25	a_334_368##3	a_334_368##14	396.127869
Rg26	a_334_368##3	a_334_368##15	439.167511
Rg27	a_334_368##4	a_334_368##16	410.806061
Rg28	a_334_368##4	a_334_368##17	453.845703
Rg29	a_334_368##5	a_334_368##18	426.918213
Rg30	a_334_368##6	a_334_368##19	402.169800
Rg31	a_334_368##7	a_334_368##20	344.184753
Rg32	a_334_368##7	a_334_368##21	447.184967
Rg33	a_334_368##8	a_334_368##22	407.645752
Rg34	a_334_368##8	a_334_368##23	450.685394
Rg35	a_334_368##9	a_334_368##24	420.629852
Rg36	a_334_368##10	a_334_368##25	397.487915
Rg37	a_334_368##11	a_334_368##26	471.862823
Rf1	A#4	A	2.217604
Rf2	A#2	A#6	162.450409
Rf3	A#4	A#6	5.042445
Rf4	a_27_112##4	a_27_112##5	75.540657
Rf5	a_27_112##5	a_27_112##6	74.986862
Rf6	a_221_368##4	a_221_368##11	75.082619
Rf7	a_221_368##11	a_221_368##12	54.404995
Rf8	a_221_368##11	a_221_368##13	49.643265
Rf9	a_334_368##7	a_334_368##28	83.951546
Rf10	a_334_368##28	a_334_368##30	15.478905
Rf11	a_334_368##28	a_334_368##31	24.504393
Rf12	a_334_368##31	a_334_368##32	75.132996
Rf13	a_334_368##30	a_334_368##33	61.957100
Rf14	a_334_368##31	a_334_368##34	24.912262
Rf15	a_334_368##29	a_334_368##30	15.000000
Rf16	X	X#1	9.733389
Rf17	X#1	X#2	20.251089
Rf18	X#2	X#4	43.072212
Rf19	X#4	X#6	45.534809
Rf20	X#6	X#7	60.048397
Rf21	X#1	X#8	14.673690
Rf22	X#8	X#9	57.204506
Rf23	X#9	X#10	65.795128
Rf24	X#10	X#11	91.830788
Rf25	X#2	X#12	17.838894
Rf26	X#8	X#13	29.389174
Rf27	X#9	X#14	25.492163
Rf28	X#10	X#15	27.027287
Rf29	X#3	X#4	15.000000
Rf30	X#5	X#6	15.000000
Rf31	VGND#1	VGND#2	36.181667
Rf32	VGND#2	VGND#3	77.445518
Rf33	VGND#3	VGND#4	67.157394
Rf34	VGND#4	VGND#5	62.774361
Rf35	VGND#5	VGND#6	56.954853
Rf36	VGND#3	VGND#7	33.129639
Rf37	VGND#4	VGND#8	33.129639
Rf38	VGND#5	VGND#9	33.129639
Rf39	VGND#6	VGND#10	81.682449
Rf40	VGND#10	VGND#11	108.796173
Rf42	VGND#6	VGND#13	36.627541
Rf43	VGND#10	VGND#14	33.129639
Rf44	VGND#11	VGND#15	38.247387
Rf45	VPWR#1	VPWR#2	40.587585
Rf46	VPWR#2	VPWR#3	73.980492
Rf47	VPWR#3	VPWR#4	65.957947
Rf48	VPWR#4	VPWR#5	66.152466
Rf49	VPWR#5	VPWR#6	58.651779
Rf50	VPWR#3	VPWR#7	41.081436
Rf51	VPWR#4	VPWR#8	39.570740
Rf52	VPWR#5	VPWR#9	41.929005
Rf53	VPWR#6	VPWR#10	41.783939
Rf54	VPWR#6	VPWR#11	82.304222
Rf55	VPWR#11	VPWR#12	44.860863
Rf56	VPWR#11	VPWR#13	111.230728
Rf57	VPWR#13	VPWR#14	41.091591
Rf60	a_27_112##2	a_27_112##5	160.232803
Re1	VPWR#2	VPWR	11.068454
Re2	VPWR	VPWR#6	0.790604
Re3	VGND#2	VGND	11.068454
Re4	VGND	VGND#6	0.790604
*
*       CAPACITOR CARDS
*
*
C1	a_27_112##6	a_221_368##13	2.63603e-18
C2	X#2	a_334_368##14	3.73529e-17
C3	X#2	X#8	3.36411e-18
C4	a_334_368##31	a_334_368##11	7.14213e-20
C5	X#1	a_334_368##14	1.13038e-19
C6	a_27_112##6	VGND#15	3.22375e-17
C7	VGND#5	a_334_368##25	2.71842e-18
C8	X#2	a_334_368##16	1.52272e-18
C9	X#1	a_334_368##8	4.34297e-19
C10	a_221_368##3	a_334_368##29	1.54941e-18
C11	a_334_368##31	a_334_368##10	4.49389e-19
C12	X#1	a_334_368##16	3.44353e-20
C13	X#2	a_334_368##19	5.17344e-19
C14	a_334_368##29	a_221_368##2	4.76261e-19
C15	X#2	a_334_368##4	8.25042e-19
C16	X#1	a_334_368##6	9.87154e-19
C17	a_334_368##3	a_334_368##2	3.58177e-18
C18	X#1	a_334_368##19	1.89677e-20
C19	X#2	a_334_368##20	2.77136e-19
C20	X#2	a_334_368##3	3.14026e-18
C21	a_334_368##31	a_334_368##8	2.34726e-19
C22	VGND#14	a_221_368##3	5.14222e-19
C23	X#1	a_334_368##20	1.01608e-20
C24	X#13	VPWR#1	7.01285e-17
C25	VGND#10	a_221_368##6	3.7242e-18
C26	X#2	a_334_368##22	1.92135e-19
C27	VPWR#7	VPWR#1	2.49756e-18
C28	X#1	a_334_368##4	1.79674e-18
C29	X#1	a_334_368##22	7.04436e-21
C30	a_334_368##28	a_334_368##11	6.09428e-19
C31	VGND#10	a_221_368##8	1.23779e-18
C32	VPWR#7	X#13	6.78451e-17
C33	X#1	a_334_368##3	1.46026e-17
C34	a_334_368##13	VGND#1	2.32704e-17
C35	X#14	X#13	5.69205e-19
C36	a_334_368##28	a_334_368##10	2.60418e-19
C37	a_334_368##13	X#12	1.5442e-17
C38	X#1	a_334_368##2	3.58243e-17
C39	VGND#1	a_334_368##14	1.37281e-18
C40	X#14	VPWR#7	6.78451e-17
C41	VGND#7	a_334_368##13	1.465e-18
C42	a_334_368##14	X#12	1.4935e-17
C43	VPWR#8	VPWR#7	2.47101e-18
C44	VGND#1	a_334_368##16	2.86953e-19
C45	a_334_368##14	VGND#7	2.02417e-17
C46	a_334_368##28	a_334_368##8	1.40851e-19
C47	VPWR#8	X#14	6.79164e-17
C48	VPWR#2	a_334_368##2	4.5102e-20
C49	VGND#7	a_334_368##16	3.57916e-17
C50	VPWR#3	a_334_368#	6.00345e-19
C51	X#15	X#14	3.71354e-19
C52	a_334_368##28	a_334_368##6	6.29905e-20
C53	X#3	a_334_368##16	4.52776e-17
C54	X#15	VPWR#8	6.60055e-17
C55	VGND#7	a_334_368##19	3.105e-18
C56	VGND#3	VGND#1	1.95889e-19
C57	VGND#8	a_334_368##16	3.105e-18
C58	a_334_368##31	a_221_368##3	1.47464e-18
C59	VPWR#3	a_334_368##15	4.20618e-18
C60	X#3	a_334_368##19	4.4316e-17
C61	VPWR#9	VPWR#8	1.52749e-18
C62	VGND#2	a_334_368##2	4.68553e-20
C63	a_221_368##11	a_221_368##5	7.0802e-21
C64	VGND#8	a_334_368##19	3.29776e-17
C65	VPWR#6	a_334_368##11	3.96166e-20
C66	VPWR#9	X#15	5.99892e-17
C67	a_334_368##31	a_221_368##2	2.6628e-19
C68	VPWR#6	a_334_368##10	6.29242e-20
C69	a_221_368##3	a_221_368##2	3.51168e-18
C70	VPWR#3	a_334_368##17	3.11006e-18
C71	a_221_368##11	a_221_368##6	1.17159e-20
C72	X#7	a_334_368##16	1.94284e-19
C73	VGND#8	a_334_368##20	3.14553e-17
C74	X#11	X#15	3.58411e-19
C75	a_221_368##11	a_334_368##31	3.37899e-19
C76	X#5	a_334_368##20	4.13417e-17
C77	VPWR#4	a_334_368##18	1.26772e-18
C78	X#7	a_334_368##19	2.80112e-19
C79	X#11	VPWR#9	6.17269e-17
C80	VGND#4	X#3	2.19751e-18
C81	a_221_368##11	a_221_368##8	1.32961e-19
C82	X#9	a_334_368#	2.23827e-19
C83	VGND#8	a_334_368##22	3.28964e-18
C84	VPWR#3	a_334_368##18	3.40047e-19
C85	VGND#9	a_334_368##20	3.28964e-18
C86	VPWR#5	a_334_368##10	1.35043e-20
C87	X#8	a_334_368#	7.68583e-18
C88	VPWR#6	a_221_368##2	4.5102e-20
C89	X#5	a_334_368##22	4.20398e-17
C90	a_27_112##6	a_27_112##4	1.76323e-18
C91	VPWR#10	VPWR#9	1.53641e-18
C92	X#7	a_334_368##20	4.63571e-19
C93	VGND#6	a_334_368##11	5.60018e-20
C94	VGND#3	X#3	2.18504e-18
C95	VGND#6	a_334_368##10	3.77275e-20
C96	a_334_368##29	a_334_368##19	1.57476e-20
C97	a_221_368##11	a_27_112#	4.96944e-18
C98	VPWR#4	a_334_368##21	1.4259e-18
C99	VGND#9	a_334_368##22	3.71281e-17
C100	X#9	a_334_368##15	3.67563e-19
C101	VPWR#10	X#11	9.38586e-17
C102	VPWR#3	a_334_368##21	8.74698e-20
C103	VGND#5	X#5	1.82327e-18
C104	a_221_368##11	a_334_368##28	5.4509e-19
C105	X#8	a_334_368##15	1.55503e-17
C106	X#7	a_334_368##22	1.51505e-18
C107	a_334_368##29	a_334_368##20	1.35342e-20
C108	a_334_368##28	a_221_368##3	8.77418e-18
C109	X#10	a_334_368##17	1.57489e-19
C110	VPWR#5	a_334_368##23	1.98731e-18
C111	a_334_368##25	VGND#9	2.02417e-17
C112	a_221_368##11	A#3	5.06543e-19
C113	X#1	a_334_368#	1.37742e-17
C114	VGND#13	a_334_368##22	2.86953e-19
C115	VGND#4	X#5	1.8108e-18
C116	X#9	a_334_368##17	1.44933e-17
C117	X#7	a_334_368##25	5.77207e-17
C118	a_334_368##34	VPWR#10	7.54918e-17
C119	a_334_368##29	a_334_368##22	2.19455e-20
C120	X#8	a_334_368##17	3.67563e-19
C121	VGND#6	a_221_368##2	1.37337e-19
C122	a_334_368##3	X#13	1.03257e-19
C123	VGND#9	a_334_368##12	7.6211e-19
C124	a_334_368##28	a_221_368##2	2.41619e-17
C125	VGND#13	a_334_368##25	7.6211e-19
C126	a_334_368##7	a_334_368##11	1.72803e-17
C127	X#10	a_334_368##18	3.83656e-19
C128	VPWR#5	a_334_368##24	3.08286e-18
C129	VPWR#12	VPWR#10	1.38242e-18
C130	a_334_368##7	a_334_368##10	1.89188e-17
C131	X#7	a_334_368##12	4.02473e-17
C132	X#9	a_334_368##18	1.46422e-17
C133	a_334_368##29	a_334_368##25	3.94814e-20
C134	a_334_368##2	X#13	1.24686e-19
C135	a_334_368##7	a_334_368##8	1.78239e-17
C136	VGND#9	a_221_368##5	2.86953e-19
C137	VGND#5	X#7	3.99508e-18
C138	a_334_368##7	a_334_368##6	2.14289e-17
C139	X#8	a_334_368##18	1.50741e-19
C140	a_334_368##12	VGND#13	1.56876e-17
C141	VPWR#12	a_334_368##34	7.18229e-17
C142	X#2	VGND#1	7.03955e-17
C143	a_334_368##7	a_334_368##4	1.68225e-17
C144	VPWR#11	a_334_368##26	6.4634e-20
C145	X#7	a_221_368##5	3.34449e-18
C146	X#10	a_334_368##21	1.7655e-17
C147	VPWR#7	a_334_368##4	3.3506e-19
C148	a_334_368##29	a_334_368##12	3.63342e-18
C149	a_334_368##7	a_334_368##3	7.35861e-18
C150	a_334_368##32	a_334_368##34	1.40629e-18
C151	X#9	a_334_368##21	3.66889e-19
C152	VGND#13	a_221_368##5	3.55917e-17
C153	VGND#1	X#1	3.87702e-18
C154	X#2	X#12	4.68449e-19
C155	VPWR#7	a_334_368##3	4.67154e-19
C156	X#7	a_221_368##6	2.19979e-19
C157	a_334_368##29	a_221_368##5	3.61439e-17
C158	a_334_368##32	VPWR#12	7.15174e-17
C159	a_334_368##33	a_334_368##12	1.24762e-19
C160	VGND#10	a_334_368##29	1.85995e-18
C161	X#10	a_334_368##23	1.56907e-17
C162	VPWR#11	a_221_368#	4.8573e-19
C163	VGND#13	a_221_368##6	3.28964e-18
C164	VGND#14	a_221_368##5	3.28964e-18
C165	X#9	a_334_368##23	1.50247e-19
C166	X#7	a_221_368##8	2.7834e-19
C167	a_334_368##29	a_221_368##6	4.03048e-17
C168	X#2	VGND#7	5.29052e-17
C169	a_334_368##33	a_221_368##5	2.05922e-19
C170	a_221_368##11	a_221_368##3	1.3375e-19
C171	VPWR#4	a_334_368##6	4.57114e-20
C172	X#1	a_334_368##21	3.91836e-19
C173	a_221_368##12	a_334_368##32	9.43544e-17
C174	VGND#14	a_221_368##6	3.28653e-17
C175	X#10	a_334_368##24	7.33841e-18
C176	a_334_368##31	a_334_368##21	1.66583e-19
C177	VPWR#11	a_221_368##7	4.21547e-18
C178	a_334_368##29	a_221_368##8	5.79672e-20
C179	VPWR#5	VPWR#4	1.23473e-18
C180	a_334_368##33	a_221_368##6	4.16392e-19
C181	a_221_368##4	a_221_368##3	1.66708e-17
C182	VGND#14	a_221_368##8	2.95385e-17
C183	a_221_368##11	a_221_368##2	6.35146e-20
C184	VPWR#8	a_334_368##6	3.32681e-19
C185	VPWR#14	a_221_368##12	5.78282e-17
C186	a_334_368##29	a_27_112#	2.15142e-20
C187	X#10	a_334_368##26	1.6e-19
C188	a_334_368##33	a_221_368##8	2.50613e-17
C189	VGND#10	a_334_368##33	1.79566e-17
C190	VPWR#11	a_221_368##9	7.41219e-18
C191	VGND#14	a_27_112#	7.56619e-19
C192	a_221_368##13	a_221_368##8	1.32468e-18
C193	a_27_112##4	a_221_368##12	2.43101e-18
C194	VPWR#11	a_221_368##3	4.11403e-20
C195	a_334_368##33	a_27_112#	1.30124e-18
C196	VGND#15	a_221_368##8	3.34404e-19
C197	a_334_368##11	a_334_368##10	3.98083e-18
C198	a_27_112##4	VPWR#14	4.75566e-17
C199	a_334_368##31	a_334_368##24	3.1924e-20
C200	a_221_368##13	a_27_112#	4.80452e-17
C201	VPWR#11	a_27_112##3	1.66111e-19
C202	VPWR#4	VPWR#3	1.26931e-18
C203	a_27_112#	VGND#15	1.9852e-17
C204	VPWR#11	a_221_368##2	3.96166e-21
C205	a_221_368##13	A#3	1.94935e-18
C206	VPWR#9	a_334_368##10	3.93669e-19
C207	a_27_112##6	a_27_112#	8.91185e-19
C208	a_334_368##31	a_334_368##26	1.17189e-18
C209	A#3	VGND#15	2.34596e-17
C210	VPWR#3	VPWR#1	1.20578e-19
C211	a_27_112##6	A#3	4.15403e-17
C212	a_334_368##31	a_221_368#	9.71461e-18
C213	VPWR#3	a_334_368##4	4.25241e-20
C214	VPWR#9	a_334_368##8	3.8842e-19
C215	a_334_368##14	a_334_368##13	3.83602e-17
C216	X#11	a_334_368##11	1.25977e-18
C217	X#13	VPWR#3	7.76117e-18
C218	a_334_368##31	a_221_368##7	1.87857e-17
C219	X#11	a_334_368##10	3.92177e-18
C220	a_221_368##11	a_221_368#	1.69903e-20
C221	a_334_368##16	a_334_368##14	2.89243e-17
C222	VPWR#3	a_334_368##3	4.11403e-20
C223	a_334_368#	VPWR#1	3.11395e-17
C224	a_334_368#	X#13	2.19351e-17
C225	a_334_368##31	a_221_368##9	4.02778e-19
C226	VPWR#1	a_334_368##15	2.91141e-18
C227	VPWR#7	a_334_368#	2.06715e-18
C228	a_334_368##19	a_334_368##16	2.82003e-17
C229	X#14	VPWR#4	7.73383e-18
C230	VPWR#3	a_334_368##2	3.96166e-21
C231	a_334_368##15	X#13	2.83064e-17
C232	X#14	a_334_368#	6.41541e-20
C233	VPWR#3	VPWR#2	1.28701e-18
C234	VPWR#5	VPWR#8	6.29163e-20
C235	VPWR#1	a_334_368##17	2.82762e-19
C236	a_334_368##15	VPWR#7	2.72921e-17
C237	X#14	VPWR#3	7.68433e-18
C238	a_334_368##31	a_27_112##3	5.01238e-20
C239	a_221_368##11	a_221_368##9	4.03997e-19
C240	a_334_368##20	a_334_368##19	3.91471e-17
C241	X#13	a_334_368##17	1.34525e-18
C242	X#14	a_334_368##15	1.34525e-18
C243	a_334_368##3	a_334_368#	1.1445e-18
C244	a_334_368##17	VPWR#7	3.17405e-17
C245	VPWR#8	a_334_368##15	2.83292e-19
C246	X#13	a_334_368##18	4.32061e-20
C247	X#15	VPWR#5	6.7439e-18
C248	a_334_368##17	X#14	2.29526e-17
C249	a_221_368##11	a_27_112##3	4.46057e-18
C250	VPWR#8	VPWR#3	1.24994e-19
C251	a_334_368##29	a_334_368##31	2.46703e-18
C252	a_334_368##22	a_334_368##20	4.05664e-17
C253	a_334_368##10	a_334_368##8	5.77378e-18
C254	VPWR#7	a_334_368##18	1.69377e-18
C255	VPWR#8	a_334_368##17	2.04503e-18
C256	VPWR#11	VPWR#6	9.34325e-19
C257	X#15	VPWR#4	7.68433e-18
C258	a_334_368##18	X#14	2.8298e-17
C259	VPWR#6	VPWR#5	9.7368e-19
C260	X#15	a_334_368##17	2.77921e-20
C261	VGND#13	a_334_368##28	1.56666e-18
C262	a_221_368##11	A#1	2.65388e-19
C263	VPWR#7	a_334_368##21	1.93862e-19
C264	a_334_368##18	VPWR#8	2.94625e-17
C265	VGND#3	VGND#2	9.71908e-19
C266	a_334_368##25	a_334_368##22	2.89243e-17
C267	X#14	a_334_368##21	1.32503e-18
C268	X#15	a_334_368##18	1.26268e-18
C269	a_334_368##21	VPWR#8	3.40868e-17
C270	VPWR#9	a_334_368##18	2.74844e-19
C271	VGND#7	VGND#1	1.6143e-18
C272	X#1	VPWR#2	5.1065e-19
C273	a_334_368##21	X#15	2.23772e-17
C274	X#14	a_334_368##23	4.11505e-20
C275	a_334_368##12	a_334_368##25	3.7384e-17
C276	VPWR#8	a_334_368##23	2.07633e-18
C277	VPWR#9	a_334_368##21	2.04739e-18
C278	X#11	VPWR#5	4.6181e-18
C279	X#8	VPWR#1	1.54585e-17
C280	VGND#2	X#2	8.45824e-18
C281	a_334_368##23	X#15	2.78456e-17
C282	X#11	a_334_368##21	1.89821e-19
C283	VGND#10	VGND#6	1.67796e-18
C284	VGND#2	X#1	6.40924e-19
C285	X#10	VPWR#5	2.72948e-19
C286	VPWR#11	VPWR#10	3.44136e-19
C287	VGND#6	VGND#5	1.17855e-18
C288	a_334_368##23	VPWR#9	2.89256e-17
C289	VPWR#8	a_334_368##24	2.86525e-19
C290	VPWR#5	a_334_368##7	7.00909e-20
C291	a_221_368##5	a_334_368##12	2.96282e-17
C292	a_221_368##11	a_334_368##29	2.37118e-19
C293	VPWR#4	a_334_368##7	6.03391e-20
C294	X#11	a_334_368##23	1.70735e-18
C295	X#15	a_334_368##24	1.32177e-18
C296	VPWR#10	VPWR#5	2.91337e-19
C297	X#8	X#13	7.80699e-18
C298	a_334_368##24	VPWR#9	3.35941e-17
C299	VPWR#10	a_334_368##23	2.82879e-19
C300	X#11	a_334_368##24	6.36944e-17
C301	X#10	VPWR#4	1.93833e-19
C302	X#15	a_334_368##26	2.7907e-20
C303	a_221_368##6	a_221_368##5	4.07355e-17
C304	X#9	VPWR#7	1.25869e-17
C305	a_221_368##4	VPWR#11	1.04911e-18
C306	VGND#5	a_334_368##7	1.46029e-19
C307	a_334_368##34	VPWR#11	8.52191e-18
C308	a_334_368##3	X#12	1.65515e-19
C309	VPWR#10	a_334_368##24	2.54802e-18
C310	VPWR#9	a_334_368##26	1.87602e-18
C311	VGND#4	a_334_368##7	1.37337e-19
C312	VGND#4	a_334_368##6	1.91229e-19
C313	X#3	VGND#7	1.84592e-17
C314	X#10	X#14	1.6092e-19
C315	a_334_368##28	VPWR#6	8.42624e-20
C316	X#11	a_334_368##26	1.91725e-17
C317	X#8	VPWR#7	1.49564e-17
C318	a_334_368##7	X#10	9.6594e-17
C319	a_221_368##8	a_221_368##6	3.91207e-17
C320	VPWR#10	a_334_368##26	6.7156e-17
C321	a_334_368##7	X#9	7.67619e-17
C322	X#9	X#14	3.23475e-18
C323	VGND#10	a_221_368##4	1.21984e-18
C324	VGND#2	VGND#1	2.17395e-17
C325	a_334_368##2	X#12	1.97476e-19
C326	X#9	VPWR#4	1.74054e-19
C327	a_334_368##7	X#8	7.04842e-18
C328	a_221_368##11	a_334_368##33	5.49918e-18
C329	a_334_368##34	a_334_368##26	1.23087e-18
C330	VGND#8	VGND#7	1.23697e-17
C331	X#1	VPWR#1	5.98675e-18
C332	X#10	VPWR#8	1.38699e-17
C333	VGND#7	a_334_368##4	5.12502e-19
C334	VPWR#12	a_334_368##26	1.98124e-19
C335	VPWR#10	a_221_368#	2.20872e-17
C336	X#2	a_334_368##7	1.1744e-17
C337	a_27_112#	a_221_368##8	5.06243e-18
C338	a_334_368##34	a_221_368#	5.63563e-17
C339	VGND#10	a_221_368##3	1.34729e-19
C340	a_334_368##7	X#1	2.98699e-17
C341	X#3	a_334_368##6	2.78356e-18
C342	VGND#5	VGND#4	1.67796e-18
C343	a_334_368##31	a_334_368##7	1.42786e-20
C344	X#3	VGND#8	1.91845e-17
C345	VPWR#12	a_221_368#	8.448e-19
C346	a_221_368##11	a_221_368##13	6.84716e-20
C347	VPWR#10	a_221_368##7	7.6432e-19
C348	X#9	VPWR#8	1.42175e-17
C349	a_221_368##3	a_334_368##34	5.73649e-20
C350	X#9	VPWR#3	1.74054e-19
C351	VGND#7	a_334_368##3	6.97872e-19
C352	a_334_368##28	a_334_368##7	9.5386e-20
C353	a_334_368##34	a_221_368##7	4.76591e-17
C354	VGND#3	a_334_368##6	1.02568e-19
C355	a_334_368##8	a_334_368##21	1.71475e-18
C356	A#3	a_27_112#	1.92905e-17
C357	X#10	X#15	3.39128e-18
C358	a_334_368##32	VPWR#11	2.09682e-17
C359	a_221_368##7	VPWR#12	2.61931e-17
C360	VPWR#10	a_221_368##9	2.83685e-19
C361	a_334_368##21	a_334_368##6	1.68472e-18
C362	a_221_368##2	a_334_368##34	1.24686e-19
C363	VGND#10	a_221_368##2	2.60766e-21
C364	a_334_368##32	a_221_368##7	1.82696e-18
C365	a_334_368##34	a_221_368##9	1.55338e-18
C366	a_221_368##4	a_334_368##31	2.93701e-17
C367	a_221_368##9	VPWR#12	3.12349e-17
C368	a_221_368##4	a_334_368##28	3.88872e-17
C369	X#8	VPWR#3	3.24374e-19
C370	X#10	a_334_368##10	1.82464e-18
C371	VPWR#2	VPWR#1	1.89419e-17
C372	a_334_368##32	a_221_368##9	9.15059e-17
C373	X#3	a_334_368##4	1.74372e-18
C374	X#5	a_334_368##10	3.03952e-19
C375	X#10	VPWR#9	2.42811e-17
C376	a_221_368##11	a_221_368##4	7.09539e-19
C377	X#13	VPWR#2	7.71149e-18
C378	X#5	VGND#8	2.19532e-17
C379	a_221_368##12	a_221_368##9	1.80077e-18
C380	VPWR#12	a_27_112##3	4.68413e-19
C381	VGND#8	a_334_368##6	1.72027e-20
C382	a_334_368##31	a_27_112##2	2.65361e-20
C383	a_334_368##7	VGND#7	2.94659e-18
C384	a_334_368##32	a_27_112##3	1.63582e-18
C385	VGND#6	X#7	1.31584e-17
C386	VGND#4	VGND#3	1.43491e-18
C387	VPWR#12	a_221_368##3	3.24723e-19
C388	a_334_368##7	X#3	7.84654e-17
C389	a_334_368##28	a_27_112##2	1.29425e-19
C390	a_221_368##12	a_27_112##3	6.79829e-17
C391	a_334_368##7	VGND#8	3.17922e-18
C392	VGND#6	a_334_368##29	1.89357e-18
C393	VGND#9	VGND#8	1.36989e-17
C394	a_334_368##7	X#5	7.95192e-17
C395	a_27_112##2	a_221_368##11	7.54095e-17
C396	a_27_112##3	VPWR#14	1.79354e-17
C397	VGND#3	a_334_368##4	8.51836e-20
C398	X#11	X#10	2.05489e-18
C399	a_334_368##7	VGND#9	3.61992e-18
C400	a_27_112##4	a_27_112##3	8.02675e-19
C401	a_334_368##15	a_334_368#	4.8e-17
C402	a_334_368##7	X#7	6.21807e-17
C403	a_221_368##12	A#1	2.4505e-18
C404	VGND#13	a_334_368##7	3.15236e-18
C405	VPWR#14	A#1	3.86049e-17
C406	X#5	a_334_368##8	8.63863e-19
C407	a_334_368##29	a_334_368##7	2.03013e-20
C408	X#5	VGND#9	1.98265e-17
C409	a_27_112##4	A#1	3.76229e-17
C410	a_221_368##11	A#2	2.29441e-19
C411	X#10	a_334_368##8	3.77794e-18
C412	a_334_368##17	a_334_368##15	4.77925e-17
C413	VGND#3	a_334_368##3	4.27382e-20
C414	VGND#9	a_334_368##10	8.05734e-19
C415	a_334_368##29	a_221_368##4	2.28116e-17
C416	a_221_368##4	VGND#14	3.00472e-18
C417	a_334_368##31	VPWR#11	1.38338e-19
C418	X#11	VPWR#6	1.09758e-17
C419	a_334_368##18	a_334_368##17	4.80376e-17
C420	a_221_368##4	a_334_368##33	6.2203e-17
C421	a_334_368##34	VPWR#6	8.47225e-18
C422	VPWR	a_334_368##2	2.15472e-23
C423	a_334_368##7	VPWR#7	1.96013e-18
C424	VPWR	a_221_368##2	2.15472e-23
C425	a_334_368##7	X#14	2.35532e-18
C426	a_334_368##29	a_27_112##2	2.96804e-20
C427	VGND#3	a_334_368##2	3.85518e-21
C428	X#7	VGND#9	5.12604e-17
C429	a_334_368##7	VPWR#8	2.90042e-18
C430	a_334_368##21	a_334_368##18	4.66707e-17
C431	X#7	a_334_368##11	1.78883e-18
C432	a_334_368##7	X#15	3.54088e-18
C433	VGND#2	a_334_368##13	2.89841e-18
C434	a_27_112##2	a_221_368##13	7.55925e-18
C435	a_334_368##7	VPWR#9	2.35532e-18
C436	VGND#9	a_334_368##8	2.32236e-19
C437	a_27_112##2	VGND#15	2.49128e-17
C438	a_334_368##7	X#11	4.36278e-17
C439	a_334_368##23	a_334_368##21	4.8101e-17
C440	a_334_368##7	VPWR#10	1.42483e-17
C441	VGND#13	VGND#9	1.61383e-18
C442	X#7	a_334_368##10	3.68472e-18
C443	a_334_368##26	a_334_368##10	1.45672e-18
C444	a_27_112##6	A#2	2.72559e-17
C445	a_334_368##24	a_334_368##23	4.78706e-17
C446	VGND	a_334_368##11	4.60239e-20
C447	VGND	a_334_368##10	7.14291e-20
C448	VGND	a_334_368##8	1.84096e-21
C449	VGND	a_334_368##6	6.44335e-20
C450	VGND#13	X#7	3.42106e-17
C451	VGND	a_334_368##4	4.93376e-20
C452	a_221_368##4	VPWR#12	2.78659e-18
C453	VGND	a_334_368##3	1.12365e-19
C454	VGND	a_221_368##3	1.14032e-18
C455	X#9	a_334_368##6	5.83954e-18
C456	a_221_368##4	a_334_368##32	5.07701e-17
C457	VGND	a_221_368##2	5.65461e-21
C458	a_334_368##26	a_334_368##24	3.80381e-17
C459	a_334_368##6	a_334_368##4	5.81583e-18
C460	a_334_368##31	X#11	1.36903e-18
C461	a_221_368##2	a_334_368##11	2.1472e-17
C462	a_334_368##29	X#7	1.84735e-17
C463	a_27_112##2	a_221_368##12	3.02612e-17
C464	a_221_368#	a_334_368##26	3.84441e-17
C465	VGND#6	a_334_368##12	4.69842e-18
C466	a_27_112##2	VPWR#14	2.30937e-17
C467	VPWR#2	a_334_368#	2.21589e-18
C468	a_27_112##2	a_27_112##4	1.55427e-18
C469	VGND#6	a_221_368##5	3.67948e-18
C470	a_221_368##7	a_221_368#	4.61139e-17
C471	a_334_368##31	VPWR#10	2.61759e-17
C472	a_334_368##29	VGND#13	2.22362e-17
C473	A#2	a_27_112##4	2.6166e-17
C474	a_334_368##11	VNB	2.86463e-17
C475	a_334_368##10	VNB	4.10706e-17
C476	a_334_368##8	VNB	2.36383e-17
C477	a_334_368##6	VNB	3.40868e-17
C478	a_221_368##9	a_221_368##7	4.70876e-17
C479	a_334_368##4	VNB	3.28919e-17
C480	X#10	X#9	1.94342e-18
C481	a_334_368##3	VNB	3.0987e-17
C482	a_334_368##2	VNB	3.41952e-17
C483	a_221_368##3	VNB	2.82683e-17
C484	a_221_368##2	VNB	2.46251e-17
C485	X#9	a_334_368##4	5.60115e-18
C486	VPWR	VPWR#11	7.32719e-17
C487	VGND#14	VGND#13	1.36989e-17
C488	a_334_368##33	X#7	9.74994e-19
C489	VPWR	VPWR#5	5.32781e-17
C490	VPWR	VPWR#4	5.50821e-17
C491	a_334_368##31	a_334_368##34	2.16821e-19
C492	VPWR	VPWR#3	7.20589e-17
C493	a_27_112##3	a_221_368##9	5.27859e-18
C494	a_334_368##28	VPWR#10	1.98456e-17
C495	a_334_368##29	a_334_368##11	1.51163e-19
C496	a_27_112##2	a_221_368##8	4.5212e-20
C497	VPWR	X#10	3.00289e-18
C498	a_27_112##2	a_27_112#	3.91664e-18
C499	VPWR	X#9	2.10398e-18
C500	VGND#1	X	3.06107e-17
C501	A#1	a_27_112##3	3.10082e-17
C502	VPWR	X#8	1.94133e-18
C503	a_334_368##29	VGND#14	2.33691e-17
C504	A#3	a_27_112##2	6.21536e-19
C505	VPWR#6	a_334_368##26	4.22812e-18
C506	a_27_112##6	A	1.80584e-17
C507	VPWR	X#1	1.19317e-18
C508	VPWR	a_334_368##31	1.38164e-18
C509	VPWR	a_334_368##28	1.64789e-18
C510	VPWR#6	a_221_368#	2.61843e-18
C511	a_334_368##31	VPWR#12	2.26276e-17
C512	a_334_368##29	a_334_368##10	5.92222e-20
C513	VGND	VGND#10	7.3451e-17
C514	VGND	VGND#5	5.26614e-17
C515	VGND	VGND#4	5.78205e-17
C516	VGND	VGND#3	6.00616e-17
C517	VGND	X#10	4.57306e-18
C518	a_221_368##3	a_221_368#	1.35182e-18
C519	VGND	X#9	3.96362e-18
C520	X	VPWR#1	2.76297e-17
C521	VGND	X#8	1.25871e-18
C522	X#9	X#8	1.98589e-18
C523	VGND	X#2	2.12185e-17
C524	VGND	X#1	2.1911e-19
C525	VGND	a_334_368##31	2.32238e-18
C526	VGND#3	X#2	8.80944e-18
C527	VGND	a_334_368##28	3.81055e-19
C528	a_334_368##32	a_334_368##31	1.58393e-18
C529	A	a_27_112##4	1.9402e-17
C530	VGND	a_221_368##11	1.98385e-18
C531	a_334_368##33	VGND#14	4.45014e-17
C532	VGND#3	a_334_368##14	2.74812e-18
C533	VPWR#11	VNB	3.78343e-17
C534	VPWR#5	VNB	2.56457e-17
C535	VPWR#4	VNB	2.80595e-17
C536	VPWR#3	VNB	2.821e-17
C537	VPWR	X#13	1.87975e-17
C538	VGND	VGND#7	1.74465e-17
C539	a_27_112##2	a_221_368##9	1.58876e-20
C540	VGND#10	VNB	3.89748e-17
C541	VGND	X#3	9.64102e-18
C542	VPWR	X#14	1.61201e-17
C543	VGND#5	VNB	2.70881e-17
C544	VGND	VGND#8	1.74057e-17
C545	VGND#4	VNB	3.00121e-17
C546	VPWR	VPWR#8	1.70563e-17
C547	VGND#3	VNB	3.14452e-17
C548	VGND	X#5	8.99623e-18
C549	a_27_112##2	a_27_112##3	8.15357e-18
C550	VPWR	X#15	1.5381e-17
C551	VGND	VGND#9	1.74332e-17
C552	a_334_368##29	a_334_368##8	3.29183e-20
C553	X#10	VNB	1.39163e-18
C554	VGND	X#7	1.85043e-17
C555	VPWR	VPWR#9	1.56602e-17
C556	X#9	VNB	1.01764e-18
C557	X#8	VNB	1.33606e-18
C558	VGND	VGND#13	1.74203e-17
C559	VPWR	X#11	1.70537e-17
C560	a_27_112##2	A#1	1.20448e-18
C561	VGND	a_334_368##29	1.26229e-17
C562	VPWR	VPWR#10	2.10781e-17
C563	VGND	VGND#14	1.74006e-17
C564	X#2	VNB	5.33371e-18
C565	VPWR	a_334_368##34	1.88738e-17
C566	VGND	a_334_368##33	1.62836e-17
C567	A#2	a_27_112##3	1.11583e-18
C568	a_334_368##31	VNB	9.43226e-19
C569	VGND	a_221_368##13	2.2025e-17
C570	VPWR	VPWR#12	1.38504e-17
C571	X#8	a_334_368##3	4.1407e-18
C572	a_334_368##28	VNB	3.08528e-18
C573	VPWR	a_334_368##32	1.90177e-17
C574	a_334_368##7	VPWR#6	3.26185e-19
C575	VGND	a_27_112##6	1.49824e-17
C576	A#2	A#1	3.40029e-18
C577	VPWR	a_221_368##12	2.0012e-17
C578	a_221_368##11	VNB	5.6777e-18
C579	VPWR	a_27_112##4	1.4227e-17
C580	VGND#6	a_334_368##7	4.41816e-19
C581	VGND#1	VNB	4.19581e-17
C582	VGND#7	VNB	5.08315e-19
C583	X#3	VNB	6.23527e-19
C584	VGND#3	a_334_368##16	3.67949e-18
C585	VGND	X#11	2.73855e-18
C586	X#5	VNB	6.31429e-19
C587	VGND	VPWR#10	3.92142e-18
C588	a_334_368##29	a_334_368##6	2.36214e-20
C589	VGND#9	VNB	5.06391e-19
C590	X#7	VNB	2.53859e-18
C591	VGND#13	VNB	5.06391e-19
C592	a_334_368##29	VNB	7.34129e-19
C593	VGND	a_334_368##32	3.47652e-18
C594	a_334_368##33	VNB	1.10574e-17
C595	a_221_368##13	VNB	1.00225e-17
C596	VGND#15	VNB	7.11975e-18
C597	a_221_368##13	a_334_368##33	5.88716e-17
C598	a_27_112##6	VNB	3.66468e-17
C599	VGND#15	VGND#14	7.30527e-19
C600	VPWR#1	VNB	4.76149e-17
C601	X#13	VNB	5.26456e-18
C602	a_27_112##2	a_221_368##4	1.41863e-17
C603	VPWR#7	VNB	3.06939e-18
C604	VGND	a_334_368##16	3.28582e-19
C605	X#14	VNB	5.06773e-18
C606	VGND	a_334_368##19	3.28582e-19
C607	VPWR#8	VNB	3.35598e-18
C608	VGND	a_334_368##20	3.25071e-19
C609	X#15	VNB	4.98696e-18
C610	VGND#4	a_334_368##19	3.67949e-18
C611	VPWR#9	VNB	3.29226e-18
C612	VGND	a_334_368##22	3.25071e-19
C613	X#11	VNB	5.50149e-18
C614	VPWR	a_334_368#	1.66735e-18
C615	VGND	a_334_368##25	1.53565e-19
C616	VPWR#10	VNB	2.58119e-18
C617	VGND	a_334_368##12	1.34814e-18
C618	VPWR	a_334_368##15	1.31516e-18
C619	a_334_368##34	VNB	2.33187e-18
C620	VPWR#12	VNB	3.2558e-18
C621	VGND	a_221_368##5	2.6484e-19
C622	A#2	a_27_112##2	7.92099e-17
C623	VPWR	a_334_368##17	6.3171e-19
C624	a_334_368##32	VNB	1.36959e-17
C625	VGND	a_221_368##6	2.6934e-19
C626	a_221_368##12	VNB	1.50907e-17
C627	VPWR	a_334_368##18	6.28776e-19
C628	a_334_368##4	a_334_368##3	5.77378e-18
C629	VGND	a_221_368##8	6.64072e-19
C630	VPWR#14	VNB	7.57928e-18
C631	VPWR	a_334_368##21	7.39911e-19
C632	a_27_112##4	VNB	4.02018e-17
C633	VGND	a_27_112#	1.49694e-18
C634	a_334_368##13	VNB	3.04181e-17
C635	VGND	A#3	9.10762e-18
C636	VPWR	a_334_368##23	1.15791e-18
C637	a_334_368##14	VNB	2.65005e-17
C638	a_334_368##16	VNB	2.57659e-17
C639	VPWR	a_334_368##24	1.97517e-18
C640	a_221_368##11	a_334_368##32	1.48553e-17
C641	a_334_368##19	VNB	2.55396e-17
C642	VPWR	a_334_368##26	2.95185e-18
C643	a_334_368##20	VNB	2.51205e-17
C644	a_334_368##22	VNB	2.53205e-17
C645	VPWR	a_221_368#	4.78971e-18
C646	a_334_368##25	VNB	2.70739e-17
C647	a_334_368##12	VNB	2.792e-17
C648	VPWR	a_221_368##7	2.52961e-19
C649	a_221_368##5	VNB	2.47223e-17
C650	VPWR	a_221_368##9	3.2623e-19
C651	a_221_368##6	VNB	2.41853e-17
C652	VPWR#2	X	1.84686e-18
C653	a_221_368##8	VNB	2.60221e-17
C654	VPWR	a_27_112##3	3.29537e-18
C655	a_27_112#	VNB	3.25137e-17
C656	VGND#2	X	3.00447e-18
C657	A#3	VNB	3.93112e-17
C658	VPWR	A#1	4.17936e-18
C659	a_334_368#	VNB	3.90072e-17
C660	a_334_368##15	VNB	3.01542e-17
C661	VPWR	VPWR#2	1.44702e-17
C662	a_334_368##17	VNB	2.9484e-17
C663	a_334_368##18	VNB	2.92309e-17
C664	a_334_368##21	VNB	3.16198e-17
C665	VPWR	VPWR#6	6.26179e-17
C666	a_334_368##23	VNB	2.99606e-17
C667	A	A#2	1.10746e-17
C668	X#2	a_334_368##13	2.50304e-17
C669	a_334_368##24	VNB	3.18132e-17
C670	a_334_368##26	VNB	3.30993e-17
C671	a_221_368#	VNB	3.16147e-17
C672	VPWR	a_334_368##7	1.61293e-17
C673	a_221_368##7	VNB	3.08929e-17
C674	VGND	VGND#2	1.30489e-17
C675	VGND#4	a_334_368##20	3.67949e-18
C676	VPWR	a_221_368##4	9.5862e-18
C677	a_221_368##9	VNB	3.8189e-17
C678	a_27_112##3	VNB	3.80067e-17
C679	VPWR	a_27_112##2	3.55384e-18
C680	VGND	VGND#6	6.53619e-17
C681	A#1	VNB	4.00119e-17
C682	VGND#15	a_221_368##13	4.54245e-17
C683	VGND	a_334_368##7	1.59144e-17
C684	VPWR	A#2	1.76623e-18
C685	VPWR#2	VNB	9.56903e-17
C686	VGND	a_221_368##4	1.08905e-17
C687	VGND#2	VNB	9.41208e-17
C688	VGND	a_27_112##2	4.18373e-18
C689	VPWR#6	VNB	3.22002e-17
C690	a_221_368##11	a_221_368##12	2.86611e-19
C691	VGND#6	VNB	3.35617e-17
C692	VGND	A#2	1.56308e-18
C693	a_334_368##7	VNB	4.90377e-17
C694	a_221_368##4	VNB	7.89049e-17
C695	a_27_112##2	VNB	3.89765e-17
C696	X#1	a_334_368##13	7.50485e-20
C697	A#2	VNB	4.98373e-17
C698	VPWR	A	1.88733e-18
C699	VGND	A	1.61153e-18
C700	A	VNB	2.30457e-17
C701	X	VNB	3.11378e-17
C702	a_221_368##9	a_221_368##3	1.70911e-18
C703	VGND#5	a_334_368##22	3.67949e-18
C704	VPWR	VNB	2.93943e-16
C705	VGND	VNB	2.83167e-16
C706	VGND#11	VGND#14	2.14228e-20
C707	VPWR#13	VPWR#12	4.02433e-19
C708	VPWR#13	a_221_368##9	9.74979e-19
C709	VPWR#13	VPWR#14	1.35336e-20
C710	VGND#11	a_221_368##13	2.20454e-17
C711	VGND#11	a_27_112#	8.88736e-18
C712	a_221_368##4	VPWR#13	4.30458e-19
C713	VGND#11	a_27_112##6	1.12792e-17
C714	VPWR	VPWR#13	1.24422e-16
C715	VGND#11	a_221_368##4	2.16961e-19
C716	VGND#11	VNB	6.20656e-17
C717	VGND#11	A#2	1.40191e-19
C718	VGND#11	VGND#10	5.11301e-19
C719	VPWR#13	a_27_112##3	1.11855e-17
C720	a_27_112##4	VPWR#13	8.16661e-18
C721	a_27_112##2	VPWR#13	2.51872e-19
C722	VGND#11	a_221_368##8	6.253e-19
C723	VGND#11	A#3	2.2136e-18
C724	VPWR#13	a_221_368##7	2.43992e-19
C725	VPWR#13	a_221_368##12	2.7216e-17
C726	VPWR#13	A#1	7.75725e-19
C727	VGND	VGND#11	1.22597e-16
C728	VPWR#13	VPWR#11	5.04984e-19
C729	VGND#11	a_27_112##2	4.41816e-19
C730	VPWR#13	A#2	7.90818e-20
C731	VPWR#13	VNB	6.56506e-17
*
*
.ENDS sky130_fd_sc_hs__bufbuf_8
*
