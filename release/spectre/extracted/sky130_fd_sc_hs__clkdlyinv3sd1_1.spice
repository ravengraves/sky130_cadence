* Extracted by Quantus, converted by sky130cad/quantus.py
*
*
*
*                       LINUX           Wed Nov 18 08:22:38 2026
*
*
*
*  PROGRAM  advgen
*
*  Name           : advgen - Quantus - (64-bit)
*  Version        : 25.1.0-p047
*  Build Date     : Thu Dec 11 23:20:30 PST 2025
*
*  HSPICE LIBRARY
*
*  OPERATING_TEMPERATURE 150
*  QRC_TECH_DIR <path>/tech
*
*
*

*
.SUBCKT sky130_fd_sc_hs__clkdlyinv3sd1_1 VPB VNB VGND VPWR Y A
*
*
*  caps2d version: 10
*
*
*       TRANSISTOR CARDS
*
*
XM2 a_28_74##7 A#3 VGND#7 VNB sky130_fd_pr__nfet_01v8_lvt l=0.15 w=0.42 ad=0.1113 as=0.3087 pd=1.37 ps=2.31
XM5 VGND#7 a_28_74# a_285_392##6 VNB sky130_fd_pr__nfet_01v8_lvt l=0.15 w=0.42 ad=0.3087 as=0.1113 pd=2.31 ps=1.37
XM4 VGND#6 a_285_392##3 Y#3 VNB sky130_fd_pr__nfet_01v8_lvt l=0.15 w=0.42 ad=0.1113 as=0.1113 pd=1.37 ps=1.37
XM3 a_28_74##5 A#1 VPWR#7 VPB sky130_fd_pr__pfet_01v8 l=0.15 w=1.12 ad=0.3136 as=0.7368 pd=2.8 ps=3.65
XM0 VPWR#7 a_28_74##4 a_285_392##7 VPB sky130_fd_pr__pfet_01v8 l=0.15 w=1 ad=0.7368 as=0.28 pd=3.65 ps=2.56
XM1 VPWR#6 a_285_392# Y#1 VPB sky130_fd_pr__pfet_01v8 l=0.15 w=1.12 ad=0.308 as=0.3136 pd=2.79 ps=2.8
*
*
*       RESISTOR AND CAP/DIODE CARDS
*
Rg1	A#1	A#2	505.110291
Rg2	A#2	A#3	382.539764
Rg3	a_28_74#	a_28_74##2	371.223999
Rg4	a_28_74##2	a_28_74##3	189.845383
Rg5	a_28_74##2	a_28_74##4	632.163513
Rg6	a_285_392#	a_285_392##2	467.246124
Rg7	a_285_392##2	a_285_392##3	455.213867
Rf1	A	A#4	3.280892
Rf2	A#5	A#2	163.513702
Rf3	A#4	A#5	1.266811
Rf4	A	A#7	3.280892
Rf5	A#5	A#7	6.545189
Rf6	a_28_74##5	a_28_74##3	99.886612
Rf7	a_28_74##3	a_28_74##7	87.592514
Rf8	a_285_392##2	a_285_392##5	187.949219
Rf9	a_285_392##5	a_285_392##6	60.177593
Rf10	a_285_392##5	a_285_392##7	17.895864
Rf11	Y	Y#2	0.271759
Rf12	Y#2	Y	13.135041
Rf13	Y	Y#4	15.111293
Rf14	Y#4	Y	1.268211
Rf15	Y#1	Y#2	5.000000
Rf16	Y#3	Y#4	15.000000
Rf18	VPWR#2	VPWR#3	48.188797
Rf19	VPWR#3	VPWR#4	51.110813
Rf21	VPWR#2	VPWR#6	38.384460
Rf22	VPWR#4	VPWR#7	30.944223
Rf24	VGND#2	VGND#3	48.188797
Rf25	VGND#3	VGND#4	50.380310
Rf27	VGND#2	VGND#6	34.704330
Rf28	VGND#4	VGND#7	33.916985
Re1	VPWR	VPWR#3	1.814012
Re2	VGND	VGND#3	1.814012
*
*       CAPACITOR CARDS
*
*
C1	VGND	VNB	2.01252e-16
C2	VPWR	VNB	1.931e-16
C3	Y	VNB	9.18806e-17
C4	A	VNB	2.02321e-17
C5	VGND	Y	1.1615e-18
C6	A#2	VNB	6.76187e-17
C7	VPWR	Y	2.46636e-17
C8	a_28_74##3	VNB	7.53761e-17
C9	a_285_392##2	VNB	5.79425e-17
C10	VPWR	A	5.56552e-18
C11	VGND#3	VNB	1.90417e-17
C12	VPWR#3	VNB	1.97516e-17
C13	VGND	A#2	6.43288e-18
C14	A#1	VNB	6.09315e-17
C15	VGND	a_28_74##3	1.32413e-17
C16	a_28_74##4	VNB	5.07659e-17
C17	a_285_392#	VNB	3.8854e-17
C18	VGND	a_285_392##2	4.61402e-18
C19	VGND	VGND#3	3.30984e-17
C20	A#3	VNB	3.80861e-17
C21	a_28_74#	VNB	3.28855e-17
C22	a_285_392##3	VNB	4.47015e-17
C23	VPWR	a_28_74##3	1.00344e-17
C24	a_28_74##5	VNB	3.55693e-17
C25	VPWR#7	VNB	4.66194e-18
C26	VPWR	a_285_392##2	3.53087e-18
C27	a_285_392##7	VNB	4.91571e-18
C28	VPWR#6	VNB	1.00911e-17
C29	Y#1	VNB	2.03372e-17
C30	Y	a_28_74##3	1.52895e-18
C31	a_28_74##7	VNB	3.79922e-17
C32	VPWR	VPWR#3	3.57791e-17
C33	VGND#7	VNB	2.39591e-18
C34	VGND	A#3	1.08841e-18
C35	A	A#2	8.24038e-18
C36	a_285_392##6	VNB	1.08157e-17
C37	a_285_392##2	Y	6.11558e-17
C38	VGND#6	VNB	7.02706e-18
C39	VGND	a_28_74#	5.33199e-18
C40	VPWR	A#1	1.30244e-18
C41	Y#3	VNB	2.64043e-17
C42	VGND	a_285_392##3	1.97503e-18
C43	A	a_28_74##3	2.65695e-17
C44	A#5	VNB	7.31546e-18
C45	VPWR	a_28_74##4	4.40552e-18
C46	VPWR	a_285_392#	4.57891e-18
C47	a_285_392##5	VNB	2.13961e-17
C48	VGND	VPWR#6	4.04438e-18
C49	VGND	a_28_74##7	1.87578e-17
C50	Y	a_28_74##4	6.23208e-19
C51	VGND	VGND#7	1.5011e-17
C52	VGND	a_285_392##6	1.8798e-17
C53	Y	a_285_392#	2.03931e-17
C54	VPWR	a_28_74##5	1.62672e-17
C55	A	A#1	9.49758e-18
C56	VPWR	VPWR#7	2.27444e-17
C57	VGND	Y#3	2.08377e-17
C58	VPWR	a_285_392##7	1.70962e-17
C59	A	a_28_74##4	6.02467e-19
C60	VPWR	VPWR#6	1.99612e-17
C61	Y	a_28_74#	7.98791e-19
C62	A#2	a_28_74##3	5.08664e-17
C63	Y	a_285_392##3	7.14369e-18
C64	VGND	a_285_392##5	4.35632e-18
C65	VPWR#6	Y	6.0904e-17
C66	a_28_74##3	a_285_392##2	7.63679e-18
C67	Y	Y#1	8.79026e-18
C68	A	a_28_74##5	5.8611e-17
C69	VGND#3	a_28_74##3	2.79164e-18
C70	A	VPWR#7	3.29015e-19
C71	a_285_392##6	Y	3.9842e-18
C72	a_28_74##3	VPWR#3	1.64762e-18
C73	VPWR	a_285_392##5	1.98962e-18
C74	Y#3	Y	5.468e-19
C75	A#1	a_28_74##3	4.30182e-18
C76	a_28_74##3	a_28_74##4	2.0137e-17
C77	a_285_392##5	Y	1.07868e-17
C78	a_28_74##3	a_285_392#	6.54776e-19
C79	a_28_74##4	a_285_392##2	1.73076e-19
C80	A#3	a_28_74##3	2.56237e-19
C81	a_28_74##5	A#2	1.74609e-18
C82	a_28_74##3	a_28_74#	7.37677e-18
C83	VPWR#3	a_28_74##4	8.25351e-18
C84	VPWR#7	A#2	6.29041e-19
C85	a_28_74##3	a_285_392##3	1.39072e-18
C86	a_28_74##3	a_28_74##5	4.84416e-18
C87	a_28_74##3	VPWR#7	5.262e-18
C88	A#1	a_28_74##4	1.20945e-17
C89	VGND#3	a_28_74#	6.06292e-18
C90	a_28_74##7	A#2	6.21258e-17
C91	VGND#7	A#2	8.77831e-19
C92	a_28_74##4	a_285_392#	7.69583e-18
C93	a_285_392##2	VPWR#6	2.54752e-17
C94	VGND#7	a_28_74##3	2.26944e-17
C95	a_28_74##3	a_285_392##6	1.75905e-17
C96	A#5	A#2	1.02069e-17
C97	a_285_392##7	VPWR#3	1.21068e-17
C98	a_28_74##5	A#1	4.36607e-17
C99	VGND#6	a_285_392##2	1.48519e-17
C100	A#5	a_28_74##3	1.46337e-17
C101	A#1	VPWR#7	4.68417e-17
C102	VGND#3	a_285_392##6	1.71263e-17
C103	a_28_74##5	a_28_74##4	1.58714e-18
C104	a_285_392##7	A#1	3.7795e-18
C105	a_28_74##4	VPWR#7	3.07959e-17
C106	a_28_74##5	a_285_392#	3.04638e-19
C107	VPWR#6	A#1	5.70621e-19
C108	A#3	a_28_74#	6.27914e-18
C109	a_285_392##7	a_28_74##4	3.34983e-17
C110	a_28_74##3	a_285_392##5	1.26209e-16
C111	VPWR#7	a_285_392#	9.94193e-19
C112	VPWR#6	a_28_74##4	4.73862e-18
C113	a_285_392##7	a_285_392#	2.09047e-18
C114	a_28_74#	a_285_392##3	4.66437e-18
C115	VPWR#6	a_285_392#	5.21371e-17
C116	a_285_392##5	a_285_392##2	2.6882e-18
C117	a_285_392#	Y#1	1.11868e-17
C118	a_28_74##5	VPWR#7	7.2547e-17
C119	a_28_74##7	A#3	4.02471e-17
C120	a_28_74##5	a_285_392##7	3.50997e-19
C121	A#3	VGND#7	2.1885e-17
C122	a_28_74##7	a_28_74#	1.60052e-18
C123	VPWR#7	a_285_392##7	1.80116e-17
C124	a_285_392##6	A#3	3.10005e-18
C125	a_28_74#	VGND#7	1.52813e-17
C126	a_28_74##7	a_285_392##3	2.91419e-19
C127	VGND#6	A#3	1.82995e-19
C128	VPWR#7	VPWR#6	2.50443e-18
C129	a_285_392##5	A#1	6.23497e-19
C130	a_285_392##6	a_28_74#	1.60238e-17
C131	VGND#7	a_285_392##3	5.337e-19
C132	a_28_74##7	a_28_74##5	1.1762e-19
C133	a_285_392##7	VPWR#6	4.77996e-17
C134	VGND#6	a_28_74#	1.62449e-18
C135	a_285_392##6	a_285_392##3	3.91311e-18
C136	a_285_392##5	a_28_74##4	1.00432e-17
C137	Y#3	a_28_74#	5.54551e-19
C138	VGND#6	a_285_392##3	3.69335e-17
C139	VPWR#6	Y#1	4.14983e-17
C140	a_285_392##5	a_285_392#	2.58316e-18
C141	Y#3	a_285_392##3	1.38724e-17
C142	a_28_74##7	VGND#7	4.43527e-17
C143	a_28_74##7	a_285_392##6	1.50063e-18
C144	a_285_392##5	a_285_392##3	6.13679e-19
C145	VGND#7	a_285_392##6	1.18074e-17
C146	a_28_74##5	a_285_392##5	1.1676e-18
C147	VGND#7	VGND#6	9.63917e-19
C148	a_285_392##6	VGND#6	3.5724e-17
C149	a_285_392##6	Y#3	2.22946e-18
C150	a_285_392##5	a_285_392##7	4.50956e-18
C151	VGND#6	Y#3	3.5506e-17
C152	a_285_392##5	VPWR#6	3.86576e-17
C153	VGND#2	a_285_392##2	4.88605e-19
C154	a_285_392##2	VPWR#2	2.74607e-19
C155	VPWR#4	VPWR#2	4.25267e-19
C156	a_285_392##7	VPWR#2	1.34866e-18
C157	Y	VPWR#2	3.28847e-17
C158	VPWR#2	a_285_392#	4.55309e-18
C159	VPWR#7	VPWR#2	9.14125e-20
C160	VGND#4	VGND#2	7.1069e-19
C161	VPWR	VPWR#2	7.48845e-17
C162	VGND#2	a_285_392##3	6.9653e-18
C163	VGND#4	a_28_74##3	3.33604e-18
C164	VGND#2	a_28_74#	9.62681e-19
C165	VPWR	VPWR#4	7.61655e-17
C166	VGND#4	a_28_74##7	2.46863e-17
C167	VGND#2	A#3	7.07779e-20
C168	a_28_74##3	VPWR#4	1.83869e-18
C169	VGND#2	Y#3	2.253e-17
C170	VPWR#2	VNB	4.6209e-17
C171	VPWR#4	VNB	4.66763e-17
C172	VGND#4	a_285_392##3	5.70416e-20
C173	VGND	VGND#2	9.7582e-17
C174	VGND#7	VGND#2	1.33584e-20
C175	VGND#4	a_28_74#	1.15076e-18
C176	VPWR#4	A#1	1.11819e-18
C177	VGND	VGND#4	7.70897e-17
C178	VGND#2	VNB	4.83563e-17
C179	VGND#4	A#3	4.84932e-18
C180	a_28_74##5	VPWR#4	9.48505e-18
C181	VGND#4	VNB	4.66305e-17
C182	a_285_392##5	VPWR#2	4.91947e-19
C183	VGND#2	a_285_392##5	1.39269e-18
*
*
.ENDS sky130_fd_sc_hs__clkdlyinv3sd1_1
*
