* Extracted by Quantus, converted by sky130cad/quantus.py
*
*
*
*                       LINUX           Wed Nov 18 09:01:03 2026
*
*
*
*  PROGRAM  advgen
*
*  Name           : advgen - Quantus - (64-bit)
*  Version        : 25.1.0-p047
*  Build Date     : Thu Dec 11 23:20:30 PST 2025
*
*  HSPICE LIBRARY
*
*  OPERATING_TEMPERATURE 150
*  QRC_TECH_DIR <path>/tech
*
*
*

*
.SUBCKT sky130_fd_sc_hs__o311ai_1 VNB VPB VGND VPWR Y A3 B1 C1 A1 A2
*
*
*  caps2d version: 10
*
*
*       TRANSISTOR CARDS
*
*
XM7 VGND#3 A1#3 a_128_74##2 VNB sky130_fd_pr__nfet_01v8_lvt l=0.15 w=0.74 ad=0.2627 as=0.2257 pd=2.19 ps=2.09
XM2 a_128_74##2 A2#3 VGND#1 VNB sky130_fd_pr__nfet_01v8_lvt l=0.15 w=0.74 ad=0.2257 as=0.444 pd=2.09 ps=2.68
XM6 VGND#1 A3#1 a_128_74# VNB sky130_fd_pr__nfet_01v8_lvt l=0.15 w=0.74 ad=0.444 as=0.259 pd=2.68 ps=2.18
XM4 a_128_74# B1#1 a_469_74# VNB sky130_fd_pr__nfet_01v8_lvt l=0.15 w=0.74 ad=0.259 as=0.2294 pd=2.18 ps=2.1
XM0 a_469_74# C1#3 Y#5 VNB sky130_fd_pr__nfet_01v8_lvt l=0.15 w=0.74 ad=0.2294 as=0.2109 pd=2.1 ps=2.05
XM8 VPWR#4 A1#1 a_138_368# VPB sky130_fd_pr__pfet_01v8 l=0.15 w=1.12 ad=0.3304 as=0.3024 pd=2.83 ps=2.78
XM9 a_138_368# A2#1 a_222_368# VPB sky130_fd_pr__pfet_01v8 l=0.15 w=1.12 ad=0.3024 as=0.4704 pd=2.78 ps=3.08
XM5 a_222_368# A3#3 Y#4 VPB sky130_fd_pr__pfet_01v8 l=0.15 w=1.12 ad=0.4704 as=0.4704 pd=3.08 ps=3.08
XM1 Y#4 B1#3 VPWR#5 VPB sky130_fd_pr__pfet_01v8 l=0.15 w=1.12 ad=0.4704 as=0.4704 pd=3.08 ps=3.08
XM3 VPWR#5 C1#4 Y#1 VPB sky130_fd_pr__pfet_01v8 l=0.15 w=1.12 ad=0.4704 as=0.3304 pd=3.08 ps=2.83
*
*
*       RESISTOR AND CAP/DIODE CARDS
*
Rg1	A1#1	A1#2	434.639221
Rg2	A1#2	A1#3	382.539734
Rg3	A2#1	A2#2	434.639221
Rg4	A2#2	A2#3	382.539734
Rg5	A3#1	A3#2	307.937683
Rg6	A3#2	A3#3	492.059540
Rg7	B1#1	B1#2	307.937683
Rg8	B1#2	B1#3	492.059540
Rg9	C1#1	C1#2	50.300888
Rg10	C1#2	C1#3	322.953644
Rg11	C1#2	C1#4	507.075531
Rf1	A1#4	A1	1.716136
Rf2	A1#2	A1#6	161.948944
Rf3	A1#4	A1#6	9.168082
Rf4	A2#2	A2	165.527542
Rf5	A3	A3#2	163.775864
Rf6	a_128_74#	a_128_74##2	110.362900
Rf7	B1	B1#4	1.588424
Rf8	B1#5	B1#2	161.821228
Rf9	B1#4	B1#5	3.176847
Rf10	Y	Y#2	0.152801
Rf11	Y#2	Y	11.154500
Rf12	Y	Y#3	23.675379
Rf13	Y#3	Y#4	74.576477
Rf14	Y#3	Y#5	76.188713
Rf15	Y#1	Y#2	5.000000
Rf16	C1	C1#1	163.775864
Rf18	VPWR#2	VPWR#3	56.224350
Rf19	VPWR#3	VPWR#4	128.886765
Rf20	VPWR#2	VPWR#5	34.939823
Rf21	VGND#1	VGND#2	27.253685
Rf22	VGND#2	VGND#3	137.604523
Re1	VPWR#3	VPWR	1.403190
Re2	VGND	VGND#2	1.403242
*
*       CAPACITOR CARDS
*
*
C1	B1#5	C1#2	2.25351e-18
C2	B1#4	C1#2	9.12136e-19
C3	B1#5	Y#3	2.62266e-17
C4	B1#4	Y#3	2.20287e-18
C5	B1#2	C1#2	2.91247e-17
C6	Y#5	C1#2	3.47417e-18
C7	A2#2	C1#2	3.57953e-20
C8	VGND#1	Y#3	4.22202e-19
C9	B1#4	Y#5	1.80019e-17
C10	VGND#1	C1#2	1.19075e-20
C11	a_128_74#	B1#4	2.56069e-17
C12	VGND#1	B1#4	1.54252e-18
C13	Y#3	VPWR#5	2.62074e-17
C14	a_128_74#	Y#5	3.28048e-17
C15	B1#5	Y#4	3.24548e-17
C16	VGND#1	Y#5	2.91567e-17
C17	a_128_74##2	Y#5	1.14511e-18
C18	a_128_74#	VGND#1	7.5427e-17
C19	a_128_74##2	a_128_74#	2.09042e-18
C20	a_128_74##2	VGND#1	7.71335e-17
C21	VGND#3	VGND#1	2.99151e-18
C22	VGND#3	a_128_74##2	7.13721e-17
C23	a_128_74#	Y#4	6.97787e-18
C24	Y#3	C1#4	1.31421e-17
C25	Y#5	C1#3	4.49346e-17
C26	A2	C1#2	3.09141e-20
C27	Y#5	B1#1	1.04233e-17
C28	a_128_74#	C1#3	5.85592e-18
C29	Y#4	VPWR#5	8.94786e-17
C30	Y#5	A3#1	5.21614e-19
C31	VGND#1	C1#3	6.00789e-18
C32	a_128_74#	B1#1	3.94446e-17
C33	a_128_74##2	C1#3	1.42113e-19
C34	Y#5	A2#3	1.52253e-19
C35	VGND#1	B1#1	9.26681e-18
C36	a_128_74#	A3#1	3.8174e-17
C37	a_128_74##2	B1#1	4.10572e-19
C38	Y#5	A1#3	2.32193e-19
C39	A3#1	VGND#1	3.18117e-17
C40	a_128_74#	A2#3	5.77831e-19
C41	a_128_74##2	A3#1	1.40003e-18
C42	A2#3	VGND#1	3.18492e-17
C43	VPWR#4	Y#4	2.28887e-18
C44	a_128_74#	A1#3	2.57609e-19
C45	VGND#3	A3#1	1.97721e-19
C46	a_128_74##2	A2#3	3.9181e-17
C47	VGND#1	A1#3	2.21524e-18
C48	VGND#3	A2#3	1.32637e-18
C49	a_128_74##2	A1#3	4.34419e-17
C50	VGND#3	A1#3	2.82587e-17
C51	B1#1	C1#3	3.32138e-17
C52	C1#4	Y#1	1.18803e-17
C53	C1#4	VPWR#5	3.57319e-17
C54	Y#3	B1#2	5.36225e-18
C55	Y#4	C1#4	8.71036e-19
C56	A3#1	B1#1	2.80145e-17
C57	B1#3	VPWR#5	3.80448e-17
C58	Y#4	B1#3	8.90237e-17
C59	Y#3	A3#2	9.58255e-20
C60	B1#5	B1#2	9.19072e-18
C61	VPWR#5	A3#3	1.30286e-18
C62	B1#4	B1#2	8.96747e-18
C63	A2#3	A3#1	1.1671e-17
C64	Y#4	A3#3	2.7099e-17
C65	VPWR#5	A2#1	5.11341e-19
C66	A2#2	Y#3	1.14659e-18
C67	B1#5	A3#2	1.97882e-18
C68	Y#4	A2#1	4.90501e-18
C69	VPWR#4	B1#3	4.09809e-19
C70	B1#4	A3#2	1.13617e-18
C71	VPWR#5	A1#1	3.92841e-19
C72	A1#3	A2#3	3.57892e-17
C73	C1#1	Y#5	6.96875e-18
C74	Y#4	A1#1	2.71014e-19
C75	VPWR#4	A3#3	9.96121e-19
C76	VGND#2	VGND#1	1.13884e-16
C77	Y#5	B1#2	1.52384e-18
C78	VPWR#4	A2#1	8.95948e-18
C79	VGND#1	C1#1	9.57196e-19
C80	VGND#2	VGND#3	2.98284e-17
C81	B1#2	a_128_74#	2.51544e-18
C82	VPWR#4	A1#1	5.30577e-17
C83	Y#4	VPWR#3	1.60936e-17
C84	VGND#1	B1#2	3.95855e-19
C85	a_128_74#	A3#2	2.51834e-18
C86	A3#2	VGND#1	1.60857e-18
C87	VPWR#3	VPWR#4	4.14749e-17
C88	B1#3	C1#4	2.98546e-17
C89	VPWR#5	B1#2	8.60927e-19
C90	VGND#1	A2#2	8.42321e-19
C91	Y#4	B1#2	3.70507e-19
C92	a_128_74##2	A2#2	1.79856e-17
C93	A3#3	B1#3	2.94893e-17
C94	VGND#1	A1#2	3.48026e-20
C95	Y#4	A3#2	5.33552e-18
C96	a_128_74##2	A1#2	2.03172e-17
C97	VGND#3	A1#2	1.49302e-17
C98	Y#4	A2#2	4.75017e-19
C99	A2#1	A3#3	2.92468e-17
C100	A1#1	A2#1	5.59116e-17
C101	A2	Y#3	2.32876e-19
C102	VPWR#3	A3#3	8.98177e-18
C103	A1#2	VPWR#4	2.11366e-17
C104	A2#3	A3#2	2.497e-18
C105	VPWR#3	A2#1	6.1525e-18
C106	VGND	C1#2	6.65907e-19
C107	Y#3	C1	2.10237e-17
C108	A2#2	A3#3	1.83032e-18
C109	C1#3	a_469_74#	1.6285e-17
C110	A1#2	A2#1	8.05373e-19
C111	VPWR#3	A3#2	2.63018e-19
C112	A2	Y#4	4.50357e-17
C113	A1#2	A1#1	3.919e-18
C114	Y#5	C1	3.9545e-17
C115	VGND#3	A1	2.1234e-17
C116	VPWR#3	A2#2	5.47507e-20
C117	A3#3	a_222_368#	2.09248e-18
C118	VGND#1	C1	1.89374e-18
C119	VPWR#4	A2	4.18401e-17
C120	A2#1	a_222_368#	2.82484e-17
C121	A3#2	B1#2	3.00359e-17
C122	A3	B1#5	1.56666e-17
C123	A3	B1#4	1.20535e-17
C124	A2#1	a_138_368#	2.24035e-17
C125	A1	VPWR#4	2.60652e-17
C126	A2#2	B1#2	7.29473e-20
C127	A1#1	a_138_368#	1.82871e-18
C128	A2#2	A3#2	3.23738e-17
C129	a_128_74#	A3	4.07611e-17
C130	A2	B1#3	3.94632e-18
C131	A1#2	A2#2	5.73062e-17
C132	A2	A3#3	1.77817e-17
C133	C1#2	VNB	2.0139e-17
C134	A2	A2#1	3.82356e-17
C135	VPWR	Y#3	2.18876e-18
C136	Y#5	Y	4.13718e-18
C137	A2	A1#1	1.46412e-17
C138	A3	Y#4	1.5389e-17
C139	VPWR	B1#5	2.12366e-18
C140	A2#2	a_222_368#	4.65238e-19
C141	B1#2	a_469_74#	3.45513e-19
C142	A2	VPWR#3	1.3199e-17
C143	Y	Y#1	5.34448e-18
C144	VPWR#5	Y	7.50853e-17
C145	Y#3	C1#2	9.33016e-18
C146	Y#4	Y	2.63873e-18
C147	VGND	Y#3	1.3064e-18
C148	A3	A2#3	1.22403e-19
C149	A2	B1#2	6.3e-20
C150	A3	A1#3	8.70301e-19
C151	VGND	B1#4	6.14678e-18
C152	A2	A3#2	3.35473e-19
C153	VPWR	VPWR#5	2.29784e-17
C154	A2	A2#2	7.33516e-18
C155	VPWR	Y#4	1.72529e-17
C156	C1	C1#1	2.17234e-17
C157	VGND	Y#5	2.26238e-17
C158	A1#2	A2	1.63206e-17
C159	VGND	a_128_74#	1.9037e-17
C160	VPWR	VPWR#4	5.12833e-17
C161	VGND	VGND#1	9.77145e-17
C162	Y	C1#4	3.82369e-17
C163	VGND	a_128_74##2	1.92766e-17
C164	A1	A1#2	1.04068e-17
C165	VGND	VGND#3	4.28871e-17
C166	Y	B1#3	2.21885e-18
C167	A2	a_222_368#	5.11823e-18
C168	A3	VPWR#3	9.22016e-19
C169	VGND	Y#4	3.93417e-18
C170	A2	a_138_368#	3.30269e-18
C171	VPWR	C1#4	2.53253e-18
C172	VGND	C1#3	1.10224e-18
C173	VPWR	B1#3	3.98647e-19
C174	A3	B1#2	4.11379e-18
C175	VGND	B1#1	1.51936e-18
C176	VPWR	A3#3	2.33378e-18
C177	A3	A3#2	2.22139e-17
C178	VGND	A3#1	8.93158e-19
C179	VPWR	A2#1	2.29834e-19
C180	VGND	A2#3	5.81219e-20
C181	Y	C1#1	9.36704e-18
C182	A2#2	A3	2.63369e-17
C183	VPWR	A1#1	1.02433e-18
C184	VGND	A1#3	1.29326e-18
C185	A3	A1#2	3.80353e-19
C186	VPWR	VPWR#3	2.84265e-17
C187	Y#3	VNB	5.19841e-18
C188	B1#5	VNB	9.7623e-19
C189	B1#4	VNB	1.44056e-18
C190	VPWR	C1#1	6.87871e-19
C191	VPWR	A3#2	2.43542e-19
C192	Y#5	VNB	3.93444e-17
C193	a_128_74#	VNB	2.62132e-18
C194	VGND#1	VNB	1.01238e-16
C195	a_128_74##2	VNB	1.62128e-17
C196	VPWR	A1#2	3.33649e-18
C197	VGND#3	VNB	7.48224e-17
C198	VGND	C1#1	1.38168e-18
C199	VPWR#5	VNB	5.07914e-18
C200	VGND	B1#2	3.32079e-19
C201	Y#4	VNB	6.97174e-18
C202	VGND	A3#2	3.32079e-19
C203	VPWR#4	VNB	8.58282e-17
C204	VGND	A2#2	4.49196e-18
C205	C1#3	VNB	3.32709e-17
C206	B1#1	VNB	2.89735e-17
C207	VGND	A1#2	2.79776e-18
C208	A3#1	VNB	2.45446e-17
C209	A2#3	VNB	2.75857e-17
C210	A1#3	VNB	3.55388e-17
C211	C1#4	VNB	4.18477e-17
C212	B1#3	VNB	3.45925e-17
C213	VPWR	A2	1.72984e-17
C214	A3#3	VNB	3.98541e-17
C215	C1	Y	3.06624e-17
C216	A2#1	VNB	3.19081e-17
C217	A1#1	VNB	4.03098e-17
C218	VPWR	A1	2.88068e-18
C219	VPWR#3	VNB	1.86231e-16
C220	VPWR	C1	3.11454e-18
C221	VGND#2	VNB	1.53698e-16
C222	C1#1	VNB	5.08002e-17
C223	B1#2	VNB	2.78113e-17
C224	VGND	A1	2.17206e-18
C225	A3#2	VNB	2.58642e-17
C226	A2#2	VNB	3.16403e-17
C227	VGND	C1	5.431e-18
C228	VPWR	A3	4.51596e-18
C229	A1#2	VNB	4.97227e-17
C230	VPWR	Y	1.99842e-17
C231	VGND	A3	3.02153e-18
C232	VGND	Y	3.39358e-18
C233	A2	VNB	2.4136e-18
C234	A1	VNB	2.63809e-17
C235	C1	VNB	2.50908e-17
C236	A3	VNB	4.7142e-18
C237	Y	VNB	6.59104e-17
C238	VPWR	VNB	7.13461e-17
C239	VGND	VNB	6.64059e-17
C240	Y#4	VPWR#2	4.85604e-18
C241	VPWR	VPWR#2	3.70977e-17
C242	Y#3	VPWR#2	3.43076e-19
C243	VPWR#3	VPWR#2	5.71433e-17
C244	VPWR#2	VNB	5.05527e-17
C245	VPWR#2	B1#3	2.59958e-18
C246	C1	VPWR#2	3.09124e-19
C247	Y	VPWR#2	2.53269e-17
C248	VPWR#2	C1#4	4.44912e-18
C249	VPWR#2	C1#1	6.4387e-19
*
*
.ENDS sky130_fd_sc_hs__o311ai_1
*
