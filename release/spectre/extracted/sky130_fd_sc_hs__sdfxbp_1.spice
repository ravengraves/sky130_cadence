* Extracted by Quantus, converted by sky130cad/quantus.py
*
*
*
*                       LINUX           Wed Nov 18 09:11:03 2026
*
*
*
*  PROGRAM  advgen
*
*  Name           : advgen - Quantus - (64-bit)
*  Version        : 25.1.0-p047
*  Build Date     : Thu Dec 11 23:20:30 PST 2025
*
*  HSPICE LIBRARY
*
*  OPERATING_TEMPERATURE 150
*  QRC_TECH_DIR <path>/tech
*
*
*

*
.SUBCKT sky130_fd_sc_hs__sdfxbp_1 VNB VPB VGND VPWR Q Q_N SCE CLK D SCD
*
*
*  caps2d version: 10
*
*
*       TRANSISTOR CARDS
*
*
XM15 a_31_74##8 SCE#4 VGND#18 VNB sky130_fd_pr__nfet_01v8_lvt l=0.15 w=0.42 ad=0.1197 as=0.147 pd=1.41 ps=1.54
XM10 VGND#18 a_31_74# a_218_74# VNB sky130_fd_pr__nfet_01v8_lvt l=0.15 w=0.42 ad=0.147 as=0.1008 pd=1.54 ps=1.32
XM8 a_218_74# D#3 a_296_74##6 VNB sky130_fd_pr__nfet_01v8_lvt l=0.15 w=0.42 ad=0.1008 as=0.2268 pd=1.32 ps=1.92
XM24 a_296_74##6 SCE#6 a_434_74# VNB sky130_fd_pr__nfet_01v8_lvt l=0.15 w=0.42 ad=0.2268 as=0.1008 pd=1.92 ps=1.32
XM12 a_434_74# SCD#3 VGND#17 VNB sky130_fd_pr__nfet_01v8_lvt l=0.15 w=0.42 ad=0.1008 as=0.227 pd=1.32 ps=2.18
XM5 VGND#17 CLK#3 a_612_74##14 VNB sky130_fd_pr__nfet_01v8_lvt l=0.15 w=0.74 ad=0.227 as=0.2109 pd=2.18 ps=2.05
XM33 VGND#16 a_612_74##8 a_828_74##12 VNB sky130_fd_pr__nfet_01v8_lvt l=0.15 w=0.74 ad=0.2805 as=0.1998 pd=2.25 ps=2.02
XM28 a_296_74# a_612_74##6 a_1021_100##6 VNB sky130_fd_pr__nfet_01v8_lvt l=0.15 w=0.42 ad=0.1155 as=0.2226 pd=1.39 ps=1.9
XM30 a_1021_100##6 a_828_74##4 a_1157_100# VNB sky130_fd_pr__nfet_01v8_lvt l=0.15 w=0.42 ad=0.2226 as=0.1932 pd=1.9 ps=1.76
XM25 a_1157_100# a_1243_398##3 VGND#15 VNB sky130_fd_pr__nfet_01v8_lvt l=0.15 w=0.42 ad=0.1932 as=0.3992 pd=1.76 ps=2.75
XM6 VGND#15 a_1021_100# a_1243_398##4 VNB sky130_fd_pr__nfet_01v8_lvt l=0.15 w=0.55 ad=0.3992 as=0.15675 pd=2.75 ps=1.67
XM20 a_1243_398##4 a_828_74##5 a_1529_74##7 VNB sky130_fd_pr__nfet_01v8_lvt l=0.15 w=0.55 ad=0.15675 as=0.2887 pd=1.67 ps=2.32
XM35 a_1529_74##7 a_612_74##9 a_1681_74# VNB sky130_fd_pr__nfet_01v8_lvt l=0.15 w=0.42 ad=0.2887 as=0.0882 pd=2.32 ps=1.26
XM13 a_1681_74# a_1723_48##3 VGND#14 VNB sky130_fd_pr__nfet_01v8_lvt l=0.15 w=0.42 ad=0.0882 as=0.29745 pd=1.26 ps=2.34
XM29 VGND#14 a_1529_74##3 a_1723_48##15 VNB sky130_fd_pr__nfet_01v8_lvt l=0.15 w=0.55 ad=0.29745 as=0.15675 pd=2.34 ps=1.67
XM7 VGND#13 a_1723_48##9 Q#2 VNB sky130_fd_pr__nfet_01v8_lvt l=0.15 w=0.74 ad=0.2109 as=0.2109 pd=2.05 ps=2.05
XM11 a_2216_94##6 a_1723_48##8 VGND#12 VNB sky130_fd_pr__nfet_01v8_lvt l=0.15 w=0.64 ad=0.1824 as=0.2848 pd=1.85 ps=2.27
XM32 VGND#12 a_2216_94##3 Q_N#3 VNB sky130_fd_pr__nfet_01v8_lvt l=0.15 w=0.74 ad=0.2848 as=0.2109 pd=2.27 ps=2.05
XM9 a_31_74##9 SCE#5 VPWR#18 VPB sky130_fd_pr__pfet_01v8 l=0.15 w=0.64 ad=0.1888 as=0.224 pd=1.87 ps=1.98
XM17 VPWR#18 SCE#1 a_233_464# VPB sky130_fd_pr__pfet_01v8 l=0.15 w=0.64 ad=0.224 as=0.1728 pd=1.98 ps=1.82
XM3 a_233_464# D#1 a_296_74##4 VPB sky130_fd_pr__pfet_01v8 l=0.15 w=0.64 ad=0.1728 as=0.192 pd=1.82 ps=1.88
XM21 a_296_74##4 a_31_74##3 a_407_464# VPB sky130_fd_pr__pfet_01v8 l=0.15 w=0.64 ad=0.192 as=0.2496 pd=1.88 ps=2.06
XM31 a_407_464# SCD#1 VPWR#17 VPB sky130_fd_pr__pfet_01v8 l=0.15 w=0.64 ad=0.2496 as=0.4856 pd=2.06 ps=3.36
XM4 VPWR#17 CLK#1 a_612_74##12 VPB sky130_fd_pr__pfet_01v8 l=0.15 w=1.12 ad=0.4856 as=0.3304 pd=3.36 ps=2.83
XM26 VPWR#16 a_612_74##7 a_828_74##16 VPB sky130_fd_pr__pfet_01v8 l=0.15 w=1.12 ad=0.5264 as=0.3136 pd=3.18 ps=2.8
XM18 a_296_74##5 a_828_74# a_1021_100##7 VPB sky130_fd_pr__pfet_01v8 l=0.15 w=0.42 ad=0.1176 as=0.126 pd=1.4 ps=1.44
XM2 a_1021_100##7 a_612_74# a_1180_496# VPB sky130_fd_pr__pfet_01v8 l=0.15 w=0.42 ad=0.126 as=0.1386 pd=1.44 ps=1.5
XM14 a_1180_496# a_1243_398##2 VPWR#15 VPB sky130_fd_pr__pfet_01v8 l=0.15 w=0.42 ad=0.1386 as=0.3765 pd=1.5 ps=3.04
XM22 VPWR#15 a_1021_100##3 a_1243_398##7 VPB sky130_fd_pr__pfet_01v8 l=0.15 w=0.84 ad=0.3765 as=0.6468 pd=3.04 ps=3.22
XM34 a_1243_398##7 a_612_74##11 a_1529_74##6 VPB sky130_fd_pr__pfet_01v8 l=0.15 w=0.84 ad=0.6468 as=0.2856 pd=3.22 ps=2.45
XM19 a_1529_74##6 a_828_74##8 a_1691_508# VPB sky130_fd_pr__pfet_01v8 l=0.15 w=0.42 ad=0.2856 as=0.1134 pd=2.45 ps=1.38
XM23 a_1691_508# a_1723_48# VPWR#14 VPB sky130_fd_pr__pfet_01v8 l=0.15 w=0.42 ad=0.1134 as=0.4015 pd=1.38 ps=3.18
XM0 VPWR#14 a_1529_74# a_1723_48##16 VPB sky130_fd_pr__pfet_01v8 l=0.15 w=1 ad=0.4015 as=0.275 pd=3.18 ps=2.55
XM16 VPWR#13 a_1723_48##10 Q#1 VPB sky130_fd_pr__pfet_01v8 l=0.15 w=1.12 ad=0.308 as=0.308 pd=2.79 ps=2.79
XM27 a_2216_94##7 a_1723_48##4 VPWR#12 VPB sky130_fd_pr__pfet_01v8 l=0.15 w=0.84 ad=0.231 as=0.3724 pd=2.23 ps=2.95
XM1 VPWR#12 a_2216_94# Q_N#1 VPB sky130_fd_pr__pfet_01v8 l=0.15 w=1.12 ad=0.3724 as=0.3192 pd=2.95 ps=2.81
*
*
*       RESISTOR AND CAP/DIODE CARDS
*
Rg1	a_31_74#	a_31_74##2	773.557800
Rg2	SCE#1	SCE#2	484.685455
Rg3	SCE#2	SCE#3	710.328552
Rg4	SCE#3	SCE#4	242.169754
Rg5	SCE#2	SCE#5	234.008942
Rg6	D#1	D#2	473.017548
Rg7	D#2	D#3	585.753723
Rg8	a_31_74##3	a_31_74##4	312.457703
Rg9	SCE#6	SCE#7	404.066101
Rg10	SCD#1	SCD#2	393.484894
Rg11	SCD#2	SCD#3	623.561768
Rg12	CLK#1	CLK#2	473.627625
Rg13	CLK#2	CLK#3	383.830872
Rg14	CLK#2	CLK#4	36.543846
Rg15	a_828_74#	a_828_74##2	452.095703
Rg16	a_612_74#	a_612_74##2	286.857635
Rg17	a_612_74##2	a_612_74##3	452.420624
Rg18	a_612_74##3	a_612_74##4	324.872070
Rg19	a_612_74##4	a_612_74##5	174.877045
Rg20	a_612_74##3	a_612_74##6	518.070618
Rg21	a_612_74##4	a_612_74##7	373.466431
Rg22	a_612_74##5	a_612_74##8	398.498138
Rg23	a_828_74##3	a_828_74##4	244.673935
Rg24	a_1243_398#	a_1243_398##2	743.031860
Rg25	a_1243_398#	a_1243_398##3	216.119781
Rg26	a_1021_100#	a_1021_100##2	616.671326
Rg27	a_1021_100##2	a_1021_100##3	362.525665
Rg28	a_828_74##5	a_828_74##6	448.085327
Rg29	a_612_74##9	a_612_74##10	745.931763
Rg30	a_612_74##10	a_612_74##11	345.237274
Rg31	a_828_74##7	a_828_74##8	578.177673
Rg32	a_1723_48#	a_1723_48##2	233.787552
Rg33	a_1723_48##2	a_1723_48##3	926.217651
Rg34	a_1529_74#	a_1529_74##2	442.513855
Rg35	a_1529_74##2	a_1529_74##3	322.572906
Rg36	a_1723_48##4	a_1723_48##5	505.266815
Rg37	a_1723_48##5	a_1723_48##6	209.587036
Rg38	a_1723_48##6	a_1723_48##7	49.357773
Rg39	a_1723_48##5	a_1723_48##8	348.245087
Rg40	a_1723_48##6	a_1723_48##9	386.011902
Rg41	a_1723_48##6	a_1723_48##10	464.375244
Rg42	a_2216_94#	a_2216_94##2	492.390228
Rg43	a_2216_94##2	a_2216_94##3	307.355530
Rf1	D#2	D	170.665131
Rf2	SCE	SCE#7	3.914606
Rf3	SCE#7	SCE#3	212.846558
Rf4	a_31_74##4	a_31_74##2	262.518860
Rf5	a_31_74##2	a_31_74##7	10.130589
Rf6	a_31_74##7	a_31_74##8	86.384056
Rf7	a_31_74##7	a_31_74##9	36.621590
Rf8	SCD#4	SCD	1.051655
Rf9	SCD#2	SCD#6	161.284454
Rf10	SCD#4	SCD#6	4.150963
Rf11	SCD#7	SCD	1.051655
Rf12	SCD#6	SCD#7	9.811368
Rf13	CLK#5	CLK#4	161.549118
Rf14	CLK	CLK#7	1.316317
Rf15	CLK#5	CLK#7	7.059660
Rf16	a_612_74##12	a_612_74##13	68.968506
Rf17	a_612_74##13	a_612_74##14	101.422440
Rf18	a_296_74#	a_296_74##2	143.036163
Rf19	a_296_74##2	a_296_74##3	95.161728
Rf20	a_296_74##3	a_296_74##4	89.726395
Rf21	a_296_74##2	a_296_74##5	69.411797
Rf22	a_296_74##3	a_296_74##6	215.881210
Rf23	a_1021_100##2	a_1021_100##5	247.806473
Rf24	a_1021_100##5	a_1021_100##6	77.190964
Rf25	a_1021_100##5	a_1021_100##7	88.646141
Rf26	a_1243_398##4	a_1243_398##5	45.976479
Rf27	a_1243_398##5	a_1243_398#	190.959976
Rf28	a_1243_398##5	a_1243_398##7	86.364792
Rf29	a_612_74##10	a_612_74##2	528.685364
Rf30	a_828_74##3	a_828_74##10	179.221313
Rf31	a_828_74##10	a_828_74##11	67.453651
Rf32	a_828_74##11	a_828_74##12	83.712166
Rf33	a_828_74##10	a_828_74##6	209.630005
Rf34	a_828_74##6	a_828_74##7	198.020004
Rf35	a_828_74##11	a_828_74##2	116.855278
Rf36	a_828_74##2	a_828_74##16	29.400009
Rf37	a_1529_74##2	a_1529_74##5	121.240654
Rf38	a_1529_74##5	a_1529_74##6	139.802948
Rf39	a_1529_74##5	a_1529_74##7	81.469444
Rf40	a_1723_48##7	a_1723_48##12	91.552597
Rf41	a_1723_48##12	a_1723_48##13	45.809269
Rf42	a_1723_48##13	a_1723_48##2	203.355545
Rf43	a_1723_48##12	a_1723_48##15	69.142227
Rf44	a_1723_48##13	a_1723_48##16	13.304452
Rf45	Q#1	Q	96.012016
Rf46	Q	Q#3	5.849958
Rf47	Q#3	Q	5.849958
Rf48	Q#2	Q#3	7.500000
Rf49	a_2216_94##2	a_2216_94##5	181.904480
Rf50	a_2216_94##5	a_2216_94##6	45.775024
Rf51	a_2216_94##5	a_2216_94##7	61.363007
Rf52	Q_N	Q_N#2	0.196836
Rf53	Q_N#2	Q_N	14.369054
Rf54	Q_N	Q_N#4	8.609523
Rf55	Q_N#4	Q_N	5.548359
Rf56	Q_N#1	Q_N#2	5.000000
Rf57	Q_N#3	Q_N#4	7.500000
Rf59	VPWR#2	VPWR#3	103.682640
Rf60	VPWR#3	VPWR#4	50.015057
Rf61	VPWR#4	VPWR#5	33.196522
Rf62	VPWR#5	VPWR#6	184.751770
Rf63	VPWR#6	VPWR#7	184.913895
Rf64	VPWR#7	VPWR#8	52.717037
Rf65	VPWR#8	VPWR#9	36.858910
Rf66	VPWR#9	VPWR#10	145.314362
Rf68	VPWR#2	VPWR#12	39.408188
Rf69	VPWR#3	VPWR#13	38.286041
Rf70	VPWR#5	VPWR#14	25.018780
Rf71	VPWR#6	VPWR#15	23.681496
Rf72	VPWR#7	VPWR#16	26.266380
Rf73	VPWR#9	VPWR#17	24.688660
Rf74	VPWR#10	VPWR#18	31.337896
Rf76	VGND#2	VGND#3	105.426422
Rf77	VGND#3	VGND#4	46.485107
Rf78	VGND#4	VGND#5	38.374992
Rf79	VGND#5	VGND#6	184.143539
Rf80	VGND#6	VGND#7	203.813477
Rf81	VGND#7	VGND#8	29.555229
Rf82	VGND#8	VGND#9	45.324123
Rf83	VGND#9	VGND#10	141.726242
Rf85	VGND#2	VGND#12	22.502884
Rf86	VGND#3	VGND#13	56.430489
Rf87	VGND#5	VGND#14	17.352871
Rf88	VGND#6	VGND#15	28.841251
Rf89	VGND#7	VGND#16	31.091198
Rf90	VGND#9	VGND#17	40.352859
Rf91	VGND#10	VGND#18	34.507496
Rf99	a_612_74##5	a_612_74##13	160.232803
Re1	VPWR#4	VPWR	2.105487
Re2	VPWR	VPWR#8	1.804703
Re3	VGND#4	VGND	2.105487
Re4	VGND	VGND#8	1.804703
*
*       CAPACITOR CARDS
*
*
C1	a_612_74##2	a_1243_398##7	9.63054e-18
C2	a_1723_48##8	a_2216_94##3	2.27381e-17
C3	a_1723_48##3	a_1529_74##2	2.4332e-17
C4	a_2216_94##6	a_2216_94##3	2.20192e-19
C5	a_1243_398##5	a_1243_398##7	2.23517e-18
C6	VGND#5	a_828_74##6	2.27297e-17
C7	a_612_74##2	VPWR#15	4.77604e-18
C8	a_828_74##10	VGND#15	7.79177e-17
C9	VPWR#5	a_828_74##7	2.7194e-19
C10	VGND#5	a_612_74##9	1.09389e-17
C11	a_296_74##3	a_612_74##8	1.20728e-19
C12	VGND#12	a_1723_48##8	4.05255e-17
C13	a_2216_94#	VPWR#12	2.18477e-17
C14	a_612_74#	a_1243_398##2	2.34104e-17
C15	VGND#5	a_1529_74##7	6.89427e-17
C16	a_1723_48##12	a_1723_48##7	3.69398e-17
C17	VGND#4	a_1243_398##5	1.6161e-18
C18	VPWR#13	Q#1	8.56868e-17
C19	a_296_74##6	a_31_74##4	3.20917e-18
C20	a_1723_48##12	a_1723_48##5	9.67839e-20
C21	a_1723_48##3	a_1723_48##2	1.71204e-18
C22	a_1723_48##9	a_2216_94##3	2.9278e-19
C23	VPWR#6	a_828_74##8	2.95313e-19
C24	Q_N#3	a_1723_48##9	2.03685e-19
C25	a_612_74##14	SCE#7	9.12893e-19
C26	a_31_74##4	SCE#2	9.85193e-20
C27	VPWR#8	CLK#2	1.94971e-19
C28	a_2216_94##5	a_1723_48##10	5.72391e-19
C29	a_1021_100##7	a_612_74##2	4.31299e-17
C30	a_1723_48##5	a_2216_94##6	3.46882e-19
C31	a_1723_48##8	a_2216_94##6	9.67395e-18
C32	VGND#6	a_828_74##5	4.45538e-18
C33	VPWR#5	a_828_74##8	1.2759e-17
C34	VPWR#12	a_1723_48##4	4.75591e-17
C35	VGND#6	a_1021_100##2	3.63581e-20
C36	a_1723_48##3	a_828_74##7	1.74298e-17
C37	a_1723_48##9	a_1723_48##8	5.02297e-18
C38	a_612_74##10	VPWR#6	1.48044e-17
C39	VGND#12	a_1723_48##9	1.07797e-18
C40	a_828_74#	a_612_74#	2.15512e-17
C41	VGND#13	a_2216_94##3	3.35142e-19
C42	SCE#7	a_296_74##6	1.26325e-17
C43	a_1529_74##2	a_1723_48##13	1.80094e-17
C44	a_296_74##3	CLK#3	1.13152e-17
C45	VPWR#5	VPWR#3	9.41173e-19
C46	a_1021_100##7	a_828_74##2	2.43033e-17
C47	a_828_74##7	a_612_74##9	1.35485e-17
C48	a_612_74##10	VPWR#5	6.30526e-19
C49	Q#2	a_1723_48##8	1.25929e-18
C50	a_828_74##11	a_1021_100##6	6.73454e-17
C51	VGND#5	a_828_74##5	6.39932e-19
C52	a_1723_48##4	a_2216_94##7	2.33285e-17
C53	a_1529_74##2	a_1723_48##12	6.74173e-17
C54	a_296_74##2	a_612_74##4	6.99275e-18
C55	a_828_74##2	a_296_74##5	3.91974e-17
C56	a_612_74##10	a_1723_48##3	9.53272e-19
C57	VPWR#13	a_2216_94#	4.71664e-19
C58	a_2216_94##6	a_1723_48##9	7.05466e-19
C59	VPWR#4	a_2216_94#	5.00257e-18
C60	VPWR#6	a_612_74##11	2.57684e-18
C61	VPWR#12	a_1723_48##10	1.07362e-18
C62	a_1529_74##5	a_1723_48##13	1.75526e-18
C63	a_612_74##7	a_828_74#	5.8433e-18
C64	Q#1	a_1723_48##4	3.71035e-18
C65	a_296_74##6	D#2	2.22309e-18
C66	a_296_74##3	CLK#2	1.88493e-17
C67	VGND#13	a_1723_48##8	3.68394e-19
C68	VGND#12	a_1529_74##3	1.35232e-19
C69	VPWR#4	a_1723_48##4	4.87274e-18
C70	VGND#8	CLK#2	4.59876e-19
C71	a_1529_74##5	a_1529_74##2	3.01125e-17
C72	VPWR#5	a_612_74##11	6.1155e-18
C73	VGND#6	a_1021_100#	4.46603e-18
C74	a_296_74##5	a_612_74##3	4.03807e-19
C75	a_828_74##6	a_1723_48##3	3.59109e-19
C76	a_2216_94##7	a_1723_48##10	1.34873e-18
C77	Q#2	a_1723_48##5	7.2288e-20
C78	a_1529_74##3	a_1723_48##9	3.79527e-18
C79	a_1021_100##6	a_828_74##10	3.32832e-17
C80	Q#2	a_1723_48##9	4.0493e-17
C81	VPWR#6	a_828_74##6	1.16603e-19
C82	a_1723_48##13	a_1723_48##2	3.26611e-19
C83	VPWR#13	a_1723_48##4	3.35835e-19
C84	VPWR#4	a_1723_48##10	3.50001e-18
C85	a_296_74##3	VPWR#8	5.29549e-18
C86	a_1723_48##13	a_1723_48##10	2.00992e-18
C87	a_828_74##6	a_612_74##9	2.32154e-17
C88	a_828_74##11	a_296_74#	5.37554e-17
C89	a_1021_100##5	a_1243_398##5	3.00099e-19
C90	a_1723_48##12	a_1723_48##2	1.66205e-19
C91	a_1723_48##10	Q#1	3.94238e-17
C92	a_612_74##5	VPWR#16	5.8814e-18
C93	VGND#5	a_1021_100#	6.61265e-20
C94	a_1723_48##5	a_2216_94##2	3.49128e-17
C95	a_612_74##14	a_612_74##12	2.87588e-18
C96	CLK#1	a_612_74##7	4.07965e-18
C97	a_296_74##6	a_31_74##2	6.62866e-19
C98	VPWR#4	a_1529_74#	3.66426e-18
C99	a_828_74##6	a_828_74##5	1.86565e-17
C100	a_296_74##2	VPWR#8	9.59272e-20
C101	a_1723_48##9	VGND#13	2.06797e-17
C102	VPWR#6	a_1021_100##3	1.83715e-17
C103	a_1723_48##12	a_1723_48##10	1.65105e-19
C104	a_1529_74##5	a_1723_48##12	2.76033e-18
C105	a_612_74##5	a_612_74##12	4.54086e-18
C106	a_828_74##6	a_1021_100#	2.41136e-17
C107	a_828_74##16	a_612_74##4	3.99196e-18
C108	VPWR#4	a_1723_48#	9.59599e-19
C109	VPWR#13	a_1723_48##10	7.8436e-17
C110	VGND#18	a_31_74##2	5.19422e-19
C111	Q#1	VPWR#3	1.5274e-17
C112	a_1529_74##5	a_1723_48##2	5.10517e-17
C113	a_828_74##6	a_1243_398##3	1.19525e-19
C114	VPWR#5	a_1021_100##3	3.71992e-19
C115	a_296_74##3	VPWR#9	6.32621e-17
C116	a_1723_48##3	a_1529_74##3	1.10758e-17
C117	VGND#6	a_1243_398##3	3.7801e-18
C118	VPWR#4	a_828_74##8	2.27922e-18
C119	a_1723_48##13	a_828_74##7	7.4086e-21
C120	a_1723_48##15	a_1723_48##9	1.53393e-18
C121	D#2	CLK#2	4.58135e-19
C122	VPWR#6	a_1021_100##2	5.89324e-19
C123	VGND#6	a_828_74##3	2.45666e-19
C124	a_296_74##6	SCE#3	3.32537e-19
C125	SCD#1	CLK#1	1.35285e-17
C126	a_2216_94##5	a_2216_94##3	5.95212e-19
C127	a_1723_48##13	a_1529_74#	4.81131e-17
C128	a_828_74##12	a_828_74##11	2.68059e-18
C129	SCE#2	D#2	8.34774e-19
C130	VPWR#5	VPWR#13	1.98382e-18
C131	a_1021_100##5	a_1021_100##7	2.20736e-18
C132	VGND#13	a_1529_74##3	1.65768e-18
C133	a_828_74##16	a_612_74##3	3.61064e-18
C134	VPWR#4	a_612_74##11	1.63676e-18
C135	CLK#5	CLK#3	8.62016e-19
C136	a_1529_74##5	a_1723_48##10	1.99001e-19
C137	VPWR#13	a_1529_74#	3.55254e-18
C138	SCE#3	VGND#18	3.54797e-17
C139	a_1723_48##12	a_1529_74#	4.03297e-19
C140	VPWR#6	a_1243_398##2	1.44608e-17
C141	a_31_74##8	SCE#3	3.29034e-17
C142	VPWR#5	a_1723_48##3	5.32001e-20
C143	VPWR#4	a_1021_100##3	4.84415e-19
C144	a_1243_398#	a_1021_100#	6.60145e-18
C145	a_612_74##12	SCD#2	5.52057e-19
C146	a_31_74##3	SCD#1	2.14371e-17
C147	a_1529_74#	a_1723_48##16	3.37578e-17
C148	a_1723_48##7	a_1723_48##5	1.04206e-18
C149	a_1529_74##3	a_1723_48##15	2.58496e-17
C150	a_1529_74##5	a_828_74##7	5.80612e-17
C151	a_612_74##9	a_1723_48##3	5.52269e-17
C152	a_1723_48##13	a_612_74##10	2.39168e-20
C153	VPWR#13	a_1723_48#	2.01209e-19
C154	VGND#6	a_828_74##4	3.0938e-18
C155	a_612_74##4	VPWR#16	1.11308e-19
C156	a_2216_94##5	a_1723_48##8	1.86837e-18
C157	VPWR#6	a_1243_398#	3.30864e-19
C158	a_1723_48##13	a_1723_48#	1.58738e-18
C159	a_1529_74#	VPWR#14	1.21893e-17
C160	VGND#6	a_612_74##2	2.68322e-20
C161	a_2216_94##5	Q_N#3	7.04111e-19
C162	a_1529_74##3	VGND#14	1.47363e-17
C163	a_1529_74##5	a_1529_74#	7.50846e-19
C164	D#1	a_31_74##3	2.94617e-17
C165	a_1529_74##2	a_1723_48##10	1.66775e-18
C166	a_1723_48##15	a_1723_48##3	1.30823e-18
C167	a_1529_74##7	a_1723_48##9	1.3387e-19
C168	a_828_74##3	a_828_74##4	1.74814e-19
C169	a_31_74##2	SCE#2	3.32765e-17
C170	VPWR#6	a_612_74#	6.41579e-18
C171	VGND#7	a_612_74##6	3.11432e-18
C172	a_612_74##10	a_1529_74##5	3.1239e-18
C173	VGND#3	a_1723_48##12	8e-19
C174	a_1723_48#	VPWR#14	1.26097e-17
C175	a_612_74##6	a_828_74##3	5.16042e-18
C176	a_31_74##4	a_296_74##4	5.56799e-17
C177	a_296_74##2	VPWR#7	6.54771e-18
C178	a_1529_74##6	a_1529_74#	3.3577e-19
C179	a_828_74##5	a_612_74##9	1.18419e-17
C180	a_296_74##2	a_1021_100##7	5.93946e-19
C181	a_1723_48##3	VGND#14	1.30399e-17
C182	a_1723_48##13	a_828_74##8	3.92339e-19
C183	SCE#1	D#1	5.1121e-17
C184	a_2216_94##5	a_1723_48##9	3.25992e-19
C185	VPWR#6	a_828_74##3	5.3193e-20
C186	a_1723_48##2	a_1529_74#	1.74626e-17
C187	VGND#12	a_2216_94##5	3.83951e-18
C188	a_1723_48##15	a_612_74##9	2.86242e-19
C189	a_1529_74##7	a_1529_74##3	6.32e-19
C190	VPWR#5	VPWR#14	9.2554e-18
C191	VPWR#7	a_828_74#	2.38405e-18
C192	VGND#9	a_612_74##8	3.10589e-19
C193	a_296_74##4	SCE#7	5.40838e-19
C194	a_31_74##9	a_31_74##4	1.11289e-19
C195	VGND#7	a_828_74##12	4.33359e-17
C196	VGND#5	VGND#3	7.94838e-19
C197	VPWR#7	a_612_74##4	5.72506e-20
C198	a_1529_74##6	a_1723_48#	3.86587e-18
C199	VPWR#6	a_828_74#	3.37855e-18
C200	a_828_74##8	a_1723_48##2	2.66277e-17
C201	SCE#5	SCE#1	2.33254e-17
C202	a_828_74##2	a_612_74##6	2.87195e-18
C203	VGND#7	a_612_74##8	3.95868e-18
C204	VPWR#8	CLK#1	4.08944e-18
C205	a_828_74##10	a_1157_100#	5.30226e-18
C206	VGND#9	VGND#16	4.38095e-19
C207	SCE#3	SCE#2	2.19973e-18
C208	a_1021_100#	a_828_74##5	2.98752e-17
C209	a_828_74##2	a_612_74##8	9.76964e-20
C210	VGND#5	a_1529_74##5	3.26948e-17
C211	a_1723_48##2	a_612_74##11	1.07288e-18
C212	VPWR#9	a_612_74##7	2.02997e-18
C213	a_1529_74##7	a_1723_48##3	1.00178e-17
C214	a_1723_48##13	a_612_74##11	2.89884e-19
C215	a_296_74##6	a_296_74##4	5.09144e-18
C216	VGND#7	a_612_74##5	3.85577e-19
C217	a_1529_74##6	a_828_74##8	1.9912e-17
C218	a_612_74##2	VPWR#6	5.04727e-17
C219	a_612_74##5	a_612_74##6	4.19792e-19
C220	a_2216_94##5	a_2216_94##6	1.51189e-19
C221	VPWR#9	CLK#2	3.05256e-19
C222	a_612_74##11	a_828_74##7	2.82425e-18
C223	VPWR#7	a_612_74##7	3.93852e-18
C224	a_612_74##5	a_612_74##8	1.61135e-17
C225	a_828_74##12	a_296_74#	5.65476e-17
C226	VGND#9	CLK#3	1.0033e-17
C227	VPWR#7	a_612_74##3	3.90138e-19
C228	a_612_74##12	CLK#2	4.04286e-18
C229	a_612_74##5	CLK#3	2.20801e-19
C230	a_1243_398##5	a_828_74##7	5.61043e-18
C231	VGND#4	a_2216_94##6	1.28395e-17
C232	Q#1	a_2216_94##5	2.82663e-17
C233	a_1723_48##12	a_1723_48##8	2.44965e-20
C234	a_612_74##10	a_612_74##11	1.14865e-17
C235	VPWR#6	a_612_74##7	9.80374e-19
C236	a_296_74##2	a_828_74##16	5.82479e-17
C237	a_1529_74##6	a_612_74##11	4.65063e-17
C238	VPWR#6	a_1529_74##6	4.1908e-18
C239	a_1529_74##7	a_612_74##9	5.08667e-17
C240	a_612_74##5	SCD#3	4.35741e-20
C241	a_31_74##2	VPWR#18	3.43672e-17
C242	a_1243_398##3	a_1021_100#	7.20214e-18
C243	a_612_74##10	a_1021_100##3	1.59337e-17
C244	VGND#9	a_612_74##14	2.05752e-18
C245	a_828_74##2	VPWR#7	1.51919e-18
C246	a_31_74##9	a_31_74##2	3.8891e-18
C247	VGND#15	a_1723_48##3	2.54245e-20
C248	VPWR#9	CLK#1	1.78887e-17
C249	a_1529_74##7	a_1681_74#	4.65718e-19
C250	a_612_74##11	a_1243_398##7	1.30523e-17
C251	a_828_74##10	a_828_74##6	2.26403e-18
C252	Q#2	a_2216_94##5	4.51666e-17
C253	a_612_74##10	a_1243_398##2	2.18787e-19
C254	a_612_74##8	a_612_74##3	6.8463e-20
C255	a_1529_74##6	a_1021_100##3	2.83893e-18
C256	a_1529_74##6	VPWR#5	3.1846e-17
C257	VPWR#7	CLK#1	8.92351e-19
C258	a_31_74##8	SCE#2	5.42586e-20
C259	a_612_74##10	a_612_74#	1.18284e-19
C260	a_828_74##5	a_1529_74##7	3.26929e-18
C261	a_1243_398##5	a_612_74##10	1.1192e-17
C262	VGND#4	a_1723_48##15	3.77358e-17
C263	a_296_74##3	a_296_74##2	1.47569e-18
C264	VGND#9	SCD#3	4.8237e-18
C265	a_296_74##2	VPWR#16	6.24875e-17
C266	a_1723_48##12	a_1723_48##9	2.26045e-19
C267	VGND#7	a_612_74##14	7.86875e-20
C268	a_1243_398##7	a_1021_100##3	4.01638e-17
C269	CLK#2	a_612_74##8	3.18609e-18
C270	VGND#15	a_612_74##9	7.53882e-20
C271	VGND#16	a_828_74##12	2.81928e-17
C272	a_828_74##4	a_1243_398##3	1.1673e-17
C273	a_296_74##3	a_612_74##12	6.42549e-17
C274	VPWR#6	a_612_74##3	6.02596e-20
C275	a_1243_398##2	a_1021_100##2	5.95797e-18
C276	a_1529_74##6	a_1243_398##2	7.48312e-19
C277	a_1243_398##4	a_828_74##5	2.69741e-17
C278	a_828_74##10	a_1021_100##2	4.64277e-18
C279	a_1021_100##3	VPWR#15	1.55047e-17
C280	VPWR#9	SCD#1	1.98897e-17
C281	a_1021_100##7	a_612_74##11	5.5308e-19
C282	a_1243_398##7	a_1243_398##2	2.04299e-18
C283	a_1243_398##5	a_828_74##6	5.07855e-17
C284	VGND#4	a_1529_74##7	2.32214e-17
C285	a_612_74##12	a_296_74##2	1.43521e-17
C286	VGND#15	a_828_74##5	3.18612e-19
C287	VPWR#4	a_2216_94##2	3.83625e-18
C288	a_612_74##14	a_828_74##12	2.21463e-18
C289	CLK#5	CLK#2	1.46272e-17
C290	a_1529_74##6	a_612_74#	4.37434e-19
C291	Q#2	Q#1	4.36399e-18
C292	SCE#7	SCD#3	1.93008e-17
C293	a_612_74##2	a_612_74##11	1.23492e-19
C294	VPWR#3	a_1723_48##5	9.49828e-20
C295	a_1529_74##5	a_1723_48##9	3.69147e-19
C296	a_2216_94##2	VGND#12	3.69493e-17
C297	VGND#9	SCE#6	6.0549e-18
C298	VGND#4	a_1243_398##4	7.91754e-18
C299	a_1243_398##2	VPWR#15	1.08066e-17
C300	a_1243_398##4	a_1021_100#	1.96227e-17
C301	VGND#4	a_2216_94##2	4.80629e-18
C302	a_296_74##3	VPWR#17	1.34936e-17
C303	VPWR#4	a_1723_48##7	1.31553e-18
C304	a_612_74##6	a_828_74##4	9.33217e-18
C305	a_612_74##2	a_1021_100##3	2.15072e-17
C306	VPWR#6	VPWR#15	1.15953e-17
C307	a_1021_100##7	a_1021_100##3	1.21116e-18
C308	a_1243_398##7	a_612_74#	1.91276e-19
C309	D#3	SCE#7	1.61913e-17
C310	VGND#4	VGND#15	2.5648e-18
C311	a_828_74##10	a_1243_398#	5.84374e-17
C312	a_612_74##2	a_1243_398##2	6.01874e-17
C313	VGND#4	a_1723_48##7	4.2502e-18
C314	VPWR#4	a_1529_74##2	3.32349e-18
C315	VPWR#9	a_31_74##3	8.32063e-18
C316	a_1021_100#	VGND#15	9.78855e-18
C317	a_296_74##4	a_407_464#	7.0882e-18
C318	a_612_74##14	VGND#16	5.30177e-17
C319	a_612_74##2	a_612_74#	5.83744e-18
C320	a_1243_398##5	a_1021_100##2	4.96225e-17
C321	a_296_74#	a_296_74##2	1.74286e-18
C322	VGND#4	a_1529_74##2	6.89876e-18
C323	VPWR#4	a_1723_48##2	6.01812e-18
C324	a_1021_100##7	a_1243_398##2	2.88796e-18
C325	a_1243_398##4	a_1243_398##3	3.26715e-19
C326	a_612_74##2	a_828_74#	5.97188e-20
C327	VGND#7	a_828_74##11	3.15199e-17
C328	a_1021_100##5	a_1021_100##2	1.68892e-18
C329	a_31_74#	D#2	2.43303e-18
C330	a_1529_74##5	a_1529_74##3	1.84742e-19
C331	a_828_74##2	a_612_74#	1.7074e-18
C332	VPWR#4	a_828_74##7	3.74595e-18
C333	a_828_74##11	a_828_74##3	2.59926e-19
C334	a_612_74##8	a_612_74##6	6.05813e-18
C335	a_612_74##7	a_612_74##2	5.98507e-19
C336	VGND#9	D#3	1.19472e-19
C337	a_1723_48##12	Q#1	1.05123e-17
C338	VGND#17	VGND#16	1.94048e-18
C339	a_1243_398##3	VGND#15	1.70652e-17
C340	VPWR#9	SCD#2	5.36437e-19
C341	VGND#4	a_828_74##7	5.65065e-18
C342	Q#2	a_1723_48##7	2.88501e-17
C343	VPWR#4	a_612_74##10	2.16012e-17
C344	a_1021_100##7	a_612_74#	2.6496e-17
C345	a_612_74##7	a_828_74##2	1.072e-17
C346	a_1723_48##13	VPWR#13	1.02408e-16
C347	a_828_74##12	a_296_74##2	8.6945e-18
C348	a_1243_398##4	a_828_74##4	4.14113e-20
C349	a_1243_398##5	a_1243_398#	2.4352e-19
C350	VPWR#9	D#1	3.35739e-19
C351	VGND#4	a_612_74##10	3.22069e-18
C352	VGND#13	a_1723_48##7	4.64667e-18
C353	VGND#9	a_296_74##6	2.45551e-17
C354	VPWR#4	a_828_74##6	6.23225e-19
C355	VGND#9	SCE#7	3.25936e-19
C356	Q#1	a_1723_48##5	1.84824e-19
C357	a_612_74##5	a_612_74##7	1.5184e-18
C358	a_1021_100##5	a_1243_398#	5.55067e-19
C359	a_1529_74##2	a_1723_48##7	2.68511e-17
C360	SCE#3	a_31_74#	3.4486e-17
C361	VGND#6	a_828_74##11	3.25795e-17
C362	SCD#3	CLK#2	1.30593e-19
C363	a_296_74##4	a_296_74##3	1.73392e-18
C364	VPWR#16	a_1243_398##2	4.05266e-19
C365	VGND#12	Q_N#3	3.93183e-17
C366	VGND#4	a_828_74##6	2.89372e-17
C367	a_1529_74##5	a_1723_48##3	3.14187e-17
C368	VPWR#4	a_1021_100##2	3.52095e-18
C369	a_1021_100##7	a_828_74#	2.36404e-17
C370	VGND#17	a_612_74##14	4.20273e-17
C371	CLK#3	a_612_74##8	4.2379e-18
C372	CLK#1	a_612_74##5	1.91839e-18
C373	a_828_74##11	a_612_74##2	1.88636e-19
C374	VGND#15	a_828_74##4	1.07608e-18
C375	CLK#5	a_612_74##12	1.35652e-17
C376	Q#2	a_1529_74##2	1.45057e-19
C377	a_1723_48##12	VPWR#13	5.17056e-17
C378	VGND#4	a_1021_100##2	2.55251e-18
C379	a_828_74##10	a_612_74##2	1.72266e-19
C380	VGND#9	a_31_74#	3.24412e-20
C381	a_1021_100##7	VPWR#6	1.90726e-17
C382	a_828_74#	a_296_74##5	1.21784e-17
C383	a_1723_48##2	a_1529_74##2	3.07323e-17
C384	VPWR#9	a_31_74##4	3.75683e-19
C385	VGND#13	a_1529_74##2	3.23677e-19
C386	Q#2	a_1723_48##12	4.16488e-17
C387	CLK	CLK#2	4.89733e-18
C388	a_296_74##3	CLK#5	3.38055e-17
C389	VPWR#16	a_612_74#	5.78618e-19
C390	a_1723_48##13	a_1723_48##16	2.61114e-18
C391	VGND#4	a_1243_398#	1.60644e-18
C392	a_1021_100##7	a_612_74##7	1.01048e-18
C393	a_612_74##14	a_296_74##3	1.2346e-17
C394	VPWR#9	SCE#1	1.89009e-19
C395	a_1529_74##2	a_1723_48##15	2.17897e-17
C396	a_296_74##5	a_1021_100##7	4.14209e-17
C397	a_1021_100##5	a_828_74##3	5.91026e-17
C398	SCD#2	CLK#1	1.10836e-17
C399	a_2216_94##6	Q_N#3	6.8003e-19
C400	a_296_74##5	VPWR#7	1.8199e-17
C401	a_1723_48##13	VPWR#5	4.24144e-17
C402	a_828_74##7	a_1723_48##2	4.06024e-17
C403	VPWR#4	a_612_74##2	4.17348e-18
C404	a_1529_74##5	a_612_74##9	2.66665e-20
C405	SCD#3	CLK#3	2.83537e-17
C406	a_296_74##5	a_612_74##7	3.51734e-18
C407	VGND#6	a_828_74##10	5.87247e-17
C408	a_1529_74##2	VGND#14	7.34303e-19
C409	a_828_74##11	a_828_74##2	1.69178e-18
C410	a_1021_100##6	a_828_74##4	6.30932e-18
C411	VPWR#16	a_828_74#	2.53772e-18
C412	a_31_74##4	SCD#1	3.2738e-18
C413	a_612_74##7	a_828_74##16	2.48569e-17
C414	SCD#7	a_296_74##3	4.389e-17
C415	a_828_74##11	a_612_74##3	1.08657e-18
C416	a_1723_48##12	VGND#13	2.86138e-17
C417	a_296_74##6	a_612_74##14	6.12278e-18
C418	a_828_74##7	a_612_74##10	5.67997e-17
C419	VPWR#9	SCE#7	1.1698e-20
C420	a_1723_48##13	VPWR#14	7.86517e-19
C421	VGND#17	a_296_74##3	8.85003e-18
C422	a_2216_94##6	VGND#12	4.15227e-17
C423	a_296_74##5	CLK#1	1.02577e-19
C424	VGND#8	a_612_74##14	1.66768e-17
C425	a_1021_100##5	a_612_74##2	7.9644e-17
C426	a_1723_48##15	a_1723_48##13	2.19315e-18
C427	VPWR#16	a_612_74##7	5.28416e-17
C428	a_31_74##4	D#1	2.18728e-17
C429	a_612_74##6	a_1021_100##6	1.48566e-17
C430	a_1723_48##13	VPWR#3	3.35179e-18
C431	SCE#6	SCD#3	3.15009e-17
C432	a_1723_48#	a_1691_508#	1.06762e-17
C433	a_296_74##5	a_828_74##16	9.31982e-18
C434	VGND#18	VGND#9	1.66425e-19
C435	a_612_74##9	a_1681_74#	6.3919e-18
C436	a_828_74##6	a_612_74##10	6.85885e-17
C437	a_828_74##7	a_1021_100##2	5.99888e-19
C438	a_612_74##12	a_612_74##7	1.32118e-18
C439	a_828_74##8	a_1691_508#	1.06762e-17
C440	a_296_74##6	VGND#17	3.62628e-17
C441	a_1021_100##2	a_612_74##10	2.07076e-17
C442	a_612_74##6	a_296_74#	2.64432e-17
C443	VPWR#16	CLK#1	5.14044e-18
C444	VPWR#4	a_2216_94##7	1.52266e-17
C445	VPWR#9	VPWR#16	1.00714e-17
C446	a_1021_100##2	a_828_74##6	1.25422e-17
C447	VPWR#6	a_828_74##16	8.38346e-20
C448	VPWR#16	a_296_74##5	6.50156e-18
C449	a_828_74##2	a_1021_100##5	8.13492e-17
C450	VPWR#4	Q#1	1.86262e-17
C451	a_612_74##12	CLK#1	3.9995e-17
C452	a_296_74##6	a_434_74#	5.33153e-18
C453	a_828_74##12	a_612_74##6	1.96849e-18
C454	D#3	SCE#6	1.01598e-17
C455	a_31_74##2	SCE#1	2.27322e-17
C456	VGND#4	VGND#6	5.49643e-17
C457	VPWR#4	VPWR#13	2.06234e-17
C458	a_1243_398##2	a_1180_496#	5.99129e-18
C459	a_1723_48##12	VPWR#3	4.73399e-19
C460	a_296_74#	a_612_74##8	2.38496e-18
C461	a_1021_100##2	a_1243_398#	1.10715e-16
C462	CLK#1	VPWR#17	1.71931e-17
C463	a_612_74##2	a_612_74##10	1.00259e-18
C464	a_1529_74##7	a_828_74##7	3.17434e-17
C465	a_612_74#	a_1180_496#	8.09244e-18
C466	Q_N	a_1723_48##5	9.49575e-19
C467	Q#2	a_2216_94##6	4.21923e-17
C468	VGND#13	VGND#12	7.93512e-19
C469	SCD#6	a_296_74##3	1.59629e-17
C470	VGND#16	a_612_74##6	3.80259e-19
C471	a_612_74##12	SCD#1	2.14045e-19
C472	VGND#4	VGND#5	1.47687e-16
C473	SCE#3	SCE#1	6.90554e-19
C474	a_296_74##2	a_828_74##2	1.68149e-18
C475	VGND#4	Q#1	9.01436e-19
C476	SCD#7	a_296_74##4	6.83359e-18
C477	a_612_74##3	a_1243_398#	6.70083e-19
C478	a_828_74##12	a_612_74##8	2.02325e-17
C479	a_828_74##3	a_1243_398#	6.5167e-17
C480	VPWR#18	SCE#2	2.74978e-18
C481	a_1021_100##2	a_612_74##2	2.75174e-17
C482	VGND#4	VGND#3	7.18027e-17
C483	SCD#1	VPWR#17	1.71971e-17
C484	SCD#4	CLK#2	2.64703e-19
C485	a_1529_74##6	a_1723_48##13	3.05069e-18
C486	VGND#18	VGND#17	1.05111e-18
C487	a_612_74##14	a_612_74##6	1.48199e-19
C488	a_296_74##4	CLK#1	1.88164e-19
C489	a_31_74#	D#3	4.94593e-17
C490	a_612_74##2	a_1243_398#	2.19757e-17
C491	a_1243_398##3	a_1157_100#	4.52819e-18
C492	a_296_74##3	a_612_74##5	6.57033e-18
C493	a_612_74##8	VGND#16	2.18914e-17
C494	a_828_74##3	a_612_74##2	2.70109e-17
C495	a_828_74##4	a_1157_100#	1.11873e-17
C496	a_828_74##2	a_1243_398#	1.17596e-19
C497	a_1529_74##5	a_1723_48##15	1.76373e-18
C498	a_828_74##10	a_612_74##9	1.35658e-19
C499	a_296_74##3	SCD#4	2.00631e-17
C500	SCD#1	a_407_464#	1.59617e-17
C501	a_1529_74##5	VPWR#5	8.16328e-19
C502	a_1243_398##4	a_612_74##10	2.05102e-18
C503	a_296_74##2	a_612_74##5	7.50514e-17
C504	a_828_74##2	a_828_74##3	5.99457e-19
C505	VPWR#4	a_1529_74##6	2.08756e-17
C506	a_828_74##12	CLK#3	6.51426e-19
C507	a_612_74##14	CLK#5	3.23156e-17
C508	a_31_74##3	a_407_464#	1.59617e-17
C509	a_296_74##4	SCD#1	2.09883e-18
C510	a_828_74##11	a_828_74##10	3.23162e-18
C511	a_612_74##14	a_612_74##8	1.47873e-18
C512	a_612_74##2	a_828_74##2	1.92489e-17
C513	VPWR#4	a_1243_398##7	5.19887e-18
C514	a_1243_398##5	a_1529_74##5	1.92021e-19
C515	VPWR#9	VPWR#17	4.66362e-18
C516	SCE#4	a_31_74#	1.99164e-17
C517	VPWR#4	VPWR#6	7.67654e-17
C518	a_828_74##6	a_1529_74##7	6.59612e-17
C519	VGND#16	CLK#3	2.52248e-18
C520	a_2216_94##2	VPWR#12	1.8674e-17
C521	VGND#13	Q#2	4.3374e-17
C522	D#1	a_233_464#	1.62684e-17
C523	VGND#4	a_1529_74##6	2.95003e-18
C524	a_296_74##4	a_31_74##3	5.08921e-17
C525	a_828_74##2	a_612_74##5	1.67878e-19
C526	a_828_74##6	a_1243_398##4	6.70998e-17
C527	a_612_74##3	a_828_74##3	2.14553e-18
C528	VGND#17	a_612_74##8	3.91208e-19
C529	a_31_74##9	SCE#2	2.50586e-17
C530	SCE#1	a_233_464#	1.62684e-17
C531	VPWR#4	VPWR#5	1.31926e-16
C532	VGND#18	a_296_74##6	1.21602e-17
C533	a_828_74##10	a_828_74##5	7.21705e-19
C534	VPWR#18	SCD#1	1.73172e-19
C535	a_612_74##14	CLK#3	4.94192e-17
C536	VPWR#4	VPWR#3	6.53593e-17
C537	a_31_74##9	SCD#1	3.82301e-19
C538	VGND#16	SCD#3	3.12217e-19
C539	a_296_74##4	D#1	3.82007e-17
C540	a_612_74##5	SCD#2	4.16604e-19
C541	VPWR#18	a_31_74##3	3.3684e-19
C542	CLK#3	VGND#17	1.66734e-17
C543	a_1021_100##5	a_612_74##7	1.49771e-19
C544	a_296_74##3	SCD#2	9.07854e-18
C545	a_31_74##7	SCE#2	1.38356e-17
C546	a_296_74##6	a_612_74##8	5.10097e-20
C547	a_612_74##14	SCD#3	2.11707e-18
C548	a_31_74##9	a_31_74##3	2.86384e-19
C549	Q#1	a_1723_48##7	1.15771e-18
C550	a_828_74##10	a_1021_100#	1.98496e-17
C551	a_296_74##2	a_828_74#	7.35044e-19
C552	a_612_74##5	SCE#7	3.97101e-20
C553	a_296_74##4	SCE#1	5.36256e-18
C554	a_2216_94##5	Q_N	8.26873e-18
C555	VPWR#18	D#1	5.34321e-18
C556	VPWR	a_612_74##3	4.37569e-19
C557	a_296_74#	a_612_74##4	6.87284e-18
C558	VPWR	SCE#2	1.51767e-22
C559	a_31_74##4	SCD#2	3.52088e-17
C560	VGND#7	a_612_74##4	7.05994e-20
C561	VPWR#13	a_1723_48##7	6.68525e-18
C562	SCD#3	a_434_74#	1.12244e-18
C563	SCD#3	VGND#17	1.56563e-17
C564	a_1723_48##15	VGND#13	5.92436e-17
C565	SCE#6	a_434_74#	6.19045e-18
C566	SCE#7	SCD#2	5.66341e-18
C567	a_31_74##9	D#1	9.29439e-19
C568	a_296_74##3	a_612_74##7	3.80436e-19
C569	VGND#3	Q	2.02019e-17
C570	a_296_74##6	CLK#3	2.284e-18
C571	SCE#7	a_31_74##4	1.16608e-17
C572	D#2	SCD#2	9.63814e-18
C573	a_612_74##14	SCE#6	6.84951e-20
C574	a_1243_398##5	a_612_74##9	5.71999e-19
C575	a_2216_94##5	a_1723_48##5	4.43978e-17
C576	Q#1	a_1529_74##2	9.50273e-20
C577	VPWR#18	SCE#1	4.45743e-17
C578	a_1243_398#	VGND#15	2.75994e-18
C579	a_296_74##3	a_31_74##4	3.96563e-19
C580	a_612_74##14	CLK	1.77898e-17
C581	a_31_74##4	D#2	4.8982e-17
C582	a_296_74##4	VPWR#9	1.89865e-17
C583	CLK#5	SCD#2	2.37992e-19
C584	a_296_74##2	a_612_74##7	3.20247e-17
C585	VPWR#13	a_1529_74##2	2.121e-19
C586	a_296_74#	a_612_74##3	1.33331e-17
C587	a_828_74##10	a_1243_398##3	2.76399e-17
C588	D#2	SCE#7	9.86174e-18
C589	a_31_74##2	a_31_74##4	4.69618e-18
C590	a_612_74##2	a_1180_496#	5.99339e-18
C591	a_31_74##9	SCE#1	1.64696e-18
C592	SCD#7	SCD#2	8.15566e-18
C593	a_31_74##8	VGND#18	3.61187e-17
C594	VGND#17	SCE#6	2.11018e-18
C595	a_1723_48##5	a_2216_94#	9.55407e-18
C596	VPWR#4	a_2216_94##5	1.49044e-18
C597	VPWR#18	SCE#5	1.89692e-17
C598	a_1723_48##4	a_2216_94#	3.86685e-17
C599	a_296_74##6	SCD#3	2.03026e-17
C600	a_31_74##2	D#2	4.55309e-17
C601	VGND#7	a_612_74##3	2.79059e-20
C602	D#3	a_218_74#	9.87534e-18
C603	a_828_74##11	a_828_74##4	1.54442e-18
C604	a_296_74##3	CLK#1	3.30077e-17
C605	a_1529_74##2	VPWR#14	1.79496e-18
C606	SCD#6	SCD#2	7.12456e-18
C607	a_31_74#	a_218_74#	9.87534e-18
C608	VGND#18	CLK#3	2.4419e-19
C609	a_1243_398##5	a_828_74##5	7.1227e-19
C610	a_31_74##9	SCE#5	3.20121e-17
C611	VGND	a_612_74##3	4.54747e-20
C612	Q_N	Q_N#3	2.11253e-18
C613	VGND	CLK#2	1.31552e-18
C614	VGND#12	Q_N	1.98091e-17
C615	a_828_74##12	a_612_74##4	4.47345e-18
C616	a_296_74##6	SCE	9.95948e-17
C617	SCD#4	SCD#2	1.00737e-17
C618	a_1723_48##10	a_2216_94#	3.40946e-19
C619	SCE#3	a_31_74##2	7.88012e-17
C620	a_828_74##2	a_612_74##3	4.95273e-17
C621	a_296_74##2	CLK#1	1.72414e-18
C622	VGND#17	D#3	2.54034e-19
C623	VPWR	VPWR#9	1.16702e-16
C624	a_31_74##8	SCE	1.91632e-18
C625	a_1529_74##6	a_612_74##9	3.49431e-19
C626	VPWR	VPWR#7	1.29229e-16
C627	VPWR	VPWR#6	8.54769e-17
C628	a_828_74##10	a_828_74##4	1.88469e-17
C629	a_1021_100##6	a_828_74##3	2.13805e-17
C630	a_31_74##4	SCD#7	2.03663e-17
C631	a_296_74##6	SCE#6	3.76129e-17
C632	a_31_74##4	a_407_464#	9.4845e-19
C633	CLK	a_612_74##12	1.19715e-17
C634	VPWR#9	VPWR#7	9.61061e-19
C635	VGND#3	a_1723_48##7	2.94591e-19
C636	a_1723_48##10	a_1723_48##4	7.59256e-18
C637	a_1723_48##2	VPWR#14	1.29337e-18
C638	VGND#4	a_2216_94##5	1.88023e-18
C639	VGND#18	SCD#3	2.71899e-19
C640	VGND#9	a_296_74##3	6.529e-19
C641	a_31_74##4	SCD#6	1.55716e-17
C642	a_296_74##3	SCD#1	2.49054e-17
C643	a_828_74##12	a_612_74##3	5.52904e-20
C644	a_828_74##11	a_612_74##6	3.89155e-17
C645	Q	VGND#12	6.6382e-18
C646	a_1723_48##13	VPWR#4	3.70574e-17
C647	Q	a_2216_94##6	5.44828e-18
C648	a_1243_398##5	a_1021_100#	1.71842e-17
C649	Q	Q#2	1.70819e-18
C650	VGND#3	a_2216_94##3	1.28115e-19
C651	VGND#17	a_31_74#	1.18271e-19
C652	VGND#7	CLK#2	1.82613e-20
C653	VGND#13	Q	1.98501e-17
C654	Q_N	Q_N#1	5.76766e-18
C655	D#2	a_296_74##3	2.7923e-18
C656	VPWR#12	Q_N	8.5009e-17
C657	a_2216_94##7	Q_N	1.05899e-18
C658	a_1529_74##6	a_1723_48##2	1.45954e-17
C659	VPWR	a_1021_100##5	1.89019e-18
C660	VGND	VGND#9	9.62517e-17
C661	a_31_74##8	SCD#3	2.0315e-19
C662	a_296_74##2	SCD#1	4.34329e-19
C663	a_296_74##6	D#3	2.92092e-17
C664	VGND	VGND#7	9.09406e-17
C665	VPWR	a_296_74##3	1.60933e-17
C666	VGND	VGND#6	7.88224e-17
C667	VPWR	a_296_74##2	1.43978e-17
C668	a_828_74##3	a_1157_100#	5.43237e-19
C669	VPWR#4	a_1723_48##12	4.32543e-18
C670	VGND#6	a_612_74##3	3.52128e-20
C671	a_828_74##10	a_612_74##6	5.58767e-19
C672	VPWR	CLK#5	2.39769e-18
C673	VPWR	SCD#7	4.46718e-18
C674	VGND#18	SCE#6	9.06074e-19
C675	VGND#5	a_1529_74##2	2.07317e-17
C676	a_1529_74#	a_1723_48##10	6.3217e-18
C677	CLK	a_612_74##8	7.93989e-19
C678	VPWR#18	VPWR#9	4.39659e-19
C679	a_612_74##5	a_612_74##3	2.53403e-18
C680	VGND#5	VGND#13	2.33234e-18
C681	a_296_74##3	a_31_74##3	5.6962e-19
C682	a_1529_74##6	a_828_74##7	6.08298e-17
C683	a_828_74##11	a_612_74##8	4.00484e-19
C684	a_31_74##8	SCE#6	4.52174e-19
C685	VPWR#4	a_1529_74##5	4.60416e-18
C686	a_296_74##6	a_31_74#	2.19848e-18
C687	a_1243_398##5	a_1243_398##3	6.12275e-20
C688	a_828_74##2	a_1021_100##6	5.80419e-18
C689	VGND	a_828_74##11	2.93561e-17
C690	CLK#2	a_612_74##5	2.93773e-17
C691	VGND	a_828_74##10	2.56259e-17
C692	VGND#4	a_1723_48##13	1.07781e-18
C693	VPWR#18	a_296_74##4	2.34144e-17
C694	Q_N	a_2216_94##3	1.13583e-17
C695	VGND#4	a_2216_94##3	3.2221e-18
C696	a_1529_74##7	a_1723_48##15	3.03347e-18
C697	Q_N	a_1723_48##8	9.40333e-19
C698	SCE	SCD#3	9.98773e-19
C699	Q_N	a_1723_48##9	1.10932e-19
C700	SCD#7	CLK#1	4.57316e-19
C701	VGND	a_1021_100##5	1.74161e-18
C702	VPWR	a_296_74#	3.51922e-18
C703	VGND#18	D#3	3.48325e-18
C704	SCE	SCE#6	2.20156e-18
C705	a_296_74#	a_828_74##2	4.79805e-17
C706	VGND	a_296_74##3	5.59513e-18
C707	VGND	a_296_74##2	2.2517e-18
C708	SCE	D#3	1.78904e-17
C709	SCE	a_31_74#	7.00435e-19
C710	a_296_74##6	SCD#4	2.33584e-17
C711	a_1723_48#	a_1529_74#	9.46835e-18
C712	VGND	CLK#5	2.07582e-18
C713	SCE	SCE#4	3.5765e-19
C714	VGND#4	a_1723_48##12	5.122e-18
C715	VGND#4	a_1723_48##8	4.87839e-18
C716	VGND	SCD#4	3.85228e-18
C717	VGND	a_31_74##7	2.39726e-18
C718	a_612_74##10	a_1529_74##6	9.01204e-17
C719	D	SCE#1	2.38566e-18
C720	a_1243_398##5	a_612_74##3	6.92507e-20
C721	a_1723_48##10	a_1723_48##5	8.65878e-19
C722	a_31_74##8	D#3	7.58925e-19
C723	D#2	SCD#6	3.15517e-18
C724	Q	a_1723_48##8	3.28224e-18
C725	a_296_74##6	SCE#4	1.54906e-19
C726	Q	a_1723_48##9	1.19318e-17
C727	VPWR#4	a_1723_48##5	8.92057e-19
C728	VGND#4	a_1723_48##9	1.86259e-18
C729	a_296_74##3	D#1	3.53309e-19
C730	a_828_74##10	a_1243_398##5	1.66162e-17
C731	a_612_74##10	a_1243_398##7	1.08386e-16
C732	VGND#5	a_1723_48##9	9.34716e-19
C733	VPWR	a_1021_100##7	1.66536e-17
C734	D#2	SCD#4	5.803e-18
C735	VGND	VGND#15	1.21387e-17
C736	VPWR	a_296_74##5	1.85277e-17
C737	Q_N	a_2216_94#	3.7708e-17
C738	SCD#6	CLK#1	4.54392e-19
C739	VGND#18	a_31_74#	2.97822e-17
C740	VGND	a_1021_100##6	7.43021e-18
C741	VPWR	a_828_74##16	2.28717e-18
C742	Q_N	a_1723_48##4	4.53331e-18
C743	VGND	a_296_74#	9.70167e-18
C744	a_1243_398##5	a_828_74##4	1.52247e-20
C745	VGND	a_828_74##12	2.26518e-17
C746	VPWR	a_612_74##12	4.69659e-18
C747	Q_N	a_1723_48##10	2.04763e-19
C748	a_612_74##5	a_296_74#	8.88886e-18
C749	VGND	VGND#16	1.93375e-17
C750	VGND#5	a_1723_48##15	4.23542e-17
C751	VGND#4	a_1529_74##5	6.94524e-18
C752	a_1723_48##5	VNB	4.04678e-17
C753	VGND	a_612_74##14	2.09683e-17
C754	a_612_74##4	VNB	2.58753e-17
C755	a_612_74##3	VNB	5.2014e-17
C756	CLK#2	VNB	5.87389e-17
C757	a_31_74##7	D#2	4.74677e-19
C758	VGND#4	a_1529_74##3	4.64924e-18
C759	SCE#2	VNB	5.60482e-17
C760	SCD#7	SCD#1	3.30275e-18
C761	VPWR	a_296_74##4	2.50966e-17
C762	VGND	a_296_74##6	3.36165e-17
C763	VPWR	VPWR#18	2.22675e-17
C764	VGND	a_31_74##8	2.03489e-17
C765	VPWR	a_31_74##9	2.29691e-17
C766	a_828_74##6	a_1529_74##6	1.94285e-18
C767	a_828_74##8	a_1723_48#	2.86874e-17
C768	a_612_74##5	a_828_74##12	3.38549e-17
C769	SCE	SCE#1	3.30815e-19
C770	VPWR#3	a_1723_48##7	7.84007e-19
C771	SCD#4	CLK#1	7.80213e-20
C772	a_31_74##8	a_31_74#	2.69163e-18
C773	VGND#3	a_1723_48##9	7.23439e-18
C774	VGND#4	a_1723_48##3	5.67786e-19
C775	a_828_74##6	a_1243_398##7	8.11947e-20
C776	a_612_74##5	VGND#16	1.29318e-17
C777	a_31_74##2	SCD#6	1.26323e-19
C778	VGND	a_612_74##12	4.07947e-18
C779	VGND#9	VNB	4.08843e-17
C780	SCE#4	VGND#18	1.2849e-17
C781	VGND#7	VNB	5.25967e-17
C782	VGND#6	VNB	7.8774e-17
C783	VGND#5	VNB	5.79083e-17
C784	VGND#3	VNB	3.26583e-17
C785	a_612_74##14	a_612_74##5	2.60679e-18
C786	VPWR#5	a_1723_48##10	9.77808e-19
C787	VGND#4	a_612_74##9	2.46789e-18
C788	VPWR#4	Q_N	2.09531e-17
C789	a_296_74##3	SCE#1	9.02611e-19
C790	VPWR#9	VNB	4.66984e-17
C791	VPWR#7	VNB	5.71908e-17
C792	VPWR#6	VNB	8.20082e-17
C793	VGND#4	Q_N	2.24825e-17
C794	VPWR#5	VNB	5.41831e-17
C795	a_828_74##10	a_1021_100##5	1.53126e-18
C796	VPWR#3	VNB	3.45841e-17
C797	a_2216_94##7	VPWR#12	6.67972e-17
C798	a_31_74##9	VPWR#18	6.22077e-17
C799	VGND#3	a_1723_48##15	2.62017e-18
C800	VGND#5	a_828_74##7	3.03056e-19
C801	a_2216_94##5	VNB	7.97051e-18
C802	a_2216_94##2	Q_N	5.14247e-17
C803	a_1723_48##13	VNB	1.53891e-17
C804	D	a_31_74##4	3.84459e-18
C805	a_1723_48##12	VNB	8.07672e-18
C806	Q_N	a_1723_48##7	1.70368e-19
C807	a_1529_74##5	VNB	6.7631e-18
C808	a_31_74##7	a_31_74##2	1.43961e-17
C809	CLK	a_612_74##5	3.99109e-17
C810	VGND	a_1243_398##3	9.47541e-18
C811	a_2216_94##5	a_2216_94##2	5.8855e-19
C812	VGND#5	a_1529_74##3	2.97852e-17
C813	a_828_74##11	VNB	1.06052e-17
C814	a_612_74##11	a_828_74##8	2.76921e-17
C815	a_828_74##10	VNB	9.99193e-18
C816	VGND#4	a_828_74##5	2.06874e-18
C817	VGND	a_612_74##8	5.9331e-18
C818	VPWR	a_1243_398##2	8.4498e-18
C819	D	D#2	7.00251e-18
C820	VGND	CLK#3	1.33162e-18
C821	VPWR	a_612_74#	9.48673e-18
C822	a_31_74##8	SCE#4	2.71902e-17
C823	a_1243_398##5	VNB	8.13642e-19
C824	VGND	SCD#3	1.5796e-18
C825	VGND#4	Q	2.45513e-17
C826	a_1243_398##7	a_1021_100##2	4.06763e-17
C827	a_1723_48##8	a_2216_94##2	1.87209e-18
C828	a_1021_100##5	VNB	8.59435e-18
C829	VPWR	a_828_74#	9.36699e-18
C830	D	a_31_74##2	5.87282e-17
C831	VPWR#5	a_1529_74##2	9.03886e-19
C832	a_1021_100##5	a_612_74##3	1.01347e-17
C833	VGND	SCE#6	2.66913e-18
C834	a_296_74##3	VNB	1.288e-17
C835	VPWR	a_612_74##7	1.7982e-18
C836	a_296_74##2	VNB	6.71327e-18
C837	VGND	D#3	1.2211e-18
C838	VPWR#3	a_1723_48##10	4.46679e-18
C839	VGND	a_31_74#	4.5305e-19
C840	VPWR	CLK#1	5.15687e-19
C841	SCE#3	D	7.26165e-18
C842	VGND#5	VGND#14	5.38203e-18
C843	CLK#5	VNB	3.74358e-18
C844	VGND	SCE#4	1.57913e-18
C845	VPWR	SCD#1	5.14236e-19
C846	SCD#7	VNB	5.18241e-18
C847	SCD#6	VNB	1.33323e-18
C848	VPWR	a_31_74##3	5.95927e-19
C849	SCD#4	VNB	1.56908e-18
C850	VGND#4	a_1723_48##5	1.21317e-18
C851	a_31_74##7	VNB	3.41026e-17
C852	VPWR	D#1	1.78041e-18
C853	VPWR	SCE#1	8.96479e-19
C854	SCE	SCD#2	3.02385e-19
C855	VPWR	SCE#5	1.00503e-18
C856	Q_N#3	VNB	2.0967e-17
C857	VGND#12	VNB	1.73204e-18
C858	SCE	a_31_74##4	1.85585e-17
C859	a_1021_100##2	VPWR#15	1.34364e-18
C860	VGND#4	a_1021_100#	1.73602e-18
C861	Q#2	VNB	7.45846e-18
C862	a_296_74##6	a_612_74##5	3.34517e-19
C863	VGND#13	VNB	2.70008e-18
C864	a_1723_48##15	VNB	1.7386e-17
C865	SCE	SCE#7	2.75346e-17
C866	a_1529_74##7	VNB	5.22308e-18
C867	a_1021_100##5	a_612_74##6	5.30245e-19
C868	a_1243_398##4	VNB	6.48784e-20
C869	SCE	D#2	4.2648e-17
C870	VPWR	VPWR#8	2.66334e-17
C871	VGND#15	VNB	3.39947e-18
C872	a_1021_100##6	VNB	5.38716e-18
C873	a_296_74#	VNB	1.73221e-17
C874	a_828_74##12	VNB	1.73564e-17
C875	Q#1	VPWR#12	3.51313e-18
C876	VGND#16	VNB	6.27495e-18
C877	a_612_74##14	VNB	9.06889e-18
C878	VGND#17	VNB	4.39883e-18
C879	SCE	SCE#3	3.2734e-20
C880	a_296_74##6	VNB	1.58291e-17
C881	VGND#3	a_1529_74##3	7.7116e-19
C882	VGND#18	VNB	1.5813e-18
C883	a_2216_94##5	a_2216_94#	1.19548e-18
C884	a_31_74##8	VNB	3.82891e-17
C885	VPWR#12	VNB	3.22075e-18
C886	CLK#2	a_612_74##14	1.03031e-17
C887	a_2216_94##7	VNB	1.41292e-17
C888	Q#1	VNB	1.84249e-17
C889	VPWR#13	VNB	1.11283e-17
C890	a_1529_74##6	VNB	5.40235e-18
C891	a_1243_398##7	VNB	1.94536e-18
C892	VPWR	a_1021_100##2	3.52999e-18
C893	a_1021_100##7	VNB	2.36693e-18
C894	a_296_74##5	VNB	1.01379e-17
C895	a_828_74##16	VNB	2.79859e-18
C896	VGND	VGND#8	2.48867e-17
C897	VPWR#16	VNB	4.26068e-18
C898	a_612_74##12	VNB	8.18766e-18
C899	VPWR	a_612_74##2	1.85946e-17
C900	VPWR#5	a_1529_74#	1.3562e-17
C901	a_31_74##7	SCE#3	6.14476e-17
C902	a_1021_100##3	a_612_74##11	8.84336e-18
C903	a_296_74##4	VNB	3.74237e-18
C904	VPWR	a_828_74##2	7.11516e-18
C905	VPWR#18	VNB	2.33704e-18
C906	VPWR	a_612_74##5	2.18015e-18
C907	a_31_74##9	VNB	4.37099e-17
C908	a_2216_94##3	VNB	3.19635e-17
C909	a_1723_48##8	VNB	3.31646e-17
C910	a_1723_48##9	VNB	3.75805e-17
C911	a_1529_74##3	VNB	3.0003e-17
C912	a_1723_48##3	VNB	5.49223e-17
C913	VGND#4	a_828_74##10	1.03768e-17
C914	a_612_74##9	VNB	5.25681e-17
C915	a_828_74##5	VNB	2.62584e-17
C916	VPWR	a_31_74##4	8.13012e-18
C917	Q_N#3	a_2216_94##3	2.63218e-17
C918	a_1021_100#	VNB	3.69831e-17
C919	VGND	a_1021_100##2	2.96661e-18
C920	SCD#2	CLK#2	1.45569e-17
C921	a_1243_398##3	VNB	2.77455e-17
C922	VGND#9	VGND#7	7.3671e-19
C923	a_828_74##4	VNB	2.31359e-17
C924	VGND	a_1243_398#	3.32534e-18
C925	a_612_74##6	VNB	4.79584e-17
C926	VGND#5	a_612_74##10	2.04653e-20
C927	a_612_74##8	VNB	4.12386e-17
C928	VGND	a_828_74##3	2.27444e-20
C929	VPWR	D#2	1.15058e-18
C930	CLK#3	VNB	3.60362e-17
C931	SCD#3	VNB	3.88902e-17
C932	VGND	a_612_74##2	6.39634e-20
C933	VPWR	a_31_74##2	6.7336e-18
C934	SCE#6	VNB	2.27683e-17
C935	a_2216_94##5	a_1723_48##7	3.89316e-19
C936	D#3	VNB	2.97986e-17
C937	VGND	a_828_74##2	1.11227e-18
C938	a_31_74#	VNB	2.93328e-17
C939	VPWR	SCE#3	6.95343e-21
C940	SCE#4	VNB	3.01254e-17
C941	VGND	a_612_74##5	2.4259e-18
C942	a_2216_94#	VNB	4.35415e-17
C943	a_1723_48##4	VNB	4.51529e-17
C944	a_1723_48##10	VNB	4.18197e-17
C945	a_1529_74#	VNB	3.54461e-17
C946	a_1723_48#	VNB	1.99128e-17
C947	VGND	a_31_74##4	4.76692e-18
C948	Q#1	a_2216_94##7	8.05324e-17
C949	a_828_74##8	VNB	3.93163e-17
C950	VGND#5	a_1723_48##3	2.96509e-17
C951	VPWR#13	VPWR#12	1.32536e-18
C952	a_612_74##11	VNB	2.94681e-17
C953	a_1021_100##3	VNB	3.41196e-17
C954	a_1243_398##2	VNB	5.17179e-17
C955	VGND	D#2	1.27553e-18
C956	a_1723_48##2	VPWR#5	3.00235e-17
C957	a_612_74#	VNB	2.56227e-17
C958	a_828_74#	VNB	2.83993e-17
C959	VGND	a_31_74##2	3.13391e-18
C960	a_612_74##7	VNB	3.89678e-17
C961	CLK#1	VNB	4.37011e-17
C962	VGND	SCE#3	6.7228e-18
C963	SCD#1	VNB	2.93178e-17
C964	a_31_74##3	VNB	2.348e-17
C965	D#1	VNB	2.91282e-17
C966	a_828_74##10	a_1243_398##4	2.7447e-17
C967	SCE#1	VNB	3.65164e-17
C968	SCE#5	VNB	2.92657e-17
C969	VPWR#4	VNB	2.79347e-16
C970	VGND#4	VNB	2.84735e-16
C971	a_296_74#	a_828_74##16	3.07424e-17
C972	VPWR#8	VNB	1.46293e-17
C973	VGND#17	SCD#2	8.02077e-19
C974	VGND#8	VNB	1.47867e-17
C975	a_2216_94##2	VNB	3.85101e-17
C976	a_1723_48##7	VNB	9.05555e-17
C977	a_1529_74##2	VNB	6.17861e-17
C978	a_1723_48##2	VNB	5.68846e-17
C979	a_828_74##7	VNB	5.47355e-17
C980	a_612_74##10	VNB	5.75367e-17
C981	a_828_74##6	VNB	3.38149e-17
C982	a_1021_100##2	VNB	6.77062e-17
C983	a_1529_74##2	a_1723_48##9	2.0325e-18
C984	a_1243_398#	VNB	5.76689e-17
C985	a_828_74##3	VNB	3.49633e-17
C986	SCE	D	1.99586e-17
C987	VPWR#6	a_1723_48#	2.32704e-19
C988	a_2216_94##3	VGND#12	1.8596e-17
C989	a_612_74##2	VNB	6.06996e-17
C990	a_828_74##2	VNB	4.80562e-17
C991	a_612_74##5	VNB	3.90242e-17
C992	SCD#2	VNB	6.04476e-17
C993	a_31_74##4	VNB	2.75455e-17
C994	SCE#7	VNB	4.34208e-17
C995	D#2	VNB	6.27238e-17
C996	a_31_74##2	VNB	5.99679e-17
C997	a_1243_398##2	a_1021_100##3	2.7929e-17
C998	SCE#3	VNB	6.97603e-17
C999	a_2216_94##5	a_1723_48##4	5.23073e-18
C1000	VPWR	D	1.4631e-18
C1001	a_31_74##8	a_31_74##7	2.98945e-18
C1002	VPWR	CLK	1.75723e-18
C1003	VGND	D	1.4313e-18
C1004	VGND	CLK	1.59412e-18
C1005	SCD#7	SCE#1	5.77475e-19
C1006	Q_N#3	a_1723_48##8	1.35055e-18
C1007	VGND	SCE	1.27291e-17
C1008	a_296_74##6	SCD#2	1.41234e-17
C1009	D	VNB	9.39124e-19
C1010	CLK	VNB	2.99736e-18
C1011	SCE	VNB	1.15646e-17
C1012	VGND#6	a_828_74##6	3.83966e-17
C1013	Q_N	VNB	9.80254e-17
C1014	Q	VNB	4.91911e-18
C1015	VPWR#5	a_1723_48#	2.53831e-17
C1016	VPWR	VNB	2.94767e-16
C1017	a_2216_94#	Q_N#1	1.16814e-17
C1018	VGND	VNB	3.01235e-16
C1019	VPWR#4	VPWR#2	1.18024e-16
C1020	VGND#2	VNB	6.42939e-17
C1021	VGND#10	D#2	6.28403e-20
C1022	a_31_74##9	VPWR#10	2.65523e-17
C1023	VGND#2	a_1529_74##3	1.58531e-19
C1024	VPWR#2	a_2216_94#	8.4613e-18
C1025	VGND#10	CLK#3	2.85458e-20
C1026	VPWR#10	SCE#7	3.98794e-20
C1027	VGND#10	D#3	8.2764e-18
C1028	a_31_74##2	VPWR#10	1.58574e-18
C1029	VGND#2	a_2216_94##5	2.82724e-19
C1030	VGND#2	a_1723_48##8	3.13101e-18
C1031	VGND#2	a_1723_48##7	2.76342e-19
C1032	VPWR#10	VPWR#9	2.42048e-19
C1033	a_2216_94##7	VPWR#2	1.02858e-17
C1034	VGND#2	Q	1.50256e-18
C1035	VGND#10	SCE	2.52123e-18
C1036	VGND#10	VNB	6.67304e-17
C1037	VPWR#2	a_1723_48##5	9.26064e-19
C1038	VPWR#2	a_1723_48##10	6.44126e-19
C1039	VGND#2	a_1723_48##5	5.71233e-19
C1040	VGND#3	VGND#2	5.63075e-19
C1041	VGND#10	VGND#9	3.32472e-20
C1042	VPWR	VPWR#10	1.16574e-16
C1043	VGND#4	VGND#2	1.28871e-16
C1044	VPWR#10	SCE#1	4.05997e-18
C1045	a_2216_94##2	VPWR#2	2.90636e-19
C1046	VGND#10	SCD#3	1.56795e-20
C1047	VPWR#13	VPWR#2	2.39925e-20
C1048	VGND#10	a_31_74#	6.67532e-18
C1049	a_296_74##4	VPWR#10	1.1435e-17
C1050	VGND	VGND#10	1.36203e-16
C1051	Q_N	VPWR#2	2.08958e-17
C1052	a_2216_94##5	VPWR#2	2.82445e-19
C1053	a_31_74##4	VPWR#10	1.08946e-18
C1054	VGND#2	a_1723_48##9	9.06778e-19
C1055	VPWR#10	D#2	1.80397e-19
C1056	VPWR#10	SCE#3	6.9064e-20
C1057	VPWR#2	VNB	5.80193e-17
C1058	VPWR#10	SCE#2	4.25768e-19
C1059	VGND#13	VGND#2	6.02764e-19
C1060	VPWR#2	a_1723_48##4	3.08111e-18
C1061	VGND#2	a_2216_94##3	9.57365e-18
C1062	VGND#10	SCE#7	2.79649e-19
C1063	VGND#2	a_2216_94##2	6.6585e-19
C1064	VGND#10	SCE#3	1.58854e-18
C1065	VGND#2	Q_N	2.13939e-17
C1066	VGND#10	SCE#6	2.61903e-19
C1067	VGND#2	a_2216_94##6	7.1778e-18
C1068	VGND#10	SCE#4	6.75875e-18
C1069	VGND#10	a_296_74##6	1.37756e-17
C1070	VPWR#3	VPWR#2	4.60988e-19
C1071	VGND#10	a_31_74##8	2.31249e-17
C1072	VPWR#10	D#1	7.55692e-18
C1073	VPWR#10	VNB	6.55106e-17
C1074	VPWR#10	SCE#5	3.29105e-18
C1075	VGND#10	SCE#1	1.10162e-19
*
*
.ENDS sky130_fd_sc_hs__sdfxbp_1
*
