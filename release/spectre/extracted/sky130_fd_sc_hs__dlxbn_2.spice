* Extracted by Quantus, converted by sky130cad/quantus.py
*
*
*
*                       LINUX           Wed Nov 18 08:33:12 2026
*
*
*
*  PROGRAM  advgen
*
*  Name           : advgen - Quantus - (64-bit)
*  Version        : 25.1.0-p047
*  Build Date     : Thu Dec 11 23:20:30 PST 2025
*
*  HSPICE LIBRARY
*
*  OPERATING_TEMPERATURE 150
*  QRC_TECH_DIR <path>/tech
*
*
*

*
.SUBCKT sky130_fd_sc_hs__dlxbn_2 VPB VNB VGND VPWR Q Q_N D GATE_N
*
*
*  caps2d version: 10
*
*
*       TRANSISTOR CARDS
*
*
XM3 a_27_136##5 D#3 VGND#15 VNB sky130_fd_pr__nfet_01v8_lvt l=0.15 w=0.55 ad=0.15675 as=0.40125 pd=1.67 ps=2.98
XM0 VGND#15 GATE_N#3 a_232_98##11 VNB sky130_fd_pr__nfet_01v8_lvt l=0.15 w=0.74 ad=0.40125 as=0.2109 pd=2.98 ps=2.05
XM16 a_343_74##8 a_232_98##4 VGND#14 VNB sky130_fd_pr__nfet_01v8_lvt l=0.15 w=0.74 ad=0.2817 as=0.38595 pd=2.29 ps=2.79
XM1 VGND#14 a_27_136# a_569_79# VNB sky130_fd_pr__nfet_01v8_lvt l=0.15 w=0.64 ad=0.38595 as=0.1536 pd=2.79 ps=1.76
XM25 a_569_79# a_232_98##7 a_647_79##7 VNB sky130_fd_pr__nfet_01v8_lvt l=0.15 w=0.64 ad=0.1536 as=0.3952 pd=1.76 ps=2.9
XM21 a_647_79##7 a_343_74##3 a_839_123# VNB sky130_fd_pr__nfet_01v8_lvt l=0.15 w=0.42 ad=0.3952 as=0.1302 pd=2.9 ps=1.46
XM17 a_839_123# a_887_270# VGND#13 VNB sky130_fd_pr__nfet_01v8_lvt l=0.15 w=0.42 ad=0.1302 as=0.2501 pd=1.46 ps=2.29
XM2 VGND#13 a_647_79##3 a_887_270##18 VNB sky130_fd_pr__nfet_01v8_lvt l=0.15 w=0.74 ad=0.2501 as=0.2109 pd=2.29 ps=2.05
XM11 Q#2 a_887_270##8 VGND#12 VNB sky130_fd_pr__nfet_01v8_lvt l=0.15 w=0.74 ad=0.2072 as=0.2109 pd=2.04 ps=2.05
XM19 VGND#11 a_887_270##10 Q#2 VNB sky130_fd_pr__nfet_01v8_lvt l=0.15 w=0.74 ad=0.3107 as=0.2072 pd=2.34 ps=2.04
XM14 VGND#11 a_887_270##9 a_1442_94##10 VNB sky130_fd_pr__nfet_01v8_lvt l=0.15 w=0.64 ad=0.3107 as=0.1824 pd=2.34 ps=1.85
XM12 VGND#10 a_1442_94##6 Q_N#3 VNB sky130_fd_pr__nfet_01v8_lvt l=0.15 w=0.74 ad=0.2627 as=0.2072 pd=2.19 ps=2.04
XM18 Q_N#3 a_1442_94# VGND#1 VNB sky130_fd_pr__nfet_01v8_lvt l=0.15 w=0.74 ad=0.2072 as=0.2109 pd=2.04 ps=2.05
XM5 a_27_136##7 D#1 VPWR#15 VPB sky130_fd_pr__pfet_01v8 l=0.15 w=0.84 ad=0.3192 as=0.294 pd=2.44 ps=2.38
XM15 VPWR#15 GATE_N#1 a_232_98##12 VPB sky130_fd_pr__pfet_01v8 l=0.15 w=0.84 ad=0.294 as=0.2478 pd=2.38 ps=2.27
XM20 a_343_74##9 a_232_98# VPWR#14 VPB sky130_fd_pr__pfet_01v8 l=0.15 w=0.84 ad=0.2478 as=0.3706 pd=2.27 ps=2.77
XM8 VPWR#14 a_27_136##3 a_565_392# VPB sky130_fd_pr__pfet_01v8 l=0.15 w=1 ad=0.3706 as=0.27 pd=2.77 ps=2.54
XM10 a_565_392# a_343_74# a_647_79##6 VPB sky130_fd_pr__pfet_01v8 l=0.15 w=1 ad=0.27 as=0.4372 pd=2.54 ps=3.35
XM6 a_647_79##6 a_232_98##5 a_814_392# VPB sky130_fd_pr__pfet_01v8 l=0.15 w=0.42 ad=0.4372 as=0.1596 pd=3.35 ps=1.6
XM23 a_814_392# a_887_270##3 VPWR#13 VPB sky130_fd_pr__pfet_01v8 l=0.15 w=0.42 ad=0.1596 as=0.4946 pd=1.6 ps=3.27
XM7 VPWR#13 a_647_79# a_887_270##14 VPB sky130_fd_pr__pfet_01v8 l=0.15 w=1.12 ad=0.4946 as=0.3304 pd=3.27 ps=2.83
XM9 VPWR#12 a_887_270##12 Q#1 VPB sky130_fd_pr__pfet_01v8 l=0.15 w=1.12 ad=0.3304 as=0.336 pd=2.83 ps=2.84
XM22 Q#1 a_887_270##11 VPWR#11 VPB sky130_fd_pr__pfet_01v8 l=0.15 w=1.12 ad=0.336 as=0.3868 pd=2.84 ps=2.95
XM4 VPWR#11 a_887_270##4 a_1442_94##11 VPB sky130_fd_pr__pfet_01v8 l=0.15 w=1 ad=0.3868 as=0.295 pd=2.95 ps=2.59
XM13 Q_N#1 a_1442_94##7 VPWR#10 VPB sky130_fd_pr__pfet_01v8 l=0.15 w=1.12 ad=0.336 as=0.3304 pd=2.84 ps=2.83
XM24 VPWR#1 a_1442_94##5 Q_N#1 VPB sky130_fd_pr__pfet_01v8 l=0.15 w=1.12 ad=0.3304 as=0.336 pd=2.83 ps=2.84
*
*
*       RESISTOR AND CAP/DIODE CARDS
*
Rg1	D#1	D#2	433.951355
Rg2	D#2	D#3	416.201172
Rg3	GATE_N#1	GATE_N#2	354.298584
Rg4	GATE_N#2	GATE_N#3	474.357666
Rg5	a_232_98#	a_232_98##2	578.064880
Rg6	a_232_98##2	a_232_98##3	335.796265
Rg7	a_232_98##2	a_232_98##4	338.290710
Rg8	a_27_136#	a_27_136##2	322.284241
Rg9	a_27_136##2	a_27_136##3	509.830780
Rg10	a_343_74#	a_343_74##2	560.440308
Rg11	a_232_98##5	a_232_98##6	251.325607
Rg12	a_232_98##6	a_232_98##7	713.346680
Rg13	a_343_74##3	a_343_74##4	239.895844
Rg14	a_887_270#	a_887_270##2	345.222107
Rg15	a_887_270##2	a_887_270##3	302.620300
Rg16	a_647_79#	a_647_79##2	500.238068
Rg17	a_647_79##2	a_647_79##3	320.356293
Rg18	a_887_270##4	a_887_270##5	490.602417
Rg19	a_887_270##5	a_887_270##6	83.680893
Rg20	a_887_270##6	a_887_270##7	76.127350
Rg21	a_887_270##7	a_887_270##8	384.320526
Rg22	a_887_270##5	a_887_270##9	340.937500
Rg23	a_887_270##6	a_887_270##10	355.595795
Rg24	a_887_270##6	a_887_270##11	458.595978
Rg25	a_887_270##7	a_887_270##12	474.928162
Rg26	a_1442_94#	a_1442_94##2	432.813019
Rg27	a_1442_94##2	a_1442_94##3	67.305496
Rg28	a_1442_94##3	a_1442_94##4	63.334919
Rg29	a_1442_94##2	a_1442_94##5	517.673706
Rg30	a_1442_94##3	a_1442_94##6	377.589386
Rg31	a_1442_94##3	a_1442_94##7	461.355103
Rf1	D#2	D#5	161.104004
Rf2	D#6	D	0.871202
Rf3	D#5	D#6	4.527236
Rf4	GATE_N#2	GATE_N#5	160.956345
Rf5	GATE_N#6	GATE_N	0.723540
Rf6	GATE_N#5	GATE_N#6	9.448145
Rf7	a_27_136##2	a_27_136##6	361.601929
Rf8	a_27_136##6	a_27_136##7	103.690727
Rf9	a_27_136##5	a_27_136##6	15.000000
Rf10	a_343_74##4	a_343_74##2	202.898590
Rf11	a_343_74##2	a_343_74##7	72.571449
Rf12	a_343_74##7	a_343_74##8	85.841713
Rf13	a_343_74##7	a_343_74##9	28.523926
Rf14	a_232_98##6	a_232_98##9	405.326111
Rf15	a_232_98##9	a_232_98##3	67.883842
Rf16	a_232_98##3	a_232_98##11	42.784138
Rf17	a_232_98##9	a_232_98##12	21.415131
Rf18	a_647_79##2	a_647_79##5	248.955658
Rf19	a_647_79##5	a_647_79##6	81.158821
Rf20	a_647_79##5	a_647_79##7	14.389237
Rf21	Q#1	Q	44.873566
Rf22	Q	Q#2	43.788166
Rf23	a_887_270##6	a_887_270##15	243.201416
Rf24	a_887_270##15	a_887_270##16	20.091120
Rf25	a_887_270##16	a_887_270##2	215.884735
Rf26	a_887_270##16	a_887_270##18	96.333954
Rf27	a_887_270##14	a_887_270##15	5.000000
Rf28	a_1442_94##4	a_1442_94##9	91.958214
Rf29	a_1442_94##9	a_1442_94##10	35.569908
Rf30	a_1442_94##9	a_1442_94##11	43.384880
Rf31	Q_N	Q_N#2	0.196836
Rf32	Q_N#2	Q_N	14.369054
Rf33	Q_N	Q_N#3	87.765038
Rf34	Q_N#1	Q_N#2	5.000000
Rf35	VPWR#1	VPWR#2	117.837311
Rf36	VPWR#2	VPWR#3	77.372467
Rf37	VPWR#3	VPWR#4	62.831711
Rf38	VPWR#4	VPWR#5	83.251938
Rf39	VPWR#5	VPWR#6	110.613060
Rf40	VPWR#6	VPWR#7	60.972630
Rf41	VPWR#7	VPWR#8	124.867279
Rf43	VPWR#2	VPWR#10	52.877037
Rf44	VPWR#3	VPWR#11	33.326477
Rf45	VPWR#4	VPWR#12	38.817978
Rf46	VPWR#5	VPWR#13	29.010410
Rf47	VPWR#7	VPWR#14	31.948624
Rf48	VPWR#8	VPWR#15	32.518913
Rf49	VGND#1	VGND#2	97.988571
Rf50	VGND#2	VGND#3	80.148392
Rf51	VGND#3	VGND#4	65.023224
Rf52	VGND#4	VGND#5	82.346458
Rf53	VGND#5	VGND#6	106.785561
Rf54	VGND#6	VGND#7	65.524803
Rf55	VGND#7	VGND#8	122.114403
Rf57	VGND#2	VGND#10	36.804161
Rf58	VGND#3	VGND#11	33.306259
Rf59	VGND#4	VGND#12	37.027283
Rf60	VGND#5	VGND#13	37.955051
Rf61	VGND#7	VGND#14	23.832428
Rf62	VGND#8	VGND#15	24.468842
Re1	VPWR#2	VPWR	3.246228
Re2	VPWR	VPWR#6	1.159367
Re3	VGND#2	VGND	3.246228
Re4	VGND	VGND#6	1.159367
*
*       CAPACITOR CARDS
*
*
C1	a_887_270##18	VGND#12	4.02869e-17
C2	VGND#2	a_1442_94##9	7.70273e-18
C3	VPWR#1	a_1442_94##5	3.14268e-17
C4	VGND#13	a_887_270##18	4.04537e-17
C5	a_1442_94##6	a_1442_94#	3.98737e-17
C6	VGND#4	a_1442_94##6	2.39415e-20
C7	Q_N#1	a_1442_94##5	3.52736e-17
C8	a_647_79##6	a_232_98##7	1.1819e-18
C9	VGND#3	a_887_270##6	4.61896e-19
C10	VPWR#1	a_1442_94##7	1.26838e-18
C11	a_27_136##5	D#5	3.35413e-17
C12	VGND#3	a_1442_94##10	7.05608e-18
C13	VPWR#10	a_1442_94##5	7.14071e-19
C14	a_647_79##5	a_647_79##6	3.78755e-18
C15	VGND#4	VGND#11	6.26714e-20
C16	Q_N#1	a_1442_94##7	3.42312e-17
C17	a_887_270##9	a_1442_94##6	4.62171e-18
C18	VGND#5	a_647_79##2	8.83266e-19
C19	VPWR#1	a_887_270##4	1.20795e-19
C20	VPWR#10	a_1442_94##7	2.21061e-17
C21	a_887_270##10	a_1442_94##6	1.76981e-19
C22	a_1442_94##3	a_1442_94##2	3.3905e-18
C23	VGND#3	a_887_270##9	3.71946e-18
C24	a_1442_94##11	a_1442_94##7	1.81312e-18
C25	VPWR#4	a_887_270##6	6.23953e-20
C26	a_1442_94##9	a_1442_94##4	2.56547e-17
C27	VGND#4	Q#2	7.87378e-18
C28	VPWR#10	a_887_270##4	2.82439e-18
C29	VGND#1	VPWR#1	1.3848e-17
C30	a_1442_94##3	Q_N#1	1.22005e-19
C31	a_887_270##6	VPWR#3	8.05597e-19
C32	a_887_270##10	a_887_270##9	2.13283e-17
C33	VPWR#11	a_1442_94##7	4.56777e-19
C34	VGND#4	a_887_270##10	6.52023e-19
C35	VGND#5	a_887_270##2	1.03314e-19
C36	VGND#5	VGND#12	2.08048e-18
C37	a_1442_94##11	a_887_270##4	6.94029e-17
C38	VPWR#10	a_887_270##11	1.66032e-19
C39	a_1442_94##2	Q_N#1	1.50472e-19
C40	VGND#3	a_887_270##10	4.71382e-18
C41	VGND#3	Q#2	6.5678e-18
C42	a_887_270##4	VPWR#11	1.89102e-17
C43	VGND#5	a_887_270##8	6.65027e-19
C44	a_887_270##6	a_1442_94##9	3.23662e-17
C45	a_1442_94##9	a_1442_94##3	1.48094e-17
C46	a_1442_94##11	a_887_270##11	2.96338e-18
C47	a_887_270##8	a_887_270##10	3.82923e-17
C48	Q#1	a_887_270##4	8.54931e-19
C49	VGND#4	a_887_270##8	4.93917e-18
C50	VGND#5	a_887_270##18	1.61415e-17
C51	VPWR#11	a_887_270##11	4.01799e-17
C52	a_887_270##2	VPWR#5	8.21469e-19
C53	a_1442_94##11	a_887_270##12	2.17441e-19
C54	a_343_74##7	a_647_79##6	4.75129e-18
C55	Q#1	a_887_270##11	3.76218e-17
C56	VGND#5	a_647_79##3	1.03465e-17
C57	a_887_270##14	a_887_270##4	2.82282e-19
C58	a_1442_94##9	a_1442_94##2	1.81373e-19
C59	a_647_79##3	a_887_270##8	4.56323e-18
C60	VPWR#11	a_887_270##12	3.58994e-18
C61	VGND#4	a_887_270##18	1.2613e-17
C62	VGND#7	a_343_74##4	1.1262e-17
C63	VPWR#12	a_887_270##11	2.77594e-18
C64	a_1442_94##11	a_647_79#	1.42914e-19
C65	VGND#4	a_647_79##3	6.64716e-19
C66	VGND#5	a_343_74##4	3.53704e-17
C67	Q#1	a_887_270##12	3.76067e-17
C68	VGND#5	VGND#13	9.07027e-20
C69	a_647_79##2	a_887_270##16	5.84986e-17
C70	a_887_270##14	a_887_270##11	4.63807e-19
C71	VGND#4	a_343_74##4	1.65631e-19
C72	a_232_98##6	VPWR#5	4.71023e-18
C73	VPWR#12	a_887_270##12	4.52658e-17
C74	VGND#5	a_887_270#	2.21295e-18
C75	a_887_270##5	a_1442_94##3	3.74378e-19
C76	a_887_270#	a_647_79##3	1.87563e-17
C77	a_1442_94##9	a_887_270##7	2.57273e-20
C78	VGND#2	VGND#1	6.28586e-17
C79	a_887_270##14	a_887_270##12	1.50215e-17
C80	a_647_79##5	a_647_79##2	1.33842e-18
C81	VGND#7	a_343_74##2	4.71154e-19
C82	VGND#2	Q_N#3	3.12973e-17
C83	VPWR#12	a_647_79#	1.27656e-18
C84	a_887_270##2	a_887_270##16	2.52401e-18
C85	VPWR#13	a_887_270##12	8.6548e-19
C86	VGND#2	VGND#10	2.21271e-17
C87	a_1442_94##9	Q_N#3	2.12216e-17
C88	a_887_270##14	a_647_79#	6.81336e-17
C89	VGND#2	a_1442_94##10	2.47593e-17
C90	a_343_74##3	a_887_270#	2.33142e-17
C91	a_1442_94##9	a_887_270##5	1.33436e-17
C92	a_647_79#	VPWR#13	3.66322e-17
C93	a_647_79##5	a_887_270##2	1.57921e-17
C94	VGND#2	VGND#11	2.13166e-17
C95	VGND#7	a_27_136##2	5.72637e-17
C96	a_887_270##14	a_887_270##3	2.13544e-19
C97	a_343_74##7	a_343_74##9	1.98302e-18
C98	a_232_98##6	a_887_270##16	1.77587e-18
C99	a_1442_94##9	VGND#10	4.11298e-17
C100	VGND#7	a_232_98##7	1.74631e-18
C101	a_887_270##3	VPWR#13	2.06172e-17
C102	a_232_98##7	a_343_74##3	2.59524e-18
C103	a_887_270##14	a_232_98##5	7.17174e-21
C104	a_647_79##5	a_232_98##6	7.98962e-17
C105	a_232_98##12	a_343_74##7	7.77997e-17
C106	VPWR#13	a_232_98##5	2.23732e-18
C107	VGND#7	a_232_98##3	3.43111e-19
C108	a_647_79##6	a_887_270##3	4.40415e-19
C109	Q_N#3	a_1442_94##3	4.48393e-18
C110	a_887_270##14	a_343_74#	2.201e-19
C111	VGND#7	a_27_136#	1.12307e-17
C112	VPWR#2	a_1442_94##3	3.69243e-20
C113	a_27_136#	a_232_98##7	4.36895e-17
C114	VGND#11	VPWR#11	8.37005e-19
C115	VPWR#5	VPWR#4	3.83493e-19
C116	VPWR#13	a_343_74#	3.24578e-18
C117	VGND#10	a_1442_94##4	6.87708e-18
C118	a_647_79##6	a_232_98##5	2.39537e-17
C119	a_343_74##4	a_647_79##5	7.12921e-17
C120	VGND#7	VGND#14	9.84617e-18
C121	VPWR#2	a_1442_94##2	4.55399e-20
C122	a_1442_94##4	a_1442_94##10	1.03974e-19
C123	Q_N#3	a_1442_94##2	7.51133e-18
C124	VPWR#13	a_27_136##3	9.68919e-19
C125	VPWR#7	a_232_98##3	2.64727e-19
C126	a_232_98##11	a_343_74##8	1.56058e-17
C127	a_647_79##6	a_343_74#	3.78883e-17
C128	VPWR#2	a_887_270##5	1.20178e-19
C129	a_232_98##4	a_27_136#	1.87959e-17
C130	VGND#7	a_232_98##4	1.47159e-17
C131	a_887_270##5	VPWR#11	9.52102e-19
C132	a_343_74##2	a_647_79##5	5.98036e-17
C133	a_1442_94##10	a_887_270##6	1.54798e-19
C134	Q#2	Q#1	2.99215e-18
C135	VPWR#2	VPWR#1	5.44141e-17
C136	a_647_79##6	a_27_136##3	2.1662e-18
C137	VGND#10	a_1442_94##3	5.78174e-19
C138	a_887_270##6	VGND#11	4.72268e-17
C139	VPWR#14	a_343_74#	5.55809e-18
C140	VGND#2	a_1442_94##3	7.33949e-19
C141	a_887_270##6	Q#2	2.9574e-17
C142	GATE_N#3	a_232_98##4	5.0407e-18
C143	VGND#2	a_1442_94##2	1.01039e-19
C144	a_647_79##6	a_232_98#	1.12769e-18
C145	VGND#2	VPWR#1	4.93889e-18
C146	VPWR#14	a_27_136##3	4.17757e-17
C147	VGND#7	GATE_N#3	1.06948e-18
C148	a_647_79##5	a_27_136##2	4.65265e-19
C149	VPWR#4	VPWR#3	1.53449e-18
C150	Q_N#3	a_887_270##5	1.47054e-19
C151	a_232_98##12	a_343_74#	1.6499e-17
C152	a_887_270##16	a_887_270##7	2.93411e-18
C153	Q#1	a_887_270##7	5.48154e-19
C154	a_343_74##7	a_343_74##2	2.14405e-18
C155	a_1442_94##11	VPWR#2	2.79825e-17
C156	VGND#2	a_887_270##5	6.32063e-19
C157	VPWR#2	VPWR#11	1.69497e-17
C158	a_232_98#	VPWR#14	2.85233e-17
C159	D#3	GATE_N#3	2.0006e-17
C160	a_232_98##12	a_27_136##3	2.80466e-17
C161	a_27_136##5	a_232_98##11	5.23464e-17
C162	a_232_98#	a_343_74##9	1.38328e-17
C163	a_647_79##2	a_887_270##18	4.81533e-17
C164	VPWR#15	a_27_136##3	5.00016e-19
C165	a_27_136##2	a_343_74##7	2.99703e-17
C166	a_1442_94##10	a_1442_94##3	9.09449e-20
C167	VPWR#14	GATE_N#1	2.34347e-18
C168	a_647_79##2	VGND#13	4.2667e-17
C169	a_232_98##12	a_232_98#	1.7889e-17
C170	a_647_79##5	a_887_270##8	5.75605e-20
C171	VGND#12	a_887_270##14	2.04947e-18
C172	a_27_136##5	VGND#15	5.77268e-18
C173	VPWR#14	D#1	3.73453e-19
C174	a_232_98##12	GATE_N#1	5.30153e-17
C175	a_1442_94##10	a_1442_94##2	3.67686e-20
C176	a_27_136##7	a_232_98#	2.67111e-19
C177	VGND#13	a_887_270##2	7.81914e-19
C178	a_232_98##3	a_343_74##7	5.63058e-17
C179	GATE_N#1	VPWR#15	2.2831e-17
C180	a_647_79##5	a_647_79##3	1.03615e-19
C181	a_232_98##12	D#1	2.39824e-18
C182	a_27_136##7	GATE_N#1	1.16963e-18
C183	VPWR#10	a_1442_94##4	8.25825e-18
C184	VGND#7	a_27_136##5	1.34166e-18
C185	VPWR#15	D#1	4.54681e-17
C186	a_1442_94##10	a_887_270##7	3.49157e-20
C187	VGND#5	a_647_79##5	2.22065e-18
C188	a_343_74##7	GATE_N#2	1.72243e-18
C189	a_27_136##7	D#1	2.20053e-17
C190	VGND#12	a_343_74##4	2.12886e-19
C191	a_1442_94##7	a_1442_94##5	4.70606e-17
C192	a_232_98##6	a_647_79##7	2.55967e-19
C193	a_647_79##5	a_887_270#	1.26799e-17
C194	a_887_270##18	a_343_74##4	1.71306e-19
C195	a_343_74##4	VGND#13	1.11886e-17
C196	a_1442_94##10	a_887_270##5	5.38451e-19
C197	a_887_270##6	a_1442_94##11	3.78617e-17
C198	a_887_270##14	a_887_270##7	1.18529e-19
C199	a_887_270##6	VPWR#11	4.05526e-17
C200	D#5	VPWR#15	1.12313e-18
C201	a_343_74##4	a_647_79##7	1.54678e-18
C202	a_887_270##4	a_1442_94##7	6.65243e-18
C203	a_887_270##6	Q#1	6.34357e-17
C204	a_887_270##18	a_887_270##16	2.81814e-18
C205	a_647_79##5	a_343_74##3	2.63601e-17
C206	Q_N#1	VPWR#1	3.27905e-17
C207	a_887_270##14	a_887_270##6	1.82191e-18
C208	a_343_74##4	a_343_74##8	2.3715e-19
C209	a_232_98##12	VPWR#6	2.30451e-18
C210	a_27_136##7	D#5	7.05036e-18
C211	a_887_270##11	a_887_270##4	3.9443e-17
C212	VGND#2	a_1442_94#	3.84523e-18
C213	VPWR#10	VPWR#1	2.00319e-18
C214	a_647_79##5	a_232_98##7	1.31307e-17
C215	VGND#11	a_887_270##5	3.31118e-18
C216	VGND#2	a_1442_94##6	7.79579e-18
C217	GATE_N#3	a_232_98##2	8.43221e-20
C218	VPWR#13	a_647_79##2	7.52934e-19
C219	a_887_270##16	VPWR#5	1.20253e-19
C220	VGND#2	a_887_270##9	9.57682e-18
C221	a_887_270##5	a_1442_94##4	2.63771e-17
C222	a_887_270##12	a_887_270##11	5.0316e-17
C223	VPWR#10	Q_N#1	3.28374e-17
C224	D#5	D#2	1.09215e-17
C225	a_27_136##2	VGND#14	6.11495e-18
C226	a_27_136##2	a_343_74##8	7.5176e-17
C227	a_887_270##2	VPWR#13	3.27664e-17
C228	VGND#1	a_1442_94#	4.79938e-17
C229	Q#2	a_887_270##7	2.70593e-18
C230	a_647_79#	a_887_270##12	5.62563e-18
C231	a_647_79##5	a_887_270##18	4.05809e-19
C232	a_232_98##6	a_887_270##14	6.63878e-20
C233	a_27_136##2	VGND#15	2.5026e-20
C234	a_647_79##6	a_887_270##2	2.39861e-21
C235	Q_N#3	a_1442_94#	1.49942e-17
C236	a_232_98##6	VPWR#13	2.76539e-17
C237	a_232_98##3	a_343_74##8	3.46039e-17
C238	VGND#1	a_1442_94##6	3.6074e-18
C239	a_1442_94##11	VPWR#10	8.23768e-17
C240	a_887_270##6	a_887_270##7	1.19425e-17
C241	a_887_270##3	a_647_79#	1.41062e-17
C242	a_232_98##6	a_647_79##6	1.16429e-16
C243	VGND#10	a_1442_94#	1.35782e-18
C244	a_887_270##6	a_887_270##5	1.12682e-17
C245	a_27_136##5	a_232_98##3	9.32978e-18
C246	a_647_79##5	VGND#13	5.35903e-18
C247	Q_N#3	a_1442_94##6	3.67001e-17
C248	a_232_98##6	VPWR#14	4.50392e-20
C249	VPWR#11	VPWR#10	2.22401e-18
C250	a_232_98##11	GATE_N#2	2.78549e-17
C251	a_1442_94##10	a_1442_94#	6.91087e-20
C252	a_647_79##6	a_343_74##4	8.11107e-20
C253	VGND#1	a_887_270##9	1.11095e-19
C254	VPWR#6	a_232_98##7	7.79122e-20
C255	a_232_98##5	a_887_270##3	1.59935e-17
C256	a_343_74#	a_647_79#	5.34371e-19
C257	a_1442_94##6	VGND#10	2.01434e-17
C258	a_27_136##5	GATE_N#2	4.34408e-18
C259	VGND#6	a_232_98##7	4.26763e-18
C260	Q_N#3	a_887_270##9	3.2168e-20
C261	VPWR#11	a_1442_94##11	4.19248e-17
C262	a_343_74##2	a_647_79##6	4.89125e-17
C263	a_232_98##11	D#2	2.848e-18
C264	a_1442_94##9	a_1442_94##5	3.0381e-19
C265	a_1442_94##10	a_1442_94##6	1.22266e-18
C266	a_343_74#	a_232_98##5	5.56145e-18
C267	VGND#1	a_887_270##10	1.65254e-19
C268	VPWR#2	a_1442_94##5	7.85165e-18
C269	a_647_79##2	a_887_270##8	5.29556e-19
C270	a_647_79##2	a_887_270##7	6.15255e-18
C271	a_27_136##5	D#2	1.02386e-17
C272	VGND#10	a_887_270##9	3.21797e-18
C273	a_647_79##5	a_839_123#	2.39687e-18
C274	a_647_79##2	a_647_79##3	8.60835e-18
C275	VPWR#2	a_1442_94##7	1.17638e-17
C276	VGND#11	a_1442_94##6	6.811e-19
C277	a_647_79##2	a_887_270#	8.75675e-18
C278	a_343_74##2	a_232_98##12	1.86011e-17
C279	VPWR#2	a_887_270##4	6.21679e-18
C280	a_27_136##3	a_343_74#	5.34536e-17
C281	VPWR#3	a_887_270##4	4.11026e-18
C282	a_1442_94##10	a_887_270##9	4.49521e-17
C283	a_647_79##5	a_647_79##7	6.53446e-18
C284	VPWR#14	a_27_136##2	3.67939e-19
C285	a_1442_94##9	a_1442_94##7	1.05553e-18
C286	VPWR#2	a_887_270##11	8.6509e-20
C287	a_887_270##18	a_887_270##7	2.63641e-19
C288	VGND#10	a_887_270##10	5.97012e-19
C289	D	a_232_98##2	8.73895e-20
C290	a_232_98##12	a_27_136##2	1.22976e-18
C291	a_887_270##9	VGND#11	2.15565e-17
C292	a_232_98#	a_27_136##3	3.65438e-17
C293	VPWR#4	a_887_270##11	7.02443e-19
C294	VGND#12	a_1442_94##6	9.13729e-20
C295	a_1442_94##10	a_887_270##10	5.45868e-19
C296	a_232_98##6	a_887_270#	1.96347e-19
C297	VPWR#12	VPWR#11	1.37013e-17
C298	a_887_270##14	a_1442_94##11	1.08863e-18
C299	GATE_N#1	a_27_136##3	3.28578e-19
C300	a_232_98##3	a_232_98##12	3.71877e-18
C301	VPWR#3	a_887_270##11	4.0129e-18
C302	a_232_98##6	a_343_74##3	1.83151e-17
C303	a_343_74##4	a_647_79##3	3.34479e-18
C304	a_887_270##2	a_887_270##7	1.02557e-19
C305	a_232_98##6	a_232_98##7	2.29433e-19
C306	a_343_74##4	a_887_270#	1.16399e-17
C307	GATE_N#1	a_232_98#	3.62582e-18
C308	a_887_270##10	VGND#11	2.77063e-17
C309	a_343_74##4	a_343_74##3	7.47584e-19
C310	VGND#12	a_887_270##9	1.97368e-19
C311	GATE_N#2	a_232_98##12	2.79968e-18
C312	a_1442_94##10	a_887_270##8	1.23124e-19
C313	VPWR#4	a_887_270##12	7.78369e-18
C314	a_343_74##4	a_232_98##7	3.35412e-17
C315	Q#2	a_887_270##10	4.76656e-17
C316	Q_N	a_1442_94##3	6.81084e-18
C317	a_887_270##6	a_887_270##4	9.73066e-18
C318	a_27_136##7	GATE_N#2	4.43501e-18
C319	Q_N	a_1442_94##2	1.00524e-17
C320	D#1	GATE_N#1	2.96861e-17
C321	a_343_74##4	a_27_136#	6.54608e-18
C322	a_343_74##2	a_343_74##3	1.76744e-19
C323	Q_N	a_887_270##5	2.22828e-19
C324	VGND#11	a_887_270##8	1.21803e-18
C325	VPWR#6	a_232_98##5	1.73264e-18
C326	a_887_270##6	a_887_270##11	1.6149e-17
C327	a_232_98##11	a_232_98##12	4.06023e-18
C328	a_232_98##4	a_343_74##4	2.35558e-18
C329	a_887_270##14	Q#1	3.42078e-17
C330	a_1442_94##9	a_887_270##11	4.67385e-19
C331	a_343_74##2	a_232_98##7	4.02115e-17
C332	VPWR#15	D#2	1.80895e-18
C333	VGND#12	a_887_270##10	1.41731e-18
C334	VPWR#5	a_647_79#	2.6036e-18
C335	a_887_270##5	a_1442_94##7	6.0994e-19
C336	VPWR#6	a_343_74#	8.3088e-18
C337	a_343_74##4	GATE_N#3	5.90493e-19
C338	a_343_74##2	a_27_136#	2.86541e-18
C339	a_887_270##6	a_887_270##12	3.58937e-19
C340	a_27_136##7	D#2	7.23507e-18
C341	VGND#7	a_232_98##2	1.16845e-20
C342	Q#2	a_887_270##8	3.2074e-17
C343	a_27_136##2	a_232_98##7	1.41921e-17
C344	a_887_270##6	a_647_79#	1.5667e-19
C345	VPWR#4	a_647_79#	8.1723e-19
C346	a_887_270##14	VPWR#12	6.38569e-17
C347	a_887_270##18	a_887_270##10	3.9665e-19
C348	VPWR#13	a_565_392#	2.37141e-20
C349	a_27_136##2	a_27_136#	2.08797e-17
C350	a_27_136##2	a_232_98##4	3.3334e-17
C351	VGND#12	a_887_270##8	3.21412e-17
C352	a_27_136##2	GATE_N#3	4.27027e-19
C353	Q#2	a_647_79##3	9.91507e-19
C354	VPWR#5	a_887_270##3	3.19202e-18
C355	a_887_270##2	a_647_79#	2.89078e-18
C356	VPWR#13	VPWR#12	1.69815e-18
C357	a_27_136##2	D#3	2.87842e-19
C358	Q	a_1442_94##3	2.83965e-20
C359	a_887_270##18	a_887_270##8	5.74057e-18
C360	VGND#4	a_887_270##7	6.67736e-20
C361	a_887_270##2	a_887_270##3	6.18873e-18
C362	Q	a_887_270##7	1.2177e-17
C363	GATE_N#3	a_232_98##3	6.84622e-18
C364	a_1442_94##11	VPWR#3	9.89133e-18
C365	Q	a_887_270##5	1.49649e-19
C366	a_232_98##12	a_565_392#	5.46428e-18
C367	a_232_98##6	a_647_79#	1.09594e-18
C368	VGND#12	a_647_79##3	1.27168e-18
C369	a_887_270##2	a_232_98##5	2.92547e-19
C370	a_27_136##5	VPWR#15	2.97257e-18
C371	a_232_98##6	a_887_270##3	1.16247e-17
C372	VPWR#13	a_887_270##14	8.19061e-17
C373	VPWR#4	VPWR#11	6.61283e-20
C374	a_232_98##6	a_232_98##5	1.77876e-17
C375	a_887_270##16	a_887_270##12	8.39328e-19
C376	a_887_270##18	a_647_79##3	4.65148e-17
C377	Q_N#3	VGND#1	7.04433e-17
C378	VPWR#5	a_232_98##5	7.05288e-19
C379	a_232_98##6	a_343_74#	1.53261e-17
C380	D#2	GATE_N#3	2.80796e-18
C381	a_27_136##5	a_27_136##7	2.15688e-18
C382	VPWR#2	a_1442_94##4	1.47677e-18
C383	a_1442_94##9	VPWR#10	3.70682e-17
C384	a_232_98##6	a_27_136##3	2.44989e-19
C385	a_647_79##3	VGND#13	1.54568e-17
C386	VGND#2	a_1442_94##4	1.89395e-18
C387	a_232_98##6	a_232_98#	2.37014e-19
C388	a_343_74##2	a_232_98##5	4.50366e-19
C389	VPWR#2	a_887_270##6	4.39116e-18
C390	a_887_270##18	a_887_270#	8.01469e-19
C391	VGND#2	a_887_270##6	3.25647e-18
C392	VGND#10	VGND#1	1.89182e-18
C393	VGND#3	a_887_270##7	5.22576e-21
C394	a_887_270##16	a_647_79#	2.45988e-17
C395	a_343_74##2	a_27_136##3	2.03811e-17
C396	VGND#13	a_887_270#	2.8142e-17
C397	a_887_270##11	a_887_270##5	3.86146e-18
C398	a_887_270##18	a_343_74##3	3.81979e-20
C399	a_232_98#	a_27_136##2	1.2586e-18
C400	VGND#10	Q_N#3	6.70137e-17
C401	VPWR#7	a_27_136##3	3.95813e-18
C402	a_232_98##3	a_232_98#	3.43169e-19
C403	a_232_98##6	VPWR#6	1.18991e-17
C404	a_887_270##16	a_887_270##3	6.13498e-19
C405	a_343_74##7	a_232_98##2	8.74142e-18
C406	VGND#13	a_343_74##3	1.9203e-18
C407	a_343_74##8	a_343_74##7	2.86862e-18
C408	VGND#6	a_232_98##6	4.42459e-20
C409	GATE_N#2	a_232_98#	3.26983e-18
C410	a_887_270#	a_839_123#	9.65183e-18
C411	a_887_270##14	VPWR#5	1.19196e-17
C412	a_343_74##2	a_232_98##2	1.31419e-19
C413	a_343_74##3	a_839_123#	9.65183e-18
C414	a_1442_94##9	Q_N	2.40432e-17
C415	VGND#6	a_343_74##4	8.29369e-17
C416	a_1442_94##10	Q_N#3	5.77723e-19
C417	VPWR#6	a_343_74##2	5.24442e-20
C418	a_887_270##3	a_814_392#	2.77385e-18
C419	D#1	GATE_N#2	4.28259e-18
C420	a_887_270##2	a_647_79##2	8.7648e-17
C421	VGND	a_887_270##7	3.49782e-20
C422	VGND#6	a_343_74##2	1.85777e-20
C423	a_232_98##5	a_814_392#	5.21314e-18
C424	VGND#13	a_232_98##7	3.1565e-19
C425	VGND	a_232_98##2	5.74624e-19
C426	a_647_79##2	a_232_98##6	1.04274e-19
C427	a_887_270##14	VPWR#4	1.24498e-17
C428	VPWR#7	a_232_98#	5.98635e-18
C429	a_887_270##16	a_232_98##5	1.9201e-19
C430	a_343_74##3	a_647_79##7	1.39815e-17
C431	a_232_98##12	a_232_98##2	9.60602e-20
C432	a_232_98##6	a_887_270##2	9.45157e-17
C433	a_343_74#	a_565_392#	2.11309e-17
C434	a_1442_94##10	VGND#10	5.16525e-17
C435	a_27_136##3	a_565_392#	2.11309e-17
C436	a_232_98##7	a_569_79#	1.14431e-17
C437	Q	a_1442_94##9	1.03979e-18
C438	a_887_270##14	VPWR#3	1.14406e-18
C439	a_27_136#	a_569_79#	1.80175e-20
C440	a_343_74##4	a_232_98##6	7.00791e-18
C441	a_887_270##16	Q	5.68459e-17
C442	a_232_98##7	a_647_79##7	7.46121e-18
C443	a_343_74##2	a_232_98##6	2.31872e-17
C444	Q_N#3	Q_N	3.62381e-19
C445	D	a_232_98##11	9.67337e-18
C446	VPWR#13	VPWR#4	4.35176e-19
C447	a_232_98##2	a_27_136##2	3.15121e-17
C448	a_343_74##4	a_343_74##2	2.4023e-18
C449	a_27_136##5	D	5.78313e-18
C450	a_27_136##2	a_232_98##6	1.39678e-18
C451	VGND#11	VGND#10	4.43191e-18
C452	VPWR	VPWR#7	8.34665e-17
C453	a_27_136##2	a_343_74##4	1.54387e-17
C454	VPWR	VPWR#5	8.5569e-17
C455	VPWR	VPWR#4	7.14599e-17
C456	VPWR	VPWR#3	1.49144e-17
C457	a_1442_94##3	VNB	2.03179e-17
C458	a_1442_94##2	VNB	4.1331e-17
C459	a_647_79#	a_887_270##7	2.57978e-19
C460	a_887_270##7	VNB	3.24638e-17
C461	a_343_74##2	a_27_136##2	1.26195e-16
C462	a_887_270##5	VNB	2.92433e-17
C463	a_232_98##2	VNB	1.97262e-17
C464	GATE_N	a_232_98##12	4.4239e-17
C465	GATE_N	VPWR#15	1.60247e-18
C466	VPWR	a_887_270##16	7.18989e-19
C467	a_27_136##7	GATE_N	7.66729e-18
C468	Q	a_1442_94##10	1.20841e-18
C469	Q_N	VPWR#1	5.24756e-17
C470	Q_N	Q_N#1	5.30673e-19
C471	a_27_136##2	a_232_98##3	1.62186e-18
C472	VPWR#10	Q_N	5.25508e-17
C473	VGND#11	a_1442_94##10	5.66628e-17
C474	VPWR	a_343_74##7	7.58672e-18
C475	a_887_270##18	Q	9.90955e-18
C476	VGND	VGND#7	9.64785e-17
C477	a_232_98##12	a_647_79##6	3.91751e-20
C478	VGND	VGND#5	1.11878e-16
C479	D	VPWR#15	6.89788e-18
C480	VGND	VGND#4	6.957e-17
C481	a_232_98##6	a_814_392#	1.156e-17
C482	VGND	VGND#3	1.68351e-17
C483	GATE_N#2	a_232_98##3	3.26242e-17
C484	a_27_136#	VGND#14	1.68579e-17
C485	VPWR	D#5	2.58118e-18
C486	a_232_98##3	D#2	2.70327e-19
C487	VGND	a_887_270##16	2.66937e-18
C488	D#2	GATE_N#2	3.76947e-17
C489	a_232_98##3	a_232_98##2	1.16485e-17
C490	VGND	a_647_79##5	1.99237e-17
C491	Q	VPWR#12	3.05661e-18
C492	a_887_270##14	Q	2.67795e-17
C493	a_343_74##7	a_232_98##5	4.28092e-20
C494	a_343_74##8	a_27_136#	1.28714e-18
C495	VGND	a_343_74##7	3.50395e-18
C496	VPWR	a_232_98##11	2.98872e-18
C497	a_232_98##4	VGND#14	9.48373e-18
C498	VGND#7	VNB	4.64933e-17
C499	VGND	D#5	1.97548e-18
C500	VGND#5	VNB	4.57577e-17
C501	a_232_98##12	VPWR#14	5.59074e-17
C502	VGND#4	VNB	3.12951e-17
C503	VGND#3	VNB	3.15973e-17
C504	VPWR#7	VNB	4.40904e-17
C505	VPWR	Q#1	2.43095e-18
C506	VGND#5	VGND#4	1.03096e-18
C507	VPWR#5	VNB	4.62579e-17
C508	Q	a_1442_94##6	9.3832e-20
C509	VPWR#4	VNB	3.05773e-17
C510	VGND	Q#2	1.95004e-17
C511	VPWR#3	VNB	3.18036e-17
C512	Q	a_887_270##9	1.68657e-19
C513	VPWR	a_887_270##14	3.09088e-17
C514	VGND	a_887_270##18	2.35518e-17
C515	VPWR	VPWR#13	2.91973e-17
C516	Q	a_887_270##10	3.98742e-19
C517	Q#2	VGND#11	6.78075e-17
C518	a_1442_94##9	VNB	1.15766e-17
C519	Q	a_887_270##8	1.94161e-18
C520	a_343_74##8	a_232_98##4	3.68008e-17
C521	GATE_N	a_232_98#	1.53214e-19
C522	VPWR	a_647_79##6	6.4083e-18
C523	a_887_270##16	VNB	1.20284e-17
C524	Q	a_647_79##3	3.08541e-20
C525	Q_N	a_1442_94##5	2.12715e-17
C526	GATE_N	GATE_N#1	7.01213e-18
C527	VPWR	VPWR#14	1.52396e-17
C528	a_647_79##5	VNB	9.46295e-18
C529	a_343_74##4	a_569_79#	2.35928e-18
C530	VGND	a_343_74##8	6.51933e-18
C531	Q_N	a_1442_94##7	2.25786e-17
C532	GATE_N	D#1	1.87667e-18
C533	VGND	a_232_98##11	5.48027e-18
C534	VPWR	a_232_98##12	4.53939e-17
C535	a_343_74##7	a_343_74#	5.63067e-19
C536	VPWR	VPWR#15	1.92026e-17
C537	a_343_74##2	a_569_79#	5.42104e-20
C538	a_343_74##7	VNB	1.32152e-17
C539	VGND	a_27_136##5	3.69907e-17
C540	a_232_98##12	a_343_74##9	3.65495e-18
C541	VPWR#15	VPWR#14	7.12187e-19
C542	VPWR	a_27_136##7	1.94541e-17
C543	D	a_232_98#	1.43001e-20
C544	a_27_136##2	a_569_79#	1.30601e-20
C545	VGND	Q#1	2.48595e-18
C546	a_232_98##11	a_232_98##4	5.38394e-19
C547	D#5	VNB	1.40895e-18
C548	VGND#1	VNB	6.917e-17
C549	Q_N#3	VNB	9.65893e-18
C550	VGND#10	VNB	1.23441e-17
C551	a_1442_94##10	VNB	1.23013e-17
C552	VGND#11	VNB	7.69569e-18
C553	Q#2	VNB	2.53045e-18
C554	VGND#12	VNB	3.68617e-19
C555	a_887_270##18	VNB	1.41829e-17
C556	Q	a_887_270##12	7.16022e-18
C557	a_887_270##16	a_887_270##14	5.20374e-19
C558	a_343_74##8	GATE_N#3	7.27098e-19
C559	VGND#13	VNB	3.90374e-19
C560	VGND#12	VGND#11	2.669e-18
C561	Q	a_647_79#	7.5011e-19
C562	GATE_N#2	a_232_98##2	1.01967e-18
C563	VGND#2	VGND#3	4.57101e-17
C564	a_343_74##8	VNB	1.77473e-18
C565	a_232_98##11	VNB	6.03066e-18
C566	Q_N	VPWR#2	3.42147e-17
C567	a_27_136##5	VNB	6.35282e-17
C568	VPWR#1	VNB	8.12581e-17
C569	VGND	a_887_270##10	1.24397e-18
C570	VGND#2	Q_N	3.81298e-18
C571	VGND	a_887_270##8	8.77313e-19
C572	a_343_74##8	a_232_98##2	6.76401e-18
C573	VPWR#10	VNB	1.38491e-17
C574	VGND	a_647_79##3	1.37479e-18
C575	a_1442_94##11	VNB	1.62585e-17
C576	VPWR	a_887_270##11	3.80361e-19
C577	VPWR#11	VNB	5.69177e-19
C578	VGND	a_887_270#	4.03935e-18
C579	Q#1	VNB	5.62415e-19
C580	VPWR	a_887_270##12	3.8589e-19
C581	VPWR#12	VNB	4.06971e-19
C582	a_343_74##7	a_27_136##3	1.53247e-18
C583	VGND	a_232_98##7	1.69157e-18
C584	VPWR	a_647_79#	5.69374e-19
C585	a_887_270##14	VNB	1.47655e-17
C586	a_232_98##11	GATE_N#3	4.13278e-17
C587	VPWR#13	VNB	1.56263e-17
C588	VGND	a_27_136#	9.10693e-18
C589	VPWR	a_887_270##3	5.74552e-18
C590	VGND	a_232_98##4	1.79346e-18
C591	a_647_79##6	VNB	2.11387e-18
C592	VPWR	a_232_98##5	1.71029e-21
C593	VGND	GATE_N#3	9.47289e-18
C594	GATE_N	a_232_98##3	5.37416e-19
C595	VPWR	a_343_74#	1.92446e-18
C596	VPWR#14	VNB	2.6489e-18
C597	VGND	D#3	6.44247e-18
C598	VPWR	a_27_136##3	4.71452e-19
C599	a_232_98##12	VNB	2.05441e-17
C600	GATE_N	GATE_N#2	5.58449e-18
C601	VPWR#15	VNB	3.24582e-18
C602	VPWR	a_232_98#	8.57331e-18
C603	a_27_136##5	a_232_98##4	3.82038e-19
C604	a_27_136##7	VNB	5.92642e-17
C605	VPWR#15	a_232_98##12	6.02111e-17
C606	VPWR	GATE_N#1	2.05942e-18
C607	a_1442_94#	VNB	2.99634e-17
C608	GATE_N	D#2	5.09122e-19
C609	a_1442_94##6	VNB	3.05092e-17
C610	VPWR	D#1	2.05964e-18
C611	D	a_232_98##3	2.53557e-18
C612	a_887_270##9	VNB	4.03677e-17
C613	a_887_270##10	VNB	3.1761e-17
C614	Q	a_887_270##6	3.18051e-17
C615	a_887_270##8	VNB	3.15245e-17
C616	D	GATE_N#2	2.28059e-17
C617	a_647_79##3	VNB	3.2219e-17
C618	Q	a_647_79##2	8.44334e-19
C619	Q#2	VGND#12	5.32344e-17
C620	a_887_270#	VNB	2.53059e-17
C621	VPWR#2	VPWR#3	4.80553e-17
C622	a_343_74##3	VNB	1.52388e-17
C623	D	D#2	5.7619e-18
C624	a_232_98##7	VNB	4.08984e-17
C625	VPWR	VPWR#6	6.76646e-17
C626	GATE_N#3	VGND#15	2.05529e-17
C627	a_27_136#	VNB	3.0627e-17
C628	a_232_98##4	VNB	3.71136e-17
C629	GATE_N#3	VNB	4.35726e-17
C630	VPWR#7	a_232_98##2	3.07107e-20
C631	a_887_270##16	VPWR#13	9.19516e-18
C632	D#3	VNB	3.22083e-17
C633	VPWR	a_887_270##6	4.41029e-18
C634	a_1442_94##5	VNB	3.91532e-17
C635	VPWR	a_647_79##2	2.68277e-18
C636	a_1442_94##7	VNB	3.9905e-17
C637	a_887_270##4	VNB	4.16369e-17
C638	VPWR	a_887_270##2	6.51733e-18
C639	a_887_270##11	VNB	3.14689e-17
C640	a_887_270##12	VNB	3.78048e-17
C641	VPWR	a_232_98##6	2.67777e-17
C642	a_232_98##11	D#3	4.27234e-18
C643	a_647_79#	VNB	4.01378e-17
C644	a_887_270##3	VNB	3.44962e-17
C645	VGND	VGND#6	5.87509e-17
C646	a_232_98##5	VNB	3.22539e-17
C647	VPWR	a_343_74##2	6.53285e-18
C648	a_27_136##7	a_232_98##12	1.54077e-18
C649	a_343_74#	VNB	3.93618e-17
C650	a_27_136##3	VNB	3.43525e-17
C651	VGND	a_887_270##6	3.21169e-18
C652	VPWR	a_27_136##2	3.08489e-18
C653	a_232_98#	VNB	5.45341e-17
C654	VGND	a_647_79##2	6.46321e-18
C655	VGND#4	VGND#3	1.11424e-18
C656	VPWR	a_232_98##3	1.88043e-18
C657	GATE_N#1	VNB	3.72771e-17
C658	a_343_74##7	a_232_98#	2.91174e-17
C659	a_27_136##5	GATE_N#3	3.69019e-17
C660	VGND	a_887_270##2	4.18805e-18
C661	D#1	VNB	3.71562e-17
C662	VGND	a_232_98##6	4.52598e-18
C663	VPWR#2	VNB	1.71149e-16
C664	VGND	a_343_74##4	5.24623e-17
C665	VGND#2	VNB	1.72356e-16
C666	VGND	a_343_74##2	4.97586e-18
C667	VPWR#6	VNB	3.63031e-17
C668	VGND#6	VNB	3.12107e-17
C669	VGND	a_27_136##2	2.31256e-17
C670	a_1442_94##4	VNB	5.57472e-17
C671	VGND	a_232_98##3	6.84849e-18
C672	a_887_270##6	VNB	4.05011e-17
C673	VGND	GATE_N#2	4.01762e-18
C674	a_647_79##2	VNB	3.01603e-17
C675	a_887_270##2	VNB	4.68867e-17
C676	D#3	VGND#15	1.75794e-17
C677	a_887_270##18	Q#2	2.61763e-17
C678	a_232_98##6	VNB	7.46845e-17
C679	a_343_74##4	VNB	7.58179e-17
C680	a_343_74##2	VNB	2.86454e-17
C681	a_27_136##2	VNB	3.37481e-17
C682	a_232_98##3	VNB	5.03126e-17
C683	GATE_N#2	VNB	3.48176e-17
C684	a_1442_94##9	VPWR#2	5.69367e-18
C685	D#2	VNB	4.77888e-17
C686	a_27_136##7	VPWR#15	5.07837e-17
C687	a_232_98##12	VPWR#7	1.05074e-17
C688	VPWR	GATE_N	6.55488e-18
C689	a_887_270##5	a_1442_94##6	5.55829e-20
C690	VPWR	D	1.97319e-18
C691	a_232_98##11	a_232_98##2	4.22331e-20
C692	VGND	D	2.57633e-18
C693	a_27_136##5	D#3	4.97589e-17
C694	VPWR	Q	3.44579e-18
C695	GATE_N	VNB	1.43031e-18
C696	D	VNB	3.00849e-18
C697	Q_N	VNB	9.00259e-18
C698	Q	VNB	8.81545e-18
C699	VPWR	VNB	3.06019e-16
C700	VGND	VNB	3.03649e-16
C701	VPWR#4	a_887_270##7	5.90708e-20
C702	a_343_74##7	GATE_N#1	7.59041e-19
C703	VPWR#8	VNB	6.15218e-17
C704	a_27_136##7	VPWR#8	2.23128e-17
C705	VPWR#8	GATE_N#1	7.58295e-18
C706	GATE_N	VPWR#8	1.27095e-18
C707	VPWR#8	VPWR#7	2.94791e-19
C708	VGND#8	D#3	2.26649e-18
C709	VGND#8	GATE_N#2	6.00859e-20
C710	VGND	VGND#8	1.17534e-16
C711	VGND#8	VGND#15	6.01522e-18
C712	VPWR#8	D#2	2.72575e-20
C713	VGND#8	a_232_98##4	2.0625e-18
C714	VGND#8	VGND#7	1.84828e-18
C715	VPWR#8	GATE_N#2	6.34593e-20
C716	VGND#8	D#2	5.73154e-19
C717	VGND#8	VNB	7.6107e-17
C718	VGND#8	a_27_136##5	6.95222e-17
C719	VGND#8	GATE_N#3	1.14348e-17
C720	VGND#8	a_232_98##3	1.41117e-19
C721	VPWR	VPWR#8	1.08133e-16
C722	a_232_98##12	VPWR#8	2.27348e-17
C723	VPWR#8	D#1	4.16826e-18
C724	D#5	VPWR#8	4.72627e-19
C725	VGND#8	a_27_136#	7.42839e-19
C726	VPWR#8	a_232_98##3	1.61273e-19
*
*
.ENDS sky130_fd_sc_hs__dlxbn_2
*
