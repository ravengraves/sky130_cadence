* Extracted by Quantus, converted by sky130cad/quantus.py
*
*
*
*                       LINUX           Wed Nov 18 08:52:39 2026
*
*
*
*  PROGRAM  advgen
*
*  Name           : advgen - Quantus - (64-bit)
*  Version        : 25.1.0-p047
*  Build Date     : Thu Dec 11 23:20:30 PST 2025
*
*  HSPICE LIBRARY
*
*  OPERATING_TEMPERATURE 150
*  QRC_TECH_DIR <path>/tech
*
*
*

*
.SUBCKT sky130_fd_sc_hs__o2111a_1 VNB VPB VGND VPWR X C1 A1 B1 A2 D1
*
*
*  caps2d version: 10
*
*
*       TRANSISTOR CARDS
*
*
XM2 X#3 a_82_48##3 VGND#7 VNB sky130_fd_pr__nfet_01v8_lvt l=0.15 w=0.74 ad=0.2035 as=0.2035 pd=2.03 ps=2.03
XM11 a_82_48##8 D1#1 a_321_74# VNB sky130_fd_pr__nfet_01v8_lvt l=0.15 w=0.74 ad=0.259 as=0.1554 pd=2.18 ps=1.9
XM5 a_321_74# C1#1 a_393_74# VNB sky130_fd_pr__nfet_01v8_lvt l=0.15 w=0.74 ad=0.1554 as=0.1776 pd=1.9 ps=1.96
XM3 a_393_74# B1#3 a_471_74##2 VNB sky130_fd_pr__nfet_01v8_lvt l=0.15 w=0.74 ad=0.1776 as=0.2664 pd=1.96 ps=2.2
XM8 a_471_74##2 A2#3 VGND#6 VNB sky130_fd_pr__nfet_01v8_lvt l=0.15 w=0.74 ad=0.2664 as=0.2886 pd=2.2 ps=2.26
XM10 VGND#6 A1#3 a_471_74# VNB sky130_fd_pr__nfet_01v8_lvt l=0.15 w=0.74 ad=0.2886 as=0.2109 pd=2.26 ps=2.05
XM0 X#1 a_82_48# VPWR#6 VPB sky130_fd_pr__pfet_01v8 l=0.15 w=1.12 ad=0.3304 as=0.483175 pd=2.83 ps=3.2
XM1 VPWR#6 D1#3 a_82_48##7 VPB sky130_fd_pr__pfet_01v8 l=0.15 w=0.84 ad=0.483175 as=0.294 pd=3.2 ps=2.38
XM4 a_82_48##7 C1#3 VPWR#5 VPB sky130_fd_pr__pfet_01v8 l=0.15 w=0.84 ad=0.294 as=0.5082 pd=2.38 ps=2.89
XM7 VPWR#5 B1#1 a_82_48##4 VPB sky130_fd_pr__pfet_01v8 l=0.15 w=0.84 ad=0.5082 as=0.3706 pd=2.89 ps=2.77
XM6 a_82_48##4 A2#1 a_600_381# VPB sky130_fd_pr__pfet_01v8 l=0.15 w=1 ad=0.3706 as=0.27 pd=2.77 ps=2.54
XM9 a_600_381# A1#4 VPWR#1 VPB sky130_fd_pr__pfet_01v8 l=0.15 w=1 ad=0.27 as=0.285 pd=2.54 ps=2.57
*
*
*       RESISTOR AND CAP/DIODE CARDS
*
Rg1	a_82_48#	a_82_48##2	489.343506
Rg2	a_82_48##2	a_82_48##3	305.221649
Rg3	D1#1	D1#2	544.599426
Rg4	D1#2	D1#3	365.402374
Rg5	C1#1	C1#2	530.596741
Rg6	C1#2	C1#3	373.483185
Rg7	B1#1	B1#2	437.381012
Rg8	B1#2	B1#3	464.105225
Rg9	A2#1	A2#2	400.207520
Rg10	A2#2	A2#3	419.840759
Rg11	A1#1	A1#2	26.676205
Rg12	A1#2	A1#3	368.862610
Rg13	A1#2	A1#4	466.118469
Rf1	X	X#2	0.186110
Rf2	X#2	X	13.585999
Rf3	X	X#3	94.222702
Rf4	X#1	X#2	5.000000
Rf5	D1	D1#2	162.201172
Rf6	C1#2	C1	162.988510
Rf7	B1#4	B1	1.217125
Rf8	B1#2	B1#6	161.449936
Rf9	B1#4	B1#6	6.436858
Rf10	a_82_48##4	a_82_48##5	108.694893
Rf11	a_82_48##5	a_82_48##6	97.147751
Rf12	a_82_48##5	a_82_48##7	17.559351
Rf13	a_82_48##6	a_82_48##8	71.744400
Rf14	A2#2	A2#5	161.313934
Rf15	A2#6	A2	1.081134
Rf16	A2#5	A2#6	8.582477
Rf17	a_471_74#	a_471_74##2	98.541138
Rf18	A1	A1#1	168.106262
Rf19	VPWR#1	VPWR#2	157.078445
Rf20	VPWR#2	VPWR#3	84.567947
Rf22	VPWR#2	VPWR#5	32.168968
Rf23	VPWR#3	VPWR#6	30.353714
Rf25	VGND#2	VGND#3	82.157272
Rf26	VGND#3	VGND#4	89.097069
Rf28	VGND#2	VGND#6	34.113823
Rf29	VGND#4	VGND#7	31.534731
Rf33	a_82_48##2	a_82_48##6	160.232803
Re1	VPWR#2	VPWR	1.227783
Re2	VGND	VGND#3	1.227829
*
*       CAPACITOR CARDS
*
*
C1	VGND	VNB	6.8783e-17
C2	VPWR	VNB	6.23324e-17
C3	X	VNB	5.14984e-17
C4	A1	VNB	1.09689e-17
C5	B1	VNB	4.92755e-18
C6	A2	VNB	5.65201e-19
C7	D1	VNB	1.96864e-18
C8	VGND	X	2.09233e-18
C9	a_82_48##2	VNB	5.13635e-17
C10	D1#2	VNB	3.57056e-17
C11	C1#2	VNB	3.97738e-17
C12	B1#2	VNB	3.93257e-17
C13	VPWR	X	1.74915e-17
C14	A2#2	VNB	3.63137e-17
C15	A1#1	VNB	9.20627e-18
C16	VGND#3	VNB	2.04155e-16
C17	VPWR#2	VNB	2.21548e-16
C18	VGND	B1	4.29083e-18
C19	a_82_48#	VNB	4.29461e-17
C20	D1#3	VNB	3.32107e-17
C21	VGND	A2	2.41629e-18
C22	C1#3	VNB	3.26184e-17
C23	VPWR	A1	2.66556e-18
C24	B1#1	VNB	3.74372e-17
C25	A2#1	VNB	2.80969e-17
C26	VGND	D1	2.40792e-18
C27	A1#4	VNB	2.94904e-17
C28	VPWR	B1	2.05229e-18
C29	a_82_48##3	VNB	3.33571e-17
C30	D1#1	VNB	4.35552e-17
C31	C1#1	VNB	3.01786e-17
C32	B1#3	VNB	2.99825e-17
C33	VPWR	A2	4.41797e-18
C34	A2#3	VNB	2.88274e-17
C35	A1#3	VNB	3.25497e-17
C36	X#1	VNB	1.95918e-17
C37	VPWR#6	VNB	5.09997e-18
C38	VPWR	D1	2.2456e-18
C39	a_82_48##7	VNB	3.00268e-18
C40	VPWR#5	VNB	6.47493e-18
C41	a_82_48##4	VNB	5.22565e-18
C42	VPWR#1	VNB	8.61544e-17
C43	X#3	VNB	4.84712e-17
C44	VGND#7	VNB	1.13428e-17
C45	a_82_48##8	VNB	1.16231e-17
C46	a_471_74##2	VNB	9.09598e-18
C47	VGND	a_82_48##2	5.35256e-18
C48	VGND#6	VNB	4.56027e-18
C49	a_471_74#	VNB	4.10032e-17
C50	VGND	D1#2	5.4382e-21
C51	VGND	C1#2	1.49455e-17
C52	a_82_48##5	VNB	7.4077e-19
C53	VGND	B1#2	2.86203e-18
C54	A2	A1	2.21395e-17
C55	VGND	A2#2	2.04075e-18
C56	VGND	A1#1	4.0983e-18
C57	VPWR	a_82_48##2	1.49457e-18
C58	VGND	VGND#3	2.73935e-17
C59	VPWR	C1#2	3.70893e-18
C60	VPWR	B1#2	1.81187e-18
C61	VPWR	A2#2	2.72954e-18
C62	X	a_82_48##2	4.58308e-17
C63	X	D1#2	5.92521e-19
C64	VPWR	VPWR#2	7.66814e-17
C65	VGND	a_82_48##3	1.60402e-18
C66	VGND	D1#1	4.03683e-18
C67	VPWR	a_82_48#	3.8483e-18
C68	VGND	C1#1	3.64545e-18
C69	VGND	B1#3	1.21657e-18
C70	VPWR	D1#3	8.87281e-18
C71	X#3	VGND#7	5.66529e-17
C72	VGND	A2#3	3.87471e-19
C73	VPWR	C1#3	7.1272e-18
C74	VGND	A1#3	9.98175e-19
C75	VPWR	B1#1	5.82496e-18
C76	VPWR	A2#1	9.24456e-18
C77	VPWR	A1#4	4.13652e-18
C78	X	a_82_48#	2.44931e-17
C79	X	D1#3	2.6934e-19
C80	VGND	X#3	1.41449e-17
C81	a_471_74##2	a_82_48##4	6.34067e-18
C82	VGND	VGND#7	2.23317e-17
C83	VGND	a_82_48##8	1.36941e-17
C84	A1	A2#2	8.21864e-19
C85	C1#2	B1	4.61255e-17
C86	VGND	a_471_74##2	1.7829e-17
C87	A1#2	VNB	6.39793e-17
C88	X#3	a_82_48##8	7.03183e-19
C89	VGND	a_471_74#	1.72834e-17
C90	VPWR	VPWR#6	2.33251e-17
C91	B1	B1#2	6.93321e-18
C92	VPWR	a_82_48##7	1.54392e-17
C93	a_82_48##2	D1	2.75079e-17
C94	VPWR	a_82_48##4	1.78228e-17
C95	D1	D1#2	1.6785e-17
C96	VPWR	VPWR#1	4.89625e-17
C97	VGND#3	B1	1.29494e-18
C98	A2	A2#2	5.74254e-18
C99	D1	C1#2	3.38619e-17
C100	X	X#1	3.19385e-18
C101	A2	A1#1	1.12217e-17
C102	X	VPWR#6	2.94172e-17
C103	VGND#7	a_82_48##8	5.37607e-17
C104	A2	VPWR#2	2.49519e-20
C105	A1	A1#4	5.80591e-19
C106	C1#2	a_321_74#	1.24418e-18
C107	X#3	X	3.38351e-18
C108	VPWR	a_82_48##5	7.92982e-18
C109	D1	a_82_48#	1.84745e-18
C110	A2	A1#4	1.73423e-18
C111	X#1	a_82_48##5	1.75387e-17
C112	X	a_82_48##5	1.20468e-17
C113	a_82_48##2	D1#2	1.6258e-17
C114	A1	VPWR#1	3.22935e-17
C115	a_82_48##2	C1#2	4.92534e-18
C116	D1#2	C1#2	3.9736e-17
C117	B1	a_82_48##4	1.04746e-17
C118	a_82_48##5	VPWR#6	4.01552e-17
C119	C1#2	B1#2	4.1395e-17
C120	a_82_48##8	a_471_74##2	1.34334e-18
C121	C1#2	A2#2	4.52942e-19
C122	A2	VPWR#1	1.28664e-18
C123	a_82_48##5	a_82_48##7	3.17474e-18
C124	D1#1	a_321_74#	1.12328e-17
C125	D1	a_82_48##7	8.17371e-19
C126	C1#2	A1#1	2.07362e-18
C127	C1#1	a_321_74#	1.12328e-17
C128	B1#2	A2#2	6.57341e-17
C129	VGND#3	C1#2	1.18329e-17
C130	A1#1	B1#2	2.85396e-19
C131	a_82_48##2	a_82_48#	3.06889e-18
C132	A2#1	a_600_381#	2.52858e-17
C133	C1#1	a_393_74#	1.73994e-17
C134	a_471_74##2	A2	2.36084e-18
C135	a_82_48##2	D1#3	1.53089e-18
C136	VGND#3	B1#2	5.06043e-19
C137	VGND	A1#2	9.75093e-19
C138	A1#1	A2#2	1.67516e-18
C139	A1#4	a_600_381#	2.61244e-17
C140	a_82_48##5	VPWR#5	3.21047e-17
C141	a_82_48#	D1#2	8.03508e-18
C142	B1#3	a_393_74#	1.73994e-17
C143	a_82_48##2	C1#3	4.67322e-19
C144	a_471_74#	A2	1.22547e-17
C145	a_82_48##8	D1	2.75921e-17
C146	B1	a_82_48##5	2.52486e-18
C147	a_82_48##2	B1#1	3.97099e-19
C148	A2#2	VPWR#2	4.63103e-19
C149	a_82_48##2	A2#1	1.61915e-19
C150	D1#3	C1#2	4.37016e-19
C151	C1#2	B1#1	2.02572e-18
C152	C1#2	A2#1	8.71632e-19
C153	a_82_48##2	D1#1	5.14161e-18
C154	C1#2	A1#4	6.78468e-19
C155	a_471_74##2	VGND#6	5.62885e-17
C156	B1#2	A2#1	4.10111e-18
C157	D1	a_82_48##5	2.88307e-17
C158	VPWR#2	a_82_48#	3.19414e-19
C159	C1#2	D1#1	3.43027e-17
C160	a_471_74##2	a_471_74#	2.58652e-18
C161	A2#2	A1#4	3.07133e-18
C162	C1#2	C1#1	2.7901e-17
C163	VPWR#2	C1#3	2.01857e-18
C164	a_82_48##2	VPWR#6	3.25623e-18
C165	C1#2	B1#3	6.05071e-18
C166	VPWR#2	B1#1	4.68608e-18
C167	C1#1	B1#2	4.74695e-18
C168	a_82_48#	D1#3	2.14303e-17
C169	C1#2	A2#3	2.54193e-18
C170	a_471_74#	VGND#6	5.86191e-17
C171	VPWR#2	A2#1	1.34774e-17
C172	C1#2	A1#3	2.68289e-19
C173	D1#3	C1#3	2.89057e-17
C174	A1#1	C1#1	1.45583e-19
C175	VPWR#1	A1#2	3.93887e-18
C176	X#3	a_82_48##2	2.78294e-17
C177	VGND#3	D1#1	8.37786e-18
C178	a_471_74#	a_600_381#	1.86194e-19
C179	C1#2	VPWR#5	3.57429e-18
C180	a_82_48##2	VGND#7	4.77248e-17
C181	VGND#3	C1#1	8.18012e-18
C182	C1#3	B1#1	1.19562e-17
C183	VPWR#2	D1#1	5.77395e-20
C184	VGND#3	B1#3	8.65016e-18
C185	VPWR#5	B1#2	5.37635e-19
C186	VPWR#1	C1#2	3.21233e-19
C187	B1#2	a_82_48##4	1.38994e-17
C188	a_82_48##8	D1#2	6.78306e-18
C189	B1#1	A2#1	3.15087e-17
C190	C1#2	A1#2	4.57364e-19
C191	A2#2	a_82_48##4	1.89759e-17
C192	a_82_48##8	C1#2	6.8109e-17
C193	A2#1	A1#4	5.73625e-17
C194	VPWR#6	VPWR#2	4.10127e-19
C195	C1#2	a_471_74##2	2.50696e-17
C196	a_82_48##7	VPWR#2	8.33249e-18
C197	X#1	a_82_48#	2.62959e-17
C198	a_82_48##2	a_82_48##5	4.50267e-18
C199	a_471_74##2	B1#2	1.64487e-17
C200	a_82_48##4	VPWR#2	1.50638e-17
C201	a_82_48#	VPWR#6	3.56669e-17
C202	X#1	D1#3	1.41815e-18
C203	a_82_48##7	a_82_48#	1.9117e-18
C204	a_471_74##2	A2#2	1.74021e-17
C205	A1	A1#2	1.20135e-17
C206	VPWR#2	VPWR#1	3.76796e-17
C207	D1#3	VPWR#6	2.33723e-17
C208	a_82_48##5	D1#2	2.61538e-18
C209	VPWR#5	a_82_48#	6.8323e-19
C210	VGND#6	A2#2	8.29253e-19
C211	a_82_48##7	D1#3	3.94884e-17
C212	VPWR#6	C1#3	1.16371e-18
C213	a_82_48##3	D1#1	4.03301e-18
C214	VPWR#5	D1#3	2.29165e-18
C215	C1#2	a_82_48##5	4.79111e-17
C216	C1#3	a_82_48##7	1.779e-17
C217	VPWR#6	B1#1	2.65665e-19
C218	a_82_48##4	D1#3	2.33115e-19
C219	A1#1	a_471_74#	3.1888e-17
C220	VGND#3	a_471_74##2	7.2844e-18
C221	C1#3	VPWR#5	3.58114e-17
C222	A2#2	A1#2	3.46305e-17
C223	a_82_48##7	B1#1	8.01577e-19
C224	D1#1	C1#1	6.78275e-17
C225	a_82_48##4	C1#3	1.31284e-18
C226	B1#1	VPWR#5	3.28402e-17
C227	a_82_48##7	A2#1	2.34623e-19
C228	a_82_48##4	B1#1	4.10264e-17
C229	C1#1	B1#3	5.77414e-17
C230	VPWR#1	C1#3	4.63342e-19
C231	VPWR#5	A2#1	2.45084e-18
C232	a_82_48##4	A2#1	6.05856e-17
C233	VPWR#5	A1#4	9.62292e-19
C234	VPWR#1	B1#1	2.01687e-18
C235	B1#3	A2#3	3.14692e-17
C236	a_82_48##4	A1#4	9.65005e-18
C237	A1#1	A1#2	1.47614e-17
C238	VPWR#1	A2#1	1.11887e-17
C239	A2	A1#2	7.85138e-18
C240	VPWR#1	A1#4	5.33182e-17
C241	A2#3	A1#3	2.42204e-17
C242	a_82_48##5	VPWR#2	4.71826e-19
C243	X#3	a_82_48##3	2.02246e-17
C244	VGND#7	a_82_48##3	5.38103e-17
C245	X#1	VPWR#6	2.81178e-17
C246	a_82_48##5	a_82_48#	5.11552e-18
C247	X#3	D1#1	1.25475e-19
C248	a_82_48##8	a_82_48##3	1.58462e-18
C249	A2#3	A1#2	2.18567e-18
C250	VGND#7	D1#1	3.20699e-18
C251	X#1	a_82_48##7	2.79637e-18
C252	a_82_48##5	D1#3	1.93967e-17
C253	a_82_48##8	D1#1	2.70182e-17
C254	VPWR#6	a_82_48##7	3.39557e-17
C255	VGND#7	C1#1	5.47157e-19
C256	a_82_48##5	C1#3	2.13567e-17
C257	VPWR#6	VPWR#5	3.3536e-18
C258	a_82_48##8	C1#1	5.82136e-19
C259	a_471_74##2	a_82_48##3	2.52759e-19
C260	VGND#7	B1#3	2.68678e-19
C261	a_82_48##7	VPWR#5	3.64762e-17
C262	a_82_48##8	B1#3	3.29056e-19
C263	a_471_74##2	D1#1	3.74272e-19
C264	VGND#7	A2#3	2.08827e-19
C265	a_82_48##7	a_82_48##4	2.63694e-18
C266	VGND#6	D1#1	3.38165e-19
C267	a_82_48##8	A2#3	2.30353e-19
C268	a_471_74##2	C1#1	4.21857e-18
C269	a_82_48##4	VPWR#5	5.33377e-17
C270	VGND#6	C1#1	4.36658e-19
C271	B1#3	a_471_74##2	2.85948e-17
C272	VGND#6	B1#3	1.42839e-18
C273	a_471_74##2	A2#3	3.63126e-17
C274	VPWR#5	VPWR#1	1.71688e-18
C275	a_471_74#	B1#3	1.9181e-19
C276	A2#3	VGND#6	2.45431e-17
C277	a_82_48##4	VPWR#1	2.99643e-17
C278	a_471_74##2	A1#3	8.31688e-19
C279	a_471_74#	A2#3	8.79569e-19
C280	A1#3	VGND#6	2.35375e-17
C281	a_471_74#	A1#2	6.77874e-18
C282	a_471_74#	A1#3	5.21285e-17
C283	a_82_48##5	D1#1	3.33664e-18
C284	VGND#2	B1#3	4.18732e-19
C285	VGND#4	a_82_48##2	1.18119e-18
C286	X	VPWR#3	2.18412e-17
C287	VGND#3	VGND#2	6.00161e-17
C288	a_82_48##2	VPWR#3	2.24627e-19
C289	VGND#2	C1#1	1.52688e-19
C290	a_82_48##5	VPWR#3	4.20003e-19
C291	VGND#4	D1#1	3.03837e-19
C292	VGND#2	A1#1	5.80139e-19
C293	VGND#2	D1#1	3.8707e-20
C294	VGND#4	a_82_48##3	4.15369e-18
C295	a_82_48##7	VPWR#3	6.22791e-18
C296	VPWR	VPWR#3	3.69458e-17
C297	VGND#2	B1#2	4.38511e-20
C298	VGND#4	a_82_48##8	1.76183e-17
C299	VGND#4	D1	3.27639e-19
C300	VGND#2	A1#2	3.54832e-19
C301	VPWR#3	D1#3	5.14189e-18
C302	VGND#4	X#3	1.80291e-17
C303	VPWR#3	a_82_48#	4.66494e-18
C304	VGND#2	a_471_74#	2.10217e-17
C305	VGND	VGND#2	5.58626e-17
C306	VPWR#3	VNB	5.05971e-17
C307	VGND#3	VGND#4	5.81395e-17
C308	VGND#2	a_471_74##2	1.44551e-17
C309	VGND	VGND#4	3.71719e-17
C310	VGND#2	A1#3	4.96368e-18
C311	VGND#2	VNB	5.39324e-17
C312	VGND#4	VNB	5.39688e-17
C313	VPWR#3	D1#2	4.87583e-20
C314	VGND#2	A2#3	2.76979e-18
C315	VPWR#2	VPWR#3	5.81341e-17
C316	VGND#4	D1#2	1.23565e-19
*
*
.ENDS sky130_fd_sc_hs__o2111a_1
*
