* Extracted by Quantus, converted by sky130cad/quantus.py
*
*
*
*                       LINUX           Wed Nov 18 09:09:07 2026
*
*
*
*  PROGRAM  advgen
*
*  Name           : advgen - Quantus - (64-bit)
*  Version        : 25.1.0-p047
*  Build Date     : Thu Dec 11 23:20:30 PST 2025
*
*  HSPICE LIBRARY
*
*  OPERATING_TEMPERATURE 150
*  QRC_TECH_DIR <path>/tech
*
*
*

*
.SUBCKT sky130_fd_sc_hs__sdfrbp_1 VNB VPB VGND RESET_B VPWR Q_N Q D CLK SCE SCD
*
*
*  caps2d version: 10
*
*
*       TRANSISTOR CARDS
*
*
XM40 a_27_74##8 SCE#3 VGND#18 VNB sky130_fd_pr__nfet_01v8_lvt l=0.15 w=0.42 ad=0.1197 as=0.1197 pd=1.41 ps=1.41
XM38 a_225_90##2 a_27_74# a_312_90# VNB sky130_fd_pr__nfet_01v8_lvt l=0.15 w=0.42 ad=0.1197 as=0.1491 pd=1.41 ps=1.55
XM19 a_312_90# D#3 a_413_90##6 VNB sky130_fd_pr__nfet_01v8_lvt l=0.15 w=0.42 ad=0.1491 as=0.215075 pd=1.55 ps=1.93
XM6 a_413_90##6 SCE#5 a_545_97# VNB sky130_fd_pr__nfet_01v8_lvt l=0.15 w=0.42 ad=0.215075 as=0.1008 pd=1.93 ps=1.32
XM35 a_545_97# SCD#1 a_225_90# VNB sky130_fd_pr__nfet_01v8_lvt l=0.15 w=0.42 ad=0.1008 as=0.171675 pd=1.32 ps=1.71
XM9 a_225_90# RESET_B#3 VGND#17 VNB sky130_fd_pr__nfet_01v8_lvt l=0.15 w=0.42 ad=0.171675 as=0.1365 pd=1.71 ps=1.49
XM5 a_850_74##13 CLK#4 VGND#16 VNB sky130_fd_pr__nfet_01v8_lvt l=0.15 w=0.74 ad=0.2109 as=0.2072 pd=2.05 ps=2.04
XM4 VGND#16 a_850_74##6 a_1023_74##10 VNB sky130_fd_pr__nfet_01v8_lvt l=0.15 w=0.74 ad=0.2072 as=0.2109 pd=2.04 ps=2.05
XM2 a_413_90# a_850_74##8 a_1221_97##7 VNB sky130_fd_pr__nfet_01v8_lvt l=0.15 w=0.42 ad=0.1197 as=0.147 pd=1.41 ps=1.54
XM36 a_1221_97##7 a_1023_74# a_1321_97# VNB sky130_fd_pr__nfet_01v8_lvt l=0.15 w=0.42 ad=0.147 as=0.1008 pd=1.54 ps=1.32
XM17 a_1321_97# a_1369_71# a_1399_97# VNB sky130_fd_pr__nfet_01v8_lvt l=0.15 w=0.42 ad=0.1008 as=0.1008 pd=1.32 ps=1.32
XM14 a_1399_97# RESET_B#5 VGND#15 VNB sky130_fd_pr__nfet_01v8_lvt l=0.15 w=0.42 ad=0.1008 as=0.480325 pd=1.32 ps=3.17
XM37 VGND#15 a_1221_97##3 a_1369_71##7 VNB sky130_fd_pr__nfet_01v8_lvt l=0.15 w=0.64 ad=0.480325 as=0.1792 pd=3.17 ps=1.84
XM33 a_1369_71##7 a_1023_74##5 a_1747_74##10 VNB sky130_fd_pr__nfet_01v8_lvt l=0.15 w=0.64 ad=0.1792 as=0.4519 pd=1.84 ps=3.17
XM22 a_1747_74##10 a_850_74# a_1966_74# VNB sky130_fd_pr__nfet_01v8_lvt l=0.15 w=0.42 ad=0.4519 as=0.0882 pd=3.17 ps=1.26
XM15 a_1966_74# a_2008_48##3 VGND#14 VNB sky130_fd_pr__nfet_01v8_lvt l=0.15 w=0.42 ad=0.0882 as=0.1176 pd=1.26 ps=1.4
XM12 VGND#14 RESET_B#9 a_2124_74# VNB sky130_fd_pr__nfet_01v8_lvt l=0.15 w=0.42 ad=0.1176 as=0.0882 pd=1.4 ps=1.26
XM32 a_2124_74# a_1747_74##8 a_2008_48##5 VNB sky130_fd_pr__nfet_01v8_lvt l=0.15 w=0.42 ad=0.0882 as=0.1197 pd=1.26 ps=1.41
XM3 VGND#13 a_1747_74##6 Q_N#3 VNB sky130_fd_pr__nfet_01v8_lvt l=0.15 w=0.74 ad=0.3159 as=0.2072 pd=2.57 ps=2.04
XM20 a_2513_424##7 a_1747_74# VGND#12 VNB sky130_fd_pr__nfet_01v8_lvt l=0.15 w=0.55 ad=0.14575 as=0.23735 pd=1.63 ps=2.16
XM8 VGND#12 a_2513_424##3 Q#3 VNB sky130_fd_pr__nfet_01v8_lvt l=0.15 w=0.74 ad=0.23735 as=0.2109 pd=2.16 ps=2.05
XM18 a_27_74##9 SCE#4 VPWR#19 VPB sky130_fd_pr__pfet_01v8 l=0.15 w=0.64 ad=0.5792 as=0.224 pd=3.09 ps=1.98
XM29 VPWR#19 SCE#1 a_338_464# VPB sky130_fd_pr__pfet_01v8 l=0.15 w=0.64 ad=0.224 as=0.1728 pd=1.98 ps=1.82
XM39 a_338_464# D#1 a_413_90##5 VPB sky130_fd_pr__pfet_01v8 l=0.15 w=0.64 ad=0.1728 as=0.192 pd=1.82 ps=1.88
XM16 a_413_90##5 a_27_74##3 a_512_464# VPB sky130_fd_pr__pfet_01v8 l=0.15 w=0.64 ad=0.192 as=0.2496 pd=1.88 ps=2.06
XM24 a_512_464# SCD#3 VPWR#18 VPB sky130_fd_pr__pfet_01v8 l=0.15 w=0.64 ad=0.2496 as=0.2688 pd=2.06 ps=2.12
XM10 VPWR#18 RESET_B#4 a_413_90##7 VPB sky130_fd_pr__pfet_01v8 l=0.15 w=0.64 ad=0.2688 as=0.1888 pd=2.12 ps=1.87
XM25 a_850_74##14 CLK#1 VPWR#17 VPB sky130_fd_pr__pfet_01v8 l=0.15 w=1.12 ad=0.3304 as=0.336 pd=2.83 ps=2.84
XM34 VPWR#17 a_850_74##10 a_1023_74##13 VPB sky130_fd_pr__pfet_01v8 l=0.15 w=1.12 ad=0.336 as=0.3192 pd=2.84 ps=2.81
XM26 a_413_90##2 a_1023_74##3 a_1221_97##9 VPB sky130_fd_pr__pfet_01v8 l=0.15 w=0.42 ad=0.1197 as=0.126 pd=1.41 ps=1.44
XM30 a_1221_97##9 a_850_74##7 a_1328_463# VPB sky130_fd_pr__pfet_01v8 l=0.15 w=0.42 ad=0.126 as=0.1008 pd=1.44 ps=1.32
XM0 a_1328_463# a_1369_71##3 VPWR#16 VPB sky130_fd_pr__pfet_01v8 l=0.15 w=0.42 ad=0.1008 as=0.25245 pd=1.32 ps=2.21
XM21 VPWR#16 RESET_B#7 a_1221_97##8 VPB sky130_fd_pr__pfet_01v8 l=0.15 w=0.42 ad=0.25245 as=0.1197 pd=2.21 ps=1.41
XM1 VPWR#15 a_1221_97# a_1369_71##4 VPB sky130_fd_pr__pfet_01v8 l=0.15 w=1 ad=0.285 as=0.3 pd=2.57 ps=2.6
XM23 a_1369_71##4 a_850_74##2 a_1747_74##12 VPB sky130_fd_pr__pfet_01v8 l=0.15 w=1 ad=0.3 as=0.41485 pd=2.6 ps=3.51
XM11 a_1747_74##12 a_1023_74##6 a_1969_489# VPB sky130_fd_pr__pfet_01v8 l=0.15 w=0.42 ad=0.41485 as=0.1008 pd=3.51 ps=1.32
XM13 a_1969_489# a_2008_48##4 VPWR#14 VPB sky130_fd_pr__pfet_01v8 l=0.15 w=0.42 ad=0.1008 as=0.235725 pd=1.32 ps=2.02
XM7 VPWR#14 RESET_B#11 a_2008_48##8 VPB sky130_fd_pr__pfet_01v8 l=0.15 w=0.42 ad=0.235725 as=0.126 pd=2.02 ps=1.44
XM27 a_2008_48##8 a_1747_74##9 VPWR#13 VPB sky130_fd_pr__pfet_01v8 l=0.15 w=0.42 ad=0.126 as=0.4459 pd=1.44 ps=3.3
XM28 VPWR#13 a_1747_74##7 Q_N#1 VPB sky130_fd_pr__pfet_01v8 l=0.15 w=1.12 ad=0.4459 as=0.3304 pd=3.3 ps=2.83
XM31 a_2513_424##6 a_1747_74##5 VPWR#12 VPB sky130_fd_pr__pfet_01v8 l=0.15 w=0.84 ad=0.231 as=0.3878 pd=2.23 ps=2.98
XM41 VPWR#12 a_2513_424# Q#1 VPB sky130_fd_pr__pfet_01v8 l=0.15 w=1.12 ad=0.3878 as=0.308 pd=2.98 ps=2.79
*
*
*       RESISTOR AND CAP/DIODE CARDS
*
Rg1	a_27_74#	a_27_74##2	256.979279
Rg2	SCE#1	SCE#2	499.250305
Rg3	SCE#2	SCE#3	704.421387
Rg4	SCE#2	SCE#4	436.550201
Rg5	D#1	D#2	664.834229
Rg6	D#2	D#3	213.403732
Rg7	a_27_74##3	a_27_74##4	296.912354
Rg8	SCE#5	SCE#6	356.715973
Rg9	SCD#1	SCD#2	505.898010
Rg10	SCD#2	SCD#3	368.945282
Rg11	RESET_B#1	RESET_B#2	52.269611
Rg12	RESET_B#2	RESET_B#3	718.918396
Rg13	RESET_B#2	RESET_B#4	316.369873
Rg14	CLK#1	CLK#2	557.805908
Rg15	CLK#2	CLK#3	48.315460
Rg16	CLK#2	CLK#4	384.976074
Rg17	a_1023_74#	a_1023_74##2	699.079224
Rg18	a_1023_74##2	a_1023_74##3	337.898376
Rg19	a_1369_71#	a_1369_71##2	444.669281
Rg20	a_1369_71##2	a_1369_71##3	396.886108
Rg21	RESET_B#5	RESET_B#6	801.465088
Rg22	RESET_B#6	RESET_B#7	300.520020
Rg23	RESET_B#6	RESET_B#8	35.518757
Rg24	a_1221_97#	a_1221_97##2	535.071472
Rg25	a_1221_97##2	a_1221_97##3	371.549805
Rg26	a_1023_74##4	a_1023_74##5	663.972717
Rg27	a_850_74#	a_850_74##2	1277.102051
Rg28	a_850_74##2	a_850_74##3	1800.040405
Rg29	a_850_74##3	a_850_74##4	1524.029419
Rg30	a_850_74##4	a_850_74##5	177.194214
Rg31	a_850_74##5	a_850_74##6	269.511658
Rg32	a_850_74##3	a_850_74##7	283.919525
Rg33	a_850_74##4	a_850_74##8	496.162689
Rg34	a_850_74##5	a_850_74##9	39.736492
Rg35	a_850_74##9	a_850_74##10	455.274872
Rg36	a_1023_74##6	a_1023_74##7	255.499878
Rg37	a_2008_48#	a_2008_48##2	21.754395
Rg38	a_2008_48##2	a_2008_48##3	646.731018
Rg39	a_2008_48##2	a_2008_48##4	382.353119
Rg40	RESET_B#9	RESET_B#10	708.150146
Rg41	RESET_B#10	RESET_B#11	377.799286
Rg42	a_1747_74#	a_1747_74##2	454.941925
Rg43	a_1747_74##2	a_1747_74##3	171.794312
Rg44	a_1747_74##3	a_1747_74##4	72.431343
Rg45	a_1747_74##2	a_1747_74##5	489.813416
Rg46	a_1747_74##3	a_1747_74##6	342.423370
Rg47	a_1747_74##3	a_1747_74##7	459.973969
Rg48	a_1747_74##4	a_1747_74##8	358.187714
Rg49	a_1747_74##4	a_1747_74##9	615.418579
Rg50	a_2513_424#	a_2513_424##2	465.025360
Rg51	a_2513_424##2	a_2513_424##3	366.265259
Rf1	D	D#4	2.722190
Rf2	D#5	D#2	162.954987
Rf3	D#4	D#5	6.737742
Rf4	a_27_74##4	a_27_74##6	268.763763
Rf5	a_27_74##6	a_27_74##7	66.165756
Rf6	a_27_74##7	a_27_74##8	44.685257
Rf7	a_27_74##6	a_27_74##10	7.605762
Rf8	a_27_74##10	a_27_74##9	7.500000
Rf9	a_27_74##7	a_27_74##2	194.306183
Rf10	a_27_74##9	a_27_74##10	7.500000
Rf11	SCE#6	SCE	217.357773
Rf12	SCE	SCE#8	3.020737
Rf13	SCE#8	SCE	13.089859
Rf14	SCD	SCD#4	10.235490
Rf15	SCD#4	SCD	4.330400
Rf16	a_225_90#	a_225_90##2	195.411758
Rf17	RESET_B#1	RESET_B#13	161.093033
Rf18	RESET_B#14	RESET_B#15	0.860229
Rf19	RESET_B#13	RESET_B#14	5.117745
Rf20	CLK	CLK#5	0.881951
Rf21	CLK#6	CLK#3	80.998352
Rf22	CLK#5	CLK#6	8.118609
Rf23	a_850_74##9	a_850_74##12	165.960739
Rf24	a_850_74##12	a_850_74##13	87.111923
Rf25	a_850_74##12	a_850_74##14	69.581528
Rf26	a_413_90#	a_413_90##3	205.336960
Rf27	a_413_90##3	a_413_90##4	153.563553
Rf28	a_413_90##4	a_413_90##5	115.744736
Rf29	a_413_90##4	a_413_90##6	193.489929
Rf30	a_413_90##4	a_413_90##7	13.473324
Rf31	a_413_90##2	a_413_90##3	15.000000
Rf32	RESET_B#8	RESET_B#17	161.345215
Rf33	RESET_B#18	RESET_B#19	10.890196
Rf34	RESET_B#17	RESET_B#18	2.362036
Rf35	a_1221_97##2	a_1221_97##5	251.120514
Rf36	a_1221_97##5	a_1221_97##6	52.701687
Rf37	a_1221_97##6	a_1221_97##7	143.067825
Rf38	a_1221_97##5	a_1221_97##8	29.216021
Rf39	a_1221_97##6	a_1221_97##9	20.021067
Rf40	a_1369_71##4	a_1369_71##5	84.989281
Rf41	a_1369_71##5	a_1369_71##2	276.000671
Rf42	a_1369_71##5	a_1369_71##7	23.869717
Rf43	a_1023_74##7	a_1023_74##4	215.680634
Rf44	a_1023_74##4	a_1023_74##11	375.273773
Rf45	a_1023_74##11	a_1023_74##12	66.433456
Rf46	a_1023_74##12	a_1023_74##13	24.949038
Rf47	a_1023_74##12	a_1023_74##2	182.188858
Rf48	a_1023_74##10	a_1023_74##11	7.500000
Rf49	RESET_B#20	RESET_B#10	161.649857
Rf50	RESET_B	RESET_B#23	11.194840
Rf51	RESET_B#20	RESET_B#23	6.706677
Rf52	a_1747_74##10	a_1747_74##11	97.417061
Rf53	a_1747_74##11	a_1747_74##13	109.134377
Rf54	a_1747_74##13	a_1747_74##12	41.643314
Rf55	a_1747_74##11	a_1747_74##4	186.065079
Rf56	a_1747_74##12	a_1747_74##13	15.000000
Rf57	a_2008_48##5	a_2008_48##6	217.190613
Rf58	a_2008_48##6	a_2008_48#	229.488174
Rf59	a_2008_48##6	a_2008_48##8	21.516296
Rf60	Q_N	Q_N#2	13.384872
Rf61	Q_N#2	Q_N	1.181018
Rf62	Q_N	Q_N#4	7.282945
Rf63	Q_N#4	Q_N	7.282945
Rf64	Q_N#1	Q_N#2	5.000000
Rf65	Q_N#3	Q_N#4	7.500000
Rf66	a_2513_424##2	a_2513_424##5	181.371292
Rf67	a_2513_424##5	a_2513_424##6	55.928963
Rf68	a_2513_424##5	a_2513_424##7	51.894482
Rf69	Q	Q#2	0.229974
Rf70	Q#2	Q	16.788086
Rf71	Q	Q#4	6.615660
Rf72	Q#4	Q	6.615660
Rf73	Q#1	Q#2	5.000000
Rf74	Q#3	Q#4	7.500000
Rf75	VPWR#1	VPWR#2	36.169212
Rf76	VPWR#2	VPWR#3	116.277672
Rf77	VPWR#3	VPWR#4	81.353928
Rf78	VPWR#4	VPWR#5	29.004652
Rf79	VPWR#5	VPWR#6	125.679665
Rf80	VPWR#6	VPWR#7	80.729080
Rf81	VPWR#7	VPWR#8	174.176361
Rf82	VPWR#8	VPWR#9	110.902649
Rf83	VPWR#9	VPWR#10	145.893829
Rf85	VPWR#2	VPWR#12	43.889961
Rf86	VPWR#3	VPWR#13	36.385578
Rf87	VPWR#4	VPWR#14	30.868931
Rf88	VPWR#6	VPWR#15	56.701656
Rf89	VPWR#7	VPWR#16	31.554951
Rf90	VPWR#8	VPWR#17	33.129639
Rf91	VPWR#9	VPWR#18	33.806259
Rf92	VPWR#10	VPWR#19	30.747387
Rf93	VGND#1	VGND#2	34.797028
Rf94	VGND#2	VGND#3	111.840767
Rf95	VGND#3	VGND#4	98.203850
Rf96	VGND#4	VGND#5	18.238092
Rf97	VGND#5	VGND#6	180.775436
Rf98	VGND#6	VGND#7	203.031311
Rf99	VGND#7	VGND#8	72.270927
Rf100	VGND#8	VGND#9	34.674454
Rf101	VGND#9	VGND#10	193.559280
Rf103	VGND#2	VGND#12	56.430489
Rf104	VGND#3	VGND#13	24.468842
Rf105	VGND#4	VGND#14	34.507496
Rf106	VGND#6	VGND#15	25.059351
Rf107	VGND#7	VGND#16	33.326477
Rf108	VGND#8	VGND#17	34.704330
Rf109	VGND#10	VGND#18	34.507496
Rf114	SCE#2	SCE#8	53.410934
Rf115	SCD#2	SCD#4	80.116402
Re2	RESET_B	RESET_B#19	4.743838
Re3	RESET_B#19	RESET_B#15	16.168276
Re4	VPWR#1	VPWR#21	11.160645
Re5	VPWR#21	VPWR	1.198481
Re6	VPWR	VPWR#9	2.081275
Re7	VGND#1	VGND#20	11.160645
Re8	VGND#20	VGND	1.198481
Re9	VGND	VGND#9	2.081275
Re14	VPWR#5	VPWR#21	0.698413
Re17	VGND#5	VGND#20	0.698413
*
*       CAPACITOR CARDS
*
*
C1	RESET_B#19	VPWR#7	6.4865e-18
C2	a_413_90##2	VPWR#7	6.86961e-19
C3	RESET_B#3	CLK#4	5.48754e-18
C4	a_1369_71##2	a_1369_71##5	1.30005e-18
C5	a_225_90#	SCD#1	2.48226e-17
C6	a_2513_424##7	a_2513_424##3	3.02921e-18
C7	a_1747_74##4	a_1747_74##9	2.43379e-18
C8	VGND#14	VGND#3	1.75632e-18
C9	a_1023_74##4	RESET_B#6	3.65648e-19
C10	a_2513_424##2	VGND#12	2.96026e-17
C11	VGND#7	a_850_74##8	3.22506e-18
C12	a_850_74##5	a_850_74##8	2.23174e-19
C13	a_1023_74##10	a_1221_97##7	9.56133e-17
C14	a_413_90##6	RESET_B#3	2.31618e-17
C15	a_1221_97##6	a_1369_71##2	2.94874e-17
C16	RESET_B#19	VPWR#6	7.43049e-18
C17	a_27_74##4	a_413_90##5	6.00663e-17
C18	SCE#4	SCE#1	2.82315e-17
C19	a_1747_74#	VGND#12	2.08573e-17
C20	a_2008_48##6	a_1747_74##5	3.92734e-20
C21	a_413_90##2	a_850_74##10	2.62939e-17
C22	a_850_74##12	CLK#1	9.77201e-19
C23	a_413_90##4	VPWR#17	2.82757e-17
C24	VPWR#3	a_2008_48##4	3.94761e-19
C25	RESET_B#10	a_1747_74##9	8.33936e-18
C26	a_2513_424##7	VGND#12	3.34592e-17
C27	a_1369_71##2	a_1221_97##5	9.80164e-18
C28	VPWR#17	a_1023_74##3	1.26182e-18
C29	a_850_74##12	a_850_74##6	9.18289e-18
C30	a_1747_74##12	a_2008_48##6	2.32433e-17
C31	a_413_90##4	RESET_B#4	3.64068e-17
C32	a_2008_48##5	a_1747_74##3	9.83682e-18
C33	VPWR#13	Q_N#1	6.62452e-17
C34	a_850_74##12	a_1023_74##13	5.59635e-19
C35	VGND#5	VGND#3	3.36626e-19
C36	a_850_74##10	a_1023_74##13	1.59795e-17
C37	VPWR#6	a_1023_74##6	4.68003e-19
C38	a_225_90#	SCE#5	1.08559e-17
C39	a_2008_48##6	a_1747_74##3	1.04389e-17
C40	a_1747_74##12	a_1969_489#	1.64285e-18
C41	a_2513_424##7	a_1747_74#	1.81018e-17
C42	a_850_74##14	a_1023_74##3	1.68152e-19
C43	a_2008_48#	a_1747_74##9	4.61658e-19
C44	SCD#1	RESET_B#3	2.72998e-17
C45	a_1023_74##10	a_413_90#	7.7762e-17
C46	a_413_90##6	SCD#1	2.60922e-17
C47	a_413_90##2	CLK#1	1.00981e-18
C48	a_1747_74##12	a_2008_48##2	4.07481e-18
C49	a_413_90##5	VPWR#18	8.25332e-18
C50	a_2008_48##4	RESET_B#10	1.85979e-18
C51	VPWR#17	a_850_74##10	3.55437e-17
C52	VGND#12	a_1747_74##6	1.31374e-18
C53	VGND#6	RESET_B#6	1.82645e-20
C54	a_2008_48#	RESET_B#11	1.04174e-18
C55	a_1221_97##6	a_1023_74##2	5.25808e-18
C56	a_1221_97##2	a_850_74##3	1.54506e-19
C57	RESET_B#15	a_850_74##10	4.33658e-18
C58	a_413_90##6	a_413_90##4	1.38433e-18
C59	a_850_74##5	a_850_74##4	1.73827e-17
C60	VGND#7	a_850_74##6	3.78885e-18
C61	VPWR#9	a_1023_74##3	4.16324e-18
C62	a_413_90##4	a_850_74##14	3.51233e-17
C63	a_2008_48##5	a_1966_74#	7.61095e-22
C64	a_2008_48#	a_2008_48##4	1.07594e-18
C65	a_2008_48##6	a_1747_74##7	2.952e-18
C66	VGND#9	a_850_74##7	3.21904e-19
C67	a_413_90##4	RESET_B#3	4.68517e-19
C68	a_1221_97##5	a_1023_74##2	1.9677e-19
C69	a_850_74##14	a_850_74##10	1.07785e-18
C70	a_850_74##12	CLK#4	1.64392e-18
C71	a_225_90#	D#3	4.92739e-19
C72	a_1221_97##2	RESET_B#6	4.06685e-17
C73	RESET_B#15	CLK#1	1.50518e-18
C74	a_413_90##4	SCD#3	2.40846e-17
C75	a_413_90##2	RESET_B#4	3.73461e-19
C76	a_850_74##12	VPWR#17	1.63523e-18
C77	VPWR#9	a_850_74##10	4.68955e-18
C78	a_2513_424##7	a_1747_74##6	1.0408e-18
C79	a_413_90##6	SCE#5	3.3008e-17
C80	VPWR#17	CLK#1	3.5749e-17
C81	RESET_B#15	a_413_90#	3.48638e-18
C82	a_2008_48##6	a_1747_74##2	1.94912e-20
C83	a_1023_74##7	a_2008_48##4	8.3545e-18
C84	a_850_74##2	a_2008_48##2	1.59244e-17
C85	VPWR#7	VPWR#6	3.7378e-19
C86	VPWR#6	a_850_74##2	4.97093e-17
C87	SCE#5	SCD#1	3.41251e-17
C88	D#3	RESET_B#3	2.08339e-19
C89	a_225_90##2	SCD#1	1.97755e-19
C90	VPWR#9	CLK#1	4.66462e-18
C91	VGND#8	CLK#4	8.84231e-19
C92	RESET_B#15	a_1023_74##10	6.02237e-18
C93	a_2008_48##5	a_1747_74##4	6.63516e-17
C94	Q_N#1	VGND#12	4.37439e-18
C95	a_850_74##14	CLK#1	3.61957e-17
C96	RESET_B#3	CLK#3	7.48549e-18
C97	VPWR#19	VPWR#18	1.46379e-19
C98	VPWR#9	RESET_B#4	5.21101e-18
C99	a_225_90#	a_27_74#	2.80357e-19
C100	a_1747_74##6	Q_N#3	2.14489e-17
C101	VPWR#4	a_850_74##2	3.27189e-19
C102	RESET_B#15	VGND#16	2.73023e-18
C103	VPWR#17	RESET_B#4	3.20874e-18
C104	a_413_90##4	a_413_90##7	2.46789e-18
C105	a_850_74##2	a_1023_74##7	3.18774e-17
C106	VPWR#19	SCE#2	8.5897e-19
C107	a_1369_71##4	a_2008_48##2	9.86903e-20
C108	D#3	a_413_90##6	1.32158e-17
C109	a_850_74##12	RESET_B#3	2.23322e-19
C110	VGND#16	a_1023_74##10	3.63849e-17
C111	VGND#7	CLK#4	1.22302e-18
C112	a_2008_48##6	a_1747_74##9	3.58543e-17
C113	VPWR#9	SCD#3	4.43631e-18
C114	a_413_90##4	a_27_74##3	4.85425e-19
C115	a_1747_74##11	a_1747_74##12	4.7261e-19
C116	a_850_74##12	a_850_74##14	2.08559e-19
C117	RESET_B#15	a_850_74##13	3.20683e-18
C118	a_1747_74##11	a_1747_74##8	8.19142e-18
C119	a_225_90##2	SCE#5	8.3759e-19
C120	a_413_90##6	a_850_74##12	1.26355e-18
C121	a_1023_74##4	a_850_74##2	5.85736e-17
C122	Q_N#1	a_2513_424##7	4.34905e-17
C123	a_1221_97##6	a_850_74##4	5.94974e-19
C124	a_1747_74##6	VGND#13	1.16864e-18
C125	VPWR#9	a_27_74##3	6.27442e-18
C126	VPWR#18	CLK#1	8.29739e-19
C127	D#3	SCE#5	1.08194e-17
C128	a_2008_48##6	a_2008_48##2	6.57007e-19
C129	RESET_B#15	VGND#17	2.56625e-18
C130	VPWR#17	SCD#3	2.58824e-19
C131	a_2513_424##5	Q#3	6.48575e-19
C132	VGND#9	a_1221_97##7	1.16475e-17
C133	VGND#8	VGND#7	1.24564e-18
C134	CLK#4	a_850_74##5	7.3158e-19
C135	VPWR#6	a_1221_97#	1.23652e-18
C136	a_1023_74##4	a_1221_97#	5.35844e-19
C137	a_850_74##13	a_850_74##14	2.52363e-18
C138	RESET_B#4	a_413_90##7	2.12821e-17
C139	RESET_B#15	VPWR#8	9.09274e-18
C140	VGND#9	VGND#8	6.50079e-17
C141	SCD#2	RESET_B#3	2.32469e-18
C142	VPWR#9	D#1	1.48494e-18
C143	a_413_90##6	a_27_74#	1.7287e-18
C144	a_1221_97##2	a_850_74##2	2.96761e-18
C145	VGND#8	RESET_B#3	1.38567e-18
C146	a_850_74##13	a_1023_74##10	2.34428e-18
C147	VGND#9	a_413_90#	1.18042e-17
C148	a_413_90##4	VPWR#18	6.21719e-17
C149	VGND#6	a_850_74##7	2.39113e-20
C150	VPWR#19	a_413_90##5	2.11125e-17
C151	a_2008_48##5	a_1747_74##6	1.16868e-17
C152	VGND#9	VGND#7	1.06449e-16
C153	a_225_90##2	D#3	1.59489e-17
C154	a_1369_71##5	RESET_B#6	5.738e-19
C155	VPWR#9	SCE#1	7.21112e-19
C156	a_1221_97##2	a_1221_97#	4.08145e-19
C157	RESET_B#4	VPWR#18	2.06529e-17
C158	Q_N#1	Q_N#3	2.98955e-18
C159	RESET_B#6	a_850_74##2	1.22666e-18
C160	a_413_90##4	D#1	1.31526e-19
C161	VGND#9	a_1023_74##10	5.64554e-17
C162	a_2008_48##6	RESET_B#11	2.92974e-17
C163	SCE#6	RESET_B#3	5.60918e-19
C164	VGND#9	VGND#6	2.80912e-17
C165	VPWR#9	SCE#4	8.21609e-19
C166	a_1747_74##11	RESET_B#9	1.39122e-17
C167	VPWR#7	RESET_B#7	1.93632e-18
C168	a_27_74#	D#3	1.67983e-17
C169	SCE#6	SCD#1	9.97556e-18
C170	a_1221_97##6	a_850_74##3	1.05464e-17
C171	VGND#9	VGND#16	1.6207e-17
C172	a_413_90##6	SCE#3	7.30144e-19
C173	a_1023_74##5	a_850_74##2	2.3842e-19
C174	a_850_74##13	VGND#16	4.00114e-17
C175	VPWR#18	SCD#3	3.00494e-17
C176	a_1747_74##2	a_2513_424##3	2.96545e-18
C177	a_2513_424##5	VGND#12	6.05217e-18
C178	a_1369_71##2	a_850_74##3	8.55808e-19
C179	a_1221_97#	a_850_74#	5.56325e-19
C180	a_225_90##2	a_27_74#	4.2012e-17
C181	a_850_74##4	a_850_74##3	1.83515e-19
C182	VGND#9	a_850_74##13	1.14105e-17
C183	a_413_90##5	RESET_B#4	2.1704e-19
C184	a_2008_48##5	a_1747_74##8	3.42785e-17
C185	RESET_B#19	VPWR#5	6.15754e-19
C186	VPWR#9	VPWR#8	1.25739e-16
C187	RESET_B#20	a_1747_74##8	3.38551e-19
C188	a_1369_71##2	RESET_B#6	3.03652e-17
C189	a_27_74##8	D#3	2.18407e-20
C190	a_413_90##5	a_512_464#	1.01111e-17
C191	a_1023_74##10	a_1399_97#	3.83495e-18
C192	a_413_90##4	SCE#1	9.22388e-20
C193	VGND#14	a_1747_74##6	3.53319e-19
C194	a_1023_74##5	a_1221_97#	9.19693e-18
C195	VPWR#9	VPWR#7	4.60411e-17
C196	CLK#3	a_413_90##4	5.65513e-18
C197	VGND#18	a_27_74#	1.01399e-18
C198	SCE#6	SCE#3	9.04423e-20
C199	VPWR#18	a_27_74##3	3.20228e-18
C200	VPWR#16	RESET_B#5	3.69551e-19
C201	a_2008_48##6	a_2008_48##4	5.73501e-18
C202	VGND#9	a_225_90#	1.39985e-16
C203	SCE#3	a_27_74#	4.26675e-18
C204	VGND#17	RESET_B#2	2.39555e-19
C205	a_413_90##5	SCD#3	2.32144e-18
C206	a_1747_74##11	a_2008_48##3	1.40762e-17
C207	VGND#17	VGND#16	2.66002e-18
C208	a_1221_97##6	RESET_B#6	1.73721e-18
C209	a_225_90##2	SCE#3	2.58002e-18
C210	a_2008_48##5	Q_N#1	7.40731e-17
C211	VGND#3	Q_N#1	2.92945e-17
C212	VPWR#7	a_1369_71##3	1.22748e-18
C213	RESET_B#6	a_1221_97#	1.15679e-17
C214	a_2513_424##2	VPWR#1	2.45021e-18
C215	D#2	SCE#5	4.03489e-18
C216	CLK#3	a_850_74##12	4.54027e-17
C217	a_2008_48##5	RESET_B#9	3.64567e-18
C218	a_27_74##8	a_27_74#	7.86467e-20
C219	a_1369_71##4	RESET_B#6	1.7596e-20
C220	VPWR#18	VPWR#8	1.20729e-19
C221	a_1023_74##2	a_1369_71##3	8.3678e-19
C222	VGND#17	RESET_B#13	6.91295e-18
C223	RESET_B#19	VPWR#9	1.78694e-17
C224	a_1747_74##10	a_850_74##2	3.03686e-19
C225	VGND#14	a_2008_48##2	8.55472e-19
C226	VGND#1	a_2513_424##2	2.28015e-18
C227	a_1221_97##5	a_850_74##3	1.26451e-18
C228	VPWR#18	D#1	2.443e-19
C229	a_413_90##5	a_413_90##4	1.4389e-18
C230	a_413_90##6	a_850_74##5	6.71759e-20
C231	a_850_74##4	a_1023_74##2	5.24142e-17
C232	VGND#9	a_413_90##6	2.06021e-17
C233	SCD	RESET_B#2	6.3262e-18
C234	VGND#18	SCE#3	2.9699e-17
C235	VGND#14	a_1747_74##8	3.88753e-18
C236	a_27_74#	D#2	1.7606e-19
C237	a_1023_74##2	a_850_74##7	3.77769e-18
C238	a_413_90##5	a_27_74##3	5.05778e-17
C239	a_1747_74##12	VPWR#14	1.03447e-17
C240	VGND#2	a_2513_424##5	3.55186e-19
C241	VPWR#19	SCD#3	1.43788e-19
C242	a_1023_74##2	a_850_74##3	1.16121e-18
C243	a_2008_48##5	VGND#13	7.57742e-18
C244	VGND#17	a_850_74##13	3.08586e-17
C245	a_413_90##4	RESET_B#1	9.46762e-18
C246	SCE#3	D#2	2.19704e-19
C247	RESET_B#19	a_1747_74##12	3.07413e-17
C248	VGND#2	a_2513_424##2	4.74053e-19
C249	a_1221_97##7	a_1321_97#	3.08847e-18
C250	a_27_74##8	SCE#3	1.25858e-17
C251	VPWR#15	a_850_74##3	2.18839e-19
C252	a_1747_74##11	a_850_74#	1.85668e-17
C253	VPWR#18	SCE#1	1.23628e-19
C254	a_2008_48##5	a_2008_48##3	3.18814e-19
C255	VGND#9	a_225_90##2	4.72667e-17
C256	a_1023_74##4	VGND#14	2.57619e-18
C257	RESET_B#7	a_850_74##3	2.16667e-17
C258	a_413_90##4	a_850_74##12	5.61393e-18
C259	a_413_90##5	D#1	3.77427e-17
C260	RESET_B#19	a_1369_71##4	3.71684e-17
C261	SCE#3	a_27_74##2	8.28108e-18
C262	RESET_B#15	VPWR#9	5.43763e-17
C263	VPWR#19	a_27_74##3	2.90066e-19
C264	VGND#14	RESET_B#9	2.64558e-17
C265	VPWR#8	a_850_74##5	1.28262e-19
C266	a_1221_97##5	RESET_B#6	1.32945e-17
C267	RESET_B#19	VPWR#15	6.53652e-17
C268	VGND#9	RESET_B#15	1.38411e-18
C269	a_1747_74##12	VPWR#5	1.86316e-17
C270	a_1023_74##4	a_1747_74##10	8.32096e-17
C271	a_1747_74##10	a_1747_74##8	5.07639e-19
C272	VPWR#4	VPWR#3	1.0101e-18
C273	RESET_B#19	a_850_74##3	8.49488e-19
C274	VGND#9	a_27_74##8	1.69111e-17
C275	VPWR#15	RESET_B#6	4.63272e-18
C276	a_413_90##4	SCD#2	1.05485e-17
C277	a_413_90##5	SCE#1	5.3744e-18
C278	RESET_B#13	CLK#3	1.16817e-18
C279	CLK#3	a_850_74##10	1.95887e-18
C280	VGND#3	a_1747_74##4	2.15844e-18
C281	RESET_B#19	a_1221_97##8	1.59773e-17
C282	a_1023_74##4	a_1369_71##7	1.19519e-19
C283	VPWR#19	D#1	5.23025e-18
C284	a_2008_48##5	a_850_74#	2.42304e-19
C285	RESET_B#19	RESET_B#6	1.02553e-17
C286	VPWR#8	a_1023_74##3	2.24191e-19
C287	a_1023_74##4	VGND#15	6.04137e-17
C288	a_1747_74##6	a_1747_74##2	2.62094e-19
C289	VGND#14	a_2008_48##3	2.37279e-17
C290	RESET_B#19	VPWR#16	5.13205e-18
C291	VGND#5	RESET_B#10	4.15171e-19
C292	RESET_B#6	a_850_74##3	1.62367e-18
C293	a_225_90#	VGND#17	4.37848e-17
C294	VGND#5	a_1747_74##11	4.71855e-18
C295	RESET_B#1	CLK#1	9.72134e-18
C296	VPWR#7	a_1023_74##3	2.08077e-18
C297	a_1747_74##8	a_2124_74#	8.8457e-18
C298	a_1747_74##10	RESET_B#9	8.51201e-19
C299	a_1747_74##11	a_2008_48##2	2.45216e-17
C300	VPWR#19	SCE#1	4.03051e-17
C301	a_1369_71##5	VGND#15	5.53778e-19
C302	a_1221_97##8	a_850_74##3	7.17235e-18
C303	VPWR#5	a_1023_74##7	2.93288e-19
C304	VPWR#8	a_850_74##4	2.12341e-19
C305	a_1369_71##3	a_850_74##3	1.8235e-17
C306	RESET_B#9	a_2124_74#	8.8457e-18
C307	RESET_B#19	a_1023_74##4	1.31442e-17
C308	a_27_74##6	SCD#3	9.70018e-20
C309	a_1747_74#	a_2513_424##3	2.8748e-17
C310	a_413_90#	a_1023_74##12	8.3964e-18
C311	a_1369_71##4	a_1747_74##12	8.65937e-17
C312	a_1747_74##5	a_2513_424#	3.37077e-17
C313	SCE#6	a_413_90##4	3.03345e-18
C314	RESET_B#13	RESET_B#1	1.3631e-17
C315	VGND#5	a_1023_74##7	1.58842e-19
C316	a_2513_424#	Q#1	1.04433e-20
C317	a_1221_97##2	RESET_B#19	2.89869e-17
C318	a_2513_424##2	VPWR#12	3.5916e-17
C319	a_1369_71##3	RESET_B#6	5.05015e-18
C320	VGND#14	a_850_74#	4.90535e-18
C321	RESET_B#13	a_413_90##7	2.84535e-18
C322	a_413_90##6	a_850_74##13	8.18326e-18
C323	SCE#4	VPWR#19	1.94403e-17
C324	VGND#5	a_1023_74##4	1.45202e-17
C325	RESET_B#19	a_413_90##2	3.70348e-17
C326	a_1221_97##8	RESET_B#6	7.25125e-18
C327	CLK#3	a_850_74##5	3.31304e-17
C328	a_2513_424##2	VPWR#2	1.65446e-19
C329	VPWR#8	a_850_74##10	3.83532e-18
C330	VGND#14	a_2008_48##5	1.56376e-17
C331	a_1747_74##10	a_2008_48##3	4.65364e-18
C332	a_1747_74##11	a_850_74##2	3.84127e-18
C333	a_2513_424#	VPWR#12	2.38662e-17
C334	RESET_B#19	a_1369_71##5	8.01489e-18
C335	CLK	RESET_B#2	2.56747e-18
C336	SCE#4	a_27_74##9	1.64561e-17
C337	a_1023_74##10	a_1023_74##4	2.17716e-18
C338	a_27_74##6	a_27_74##3	1.27061e-19
C339	RESET_B#19	a_1369_71##2	2.36969e-17
C340	a_1747_74##4	RESET_B#10	5.12505e-17
C341	VGND#7	a_1023_74##10	7.86859e-17
C342	a_1747_74##7	a_1747_74##5	7.0473e-18
C343	D#1	SCD#2	1.44164e-19
C344	RESET_B#19	a_1221_97##6	4.66101e-17
C345	a_1023_74##10	a_1023_74##12	4.12619e-18
C346	a_413_90##6	a_413_90##5	3.20446e-18
C347	a_27_74##4	a_413_90##4	3.05609e-18
C348	VPWR#8	a_850_74##3	1.64711e-17
C349	VPWR#3	a_1747_74##3	3.13047e-19
C350	a_1747_74##6	a_1747_74#	5.30395e-18
C351	a_2513_424##6	a_2513_424#	1.46459e-18
C352	VGND#14	a_1023_74##5	4.80922e-19
C353	a_2008_48##3	a_1966_74#	8.8457e-18
C354	a_2008_48##4	a_1969_489#	7.463e-18
C355	RESET_B#19	a_1023_74##2	1.30551e-17
C356	VPWR#16	a_850_74##3	2.37647e-17
C357	VPWR#3	VPWR#2	7.68368e-19
C358	a_27_74##4	SCD#3	7.15046e-18
C359	a_850_74#	a_1966_74#	8.8457e-18
C360	RESET_B#19	a_1221_97##5	3.65101e-17
C361	a_850_74##3	a_850_74##7	7.17477e-19
C362	VGND#8	VGND#16	5.14775e-20
C363	VPWR#15	a_1369_71##4	7.21332e-17
C364	a_1023_74##6	a_1969_489#	7.463e-18
C365	a_1747_74##5	VPWR#12	2.5707e-17
C366	VPWR#3	a_1747_74##4	7.22704e-20
C367	a_1747_74##10	a_850_74#	3.9329e-17
C368	a_2008_48#	RESET_B#10	9.66384e-18
C369	VPWR#2	VPWR#12	4.17704e-18
C370	Q_N#1	a_1747_74##4	1.24749e-18
C371	RESET_B#2	CLK#3	9.32639e-18
C372	a_2513_424##5	a_2513_424##2	5.55e-19
C373	VGND#6	a_1023_74##10	7.3537e-17
C374	a_27_74##4	D#1	5.3277e-17
C375	D#5	a_312_90#	6.74919e-20
C376	VPWR#8	CLK#1	3.83222e-18
C377	a_27_74##6	D#1	4.39384e-19
C378	a_1747_74##9	a_1747_74##7	1.95813e-17
C379	a_2513_424##6	a_1747_74##5	6.92125e-17
C380	a_1747_74##4	VPWR#13	5.04879e-18
C381	a_225_90#	a_413_90##6	9.4431e-17
C382	a_27_74##4	SCE#1	2.59104e-19
C383	RESET_B#15	a_1023_74##2	5.92781e-18
C384	VGND#14	a_1221_97##3	1.15311e-20
C385	a_1221_97##6	VPWR#7	1.54827e-17
C386	VPWR#9	a_1023_74##2	2.50556e-19
C387	a_1747_74##8	a_1747_74##6	2.61016e-18
C388	RESET_B#15	a_1023_74##12	4.05881e-17
C389	a_1023_74##5	a_1747_74##10	1.94833e-17
C390	VPWR#4	RESET_B#10	1.88809e-20
C391	Q_N#1	a_1747_74##5	2.0366e-18
C392	VGND#3	a_2513_424##3	3.31692e-19
C393	RESET_B#15	a_413_90##2	2.68583e-17
C394	VGND#9	a_1023_74##2	3.01948e-18
C395	a_850_74##4	a_1023_74##3	1.64797e-17
C396	a_1369_71##3	a_1328_463#	1.78716e-18
C397	VPWR#7	a_850_74##3	4.7902e-17
C398	VGND#15	a_850_74#	8.49612e-20
C399	RESET_B#15	CLK#3	1.41771e-17
C400	VPWR#3	RESET_B#10	6.95895e-20
C401	a_2513_424##6	a_1747_74##7	1.56553e-18
C402	VPWR#2	a_1747_74##3	4.04842e-21
C403	VGND#8	a_850_74##13	5.97533e-18
C404	RESET_B#19	RESET_B#17	1.02356e-17
C405	a_2513_424##6	VPWR#2	3.17814e-17
C406	a_1221_97##7	a_1369_71##2	6.1595e-17
C407	a_27_74##6	SCE#1	2.00822e-17
C408	a_850_74##7	a_1328_463#	6.58677e-18
C409	a_1221_97##8	VPWR#15	2.91023e-17
C410	RESET_B#11	a_1747_74##9	2.76828e-17
C411	VPWR#9	CLK#3	5.86156e-19
C412	VGND#8	CLK	1.04568e-18
C413	SCE#2	D#1	7.35075e-18
C414	RESET_B#5	a_1399_97#	3.85381e-18
C415	a_1023_74##5	a_1369_71##7	1.24533e-17
C416	a_850_74##3	a_1023_74##3	2.32509e-17
C417	VGND#1	a_2513_424##3	4.45485e-18
C418	RESET_B#15	RESET_B#1	6.69131e-18
C419	a_413_90#	a_1369_71##2	7.47254e-19
C420	a_1221_97##7	a_1369_71##5	1.92041e-18
C421	VGND#2	a_2513_424##3	4.7812e-18
C422	a_1369_71#	a_1399_97#	5.61175e-18
C423	SCE#2	SCE#1	6.07944e-18
C424	VGND#9	CLK#3	4.49766e-18
C425	RESET_B#15	VPWR#17	2.8936e-18
C426	a_1221_97##7	a_850_74##7	4.51184e-20
C427	Q_N#1	a_1747_74##7	2.47524e-17
C428	RESET_B#15	a_850_74##4	1.48096e-18
C429	a_413_90##4	a_850_74##5	2.08172e-19
C430	VPWR#9	a_413_90##2	2.27311e-17
C431	a_1023_74##4	a_1221_97##2	1.41507e-18
C432	VPWR#9	RESET_B#1	1.46253e-18
C433	VPWR#3	Q_N#1	3.20048e-17
C434	VPWR#14	RESET_B#10	4.14085e-19
C435	a_1023_74##10	a_1369_71##2	2.51812e-17
C436	SCD	a_413_90##4	8.00352e-17
C437	D#5	SCD#2	6.27534e-21
C438	a_27_74##7	a_27_74##6	6.39744e-18
C439	Q	a_1747_74##2	4.68493e-19
C440	a_1221_97##5	VPWR#7	9.81245e-19
C441	RESET_B#15	a_850_74##14	5.8179e-17
C442	VPWR#9	a_1023_74##12	3.54729e-18
C443	a_1747_74##11	a_2008_48##6	4.1452e-18
C444	VGND#15	a_1023_74##5	3.09936e-19
C445	VGND#7	a_850_74##13	8.7779e-18
C446	RESET_B#9	a_1747_74##8	5.25186e-17
C447	D#5	RESET_B#3	1.77615e-19
C448	VPWR#16	VPWR#15	4.86878e-18
C449	VGND#6	a_1023_74##4	6.95598e-17
C450	a_1221_97##7	a_1023_74##2	2.96877e-18
C451	a_1747_74##7	VPWR#13	2.29406e-17
C452	VGND#3	a_1747_74#	7.26271e-19
C453	a_27_74##6	SCE#4	3.9005e-17
C454	RESET_B#17	a_850_74##3	3.31821e-19
C455	a_1023_74##4	a_1369_71##2	2.10948e-17
C456	VGND#9	SCD#2	2.98889e-20
C457	a_2008_48##4	RESET_B#11	1.4114e-17
C458	a_1221_97##3	a_1369_71##7	1.24533e-17
C459	VPWR#9	VPWR#17	1.01817e-18
C460	VPWR#9	SCE#6	4.62776e-18
C461	a_1747_74##12	RESET_B#10	1.89279e-19
C462	a_413_90#	a_1023_74##2	3.17236e-17
C463	VGND#7	a_850_74##12	5.30885e-19
C464	a_1221_97##7	a_1221_97##6	3.23027e-19
C465	VPWR#7	RESET_B#6	3.90236e-19
C466	Q_N#1	a_1747_74##9	7.28346e-19
C467	VPWR#2	a_1747_74##2	4.1918e-19
C468	RESET_B#15	a_27_74##4	3.70659e-18
C469	a_1023_74##10	a_850_74##7	1.09135e-19
C470	a_1369_71##2	a_1221_97##2	6.24927e-17
C471	a_1369_71##5	a_850_74#	5.2653e-19
C472	a_850_74##10	a_850_74##4	3.07689e-17
C473	VGND#9	SCE#6	4.87596e-18
C474	a_1369_71##5	VPWR#15	9.07932e-18
C475	SCD#3	a_512_464#	1.59617e-17
C476	a_1023_74##10	a_1023_74##2	5.8873e-19
C477	a_1747_74##10	VGND#14	1.73904e-17
C478	VPWR#9	a_850_74##14	2.51858e-18
C479	VPWR#9	a_27_74##4	1.03033e-17
C480	a_1369_71#	a_1321_97#	2.39305e-18
C481	VPWR#6	a_850_74##3	3.82491e-18
C482	a_413_90##4	a_850_74##4	2.02997e-19
C483	VPWR#16	a_1221_97##8	1.03534e-17
C484	D#5	SCE#6	1.35687e-17
C485	a_27_74##3	a_512_464#	1.59617e-17
C486	a_1023_74#	a_1321_97#	7.46324e-18
C487	a_27_74##7	D#3	1.61665e-19
C488	VGND#2	a_1747_74#	6.41085e-18
C489	a_1747_74##9	VPWR#13	1.79688e-17
C490	a_1221_97##3	VGND#15	1.33242e-17
C491	VGND#9	a_27_74##4	3.54675e-20
C492	RESET_B#20	a_2008_48##2	3.56814e-18
C493	a_2008_48##6	a_1747_74##4	5.18066e-17
C494	VPWR#3	VPWR#13	2.49517e-18
C495	a_850_74##10	a_850_74##3	2.10562e-17
C496	D#5	SCD#1	2.47248e-19
C497	a_27_74##6	a_27_74##4	2.4578e-19
C498	a_413_90##2	a_850_74##5	5.02853e-19
C499	a_1747_74##12	a_2008_48#	1.78141e-17
C500	VPWR#14	a_1747_74##7	8.89867e-19
C501	a_2513_424##5	VPWR#12	6.61891e-18
C502	VGND#9	a_1023_74##12	2.47767e-18
C503	a_1023_74##6	a_2008_48##4	3.18043e-17
C504	SCD#2	RESET_B#2	4.63311e-17
C505	a_2008_48##3	RESET_B#9	4.05457e-17
C506	VPWR#9	VPWR#18	1.79127e-17
C507	a_1023_74##2	a_1369_71##2	2.47015e-17
C508	RESET_B#17	RESET_B#6	8.62216e-18
C509	VGND#9	a_850_74##14	3.30081e-18
C510	D#1	a_338_464#	1.62684e-17
C511	a_1747_74##9	a_2008_48##8	8.89917e-18
C512	VGND#6	a_1221_97##2	1.42574e-19
C513	a_413_90#	a_1221_97##6	1.62995e-18
C514	VGND#3	a_1747_74##6	1.62165e-17
C515	SCE#1	a_338_464#	1.62684e-17
C516	VGND#9	a_27_74##2	6.48149e-18
C517	VPWR#9	a_850_74##3	2.46778e-18
C518	a_1369_71##5	a_850_74##2	3.49548e-19
C519	VPWR#9	SCE#2	2.24147e-18
C520	a_1369_71##5	a_1023_74##5	2.37757e-17
C521	a_225_90##2	a_413_90##6	6.80642e-18
C522	a_413_90##2	a_850_74##4	2.25404e-17
C523	RESET_B#5	VGND#15	1.91258e-17
C524	a_413_90##4	a_850_74##3	2.63459e-19
C525	a_27_74##7	a_27_74#	5.56819e-19
C526	a_27_74##7	D#2	2.12951e-19
C527	a_1747_74##12	a_1023_74##7	8.95545e-17
C528	a_27_74##7	SCE	2.30027e-17
C529	VPWR#14	a_1747_74##9	1.3543e-18
C530	VGND#9	SCE#2	3.06392e-18
C531	a_1747_74##11	a_1747_74##4	7.51063e-18
C532	a_27_74##6	SCE	5.91667e-17
C533	VPWR#9	a_1221_97##6	1.68063e-17
C534	a_413_90##4	CLK	1.22646e-17
C535	VPWR#12	a_1747_74##2	1.29241e-18
C536	a_413_90##5	VPWR#9	3.71881e-17
C537	VPWR#6	RESET_B#6	1.16674e-18
C538	D#5	SCE#5	8.18179e-19
C539	VGND#3	VGND#2	4.70814e-19
C540	a_1221_97##5	VPWR#15	4.68957e-18
C541	D#5	SCE	1.80843e-17
C542	a_1369_71##4	a_1023_74##7	2.35668e-18
C543	RESET_B#11	a_2008_48##8	8.89917e-18
C544	a_2008_48##5	a_2008_48##6	3.10134e-18
C545	VGND#2	a_1747_74##6	3.23884e-19
C546	a_850_74##2	a_1023_74##6	1.28577e-17
C547	a_2008_48##6	RESET_B#10	8.83385e-18
C548	a_413_90##4	RESET_B#13	6.10957e-17
C549	VPWR#6	a_1023_74##4	2.29179e-19
C550	a_1221_97##6	a_1221_97##8	2.4382e-18
C551	a_850_74#	a_2008_48##3	6.29376e-17
C552	CLK	RESET_B#13	4.1688e-18
C553	a_413_90##2	a_850_74##3	9.87363e-18
C554	VGND#9	a_850_74##5	1.43826e-18
C555	VPWR#9	RESET_B#2	9.36227e-19
C556	a_1023_74##4	a_1747_74##12	2.22118e-17
C557	VPWR#9	VPWR#19	2.32725e-17
C558	RESET_B#11	VPWR#14	1.73605e-17
C559	a_1221_97##7	a_1221_97##3	4.24639e-19
C560	VGND#5	a_1747_74##6	7.92981e-20
C561	VGND#15	a_1369_71#	8.18273e-19
C562	VPWR#2	Q	1.12145e-17
C563	a_1023_74##12	a_413_90##2	4.11856e-17
C564	D#5	D#2	1.43979e-17
C565	a_1369_71##5	a_1221_97#	2.53217e-18
C566	RESET_B#15	a_413_90##4	3.50784e-17
C567	a_1369_71##5	a_1221_97##3	2.72155e-17
C568	RESET_B#20	a_1747_74##4	2.40605e-18
C569	SCE#6	RESET_B#2	2.22586e-19
C570	a_27_74##7	SCE#3	3.58317e-17
C571	VGND#9	a_850_74##4	3.92364e-19
C572	a_850_74#	a_2008_48##2	1.70667e-17
C573	CLK#3	a_850_74##13	4.3877e-17
C574	CLK#3	RESET_B#1	8.56249e-18
C575	VGND#3	a_1747_74##8	2.35885e-18
C576	a_850_74##12	a_850_74##5	2.25794e-17
C577	a_1221_97##6	a_1328_463#	1.42087e-18
C578	a_1369_71##4	a_1023_74##4	1.32612e-17
C579	a_2513_424##5	Q	1.05516e-18
C580	a_413_90##6	SCD	1.71059e-17
C581	D#5	D#3	6.92547e-18
C582	VGND#5	a_1747_74##8	8.34184e-18
C583	a_1747_74##11	RESET_B#10	2.78479e-17
C584	VPWR	a_1747_74##3	7.99341e-19
C585	a_1221_97#	a_850_74##2	6.92361e-17
C586	VGND#17	CLK#3	2.60151e-18
C587	VPWR	a_1747_74##2	1.6292e-18
C588	RESET_B#19	a_1023_74##5	4.59018e-19
C589	a_1747_74##2	a_2513_424#	7.1115e-18
C590	VPWR	a_850_74##3	1.86102e-18
C591	a_1023_74##12	a_1023_74#	1.42534e-19
C592	VGND#5	RESET_B#9	6.64265e-18
C593	a_2008_48#	a_2008_48##6	3.92346e-18
C594	a_2008_48##4	VPWR#14	1.92966e-17
C595	RESET_B#15	a_850_74##12	2.33515e-17
C596	a_1747_74##2	a_2513_424##2	3.4519e-17
C597	VPWR#14	VPWR#3	4.10042e-18
C598	a_1221_97##7	RESET_B#5	2.15852e-18
C599	a_2513_424##6	a_1747_74##2	3.1488e-19
C600	a_1221_97##6	VPWR#16	1.35704e-17
C601	a_1747_74##12	RESET_B#11	8.16182e-19
C602	Q_N#1	a_2513_424##5	5.92238e-17
C603	RESET_B#20	a_2008_48##6	2.37956e-17
C604	SCD#1	a_545_97#	7.26474e-18
C605	a_1221_97##2	a_1369_71##4	4.1471e-18
C606	a_1221_97##2	VPWR#6	5.50733e-19
C607	a_1023_74##5	a_850_74#	2.63021e-18
C608	a_1221_97##5	a_1221_97#	1.91131e-19
C609	VGND#5	a_2008_48##3	6.36906e-18
C610	SCE#5	a_545_97#	7.26474e-18
C611	SCE#6	SCD#2	3.40907e-17
C612	a_1023_74##10	a_1221_97##3	1.36001e-18
C613	a_27_74##7	SCE#2	7.77175e-18
C614	a_413_90##6	CLK#3	1.37598e-18
C615	a_27_74##7	D	1.19097e-18
C616	VGND#15	RESET_B#6	1.51419e-19
C617	RESET_B#2	CLK#1	1.85546e-18
C618	a_225_90##2	SCE	1.62322e-18
C619	a_1023_74##12	a_1023_74##13	2.41307e-18
C620	RESET_B#19	RESET_B#5	1.58018e-18
C621	a_413_90##4	VPWR#9	5.55428e-17
C622	a_1221_97##2	VPWR#15	1.24883e-17
C623	a_850_74##12	a_850_74##4	2.30868e-18
C624	VGND#17	RESET_B#1	2.43017e-18
C625	a_1369_71##5	RESET_B#5	6.95471e-18
C626	RESET_B#20	RESET_B#10	1.23675e-17
C627	RESET_B#7	a_1221_97#	3.38766e-18
C628	VGND#5	a_850_74#	3.97978e-18
C629	a_27_74##4	SCD#2	2.22479e-17
C630	a_27_74##6	SCE#2	8.89895e-17
C631	a_2513_424##5	VPWR#2	2.10717e-19
C632	VGND#6	a_1369_71##2	2.50116e-20
C633	VPWR#14	a_1023_74##6	2.78665e-18
C634	VGND#18	a_225_90##2	3.95531e-17
C635	VGND#3	RESET_B#9	4.76554e-19
C636	a_1221_97##2	a_1221_97##8	1.32757e-18
C637	RESET_B#4	a_850_74##3	1.18251e-19
C638	a_1747_74##11	a_2008_48#	5.31629e-17
C639	SCE#6	a_27_74##4	6.93836e-17
C640	D#2	SCD#2	2.09217e-18
C641	a_1221_97##5	VPWR#16	2.94987e-17
C642	a_1747_74##12	a_2008_48##4	1.90602e-17
C643	a_1221_97##6	RESET_B#7	1.18556e-18
C644	VGND#17	CLK	3.01548e-18
C645	VGND#5	a_1023_74##5	1.17846e-19
C646	VPWR#16	a_1023_74##13	2.31929e-20
C647	a_27_74##4	RESET_B#2	6.30308e-19
C648	Q_N#1	a_1747_74##3	4.05584e-17
C649	a_1221_97##7	a_1369_71#	1.20668e-17
C650	SCE#6	D#2	4.1046e-17
C651	VGND#8	a_413_90##6	1.13803e-18
C652	VPWR#9	a_850_74##12	1.2012e-18
C653	a_413_90##6	CLK	7.55807e-18
C654	a_1747_74##12	VPWR#6	5.40192e-18
C655	a_1747_74##3	a_1747_74##2	1.04265e-18
C656	a_1023_74##10	RESET_B#5	1.00642e-17
C657	RESET_B#19	a_1399_97#	3.1611e-19
C658	VGND#5	a_1221_97##3	3.0929e-20
C659	a_27_74##4	D#2	5.0287e-19
C660	a_1747_74##4	a_1747_74##3	4.74137e-19
C661	a_1221_97##5	RESET_B#7	1.20561e-17
C662	VGND#18	a_27_74##7	1.68694e-17
C663	a_1221_97##3	a_1023_74##5	3.57529e-17
C664	D#3	a_312_90#	8.999e-18
C665	a_1369_71##3	RESET_B#7	1.20011e-17
C666	VPWR#14	a_850_74##2	2.54031e-18
C667	a_2008_48##5	a_1747_74##11	1.15839e-17
C668	SCE#6	SCE#2	1.08995e-19
C669	a_27_74#	a_312_90#	9.50286e-18
C670	a_413_90#	a_1369_71#	4.30394e-19
C671	a_225_90#	SCD#2	6.94439e-19
C672	VGND#3	VGND#12	1.05242e-18
C673	a_1369_71##5	a_1369_71#	2.10914e-19
C674	a_1747_74##12	a_1023_74##6	3.80251e-17
C675	VPWR	VPWR#7	6.61399e-17
C676	a_413_90##4	RESET_B#2	2.00315e-17
C677	a_1221_97##5	RESET_B#5	1.23113e-19
C678	VPWR	VPWR#6	9.95231e-17
C679	D#5	a_413_90##6	3.21201e-17
C680	Q	Q#3	5.47211e-18
C681	a_1023_74##12	a_1023_74##3	2.09753e-19
C682	VGND#7	a_1023_74##2	1.78217e-20
C683	VPWR	VPWR#4	4.85555e-17
C684	a_27_74##2	D#2	2.04493e-17
C685	a_2008_48#	RESET_B#20	2.0935e-17
C686	a_27_74##4	SCE#2	1.21641e-18
C687	VGND#12	Q	1.97321e-17
C688	Q_N#1	a_1747_74##2	4.40491e-19
C689	VPWR	VPWR#3	1.09916e-16
C690	VPWR	VPWR#2	7.59336e-17
C691	a_1221_97##6	a_1221_97##5	9.27831e-18
C692	VPWR#15	a_2008_48##4	4.88382e-19
C693	a_1221_97##7	a_1023_74#	3.69825e-17
C694	a_1023_74##12	a_850_74##5	7.97851e-18
C695	a_413_90##4	VPWR#8	6.91828e-18
C696	VPWR	a_2513_424##5	1.53942e-18
C697	SCE#2	D#2	1.92902e-17
C698	VGND#6	a_1023_74##2	2.59824e-20
C699	RESET_B#19	a_1321_97#	5.92751e-22
C700	a_1023_74##7	a_1747_74##11	3.11354e-17
C701	a_1221_97##6	a_1369_71##3	2.45717e-17
C702	a_225_90##2	D	1.53246e-17
C703	a_413_90##6	SCD#2	2.68203e-18
C704	Q#3	a_1747_74##3	2.15808e-20
C705	VPWR	a_2008_48##6	2.25832e-17
C706	a_1023_74##10	a_1369_71#	9.49937e-18
C707	a_27_74##2	SCE#2	9.14838e-17
C708	a_27_74##8	D	1.30804e-18
C709	VGND#9	a_850_74##12	4.64637e-18
C710	a_2513_424##5	a_1747_74##3	2.69654e-19
C711	VPWR#14	a_1221_97#	3.10266e-19
C712	VPWR	a_1747_74##11	2.34608e-18
C713	VPWR#17	a_850_74##3	5.3321e-18
C714	a_27_74##8	VGND#18	3.8252e-17
C715	a_850_74##7	a_1369_71##3	4.4295e-17
C716	a_1747_74##4	a_1747_74##6	1.01471e-17
C717	RESET_B#15	RESET_B#13	1.78707e-17
C718	a_850_74##2	a_1747_74##12	2.40666e-17
C719	a_1221_97##6	a_1221_97##9	1.06425e-18
C720	a_1369_71##4	VPWR#6	6.71637e-18
C721	a_413_90#	a_1023_74#	1.02561e-17
C722	a_225_90#	SCE#6	1.34812e-18
C723	Q_N#1	a_2513_424##3	7.80529e-19
C724	VPWR#16	a_1369_71##2	9.87247e-19
C725	a_1221_97##5	a_1369_71##3	2.8496e-18
C726	VPWR#15	a_1023_74##6	6.44041e-19
C727	a_1747_74##3	VPWR#13	3.09415e-18
C728	VPWR	a_1369_71##5	3.6582e-19
C729	RESET_B#5	a_1221_97##3	6.93903e-18
C730	VPWR	a_1221_97##6	6.27109e-18
C731	a_27_74##4	a_512_464#	4.24087e-19
C732	RESET_B#17	a_1221_97##8	1.26202e-17
C733	VPWR	a_1221_97##5	3.964e-18
C734	a_850_74##8	a_1221_97##7	1.21101e-17
C735	a_413_90##4	a_338_464#	9.5833e-21
C736	a_850_74##14	a_1023_74##12	1.16097e-18
C737	a_1369_71##5	a_1023_74#	1.48246e-19
C738	a_1023_74##3	a_1369_71##3	8.95613e-19
C739	VPWR	RESET_B#17	4.20285e-19
C740	a_1369_71##4	a_850_74##2	5.76463e-17
C741	a_1023_74##12	a_850_74##10	9.99018e-18
C742	a_413_90##6	SCE#6	4.45827e-17
C743	VGND	a_1747_74##3	9.48018e-19
C744	VGND	a_1747_74##2	2.05687e-18
C745	RESET_B#9	a_1747_74##4	2.8573e-18
C746	a_1747_74##7	a_1747_74##2	1.16329e-18
C747	a_1023_74##10	a_1023_74#	6.16645e-18
C748	Q	Q#1	1.01499e-17
C749	a_27_74##6	VPWR#19	9.6173e-17
C750	a_1023_74##12	a_850_74##4	3.70936e-17
C751	VGND	RESET_B#6	2.6695e-19
C752	a_413_90##2	a_1023_74##13	3.09192e-18
C753	VPWR#12	Q	6.40607e-17
C754	Q#3	a_1747_74##2	2.06964e-19
C755	a_850_74##14	a_850_74##4	2.75145e-19
C756	a_1221_97##6	a_850_74##7	2.21251e-17
C757	a_850_74##12	a_1023_74##12	6.35616e-17
C758	Q_N#1	a_1747_74#	3.27853e-18
C759	a_1023_74##4	a_1747_74##11	7.63147e-17
C760	a_1023_74##3	a_850_74##7	3.08286e-17
C761	a_225_90#	a_27_74##4	1.17758e-19
C762	a_413_90##2	a_1369_71##2	6.49377e-19
C763	a_413_90#	a_850_74##8	3.2328e-17
C764	a_1747_74##8	RESET_B#10	6.25488e-18
C765	VPWR#15	a_850_74##2	5.22502e-18
C766	a_225_90##2	SCE#6	8.73711e-19
C767	VPWR#9	RESET_B#13	2.12908e-18
C768	a_2513_424##5	a_1747_74##2	5.54725e-17
C769	VGND#6	a_1023_74##5	4.5076e-18
C770	a_413_90##2	a_1221_97##6	1.19628e-16
C771	VPWR#1	a_2513_424#	7.66233e-18
C772	VPWR#8	a_1023_74##2	1.26798e-19
C773	SCD#3	RESET_B#2	2.99082e-18
C774	a_2008_48##2	RESET_B#10	4.9645e-17
C775	a_1369_71##4	a_1221_97#	1.83455e-17
C776	VPWR#3	a_2513_424#	3.39203e-19
C777	a_225_90##2	D#5	1.11725e-17
C778	a_1747_74##11	RESET_B#20	2.53453e-17
C779	a_413_90##2	VPWR#17	1.78796e-17
C780	a_2513_424##5	a_2513_424##3	4.61136e-19
C781	a_1369_71#	RESET_B#5	4.24382e-17
C782	VPWR#7	a_1023_74##2	3.15463e-19
C783	a_1023_74##10	a_850_74##8	3.12924e-17
C784	VGND#2	a_2513_424##7	1.15322e-17
C785	VGND#14	a_1747_74##11	3.00064e-17
C786	a_2008_48##3	RESET_B#10	1.10018e-19
C787	CLK	RESET_B#3	1.03921e-18
C788	a_413_90##2	a_1023_74##2	8.48082e-17
C789	Q_N#1	a_1747_74##6	2.79172e-17
C790	a_1023_74##12	CLK#1	1.64799e-18
C791	a_27_74##6	a_27_74##9	1.21885e-17
C792	a_2008_48##6	Q_N#1	4.24913e-17
C793	VPWR#15	a_1221_97#	5.78901e-17
C794	VGND	VGND#6	1.08748e-16
C795	VGND	VGND#3	9.91343e-17
C796	VPWR#2	a_2513_424#	1.05439e-17
C797	VGND	VGND#2	6.83483e-17
C798	VGND#8	CLK#3	9.17931e-19
C799	a_413_90#	a_850_74##5	5.10276e-20
C800	a_413_90#	a_850_74##6	8.81111e-19
C801	a_1023_74##12	a_850_74##3	1.23405e-20
C802	VPWR#16	a_850_74##2	6.96239e-19
C803	a_1221_97##8	VPWR#7	4.402e-18
C804	Q	a_2513_424##3	1.08937e-17
C805	a_1221_97##6	a_1023_74##3	1.28951e-17
C806	Q	a_1747_74#	6.50052e-19
C807	VGND#7	CLK#3	1.14312e-19
C808	a_1747_74##11	a_1221_97##2	5.5918e-20
C809	VGND	a_2513_424##5	1.99773e-18
C810	VGND#16	a_850_74##8	2.56092e-19
C811	VGND#9	RESET_B#13	3.33651e-18
C812	a_850_74##14	a_413_90##2	1.92588e-18
C813	SCD	SCD#3	3.30078e-18
C814	a_1221_97##8	a_1221_97#	2.19469e-18
C815	a_2008_48##6	VPWR#4	6.24764e-18
C816	a_413_90##6	D#2	5.27473e-18
C817	VGND	a_2008_48##6	3.01407e-18
C818	VGND	a_1747_74##11	1.54437e-17
C819	SCD	D#1	9.40689e-20
C820	VGND#9	a_850_74##6	1.2726e-18
C821	VPWR	a_2513_424##6	1.65018e-17
C822	D	a_27_74#	5.24227e-18
C823	VGND	RESET_B#20	3.54249e-18
C824	VPWR	Q_N#1	2.14094e-17
C825	a_1221_97##5	a_1023_74##3	5.79868e-20
C826	a_1023_74##10	a_850_74##6	1.87072e-17
C827	D	SCE#3	1.40174e-18
C828	Q_N#1	a_1747_74##8	4.74887e-19
C829	VPWR#15	RESET_B#7	3.40679e-18
C830	a_850_74##12	RESET_B#2	3.30415e-19
C831	VPWR	VPWR#14	1.3087e-17
C832	VGND#6	a_1221_97##3	4.48351e-18
C833	VGND	a_1369_71##5	1.41552e-17
C834	VPWR#3	a_1747_74##5	5.87955e-19
C835	VPWR	a_1747_74##12	2.9446e-17
C836	VPWR	a_1369_71##4	1.11898e-17
C837	a_1023_74#	a_1369_71#	4.05154e-17
C838	CLK#1	a_850_74##10	5.04316e-17
C839	VPWR#16	a_1221_97#	1.0141e-18
C840	a_1221_97##8	VPWR#6	2.59285e-18
C841	a_225_90##2	D#2	1.36005e-18
C842	VGND#9	CLK#4	7.27634e-19
C843	a_850_74##13	a_850_74##8	6.43218e-20
C844	a_2513_424##5	a_1747_74#	1.91712e-18
C845	VGND	RESET_B#17	6.80256e-19
C846	VPWR	a_1221_97##8	1.02126e-17
C847	a_413_90#	a_850_74##4	2.29759e-17
C848	SCE	D#1	2.02444e-18
C849	VPWR	VPWR#16	1.14333e-17
C850	VGND#7	a_850_74##5	1.48358e-19
C851	a_1221_97##7	RESET_B#6	4.12668e-21
C852	a_2008_48#	a_2008_48##2	1.87804e-17
C853	a_1221_97##8	RESET_B#7	2.87234e-17
C854	a_2008_48##6	VPWR#13	9.524e-17
C855	VGND#16	a_850_74##6	3.12097e-17
C856	VGND#9	RESET_B#3	8.16112e-18
C857	Q	a_2513_424#	2.89356e-17
C858	VGND#1	VGND#2	3.84129e-18
C859	RESET_B#15	SCD	2.90876e-18
C860	VPWR#2	a_1747_74##5	1.31085e-17
C861	Q	a_1747_74##5	1.95271e-18
C862	VPWR#9	SCD	3.64361e-18
C863	VGND#9	SCD	4.48055e-18
C864	VPWR#15	a_1369_71##3	4.17733e-19
C865	VGND#3	VGND#13	5.36361e-18
C866	a_1023_74##10	CLK#4	7.52659e-19
C867	VGND	a_2513_424##7	1.81088e-17
C868	VGND#9	SCD#1	3.24431e-18
C869	VGND	a_2008_48##5	2.24981e-17
C870	RESET_B#7	VPWR#16	1.74875e-17
C871	VPWR#9	a_27_74##6	4.42824e-17
C872	a_2008_48##6	VPWR#3	1.02175e-17
C873	a_1023_74##4	a_2008_48##3	3.63734e-19
C874	a_1023_74##10	a_850_74##5	6.74216e-18
C875	VGND	a_1747_74##10	2.31966e-17
C876	VPWR#9	SCE	4.22755e-18
C877	RESET_B#4	CLK#1	4.01715e-18
C878	a_27_74##2	a_225_90##2	4.05907e-17
C879	VGND	VGND#15	1.93671e-17
C880	VPWR	a_1023_74##5	1.09122e-19
C881	a_850_74##14	VPWR#17	8.36837e-20
C882	VGND#9	SCE	5.06714e-18
C883	a_850_74##13	a_850_74##6	8.44666e-19
C884	VGND	a_1221_97##7	3.50838e-18
C885	a_413_90#	a_850_74##3	1.25292e-19
C886	VGND	a_1023_74##10	1.73587e-17
C887	VGND#9	SCE#5	3.23884e-18
C888	a_1221_97##8	a_1369_71##3	7.71668e-19
C889	RESET_B#5	a_850_74##3	1.69062e-19
C890	VGND#18	a_27_74##2	2.40997e-17
C891	a_1023_74##4	a_850_74#	3.43536e-17
C892	VGND#3	a_1747_74##3	1.20693e-18
C893	CLK	RESET_B#15	1.42615e-17
C894	a_1023_74##4	a_1369_71##5	1.90693e-16
C895	a_850_74##8	a_1023_74#	2.09041e-17
C896	VPWR#9	CLK	2.16238e-19
C897	D#2	a_312_90#	7.45112e-19
C898	a_850_74##12	a_1023_74##10	4.24214e-17
C899	a_2513_424##5	a_2513_424#	2.23266e-19
C900	VPWR#8	CLK#3	3.24397e-19
C901	a_1747_74##3	VNB	4.66476e-17
C902	VGND#16	CLK#4	2.57959e-17
C903	CLK#3	a_850_74##14	2.57768e-17
C904	VPWR#3	a_1747_74##7	1.79214e-17
C905	a_1747_74##2	VNB	5.36529e-17
C906	a_2008_48##2	VNB	6.16088e-17
C907	VGND#9	CLK	3.31576e-18
C908	VGND#6	RESET_B#5	2.16866e-18
C909	a_850_74##5	VNB	4.07293e-17
C910	a_850_74##4	VNB	8.5595e-17
C911	a_850_74##3	VNB	1.78627e-16
C912	RESET_B#6	VNB	6.52736e-17
C913	VGND	VPWR#12	3.47151e-18
C914	RESET_B#2	VNB	3.64498e-17
C915	a_2513_424##5	a_1747_74##6	2.01796e-19
C916	VPWR#16	VPWR#6	2.02399e-18
C917	VPWR#15	a_850_74##7	1.62103e-19
C918	VGND	Q_N#1	2.09546e-17
C919	a_1023_74##4	a_1023_74##5	2.68228e-17
C920	VPWR	a_2513_424#	9.63584e-19
C921	VGND#9	a_27_74##7	2.26793e-18
C922	VGND	a_1747_74##12	2.55085e-18
C923	VPWR	a_1747_74##5	3.64892e-18
C924	a_1369_71##3	VPWR#16	1.78042e-17
C925	Q	VPWR#1	3.68336e-17
C926	VPWR	a_1747_74##7	5.21659e-18
C927	VGND	VPWR#15	2.83384e-18
C928	a_1023_74##10	RESET_B#3	6.33574e-20
C929	VPWR	a_1747_74##9	8.86757e-18
C930	VGND#1	Q	4.634e-17
C931	a_2008_48##6	a_2008_48##8	3.35414e-19
C932	VGND#9	D	5.1764e-18
C933	VPWR	RESET_B#11	6.58877e-18
C934	VGND#7	a_850_74##4	4.00854e-19
C935	VPWR	a_2008_48##4	7.1434e-18
C936	SCD	SCD#2	3.06983e-17
C937	VPWR	a_1023_74##6	7.95833e-18
C938	RESET_B#5	RESET_B#6	5.86988e-19
C939	a_1023_74##4	a_1221_97##3	2.16468e-17
C940	a_225_90##2	SCE#2	1.53486e-18
C941	SCD#3	RESET_B#4	1.78037e-17
C942	VPWR	a_850_74##2	1.06477e-17
C943	SCE#6	SCD	2.3121e-17
C944	a_1221_97##2	a_850_74#	3.76526e-19
C945	a_1023_74##10	a_850_74##4	1.14222e-17
C946	VPWR#2	a_1747_74##7	1.0127e-18
C947	VPWR	a_1221_97#	2.07824e-18
C948	VPWR	RESET_B#7	3.2482e-18
C949	a_27_74##4	SCD	3.33434e-17
C950	RESET_B#19	a_1747_74##10	1.61653e-18
C951	a_850_74##13	CLK#4	2.99323e-17
C952	VGND#8	VNB	2.65165e-17
C953	a_1221_97##8	a_850_74##7	1.59016e-19
C954	VGND#7	VNB	6.06719e-17
C955	VGND#6	VNB	8.03891e-17
C956	VPWR	a_1369_71##3	3.62718e-18
C957	VGND#3	VNB	5.07791e-17
C958	VGND#2	VNB	3.26554e-17
C959	SCD	D#2	6.60456e-19
C960	SCE	SCD#2	4.95341e-19
C961	VPWR#8	VNB	6.39176e-17
C962	VPWR#7	VNB	4.36968e-17
C963	a_1023_74##7	a_2008_48##2	2.72076e-17
C964	VGND#18	SCE#2	1.44634e-18
C965	VPWR#6	VNB	3.85878e-17
C966	a_850_74##14	RESET_B#1	3.8885e-18
C967	VPWR#4	VNB	2.46763e-17
C968	VGND	a_2513_424##3	3.42781e-19
C969	VPWR#3	VNB	5.00563e-17
C970	VPWR#2	VNB	3.74674e-17
C971	VGND	a_1747_74#	5.58617e-19
C972	a_2513_424##2	Q	2.45137e-17
C973	a_1023_74##4	RESET_B#5	2.13477e-17
C974	VGND	a_1747_74##6	4.38872e-18
C975	a_413_90##4	a_1023_74##3	3.75654e-19
C976	CLK	CLK#3	1.02478e-17
C977	VGND#3	a_2008_48##5	5.76706e-17
C978	a_1221_97##2	a_1023_74##5	5.64887e-18
C979	a_2513_424##5	VNB	4.63289e-18
C980	VGND	a_1747_74##8	1.49939e-18
C981	SCD	SCE#2	4.30304e-19
C982	SCE	a_27_74##4	1.95937e-17
C983	VGND#9	SCE#3	1.63279e-18
C984	VGND	a_2008_48##3	3.22348e-19
C985	CLK	RESET_B#1	3.84701e-18
C986	a_2008_48##6	VNB	1.11359e-17
C987	VGND	a_850_74#	1.60909e-19
C988	SCE	D#2	1.65035e-17
C989	VGND#16	RESET_B#3	3.65168e-19
C990	a_1747_74##11	VNB	1.00491e-17
C991	VGND	a_1023_74##5	1.4932e-18
C992	VPWR#1	VPWR#2	4.95465e-18
C993	VPWR#18	a_850_74##3	1.28357e-19
C994	VGND	a_1221_97##3	2.21686e-18
C995	RESET_B#19	a_1369_71##7	8.46788e-22
C996	a_27_74##2	SCE	1.62682e-17
C997	VGND	RESET_B#5	7.41865e-18
C998	a_1023_74##10	VGND#15	1.3674e-17
C999	SCE	SCE#2	2.98729e-17
C1000	a_2513_424##6	VPWR#12	7.06017e-17
C1001	a_1369_71##5	VNB	1.13057e-17
C1002	a_1221_97##6	VNB	8.99508e-18
C1003	VGND#5	a_2008_48##5	2.25588e-18
C1004	VPWR#16	a_850_74##7	2.81817e-18
C1005	a_1023_74##4	a_1369_71#	1.47525e-19
C1006	a_850_74##12	VGND#16	1.86419e-17
C1007	RESET_B#17	VNB	2.88965e-18
C1008	a_413_90##4	VNB	7.83172e-18
C1009	a_1369_71##5	a_1221_97##2	8.59379e-17
C1010	a_850_74##6	a_850_74##8	4.33885e-18
C1011	VPWR#18	VPWR#17	2.57406e-19
C1012	a_850_74##12	VNB	2.85407e-18
C1013	VGND#17	CLK#4	1.87736e-18
C1014	RESET_B#19	VPWR	6.08007e-17
C1015	VPWR#5	a_2008_48##4	5.80721e-18
C1016	VPWR	VPWR#5	5.97526e-17
C1017	RESET_B#13	VNB	3.29789e-18
C1018	VGND#3	a_1747_74##2	1.62004e-19
C1019	VPWR#14	a_2008_48##2	1.20864e-18
C1020	a_27_74##7	VNB	3.99743e-17
C1021	a_1221_97##5	RESET_B#17	2.67671e-17
C1022	RESET_B#19	VGND#15	1.40062e-18
C1023	a_27_74##6	VNB	7.56856e-17
C1024	D	D#2	5.42256e-18
C1025	VPWR#3	a_1747_74##9	7.78437e-18
C1026	a_27_74##3	SCD#3	2.04179e-17
C1027	VPWR#8	RESET_B#1	3.98393e-19
C1028	D#5	VNB	1.45916e-18
C1029	a_1221_97##2	RESET_B#5	2.09041e-17
C1030	Q#3	VNB	3.84351e-17
C1031	a_27_74##2	D	3.79878e-17
C1032	VGND#12	VNB	6.7485e-18
C1033	a_2513_424##7	VNB	8.35193e-18
C1034	VPWR	a_2513_424##2	1.64775e-18
C1035	VGND#6	a_1369_71#	3.23896e-18
C1036	RESET_B#19	a_850_74##2	6.33211e-18
C1037	a_2008_48##5	VNB	8.22349e-18
C1038	VPWR	a_1747_74##4	7.8311e-19
C1039	D	SCE#2	4.93879e-18
C1040	VGND	a_850_74##2	5.39745e-19
C1041	a_850_74##13	RESET_B#3	3.49044e-18
C1042	VGND#14	VNB	4.98624e-20
C1043	VGND	a_1221_97#	2.20824e-20
C1044	a_1747_74##10	VNB	4.62072e-19
C1045	VGND#15	VNB	4.90008e-18
C1046	VPWR#5	a_1023_74##6	6.50643e-18
C1047	a_1221_97##7	VNB	8.13066e-18
C1048	VPWR	a_1023_74##7	2.5304e-18
C1049	VGND#17	a_413_90##4	2.85124e-18
C1050	a_413_90#	VNB	4.78923e-18
C1051	a_1023_74##10	VNB	2.94945e-17
C1052	VGND#16	VNB	7.55395e-20
C1053	VPWR	a_1023_74##4	6.96125e-19
C1054	VGND#9	D#5	5.60364e-18
C1055	a_2008_48##6	VPWR#14	5.5383e-17
C1056	a_850_74##13	VNB	6.79025e-18
C1057	VGND#17	VNB	6.68215e-18
C1058	a_225_90#	VNB	1.61291e-17
C1059	VPWR	a_1221_97##2	1.84306e-18
C1060	a_413_90##6	VNB	1.07386e-17
C1061	a_413_90##2	a_1369_71##3	8.03085e-19
C1062	a_225_90##2	VNB	1.98176e-17
C1063	VGND#18	VNB	1.04783e-17
C1064	a_27_74##8	VNB	2.43683e-17
C1065	VPWR	a_1369_71##2	1.74677e-18
C1066	a_225_90#	CLK#4	4.39266e-19
C1067	VPWR#12	VNB	2.88956e-18
C1068	a_2513_424##6	VNB	4.66204e-18
C1069	Q_N#1	VNB	3.24883e-17
C1070	RESET_B#19	a_1221_97#	4.885e-18
C1071	VPWR#16	a_1023_74##3	6.38312e-19
C1072	VPWR#14	VNB	7.6456e-18
C1073	a_1747_74##12	VNB	4.12715e-18
C1074	a_1369_71##4	VNB	3.95318e-18
C1075	VPWR#2	a_1747_74##9	1.72837e-19
C1076	VPWR#15	VNB	2.7017e-18
C1077	a_1221_97##8	VNB	5.1529e-18
C1078	VPWR#16	VNB	7.39547e-18
C1079	a_413_90##4	a_850_74##10	8.09724e-19
C1080	VPWR#5	a_850_74##2	7.85229e-20
C1081	a_413_90##2	VNB	1.22379e-17
C1082	VGND	RESET_B#19	1.34562e-18
C1083	SCD#2	VPWR#18	9.80516e-19
C1084	VPWR#17	VNB	6.00915e-19
C1085	a_850_74##14	VNB	1.57183e-18
C1086	a_850_74##7	a_1221_97##9	8.9097e-18
C1087	VGND	VGND#5	1.48473e-16
C1088	VPWR#18	VNB	1.81786e-18
C1089	a_413_90##5	VNB	2.02738e-18
C1090	a_413_90##6	a_850_74##6	1.8358e-19
C1091	VPWR#19	VNB	2.26394e-18
C1092	RESET_B#3	VGND#17	1.86534e-17
C1093	a_1369_71##2	a_1023_74##5	2.87306e-19
C1094	VGND#12	Q#3	4.3116e-17
C1095	a_2513_424##3	VNB	3.32403e-17
C1096	a_1747_74#	VNB	3.60482e-17
C1097	VGND	a_2513_424##2	1.65227e-18
C1098	a_1747_74##6	VNB	3.65518e-17
C1099	a_1023_74##12	a_1369_71##2	1.58644e-20
C1100	a_1747_74##8	VNB	3.32824e-17
C1101	VGND	a_1747_74##4	3.62585e-18
C1102	Q#3	Q#1	4.6289e-19
C1103	RESET_B#9	VNB	3.10543e-17
C1104	a_2008_48##3	VNB	3.02459e-17
C1105	a_850_74#	VNB	3.99168e-17
C1106	a_1023_74##5	VNB	4.41083e-17
C1107	VGND	a_2008_48#	3.36161e-18
C1108	a_1221_97##3	VNB	3.01802e-17
C1109	VPWR#4	RESET_B#11	4.88891e-18
C1110	Q#3	a_2513_424##3	2.4704e-17
C1111	RESET_B#5	VNB	5.24003e-17
C1112	VGND	a_1023_74##7	2.9327e-19
C1113	a_413_90#	a_413_90##2	1.0668e-18
C1114	D#1	a_27_74##3	2.81989e-17
C1115	a_1369_71#	VNB	3.26143e-17
C1116	a_1023_74#	VNB	3.7679e-17
C1117	VGND	a_1023_74##4	5.19817e-17
C1118	a_850_74##8	VNB	4.03355e-17
C1119	a_850_74##6	VNB	2.75044e-17
C1120	VGND	a_1221_97##2	8.63091e-18
C1121	VPWR#6	a_1023_74##5	7.3176e-19
C1122	CLK#4	VNB	2.75685e-17
C1123	RESET_B#3	VNB	5.23459e-17
C1124	SCD#1	VNB	3.36971e-17
C1125	SCE#5	VNB	2.8272e-17
C1126	VGND	a_1369_71##2	6.5202e-18
C1127	D#3	VNB	2.28552e-17
C1128	CLK#4	a_850_74##6	3.67124e-17
C1129	a_27_74#	VNB	2.39128e-17
C1130	SCE#3	VNB	6.19335e-17
C1131	a_2513_424#	VNB	4.10677e-17
C1132	a_1747_74##5	VNB	4.65822e-17
C1133	a_850_74##13	SCD#1	1.98399e-19
C1134	a_1747_74##7	VNB	4.06751e-17
C1135	a_1747_74##9	VNB	4.40012e-17
C1136	RESET_B#11	VNB	3.24598e-17
C1137	a_1023_74##4	a_2008_48##2	2.44073e-18
C1138	VGND#5	a_850_74##2	6.21873e-20
C1139	a_2008_48##4	VNB	3.34515e-17
C1140	a_1023_74##6	VNB	2.59326e-17
C1141	RESET_B#19	a_1221_97##7	3.91833e-18
C1142	a_413_90##2	a_850_74##7	8.08788e-18
C1143	a_850_74##2	VNB	1.43017e-16
C1144	a_1221_97#	VNB	3.65223e-17
C1145	RESET_B#7	VNB	2.28402e-17
C1146	a_1369_71##3	VNB	3.21777e-17
C1147	VGND#5	a_1747_74##10	2.60601e-17
C1148	a_850_74##7	VNB	2.58947e-17
C1149	a_1023_74##3	VNB	2.34013e-17
C1150	a_850_74##10	VNB	3.49029e-17
C1151	CLK#1	VNB	4.86036e-17
C1152	RESET_B#4	VNB	3.47595e-17
C1153	D	a_312_90#	3.21354e-18
C1154	RESET_B#19	a_1369_71##3	1.26182e-18
C1155	SCD#3	VNB	2.68547e-17
C1156	a_27_74##3	VNB	2.23615e-17
C1157	SCE	SCD	1.80161e-18
C1158	VPWR#16	a_850_74##10	7.84051e-19
C1159	D#1	VNB	4.1899e-17
C1160	SCE#1	VNB	3.45011e-17
C1161	a_850_74##4	a_1023_74#	5.65162e-18
C1162	a_2513_424##5	a_1747_74##7	2.06178e-19
C1163	a_1747_74##3	VGND#13	7.22269e-19
C1164	SCE#4	VNB	3.95474e-17
C1165	a_1369_71##2	RESET_B#5	3.58912e-17
C1166	VPWR#17	a_1369_71##3	2.30963e-19
C1167	RESET_B#3	a_225_90#	1.63047e-17
C1168	VPWR#1	VNB	8.82629e-17
C1169	VGND#1	VNB	8.96882e-17
C1170	RESET_B#19	VNB	1.14305e-17
C1171	Q_N#1	a_2513_424##6	7.88678e-17
C1172	VPWR#3	RESET_B#11	8.55662e-19
C1173	VPWR#5	VNB	3.1905e-17
C1174	a_413_90##2	VPWR#8	1.2775e-17
C1175	VGND#5	VNB	6.7992e-17
C1176	RESET_B#15	VNB	8.136e-18
C1177	a_1023_74##3	a_1221_97##9	8.9097e-18
C1178	VPWR#9	VNB	3.48497e-16
C1179	VGND#9	VNB	3.76405e-16
C1180	a_2513_424##2	VNB	4.9784e-17
C1181	a_1747_74##4	VNB	7.61215e-17
C1182	RESET_B#10	VNB	6.24393e-17
C1183	D	SCE	2.71903e-17
C1184	a_2008_48#	VNB	8.88087e-18
C1185	a_413_90#	a_1221_97##7	1.0142e-16
C1186	a_1023_74##7	VNB	3.83764e-17
C1187	RESET_B#19	a_413_90#	2.33589e-18
C1188	a_1023_74##4	VNB	4.76257e-17
C1189	a_850_74##12	a_850_74##10	4.66597e-18
C1190	a_1221_97##2	VNB	5.32004e-17
C1191	VGND#6	a_1023_74#	3.26871e-18
C1192	a_413_90##4	a_1023_74##13	4.2945e-22
C1193	a_2513_424##3	VGND#12	1.94023e-17
C1194	a_1369_71##2	VNB	6.21675e-17
C1195	a_1023_74##2	VNB	7.06175e-17
C1196	CLK#3	VNB	7.51308e-17
C1197	a_1221_97##2	RESET_B#17	9.39798e-18
C1198	a_1369_71##2	a_1369_71#	3.64767e-18
C1199	RESET_B#1	VNB	2.99524e-17
C1200	a_413_90##6	CLK#4	1.4122e-18
C1201	SCD#2	VNB	4.77166e-17
C1202	RESET_B#19	a_850_74##7	2.0488e-18
C1203	SCE#6	VNB	4.65234e-17
C1204	a_27_74##4	VNB	3.80869e-17
C1205	VGND#17	SCD#1	4.64434e-19
C1206	D#2	VNB	5.28504e-17
C1207	a_27_74##2	VNB	3.87519e-17
C1208	VGND#2	a_1747_74##2	4.21964e-19
C1209	SCE#2	VNB	1.35181e-16
C1210	VPWR#6	a_2008_48##4	2.52892e-19
C1211	SCE#1	D#1	5.37705e-17
C1212	RESET_B#19	VPWR#8	1.32378e-19
C1213	a_413_90##4	CLK#1	2.95971e-17
C1214	SCE#6	a_413_90##5	3.21696e-18
C1215	RESET_B#19	a_1023_74##10	4.37325e-18
C1216	a_413_90##2	a_1023_74##3	2.11805e-17
C1217	a_1023_74#	a_1369_71##2	1.08856e-17
C1218	a_850_74##12	a_413_90##2	4.31795e-18
C1219	Q#3	a_1747_74#	1.23969e-18
C1220	a_1747_74##4	a_1747_74##7	8.88617e-18
C1221	VGND#6	a_1221_97#	2.01006e-20
C1222	SCD	VNB	2.95036e-18
C1223	a_850_74##13	SCE#5	1.10419e-19
C1224	SCE	VNB	7.89474e-18
C1225	CLK	VNB	4.54417e-18
C1226	D	VNB	1.44872e-18
C1227	Q#3	a_2513_424##2	3.24229e-17
C1228	Q	VNB	8.25595e-17
C1229	a_1023_74##12	a_1023_74##2	1.0599e-18
C1230	VPWR	VNB	2.26195e-16
C1231	VPWR#17	a_850_74##7	5.79379e-19
C1232	VGND	VNB	2.52315e-16
C1233	VGND#10	VNB	7.56492e-17
C1234	VGND#10	a_225_90##2	7.31061e-17
C1235	VGND#10	SCE#3	4.71356e-18
C1236	VGND#10	a_27_74#	3.46889e-18
C1237	VGND#10	D#3	3.58389e-18
C1238	VGND#10	SCE#2	1.77145e-19
C1239	VGND#9	VGND#10	1.45048e-16
C1240	VGND#10	a_27_74##7	3.08346e-19
C1241	VGND#10	a_27_74##2	2.12488e-18
C1242	VGND#10	a_27_74##8	1.76193e-17
C1243	a_27_74##4	VPWR#10	2.4821e-18
C1244	VGND#10	D#2	1.73133e-19
C1245	RESET_B	RESET_B#20	1.44554e-17
C1246	RESET_B	a_1747_74##10	5.75148e-19
C1247	RESET_B	VPWR#13	2.28458e-18
C1248	VPWR#10	SCE#1	4.03082e-18
C1249	VPWR#10	D#2	3.06586e-19
C1250	RESET_B	VNB	3.98527e-18
C1251	RESET_B	a_850_74##2	3.15689e-18
C1252	RESET_B	Q_N#1	2.00574e-18
C1253	VPWR#9	VPWR#10	1.44956e-16
C1254	RESET_B	a_1023_74##4	1.97535e-18
C1255	RESET_B	a_1966_74#	8.92829e-19
C1256	RESET_B	VPWR#4	1.49891e-18
C1257	VPWR#10	SCE#4	2.55959e-18
C1258	RESET_B	VGND#14	4.64936e-18
C1259	RESET_B	a_2513_424##6	1.82317e-18
C1260	a_413_90##5	VPWR#10	1.24242e-17
C1261	RESET_B	a_1023_74##7	3.70977e-17
C1262	RESET_B	a_1747_74##11	3.45682e-17
C1263	RESET_B	a_2008_48##3	1.8148e-19
C1264	VPWR#10	VNB	8.20049e-17
C1265	RESET_B	a_1747_74##12	1.9748e-17
C1266	a_2008_48#	RESET_B	4.78959e-17
C1267	RESET_B	a_2124_74#	4.25836e-19
C1268	VPWR#10	SCE#2	2.35493e-19
C1269	RESET_B	VPWR#5	4.4356e-18
C1270	a_27_74##6	VPWR#10	5.03949e-17
C1271	RESET_B	RESET_B#10	8.83591e-18
C1272	VPWR	RESET_B	4.18151e-17
C1273	RESET_B	a_1747_74##9	1.14899e-18
C1274	RESET_B	a_2008_48##2	6.54983e-18
C1275	RESET_B	VPWR#14	3.94522e-18
C1276	RESET_B	a_1747_74##4	4.28992e-19
C1277	RESET_B	a_2008_48##6	6.33486e-17
C1278	RESET_B	a_1747_74##7	7.94245e-19
C1279	VPWR#10	D#1	7.55449e-18
*
*
.ENDS sky130_fd_sc_hs__sdfrbp_1
*
