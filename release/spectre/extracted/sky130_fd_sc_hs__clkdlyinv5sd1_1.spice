* Extracted by Quantus, converted by sky130cad/quantus.py
*
*
*
*                       LINUX           Wed Nov 18 08:23:30 2026
*
*
*
*  PROGRAM  advgen
*
*  Name           : advgen - Quantus - (64-bit)
*  Version        : 25.1.0-p047
*  Build Date     : Thu Dec 11 23:20:30 PST 2025
*
*  HSPICE LIBRARY
*
*  OPERATING_TEMPERATURE 150
*  QRC_TECH_DIR <path>/tech
*
*
*

*
.SUBCKT sky130_fd_sc_hs__clkdlyinv5sd1_1 VPB VNB VGND VPWR Y A
*
*
*  caps2d version: 10
*
*
*       TRANSISTOR CARDS
*
*
XM4 a_28_74##7 A#3 VGND#9 VNB sky130_fd_pr__nfet_01v8_lvt l=0.15 w=0.42 ad=0.1113 as=0.3087 pd=1.37 ps=2.31
XM8 VGND#9 a_28_74##4 a_288_74##7 VNB sky130_fd_pr__nfet_01v8_lvt l=0.15 w=0.42 ad=0.3087 as=0.1113 pd=2.31 ps=1.37
XM9 VGND#8 a_288_74##4 a_549_74##7 VNB sky130_fd_pr__nfet_01v8_lvt l=0.15 w=0.42 ad=0.2604 as=0.1113 pd=2.08 ps=1.37
XM7 a_682_74##6 a_549_74# VGND#7 VNB sky130_fd_pr__nfet_01v8_lvt l=0.15 w=0.42 ad=0.2583 as=0.1932 pd=2.07 ps=1.76
XM3 VGND#7 a_682_74##3 Y#3 VNB sky130_fd_pr__nfet_01v8_lvt l=0.15 w=0.42 ad=0.1932 as=0.1113 pd=1.76 ps=1.37
XM5 a_28_74##5 A#1 VPWR#9 VPB sky130_fd_pr__pfet_01v8 l=0.15 w=1.12 ad=0.3136 as=0.7568 pd=2.8 ps=3.69
XM2 VPWR#9 a_28_74# a_288_74##8 VPB sky130_fd_pr__pfet_01v8 l=0.15 w=1 ad=0.7568 as=0.26 pd=3.69 ps=2.52
XM1 VPWR#8 a_288_74# a_549_74##8 VPB sky130_fd_pr__pfet_01v8 l=0.15 w=1 ad=0.62 as=0.265 pd=3.24 ps=2.53
XM0 a_682_74##4 a_549_74##4 VPWR#7 VPB sky130_fd_pr__pfet_01v8 l=0.15 w=1 ad=0.61 as=0.508 pd=3.22 ps=3.19
XM6 VPWR#7 a_682_74# Y#1 VPB sky130_fd_pr__pfet_01v8 l=0.15 w=1.12 ad=0.508 as=0.3136 pd=3.19 ps=2.8
*
*
*       RESISTOR AND CAP/DIODE CARDS
*
Rg1	A#1	A#2	505.110291
Rg2	A#2	A#3	382.539764
Rg3	a_28_74#	a_28_74##2	628.342224
Rg4	a_28_74##2	a_28_74##3	190.829742
Rg5	a_28_74##2	a_28_74##4	370.314697
Rg6	a_288_74#	a_288_74##2	621.882568
Rg7	a_288_74##2	a_288_74##3	33.550034
Rg8	a_288_74##2	a_288_74##4	375.121918
Rg9	a_549_74#	a_549_74##2	372.839691
Rg10	a_549_74##2	a_549_74##3	49.298141
Rg11	a_549_74##2	a_549_74##4	619.600342
Rg12	a_682_74#	a_682_74##2	467.246124
Rg13	a_682_74##2	a_682_74##3	455.213867
Rf1	A	A#4	3.280892
Rf2	A#5	A#2	163.513702
Rf3	A#4	A#5	1.266811
Rf4	A	A#7	3.280892
Rf5	A#5	A#7	6.545189
Rf6	a_28_74##5	a_28_74##3	99.886612
Rf7	a_28_74##3	a_28_74##7	87.592514
Rf8	a_288_74##3	a_288_74##6	194.951324
Rf9	a_288_74##6	a_288_74##7	52.096035
Rf10	a_288_74##6	a_288_74##8	17.895864
Rf11	a_549_74##3	a_549_74##6	224.869141
Rf12	a_549_74##6	a_549_74##7	68.059647
Rf13	a_549_74##6	a_549_74##8	89.471367
Rf14	a_682_74##4	a_682_74##5	129.092072
Rf15	a_682_74##5	a_682_74##6	127.751671
Rf16	Y#2	Y	1.177624
Rf17	Y	Y#4	15.111293
Rf18	Y#4	Y	1.268211
Rf19	Y#2	Y	12.229176
Rf20	Y#1	Y#2	5.000000
Rf21	Y#3	Y#4	15.000000
Rf23	VPWR#2	VPWR#3	135.484131
Rf24	VPWR#3	VPWR#4	40.142254
Rf25	VPWR#4	VPWR#5	98.558121
Rf27	VPWR#2	VPWR#7	38.384460
Rf28	VPWR#4	VPWR#8	34.238716
Rf29	VPWR#5	VPWR#9	30.944223
Rf31	VGND#2	VGND#3	135.484131
Rf32	VGND#3	VGND#4	40.142254
Rf33	VGND#4	VGND#5	97.827614
Rf35	VGND#2	VGND#7	34.704330
Rf36	VGND#4	VGND#8	33.444363
Rf37	VGND#5	VGND#9	33.916985
Rf42	a_682_74##2	a_682_74##5	160.232803
Re1	VPWR#3	VPWR	1.165462
Re2	VGND#3	VGND	1.165462
*
*       CAPACITOR CARDS
*
*
C1	VGND#4	a_288_74##6	8.83117e-19
C2	a_288_74##6	a_549_74##6	4.71415e-18
C3	VGND#4	a_288_74##7	1.71263e-17
C4	VGND#9	VGND#4	1.38123e-20
C5	a_549_74##6	a_682_74##6	6.75623e-18
C6	a_288_74##6	a_549_74##7	4.54999e-19
C7	VGND#8	a_288_74##6	5.71588e-18
C8	VGND#7	Y#3	3.04946e-17
C9	a_288_74##8	VPWR#4	1.3381e-17
C10	a_682_74##6	Y#3	2.494e-18
C11	VPWR#9	VPWR#4	1.93468e-19
C12	a_549_74##6	a_682_74##4	8.05504e-18
C13	a_682_74##6	VGND#7	8.78295e-18
C14	VGND#4	a_549_74#	1.73128e-19
C15	a_549_74##7	a_682_74##6	2.39756e-17
C16	VGND#4	a_288_74##4	2.01902e-18
C17	a_288_74##6	a_549_74##8	3.81891e-18
C18	VGND#8	a_682_74##6	1.7109e-18
C19	VGND#4	a_28_74##4	1.27245e-18
C20	VGND#8	a_549_74##7	1.16041e-17
C21	a_288_74##6	VPWR#8	4.40832e-17
C22	a_288_74##7	a_549_74##7	2.67542e-18
C23	VGND#4	A#3	1.13023e-19
C24	a_288_74##6	a_288_74##8	4.75014e-18
C25	Y#3	Y#1	5.25545e-19
C26	a_288_74##7	VGND#8	3.65628e-17
C27	VGND#9	VGND#8	7.62371e-19
C28	a_682_74##6	Y#1	8.488e-20
C29	a_28_74##5	a_288_74##6	1.16498e-18
C30	VGND#9	a_288_74##7	1.18074e-17
C31	A#7	VPWR#9	3.29948e-19
C32	a_549_74##6	a_549_74#	1.82204e-20
C33	a_28_74##7	a_288_74##7	1.50063e-18
C34	a_28_74##7	VGND#9	4.43527e-17
C35	A#7	a_28_74##5	5.8611e-17
C36	a_549_74##6	a_288_74##4	5.53914e-19
C37	a_549_74##6	a_28_74##4	4.68906e-20
C38	a_288_74##6	a_288_74##4	3.16716e-19
C39	a_288_74##6	a_28_74##4	9.24601e-19
C40	VPWR#7	Y#1	6.52116e-17
C41	Y#3	a_682_74##3	1.38239e-17
C42	a_682_74##4	Y#1	4.10973e-19
C43	VGND#7	a_682_74##3	2.66123e-17
C44	Y#3	a_549_74#	1.66126e-18
C45	a_682_74##4	VPWR#7	3.04143e-17
C46	a_682_74##6	a_682_74##3	2.21714e-18
C47	VPWR#4	a_28_74#	2.24403e-18
C48	a_549_74#	VGND#7	1.49895e-17
C49	Y#3	a_288_74##4	4.68898e-19
C50	a_682_74##6	a_549_74#	3.03838e-17
C51	VGND#7	a_288_74##4	1.13433e-18
C52	a_549_74##8	a_682_74##4	5.11807e-17
C53	a_549_74##7	a_549_74#	5.27337e-19
C54	a_682_74##6	a_288_74##4	5.52914e-18
C55	VGND#8	a_549_74#	7.83975e-19
C56	a_28_74##7	a_28_74##5	1.1762e-19
C57	a_288_74##4	a_549_74##7	2.34221e-17
C58	a_682_74##6	a_28_74##4	1.76249e-19
C59	VPWR#8	a_549_74##8	3.47422e-17
C60	a_288_74##4	VGND#8	1.45251e-17
C61	a_288_74##6	a_288_74#	2.32283e-18
C62	a_549_74##7	a_28_74##4	7.0265e-19
C63	a_288_74##7	a_288_74##4	2.10622e-18
C64	Y#1	a_682_74##3	2.05888e-18
C65	VGND#8	a_28_74##4	1.57053e-18
C66	a_288_74##8	VPWR#8	5.2351e-17
C67	VGND#9	a_288_74##4	4.77344e-19
C68	a_288_74##6	a_28_74#	1.19403e-17
C69	a_28_74##4	a_288_74##7	2.31771e-17
C70	Y#1	a_549_74#	5.36095e-20
C71	VGND#8	A#3	1.42497e-19
C72	VPWR#9	VPWR#8	2.51892e-18
C73	a_28_74##4	VGND#9	1.55532e-17
C74	a_288_74##6	A#1	6.27863e-19
C75	a_288_74##7	A#3	3.10005e-18
C76	A#7	a_28_74#	6.02451e-19
C77	VPWR#9	a_288_74##8	1.80799e-17
C78	a_28_74##7	a_28_74##4	1.7008e-18
C79	A#3	VGND#9	2.1885e-17
C80	a_28_74##5	a_288_74##8	3.50209e-19
C81	a_28_74##7	A#3	4.02471e-17
C82	A#7	A#1	9.51539e-18
C83	a_28_74##5	VPWR#9	7.20445e-17
C84	VGND#4	a_288_74##3	7.86324e-19
C85	VGND#3	a_549_74##6	2.4683e-18
C86	a_682_74#	Y#1	1.84824e-17
C87	a_549_74##6	a_682_74##2	8.98601e-19
C88	VPWR#7	a_682_74#	6.41777e-17
C89	VPWR#4	a_288_74##3	6.04792e-19
C90	Y#1	a_549_74##4	5.89979e-20
C91	a_549_74#	a_682_74##3	1.32778e-17
C92	a_682_74##4	a_682_74#	4.90357e-18
C93	VPWR#7	a_549_74##4	2.93254e-17
C94	a_549_74##6	a_549_74##3	1.9691e-18
C95	a_549_74##4	a_682_74##4	5.59282e-17
C96	VPWR#7	a_288_74#	1.39278e-18
C97	a_288_74##4	a_549_74#	2.66787e-18
C98	a_549_74##8	a_549_74##4	1.33979e-18
C99	a_682_74##4	a_288_74#	9.76035e-18
C100	a_288_74##3	a_549_74##6	4.59321e-17
C101	VPWR#8	a_549_74##4	1.23637e-18
C102	a_549_74##8	a_288_74#	3.16428e-17
C103	a_28_74##4	a_288_74##4	2.33632e-18
C104	a_288_74##6	a_288_74##3	1.84584e-18
C105	VGND#3	a_682_74##6	1.00789e-17
C106	a_288_74#	VPWR#8	3.06435e-17
C107	VGND#3	a_549_74##7	8.52972e-18
C108	a_549_74##8	a_28_74#	1.20112e-18
C109	a_549_74##6	a_28_74##3	7.72989e-19
C110	VGND#7	a_682_74##2	2.81763e-17
C111	a_288_74##8	a_288_74#	1.26221e-18
C112	VPWR#8	a_28_74#	5.49878e-18
C113	a_682_74##6	a_682_74##2	5.34545e-18
C114	VPWR#9	a_288_74#	9.03102e-19
C115	a_28_74##3	a_288_74##6	1.34259e-16
C116	A#3	a_28_74##4	6.31166e-18
C117	a_288_74##8	a_28_74#	4.16051e-17
C118	VPWR#8	A#1	6.44576e-19
C119	a_28_74#	VPWR#9	3.1007e-17
C120	a_682_74##6	a_549_74##3	7.54879e-17
C121	A#7	a_28_74##3	2.65768e-17
C122	a_288_74##8	A#1	3.80468e-18
C123	a_28_74##5	a_28_74#	1.66674e-18
C124	a_682_74##4	VPWR#3	9.78867e-18
C125	A#1	VPWR#9	4.70677e-17
C126	a_549_74##8	VPWR#3	1.36807e-17
C127	a_682_74##6	a_288_74##3	1.09885e-18
C128	a_28_74##5	A#1	4.38081e-17
C129	A#7	A#2	8.25149e-18
C130	a_682_74##2	Y#1	9.21702e-17
C131	a_682_74##2	VPWR#7	3.69003e-17
C132	VGND#8	a_288_74##3	1.66336e-17
C133	a_549_74##4	a_682_74#	2.65174e-17
C134	a_549_74##3	a_682_74##4	5.56275e-17
C135	a_28_74##3	a_288_74##7	1.01689e-17
C136	a_549_74##8	a_549_74##3	9.2639e-21
C137	VGND#9	a_28_74##3	2.26944e-17
C138	a_682_74##4	a_288_74##3	1.53603e-18
C139	a_288_74#	a_549_74##4	4.40973e-18
C140	a_549_74##8	a_288_74##3	2.29136e-19
C141	VGND#9	A#2	8.77831e-19
C142	a_682_74##2	a_682_74##3	1.00458e-18
C143	a_288_74##3	VPWR#8	1.56798e-17
C144	VGND#3	a_288_74##4	9.72257e-18
C145	a_28_74##7	A#2	6.21258e-17
C146	a_28_74#	a_288_74#	4.39937e-18
C147	a_549_74##8	a_28_74##3	1.11968e-20
C148	a_549_74##3	a_682_74##3	1.68462e-18
C149	a_28_74##3	VPWR#9	5.74038e-18
C150	A#1	a_28_74#	1.12807e-17
C151	a_28_74##3	a_28_74##5	6.41214e-18
C152	VPWR#3	a_288_74#	9.72257e-18
C153	VPWR#9	A#2	6.29041e-19
C154	a_28_74##5	A#2	1.74609e-18
C155	a_682_74##2	a_549_74##4	3.39943e-17
C156	a_28_74##3	a_288_74##4	3.94749e-19
C157	a_28_74##3	a_28_74##4	7.39914e-18
C158	A#3	a_28_74##3	2.47695e-19
C159	a_28_74#	a_288_74##3	1.70354e-20
C160	a_28_74##3	a_288_74#	3.27092e-19
C161	VPWR	VPWR#4	6.32431e-17
C162	a_28_74##3	a_28_74#	2.00873e-17
C163	A#1	a_28_74##3	4.30879e-18
C164	VGND#3	a_549_74##3	4.9442e-20
C165	VPWR#3	a_288_74##3	9.73952e-19
C166	VPWR	a_549_74##6	5.28233e-18
C167	VGND	VGND#4	8.141e-17
C168	a_682_74##2	a_549_74##3	5.14787e-17
C169	VPWR	a_288_74##6	1.27095e-18
C170	VGND#3	a_288_74##3	1.74066e-18
C171	VPWR	A#7	5.56552e-18
C172	a_682_74##2	a_288_74##3	5.01385e-20
C173	a_288_74##3	a_549_74##3	4.54318e-18
C174	Y	Y#1	4.16662e-18
C175	VPWR#7	Y	3.54634e-17
C176	VGND	a_549_74##6	6.83093e-18
C177	VGND	a_288_74##6	3.28876e-18
C178	a_28_74##3	a_288_74##3	4.90409e-18
C179	VGND#4	VNB	3.43808e-17
C180	VPWR	VPWR#7	2.20596e-17
C181	VPWR#4	VNB	3.35553e-17
C182	VGND	Y#3	2.08377e-17
C183	VPWR	a_682_74##4	1.84784e-17
C184	A#2	a_28_74##3	7.15183e-17
C185	VGND	a_682_74##6	2.26348e-17
C186	VPWR	a_549_74##8	1.28416e-17
C187	VGND	a_549_74##7	1.37836e-17
C188	VPWR	VPWR#8	2.00863e-17
C189	VPWR	a_288_74##8	1.70906e-17
C190	a_549_74##6	VNB	2.09197e-17
C191	VGND	a_288_74##7	1.8798e-17
C192	VPWR	VPWR#9	2.31108e-17
C193	VGND	VGND#9	1.50109e-17
C194	a_288_74##6	VNB	2.32957e-17
C195	VGND	a_28_74##7	1.87578e-17
C196	VPWR	a_28_74##5	1.62672e-17
C197	VGND	Y#1	1.06696e-18
C198	A#7	VNB	2.02323e-17
C199	Y	a_682_74#	1.04357e-17
C200	VGND	a_682_74##4	4.38723e-18
C201	Y#3	VNB	2.64043e-17
C202	VGND	VPWR#8	4.56327e-18
C203	VGND#7	VNB	3.28283e-18
C204	a_682_74##6	VNB	1.8675e-17
C205	a_549_74##7	VNB	2.63462e-18
C206	VGND#8	VNB	1.06336e-17
C207	a_288_74##7	VNB	1.06213e-17
C208	VPWR	a_682_74#	2.72975e-18
C209	VGND	a_682_74##3	1.6316e-18
C210	VGND#9	VNB	2.42559e-18
C211	a_28_74##7	VNB	3.79922e-17
C212	VGND	a_549_74#	9.62909e-19
C213	VPWR	a_549_74##4	1.82241e-18
C214	Y#1	VNB	8.55623e-17
C215	VGND	a_288_74##4	5.6359e-18
C216	VPWR	a_288_74#	5.64899e-18
C217	VPWR#7	VNB	3.549e-18
C218	VGND	a_28_74##4	5.45504e-18
C219	a_682_74##4	VNB	1.94508e-17
C220	VPWR	a_28_74#	4.31873e-18
C221	a_549_74##8	VNB	8.27604e-18
C222	VGND	A#3	1.08841e-18
C223	VPWR#8	VNB	1.75695e-17
C224	VPWR	A#1	1.30244e-18
C225	a_288_74##8	VNB	5.33872e-18
C226	VPWR#9	VNB	4.86334e-18
C227	a_28_74##5	VNB	3.55693e-17
C228	VPWR	VPWR#3	6.66137e-17
C229	a_682_74##3	VNB	3.36336e-17
C230	a_549_74#	VNB	3.10365e-17
C231	a_288_74##4	VNB	4.13657e-17
C232	VPWR	a_682_74##2	7.31751e-18
C233	a_28_74##4	VNB	3.67325e-17
C234	A#3	VNB	3.80861e-17
C235	VPWR	a_549_74##3	8.38336e-19
C236	a_682_74#	VNB	3.75569e-17
C237	VPWR	a_288_74##3	9.62305e-18
C238	a_549_74##4	VNB	5.12281e-17
C239	VGND	VGND#3	6.48715e-17
C240	VPWR	a_28_74##3	1.01589e-17
C241	a_288_74#	VNB	5.33238e-17
C242	VGND	a_682_74##2	8.05905e-18
C243	a_28_74#	VNB	5.39191e-17
C244	VGND	a_549_74##3	3.48137e-18
C245	A#1	VNB	6.09971e-17
C246	VGND	a_288_74##3	1.2786e-17
C247	VPWR#3	VNB	4.1256e-17
C248	VGND	a_28_74##3	1.3679e-17
C249	VGND#3	VNB	3.79955e-17
C250	VGND	A#2	6.43288e-18
C251	a_682_74##2	VNB	6.694e-17
C252	a_549_74##3	VNB	8.21934e-17
C253	a_288_74##3	VNB	9.44123e-17
C254	a_28_74##3	VNB	8.13539e-17
C255	A#2	VNB	7.29224e-17
C256	VPWR	Y	2.46636e-17
C257	Y	VNB	2.4356e-17
C258	VPWR	VNB	2.97858e-16
C259	VGND	VNB	2.97258e-16
C260	Y	VPWR#2	3.28847e-17
C261	VPWR	VPWR#5	9.30733e-17
C262	VGND	VGND#2	1.2883e-16
C263	VPWR#2	a_549_74##4	8.78858e-18
C264	VGND#5	a_28_74##7	2.46863e-17
C265	VPWR#5	VPWR#4	4.40448e-19
C266	VGND#5	A#3	4.84932e-18
C267	VGND#2	a_682_74##3	6.1519e-18
C268	VGND	VGND#5	9.38544e-17
C269	VGND#5	a_28_74##3	5.44538e-18
C270	VGND#2	a_549_74##3	1.16203e-18
C271	VPWR#2	a_682_74#	4.54745e-18
C272	a_682_74##4	VPWR#2	8.50731e-18
C273	VPWR#5	A#1	1.11819e-18
C274	VGND#2	Y#3	2.25397e-17
C275	VGND#5	a_28_74##4	7.23258e-18
C276	VGND#2	a_682_74##2	7.1945e-19
C277	VPWR#2	VNB	6.61365e-17
C278	VGND#5	VGND#4	7.36134e-19
C279	VPWR#5	a_28_74#	5.81467e-18
C280	VPWR#5	VNB	5.64416e-17
C281	a_28_74##5	VPWR#5	9.48505e-18
C282	VGND#2	a_288_74##4	1.62319e-19
C283	VPWR#2	a_549_74##3	6.50822e-19
C284	VGND#5	a_288_74##4	5.85913e-20
C285	VGND#2	VNB	6.52252e-17
C286	VPWR	VPWR#2	1.12112e-16
C287	a_682_74##2	VPWR#2	9.10129e-19
C288	VGND#2	a_682_74##6	1.19559e-17
C289	VGND#5	VNB	5.59087e-17
C290	a_28_74##3	VPWR#5	3.36886e-18
C291	VGND#2	a_549_74#	1.02417e-17
*
*
.ENDS sky130_fd_sc_hs__clkdlyinv5sd1_1
*
