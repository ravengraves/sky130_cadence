* Extracted by Quantus, converted by sky130cad/quantus.py
*
*
*
*                       LINUX           Wed Nov 18 08:19:58 2026
*
*
*
*  PROGRAM  advgen
*
*  Name           : advgen - Quantus - (64-bit)
*  Version        : 25.1.0-p047
*  Build Date     : Thu Dec 11 23:20:30 PST 2025
*
*  HSPICE LIBRARY
*
*  OPERATING_TEMPERATURE 150
*  QRC_TECH_DIR <path>/tech
*
*
*

*
.SUBCKT sky130_fd_sc_hs__buf_1 VPB VNB VGND VPWR X A
*
*
*  caps2d version: 10
*
*
*       TRANSISTOR CARDS
*
*
XM1 a_27_164##6 A#4 VGND#3 VNB sky130_fd_pr__nfet_01v8_lvt l=0.15 w=0.55 ad=0.24915 as=0.30395 pd=2.37 ps=2.34
XM0 VGND#3 a_27_164# X#1 VNB sky130_fd_pr__nfet_01v8_lvt l=0.15 w=0.74 ad=0.30395 as=0.2109 pd=2.34 ps=2.05
XM2 a_27_164##4 A#1 VPWR#3 VPB sky130_fd_pr__pfet_01v8 l=0.15 w=0.84 ad=0.2478 as=0.4102 pd=2.27 ps=3.04
XM3 VPWR#3 a_27_164##3 X#2 VPB sky130_fd_pr__pfet_01v8 l=0.15 w=1.12 ad=0.4102 as=0.3304 pd=3.04 ps=2.83
*
*
*       RESISTOR AND CAP/DIODE CARDS
*
Rg1	A#1	A#2	470.389893
Rg2	A#2	A#3	118.588242
Rg3	A#2	A#4	406.684326
Rg4	a_27_164#	a_27_164##2	352.702850
Rg5	a_27_164##2	a_27_164##3	455.703033
Rf1	A	A#3	5.708254
Rf2	A#3	A	13.188035
Rf3	a_27_164##4	a_27_164##5	93.568398
Rf4	a_27_164##5	a_27_164##6	61.980118
Rf5	X#1	X	86.861336
Rf6	X	X#3	13.225628
Rf7	X#3	X	0.181173
Rf8	X#2	X#3	5.000000
Rf10	VGND#2	VGND#3	34.638962
Rf12	VPWR#2	VPWR#3	35.032631
Rf14	a_27_164##2	a_27_164##5	160.232803
Re1	VPWR#2	VPWR	2.455682
Re2	VGND	VGND#2	2.455774
*
*       CAPACITOR CARDS
*
*
C1	VGND	VNB	5.71304e-17
C2	VPWR	VNB	5.88832e-17
C3	X	VNB	6.91211e-17
C4	A	VNB	2.99846e-17
C5	VGND	X	1.46282e-18
C6	A#3	VNB	1.04651e-16
C7	VGND	A	2.43837e-18
C8	a_27_164##2	VNB	4.70052e-17
C9	VPWR	X	2.00338e-17
C10	VPWR	A	6.22866e-18
C11	VGND	A#3	1.65962e-18
C12	A#1	VNB	4.15599e-17
C13	a_27_164##3	VNB	3.73038e-17
C14	VGND	a_27_164##2	4.18227e-18
C15	A#4	VNB	4.86723e-17
C16	a_27_164#	VNB	3.21232e-17
C17	VPWR	A#3	4.13554e-18
C18	a_27_164##4	VNB	5.16913e-17
C19	VPWR#3	VNB	5.36303e-18
C20	VPWR	a_27_164##2	2.67666e-18
C21	a_27_164##6	VNB	3.94263e-17
C22	X	A#3	5.4765e-19
C23	VGND#3	VNB	1.11908e-17
C24	X#1	VNB	5.20023e-17
C25	a_27_164##2	X	5.48263e-17
C26	VGND	A#4	7.79466e-18
C27	A	A#3	1.62043e-17
C28	VGND	a_27_164#	1.82039e-18
C29	VPWR	A#1	1.43701e-18
C30	VPWR	a_27_164##3	4.015e-18
C31	VGND	a_27_164##6	1.79513e-17
C32	VGND	VGND#3	2.2487e-17
C33	X	A#1	1.77103e-18
C34	VGND	X#1	1.91921e-17
C35	X	a_27_164##3	3.5043e-17
C36	VPWR	a_27_164##4	1.7266e-17
C37	VPWR	VPWR#3	2.23592e-17
C38	A#3	a_27_164##2	6.67655e-17
C39	a_27_164##4	X	3.65263e-18
C40	VPWR#3	X	6.78597e-17
C41	X	X#2	5.75544e-18
C42	A	a_27_164##4	1.36407e-17
C43	X#1	X	3.2747e-18
C44	a_27_164##6	A	3.61166e-17
C45	A#3	a_27_164##3	9.16567e-18
C46	a_27_164##2	a_27_164##3	5.47811e-18
C47	A#4	a_27_164##2	1.81345e-18
C48	A#3	a_27_164##4	4.21185e-17
C49	a_27_164##2	a_27_164#	1.95056e-18
C50	a_27_164##2	a_27_164##4	3.70392e-18
C51	a_27_164##6	A#3	4.3608e-17
C52	a_27_164##2	VPWR#3	1.74053e-17
C53	A#1	a_27_164##3	2.87013e-17
C54	a_27_164##2	VGND#3	3.39535e-17
C55	a_27_164##2	X#1	3.29895e-17
C56	a_27_164##4	A#1	5.51787e-17
C57	A#1	VPWR#3	3.29894e-17
C58	a_27_164##4	a_27_164##3	1.27466e-18
C59	a_27_164##3	VPWR#3	2.99566e-17
C60	A#4	a_27_164#	1.91705e-17
C61	a_27_164##3	X#2	1.20052e-17
C62	a_27_164##6	A#4	4.56745e-17
C63	a_27_164##4	VPWR#3	8.029e-17
C64	A#4	VGND#3	2.67631e-17
C65	a_27_164##6	a_27_164#	1.03728e-18
C66	X#1	A#4	2.93835e-18
C67	a_27_164#	VGND#3	2.9278e-17
C68	a_27_164##6	a_27_164##4	1.63036e-18
C69	X#1	a_27_164#	3.61524e-17
C70	a_27_164##6	VGND#3	1.53355e-17
C71	a_27_164##6	X#1	2.85394e-18
C72	VGND#3	X#1	5.39549e-17
C73	VGND#2	A#3	5.39862e-19
C74	A	VPWR#2	1.63771e-18
C75	VPWR#2	a_27_164##3	4.63558e-18
C76	VPWR	VPWR#2	5.77253e-17
C77	VGND#2	VNB	1.89034e-16
C78	VGND#2	X#1	2.20849e-17
C79	VPWR#2	VNB	1.86715e-16
C80	VGND#2	A#4	4.38438e-18
C81	VPWR#2	A#3	4.69907e-19
C82	VGND#2	a_27_164##6	1.10962e-17
C83	VGND#2	a_27_164##2	4.41816e-19
C84	VGND	VGND#2	5.94447e-17
C85	X	VPWR#2	2.23576e-17
C86	VPWR#2	A#1	2.57139e-18
C87	VGND#2	a_27_164#	4.75482e-18
C88	a_27_164##2	VPWR#2	2.51872e-19
C89	a_27_164##4	VPWR#2	2.08475e-17
*
*
.ENDS sky130_fd_sc_hs__buf_1
*
