* Extracted by Quantus, converted by sky130cad/quantus.py
*
*
*
*                       LINUX           Wed Nov 18 08:55:14 2026
*
*
*
*  PROGRAM  advgen
*
*  Name           : advgen - Quantus - (64-bit)
*  Version        : 25.1.0-p047
*  Build Date     : Thu Dec 11 23:20:30 PST 2025
*
*  HSPICE LIBRARY
*
*  OPERATING_TEMPERATURE 150
*  QRC_TECH_DIR <path>/tech
*
*
*

*
.SUBCKT sky130_fd_sc_hs__o21ai_1 VNB VPB VGND VPWR Y A1 A2 B1
*
*
*  caps2d version: 10
*
*
*       TRANSISTOR CARDS
*
*
XM5 a_27_74##2 A1#3 VGND#4 VNB sky130_fd_pr__nfet_01v8_lvt l=0.15 w=0.74 ad=0.2109 as=0.6722 pd=2.05 ps=3.36
XM0 VGND#4 A2#1 a_27_74# VNB sky130_fd_pr__nfet_01v8_lvt l=0.15 w=0.74 ad=0.6722 as=0.2072 pd=3.36 ps=2.04
XM1 a_27_74# B1#1 Y#1 VNB sky130_fd_pr__nfet_01v8_lvt l=0.15 w=0.74 ad=0.2072 as=0.2627 pd=2.04 ps=2.19
XM2 VPWR#5 A1#1 a_162_368# VPB sky130_fd_pr__pfet_01v8 l=0.15 w=1.12 ad=0.4648 as=0.3024 pd=3.07 ps=2.78
XM3 a_162_368# A2#3 Y#2 VPB sky130_fd_pr__pfet_01v8 l=0.15 w=1.12 ad=0.3024 as=0.5656 pd=2.78 ps=3.25
XM4 Y#2 B1#3 VPWR#1 VPB sky130_fd_pr__pfet_01v8 l=0.15 w=1.12 ad=0.5656 as=0.3304 pd=3.25 ps=2.83
*
*
*       RESISTOR AND CAP/DIODE CARDS
*
Rg1	A1#1	A1#2	537.384216
Rg2	A1#2	A1#3	301.252594
Rg3	A2#1	A2#2	403.362732
Rg4	A2#2	A2#3	451.603058
Rg5	B1#1	B1#2	382.539734
Rg6	B1#2	B1#3	434.639221
Rf1	A1	A1#4	1.375212
Rf2	A1#5	A1#2	161.608017
Rf3	A1#4	A1#5	5.294745
Rf4	A2#2	A2	166.137894
Rf5	a_27_74#	a_27_74##2	110.847694
Rf6	B1#4	B1	1.409262
Rf7	B1#2	B1#6	161.642059
Rf8	B1#4	B1#6	6.264856
Rf9	B1#7	B1	1.409262
Rf10	B1#6	B1#7	8.404075
Rf11	Y#1	Y	186.455261
Rf12	Y	Y#2	7.348500
Rf13	VPWR#1	VPWR#2	93.067902
Rf14	VPWR#2	VPWR#3	56.281700
Rf16	VPWR#3	VPWR#5	48.259808
Rf19	VGND#2	VGND#4	14.013233
Re1	VPWR#2	VPWR	1.964508
Re2	VGND	VGND#2	1.964582
*
*       CAPACITOR CARDS
*
*
C1	VGND	VNB	5.66341e-17
C2	VPWR	VNB	6.2584e-17
C3	Y	VNB	1.57936e-17
C4	A2	VNB	4.6528e-18
C5	B1	VNB	2.59935e-17
C6	A1#2	VNB	5.88728e-17
C7	A2#2	VNB	3.32361e-17
C8	B1#2	VNB	4.55598e-17
C9	VGND	Y	1.83137e-18
C10	VPWR#2	VNB	1.47743e-16
C11	A1#1	VNB	4.80213e-17
C12	A2#3	VNB	3.36692e-17
C13	B1#3	VNB	3.69388e-17
C14	VPWR	Y	3.26448e-17
C15	VGND	A2	2.59275e-18
C16	A1#3	VNB	3.40804e-17
C17	A2#1	VNB	2.47453e-17
C18	B1#1	VNB	3.25151e-17
C19	VGND	B1	4.20328e-18
C20	VPWR#5	VNB	4.49524e-17
C21	VPWR#1	VNB	7.83867e-17
C22	VPWR	A2	2.51368e-18
C23	a_27_74##2	VNB	3.87173e-17
C24	VGND#4	VNB	5.16975e-17
C25	a_27_74#	VNB	2.82935e-18
C26	Y#1	VNB	5.20534e-17
C27	VPWR	B1	7.23063e-18
C28	A1#4	VNB	2.36846e-17
C29	A1#5	VNB	4.14843e-18
C30	Y	A2	7.5234e-17
C31	VGND	A1#2	1.39974e-18
C32	B1#6	VNB	1.30044e-18
C33	VPWR	A1#2	1.25202e-18
C34	Y	a_162_368#	3.47349e-18
C35	A2	B1	3.8463e-17
C36	Y	A1#2	1.33852e-17
C37	VPWR	VPWR#2	2.10853e-17
C38	Y	A2#2	1.28509e-17
C39	VGND	A1#3	1.91316e-18
C40	VGND	A2#1	3.21963e-19
C41	Y	B1#2	2.09055e-19
C42	VPWR	A1#1	2.29384e-18
C43	VGND	B1#1	2.30782e-18
C44	VGND	VPWR#5	2.88572e-18
C45	VPWR	A2#3	7.66352e-20
C46	VPWR	B1#3	7.90297e-19
C47	Y	VPWR#2	3.3938e-17
C48	A2	A1#2	3.72106e-18
C49	VGND	a_27_74##2	2.05969e-17
C50	Y	A1#1	3.48525e-17
C51	VGND	VGND#4	6.37453e-17
C52	A2	A2#2	1.57985e-17
C53	VGND	a_27_74#	1.86136e-17
C54	Y	A2#3	5.9428e-17
C55	VGND	Y#1	2.25356e-17
C56	A2	B1#2	2.32293e-18
C57	VGND	A1#4	2.01884e-18
C58	Y	B1#3	2.02256e-17
C59	VGND	A1#5	1.54511e-18
C60	B1	A2#2	8.18491e-18
C61	Y	A1#3	7.93565e-18
C62	B1	B1#2	1.63019e-17
C63	VPWR	VPWR#1	4.42773e-17
C64	VGND	B1#6	1.23129e-18
C65	VPWR#5	Y	1.09884e-16
C66	A2	A1#1	1.47197e-18
C67	B1	VPWR#2	1.10234e-18
C68	VPWR	A1#4	2.85818e-18
C69	A2	A2#3	1.47897e-18
C70	Y	Y#2	9.31065e-18
C71	VPWR	A1#5	1.74852e-18
C72	Y	VPWR#1	5.53015e-17
C73	A2	B1#3	7.02499e-19
C74	a_27_74##2	Y	2.5538e-17
C75	Y	VGND#4	6.71308e-18
C76	VPWR	B1#6	1.04581e-18
C77	B1	A2#3	4.73857e-19
C78	A1#2	A2#2	2.23984e-17
C79	B1	B1#3	1.62566e-18
C80	Y#1	Y	9.10753e-18
C81	A1#5	Y	3.93946e-17
C82	A1#1	a_162_368#	2.27629e-17
C83	A2#2	B1#2	3.01762e-17
C84	A2#3	a_162_368#	1.98156e-17
C85	VPWR#2	A2#2	1.01115e-19
C86	Y#1	A2	3.6026e-17
C87	B1	VPWR#1	2.72513e-17
C88	A1#1	A2#2	5.45903e-18
C89	Y#1	B1	4.93674e-17
C90	A1#2	A2#1	1.65357e-18
C91	VPWR#5	A1#2	8.27196e-18
C92	VPWR#2	A2#3	5.33885e-18
C93	A1#1	A2#3	5.30976e-17
C94	A1#2	a_27_74##2	7.49882e-18
C95	A2#2	Y#2	3.28931e-19
C96	A1#2	VGND#4	1.98748e-18
C97	A2#3	B1#3	2.08788e-17
C98	VGND#4	A2#2	9.8353e-19
C99	B1#2	VPWR#1	3.46568e-18
C100	A1#4	A1#2	1.09782e-17
C101	a_27_74#	A2#2	8.22277e-19
C102	A1#5	A1#2	1.59163e-17
C103	Y#1	A2#2	3.64593e-18
C104	VPWR#2	VPWR#1	3.13035e-17
C105	Y#1	B1#2	2.91361e-18
C106	VPWR#5	A1#1	2.15777e-17
C107	VPWR#5	A2#3	7.28434e-19
C108	VPWR#5	B1#3	3.89995e-19
C109	VPWR#1	A1#1	6.59721e-19
C110	A1#3	A2#1	5.2495e-18
C111	A2#3	Y#2	3.14459e-17
C112	B1#6	B1#2	1.0491e-17
C113	VPWR#1	A2#3	6.93426e-18
C114	B1#3	Y#2	3.89919e-18
C115	A2#1	B1#1	3.98205e-17
C116	VPWR#1	B1#3	5.11094e-17
C117	a_27_74##2	A1#3	4.75993e-17
C118	A1#3	VGND#4	3.43144e-17
C119	a_27_74##2	A2#1	1.85122e-18
C120	a_27_74#	A1#3	8.05339e-19
C121	A2#1	VGND#4	3.23654e-17
C122	a_27_74##2	B1#1	7.35842e-19
C123	VPWR#5	VPWR#1	1.08012e-18
C124	Y#1	A1#3	1.58174e-19
C125	a_27_74#	A2#1	4.22633e-17
C126	VGND#4	B1#1	5.78301e-18
C127	a_27_74##2	VPWR#5	2.73821e-19
C128	Y#1	A2#1	1.99854e-17
C129	a_27_74#	B1#1	3.21428e-17
C130	B1#6	B1#3	2.34509e-18
C131	Y#1	B1#1	3.01135e-17
C132	A1#4	VPWR#5	7.00535e-18
C133	A1#5	VPWR#5	1.56287e-17
C134	a_27_74##2	VGND#4	6.03843e-17
C135	a_27_74##2	a_27_74#	1.49559e-18
C136	a_27_74##2	Y#1	1.93144e-18
C137	a_27_74#	VGND#4	7.15871e-17
C138	a_27_74##2	A1#4	1.84166e-17
C139	Y#1	VGND#4	1.49027e-18
C140	a_27_74##2	A1#5	2.22376e-17
C141	Y#1	a_27_74#	1.12875e-16
C142	B1#6	VPWR#1	2.21097e-17
C143	Y#1	B1#6	2.0068e-17
C144	VGND#2	VGND#4	6.301e-17
C145	VGND#2	Y#1	2.49551e-17
C146	VPWR#3	A1#2	4.04135e-19
C147	VGND#2	VNB	1.67962e-16
C148	VGND	VGND#2	2.73634e-17
C149	VPWR#3	B1#3	1.78249e-19
C150	A1#4	VPWR#3	5.33128e-19
C151	VPWR#3	VPWR#1	3.06929e-19
C152	Y	VPWR#3	4.81017e-18
C153	VPWR#3	A1#1	9.84567e-18
C154	VGND#2	a_27_74##2	1.34537e-17
C155	VPWR#2	VPWR#3	3.71215e-17
C156	VGND#2	A1#2	1.23509e-19
C157	VPWR#3	A2#3	5.37219e-19
C158	VGND#2	B1#2	7.02761e-20
C159	VPWR#3	VNB	3.73111e-17
C160	VGND#2	B1#1	1.09463e-18
C161	VPWR	VPWR#3	4.03584e-17
*
*
.ENDS sky130_fd_sc_hs__o21ai_1
*
