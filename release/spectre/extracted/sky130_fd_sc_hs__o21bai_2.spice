* Extracted by Quantus, converted by sky130cad/quantus.py
*
*
*
*                       LINUX           Wed Nov 18 08:56:46 2026
*
*
*
*  PROGRAM  advgen
*
*  Name           : advgen - Quantus - (64-bit)
*  Version        : 25.1.0-p047
*  Build Date     : Thu Dec 11 23:20:30 PST 2025
*
*  HSPICE LIBRARY
*
*  OPERATING_TEMPERATURE 150
*  QRC_TECH_DIR <path>/tech
*
*
*

*
.SUBCKT sky130_fd_sc_hs__o21bai_2 VNB VPB VGND VPWR Y A1 B1_N A2
*
*
*  caps2d version: 10
*
*
*       TRANSISTOR CARDS
*
*
XM12 a_27_74##10 B1_N#3 VGND#9 VNB sky130_fd_pr__nfet_01v8_lvt l=0.15 w=0.64 ad=0.1824 as=0.1824 pd=1.85 ps=1.85
XM8 Y#4 a_27_74##6 a_225_74##5 VNB sky130_fd_pr__nfet_01v8_lvt l=0.15 w=0.74 ad=0.2072 as=0.2109 pd=2.04 ps=2.05
XM10 a_225_74##3 a_27_74##5 Y#4 VNB sky130_fd_pr__nfet_01v8_lvt l=0.15 w=0.74 ad=0.259 as=0.2072 pd=2.18 ps=2.04
XM13 VGND#8 A1#3 a_225_74##3 VNB sky130_fd_pr__nfet_01v8_lvt l=0.15 w=0.74 ad=0.2812 as=0.259 pd=2.24 ps=2.18
XM11 VGND#8 A2#5 a_225_74##6 VNB sky130_fd_pr__nfet_01v8_lvt l=0.15 w=0.74 ad=0.2812 as=0.2072 pd=2.24 ps=2.04
XM1 a_225_74##6 A2#1 VGND#7 VNB sky130_fd_pr__nfet_01v8_lvt l=0.15 w=0.74 ad=0.2072 as=0.2072 pd=2.04 ps=2.04
XM5 a_225_74# A1#6 VGND#7 VNB sky130_fd_pr__nfet_01v8_lvt l=0.15 w=0.74 ad=0.2109 as=0.2072 pd=2.05 ps=2.04
XM4 a_27_74##11 B1_N#1 VPWR#6 VPB sky130_fd_pr__pfet_01v8 l=0.15 w=1 ad=0.305 as=0.6728 pd=2.61 ps=3.48
XM3 VPWR#6 a_27_74##7 Y#2 VPB sky130_fd_pr__pfet_01v8 l=0.15 w=1.12 ad=0.6728 as=0.336 pd=3.48 ps=2.84
XM9 Y#2 a_27_74# VPWR#5 VPB sky130_fd_pr__pfet_01v8 l=0.15 w=1.12 ad=0.336 as=0.4368 pd=2.84 ps=3.02
XM6 a_507_368##2 A1#1 VPWR#5 VPB sky130_fd_pr__pfet_01v8 l=0.15 w=1.12 ad=0.336 as=0.4368 pd=2.84 ps=3.02
XM2 Y#1 A2#6 a_507_368##2 VPB sky130_fd_pr__pfet_01v8 l=0.15 w=1.12 ad=0.336 as=0.336 pd=2.84 ps=2.84
XM7 a_507_368# A2#4 Y#1 VPB sky130_fd_pr__pfet_01v8 l=0.15 w=1.12 ad=0.3416 as=0.336 pd=2.85 ps=2.84
XM0 VPWR#1 A1#4 a_507_368# VPB sky130_fd_pr__pfet_01v8 l=0.15 w=1.12 ad=0.3304 as=0.3416 pd=2.83 ps=2.85
*
*
*       RESISTOR AND CAP/DIODE CARDS
*
Rg1	B1_N#1	B1_N#2	417.171356
Rg2	B1_N#2	B1_N#3	438.086243
Rg3	a_27_74#	a_27_74##2	563.218445
Rg4	a_27_74##2	a_27_74##3	72.593590
Rg5	a_27_74##3	a_27_74##4	49.877266
Rg6	a_27_74##2	a_27_74##5	368.220947
Rg7	a_27_74##3	a_27_74##6	319.959229
Rg8	a_27_74##3	a_27_74##7	504.081116
Rg9	A1#1	A1#2	442.817719
Rg10	A1#2	A1#3	394.958344
Rg11	A2#1	A2#2	397.555725
Rg12	A2#2	A2#3	47.331100
Rg13	A2#2	A2#4	449.655212
Rg14	A2#3	A2#5	401.056915
Rg15	A2#3	A2#6	447.848328
Rg16	A1#4	A1#5	447.963806
Rg17	A1#5	A1#6	365.323883
Rf1	B1_N#2	B1_N#5	161.684418
Rf2	B1_N#6	B1_N	1.451613
Rf3	B1_N#5	B1_N#6	5.227210
Rf4	a_27_74##4	a_27_74##9	227.615967
Rf5	a_27_74##9	a_27_74##10	28.728701
Rf6	a_27_74##9	a_27_74##11	83.946533
Rf7	Y#1	Y#3	115.854256
Rf8	Y#3	Y	14.381578
Rf9	Y	Y#4	39.733986
Rf10	Y#2	Y#3	5.000000
Rf11	A2#3	A2#8	161.608017
Rf12	A2#9	A2	1.375212
Rf13	A2#8	A2#9	4.743209
Rf14	a_507_368#	a_507_368##2	97.422989
Rf15	A1#5	A1	175.791367
Rf16	A1	A1#2	275.826935
Rf17	a_225_74#	a_225_74##2	84.292526
Rf18	a_225_74##2	a_225_74##4	77.621117
Rf19	a_225_74##4	a_225_74##5	98.348511
Rf20	a_225_74##2	a_225_74##6	26.376577
Rf21	a_225_74##3	a_225_74##4	7.500000
Rf22	VPWR#1	VPWR#2	188.586716
Rf23	VPWR#2	VPWR#3	73.610367
Rf25	VPWR#2	VPWR#5	33.316479
Rf26	VPWR#3	VPWR#6	38.286041
Rf28	VGND#2	VGND#3	64.965874
Rf29	VGND#3	VGND#4	39.422733
Rf30	VGND#4	VGND#5	105.898689
Rf32	VGND#2	VGND#7	37.066368
Rf33	VGND#3	VGND#8	38.247387
Rf34	VGND#5	VGND#9	38.247387
Re1	VPWR#2	VPWR	1.091357
Re2	VGND	VGND#4	1.091398
*
*       CAPACITOR CARDS
*
*
C1	a_225_74##2	A2#8	4.18371e-17
C2	VGND#3	VGND#7	4.17523e-19
C3	VGND#3	a_225_74##6	4.50772e-18
C4	VGND#3	a_225_74##3	6.21911e-18
C5	a_225_74##3	a_27_74##2	1.32921e-18
C6	a_225_74##2	a_225_74#	1.89366e-19
C7	a_225_74##2	VGND#7	2.32591e-17
C8	a_225_74##2	a_225_74##6	1.8457e-18
C9	a_27_74##2	Y#4	4.34011e-19
C10	a_225_74##2	VGND#8	2.05684e-17
C11	a_225_74##3	a_225_74##2	1.733e-18
C12	a_225_74##5	a_27_74##2	1.95424e-19
C13	a_27_74##9	B1_N#5	4.35275e-17
C14	VPWR#2	a_27_74##2	4.13939e-20
C15	VGND#4	a_27_74##2	6.3249e-20
C16	a_27_74##9	Y#4	5.64685e-19
C17	a_225_74#	VGND#7	4.80014e-17
C18	a_225_74##6	a_225_74#	2.06074e-18
C19	VGND#9	a_27_74##9	1.68256e-17
C20	a_225_74##6	VGND#7	3.9266e-17
C21	a_27_74##9	a_27_74##10	1.56812e-18
C22	VGND#8	VGND#7	1.56571e-18
C23	VGND#8	a_225_74##6	3.62659e-17
C24	VGND#3	A2#1	8.7173e-19
C25	a_225_74##3	a_225_74##6	1.41585e-18
C26	a_27_74##2	A1#2	3.2836e-17
C27	a_225_74##3	VGND#8	6.18161e-17
C28	VGND#3	A2#5	5.13483e-18
C29	VGND#3	A1#3	4.87685e-18
C30	a_225_74##3	Y#4	5.02924e-17
C31	a_225_74##2	A1#6	7.05443e-20
C32	a_225_74#	VPWR#1	5.42094e-18
C33	a_27_74##4	a_27_74##2	6.14646e-18
C34	VGND#3	a_27_74##5	2.9235e-19
C35	a_225_74##5	a_225_74##3	3.4302e-18
C36	a_225_74##2	A2#1	1.67673e-17
C37	a_225_74##5	Y#4	4.07632e-17
C38	VGND#3	a_27_74##6	8.37594e-20
C39	a_225_74##2	A2#5	2.11194e-17
C40	VGND#9	a_225_74##5	3.98899e-17
C41	VGND#3	B1_N#3	5.11682e-20
C42	a_27_74##10	Y#4	6.11257e-19
C43	a_27_74##9	a_27_74##11	2.2254e-18
C44	a_225_74##2	A1#3	2.9897e-19
C45	a_27_74##10	VGND#9	4.23256e-17
C46	a_225_74##3	Y#2	5.23622e-18
C47	a_225_74#	A1#6	3.01341e-17
C48	a_507_368#	VPWR#1	9.29016e-17
C49	VGND#7	A1#6	2.9306e-17
C50	a_27_74##9	a_27_74##5	8.94025e-20
C51	a_225_74#	A2#1	8.48022e-19
C52	a_225_74##6	A1#6	7.67688e-19
C53	VGND#7	A2#1	2.80717e-17
C54	a_507_368#	Y#1	4.48922e-17
C55	a_225_74#	A2#5	1.87602e-19
C56	a_27_74##9	a_27_74##6	3.25148e-19
C57	a_225_74##5	VPWR#6	2.92072e-19
C58	A2#1	a_225_74##6	1.37348e-17
C59	VGND#7	A2#5	1.45998e-18
C60	a_507_368##2	a_507_368#	3.02429e-18
C61	VPWR#5	VPWR#1	7.82013e-20
C62	VGND#8	A2#1	1.20768e-18
C63	a_27_74##9	B1_N#3	2.33668e-17
C64	A2#5	a_225_74##6	1.72361e-17
C65	Y#1	a_507_368##2	5.35021e-17
C66	VGND#7	A1#3	1.48756e-19
C67	a_225_74##3	A2#1	2.66817e-19
C68	A2#5	VGND#8	2.07385e-17
C69	a_225_74##6	A1#3	8.16466e-19
C70	a_225_74##3	A2#5	1.57558e-18
C71	A1#3	VGND#8	2.2082e-17
C72	VPWR#5	a_507_368##2	3.92745e-17
C73	Y#2	Y#1	9.39983e-19
C74	a_225_74##3	A1#3	6.30083e-17
C75	Y#2	a_507_368##2	9.22411e-19
C76	Y#4	A1#3	7.01473e-19
C77	a_225_74##3	a_27_74##5	2.7582e-17
C78	Y#2	VPWR#5	6.40426e-17
C79	a_225_74##5	A1#3	2.60206e-19
C80	Y#4	a_27_74##5	3.05321e-17
C81	VPWR#6	VPWR#5	1.93155e-18
C82	a_225_74##3	a_27_74##6	5.29028e-19
C83	a_225_74##5	a_27_74##5	1.17892e-18
C84	a_27_74##6	Y#4	1.27467e-17
C85	VPWR#6	Y#2	6.37095e-17
C86	a_225_74##5	a_27_74##6	6.19112e-17
C87	Y#4	B1_N#3	7.90327e-19
C88	a_27_74##10	a_27_74##5	9.67759e-20
C89	VGND#9	a_27_74##6	9.78893e-19
C90	a_225_74##5	B1_N#3	1.53135e-18
C91	a_27_74##11	VPWR#6	4.76438e-17
C92	a_27_74##10	a_27_74##6	3.51965e-19
C93	VGND#9	B1_N#3	3.78056e-17
C94	VGND#4	VGND#3	3.04298e-17
C95	B1_N#3	a_27_74##10	1.45104e-17
C96	A2#1	A1#6	3.90865e-17
C97	VPWR#1	A1#4	3.40798e-17
C98	VGND#3	A2#3	2.94706e-20
C99	a_507_368#	A1#4	4.6729e-17
C100	A2#5	A2#1	4.14471e-17
C101	VPWR#1	A2#4	4.50454e-18
C102	a_225_74##2	A1#5	2.34478e-17
C103	a_507_368#	A2#4	5.50251e-17
C104	VPWR#1	A2#6	5.01684e-19
C105	A2#4	Y#1	2.44627e-17
C106	A1#3	A2#5	2.57378e-17
C107	VPWR#5	A1#4	7.57205e-20
C108	a_507_368#	A2#6	1.38137e-18
C109	a_507_368##2	A2#4	8.28236e-19
C110	a_225_74##2	A2#3	6.50456e-18
C111	VPWR#1	A1#1	2.792e-19
C112	Y#1	A2#6	3.89784e-17
C113	Y#2	A1#4	1.49412e-19
C114	A2#8	A1#5	1.69446e-17
C115	VPWR#5	A2#4	9.64397e-20
C116	a_507_368##2	A2#6	4.44146e-17
C117	VPWR#1	a_27_74#	3.10093e-19
C118	a_27_74##5	A1#3	2.70719e-17
C119	Y#2	A2#4	2.60347e-19
C120	Y#1	A1#1	7.23367e-18
C121	a_225_74##2	A1#2	3.24489e-18
C122	VPWR#5	A2#6	3.23382e-19
C123	a_507_368##2	A1#1	3.74509e-17
C124	A2#8	A2#3	1.46935e-17
C125	Y#2	A2#6	4.25959e-19
C126	Y#1	a_27_74#	1.78103e-19
C127	A1#1	VPWR#5	2.96046e-17
C128	a_27_74##6	a_27_74##5	3.74842e-17
C129	a_507_368##2	a_27_74#	8.48293e-19
C130	a_27_74##2	A1#3	2.17169e-18
C131	Y#2	A1#1	1.21569e-17
C132	Y#1	a_27_74##7	9.11229e-20
C133	A1#2	A2#8	1.76582e-17
C134	VPWR#5	a_27_74#	3.68587e-17
C135	A1#5	a_225_74#	4.54414e-17
C136	a_507_368##2	a_27_74##7	1.97296e-19
C137	Y#2	a_27_74#	4.1511e-17
C138	VGND#4	a_225_74##3	4.3839e-17
C139	B1_N#3	a_27_74##6	4.18457e-18
C140	Y	a_27_74##2	1.82296e-17
C141	VPWR#5	a_27_74##7	2.13705e-18
C142	VPWR#6	a_27_74#	1.18943e-18
C143	Y#2	a_27_74##7	4.57997e-17
C144	VGND#4	a_225_74##5	2.03771e-17
C145	VPWR#2	VPWR#1	4.37153e-17
C146	a_27_74##7	VPWR#6	3.33329e-17
C147	a_27_74##9	a_27_74##4	2.62244e-18
C148	a_507_368#	VPWR#2	1.29811e-17
C149	Y#2	B1_N#1	1.29667e-18
C150	a_27_74##11	a_27_74##7	1.91645e-18
C151	Y#1	VPWR#2	5.14161e-19
C152	B1_N#1	VPWR#6	3.83534e-17
C153	a_507_368##2	VPWR#2	4.50253e-17
C154	a_27_74##11	B1_N#1	4.45713e-17
C155	a_27_74##9	B1_N#2	8.97986e-18
C156	a_27_74##4	B1_N#5	3.21485e-17
C157	VGND#8	A1#2	5.2134e-19
C158	A1#5	VPWR#1	2.70043e-17
C159	a_225_74##3	A1#2	4.21082e-17
C160	Y#2	VPWR#2	7.92128e-18
C161	B1_N#5	B1_N#2	1.04069e-17
C162	A2#4	A1#4	4.47045e-17
C163	a_507_368#	A2#3	8.18384e-20
C164	a_27_74##4	Y#4	6.85709e-18
C165	A2#3	Y#1	1.37405e-18
C166	a_27_74##4	a_225_74##5	3.57657e-17
C167	A2#6	A2#4	4.66773e-17
C168	a_507_368##2	A2#3	1.00152e-19
C169	VGND#9	a_27_74##4	2.32492e-17
C170	A1#2	Y#1	4.467e-17
C171	A1#2	a_507_368##2	3.31593e-18
C172	A1#1	A2#6	4.59623e-17
C173	VGND#9	B1_N#2	1.1566e-18
C174	A2#1	A1#5	6.95981e-19
C175	VGND#4	A1#3	1.47809e-18
C176	A1#2	Y#2	1.86338e-17
C177	VGND#4	a_27_74##5	4.43427e-18
C178	a_27_74#	A1#1	3.1862e-17
C179	VGND#4	a_27_74##6	2.3746e-18
C180	VGND#3	a_225_74##2	4.90681e-19
C181	a_27_74##4	VPWR#6	2.65386e-17
C182	a_27_74##7	a_27_74#	4.94256e-17
C183	VPWR#2	A2#4	1.70683e-18
C184	VPWR#2	A2#6	4.4526e-18
C185	B1_N#2	a_27_74##11	7.61719e-18
C186	B1_N#1	a_27_74##7	1.3736e-17
C187	VPWR#2	A1#1	4.17843e-18
C188	a_27_74##4	a_27_74##5	7.14024e-19
C189	VPWR#2	a_27_74#	1.7986e-18
C190	A2#3	A1#4	5.90261e-19
C191	a_27_74##4	a_27_74##6	3.09325e-18
C192	a_27_74##9	B1_N	2.06279e-18
C193	a_225_74##2	A1	4.09633e-18
C194	B1_N#3	a_27_74##4	8.09492e-20
C195	A1#2	A1#4	9.08834e-20
C196	A1#2	A2#4	1.52613e-19
C197	A1#2	A2#6	1.62273e-17
C198	A1#2	A1#1	1.34106e-17
C199	a_27_74#	A1#2	8.2691e-18
C200	a_27_74##4	a_27_74#	4.87078e-19
C201	VPWR#2	A2#3	2.86166e-20
C202	B1_N#5	Y	1.051e-18
C203	B1_N#2	a_27_74##7	9.8389e-19
C204	a_27_74##2	VNB	2.42582e-17
C205	A1	VPWR#1	2.22037e-17
C206	A2#3	A1#5	3.50388e-17
C207	VGND#4	A1#2	2.144e-20
C208	A1	a_507_368#	3.93564e-17
C209	VPWR#2	a_27_74##4	2.04172e-20
C210	a_27_74##11	B1_N	3.50559e-17
C211	Y	a_225_74##3	1.57354e-17
C212	A1	Y#1	2.41205e-17
C213	VGND	VGND#3	4.16947e-17
C214	VGND#4	a_27_74##4	5.64994e-20
C215	a_225_74##5	Y	8.90503e-19
C216	A1#2	A2#3	2.93944e-17
C217	VGND	a_225_74##2	4.05714e-18
C218	A2	A1#4	4.33512e-19
C219	A2	A2#4	1.34793e-18
C220	VGND	A2#8	3.43468e-18
C221	A2	A2#6	2.05777e-18
C222	VGND	a_27_74##9	1.71412e-18
C223	VPWR#6	Y	2.73796e-17
C224	A2	A1#1	5.49273e-19
C225	a_27_74##11	Y	4.9975e-19
C226	VPWR	VPWR#1	4.34524e-17
C227	VGND	B1_N#5	3.44454e-18
C228	Y	A1#6	8.54186e-20
C229	VPWR	a_507_368#	2.20183e-17
C230	VGND	a_225_74#	1.45304e-17
C231	VPWR	Y#1	8.63243e-18
C232	Y	A2#1	1.07275e-19
C233	B1_N#2	a_27_74##4	3.04179e-17
C234	VPWR	a_507_368##2	1.99294e-17
C235	VGND	a_225_74##6	1.13075e-17
C236	Y	A2#5	2.38228e-19
C237	VPWR	VPWR#5	1.98107e-17
C238	Y	A1#3	5.40066e-19
C239	VGND	a_225_74##3	2.39834e-17
C240	A1	A1#4	9.52738e-18
C241	VPWR	Y#2	1.86486e-17
C242	VGND	Y#4	7.84713e-18
C243	Y	a_27_74##5	1.04581e-18
C244	VPWR	VPWR#6	2.08909e-17
C245	A1	A2#4	2.29527e-17
C246	VGND	a_225_74##5	2.29427e-17
C247	Y	a_27_74##6	3.29729e-19
C248	VPWR	a_27_74##11	2.24997e-17
C249	B1_N	a_27_74##7	1.33264e-18
C250	A1	A2#6	5.49562e-19
C251	VGND	a_27_74##10	1.60692e-17
C252	Y	B1_N#3	3.76311e-20
C253	VGND	VPWR#1	3.425e-18
C254	B1_N	B1_N#1	4.48145e-18
C255	A1	A1#1	9.93214e-20
C256	Y	A1#4	1.10771e-19
C257	Y	A2#4	1.14611e-19
C258	A2	A1#5	4.48918e-18
C259	Y	A2#6	1.85597e-19
C260	A2	A2#3	8.41942e-18
C261	VGND	VPWR#6	2.686e-18
C262	Y	A1#1	2.00171e-18
C263	VGND#3	VNB	2.54216e-17
C264	VGND	A1#6	1.46575e-18
C265	Y	a_27_74#	1.1753e-17
C266	A1#2	A2	3.26325e-17
C267	VGND	A2#1	6.54655e-19
C268	VPWR	A1#4	2.97324e-18
C269	Y	a_27_74##7	1.01518e-17
C270	VGND	A2#5	9.09012e-19
C271	VPWR	A2#4	1.37625e-18
C272	VGND	A1#3	1.31865e-18
C273	Y	B1_N#1	1.4065e-18
C274	a_225_74##2	VNB	3.94208e-18
C275	VPWR	A2#6	1.49369e-18
C276	VGND	a_27_74##5	1.50795e-18
C277	A1	A1#5	2.42228e-18
C278	VPWR	A1#1	1.51943e-18
C279	VGND	a_27_74##6	1.68211e-18
C280	A2#8	VNB	2.52093e-18
C281	VGND	B1_N#3	1.65689e-18
C282	VPWR	a_27_74#	7.62943e-19
C283	B1_N	a_27_74##4	7.77374e-19
C284	A1	A2#3	3.98744e-18
C285	a_27_74##9	VNB	3.30236e-17
C286	VPWR	a_27_74##7	5.0325e-18
C287	A1#2	A1	1.85602e-18
C288	B1_N	B1_N#2	6.76061e-18
C289	VPWR	B1_N#1	8.9998e-18
C290	B1_N#5	VNB	3.41318e-18
C291	Y	A1#5	1.39847e-18
C292	a_225_74#	VNB	4.30709e-17
C293	VGND#7	VNB	1.66473e-18
C294	a_225_74##6	VNB	4.55126e-18
C295	Y	A2#3	4.10276e-19
C296	VGND#8	VNB	1.99921e-18
C297	VPWR	VPWR#2	3.59974e-17
C298	a_225_74##3	VNB	1.03458e-17
C299	Y	A1#2	3.87335e-17
C300	a_225_74##5	VNB	1.08177e-17
C301	VGND#9	VNB	7.01727e-18
C302	a_27_74##10	VNB	2.64842e-17
C303	VPWR	A1#5	2.34485e-18
C304	Y	a_27_74##4	5.90298e-17
C305	VPWR#1	VNB	9.54072e-17
C306	a_507_368#	VNB	3.45222e-18
C307	Y	B1_N#2	1.23605e-18
C308	a_507_368##2	VNB	3.18756e-18
C309	VPWR#5	VNB	1.41856e-18
C310	VPWR	A1#2	5.37899e-18
C311	Y#2	VNB	2.3068e-18
C312	VPWR#6	VNB	9.04338e-18
C313	VGND	VGND#4	1.63647e-17
C314	VPWR	a_27_74##4	2.29074e-18
C315	a_27_74##11	VNB	6.55169e-17
C316	A1#6	VNB	3.04865e-17
C317	VGND	A1#5	4.90375e-18
C318	A2#1	VNB	2.52465e-17
C319	A2#5	VNB	2.71089e-17
C320	A1#3	VNB	3.01843e-17
C321	a_27_74##5	VNB	2.67815e-17
C322	VGND	A1#2	3.62166e-18
C323	A2	A1	2.85715e-17
C324	a_27_74##6	VNB	2.86548e-17
C325	B1_N#3	VNB	3.81172e-17
C326	VGND	a_27_74##4	7.41672e-18
C327	A1#4	VNB	4.17099e-17
C328	A2#4	VNB	3.45074e-17
C329	A2#6	VNB	3.19388e-17
C330	A1#1	VNB	3.05466e-17
C331	a_27_74#	VNB	3.341e-17
C332	B1_N	Y	7.18454e-18
C333	a_27_74##7	VNB	4.0857e-17
C334	VPWR	A2	2.9746e-18
C335	B1_N#1	VNB	4.46036e-17
C336	VPWR#2	VNB	2.36784e-16
C337	VPWR	B1_N	5.47218e-18
C338	VGND#4	VNB	2.13841e-16
C339	A1#5	VNB	6.76185e-17
C340	VPWR	A1	4.45123e-18
C341	A2#3	VNB	4.99424e-17
C342	A1#2	VNB	3.63932e-17
C343	a_27_74##4	VNB	6.52597e-17
C344	B1_N#2	VNB	4.85674e-17
C345	VGND	Y	1.23662e-18
C346	A2	VNB	2.62892e-18
C347	B1_N	VNB	1.575e-18
C348	A1	VNB	4.73402e-18
C349	Y	VNB	1.82411e-18
C350	VPWR	VNB	7.36399e-17
C351	VGND	VNB	6.9199e-17
C352	a_27_74##11	VPWR#3	2.03056e-17
C353	VGND#5	VGND#3	2.7097e-19
C354	VGND#5	A2#5	1.48752e-20
C355	VGND#2	A1#6	4.88934e-18
C356	VGND#5	A1#3	2.50461e-20
C357	VGND#5	a_27_74##5	1.95536e-19
C358	VGND#3	VGND#2	1.3976e-18
C359	VGND#5	a_27_74##6	3.1218e-18
C360	VGND#2	A2#1	4.96896e-18
C361	VPWR	VPWR#3	4.65684e-17
C362	VGND#5	B1_N#3	5.60569e-18
C363	VGND#2	A2#5	8.84261e-19
C364	VPWR#3	a_27_74##7	6.23055e-18
C365	VGND#2	A1#3	1.69263e-19
C366	VGND#5	a_27_74##9	2.91756e-19
C367	VPWR#3	B1_N#1	1.34772e-17
C368	VGND#4	VGND#2	5.10365e-17
C369	VGND#4	VGND#5	6.31842e-17
C370	VPWR#3	VPWR#5	1.44748e-19
C371	VGND#2	A1#5	1.01125e-19
C372	VPWR#3	a_27_74##4	2.09766e-20
C373	VGND#5	a_27_74##4	2.33396e-18
C374	VGND#2	A2#3	4.4886e-20
C375	VPWR#3	VNB	6.25478e-17
C376	VGND	VGND#2	5.03876e-17
C377	Y#2	VPWR#3	6.66162e-18
C378	B1_N	VPWR#3	8.90265e-19
C379	VGND#2	a_225_74#	1.78523e-17
C380	VGND#2	a_225_74##2	3.0608e-19
C381	VPWR#3	B1_N#2	6.69616e-20
C382	VGND#5	a_225_74##5	3.36935e-17
C383	VPWR#2	VPWR#3	7.09838e-17
C384	VGND#5	a_27_74##10	1.76149e-17
C385	VGND#2	VNB	4.56129e-17
C386	VGND#2	a_225_74##6	5.95278e-18
C387	VGND	VGND#5	6.05823e-17
C388	VGND#5	VNB	5.92563e-17
*
*
.ENDS sky130_fd_sc_hs__o21bai_2
*
