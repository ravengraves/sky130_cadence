* Extracted by Quantus, converted by sky130cad/quantus.py
*
*
*
*                       LINUX           Wed Nov 18 08:47:05 2026
*
*
*
*  PROGRAM  advgen
*
*  Name           : advgen - Quantus - (64-bit)
*  Version        : 25.1.0-p047
*  Build Date     : Thu Dec 11 23:20:30 PST 2025
*
*  HSPICE LIBRARY
*
*  OPERATING_TEMPERATURE 150
*  QRC_TECH_DIR <path>/tech
*
*
*

*
.SUBCKT sky130_fd_sc_hs__nand4_1 VPB VNB VGND VPWR Y D C B A
*
*
*  caps2d version: 10
*
*
*       TRANSISTOR CARDS
*
*
XM0 VGND#2 D#1 a_181_74# VNB sky130_fd_pr__nfet_01v8_lvt l=0.15 w=0.74 ad=0.2923 as=0.1776 pd=2.72 ps=1.96
XM5 a_181_74# C#3 a_259_74# VNB sky130_fd_pr__nfet_01v8_lvt l=0.15 w=0.74 ad=0.1776 as=0.3108 pd=1.96 ps=2.32
XM2 a_259_74# B#3 a_373_74# VNB sky130_fd_pr__nfet_01v8_lvt l=0.15 w=0.74 ad=0.3108 as=0.3108 pd=2.32 ps=2.32
XM4 a_373_74# A#3 Y#1 VNB sky130_fd_pr__nfet_01v8_lvt l=0.15 w=0.74 ad=0.3108 as=0.2085 pd=2.32 ps=2.05
XM1 VPWR#5 D#3 Y#2 VPB sky130_fd_pr__pfet_01v8 l=0.15 w=1.12 ad=0.3864 as=0.336 pd=2.93 ps=2.84
XM7 Y#2 C#1 VPWR#3 VPB sky130_fd_pr__pfet_01v8 l=0.15 w=1.12 ad=0.336 as=0.5152 pd=2.84 ps=3.16
XM3 VPWR#3 B#1 Y#3 VPB sky130_fd_pr__pfet_01v8 l=0.15 w=1.12 ad=0.5152 as=0.392 pd=3.16 ps=2.94
XM6 Y#3 A#4 VPWR#1 VPB sky130_fd_pr__pfet_01v8 l=0.15 w=1.12 ad=0.392 as=0.3304 pd=2.94 ps=2.83
*
*
*       RESISTOR AND CAP/DIODE CARDS
*
Rg1	D#1	D#2	307.937683
Rg2	D#2	D#3	492.059540
Rg3	C#1	C#2	492.059540
Rg4	C#2	C#3	307.937683
Rg5	B#1	B#2	493.808685
Rg6	B#2	B#3	440.886749
Rg7	A#1	A#2	28.644930
Rg8	A#2	A#3	322.953644
Rg9	A#2	A#4	507.075531
Rf1	D	D#2	163.775864
Rf2	C	C#4	1.510368
Rf3	C#5	C#2	161.743164
Rf4	C#4	C#5	3.882813
Rf5	B#4	B#2	161.298172
Rf6	B	B#6	1.065372
Rf7	B#4	B#6	9.883524
Rf8	Y#1	Y	298.927002
Rf9	Y	Y#2	22.410164
Rf10	Y	Y#3	31.301403
Rf11	A	A#1	163.775864
Rf12	VPWR#1	VPWR#2	121.486649
Rf13	VPWR#2	VPWR#3	35.623142
Rf14	VPWR#2	VPWR#4	65.720917
Rf15	VPWR#4	VPWR#5	34.939823
Rf17	VGND#1	VGND#2	76.734001
Re1	VPWR#2	VPWR	1.637070
Re2	VGND	VGND#1	1.637131
*
*       CAPACITOR CARDS
*
*
C1	VGND	VNB	5.37731e-17
C2	VPWR	VNB	5.95131e-17
C3	Y	VNB	8.04182e-17
C4	D	VNB	7.58544e-18
C5	VGND	Y	1.80129e-17
C6	A	VNB	2.09324e-17
C7	VGND	D	2.6291e-18
C8	VPWR	Y	8.38495e-18
C9	VPWR	D	1.92839e-18
C10	VGND	A	4.33077e-18
C11	D#2	VNB	3.83732e-17
C12	C#2	VNB	3.40453e-17
C13	Y	D	9.00916e-17
C14	B#2	VNB	3.47066e-17
C15	VGND#1	VNB	2.13853e-16
C16	VPWR	A	2.12655e-18
C17	VPWR#2	VNB	1.72934e-16
C18	D#3	VNB	4.35998e-17
C19	C#1	VNB	3.6186e-17
C20	VGND	C#2	3.32079e-19
C21	B#1	VNB	3.83857e-17
C22	A#4	VNB	4.22549e-17
C23	VGND	B#2	3.44664e-19
C24	D#1	VNB	3.75157e-17
C25	C#3	VNB	2.41834e-17
C26	VGND	VGND#1	5.70208e-17
C27	B#3	VNB	2.53943e-17
C28	A#3	VNB	3.2018e-17
C29	VPWR#5	VNB	4.45383e-17
C30	Y	a_373_74#	1.13244e-20
C31	Y#2	VNB	2.20022e-18
C32	VPWR#3	VNB	4.01469e-18
C33	Y#3	VNB	2.80211e-18
C34	VPWR#1	VNB	8.4063e-17
C35	VGND#2	VNB	6.35068e-17
C36	Y	D#2	1.63321e-17
C37	Y	C#2	2.34299e-18
C38	VPWR	VPWR#2	2.71255e-17
C39	VGND	D#1	8.44182e-19
C40	Y#1	VNB	3.55403e-17
C41	Y	B#2	3.75924e-18
C42	VGND	C#3	1.29854e-18
C43	C#4	VNB	2.83864e-19
C44	VPWR	D#3	2.29407e-19
C45	D	D#2	1.70422e-17
C46	C#5	VNB	1.71278e-18
C47	VGND	B#3	1.37197e-18
C48	VGND	A#3	1.09174e-18
C49	VPWR	C#1	6.1888e-19
C50	B#4	VNB	3.78648e-19
C51	D	C#2	2.96948e-18
C52	VPWR	B#1	1.53022e-19
C53	B#6	VNB	1.37466e-18
C54	Y	VPWR#2	6.49315e-19
C55	VPWR	A#4	3.90255e-18
C56	VGND	VPWR#1	3.50708e-18
C57	VGND	VGND#2	5.61653e-17
C58	Y	D#3	3.05615e-17
C59	Y	C#1	3.17612e-17
C60	Y	B#1	2.75711e-17
C61	VGND	Y#1	3.89572e-17
C62	VPWR	VPWR#5	2.21357e-17
C63	Y	A#4	7.16882e-18
C64	VGND	C#4	1.35477e-18
C65	VPWR	Y#2	1.61745e-17
C66	VGND	C#5	1.72326e-18
C67	VPWR	VPWR#3	2.14054e-17
C68	Y	D#1	1.33588e-17
C69	VGND	B#4	1.99364e-18
C70	VPWR	Y#3	1.66288e-17
C71	Y	C#3	3.75332e-19
C72	VPWR	VPWR#1	4.29634e-17
C73	VGND	B#6	2.3202e-18
C74	Y	B#3	2.07156e-19
C75	A	B#2	8.0872e-19
C76	Y	A#3	2.5766e-19
C77	Y	VPWR#5	5.45144e-17
C78	Y	Y#2	2.80709e-19
C79	Y	VPWR#3	3.77791e-17
C80	VGND#1	A	9.88041e-19
C81	VPWR	C#4	8.24021e-19
C82	Y	Y#3	1.76988e-18
C83	C#2	a_259_74#	9.77477e-19
C84	VPWR	C#5	1.58387e-18
C85	Y	VPWR#1	3.39661e-17
C86	Y	VGND#2	4.71314e-17
C87	VPWR	B#4	1.99842e-18
C88	VPWR	B#6	2.61256e-18
C89	B#2	a_373_74#	9.71892e-19
C90	Y#1	Y	1.1862e-17
C91	C#4	Y	2.58567e-17
C92	D#2	C#2	2.93921e-17
C93	C#5	Y	1.76509e-17
C94	B#4	Y	2.29465e-17
C95	B#6	Y	1.6648e-17
C96	Y#1	D	1.37446e-17
C97	C#2	B#2	2.56679e-17
C98	D	C#4	3.04244e-17
C99	D#1	a_181_74#	1.65047e-17
C100	C#3	a_181_74#	1.58072e-17
C101	VGND#1	C#2	5.21252e-19
C102	A#2	VNB	6.02695e-17
C103	VGND#1	B#2	5.21252e-19
C104	C#3	a_259_74#	2.12899e-17
C105	VPWR#2	B#2	5.45167e-20
C106	A	VPWR#1	2.34009e-17
C107	B#3	a_259_74#	2.12899e-17
C108	B#2	A#2	3.04991e-17
C109	B#3	a_373_74#	2.16684e-17
C110	A#3	a_373_74#	2.19451e-17
C111	Y#1	A	2.70695e-17
C112	Y#1	a_181_74#	4.74317e-18
C113	B#6	A	3.226e-17
C114	VPWR#2	C#1	3.30517e-18
C115	VGND	A#2	6.86297e-19
C116	VPWR#5	D#2	8.82593e-19
C117	Y#1	a_259_74#	9.33776e-18
C118	VPWR#2	B#1	5.69975e-18
C119	D#3	C#1	4.76873e-17
C120	Y#1	a_373_74#	5.73935e-18
C121	VGND#1	D#1	2.2927e-18
C122	VPWR#3	C#2	5.5816e-19
C123	VGND#1	C#3	8.33879e-18
C124	D#2	VGND#2	1.7784e-18
C125	VGND#1	B#3	8.33879e-18
C126	C#1	B#1	2.65802e-17
C127	VPWR#3	B#2	3.13763e-19
C128	VGND#1	A#3	5.43974e-18
C129	B#1	A#4	3.96917e-17
C130	VPWR	A#2	6.15463e-19
C131	C#4	D#2	5.93945e-18
C132	Y#1	C#2	2.67563e-18
C133	Y#2	VPWR#2	8.92278e-18
C134	VGND#1	A#2	6.08162e-19
C135	C#4	C#2	7.07771e-18
C136	Y#1	B#2	2.66191e-18
C137	Y#3	VPWR#2	1.40773e-17
C138	VGND#1	VGND#2	4.07907e-17
C139	C#5	C#2	1.12712e-17
C140	D#3	VPWR#5	2.94015e-17
C141	VPWR#2	VPWR#1	3.10501e-17
C142	B#6	A#2	8.84724e-18
C143	Y#2	D#3	4.62738e-17
C144	VPWR#5	C#1	1.3716e-18
C145	B#4	C#2	3.75194e-18
C146	VPWR#3	D#3	1.33394e-18
C147	C#5	B#2	2.86105e-18
C148	Y#2	C#1	5.30853e-17
C149	VPWR#5	B#1	2.77588e-19
C150	Y	A#2	1.18911e-19
C151	D#1	C#3	5.00741e-17
C152	VGND#1	Y#1	3.7187e-17
C153	B#4	B#2	1.72319e-17
C154	C#1	VPWR#3	3.79734e-17
C155	Y#2	B#1	6.89389e-19
C156	Y#3	C#1	1.60202e-18
C157	B#6	B#2	6.22588e-18
C158	B#1	VPWR#3	3.33928e-17
C159	VPWR#1	C#1	2.78155e-19
C160	C#3	B#3	2.50091e-17
C161	Y#3	B#1	4.97553e-17
C162	VPWR#3	A#4	1.19992e-18
C163	VPWR#1	B#1	3.21842e-18
C164	A#4	Y#3	1.56674e-17
C165	B#3	A#3	2.47489e-17
C166	VPWR#1	A#4	5.25823e-17
C167	VPWR#1	A#2	7.87137e-18
C168	VGND#2	D#1	3.33133e-17
C169	VPWR#5	Y#2	6.87228e-17
C170	VGND#2	C#3	6.20079e-18
C171	VPWR#5	VPWR#3	1.61771e-18
C172	VGND#2	B#3	2.05486e-18
C173	Y#2	VPWR#3	5.28327e-17
C174	Y#1	D#1	1.33295e-17
C175	VGND#2	A#3	1.96263e-18
C176	Y#2	Y#3	3.03693e-18
C177	Y#1	C#3	2.34939e-17
C178	VPWR#3	Y#3	5.0648e-17
C179	VPWR#3	VPWR#1	1.68905e-18
C180	Y#1	B#3	2.89405e-17
C181	Y#3	VPWR#1	7.21995e-17
C182	Y#1	A#3	5.70682e-17
C183	A	A#2	2.16834e-17
C184	Y#1	Y#3	1.73379e-19
C185	Y#1	VPWR#1	2.66911e-19
C186	VGND#2	Y#1	5.18276e-18
C187	B#6	VPWR#1	3.74356e-19
C188	A#2	Y#1	7.45151e-18
C189	Y#1	C#4	2.03256e-17
C190	Y#1	C#5	2.5053e-17
C191	Y#1	B#4	3.12117e-17
C192	Y#1	B#6	2.94296e-17
C193	C#5	B#4	2.47145e-17
C194	Y#2	VPWR#4	8.00402e-18
C195	Y	VPWR#4	1.07034e-18
C196	VPWR	VPWR#4	2.89072e-17
C197	VPWR#4	VNB	4.30033e-17
C198	VPWR#4	D#3	2.59958e-18
C199	VPWR#4	VPWR#3	5.71531e-20
C200	VPWR#2	VPWR#4	4.57101e-17
*
*
.ENDS sky130_fd_sc_hs__nand4_1
*
