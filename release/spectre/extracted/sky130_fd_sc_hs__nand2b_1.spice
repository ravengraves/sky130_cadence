* Extracted by Quantus, converted by sky130cad/quantus.py
*
*
*
*                       LINUX           Wed Nov 18 08:45:26 2026
*
*
*
*  PROGRAM  advgen
*
*  Name           : advgen - Quantus - (64-bit)
*  Version        : 25.1.0-p047
*  Build Date     : Thu Dec 11 23:20:30 PST 2025
*
*  HSPICE LIBRARY
*
*  OPERATING_TEMPERATURE 150
*  QRC_TECH_DIR <path>/tech
*
*
*

*
.SUBCKT sky130_fd_sc_hs__nand2b_1 VPB VNB VGND VPWR Y A_N B
*
*
*  caps2d version: 10
*
*
*       TRANSISTOR CARDS
*
*
XM2 a_27_112##6 A_N#3 VGND#1 VNB sky130_fd_pr__nfet_01v8_lvt l=0.15 w=0.55 ad=0.15675 as=0.44825 pd=1.67 ps=2.73
XM4 VGND#1 B#1 a_269_74# VNB sky130_fd_pr__nfet_01v8_lvt l=0.15 w=0.74 ad=0.44825 as=0.1776 pd=2.73 ps=1.96
XM3 a_269_74# a_27_112##3 Y#1 VNB sky130_fd_pr__nfet_01v8_lvt l=0.15 w=0.74 ad=0.1776 as=0.3182 pd=1.96 ps=2.34
XM0 a_27_112##4 A_N#1 VPWR#7 VPB sky130_fd_pr__pfet_01v8 l=0.15 w=0.84 ad=0.2478 as=0.5572 pd=2.27 ps=3.28
XM1 VPWR#7 B#3 Y#2 VPB sky130_fd_pr__pfet_01v8 l=0.15 w=1.12 ad=0.5572 as=0.392 pd=3.28 ps=2.94
XM5 Y#2 a_27_112# VPWR#6 VPB sky130_fd_pr__pfet_01v8 l=0.15 w=1.12 ad=0.392 as=0.336 pd=2.94 ps=2.84
*
*
*       RESISTOR AND CAP/DIODE CARDS
*
Rg1	A_N#1	A_N#2	358.518341
Rg2	A_N#2	A_N#3	281.341919
Rg3	B#1	B#2	431.939270
Rg4	B#2	B#3	437.757690
Rg5	a_27_112#	a_27_112##2	456.846832
Rg6	a_27_112##2	a_27_112##3	353.846649
Rf1	A_N#4	A_N	1.828707
Rf2	A_N#2	A_N#6	81.945107
Rf3	A_N#4	A_N#6	5.497160
Rf4	A_N#7	A_N	1.828707
Rf5	A_N#6	A_N#7	7.696024
Rf6	B	B#2	166.137894
Rf7	a_27_112##4	a_27_112##5	138.588303
Rf8	a_27_112##5	a_27_112##6	137.704620
Rf9	Y#1	Y	181.865036
Rf10	Y	Y#3	6.375274
Rf11	Y#3	Y	3.848012
Rf12	Y#2	Y#3	7.500000
Rf14	VPWR#2	VPWR#3	51.290546
Rf15	VPWR#3	VPWR#4	30.519358
Rf17	VPWR#2	VPWR#6	31.707861
Rf18	VPWR#4	VPWR#7	37.559372
Rf19	VGND#1	VGND#2	21.561243
Rf23	a_27_112##2	a_27_112##5	160.232803
Re1	VPWR#3	VPWR	1.964508
Re2	VGND	VGND#2	1.964582
*
*       CAPACITOR CARDS
*
*
C1	VGND	VNB	5.73837e-17
C2	VPWR	VNB	5.84811e-17
C3	Y	VNB	3.44307e-18
C4	A_N	VNB	2.95204e-17
C5	B	VNB	1.85167e-18
C6	VGND	A_N	5.10161e-18
C7	VPWR	Y	2.04635e-17
C8	A_N#2	VNB	7.50188e-17
C9	B#2	VNB	2.63502e-17
C10	VPWR	A_N	4.80759e-18
C11	a_27_112##2	VNB	5.46622e-17
C12	VPWR	B	2.50972e-18
C13	VPWR#3	VNB	1.37054e-16
C14	VGND	A_N#2	8.41471e-19
C15	A_N#1	VNB	4.38989e-17
C16	B#3	VNB	3.78704e-17
C17	VGND	B#2	2.62251e-18
C18	a_27_112#	VNB	3.83373e-17
C19	VGND	a_27_112##2	1.13795e-17
C20	A_N#3	VNB	3.72913e-17
C21	A_N	B	2.0105e-17
C22	B#1	VNB	2.9657e-17
C23	a_27_112##3	VNB	2.44375e-17
C24	a_27_112##4	VNB	3.94631e-17
C25	VPWR#7	VNB	1.25911e-17
C26	Y#2	VNB	2.88141e-17
C27	VPWR	a_27_112##2	5.71587e-18
C28	VPWR#6	VNB	1.94147e-17
C29	a_27_112##6	VNB	3.86619e-17
C30	VGND#1	VNB	5.78054e-18
C31	VPWR	VPWR#3	1.20146e-17
C32	Y#1	VNB	7.99826e-17
C33	VGND	A_N#3	4.04068e-18
C34	A_N	A_N#2	2.39331e-17
C35	A_N#6	VNB	6.82476e-20
C36	VGND	B#1	5.06286e-19
C37	VPWR	A_N#1	6.66191e-18
C38	VGND	a_27_112##3	1.51451e-18
C39	VPWR	B#3	2.68011e-19
C40	A_N	B#2	2.38991e-17
C41	Y	VPWR#3	1.99125e-17
C42	VPWR	a_27_112#	3.96125e-19
C43	B	A_N#2	1.55176e-18
C44	A_N	a_27_112##2	3.05902e-18
C45	B	B#2	7.2757e-18
C46	VGND	a_27_112##6	1.49847e-17
C47	Y	A_N#1	3.12597e-19
C48	Y	B#3	1.3168e-17
C49	B	a_27_112##2	4.28071e-17
C50	VGND	Y#1	1.96838e-17
C51	Y	a_27_112#	5.49043e-18
C52	VPWR	a_27_112##4	1.66269e-17
C53	VGND	A_N#6	1.22297e-18
C54	A_N	A_N#1	3.77979e-19
C55	VPWR	Y#2	9.01918e-18
C56	VPWR	VPWR#6	1.69904e-17
C57	A_N	B#3	9.98911e-19
C58	a_27_112##2	a_269_74#	3.10846e-18
C59	B	A_N#1	3.68732e-19
C60	Y	VPWR#7	2.23345e-17
C61	B	B#3	2.05068e-18
C62	Y	Y#2	5.54435e-19
C63	A_N#2	B#2	2.6987e-17
C64	VPWR	A_N#6	1.11402e-18
C65	B	a_27_112#	9.60322e-19
C66	Y	VPWR#6	1.97994e-17
C67	a_27_112##2	A_N#2	2.39015e-19
C68	A_N	a_27_112##4	5.05285e-17
C69	B#2	a_27_112##2	8.29598e-17
C70	A_N	a_27_112##6	4.64587e-17
C71	B	a_27_112##4	1.52287e-17
C72	A_N	VGND#1	2.84535e-18
C73	VPWR#3	B#2	4.73934e-20
C74	B#1	a_269_74#	1.63029e-17
C75	A_N#1	B#2	4.63633e-19
C76	a_27_112##3	a_269_74#	1.70186e-17
C77	a_27_112##2	A_N#1	3.92066e-19
C78	B#2	a_27_112#	8.64322e-19
C79	a_27_112##2	B#3	1.12168e-17
C80	A_N#2	B#1	5.34819e-19
C81	a_27_112##2	a_27_112#	9.41105e-18
C82	A_N#2	a_27_112##4	7.05294e-18
C83	VPWR#3	B#3	5.33885e-18
C84	a_27_112##2	A_N#3	5.07001e-20
C85	A_N#2	VPWR#7	1.17949e-18
C86	a_27_112##2	B#1	2.36129e-17
C87	a_27_112##4	B#2	1.07106e-18
C88	a_27_112##2	a_27_112##3	1.04174e-17
C89	B#2	VPWR#7	2.37561e-19
C90	A_N#1	B#3	1.74145e-17
C91	a_27_112##6	A_N#2	1.03746e-17
C92	B#2	Y#2	8.26695e-19
C93	VGND#1	A_N#2	1.30584e-18
C94	a_27_112##6	B#2	2.84075e-18
C95	a_27_112##2	Y#2	6.63033e-17
C96	B#3	a_27_112#	3.71347e-17
C97	VGND#1	B#2	8.60084e-19
C98	a_27_112##2	VPWR#6	1.88001e-18
C99	a_27_112##4	VPWR#3	5.30879e-19
C100	A_N#6	A_N#2	1.16869e-17
C101	a_27_112##2	VGND#1	1.70779e-17
C102	a_27_112##2	Y#1	9.31354e-17
C103	a_27_112##4	A_N#1	4.79217e-17
C104	A_N#1	VPWR#7	2.77481e-17
C105	a_27_112##4	B#3	5.94575e-18
C106	Y#2	A_N#1	1.82104e-18
C107	B#3	VPWR#7	3.79734e-17
C108	a_27_112##4	a_27_112#	1.78314e-19
C109	A_N#3	B#1	8.59447e-18
C110	Y#2	B#3	4.48141e-17
C111	VPWR#7	a_27_112#	6.21545e-19
C112	VPWR#6	B#3	2.28338e-18
C113	Y#2	a_27_112#	3.91595e-17
C114	B#1	a_27_112##3	5.25927e-17
C115	VPWR#6	a_27_112#	2.51726e-17
C116	A_N#6	A_N#1	4.25114e-18
C117	a_27_112##6	A_N#3	2.78121e-17
C118	Y#1	a_27_112#	3.44626e-18
C119	a_27_112##4	VPWR#7	7.1588e-17
C120	VGND#1	A_N#3	3.45547e-17
C121	a_27_112##6	B#1	9.29568e-19
C122	a_27_112##4	Y#2	9.50658e-18
C123	VGND#1	B#1	4.04719e-17
C124	a_27_112##6	a_27_112##3	4.12818e-19
C125	Y#2	VPWR#7	4.9769e-17
C126	Y#1	A_N#3	4.20181e-19
C127	VGND#1	a_27_112##3	6.90223e-18
C128	a_27_112##6	a_27_112##4	4.01273e-18
C129	VPWR#7	VPWR#6	1.79879e-18
C130	Y#1	B#1	4.91958e-18
C131	Y#2	VPWR#6	4.34928e-17
C132	Y#1	a_27_112##3	2.17564e-17
C133	A_N#6	a_27_112##4	1.98121e-17
C134	Y#1	Y#2	1.67153e-18
C135	a_27_112##6	VGND#1	6.57857e-17
C136	a_27_112##6	Y#1	1.04362e-18
C137	VGND#1	Y#1	1.36167e-17
C138	A_N#6	a_27_112##6	2.0962e-17
C139	a_27_112##4	VPWR#4	9.20425e-18
C140	VPWR#4	B#3	2.33855e-18
C141	A_N	VPWR#4	4.94776e-19
C142	VPWR#3	VPWR#2	3.92882e-17
C143	VGND#2	VNB	2.22075e-16
C144	VPWR#4	a_27_112#	4.95605e-19
C145	VGND#2	B#1	1.00123e-17
C146	VPWR#2	VNB	4.00964e-17
C147	VPWR#4	VNB	4.37544e-17
C148	VPWR#4	VPWR#6	9.26999e-20
C149	VPWR#3	VPWR#4	4.43438e-17
C150	VGND	VGND#2	1.08632e-16
C151	Y#2	VPWR#2	3.74333e-18
C152	VGND#2	a_27_112##2	4.29455e-18
C153	VPWR	VPWR#2	2.98187e-17
C154	VPWR#2	a_27_112#	9.56285e-19
C155	VGND#2	a_27_112##3	6.47776e-18
C156	VGND#2	a_27_112##6	1.00928e-17
C157	VPWR#4	VPWR#2	8.70015e-19
C158	Y	VPWR#2	3.71441e-18
C159	VPWR	VPWR#4	4.88168e-17
C160	VGND#2	A_N	5.01029e-19
C161	VGND#2	A_N#2	3.71896e-19
C162	VPWR#4	A_N#1	3.40336e-18
C163	VGND#2	A_N#3	6.67695e-19
C164	VPWR#4	A_N#2	4.65037e-19
C165	VGND#2	Y#1	2.51064e-17
*
*
.ENDS sky130_fd_sc_hs__nand2b_1
*
