* Extracted by Quantus, converted by sky130cad/quantus.py
*
*
*
*                       LINUX           Wed Nov 18 08:23:20 2026
*
*
*
*  PROGRAM  advgen
*
*  Name           : advgen - Quantus - (64-bit)
*  Version        : 25.1.0-p047
*  Build Date     : Thu Dec 11 23:20:30 PST 2025
*
*  HSPICE LIBRARY
*
*  OPERATING_TEMPERATURE 150
*  QRC_TECH_DIR <path>/tech
*
*
*

*
.SUBCKT sky130_fd_sc_hs__clkdlyinv3sd3_1 VPB VNB VGND VPWR Y A
*
*
*  caps2d version: 10
*
*
*       TRANSISTOR CARDS
*
*
XM2 a_28_74##6 A#3 VGND#7 VNB sky130_fd_pr__nfet_01v8_lvt l=0.15 w=0.42 ad=0.1113 as=0.2961 pd=1.37 ps=2.25
XM5 VGND#7 a_28_74# a_288_74##6 VNB sky130_fd_pr__nfet_01v8_lvt l=0.18 w=0.42 ad=0.2961 as=0.1113 pd=2.25 ps=1.37
XM4 VGND#6 a_288_74##3 Y#3 VNB sky130_fd_pr__nfet_01v8_lvt l=0.15 w=0.42 ad=0.1113 as=0.1113 pd=1.37 ps=1.37
XM3 a_28_74##4 A#1 VPWR#7 VPB sky130_fd_pr__pfet_01v8 l=0.15 w=1.12 ad=0.3136 as=0.4068 pd=2.8 ps=2.99
XM0 VPWR#7 a_28_74##3 a_288_74##7 VPB sky130_fd_pr__pfet_01v8 l=0.5 w=1 ad=0.4068 as=0.26 pd=2.99 ps=2.52
XM1 VPWR#6 a_288_74# Y#1 VPB sky130_fd_pr__pfet_01v8 l=0.15 w=1.12 ad=0.308 as=0.3136 pd=2.79 ps=2.8
*
*
*       RESISTOR AND CAP/DIODE CARDS
*
Rg1	A#1	A#2	505.110291
Rg2	A#2	A#3	382.539764
Rg3	a_28_74#	a_28_74##2	275.028717
Rg4	a_28_74##2	a_28_74##3	141.539703
Rg5	a_288_74#	a_288_74##2	467.246124
Rg6	a_288_74##2	a_288_74##3	455.213867
Rf1	A	A#4	3.280892
Rf2	A#5	A#2	163.513702
Rf3	A#4	A#5	1.266811
Rf4	A	A#7	3.280892
Rf5	A#5	A#7	6.545189
Rf6	a_28_74##4	a_28_74##5	99.886612
Rf7	a_28_74##5	a_28_74##6	87.592514
Rf8	a_288_74##2	a_288_74##5	187.949219
Rf9	a_288_74##5	a_288_74##6	60.177593
Rf10	a_288_74##5	a_288_74##7	17.895864
Rf11	Y	Y#2	0.271759
Rf12	Y#2	Y	13.135041
Rf13	Y	Y#4	15.111293
Rf14	Y#4	Y	1.268211
Rf15	Y#1	Y#2	5.000000
Rf16	Y#3	Y#4	15.000000
Rf18	VPWR#2	VPWR#3	48.188797
Rf19	VPWR#3	VPWR#4	51.110813
Rf21	VPWR#2	VPWR#6	38.384460
Rf22	VPWR#4	VPWR#7	30.944223
Rf24	VGND#2	VGND#3	48.188797
Rf25	VGND#3	VGND#4	50.380310
Rf27	VGND#2	VGND#6	34.704330
Rf28	VGND#4	VGND#7	33.916985
Rf30	a_28_74##2	a_28_74##5	160.232803
Re1	VPWR	VPWR#3	1.814012
Re2	VGND	VGND#3	1.814012
*
*       CAPACITOR CARDS
*
*
C1	a_288_74##5	VPWR#6	3.86576e-17
C2	VGND#6	Y#3	3.5506e-17
C3	a_288_74##5	a_288_74##7	3.86211e-18
C4	a_288_74##6	Y#3	2.22946e-18
C5	a_288_74##6	VGND#6	3.5724e-17
C6	a_28_74##4	a_288_74##5	1.16498e-18
C7	VGND#7	VGND#6	9.52172e-19
C8	VGND#7	a_288_74##6	1.17317e-17
C9	a_288_74##5	a_288_74##3	6.13679e-19
C10	a_28_74##6	a_288_74##6	1.50063e-18
C11	a_28_74##6	VGND#7	4.43527e-17
C12	a_288_74##5	a_288_74#	2.5696e-18
C13	Y#3	a_288_74##3	1.38724e-17
C14	VPWR#6	Y#1	4.14983e-17
C15	VGND#6	a_288_74##3	3.71028e-17
C16	Y#3	a_28_74#	5.8197e-19
C17	a_288_74##5	a_28_74##3	1.32123e-17
C18	a_288_74##6	a_288_74##3	3.91311e-18
C19	VGND#6	a_28_74#	1.71822e-18
C20	a_288_74##7	VPWR#6	4.77996e-17
C21	a_28_74##6	a_28_74##4	1.1762e-19
C22	VGND#7	a_288_74##3	5.337e-19
C23	a_288_74##6	a_28_74#	1.686e-17
C24	a_288_74##5	A#1	3.34387e-19
C25	VPWR#7	VPWR#6	2.19821e-18
C26	VGND#6	A#3	1.75263e-19
C27	a_28_74##6	a_288_74##3	2.91419e-19
C28	a_28_74#	VGND#7	1.60993e-17
C29	a_288_74##6	A#3	3.0678e-18
C30	VPWR#7	a_288_74##7	1.70926e-17
C31	a_28_74##6	a_28_74#	1.7208e-18
C32	A#3	VGND#7	2.1631e-17
C33	a_28_74##4	a_288_74##7	3.50209e-19
C34	a_28_74##6	A#3	3.94294e-17
C35	a_28_74##4	VPWR#7	7.004e-17
C36	a_288_74#	Y#1	1.11868e-17
C37	a_288_74##5	a_288_74##2	1.98184e-18
C38	VPWR#6	a_288_74#	5.19809e-17
C39	a_28_74#	a_288_74##3	4.79013e-18
C40	a_288_74##7	a_288_74#	2.07773e-18
C41	VPWR#6	a_28_74##3	6.08117e-18
C42	a_28_74##2	a_288_74##5	1.27314e-16
C43	VPWR#7	a_288_74#	9.75577e-19
C44	a_288_74##7	a_28_74##3	4.12172e-17
C45	A#3	a_28_74#	7.07307e-18
C46	VPWR#6	A#1	5.49152e-19
C47	a_28_74##4	a_288_74#	2.63254e-19
C48	a_28_74##3	VPWR#7	3.78601e-17
C49	a_288_74##7	A#1	2.0161e-18
C50	VGND#3	a_288_74##6	1.71263e-17
C51	a_28_74##4	a_28_74##3	6.05146e-18
C52	A#1	VPWR#7	3.99557e-17
C53	A#5	a_28_74##2	1.43758e-17
C54	VGND#6	a_288_74##2	1.48519e-17
C55	a_28_74##4	A#1	3.74329e-17
C56	a_288_74##7	VPWR#3	1.19857e-17
C57	A#5	A#2	1.02069e-17
C58	a_28_74##2	a_288_74##6	1.73184e-17
C59	VGND#7	a_28_74##2	2.26944e-17
C60	a_288_74##2	VPWR#6	2.54752e-17
C61	a_28_74##3	a_288_74#	8.42623e-18
C62	VGND#7	A#2	8.77831e-19
C63	a_28_74##6	A#2	6.21166e-17
C64	VGND#3	a_28_74#	6.89572e-18
C65	A#1	a_28_74##3	4.08977e-17
C66	a_28_74##2	a_28_74##4	3.93163e-18
C67	a_28_74##2	a_288_74##3	1.2769e-18
C68	VPWR#7	A#2	6.29041e-19
C69	VPWR#3	a_28_74##3	1.06151e-17
C70	a_28_74##4	A#2	1.74609e-18
C71	a_28_74##2	a_28_74#	8.35937e-18
C72	A#3	a_28_74##2	1.4739e-19
C73	a_288_74##5	Y	1.07868e-17
C74	a_28_74##3	a_288_74##2	3.06733e-19
C75	a_28_74##2	a_288_74#	6.72635e-19
C76	a_28_74##2	a_28_74##3	3.80122e-17
C77	A#1	a_28_74##2	3.04423e-18
C78	VPWR	a_288_74##5	1.98962e-18
C79	Y#3	Y	5.468e-19
C80	a_288_74##6	Y	3.9842e-18
C81	a_28_74##2	VPWR#3	1.46962e-18
C82	Y	Y#1	8.79026e-18
C83	A	a_28_74##4	5.8611e-17
C84	VGND#3	a_28_74##2	2.32091e-18
C85	VPWR#6	Y	6.0904e-17
C86	VGND	a_288_74##5	4.35632e-18
C87	a_28_74##2	a_288_74##2	7.58605e-18
C88	Y	a_288_74##3	7.14369e-18
C89	VPWR	VPWR#6	1.99671e-17
C90	VGND	Y#3	2.08377e-17
C91	Y	a_28_74#	8.93244e-19
C92	A#2	a_28_74##2	6.45745e-17
C93	VPWR	a_288_74##7	1.70358e-17
C94	A	a_28_74##3	2.95271e-18
C95	VPWR	VPWR#7	2.27322e-17
C96	VGND	a_288_74##6	1.8798e-17
C97	a_288_74##5	VNB	1.98416e-17
C98	VGND	VGND#7	1.50108e-17
C99	VPWR	a_28_74##4	1.62672e-17
C100	A	A#1	9.07067e-18
C101	VGND	a_28_74##6	1.87578e-17
C102	Y	a_288_74#	2.03931e-17
C103	VGND	VPWR#6	4.04438e-18
C104	Y	a_28_74##3	8.40078e-19
C105	A#5	VNB	7.31546e-18
C106	Y#3	VNB	2.64043e-17
C107	VGND#6	VNB	6.88278e-18
C108	VPWR	a_288_74#	4.57891e-18
C109	a_288_74##6	VNB	1.07686e-17
C110	VGND	a_288_74##3	1.97503e-18
C111	VGND#7	VNB	2.36614e-18
C112	VPWR	a_28_74##3	1.00692e-17
C113	VGND	a_28_74#	5.82204e-18
C114	a_28_74##6	VNB	3.80407e-17
C115	VPWR	A#1	1.30244e-18
C116	Y#1	VNB	2.03372e-17
C117	VGND	A#3	1.08819e-18
C118	A	a_28_74##2	2.6001e-17
C119	VPWR#6	VNB	8.89988e-18
C120	a_288_74##7	VNB	4.92081e-18
C121	a_288_74##2	Y	6.11558e-17
C122	A	A#2	7.92757e-18
C123	VPWR#7	VNB	3.72685e-18
C124	VPWR	VPWR#3	3.65972e-17
C125	a_28_74##4	VNB	3.55693e-17
C126	Y	a_28_74##2	1.55971e-18
C127	a_288_74##3	VNB	4.48363e-17
C128	a_28_74#	VNB	3.55622e-17
C129	VPWR	a_288_74##2	3.53087e-18
C130	A#3	VNB	3.67631e-17
C131	VPWR	a_28_74##2	8.54351e-18
C132	a_288_74#	VNB	3.88208e-17
C133	VGND	VGND#3	3.31176e-17
C134	a_28_74##3	VNB	1.08973e-16
C135	VGND	a_288_74##2	4.61402e-18
C136	A#1	VNB	5.62308e-17
C137	VGND	a_28_74##2	1.31006e-17
C138	VPWR#3	VNB	1.7974e-17
C139	VGND	A#2	6.43288e-18
C140	VGND#3	VNB	1.89316e-17
C141	a_288_74##2	VNB	5.61681e-17
C142	a_28_74##2	VNB	7.54784e-17
C143	VPWR	A	5.08839e-18
C144	A#2	VNB	6.59963e-17
C145	VPWR	Y	2.46636e-17
C146	VGND	Y	1.1615e-18
C147	A	VNB	1.74516e-17
C148	Y	VNB	9.18806e-17
C149	VPWR	VNB	1.92576e-16
C150	VGND	VNB	2.00319e-16
C151	VGND#2	a_288_74##2	4.88605e-19
C152	a_288_74##2	VPWR#2	2.74607e-19
C153	VPWR#4	VPWR#2	4.25267e-19
C154	a_288_74##7	VPWR#2	1.34866e-18
C155	Y	VPWR#2	3.28847e-17
C156	VPWR#2	a_288_74#	4.55309e-18
C157	VPWR#7	VPWR#2	9.14125e-20
C158	VGND#4	VGND#2	7.1065e-19
C159	VPWR	VPWR#2	7.48845e-17
C160	VGND#2	a_288_74##3	6.9653e-18
C161	VGND#4	a_28_74##2	3.02728e-18
C162	VPWR	VPWR#4	7.70104e-17
C163	VGND#2	a_28_74#	9.91713e-19
C164	VGND#4	a_28_74##6	2.46863e-17
C165	a_28_74##2	VPWR#4	8.93392e-19
C166	VGND#2	A#3	6.56088e-20
C167	VGND#2	Y#3	2.253e-17
C168	VPWR#2	VNB	4.6209e-17
C169	VPWR#4	VNB	4.48254e-17
C170	VPWR#4	a_28_74##3	4.46656e-18
C171	VGND	VGND#2	9.75822e-17
C172	VGND#4	a_288_74##3	5.70416e-20
C173	VGND#7	VGND#2	1.32908e-20
C174	VPWR#4	A#1	1.11819e-18
C175	VGND#4	a_28_74#	1.27177e-18
C176	VGND#2	VNB	4.83548e-17
C177	VGND	VGND#4	7.70896e-17
C178	VGND#4	A#3	4.84508e-18
C179	VGND#4	VNB	4.67844e-17
C180	a_28_74##4	VPWR#4	9.48505e-18
C181	a_288_74##5	VPWR#2	4.91947e-19
C182	VGND#2	a_288_74##5	1.39269e-18
*
*
.ENDS sky130_fd_sc_hs__clkdlyinv3sd3_1
*
