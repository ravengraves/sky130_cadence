* Extracted by Quantus, converted by sky130cad/quantus.py
*
*
*
*                       LINUX           Wed Nov 18 08:48:43 2026
*
*
*
*  PROGRAM  advgen
*
*  Name           : advgen - Quantus - (64-bit)
*  Version        : 25.1.0-p047
*  Build Date     : Thu Dec 11 23:20:30 PST 2025
*
*  HSPICE LIBRARY
*
*  OPERATING_TEMPERATURE 150
*  QRC_TECH_DIR <path>/tech
*
*
*

*
.SUBCKT sky130_fd_sc_hs__nor2_2 VPB VNB VGND VPWR Y A B
*
*
*  caps2d version: 10
*
*
*       TRANSISTOR CARDS
*
*
XM2 VGND#3 B#6 Y#1 VNB sky130_fd_pr__nfet_01v8_lvt l=0.15 w=0.74 ad=0.2627 as=0.2072 pd=2.19 ps=2.04
XM5 Y#1 A#4 VGND#4 VNB sky130_fd_pr__nfet_01v8_lvt l=0.15 w=0.74 ad=0.2072 as=0.2627 pd=2.04 ps=2.19
XM0 a_35_368##4 B#5 Y#2 VPB sky130_fd_pr__pfet_01v8 l=0.15 w=1.12 ad=0.3304 as=0.336 pd=2.83 ps=2.84
XM3 Y#2 B#1 a_35_368##2 VPB sky130_fd_pr__pfet_01v8 l=0.15 w=1.12 ad=0.336 as=0.336 pd=2.84 ps=2.84
XM4 VPWR#4 A#6 a_35_368##2 VPB sky130_fd_pr__pfet_01v8 l=0.15 w=1.12 ad=0.336 as=0.336 pd=2.84 ps=2.84
XM1 a_35_368# A#1 VPWR#4 VPB sky130_fd_pr__pfet_01v8 l=0.15 w=1.12 ad=0.3304 as=0.336 pd=2.83 ps=2.84
*
*
*       RESISTOR AND CAP/DIODE CARDS
*
Rg1	B#1	B#2	567.240845
Rg2	B#2	B#3	95.576347
Rg3	B#3	B#4	34.534393
Rg4	B#2	B#5	388.144409
Rg5	B#3	B#6	322.141815
Rg6	A#1	A#2	469.521027
Rg7	A#2	A#3	57.925327
Rg8	A#3	A#4	498.102905
Rg9	A#2	A#5	120.618378
Rg10	A#3	A#6	459.019470
Rf1	B	B#7	0.705966
Rf2	B#8	B#4	160.938766
Rf3	B#7	B#8	3.543054
Rf4	Y#1	Y	58.260216
Rf5	Y	Y#3	9.279152
Rf6	Y#3	Y	4.878730
Rf7	Y#2	Y#3	7.500000
Rf8	A	A#5	0.140251
Rf9	A#5	A	10.238319
Rf10	a_35_368#	a_35_368##3	119.705521
Rf11	a_35_368##3	a_35_368##4	136.841568
Rf12	a_35_368##2	a_35_368##3	5.000000
Rf14	VPWR#2	VPWR#3	31.444530
Rf15	VPWR#2	VPWR#4	43.213310
Rf17	VGND#2	VGND#3	97.754425
Rf18	VGND#2	VGND#4	36.804161
Re1	VPWR#3	VPWR	1.964508
Re2	VGND	VGND#2	1.964582
*
*       CAPACITOR CARDS
*
*
C1	VGND#4	A#3	1.45474e-17
C2	Y#1	A#3	1.35831e-18
C3	a_35_368#	A#3	2.35284e-18
C4	a_35_368#	A#2	6.31315e-18
C5	VPWR#4	A#3	4.01591e-19
C6	VPWR#4	A#2	3.96237e-19
C7	a_35_368##2	A#3	2.7625e-18
C8	B#2	Y#2	1.06923e-18
C9	a_35_368##4	B#2	2.43496e-19
C10	B#1	A#3	7.20223e-18
C11	VPWR#3	A#3	3.17794e-20
C12	VPWR#3	B#2	2.68041e-20
C13	A#5	A#2	6.52902e-19
C14	B#4	A#3	1.77618e-18
C15	A#3	A#2	6.15365e-18
C16	B#2	A#3	6.12425e-20
C17	A	A#2	3.75157e-17
C18	B#8	Y#1	1.12149e-17
C19	A	B#2	3.10825e-20
C20	B#7	Y#1	2.07432e-17
C21	Y#1	VGND#4	7.52794e-17
C22	VGND#3	B#7	3.28415e-17
C23	VGND#3	VGND#4	1.84033e-18
C24	VGND#3	Y#1	6.70781e-17
C25	Y	A#3	2.92802e-18
C26	Y	A#2	7.48684e-19
C27	Y	B#2	1.21975e-17
C28	VGND#4	a_35_368##2	1.08397e-17
C29	B#8	a_35_368##4	1.60029e-17
C30	a_35_368#	VPWR#4	8.14813e-17
C31	a_35_368##2	a_35_368#	2.52173e-18
C32	VGND#4	A#4	2.12086e-17
C33	a_35_368##2	VPWR#4	7.71543e-17
C34	Y#1	A#4	5.69995e-17
C35	VGND#4	B#6	1.465e-18
C36	VGND#3	A#4	1.41935e-18
C37	Y#1	B#6	3.91316e-17
C38	B#6	VGND#3	2.69533e-17
C39	a_35_368##4	a_35_368##2	2.14025e-18
C40	a_35_368##4	Y#2	2.47311e-19
C41	a_35_368##2	A#4	2.61612e-18
C42	VGND	A#3	5.67411e-18
C43	VGND	A#2	9.34904e-19
C44	a_35_368#	A#1	5.58391e-17
C45	a_35_368##4	A#4	7.77649e-20
C46	A#1	VPWR#4	2.29286e-17
C47	a_35_368#	A#6	2.50543e-18
C48	a_35_368##2	A#1	7.17196e-19
C49	VPWR#4	A#6	4.56663e-17
C50	B#6	A#4	3.66708e-17
C51	a_35_368#	B#1	2.11095e-19
C52	a_35_368##2	A#6	5.70844e-17
C53	B#8	VPWR#3	3.68004e-19
C54	VPWR#4	B#1	1.68652e-18
C55	a_35_368##2	B#1	2.42617e-17
C56	a_35_368##4	A#6	1.83236e-19
C57	B#1	Y#2	2.36643e-17
C58	A#3	VNB	4.78573e-17
C59	a_35_368##2	B#5	7.58329e-19
C60	A#2	VNB	5.65532e-17
C61	B#2	VNB	2.02162e-17
C62	a_35_368##4	B#1	8.58681e-18
C63	B#5	Y#2	2.40733e-17
C64	A#4	B#1	9.54601e-18
C65	a_35_368##4	B#5	4.44493e-17
C66	VGND#4	A#5	3.658e-17
C67	B#8	B#4	1.46308e-17
C68	a_35_368##2	VPWR#3	2.44781e-17
C69	Y#1	A#5	6.19505e-19
C70	A#6	A#1	4.9132e-17
C71	B#7	B#4	9.52678e-18
C72	VGND#3	A#5	2.93251e-19
C73	a_35_368##4	VPWR#3	6.47949e-17
C74	Y#1	B#4	8.07702e-18
C75	B#4	VGND#3	9.5682e-18
C76	VPWR#3	A#4	2.40349e-20
C77	B#1	A#6	4.92955e-17
C78	B#5	B#1	4.64022e-17
C79	A#4	A#5	1.06514e-17
C80	a_35_368##4	B#4	5.38018e-18
C81	VPWR#3	A#6	6.40807e-19
C82	B#4	A#4	8.46856e-18
C83	VPWR#3	B#1	4.46757e-18
C84	VPWR#3	B#5	4.43427e-18
C85	VGND#4	A	2.20028e-17
C86	Y#1	A	5.91832e-18
C87	B#8	Y	1.34917e-17
C88	A	a_35_368#	4.90189e-17
C89	VPWR	B#8	3.13757e-18
C90	A	A#4	1.07609e-18
C91	VPWR#3	B#4	6.18578e-19
C92	Y	a_35_368##2	7.6254e-17
C93	a_35_368##4	Y	1.01714e-16
C94	VPWR	a_35_368#	1.819e-17
C95	VPWR	a_35_368##2	1.28373e-17
C96	VGND	B#7	3.64626e-18
C97	VGND	VGND#4	1.74214e-17
C98	VGND	Y#1	1.71402e-17
C99	VPWR	a_35_368##4	2.91537e-17
C100	Y	A#1	8.51714e-19
C101	VGND	VGND#3	4.15463e-17
C102	VGND	a_35_368#	5.20217e-18
C103	Y	A#6	2.78428e-18
C104	Y	B#1	3.93156e-17
C105	VGND	a_35_368##2	3.16835e-18
C106	B#8	VNB	1.40494e-17
C107	Y	B#5	2.27232e-17
C108	VPWR	A#1	1.43402e-18
C109	B#7	VNB	7.5285e-18
C110	VGND	a_35_368##4	2.65335e-18
C111	VGND#4	VNB	5.15889e-18
C112	VPWR	A#6	1.44997e-18
C113	VGND	A#4	5.35975e-18
C114	Y#1	VNB	6.75603e-18
C115	VPWR	B#1	1.52841e-18
C116	VGND#3	VNB	6.34514e-17
C117	VGND	B#6	4.78355e-18
C118	A	A#5	2.42917e-17
C119	a_35_368#	VNB	5.95033e-17
C120	VPWR	B#5	2.38389e-18
C121	VPWR#4	VNB	1.3526e-18
C122	A	B#4	1.03888e-18
C123	a_35_368##2	VNB	3.47569e-18
C124	VPWR	VPWR#3	2.86803e-17
C125	a_35_368##4	VNB	5.95618e-17
C126	VGND	B#1	7.73739e-19
C127	A#4	VNB	4.00898e-17
C128	Y	B#4	3.97681e-18
C129	B#6	VNB	3.2473e-17
C130	A#1	VNB	4.19114e-17
C131	VPWR	B#4	8.32686e-19
C132	A#6	VNB	2.99929e-17
C133	B#1	VNB	4.3323e-17
C134	B#5	VNB	3.74409e-17
C135	VGND	A#5	6.51076e-18
C136	VGND	B#4	6.33325e-20
C137	VPWR#3	VNB	1.72908e-16
C138	Y	A	4.20171e-18
C139	A#5	VNB	9.9386e-17
C140	VPWR	A	3.69806e-18
C141	B#4	VNB	5.66528e-17
C142	VPWR	Y	9.21804e-18
C143	VGND	A	2.06368e-17
C144	A	VNB	4.12033e-17
C145	Y	VNB	2.1263e-18
C146	VPWR	VNB	5.33351e-17
C147	VGND	VNB	5.45251e-17
C148	VGND#2	Y#1	1.49652e-17
C149	VGND#2	A#3	8.46655e-19
C150	VGND#2	a_35_368#	9.75295e-19
C151	VGND#2	A	3.56421e-17
C152	VGND#2	a_35_368##2	2.14466e-19
C153	VPWR#2	B#1	5.91345e-19
C154	VPWR#2	A#2	1.38913e-19
C155	VGND#2	VNB	1.8636e-16
C156	VPWR#3	VPWR#2	4.39024e-17
C157	VGND#2	A#5	6.76404e-18
C158	a_35_368#	VPWR#2	2.10676e-17
C159	VPWR	VPWR#2	4.70477e-17
C160	VGND#2	VGND#3	3.07818e-17
C161	VPWR#2	A#6	3.99365e-18
C162	VGND#2	B#1	3.73756e-19
C163	VGND#2	A#2	4.02084e-19
C164	VGND#2	B#2	6.61844e-20
C165	a_35_368##2	VPWR#2	1.92617e-18
C166	VGND	VGND#2	4.51958e-17
C167	VGND#2	A#4	5.00878e-18
C168	VPWR#2	A#1	5.53144e-18
C169	VPWR#2	VNB	4.10431e-17
C170	VPWR#2	B#5	3.1185e-19
*
*
.ENDS sky130_fd_sc_hs__nor2_2
*
