* Extracted by Quantus, converted by sky130cad/quantus.py
*
*
*
*                       LINUX           Wed Nov 18 08:02:02 2026
*
*
*
*  PROGRAM  advgen
*
*  Name           : advgen - Quantus - (64-bit)
*  Version        : 25.1.0-p047
*  Build Date     : Thu Dec 11 23:20:30 PST 2025
*
*  HSPICE LIBRARY
*
*  OPERATING_TEMPERATURE 150
*  QRC_TECH_DIR <path>/tech
*
*
*

*
.SUBCKT sky130_fd_sc_hs__a2111o_2 VPB VNB VGND VPWR X D1 C1 B1 A2 A1
*
*
*  caps2d version: 10
*
*
*       TRANSISTOR CARDS
*
*
XM8 VGND#5 a_91_244##7 X#3 VNB sky130_fd_pr__nfet_01v8_lvt l=0.15 w=0.74 ad=0.1961 as=0.2072 pd=2.01 ps=2.04
XM11 X#3 a_91_244##5 VGND#8 VNB sky130_fd_pr__nfet_01v8_lvt l=0.15 w=0.74 ad=0.2072 as=0.1961 pd=2.04 ps=2.01
XM4 a_91_244##13 D1#1 VGND#7 VNB sky130_fd_pr__nfet_01v8_lvt l=0.15 w=0.74 ad=0.1961 as=0.2368 pd=2.01 ps=2.12
XM12 VGND#7 C1#1 a_91_244##12 VNB sky130_fd_pr__nfet_01v8_lvt l=0.15 w=0.74 ad=0.2368 as=0.2072 pd=2.12 ps=2.04
XM5 a_91_244##12 B1#3 VGND#6 VNB sky130_fd_pr__nfet_01v8_lvt l=0.15 w=0.74 ad=0.2072 as=0.4218 pd=2.04 ps=2.62
XM7 VGND#6 A2#1 a_771_74# VNB sky130_fd_pr__nfet_01v8_lvt l=0.15 w=0.74 ad=0.4218 as=0.1554 pd=2.62 ps=1.9
XM13 a_771_74# A1#3 a_91_244##8 VNB sky130_fd_pr__nfet_01v8_lvt l=0.15 w=0.74 ad=0.1554 as=0.1961 pd=1.9 ps=2.01
XM0 VPWR#5 a_91_244##4 X#1 VPB sky130_fd_pr__pfet_01v8 l=0.15 w=1.12 ad=0.308 as=0.336 pd=2.79 ps=2.84
XM9 X#1 a_91_244##6 VPWR#7 VPB sky130_fd_pr__pfet_01v8 l=0.15 w=1.12 ad=0.336 as=0.308 pd=2.84 ps=2.79
XM6 a_91_244##14 D1#3 a_444_368# VPB sky130_fd_pr__pfet_01v8 l=0.15 w=1.12 ad=0.308 as=0.2688 pd=2.79 ps=2.72
XM3 a_444_368# C1#3 a_522_368# VPB sky130_fd_pr__pfet_01v8 l=0.15 w=1.12 ad=0.2688 as=0.4368 pd=2.72 ps=3.02
XM2 a_522_368# B1#1 a_630_368##2 VPB sky130_fd_pr__pfet_01v8 l=0.15 w=1.12 ad=0.4368 as=0.4368 pd=3.02 ps=3.02
XM10 a_630_368##2 A2#3 VPWR#6 VPB sky130_fd_pr__pfet_01v8 l=0.15 w=1.12 ad=0.4368 as=0.4368 pd=3.02 ps=3.02
XM1 VPWR#6 A1#4 a_630_368# VPB sky130_fd_pr__pfet_01v8 l=0.15 w=1.12 ad=0.4368 as=0.308 pd=3.02 ps=2.79
*
*
*       RESISTOR AND CAP/DIODE CARDS
*
Rg1	a_91_244#	a_91_244##2	191.176041
Rg2	a_91_244##2	a_91_244##3	61.894783
Rg3	a_91_244##3	a_91_244##4	507.075531
Rg4	a_91_244##2	a_91_244##5	362.264893
Rg5	a_91_244##2	a_91_244##6	451.213501
Rg6	a_91_244##3	a_91_244##7	322.953644
Rg7	D1#1	D1#2	382.539734
Rg8	D1#2	D1#3	434.639221
Rg9	C1#1	C1#2	382.539734
Rg10	C1#2	C1#3	434.639221
Rg11	B1#1	B1#2	434.639221
Rg12	B1#2	B1#3	382.539734
Rg13	A2#1	A2#2	382.539734
Rg14	A2#2	A2#3	434.639221
Rg15	A1#1	A1#2	56.207058
Rg16	A1#2	A1#3	397.555725
Rg17	A1#2	A1#4	449.655212
Rf1	X	X#2	0.251111
Rf2	X#2	X	18.331108
Rf3	X	X#3	73.791527
Rf4	X#1	X#2	5.000000
Rf5	D1#4	D1	1.409262
Rf6	D1#2	D1#6	161.642059
Rf7	D1#4	D1#6	11.918507
Rf8	D1#7	D1	1.409262
Rf9	D1#6	D1#7	2.750425
Rf10	C1	C1#2	166.137894
Rf11	B1#2	B1	166.137894
Rf12	A2#4	A2	1.409262
Rf13	A2#2	A2#6	161.642059
Rf14	A2#4	A2#6	2.750425
Rf15	A2#7	A2	1.409262
Rf16	A2#6	A2#7	11.918507
Rf17	a_91_244##8	a_91_244##9	121.910477
Rf18	a_91_244##9	a_91_244##10	71.655113
Rf19	a_91_244##10	a_91_244#	56.917969
Rf20	a_91_244##9	a_91_244##12	21.341251
Rf21	a_91_244##10	a_91_244##13	21.341251
Rf22	a_91_244#	a_91_244##14	99.665573
Rf23	a_630_368#	a_630_368##2	105.289223
Rf24	A1#1	A1	166.137894
Rf26	VPWR#2	VPWR#3	106.608849
Rf27	VPWR#3	VPWR#4	86.175049
Rf28	VPWR#4	VPWR#5	117.331512
Rf29	VPWR#2	VPWR#6	29.050425
Rf30	VPWR#4	VPWR#7	31.534731
Rf32	VGND#2	VGND#3	78.333511
Rf33	VGND#3	VGND#4	88.658768
Rf34	VGND#4	VGND#5	94.618958
Rf35	VGND#2	VGND#6	29.226990
Rf36	VGND#3	VGND#7	38.964211
Rf37	VGND#4	VGND#8	38.247387
Re1	VPWR#3	VPWR	0.982218
Re2	VGND	VGND#3	0.982254
*
*       CAPACITOR CARDS
*
*
C1	VGND	VNB	6.86069e-17
C2	VPWR	VNB	8.33611e-17
C3	a_91_244##12	B1#3	3.60397e-17
C4	X	VNB	1.42519e-17
C5	D1	VNB	6.42716e-18
C6	C1	VNB	2.36346e-18
C7	VGND	X	1.7829e-18
C8	B1	VNB	3.54697e-18
C9	A2	VNB	5.56137e-18
C10	VGND	D1	3.79953e-18
C11	A1	VNB	2.71731e-17
C12	VPWR	X	1.73859e-17
C13	VGND	C1	4.20614e-18
C14	VPWR	D1	5.74643e-18
C15	VGND	B1	2.7371e-18
C16	VGND#7	A2#1	1.55883e-19
C17	VGND#4	a_91_244##13	1.54374e-18
C18	VGND	A2	3.36142e-18
C19	VPWR	C1	1.59877e-17
C20	VGND	A1	5.77804e-18
C21	VPWR	B1	4.73093e-18
C22	a_91_244#	VNB	1.11094e-17
C23	D1#2	VNB	3.92524e-17
C24	VPWR	A2	3.03879e-18
C25	C1#2	VNB	2.92196e-17
C26	B1#2	VNB	2.80543e-17
C27	VPWR	A1	5.42156e-18
C28	A2#2	VNB	3.25914e-17
C29	D1	C1	4.57179e-17
C30	A1#1	VNB	5.07587e-17
C31	VGND#3	VNB	2.34466e-16
C32	B1#3	VGND#6	1.93882e-17
C33	VPWR#3	VNB	2.38228e-16
C34	VGND	a_91_244#	5.04383e-18
C35	a_91_244##4	VNB	4.38247e-17
C36	a_91_244##6	VNB	3.74594e-17
C37	D1#3	VNB	3.91089e-17
C38	C1	B1	3.69684e-17
C39	C1#3	VNB	3.18772e-17
C40	B1#1	VNB	3.33829e-17
C41	A2#3	VNB	2.81947e-17
C42	A1#4	VNB	3.81614e-17
C43	a_91_244##12	A2#1	9.6006e-19
C44	VGND	A1#1	2.37236e-18
C45	a_91_244##7	VNB	3.22876e-17
C46	VPWR	a_91_244#	1.78876e-18
C47	VGND	VGND#3	4.86679e-17
C48	a_91_244##5	VNB	3.20983e-17
C49	D1#1	VNB	2.85583e-17
C50	B1	A2	3.86706e-17
C51	C1#1	VNB	2.52267e-17
C52	VGND#4	a_91_244##2	6.17547e-20
C53	B1#3	VNB	2.79449e-17
C54	A2#1	VNB	2.55847e-17
C55	A1#3	VNB	2.62636e-17
C56	VPWR#5	VNB	8.28566e-17
C57	X	a_91_244#	4.74638e-17
C58	VPWR#7	VNB	1.14061e-17
C59	a_91_244##14	VNB	2.0679e-17
C60	A2	A1	3.77707e-17
C61	X	D1#2	2.70312e-19
C62	C1	a_444_368#	2.75683e-19
C63	a_630_368##2	VNB	3.09676e-18
C64	VPWR	VPWR#3	3.52863e-17
C65	VPWR#6	VNB	2.74312e-18
C66	C1	a_522_368#	4.02347e-18
C67	a_630_368#	VNB	5.01402e-17
C68	VGND#5	VNB	6.98481e-17
C69	VGND	a_91_244##7	2.83093e-18
C70	X#3	VNB	1.03441e-17
C71	a_91_244#	D1	3.72902e-17
C72	VGND#6	A2#1	4.37602e-17
C73	VPWR	a_91_244##4	5.34408e-18
C74	VGND#8	VNB	6.77525e-18
C75	VGND#4	VGND#7	2.00008e-19
C76	VGND	a_91_244##5	4.29601e-18
C77	a_91_244##13	VNB	9.77372e-18
C78	VPWR	a_91_244##6	4.03422e-18
C79	VGND	D1#1	9.17065e-19
C80	D1	D1#2	6.71286e-18
C81	VGND#7	VNB	5.26397e-20
C82	a_91_244##12	VNB	2.12109e-18
C83	VGND	C1#1	6.74416e-19
C84	VPWR	D1#3	3.02204e-18
C85	VGND#6	VNB	7.54016e-19
C86	VGND	B1#3	4.76554e-20
C87	D1	C1#2	4.29245e-18
C88	VPWR	C1#3	3.81479e-19
C89	a_91_244##8	VNB	4.32344e-17
C90	VGND	A2#1	5.13558e-19
C91	a_91_244#	C1	1.69968e-18
C92	a_91_244##12	A1#3	3.01426e-19
C93	VPWR	B1#1	2.24934e-18
C94	VGND	A1#3	8.69975e-19
C95	D1#6	VNB	2.887e-18
C96	VGND	VPWR#5	3.02461e-18
C97	a_91_244##8	B1#3	5.40778e-19
C98	VPWR	A2#3	7.284e-19
C99	C1	D1#2	3.64579e-18
C100	VPWR	A1#4	6.4332e-19
C101	X	a_91_244##4	3.22779e-17
C102	C1	C1#2	1.60705e-17
C103	A2#6	VNB	3.44899e-19
C104	X	a_91_244##6	1.98924e-17
C105	a_91_244##9	VNB	1.40887e-17
C106	X	D1#3	6.59815e-19
C107	C1	B1#2	3.74191e-18
C108	a_91_244##10	VNB	1.12435e-17
C109	D1	VPWR#3	7.3014e-19
C110	VGND	VGND#5	3.83475e-17
C111	VPWR#4	VNB	4.24066e-17
C112	B1	C1#2	3.55808e-18
C113	VGND	X#3	1.42168e-17
C114	VGND#4	a_91_244##3	6.65982e-20
C115	VGND#4	VNB	3.84172e-17
C116	VGND	a_91_244##13	1.37229e-17
C117	VGND#6	A1#3	5.98871e-18
C118	B1	B1#2	1.52482e-17
C119	VPWR	VPWR#5	3.34905e-17
C120	VGND	a_91_244##12	1.39392e-17
C121	D1	D1#3	3.45117e-18
C122	C1	VPWR#3	1.17213e-17
C123	B1	A2#2	2.55922e-18
C124	a_91_244##10	D1#6	2.06284e-17
C125	VPWR	VPWR#7	2.01056e-17
C126	VGND	a_91_244##8	2.01797e-17
C127	D1	C1#3	7.59293e-19
C128	a_630_368##2	VPWR#6	8.06166e-17
C129	VPWR	a_91_244##14	1.97176e-17
C130	A2	B1#2	4.45279e-18
C131	a_91_244##8	A2#1	2.44891e-17
C132	VGND	D1#6	1.32652e-18
C133	VPWR	a_630_368##2	1.89176e-17
C134	A2	A2#2	5.27158e-18
C135	C1	a_91_244##6	2.83068e-19
C136	VPWR	VPWR#6	2.56941e-17
C137	B1	VPWR#3	4.65159e-19
C138	VPWR	a_630_368#	1.73719e-17
C139	C1	D1#3	1.19718e-17
C140	VGND	A2#6	1.15111e-18
C141	C1	C1#3	3.66789e-17
C142	VPWR#5	X	8.54536e-17
C143	X	X#1	4.89295e-18
C144	VGND	a_91_244##9	5.15914e-18
C145	C1	B1#1	1.46378e-17
C146	VGND	a_91_244##10	3.69642e-18
C147	X	VPWR#7	5.42146e-17
C148	C1	A2#3	8.97341e-19
C149	A1	A1#1	2.06288e-17
C150	X	a_91_244##14	2.34967e-18
C151	a_630_368##2	a_630_368#	2.4705e-18
C152	C1	A1#4	5.37047e-19
C153	B1	C1#3	3.83551e-19
C154	VGND	VGND#4	4.87814e-17
C155	a_91_244##8	A1#3	4.40843e-17
C156	B1	B1#1	4.62024e-18
C157	VPWR	D1#6	1.50006e-18
C158	B1	A2#3	5.57291e-19
C159	VGND#5	X	3.81269e-19
C160	D1	a_91_244##14	2.99568e-17
C161	C1#2	a_522_368#	4.65238e-19
C162	VPWR	A2#6	1.23851e-18
C163	A2	B1#1	4.36526e-19
C164	a_630_368#	VPWR#6	8.19839e-17
C165	A2	A2#3	1.41154e-18
C166	A2	A1#4	2.56578e-18
C167	a_91_244##2	D1#3	2.6924e-20
C168	VPWR	VPWR#4	3.13482e-17
C169	a_91_244#	D1#2	1.43219e-18
C170	a_91_244##14	C1	4.50274e-17
C171	a_91_244##2	VNB	4.24453e-17
C172	a_91_244##3	VNB	4.35138e-17
C173	A1	A1#4	1.42058e-18
C174	A1#2	VNB	2.18855e-17
C175	a_91_244#	C1#2	1.8619e-19
C176	C1	a_630_368##2	4.57159e-17
C177	a_91_244##10	a_91_244##7	7.40973e-20
C178	a_91_244#	B1#2	1.3215e-19
C179	D1#2	C1#2	3.42973e-17
C180	C1	a_630_368#	4.25936e-20
C181	D1#3	a_444_368#	1.58812e-18
C182	a_91_244##9	a_91_244##5	2.88556e-20
C183	B1	a_630_368##2	2.61383e-17
C184	C1#3	a_444_368#	2.01554e-17
C185	C1#2	B1#2	3.5155e-17
C186	X	VPWR#4	1.40076e-17
C187	a_91_244##10	a_91_244##5	1.78753e-19
C188	C1#3	a_522_368#	2.737e-17
C189	VGND#3	D1#2	8.84885e-20
C190	B1#1	a_522_368#	2.12123e-18
C191	B1#2	A2#2	2.84248e-17
C192	A2	a_630_368##2	2.05319e-17
C193	a_91_244##10	D1	4.74e-17
C194	VPWR#3	D1#2	4.50366e-20
C195	VGND#3	C1#2	3.85385e-20
C196	a_91_244##9	D1#1	1.91719e-19
C197	A2	a_630_368#	2.50202e-17
C198	a_91_244#	a_91_244##4	2.26177e-18
C199	VPWR#3	C1#2	5.31029e-20
C200	a_91_244#	a_91_244##6	7.59225e-18
C201	A2#1	a_771_74#	1.45628e-17
C202	a_91_244##3	a_91_244##2	3.90425e-18
C203	VGND#5	X#3	6.92072e-17
C204	a_91_244##10	D1#1	1.58839e-17
C205	a_91_244#	D1#3	6.48389e-19
C206	A1#3	a_771_74#	1.54251e-17
C207	VGND	a_91_244##3	2.87134e-19
C208	a_91_244##9	C1	4.46075e-17
C209	A1	a_630_368#	3.19006e-17
C210	a_91_244#	C1#3	6.45806e-20
C211	a_91_244##9	C1#1	1.67508e-17
C212	VGND#5	VGND#8	1.66094e-18
C213	a_91_244##8	A2	3.25675e-17
C214	a_91_244##9	A2#6	5.44693e-19
C215	a_91_244##10	C1#1	1.61831e-19
C216	a_91_244##9	B1	4.2144e-17
C217	X#3	VGND#8	4.16102e-17
C218	a_91_244#	a_91_244##7	1.16011e-18
C219	a_91_244##9	B1#3	2.06424e-17
C220	a_91_244##8	A1	2.95852e-17
C221	VPWR#7	a_91_244##2	1.07039e-18
C222	a_91_244#	a_91_244##5	3.82684e-18
C223	D1#6	a_91_244##14	1.88651e-17
C224	VGND#4	a_91_244##7	1.0487e-18
C225	a_91_244#	D1#1	1.03198e-19
C226	a_91_244##10	B1#3	4.17075e-20
C227	a_91_244#	a_91_244##2	2.9168e-17
C228	X#3	a_91_244##13	1.42801e-18
C229	a_91_244#	C1#1	2.79285e-20
C230	a_91_244##9	A2	2.03859e-17
C231	VPWR	a_91_244##2	1.72646e-19
C232	a_91_244#	a_91_244##3	2.55108e-19
C233	a_91_244#	B1#3	2.01584e-20
C234	a_91_244##9	A2#1	1.31242e-19
C235	VPWR#3	D1#3	7.7479e-18
C236	VGND#8	a_91_244##13	2.42389e-17
C237	VGND#4	a_91_244##5	1.06216e-17
C238	a_91_244##8	a_771_74#	2.77486e-18
C239	VPWR#3	C1#3	6.14085e-18
C240	a_91_244##4	a_91_244##6	4.75944e-17
C241	a_91_244##9	A1#3	9.14002e-20
C242	VPWR#3	B1#1	4.56541e-18
C243	VGND#8	VGND#7	1.16671e-18
C244	a_91_244#	VPWR#7	2.57363e-17
C245	a_91_244#	a_91_244##14	2.71036e-18
C246	a_91_244##6	D1#3	4.79252e-18
C247	a_91_244##8	a_630_368#	4.62164e-18
C248	VGND#4	D1#1	8.23233e-19
C249	a_91_244##2	D1#2	8.27453e-18
C250	a_91_244##13	VGND#7	4.25606e-17
C251	D1#2	a_91_244##14	3.15925e-18
C252	X	a_91_244##2	9.72199e-18
C253	X	a_91_244##3	1.32682e-17
C254	VGND#3	a_91_244##5	2.22116e-19
C255	a_91_244##10	a_91_244##9	5.07996e-19
C256	D1#3	C1#3	6.49438e-17
C257	VGND#3	D1#1	5.24147e-18
C258	a_91_244##13	a_91_244##12	1.67531e-18
C259	VGND#3	C1#1	5.28733e-18
C260	X#3	a_91_244#	2.92316e-17
C261	C1#3	B1#1	3.25912e-17
C262	VGND#3	B1#3	9.39143e-19
C263	a_91_244#	VGND#8	2.50819e-17
C264	VGND#7	a_91_244##12	4.25192e-17
C265	VGND#3	A2#1	1.79048e-19
C266	B1#1	A2#3	3.18881e-17
C267	B1#2	a_630_368##2	3.15925e-18
C268	VGND#7	VGND#6	1.13401e-18
C269	D1	a_91_244##2	7.49924e-18
C270	VPWR#3	VPWR#5	2.60272e-17
C271	a_630_368##2	A2#2	4.06809e-18
C272	A2#3	A1#4	3.13094e-17
C273	a_91_244##12	VGND#6	4.38305e-17
C274	A2#2	VPWR#6	1.61108e-18
C275	a_91_244##8	A1#2	1.1036e-18
C276	VGND#7	C1#2	5.49724e-19
C277	VPWR#5	VPWR#4	9.84578e-19
C278	a_91_244##10	a_91_244##14	3.70195e-19
C279	a_91_244##14	VPWR#3	1.45835e-17
C280	VPWR#5	a_91_244##4	3.07726e-17
C281	A2#6	a_630_368##2	1.81046e-17
C282	A1#1	a_630_368#	6.64797e-18
C283	a_91_244##4	X#1	2.43397e-17
C284	D1#6	D1#2	1.29652e-17
C285	VPWR#5	a_91_244##6	1.24215e-18
C286	a_91_244##12	a_91_244##8	1.05189e-18
C287	VPWR#7	a_91_244##4	2.92902e-18
C288	VGND#6	B1#2	1.00988e-18
C289	a_91_244##6	X#1	8.09955e-20
C290	a_91_244##14	a_91_244##4	4.01091e-19
C291	VGND#3	VGND#5	2.96266e-17
C292	VPWR#7	a_91_244##6	5.78974e-17
C293	a_91_244##8	VGND#6	2.59978e-17
C294	VGND#6	A2#2	9.29327e-19
C295	a_91_244##14	a_91_244##6	3.68232e-18
C296	a_91_244##7	a_91_244##5	3.86833e-17
C297	A2#6	a_630_368#	1.21733e-18
C298	VPWR#7	D1#3	4.70168e-18
C299	a_91_244##9	a_630_368##2	4.79837e-18
C300	VGND#3	a_91_244##13	1.28563e-17
C301	a_91_244##14	D1#3	7.19956e-17
C302	VPWR#7	C1#3	5.0102e-19
C303	a_91_244##5	D1#1	3.28216e-18
C304	a_91_244##14	VPWR#4	7.59183e-18
C305	VGND#3	a_91_244##12	6.99235e-18
C306	a_91_244##14	C1#3	6.13615e-18
C307	a_91_244##8	A1#1	6.7111e-18
C308	a_91_244##10	D1#2	3.84692e-18
C309	VPWR#7	B1#1	3.02134e-19
C310	A2#2	A1#2	3.53706e-17
C311	a_630_368##2	D1#3	3.47763e-19
C312	a_91_244##14	B1#1	4.54378e-19
C313	a_91_244##9	C1#2	3.47993e-18
C314	D1#1	C1#1	3.26981e-17
C315	VGND#4	a_91_244#	1.13234e-18
C316	VPWR#6	D1#3	3.88885e-19
C317	a_630_368##2	C1#3	4.97058e-18
C318	VPWR#6	C1#3	6.39242e-19
C319	a_91_244##9	B1#2	2.79834e-18
C320	C1#1	B1#3	4.00299e-17
C321	A2#6	A2#2	1.35651e-17
C322	a_630_368##2	B1#1	6.07563e-17
C323	VPWR#6	B1#1	1.37093e-18
C324	VGND#4	a_91_244##10	1.62774e-18
C325	A2	A1#2	1.53309e-17
C326	a_630_368##2	A2#3	3.47496e-17
C327	D1#6	VPWR#3	9.15876e-20
C328	a_630_368#	B1#1	1.90979e-19
C329	a_91_244##9	A2#2	2.53112e-18
C330	B1#3	A2#1	9.79553e-18
C331	VPWR#6	A2#3	5.25611e-17
C332	a_630_368##2	A1#4	8.14832e-19
C333	a_630_368#	A2#3	8.65807e-19
C334	A1#4	VPWR#6	3.11845e-17
C335	X#3	a_91_244##10	4.33009e-19
C336	A2#1	A1#3	6.12083e-17
C337	a_91_244##2	D1#1	1.07213e-18
C338	a_630_368#	A1#4	5.70423e-17
C339	VGND#3	a_91_244##9	2.91756e-19
C340	A1	A1#2	3.37388e-19
C341	VGND#3	a_91_244##10	2.91756e-19
C342	VPWR#4	a_91_244##2	3.81617e-20
C343	a_91_244##10	a_91_244##13	1.60704e-18
C344	a_91_244##9	VGND#7	1.59779e-17
C345	VGND#5	a_91_244##7	4.77319e-17
C346	D1#6	D1#3	1.21404e-18
C347	a_91_244##7	X#3	2.05756e-17
C348	VGND#5	a_91_244##5	3.45104e-18
C349	a_91_244##10	VGND#7	1.76586e-17
C350	VPWR#4	a_91_244##3	4.73434e-20
C351	VPWR#5	VPWR#7	1.79859e-18
C352	VGND#8	a_91_244##7	1.41478e-18
C353	a_91_244##9	a_91_244##12	5.46028e-19
C354	a_91_244##5	X#3	1.61962e-17
C355	a_91_244##13	a_91_244##7	2.44364e-19
C356	a_91_244##8	A2#6	1.78847e-17
C357	VGND#3	VGND#4	4.68664e-17
C358	VGND#8	a_91_244##5	4.03412e-17
C359	VPWR#3	VPWR#4	5.18199e-17
C360	X#3	D1#1	3.23304e-19
C361	a_91_244##9	VGND#6	4.28945e-17
C362	a_91_244##13	a_91_244##5	2.6985e-18
C363	X#3	a_91_244##2	4.13745e-18
C364	VGND#5	VGND#4	1.69166e-18
C365	VGND#8	D1#1	2.57968e-18
C366	VGND#7	a_91_244##5	1.78967e-19
C367	VPWR#7	a_91_244##14	3.71551e-17
C368	D1#1	a_91_244##13	1.65871e-17
C369	X#3	a_91_244##3	5.7369e-18
C370	a_91_244##12	a_91_244##5	9.51621e-20
C371	VGND#7	D1#1	3.05613e-17
C372	VGND#4	X#3	1.05552e-17
C373	a_91_244##13	C1#1	5.33699e-19
C374	VPWR#4	a_91_244##4	3.11958e-18
C375	a_91_244##9	a_91_244##8	3.1896e-19
C376	a_91_244##12	D1#1	6.32264e-19
C377	VGND#7	C1#1	3.50813e-17
C378	a_91_244##13	B1#3	1.37546e-19
C379	a_91_244##2	VGND#8	3.2319e-18
C380	C1#1	a_91_244##12	1.14035e-17
C381	VGND#5	VPWR#5	1.01793e-17
C382	VPWR#4	a_91_244##6	5.98525e-18
C383	VGND#7	B1#3	1.50756e-18
C384	a_91_244##4	a_91_244##2	3.25354e-18
C385	a_91_244##14	a_630_368##2	1.45853e-18
C386	VGND#6	C1#1	3.02857e-19
C387	A2#6	A2#3	6.56876e-19
C388	a_630_368#	VPWR#2	2.09699e-17
C389	VPWR#2	B1#2	4.50366e-20
C390	VPWR	VPWR#2	4.51674e-17
C391	VGND#2	VNB	7.27421e-17
C392	VGND#2	B1#3	6.48118e-18
C393	VPWR#2	B1#1	3.19564e-18
C394	VPWR#2	A1#1	4.17011e-19
C395	VGND#2	A1#2	1.36018e-20
C396	VGND#3	VGND#2	8.34378e-17
C397	VGND#2	a_91_244##9	2.25448e-19
C398	VPWR#2	A1#4	2.58378e-18
C399	VPWR#3	VPWR#2	7.25909e-17
C400	VGND#2	C1#1	9.94257e-19
C401	VGND#2	a_91_244##12	6.71484e-18
C402	B1	VPWR#2	1.64858e-19
C403	VGND#2	A1#1	4.35368e-19
C404	VGND#2	A1#3	6.96864e-18
C405	VGND#2	a_91_244##8	2.16827e-17
C406	a_630_368##2	VPWR#2	2.2292e-17
C407	A1	VPWR#2	1.22098e-18
C408	VGND#7	VGND#2	7.01296e-19
C409	VPWR#2	A2#3	9.77087e-19
C410	VPWR#2	VNB	6.33912e-17
C411	VGND	VGND#2	8.69643e-17
C412	VGND#2	A2#1	8.68062e-18
C413	VGND#2	A1	1.28639e-18
*
*
.ENDS sky130_fd_sc_hs__a2111o_2
*
