* Extracted by Quantus, converted by sky130cad/quantus.py
*
*
*
*                       LINUX           Wed Nov 18 08:05:01 2026
*
*
*
*  PROGRAM  advgen
*
*  Name           : advgen - Quantus - (64-bit)
*  Version        : 25.1.0-p047
*  Build Date     : Thu Dec 11 23:20:30 PST 2025
*
*  HSPICE LIBRARY
*
*  OPERATING_TEMPERATURE 150
*  QRC_TECH_DIR <path>/tech
*
*
*

*
.SUBCKT sky130_fd_sc_hs__a21boi_2 VPB VNB VGND VPWR Y A2 A1 B1_N
*
*
*  caps2d version: 10
*
*
*       TRANSISTOR CARDS
*
*
XM6 a_62_94##9 B1_N#1 VGND#9 VNB sky130_fd_pr__nfet_01v8_lvt l=0.15 w=0.64 ad=0.1696 as=0.2441 pd=1.81 ps=2.16
XM12 Y#3 a_62_94##4 VGND#9 VNB sky130_fd_pr__nfet_01v8_lvt l=0.15 w=0.74 ad=0.2072 as=0.2441 pd=2.04 ps=2.16
XM4 VGND#8 a_62_94##5 Y#3 VNB sky130_fd_pr__nfet_01v8_lvt l=0.15 w=0.74 ad=0.1961 as=0.2072 pd=2.01 ps=2.04
XM5 a_436_74##4 A1#7 Y#1 VNB sky130_fd_pr__nfet_01v8_lvt l=0.15 w=0.74 ad=0.1961 as=0.2072 pd=2.01 ps=2.04
XM8 Y#1 A1#1 a_436_74##2 VNB sky130_fd_pr__nfet_01v8_lvt l=0.15 w=0.74 ad=0.2072 as=0.2072 pd=2.04 ps=2.04
XM13 a_436_74##2 A2#5 VGND#7 VNB sky130_fd_pr__nfet_01v8_lvt l=0.15 w=0.74 ad=0.2072 as=0.2072 pd=2.04 ps=2.04
XM11 VGND#7 A2#4 a_436_74# VNB sky130_fd_pr__nfet_01v8_lvt l=0.15 w=0.74 ad=0.2072 as=0.1961 pd=2.04 ps=2.01
XM0 VPWR#5 B1_N#4 a_62_94##10 VPB sky130_fd_pr__pfet_01v8 l=0.15 w=1 ad=0.275 as=0.275 pd=2.55 ps=2.55
XM1 a_241_368##5 a_62_94##6 Y#4 VPB sky130_fd_pr__pfet_01v8 l=0.15 w=1.12 ad=0.308 as=0.336 pd=2.79 ps=2.84
XM9 Y#4 a_62_94# a_241_368##3 VPB sky130_fd_pr__pfet_01v8 l=0.15 w=1.12 ad=0.336 as=0.336 pd=2.84 ps=2.84
XM2 a_241_368##3 A1#5 VPWR#7 VPB sky130_fd_pr__pfet_01v8 l=0.15 w=1.12 ad=0.336 as=0.336 pd=2.84 ps=2.84
XM10 VPWR#7 A1#6 a_241_368##6 VPB sky130_fd_pr__pfet_01v8 l=0.15 w=1.12 ad=0.336 as=0.336 pd=2.84 ps=2.84
XM3 a_241_368##6 A2#6 VPWR#6 VPB sky130_fd_pr__pfet_01v8 l=0.15 w=1.12 ad=0.336 as=0.3584 pd=2.84 ps=2.88
XM7 VPWR#6 A2#1 a_241_368# VPB sky130_fd_pr__pfet_01v8 l=0.15 w=1.12 ad=0.3584 as=0.308 pd=2.88 ps=2.79
*
*
*       RESISTOR AND CAP/DIODE CARDS
*
Rg1	B1_N#1	B1_N#2	422.111755
Rg2	B1_N#2	B1_N#3	36.503117
Rg3	B1_N#2	B1_N#4	424.501587
Rg4	a_62_94#	a_62_94##2	610.390503
Rg5	a_62_94##2	a_62_94##3	59.538967
Rg6	a_62_94##3	a_62_94##4	359.811462
Rg7	a_62_94##2	a_62_94##5	397.296143
Rg8	a_62_94##2	a_62_94##6	430.501556
Rg9	A1#1	A1#2	380.374634
Rg10	A1#2	A1#3	48.320618
Rg11	A1#3	A1#4	20.770033
Rg12	A1#4	A1#5	468.193665
Rg13	A1#2	A1#6	462.815369
Rg14	A1#4	A1#7	400.923340
Rg15	A2#1	A2#2	507.075531
Rg16	A2#2	A2#3	60.127804
Rg17	A2#2	A2#4	322.953644
Rg18	A2#3	A2#5	327.168701
Rg19	A2#3	A2#6	506.808380
Rf1	B1_N#5	B1_N	0.930548
Rf2	B1_N#3	B1_N#7	161.163345
Rf3	B1_N#5	B1_N#7	2.755709
Rf4	a_62_94##3	a_62_94##8	170.291138
Rf5	a_62_94##8	a_62_94##9	75.429314
Rf6	a_62_94##8	a_62_94##10	61.569977
Rf7	A1	A1#3	167.318909
Rf8	Y#1	Y#2	66.349358
Rf9	Y#2	Y#3	69.592918
Rf10	Y#2	Y	2.936145
Rf11	Y	Y#4	43.927422
Rf12	A2#3	A2	167.270004
Rf13	a_436_74#	a_436_74##3	88.640106
Rf14	a_436_74##3	a_436_74##4	70.088165
Rf15	a_436_74##2	a_436_74##3	7.500000
Rf16	a_241_368#	a_241_368##2	112.066864
Rf17	a_241_368##2	a_241_368##4	79.815475
Rf18	a_241_368##4	a_241_368##5	129.538666
Rf19	a_241_368##2	a_241_368##6	31.761475
Rf20	a_241_368##3	a_241_368##4	5.000000
Rf22	VPWR#2	VPWR#3	66.415901
Rf23	VPWR#3	VPWR#4	37.961727
Rf24	VPWR#4	VPWR#5	180.162766
Rf25	VPWR#2	VPWR#6	33.308170
Rf26	VPWR#3	VPWR#7	33.109421
Rf28	VGND#2	VGND#3	104.802925
Rf29	VGND#3	VGND#4	27.369404
Rf30	VGND#4	VGND#5	62.774361
Rf32	VGND#2	VGND#7	33.326477
Rf33	VGND#4	VGND#8	37.066368
Rf34	VGND#5	VGND#9	31.141060
Re1	VPWR#4	VPWR	1.091357
Re2	VGND	VGND#3	1.091398
*
*       CAPACITOR CARDS
*
*
C1	A1#4	A2#6	2.08399e-18
C2	a_436_74##2	A1#4	2.14865e-19
C3	Y#1	A1#4	2.71547e-18
C4	VGND#4	VGND#7	1.24123e-20
C5	a_62_94#	A1#4	1.20075e-17
C6	a_436_74##4	A1#4	9.58039e-19
C7	a_62_94##8	Y#2	1.92223e-18
C8	VGND#4	Y#3	5.19844e-18
C9	VGND#9	VGND#4	1.42527e-19
C10	a_436_74##2	a_241_368##2	9.86811e-18
C11	B1_N#7	a_62_94##8	2.11167e-17
C12	Y#1	a_241_368##2	3.12933e-18
C13	Y#2	a_436_74##4	1.73815e-17
C14	VPWR#3	VPWR#6	1.73677e-19
C15	Y#2	VGND#8	3.50506e-17
C16	a_241_368#	A2#2	3.15846e-19
C17	VGND#3	A1#4	1.34127e-19
C18	Y#2	Y#3	8.10466e-19
C19	a_241_368##6	VPWR#3	5.26135e-18
C20	a_241_368##2	a_241_368#	2.75907e-18
C21	a_436_74#	VGND#7	4.58743e-17
C22	a_62_94##8	Y#3	5.19687e-18
C23	a_241_368##2	VPWR#6	2.65838e-17
C24	a_436_74##2	a_436_74#	2.27239e-18
C25	VPWR#6	A2#2	1.25703e-19
C26	A2#3	A2#2	1.44948e-17
C27	a_241_368##3	VPWR#3	3.23419e-19
C28	A1#4	A2#3	4.04974e-17
C29	VGND#9	a_62_94##8	2.49832e-17
C30	a_436_74##2	VGND#7	4.38925e-17
C31	Y#1	a_436_74#	1.56213e-18
C32	a_241_368##2	a_241_368##6	2.82215e-18
C33	a_62_94##9	a_62_94##8	2.1404e-18
C34	a_241_368##2	VPWR#7	2.48758e-17
C35	a_436_74##2	Y#1	4.24422e-17
C36	A1#3	A2#2	4.97088e-19
C37	a_241_368##3	a_241_368##2	4.55564e-18
C38	A1#3	A1#4	2.25447e-17
C39	VGND#8	VGND#7	7.53112e-19
C40	a_62_94##9	B1_N#7	1.98031e-17
C41	Y#4	a_241_368##2	7.06445e-19
C42	Y#1	a_436_74##4	1.78256e-17
C43	VGND#8	a_436_74##2	1.42477e-18
C44	VGND#4	A2#5	6.13711e-20
C45	Y#2	a_241_368##3	1.06019e-17
C46	VGND#8	Y#1	2.3669e-18
C47	a_62_94##3	A1#4	3.19668e-18
C48	VGND#8	a_436_74##4	2.67319e-17
C49	Y#3	Y#1	1.37043e-18
C50	VGND#4	A1#1	1.47896e-19
C51	A1#4	VPWR#7	1.12873e-18
C52	a_436_74#	a_241_368#	1.69425e-17
C53	Y#2	a_241_368##5	2.92249e-19
C54	VGND#4	A1#7	1.33129e-18
C55	a_62_94##8	Y#4	2.654e-18
C56	Y#3	VGND#8	3.9266e-17
C57	VGND#9	VGND#8	2.1355e-18
C58	a_62_94##8	a_241_368##5	1.38413e-17
C59	VGND#4	a_62_94##5	9.57315e-18
C60	VGND#9	Y#3	4.93919e-17
C61	a_62_94##8	a_62_94##10	3.62238e-20
C62	VGND#4	a_62_94##4	8.47403e-19
C63	a_62_94##9	Y#3	2.47555e-18
C64	VPWR#5	a_62_94##8	1.55679e-18
C65	a_62_94##9	VGND#9	3.29235e-17
C66	Y#4	A1#4	8.28282e-19
C67	Y#1	a_241_368##3	1.096e-18
C68	B1_N#7	VPWR#5	1.92512e-17
C69	a_241_368#	VPWR#6	8.79406e-17
C70	Y#2	a_62_94##5	1.54795e-17
C71	a_436_74#	A2#4	3.59347e-17
C72	VGND#7	A2#4	2.97286e-17
C73	a_241_368##6	VPWR#6	5.59406e-17
C74	a_436_74#	A2#5	2.24701e-18
C75	a_62_94##8	a_62_94##5	6.24686e-19
C76	Y#3	a_241_368##5	6.48704e-19
C77	a_436_74##2	A2#4	8.46531e-19
C78	VGND#7	A2#5	2.90359e-17
C79	VPWR#7	VPWR#6	2.07898e-18
C80	Y#1	A2#4	1.09678e-18
C81	a_436_74#	A1#1	5.02983e-19
C82	Y#2	B1_N#1	3.29952e-19
C83	a_62_94##8	a_62_94##4	2.25627e-18
C84	a_436_74##2	A2#5	2.31762e-17
C85	VPWR#7	a_241_368##6	5.20507e-17
C86	VGND#7	A1#1	2.47888e-18
C87	a_241_368##2	A2#1	7.36672e-19
C88	Y#1	A2#5	1.92354e-18
C89	a_241_368##2	A1#4	3.5178e-18
C90	a_436_74##2	A1#1	3.85809e-17
C91	a_62_94##8	B1_N#1	9.29389e-18
C92	a_241_368##3	a_241_368##6	1.49075e-18
C93	VPWR#3	A1#6	1.84009e-18
C94	VGND#7	A1#7	7.0826e-19
C95	Y#1	A1#1	3.38303e-17
C96	a_241_368##3	VPWR#7	6.45574e-17
C97	a_241_368##2	A2#6	2.06874e-17
C98	a_436_74##2	A1#7	7.49025e-19
C99	VGND#8	A2#5	2.11849e-19
C100	VGND#7	a_62_94##5	1.75334e-19
C101	VPWR#3	A1#5	1.8976e-18
C102	Y#1	A1#7	3.89314e-17
C103	VGND#8	A1#1	3.46504e-19
C104	a_436_74##2	a_62_94##5	1.5446e-19
C105	a_241_368##2	A1#6	2.05701e-17
C106	a_436_74##4	A1#7	4.11209e-17
C107	Y#4	a_241_368##3	8.05075e-17
C108	Y#1	a_62_94##5	9.00874e-19
C109	VGND#8	A1#7	3.86232e-18
C110	a_241_368##5	a_241_368##3	2.26169e-18
C111	a_436_74##4	a_62_94##5	5.71308e-19
C112	a_241_368##2	A1#5	4.88601e-19
C113	Y#3	A1#7	3.40637e-19
C114	Y#1	a_62_94##4	1.24404e-19
C115	VGND#8	a_62_94##5	4.11109e-17
C116	a_241_368##5	Y#4	1.02102e-16
C117	a_62_94##5	Y#3	1.28392e-17
C118	a_241_368##2	a_62_94#	1.67365e-19
C119	VGND#8	a_62_94##4	1.44545e-18
C120	VGND#9	a_62_94##5	2.55354e-18
C121	a_62_94##4	Y#3	2.00724e-17
C122	a_62_94##10	a_241_368##5	8.41342e-17
C123	a_62_94##9	a_62_94##5	2.77983e-19
C124	Y#2	a_62_94#	2.40774e-18
C125	VGND#9	a_62_94##4	4.72213e-17
C126	VPWR#5	a_241_368##5	3.27927e-18
C127	Y#3	B1_N#1	1.27564e-18
C128	a_62_94##9	a_62_94##4	1.46048e-18
C129	B1_N#1	VGND#9	2.0128e-17
C130	VPWR#5	a_62_94##10	9.20167e-17
C131	a_62_94##9	B1_N#1	2.67928e-17
C132	VGND#3	VGND#4	2.64949e-17
C133	a_62_94##8	a_62_94##6	3.03612e-19
C134	VPWR#4	VPWR#3	3.00528e-17
C135	Y#2	A1#4	8.61309e-18
C136	a_62_94##8	B1_N#4	5.33584e-18
C137	A2#5	A2#4	3.77078e-17
C138	a_241_368#	A2#1	4.86023e-17
C139	VPWR#6	A2#1	5.44177e-17
C140	a_241_368#	A2#6	8.1285e-19
C141	A1#1	A2#5	3.90593e-17
C142	VPWR#6	A2#6	5.27708e-17
C143	VGND#8	a_62_94#	8.55562e-19
C144	a_241_368#	A1#6	1.93264e-19
C145	A2#6	a_241_368##6	1.75932e-17
C146	VGND#3	Y#2	1.38386e-18
C147	VPWR#6	A1#6	3.04676e-18
C148	A2#3	a_241_368##2	2.7929e-17
C149	VPWR#7	A2#6	2.13205e-18
C150	VGND#4	a_62_94##3	6.70754e-20
C151	A1#7	A1#1	3.95539e-17
C152	A1#6	a_241_368##6	2.39487e-17
C153	a_241_368##3	A2#6	2.79276e-19
C154	VPWR#7	A1#6	5.19665e-17
C155	Y#2	A2#3	4.2496e-18
C156	A1#3	a_241_368##2	3.37204e-17
C157	a_241_368##6	A1#5	2.69735e-19
C158	a_241_368##3	A1#6	6.36002e-19
C159	a_62_94##5	A1#7	4.06223e-18
C160	VPWR#7	A1#5	4.5309e-17
C161	a_241_368##6	a_62_94#	1.16351e-19
C162	Y#2	A1#3	1.19803e-17
C163	a_241_368##3	A1#5	3.32041e-17
C164	VPWR#7	a_62_94#	2.01946e-18
C165	Y#4	A1#5	1.93389e-18
C166	a_62_94##4	a_62_94##5	4.09946e-17
C167	a_241_368##3	a_62_94#	3.64173e-17
C168	VGND#3	a_436_74##2	4.43679e-18
C169	a_241_368##5	A1#5	1.82159e-19
C170	VPWR#7	a_62_94##6	2.78225e-19
C171	a_436_74#	A2#3	2.04194e-17
C172	Y#2	a_62_94##3	2.89486e-17
C173	Y#4	a_62_94#	6.34179e-17
C174	A2#3	VGND#7	1.36632e-18
C175	VGND#3	a_436_74##4	2.76441e-17
C176	a_241_368##3	a_62_94##6	4.31219e-19
C177	a_241_368##5	a_62_94#	6.30254e-18
C178	a_62_94##8	a_62_94##3	3.18262e-18
C179	B1_N#1	a_62_94##4	3.01527e-17
C180	a_436_74##2	A2#3	2.62959e-17
C181	VPWR#5	A1#5	3.3528e-20
C182	VPWR#7	B1_N#4	8.54606e-20
C183	Y#4	a_62_94##6	4.61233e-17
C184	a_241_368##3	B1_N#4	6.10225e-20
C185	a_241_368##5	a_62_94##6	3.56631e-17
C186	VPWR#5	a_62_94#	6.15178e-20
C187	B1_N#7	a_62_94##3	2.35117e-18
C188	a_62_94##10	a_62_94##6	1.68048e-18
C189	a_62_94##8	B1_N#3	1.29624e-17
C190	A1#3	Y#1	3.4392e-17
C191	a_241_368##5	B1_N#4	4.22666e-18
C192	VPWR#5	a_62_94##6	8.88882e-19
C193	a_62_94##10	B1_N#4	6.29662e-17
C194	B1_N#7	B1_N#3	1.22426e-17
C195	a_241_368##3	VPWR#4	2.62579e-17
C196	VPWR#5	B1_N#4	3.90378e-17
C197	A2#3	a_241_368#	2.05044e-17
C198	VPWR#6	A2#3	1.07647e-18
C199	a_241_368##5	VPWR#4	5.89067e-17
C200	VGND#8	a_62_94##3	4.85833e-19
C201	a_62_94##3	Y#3	1.99188e-17
C202	A2#6	A2#1	4.38845e-17
C203	VGND#9	a_62_94##3	3.25113e-18
C204	VPWR#4	VPWR#5	4.72929e-17
C205	A1#6	A2#6	4.70414e-17
C206	A1#3	a_241_368##3	8.81136e-18
C207	a_62_94##9	B1_N#3	7.14624e-18
C208	Y#4	A1#3	8.0082e-18
C209	A1#5	A1#6	4.71283e-17
C210	Y#4	a_62_94##3	2.10065e-17
C211	VGND#3	A1#7	5.35183e-18
C212	a_62_94##3	a_241_368##5	3.36084e-17
C213	A1#1	A2#3	2.60374e-18
C214	a_62_94#	A1#5	4.70524e-17
C215	Y#4	B1_N#3	4.97766e-19
C216	a_62_94##3	VPWR#5	2.04777e-19
C217	a_241_368##5	B1_N#3	4.92693e-19
C218	a_62_94##6	a_62_94#	4.65291e-17
C219	VPWR#5	B1_N#3	9.10028e-18
C220	A2#2	VNB	4.11225e-17
C221	A1#4	VNB	5.27463e-17
C222	B1_N#4	a_62_94##6	6.82713e-18
C223	VPWR#4	a_62_94#	4.48513e-18
C224	B1_N#1	a_62_94##3	2.15622e-18
C225	A1#3	A2#1	1.42025e-19
C226	VPWR#4	a_62_94##6	4.43427e-18
C227	A1#3	A2#6	6.63127e-19
C228	VGND#3	a_62_94#	2.48298e-19
C229	a_62_94##9	B1_N	8.09208e-18
C230	A1#3	A1#6	1.73993e-18
C231	A1#3	A1#5	1.5956e-18
C232	A1#3	a_62_94#	3.17518e-18
C233	VPWR	VPWR#3	1.95547e-17
C234	B1_N	VPWR#5	1.6974e-17
C235	VPWR	a_241_368##2	3.14215e-18
C236	B1_N#3	a_62_94##6	5.33898e-19
C237	VPWR	Y#2	1.96081e-18
C238	a_62_94##3	VPWR#4	4.31547e-19
C239	VGND	VGND#4	4.03618e-17
C240	VPWR	B1_N#7	6.42875e-19
C241	A1#3	A2#3	1.30512e-17
C242	VGND#3	a_62_94##3	6.20584e-20
C243	A2#3	a_62_94##3	2.15172e-19
C244	VGND	a_241_368##2	2.41495e-18
C245	VGND	Y#2	1.04949e-17
C246	A1#3	a_62_94##3	3.89089e-19
C247	VGND	a_62_94##8	2.98772e-18
C248	VGND	B1_N#7	1.14684e-18
C249	VPWR	a_241_368#	1.55943e-17
C250	VPWR	VPWR#6	2.41493e-17
C251	VGND#4	VNB	2.19929e-17
C252	VGND	a_436_74#	1.56739e-17
C253	VPWR	a_241_368##6	1.16114e-17
C254	B1_N#3	a_62_94##3	1.68308e-17
C255	VGND	VGND#7	1.62136e-17
C256	VPWR	VPWR#7	2.18156e-17
C257	VGND	a_436_74##2	1.91331e-17
C258	VPWR#3	VNB	2.27937e-17
C259	VGND	Y#1	5.43447e-18
C260	VPWR	a_241_368##3	1.55025e-17
C261	VGND	a_436_74##4	1.82346e-17
C262	VPWR	Y#4	9.27411e-18
C263	VPWR	a_241_368##5	2.87303e-17
C264	a_241_368##2	VNB	3.3525e-18
C265	VGND	Y#3	1.09847e-17
C266	VPWR	a_62_94##10	1.60389e-17
C267	VGND	VGND#9	2.21634e-17
C268	Y#2	VNB	6.6556e-18
C269	VGND	a_62_94##9	1.33783e-17
C270	VPWR	VPWR#5	4.85513e-17
C271	a_436_74#	A2#2	3.07023e-19
C272	VGND	a_241_368#	5.36917e-18
C273	a_62_94##8	VNB	9.14842e-18
C274	B1_N#7	VNB	3.70843e-18
C275	VGND#4	Y#2	8.7078e-19
C276	VGND	a_241_368##3	1.86221e-18
C277	a_436_74#	VNB	4.48321e-17
C278	VGND#7	VNB	1.81097e-18
C279	a_436_74##2	VNB	2.90077e-18
C280	VGND	a_241_368##5	7.20429e-19
C281	a_436_74##4	VNB	6.64494e-18
C282	VGND#8	VNB	2.41682e-18
C283	Y#3	VNB	4.70564e-18
C284	VGND	A2#4	1.42342e-18
C285	VGND#9	VNB	4.63691e-18
C286	VGND	A2#5	7.53597e-19
C287	a_62_94##9	VNB	4.26344e-17
C288	VPWR	A2#1	2.11747e-18
C289	a_241_368#	VNB	6.41122e-17
C290	VGND	A1#1	1.42669e-18
C291	VPWR	A2#6	1.31989e-18
C292	VPWR#6	VNB	2.86696e-18
C293	VGND	A1#7	9.80095e-19
C294	a_241_368##6	VNB	4.6621e-18
C295	B1_N	B1_N#3	9.86243e-18
C296	VPWR	A1#6	1.04357e-18
C297	VGND	a_62_94##5	1.38536e-18
C298	VPWR#7	VNB	2.4038e-19
C299	a_241_368##2	VPWR#3	3.13618e-19
C300	a_241_368##3	VNB	3.82175e-18
C301	VGND	a_62_94##4	3.26216e-19
C302	VPWR	A1#5	2.12802e-18
C303	VGND	B1_N#1	7.71677e-18
C304	VPWR	a_62_94#	1.52207e-18
C305	a_241_368##5	VNB	1.7142e-17
C306	a_62_94##10	VNB	1.31057e-17
C307	VPWR	a_62_94##6	1.38513e-18
C308	VPWR#5	VNB	9.45463e-17
C309	A2#4	VNB	2.77196e-17
C310	VPWR	B1_N#4	4.63617e-18
C311	A2#5	VNB	2.14976e-17
C312	A1#1	VNB	2.92909e-17
C313	A1#7	VNB	3.55326e-17
C314	VPWR	VPWR#4	2.36776e-17
C315	a_62_94##5	VNB	3.15538e-17
C316	a_62_94##4	VNB	3.12906e-17
C317	B1_N#1	VNB	4.42072e-17
C318	VPWR	A2#3	2.38382e-18
C319	A2#1	VNB	3.85317e-17
C320	VPWR	A1#3	2.58224e-18
C321	A2#6	VNB	2.98971e-17
C322	A1#6	VNB	2.96692e-17
C323	VPWR	a_62_94##3	4.8423e-18
C324	A1#5	VNB	3.12094e-17
C325	VGND	VGND#3	1.95273e-17
C326	VPWR	B1_N#3	7.24256e-19
C327	a_62_94#	VNB	4.44538e-17
C328	VGND	A2#3	3.71477e-18
C329	a_62_94##6	VNB	3.39546e-17
C330	VGND	A1#3	2.63746e-18
C331	B1_N#4	VNB	4.32567e-17
C332	VGND	a_62_94##3	3.27976e-18
C333	VPWR#4	VNB	2.25176e-16
C334	VGND	B1_N#3	1.7933e-18
C335	VGND#3	VNB	2.12834e-16
C336	A2#3	VNB	4.91985e-17
C337	A1#3	VNB	4.08806e-18
C338	a_62_94##3	VNB	6.91911e-17
C339	VPWR	B1_N	1.82001e-18
C340	B1_N#3	VNB	8.04013e-17
C341	VGND	B1_N	3.5553e-18
C342	B1_N	VNB	2.16034e-17
C343	A2#2	VGND#7	2.33798e-19
C344	VPWR	VNB	5.65394e-17
C345	VGND	VNB	7.54327e-17
C346	VGND#3	VGND#5	5.83412e-17
C347	VGND#3	VGND#2	6.34465e-17
C348	VGND#5	VGND#4	1.35859e-18
C349	VPWR#2	A2#1	1.87469e-18
C350	VGND#5	a_62_94##3	5.65063e-19
C351	VGND#2	A2#4	1.22302e-18
C352	VGND#5	B1_N#3	3.52859e-19
C353	VGND#2	a_241_368#	4.74698e-19
C354	VGND#2	a_436_74#	1.79321e-17
C355	VGND#4	VGND#2	3.24067e-19
C356	VGND#2	A2#5	1.23175e-18
C357	VPWR#2	VNB	4.55217e-17
C358	a_241_368##2	VPWR#2	2.26359e-19
C359	VPWR#2	A2#6	1.8725e-18
C360	VGND#5	a_62_94##4	3.83219e-18
C361	VGND#5	B1_N#1	2.4409e-18
C362	VGND#2	A1#1	5.32261e-18
C363	VGND#5	Y#3	5.24783e-18
C364	a_241_368#	VPWR#2	1.78179e-17
C365	VGND#2	a_436_74##2	1.95738e-17
C366	VPWR#3	VPWR#2	1.03241e-18
C367	VGND#5	B1_N	8.47309e-19
C368	VGND	VGND#2	4.12472e-17
C369	VGND#5	a_62_94##9	1.29758e-17
C370	VGND#2	VNB	5.70839e-17
C371	VGND	VGND#5	3.76778e-17
C372	VGND#5	VNB	5.27135e-17
C373	VGND#5	a_62_94##8	2.23409e-19
C374	VPWR#4	VPWR#2	5.13253e-17
C375	VPWR	VPWR#2	3.18397e-17
C376	a_241_368##6	VPWR#2	5.21184e-18
*
*
.ENDS sky130_fd_sc_hs__a21boi_2
*
