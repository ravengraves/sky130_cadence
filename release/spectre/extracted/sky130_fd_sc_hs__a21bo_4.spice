* Extracted by Quantus, converted by sky130cad/quantus.py
*
*
*
*                       LINUX           Wed Nov 18 08:04:12 2026
*
*
*
*  PROGRAM  advgen
*
*  Name           : advgen - Quantus - (64-bit)
*  Version        : 25.1.0-p047
*  Build Date     : Thu Dec 11 23:20:30 PST 2025
*
*  HSPICE LIBRARY
*
*  OPERATING_TEMPERATURE 150
*  QRC_TECH_DIR <path>/tech
*
*
*

*
.SUBCKT sky130_fd_sc_hs__a21bo_4 VPB VNB VGND VPWR X B1_N A2 A1
*
*
*  caps2d version: 10
*
*
*       TRANSISTOR CARDS
*
*
XM20 a_29_392##11 B1_N#2 VGND#13 VNB sky130_fd_pr__nfet_01v8_lvt l=0.15 w=0.64 ad=0.1696 as=0.32245 pd=1.81 ps=2.39
XM17 VGND#13 a_187_338##12 X#3 VNB sky130_fd_pr__nfet_01v8_lvt l=0.15 w=0.74 ad=0.32245 as=0.2072 pd=2.39 ps=2.04
XM1 VGND#12 a_187_338##8 X#3 VNB sky130_fd_pr__nfet_01v8_lvt l=0.15 w=0.74 ad=0.2072 as=0.2072 pd=2.04 ps=2.04
XM3 X#1 a_187_338##5 VGND#12 VNB sky130_fd_pr__nfet_01v8_lvt l=0.15 w=0.74 ad=0.2072 as=0.2072 pd=2.04 ps=2.04
XM18 X#1 a_187_338# VGND#11 VNB sky130_fd_pr__nfet_01v8_lvt l=0.15 w=0.74 ad=0.2072 as=0.246725 pd=2.04 ps=2.19
XM13 a_187_338##20 a_29_392##7 VGND#11 VNB sky130_fd_pr__nfet_01v8_lvt l=0.15 w=0.64 ad=0.1792 as=0.246725 pd=1.84 ps=2.19
XM15 VGND#10 a_29_392##5 a_187_338##20 VNB sky130_fd_pr__nfet_01v8_lvt l=0.15 w=0.64 ad=0.4032 as=0.1792 pd=2.54 ps=1.84
XM21 a_864_123##2 A2#4 VGND#10 VNB sky130_fd_pr__nfet_01v8_lvt l=0.15 w=0.64 ad=0.2176 as=0.4032 pd=1.96 ps=2.54
XM14 a_187_338##15 A1#6 a_864_123##2 VNB sky130_fd_pr__nfet_01v8_lvt l=0.15 w=0.64 ad=0.1792 as=0.2176 pd=1.84 ps=1.96
XM0 a_864_123# A1#1 a_187_338##15 VNB sky130_fd_pr__nfet_01v8_lvt l=0.15 w=0.64 ad=0.1792 as=0.1792 pd=1.84 ps=1.84
XM19 VGND#9 A2#2 a_864_123# VNB sky130_fd_pr__nfet_01v8_lvt l=0.15 w=0.64 ad=0.1696 as=0.1792 pd=1.81 ps=1.84
XM11 a_29_392##9 B1_N#1 VPWR#13 VPB sky130_fd_pr__pfet_01v8 l=0.15 w=1 ad=0.275 as=0.398 pd=2.55 ps=2.97
XM12 X#4 a_187_338##14 VPWR#13 VPB sky130_fd_pr__pfet_01v8 l=0.15 w=1.12 ad=0.336 as=0.398 pd=2.84 ps=2.97
XM5 VPWR#12 a_187_338##13 X#4 VPB sky130_fd_pr__pfet_01v8 l=0.15 w=1.12 ad=0.336 as=0.336 pd=2.84 ps=2.84
XM9 X#6 a_187_338##9 VPWR#12 VPB sky130_fd_pr__pfet_01v8 l=0.15 w=1.12 ad=0.336 as=0.336 pd=2.84 ps=2.84
XM2 VPWR#11 a_187_338##4 X#6 VPB sky130_fd_pr__pfet_01v8 l=0.15 w=1.12 ad=0.308 as=0.336 pd=2.79 ps=2.84
XM4 a_187_338##19 a_29_392##6 a_596_392##5 VPB sky130_fd_pr__pfet_01v8 l=0.15 w=1 ad=0.3 as=0.275 pd=2.6 ps=2.55
XM8 a_596_392##3 a_29_392# a_187_338##19 VPB sky130_fd_pr__pfet_01v8 l=0.15 w=1 ad=0.3 as=0.3 pd=2.6 ps=2.6
XM16 VPWR#10 A2#5 a_596_392##3 VPB sky130_fd_pr__pfet_01v8 l=0.15 w=1 ad=0.3 as=0.3 pd=2.6 ps=2.6
XM6 VPWR#10 A1#4 a_596_392##6 VPB sky130_fd_pr__pfet_01v8 l=0.15 w=1 ad=0.3 as=0.3 pd=2.6 ps=2.6
XM7 a_596_392##6 A1#5 VPWR#9 VPB sky130_fd_pr__pfet_01v8 l=0.15 w=1 ad=0.3 as=0.3 pd=2.6 ps=2.6
XM10 a_596_392# A2#1 VPWR#9 VPB sky130_fd_pr__pfet_01v8 l=0.15 w=1 ad=0.275 as=0.3 pd=2.55 ps=2.6
*
*
*       RESISTOR AND CAP/DIODE CARDS
*
Rg1	B1_N#1	B1_N#2	801.846558
Rg2	B1_N#2	B1_N#3	305.973755
Rg3	a_187_338#	a_187_338##2	326.906158
Rg4	a_187_338##2	a_187_338##3	45.174133
Rg5	a_187_338##2	a_187_338##4	419.554810
Rg6	a_187_338##3	a_187_338##5	302.425262
Rg7	a_187_338##3	a_187_338##6	32.598167
Rg8	a_187_338##6	a_187_338##7	37.362804
Rg9	a_187_338##7	a_187_338##8	296.149994
Rg10	a_187_338##6	a_187_338##9	419.554810
Rg11	a_187_338##7	a_187_338##10	37.362804
Rg12	a_187_338##10	a_187_338##11	33.425358
Rg13	a_187_338##11	a_187_338##12	296.149994
Rg14	a_187_338##10	a_187_338##13	419.554810
Rg15	a_187_338##11	a_187_338##14	480.030548
Rg16	a_29_392#	a_29_392##2	594.015686
Rg17	a_29_392##2	a_29_392##3	61.783062
Rg18	a_29_392##3	a_29_392##4	39.496929
Rg19	a_29_392##2	a_29_392##5	310.809753
Rg20	a_29_392##3	a_29_392##6	390.658630
Rg21	a_29_392##4	a_29_392##7	354.876251
Rg22	A1#1	A1#2	340.977417
Rg23	A1#2	A1#3	66.432877
Rg24	A1#3	A1#4	403.578156
Rg25	A1#2	A1#5	423.054657
Rg26	A1#3	A1#6	322.510437
Rg27	A2#1	A2#2	803.013733
Rg28	A2#2	A2#3	1132.425293
Rg29	A2#3	A2#4	302.108215
Rg30	A2#4	A2#5	803.013733
Rf1	B1_N#3	B1_N	176.003006
Rf2	X#1	X#2	72.117531
Rf3	X#2	X	37.297829
Rf4	X#2	X#3	19.325985
Rf5	X	X#5	5.551670
Rf6	X#5	X#6	61.690063
Rf7	X#4	X#5	15.000000
Rf8	a_29_392##4	a_29_392##10	386.682922
Rf9	a_29_392##10	a_29_392##11	69.097992
Rf10	a_29_392##9	a_29_392##10	5.000000
Rf11	A2	A2#3	168.696762
Rf12	a_187_338##15	a_187_338##16	111.257004
Rf13	a_187_338##16	a_187_338##17	25.210705
Rf14	a_187_338##17	a_187_338##3	130.463013
Rf15	a_187_338##16	a_187_338##19	61.887695
Rf16	a_187_338##17	a_187_338##20	14.409969
Rf17	A1	A1#7	11.219672
Rf18	A1#7	A1	7.676618
Rf19	a_864_123#	a_864_123##2	128.047897
Rf20	a_596_392#	a_596_392##2	89.679825
Rf21	a_596_392##2	a_596_392##4	92.003815
Rf22	a_596_392##4	a_596_392##5	116.600937
Rf23	a_596_392##2	a_596_392##6	18.602406
Rf24	a_596_392##3	a_596_392##4	5.000000
Rf26	VGND#2	VGND#3	158.650436
Rf27	VGND#3	VGND#4	41.006321
Rf28	VGND#4	VGND#5	29.253016
Rf29	VGND#5	VGND#6	62.889057
Rf30	VGND#6	VGND#7	68.733101
Rf32	VGND#2	VGND#9	51.015621
Rf33	VGND#3	VGND#10	66.487259
Rf34	VGND#5	VGND#11	50.329590
Rf35	VGND#6	VGND#12	44.445877
Rf36	VGND#7	VGND#13	48.073765
Rf38	VPWR#2	VPWR#3	71.655113
Rf39	VPWR#3	VPWR#4	94.633202
Rf40	VPWR#4	VPWR#5	39.057484
Rf41	VPWR#5	VPWR#6	65.696381
Rf42	VPWR#6	VPWR#7	65.696381
Rf44	VPWR#2	VPWR#9	38.736572
Rf45	VPWR#3	VPWR#10	38.736572
Rf46	VPWR#5	VPWR#11	33.523315
Rf47	VPWR#6	VPWR#12	33.523315
Rf48	VPWR#7	VPWR#13	33.523315
Rf53	A1#3	A1#7	160.232803
Re1	VPWR#4	VPWR	0.755546
Re2	VGND	VGND#4	0.755573
*
*       CAPACITOR CARDS
*
*
C1	a_864_123#	A1#2	3.75938e-19
C2	VGND#9	a_596_392#	1.02676e-17
C3	a_187_338##17	a_596_392##5	1.32146e-18
C4	VPWR#6	a_187_338##6	5.70628e-20
C5	X#1	VGND#11	3.92789e-17
C6	B1_N#1	a_187_338##11	3.41627e-18
C7	a_864_123#	a_596_392#	2.81621e-18
C8	VGND#12	VGND#11	2.4284e-18
C9	a_29_392##9	a_187_338##11	5.71656e-19
C10	A1#2	A2#2	1.57612e-17
C11	a_187_338##15	A1#2	2.98424e-18
C12	X#1	VGND#12	3.8902e-17
C13	a_29_392##9	a_187_338##10	4.64749e-19
C14	VPWR#5	a_187_338##6	5.63019e-20
C15	VGND#13	VGND#12	3.08303e-18
C16	VPWR#4	a_29_392##3	4.58521e-20
C17	a_596_392##2	A2#2	3.75261e-19
C18	VGND#6	VGND#5	2.99676e-18
C19	VGND#4	a_29_392##3	4.25839e-20
C20	a_29_392##11	VGND#13	3.70212e-17
C21	VGND#3	a_29_392##5	1.6099e-18
C22	a_29_392##3	VGND#10	1.47946e-18
C23	VGND#4	a_187_338##10	1.11125e-22
C24	a_187_338##16	A2#2	2.32163e-19
C25	a_596_392##2	VPWR#3	3.13618e-19
C26	VGND#5	a_187_338#	7.84391e-18
C27	a_187_338##16	A1#1	9.50313e-21
C28	VGND#5	VGND#3	3.31756e-18
C29	A1#3	A1#2	3.63751e-18
C30	VGND#3	a_187_338#	4.65435e-19
C31	a_187_338##17	A1#6	1.64155e-19
C32	VGND#6	a_187_338##5	2.49123e-18
C33	a_29_392##3	A2#4	1.36606e-17
C34	a_187_338##16	A1#6	2.27066e-20
C35	VGND#5	a_187_338##5	7.67549e-19
C36	VPWR#9	a_596_392#	5.20507e-17
C37	a_187_338##17	A2#4	9.83301e-19
C38	VGND#6	a_187_338##8	9.65356e-19
C39	a_596_392##6	a_596_392#	2.03743e-18
C40	a_187_338##16	A2#4	1.59713e-17
C41	VGND#5	a_187_338##8	1.90842e-19
C42	A2#3	A1#2	4.3331e-19
C43	a_187_338##17	a_29_392##5	2.62523e-17
C44	a_596_392##6	VPWR#9	5.29637e-17
C45	a_187_338##16	a_29_392##5	1.33049e-17
C46	VGND#9	A2#2	2.07999e-17
C47	VPWR#10	VPWR#9	2.00319e-18
C48	a_187_338##17	a_29_392##7	3.2836e-17
C49	a_864_123#	A2#2	5.30604e-17
C50	a_187_338##16	a_29_392##7	5.01533e-20
C51	VPWR#10	a_596_392##6	5.30395e-17
C52	VPWR#3	A2#1	2.40895e-19
C53	a_187_338##17	a_187_338#	2.38561e-18
C54	a_864_123#	A1#1	4.20496e-17
C55	a_596_392##3	a_596_392##6	1.97783e-18
C56	VGND#6	a_187_338##10	7.19045e-20
C57	a_29_392##4	a_29_392##3	1.36991e-17
C58	a_187_338##15	A1#1	1.2881e-17
C59	VPWR#3	A1#5	5.45681e-19
C60	a_596_392##3	VPWR#10	5.74942e-17
C61	a_864_123#	A1#6	1.81706e-18
C62	a_187_338##17	a_187_338##5	2.04453e-19
C63	a_29_392##4	a_187_338##10	7.41174e-20
C64	a_864_123##2	A1#1	3.8405e-19
C65	VGND#3	a_29_392##3	1.21193e-19
C66	a_187_338##6	a_29_392##4	2.37259e-17
C67	a_187_338##15	A1#6	4.38171e-17
C68	a_864_123#	A2#4	7.65793e-20
C69	VPWR#3	A1#4	5.35599e-18
C70	A1#6	a_864_123##2	2.00234e-17
C71	a_187_338##19	a_596_392##3	6.03895e-17
C72	a_187_338##15	A2#4	1.51947e-17
C73	VGND#6	a_187_338##6	1.83806e-20
C74	VGND#10	A1#6	6.59696e-19
C75	a_187_338##3	a_29_392##3	9.66976e-20
C76	A2#4	a_864_123##2	1.88949e-17
C77	X#2	a_187_338#	5.00147e-20
C78	a_596_392##5	a_596_392##3	2.52173e-18
C79	VPWR#3	A2#5	6.8177e-18
C80	a_187_338##15	a_29_392##5	1.82734e-19
C81	a_187_338##3	a_187_338##10	1.17513e-17
C82	a_187_338##6	a_29_392##7	1.64157e-18
C83	A2#4	VGND#10	2.34571e-17
C84	a_596_392##5	a_187_338##19	6.97143e-17
C85	a_187_338##3	a_187_338##6	3.60681e-17
C86	a_864_123##2	a_29_392##5	1.18471e-18
C87	X#2	a_187_338##5	5.14257e-19
C88	a_29_392##11	a_29_392##9	1.58775e-18
C89	a_29_392##5	VGND#10	1.88805e-17
C90	VPWR#3	a_29_392#	3.0753e-18
C91	VGND#11	A2#4	4.80859e-20
C92	VGND#5	a_187_338##17	4.74607e-19
C93	a_596_392##2	A2#1	4.66286e-18
C94	VGND#5	a_187_338##6	1.02576e-19
C95	a_29_392##5	a_187_338##20	1.2912e-17
C96	X#2	a_187_338##8	2.36981e-17
C97	VPWR#11	a_596_392##5	4.25371e-17
C98	VGND#10	a_29_392##7	7.32591e-19
C99	X#1	a_187_338##6	5.63365e-18
C100	VGND#11	a_29_392##5	6.58928e-19
C101	VGND#3	a_187_338##17	6.34579e-19
C102	a_187_338##6	a_187_338#	4.33956e-19
C103	VPWR#3	a_29_392##6	1.04129e-19
C104	a_29_392##7	a_187_338##20	1.2912e-17
C105	a_596_392##2	A1#5	1.8578e-17
C106	X#2	a_187_338##12	2.27181e-17
C107	VGND#10	a_187_338#	5.26899e-19
C108	VPWR#9	A2#2	5.26175e-19
C109	a_29_392##7	VGND#11	1.63194e-17
C110	VPWR#5	a_187_338##4	3.99123e-18
C111	VGND#3	a_187_338##16	1.58432e-18
C112	X#2	B1_N#2	1.89984e-18
C113	X#1	a_29_392##7	3.79609e-19
C114	VPWR#3	a_187_338##4	3.36696e-20
C115	a_596_392##2	A1#4	1.86313e-17
C116	VPWR#12	VPWR#11	1.16956e-17
C117	VGND#11	a_187_338#	2.94575e-17
C118	a_596_392##5	X#4	1.3727e-20
C119	VPWR#6	a_187_338##9	3.99123e-18
C120	VGND#12	a_187_338##6	1.27744e-18
C121	a_187_338#	X#1	1.25331e-17
C122	VGND#11	a_187_338##5	1.62343e-18
C123	a_596_392##2	A2#5	4.92082e-18
C124	VGND#12	a_187_338#	7.49461e-19
C125	a_187_338##10	X#3	3.39769e-19
C126	X#1	a_187_338##5	4.57281e-17
C127	VPWR#6	a_187_338##13	3.99123e-18
C128	VGND#11	a_187_338##8	1.92928e-19
C129	a_187_338##5	VGND#12	1.76929e-17
C130	a_596_392##2	a_29_392#	4.34608e-20
C131	X#1	a_187_338##8	1.24394e-18
C132	a_187_338##16	A2#5	2.47606e-19
C133	VPWR#13	VPWR#12	1.16956e-17
C134	VGND#13	a_187_338##11	8.14537e-18
C135	X#6	a_29_392##9	3.22699e-18
C136	VGND#12	a_187_338##8	3.12427e-17
C137	X#1	a_187_338##12	2.05589e-19
C138	a_187_338##8	X#3	3.42975e-18
C139	a_29_392##9	VPWR#12	3.05068e-17
C140	VGND#6	X#2	6.24007e-18
C141	VGND#12	a_187_338##12	1.72535e-18
C142	VGND#13	a_187_338##8	6.27578e-19
C143	a_29_392##9	X#4	3.9139e-18
C144	a_187_338##12	X#3	1.49756e-17
C145	a_29_392##9	VPWR#13	7.16286e-17
C146	a_187_338##12	VGND#13	2.04085e-17
C147	a_187_338##16	a_596_392##2	1.96499e-19
C148	a_29_392##11	a_187_338##11	3.13676e-18
C149	B1_N#2	VGND#13	2.4512e-17
C150	a_29_392##11	B1_N#2	4.61915e-17
C151	B1_N#2	a_187_338##11	2.90939e-17
C152	VPWR#4	VPWR#6	3.60713e-17
C153	A2#2	A1#1	5.41227e-17
C154	VPWR#4	VPWR#5	3.03537e-17
C155	VPWR#4	VPWR#3	4.64032e-17
C156	a_596_392#	A2#1	3.37486e-17
C157	A1#6	A1#1	3.53034e-17
C158	VPWR#9	A2#1	4.17479e-17
C159	a_596_392#	A1#5	7.46456e-19
C160	a_596_392##6	A2#1	2.07075e-18
C161	A1#5	VPWR#9	1.99095e-17
C162	VPWR#10	A2#1	1.72497e-19
C163	A2#4	A1#6	2.51479e-17
C164	a_596_392##6	A1#5	4.98492e-17
C165	A1#2	A2#1	1.55144e-17
C166	VPWR#3	A1#3	2.78681e-20
C167	VPWR#9	A1#4	6.87375e-19
C168	VGND#4	VGND#6	3.62817e-17
C169	VPWR#10	A1#5	3.71489e-19
C170	a_187_338##11	a_187_338##10	1.34325e-18
C171	VGND#3	a_187_338##15	8.72672e-19
C172	a_187_338##19	A2#1	4.31582e-19
C173	VGND#4	VGND#5	2.61922e-17
C174	a_596_392##6	A1#4	4.34351e-17
C175	a_29_392##5	A2#4	8.8823e-18
C176	VGND#4	VGND#3	5.42409e-17
C177	VPWR#9	A2#5	1.72497e-19
C178	A1#4	VPWR#10	1.94818e-17
C179	a_187_338##19	A1#5	2.32968e-19
C180	a_596_392##6	A2#5	1.68066e-18
C181	a_596_392##3	A1#4	3.66711e-19
C182	VGND#3	a_864_123##2	2.69321e-17
C183	VPWR#10	A2#5	3.95853e-17
C184	VPWR#13	B1_N#2	6.35924e-19
C185	a_187_338##19	A1#4	3.96632e-19
C186	a_29_392##7	a_29_392##5	3.34415e-17
C187	a_596_392##6	a_29_392#	1.65565e-19
C188	a_596_392##3	A2#5	2.87722e-17
C189	a_29_392##4	VPWR#6	1.96369e-18
C190	a_29_392##9	B1_N#2	1.19179e-18
C191	A1	A1#2	1.76213e-17
C192	a_29_392##4	VPWR#5	2.45606e-18
C193	VPWR#10	a_29_392#	1.3398e-18
C194	A1	a_29_392##3	1.47739e-18
C195	a_187_338##19	A2#5	3.56341e-18
C196	VGND#6	A2#3	2.57932e-19
C197	VGND#5	A2#3	1.61277e-18
C198	a_596_392##3	a_29_392#	3.31062e-17
C199	VGND#4	a_187_338##17	6.84549e-18
C200	a_596_392##5	A2#5	2.11095e-19
C201	a_187_338#	a_29_392##7	2.78075e-17
C202	VGND#3	A2#3	2.68183e-17
C203	A1#3	a_596_392##2	1.69443e-17
C204	a_187_338##19	a_29_392#	5.08121e-17
C205	VPWR#11	A2#5	2.58572e-20
C206	a_596_392##3	a_29_392##6	3.70342e-19
C207	a_187_338##17	a_29_392##3	2.44881e-18
C208	a_596_392##5	a_29_392#	8.16376e-18
C209	a_864_123#	a_596_392##2	9.58249e-18
C210	a_29_392##6	a_187_338##19	1.84095e-17
C211	a_187_338##5	a_187_338#	3.81051e-17
C212	VPWR#11	a_29_392#	8.99667e-20
C213	a_187_338##16	A1#3	1.03713e-18
C214	a_596_392##2	A2#3	2.36536e-19
C215	a_596_392##5	a_29_392##6	8.08821e-17
C216	VGND#6	X#1	3.12757e-18
C217	a_187_338##19	a_187_338##4	3.18746e-19
C218	VPWR#11	a_29_392##6	1.81469e-18
C219	a_29_392##11	a_187_338##14	1.0004e-19
C220	a_187_338##16	A1#2	9.9104e-20
C221	a_187_338##15	a_596_392##2	3.16638e-18
C222	a_187_338##8	a_187_338##5	3.79854e-17
C223	a_596_392##5	a_187_338##4	3.62335e-18
C224	X#6	a_29_392##6	1.28652e-19
C225	VGND#5	a_187_338##3	4.66443e-19
C226	a_187_338##16	A2#3	2.55405e-18
C227	VGND#5	X#1	4.65735e-18
C228	VPWR#11	a_187_338##4	4.84357e-17
C229	a_29_392##11	B1_N#1	3.11539e-18
C230	a_596_392##5	a_187_338##9	4.46074e-19
C231	X#6	a_187_338##4	3.86193e-17
C232	a_187_338##16	a_29_392##3	2.11794e-17
C233	a_187_338##12	a_187_338##8	3.76033e-17
C234	a_187_338##17	a_29_392##4	3.39521e-17
C235	VPWR#11	a_187_338##9	3.20725e-18
C236	VPWR#12	a_187_338##4	4.74333e-18
C237	VGND#6	B1_N#3	1.44521e-18
C238	a_864_123#	A1#3	8.21933e-20
C239	a_29_392##4	a_187_338##16	1.8248e-17
C240	VGND#5	B1_N#3	2.77296e-19
C241	a_596_392##5	a_187_338##13	2.72739e-19
C242	X#6	a_187_338##9	4.37589e-17
C243	VGND#12	VGND#5	1.24501e-18
C244	a_187_338##15	A1#3	1.66384e-17
C245	VPWR#12	a_187_338##9	4.04999e-17
C246	a_864_123##2	A1#3	2.1499e-19
C247	B1_N#2	a_187_338##12	1.53872e-17
C248	a_596_392##5	a_187_338##14	1.8704e-19
C249	a_864_123#	A2#3	6.00354e-18
C250	a_29_392##9	a_187_338##4	5.38229e-19
C251	a_187_338##19	A1#2	7.50675e-20
C252	a_187_338##10	a_187_338##6	1.08091e-18
C253	a_187_338##3	a_187_338##16	2.7266e-18
C254	VPWR#12	a_187_338##13	3.92526e-17
C255	a_187_338##15	A2#3	4.92245e-18
C256	a_29_392##3	A2#5	5.42525e-18
C257	a_864_123##2	A2#3	1.29858e-17
C258	a_187_338##17	a_187_338##15	1.15732e-18
C259	a_187_338##13	X#4	2.62252e-17
C260	a_29_392##9	a_187_338##9	5.46826e-19
C261	VGND#10	A2#3	2.81119e-18
C262	a_187_338##19	a_29_392##3	6.2103e-18
C263	VGND#13	VGND#6	1.70188e-19
C264	VPWR#12	a_187_338##14	3.20725e-18
C265	VPWR#13	a_187_338##13	3.20725e-18
C266	X#2	a_187_338##3	3.41166e-17
C267	VGND#11	A2#3	6.93146e-19
C268	a_187_338##14	X#4	2.62252e-17
C269	a_29_392##9	a_187_338##13	1.70745e-17
C270	VPWR#13	a_187_338##14	4.38821e-17
C271	VGND#12	A2#3	6.62477e-20
C272	a_596_392##6	VPWR#3	8.50531e-18
C273	a_29_392##4	a_187_338##20	1.88932e-18
C274	a_29_392##9	a_187_338##14	1.94446e-17
C275	a_596_392##5	VPWR#4	5.88802e-17
C276	B1_N#1	VPWR#13	2.56193e-17
C277	X#2	B1_N#3	4.2455e-19
C278	A1#3	a_596_392##6	7.19241e-19
C279	X	a_29_392##3	1.66675e-19
C280	a_29_392##9	B1_N#1	6.26996e-17
C281	A1#5	A2#1	4.26404e-17
C282	X	a_187_338##11	2.03851e-17
C283	a_187_338##17	VGND#10	3.02598e-17
C284	X	a_187_338##10	8.1639e-18
C285	a_29_392##3	a_29_392#	1.1116e-17
C286	X	a_187_338##6	1.92043e-19
C287	a_187_338##3	VGND#11	2.26428e-17
C288	a_187_338##3	X#1	6.62127e-17
C289	a_187_338##19	A1#3	7.72256e-19
C290	a_596_392##5	a_29_392##3	1.11166e-19
C291	a_187_338##3	VGND#12	3.32799e-18
C292	A1#4	A1#5	4.1599e-17
C293	VPWR#10	A2#3	4.22665e-19
C294	a_187_338##16	VGND#10	2.61572e-17
C295	a_596_392##3	A2#3	9.94768e-19
C296	a_187_338##17	a_187_338##20	4.05145e-19
C297	a_187_338##16	a_187_338##6	7.58939e-19
C298	VGND#12	B1_N#3	7.74627e-19
C299	A2#5	A1#4	4.27389e-17
C300	a_596_392##3	VPWR#3	2.59602e-17
C301	a_29_392##4	a_187_338##19	3.8738e-17
C302	B1_N#3	VGND#13	2.78246e-17
C303	a_187_338##17	VGND#11	2.42203e-17
C304	B1_N#3	a_29_392##11	1.43976e-17
C305	a_29_392##4	a_596_392##5	5.00389e-17
C306	a_29_392#	A2#5	5.20754e-17
C307	a_29_392##4	VPWR#11	4.01757e-17
C308	a_29_392##4	X#6	7.38805e-17
C309	a_29_392##4	VPWR#12	1.28655e-17
C310	VGND#4	a_29_392##5	1.11187e-18
C311	a_187_338##3	VPWR#11	1.87827e-18
C312	X#1	a_187_338##17	2.67474e-18
C313	a_29_392##6	a_29_392#	4.24728e-17
C314	A2#3	A2#2	4.45241e-19
C315	a_187_338##3	X#6	5.68243e-17
C316	VGND#4	a_29_392##7	3.57707e-18
C317	a_29_392##4	VPWR#13	1.6842e-20
C318	A2#4	A1#3	1.26216e-17
C319	a_187_338##3	VPWR#12	2.84535e-18
C320	VGND#4	a_187_338#	3.431e-20
C321	A2#3	A1#6	1.88091e-17
C322	a_187_338##4	a_29_392##6	6.21351e-18
C323	VGND#4	a_187_338##8	3.431e-20
C324	a_29_392##5	A2#3	4.89447e-18
C325	a_596_392##5	VPWR#3	1.77666e-18
C326	VPWR#6	VPWR#5	1.60643e-18
C327	a_864_123#	VGND#9	7.13087e-17
C328	A1	a_596_392##2	6.00193e-17
C329	a_187_338#	A2#3	6.41173e-19
C330	a_187_338##9	a_187_338##4	4.86804e-17
C331	VGND	a_187_338##11	4.33139e-19
C332	a_187_338##16	A1	5.6951e-18
C333	a_29_392##9	B1_N#3	2.11286e-19
C334	VGND	a_187_338##6	2.93295e-19
C335	VGND#3	A2	4.25899e-17
C336	a_187_338##4	a_29_392##3	1.1488e-18
C337	a_187_338##3	a_29_392##5	1.65167e-20
C338	a_187_338##13	a_187_338##9	4.62021e-17
C339	VPWR#11	VPWR#3	1.69063e-20
C340	a_187_338##3	a_29_392##7	6.7737e-20
C341	a_187_338##3	a_187_338#	4.85773e-18
C342	a_864_123#	A1	2.87708e-18
C343	A2	a_187_338##16	1.2562e-17
C344	a_187_338##15	A1	4.66906e-17
C345	VPWR#4	a_29_392#	1.74738e-18
C346	a_187_338##3	a_187_338##5	4.74771e-19
C347	a_187_338##14	a_187_338##13	4.85985e-17
C348	a_596_392##2	a_596_392#	5.34827e-19
C349	a_864_123#	a_187_338##15	7.40827e-17
C350	a_187_338##3	a_187_338##8	8.65533e-20
C351	VPWR#4	a_29_392##6	4.43469e-18
C352	a_187_338##3	a_187_338##12	6.41472e-20
C353	VPWR#11	a_187_338##6	8.76375e-19
C354	A2#5	A1#3	1.32601e-17
C355	B1_N#1	a_187_338##14	3.96841e-17
C356	VPWR#5	VPWR#3	2.99129e-19
C357	B1_N#3	a_187_338##12	7.05786e-18
C358	A2	a_864_123##2	3.72949e-17
C359	A1#2	VNB	2.23189e-17
C360	a_29_392##3	VNB	3.92817e-17
C361	A2	VGND#10	2.61043e-17
C362	a_187_338##11	VNB	2.93146e-17
C363	B1_N#3	B1_N#2	1.67267e-18
C364	a_864_123##2	a_864_123#	2.67476e-18
C365	a_187_338##10	VNB	1.89456e-17
C366	a_596_392##2	VPWR#9	2.44156e-17
C367	a_187_338##6	VNB	4.31336e-17
C368	A1	a_596_392##6	1.95223e-18
C369	X#6	a_187_338##10	7.94734e-19
C370	a_29_392##4	a_29_392#	1.10209e-18
C371	a_187_338##19	A1	3.69795e-18
C372	a_29_392##4	a_29_392##6	1.26258e-17
C373	VPWR	VPWR#6	2.67507e-17
C374	VPWR	VPWR#5	2.30405e-17
C375	VPWR	VPWR#3	4.31127e-17
C376	a_29_392##4	a_187_338##4	2.84734e-17
C377	a_187_338##15	a_864_123##2	6.37475e-17
C378	a_29_392##4	a_187_338##9	1.72475e-17
C379	a_596_392##2	a_596_392##6	1.98852e-19
C380	X#2	X#1	2.73106e-18
C381	X#2	X	2.62564e-18
C382	a_29_392##4	a_187_338##13	5.44273e-19
C383	B1_N	VGND#13	6.28761e-18
C384	B1_N	a_29_392##11	2.57872e-17
C385	a_29_392##4	a_187_338##14	2.63727e-19
C386	VPWR	a_596_392##2	4.04362e-18
C387	A1	A2#2	3.69487e-18
C388	X#6	a_187_338##6	2.16746e-18
C389	a_29_392##4	B1_N#1	2.42599e-19
C390	A1	A2#4	5.09743e-18
C391	X#2	VGND#12	4.70848e-17
C392	VGND#13	X	2.75e-17
C393	A2	A2#2	5.68858e-20
C394	a_29_392##4	VPWR#4	3.61631e-19
C395	a_596_392##2	VPWR#10	2.44156e-17
C396	a_29_392##11	X	3.32844e-17
C397	VGND	VGND#6	3.8039e-17
C398	VGND	VGND#5	3.43926e-17
C399	VGND	VGND#3	4.76717e-17
C400	A2	A1#6	5.80529e-19
C401	A2#3	A1#3	7.83142e-19
C402	VGND#4	a_29_392##4	3.41515e-20
C403	A2	A2#4	8.58205e-18
C404	A2	a_29_392##5	5.28255e-19
C405	VPWR#12	a_187_338##10	5.29936e-19
C406	VGND#10	a_864_123##2	6.40727e-18
C407	VGND	a_187_338##17	1.47162e-17
C408	A2	a_187_338#	1.09427e-19
C409	VGND	a_187_338##16	7.63478e-18
C410	X#2	a_187_338##11	2.05704e-18
C411	A1	A2#1	4.13525e-18
C412	X	VPWR#12	9.34639e-19
C413	X#2	X#3	1.6532e-18
C414	VPWR	a_596_392#	1.56131e-17
C415	VGND	X#2	1.52983e-17
C416	X	X#4	6.98194e-20
C417	VPWR#6	VNB	3.02355e-17
C418	VPWR#5	VNB	2.61618e-17
C419	X	VPWR#13	1.50496e-18
C420	VPWR	a_596_392##6	1.60511e-17
C421	VPWR#3	VNB	3.47771e-17
C422	VGND	a_864_123#	2.26666e-17
C423	a_29_392##9	X	1.27067e-16
C424	a_596_392##3	a_596_392##2	5.1918e-19
C425	VGND	a_187_338##15	9.66555e-18
C426	a_187_338##3	a_29_392##4	6.62039e-17
C427	a_29_392##9	VPWR#6	1.95158e-18
C428	VPWR	a_596_392##3	1.28394e-17
C429	A1	A2#5	5.41404e-18
C430	VGND	a_864_123##2	1.46319e-17
C431	VPWR	a_187_338##19	7.94794e-18
C432	VGND#6	VNB	3.08105e-17
C433	VGND#5	VNB	2.51117e-17
C434	A1	a_29_392#	7.08263e-19
C435	VPWR	a_596_392##5	2.94463e-17
C436	VGND#3	VNB	4.23516e-17
C437	VPWR	VPWR#11	1.72418e-17
C438	VGND	X#1	1.23918e-17
C439	B1_N	a_187_338##12	9.95853e-19
C440	VPWR	X#6	3.10011e-18
C441	VPWR	VPWR#12	1.72774e-17
C442	B1_N	B1_N#2	3.51603e-18
C443	a_596_392##2	VNB	5.30353e-18
C444	VGND	a_29_392##11	9.24875e-18
C445	VPWR	VPWR#13	1.72476e-17
C446	a_187_338##17	VNB	3.05144e-18
C447	VGND	a_596_392#	2.59342e-18
C448	a_187_338##16	VNB	4.32922e-18
C449	X#2	a_187_338##10	6.83881e-18
C450	VPWR	a_29_392##9	2.82657e-17
C451	VPWR#6	a_187_338##11	8.67354e-20
C452	VGND#13	X#2	6.00636e-17
C453	X#2	VNB	2.63076e-18
C454	VGND	a_596_392##3	2.71812e-18
C455	VGND#9	VNB	4.7534e-17
C456	X	B1_N#2	7.46681e-18
C457	a_864_123#	VNB	8.93747e-18
C458	a_187_338##15	VNB	2.32937e-18
C459	a_187_338##11	X#4	6.52932e-19
C460	a_864_123##2	VNB	6.37741e-18
C461	VGND#10	VNB	4.38787e-18
C462	VGND#11	VNB	2.23045e-18
C463	X#1	VNB	2.60419e-18
C464	VGND#12	VNB	1.23512e-18
C465	VGND#13	VNB	9.07196e-18
C466	VGND	A2#2	9.06879e-18
C467	a_29_392##11	VNB	4.39076e-17
C468	VGND	A1#1	1.78194e-19
C469	a_596_392#	VNB	5.24509e-17
C470	VPWR#9	VNB	2.60465e-18
C471	A1	A1#3	1.29116e-17
C472	a_596_392##6	VNB	2.1429e-18
C473	VPWR#10	VNB	4.09278e-19
C474	VPWR	A2#1	3.27041e-18
C475	VGND	a_29_392##5	7.09031e-18
C476	a_596_392##3	VNB	4.44493e-18
C477	X	a_187_338##4	2.64272e-19
C478	A1	A2#3	8.49038e-19
C479	VGND	a_29_392##7	8.64168e-18
C480	VPWR	A1#5	7.93923e-19
C481	a_187_338##19	VNB	8.19925e-19
C482	a_596_392##5	VNB	1.29849e-17
C483	VGND	a_187_338#	3.74709e-18
C484	X	a_187_338##9	5.44329e-19
C485	VPWR	A1#4	7.93923e-19
C486	VPWR#11	VNB	4.31271e-18
C487	VGND	a_187_338##5	7.40902e-18
C488	VPWR	A2#5	2.60039e-18
C489	X	a_187_338##13	1.63314e-17
C490	a_29_392##11	X#2	1.53689e-18
C491	VGND	a_187_338##8	3.74709e-18
C492	VPWR	a_29_392#	1.55603e-18
C493	VGND	a_187_338##12	9.19741e-18
C494	X	a_187_338##14	1.8338e-17
C495	A2	A2#3	1.61159e-17
C496	VPWR#13	VNB	1.53675e-18
C497	VGND	B1_N#2	1.64404e-19
C498	VPWR	a_29_392##6	1.64048e-18
C499	a_29_392##9	VNB	5.46271e-17
C500	X	B1_N#1	9.32343e-18
C501	A2#2	VNB	8.92365e-17
C502	VPWR	a_187_338##4	3.68838e-19
C503	A1#1	VNB	2.28294e-17
C504	VPWR	a_187_338##9	4.24532e-19
C505	A1#6	VNB	2.30496e-17
C506	A2#4	VNB	2.66503e-17
C507	VPWR	a_187_338##13	4.24532e-19
C508	VGND#11	VGND#10	4.70375e-18
C509	a_29_392##5	VNB	2.88899e-17
C510	a_29_392##7	VNB	2.84062e-17
C511	VPWR	a_187_338##14	4.80209e-19
C512	a_187_338#	VNB	3.0257e-17
C513	VPWR	B1_N#1	9.07692e-19
C514	a_187_338##5	VNB	2.79795e-17
C515	a_187_338##8	VNB	2.53585e-17
C516	a_187_338##12	VNB	3.3128e-17
C517	B1_N#2	VNB	5.39298e-17
C518	VPWR	VPWR#4	1.59955e-17
C519	X	a_29_392##4	1.29547e-18
C520	A2#1	VNB	5.72312e-17
C521	A1#5	VNB	2.92712e-17
C522	X	a_187_338##3	3.9118e-17
C523	VPWR	A1#3	5.30747e-19
C524	A1#4	VNB	2.91937e-17
C525	A2#5	VNB	4.19415e-17
C526	B1_N#3	X	1.52102e-18
C527	a_29_392#	VNB	3.90037e-17
C528	X#2	a_187_338##6	1.57306e-18
C529	VPWR	a_29_392##4	1.31694e-17
C530	a_29_392##6	VNB	3.69661e-17
C531	a_187_338##4	VNB	3.38379e-17
C532	VGND	VGND#4	1.10407e-17
C533	VPWR	a_187_338##3	6.20592e-18
C534	a_187_338##9	VNB	2.81329e-17
C535	a_187_338##14	a_187_338##10	1.80644e-18
C536	VGND	A1#3	5.29966e-19
C537	a_187_338##13	VNB	2.84693e-17
C538	a_187_338##14	VNB	3.08502e-17
C539	VGND	A2#3	1.33026e-17
C540	B1_N#1	VNB	5.09587e-17
C541	VGND	a_29_392##4	3.0764e-18
C542	VGND	a_187_338##3	6.96208e-18
C543	VPWR#4	VNB	2.76053e-16
C544	VGND#4	VNB	2.64961e-16
C545	VGND	B1_N#3	2.45459e-17
C546	a_187_338##16	a_596_392##3	1.20644e-17
C547	A1#3	VNB	3.12027e-17
C548	A2#3	VNB	8.58804e-17
C549	a_29_392##4	VNB	2.52127e-17
C550	a_187_338##3	VNB	1.37485e-18
C551	B1_N#3	VNB	7.45371e-17
C552	VPWR	A1	2.77769e-18
C553	VGND	A1	4.41062e-18
C554	VGND	A2	1.48258e-17
C555	VPWR	X	8.47168e-18
C556	A2	VNB	4.24414e-18
C557	VGND	X	4.98327e-18
C558	B1_N	VNB	1.0223e-17
C559	X	VNB	2.75284e-18
C560	VPWR	VNB	6.8735e-17
C561	VGND	VNB	7.56372e-17
C562	VGND#7	VNB	5.15837e-17
C563	VPWR#4	VPWR#7	5.3171e-17
C564	VPWR	VPWR#7	3.72607e-17
C565	VGND#7	X	5.99616e-19
C566	VGND#7	a_29_392##11	1.50352e-18
C567	VPWR#7	VPWR#6	1.60907e-18
C568	VGND#4	VGND#2	6.3951e-17
C569	VPWR#2	A2#5	8.74044e-20
C570	VGND#2	A2#2	2.11045e-17
C571	VGND#7	B1_N#3	6.82498e-17
C572	VGND#7	a_187_338##10	1.79138e-20
C573	VPWR#2	VNB	5.06435e-17
C574	a_596_392##6	VPWR#2	8.43957e-18
C575	VPWR#2	A2#1	6.50647e-18
C576	a_29_392##9	VPWR#7	2.32461e-17
C577	VGND	VGND#2	5.7936e-17
C578	VPWR#7	VNB	4.95534e-17
C579	VPWR#3	VPWR#2	7.06672e-19
C580	VGND#2	a_864_123##2	8.15209e-18
C581	VPWR#4	VPWR#2	5.71433e-17
C582	VGND#7	a_187_338##12	6.78779e-18
C583	VPWR#7	a_187_338##14	3.99544e-18
C584	VPWR#2	A1#5	5.35599e-18
C585	VGND#4	VGND#7	5.97538e-17
C586	a_596_392##2	VPWR#2	3.13618e-19
C587	VGND#2	a_864_123#	5.96512e-17
C588	VPWR#7	B1_N#1	2.98563e-18
C589	VPWR	VPWR#2	5.27021e-17
C590	a_596_392#	VPWR#2	1.81998e-17
C591	VGND	VGND#7	5.30804e-17
C592	VGND#7	VGND#6	1.95325e-18
C593	VGND#2	VNB	6.08689e-17
C594	VPWR#2	A1#4	5.45681e-19
C595	VGND#2	A2#3	6.98775e-18
C596	VGND#7	a_187_338##11	1.49274e-20
C597	VGND#7	X#2	3.00469e-18
C598	VPWR#7	a_187_338##11	5.70628e-20
C599	VPWR#2	A1#3	2.17077e-20
*
*
.ENDS sky130_fd_sc_hs__a21bo_4
*
