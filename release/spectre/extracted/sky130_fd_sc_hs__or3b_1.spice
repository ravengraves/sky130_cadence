* Extracted by Quantus, converted by sky130cad/quantus.py
*
*
*
*                       LINUX           Wed Nov 18 09:06:33 2026
*
*
*
*  PROGRAM  advgen
*
*  Name           : advgen - Quantus - (64-bit)
*  Version        : 25.1.0-p047
*  Build Date     : Thu Dec 11 23:20:30 PST 2025
*
*  HSPICE LIBRARY
*
*  OPERATING_TEMPERATURE 150
*  QRC_TECH_DIR <path>/tech
*
*
*

*
.SUBCKT sky130_fd_sc_hs__or3b_1 VNB VPB VGND VPWR X C_N B A
*
*
*  caps2d version: 10
*
*
*       TRANSISTOR CARDS
*
*
XM6 VGND#4 C_N#1 a_124_424##6 VNB sky130_fd_pr__nfet_01v8_lvt l=0.15 w=0.55 ad=0.1925 as=0.1595 pd=1.8 ps=1.68
XM1 a_239_74##7 a_124_424##3 VGND#6 VNB sky130_fd_pr__nfet_01v8_lvt l=0.15 w=0.55 ad=0.15675 as=0.231 pd=1.67 ps=1.94
XM0 VGND#6 B#3 a_239_74##8 VNB sky130_fd_pr__nfet_01v8_lvt l=0.15 w=0.55 ad=0.231 as=0.17325 pd=1.94 ps=1.73
XM5 a_239_74##8 A#3 VGND#5 VNB sky130_fd_pr__nfet_01v8_lvt l=0.15 w=0.55 ad=0.17325 as=0.38025 pd=1.73 ps=2.69
XM3 VGND#5 a_239_74# X#1 VNB sky130_fd_pr__nfet_01v8_lvt l=0.15 w=0.74 ad=0.38025 as=0.2109 pd=2.69 ps=2.05
XM8 VPWR#4 C_N#3 a_124_424##7 VPB sky130_fd_pr__pfet_01v8 l=0.15 w=0.84 ad=0.2814 as=0.2562 pd=2.35 ps=2.29
XM7 a_239_74##9 a_124_424# a_368_391# VPB sky130_fd_pr__pfet_01v8 l=0.15 w=1 ad=0.295 as=0.27 pd=2.59 ps=2.54
XM2 a_368_391# B#1 a_452_391# VPB sky130_fd_pr__pfet_01v8 l=0.15 w=1 ad=0.27 as=0.27 pd=2.54 ps=2.54
XM4 a_452_391# A#1 VPWR#5 VPB sky130_fd_pr__pfet_01v8 l=0.15 w=1 ad=0.27 as=0.4764 pd=2.54 ps=3.11
XM9 VPWR#5 a_239_74##3 X#3 VPB sky130_fd_pr__pfet_01v8 l=0.15 w=1.12 ad=0.4764 as=0.3304 pd=3.11 ps=2.83
*
*
*       RESISTOR AND CAP/DIODE CARDS
*
Rg1	C_N#1	C_N#2	326.289612
Rg2	C_N#2	C_N#3	460.429962
Rg3	a_124_424#	a_124_424##2	710.586365
Rg4	a_124_424##2	a_124_424##3	595.020996
Rg5	B#1	B#2	523.992432
Rg6	B#2	B#3	345.238708
Rg7	A#1	A#2	472.853699
Rg8	A#2	A#3	408.363556
Rg9	a_239_74#	a_239_74##2	353.264496
Rg10	a_239_74##2	a_239_74##3	456.264679
Rf1	C_N	C_N#4	1.988420
Rf2	C_N#5	C_N#2	82.104820
Rf3	C_N#4	C_N#5	4.122870
Rf4	C_N	C_N#7	1.988420
Rf5	C_N#5	C_N#7	6.046876
Rf6	a_124_424##2	a_124_424##5	82.015343
Rf7	a_124_424##5	a_124_424##6	73.717926
Rf8	a_124_424##5	a_124_424##7	68.273651
Rf9	B	B#2	171.465530
Rf10	A#4	A#2	160.782516
Rf11	A	A#6	0.549716
Rf12	A#4	A#6	7.873454
Rf13	a_239_74##2	a_239_74##5	246.527252
Rf14	a_239_74##5	a_239_74##6	51.251347
Rf15	a_239_74##6	a_239_74##7	25.859945
Rf16	a_239_74##5	a_239_74##8	23.090988
Rf17	a_239_74##6	a_239_74##9	66.100319
Rf18	X#2	X	6.703401
Rf19	X	X#3	83.656532
Rf20	X#2	X	6.703401
Rf21	X#1	X#2	7.500000
Rf23	VGND#2	VGND#3	75.813271
Rf24	VGND#3	VGND#4	156.559128
Rf25	VGND#2	VGND#5	25.372189
Rf26	VGND#3	VGND#6	35.446526
Rf28	VPWR#2	VPWR#3	72.660713
Rf29	VPWR#3	VPWR#4	152.977661
Rf30	VPWR#2	VPWR#5	35.727165
Re1	VPWR#3	VPWR	1.227783
Re2	VGND	VGND#3	1.227829
*
*       CAPACITOR CARDS
*
*
C1	VGND	VNB	6.13558e-17
C2	VPWR	VNB	7.77128e-17
C3	X	VNB	1.49845e-17
C4	C_N	VNB	1.24983e-17
C5	B	VNB	3.48462e-18
C6	A	VNB	6.79389e-19
C7	C_N#2	VNB	1.0236e-16
C8	a_124_424##2	VNB	7.4882e-17
C9	VGND	X	2.0086e-17
C10	B#2	VNB	4.24772e-17
C11	A#2	VNB	3.65803e-17
C12	a_239_74##2	VNB	4.62919e-17
C13	VGND#3	VNB	2.15838e-16
C14	VPWR#3	VNB	2.12507e-16
C15	VGND	B	4.87727e-18
C16	C_N#3	VNB	4.58206e-17
C17	a_124_424#	VNB	5.3183e-17
C18	B#1	VNB	3.68122e-17
C19	VPWR	C_N	5.5683e-18
C20	A#1	VNB	4.11907e-17
C21	a_239_74##3	VNB	4.26169e-17
C22	C_N#1	VNB	3.14592e-17
C23	VPWR	B	1.69643e-17
C24	a_124_424##3	VNB	4.4358e-17
C25	B#3	VNB	2.56394e-17
C26	A#3	VNB	2.70493e-17
C27	a_239_74#	VNB	3.14542e-17
C28	VPWR	A	4.57456e-18
C29	VPWR#4	VNB	8.68377e-17
C30	a_124_424##7	VNB	1.48882e-17
C31	a_239_74##9	VNB	1.25698e-17
C32	VPWR#5	VNB	6.65589e-18
C33	X#3	VNB	8.25179e-17
C34	VGND#4	VNB	7.12073e-17
C35	a_124_424##6	VNB	1.04006e-17
C36	VGND	C_N#2	5.72769e-18
C37	VGND#6	VNB	4.24429e-18
C38	VGND	a_124_424##2	5.09394e-18
C39	X#1	VNB	3.31214e-17
C40	C_N#5	VNB	6.28942e-18
C41	a_124_424##5	VNB	1.59345e-17
C42	A#4	VNB	2.19054e-18
C43	VGND	a_239_74##2	5.23917e-18
C44	B	A	1.92222e-17
C45	VGND	VGND#3	3.35737e-17
C46	a_239_74##5	VNB	1.40098e-17
C47	a_239_74##6	VNB	1.92746e-17
C48	VPWR	a_124_424##2	3.91751e-18
C49	VPWR	a_239_74##2	3.20906e-18
C50	B	a_368_391#	2.67046e-18
C51	VPWR	VPWR#3	3.37602e-17
C52	C_N	C_N#2	1.65009e-17
C53	VGND	C_N#1	1.36889e-18
C54	B	a_452_391#	3.09422e-19
C55	VGND	a_124_424##3	1.46721e-20
C56	VPWR	C_N#3	2.59997e-18
C57	VGND	B#3	1.37639e-19
C58	C_N	a_124_424##2	3.0363e-18
C59	VPWR	a_124_424#	9.35223e-18
C60	VGND	A#3	6.51343e-20
C61	VGND	a_239_74#	2.15788e-18
C62	VPWR	B#1	1.01914e-17
C63	VPWR	A#1	7.9602e-18
C64	VPWR	a_239_74##3	3.71674e-18
C65	B	a_124_424##2	2.79637e-19
C66	B	B#2	2.35049e-17
C67	VGND	X#3	2.26231e-18
C68	B	A#2	6.35908e-18
C69	VGND	VGND#4	4.78985e-17
C70	VGND	a_124_424##6	2.04609e-17
C71	B	a_239_74##2	3.12154e-18
C72	A	B#2	1.40016e-18
C73	VGND	VGND#6	1.82338e-17
C74	VPWR	VPWR#4	5.08571e-17
C75	A	A#2	1.23294e-17
C76	VPWR	a_124_424##7	1.62965e-17
C77	B	VPWR#3	1.28467e-17
C78	VPWR	a_239_74##9	1.75906e-17
C79	A	a_239_74##2	8.29402e-18
C80	a_124_424##6	a_124_424##5	1.01835e-18
C81	VPWR	VPWR#5	2.12246e-17
C82	VGND	a_124_424##5	4.12554e-18
C83	VPWR	X#3	2.43871e-17
C84	X	a_239_74#	1.07479e-17
C85	B	a_124_424#	2.13047e-17
C86	VGND	A#4	3.45254e-18
C87	B	B#1	3.26841e-17
C88	VGND	a_239_74##5	1.93631e-17
C89	B	A#1	1.24873e-17
C90	VGND	a_239_74##6	1.99347e-17
C91	B	a_239_74##3	5.20525e-18
C92	A	B#1	9.94608e-19
C93	C_N	VPWR#4	2.64234e-17
C94	B	a_124_424##3	2.35874e-18
C95	VPWR	a_124_424##5	5.06987e-18
C96	A	a_239_74##3	1.95104e-18
C97	C_N#2	a_124_424##2	4.77885e-17
C98	a_239_74##5	VPWR#5	1.79897e-18
C99	B	a_239_74#	5.4148e-19
C100	X	X#1	1.0608e-18
C101	a_124_424##2	B#2	2.57356e-18
C102	a_239_74##9	B	8.88335e-17
C103	a_124_424#	a_368_391#	1.59894e-18
C104	B#1	a_368_391#	1.97124e-17
C105	B	VPWR#5	3.51633e-17
C106	B#2	A#2	3.34104e-17
C107	B	X#3	4.0145e-18
C108	VGND#3	a_124_424##2	8.52567e-19
C109	B#1	a_452_391#	1.99228e-17
C110	a_239_74##2	B#2	5.46179e-19
C111	A#1	a_452_391#	1.59894e-18
C112	VPWR#3	a_124_424##2	6.77157e-19
C113	A	VPWR#5	1.38282e-17
C114	A#2	a_239_74##2	2.54317e-17
C115	C_N	a_124_424##5	2.72436e-17
C116	A	X#3	3.93604e-18
C117	VPWR#3	B#2	1.23131e-19
C118	C_N#2	a_124_424#	4.21382e-20
C119	a_124_424#	B#2	4.50735e-18
C120	B	A#4	1.84025e-17
C121	C_N#2	a_124_424##3	8.27184e-19
C122	a_239_74##5	B	2.9681e-17
C123	B#1	A#2	2.9441e-18
C124	a_239_74##6	B	3.9519e-17
C125	a_124_424##6	a_239_74##6	4.87812e-17
C126	VGND#3	a_124_424#	4.75316e-20
C127	A#2	a_239_74##3	2.80832e-18
C128	VPWR#3	a_124_424#	6.266e-18
C129	VPWR#4	C_N#2	5.30043e-18
C130	a_124_424##3	B#2	1.36854e-17
C131	VPWR#3	B#1	6.07284e-18
C132	a_239_74##9	C_N#2	7.53181e-21
C133	a_239_74##6	a_239_74##7	2.18491e-18
C134	VPWR#4	a_124_424##2	4.73356e-20
C135	B#2	A#3	2.60382e-18
C136	C_N#3	a_124_424#	4.1299e-18
C137	a_239_74##5	VGND#6	3.88024e-17
C138	C_N#5	a_124_424##5	1.62227e-17
C139	a_239_74##2	a_124_424##3	4.85746e-20
C140	a_239_74##9	a_124_424##2	1.1899e-17
C141	A#2	a_239_74#	1.33622e-18
C142	a_239_74##6	VGND#6	5.82854e-17
C143	VGND#3	a_124_424##3	2.71607e-18
C144	a_124_424#	B#1	5.785e-17
C145	a_239_74##2	A#3	2.9566e-19
C146	C_N#2	VGND#4	5.33828e-17
C147	a_239_74##9	B#2	1.03616e-19
C148	a_239_74##5	a_239_74##8	3.02713e-18
C149	VGND#3	B#3	2.71641e-18
C150	a_239_74##2	a_239_74#	6.6735e-18
C151	B#1	A#1	5.53168e-17
C152	a_239_74##5	VGND#5	7.06376e-19
C153	A#2	VPWR#5	2.92836e-18
C154	a_239_74##6	a_368_391#	9.20178e-20
C155	A#1	a_239_74##3	3.10122e-17
C156	VPWR#3	VPWR#4	4.4083e-17
C157	X#3	A#2	3.58664e-19
C158	a_124_424##3	a_124_424#	5.17041e-18
C159	C_N#5	C_N#2	9.45247e-18
C160	a_239_74##5	X#1	1.93146e-18
C161	a_239_74##2	VPWR#5	6.23159e-18
C162	VGND#6	B#2	7.25274e-19
C163	a_239_74##9	VPWR#3	1.98964e-17
C164	a_239_74##2	X#3	5.11691e-17
C165	C_N#5	a_124_424##2	1.68211e-18
C166	VPWR#4	C_N#3	3.25957e-17
C167	C_N#2	a_124_424##5	4.25839e-17
C168	a_124_424##7	C_N#3	5.45832e-17
C169	VPWR#4	a_124_424#	9.48316e-19
C170	VGND#3	VGND#4	3.8877e-17
C171	a_239_74##9	C_N#3	8.26675e-18
C172	VGND#3	a_124_424##6	8.2703e-18
C173	a_124_424##5	a_124_424##2	3.46413e-17
C174	a_124_424##7	a_124_424#	4.21365e-18
C175	X#1	A#2	2.99233e-19
C176	VPWR#4	B#1	3.46198e-19
C177	a_239_74##9	a_124_424#	9.01508e-17
C178	a_239_74##2	VGND#5	2.04708e-18
C179	C_N#1	a_124_424##3	3.5566e-18
C180	a_124_424##7	B#1	2.84503e-19
C181	VPWR#4	A#1	4.17091e-19
C182	a_239_74##6	C_N#2	7.38082e-19
C183	a_239_74##2	X#1	5.14258e-17
C184	a_124_424##5	B#2	3.49105e-19
C185	a_239_74##9	B#1	5.23201e-18
C186	a_124_424##7	A#1	1.80796e-19
C187	A#4	B#2	2.82867e-18
C188	a_124_424##3	B#3	1.86527e-17
C189	VPWR#5	a_124_424#	1.25566e-18
C190	a_239_74##9	A#1	3.75116e-19
C191	a_239_74##6	a_124_424##2	1.79191e-17
C192	a_239_74##9	a_239_74##3	2.38514e-19
C193	VPWR#5	B#1	5.4621e-18
C194	A#4	A#2	1.29408e-17
C195	a_239_74##5	B#2	7.03173e-19
C196	B#3	A#3	2.6928e-17
C197	X#3	B#1	4.70866e-19
C198	a_239_74##6	B#2	7.35577e-18
C199	A#1	VPWR#5	3.99831e-17
C200	A#4	a_239_74##2	2.31415e-17
C201	X#3	A#1	4.38776e-18
C202	a_239_74##5	A#2	2.36225e-18
C203	a_239_74##3	VPWR#5	3.54079e-17
C204	VGND#3	a_124_424##5	9.62694e-19
C205	VGND#6	a_124_424#	1.07987e-18
C206	A#3	a_239_74#	1.08444e-17
C207	a_239_74##6	A#2	4.70088e-20
C208	X#3	a_239_74##3	5.08992e-17
C209	a_124_424##5	VPWR#3	1.23253e-18
C210	a_239_74##6	a_239_74##2	1.18579e-18
C211	a_124_424##5	a_239_74##6	5.10975e-17
C212	VGND#3	a_239_74##5	8.76448e-18
C213	VGND#4	C_N#1	2.59307e-17
C214	VGND#3	a_239_74##6	2.11587e-17
C215	VPWR#4	a_124_424##7	9.49664e-17
C216	a_124_424##5	C_N#3	3.3557e-18
C217	a_239_74##5	A#4	1.88669e-17
C218	a_124_424##6	C_N#1	4.11133e-17
C219	VGND#4	a_124_424##3	9.86708e-19
C220	a_124_424##6	a_124_424##3	1.14796e-18
C221	a_124_424##7	a_239_74##9	3.82659e-17
C222	a_124_424##5	a_124_424#	7.59441e-19
C223	VGND#4	B#3	2.41538e-19
C224	VGND#6	C_N#1	1.00604e-18
C225	a_124_424##3	a_239_74##7	1.87393e-17
C226	a_124_424##3	VGND#6	2.15266e-17
C227	B#3	VGND#6	1.90353e-17
C228	B#3	a_239_74##8	1.20298e-17
C229	VGND#4	VPWR#4	2.37427e-19
C230	a_239_74##9	VPWR#5	2.6756e-18
C231	VGND#6	A#3	1.28642e-18
C232	a_239_74##6	a_124_424#	2.69095e-18
C233	A#3	a_239_74##8	1.53049e-18
C234	VGND#6	a_239_74#	3.06299e-19
C235	X#1	B#3	2.30011e-19
C236	A#3	VGND#5	1.23348e-17
C237	X#1	A#3	1.08111e-18
C238	a_239_74##6	a_239_74##5	2.65318e-18
C239	a_239_74#	VGND#5	9.49108e-18
C240	a_124_424##5	C_N#1	7.92211e-20
C241	X#1	a_239_74#	2.4827e-17
C242	VPWR#5	X#3	9.29948e-17
C243	a_124_424##5	a_124_424##3	2.96755e-19
C244	VGND#4	a_124_424##6	6.45722e-17
C245	a_239_74##6	C_N#1	1.24966e-18
C246	a_239_74##5	a_124_424##3	8.49436e-19
C247	a_239_74##6	a_124_424##3	4.54626e-17
C248	VPWR#4	a_124_424##5	2.25139e-18
C249	VGND#4	VGND#6	5.88115e-19
C250	a_239_74##5	B#3	3.49834e-17
C251	a_124_424##5	a_124_424##7	3.90117e-20
C252	a_239_74##6	B#3	5.46317e-19
C253	X#1	X#3	2.90364e-18
C254	a_239_74##5	A#3	2.91608e-17
C255	a_124_424##5	a_239_74##9	3.45086e-17
C256	a_239_74##6	A#3	5.44313e-20
C257	a_239_74##5	a_239_74#	8.95926e-19
C258	a_239_74##6	a_239_74#	1.42552e-19
C259	VGND#2	X	4.43365e-17
C260	VPWR#3	VPWR#2	6.22591e-17
C261	VGND#2	A#2	8.87317e-19
C262	VGND#2	X#1	1.61041e-17
C263	VGND#2	a_124_424##3	4.30866e-19
C264	VGND#2	a_239_74##5	6.44944e-17
C265	A	VPWR#2	8.47252e-19
C266	VPWR	VPWR#2	4.35786e-17
C267	VPWR#2	A#1	1.69478e-17
C268	VGND#2	a_239_74##2	2.74498e-17
C269	VGND#2	B#3	2.12965e-18
C270	VGND#2	VNB	6.15303e-17
C271	VGND#3	VGND#2	6.58959e-17
C272	VPWR#2	VNB	5.43411e-17
C273	VGND#2	A#3	1.45308e-17
C274	VPWR#2	a_239_74##3	4.63558e-18
C275	a_239_74##2	VPWR#2	3.86767e-19
C276	VGND#6	VGND#2	1.98778e-18
C277	X#3	VPWR#2	2.9525e-17
C278	VGND#2	a_239_74#	1.96996e-17
C279	VGND	VGND#2	6.9853e-17
C280	VGND#2	VGND#5	1.8183e-17
*
*
.ENDS sky130_fd_sc_hs__or3b_1
*
