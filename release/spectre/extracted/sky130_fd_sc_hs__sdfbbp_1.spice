* Extracted by Quantus, converted by sky130cad/quantus.py
*
*
*
*                       LINUX           Wed Nov 18 09:08:59 2026
*
*
*
*  PROGRAM  advgen
*
*  Name           : advgen - Quantus - (64-bit)
*  Version        : 25.1.0-p047
*  Build Date     : Thu Dec 11 23:20:30 PST 2025
*
*  HSPICE LIBRARY
*
*  OPERATING_TEMPERATURE 150
*  QRC_TECH_DIR <path>/tech
*
*
*

*
.SUBCKT sky130_fd_sc_hs__sdfbbp_1 VNB VPB VGND VPWR Q_N Q SCD CLK RESET_B SET_B D SCE
*
*
*  caps2d version: 10
*
*
*       TRANSISTOR CARDS
*
*
XM28 VGND#12 SCD#3 a_119_119# VNB sky130_fd_pr__nfet_01v8_lvt l=0.15 w=0.42 ad=0.1197 as=0.1008 pd=1.41 ps=1.32
XM46 a_119_119# SCE#3 a_197_119##5 VNB sky130_fd_pr__nfet_01v8_lvt l=0.15 w=0.42 ad=0.1008 as=0.1512 pd=1.32 ps=1.56
XM21 a_197_119##5 D#3 a_299_119# VNB sky130_fd_pr__nfet_01v8_lvt l=0.15 w=0.42 ad=0.1512 as=0.0882 pd=1.56 ps=1.26
XM31 a_299_119# a_341_93##3 VGND#19 VNB sky130_fd_pr__nfet_01v8_lvt l=0.15 w=0.42 ad=0.0882 as=0.231 pd=1.26 ps=1.94
XM42 VGND#19 SCE#2 a_341_93##7 VNB sky130_fd_pr__nfet_01v8_lvt l=0.15 w=0.42 ad=0.231 as=0.1197 pd=1.94 ps=1.41
XM29 a_622_98##14 CLK#3 VGND#18 VNB sky130_fd_pr__nfet_01v8_lvt l=0.15 w=0.74 ad=0.2109 as=0.6005 pd=2.05 ps=3.48
XM12 VGND#18 a_622_98##5 a_877_98##8 VNB sky130_fd_pr__nfet_01v8_lvt l=0.15 w=0.74 ad=0.6005 as=0.2516 pd=3.48 ps=2.16
XM19 a_197_119##2 a_622_98##8 a_1092_96##6 VNB sky130_fd_pr__nfet_01v8_lvt l=0.15 w=0.42 ad=0.1197 as=0.147 pd=1.41 ps=1.54
XM0 a_1092_96##6 a_877_98##3 a_1192_96# VNB sky130_fd_pr__nfet_01v8_lvt l=0.15 w=0.42 ad=0.147 as=0.161875 pd=1.54 ps=1.78
XM38 a_1192_96# a_1250_231##2 VGND#17 VNB sky130_fd_pr__nfet_01v8_lvt l=0.15 w=0.42 ad=0.161875 as=0.349325 pd=1.78 ps=2.7
XM23 VGND#17 SET_B#3 a_1418_125##2 VNB sky130_fd_pr__nfet_01v8_lvt l=0.15 w=0.55 ad=0.349325 as=0.458575 pd=2.7 ps=2.9
XM32 a_1418_125##2 a_1092_96##3 a_1250_231##9 VNB sky130_fd_pr__nfet_01v8_lvt l=0.15 w=0.55 ad=0.458575 as=0.154 pd=2.9 ps=1.66
XM43 a_1250_231##9 a_1625_93##3 a_1418_125# VNB sky130_fd_pr__nfet_01v8_lvt l=0.15 w=0.55 ad=0.154 as=0.322425 pd=1.66 ps=2.47
XM25 VGND#16 a_1250_231##4 a_1880_119# VNB sky130_fd_pr__nfet_01v8_lvt l=0.15 w=0.55 ad=0.15675 as=0.1155 pd=1.67 ps=1.52
XM26 a_1880_119# a_877_98##4 a_1878_420##7 VNB sky130_fd_pr__nfet_01v8_lvt l=0.15 w=0.55 ad=0.1155 as=0.23445 pd=1.52 ps=2.34
XM27 a_1878_420##7 a_622_98##11 a_2061_74# VNB sky130_fd_pr__nfet_01v8_lvt l=0.15 w=0.42 ad=0.23445 as=0.1638 pd=2.34 ps=1.62
XM16 a_2061_74# a_2037_442# VGND#15 VNB sky130_fd_pr__nfet_01v8_lvt l=0.15 w=0.42 ad=0.1638 as=0.2424 pd=1.62 ps=2.2
XM6 VGND#15 SET_B#6 a_2271_74##2 VNB sky130_fd_pr__nfet_01v8_lvt l=0.15 w=0.74 ad=0.2424 as=0.2072 pd=2.2 ps=2.04
XM47 a_2271_74##2 a_1878_420##3 a_2037_442##15 VNB sky130_fd_pr__nfet_01v8_lvt l=0.15 w=0.74 ad=0.2072 as=0.2886 pd=2.04 ps=2.26
XM2 a_2037_442##15 a_1625_93##4 a_2271_74# VNB sky130_fd_pr__nfet_01v8_lvt l=0.15 w=0.74 ad=0.2886 as=0.2146 pd=2.26 ps=2.06
XM20 a_1625_93##12 RESET_B#3 VGND#14 VNB sky130_fd_pr__nfet_01v8_lvt l=0.15 w=0.42 ad=0.1197 as=0.2165 pd=1.41 ps=2.13
XM37 VGND#14 a_2037_442##7 Q_N#2 VNB sky130_fd_pr__nfet_01v8_lvt l=0.15 w=0.74 ad=0.2165 as=0.2109 pd=2.13 ps=2.05
XM30 a_2881_74##5 a_2037_442##8 VGND#13 VNB sky130_fd_pr__nfet_01v8_lvt l=0.15 w=0.55 ad=0.15675 as=0.30395 pd=1.67 ps=2.34
XM24 VGND#13 a_2881_74##4 Q#3 VNB sky130_fd_pr__nfet_01v8_lvt l=0.15 w=0.74 ad=0.30395 as=0.2109 pd=2.34 ps=2.05
XM36 a_27_464##2 SCD#1 VPWR#23 VPB sky130_fd_pr__pfet_01v8 l=0.15 w=0.64 ad=0.1888 as=0.2304 pd=1.87 ps=2
XM34 VPWR#23 SCE#5 a_218_464# VPB sky130_fd_pr__pfet_01v8 l=0.15 w=0.64 ad=0.2304 as=0.1728 pd=2 ps=1.82
XM22 a_218_464# D#4 a_197_119##6 VPB sky130_fd_pr__pfet_01v8 l=0.15 w=0.64 ad=0.1728 as=0.192 pd=1.82 ps=1.88
XM41 a_197_119##6 a_341_93# a_27_464# VPB sky130_fd_pr__pfet_01v8 l=0.15 w=0.64 ad=0.192 as=0.1888 pd=1.88 ps=1.87
XM44 VPWR#22 SCE#1 a_341_93##4 VPB sky130_fd_pr__pfet_01v8 l=0.15 w=0.64 ad=0.1888 as=0.1888 pd=1.87 ps=1.87
XM15 a_622_98##15 CLK#1 VPWR#21 VPB sky130_fd_pr__pfet_01v8 l=0.15 w=1.12 ad=0.3304 as=0.336 pd=2.83 ps=2.84
XM35 VPWR#21 a_622_98##9 a_877_98##9 VPB sky130_fd_pr__pfet_01v8 l=0.15 w=1.12 ad=0.336 as=0.3304 pd=2.84 ps=2.83
XM11 a_197_119# a_877_98# a_1092_96##7 VPB sky130_fd_pr__pfet_01v8 l=0.15 w=0.64 ad=0.1888 as=0.2326 pd=1.87 ps=2.11
XM3 a_1092_96##7 a_622_98# a_1221_419# VPB sky130_fd_pr__pfet_01v8 l=0.15 w=0.42 ad=0.2326 as=0.1134 pd=2.11 ps=1.38
XM9 a_1221_419# a_1250_231##3 VPWR#20 VPB sky130_fd_pr__pfet_01v8 l=0.15 w=0.42 ad=0.1134 as=0.4716 pd=1.38 ps=3.05
XM40 VPWR#20 SET_B#1 a_1250_231##7 VPB sky130_fd_pr__pfet_01v8 l=0.15 w=0.84 ad=0.4716 as=0.3276 pd=3.05 ps=2.46
XM10 a_1250_231##7 a_1092_96# a_1580_379# VPB sky130_fd_pr__pfet_01v8 l=0.15 w=0.84 ad=0.3276 as=0.2268 pd=2.46 ps=2.22
XM17 a_1580_379# a_1625_93# VPWR#19 VPB sky130_fd_pr__pfet_01v8 l=0.15 w=0.84 ad=0.2268 as=0.3024 pd=2.22 ps=2.4
XM7 VPWR#19 a_1250_231##6 a_1766_379# VPB sky130_fd_pr__pfet_01v8 l=0.15 w=0.84 ad=0.3024 as=0.369 pd=2.4 ps=2.91
XM18 a_1766_379# a_622_98##6 a_1878_420##6 VPB sky130_fd_pr__pfet_01v8 l=0.15 w=0.84 ad=0.369 as=0.2898 pd=2.91 ps=2.46
XM33 a_1878_420##6 a_877_98##5 a_1986_504# VPB sky130_fd_pr__pfet_01v8 l=0.15 w=0.42 ad=0.2898 as=0.1134 pd=2.46 ps=1.38
XM8 a_1986_504# a_2037_442##3 VPWR#18 VPB sky130_fd_pr__pfet_01v8 l=0.15 w=0.42 ad=0.1134 as=0.53585 pd=1.38 ps=3.76
XM4 VPWR#18 SET_B#4 a_2037_442##12 VPB sky130_fd_pr__pfet_01v8 l=0.15 w=1 ad=0.53585 as=0.4 pd=3.76 ps=2.8
XM45 a_2037_442##12 a_1878_420# a_2384_392# VPB sky130_fd_pr__pfet_01v8 l=0.15 w=1 ad=0.4 as=0.24 pd=2.8 ps=2.48
XM13 a_2384_392# a_1625_93##6 VPWR#17 VPB sky130_fd_pr__pfet_01v8 l=0.15 w=1 ad=0.24 as=0.28 pd=2.48 ps=2.56
XM1 a_1625_93##15 RESET_B#1 VPWR#16 VPB sky130_fd_pr__pfet_01v8 l=0.15 w=0.64 ad=0.1792 as=0.3656 pd=1.84 ps=2.97
XM14 VPWR#16 a_2037_442##9 Q_N#1 VPB sky130_fd_pr__pfet_01v8 l=0.15 w=1.12 ad=0.3656 as=0.308 pd=2.97 ps=2.79
XM5 a_2881_74##7 a_2037_442##4 VPWR#15 VPB sky130_fd_pr__pfet_01v8 l=0.15 w=0.84 ad=0.2478 as=0.3766 pd=2.27 ps=2.96
XM39 VPWR#15 a_2881_74# Q#1 VPB sky130_fd_pr__pfet_01v8 l=0.15 w=1.12 ad=0.3766 as=0.3192 pd=2.96 ps=2.81
*
*
*       RESISTOR AND CAP/DIODE CARDS
*
Rg1	SCD#1	SCD#2	360.927948
Rg2	SCD#2	SCD#3	269.031525
Rg3	D#1	D#2	16.832588
Rg4	D#2	D#3	460.680542
Rg5	D#2	D#4	445.477936
Rg6	a_341_93#	a_341_93##2	344.985229
Rg7	a_341_93##2	a_341_93##3	696.503113
Rg8	SCE#1	SCE#2	1066.887451
Rg9	SCE#2	SCE#3	1585.338379
Rg10	SCE#3	SCE#4	615.057922
Rg11	SCE#4	SCE#5	337.886139
Rg12	CLK#1	CLK#2	483.528442
Rg13	CLK#2	CLK#3	334.791077
Rg14	a_1250_231#	a_1250_231##2	228.538391
Rg15	a_1250_231#	a_1250_231##3	438.594208
Rg16	SET_B#1	SET_B#2	386.807739
Rg17	SET_B#2	SET_B#3	337.643768
Rg18	a_1092_96#	a_1092_96##2	420.419403
Rg19	a_1092_96##2	a_1092_96##3	253.420792
Rg20	a_1625_93#	a_1625_93##2	420.419403
Rg21	a_1625_93##2	a_1625_93##3	253.420792
Rg22	a_1250_231##4	a_1250_231##5	426.271637
Rg23	a_1250_231##5	a_1250_231##6	398.734711
Rg24	a_622_98#	a_622_98##2	379.624908
Rg25	a_622_98##2	a_622_98##3	1564.557129
Rg26	a_622_98##3	a_622_98##4	169.162537
Rg27	a_622_98##4	a_622_98##5	302.425262
Rg28	a_622_98##2	a_622_98##6	2152.750244
Rg29	a_622_98##6	a_622_98##7	351.092926
Rg30	a_622_98##3	a_622_98##8	996.111816
Rg31	a_622_98##4	a_622_98##9	433.568329
Rg32	a_877_98#	a_877_98##2	405.702942
Rg33	a_877_98##2	a_877_98##3	615.851807
Rg34	a_877_98##3	a_877_98##4	2761.654297
Rg35	a_877_98##4	a_877_98##5	1034.029419
Rg36	a_622_98##10	a_622_98##11	216.119781
Rg37	a_2037_442#	a_2037_442##2	855.522522
Rg38	a_2037_442##2	a_2037_442##3	316.155182
Rg39	SET_B#4	SET_B#5	400.207520
Rg40	SET_B#5	SET_B#6	451.403168
Rg41	a_1878_420#	a_1878_420##2	530.148987
Rg42	a_1878_420##2	a_1878_420##3	324.062012
Rg43	a_1625_93##4	a_1625_93##5	377.236847
Rg44	a_1625_93##5	a_1625_93##6	579.129944
Rg45	a_1625_93##5	a_1625_93##7	216.423157
Rg46	RESET_B#1	RESET_B#2	318.415436
Rg47	RESET_B#2	RESET_B#3	228.538391
Rg48	a_2037_442##4	a_2037_442##5	935.856262
Rg49	a_2037_442##5	a_2037_442##6	172.031845
Rg50	a_2037_442##6	a_2037_442##7	302.425262
Rg51	a_2037_442##5	a_2037_442##8	554.238037
Rg52	a_2037_442##6	a_2037_442##9	442.451355
Rg53	a_2881_74#	a_2881_74##2	503.482605
Rg54	a_2881_74##2	a_2881_74##3	436.511108
Rg55	a_2881_74##2	a_2881_74##4	376.329346
Rf1	SCD	SCD#4	0.964345
Rf2	SCD#5	SCD#2	54.375278
Rf3	SCD#4	SCD#5	10.353502
Rf4	SCD	SCD#7	0.964345
Rf5	SCD#5	SCD#7	1.081709
Rf6	SCE#6	SCE	2.795286
Rf7	SCE#4	SCE#8	163.028091
Rf8	SCE#6	SCE#8	7.283737
Rf9	D#1	D	162.988510
Rf10	a_27_464#	a_27_464##2	196.350555
Rf11	a_341_93##4	a_341_93##5	49.034508
Rf12	a_341_93##5	a_341_93##2	167.557907
Rf13	a_341_93##5	a_341_93##7	89.291977
Rf14	CLK	CLK#2	168.499924
Rf15	a_622_98##4	a_622_98##13	223.656342
Rf16	a_622_98##13	a_622_98##14	125.929718
Rf17	a_622_98##13	a_622_98##15	20.767605
Rf18	a_877_98##2	a_877_98##7	176.786743
Rf19	a_877_98##7	a_877_98##8	62.443005
Rf20	a_877_98##7	a_877_98##9	44.714516
Rf21	a_197_119#	a_197_119##3	160.483765
Rf22	a_197_119##3	a_197_119##4	302.713745
Rf23	a_197_119##4	a_197_119##5	86.398537
Rf24	a_197_119##4	a_197_119##6	111.064941
Rf25	a_197_119##2	a_197_119##3	15.000000
Rf26	a_1092_96##2	a_1092_96##5	316.680054
Rf27	a_1092_96##5	a_1092_96##6	101.639618
Rf28	a_1092_96##5	a_1092_96##7	65.207573
Rf29	a_1625_93##8	a_1625_93##9	1.780389
Rf30	a_1625_93##2	a_1625_93##11	162.013199
Rf31	a_1625_93##8	a_1625_93##11	4.195467
Rf32	a_1418_125#	a_1418_125##2	105.400314
Rf33	a_1250_231##7	a_1250_231##8	116.980377
Rf34	a_1250_231##8	a_1250_231##10	94.752014
Rf35	a_1250_231##10	a_1250_231#	294.221527
Rf36	a_1250_231##9	a_1250_231##10	15.000000
Rf37	a_622_98##10	a_622_98##7	488.712463
Rf38	SET_B	SET_B#7	13.880821
Rf39	SET_B#7	SET_B#2	676.668396
Rf40	a_1878_420##2	a_1878_420##5	290.920288
Rf41	a_1878_420##5	a_1878_420##6	71.542557
Rf42	a_1878_420##5	a_1878_420##7	50.253296
Rf43	a_2271_74#	a_2271_74##2	114.153862
Rf44	a_1625_93##12	a_1625_93##13	49.521168
Rf45	a_1625_93##13	a_1625_93##7	2.632633
Rf46	a_1625_93##7	a_1625_93##15	43.029739
Rf47	RESET_B#2	RESET_B	164.173309
Rf48	a_2037_442##6	a_2037_442##11	319.600494
Rf49	a_2037_442##11	a_2037_442##13	30.568289
Rf50	a_2037_442##13	a_2037_442##2	237.880569
Rf51	a_2037_442##11	a_2037_442##15	99.620262
Rf52	a_2037_442##12	a_2037_442##13	5.000000
Rf53	Q_N#1	Q_N	7.368414
Rf54	Q_N	Q_N#2	97.228798
Rf55	a_2881_74##5	a_2881_74##3	54.199337
Rf56	a_2881_74##3	a_2881_74##7	46.564228
Rf57	Q	Q#2	0.191323
Rf58	Q#2	Q	13.966559
Rf59	Q	Q#4	7.078941
Rf60	Q#4	Q	7.078941
Rf61	Q#1	Q#2	5.000000
Rf62	Q#3	Q#4	7.500000
Rf64	VGND#2	VGND#3	30.656675
Rf65	VGND#3	VGND#4	87.476212
Rf66	VGND#4	VGND#5	176.630646
Rf67	VGND#5	VGND#6	69.065536
Rf68	VGND#6	VGND#7	67.969780
Rf69	VGND#7	VGND#8	179.865479
Rf70	VGND#8	VGND#9	195.148743
Rf71	VGND#9	VGND#10	47.823540
Rf72	VGND#10	VGND#11	102.668762
Rf73	VGND#11	VGND#12	160.495377
Rf74	VGND#2	VGND#13	30.747387
Rf75	VGND#4	VGND#14	47.860756
Rf76	VGND#5	VGND#15	37.713318
Rf77	VGND#7	VGND#16	53.910976
Rf78	VGND#8	VGND#17	27.948292
Rf79	VGND#9	VGND#18	24.468842
Rf80	VGND#11	VGND#19	51.352844
Rf82	VPWR#2	VPWR#3	31.801710
Rf83	VPWR#3	VPWR#4	82.887779
Rf84	VPWR#4	VPWR#5	76.288704
Rf85	VPWR#5	VPWR#6	121.851883
Rf86	VPWR#6	VPWR#7	52.113197
Rf87	VPWR#7	VPWR#8	115.374908
Rf88	VPWR#8	VPWR#9	127.038452
Rf89	VPWR#9	VPWR#10	192.196320
Rf90	VPWR#10	VPWR#11	56.346924
Rf91	VPWR#11	VPWR#12	53.359676
Rf92	VPWR#12	VPWR#13	135.151703
Rf94	VPWR#2	VPWR#15	41.923954
Rf95	VPWR#4	VPWR#16	38.641060
Rf96	VPWR#5	VPWR#17	38.641060
Rf97	VPWR#6	VPWR#18	15.347511
Rf98	VPWR#8	VPWR#19	38.138847
Rf99	VPWR#9	VPWR#20	40.392368
Rf100	VPWR#10	VPWR#21	57.160992
Rf101	VPWR#12	VPWR#22	40.352859
Rf102	VPWR#13	VPWR#23	33.720150
Rf116	SET_B#5	SET_B#7	160.232803
Rf112	a_1250_231##5	a_1250_231##8	160.232803
Re1	a_1625_93##13	a_1625_93##9	26.769386
Re2	VPWR#3	VPWR#25	3.707182
Re3	VPWR#25	VPWR	0.829717
Re4	VPWR	VPWR#11	2.450039
Re5	VGND#3	VGND#21	3.707182
Re6	VGND#21	VGND	0.829717
Re7	VGND	VGND#10	2.450039
Re11	VPWR#7	VPWR#25	0.698413
Re14	VGND#6	VGND#21	0.698413
*
*       CAPACITOR CARDS
*
*
C1	a_2037_442##11	a_2037_442##6	1.31627e-18
C2	a_2037_442##9	a_2037_442##4	4.23031e-18
C3	a_877_98##7	a_197_119#	7.51804e-20
C4	VPWR#12	a_622_98##2	6.97062e-20
C5	a_2881_74##5	a_2881_74##4	8.29152e-19
C6	a_27_464#	VPWR#12	4.48588e-17
C7	a_341_93##3	a_341_93##2	2.11583e-18
C8	a_622_98##13	CLK#2	6.74843e-17
C9	VPWR#17	a_1878_420#	3.32889e-18
C10	a_1625_93##2	a_622_98##6	6.19723e-19
C11	a_2037_442##6	a_2037_442##5	1.38586e-17
C12	VPWR#16	RESET_B#2	2.98614e-19
C13	a_1250_231##5	a_1418_125#	1.30519e-17
C14	a_1250_231##5	a_1625_93#	6.89322e-18
C15	a_197_119##4	a_341_93##2	3.92476e-17
C16	a_2037_442##2	VPWR#6	7.62794e-17
C17	a_27_464##2	SCD#1	4.13225e-17
C18	a_1250_231##7	a_622_98##2	1.92722e-18
C19	VGND#5	SET_B#6	6.46309e-18
C20	VPWR#10	a_622_98##3	2.86753e-20
C21	a_2037_442##12	a_1625_93##6	6.67788e-18
C22	VGND#17	a_877_98##3	1.87284e-17
C23	a_2037_442##8	VGND#13	2.34493e-17
C24	a_2037_442#	SET_B#6	3.23775e-17
C25	a_2037_442##6	a_1625_93##5	6.58439e-20
C26	a_1250_231##9	a_1250_231##5	1.03784e-18
C27	a_1250_231##5	a_1092_96#	4.07749e-20
C28	a_197_119##2	a_877_98##8	6.97004e-17
C29	RESET_B#2	a_1625_93##15	1.42978e-17
C30	a_1092_96##6	a_1092_96##7	1.22458e-18
C31	VPWR#4	RESET_B#1	1.80963e-18
C32	Q_N#2	a_2037_442##5	2.06592e-17
C33	a_1092_96##6	a_1250_231##2	5.31026e-18
C34	VGND#7	VGND#5	1.83699e-19
C35	a_1625_93##9	VGND#6	2.37881e-18
C36	a_622_98##3	a_877_98##3	1.55931e-18
C37	Q_N#2	a_2881_74##4	4.92751e-20
C38	a_877_98##9	a_197_119#	8.34133e-17
C39	VGND#5	a_1878_420##2	1.77499e-18
C40	VPWR#3	a_2881_74##3	1.78937e-18
C41	VPWR#6	VPWR#5	4.14868e-19
C42	a_877_98##7	VPWR#10	2.02931e-19
C43	VPWR#6	a_1625_93##6	4.40999e-19
C44	a_1625_93##12	a_1625_93##15	2.78791e-18
C45	VPWR#17	SET_B#4	1.25769e-19
C46	VGND#7	a_2037_442#	3.07055e-20
C47	VGND#4	SET_B#6	3.32714e-20
C48	RESET_B#1	a_2037_442##9	2.51475e-17
C49	a_27_464#	a_218_464#	6.05504e-18
C50	a_2881_74##5	a_2037_442##8	4.88565e-17
C51	SET_B#2	a_622_98##6	1.41109e-17
C52	a_2037_442##12	a_1878_420#	6.58469e-17
C53	VGND#3	a_2881_74##3	6.05291e-18
C54	a_1418_125#	a_1625_93##2	2.44302e-19
C55	VPWR#20	a_622_98##3	2.86268e-20
C56	VPWR#3	a_2037_442##6	5.01195e-18
C57	RESET_B#2	a_2037_442##11	6.6759e-19
C58	a_341_93##2	a_622_98##13	3.08693e-17
C59	VPWR#6	VPWR#17	7.46229e-19
C60	VGND#17	a_622_98##8	1.99982e-18
C61	VPWR#22	SCE#2	4.45304e-19
C62	SET_B#2	a_1250_231##6	3.78774e-19
C63	VPWR#12	D#2	2.13873e-20
C64	VPWR#5	a_1625_93##6	9.28365e-18
C65	VGND#13	a_2037_442##7	9.33187e-19
C66	CLK#2	a_622_98##3	4.04277e-19
C67	a_197_119##2	VGND#18	5.5524e-18
C68	a_1250_231##9	a_1625_93##2	1.78547e-18
C69	VGND#3	a_2037_442##6	7.04024e-18
C70	a_1625_93##6	a_2037_442##9	1.29175e-18
C71	a_1092_96##6	a_877_98##3	4.78879e-17
C72	VGND#5	a_2037_442#	1.03228e-17
C73	VPWR#6	a_622_98##10	1.94488e-19
C74	SET_B#2	a_1625_93#	2.75918e-17
C75	VPWR#10	a_622_98##2	1.89429e-17
C76	SCE#3	SCE#4	3.73433e-19
C77	VGND#15	a_2271_74##2	6.10127e-17
C78	VPWR#17	a_1625_93##7	1.04644e-18
C79	a_622_98##11	a_2037_442#	1.50472e-17
C80	Q_N#2	a_2037_442##8	1.35351e-18
C81	VPWR#17	a_2037_442##3	6.46099e-20
C82	a_27_464##2	a_218_464#	5.83566e-18
C83	a_1625_93##13	a_2037_442##6	3.11729e-18
C84	VPWR#11	a_1092_96##7	1.63727e-17
C85	VPWR#17	VPWR#16	1.65615e-17
C86	SET_B#2	a_1092_96#	1.73945e-17
C87	VPWR#11	a_1092_96##5	5.83135e-18
C88	VPWR#20	a_622_98##2	3.33722e-18
C89	VPWR#4	a_1625_93##6	7.14917e-19
C90	a_2037_442##12	SET_B#4	4.46613e-17
C91	a_877_98##3	a_622_98#	1.51394e-19
C92	a_2037_442##11	a_2384_392#	3.79332e-18
C93	a_2037_442##7	a_2037_442##5	7.90716e-18
C94	a_1625_93##6	RESET_B#1	4.32651e-18
C95	a_2881_74##5	a_2037_442##7	7.23039e-19
C96	a_1625_93##5	RESET_B#2	2.74136e-19
C97	Q_N#1	a_2037_442##5	2.22779e-17
C98	a_197_119##2	a_877_98##3	7.35971e-18
C99	SET_B#2	SET_B#1	3.2393e-17
C100	VPWR#11	a_197_119#	1.95009e-17
C101	VPWR#21	a_877_98##9	6.12062e-17
C102	SCD#2	SCE#3	1.90633e-17
C103	a_1625_93##13	RESET_B#2	1.77517e-18
C104	VGND#7	a_622_98##11	3.66569e-19
C105	VPWR#6	a_1878_420#	2.85552e-18
C106	a_197_119##2	a_197_119#	2.2673e-18
C107	a_622_98##3	a_622_98##8	1.2453e-17
C108	a_197_119##2	a_622_98##14	3.05067e-17
C109	a_877_98##4	a_2037_442#	1.63312e-18
C110	a_1092_96##2	a_1250_231##9	6.98491e-17
C111	a_2037_442##11	a_1625_93##7	1.40632e-17
C112	a_2037_442##11	VPWR#5	4.84901e-18
C113	SET_B#4	VPWR#18	1.60214e-17
C114	a_1250_231##3	SET_B#2	2.71935e-18
C115	a_622_98##8	a_1092_96##6	1.06699e-17
C116	a_197_119##4	SCE#4	1.95358e-19
C117	VPWR#11	a_877_98##9	2.33e-17
C118	a_1625_93##13	a_1625_93##7	5.16423e-17
C119	a_622_98##13	a_877_98##9	1.48823e-18
C120	a_1092_96##2	a_1418_125##2	1.88792e-18
C121	VGND#3	a_2881_74##4	5.56967e-18
C122	SET_B#2	a_622_98#	2.93394e-19
C123	a_2037_442##12	a_2037_442##3	5.83784e-19
C124	a_877_98##8	a_877_98##3	1.85057e-19
C125	SCE	D#2	5.24071e-18
C126	VPWR#5	a_1878_420#	6.26319e-18
C127	Q_N#2	a_2037_442##7	4.65125e-17
C128	a_1092_96##5	a_877_98##3	2.05553e-18
C129	VGND#5	a_622_98##11	5.53757e-19
C130	VGND#8	a_877_98##4	2.37717e-18
C131	SCE#8	a_341_93##2	2.49541e-19
C132	a_1092_96##2	VGND#17	1.44865e-18
C133	VGND#10	a_197_119#	5.78154e-19
C134	a_622_98##15	a_877_98##9	1.61098e-18
C135	a_1625_93##13	a_1878_420##2	7.28743e-17
C136	a_877_98##4	a_622_98##11	1.90735e-17
C137	SET_B#2	a_877_98#	9.89877e-20
C138	VGND#10	a_1092_96##5	2.6929e-18
C139	a_197_119##2	a_622_98##8	4.36101e-17
C140	VGND#3	a_2037_442##8	3.02402e-18
C141	a_1878_420#	a_1625_93##6	6.84005e-17
C142	a_1878_420##2	a_2037_442##12	1.65512e-17
C143	a_197_119##6	a_341_93##3	7.48288e-19
C144	a_2037_442##3	VPWR#18	1.08534e-17
C145	a_622_98##14	a_877_98##8	5.65651e-18
C146	a_622_98##15	VPWR#11	3.33658e-17
C147	VPWR#9	a_622_98##2	7.73872e-17
C148	VGND#10	a_877_98##9	7.92978e-19
C149	a_1250_231##9	SET_B#2	5.27681e-19
C150	VGND#5	a_2037_442##2	1.00279e-19
C151	VPWR#11	a_877_98##7	1.0355e-18
C152	a_877_98##2	a_1250_231##3	7.23789e-19
C153	a_1625_93##13	SET_B#5	1.87704e-17
C154	a_2037_442##7	VGND#14	1.55388e-17
C155	a_1625_93##7	a_2037_442##5	1.24578e-19
C156	VGND#3	a_2037_442##7	1.5839e-18
C157	VPWR#5	VPWR#4	1.48308e-18
C158	VGND#7	a_877_98##4	5.57074e-17
C159	D#2	a_341_93##2	2.70387e-17
C160	a_622_98##13	VPWR#10	2.67866e-19
C161	VPWR#6	SET_B#4	2.35048e-17
C162	a_1418_125##2	SET_B#2	3.73687e-19
C163	SCD#2	a_197_119##4	9.78987e-19
C164	a_877_98##2	a_622_98#	9.82549e-19
C165	a_341_93##4	VPWR#11	3.55454e-17
C166	a_1878_420##2	a_2037_442##11	1.46797e-17
C167	a_2271_74#	a_2037_442##11	8.12042e-19
C168	a_877_98##8	a_622_98##8	1.17653e-18
C169	a_2037_442##11	VPWR#4	1.34282e-18
C170	a_1625_93##9	SET_B#5	1.7179e-17
C171	a_622_98##15	VPWR#21	6.43972e-17
C172	a_1625_93##13	a_2037_442##2	3.8549e-18
C173	a_622_98##13	VPWR#21	8.64412e-19
C174	VGND#10	a_197_119##4	8.57748e-17
C175	Q_N#2	RESET_B#3	1.06884e-18
C176	a_1625_93##7	a_1625_93##5	2.63739e-19
C177	VGND#3	VGND#13	1.61622e-17
C178	a_2037_442##12	VPWR#6	2.87549e-17
C179	a_877_98##8	a_877_98##9	2.96375e-18
C180	SET_B#5	a_2037_442##12	1.17456e-18
C181	a_622_98##5	a_622_98##3	1.59465e-17
C182	a_197_119##2	a_622_98##5	3.04423e-17
C183	SET_B#5	VPWR#7	6.83662e-17
C184	VPWR#8	a_1250_231##5	7.21687e-20
C185	VGND#7	a_1418_125#	4.56326e-17
C186	a_1625_93##9	a_2037_442##2	1.54397e-18
C187	a_622_98##13	VPWR#11	7.96982e-18
C188	VPWR#5	SET_B#4	2.60404e-19
C189	a_1625_93##12	a_2037_442##7	3.96023e-19
C190	SET_B#4	a_1878_420#	2.65674e-17
C191	SCD#4	a_341_93##2	3.13099e-20
C192	VGND#5	a_877_98##4	4.6845e-19
C193	VPWR#23	VPWR#12	1.0796e-20
C194	a_1878_420##6	a_2037_442##3	2.44387e-18
C195	a_877_98##4	a_1250_231##4	7.2142e-17
C196	SET_B#5	VPWR#18	5.04222e-19
C197	VGND#3	a_2881_74##5	3.63137e-17
C198	VGND#7	a_622_98##10	3.11396e-17
C199	VPWR#11	a_27_464#	4.43447e-17
C200	D	D#2	2.04095e-17
C201	VGND#8	a_1250_231##9	1.11527e-18
C202	a_1625_93##9	a_622_98##10	1.6026e-17
C203	VGND#14	RESET_B#3	2.68134e-17
C204	VGND#10	a_877_98##7	6.48438e-19
C205	a_1092_96##6	a_1192_96#	5.90887e-19
C206	RESET_B#2	a_2037_442##6	5.15697e-17
C207	a_877_98##8	a_622_98##5	2.41099e-17
C208	a_622_98##4	a_622_98##9	4.9236e-18
C209	VGND#6	a_2037_442##2	4.64402e-20
C210	VGND#3	Q_N#2	3.94527e-17
C211	VPWR#11	a_197_119##6	1.14793e-17
C212	a_2037_442##12	VPWR#5	3.74501e-18
C213	VPWR#7	a_622_98##10	6.48293e-20
C214	a_2271_74#	a_2037_442##7	1.19383e-18
C215	a_2037_442##2	a_2037_442##12	6.05156e-18
C216	Q_N#2	a_1625_93##4	2.84936e-19
C217	a_1625_93##9	a_622_98##7	4.63007e-17
C218	a_1250_231#	VGND#17	4.87673e-17
C219	VGND#7	a_1250_231##4	4.11652e-19
C220	a_622_98##14	a_622_98##8	2.19354e-19
C221	a_1625_93##6	a_2384_392#	2.14597e-17
C222	CLK#1	a_622_98##4	4.4598e-18
C223	a_622_98##13	a_622_98##15	3.25686e-18
C224	SET_B#5	a_2037_442##11	1.09824e-17
C225	a_877_98##4	a_1625_93##3	1.91501e-17
C226	a_1625_93##7	a_2037_442##6	2.05249e-18
C227	a_2037_442##15	a_2037_442##11	5.85233e-19
C228	a_197_119##2	CLK#3	3.09387e-17
C229	SET_B#5	a_1878_420##6	1.51287e-16
C230	VPWR#8	a_622_98##2	2.54275e-18
C231	a_1878_420##5	a_1878_420##2	7.67603e-21
C232	VPWR#6	a_2037_442##3	1.39352e-17
C233	a_1878_420##6	a_877_98##5	3.41092e-17
C234	VGND#6	a_622_98##10	6.20801e-17
C235	a_1250_231##9	a_1625_93##8	2.07303e-17
C236	SCE#8	SCE#4	1.48955e-17
C237	a_1878_420#	a_2384_392#	2.12813e-17
C238	a_2037_442##2	VPWR#18	3.58642e-18
C239	VPWR#7	a_622_98##7	3.59081e-20
C240	a_622_98##4	SCE#1	1.65122e-19
C241	RESET_B#3	a_1625_93##12	1.38691e-17
C242	a_2037_442##3	SET_B#4	4.65499e-18
C243	a_2037_442##12	VPWR#17	1.74151e-17
C244	a_622_98##5	VGND#18	1.69126e-17
C245	a_341_93##4	a_622_98##15	5.93368e-17
C246	VGND#10	a_622_98##13	3.45334e-18
C247	VPWR#22	VPWR#21	6.49187e-19
C248	a_1625_93##9	a_1250_231##5	4.88853e-17
C249	a_1092_96##7	a_622_98##2	5.61061e-18
C250	a_1625_93##7	RESET_B#2	3.93143e-17
C251	a_877_98##7	a_877_98##3	2.66238e-19
C252	a_1092_96##5	SET_B#1	9.23431e-19
C253	VPWR#6	VPWR#18	1.56746e-17
C254	a_197_119##4	a_27_464#	2.79783e-18
C255	a_1092_96##6	a_1250_231#	4.41874e-17
C256	VPWR#11	VPWR#23	1.60657e-17
C257	a_1878_420##2	a_1625_93##5	3.97766e-17
C258	VPWR#5	a_2037_442##3	1.58464e-19
C259	VGND#14	a_1625_93##4	9.65435e-19
C260	a_877_98##8	CLK#3	1.62114e-18
C261	a_1625_93##3	a_1250_231##4	2.90751e-18
C262	a_877_98##4	a_1092_96##3	4.94711e-18
C263	SCE#1	CLK#2	3.66414e-18
C264	SET_B#5	VPWR#19	6.82539e-17
C265	a_1625_93##9	a_1625_93##2	1.46257e-17
C266	a_2037_442##15	a_2037_442##12	2.26983e-19
C267	VGND#7	a_622_98##7	3.84477e-19
C268	a_1625_93##13	Q_N#2	1.21955e-18
C269	VGND#8	a_1418_125##2	4.10691e-17
C270	a_1878_420##6	a_2037_442##2	2.01383e-18
C271	a_341_93##2	CLK#1	4.67234e-19
C272	a_622_98##14	a_622_98##5	1.5064e-18
C273	VPWR#11	a_27_464##2	2.09877e-17
C274	a_2271_74#	RESET_B#3	1.93913e-18
C275	VPWR#4	a_2037_442##5	2.71729e-20
C276	a_1878_420##6	a_622_98##6	3.48453e-17
C277	a_197_119##2	SCE#2	5.34266e-19
C278	a_1625_93##9	a_1092_96##2	6.7129e-18
C279	a_341_93##7	a_622_98##14	5.2395e-17
C280	a_341_93##2	SCE#1	5.08979e-17
C281	a_622_98##13	a_341_93##4	2.4291e-17
C282	a_2037_442##3	a_1986_504#	8.31662e-18
C283	a_1625_93##13	a_2037_442#	4.95541e-19
C284	a_197_119#	a_622_98##3	1.42357e-17
C285	CLK#3	VGND#18	2.23714e-17
C286	VPWR#3	VPWR#4	5.93725e-17
C287	a_877_98##5	a_2037_442##3	2.74559e-17
C288	a_1625_93##12	a_1625_93##4	1.85751e-18
C289	a_2271_74##2	a_2037_442##7	3.77965e-20
C290	a_622_98##6	SET_B#4	1.12552e-19
C291	SCE#8	SCD#2	4.57776e-18
C292	VGND#7	a_1625_93##3	4.64849e-18
C293	a_1878_420##5	SET_B#5	7.83242e-17
C294	a_877_98##5	a_1986_504#	6.86418e-19
C295	a_341_93##2	a_341_93#	2.35466e-18
C296	SCD#4	SCE#4	5.51173e-19
C297	a_27_464##2	SCE#3	4.07511e-19
C298	a_1092_96##6	a_877_98##2	1.20078e-18
C299	a_1625_93##15	a_1625_93##5	7.00271e-19
C300	a_1625_93##9	SET_B#2	1.4561e-18
C301	a_877_98##7	a_622_98##8	1.82892e-19
C302	a_1092_96##5	a_1250_231##3	1.63058e-17
C303	a_877_98##8	SCE#2	4.40193e-19
C304	VPWR#9	a_1092_96##2	8.54427e-20
C305	a_2037_442##15	RESET_B#3	5.24555e-19
C306	D#4	a_341_93##2	1.09766e-17
C307	a_197_119##4	a_197_119##6	3.02247e-18
C308	a_622_98##10	a_1878_420##6	1.01302e-20
C309	a_197_119##2	a_622_98##3	2.56716e-17
C310	a_1878_420##2	SET_B#5	9.82276e-17
C311	a_197_119##2	a_877_98##2	5.17346e-17
C312	VPWR#11	SCE#8	5.73772e-18
C313	VPWR#22	a_341_93##4	3.63855e-17
C314	a_1878_420##6	a_1250_231##6	3.50804e-18
C315	CLK#3	a_622_98##14	2.09371e-17
C316	a_1625_93##9	a_1250_231#	3.72964e-21
C317	a_622_98##11	a_2061_74#	1.02744e-17
C318	VPWR#8	a_1092_96##2	4.19446e-20
C319	a_1092_96##3	a_1625_93##3	2.99753e-17
C320	a_2271_74#	a_1625_93##4	3.92102e-17
C321	VGND#11	SCE	4.79868e-19
C322	VPWR#19	a_622_98##6	7.83091e-19
C323	SCE#4	D#2	3.65465e-17
C324	a_197_119#	a_622_98##2	7.96329e-18
C325	VGND#8	a_1092_96##3	4.633e-18
C326	a_1625_93##13	a_2271_74#	7.20858e-18
C327	a_1878_420##2	a_2037_442##2	4.61176e-18
C328	a_622_98##6	a_1766_379#	5.66617e-18
C329	VGND#7	a_1250_231##5	4.19018e-18
C330	VGND#10	a_1092_96##2	1.59061e-18
C331	a_622_98##6	a_877_98##5	3.24302e-17
C332	a_2271_74##2	RESET_B#3	7.58679e-20
C333	a_1250_231##6	a_1766_379#	1.32729e-17
C334	SET_B#5	a_2037_442##2	1.46582e-16
C335	VPWR#8	a_622_98##6	4.09921e-17
C336	a_1878_420##2	a_622_98##10	2.08229e-18
C337	a_1625_93##13	a_2037_442##15	3.167e-17
C338	a_341_93##7	CLK#3	1.46087e-18
C339	SCD#4	SCD#2	2.26555e-17
C340	SCE#4	D#4	8.59441e-18
C341	a_622_98##7	a_1878_420##6	4.28418e-17
C342	a_1878_420##5	a_2037_442##2	8.63642e-18
C343	a_1878_420##6	a_1625_93#	3.44894e-19
C344	a_2037_442##15	a_1625_93##4	3.87257e-17
C345	a_1625_93##9	a_877_98##4	1.57914e-18
C346	a_197_119##4	CLK#3	3.74718e-19
C347	a_197_119##2	a_622_98##4	1.02213e-17
C348	SET_B#5	a_622_98##10	1.89696e-18
C349	a_877_98##7	a_622_98##5	8.58218e-19
C350	a_2881_74##3	a_2881_74##4	1.01209e-18
C351	a_1092_96##5	a_622_98#	5.51689e-18
C352	a_622_98##14	SCE#2	6.64246e-18
C353	VPWR#19	a_1250_231##6	3.52207e-17
C354	a_1625_93##13	a_2271_74##2	1.00199e-17
C355	VPWR#6	a_622_98##6	9.94749e-19
C356	a_877_98##9	a_622_98##3	2.91492e-17
C357	a_622_98##4	a_877_98##8	3.15529e-17
C358	VGND#10	a_1250_231#	8.67009e-18
C359	a_1250_231##7	a_622_98##6	7.675e-19
C360	a_2271_74#	a_1878_420##3	6.25966e-19
C361	a_622_98##10	a_2037_442##2	3.19875e-18
C362	a_1625_93#	a_1580_379#	1.60629e-17
C363	a_622_98##7	SET_B#5	3.38537e-18
C364	VPWR#9	SET_B#2	4.71647e-17
C365	a_1625_93##9	a_1250_231##4	5.20303e-18
C366	a_2881_74##3	a_2037_442##8	3.40357e-17
C367	VPWR#11	a_877_98##2	3.13537e-18
C368	SCD#2	SCE#5	9.28492e-19
C369	a_1625_93##13	VGND#15	8.07255e-18
C370	SET_B#3	a_1092_96##3	9.04103e-18
C371	a_1092_96#	a_1580_379#	5.34203e-18
C372	VGND#8	a_1092_96##5	3.38913e-19
C373	a_1625_93##13	VPWR#6	4.85893e-18
C374	SCE#8	a_197_119##4	1.23877e-18
C375	a_27_464#	VPWR#22	3.6594e-17
C376	a_1250_231##6	a_622_98##6	3.92658e-17
C377	a_197_119##6	a_341_93##4	1.30862e-18
C378	SET_B#2	VPWR#8	4.16618e-17
C379	VPWR#7	a_877_98##4	6.34852e-20
C380	a_2271_74##2	a_1625_93##4	1.50098e-18
C381	a_1250_231##5	a_1878_420##6	2.1382e-18
C382	a_877_98##4	a_1880_119#	8.35921e-18
C383	VGND#10	a_877_98##2	3.86385e-18
C384	a_1250_231##5	SET_B#5	5.06094e-17
C385	VGND#8	SET_B#3	2.82343e-18
C386	a_341_93##7	SCE#2	3.50954e-17
C387	a_877_98##8	a_622_98##3	9.15458e-18
C388	a_1625_93##9	a_1625_93##3	3.98662e-20
C389	a_2037_442##11	a_2037_442##9	1.87333e-19
C390	VPWR#11	a_622_98##4	3.66805e-18
C391	a_1878_420##6	a_1092_96#	2.13231e-19
C392	a_2037_442##15	a_1625_93##5	5.49079e-18
C393	VGND#11	a_197_119##4	4.84215e-17
C394	VGND#6	a_622_98##11	4.45322e-18
C395	VPWR#19	a_1625_93#	3.14436e-17
C396	a_197_119##2	CLK#2	2.33231e-17
C397	a_622_98##7	a_622_98##10	3.03222e-18
C398	SCE#2	D#2	1.1506e-19
C399	SET_B#5	a_1625_93##2	2.67534e-19
C400	a_1878_420##3	a_2037_442##15	1.55856e-17
C401	SCD#2	D#2	2.8145e-19
C402	a_877_98##9	a_622_98##2	1.47976e-17
C403	VGND#10	a_622_98##4	7.06458e-18
C404	VPWR#8	a_1250_231##6	4.24377e-19
C405	a_1250_231##7	a_1250_231##6	1.32947e-19
C406	a_1625_93#	a_622_98##6	2.16248e-17
C407	VPWR#11	CLK#2	3.48367e-18
C408	a_622_98##10	a_1878_420##5	4.17159e-17
C409	a_197_119##4	SCE#2	6.79019e-17
C410	a_877_98##7	CLK#3	1.66005e-19
C411	CLK#2	a_877_98##8	2.20132e-18
C412	a_1250_231##5	VPWR#19	5.99854e-19
C413	a_1092_96##5	a_877_98#	3.23419e-19
C414	SCE#2	VGND#19	1.80629e-17
C415	VGND#6	a_877_98##4	4.47511e-18
C416	VGND#15	a_1625_93##4	1.55267e-20
C417	VGND#10	CLK#2	4.62747e-18
C418	CLK#2	VGND#18	1.92676e-18
C419	VPWR#11	a_341_93##2	1.15611e-17
C420	a_1250_231##5	a_622_98##7	6.99362e-17
C421	a_341_93##7	a_341_93##3	3.45894e-20
C422	a_1625_93#	a_1250_231##6	2.97305e-17
C423	a_1092_96#	a_622_98##6	1.91882e-17
C424	a_622_98#	a_1221_419#	8.36859e-18
C425	SET_B#2	SET_B#5	2.00348e-18
C426	a_2271_74##2	a_1878_420##3	5.10203e-17
C427	a_622_98##14	CLK#2	2.97187e-17
C428	VPWR#19	a_1092_96#	1.89609e-18
C429	VPWR#9	a_1250_231#	5.28076e-19
C430	VGND#10	a_341_93##2	3.09907e-18
C431	a_1250_231##2	SET_B#3	1.09736e-17
C432	a_877_98##3	a_1092_96##3	1.42402e-17
C433	VPWR#3	a_2037_442##5	1.4204e-18
C434	a_1250_231##7	a_1625_93#	5.72342e-18
C435	a_1625_93##9	VPWR#6	1.99258e-18
C436	VGND#10	SCD#4	5.29305e-18
C437	a_341_93##7	CLK#2	3.9517e-19
C438	a_2037_442##15	SET_B#6	2.12445e-19
C439	VGND#8	a_1250_231##2	3.64738e-18
C440	a_2037_442##11	RESET_B#1	1.17192e-17
C441	VPWR#19	a_1625_93##2	2.36815e-19
C442	a_27_464#	a_197_119##6	6.01594e-17
C443	a_1625_93##2	a_1250_231##5	8.30695e-17
C444	VGND#19	a_341_93##3	3.53238e-17
C445	VGND#8	a_1092_96##6	1.96153e-17
C446	a_197_119##4	a_341_93##3	2.5291e-17
C447	VGND#15	a_1878_420##3	1.84806e-20
C448	a_622_98##7	a_1878_420##5	6.22267e-17
C449	a_877_98##3	SET_B#3	1.68766e-17
C450	a_1625_93##13	a_2384_392#	1.09565e-18
C451	a_197_119##5	SCE#2	3.26904e-19
C452	a_1092_96##2	a_1250_231##5	3.38249e-18
C453	VPWR#8	a_1625_93#	9.74099e-19
C454	a_1878_420##6	a_877_98##4	2.31535e-19
C455	a_1878_420##5	a_2037_442#	8.66429e-18
C456	a_1092_96#	a_1625_93#	4.73557e-17
C457	VGND#9	a_197_119##2	9.10668e-17
C458	D#2	a_341_93##3	1.24187e-17
C459	a_341_93##2	a_622_98##14	2.63703e-18
C460	a_1625_93##2	a_1250_231##7	1.16883e-17
C461	a_2271_74##2	SET_B#6	3.70031e-17
C462	VPWR#21	a_622_98##2	9.30225e-19
C463	a_1250_231##7	a_1092_96#	6.13358e-17
C464	a_2037_442##8	a_2037_442##4	1.42112e-19
C465	VGND#9	a_877_98##3	1.0337e-18
C466	a_1092_96##2	a_1625_93##2	5.9342e-17
C467	a_1250_231##5	SET_B#2	1.79992e-17
C468	a_1625_93##7	a_2037_442##7	1.62888e-19
C469	a_877_98##2	VPWR#10	4.28211e-19
C470	a_197_119##4	D	5.05542e-17
C471	a_341_93##7	a_341_93##2	1.54638e-19
C472	a_877_98##3	a_1250_231##2	3.93318e-17
C473	a_197_119##5	VGND#19	1.68674e-17
C474	a_1625_93##9	a_1986_504#	3.31681e-18
C475	a_2037_442##15	a_2037_442#	1.45075e-19
C476	SET_B#2	a_1625_93##2	3.04374e-19
C477	VPWR#12	a_341_93##3	5.40169e-21
C478	a_1625_93##9	VGND#16	1.56612e-17
C479	VGND#19	D#3	3.69171e-18
C480	VPWR#9	a_877_98##2	7.13375e-19
C481	a_1625_93##7	RESET_B#3	1.24255e-18
C482	VGND#3	a_2881_74##2	3.06088e-18
C483	D#4	a_218_464#	2.56942e-18
C484	a_2037_442##11	a_1625_93##6	2.85493e-17
C485	SET_B#2	a_1092_96##2	8.91064e-17
C486	a_197_119##5	a_341_93##3	3.86033e-18
C487	SET_B#6	VGND#15	1.72572e-17
C488	VGND#8	a_877_98##3	5.16789e-17
C489	SCE#5	a_218_464#	7.99396e-18
C490	a_1625_93##9	a_1766_379#	6.12594e-18
C491	a_1092_96##2	a_1250_231##7	3.43031e-17
C492	a_1625_93##9	a_1418_125#	3.52839e-18
C493	a_1250_231##7	SET_B#1	1.42812e-17
C494	a_1625_93##7	a_1625_93##4	2.26383e-19
C495	a_197_119##4	D#3	1.83707e-19
C496	a_622_98##13	SCE#2	2.06503e-18
C497	VGND#3	VGND#4	5.41935e-17
C498	SET_B#1	a_1092_96#	2.56439e-17
C499	VPWR#23	a_27_464#	3.3492e-17
C500	VGND#8	a_197_119##2	8.32912e-19
C501	VGND#3	a_2037_442##5	4.55377e-18
C502	a_1250_231#	a_1092_96##2	6.22149e-17
C503	VGND#12	SCE#2	5.45832e-19
C504	a_1878_420##5	a_1250_231##5	2.4672e-19
C505	VGND#4	RESET_B	3.87477e-19
C506	SET_B#2	VPWR#19	4.74928e-17
C507	SCE#8	D	1.22008e-17
C508	a_2271_74##2	a_2037_442#	1.24257e-18
C509	a_2037_442##11	a_1625_93##5	6.47894e-18
C510	VGND#13	a_2881_74##3	2.2692e-18
C511	a_1625_93##9	a_1250_231##9	7.55841e-18
C512	VPWR#8	a_1092_96#	1.66554e-18
C513	a_1250_231##2	a_1192_96#	1.60326e-18
C514	a_1250_231#	SET_B#2	1.74675e-17
C515	SET_B#1	VPWR#20	2.96383e-17
C516	VGND#19	SCE#3	9.70436e-19
C517	a_877_98##3	a_1192_96#	8.718e-18
C518	a_1418_125#	VGND#16	9.07591e-18
C519	a_622_98##14	a_622_98##3	2.43902e-19
C520	VGND#9	a_622_98##8	1.7234e-17
C521	SET_B#2	a_877_98##2	2.86921e-21
C522	a_2881_74##5	VGND#13	5.55159e-17
C523	SCD#4	a_197_119##5	1.26916e-17
C524	SET_B#2	a_1250_231##7	1.90039e-16
C525	a_622_98##8	a_877_98##3	3.08487e-17
C526	a_877_98##7	a_622_98##9	8.86945e-19
C527	a_197_119##5	D#3	3.97049e-17
C528	a_622_98##4	VPWR#10	3.32239e-19
C529	a_2037_442#	VGND#15	2.06553e-17
C530	VGND#10	a_1250_231##2	4.3311e-18
C531	a_197_119##2	a_1092_96##5	1.75325e-17
C532	a_877_98##2	a_1250_231#	1.54441e-17
C533	Q_N#2	a_2881_74##3	2.78338e-17
C534	a_1625_93##13	VGND#5	4.78612e-18
C535	VPWR#3	a_2881_74#	5.59473e-18
C536	a_1250_231##3	SET_B#1	9.88654e-18
C537	VGND#8	a_1250_231#	2.94336e-18
C538	VGND#12	a_341_93##3	2.44081e-19
C539	SET_B#2	VPWR#20	8.81394e-17
C540	a_2037_442##11	a_1878_420#	1.12786e-17
C541	VPWR#11	VPWR#12	8.94246e-17
C542	a_197_119##4	SCE#3	1.14911e-18
C543	VGND#8	a_622_98##8	1.03146e-17
C544	VGND#10	a_877_98##3	1.33153e-17
C545	VPWR#20	a_1250_231##3	1.48781e-17
C546	VPWR#9	SET_B#1	1.16648e-18
C547	a_1878_420##2	SET_B#6	2.08555e-17
C548	a_1625_93##13	VGND#4	3.85753e-18
C549	VGND#12	VGND#19	2.17019e-18
C550	VPWR#3	a_2037_442##4	5.8054e-18
C551	a_1092_96##7	SET_B#1	6.05386e-19
C552	VGND#19	SCD#3	2.33358e-19
C553	a_622_98#	SET_B#1	6.3828e-19
C554	Q	a_2881_74##2	1.69161e-17
C555	a_27_464##2	a_197_119##6	3.30603e-17
C556	VPWR#11	VPWR#10	1.10344e-16
C557	a_1250_231##9	VGND#16	1.88077e-18
C558	Q	a_2037_442##5	6.33439e-19
C559	a_1878_420##5	a_877_98##4	2.93878e-17
C560	a_1092_96##7	SET_B#2	8.42625e-19
C561	VGND#10	a_622_98##8	2.57496e-17
C562	a_1250_231##7	a_877_98##4	6.72597e-19
C563	a_622_98##13	a_622_98##9	3.77429e-19
C564	a_197_119##5	SCE#3	2.63014e-17
C565	a_1878_420##2	a_2037_442#	1.72066e-17
C566	a_197_119##5	SCE	2.58931e-17
C567	SET_B#5	a_1986_504#	2.10539e-19
C568	VPWR#3	a_2037_442##9	3.24515e-18
C569	VGND#9	VGND#18	7.78822e-18
C570	a_2037_442##5	a_2881_74##2	3.5369e-19
C571	VGND#12	SCE	4.8634e-19
C572	VPWR#11	VPWR#9	1.01302e-16
C573	VGND#15	a_622_98##11	2.17067e-18
C574	a_197_119#	SET_B#1	4.86866e-19
C575	a_1625_93##9	VGND#7	4.86472e-18
C576	a_877_98##7	CLK#1	2.59055e-19
C577	VGND#12	D#3	1.511e-18
C578	VGND#3	a_2037_442##4	1.20469e-18
C579	a_622_98#	a_1250_231##3	3.84545e-17
C580	VGND#9	a_622_98##5	1.17251e-17
C581	a_197_119##5	a_27_464#	7.14212e-19
C582	a_622_98##5	a_622_98##8	1.33707e-17
C583	a_197_119##5	SCE#4	5.19953e-19
C584	VGND#10	a_622_98##5	9.47289e-18
C585	a_2037_442##6	Q_N#2	4.09108e-17
C586	CLK#2	a_622_98##4	5.53618e-17
C587	SET_B#5	a_1766_379#	1.48823e-17
C588	VPWR#20	a_622_98#	4.33125e-18
C589	VGND#9	a_877_98##2	2.31483e-19
C590	a_1625_93##13	a_1625_93##5	1.559e-18
C591	a_197_119##4	SCE#1	7.70089e-19
C592	VPWR#10	CLK#2	2.4337e-21
C593	a_1092_96##7	a_1250_231##3	4.95914e-18
C594	a_1625_93##9	VGND#5	2.67436e-19
C595	a_2037_442#	SET_B#5	3.75393e-18
C596	a_1878_420##2	a_877_98##4	2.515e-19
C597	VGND#10	CLK#3	3.19799e-18
C598	VGND#8	a_877_98##2	1.5856e-19
C599	VGND#14	a_2037_442##6	9.91065e-18
C600	a_2037_442##11	SET_B#4	2.70759e-19
C601	VGND#4	VGND#13	5.54828e-19
C602	a_877_98#	a_1250_231##3	5.11776e-19
C603	a_1092_96#	a_622_98##2	2.09699e-19
C604	SCE#3	D#2	4.02071e-18
C605	a_1250_231##9	a_1418_125#	5.90538e-17
C606	VGND#16	a_1418_125##2	3.10867e-20
C607	a_341_93##2	CLK#2	1.03491e-18
C608	a_197_119##5	SCD#3	5.10843e-18
C609	a_197_119##5	D	1.43443e-17
C610	a_197_119#	a_1250_231#	1.72641e-19
C611	a_197_119#	a_1250_231##3	5.61797e-19
C612	VGND#10	SCE#2	1.32077e-17
C613	VPWR#9	a_1250_231##3	3.59122e-18
C614	a_622_98##10	a_1625_93##4	9.38758e-20
C615	a_197_119##4	a_197_119##2	1.36727e-18
C616	a_622_98##13	CLK#1	2.08335e-17
C617	VGND#12	SCE#3	1.82224e-17
C618	VPWR#20	a_877_98#	7.65571e-19
C619	Q_N#2	a_2881_74##5	6.00601e-17
C620	a_877_98#	a_622_98#	2.45515e-17
C621	a_197_119##5	SCD#2	3.70442e-18
C622	SCD#4	VGND#12	3.71699e-17
C623	a_1250_231##5	a_1766_379#	1.57581e-19
C624	VGND#15	a_877_98##4	2.95246e-20
C625	a_27_464##2	VPWR#23	6.79778e-17
C626	a_877_98##9	a_1250_231#	1.3687e-20
C627	SCD#4	a_197_119##4	4.61708e-19
C628	RESET_B	Q_N#2	1.39423e-18
C629	a_1092_96##7	a_622_98#	2.6505e-17
C630	SET_B#5	a_877_98##4	3.77197e-18
C631	VGND#14	RESET_B	8.48273e-18
C632	a_622_98##10	a_1878_420##3	1.32094e-19
C633	VGND#10	a_341_93##3	4.53116e-18
C634	a_1625_93##12	RESET_B	8.67822e-18
C635	a_877_98##9	a_1250_231##3	3.18301e-20
C636	a_1092_96##7	a_877_98##2	2.13316e-18
C637	VGND#12	a_197_119##5	1.43372e-17
C638	VPWR#12	VPWR#10	2.70624e-19
C639	CLK#3	a_622_98##5	7.46468e-18
C640	a_622_98##11	a_1878_420##7	9.88507e-18
C641	SCE#8	D#2	4.00573e-18
C642	VGND#9	CLK#3	3.12104e-18
C643	SET_B#5	a_1250_231##4	5.13821e-20
C644	VGND#12	SCD#2	8.78024e-18
C645	a_622_98##10	SET_B#6	2.89382e-18
C646	a_341_93##2	VPWR#12	4.11883e-18
C647	a_197_119#	a_877_98##2	8.26379e-17
C648	VGND#10	D#3	5.72787e-18
C649	VGND#9	a_622_98##4	1.20667e-19
C650	a_197_119#	a_622_98#	4.02613e-18
C651	a_1625_93##8	a_1250_231##5	1.48222e-17
C652	a_1418_125##2	a_1418_125#	3.08968e-19
C653	SCE#8	a_197_119##6	1.45102e-17
C654	SCD#2	a_341_93##2	4.0839e-21
C655	a_877_98##4	a_2037_442##2	4.2607e-18
C656	a_622_98##10	a_2037_442#	4.32053e-17
C657	a_877_98##9	a_877_98##2	6.89444e-19
C658	VGND#12	SCD#3	3.11823e-17
C659	RESET_B#2	a_1625_93##12	3.92643e-18
C660	a_877_98#	a_1092_96##7	9.60253e-18
C661	VGND#10	SCE#3	1.29739e-17
C662	SET_B#2	a_1580_379#	1.1133e-17
C663	a_1092_96##5	a_622_98##3	8.91078e-20
C664	a_877_98##9	a_622_98#	1.03225e-19
C665	a_622_98##13	SCE#1	7.21285e-18
C666	a_622_98##10	a_622_98##11	2.19982e-17
C667	SCD#2	SCE#4	5.49341e-17
C668	a_1250_231##7	a_1878_420##6	1.45162e-18
C669	VGND#11	SCE#2	3.9614e-17
C670	a_341_93##3	a_299_119#	8.8457e-18
C671	a_622_98##2	SET_B#1	1.97997e-17
C672	a_1625_93##7	Q_N#2	1.02504e-18
C673	VGND#10	SCD#3	4.50291e-18
C674	D#3	a_299_119#	8.8457e-18
C675	a_877_98##4	a_1878_420##7	1.09579e-17
C676	a_197_119#	a_877_98#	5.26513e-17
C677	SET_B	a_2037_442##12	3.61992e-17
C678	SET_B	VPWR#18	1.51108e-19
C679	a_2881_74##7	VPWR#3	3.9945e-17
C680	a_622_98##10	a_877_98##4	4.88892e-17
C681	SCE#2	CLK#3	5.50087e-18
C682	a_622_98##4	a_877_98##9	4.75474e-17
C683	a_1250_231##9	a_1418_125##2	8.03821e-17
C684	a_1625_93##13	a_2037_442##11	6.43326e-18
C685	a_622_98##10	a_1250_231##4	1.32235e-18
C686	SCD	SCE#8	1.86051e-17
C687	D	a_27_464#	1.37858e-18
C688	a_622_98##7	a_622_98##11	4.25843e-19
C689	VGND#9	SCE#2	6.77283e-19
C690	a_1625_93##8	a_1625_93##2	6.7573e-18
C691	a_877_98##9	a_877_98#	2.77142e-18
C692	D	a_197_119##6	2.56251e-17
C693	a_197_119##2	a_877_98##7	4.09223e-18
C694	CLK#1	a_622_98##9	4.77736e-17
C695	Q_N#1	VPWR#3	2.8172e-17
C696	a_622_98##4	VPWR#21	1.65365e-17
C697	VGND#9	CLK#2	9.57487e-19
C698	a_1625_93##7	a_1625_93##12	6.37823e-20
C699	a_2037_442##11	a_1625_93##15	6.43388e-17
C700	VGND#14	Q_N#2	5.05019e-17
C701	a_622_98##7	a_877_98##4	4.97214e-17
C702	a_622_98##10	a_2061_74#	2.0972e-18
C703	VGND#10	VGND#17	1.08975e-17
C704	a_1092_96##5	a_622_98##2	1.97089e-18
C705	VPWR	a_622_98##2	8.3671e-18
C706	VGND#4	Q_N#2	2.13405e-17
C707	VPWR#10	a_877_98#	8.91232e-19
C708	a_1625_93##7	a_2271_74#	2.3726e-17
C709	a_1092_96##7	VPWR#9	6.7546e-18
C710	a_622_98##7	a_1250_231##4	3.10521e-17
C711	a_2037_442##5	a_2881_74#	9.45281e-19
C712	SCE#3	a_119_119#	9.7209e-18
C713	VGND#11	a_341_93##3	2.64109e-18
C714	a_2881_74##3	a_2881_74#	3.26083e-18
C715	a_877_98##9	a_622_98##9	5.11388e-17
C716	a_2037_442##15	a_1625_93##7	1.56606e-17
C717	SCD#3	a_119_119#	1.01349e-17
C718	VGND#16	a_877_98##4	2.75261e-18
C719	VGND#16	a_622_98##6	8.00651e-19
C720	VPWR#9	a_877_98#	2.58651e-18
C721	SCE#2	a_341_93##3	4.91329e-17
C722	a_622_98##7	a_1625_93##3	2.62735e-19
C723	VGND#3	Q_N#1	1.97552e-18
C724	SCE#1	CLK#1	7.37584e-18
C725	a_877_98##4	a_1250_231##5	1.00056e-17
C726	VGND#10	a_1092_96##6	2.24787e-17
C727	a_1625_93##9	a_877_98##5	4.5087e-21
C728	CLK#2	a_622_98##15	3.49033e-18
C729	a_2037_442##8	a_2881_74##4	2.07329e-17
C730	a_622_98##7	a_1880_119#	1.87911e-18
C731	a_2881_74##3	a_2037_442##4	2.72709e-17
C732	a_1250_231##3	a_622_98##2	9.57887e-18
C733	a_197_119#	VPWR#10	8.30343e-18
C734	a_1092_96##2	a_1625_93##8	1.62823e-17
C735	VPWR#7	a_2037_442##3	1.87446e-18
C736	a_622_98##9	VPWR#21	2.14324e-17
C737	VGND#11	a_341_93##2	9.87413e-20
C738	a_1250_231##5	a_1250_231##4	2.59567e-18
C739	Q	Q#3	3.81759e-18
C740	VGND#9	a_622_98##3	3.03211e-20
C741	SCE	SCE#3	5.66451e-19
C742	a_1625_93##12	Q_N#2	2.75268e-19
C743	VGND#13	Q	5.92934e-17
C744	VPWR#12	a_622_98##9	8.53364e-20
C745	a_2881_74#	Q#1	1.1681e-17
C746	a_2881_74##5	Q	2.81297e-18
C747	a_1625_93##13	a_1878_420##5	5.28325e-18
C748	VGND#10	a_197_119##2	7.99549e-17
C749	a_1625_93##9	a_622_98##6	5.86948e-19
C750	a_1092_96##5	a_1092_96##2	8.89509e-19
C751	a_1418_125#	a_877_98##4	1.61004e-17
C752	VGND#10	VGND#11	1.27385e-16
C753	a_1250_231##5	a_1625_93##3	3.06885e-18
C754	a_877_98##9	CLK#1	2.57569e-18
C755	a_2037_442##11	VPWR#17	4.11893e-17
C756	a_877_98##4	a_1625_93##2	8.21051e-19
C757	VPWR#7	a_877_98##5	4.11702e-18
C758	a_197_119##4	a_622_98##14	2.49887e-17
C759	a_622_98##15	a_622_98##9	1.70029e-18
C760	D	SCE#2	4.19374e-20
C761	VGND#4	VGND#14	4.09567e-19
C762	a_1250_231##7	a_877_98##3	3.97024e-19
C763	VGND#17	a_1418_125##2	1.93458e-17
C764	VPWR	VPWR#9	6.03801e-17
C765	D	a_341_93##3	1.91652e-18
C766	VGND#10	a_877_98##8	6.52152e-18
C767	a_1625_93##13	Q_N#1	3.35419e-19
C768	VPWR	VPWR#8	1.24266e-16
C769	a_341_93#	SCE#1	4.18426e-18
C770	VPWR	VPWR#6	1.25728e-16
C771	VPWR#10	a_622_98##9	6.25574e-18
C772	VGND#16	a_1250_231##4	4.60249e-17
C773	a_1878_420##2	a_2037_442##15	3.85336e-17
C774	a_1250_231##5	a_1092_96##3	8.31351e-19
C775	VPWR	VPWR#5	9.66741e-17
C776	VGND#4	a_2881_74##4	3.28757e-19
C777	VPWR	VPWR#4	2.89928e-17
C778	VGND#10	VGND#9	1.16383e-16
C779	D	SCE#3	1.51278e-19
C780	a_197_119##2	a_622_98##13	5.02877e-18
C781	a_2881_74#	VPWR#15	2.59535e-17
C782	a_197_119#	VPWR#9	7.85416e-19
C783	VPWR#7	a_622_98##6	2.87487e-18
C784	CLK#1	VPWR#21	2.96667e-17
C785	a_27_464#	D#2	2.74367e-19
C786	a_2037_442##6	a_2037_442##9	2.14504e-17
C787	D#3	a_341_93##3	5.13016e-17
C788	SCE#3	SCE#2	3.35128e-19
C789	VGND#11	D#3	4.28017e-18
C790	VGND#13	VPWR#15	7.56896e-18
C791	a_1250_231##5	SET_B#3	2.49396e-19
C792	a_1250_231##9	a_877_98##4	1.96263e-18
C793	SCE#8	a_27_464##2	3.63516e-17
C794	a_2271_74##2	a_1878_420##2	3.44763e-17
C795	a_1092_96##2	a_622_98##2	1.36833e-18
C796	a_877_98##4	a_1092_96##2	5.70636e-19
C797	VGND#10	VGND#8	9.0578e-17
C798	a_1092_96##5	VPWR#20	2.464e-17
C799	a_2037_442##5	a_2037_442##4	1.80254e-18
C800	a_341_93##2	VPWR#22	3.67476e-17
C801	VGND#11	D#2	9.00583e-19
C802	VPWR#20	a_877_98##3	9.83113e-19
C803	a_1625_93##12	VGND#14	3.01239e-17
C804	a_2037_442##6	RESET_B#1	1.88404e-17
C805	VPWR	a_2037_442##11	1.55021e-17
C806	a_622_98##15	CLK#1	6.16588e-17
C807	a_1418_125#	a_1250_231##4	9.2572e-19
C808	a_2881_74##7	a_2881_74#	2.4181e-18
C809	a_2037_442##7	a_2037_442##8	2.67595e-18
C810	VGND#15	a_1878_420##2	2.7312e-17
C811	VGND#10	a_622_98##14	7.19418e-18
C812	VPWR	a_1878_420##5	2.82191e-18
C813	a_1092_96##2	a_1250_231##4	3.50374e-19
C814	Q	Q#1	5.77798e-18
C815	VPWR#22	a_622_98##9	6.46113e-20
C816	a_877_98##9	VPWR#10	2.66906e-17
C817	a_27_464#	a_341_93##2	7.69374e-18
C818	VPWR#15	Q	7.39059e-17
C819	a_1625_93##9	a_1878_420##5	4.44518e-17
C820	a_2881_74##7	Q	6.15937e-18
C821	a_1092_96##5	SET_B#2	4.2422e-17
C822	D#4	a_341_93#	3.06784e-17
C823	a_2037_442##6	a_1625_93##6	2.18663e-19
C824	VPWR#21	SCE#1	5.66311e-19
C825	VPWR#12	CLK#1	4.43838e-19
C826	a_1418_125##2	a_877_98##4	1.00656e-18
C827	a_2037_442##4	VPWR#15	2.8756e-17
C828	a_197_119##4	a_341_93##7	9.18442e-17
C829	a_1092_96##2	a_1625_93##3	2.75418e-18
C830	VGND#16	a_1625_93##3	1.6301e-18
C831	a_2037_442##6	VPWR#4	1.13876e-18
C832	a_197_119##6	a_341_93##2	5.24689e-17
C833	VGND#10	a_341_93##7	7.95325e-18
C834	VPWR	a_1092_96##5	1.64353e-18
C835	a_341_93##4	CLK#1	1.35595e-18
C836	SET_B#2	a_877_98##4	4.44592e-19
C837	SCD	a_197_119##6	2.52484e-18
C838	a_1625_93##13	VPWR#17	4.34915e-18
C839	VGND#11	a_197_119##5	8.85327e-18
C840	SET_B	a_1878_420#	4.43153e-19
C841	Q_N#1	a_2881_74#	2.68004e-19
C842	VGND#4	a_1625_93##12	8.29719e-18
C843	SET_B	SET_B#4	7.07039e-18
C844	SCD	a_27_464##2	4.79353e-17
C845	a_1092_96##2	a_1092_96##3	6.47687e-18
C846	a_1250_231##9	a_1250_231##4	4.93612e-19
C847	a_622_98##15	SCE#1	1.40061e-18
C848	VGND#4	a_2037_442##8	6.65155e-19
C849	SET_B	a_877_98##5	5.78798e-20
C850	SCE#3	D#3	4.43311e-17
C851	VPWR#10	CLK#1	5.47103e-18
C852	VPWR#12	VPWR#21	3.40823e-19
C853	VPWR#22	CLK#1	2.00012e-19
C854	VGND#5	a_2271_74#	1.23906e-17
C855	a_2881_74##7	a_2037_442##4	9.10532e-17
C856	a_1092_96##2	SET_B#3	1.82473e-17
C857	VGND	VGND#8	7.46937e-17
C858	a_2271_74#	VGND#14	6.08804e-18
C859	a_1250_231##9	a_1250_231##7	3.82196e-18
C860	VGND	VGND#7	1.14958e-16
C861	VGND	VGND#5	1.12929e-16
C862	a_1418_125#	a_1625_93##3	1.3641e-17
C863	VGND	VGND#4	7.31648e-17
C864	VGND#11	SCE#3	2.27493e-17
C865	VGND#5	a_1878_420##5	7.67185e-19
C866	VGND#15	SET_B#5	9.87972e-19
C867	VPWR#21	a_341_93#	1.844e-19
C868	SCE#5	D#4	3.58124e-17
C869	SCD#4	a_341_93##3	4.48137e-20
C870	VPWR#16	a_2881_74#	1.34331e-19
C871	a_341_93##4	SCE#1	5.76185e-17
C872	a_197_119##6	D#2	1.08531e-17
C873	a_1092_96##2	a_1250_231##2	5.33523e-19
C874	VPWR#15	a_2037_442##9	5.09971e-19
C875	a_1625_93##13	a_2037_442##12	7.34106e-18
C876	VGND	a_1878_420##5	2.39564e-18
C877	a_1418_125##2	a_1250_231##4	7.7053e-20
C878	VGND#16	a_1092_96##3	3.18979e-19
C879	Q	a_2881_74##4	2.8113e-17
C880	a_1092_96##5	a_1250_231#	7.91012e-17
C881	SET_B#2	a_622_98##2	1.47952e-17
C882	RESET_B#3	a_2037_442##7	2.39699e-17
C883	Q	a_2037_442##8	2.59821e-18
C884	Q_N#1	a_2037_442##4	1.42981e-18
C885	VGND#11	SCE#4	1.87433e-19
C886	VGND#10	a_197_119##5	1.58614e-17
C887	a_877_98##3	a_1092_96##2	2.54857e-18
C888	a_197_119##4	VGND#19	8.37637e-17
C889	VGND	a_1625_93##8	3.17868e-18
C890	a_2037_442##9	a_2037_442##5	1.64669e-17
C891	a_622_98##3	a_877_98#	2.05509e-17
C892	a_1625_93##8	a_877_98##4	3.575e-19
C893	SCE#1	VPWR#22	1.80491e-17
C894	VGND#10	SCE	8.30662e-18
C895	a_1250_231#	a_1625_93##3	2.49086e-19
C896	a_1250_231##9	a_1625_93##3	3.01073e-17
C897	VGND#8	a_622_98#	2.71686e-19
C898	a_1625_93##13	VPWR#18	9.32712e-20
C899	VPWR#9	VPWR#8	2.35996e-19
C900	VPWR#12	SCE#1	6.69756e-18
C901	VPWR#4	RESET_B#2	1.94998e-19
C902	a_2881_74##7	a_2037_442##9	2.45621e-18
C903	a_197_119##6	SCE#4	1.89066e-18
C904	VPWR#11	D	2.55172e-18
C905	SCD#3	SCE#3	4.00152e-17
C906	a_1250_231#	a_1092_96##3	4.45111e-19
C907	SCD#1	SCE#5	2.26198e-17
C908	a_341_93##4	a_341_93#	4.11646e-19
C909	VGND#4	a_2271_74#	3.01976e-17
C910	VGND#10	D	1.94396e-18
C911	a_2271_74#	a_1625_93##12	3.32237e-17
C912	a_1418_125#	a_1092_96##3	4.39109e-19
C913	VPWR#16	a_2037_442##4	5.86654e-19
C914	VPWR	a_1625_93##15	5.21541e-18
C915	a_197_119##5	D#2	1.63048e-17
C916	a_622_98##2	a_877_98#	2.05443e-17
C917	a_27_464#	SCE#1	1.06239e-18
C918	VGND#4	a_2037_442##7	1.15139e-17
C919	a_1625_93##4	a_2037_442##7	7.8282e-19
C920	SCE#8	D#4	1.30289e-18
C921	VPWR	a_2037_442##12	2.16139e-17
C922	a_877_98##3	SET_B#2	9.15392e-19
C923	SCD#4	D#3	6.28015e-19
C924	VGND	a_1625_93##12	1.43181e-17
C925	a_1092_96##6	VGND#17	5.62635e-18
C926	VPWR#10	SCE#1	3.37727e-19
C927	a_1250_231#	SET_B#3	2.26977e-17
C928	VGND	a_2271_74#	1.69259e-17
C929	VGND#10	VGND#12	8.6808e-17
C930	VGND	a_2037_442##15	4.84145e-18
C931	VPWR	a_1878_420##6	1.3101e-17
C932	VGND	a_2271_74##2	2.91798e-17
C933	a_2881_74##7	VPWR#15	8.13455e-17
C934	a_1418_125##2	a_1625_93##3	7.80722e-19
C935	VGND	a_1878_420##7	2.98759e-18
C936	Q_N#1	a_2037_442##9	2.25845e-17
C937	VPWR#23	SCE#4	5.35036e-19
C938	VPWR	a_1250_231##7	1.11252e-17
C939	VGND#16	SET_B#3	1.63203e-19
C940	VPWR#11	a_1250_231##3	3.82608e-18
C941	VPWR#22	a_341_93#	8.83254e-19
C942	SET_B#5	a_1625_93##6	7.74219e-21
C943	VGND	a_1418_125#	2.21477e-17
C944	a_1625_93##13	RESET_B	3.74541e-18
C945	VGND	a_1250_231##9	1.64429e-17
C946	a_197_119##4	D#2	1.04344e-17
C947	VGND	a_1418_125##2	2.30062e-17
C948	Q	a_2881_74#	3.93152e-17
C949	VPWR#4	VPWR#15	6.70699e-19
C950	a_622_98##10	a_2037_442##15	1.89306e-18
C951	VGND	VGND#17	4.58305e-18
C952	a_1250_231#	a_1250_231##2	1.24322e-17
C953	Q	a_2037_442##4	5.09225e-18
C954	a_197_119##6	SCE#1	4.32479e-19
C955	a_877_98##7	a_1250_231#	2.22811e-21
C956	a_197_119#	a_622_98##8	9.48451e-19
C957	VPWR#11	a_622_98##2	2.85147e-17
C958	a_1092_96##5	a_877_98##2	5.50043e-18
C959	a_27_464##2	SCE#4	1.91461e-18
C960	VGND#13	a_2881_74##2	3.45376e-18
C961	a_197_119##6	SCD#2	6.48048e-19
C962	a_1250_231##9	a_1092_96##3	2.65414e-17
C963	a_341_93##4	D#4	1.18737e-19
C964	VGND#6	a_1878_420##5	3.13002e-19
C965	SET_B#5	a_1878_420#	7.61388e-18
C966	SET_B#5	SET_B	1.84839e-18
C967	a_877_98##3	a_1250_231#	1.54054e-17
C968	a_27_464#	a_341_93#	5.60585e-17
C969	a_1625_93##4	RESET_B#3	4.03265e-18
C970	a_1625_93##8	a_1250_231##4	5.2198e-20
C971	VPWR#5	a_1625_93##7	3.19729e-19
C972	a_2037_442##2	SET_B	2.47248e-17
C973	RESET_B	a_2037_442##6	1.57615e-17
C974	a_1092_96##5	VPWR#9	1.25693e-18
C975	VPWR#16	a_2037_442##9	5.38006e-17
C976	VPWR#4	a_2881_74#	1.92254e-19
C977	RESET_B	RESET_B#2	6.50299e-18
C978	VGND	a_1625_93##15	1.87507e-18
C979	a_622_98##14	a_622_98##13	2.30843e-18
C980	a_2881_74##2	VNB	3.05608e-17
C981	a_2037_442##5	VNB	6.29911e-17
C982	a_1625_93##5	VNB	1.97415e-17
C983	a_622_98##3	VNB	9.62118e-17
C984	a_1625_93##7	RESET_B	2.05955e-17
C985	a_622_98##2	VNB	2.02824e-16
C986	a_622_98##15	VPWR#10	5.22785e-18
C987	D#2	VNB	5.50654e-17
C988	a_1418_125#	SET_B#3	1.67454e-19
C989	VGND#4	a_2037_442##5	2.79824e-20
C990	a_2037_442##15	a_1625_93##12	2.55622e-18
C991	SET_B#5	SET_B#4	3.07062e-18
C992	a_622_98##10	VGND#15	3.30812e-17
C993	a_1250_231#	a_622_98##2	4.2126e-19
C994	VPWR#11	a_877_98#	4.99734e-18
C995	VPWR	a_1250_231##4	5.61932e-20
C996	VGND	a_1250_231##7	6.26535e-18
C997	VPWR#12	a_341_93#	5.38815e-18
C998	SCE	SCE#4	1.2455e-17
C999	Q_N#1	RESET_B#1	1.19187e-18
C1000	SCD#4	SCE#3	3.46679e-18
C1001	a_341_93#	a_197_119##6	1.30936e-17
C1002	a_2037_442##2	a_1878_420#	3.51615e-19
C1003	a_1418_125##2	a_1092_96##3	2.57304e-17
C1004	VGND#12	VGND#11	1.00552e-18
C1005	SCD#2	SCE	1.47628e-17
C1006	a_1625_93##9	a_1878_420##6	2.2936e-18
C1007	a_622_98##9	a_622_98##3	3.15597e-17
C1008	D	a_341_93##2	2.79592e-18
C1009	a_1092_96##7	VPWR#20	2.13566e-17
C1010	a_27_464##2	SCD#2	4.49744e-18
C1011	a_197_119#	a_1092_96##5	5.01941e-17
C1012	SET_B#5	a_2037_442##3	1.67835e-17
C1013	VPWR#23	SCE#1	5.26159e-20
C1014	VPWR#11	SCD	5.55771e-18
C1015	VGND#4	RESET_B#3	1.89104e-18
C1016	a_1625_93##15	a_2037_442##9	1.6591e-18
C1017	D	SCE#4	2.04057e-18
C1018	VPWR#11	a_622_98##9	4.02194e-18
C1019	a_877_98##7	a_622_98##3	2.87603e-17
C1020	VPWR#12	VNB	4.06278e-17
C1021	VPWR#3	Q	2.13399e-17
C1022	VPWR#10	VNB	4.77109e-17
C1023	SCD#2	D	2.4563e-18
C1024	VPWR#9	VNB	5.32372e-17
C1025	VPWR#8	VNB	4.18523e-17
C1026	a_27_464#	D#4	2.02833e-17
C1027	VGND#4	a_2037_442##6	6.84359e-19
C1028	Q_N#2	Q_N#1	4.01942e-18
C1029	VPWR#6	VNB	4.90329e-17
C1030	VGND#3	Q	2.13399e-17
C1031	VPWR#5	VNB	4.30794e-17
C1032	a_2037_442##2	SET_B#4	1.84243e-17
C1033	VGND#5	a_2271_74##2	5.20781e-17
C1034	VPWR#4	VNB	3.7985e-17
C1035	VGND	RESET_B#3	3.70424e-18
C1036	VGND	a_1625_93##4	3.52172e-19
C1037	VPWR#10	a_341_93#	4.25923e-20
C1038	a_1250_231##9	SET_B#3	9.90916e-18
C1039	VGND#11	VNB	4.71562e-17
C1040	VGND#9	VNB	5.75696e-17
C1041	a_341_93##4	VPWR#12	3.42609e-18
C1042	VGND#8	VNB	6.89244e-17
C1043	a_622_98##8	a_877_98##2	1.07769e-17
C1044	VPWR	RESET_B#1	6.02493e-18
C1045	VGND#7	VNB	4.45596e-17
C1046	VGND#5	VNB	5.53455e-17
C1047	a_877_98##7	a_877_98##2	1.29724e-19
C1048	VGND#4	VNB	6.42905e-17
C1049	VPWR	a_1625_93##6	2.83678e-19
C1050	SET_B#5	a_877_98##5	1.93446e-17
C1051	VPWR	a_1878_420#	1.15023e-19
C1052	a_622_98##10	a_1878_420##7	7.54009e-17
C1053	VGND	a_877_98##4	7.9975e-18
C1054	RESET_B#1	VPWR#16	1.01472e-17
C1055	VPWR	SET_B#4	8.4325e-19
C1056	a_622_98##9	a_622_98##2	1.25664e-17
C1057	VGND	a_1250_231##4	1.20101e-18
C1058	VPWR	a_2037_442##3	2.13735e-18
C1059	a_2037_442##11	VNB	3.60186e-18
C1060	a_1878_420##5	VNB	8.15415e-18
C1061	VGND	SET_B#3	4.23768e-18
C1062	VPWR#15	a_2881_74##3	3.37936e-18
C1063	a_1625_93##5	RESET_B#1	8.97484e-19
C1064	VPWR	a_622_98##6	1.34584e-17
C1065	VPWR#11	CLK#1	9.68776e-19
C1066	a_2881_74##3	Q	2.61643e-17
C1067	VPWR	a_1250_231##6	2.23063e-18
C1068	VPWR#6	a_1878_420##2	9.09794e-20
C1069	VGND	a_877_98##3	9.83313e-18
C1070	a_197_119##5	a_197_119##4	1.93221e-18
C1071	a_2037_442##2	a_2037_442##3	1.92303e-18
C1072	VPWR	a_1625_93#	1.96437e-18
C1073	VGND#7	VGND#15	2.04785e-20
C1074	VGND#10	a_622_98##3	5.54619e-19
C1075	VGND#17	a_1092_96##3	3.07906e-19
C1076	a_1625_93##8	VNB	1.43708e-18
C1077	VPWR#17	a_2037_442##9	2.97674e-18
C1078	a_197_119##6	D#4	3.01706e-17
C1079	a_1092_96##5	VNB	1.24212e-17
C1080	a_1250_231##7	a_1580_379#	1.74919e-19
C1081	a_197_119##4	VNB	2.32956e-17
C1082	a_1625_93##8	a_1625_93##3	3.07836e-18
C1083	Q_N#1	a_2881_74##7	8.92216e-17
C1084	a_877_98##7	VNB	4.28003e-19
C1085	SET_B#5	a_622_98##6	3.97122e-17
C1086	VPWR#16	VPWR#15	6.61433e-19
C1087	a_622_98##13	VNB	9.76519e-18
C1088	VGND#5	a_1625_93##4	2.07249e-18
C1089	a_1625_93##9	VPWR#19	4.01861e-18
C1090	a_2271_74#	a_2037_442##15	5.97094e-17
C1091	Q_N#1	a_1625_93##6	5.42746e-19
C1092	a_197_119#	VPWR#20	4.12733e-18
C1093	VPWR#23	a_341_93#	2.44837e-19
C1094	a_1878_420##3	a_1625_93##4	2.26907e-17
C1095	SCD#4	VNB	1.41165e-17
C1096	VPWR#11	SCE#1	7.54752e-19
C1097	a_877_98##5	a_2037_442##2	1.92346e-17
C1098	VGND#13	VNB	6.14825e-18
C1099	a_2881_74##5	VNB	3.43742e-18
C1100	Q_N#2	VNB	1.32856e-17
C1101	SET_B#3	a_1418_125##2	2.02713e-17
C1102	VGND#14	VNB	1.50988e-18
C1103	a_1625_93##12	VNB	1.15124e-17
C1104	VPWR#4	a_2037_442##4	7.39289e-19
C1105	a_2271_74#	VNB	4.82076e-18
C1106	a_27_464#	SCE#5	6.39858e-18
C1107	a_1625_93##15	RESET_B#1	3.00027e-17
C1108	a_2037_442##15	VNB	2.07906e-20
C1109	a_2271_74##2	VNB	4.18033e-18
C1110	VGND#15	VNB	5.71071e-18
C1111	a_1878_420##7	VNB	2.2454e-19
C1112	VGND#16	a_622_98##10	5.2797e-18
C1113	SET_B#5	a_1250_231##6	2.14802e-17
C1114	VGND#16	VNB	2.27592e-18
C1115	VPWR#15	a_2881_74##2	2.42322e-18
C1116	a_1418_125#	VNB	7.05098e-18
C1117	a_1418_125##2	VNB	8.79534e-18
C1118	VGND#17	VNB	9.43385e-18
C1119	SCD	SCE#4	5.25569e-18
C1120	a_1092_96##6	VNB	3.3747e-18
C1121	VPWR	VPWR#7	4.88949e-17
C1122	a_197_119##2	VNB	1.62946e-17
C1123	SCD	SCD#2	2.96864e-17
C1124	a_1625_93##9	a_1625_93##8	1.64543e-17
C1125	a_622_98##14	VNB	8.70278e-18
C1126	a_341_93##7	VNB	9.1721e-18
C1127	VGND#19	VNB	1.87468e-18
C1128	a_622_98##3	a_877_98##2	3.50917e-17
C1129	a_2881_74##3	a_2881_74##2	5.05157e-18
C1130	a_197_119##5	VNB	6.42045e-18
C1131	Q_N#1	a_2881_74##3	4.5348e-17
C1132	VGND#12	VNB	7.38684e-17
C1133	SCD#4	D#2	3.46868e-19
C1134	VPWR#11	a_341_93#	1.6143e-18
C1135	VPWR#15	VNB	4.97294e-18
C1136	a_2881_74##7	VNB	1.02011e-17
C1137	VPWR	a_2037_442##6	1.57818e-18
C1138	VPWR#12	D#4	1.77218e-19
C1139	Q_N#1	VNB	1.89836e-17
C1140	VPWR#16	a_1625_93##6	2.20718e-18
C1141	VPWR#16	VNB	1.06454e-17
C1142	VPWR	RESET_B#2	3.06111e-18
C1143	a_1625_93##15	VNB	6.542e-18
C1144	VGND#10	D#2	1.28971e-20
C1145	VPWR#17	VNB	8.9582e-18
C1146	a_877_98##7	a_622_98##2	1.54633e-19
C1147	a_2037_442##12	VNB	2.25825e-18
C1148	VPWR	a_1878_420##2	3.75023e-18
C1149	SET_B#5	a_1625_93#	4.15398e-19
C1150	a_197_119##6	SCE#5	2.96413e-18
C1151	VPWR	SET_B#5	5.50672e-17
C1152	VPWR#19	VNB	3.14791e-18
C1153	a_622_98##7	a_1878_420##7	4.67112e-17
C1154	VGND#4	a_1625_93##4	4.03772e-18
C1155	VPWR	a_2037_442##2	6.44732e-18
C1156	a_1250_231##7	VNB	5.80216e-18
C1157	VPWR#20	VNB	9.52807e-18
C1158	VGND	a_1625_93##13	5.77082e-17
C1159	a_1092_96##7	VNB	5.08115e-19
C1160	a_877_98##2	a_622_98##2	1.82795e-18
C1161	a_197_119#	VNB	7.17025e-18
C1162	VGND	a_1625_93##9	5.61618e-17
C1163	VPWR	a_622_98##7	5.38149e-18
C1164	VPWR#17	RESET_B#1	2.11265e-18
C1165	VPWR#21	VNB	3.82352e-18
C1166	VPWR#23	D#4	1.55127e-18
C1167	a_622_98##15	VNB	1.03415e-17
C1168	VPWR	a_1250_231##5	5.55228e-18
C1169	a_622_98##4	a_877_98##7	3.79705e-17
C1170	a_341_93##4	VNB	1.70702e-17
C1171	VGND	VGND#6	4.74761e-17
C1172	a_1625_93##9	a_1092_96##5	5.32262e-19
C1173	VPWR#22	VNB	5.71099e-18
C1174	VPWR	a_1625_93##2	3.50538e-18
C1175	a_27_464#	VNB	1.33763e-17
C1176	SET_B#3	VGND#17	1.30697e-17
C1177	VGND#4	RESET_B#2	3.70141e-19
C1178	a_197_119##6	VNB	1.41872e-18
C1179	a_2881_74##3	a_2037_442##5	3.53001e-17
C1180	a_877_98##9	VPWR#20	2.27842e-18
C1181	VPWR	a_1092_96##2	3.22446e-18
C1182	VPWR#16	a_2881_74##7	4.12915e-18
C1183	VPWR#23	VNB	1.29782e-18
C1184	a_27_464##2	VNB	4.78358e-17
C1185	VPWR	SET_B#2	4.07187e-17
C1186	a_2881_74##4	VNB	3.30352e-17
C1187	a_2037_442##8	VNB	4.38546e-17
C1188	VPWR#11	D#4	1.33766e-18
C1189	SET_B#5	VPWR#8	4.27069e-17
C1190	Q_N#1	a_1878_420#	3.55711e-19
C1191	a_2037_442##7	VNB	3.04643e-17
C1192	RESET_B#3	VNB	2.19314e-17
C1193	VGND	RESET_B#2	1.05444e-18
C1194	a_1625_93##4	VNB	3.26555e-17
C1195	a_1878_420##3	VNB	2.73526e-17
C1196	VGND	a_1625_93##7	2.81569e-18
C1197	SET_B#6	VNB	3.22152e-17
C1198	SET_B#5	a_1092_96#	1.59559e-19
C1199	a_2037_442#	VNB	5.52535e-17
C1200	VGND	a_1878_420##2	5.66978e-18
C1201	a_622_98##11	VNB	2.37459e-17
C1202	a_877_98##4	VNB	1.93286e-16
C1203	a_1250_231##4	VNB	3.20785e-17
C1204	a_2881_74##4	Q#3	7.71782e-18
C1205	a_2037_442##12	a_2037_442##9	3.29399e-19
C1206	a_1625_93##3	VNB	1.90867e-17
C1207	a_197_119##2	a_1092_96##6	8.40527e-17
C1208	a_1092_96##3	VNB	2.09272e-17
C1209	SET_B#3	VNB	2.42663e-17
C1210	VGND	a_622_98##10	4.64887e-17
C1211	a_1250_231##2	VNB	1.90081e-17
C1212	a_2271_74##2	a_2271_74#	2.26125e-18
C1213	a_877_98##3	VNB	1.4634e-16
C1214	VGND	a_622_98##7	1.54893e-19
C1215	a_622_98##8	VNB	8.36989e-17
C1216	a_2037_442##5	a_2881_74##4	1.57155e-19
C1217	CLK#2	a_622_98##5	2.22893e-18
C1218	a_622_98##5	VNB	3.03373e-17
C1219	VGND	a_1250_231##5	8.27022e-18
C1220	a_1625_93##15	a_1625_93##6	3.53178e-18
C1221	CLK#3	VNB	3.1157e-17
C1222	SCE#2	VNB	1.37368e-16
C1223	VGND	a_1625_93##2	4.29252e-20
C1224	a_341_93##3	VNB	4.24932e-17
C1225	a_1092_96##6	a_1092_96##3	2.47866e-19
C1226	D#3	VNB	1.88348e-17
C1227	VGND	a_1092_96##2	1.03098e-17
C1228	SCE#3	VNB	9.48193e-17
C1229	a_1625_93##8	a_1092_96##3	6.11168e-19
C1230	SCD#3	VNB	2.48183e-17
C1231	VGND	SET_B#2	2.27108e-18
C1232	a_1418_125##2	a_1250_231##2	3.09638e-19
C1233	VPWR	a_2384_392#	9.48026e-20
C1234	a_622_98##7	a_877_98##5	9.42706e-18
C1235	a_2881_74#	VNB	4.69063e-17
C1236	VGND	a_1250_231#	3.06022e-18
C1237	Q_N#1	VPWR#4	9.71476e-18
C1238	a_2037_442##4	VNB	5.91893e-17
C1239	a_2037_442##9	VNB	3.77543e-17
C1240	VPWR	a_1986_504#	2.89295e-18
C1241	a_27_464##2	D#4	5.99584e-18
C1242	RESET_B#1	VNB	3.11453e-17
C1243	SET_B#5	VPWR#6	4.27822e-17
C1244	a_1625_93##6	VNB	3.68174e-17
C1245	a_1878_420#	VNB	3.31969e-17
C1246	a_2037_442##4	a_2881_74#	3.57784e-17
C1247	SET_B#4	VNB	3.76632e-17
C1248	VPWR#11	SCE#5	5.90664e-19
C1249	a_2037_442##3	VNB	2.70201e-17
C1250	a_877_98##5	VNB	4.60958e-17
C1251	a_622_98##6	VNB	1.15692e-16
C1252	VGND#16	a_622_98##7	5.26598e-17
C1253	a_1250_231##6	VNB	2.83474e-17
C1254	a_1625_93#	VNB	2.92345e-17
C1255	a_622_98##13	a_622_98##4	2.08115e-18
C1256	a_2881_74##5	a_2037_442##5	4.75658e-18
C1257	a_1092_96#	VNB	3.06114e-17
C1258	SET_B#1	VNB	3.11905e-17
C1259	CLK#2	CLK#3	4.34237e-18
C1260	VGND#5	a_1878_420##3	4.8896e-18
C1261	a_1250_231##3	VNB	2.98889e-17
C1262	SCE	D	2.13406e-17
C1263	a_622_98#	VNB	3.21057e-17
C1264	a_2037_442##6	Q_N#1	9.03163e-17
C1265	a_877_98#	VNB	2.592e-17
C1266	a_197_119##6	SCD#1	5.92356e-19
C1267	a_622_98##9	VNB	3.73889e-17
C1268	CLK#1	VNB	4.24433e-17
C1269	SCE#1	VNB	6.11448e-17
C1270	a_341_93#	VNB	2.94473e-17
C1271	D#4	VNB	3.04968e-17
C1272	SCE#5	VNB	2.13508e-17
C1273	SCD#1	VNB	3.34377e-17
C1274	SET_B#6	a_1878_420##3	3.79089e-17
C1275	VPWR#3	VNB	1.67713e-16
C1276	VGND#3	VNB	1.65247e-16
C1277	VPWR#23	SCE#5	3.28102e-17
C1278	a_1625_93##13	VNB	1.94286e-18
C1279	a_1625_93##9	VNB	2.08239e-18
C1280	a_1250_231##9	a_877_98##3	1.37661e-18
C1281	VPWR#7	VNB	2.91843e-17
C1282	VGND#6	VNB	2.83474e-17
C1283	VPWR#11	VNB	3.309e-16
C1284	VGND#10	VNB	3.47767e-16
C1285	a_2881_74##3	VNB	3.3441e-17
C1286	a_2037_442##6	VNB	2.62182e-17
C1287	a_197_119#	a_1092_96##7	6.052e-17
C1288	SCE#2	CLK#2	1.13651e-17
C1289	VPWR#4	a_2037_442##9	2.81077e-18
C1290	RESET_B#2	VNB	2.86645e-17
C1291	a_1625_93##7	VNB	3.66559e-17
C1292	VPWR#17	a_1625_93##6	5.05076e-17
C1293	a_1878_420##2	VNB	3.77043e-17
C1294	VPWR#11	SCD#1	5.83692e-19
C1295	SET_B#5	VNB	5.65602e-17
C1296	a_2037_442##2	VNB	7.52362e-17
C1297	a_622_98##10	VNB	3.98321e-17
C1298	SCD	SCE	9.34961e-18
C1299	a_622_98##7	VNB	2.90566e-17
C1300	a_1250_231##5	VNB	5.34091e-17
C1301	a_1625_93##2	VNB	2.74825e-17
C1302	a_2881_74##4	VGND#13	2.46062e-17
C1303	VPWR#16	Q_N#1	3.36155e-17
C1304	a_1092_96##2	VNB	3.97318e-17
C1305	a_2037_442##6	VPWR#16	3.9587e-17
C1306	SET_B#2	VNB	6.74708e-17
C1307	a_1250_231#	VNB	4.32718e-17
C1308	a_877_98##2	VNB	5.99135e-17
C1309	a_622_98##4	VNB	2.46863e-17
C1310	CLK#2	VNB	4.47504e-17
C1311	a_341_93##2	VNB	9.33887e-17
C1312	a_1250_231##2	VGND#17	1.71663e-17
C1313	a_1250_231##6	a_622_98##7	8.78052e-18
C1314	SCE#4	VNB	4.92693e-17
C1315	SCD#2	VNB	1.12288e-16
C1316	a_2037_442##12	RESET_B#1	5.92044e-19
C1317	a_27_464##2	SCE#5	1.48592e-17
C1318	CLK#2	a_877_98##7	2.18513e-18
C1319	VPWR	SET_B	3.56076e-18
C1320	VPWR#12	SCE#5	2.42177e-20
C1321	Q_N#2	a_2881_74##2	1.10197e-19
C1322	a_1250_231##5	a_622_98##6	1.43414e-18
C1323	VGND#7	SET_B#6	1.37924e-20
C1324	VGND#4	a_1878_420##3	6.20716e-20
C1325	VGND	RESET_B	4.13338e-18
C1326	a_1625_93##15	a_2037_442##6	1.3213e-17
C1327	a_2271_74##2	a_2037_442##15	4.86793e-17
C1328	a_1092_96##6	SET_B#3	7.84379e-19
C1329	SCE	VNB	1.12709e-18
C1330	a_1418_125##2	a_877_98##3	1.30707e-17
C1331	D	VNB	3.49749e-18
C1332	a_622_98##4	a_622_98##3	1.31165e-17
C1333	VGND#4	a_1625_93##7	1.6724e-18
C1334	SET_B	VNB	2.53889e-20
C1335	RESET_B	VNB	1.71899e-18
C1336	a_341_93##2	SCE#2	2.35754e-17
C1337	SCD	VNB	1.84959e-17
C1338	Q	VNB	1.13659e-16
C1339	SCD#1	VPWR#23	2.02847e-17
C1340	VPWR	VNB	2.47484e-16
C1341	VGND	VNB	2.30246e-16
C1342	a_1250_231##5	VGND#16	4.35114e-17
C1343	a_1250_231##5	a_1250_231##6	1.00552e-17
C1344	VPWR#11	VPWR#13	1.07753e-16
C1345	VPWR#13	SCD#1	2.51746e-18
C1346	Q	VPWR#2	2.13182e-17
C1347	VPWR#4	VPWR#2	3.30128e-19
C1348	a_27_464#	VPWR#13	4.50538e-17
C1349	VGND#4	VGND#2	2.76519e-19
C1350	VPWR#13	D#2	2.4147e-20
C1351	VGND#2	a_2881_74##3	6.51567e-19
C1352	VPWR#2	VNB	4.0979e-17
C1353	VGND#2	Q	2.13939e-17
C1354	VPWR#13	SCE#5	9.47898e-19
C1355	VGND#2	a_2881_74##4	5.07635e-18
C1356	a_2881_74##3	VPWR#2	4.87561e-19
C1357	VGND#2	a_2037_442##8	2.97506e-18
C1358	VGND#3	VGND#2	6.91678e-17
C1359	a_27_464##2	VPWR#13	2.14151e-17
C1360	VPWR#2	a_2037_442##4	2.63164e-18
C1361	VPWR#13	VNB	6.37851e-17
C1362	VPWR#13	SCD#2	2.16634e-19
C1363	VGND#2	VNB	4.24767e-17
C1364	VPWR#13	D#4	4.41398e-18
C1365	VPWR#3	VPWR#2	7.99403e-17
C1366	VPWR#2	a_2881_74#	7.49512e-18
C1367	VPWR#13	VPWR#12	2.98709e-19
*
*
.ENDS sky130_fd_sc_hs__sdfbbp_1
*
