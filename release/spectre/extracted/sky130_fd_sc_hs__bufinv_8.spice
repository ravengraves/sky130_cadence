* Extracted by Quantus, converted by sky130cad/quantus.py
*
*
*
*                       LINUX           Wed Nov 18 08:21:36 2026
*
*
*
*  PROGRAM  advgen
*
*  Name           : advgen - Quantus - (64-bit)
*  Version        : 25.1.0-p047
*  Build Date     : Thu Dec 11 23:20:30 PST 2025
*
*  HSPICE LIBRARY
*
*  OPERATING_TEMPERATURE 150
*  QRC_TECH_DIR <path>/tech
*
*
*

*
.SUBCKT sky130_fd_sc_hs__bufinv_8 VPB VNB VGND VPWR Y A
*
*
*  caps2d version: 10
*
*
*       TRANSISTOR CARDS
*
*
XM14 a_27_368##13 A#1 VGND#15 VNB sky130_fd_pr__nfet_01v8_lvt l=0.15 w=0.74 ad=0.2109 as=0.2442 pd=2.05 ps=2.14
XM3 VGND#15 a_183_48##12 Y#4 VNB sky130_fd_pr__nfet_01v8_lvt l=0.15 w=0.74 ad=0.2442 as=0.222 pd=2.14 ps=2.08
XM4 VGND#14 a_183_48##24 Y#4 VNB sky130_fd_pr__nfet_01v8_lvt l=0.15 w=0.74 ad=0.259 as=0.222 pd=2.18 ps=2.08
XM23 VGND#14 a_183_48##22 Y#7 VNB sky130_fd_pr__nfet_01v8_lvt l=0.15 w=0.74 ad=0.259 as=0.2072 pd=2.18 ps=2.04
XM6 Y#7 a_183_48##20 VGND#13 VNB sky130_fd_pr__nfet_01v8_lvt l=0.15 w=0.74 ad=0.2072 as=0.259 pd=2.04 ps=2.18
XM8 Y#6 a_183_48##18 VGND#13 VNB sky130_fd_pr__nfet_01v8_lvt l=0.15 w=0.74 ad=0.2072 as=0.259 pd=2.04 ps=2.18
XM20 Y#6 a_183_48##16 VGND#12 VNB sky130_fd_pr__nfet_01v8_lvt l=0.15 w=0.74 ad=0.2072 as=0.259 pd=2.04 ps=2.18
XM15 Y#1 a_183_48##14 VGND#12 VNB sky130_fd_pr__nfet_01v8_lvt l=0.15 w=0.74 ad=0.259 as=0.259 pd=2.18 ps=2.18
XM11 VGND#11 a_183_48# Y#1 VNB sky130_fd_pr__nfet_01v8_lvt l=0.15 w=0.74 ad=0.259 as=0.259 pd=2.18 ps=2.18
XM16 VGND#11 a_27_368##7 a_183_48##34 VNB sky130_fd_pr__nfet_01v8_lvt l=0.15 w=0.74 ad=0.259 as=0.2183 pd=2.18 ps=2.07
XM17 VGND#10 a_27_368##5 a_183_48##34 VNB sky130_fd_pr__nfet_01v8_lvt l=0.15 w=0.74 ad=0.259 as=0.2183 pd=2.18 ps=2.07
XM21 a_183_48##33 a_27_368# VGND#10 VNB sky130_fd_pr__nfet_01v8_lvt l=0.15 w=0.74 ad=0.2109 as=0.259 pd=2.05 ps=2.18
XM0 a_27_368##12 A#3 VPWR#15 VPB sky130_fd_pr__pfet_01v8 l=0.15 w=1.12 ad=0.3304 as=0.392 pd=2.83 ps=2.94
XM19 Y#8 a_183_48##26 VPWR#15 VPB sky130_fd_pr__pfet_01v8 l=0.15 w=1.12 ad=0.336 as=0.392 pd=2.84 ps=2.94
XM1 Y#8 a_183_48##25 VPWR#14 VPB sky130_fd_pr__pfet_01v8 l=0.15 w=1.12 ad=0.336 as=0.336 pd=2.84 ps=2.84
XM7 VPWR#14 a_183_48##23 Y#10 VPB sky130_fd_pr__pfet_01v8 l=0.15 w=1.12 ad=0.336 as=0.336 pd=2.84 ps=2.84
XM12 VPWR#13 a_183_48##21 Y#10 VPB sky130_fd_pr__pfet_01v8 l=0.15 w=1.12 ad=0.336 as=0.336 pd=2.84 ps=2.84
XM13 VPWR#13 a_183_48##19 Y#12 VPB sky130_fd_pr__pfet_01v8 l=0.15 w=1.12 ad=0.336 as=0.336 pd=2.84 ps=2.84
XM22 Y#12 a_183_48##17 VPWR#12 VPB sky130_fd_pr__pfet_01v8 l=0.15 w=1.12 ad=0.336 as=0.336 pd=2.84 ps=2.84
XM18 Y#14 a_183_48##15 VPWR#12 VPB sky130_fd_pr__pfet_01v8 l=0.15 w=1.12 ad=0.4816 as=0.336 pd=3.1 ps=2.84
XM10 VPWR#11 a_183_48##13 Y#14 VPB sky130_fd_pr__pfet_01v8 l=0.15 w=1.12 ad=0.392 as=0.4816 pd=2.94 ps=3.1
XM2 VPWR#11 a_27_368##9 a_183_48##32 VPB sky130_fd_pr__pfet_01v8 l=0.15 w=1.12 ad=0.392 as=0.336 pd=2.94 ps=2.84
XM5 a_183_48##32 a_27_368##8 VPWR#10 VPB sky130_fd_pr__pfet_01v8 l=0.15 w=1.12 ad=0.336 as=0.392 pd=2.84 ps=2.94
XM9 VPWR#10 a_27_368##4 a_183_48##27 VPB sky130_fd_pr__pfet_01v8 l=0.15 w=1.12 ad=0.392 as=0.3304 pd=2.94 ps=2.83
*
*
*       RESISTOR AND CAP/DIODE CARDS
*
Rg1	A#1	A#2	377.957367
Rg2	A#2	A#3	430.056854
Rg3	a_183_48#	a_183_48##2	368.862610
Rg4	a_183_48##2	a_183_48##3	69.416878
Rg5	a_183_48##3	a_183_48##4	20.231285
Rg6	a_183_48##4	a_183_48##5	74.955566
Rg7	a_183_48##5	a_183_48##6	42.956833
Rg8	a_183_48##6	a_183_48##7	31.466652
Rg9	a_183_48##7	a_183_48##8	78.855904
Rg10	a_183_48##8	a_183_48##9	73.191963
Rg11	a_183_48##9	a_183_48##10	78.251884
Rg12	a_183_48##10	a_183_48##11	62.699757
Rg13	a_183_48##11	a_183_48##12	368.862610
Rg14	a_183_48##2	a_183_48##13	471.862823
Rg15	a_183_48##3	a_183_48##14	379.087921
Rg16	a_183_48##4	a_183_48##15	441.762421
Rg17	a_183_48##5	a_183_48##16	414.365143
Rg18	a_183_48##5	a_183_48##17	457.404785
Rg19	a_183_48##7	a_183_48##18	434.948303
Rg20	a_183_48##7	a_183_48##19	477.987946
Rg21	a_183_48##8	a_183_48##20	397.730652
Rg22	a_183_48##8	a_183_48##21	440.770294
Rg23	a_183_48##9	a_183_48##22	407.645752
Rg24	a_183_48##9	a_183_48##23	450.685394
Rg25	a_183_48##10	a_183_48##24	397.730652
Rg26	a_183_48##10	a_183_48##25	440.770294
Rg27	a_183_48##11	a_183_48##26	471.862823
Rg28	a_27_368#	a_27_368##2	434.623047
Rg29	a_27_368##2	a_27_368##3	67.018333
Rg30	a_27_368##2	a_27_368##4	517.262939
Rg31	a_27_368##3	a_27_368##5	353.032867
Rg32	a_27_368##3	a_27_368##6	73.354103
Rg33	a_27_368##6	a_27_368##7	386.599152
Rg34	a_27_368##3	a_27_368##8	400.472290
Rg35	a_27_368##6	a_27_368##9	477.059937
Rf1	A#4	A#2	162.448425
Rf2	A	A#6	2.215620
Rf3	A#4	A#6	4.635897
Rf4	Y#1	Y#2	83.984344
Rf5	Y#2	Y#3	48.341530
Rf6	Y#3	Y	46.986458
Rf7	Y	Y#5	7.374206
Rf8	Y#2	Y#6	13.032116
Rf9	Y#3	Y#7	19.086887
Rf10	Y	Y#9	12.972709
Rf11	Y#9	Y#11	43.317123
Rf12	Y#11	Y#13	42.837627
Rf13	Y#13	Y#14	60.931454
Rf14	Y#5	Y	7.282945
Rf15	Y#4	Y#5	7.500000
Rf16	Y#8	Y#9	15.000000
Rf17	Y#10	Y#11	15.000000
Rf18	Y#12	Y#13	15.000000
Rf19	a_27_368##3	a_27_368##11	426.236420
Rf20	a_27_368##11	a_27_368##12	33.549011
Rf21	a_27_368##11	a_27_368##13	140.454071
Rf22	a_183_48##27	a_183_48##28	12.966060
Rf23	a_183_48##28	a_183_48##29	48.092796
Rf24	a_183_48##29	a_183_48##30	41.886597
Rf25	a_183_48##30	a_183_48##6	123.641060
Rf26	a_183_48##28	a_183_48##32	75.327507
Rf27	a_183_48##29	a_183_48##33	17.838894
Rf28	a_183_48##30	a_183_48##34	18.130169
Rf30	VPWR#2	VPWR#3	73.001427
Rf31	VPWR#3	VPWR#4	75.192947
Rf32	VPWR#4	VPWR#5	26.273645
Rf33	VPWR#5	VPWR#6	39.422733
Rf34	VPWR#6	VPWR#7	65.696381
Rf35	VPWR#7	VPWR#8	65.696381
Rf37	VPWR#2	VPWR#10	38.641060
Rf38	VPWR#3	VPWR#11	34.704330
Rf39	VPWR#4	VPWR#12	34.704330
Rf40	VPWR#6	VPWR#13	34.704330
Rf41	VPWR#7	VPWR#14	34.704330
Rf42	VPWR#8	VPWR#15	34.704330
Rf44	VGND#2	VGND#3	63.870117
Rf45	VGND#3	VGND#4	73.001427
Rf46	VGND#4	VGND#5	33.943947
Rf47	VGND#5	VGND#6	39.057484
Rf48	VGND#6	VGND#7	62.774361
Rf49	VGND#7	VGND#8	73.001427
Rf51	VGND#2	VGND#10	33.129639
Rf52	VGND#3	VGND#11	33.129639
Rf53	VGND#4	VGND#12	36.279022
Rf54	VGND#6	VGND#13	33.129639
Rf55	VGND#7	VGND#14	34.113823
Rf56	VGND#8	VGND#15	35.098007
Re1	VPWR#5	VPWR	0.755546
Re2	VGND	VGND#5	0.755573
*
*       CAPACITOR CARDS
*
*
C1	Y#1	a_183_48##34	3.65052e-18
C2	Y#2	a_183_48##8	4.23933e-19
C3	Y#12	a_183_48##4	5.95138e-19
C4	VPWR#13	a_183_48##8	3.20769e-19
C5	Y#1	VGND#11	3.4189e-17
C6	Y#2	a_183_48##7	7.52657e-18
C7	VPWR#13	a_183_48##7	1.23832e-19
C8	VGND#12	VGND#11	1.97291e-18
C9	a_183_48##4	a_183_48##2	3.21472e-18
C10	Y#1	VGND#12	5.31645e-17
C11	Y#10	a_183_48##9	4.80889e-18
C12	Y#2	a_183_48##4	2.07742e-18
C13	Y#10	a_183_48##8	5.12995e-18
C14	VGND#4	a_183_48##4	5.89493e-20
C15	VPWR#14	a_183_48##10	2.53631e-19
C16	A#4	a_183_48##11	2.05644e-18
C17	a_27_368##11	Y#12	3.39873e-17
C18	a_27_368##13	A#4	4.82477e-17
C19	VPWR#7	VPWR#6	9.53643e-19
C20	VPWR#14	a_183_48##9	1.90969e-19
C21	VGND#13	VGND#12	1.94088e-18
C22	VGND#4	a_27_368##7	1.2617e-19
C23	VGND#3	a_27_368##7	9.59264e-19
C24	a_27_368##11	VPWR#13	4.43082e-17
C25	VGND#4	a_183_48##2	2.88851e-20
C26	Y#8	a_183_48##11	7.06064e-18
C27	VGND#4	a_183_48#	4.89724e-19
C28	Y#8	a_183_48##10	1.18797e-17
C29	a_27_368##11	Y#10	7.37817e-17
C30	VGND#3	a_183_48#	4.75482e-18
C31	Y#8	a_183_48##9	7.82005e-19
C32	VPWR#6	VPWR#4	9.53643e-19
C33	Y#7	VGND#13	3.32474e-17
C34	VGND#3	a_183_48##30	2.80471e-19
C35	VGND#4	a_183_48##14	4.54433e-18
C36	Y#8	a_183_48##8	1.98513e-19
C37	a_27_368##11	VPWR#14	4.42924e-17
C38	VGND#3	a_183_48##2	6.42547e-20
C39	VGND#10	a_27_368##2	2.89025e-19
C40	VGND#14	VGND#13	3.32188e-18
C41	Y#8	a_183_48##7	2.00906e-19
C42	a_27_368##11	Y#8	1.1665e-16
C43	VGND#14	Y#7	3.32325e-17
C44	VGND#4	a_183_48##16	3.40497e-18
C45	VPWR#4	VPWR#3	4.84321e-19
C46	VPWR#7	a_183_48##11	1.09703e-20
C47	VGND#6	a_183_48##18	2.07772e-18
C48	a_27_368##11	VPWR#15	5.48503e-17
C49	VGND#4	a_183_48##18	4.07818e-19
C50	a_183_48##30	a_27_368#	8.66466e-20
C51	VGND#7	a_183_48##20	3.5794e-19
C52	a_183_48##29	a_27_368#	4.22198e-17
C53	VPWR#7	a_183_48##10	1.12234e-19
C54	a_27_368##12	a_27_368##11	1.31574e-17
C55	VGND#6	a_183_48##20	9.59264e-19
C56	VGND#15	VGND#14	2.31327e-18
C57	a_183_48##30	a_27_368##5	2.0847e-17
C58	VGND#4	a_183_48##20	1.2617e-19
C59	VGND#7	a_183_48##22	3.7325e-18
C60	a_183_48##29	a_27_368##5	2.11013e-18
C61	VPWR#7	a_183_48##9	1.2658e-19
C62	a_183_48##30	a_27_368##7	1.65258e-17
C63	a_183_48##26	a_183_48##10	1.39165e-18
C64	a_183_48##29	a_27_368##7	3.30813e-19
C65	VGND#7	a_183_48##24	4.41594e-18
C66	a_27_368##13	VGND#15	7.51482e-17
C67	a_183_48##30	a_183_48#	3.18269e-18
C68	VPWR#6	a_183_48##9	1.09703e-20
C69	VPWR#3	a_27_368##6	2.05092e-20
C70	VGND#7	a_183_48##12	2.75411e-19
C71	a_183_48##30	a_183_48##14	3.59042e-20
C72	A#6	a_27_368##12	3.33411e-17
C73	VPWR#6	a_183_48##8	1.12234e-19
C74	a_183_48##30	a_183_48##16	2.0387e-20
C75	VGND#7	A#1	1.08921e-19
C76	VGND#7	Y#3	2.80471e-19
C77	a_27_368##11	VPWR#7	3.30381e-18
C78	VPWR#6	a_183_48##7	1.27756e-21
C79	a_183_48##30	a_183_48##18	1.41471e-20
C80	VGND#6	Y#3	2.80471e-19
C81	a_27_368##11	VPWR#6	2.35717e-18
C82	a_183_48##32	VPWR#10	5.72207e-17
C83	a_27_368#	a_183_48##33	7.72968e-18
C84	VGND#6	Y#2	6.14561e-19
C85	a_27_368#	VGND#10	2.21444e-17
C86	VPWR#11	VPWR#10	1.18789e-18
C87	Y#2	a_183_48#	2.01975e-19
C88	a_183_48##34	a_27_368#	1.08573e-18
C89	VPWR#11	a_183_48##32	3.7601e-17
C90	VGND#4	Y#2	2.76648e-19
C91	VGND#10	a_27_368##5	3.3341e-17
C92	Y#2	a_183_48##14	1.2258e-18
C93	a_27_368##5	a_183_48##34	1.63851e-17
C94	VPWR#5	a_183_48##7	3.35635e-19
C95	VGND#10	a_27_368##7	2.07509e-18
C96	VGND#11	a_27_368##5	1.58149e-18
C97	Y#2	a_183_48##16	4.2677e-17
C98	a_27_368##7	a_183_48##34	1.91688e-17
C99	Y#1	a_27_368##5	2.96435e-19
C100	Y#1	a_183_48##4	2.69529e-18
C101	VPWR#12	VPWR#11	1.23683e-17
C102	VGND#11	a_27_368##7	3.70846e-17
C103	VPWR#4	a_183_48##4	2.37335e-19
C104	Y#2	a_183_48##18	4.10807e-17
C105	a_183_48##34	a_183_48#	5.80971e-19
C106	VGND#12	a_183_48##7	1.92036e-19
C107	VGND#5	a_183_48##11	5.34301e-21
C108	Y#1	a_27_368##7	3.01471e-18
C109	a_183_48##2	a_27_368##7	3.33835e-19
C110	VGND#5	a_183_48##10	3.15831e-21
C111	Y#3	a_183_48##20	2.04526e-17
C112	a_183_48#	VGND#11	1.55383e-17
C113	VGND#12	a_27_368##7	1.58735e-19
C114	Y#2	a_183_48##20	1.36648e-18
C115	VGND#5	a_183_48##7	9.43189e-20
C116	VPWR#3	a_27_368##4	1.28473e-19
C117	Y#1	a_183_48#	4.83409e-17
C118	Y#1	a_183_48##2	2.99394e-18
C119	a_183_48##30	a_183_48##29	2.19756e-18
C120	Y#3	a_183_48##22	2.03834e-17
C121	VGND#11	a_183_48##14	6.93239e-19
C122	VGND#12	a_183_48#	1.10266e-18
C123	Y#12	VPWR#12	5.99111e-19
C124	Y#2	a_183_48##22	2.91772e-19
C125	VGND#12	a_183_48##4	1.0096e-18
C126	Y#1	a_183_48##14	3.12628e-17
C127	VPWR#3	a_183_48##4	6.58217e-20
C128	VPWR#3	a_27_368##8	3.20942e-19
C129	a_27_368##3	a_27_368##6	7.65965e-18
C130	a_27_368##13	a_27_368##12	4.07762e-19
C131	VPWR#13	VPWR#12	1.4729e-17
C132	a_27_368##3	a_27_368##2	1.11034e-17
C133	VGND#12	a_183_48##14	3.63349e-17
C134	Y#1	a_183_48##16	4.24687e-19
C135	Y#12	VPWR#13	2.57737e-19
C136	a_27_368##3	a_183_48##7	6.79606e-19
C137	VPWR#3	a_27_368##9	6.45923e-18
C138	a_183_48##16	VGND#12	1.71352e-17
C139	a_183_48##29	a_183_48##28	1.79918e-18
C140	VGND#13	a_183_48##14	2.84905e-19
C141	a_183_48##28	a_27_368##4	4.18588e-17
C142	a_27_368##3	a_183_48##4	1.12613e-18
C143	a_183_48##16	Y#6	1.49295e-17
C144	a_27_368##3	a_183_48##2	9.58964e-19
C145	VGND#13	a_183_48##8	4.87656e-19
C146	VPWR#4	a_183_48##13	3.74135e-19
C147	VGND#12	a_183_48##18	3.49779e-19
C148	Y#10	VPWR#13	2.469e-19
C149	VGND#13	a_183_48##16	7.57597e-19
C150	VPWR#3	a_183_48##2	1.67086e-19
C151	VPWR#3	a_183_48##13	6.95339e-18
C152	a_183_48##18	Y#6	1.49295e-17
C153	a_183_48##28	a_27_368##8	1.32428e-18
C154	VGND#13	a_183_48##7	7.43785e-19
C155	a_183_48##30	a_27_368##6	1.64008e-17
C156	VPWR#14	VPWR#13	1.4729e-17
C157	VGND#12	a_183_48##20	1.58735e-19
C158	a_183_48##11	a_183_48##10	3.36838e-18
C159	a_183_48##6	a_183_48##10	6.79208e-18
C160	a_183_48##18	VGND#13	2.00924e-17
C161	a_183_48##6	a_183_48##9	1.71881e-17
C162	VPWR#4	a_183_48##15	6.96741e-18
C163	a_183_48##6	a_183_48##8	1.79909e-17
C164	Y#7	a_183_48##18	5.63613e-19
C165	a_183_48##6	a_183_48##7	3.31729e-17
C166	VPWR#3	a_183_48##15	3.74135e-19
C167	a_183_48##28	a_27_368##9	7.01329e-20
C168	a_183_48##30	a_27_368##2	2.38278e-19
C169	a_183_48##6	a_183_48##4	2.05289e-17
C170	VGND#13	a_183_48##20	3.33556e-17
C171	VPWR#6	a_183_48##17	3.76886e-19
C172	a_183_48##6	a_183_48##2	1.99425e-17
C173	VGND#3	a_183_48##34	6.12417e-18
C174	a_183_48##20	Y#7	1.57477e-17
C175	VPWR#4	a_183_48##17	2.93918e-18
C176	VGND#4	VGND#11	4.93192e-20
C177	VGND#13	a_183_48##22	1.6129e-18
C178	Y#8	VPWR#14	6.10141e-19
C179	a_183_48##28	a_183_48##13	4.14764e-20
C180	VGND#14	a_183_48##20	1.25496e-18
C181	VGND#14	a_183_48##10	5.37177e-19
C182	a_183_48##22	Y#7	1.84378e-17
C183	a_183_48##29	a_27_368##6	8.8979e-20
C184	A#2	a_183_48##11	2.00675e-17
C185	VPWR#6	a_183_48##19	6.9299e-18
C186	VPWR#15	VPWR#14	1.4729e-17
C187	VPWR#4	a_183_48##19	3.76886e-19
C188	VGND#14	a_183_48##22	3.45309e-17
C189	VGND#14	a_183_48##9	7.10643e-19
C190	Y#7	a_183_48##24	5.63613e-19
C191	VGND#4	Y#1	9.44242e-18
C192	VPWR#7	a_183_48##21	3.76886e-19
C193	a_183_48##29	a_27_368##2	1.71051e-17
C194	a_183_48##24	VGND#14	1.83582e-17
C195	VPWR#6	a_183_48##21	6.90862e-18
C196	VGND#15	a_183_48##22	1.89458e-19
C197	a_183_48##11	Y#4	2.56833e-19
C198	a_183_48##24	Y#4	1.56766e-17
C199	VGND#3	Y#1	8.43095e-18
C200	a_27_368##12	VPWR#15	3.64793e-17
C201	VGND#14	a_183_48##12	4.56527e-19
C202	VGND#15	a_183_48##24	7.62719e-19
C203	VPWR#7	a_183_48##23	6.9299e-18
C204	a_183_48##10	Y#4	1.51817e-19
C205	a_183_48##12	Y#4	1.56766e-17
C206	VPWR#6	a_183_48##23	3.76886e-19
C207	a_183_48##10	a_183_48##9	5.77378e-18
C208	VGND#14	A#1	3.11864e-19
C209	a_183_48##12	VGND#15	1.60232e-17
C210	VGND#7	VGND#13	6.10825e-20
C211	a_27_368##11	a_183_48##19	1.64933e-17
C212	a_27_368##13	a_183_48##12	5.46543e-18
C213	VPWR#7	a_183_48##25	6.74791e-18
C214	a_183_48##28	a_27_368##2	3.8811e-18
C215	VGND#15	A#1	3.38115e-17
C216	a_27_368##13	A#1	3.1922e-17
C217	a_27_368##5	a_27_368#	2.82476e-17
C218	a_27_368##11	a_183_48##21	1.6689e-17
C219	a_183_48##30	a_183_48##7	1.23336e-19
C220	VGND#7	Y#7	5.7411e-18
C221	VPWR#7	a_183_48##26	3.76886e-19
C222	VGND#13	VGND#4	1.56943e-19
C223	VGND#6	Y#7	5.69171e-18
C224	a_27_368##11	a_183_48##23	1.67409e-17
C225	a_27_368##7	a_27_368##5	3.76048e-17
C226	a_27_368##4	a_183_48##27	5.0609e-18
C227	VPWR#10	a_27_368##4	3.97752e-17
C228	a_27_368##13	a_183_48##11	4.32657e-18
C229	a_27_368##11	a_183_48##25	1.71298e-17
C230	a_183_48#	a_27_368##7	2.87519e-17
C231	a_183_48##30	a_183_48##4	1.49601e-19
C232	a_183_48##32	a_27_368##4	2.04263e-18
C233	a_27_368##11	a_183_48##11	7.13279e-18
C234	a_27_368##8	VPWR#10	2.48968e-17
C235	VPWR#11	a_27_368##4	2.8853e-19
C236	a_183_48##9	a_183_48##8	6.13118e-18
C237	a_183_48##14	a_183_48#	2.68556e-17
C238	a_27_368##11	a_183_48##26	2.56824e-17
C239	a_183_48##32	a_27_368##8	6.34319e-17
C240	VPWR#10	a_27_368##9	3.79606e-19
C241	VPWR#11	a_27_368##8	4.37944e-19
C242	A#6	a_27_368##11	1.74734e-17
C243	VGND#5	VGND#7	3.74924e-17
C244	a_27_368##11	a_183_48##10	4.98528e-19
C245	a_183_48##32	a_27_368##9	4.79439e-17
C246	VGND#5	VGND#6	2.97235e-17
C247	VPWR#5	VPWR#7	3.60713e-17
C248	a_183_48##16	a_183_48##14	2.38217e-17
C249	VGND#5	VGND#4	3.11361e-17
C250	a_27_368##11	A#3	6.86031e-18
C251	a_27_368##9	VPWR#11	2.39058e-17
C252	VPWR#10	a_183_48##13	9.59962e-20
C253	VPWR#5	VPWR#6	3.0454e-17
C254	VGND#5	VGND#3	3.77951e-17
C255	a_183_48##30	a_183_48##2	3.57144e-19
C256	VPWR#5	VPWR#4	2.94509e-17
C257	a_183_48##32	a_183_48##13	3.43462e-18
C258	Y#14	a_27_368##9	5.05012e-19
C259	VPWR#5	VPWR#3	4.06856e-17
C260	a_27_368##11	a_183_48##9	4.67863e-19
C261	VPWR#11	a_183_48##13	3.38531e-17
C262	a_183_48##29	a_183_48##33	3.85735e-18
C263	A#6	a_183_48##26	2.1322e-19
C264	a_183_48##18	a_183_48##16	3.73861e-17
C265	Y#14	a_183_48##13	4.38578e-17
C266	a_183_48##32	a_183_48##15	8.68419e-19
C267	a_183_48##30	VGND#10	1.41922e-17
C268	VPWR#12	a_183_48##13	3.08999e-18
C269	VPWR#11	a_183_48##15	3.08999e-18
C270	a_183_48##2	a_27_368##6	2.12121e-17
C271	A#4	a_27_368##11	1.18141e-17
C272	Y#14	a_183_48##15	4.82402e-17
C273	a_27_368##11	a_183_48##8	5.56291e-19
C274	a_183_48##32	a_183_48##17	4.12515e-19
C275	A#6	A#3	2.69407e-18
C276	a_183_48##20	a_183_48##18	2.7982e-17
C277	a_27_368##2	VPWR#10	2.53904e-19
C278	A#1	a_183_48##11	8.24045e-19
C279	a_183_48##29	VGND#10	5.0698e-17
C280	VPWR#12	a_183_48##15	4.00345e-17
C281	a_27_368##11	VPWR#5	1.14406e-18
C282	a_183_48##30	a_183_48##34	3.38957e-19
C283	a_183_48##32	a_183_48##19	4.20345e-19
C284	a_27_368##3	VPWR#4	2.21214e-18
C285	VGND#3	a_183_48##6	4.41816e-19
C286	VPWR#12	a_183_48##17	3.78764e-17
C287	a_183_48##22	a_183_48##20	4.00568e-17
C288	a_27_368##11	a_183_48##7	6.00855e-19
C289	a_27_368##3	VPWR#3	2.99746e-18
C290	VGND#7	VGND#6	1.67796e-18
C291	Y#12	a_183_48##17	3.97538e-17
C292	a_183_48##34	a_183_48##29	3.65052e-18
C293	a_183_48##30	VGND#11	1.18787e-17
C294	VPWR#13	a_183_48##17	2.97866e-18
C295	VPWR#12	a_183_48##19	2.97866e-18
C296	a_183_48##8	a_183_48##7	5.34509e-18
C297	a_27_368##6	a_183_48##32	5.51584e-19
C298	Y	a_183_48##11	8.10149e-18
C299	Y#12	a_183_48##19	3.97538e-17
C300	a_183_48##24	a_183_48##22	2.38474e-17
C301	a_183_48##30	a_27_368##3	9.26402e-17
C302	Y	a_183_48##10	9.26064e-18
C303	Y	a_183_48##9	1.31866e-18
C304	a_183_48##29	a_27_368##3	4.12429e-17
C305	Y	a_183_48##8	1.0821e-19
C306	VPWR#13	a_183_48##19	3.98315e-17
C307	Y	a_183_48##7	1.08432e-19
C308	a_27_368##3	a_183_48##28	4.5598e-17
C309	Y#1	a_183_48##30	1.58385e-17
C310	VGND#5	Y#2	1.67763e-17
C311	a_183_48##12	a_183_48##24	3.56201e-17
C312	VPWR#13	a_183_48##21	3.78764e-17
C313	Y#10	a_183_48##21	3.97538e-17
C314	VPWR#14	a_183_48##21	2.97866e-18
C315	VPWR#13	a_183_48##23	2.97866e-18
C316	A#1	a_183_48##12	2.87322e-17
C317	VGND#6	VGND#4	1.17855e-18
C318	Y#10	a_183_48##23	3.97538e-17
C319	VPWR#14	a_183_48##23	3.98315e-17
C320	a_27_368##12	a_183_48##21	1.78798e-19
C321	Y#3	a_183_48##6	7.3059e-17
C322	a_27_368##11	A#2	3.95943e-18
C323	a_27_368##3	VGND#10	5.3922e-18
C324	VPWR#14	a_183_48##25	3.78764e-17
C325	Y#2	a_183_48##6	8.71093e-17
C326	a_27_368##3	a_183_48##34	2.03729e-18
C327	a_27_368##12	a_183_48##23	2.75436e-19
C328	Y#8	a_183_48##25	3.97563e-17
C329	VPWR#15	a_183_48##25	2.97866e-18
C330	VPWR#14	a_183_48##26	2.97866e-18
C331	a_27_368##12	a_183_48##25	4.55812e-19
C332	Y#8	a_183_48##26	3.48148e-17
C333	VPWR#15	a_183_48##26	3.79569e-17
C334	A#6	A#2	8.78361e-18
C335	VGND#11	a_183_48##6	8.75743e-18
C336	a_183_48##6	Y#1	6.05053e-17
C337	a_27_368##12	a_183_48##26	3.18805e-18
C338	a_27_368##8	a_27_368##4	3.75311e-17
C339	A#4	A#2	1.45036e-17
C340	Y#8	A#3	1.0224e-18
C341	a_183_48##6	VGND#12	3.66085e-18
C342	VGND#4	VGND#3	1.17855e-18
C343	a_183_48##6	Y#6	2.5292e-18
C344	A#3	VPWR#15	2.47444e-17
C345	a_183_48##6	VGND#13	3.84213e-18
C346	a_27_368##12	A#3	5.91381e-17
C347	a_183_48##6	Y#7	2.68988e-18
C348	a_27_368##9	a_27_368##8	4.60266e-17
C349	VGND	a_183_48##10	1.89619e-19
C350	VGND	a_183_48##9	5.24673e-20
C351	a_183_48##6	VGND#14	2.40574e-18
C352	VGND	a_183_48##8	4.65762e-20
C353	a_27_368##3	VPWR#10	1.4585e-18
C354	VGND	a_183_48##7	1.27026e-19
C355	VGND	a_183_48##4	8.83659e-20
C356	a_27_368##3	a_183_48##32	7.10669e-17
C357	VGND#7	a_183_48##11	6.77917e-21
C358	VGND	a_183_48##2	5.85424e-20
C359	a_27_368##3	VPWR#11	3.76227e-17
C360	a_27_368##3	Y#14	9.52395e-17
C361	a_183_48##13	a_27_368##9	4.22744e-17
C362	a_27_368##3	VPWR#12	4.4298e-17
C363	a_27_368##3	Y#12	4.54223e-17
C364	a_27_368##3	VPWR#13	7.55756e-22
C365	a_27_368##13	A#2	8.3341e-18
C366	a_183_48##6	Y#14	7.1647e-17
C367	a_183_48##15	a_183_48##13	3.00421e-17
C368	a_183_48##6	VPWR#12	2.35532e-18
C369	VGND#7	Y	8.75021e-18
C370	VGND#7	a_183_48##10	3.92013e-20
C371	a_183_48##6	Y#12	8.09466e-17
C372	a_183_48##6	VPWR#13	2.35532e-18
C373	a_183_48##6	Y#10	7.49248e-17
C374	a_183_48##17	a_183_48##15	4.70068e-17
C375	a_183_48##7	a_183_48##4	4.00188e-18
C376	a_183_48##6	VPWR#14	1.40687e-18
C377	a_27_368##6	VNB	2.60593e-17
C378	a_27_368##2	VNB	3.45027e-17
C379	a_183_48##11	VNB	2.45559e-17
C380	Y#8	a_183_48##6	1.76684e-17
C381	a_183_48##10	VNB	3.07306e-17
C382	a_183_48##9	VNB	3.46176e-17
C383	a_183_48##8	VNB	3.77616e-17
C384	a_183_48##7	VNB	6.8954e-17
C385	a_183_48##4	VNB	4.42706e-17
C386	a_183_48##19	a_183_48##17	4.93913e-17
C387	a_183_48##2	VNB	3.29272e-17
C388	VGND#5	a_183_48##16	1.78286e-18
C389	VGND#5	a_183_48##18	1.765e-18
C390	Y#8	A#2	7.03821e-19
C391	VGND#7	a_183_48##9	3.68433e-20
C392	a_27_368##11	Y	2.50819e-18
C393	A#2	a_27_368##12	4.0408e-18
C394	a_183_48##21	a_183_48##19	4.70068e-17
C395	VPWR	VPWR#7	4.37323e-17
C396	VPWR	VPWR#6	3.97009e-17
C397	VPWR	VPWR#4	3.94012e-17
C398	VPWR	VPWR#3	4.51508e-17
C399	a_183_48##23	a_183_48##21	4.93913e-17
C400	VPWR	a_183_48##30	1.15525e-18
C401	VPWR	a_183_48##28	2.08785e-17
C402	VPWR	a_27_368##11	2.14325e-17
C403	VGND	VGND#7	3.95646e-17
C404	VGND#7	a_183_48##8	1.15712e-20
C405	VGND	VGND#6	1.93894e-17
C406	VGND	VGND#4	3.93934e-17
C407	a_183_48##25	a_183_48##23	4.70068e-17
C408	VGND	VGND#3	2.44511e-17
C409	Y#2	Y#1	2.67919e-18
C410	a_183_48##32	VPWR#3	8.48061e-18
C411	a_27_368##3	a_27_368##4	6.85562e-18
C412	Y	Y#7	3.56937e-18
C413	a_27_368##3	a_27_368##8	8.12153e-18
C414	a_183_48##13	a_27_368##6	4.15971e-19
C415	VPWR	A#6	2.98376e-18
C416	Y	VGND#14	5.07648e-17
C417	VPWR#5	a_183_48##17	4.33284e-18
C418	Y	Y#4	5.3256e-20
C419	a_183_48##26	a_183_48##25	4.93901e-17
C420	a_27_368##3	a_27_368##9	1.9867e-17
C421	VGND#15	Y	5.05713e-17
C422	VGND#3	a_27_368##6	4.68172e-20
C423	a_27_368##13	Y	5.05451e-17
C424	a_27_368##3	a_183_48##13	2.58514e-17
C425	VGND	a_183_48##30	4.08679e-18
C426	VGND	a_183_48##29	2.22478e-17
C427	a_27_368##3	a_183_48##15	1.91007e-17
C428	A#3	a_183_48##26	3.74972e-17
C429	Y#2	VGND#12	5.95343e-17
C430	Y#14	a_183_48##4	3.74225e-18
C431	a_27_368##3	a_183_48##17	1.71652e-17
C432	VGND#7	VNB	2.94535e-17
C433	VGND#6	VNB	2.31707e-17
C434	VGND	Y#3	3.48881e-18
C435	a_27_368##3	a_183_48##19	2.16368e-19
C436	VGND#4	VNB	2.47877e-17
C437	VGND	Y#2	1.94341e-17
C438	VGND#3	VNB	2.92451e-17
C439	a_27_368##3	a_183_48##21	2.16546e-19
C440	VGND	A#4	4.2096e-18
C441	VPWR#7	VNB	2.95082e-17
C442	VPWR#6	VNB	2.42709e-17
C443	VGND	VGND#10	1.74506e-17
C444	Y	Y#8	4.84204e-18
C445	VPWR#4	VNB	2.40036e-17
C446	VGND	a_183_48##34	1.23518e-17
C447	VPWR	a_183_48##32	1.66004e-17
C448	VPWR#3	VNB	3.16715e-17
C449	VGND	VGND#11	1.74239e-17
C450	VGND	Y#1	1.68848e-17
C451	VPWR	Y#14	3.86991e-18
C452	a_183_48##30	VNB	1.35779e-19
C453	a_183_48##29	VNB	5.72711e-17
C454	VGND	VGND#13	1.74108e-17
C455	VPWR	Y#12	4.5065e-18
C456	a_183_48##28	VNB	5.92093e-17
C457	VGND	Y#7	1.14664e-17
C458	a_27_368##11	VNB	8.22029e-18
C459	Y#2	Y#6	4.68449e-19
C460	Y#3	a_183_48##9	3.76186e-18
C461	VPWR	Y#10	4.14876e-18
C462	VPWR#12	a_183_48##7	1.90501e-19
C463	Y#3	VGND#13	1.47648e-17
C464	VGND	a_27_368##13	1.79961e-17
C465	VPWR	Y#8	5.1052e-18
C466	Y#3	VNB	4.42009e-19
C467	Y	a_183_48##16	1.22526e-20
C468	Y#2	VNB	2.88486e-18
C469	VGND#6	a_183_48##8	5.54015e-20
C470	A#6	VNB	1.13359e-17
C471	VPWR	a_27_368##12	1.69867e-17
C472	Y	a_183_48##18	1.81082e-20
C473	A#4	VNB	1.5273e-17
C474	Y	a_183_48##20	3.22071e-19
C475	Y#14	a_183_48##2	1.55049e-18
C476	VGND	Y#14	2.69371e-18
C477	VGND#10	VNB	1.2617e-18
C478	Y	a_183_48##22	1.42479e-18
C479	A#2	a_183_48##26	9.00606e-19
C480	a_183_48##34	VNB	4.70389e-18
C481	a_27_368##3	VPWR#5	2.40487e-18
C482	VGND#11	VNB	5.15269e-19
C483	VGND	Y#12	3.14676e-18
C484	Y	a_183_48##24	4.23444e-17
C485	a_27_368##13	a_27_368##11	1.03579e-18
C486	a_183_48##34	VGND#10	3.33515e-17
C487	Y#1	VNB	3.17157e-18
C488	VGND#12	VNB	4.56457e-19
C489	Y	a_183_48##12	2.30244e-17
C490	VGND	Y#10	2.90912e-18
C491	VGND#13	VNB	5.14741e-19
C492	Y	A#1	2.48829e-18
C493	Y#7	VNB	4.62477e-18
C494	VGND	Y#8	1.2823e-18
C495	VGND#14	VNB	5.87413e-19
C496	VGND#15	VNB	2.83798e-18
C497	a_183_48##28	a_183_48##27	1.17519e-17
C498	a_27_368##13	VNB	4.84087e-17
C499	VGND	a_27_368#	5.17462e-19
C500	Y#2	VGND#13	5.1059e-17
C501	VGND	a_27_368##5	4.80216e-19
C502	VPWR#10	VNB	1.54196e-18
C503	Y#3	a_183_48##8	3.4977e-18
C504	a_183_48##32	VNB	2.1098e-18
C505	VGND	a_27_368##7	4.15046e-19
C506	a_183_48##6	a_27_368##3	3.43176e-17
C507	VPWR#11	VNB	6.08476e-19
C508	VGND	a_183_48#	1.39996e-18
C509	Y#14	VNB	9.80083e-19
C510	Y#3	Y#7	3.18435e-19
C511	VGND	a_183_48##14	5.6547e-19
C512	VPWR#12	VNB	6.18977e-20
C513	Y#12	VNB	7.85099e-19
C514	VGND	a_183_48##16	3.32891e-19
C515	VPWR#13	VNB	6.18977e-20
C516	VGND	a_183_48##18	8.1872e-19
C517	VPWR	a_27_368##4	1.60777e-18
C518	Y#10	VNB	5.3265e-19
C519	VGND	a_183_48##20	4.85636e-19
C520	VPWR#14	VNB	6.18977e-20
C521	VPWR	a_27_368##8	1.86438e-19
C522	Y#8	VNB	1.39526e-18
C523	VGND	a_183_48##22	4.98428e-19
C524	VPWR#12	a_183_48##4	2.43187e-19
C525	VPWR	a_27_368##9	1.59055e-18
C526	VPWR#15	VNB	1.57587e-18
C527	VGND	a_183_48##24	8.87933e-20
C528	a_27_368##12	VNB	5.24453e-17
C529	VPWR	a_183_48##13	4.33232e-19
C530	VGND#11	VGND#10	2.21848e-18
C531	VGND	a_183_48##12	5.75594e-18
C532	a_27_368#	VNB	2.98413e-17
C533	a_27_368##5	VNB	2.48748e-17
C534	VGND	A#1	1.66197e-18
C535	VPWR	a_183_48##15	4.33232e-19
C536	a_27_368##7	VNB	2.45697e-17
C537	VPWR	a_183_48##17	7.05853e-19
C538	a_183_48#	VNB	2.80361e-17
C539	a_183_48##14	VNB	2.53212e-17
C540	VPWR	a_183_48##19	4.76814e-19
C541	a_183_48##16	VNB	2.70303e-17
C542	Y#12	a_183_48##8	5.09e-19
C543	a_183_48##18	VNB	2.79822e-17
C544	VPWR	a_183_48##21	4.76814e-19
C545	a_183_48##20	VNB	2.46409e-17
C546	VPWR	a_183_48##23	4.76814e-19
C547	a_183_48##22	VNB	2.46986e-17
C548	a_183_48##24	VNB	2.61906e-17
C549	VPWR	a_183_48##25	3.77312e-19
C550	a_183_48##12	VNB	2.74139e-17
C551	A#1	VNB	3.32459e-17
C552	VPWR	a_183_48##26	4.4248e-19
C553	Y#7	Y#2	3.56937e-18
C554	a_183_48##28	VPWR#10	6.85821e-17
C555	VPWR	A#3	6.28424e-19
C556	a_27_368##4	VNB	3.67945e-17
C557	a_27_368##8	VNB	2.93551e-17
C558	a_27_368##9	VNB	3.26737e-17
C559	Y#3	VGND#14	1.4969e-17
C560	a_183_48##13	VNB	3.20717e-17
C561	VPWR	VPWR#5	1.07493e-17
C562	a_183_48##15	VNB	3.04734e-17
C563	Y	a_183_48##6	2.03178e-17
C564	a_183_48##17	VNB	2.8886e-17
C565	a_183_48##19	VNB	2.8761e-17
C566	Y	A#2	6.92512e-19
C567	VPWR	a_27_368##3	2.22925e-17
C568	a_183_48##21	VNB	2.87517e-17
C569	VGND#11	a_183_48##34	3.3335e-17
C570	a_183_48##23	VNB	2.85328e-17
C571	VPWR	a_183_48##6	1.33952e-17
C572	Y#12	a_183_48##7	1.21459e-17
C573	a_183_48##25	VNB	2.81615e-17
C574	VGND	VGND#5	8.15815e-18
C575	a_183_48##26	VNB	3.19358e-17
C576	VGND	a_27_368##3	7.87459e-18
C577	A#3	VNB	4.53723e-17
C578	VGND	a_183_48##6	1.65082e-17
C579	VPWR#5	VNB	2.61769e-16
C580	VGND#5	VNB	2.62125e-16
C581	a_27_368##3	VNB	4.12498e-17
C582	a_183_48##6	VNB	7.18545e-18
C583	A#2	VNB	5.79666e-17
C584	a_183_48##7	a_183_48##15	1.71475e-18
C585	VGND	Y	1.92852e-17
C586	A#6	a_183_48##11	4.60754e-19
C587	Y	VNB	3.40417e-18
C588	VPWR	VNB	5.40495e-17
C589	VGND	VNB	6.41281e-17
C590	a_183_48##32	a_183_48##28	2.54741e-18
C591	VGND	VGND#2	3.37256e-17
C592	VPWR	VPWR#2	5.3013e-17
C593	VGND#8	a_183_48##22	9.45487e-20
C594	VPWR#5	VPWR#2	5.29303e-17
C595	VGND#2	a_183_48##34	6.0621e-18
C596	VPWR#8	VNB	4.86381e-17
C597	VGND#8	Y	7.53396e-18
C598	VPWR#2	a_183_48##13	1.81634e-19
C599	VGND#2	a_183_48##30	2.80471e-19
C600	VPWR#8	VPWR#7	9.56424e-19
C601	VGND#8	a_183_48##24	6.19267e-19
C602	VGND#2	a_27_368##5	9.59264e-19
C603	VGND#8	VGND#14	2.87596e-19
C604	VGND#2	VNB	4.88396e-17
C605	VPWR#8	a_183_48##25	5.89728e-19
C606	VPWR#2	a_27_368##8	5.68036e-18
C607	VGND#8	a_183_48##12	6.78426e-18
C608	a_27_368##12	VPWR#8	2.13177e-17
C609	VGND#8	A#2	1.06094e-19
C610	VGND#8	VGND#7	1.34628e-18
C611	VGND#2	a_183_48##29	2.11776e-17
C612	a_183_48##32	VPWR#2	8.65313e-18
C613	VGND	VGND#8	5.51838e-17
C614	VGND#8	a_183_48##11	5.89493e-20
C615	a_27_368##11	VPWR#8	1.85438e-18
C616	VPWR#5	VPWR#8	5.29704e-17
C617	VPWR#2	a_27_368##6	3.14475e-21
C618	VGND#8	A#1	4.12446e-18
C619	VPWR	VPWR#8	5.59342e-17
C620	VGND#8	VNB	4.92018e-17
C621	VGND#5	VGND#2	5.27517e-17
C622	VPWR#8	a_183_48##26	6.97317e-18
C623	VPWR#8	A#2	5.70463e-20
C624	VGND#8	a_27_368##13	1.7841e-17
C625	VPWR#2	a_27_368##9	9.53883e-19
C626	a_183_48##28	VPWR#2	1.95052e-17
C627	VGND#8	A#4	5.97387e-19
C628	VPWR#11	VPWR#2	1.22541e-18
C629	VPWR#2	VNB	4.84307e-17
C630	VGND#2	a_27_368##3	5.51835e-20
C631	VPWR#2	a_27_368##3	1.68176e-20
C632	VPWR#8	A#3	7.7285e-18
C633	VPWR#8	a_183_48##11	1.2658e-19
C634	VGND#5	VGND#8	5.30947e-17
C635	VPWR#2	a_27_368##4	5.76489e-18
C636	VPWR#3	VPWR#2	8.12629e-19
C637	VGND#3	VGND#2	1.61409e-18
C638	VGND#2	a_27_368#	2.74812e-18
*
*
.ENDS sky130_fd_sc_hs__bufinv_8
*
