* Extracted by Quantus, converted by sky130cad/quantus.py
*
*
*
*                       LINUX           Wed Nov 18 08:35:10 2026
*
*
*
*  PROGRAM  advgen
*
*  Name           : advgen - Quantus - (64-bit)
*  Version        : 25.1.0-p047
*  Build Date     : Thu Dec 11 23:20:30 PST 2025
*
*  HSPICE LIBRARY
*
*  OPERATING_TEMPERATURE 150
*  QRC_TECH_DIR <path>/tech
*
*
*

*
.SUBCKT sky130_fd_sc_hs__dlymetal6s4s_1 VPB VNB VGND X VPWR A
*
*
*  caps2d version: 10
*
*
*       TRANSISTOR CARDS
*
*
XM9 a_28_138##6 A#3 VGND#8 VNB sky130_fd_pr__nfet_01v8_lvt l=0.15 w=0.42 ad=0.1113 as=0.2276 pd=1.37 ps=2.16
XM0 VGND#8 a_28_138##3 a_209_74##6 VNB sky130_fd_pr__nfet_01v8_lvt l=0.15 w=0.74 ad=0.2276 as=0.1961 pd=2.16 ps=2.01
XM1 a_316_138##6 a_209_74##3 VGND#7 VNB sky130_fd_pr__nfet_01v8_lvt l=0.15 w=0.42 ad=0.1113 as=0.2276 pd=1.37 ps=2.16
XM8 VGND#7 a_316_138##3 X#6 VNB sky130_fd_pr__nfet_01v8_lvt l=0.15 w=0.74 ad=0.2276 as=0.1961 pd=2.16 ps=2.01
XM11 a_604_138##6 X#3 VGND#4 VNB sky130_fd_pr__nfet_01v8_lvt l=0.15 w=0.42 ad=0.1113 as=0.2276 pd=1.37 ps=2.16
XM2 VGND#4 a_604_138##3 a_785_74# VNB sky130_fd_pr__nfet_01v8_lvt l=0.15 w=0.74 ad=0.2276 as=0.1961 pd=2.16 ps=2.01
XM7 a_28_138##4 A#1 VPWR#7 VPB sky130_fd_pr__pfet_01v8 l=0.15 w=0.42 ad=0.1155 as=0.3458 pd=1.39 ps=2.97
XM3 VPWR#7 a_28_138# a_209_74##8 VPB sky130_fd_pr__pfet_01v8 l=0.15 w=1.12 ad=0.3458 as=0.308 pd=2.97 ps=2.79
XM10 a_316_138##7 a_209_74# VPWR#5 VPB sky130_fd_pr__pfet_01v8 l=0.15 w=0.42 ad=0.1155 as=0.3458 pd=1.39 ps=2.97
XM4 VPWR#5 a_316_138# X#8 VPB sky130_fd_pr__pfet_01v8 l=0.15 w=1.12 ad=0.3458 as=0.308 pd=2.97 ps=2.79
XM5 a_604_138##7 X#1 VPWR#4 VPB sky130_fd_pr__pfet_01v8 l=0.15 w=0.42 ad=0.1155 as=0.3514 pd=1.39 ps=2.98
XM6 VPWR#4 a_604_138# a_785_74##3 VPB sky130_fd_pr__pfet_01v8 l=0.15 w=1.12 ad=0.3514 as=0.308 pd=2.98 ps=2.79
*
*
*       RESISTOR AND CAP/DIODE CARDS
*
Rg1	A#1	A#2	264.382935
Rg2	A#2	A#3	244.966141
Rg3	a_28_138#	a_28_138##2	476.129150
Rg4	a_28_138##2	a_28_138##3	346.263855
Rg5	a_209_74#	a_209_74##2	260.488892
Rg6	a_209_74##2	a_209_74##3	241.072083
Rg7	a_316_138#	a_316_138##2	476.129150
Rg8	a_316_138##2	a_316_138##3	346.263855
Rg9	X#1	X#2	257.495758
Rg10	X#2	X#3	238.078964
Rg11	a_604_138#	a_604_138##2	467.950653
Rg12	a_604_138##2	a_604_138##3	333.845245
Rf1	A#4	A#2	162.552200
Rf2	A	A#6	2.319396
Rf3	A#4	A#6	6.581583
Rf4	a_28_138##4	a_28_138##5	82.698280
Rf5	a_28_138##5	a_28_138##6	78.975357
Rf6	a_209_74##2	a_209_74##5	180.278503
Rf7	a_209_74##5	a_209_74##6	52.604900
Rf8	a_209_74##5	a_209_74##7	38.209469
Rf9	a_209_74##7	a_209_74##8	20.326851
Rf10	a_316_138##2	a_316_138##5	164.386047
Rf11	a_316_138##5	a_316_138##6	81.698418
Rf12	a_316_138##5	a_316_138##7	76.410072
Rf13	X#2	X#5	178.276154
Rf14	X#5	X#6	51.611641
Rf15	X#5	X#7	37.775482
Rf16	X#7	X#8	20.543203
Rf17	a_604_138##2	a_604_138##5	164.976562
Rf18	a_604_138##5	a_604_138##6	81.388809
Rf19	a_604_138##5	a_604_138##7	69.035263
Rf20	a_785_74#	a_785_74##2	87.578560
Rf21	a_785_74##2	a_785_74##3	20.489510
Rf23	VPWR#2	VPWR#3	97.338036
Rf24	VPWR#2	VPWR#4	33.793236
Rf25	VPWR#3	VPWR#5	37.706139
Rf26	VPWR#3	VPWR#6	123.636215
Rf27	VPWR#6	VPWR#7	33.793236
Rf30	VGND#2	VGND#3	90.192825
Rf31	VGND#2	VGND#4	40.018913
Rf32	VGND#3	VGND#5	122.846397
Rf34	VGND#3	VGND#7	43.516815
Rf35	VGND#5	VGND#8	40.018913
Rf37	a_28_138##2	a_28_138##5	160.232803
Re1	X#7	X	9.932536
Re2	VPWR#3	VPWR	1.160239
Re3	VGND#3	VGND	1.160239
*
*       CAPACITOR CARDS
*
*
C1	a_209_74##5	a_316_138##5	2.88601e-18
C2	a_604_138##5	a_785_74#	3.58617e-17
C3	a_604_138##5	VGND#4	2.55336e-17
C4	X#5	a_604_138##6	7.61624e-18
C5	X#5	X#6	1.89117e-19
C6	a_316_138##5	X#6	1.12639e-17
C7	a_316_138##5	VGND#7	2.56154e-17
C8	a_209_74##5	a_316_138##6	8.50593e-18
C9	a_604_138##5	VPWR#4	6.70935e-19
C10	a_209_74##5	a_209_74##6	2.42496e-19
C11	VGND#4	a_785_74#	4.32784e-17
C12	a_604_138##5	a_604_138##7	8.69133e-19
C13	a_604_138##6	a_785_74#	2.38792e-18
C14	a_604_138##6	VGND#4	1.45763e-17
C15	X#6	VGND#4	1.13336e-17
C16	X#6	a_604_138##6	3.27183e-17
C17	VGND#7	X#6	4.30446e-17
C18	a_316_138##5	VPWR#5	1.99598e-17
C19	a_28_138##6	A#4	3.35521e-17
C20	a_316_138##6	X#6	2.4212e-18
C21	a_316_138##5	a_316_138##7	2.42462e-18
C22	a_316_138##6	VGND#7	1.50116e-17
C23	a_209_74##6	VGND#7	1.06108e-17
C24	a_604_138##5	a_604_138##3	4.99863e-18
C25	a_209_74##6	a_316_138##6	3.67051e-17
C26	VGND#8	a_209_74##6	4.26579e-17
C27	X#5	X#3	1.16751e-19
C28	a_604_138##6	a_604_138##7	1.14326e-18
C29	a_28_138##6	a_209_74##6	2.39152e-18
C30	X#5	a_316_138##3	1.64703e-18
C31	a_316_138##5	X#3	1.69174e-19
C32	a_28_138##6	VGND#8	1.9928e-17
C33	X#5	a_209_74##3	2.78076e-19
C34	a_316_138##5	a_316_138##3	5.87319e-18
C35	A#6	a_28_138##4	4.1364e-17
C36	a_209_74##5	a_209_74##3	9.452e-20
C37	VPWR#4	a_785_74##3	6.10826e-17
C38	a_316_138##6	a_316_138##7	1.3918e-18
C39	a_785_74#	a_604_138##3	2.29954e-17
C40	a_604_138##7	a_785_74##3	2.47816e-18
C41	a_604_138##5	a_604_138#	2.55149e-18
C42	a_209_74##5	a_28_138##3	1.80776e-18
C43	VGND#4	a_604_138##3	2.7231e-17
C44	a_785_74#	X#3	1.28024e-18
C45	a_604_138##7	VPWR#4	2.8603e-17
C46	X#8	a_785_74##3	1.21328e-18
C47	a_604_138##6	a_604_138##3	1.06283e-18
C48	a_209_74##5	A#3	2.01084e-19
C49	a_604_138##5	X#1	3.04113e-18
C50	X#3	VGND#4	1.52579e-17
C51	X#8	VPWR#4	1.17383e-17
C52	a_785_74#	a_316_138##3	7.18478e-20
C53	X#6	a_604_138##3	3.34617e-18
C54	a_604_138##6	X#3	2.46916e-17
C55	VGND#4	a_316_138##3	1.57452e-18
C56	X#8	a_604_138##7	8.08785e-18
C57	VPWR#5	VPWR#4	4.08243e-20
C58	VGND#7	a_604_138##3	2.14149e-19
C59	a_604_138##5	a_316_138#	4.34091e-19
C60	X#6	X#3	3.44416e-18
C61	a_604_138##6	a_316_138##3	8.67105e-19
C62	VGND#7	X#3	3.1994e-19
C63	a_316_138##5	X#1	1.6623e-19
C64	a_316_138##3	X#6	2.64558e-17
C65	VPWR#5	X#8	6.14951e-17
C66	a_316_138##6	X#3	6.85317e-20
C67	VGND#7	a_316_138##3	3.1033e-17
C68	a_28_138##6	a_28_138##4	2.81564e-18
C69	a_316_138##5	a_316_138#	7.40118e-18
C70	X#6	a_209_74##3	6.4349e-19
C71	a_316_138##7	X#8	9.80481e-19
C72	a_316_138##6	a_316_138##3	7.23123e-19
C73	a_209_74##3	VGND#7	1.51585e-17
C74	a_316_138##7	VPWR#5	1.02814e-17
C75	a_209_74##8	X#8	4.14619e-19
C76	X#6	a_28_138##3	6.84386e-20
C77	a_209_74##6	a_316_138##3	2.2444e-18
C78	a_209_74##5	a_316_138#	4.77874e-20
C79	a_316_138##5	a_209_74#	2.42772e-18
C80	a_316_138##6	a_209_74##3	2.53261e-17
C81	VGND#7	a_28_138##3	2.08581e-18
C82	VGND#8	a_316_138##3	1.9893e-19
C83	a_209_74##8	VPWR#5	1.18132e-17
C84	a_209_74##6	a_209_74##3	3.14524e-18
C85	a_209_74##5	a_209_74#	2.98606e-19
C86	a_316_138##6	a_28_138##3	9.49413e-19
C87	a_316_138##5	a_28_138#	3.48973e-19
C88	a_209_74##8	a_316_138##7	8.28039e-18
C89	VPWR#7	VPWR#5	1.13696e-19
C90	VGND#8	a_209_74##3	3.1994e-19
C91	a_28_138##3	a_209_74##6	2.69429e-17
C92	a_28_138##6	a_209_74##3	6.9477e-20
C93	a_209_74##5	a_28_138#	5.4809e-19
C94	VGND#8	a_28_138##3	2.66827e-17
C95	a_209_74##6	A#3	1.08971e-18
C96	VPWR#7	a_209_74##8	5.91499e-17
C97	a_28_138##6	a_28_138##3	1.23334e-18
C98	A#3	VGND#8	1.64331e-17
C99	a_209_74##5	A#1	5.54045e-20
C100	a_28_138##4	a_209_74##8	2.40959e-18
C101	A#6	a_28_138#	1.21787e-19
C102	a_28_138##6	A#3	2.42818e-17
C103	X#7	a_604_138##5	2.92354e-18
C104	a_28_138##4	VPWR#7	4.15712e-17
C105	A#6	A#1	4.74498e-18
C106	a_316_138##5	X#7	3.00932e-17
C107	a_785_74##3	a_604_138#	3.48032e-17
C108	a_604_138#	VPWR#4	3.20595e-17
C109	a_785_74##3	X#1	1.06471e-18
C110	X#3	a_604_138##3	2.24324e-17
C111	a_604_138##7	a_604_138#	6.52767e-18
C112	X#5	VPWR#3	2.67096e-19
C113	X#1	VPWR#4	1.53747e-17
C114	a_316_138##3	a_604_138##3	8.83317e-19
C115	X#8	a_604_138#	5.10998e-18
C116	a_785_74##3	a_316_138#	8.82295e-19
C117	a_604_138##7	X#1	4.27013e-17
C118	a_316_138##5	VPWR#3	9.38815e-20
C119	VPWR#4	a_316_138#	3.95855e-18
C120	VPWR#5	a_604_138#	6.37273e-19
C121	a_316_138##3	X#3	4.47629e-18
C122	VGND#3	X#5	4.7954e-19
C123	X#8	X#1	2.61058e-18
C124	a_604_138##7	a_316_138#	9.5256e-19
C125	a_209_74##5	VPWR#3	1.81774e-19
C126	a_604_138##5	a_604_138##2	1.95656e-17
C127	VPWR#5	X#1	5.7947e-20
C128	VGND#3	a_316_138##5	9.33661e-19
C129	a_316_138#	X#8	4.56129e-17
C130	a_316_138##7	X#1	1.1066e-20
C131	a_209_74##3	a_316_138##3	2.25203e-17
C132	X#5	a_604_138##2	1.19296e-19
C133	a_316_138#	VPWR#5	2.44608e-17
C134	VGND#3	a_209_74##5	4.55563e-19
C135	X#8	a_209_74#	8.21515e-19
C136	a_209_74##8	X#1	1.24052e-20
C137	X#2	a_604_138##5	3.66481e-17
C138	a_28_138##3	a_316_138##3	8.83317e-19
C139	X#6	X#7	2.8894e-18
C140	a_316_138##7	a_316_138#	3.55721e-19
C141	a_209_74#	VPWR#5	1.20241e-17
C142	a_28_138##3	a_209_74##3	4.52914e-18
C143	a_209_74##8	a_316_138#	3.59817e-18
C144	X#5	X#2	4.86736e-19
C145	X#8	a_28_138#	8.57741e-19
C146	a_316_138##7	a_209_74#	3.07098e-17
C147	VPWR#5	a_28_138#	5.16193e-18
C148	VPWR#7	a_316_138#	3.47193e-20
C149	a_604_138##5	a_316_138##2	1.48895e-19
C150	a_316_138##5	X#2	1.92248e-19
C151	a_209_74##8	a_209_74#	2.54368e-18
C152	a_316_138##7	a_28_138#	8.57957e-19
C153	X#5	a_316_138##2	9.36584e-18
C154	A#3	a_28_138##3	2.24306e-17
C155	a_209_74##8	a_28_138#	6.14132e-17
C156	a_316_138##5	a_316_138##2	1.95433e-17
C157	a_28_138#	VPWR#7	2.57247e-17
C158	a_209_74##8	A#1	1.25807e-18
C159	a_785_74#	a_604_138##2	9.02893e-18
C160	VGND#3	X#6	3.62228e-17
C161	X#5	a_209_74##2	1.69971e-19
C162	a_209_74##5	a_316_138##2	8.44812e-20
C163	a_28_138##4	a_28_138#	6.42986e-18
C164	A#1	VPWR#7	1.61146e-17
C165	X#7	a_604_138##7	2.49991e-17
C166	a_209_74##2	a_316_138##5	3.45927e-17
C167	VGND#3	a_316_138##6	6.25532e-18
C168	a_28_138##4	A#1	2.84909e-17
C169	X#7	X#8	1.69705e-18
C170	a_785_74#	X#2	2.50768e-20
C171	a_209_74##6	VGND#3	2.35591e-18
C172	a_209_74##5	a_209_74##2	5.27892e-19
C173	VGND#4	X#2	7.86167e-19
C174	a_604_138##6	X#2	3.91199e-17
C175	a_316_138##5	a_28_138##2	1.38336e-19
C176	a_28_138##2	a_209_74##5	6.2792e-17
C177	X#1	a_604_138#	2.01709e-17
C178	X#8	VPWR#3	2.6288e-17
C179	X#6	a_316_138##2	4.41259e-18
C180	a_316_138#	a_604_138#	1.1877e-18
C181	A#6	a_28_138##2	2.0923e-17
C182	a_316_138##7	VPWR#3	5.09884e-18
C183	VPWR#4	a_604_138##2	4.94214e-19
C184	a_316_138#	X#1	4.02372e-18
C185	a_209_74##5	A#2	1.10306e-19
C186	A#4	a_28_138##2	2.15765e-17
C187	VGND#7	a_209_74##2	5.14032e-19
C188	A#6	A#2	8.56135e-18
C189	a_316_138##6	a_209_74##2	4.6323e-17
C190	a_209_74#	a_316_138#	2.00896e-17
C191	X#2	a_604_138##7	2.58341e-17
C192	A#4	A#2	1.32201e-17
C193	a_28_138#	a_316_138#	1.68652e-18
C194	VGND#3	a_604_138##3	2.01745e-19
C195	a_28_138#	a_209_74#	4.11798e-18
C196	a_28_138##2	a_209_74##6	1.41957e-17
C197	a_28_138##2	VGND#8	2.1968e-17
C198	VPWR#5	a_316_138##2	5.8228e-19
C199	VGND#3	a_316_138##3	1.20255e-17
C200	X#7	a_604_138#	3.73938e-19
C201	X#3	a_604_138##2	2.23866e-19
C202	A#1	a_28_138#	1.99736e-17
C203	VGND#3	a_209_74##3	8.18815e-19
C204	X#7	X#1	2.00413e-18
C205	VGND#3	a_28_138##3	9.76681e-19
C206	a_28_138##6	A#2	5.60922e-18
C207	a_209_74##2	a_316_138##7	2.88336e-17
C208	X#7	a_316_138#	1.22954e-17
C209	X#7	a_209_74#	9.73124e-19
C210	a_316_138##2	X#3	5.28655e-20
C211	VPWR#3	a_316_138#	1.25348e-18
C212	a_28_138##2	VPWR#7	3.06395e-18
C213	a_209_74##3	a_316_138##2	2.23864e-19
C214	VPWR#3	a_209_74#	8.0643e-19
C215	a_28_138##4	A#2	2.2738e-18
C216	a_28_138##2	a_209_74##3	2.41468e-19
C217	a_28_138##2	a_28_138##3	5.9665e-18
C218	A#3	a_28_138##2	2.23866e-19
C219	X#7	a_604_138##2	6.48347e-21
C220	a_28_138##2	a_209_74#	2.0183e-19
C221	X#7	X#2	2.6453e-20
C222	VPWR	a_604_138##5	8.51825e-20
C223	a_28_138##2	a_28_138#	3.28979e-18
C224	VPWR	X#5	3.06543e-19
C225	X#7	a_316_138##2	5.07094e-20
C226	a_28_138##2	A#1	2.84959e-18
C227	X#5	a_604_138##5	2.34894e-18
C228	VPWR	a_316_138##5	1.32506e-19
C229	X#2	VPWR#3	2.02177e-19
C230	VPWR	a_209_74##5	3.9808e-19
C231	X#7	a_209_74##2	8.276e-21
C232	VPWR	A#6	3.62572e-18
C233	X#2	a_604_138##2	3.61931e-17
C234	X	a_604_138##5	3.30201e-19
C235	VGND#3	a_316_138##2	7.03698e-20
C236	a_209_74##2	VPWR#3	3.10101e-19
C237	X	X#5	1.58265e-18
C238	X	a_316_138##5	2.14374e-17
C239	VGND#3	a_209_74##2	4.5267e-19
C240	X	a_209_74##5	2.05525e-18
C241	a_316_138##2	X#2	8.79175e-18
C242	VPWR	a_785_74##3	1.957e-17
C243	VPWR	VPWR#4	1.01077e-17
C244	X	VGND#4	2.59933e-18
C245	VGND	a_604_138##5	6.46937e-18
C246	a_209_74##2	a_316_138##2	3.60327e-17
C247	X	a_604_138##6	2.39861e-18
C248	VPWR	a_604_138##7	5.11164e-18
C249	X	X#6	2.3282e-18
C250	VGND	X#5	1.52607e-18
C251	VPWR	X#8	1.82078e-17
C252	X	VGND#7	2.5937e-18
C253	VPWR	VPWR#5	9.99917e-18
C254	VGND	a_316_138##5	6.31573e-18
C255	X	a_316_138##6	2.76208e-18
C256	VPWR	a_316_138##7	5.4392e-18
C257	VGND	a_209_74##5	2.00968e-18
C258	VPWR	a_209_74##8	1.85043e-17
C259	a_28_138##2	a_209_74##2	7.87522e-18
C260	X	a_785_74##3	3.05613e-17
C261	VPWR	a_28_138##4	1.21116e-17
C262	X	VPWR#4	3.12657e-17
C263	VGND	A#4	3.415e-18
C264	X	a_604_138##7	3.46929e-17
C265	VGND	a_785_74#	2.34071e-17
C266	X	X#8	2.64294e-17
C267	VGND	a_604_138##6	9.82063e-18
C268	X	VPWR#5	2.87134e-17
C269	VGND	X#6	2.10793e-17
C270	X	a_316_138##7	2.36281e-17
C271	A#2	a_28_138##2	4.02736e-17
C272	X	a_209_74##8	4.0375e-17
C273	a_604_138##5	VNB	6.0328e-18
C274	VGND	a_316_138##6	1.15592e-17
C275	VGND	a_209_74##6	2.15957e-17
C276	X	VPWR#7	9.62638e-18
C277	X#5	VNB	6.75837e-18
C278	a_316_138##5	VNB	5.81616e-18
C279	VGND	a_28_138##6	1.21187e-17
C280	a_209_74##5	VNB	7.76969e-18
C281	VPWR	a_604_138#	1.41991e-18
C282	VGND	a_604_138##7	3.10075e-18
C283	VPWR	X#1	2.93651e-18
C284	A#6	VNB	1.30598e-17
C285	VPWR	a_316_138#	2.55809e-18
C286	A#4	VNB	9.69774e-18
C287	a_785_74#	VNB	5.99387e-17
C288	VGND	a_316_138##7	4.15917e-18
C289	VPWR	a_209_74#	2.84066e-18
C290	VGND#4	VNB	3.71831e-18
C291	a_604_138##6	VNB	5.12284e-19
C292	VPWR	a_28_138#	2.55796e-18
C293	X#6	VNB	1.40081e-17
C294	VGND#7	VNB	3.42741e-18
C295	VGND	a_28_138##4	1.67675e-18
C296	VPWR	A#1	4.16874e-18
C297	X	a_604_138#	1.93529e-18
C298	a_316_138##6	VNB	4.94455e-18
C299	VGND	a_604_138##3	2.25289e-18
C300	a_209_74##6	VNB	1.27194e-17
C301	X	X#1	9.45179e-19
C302	VGND	X#3	8.14724e-18
C303	VGND#8	VNB	1.04476e-17
C304	X	a_316_138#	2.63587e-18
C305	a_28_138##6	VNB	2.74521e-17
C306	VGND	a_316_138##3	6.5928e-19
C307	a_785_74##3	VNB	3.61992e-17
C308	VGND	a_209_74##3	8.14724e-18
C309	X	a_209_74#	1.87272e-18
C310	VPWR#4	VNB	9.40436e-18
C311	VGND	a_28_138##3	1.06562e-18
C312	a_604_138##7	VNB	1.51033e-18
C313	X	a_28_138#	2.63064e-18
C314	X#8	VNB	1.00973e-17
C315	VGND	A#3	8.4581e-18
C316	X	A#1	2.8354e-18
C317	VPWR#5	VNB	8.92291e-18
C318	a_316_138##7	VNB	3.26569e-18
C319	VPWR	VPWR#3	9.01064e-17
C320	a_316_138##5	X#5	4.57189e-17
C321	a_209_74##8	VNB	9.37966e-18
C322	VPWR#7	VNB	3.14942e-17
C323	a_28_138##4	VNB	1.9166e-17
C324	X	X#7	2.47744e-17
C325	a_604_138##3	VNB	3.20124e-17
C326	X#3	VNB	2.95853e-17
C327	a_316_138##3	VNB	3.13752e-17
C328	VPWR	X#2	1.21879e-18
C329	a_209_74##3	VNB	2.99949e-17
C330	X	VPWR#3	7.09417e-18
C331	a_28_138##3	VNB	3.46136e-17
C332	A#3	VNB	3.46e-17
C333	VPWR	a_209_74##2	9.0199e-19
C334	a_604_138#	VNB	3.76574e-17
C335	VGND	X#7	1.39392e-18
C336	X#1	VNB	3.7546e-17
C337	X	X#2	4.45125e-18
C338	VPWR	a_28_138##2	5.28989e-19
C339	a_316_138#	VNB	3.92182e-17
C340	X	a_316_138##2	8.70903e-20
C341	a_209_74#	VNB	3.13049e-17
C342	a_28_138#	VNB	4.39366e-17
C343	VGND	VGND#3	1.0966e-16
C344	X	a_209_74##2	3.7583e-18
C345	A#1	VNB	3.89177e-17
C346	VGND	a_604_138##2	3.57537e-19
C347	X	a_28_138##2	6.28028e-19
C348	VGND	X#2	3.53933e-18
C349	X#7	VNB	2.97187e-18
C350	VGND	a_316_138##2	3.4425e-19
C351	VGND	a_209_74##2	2.83157e-18
C352	VPWR#3	VNB	5.31993e-17
C353	VGND#3	VNB	5.14404e-17
C354	VGND	a_28_138##2	4.56028e-18
C355	a_604_138##2	VNB	3.62079e-17
C356	X#2	VNB	4.39982e-17
C357	a_316_138##2	VNB	3.3799e-17
C358	a_209_74##2	VNB	4.04284e-17
C359	a_28_138##2	VNB	4.18153e-17
C360	A#2	VNB	5.45226e-17
C361	X	VPWR	1.40289e-16
C362	VPWR	VNB	2.73029e-16
C363	X	VNB	3.51217e-17
C364	VGND	VNB	2.76966e-16
C365	VGND#2	X#3	8.18815e-19
C366	VGND#2	a_604_138##3	1.3099e-17
C367	VGND#5	a_209_74##6	3.27038e-17
C368	a_209_74##6	a_209_74##7	3.05139e-18
C369	VGND#2	VNB	7.39899e-17
C370	VGND	VGND#2	1.34498e-16
C371	VGND#5	VNB	5.9623e-17
C372	a_785_74##2	VPWR#4	1.66141e-18
C373	a_604_138##5	VPWR#2	6.03524e-20
C374	a_209_74##7	a_28_138#	1.84874e-17
C375	a_209_74##5	VPWR#6	1.6508e-19
C376	VPWR#2	a_604_138#	2.19144e-18
C377	VGND	VGND#5	1.13977e-16
C378	VPWR#2	X#1	1.09235e-18
C379	a_785_74##2	a_604_138#	1.66224e-17
C380	VGND	a_209_74##7	2.27959e-18
C381	a_785_74##2	a_604_138##2	5.60936e-18
C382	a_209_74##7	a_316_138##5	1.69902e-18
C383	VGND	a_785_74##2	1.43411e-18
C384	a_785_74##2	VPWR#2	8.36973e-19
C385	a_209_74##7	a_209_74##8	1.36612e-18
C386	a_604_138##5	a_785_74##2	2.81099e-17
C387	VGND#5	A#3	8.19687e-19
C388	VGND#5	a_28_138##3	1.02934e-17
C389	a_785_74##2	a_785_74#	5.13823e-18
C390	VPWR#6	VPWR#5	3.93008e-20
C391	VPWR#3	VPWR#2	4.96252e-19
C392	a_209_74##7	a_209_74#	1.48675e-18
C393	a_209_74##8	VPWR#6	2.65271e-17
C394	a_785_74##2	a_785_74##3	1.91369e-18
C395	X#6	VGND#2	2.51063e-18
C396	a_28_138##4	VPWR#6	4.00203e-18
C397	VGND#5	a_316_138##3	1.99766e-19
C398	VGND#2	a_604_138##6	5.01311e-18
C399	VGND#2	X#2	7.78072e-19
C400	X#2	VPWR#2	3.44105e-19
C401	a_209_74##7	X	5.53694e-17
C402	VGND#2	a_604_138##2	9.38264e-20
C403	a_209_74##7	a_28_138##2	1.98308e-17
C404	VGND#2	a_785_74#	4.44614e-17
C405	VGND#5	a_209_74##5	1.84965e-19
C406	VGND#3	VGND#2	2.60448e-19
C407	a_785_74##2	X#7	1.10604e-18
C408	VGND#5	A#2	5.10699e-19
C409	VPWR#6	a_316_138#	9.59027e-20
C410	VGND#5	a_28_138##2	6.62715e-19
C411	VPWR#6	a_28_138#	7.11481e-18
C412	X	a_785_74##2	5.54782e-17
C413	VPWR#6	A#1	8.74258e-19
C414	a_209_74##7	a_316_138##7	3.77356e-17
C415	a_209_74##7	VPWR#6	2.77531e-19
C416	VPWR#6	VPWR#3	4.77661e-19
C417	a_785_74##3	VPWR#2	3.03299e-17
C418	a_209_74##7	a_316_138#	2.22376e-19
C419	a_209_74##7	a_28_138##4	3.40699e-17
C420	a_604_138##7	VPWR#2	4.14885e-18
C421	a_28_138##2	VPWR#6	3.6241e-19
C422	a_785_74##2	a_604_138##7	3.66318e-17
C423	VGND#2	X#5	6.85057e-21
C424	VPWR#6	A#2	4.34657e-19
C425	VGND#5	VGND#3	2.60448e-19
C426	VPWR	VPWR#2	1.10582e-16
C427	a_209_74##7	A#1	2.12945e-18
C428	X	VPWR#2	5.2619e-18
C429	VGND#2	a_604_138##5	7.827e-19
C430	a_785_74##2	X#1	1.57903e-18
C431	a_209_74##7	VNB	8.0847e-18
C432	VPWR#2	VNB	7.1694e-17
C433	a_785_74##2	X#2	1.93916e-19
C434	VPWR	VPWR#6	1.14834e-16
C435	X	VPWR#6	2.20266e-18
C436	VPWR#6	VNB	5.83395e-17
C437	a_785_74##2	VPWR	2.68193e-18
C438	VGND#5	a_28_138##6	7.54634e-18
C439	a_785_74##2	VNB	4.18353e-17
C440	VGND#2	a_316_138##3	8.33444e-19
*
*
.ENDS sky130_fd_sc_hs__dlymetal6s4s_1
*
