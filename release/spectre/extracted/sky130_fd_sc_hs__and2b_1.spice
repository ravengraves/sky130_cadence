* Extracted by Quantus, converted by sky130cad/quantus.py
*
*
*
*                       LINUX           Wed Nov 18 08:16:34 2026
*
*
*
*  PROGRAM  advgen
*
*  Name           : advgen - Quantus - (64-bit)
*  Version        : 25.1.0-p047
*  Build Date     : Thu Dec 11 23:20:30 PST 2025
*
*  HSPICE LIBRARY
*
*  OPERATING_TEMPERATURE 150
*  QRC_TECH_DIR <path>/tech
*
*
*

*
.SUBCKT sky130_fd_sc_hs__and2b_1 VPB VNB VGND VPWR X A_N B
*
*
*  caps2d version: 10
*
*
*       TRANSISTOR CARDS
*
*
XM7 a_27_74##7 A_N#3 VGND#7 VNB sky130_fd_pr__nfet_01v8_lvt l=0.15 w=0.55 ad=0.15675 as=0.19525 pd=1.67 ps=1.81
XM4 a_266_98##6 a_27_74# a_353_98# VNB sky130_fd_pr__nfet_01v8_lvt l=0.15 w=0.64 ad=0.1824 as=0.1536 pd=1.85 ps=1.76
XM3 a_353_98# B#3 VGND#6 VNB sky130_fd_pr__nfet_01v8_lvt l=0.15 w=0.64 ad=0.1536 as=0.4314 pd=1.76 ps=2.75
XM2 VGND#6 a_266_98# X#1 VNB sky130_fd_pr__nfet_01v8_lvt l=0.15 w=0.74 ad=0.4314 as=0.2109 pd=2.75 ps=2.05
XM0 a_27_74##5 A_N#1 VPWR#7 VPB sky130_fd_pr__pfet_01v8 l=0.15 w=0.84 ad=0.8526 as=0.252 pd=3.71 ps=2.28
XM5 VPWR#7 a_27_74##4 a_266_98##7 VPB sky130_fd_pr__pfet_01v8 l=0.15 w=0.84 ad=0.252 as=0.252 pd=2.28 ps=2.28
XM1 a_266_98##7 B#1 VPWR#6 VPB sky130_fd_pr__pfet_01v8 l=0.15 w=0.84 ad=0.252 as=0.462 pd=2.28 ps=3.11
XM6 VPWR#6 a_266_98##3 X#2 VPB sky130_fd_pr__pfet_01v8 l=0.15 w=1.12 ad=0.462 as=0.3304 pd=3.11 ps=2.83
*
*
*       RESISTOR AND CAP/DIODE CARDS
*
Rg1	A_N#1	A_N#2	697.261780
Rg2	A_N#2	A_N#3	454.186462
Rg3	a_27_74#	a_27_74##2	251.621262
Rg4	a_27_74##2	a_27_74##3	457.681274
Rg5	a_27_74##2	a_27_74##4	483.966064
Rg6	B#1	B#2	350.160492
Rg7	B#2	B#3	338.231323
Rg8	a_266_98#	a_266_98##2	351.130615
Rg9	a_266_98##2	a_266_98##3	445.247742
Rf1	A_N#4	A_N#2	161.445023
Rf2	A_N	A_N#6	1.212218
Rf3	A_N#4	A_N#6	4.635897
Rf4	A_N	A_N#7	1.212218
Rf5	A_N#6	A_N#7	11.435212
Rf6	a_27_74##5	a_27_74##3	63.648689
Rf7	a_27_74##3	a_27_74##7	78.149246
Rf8	B#4	B#2	160.996811
Rf9	B	B#6	0.764007
Rf10	B#4	B#6	5.905091
Rf11	a_266_98##2	a_266_98##5	244.062744
Rf12	a_266_98##5	a_266_98##6	34.106155
Rf13	a_266_98##5	a_266_98##7	84.080956
Rf14	X#1	X	85.937096
Rf15	X	X#3	9.932393
Rf16	X#3	X	0.136060
Rf17	X#2	X#3	5.000000
Rf19	VGND#2	VGND#3	55.318737
Rf20	VGND#3	VGND#4	65.720917
Rf22	VGND#2	VGND#6	19.615295
Rf23	VGND#4	VGND#7	35.098007
Rf25	VPWR#2	VPWR#3	55.128593
Rf26	VPWR#3	VPWR#4	16.899656
Rf28	VPWR#2	VPWR#6	37.498695
Rf29	VPWR#4	VPWR#7	80.537155
Re1	VPWR#3	VPWR	1.403190
Re2	VGND	VGND#3	1.403242
*
*       CAPACITOR CARDS
*
*
C1	a_27_74##2	B#3	3.7902e-18
C2	a_266_98##5	a_27_74##2	1.17891e-17
C3	VGND#3	a_27_74##2	2.28195e-19
C4	a_266_98##2	a_27_74##2	6.02059e-19
C5	a_266_98##5	B#4	4.1623e-17
C6	B#4	a_27_74##2	2.09727e-18
C7	a_27_74##2	B#2	1.96046e-17
C8	a_27_74##3	a_27_74##2	2.25927e-18
C9	a_266_98##5	VGND#6	1.63274e-17
C10	A_N#2	a_27_74##2	9.36847e-19
C11	a_266_98##5	a_266_98##7	1.906e-18
C12	A_N#4	a_27_74##2	3.12022e-19
C13	VGND#6	X#1	4.80403e-17
C14	a_266_98##6	X#1	1.31028e-18
C15	a_266_98##5	a_266_98#	3.55857e-20
C16	a_266_98##6	VGND#6	1.37141e-17
C17	a_27_74##7	A_N#4	3.69031e-17
C18	VGND#7	VGND#6	1.80579e-18
C19	a_266_98##5	B#3	2.27905e-17
C20	X#1	X#2	3.88576e-18
C21	a_266_98##5	a_27_74#	9.2052e-18
C22	VGND#7	a_266_98##6	2.18033e-17
C23	A_N#7	a_27_74##5	7.09387e-17
C24	a_27_74##7	a_266_98##6	2.98372e-18
C25	a_27_74##7	VGND#7	4.52314e-17
C26	B	a_27_74##2	4.91033e-20
C27	X#1	a_266_98#	3.61755e-17
C28	a_266_98##6	VPWR#7	7.2851e-18
C29	a_266_98#	VGND#6	2.03511e-17
C30	VPWR#6	X#2	9.2791e-17
C31	X#1	B#3	1.86267e-18
C32	a_266_98##5	a_27_74##4	1.65728e-18
C33	VGND#6	B#3	4.2963e-17
C34	a_266_98##7	X#2	2.7513e-18
C35	X#1	a_27_74#	3.59293e-19
C36	a_266_98##6	a_266_98#	5.49275e-19
C37	a_266_98##7	VPWR#6	5.57681e-17
C38	VGND#6	a_27_74#	5.94764e-18
C39	a_27_74##7	a_27_74##5	1.96611e-19
C40	A_N	a_27_74##2	1.46834e-20
C41	a_266_98##5	A_N#1	1.84182e-18
C42	VGND#7	a_266_98#	8.17426e-19
C43	a_266_98##6	B#3	3.46346e-18
C44	VPWR#7	VPWR#6	5.51373e-18
C45	VGND#6	A_N#3	6.90968e-19
C46	VGND#7	B#3	5.60198e-19
C47	a_266_98##6	a_27_74##2	7.0615e-18
C48	a_266_98##6	a_27_74#	3.19786e-17
C49	VPWR#7	a_266_98##7	7.57705e-17
C50	VGND#7	a_27_74#	3.33499e-18
C51	a_266_98##6	A_N#3	2.99028e-18
C52	a_27_74##7	a_27_74#	1.15595e-18
C53	A_N#3	VGND#7	2.3432e-17
C54	a_27_74##5	VPWR#7	6.02604e-17
C55	A_N#7	A_N#1	1.36489e-18
C56	a_27_74##7	A_N#3	3.46171e-17
C57	VGND#3	a_266_98##5	2.28465e-18
C58	a_266_98##5	a_266_98##2	3.26801e-18
C59	X#2	a_266_98##3	5.16467e-17
C60	B#3	a_266_98#	1.02862e-17
C61	a_266_98##3	VPWR#6	3.76811e-17
C62	a_266_98##5	B#2	6.6238e-18
C63	X#2	B#1	9.11521e-19
C64	a_266_98##2	B#4	2.89754e-17
C65	a_266_98##7	a_266_98##3	1.55086e-18
C66	B#1	VPWR#6	3.06928e-17
C67	a_27_74#	B#3	4.3017e-17
C68	VPWR	a_27_74##2	5.74502e-21
C69	X#2	a_27_74##4	1.21947e-19
C70	VPWR#7	a_266_98##3	1.22671e-18
C71	a_27_74##3	a_266_98##5	1.38917e-17
C72	a_266_98##7	B#1	4.87061e-17
C73	B#4	B#2	1.01031e-17
C74	VPWR#6	a_27_74##4	7.57435e-19
C75	VPWR#7	B#1	1.3106e-18
C76	a_266_98##7	a_27_74##4	4.44152e-17
C77	A_N#3	a_27_74#	2.97207e-18
C78	VPWR#6	A_N#1	3.6277e-19
C79	a_266_98##5	A_N#2	2.80798e-19
C80	a_27_74##4	VPWR#7	1.90334e-17
C81	a_266_98##2	X#1	3.9675e-17
C82	a_266_98##7	A_N#1	3.4648e-18
C83	VGND#3	a_266_98##6	1.15036e-17
C84	a_27_74##5	a_27_74##4	1.48844e-18
C85	a_266_98##2	VGND#6	3.97781e-17
C86	A_N#1	VPWR#7	2.58846e-17
C87	X#1	B#2	1.50942e-20
C88	a_27_74##5	A_N#1	3.76406e-17
C89	VGND#6	B#2	1.15389e-18
C90	VGND	a_27_74##2	2.23159e-18
C91	a_27_74##3	A_N#4	2.13712e-17
C92	a_266_98##7	VPWR#3	6.38225e-18
C93	a_266_98##5	a_353_98#	2.56115e-18
C94	a_266_98##2	X#2	6.05807e-17
C95	A_N#4	A_N#2	1.48425e-17
C96	a_266_98##2	VPWR#6	7.56399e-18
C97	B#1	a_266_98##3	2.35818e-17
C98	a_27_74##3	a_266_98##6	3.56387e-17
C99	X#2	B#2	9.38251e-20
C100	a_27_74##3	VGND#7	4.14908e-17
C101	B#2	VPWR#6	3.70304e-18
C102	a_266_98##7	B#2	1.12734e-18
C103	a_27_74##4	B#1	3.53053e-17
C104	VGND#3	B#3	3.45186e-20
C105	VGND#7	A_N#2	7.59334e-19
C106	a_266_98##2	a_266_98#	4.66283e-18
C107	a_27_74##7	A_N#2	5.10062e-18
C108	VGND#3	a_27_74#	5.34129e-18
C109	a_27_74##3	a_266_98##7	4.23912e-18
C110	B#3	a_266_98##2	4.47141e-19
C111	a_27_74##2	VNB	3.39778e-17
C112	a_27_74##3	VPWR#7	1.87567e-18
C113	A_N#1	a_27_74##4	4.58359e-17
C114	a_27_74##3	a_27_74##5	2.91903e-18
C115	a_266_98##5	B	6.39306e-18
C116	VPWR#3	a_27_74##4	4.39635e-18
C117	A_N#2	a_27_74##5	7.56656e-18
C118	a_27_74##3	a_27_74#	5.02153e-18
C119	a_27_74##3	A_N#3	2.24895e-17
C120	B#2	a_266_98##3	4.00416e-19
C121	VGND#3	A_N#1	1.22892e-19
C122	a_27_74##4	B#2	9.37121e-18
C123	B#3	a_353_98#	1.41674e-17
C124	a_27_74##3	a_27_74##4	1.16774e-18
C125	a_27_74#	a_353_98#	1.41674e-17
C126	a_27_74##3	A_N#1	4.05295e-17
C127	B	X#2	3.59514e-18
C128	B	VPWR#6	2.15114e-17
C129	a_266_98##7	B	2.07937e-17
C130	B#2	a_266_98##2	3.58476e-17
C131	VGND#3	a_27_74##3	2.56084e-19
C132	VPWR	A_N#7	5.09035e-18
C133	A_N	a_27_74##5	1.69421e-18
C134	VGND	a_266_98##5	7.00123e-18
C135	B	a_266_98##3	1.78184e-18
C136	a_27_74##3	A_N#2	4.20824e-17
C137	VGND	B#4	2.89359e-18
C138	B	B#1	3.77843e-18
C139	B	a_27_74##4	8.94927e-19
C140	VPWR	X#2	2.37144e-17
C141	VGND	A_N#4	4.35101e-18
C142	VPWR	VPWR#6	2.00627e-17
C143	VGND	X#1	1.85557e-17
C144	VPWR	a_266_98##7	1.4342e-17
C145	VPWR	a_27_74##5	2.99174e-17
C146	VGND	a_266_98##6	1.44736e-17
C147	A_N	A_N#1	8.90169e-20
C148	VGND	a_27_74##7	1.59821e-17
C149	B#4	VNB	2.71738e-18
C150	VGND	X#2	8.52879e-19
C151	A_N#7	VNB	1.40147e-17
C152	B	a_266_98##2	7.4131e-18
C153	A_N#4	VNB	1.25524e-17
C154	VGND	VPWR#7	2.52656e-18
C155	B	B#2	5.81931e-18
C156	X#1	VNB	4.60438e-17
C157	VPWR	a_266_98##3	3.72319e-18
C158	VGND#6	VNB	3.07381e-18
C159	VGND	a_266_98#	7.93487e-18
C160	VPWR	B#1	6.62551e-18
C161	a_266_98##6	VNB	7.4343e-18
C162	VGND	B#3	4.07956e-18
C163	VGND#7	VNB	7.94431e-18
C164	VPWR	a_27_74##4	6.69393e-18
C165	VGND	a_27_74#	9.45518e-18
C166	a_27_74##7	VNB	4.1955e-17
C167	VPWR#7	a_27_74##2	4.89809e-18
C168	VGND	A_N#3	7.92961e-19
C169	VPWR	A_N#1	6.69393e-18
C170	X#2	VNB	8.1005e-17
C171	A_N	a_27_74##3	1.35587e-17
C172	VPWR#6	VNB	7.7905e-18
C173	a_266_98##7	VNB	3.62413e-18
C174	A_N	A_N#2	1.66141e-17
C175	VPWR#7	VNB	1.10981e-17
C176	VPWR	VPWR#3	1.13428e-17
C177	a_27_74##5	VNB	2.43337e-17
C178	a_266_98#	VNB	3.806e-17
C179	B#3	VNB	2.60334e-17
C180	VGND	A_N#1	6.16224e-19
C181	VPWR	a_266_98##2	3.01927e-18
C182	a_27_74#	VNB	2.77312e-17
C183	A_N#3	VNB	4.66755e-17
C184	VPWR	a_27_74##3	2.66824e-19
C185	a_266_98##3	VNB	4.27223e-17
C186	VGND	VGND#3	1.7333e-17
C187	B#1	VNB	3.35216e-17
C188	VGND	a_266_98##2	6.72583e-18
C189	a_27_74##4	VNB	3.75895e-17
C190	A_N#1	VNB	5.2053e-17
C191	VGND	a_27_74##3	8.62501e-18
C192	VPWR#3	VNB	1.69064e-16
C193	VGND#3	VNB	1.7629e-16
C194	a_266_98##2	VNB	4.41972e-17
C195	B#2	VNB	3.15708e-17
C196	a_27_74##3	VNB	4.8756e-17
C197	VPWR	B	3.32251e-18
C198	A_N#2	VNB	6.6497e-17
C199	B	VNB	1.17334e-18
C200	A_N	VNB	1.09138e-17
C201	VPWR	VNB	5.93704e-17
C202	VGND	VNB	6.47625e-17
C203	VGND#2	VNB	5.97245e-17
C204	VGND	VGND#2	7.93519e-17
C205	VGND#2	a_266_98##2	7.90462e-19
C206	VGND#3	VGND#2	6.1567e-17
C207	VGND#2	A_N#3	5.43151e-19
C208	VGND#2	B#3	2.93533e-18
C209	VGND#2	a_266_98#	1.04286e-17
C210	VGND#7	VGND#2	1.11716e-18
C211	VGND#2	X#1	1.98438e-17
C212	VGND#2	a_266_98##5	5.74545e-19
C213	VGND#4	VGND#2	5.94455e-19
C214	VPWR#4	VPWR#6	2.90837e-18
C215	VGND#4	VNB	5.11727e-17
C216	VGND	VGND#4	5.69024e-17
C217	VPWR#4	a_266_98##3	1.31164e-18
C218	a_266_98##2	VPWR#2	3.20086e-19
C219	VPWR#2	VNB	5.14793e-17
C220	VPWR#4	A_N#2	3.26616e-19
C221	VGND#4	A_N#2	9.69473e-20
C222	VGND#4	a_27_74##3	3.94655e-18
C223	VPWR#4	VNB	7.07738e-17
C224	VPWR#4	a_27_74##3	3.3772e-19
C225	VGND#3	VGND#4	5.49108e-17
C226	a_266_98##7	VPWR#2	7.89657e-19
C227	VPWR#3	VPWR#2	5.74442e-17
C228	VPWR	VPWR#2	3.9831e-17
C229	VGND#4	A_N#1	3.30862e-19
C230	VPWR#4	VPWR#2	9.37947e-19
C231	VPWR	VPWR#4	6.05768e-17
C232	VGND#4	A_N#3	6.01156e-18
C233	X#2	VPWR#2	2.85352e-17
C234	B	VPWR#2	4.3576e-19
C235	VGND#4	a_27_74##7	2.08791e-17
C236	VPWR#2	B#1	4.65961e-18
C237	VPWR#3	VPWR#4	6.64119e-17
C238	VPWR#2	a_266_98##3	4.62988e-18
C239	a_27_74##5	VPWR#4	2.12056e-17
C240	VPWR#4	A_N#1	5.44389e-18
*
*
.ENDS sky130_fd_sc_hs__and2b_1
*
