* Extracted by Quantus, converted by sky130cad/quantus.py
*
*
*
*                       LINUX           Wed Nov 18 08:30:11 2026
*
*
*
*  PROGRAM  advgen
*
*  Name           : advgen - Quantus - (64-bit)
*  Version        : 25.1.0-p047
*  Build Date     : Thu Dec 11 23:20:30 PST 2025
*
*  HSPICE LIBRARY
*
*  OPERATING_TEMPERATURE 150
*  QRC_TECH_DIR <path>/tech
*
*
*

*
.SUBCKT sky130_fd_sc_hs__dlclkp_1 VPB VNB VGND VPWR GCLK GATE CLK
*
*
*  caps2d version: 10
*
*
*       TRANSISTOR CARDS
*
*
XM17 a_27_74##7 a_83_260##3 VGND#10 VNB sky130_fd_pr__nfet_01v8_lvt l=0.15 w=0.74 ad=0.2109 as=0.43945 pd=2.05 ps=2.83
XM8 VGND#10 GATE#1 a_267_80# VNB sky130_fd_pr__nfet_01v8_lvt l=0.15 w=0.64 ad=0.43945 as=0.1536 pd=2.83 ps=1.76
XM3 a_267_80# a_315_54##2 a_83_260##6 VNB sky130_fd_pr__nfet_01v8_lvt l=0.15 w=0.64 ad=0.1536 as=0.2692 pd=1.76 ps=2.3
XM15 a_83_260##6 a_309_338# a_477_124# VNB sky130_fd_pr__nfet_01v8_lvt l=0.15 w=0.42 ad=0.2692 as=0.1008 pd=2.3 ps=1.32
XM6 a_477_124# a_27_74##4 VGND#9 VNB sky130_fd_pr__nfet_01v8_lvt l=0.15 w=0.42 ad=0.1008 as=0.283775 pd=1.32 ps=2.46
XM11 VGND#9 a_315_54##5 a_309_338##7 VNB sky130_fd_pr__nfet_01v8_lvt l=0.15 w=0.74 ad=0.283775 as=0.2109 pd=2.46 ps=2.05
XM19 a_315_54##8 CLK#6 VGND#6 VNB sky130_fd_pr__nfet_01v8_lvt l=0.15 w=0.74 ad=0.2183 as=0.2589 pd=2.07 ps=2.2
XM4 VGND#6 CLK#5 a_984_125# VNB sky130_fd_pr__nfet_01v8_lvt l=0.15 w=0.64 ad=0.2589 as=0.1536 pd=2.2 ps=1.76
XM13 a_984_125# a_27_74##2 a_987_393##8 VNB sky130_fd_pr__nfet_01v8_lvt l=0.15 w=0.64 ad=0.1536 as=0.1824 pd=1.76 ps=1.85
XM18 VGND#5 a_987_393# GCLK#1 VNB sky130_fd_pr__nfet_01v8_lvt l=0.15 w=0.74 ad=0.2109 as=0.2109 pd=2.05 ps=2.05
XM0 a_27_74##9 a_83_260# VPWR#11 VPB sky130_fd_pr__pfet_01v8 l=0.15 w=1.12 ad=0.3304 as=0.5918 pd=2.83 ps=3.36
XM10 VPWR#11 GATE#3 a_258_392# VPB sky130_fd_pr__pfet_01v8 l=0.15 w=1 ad=0.5918 as=0.27 pd=3.36 ps=2.54
XM1 a_258_392# a_309_338##3 a_83_260##4 VPB sky130_fd_pr__pfet_01v8 l=0.15 w=1 ad=0.27 as=0.3889 pd=2.54 ps=3.12
XM2 a_83_260##4 a_315_54##3 a_484_508# VPB sky130_fd_pr__pfet_01v8 l=0.15 w=0.42 ad=0.3889 as=0.1134 pd=3.12 ps=1.38
XM9 a_484_508# a_27_74##5 VPWR#10 VPB sky130_fd_pr__pfet_01v8 l=0.15 w=0.42 ad=0.1134 as=0.29995 pd=1.38 ps=2.73
XM14 VPWR#10 a_315_54##7 a_309_338##4 VPB sky130_fd_pr__pfet_01v8 l=0.15 w=0.84 ad=0.29995 as=0.2478 pd=2.73 ps=2.27
XM7 a_315_54##9 CLK#4 VPWR#9 VPB sky130_fd_pr__pfet_01v8 l=0.15 w=0.84 ad=0.2478 as=0.3276 pd=2.27 ps=2.46
XM12 VPWR#9 CLK#1 a_987_393##7 VPB sky130_fd_pr__pfet_01v8 l=0.15 w=0.84 ad=0.3276 as=0.2604 pd=2.46 ps=2.3
XM5 a_987_393##7 a_27_74# VPWR#8 VPB sky130_fd_pr__pfet_01v8 l=0.15 w=0.84 ad=0.2604 as=0.6636 pd=2.3 ps=3.59
XM16 VPWR#8 a_987_393##4 GCLK#2 VPB sky130_fd_pr__pfet_01v8 l=0.15 w=1.12 ad=0.6636 as=0.3304 pd=3.59 ps=2.83
*
*
*       RESISTOR AND CAP/DIODE CARDS
*
Rg1	a_83_260#	a_83_260##2	454.637054
Rg2	a_83_260##2	a_83_260##3	351.636841
Rg3	GATE#1	GATE#2	462.880432
Rg4	GATE#2	GATE#3	400.207520
Rg5	a_315_54#	a_315_54##2	311.736206
Rg6	a_315_54##3	a_315_54##4	394.020355
Rg7	a_309_338#	a_309_338##2	417.197662
Rg8	a_309_338##2	a_309_338##3	682.876648
Rg9	a_315_54##5	a_315_54##6	334.702850
Rg10	a_315_54##6	a_315_54##7	362.477081
Rg11	CLK#1	CLK#2	346.734436
Rg12	CLK#2	CLK#3	46.028751
Rg13	CLK#3	CLK#4	346.691864
Rg14	CLK#2	CLK#5	342.352264
Rg15	CLK#3	CLK#6	333.642395
Rg16	a_27_74#	a_27_74##2	844.136108
Rg17	a_27_74##2	a_27_74##3	1744.920288
Rg18	a_27_74##3	a_27_74##4	216.119781
Rg19	a_27_74##4	a_27_74##5	1031.662109
Rg20	a_987_393#	a_987_393##2	389.052795
Rg21	a_987_393##2	a_987_393##3	52.258068
Rg22	a_987_393##2	a_987_393##4	475.629547
Rf1	GATE#2	GATE	161.413818
Rf2	a_83_260##4	a_83_260##5	160.612183
Rf3	a_83_260##5	a_83_260##6	117.758438
Rf4	a_27_74##3	a_27_74##8	369.786682
Rf5	a_27_74##8	a_27_74##9	96.778053
Rf6	a_27_74##7	a_27_74##8	7.500000
Rf7	a_309_338##4	a_309_338##5	76.974602
Rf8	a_309_338##5	a_309_338##2	253.667816
Rf9	a_309_338##5	a_309_338##7	19.685410
Rf10	a_315_54##8	a_315_54##10	69.560699
Rf11	a_315_54##10	a_315_54##11	81.878510
Rf12	a_315_54##11	a_315_54##4	28.758804
Rf13	a_315_54##4	a_315_54#	214.904678
Rf14	a_315_54##11	a_315_54##6	193.673889
Rf15	a_315_54##9	a_315_54##10	7.500000
Rf16	CLK	CLK#7	11.219672
Rf17	CLK#7	CLK	7.676618
Rf18	a_987_393##3	a_987_393##6	170.291138
Rf19	a_987_393##6	a_987_393##7	77.386612
Rf20	a_987_393##6	a_987_393##8	30.872488
Rf21	GCLK#1	GCLK	43.580002
Rf22	GCLK	GCLK#3	11.956982
Rf23	GCLK#3	GCLK	0.163794
Rf24	GCLK#2	GCLK#3	5.000000
Rf26	VGND#2	VGND#3	103.739990
Rf27	VGND#3	VGND#4	86.905556
Rf28	VGND#2	VGND#5	41.038895
Rf29	VGND#3	VGND#6	41.770222
Rf30	VGND#4	VGND#7	192.411301
Rf32	VGND#4	VGND#9	79.420441
Rf33	VGND#7	VGND#10	33.957520
Rf35	VPWR#2	VPWR#3	93.090317
Rf36	VPWR#3	VPWR#4	90.192833
Rf37	VPWR#4	VPWR#5	26.273645
Rf38	VPWR#5	VPWR#6	162.123032
Rf40	VPWR#2	VPWR#8	35.825584
Rf41	VPWR#3	VPWR#9	40.786041
Rf42	VPWR#5	VPWR#10	31.948624
Rf43	VPWR#6	VPWR#11	31.141060
Rf51	CLK#2	CLK#7	160.232803
Rf45	a_83_260##2	a_83_260##5	160.232803
Re1	VPWR#4	VPWR	0.701577
Re2	VGND	VGND#4	0.701602
*
*       CAPACITOR CARDS
*
*
C1	a_309_338##5	CLK#6	6.40971e-18
C2	GCLK#1	a_987_393#	3.40062e-17
C3	a_987_393#	VGND#5	2.12678e-17
C4	VPWR#3	CLK#1	3.40154e-18
C5	a_309_338##5	a_315_54##5	2.81695e-17
C6	GCLK#1	a_27_74##2	2.16987e-18
C7	a_987_393##7	VPWR#8	5.73472e-17
C8	a_987_393##6	CLK#3	2.88267e-18
C9	a_987_393##8	a_987_393#	2.83749e-18
C10	VGND#5	a_27_74##2	5.02871e-18
C11	a_309_338##5	a_27_74##4	1.32689e-18
C12	VPWR#9	VPWR#8	4.1105e-18
C13	VPWR#3	CLK#4	2.74069e-18
C14	a_987_393##8	a_27_74##2	4.95619e-17
C15	a_83_260##6	a_83_260##4	7.37061e-18
C16	VGND#5	CLK#5	3.32302e-19
C17	VGND#6	a_987_393#	9.95844e-19
C18	VPWR#9	a_987_393##7	7.44745e-17
C19	a_309_338##5	a_309_338#	4.35287e-19
C20	a_987_393##8	CLK#5	4.79248e-18
C21	a_987_393##6	a_987_393##4	1.79061e-18
C22	VGND#5	CLK#6	2.32243e-19
C23	VGND#6	a_27_74##2	9.16399e-18
C24	a_309_338##5	a_315_54##2	1.11311e-19
C25	a_987_393##8	CLK#6	1.9357e-18
C26	VPWR#5	a_27_74##5	4.22474e-18
C27	a_315_54##8	a_27_74##2	3.33735e-19
C28	a_315_54##9	VPWR#9	7.66453e-17
C29	VGND#6	CLK#5	2.08147e-17
C30	a_987_393##6	a_27_74#	8.10403e-18
C31	VPWR#3	a_27_74##5	3.08708e-19
C32	a_315_54##8	CLK#5	2.47489e-19
C33	VGND#6	CLK#6	4.20169e-17
C34	VPWR#5	a_315_54##3	7.95991e-18
C35	VGND#9	a_27_74##2	2.98704e-19
C36	a_315_54##9	a_309_338##4	6.56359e-17
C37	VPWR#10	VPWR#9	2.9499e-18
C38	CLK#6	a_315_54##8	1.39349e-17
C39	VGND#6	a_315_54##5	2.39202e-18
C40	VPWR#10	a_315_54##9	4.71342e-18
C41	VPWR#5	a_309_338##3	4.63307e-21
C42	a_315_54##8	a_315_54##5	6.04918e-19
C43	a_27_74##7	a_27_74##9	3.85402e-18
C44	VGND#9	CLK#6	1.13095e-18
C45	a_315_54##5	a_309_338##7	1.57905e-17
C46	VGND#9	a_315_54##5	3.51072e-17
C47	a_83_260##4	a_315_54##9	1.16302e-18
C48	a_83_260##6	CLK#6	2.34748e-19
C49	VGND#9	a_27_74##4	2.78896e-17
C50	a_83_260##6	a_315_54##5	5.4854e-19
C51	a_83_260##4	VPWR#10	6.46471e-18
C52	a_315_54##11	CLK#4	5.52567e-19
C53	VGND#9	a_309_338#	3.19646e-18
C54	VGND#3	VGND#5	1.39507e-18
C55	a_83_260##6	a_27_74##4	2.68417e-18
C56	a_987_393##7	a_27_74##2	3.3789e-18
C57	VGND#9	a_315_54##2	4.563e-19
C58	a_315_54##11	a_315_54##7	1.62124e-17
C59	a_83_260##6	a_309_338#	3.20344e-17
C60	a_27_74##7	a_315_54##5	1.83404e-19
C61	VGND#9	GATE#1	2.67667e-19
C62	VPWR#4	VPWR#5	5.33246e-17
C63	a_315_54##11	a_27_74##5	2.1447e-17
C64	a_83_260##6	a_315_54##2	4.42141e-17
C65	a_27_74##7	a_27_74##4	1.58123e-19
C66	VPWR#4	VPWR#3	5.19202e-17
C67	VPWR#11	a_83_260##4	2.39981e-17
C68	CLK#3	a_27_74#	1.09406e-17
C69	a_83_260##6	GATE#1	1.11355e-17
C70	a_27_74##7	a_309_338#	7.43658e-19
C71	a_315_54##11	a_315_54##3	4.81154e-19
C72	a_27_74##9	a_83_260##4	1.71735e-18
C73	a_27_74##7	a_315_54##2	2.60651e-18
C74	a_83_260##6	a_83_260##3	6.82131e-19
C75	GATE#1	VGND#10	2.30958e-17
C76	a_315_54##11	a_309_338##3	1.20319e-19
C77	a_309_338##5	a_315_54##11	1.08708e-18
C78	a_27_74##9	VPWR#11	6.61408e-17
C79	a_27_74##7	GATE#1	2.81527e-17
C80	a_83_260##3	VGND#10	2.14124e-17
C81	VGND#3	a_315_54##8	3.1273e-18
C82	a_315_54##11	GATE#3	9.67831e-20
C83	a_27_74##7	a_83_260##3	5.55072e-17
C84	VGND#4	VGND#3	5.46382e-17
C85	VPWR#9	CLK#3	6.25213e-18
C86	a_27_74##2	a_987_393#	6.19254e-18
C87	a_987_393##4	GCLK#2	1.19331e-17
C88	a_987_393##4	VPWR#8	3.47845e-17
C89	a_315_54##11	VPWR#4	3.85436e-18
C90	a_27_74##2	CLK#5	6.89501e-17
C91	a_987_393##6	a_987_393##3	1.99836e-19
C92	VGND#6	a_987_393##6	8.95056e-19
C93	a_987_393##7	a_987_393##4	4.49576e-18
C94	a_27_74#	VPWR#8	3.00548e-17
C95	VPWR#9	a_987_393##4	9.10649e-19
C96	a_27_74##2	CLK#6	1.34578e-17
C97	a_315_54##7	CLK#3	5.02189e-19
C98	a_315_54##9	CLK#3	3.80974e-18
C99	a_987_393##7	a_27_74#	5.78749e-17
C100	VPWR#8	CLK#1	4.59843e-19
C101	a_315_54##8	a_987_393##6	2.37702e-18
C102	CLK#6	CLK#5	2.46844e-17
C103	VPWR#5	a_309_338##2	2.52863e-19
C104	VPWR#9	a_27_74#	1.59939e-18
C105	a_987_393##7	CLK#1	4.36233e-17
C106	VGND#3	a_27_74##3	8.1545e-18
C107	a_315_54##9	a_27_74#	2.89416e-19
C108	VPWR#8	CLK#4	2.75935e-19
C109	CLK#1	VPWR#9	2.54025e-17
C110	VGND#4	a_309_338##5	7.51457e-18
C111	a_987_393##6	a_315_54##6	1.50633e-19
C112	a_315_54##5	CLK#6	4.70868e-18
C113	a_315_54##4	VPWR#5	3.68979e-18
C114	CLK#4	VPWR#9	3.14115e-17
C115	a_83_260##6	a_309_338##3	3.68865e-18
C116	a_309_338##4	CLK#3	4.02452e-19
C117	a_309_338##5	CLK#3	3.85525e-19
C118	a_315_54##9	CLK#4	6.45605e-17
C119	VPWR#3	VPWR#8	2.51823e-19
C120	VPWR#10	CLK#1	2.12906e-19
C121	VPWR#9	a_315_54##7	1.388e-18
C122	a_27_74##4	a_315_54##5	2.14381e-17
C123	a_309_338##4	CLK#4	6.03261e-19
C124	a_315_54##9	a_315_54##7	5.07907e-18
C125	a_315_54##6	a_315_54##11	2.53711e-18
C126	VPWR#10	CLK#4	1.4037e-18
C127	VPWR#9	a_27_74##5	4.82583e-19
C128	a_309_338##4	a_315_54##7	2.37504e-17
C129	a_987_393##7	VPWR#3	8.89241e-18
C130	a_309_338#	a_27_74##4	4.28436e-17
C131	a_315_54##9	a_27_74##5	8.6445e-19
C132	GCLK#1	a_987_393##3	8.43374e-18
C133	a_315_54##7	VPWR#10	1.50779e-17
C134	a_309_338##5	a_315_54##6	5.94283e-17
C135	a_987_393##3	VGND#5	3.28134e-17
C136	a_83_260##4	CLK#4	1.42247e-19
C137	a_315_54##11	a_27_74##3	3.06793e-19
C138	a_309_338##4	a_27_74##5	5.74401e-19
C139	VGND#4	VGND#6	9.06215e-19
C140	VPWR#5	VPWR#3	3.52351e-19
C141	a_987_393##8	a_987_393##3	4.03515e-19
C142	a_315_54##9	a_315_54##3	1.1418e-19
C143	VPWR#10	a_27_74##5	2.59749e-17
C144	a_83_260##4	a_315_54##7	5.07294e-19
C145	a_315_54##2	a_309_338#	1.33141e-17
C146	a_309_338##5	a_27_74##3	1.09455e-17
C147	a_309_338##2	a_315_54##11	2.79587e-18
C148	VGND#4	VGND#9	1.39982e-18
C149	VPWR#10	a_315_54##3	4.10291e-18
C150	a_83_260##4	a_27_74##5	2.22599e-18
C151	GATE#1	a_315_54##2	4.21615e-17
C152	VPWR#10	a_309_338##3	1.13384e-18
C153	a_309_338##2	a_309_338##5	1.55764e-18
C154	a_315_54##9	VPWR#3	1.19836e-17
C155	a_83_260##4	a_315_54##3	3.2551e-17
C156	a_315_54##4	a_315_54##11	7.35693e-19
C157	VPWR#11	a_27_74##5	5.36849e-19
C158	VPWR#10	GATE#3	4.57262e-19
C159	a_83_260##4	a_309_338##3	6.01701e-17
C160	a_83_260##3	GATE#1	1.16233e-17
C161	VPWR#11	a_315_54##3	7.98961e-19
C162	a_309_338##5	VGND#6	1.54698e-17
C163	a_315_54##8	a_315_54##6	6.00727e-19
C164	a_83_260##4	GATE#3	1.73801e-17
C165	VPWR#11	a_309_338##3	3.61568e-18
C166	VGND#6	a_27_74##3	8.78402e-19
C167	VGND#9	a_315_54##6	5.51604e-19
C168	a_309_338##5	a_315_54##8	6.43354e-17
C169	a_27_74##9	a_309_338##3	2.46652e-19
C170	a_315_54##8	a_27_74##3	6.37833e-18
C171	a_315_54##9	VPWR#4	5.44571e-18
C172	a_83_260##4	a_83_260#	4.12394e-18
C173	GATE#3	VPWR#11	2.89014e-17
C174	a_987_393##3	VPWR#8	2.89582e-17
C175	VPWR#10	VPWR#3	1.52593e-19
C176	VGND#5	GCLK#1	7.04433e-17
C177	a_27_74##3	VGND#9	3.7368e-17
C178	a_27_74##9	GATE#3	2.43335e-18
C179	a_83_260#	VPWR#11	4.03759e-17
C180	a_309_338##5	a_309_338##7	9.05349e-18
C181	a_27_74##3	a_83_260##6	5.64913e-17
C182	a_27_74##9	a_83_260#	4.99954e-17
C183	a_27_74##4	a_27_74##5	6.91855e-19
C184	VGND#9	a_309_338##2	1.10165e-17
C185	a_987_393##8	GCLK#1	4.40064e-18
C186	VGND#10	a_27_74##3	1.95308e-19
C187	a_309_338##5	VGND#9	6.12383e-17
C188	a_27_74#	a_987_393##4	1.30295e-17
C189	a_83_260##6	a_309_338##2	1.36763e-17
C190	a_27_74##7	a_27_74##3	1.2194e-18
C191	a_83_260##4	VPWR#5	1.32821e-17
C192	a_987_393##8	VGND#5	3.95758e-17
C193	a_83_260##6	a_315_54##4	3.11065e-18
C194	a_315_54##9	a_315_54##6	2.27262e-19
C195	CLK#1	a_27_74#	3.47302e-17
C196	a_315_54##6	a_309_338##4	2.50967e-17
C197	a_315_54##6	VPWR#10	7.25157e-19
C198	a_315_54#	a_83_260##6	7.06252e-17
C199	CLK#4	CLK#1	2.58135e-17
C200	VGND#4	a_27_74##2	2.46994e-19
C201	a_83_260##6	a_309_338##5	1.96768e-18
C202	a_309_338##4	a_27_74##3	1.46283e-19
C203	VGND#6	VGND#5	4.02116e-18
C204	a_83_260##6	GATE#2	3.81704e-18
C205	a_27_74##2	a_987_393##3	1.87272e-17
C206	CLK	CLK#3	3.10679e-17
C207	a_315_54##7	CLK#4	4.6095e-18
C208	VGND#4	a_315_54##5	4.68398e-19
C209	VGND#6	a_987_393##8	2.25562e-17
C210	a_27_74##7	GATE#2	7.56956e-19
C211	a_315_54##9	a_987_393##6	1.10249e-18
C212	a_309_338##2	a_83_260##4	9.56203e-19
C213	VGND#4	a_309_338#	1.11547e-18
C214	a_27_74##5	a_315_54##7	3.53874e-17
C215	a_83_260##2	VGND#10	2.0081e-18
C216	a_27_74##7	a_83_260##2	1.04261e-16
C217	a_315_54##4	a_83_260##4	1.07872e-16
C218	a_315_54##3	a_27_74##5	2.87353e-17
C219	a_83_260##4	a_315_54#	3.41773e-19
C220	a_309_338##3	a_27_74##5	1.03163e-18
C221	a_27_74##4	a_315_54##6	3.72747e-17
C222	a_27_74##3	a_315_54##5	2.11412e-17
C223	a_309_338##3	a_315_54##3	1.11055e-17
C224	a_309_338##2	CLK#6	3.36969e-20
C225	a_27_74##3	a_27_74##4	2.24864e-18
C226	a_315_54##8	VGND#6	3.34541e-17
C227	a_309_338##2	a_315_54##5	1.10903e-19
C228	a_309_338#	a_27_74##3	2.32968e-17
C229	a_309_338##2	a_27_74##4	6.96438e-17
C230	a_27_74##3	a_315_54##2	1.66162e-17
C231	GATE#3	a_309_338##3	5.05438e-17
C232	a_27_74#	a_987_393##3	5.37047e-19
C233	a_27_74##9	GATE#2	1.30704e-19
C234	VPWR#4	a_315_54##7	6.39015e-18
C235	a_309_338##2	a_309_338#	6.73179e-18
C236	a_27_74##3	GATE#1	1.33769e-19
C237	a_315_54##4	a_27_74##4	1.84656e-18
C238	a_83_260##2	VPWR#11	4.41534e-17
C239	a_83_260##3	a_27_74##3	7.83942e-20
C240	a_27_74##9	a_83_260##2	4.77149e-17
C241	a_83_260#	GATE#3	1.77449e-17
C242	VPWR#3	a_27_74##2	6.84145e-20
C243	a_315_54#	a_309_338#	1.17089e-17
C244	VGND#9	VGND#6	1.86717e-18
C245	a_315_54##11	a_315_54##9	4.66531e-18
C246	a_315_54##6	CLK#4	1.57931e-20
C247	VPWR#11	a_484_508#	4.34155e-20
C248	GATE#1	a_315_54#	8.84927e-18
C249	a_315_54##6	a_315_54##7	1.63974e-18
C250	a_83_260##4	a_258_392#	1.72214e-17
C251	a_27_74##5	a_315_54##6	2.58374e-18
C252	a_315_54##11	a_309_338##4	4.02163e-17
C253	VGND#3	a_987_393#	4.3929e-19
C254	VPWR	CLK#3	8.16477e-20
C255	a_315_54##6	a_309_338##3	2.19602e-19
C256	a_83_260##2	GATE#1	7.32911e-18
C257	a_27_74##2	CLK#3	1.78761e-17
C258	a_309_338##2	a_27_74##5	7.66854e-19
C259	a_83_260##2	a_83_260##3	2.18855e-18
C260	a_315_54##4	a_315_54##7	2.30757e-19
C261	a_27_74##3	a_309_338##3	1.34256e-19
C262	a_315_54##11	VPWR#10	2.71751e-17
C263	a_315_54##4	a_27_74##5	4.6281e-17
C264	CLK	VPWR#3	3.32275e-19
C265	VGND#3	a_27_74##2	4.75576e-17
C266	a_315_54##4	a_309_338##3	2.5542e-17
C267	VGND#9	a_267_80#	1.49759e-20
C268	VGND#3	CLK	1.50487e-18
C269	a_27_74##2	a_984_125#	1.50481e-17
C270	a_315_54##4	GATE#3	1.40846e-18
C271	CLK#5	a_984_125#	1.50481e-17
C272	a_83_260##6	a_267_80#	1.3414e-18
C273	a_315_54#	a_309_338##3	3.09061e-17
C274	a_309_338##5	a_309_338##4	2.58495e-18
C275	a_315_54##4	a_83_260#	9.0018e-20
C276	CLK	a_987_393##6	3.24025e-17
C277	VGND#4	a_27_74##3	1.28281e-16
C278	a_83_260##2	a_27_74##5	1.18689e-20
C279	a_27_74##7	a_267_80#	5.05994e-19
C280	GATE#2	a_309_338##3	1.96672e-17
C281	VGND	CLK#3	8.33255e-19
C282	VGND#3	CLK#5	4.19318e-18
C283	VGND#6	CLK#3	5.35794e-18
C284	VGND#4	a_309_338##2	7.26028e-20
C285	VPWR#5	a_27_74##4	9.62189e-20
C286	a_83_260##2	a_309_338##3	2.37921e-19
C287	a_83_260#	GATE#2	3.18521e-18
C288	a_83_260##4	a_315_54##11	2.67779e-18
C289	a_83_260##6	VGND#9	1.06271e-17
C290	a_83_260##2	GATE#3	1.67981e-17
C291	a_27_74##4	a_477_124#	9.87534e-18
C292	a_27_74##3	a_315_54##6	1.28584e-18
C293	a_27_74##5	a_484_508#	1.06762e-17
C294	a_309_338#	a_477_124#	9.87534e-18
C295	a_83_260##2	a_83_260#	5.73282e-18
C296	a_315_54##3	a_484_508#	1.06762e-17
C297	a_309_338##2	a_315_54##6	1.73723e-17
C298	VGND#3	CLK#6	2.33843e-18
C299	a_27_74##3	a_309_338##2	1.22403e-17
C300	a_315_54##4	a_315_54##6	1.77998e-18
C301	VGND#6	CLK	2.97349e-17
C302	a_309_338##3	a_258_392#	5.53384e-18
C303	a_315_54##8	CLK	2.10984e-17
C304	GATE#3	a_258_392#	1.33344e-17
C305	a_315_54##4	a_309_338##2	7.6592e-17
C306	a_987_393##8	a_987_393##7	2.62178e-19
C307	a_27_74##3	a_315_54#	7.06521e-19
C308	a_987_393##6	GCLK	5.13111e-18
C309	a_987_393##6	a_27_74##2	1.4689e-17
C310	CLK#3	VNB	5.35472e-17
C311	a_315_54##6	CLK#3	5.67884e-18
C312	a_315_54#	a_309_338##2	8.09431e-17
C313	CLK#6	CLK#3	2.0243e-18
C314	a_315_54##8	CLK#3	7.56029e-18
C315	VPWR	VPWR#5	3.74471e-17
C316	VPWR	VPWR#3	5.62041e-17
C317	GATE#2	a_309_338##2	1.58074e-18
C318	CLK	a_987_393##7	2.98122e-17
C319	a_315_54##2	a_267_80#	1.0848e-17
C320	CLK	VPWR#9	3.68202e-17
C321	GATE#1	a_267_80#	4.52009e-18
C322	a_315_54##4	GATE#2	3.41032e-19
C323	a_315_54##9	CLK	3.03726e-18
C324	a_83_260##6	GATE	5.41147e-18
C325	a_315_54##11	VPWR#5	4.31308e-19
C326	GATE#2	a_315_54#	1.74537e-17
C327	a_83_260##2	a_315_54##4	1.53142e-18
C328	VPWR	a_987_393##6	8.53413e-19
C329	a_987_393##6	CLK#5	3.8576e-19
C330	a_83_260##2	a_315_54#	2.39296e-18
C331	VPWR	a_315_54##11	1.02574e-17
C332	a_83_260##2	GATE#2	3.53486e-17
C333	CLK	a_27_74##2	7.42788e-18
C334	GATE	a_83_260##4	8.24962e-18
C335	VGND	VGND#3	5.8642e-17
C336	GCLK	GCLK#2	5.52502e-18
C337	VPWR#8	GCLK	9.78179e-17
C338	GATE	VPWR#11	9.4845e-19
C339	a_987_393##7	GCLK	1.16207e-18
C340	a_987_393##6	CLK#6	3.42691e-19
C341	VGND#6	VPWR#9	1.27036e-18
C342	a_27_74##3	CLK#3	9.43547e-19
C343	a_315_54##5	CLK#3	6.52085e-20
C344	VGND	a_309_338##5	1.68213e-17
C345	a_27_74##7	a_83_260##6	4.30688e-17
C346	CLK	a_27_74#	2.61708e-18
C347	VPWR	VPWR#8	2.06162e-17
C348	VPWR	a_987_393##7	1.99234e-17
C349	VGND	GCLK#1	2.04417e-17
C350	VPWR#5	VNB	4.29771e-17
C351	VPWR#3	VNB	4.45757e-17
C352	VGND	a_987_393##8	1.32669e-17
C353	VPWR	a_315_54##9	2.17986e-17
C354	VPWR	a_309_338##4	4.23266e-18
C355	VPWR	VPWR#10	1.59779e-17
C356	VGND#3	VNB	3.6331e-17
C357	VGND	a_315_54##8	7.95685e-18
C358	VGND	VGND#9	5.43455e-18
C359	VPWR	a_83_260##4	2.93638e-17
C360	a_27_74##3	a_267_80#	4.8005e-19
C361	a_987_393##6	VNB	2.88896e-18
C362	VGND	a_83_260##6	1.53537e-17
C363	VPWR	VPWR#11	2.24514e-17
C364	a_987_393##6	a_315_54##5	2.14407e-19
C365	VPWR	a_27_74##9	1.92965e-17
C366	VGND	VGND#10	1.18613e-17
C367	VGND	a_27_74##7	3.79046e-17
C368	a_315_54##11	VNB	1.92801e-18
C369	VGND	VPWR#8	3.08481e-18
C370	a_309_338##5	VNB	1.48617e-17
C371	GCLK	a_987_393##4	3.66778e-17
C372	GCLK	a_27_74#	3.3218e-18
C373	GATE	a_309_338##3	3.59166e-18
C374	GCLK#1	VNB	4.35229e-17
C375	VGND#5	VNB	1.02798e-17
C376	a_987_393##8	VNB	9.67488e-18
C377	GATE	a_83_260#	6.99084e-19
C378	VGND#6	VNB	5.30785e-18
C379	a_315_54##8	VNB	9.76588e-18
C380	VGND	a_27_74##9	1.38656e-18
C381	VGND#9	VNB	3.25185e-18
C382	VGND	a_987_393#	2.74515e-18
C383	CLK	a_315_54##6	6.6897e-19
C384	VPWR	a_987_393##4	6.00536e-18
C385	a_83_260##6	VNB	4.28171e-18
C386	VGND	a_27_74##2	1.43341e-17
C387	VGND	CLK#5	3.87829e-18
C388	VPWR	a_27_74#	8.94079e-18
C389	VGND#10	VNB	1.34299e-18
C390	VGND	CLK#6	2.54316e-18
C391	a_27_74##7	VNB	6.42387e-17
C392	VPWR	CLK#1	5.54765e-18
C393	VGND	a_315_54##5	2.24021e-18
C394	a_27_74##7	VGND#10	9.42323e-17
C395	VPWR	CLK#4	7.93523e-18
C396	VPWR#8	VNB	7.70906e-18
C397	a_987_393##7	VNB	3.1466e-18
C398	VPWR	a_315_54##7	6.92116e-18
C399	VPWR#9	VNB	8.59732e-18
C400	a_315_54##9	VNB	1.8431e-17
C401	VGND	a_315_54##2	2.21613e-18
C402	VPWR	a_27_74##5	8.01195e-19
C403	a_309_338##4	VNB	5.92423e-18
C404	VPWR	a_315_54##3	1.7972e-18
C405	VPWR#10	VNB	5.0633e-18
C406	a_309_338##2	CLK#3	1.60826e-20
C407	VGND	a_83_260##3	1.30967e-18
C408	VPWR	a_309_338##3	4.76223e-18
C409	GCLK	a_987_393##3	4.75548e-17
C410	GATE	a_309_338##2	3.21405e-19
C411	VPWR	GATE#3	1.62688e-18
C412	VPWR#11	VNB	5.3067e-18
C413	VPWR	a_83_260#	4.17477e-18
C414	a_27_74##9	VNB	6.08809e-17
C415	a_987_393#	VNB	3.26976e-17
C416	GATE	a_315_54#	1.67627e-17
C417	a_27_74##2	VNB	1.18136e-16
C418	CLK#5	VNB	2.0378e-17
C419	VPWR	VPWR#4	1.95955e-17
C420	a_309_338##4	a_315_54##8	7.66388e-18
C421	CLK#6	VNB	3.35224e-17
C422	GATE	GATE#2	1.58509e-17
C423	a_315_54##5	VNB	2.43804e-17
C424	a_27_74##4	VNB	4.85231e-17
C425	VPWR	a_987_393##3	2.65659e-18
C426	a_83_260##2	GATE	7.60898e-17
C427	a_309_338#	VNB	2.95616e-17
C428	VGND	a_309_338##3	3.54927e-19
C429	a_315_54##2	VNB	2.48984e-17
C430	GATE#1	VNB	3.35386e-17
C431	VPWR	a_315_54##6	1.26417e-18
C432	a_83_260##3	VNB	3.31063e-17
C433	a_987_393##4	VNB	4.33132e-17
C434	a_27_74#	VNB	4.6235e-17
C435	VPWR	a_309_338##2	4.7479e-18
C436	CLK#1	VNB	3.03467e-17
C437	VGND	VGND#4	5.59647e-17
C438	VPWR	a_315_54##4	1.28798e-17
C439	CLK#4	VNB	3.5397e-17
C440	VGND	a_987_393##3	5.46733e-18
C441	a_315_54##7	VNB	4.791e-17
C442	VPWR	a_315_54#	6.7132e-19
C443	a_27_74##5	VNB	5.2363e-17
C444	a_315_54##3	VNB	2.22561e-17
C445	VGND	a_315_54##6	2.89529e-18
C446	a_309_338##3	VNB	4.95523e-17
C447	VGND	a_27_74##3	5.9307e-17
C448	VPWR	a_83_260##2	7.5721e-18
C449	GATE#3	VNB	3.36926e-17
C450	a_83_260#	VNB	4.00558e-17
C451	VGND	a_309_338##2	6.05654e-18
C452	VPWR#4	VNB	2.90487e-16
C453	VGND	a_315_54#	3.96931e-18
C454	VGND#4	VNB	3.24134e-16
C455	a_987_393##3	VNB	6.06867e-17
C456	VGND	a_83_260##2	5.1335e-18
C457	a_315_54##6	VNB	2.30256e-17
C458	a_27_74##3	VNB	1.30537e-16
C459	a_309_338##2	VNB	5.30971e-17
C460	a_315_54##4	VNB	3.64506e-17
C461	a_315_54#	VNB	2.83831e-17
C462	GATE#2	VNB	3.21424e-17
C463	a_83_260##2	VNB	4.83875e-17
C464	VPWR#3	a_987_393##4	3.83326e-19
C465	VPWR	CLK	4.60795e-18
C466	VPWR	GATE	1.77248e-18
C467	VGND	CLK	8.1859e-18
C468	VPWR	GCLK	2.34072e-17
C469	VGND	GATE	1.79171e-18
C470	CLK	VNB	2.65083e-18
C471	VGND	GCLK	1.26622e-18
C472	GATE	VNB	2.15158e-18
C473	GCLK	VNB	7.46687e-17
C474	VPWR	VNB	7.91956e-17
C475	VGND	VNB	8.82002e-17
C476	a_27_74##9	VPWR#6	2.18539e-17
C477	VGND#2	GCLK#1	2.08972e-17
C478	VGND#3	VGND#2	4.0637e-19
C479	VGND#4	VGND#7	8.4372e-17
C480	VPWR#6	a_309_338##3	6.25538e-18
C481	VPWR#6	GATE#3	8.54867e-18
C482	VGND	VGND#2	5.59887e-17
C483	VGND#2	a_987_393##3	6.63222e-19
C484	VPWR#6	a_83_260#	4.6431e-18
C485	VGND#2	a_987_393#	6.00511e-18
C486	VGND#7	a_309_338##3	3.70289e-20
C487	VGND#7	a_315_54#	2.02306e-19
C488	VPWR#4	VPWR#6	7.94521e-17
C489	VGND	VGND#7	4.40882e-17
C490	GCLK	VPWR#2	2.43728e-17
C491	VPWR#2	a_987_393##4	2.96837e-18
C492	VGND#7	a_315_54##2	4.07902e-18
C493	VGND#2	VNB	5.71813e-17
C494	VGND#2	a_27_74##2	4.81383e-18
C495	VPWR	VPWR#2	3.92006e-17
C496	VGND#7	GATE#2	1.3782e-20
C497	VGND#2	a_987_393##8	7.97446e-18
C498	VPWR#2	a_27_74#	4.30906e-18
C499	VGND#7	VNB	7.29002e-17
C500	VGND#7	GATE#1	4.10966e-18
C501	VPWR#3	VPWR#2	5.81483e-19
C502	VPWR#4	VPWR#2	6.32622e-17
C503	VPWR#2	VNB	5.71932e-17
C504	VGND#7	a_83_260##3	2.98936e-18
C505	a_987_393##6	VPWR#2	2.46354e-19
C506	VPWR	VPWR#6	5.45027e-17
C507	VGND#7	a_27_74##3	3.83638e-17
C508	VPWR#6	GATE#2	5.70026e-20
C509	VPWR#6	VNB	6.85691e-17
C510	a_83_260##4	VPWR#6	1.68937e-17
C511	VPWR#2	a_987_393##3	5.83974e-20
C512	a_83_260##2	VPWR#6	1.45878e-18
C513	VGND#7	a_309_338##2	1.58094e-21
C514	VGND#7	a_27_74##7	5.63112e-17
C515	a_987_393##7	VPWR#2	2.67757e-18
C516	VGND#4	VGND#2	6.17313e-17
*
*
.ENDS sky130_fd_sc_hs__dlclkp_1
*
