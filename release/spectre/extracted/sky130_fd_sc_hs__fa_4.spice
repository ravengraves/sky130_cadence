* Extracted by Quantus, converted by sky130cad/quantus.py
*
*
*
*                       LINUX           Wed Nov 18 08:38:38 2026
*
*
*
*  PROGRAM  advgen
*
*  Name           : advgen - Quantus - (64-bit)
*  Version        : 25.1.0-p047
*  Build Date     : Thu Dec 11 23:20:30 PST 2025
*
*  HSPICE LIBRARY
*
*  OPERATING_TEMPERATURE 150
*  QRC_TECH_DIR <path>/tech
*
*
*

*
.SUBCKT sky130_fd_sc_hs__fa_4 VPB VNB VGND CIN VPWR SUM COUT A B
*
*
*  caps2d version: 10
*
*
*       TRANSISTOR CARDS
*
*
XM38 a_27_74##2 A#11 VGND#16 VNB sky130_fd_pr__nfet_01v8_lvt l=0.15 w=0.74 ad=0.2109 as=0.7887 pd=2.05 ps=3.74
XM12 VGND#16 B#1 a_27_74# VNB sky130_fd_pr__nfet_01v8_lvt l=0.15 w=0.74 ad=0.7887 as=0.2072 pd=3.74 ps=2.04
XM31 a_27_74# CIN#3 a_418_74##21 VNB sky130_fd_pr__nfet_01v8_lvt l=0.15 w=0.74 ad=0.2072 as=0.3108 pd=2.04 ps=2.32
XM27 a_418_74##21 B#6 a_532_74# VNB sky130_fd_pr__nfet_01v8_lvt l=0.15 w=0.74 ad=0.3108 as=0.2886 pd=2.32 ps=2.26
XM32 a_532_74# A#10 VGND#15 VNB sky130_fd_pr__nfet_01v8_lvt l=0.15 w=0.74 ad=0.2886 as=0.2368 pd=2.26 ps=2.12
XM2 VGND#15 CIN#6 a_734_74##2 VNB sky130_fd_pr__nfet_01v8_lvt l=0.15 w=0.74 ad=0.2368 as=0.2072 pd=2.12 ps=2.04
XM39 a_734_74##2 B#9 VGND#14 VNB sky130_fd_pr__nfet_01v8_lvt l=0.15 w=0.74 ad=0.2072 as=0.3807 pd=2.04 ps=2.74
XM6 VGND#14 A#8 a_734_74# VNB sky130_fd_pr__nfet_01v8_lvt l=0.15 w=0.74 ad=0.3807 as=0.2072 pd=2.74 ps=2.04
XM3 a_734_74# a_418_74##3 a_1024_74##17 VNB sky130_fd_pr__nfet_01v8_lvt l=0.15 w=0.74 ad=0.2072 as=0.3922 pd=2.04 ps=2.54
XM11 a_1024_74##17 CIN#7 a_1160_74# VNB sky130_fd_pr__nfet_01v8_lvt l=0.15 w=0.74 ad=0.3922 as=0.1776 pd=2.54 ps=1.96
XM28 a_1160_74# B#10 a_1238_74# VNB sky130_fd_pr__nfet_01v8_lvt l=0.15 w=0.74 ad=0.1776 as=0.2664 pd=1.96 ps=2.2
XM24 a_1238_74# A#1 VGND#13 VNB sky130_fd_pr__nfet_01v8_lvt l=0.15 w=0.74 ad=0.2664 as=0.3877 pd=2.2 ps=2.82
XM33 VGND#13 a_1024_74##13 SUM#1 VNB sky130_fd_pr__nfet_01v8_lvt l=0.15 w=0.74 ad=0.3877 as=0.2072 pd=2.82 ps=2.04
XM25 SUM#1 a_1024_74##11 VGND#12 VNB sky130_fd_pr__nfet_01v8_lvt l=0.15 w=0.74 ad=0.2072 as=0.3923 pd=2.04 ps=2.82
XM20 VGND#12 a_1024_74##9 SUM#2 VNB sky130_fd_pr__nfet_01v8_lvt l=0.15 w=0.74 ad=0.3923 as=0.2072 pd=2.82 ps=2.04
XM26 SUM#2 a_1024_74# VGND#11 VNB sky130_fd_pr__nfet_01v8_lvt l=0.15 w=0.74 ad=0.2072 as=0.3923 pd=2.04 ps=2.82
XM9 COUT#5 a_418_74##15 VGND#11 VNB sky130_fd_pr__nfet_01v8_lvt l=0.15 w=0.74 ad=0.2072 as=0.3923 pd=2.04 ps=2.82
XM21 COUT#5 a_418_74##13 VGND#10 VNB sky130_fd_pr__nfet_01v8_lvt l=0.15 w=0.74 ad=0.2072 as=0.2072 pd=2.04 ps=2.04
XM34 VGND#10 a_418_74##11 COUT#1 VNB sky130_fd_pr__nfet_01v8_lvt l=0.15 w=0.74 ad=0.2072 as=0.2072 pd=2.04 ps=2.04
XM22 VGND#1 a_418_74##4 COUT#1 VNB sky130_fd_pr__nfet_01v8_lvt l=0.15 w=0.74 ad=0.2109 as=0.2072 pd=2.05 ps=2.04
XM17 a_27_392##2 A#5 VPWR#16 VPB sky130_fd_pr__pfet_01v8 l=0.15 w=1 ad=0.295 as=0.50675 pd=2.59 ps=3.45
XM35 VPWR#16 B#3 a_27_392# VPB sky130_fd_pr__pfet_01v8 l=0.15 w=1 ad=0.50675 as=0.981325 pd=3.45 ps=4.1
XM19 a_27_392# CIN#1 a_418_74##23 VPB sky130_fd_pr__pfet_01v8 l=0.15 w=1 ad=0.981325 as=0.3 pd=4.1 ps=2.6
XM0 a_418_74##23 B#4 a_535_347# VPB sky130_fd_pr__pfet_01v8 l=0.15 w=1 ad=0.3 as=0.36 pd=2.6 ps=2.72
XM29 a_535_347# A#9 VPWR#15 VPB sky130_fd_pr__pfet_01v8 l=0.15 w=1 ad=0.36 as=0.35 pd=2.72 ps=2.7
XM4 VPWR#15 CIN#4 a_737_347##2 VPB sky130_fd_pr__pfet_01v8 l=0.15 w=1 ad=0.35 as=0.3 pd=2.7 ps=2.6
XM10 a_737_347##2 B#7 VPWR#14 VPB sky130_fd_pr__pfet_01v8 l=0.15 w=1 ad=0.3 as=0.42 pd=2.6 ps=2.84
XM14 VPWR#14 A#7 a_737_347# VPB sky130_fd_pr__pfet_01v8 l=0.15 w=1 ad=0.42 as=0.35 pd=2.84 ps=2.7
XM5 a_737_347# a_418_74# a_1024_74##16 VPB sky130_fd_pr__pfet_01v8 l=0.15 w=1 ad=0.35 as=0.35 pd=2.7 ps=2.7
XM13 a_1024_74##16 CIN#9 a_1141_347# VPB sky130_fd_pr__pfet_01v8 l=0.15 w=1 ad=0.35 as=0.32 pd=2.7 ps=2.64
XM1 a_1141_347# B#12 a_1235_347# VPB sky130_fd_pr__pfet_01v8 l=0.15 w=1 ad=0.32 as=0.4047 pd=2.64 ps=2.99
XM15 a_1235_347# A#2 VPWR#13 VPB sky130_fd_pr__pfet_01v8 l=0.15 w=1 ad=0.4047 as=0.4304 pd=2.99 ps=3.03
XM23 SUM#5 a_1024_74##7 VPWR#13 VPB sky130_fd_pr__pfet_01v8 l=0.15 w=1.12 ad=0.336 as=0.4304 pd=2.84 ps=3.03
XM36 SUM#5 a_1024_74##12 VPWR#12 VPB sky130_fd_pr__pfet_01v8 l=0.15 w=1.12 ad=0.336 as=0.392 pd=2.84 ps=2.94
XM7 VPWR#12 a_1024_74##10 SUM#6 VPB sky130_fd_pr__pfet_01v8 l=0.15 w=1.12 ad=0.392 as=0.336 pd=2.94 ps=2.84
XM16 VPWR#11 a_1024_74##8 SUM#6 VPB sky130_fd_pr__pfet_01v8 l=0.15 w=1.12 ad=0.392 as=0.336 pd=2.94 ps=2.84
XM8 VPWR#11 a_418_74##17 COUT#4 VPB sky130_fd_pr__pfet_01v8 l=0.15 w=1.12 ad=0.392 as=0.336 pd=2.94 ps=2.84
XM30 VPWR#10 a_418_74##16 COUT#4 VPB sky130_fd_pr__pfet_01v8 l=0.15 w=1.12 ad=0.392 as=0.336 pd=2.94 ps=2.84
XM18 COUT#6 a_418_74##12 VPWR#10 VPB sky130_fd_pr__pfet_01v8 l=0.15 w=1.12 ad=0.336 as=0.392 pd=2.84 ps=2.94
XM37 COUT#6 a_418_74##10 VPWR#1 VPB sky130_fd_pr__pfet_01v8 l=0.15 w=1.12 ad=0.336 as=0.3304 pd=2.84 ps=2.83
*
*
*       RESISTOR AND CAP/DIODE CARDS
*
Rg1	B#1	B#2	344.913635
Rg2	B#2	B#3	458.917694
Rg3	CIN#1	CIN#2	411.311340
Rg4	CIN#2	CIN#3	307.937683
Rg5	B#4	B#5	400.207520
Rg6	B#5	B#6	322.284241
Rg7	CIN#4	CIN#5	408.386017
Rg8	CIN#5	CIN#6	334.702850
Rg9	B#7	B#8	400.207520
Rg10	B#8	B#9	322.284241
Rg11	a_418_74#	a_418_74##2	422.620483
Rg12	a_418_74##2	a_418_74##3	394.243530
Rg13	CIN#7	CIN#8	357.337219
Rg14	CIN#8	CIN#9	414.429810
Rg15	B#10	B#11	322.284241
Rg16	B#11	B#12	400.207520
Rg17	A#1	A#2	901.461060
Rg18	A#2	A#3	1498.819092
Rg19	A#3	A#4	792.772766
Rg20	A#4	A#5	1785.211060
Rg21	A#5	A#6	480.967316
Rg22	A#3	A#7	356.351532
Rg23	A#7	A#8	796.904907
Rg24	A#4	A#9	356.351532
Rg25	A#9	A#10	796.904907
Rg26	A#6	A#11	304.296387
Rg27	a_1024_74#	a_1024_74##2	389.052795
Rg28	a_1024_74##2	a_1024_74##3	58.979431
Rg29	a_1024_74##3	a_1024_74##4	26.066662
Rg30	a_1024_74##4	a_1024_74##5	91.909409
Rg31	a_1024_74##5	a_1024_74##6	58.569527
Rg32	a_1024_74##6	a_1024_74##7	455.516602
Rg33	a_1024_74##2	a_1024_74##8	457.863434
Rg34	a_1024_74##3	a_1024_74##9	372.745422
Rg35	a_1024_74##4	a_1024_74##10	406.038116
Rg36	a_1024_74##5	a_1024_74##11	352.054443
Rg37	a_1024_74##5	a_1024_74##12	437.288544
Rg38	a_1024_74##6	a_1024_74##13	371.813751
Rg39	a_418_74##4	a_418_74##5	363.057404
Rg40	a_418_74##5	a_418_74##6	75.384476
Rg41	a_418_74##6	a_418_74##7	8.882398
Rg42	a_418_74##7	a_418_74##8	53.921463
Rg43	a_418_74##8	a_418_74##9	30.960432
Rg44	a_418_74##5	a_418_74##10	464.375244
Rg45	a_418_74##6	a_418_74##11	390.078186
Rg46	a_418_74##7	a_418_74##12	426.291779
Rg47	a_418_74##8	a_418_74##13	332.676849
Rg48	a_418_74##9	a_418_74##14	45.123474
Rg49	a_418_74##14	a_418_74##15	330.581726
Rg50	a_418_74##9	a_418_74##16	442.451355
Rg51	a_418_74##14	a_418_74##17	467.142303
Rf1	A#12	A	2.395745
Rf2	A#6	A#14	82.512146
Rf3	A#12	A#14	5.444379
Rf4	A#15	A	2.395745
Rf5	A#14	A#15	6.434267
Rf6	a_27_74#	a_27_74##2	109.774521
Rf7	a_27_392#	a_27_392##2	132.124268
Rf8	CIN#10	CIN	10.386635
Rf9	CIN#2	CIN#13	160.841660
Rf10	CIN#10	CIN#13	4.283762
Rf11	CIN#5	CIN#15	188.267960
Rf12	a_734_74#	a_734_74##2	91.215263
Rf13	a_737_347#	a_737_347##2	96.174889
Rf14	CIN#16	CIN#17	1.851566
Rf15	CIN#18	CIN#8	162.084366
Rf16	CIN#17	CIN#18	4.059305
Rf17	B#8	B#14	173.440521
Rf18	B#14	B#15	100.085625
Rf19	B#15	B#2	272.236572
Rf20	B#14	B	143.542191
Rf21	B	B#11	167.268707
Rf22	B#15	B#5	178.128937
Rf23	a_1024_74##5	a_1024_74##15	74.098434
Rf24	a_1024_74##15	a_1024_74##16	157.096375
Rf25	a_1024_74##15	a_1024_74##17	148.680740
Rf26	SUM#1	SUM#3	67.760010
Rf27	SUM#3	SUM#4	46.093586
Rf28	SUM#4	SUM#5	78.543274
Rf29	SUM#4	SUM	4.634720
Rf30	SUM	SUM#7	0.196836
Rf31	SUM#7	SUM	14.369054
Rf32	SUM#2	SUM#3	15.000000
Rf33	SUM#6	SUM#7	5.000000
Rf34	a_418_74##9	a_418_74##19	456.701294
Rf35	a_418_74##19	a_418_74##20	196.688110
Rf36	a_418_74##20	a_418_74##21	12.244770
Rf37	a_418_74##19	a_418_74##2	177.279663
Rf38	a_418_74##20	a_418_74##23	268.852448
Rf39	COUT#1	COUT#2	21.552849
Rf40	COUT#2	COUT	29.414471
Rf41	COUT	COUT#3	10.844626
Rf42	COUT#3	COUT#4	79.175865
Rf43	COUT#2	COUT#5	73.943802
Rf44	COUT#3	COUT	5.188939
Rf45	COUT	COUT#7	13.966559
Rf46	COUT#7	COUT	0.191323
Rf47	COUT#6	COUT#7	5.000000
Rf48	VGND#1	VGND#2	97.002777
Rf49	VGND#2	VGND#3	73.412041
Rf50	VGND#3	VGND#4	69.263863
Rf51	VGND#4	VGND#5	74.462440
Rf52	VGND#5	VGND#6	189.882217
Rf53	VGND#6	VGND#7	71.163177
Rf54	VGND#7	VGND#8	181.729950
Rf56	VGND#2	VGND#10	43.678436
Rf57	VGND#3	VGND#11	27.966743
Rf58	VGND#4	VGND#12	24.468842
Rf59	VGND#5	VGND#13	24.468842
Rf60	VGND#6	VGND#14	24.468842
Rf61	VGND#7	VGND#15	36.824379
Rf62	VGND#8	VGND#16	21.006500
Rf63	VPWR#1	VPWR#2	116.372597
Rf64	VPWR#2	VPWR#3	67.933250
Rf65	VPWR#3	VPWR#4	72.754585
Rf66	VPWR#4	VPWR#5	71.655113
Rf67	VPWR#5	VPWR#6	186.255859
Rf68	VPWR#6	VPWR#7	74.747993
Rf69	VPWR#7	VPWR#8	193.608810
Rf71	VPWR#2	VPWR#10	42.062149
Rf72	VPWR#3	VPWR#11	52.877037
Rf73	VPWR#4	VPWR#12	41.550522
Rf74	VPWR#5	VPWR#13	38.736572
Rf75	VPWR#6	VPWR#14	36.474125
Rf76	VPWR#7	VPWR#15	45.071289
Rf77	VPWR#8	VPWR#16	63.930489
Re1	CIN#16	CIN#15	13.698293
Re2	CIN#15	CIN	1.450526
Re4	VPWR#3	VPWR	2.377092
Re5	VPWR	VPWR#7	1.528131
Re6	VGND#3	VGND	2.377092
Re7	VGND	VGND#7	1.528131
*
*       CAPACITOR CARDS
*
*
C1	VPWR#15	B#4	4.07983e-18
C2	a_737_347##2	VPWR#14	5.30442e-17
C3	a_418_74##23	A#9	3.1278e-18
C4	B#14	VPWR#15	1.98322e-17
C5	a_418_74##9	SUM#2	8.97734e-17
C6	SUM#4	a_1024_74##12	1.76041e-18
C7	VPWR#7	A#4	8.82826e-17
C8	COUT#4	VPWR#2	7.97954e-18
C9	a_418_74##20	B#5	2.06807e-17
C10	VGND#4	a_1024_74##9	1.13268e-17
C11	a_418_74##9	VGND#12	1.76497e-18
C12	a_27_392#	A#9	3.4144e-20
C13	VPWR#7	A#3	1.79892e-17
C14	a_418_74##3	a_734_74#	1.4569e-17
C15	a_737_347##2	A#4	3.59296e-18
C16	VGND#2	a_418_74##14	6.24126e-20
C17	a_418_74##2	CIN#17	2.99618e-17
C18	a_418_74##9	SUM#1	5.36916e-17
C19	VGND#15	a_734_74##2	2.48766e-17
C20	A#3	A#2	9.73678e-19
C21	VPWR#15	CIN#1	5.93606e-19
C22	a_418_74##23	B#4	4.21088e-17
C23	VGND#3	VPWR#11	3.10629e-18
C24	VPWR#15	VPWR#14	7.33043e-18
C25	VGND#7	a_1024_74##17	9.7489e-18
C26	VPWR#6	B#7	1.5206e-18
C27	VPWR#3	SUM#5	1.90386e-17
C28	VGND#5	a_1024_74##11	2.14852e-18
C29	a_1024_74##15	a_1024_74##12	3.31177e-19
C30	COUT#2	a_418_74##15	3.60375e-20
C31	a_418_74##14	VGND#11	5.76807e-19
C32	SUM#2	a_1024_74##5	3.38981e-17
C33	a_27_392#	B#4	6.2504e-19
C34	VGND#7	a_734_74#	1.67438e-17
C35	a_737_347##2	A#3	3.10288e-18
C36	SUM#4	a_1024_74##7	1.51043e-19
C37	a_1024_74##5	VGND#12	6.01004e-18
C38	a_418_74##9	a_418_74##14	3.89925e-17
C39	a_734_74#	A#8	4.03674e-17
C40	VPWR#15	B#3	3.80017e-19
C41	a_418_74##23	CIN#1	4.71291e-17
C42	VPWR#15	a_737_347##2	5.98973e-17
C43	a_418_74##20	a_418_74##21	1.65994e-17
C44	a_418_74##20	CIN#2	3.03713e-18
C45	B#15	a_418_74##23	4.70339e-17
C46	a_1024_74##5	SUM#1	6.34056e-17
C47	CIN#5	B#15	4.60536e-18
C48	VGND#4	a_1024_74##11	1.13731e-17
C49	VGND#7	a_734_74##2	2.28186e-17
C50	CIN#1	a_27_392#	2.52489e-17
C51	CIN#5	B#14	3.30731e-17
C52	a_418_74##9	a_418_74##7	8.98896e-18
C53	A#8	VGND#14	1.77566e-17
C54	VGND#7	VGND#15	9.71901e-18
C55	a_418_74##23	B#3	2.14545e-17
C56	a_1024_74##15	a_1024_74##7	7.73112e-18
C57	a_734_74#	B#9	5.42406e-19
C58	VGND#5	a_1024_74##13	1.15701e-17
C59	COUT#2	a_1024_74#	3.36109e-20
C60	VPWR#15	A#4	5.47091e-18
C61	SUM#4	A#2	1.15295e-19
C62	a_27_392#	B#3	5.84159e-17
C63	a_418_74##12	a_418_74##10	4.69426e-17
C64	a_734_74##2	A#8	5.42406e-19
C65	a_27_392##2	CIN#1	3.81562e-19
C66	B#15	a_27_392#	3.15059e-19
C67	a_418_74##9	a_1024_74##6	1.63026e-20
C68	a_418_74##20	a_27_74#	1.09144e-16
C69	a_418_74##20	B#2	8.52124e-17
C70	VGND#7	a_27_74#	2.44297e-17
C71	a_418_74##23	A#5	4.43189e-18
C72	B#9	VGND#14	1.75875e-17
C73	B#3	VPWR#16	2.80644e-17
C74	VGND#4	a_1024_74##13	1.27566e-18
C75	VGND#6	A#1	4.12397e-20
C76	B#5	B#14	2.56292e-19
C77	SUM#2	a_418_74##14	2.93811e-18
C78	a_418_74##9	a_1024_74##4	9.17831e-18
C79	VPWR#15	A#3	1.342e-18
C80	VGND#2	a_418_74##7	1.3506e-21
C81	VGND#15	A#8	3.06558e-19
C82	VGND#5	a_1024_74##6	2.56356e-21
C83	a_27_392#	A#5	1.97687e-17
C84	a_27_392##2	B#3	2.06592e-18
C85	a_1024_74##15	A#2	3.67582e-17
C86	VGND#7	a_27_74##2	2.4049e-17
C87	a_734_74##2	B#9	4.16727e-17
C88	a_418_74##16	a_418_74##12	3.70361e-17
C89	A#5	VPWR#16	1.90492e-17
C90	VGND#5	A#1	1.21659e-17
C91	a_1024_74##17	B#11	2.59458e-18
C92	a_418_74##23	VPWR#15	1.72611e-17
C93	CIN#16	a_1024_74##16	5.12541e-18
C94	COUT#3	VPWR#1	1.7228e-17
C95	CIN#2	B#15	3.41898e-17
C96	a_27_392##2	A#5	5.69428e-17
C97	SUM#5	VPWR#5	8.49389e-18
C98	a_418_74##7	COUT#6	1.48541e-19
C99	a_418_74##20	VGND#16	4.92905e-18
C100	VGND#15	B#9	2.14401e-18
C101	a_418_74##20	A#6	3.7124e-18
C102	CIN#16	a_737_347#	5.22268e-18
C103	VGND#4	A#1	9.11197e-19
C104	VPWR#10	a_418_74##14	8.39376e-19
C105	VGND#6	B#10	5.07988e-20
C106	CIN#6	a_734_74##2	1.58967e-17
C107	a_27_392#	VPWR#15	3.4888e-18
C108	CIN#9	A#3	1.74216e-17
C109	CIN#16	VPWR#14	3.22498e-18
C110	a_418_74##17	a_418_74##16	4.64262e-17
C111	CIN#8	a_1024_74##17	2.23776e-17
C112	a_1024_74##15	B#12	1.27583e-19
C113	a_1024_74##5	a_1024_74##6	2.14281e-17
C114	SUM#5	VPWR#4	8.76586e-18
C115	CIN#10	B#5	7.81796e-18
C116	CIN#16	a_737_347##2	3.15352e-19
C117	VGND#5	B#10	5.66309e-18
C118	a_1024_74##5	a_1024_74##4	1.38401e-17
C119	CIN#6	VGND#15	2.09723e-17
C120	B#2	B#15	4.68314e-18
C121	a_418_74##9	VPWR#10	3.14569e-18
C122	COUT#3	COUT#6	1.36561e-19
C123	CIN#15	VPWR#14	2.42858e-18
C124	a_27_74##2	a_418_74##20	1.59843e-17
C125	a_734_74##2	A#10	1.08785e-18
C126	a_418_74##9	COUT#4	4.77657e-17
C127	a_418_74##19	a_1024_74##9	2.50377e-19
C128	a_1024_74##8	a_418_74##17	3.77334e-17
C129	a_418_74##2	a_1024_74##17	1.40309e-19
C130	CIN#15	a_737_347##2	5.31922e-18
C131	VGND#6	CIN#7	1.84863e-19
C132	a_418_74##5	COUT#6	1.7935e-19
C133	a_418_74##9	VPWR#11	1.69014e-17
C134	VGND#2	a_418_74##5	8.39925e-20
C135	a_418_74##23	a_27_392#	1.47086e-16
C136	CIN#15	VPWR#15	7.64675e-18
C137	VGND#15	A#10	3.19342e-17
C138	CIN#10	CIN#2	6.94413e-18
C139	VPWR#10	a_418_74##7	1.25373e-19
C140	a_418_74##23	A#4	6.57056e-18
C141	VPWR#7	a_1024_74##16	2.34735e-17
C142	COUT#4	a_418_74##14	2.82781e-18
C143	a_734_74##2	B#6	3.28162e-19
C144	VGND#5	CIN#7	4.65706e-18
C145	A#3	a_418_74#	2.58415e-17
C146	VGND#3	a_418_74##4	4.76975e-18
C147	VGND#4	a_1024_74##4	7.47052e-19
C148	COUT#3	a_418_74##14	2.71209e-18
C149	VPWR#7	a_737_347#	1.54976e-17
C150	COUT#3	VPWR#10	2.37715e-17
C151	a_1024_74##10	a_1024_74##8	4.71008e-17
C152	SUM#4	VPWR#4	1.42304e-19
C153	a_418_74##23	VPWR#16	9.74405e-19
C154	VGND#3	a_418_74##11	9.21351e-18
C155	VPWR#7	VPWR#14	5.43969e-19
C156	a_418_74##19	a_1024_74##11	3.65703e-19
C157	VGND#15	B#6	3.53447e-18
C158	B#2	CIN#10	1.5786e-17
C159	VGND#6	a_418_74##3	5.93654e-18
C160	a_737_347##2	VPWR#7	1.8745e-17
C161	VGND#3	a_418_74##13	5.47233e-18
C162	a_1024_74##5	VPWR#12	3.70457e-18
C163	a_734_74##2	CIN#3	2.01798e-19
C164	A#15	B#2	4.03697e-18
C165	a_734_74##2	B#8	7.23291e-19
C166	VGND#2	COUT#2	3.08828e-19
C167	a_27_392#	VPWR#16	5.05308e-17
C168	a_27_392##2	a_418_74##23	2.74146e-18
C169	COUT#1	VGND#1	4.67444e-17
C170	a_1024_74##5	SUM#5	5.23641e-17
C171	VGND#3	a_418_74##15	1.95564e-17
C172	VGND#6	a_418_74##19	4.48813e-17
C173	a_1024_74##12	a_1024_74##10	3.74247e-17
C174	VGND#5	a_418_74##3	6.39101e-20
C175	a_1024_74##15	a_1235_347#	1.7364e-18
C176	VGND#15	CIN#3	1.42029e-18
C177	VGND#3	a_1024_74#	2.15275e-17
C178	a_27_74#	VGND#16	4.53531e-18
C179	B#6	a_418_74##21	9.83093e-18
C180	a_418_74##23	VPWR#7	3.13752e-17
C181	a_418_74##19	a_1024_74##13	2.03282e-17
C182	a_27_392#	A#4	7.8255e-18
C183	SUM#2	a_1024_74##6	4.5523e-20
C184	a_27_392##2	a_27_392#	3.09963e-18
C185	a_1024_74##15	VPWR#5	2.06398e-18
C186	CIN#10	A#6	2.53658e-19
C187	VGND#3	a_1024_74##9	9.85805e-18
C188	a_734_74##2	CIN#5	3.72798e-19
C189	VGND#2	VGND#1	2.6963e-18
C190	a_418_74##20	CIN#10	3.00201e-17
C191	A#15	A#6	1.3384e-17
C192	a_27_392#	VPWR#7	3.77343e-17
C193	VGND#6	A#8	9.31425e-18
C194	VGND#15	CIN#5	5.36739e-19
C195	VGND#3	a_1024_74##11	1.00556e-17
C196	a_1024_74##7	a_1024_74##12	4.52557e-17
C197	COUT#2	a_418_74##14	7.34178e-19
C198	VGND#10	VGND#1	1.82181e-18
C199	a_27_74#	B#6	9.77177e-19
C200	CIN#8	a_1024_74##6	2.04666e-20
C201	VGND#15	B#1	3.30986e-19
C202	A#14	A#6	1.51162e-17
C203	a_1024_74##16	VPWR#6	9.76097e-18
C204	VGND#5	a_418_74##19	1.12423e-16
C205	VGND#7	a_418_74##23	1.20686e-18
C206	a_27_392##2	VPWR#16	6.59696e-17
C207	VGND#3	a_1024_74##13	9.25484e-18
C208	a_27_74##2	a_27_74#	2.30852e-18
C209	a_1024_74##15	a_1024_74##9	1.32971e-20
C210	CIN#3	a_418_74##21	1.28796e-17
C211	A#15	a_418_74##23	2.29353e-17
C212	A#12	A#6	1.51313e-17
C213	VPWR#7	a_27_392##2	2.04221e-17
C214	VGND#5	A#8	3.28195e-20
C215	COUT#3	a_418_74##7	7.41302e-18
C216	SUM#2	a_1024_74##4	1.6828e-17
C217	a_1024_74##17	CIN#17	1.32498e-17
C218	a_418_74##19	A#1	2.54284e-17
C219	a_1024_74##16	B#11	1.13336e-18
C220	A#2	a_1024_74##7	3.53991e-17
C221	a_27_74#	CIN#3	2.85317e-17
C222	a_1024_74##16	VPWR#5	4.50662e-18
C223	VGND#10	COUT#1	3.62299e-17
C224	A#15	a_418_74##20	3.09905e-17
C225	VGND#2	COUT#1	1.23498e-17
C226	B#14	a_418_74#	7.43106e-18
C227	VGND#6	B#9	9.27669e-18
C228	a_27_74##2	VGND#16	7.89162e-18
C229	CIN#16	A#1	1.7864e-19
C230	CIN#8	A#3	2.01109e-19
C231	a_1024_74##15	a_1024_74##11	5.11929e-20
C232	a_1024_74##16	CIN#8	8.76155e-19
C233	a_737_347#	VPWR#6	8.47708e-18
C234	B#7	A#3	2.29974e-17
C235	B#12	A#2	5.70479e-17
C236	B#15	A#4	3.08315e-18
C237	a_27_74#	B#1	3.89164e-17
C238	B#15	A#7	2.63252e-19
C239	a_27_74##2	CIN#3	2.80427e-20
C240	COUT#5	COUT#1	3.06964e-18
C241	a_418_74##19	B#10	2.20569e-17
C242	CIN#2	a_418_74##21	9.77477e-19
C243	B#14	A#7	1.84258e-17
C244	B#1	VGND#16	2.19304e-17
C245	a_418_74##9	a_418_74##11	2.90945e-20
C246	COUT#2	a_418_74##7	6.4639e-18
C247	VGND#6	CIN#6	7.25957e-19
C248	CIN#16	A#8	2.2048e-18
C249	A#15	VPWR#16	2.47698e-19
C250	COUT#2	COUT#3	3.07597e-18
C251	a_737_347#	a_418_74##2	2.86298e-19
C252	CIN#9	B#12	4.28372e-17
C253	a_418_74##9	a_418_74##13	6.40094e-20
C254	a_27_74#	A#11	1.18604e-18
C255	a_1024_74##15	a_1024_74##13	4.76425e-18
C256	a_27_74##2	B#1	1.72394e-18
C257	a_418_74##9	a_418_74##15	1.06141e-17
C258	B#15	B#7	3.91536e-19
C259	COUT#5	VGND#10	4.16899e-17
C260	a_418_74##11	a_418_74##4	3.87268e-17
C261	COUT#3	a_418_74##5	1.24903e-17
C262	CIN#15	A#8	2.45289e-19
C263	A#4	CIN#4	2.41715e-17
C264	a_418_74##9	a_1024_74#	2.71595e-17
C265	A#11	VGND#16	1.26885e-17
C266	a_418_74##2	A#3	4.18023e-19
C267	a_418_74##19	CIN#7	2.28396e-17
C268	a_27_74#	B#2	1.78146e-18
C269	SUM#1	a_1024_74##6	7.63928e-20
C270	B#14	B#7	1.02561e-17
C271	a_418_74##9	a_1024_74##9	2.0131e-17
C272	a_418_74#	CIN#9	3.49449e-17
C273	B#15	a_535_347#	2.22888e-18
C274	VPWR#14	B#8	4.94797e-19
C275	A#15	a_27_392##2	1.41657e-17
C276	VGND#2	COUT#5	6.56053e-18
C277	B#14	A#4	5.65056e-19
C278	VPWR#3	VPWR#5	6.27704e-17
C279	VGND#7	A#1	1.18703e-18
C280	a_27_74##2	A#11	4.77654e-17
C281	a_418_74##9	a_1024_74##11	2.01448e-17
C282	VGND#6	A#10	2.80203e-19
C283	a_737_347##2	B#8	4.44265e-19
C284	COUT#2	VGND#1	2.85816e-17
C285	a_418_74##20	a_418_74##3	1.33149e-19
C286	a_1024_74##15	A#1	2.61873e-17
C287	VGND#7	B#10	1.47943e-18
C288	VPWR#3	VPWR#4	7.15466e-17
C289	a_418_74##9	a_1024_74##13	7.49688e-18
C290	CIN#15	A#10	9.62374e-18
C291	B#15	CIN#4	7.56738e-19
C292	VGND#7	CIN#7	2.08844e-18
C293	a_737_347##2	VPWR#6	3.73349e-18
C294	A#7	a_418_74#	3.07338e-17
C295	SUM#1	a_1024_74##4	8.4032e-20
C296	VPWR#3	VPWR#2	8.04149e-17
C297	a_418_74##13	a_418_74##11	3.89264e-17
C298	VPWR#3	a_418_74##10	4.8604e-18
C299	a_418_74##19	a_1238_74#	6.28966e-18
C300	a_418_74##19	a_418_74##3	2.53438e-17
C301	B#14	CIN#4	1.94208e-17
C302	a_27_74##2	A#6	9.13266e-18
C303	COUT#6	VPWR#1	3.82178e-17
C304	VPWR#11	a_1024_74##4	2.98691e-18
C305	VPWR#3	a_418_74##12	2.67982e-19
C306	B#14	A#3	9.445e-19
C307	VPWR#15	CIN#5	3.19531e-19
C308	COUT#2	a_418_74##5	6.54584e-18
C309	A#14	a_27_392##2	2.00498e-17
C310	VPWR#3	a_418_74##16	6.40502e-19
C311	a_1024_74##15	B#10	1.738e-19
C312	B#8	A#3	3.49506e-19
C313	a_418_74##20	A#8	3.03698e-19
C314	COUT#2	COUT#1	1.66735e-19
C315	B#7	A#7	2.25906e-17
C316	a_1024_74##15	a_1238_74#	5.35257e-19
C317	B#15	A#9	2.19375e-17
C318	VPWR#3	a_418_74##17	9.85707e-18
C319	VGND#7	CIN#6	2.29317e-18
C320	VPWR#10	VPWR#1	2.09124e-18
C321	B#11	A#1	2.02244e-17
C322	COUT#3	a_1024_74##4	2.06725e-19
C323	A#12	a_27_392##2	1.82784e-17
C324	a_418_74##19	a_1160_74#	1.55821e-18
C325	a_418_74##15	a_418_74##13	3.8684e-17
C326	a_418_74##19	A#8	2.3942e-17
C327	VGND#7	A#10	2.89758e-18
C328	VPWR#3	a_1024_74##8	1.1013e-17
C329	CIN#8	a_1024_74##13	2.19285e-19
C330	CIN#4	B#7	4.07817e-17
C331	a_418_74##20	A#5	9.59282e-20
C332	VPWR#1	a_418_74##10	3.19016e-17
C333	VGND#7	B#6	4.29101e-18
C334	VPWR#3	a_1024_74##10	5.37746e-19
C335	CIN#8	A#1	2.69866e-19
C336	a_1024_74##15	CIN#7	5.97433e-20
C337	B	a_1024_74##6	3.55078e-18
C338	VGND#7	CIN#3	1.30565e-18
C339	VPWR#10	COUT#6	4.13887e-17
C340	SUM#4	VPWR#11	6.76757e-17
C341	a_418_74##20	B#9	9.8892e-19
C342	COUT#2	VGND#10	1.89534e-17
C343	VPWR#3	a_1024_74##12	3.00661e-19
C344	B#15	B#4	1.81816e-17
C345	CIN#8	B#10	7.24346e-19
C346	COUT#6	a_418_74##10	3.66093e-17
C347	VGND#4	VGND#12	8.3275e-18
C348	a_418_74##2	a_1024_74##13	6.43451e-20
C349	a_1024_74##4	SUM#6	4.29926e-19
C350	B#14	VPWR#6	1.97146e-19
C351	VGND#7	B#1	7.60186e-19
C352	B	A#3	5.45343e-19
C353	CIN#5	A#4	4.43976e-19
C354	A#9	CIN#4	3.09517e-17
C355	VPWR#3	a_1024_74##7	2.09627e-18
C356	a_418_74##2	A#1	1.0239e-19
C357	a_1024_74#	a_418_74##14	1.92218e-19
C358	VPWR#1	a_418_74##12	1.22325e-18
C359	B#4	A#4	2.5412e-17
C360	VGND#7	A#11	1.04373e-18
C361	CIN#2	a_27_392#	1.21485e-19
C362	a_418_74##19	B#9	1.50296e-17
C363	VPWR#10	a_418_74##10	7.81638e-19
C364	VGND#3	VGND#5	5.7788e-17
C365	a_1024_74#	a_418_74##15	2.13348e-17
C366	a_418_74##2	B#10	1.42809e-19
C367	VPWR#3	A#2	1.01266e-18
C368	a_418_74##7	a_418_74##10	9.29322e-19
C369	COUT#4	COUT#6	2.76712e-19
C370	a_418_74##2	CIN#7	8.25273e-19
C371	COUT#6	a_418_74##12	3.51863e-17
C372	VGND#3	VGND#4	7.88981e-17
C373	VGND#1	a_418_74##4	4.32166e-17
C374	a_418_74##23	B#2	9.46749e-17
C375	VPWR#3	COUT#3	1.52903e-18
C376	a_1024_74##15	a_418_74##3	4.85227e-20
C377	COUT#2	a_1024_74##4	9.41106e-21
C378	B#4	A#9	2.905e-17
C379	a_418_74##2	a_418_74##3	1.63161e-18
C380	SUM#4	SUM#6	6.49962e-19
C381	B#15	CIN#1	1.82633e-17
C382	a_418_74##20	CIN#6	2.33946e-17
C383	B#2	a_27_392#	9.33087e-18
C384	VGND#3	VGND#2	7.82611e-17
C385	VPWR#1	a_418_74##16	2.54733e-19
C386	VPWR#5	VPWR#4	7.06672e-19
C387	A#8	a_418_74##2	2.0797e-17
C388	a_418_74##12	VPWR#10	2.78689e-17
C389	A#4	A#3	4.2479e-19
C390	COUT#4	VPWR#10	6.25108e-17
C391	CIN#16	VGND#6	5.21086e-18
C392	a_418_74##2	B#9	3.96781e-19
C393	a_418_74##4	COUT#1	9.59357e-18
C394	VGND#5	VGND#13	8.82763e-18
C395	a_418_74##23	A#6	1.29053e-18
C396	a_418_74##19	CIN#6	5.49033e-20
C397	COUT#6	a_418_74##16	6.92179e-19
C398	a_418_74##2	CIN#6	1.71594e-19
C399	CIN#1	B#4	4.13759e-17
C400	a_1024_74##9	a_1024_74#	4.08097e-17
C401	COUT#4	a_418_74##12	2.0101e-18
C402	B#8	A#8	1.62338e-17
C403	a_1024_74##17	A#2	2.22446e-19
C404	VGND#1	a_418_74##11	3.1403e-18
C405	a_1024_74##16	a_1235_347#	3.78168e-18
C406	VPWR#12	a_1024_74##4	4.75696e-19
C407	VPWR#16	A#6	3.49134e-19
C408	a_418_74##2	A#10	1.24335e-19
C409	B#5	A#4	2.92888e-19
C410	VGND#3	COUT#3	8.48185e-19
C411	a_418_74##16	VPWR#10	3.22801e-17
C412	B#15	B#3	2.86615e-19
C413	CIN#1	A#4	2.33324e-17
C414	a_27_392##2	A#6	4.06992e-18
C415	SUM#4	VPWR#12	6.58954e-17
C416	VGND#10	a_418_74##4	5.11331e-19
C417	a_418_74##20	A#10	2.37936e-17
C418	VPWR#11	VPWR#10	2.09124e-18
C419	VPWR#11	a_418_74##12	1.78501e-19
C420	SUM#2	VGND#12	2.06062e-19
C421	VGND#3	COUT#2	1.72608e-18
C422	B#3	CIN#1	5.42063e-18
C423	COUT#1	a_418_74##11	3.10586e-17
C424	COUT#4	a_418_74##16	7.64817e-17
C425	a_1024_74##16	a_1141_347#	1.99075e-18
C426	a_418_74##20	a_532_74#	5.12982e-18
C427	VPWR#7	A#2	1.90569e-17
C428	CIN#15	VGND#6	2.01204e-18
C429	a_1024_74##17	a_1238_74#	8.35894e-19
C430	a_418_74##14	a_418_74##7	2.9263e-18
C431	a_418_74##19	A#10	3.36325e-20
C432	VGND#1	a_418_74##13	4.04323e-19
C433	VPWR#10	a_418_74##17	3.70183e-19
C434	SUM#5	a_1024_74##6	3.89749e-19
C435	VPWR#7	B#12	5.09353e-18
C436	a_1024_74##11	a_1024_74##9	2.05525e-17
C437	A#10	CIN#5	1.64034e-17
C438	VPWR#11	COUT#4	9.98405e-17
C439	VPWR#11	a_418_74##16	4.09291e-19
C440	A#5	B#3	3.54508e-17
C441	a_418_74##11	VGND#10	1.49608e-17
C442	VPWR#3	SUM#4	1.54651e-18
C443	VPWR#7	CIN#9	5.10703e-18
C444	SUM#5	SUM#4	2.81393e-18
C445	VGND#3	a_418_74##19	6.50992e-18
C446	COUT#4	a_418_74##17	5.51349e-17
C447	a_418_74##20	a_418_74##19	1.29916e-18
C448	a_418_74##20	B#6	3.76876e-17
C449	VPWR#2	a_418_74##10	2.78771e-18
C450	COUT#1	a_418_74##13	1.43056e-18
C451	SUM#4	COUT#3	8.65649e-19
C452	VPWR#7	VPWR#6	1.43906e-16
C453	B#5	A#10	1.80021e-17
C454	VPWR#7	a_418_74#	5.31697e-18
C455	a_1024_74##17	a_1160_74#	8.14044e-19
C456	VPWR#10	a_1024_74##8	1.71283e-19
C457	COUT#5	a_418_74##11	4.74523e-19
C458	VPWR#7	VPWR#5	6.43467e-17
C459	VPWR#3	a_1024_74##15	3.04868e-18
C460	CIN#2	A#4	2.99492e-19
C461	a_418_74##17	VPWR#11	2.61492e-17
C462	CIN#15	A#9	9.92035e-18
C463	VGND#10	a_418_74##13	2.76606e-17
C464	VPWR#7	B#7	4.19587e-18
C465	COUT#4	a_1024_74##8	1.59995e-18
C466	a_1024_74##13	a_1024_74##11	4.06772e-17
C467	a_418_74##16	a_418_74##7	9.68536e-19
C468	CIN#2	B#6	4.22337e-19
C469	VGND#3	SUM#4	6.95008e-19
C470	B#11	A#2	1.28191e-17
C471	VPWR#7	CIN#4	6.5591e-18
C472	COUT#1	a_418_74##15	2.37814e-19
C473	CIN#16	a_418_74##19	1.51395e-17
C474	a_418_74##20	CIN#3	2.70688e-17
C475	a_1024_74##8	VPWR#11	3.23782e-17
C476	B#1	CIN#2	5.69567e-19
C477	VPWR#2	a_418_74##12	4.54441e-18
C478	COUT#5	a_418_74##13	2.9557e-17
C479	VPWR#12	a_418_74##17	1.78501e-19
C480	CIN#8	A#2	3.46714e-19
C481	a_1024_74##15	SUM#5	3.84474e-17
C482	CIN#9	B#11	4.92321e-19
C483	SUM#4	a_418_74##14	1.95937e-18
C484	VGND#3	a_1024_74##15	5.48101e-18
C485	VPWR#7	B#4	7.59969e-18
C486	B	VPWR#6	4.46982e-19
C487	a_1024_74##8	SUM#6	2.37282e-17
C488	VGND#10	a_418_74##15	1.14877e-18
C489	VPWR#7	CIN#1	7.93476e-18
C490	VPWR#12	VPWR#11	2.09124e-18
C491	a_418_74##20	CIN#15	5.00823e-17
C492	VPWR#11	a_1024_74##10	3.70183e-19
C493	A#1	a_1024_74##13	2.3179e-17
C494	CIN#17	A#3	1.37964e-19
C495	VPWR#12	a_1024_74##8	4.09291e-19
C496	A#15	B#3	3.65756e-18
C497	B#2	A#4	3.8047e-19
C498	VGND#6	a_734_74#	3.88305e-17
C499	CIN#15	a_418_74##19	1.22565e-17
C500	COUT#5	a_418_74##15	3.86823e-17
C501	a_418_74##20	B#1	1.91346e-17
C502	VPWR#7	A#5	1.43125e-17
C503	a_1024_74##10	SUM#6	2.37282e-17
C504	B#8	B#12	4.51668e-21
C505	a_1024_74##15	VPWR#13	3.90023e-17
C506	VPWR#2	a_418_74##16	7.60857e-18
C507	VGND#10	a_1024_74#	1.48343e-19
C508	CIN#16	a_1024_74##15	3.24781e-18
C509	B#8	CIN#9	2.76003e-20
C510	VPWR#11	a_1024_74##12	1.71283e-19
C511	A#7	a_418_74##2	1.74818e-17
C512	a_418_74##19	B	1.0757e-18
C513	a_1024_74##10	VPWR#12	2.79128e-17
C514	a_418_74##15	VGND#11	7.93748e-18
C515	B#8	a_418_74#	4.54645e-20
C516	VPWR#3	a_418_74##14	2.31024e-20
C517	VGND#7	VGND#6	1.13228e-16
C518	B#10	A#1	2.70048e-17
C519	B#8	A#7	1.45731e-17
C520	A#15	A#5	7.08616e-19
C521	B	a_1024_74##15	5.00043e-17
C522	COUT#5	a_1024_74#	1.42399e-18
C523	VGND#7	VGND#5	5.64107e-17
C524	SUM#5	a_1024_74##10	1.7595e-18
C525	B#8	B#7	1.01438e-19
C526	VPWR#4	a_418_74##17	9.12873e-20
C527	VGND#6	VGND#14	6.71133e-18
C528	a_418_74##20	A#11	6.07508e-18
C529	SUM#2	a_418_74##15	1.44351e-18
C530	a_418_74##9	VPWR#3	7.53488e-18
C531	B#8	CIN#4	5.57449e-20
C532	a_1024_74##12	VPWR#12	3.22132e-17
C533	A#15	VGND#16	3.1615e-18
C534	VPWR#13	a_1024_74##10	1.72407e-19
C535	SUM#4	a_418_74##7	5.07615e-20
C536	VPWR#7	CIN#15	1.76844e-18
C537	VGND#7	CIN#16	3.41346e-17
C538	B#8	A#9	6.51979e-20
C539	A#14	A#5	2.07913e-18
C540	a_1024_74#	VGND#11	1.45334e-17
C541	VGND#3	a_418_74##9	8.06319e-17
C542	VPWR#2	a_418_74##17	2.99535e-19
C543	VPWR#3	a_1024_74##5	7.18958e-18
C544	VPWR#2	a_418_74##14	1.51449e-20
C545	CIN#17	B	1.91749e-17
C546	a_418_74##19	VGND#12	2.55919e-19
C547	B#8	B#4	5.02386e-21
C548	SUM#5	a_1024_74##12	7.58882e-17
C549	VGND#7	CIN#15	4.72172e-17
C550	B#5	B#7	4.84534e-21
C551	VGND#3	a_1024_74##5	6.26627e-18
C552	COUT#5	a_1024_74##9	4.03127e-19
C553	A#9	CIN#5	1.54694e-17
C554	a_1024_74##5	VPWR#5	4.17505e-19
C555	SUM#5	VPWR#12	6.10797e-17
C556	CIN#7	B#10	4.47871e-17
C557	COUT	VPWR#2	1.715e-17
C558	B#5	CIN#4	8.9936e-21
C559	VPWR#12	a_1024_74##7	3.71489e-19
C560	COUT#3	a_418_74##10	6.54787e-18
C561	CIN#16	B#14	1.50748e-17
C562	SUM#2	a_1024_74#	2.97028e-17
C563	VPWR#4	a_1024_74##5	2.00104e-20
C564	VPWR#13	a_1024_74##12	6.87375e-19
C565	A#1	a_1238_74#	9.93781e-18
C566	VGND#5	a_418_74##9	3.37037e-18
C567	a_1024_74##4	a_418_74##17	5.53819e-19
C568	B#5	A#9	1.68378e-17
C569	B#10	a_1238_74#	1.37465e-17
C570	a_418_74##20	A#4	2.82369e-19
C571	VPWR#4	a_1024_74##8	3.40035e-19
C572	VGND#6	a_734_74##2	3.28061e-17
C573	a_27_74##2	A#15	9.04464e-18
C574	CIN#16	B#11	1.17542e-18
C575	B#5	B#4	3.5815e-19
C576	VGND#3	a_418_74##14	1.12647e-18
C577	VGND#4	a_418_74##9	5.53347e-17
C578	SUM#5	a_1024_74##7	5.495e-17
C579	VPWR#3	a_1024_74##4	1.96449e-20
C580	CIN#1	B#5	1.2632e-18
C581	VPWR#13	VPWR#12	2.00319e-18
C582	CIN#16	CIN#8	1.37525e-17
C583	VPWR#13	A#3	6.61673e-19
C584	VPWR#2	a_1024_74##8	8.34499e-20
C585	CIN#2	B#4	1.41115e-18
C586	COUT#5	a_1024_74##11	2.42942e-19
C587	VPWR#12	A#2	2.56663e-19
C588	A#2	a_1235_347#	2.35349e-17
C589	B#10	a_1160_74#	1.29358e-17
C590	CIN#15	B#15	3.67356e-17
C591	a_1024_74##7	VPWR#13	2.33831e-17
C592	CIN#2	CIN#1	5.33009e-18
C593	CIN#16	a_418_74##2	3.07523e-17
C594	a_1024_74##17	A#3	2.8924e-20
C595	CIN#7	a_1160_74#	1.15826e-17
C596	B#12	a_1235_347#	2.32213e-17
C597	VGND#3	a_418_74##7	1.57203e-22
C598	SUM#2	a_1024_74##9	3.38513e-17
C599	a_418_74##3	CIN#7	1.37217e-17
C600	VGND#7	a_418_74##20	5.7103e-17
C601	B#2	B#4	3.25533e-19
C602	VPWR#5	a_1024_74##10	8.40062e-20
C603	VPWR#5	B#11	6.78016e-19
C604	CIN#15	B#14	7.48226e-18
C605	B#3	CIN#2	6.46813e-19
C606	SUM	VPWR#4	9.26639e-18
C607	a_1024_74##17	B	3.92293e-17
C608	SUM#5	A#2	1.86137e-18
C609	CIN	A#4	6.95815e-19
C610	COUT#3	a_418_74##12	1.81291e-17
C611	CIN#16	CIN#17	8.98583e-18
C612	B#2	CIN#1	3.133e-18
C613	SUM#2	SUM#4	2.52953e-18
C614	a_418_74##9	a_1024_74##5	1.37518e-18
C615	VPWR#7	CIN#8	1.11871e-18
C616	VGND#7	a_418_74##19	5.76793e-17
C617	VGND#5	a_1024_74##5	3.79407e-20
C618	VPWR#13	SUM#5	5.30395e-17
C619	B#12	a_1141_347#	2.4433e-17
C620	a_418_74##9	COUT#3	4.51361e-17
C621	CIN#15	B#8	3.64543e-17
C622	B#2	B#3	1.63708e-18
C623	VGND#15	VGND#6	1.66467e-18
C624	VPWR#4	a_1024_74##10	4.54306e-18
C625	CIN#9	a_1141_347#	2.4433e-17
C626	VGND#7	CIN#8	1.04078e-18
C627	VPWR#7	a_1024_74##15	4.91916e-18
C628	A#2	VPWR#13	3.71071e-17
C629	a_1024_74##9	VGND#12	1.85304e-17
C630	VGND#3	a_418_74##5	9.84093e-21
C631	VGND#4	a_1024_74##5	6.73619e-19
C632	VPWR#7	a_418_74##2	2.30938e-18
C633	SUM#4	a_418_74##5	5.93672e-20
C634	B#2	A#5	1.20451e-18
C635	COUT#5	a_1024_74##13	1.91226e-19
C636	COUT#2	a_418_74##9	2.29492e-17
C637	CIN#15	CIN#5	2.03379e-17
C638	A#6	B#3	4.08359e-18
C639	VGND#7	a_418_74##2	7.69065e-21
C640	a_1024_74##4	a_1024_74##8	4.65392e-19
C641	SUM#2	a_1024_74##11	3.86565e-20
C642	SUM#5	B#12	7.96838e-20
C643	A#14	a_27_74##2	1.39384e-17
C644	a_418_74##19	VGND#13	2.32473e-18
C645	A#6	A#5	5.29696e-19
C646	a_418_74##19	A#4	2.57469e-20
C647	CIN#15	B#5	4.29289e-17
C648	VPWR#2	a_418_74##7	1.73268e-20
C649	VPWR#6	CIN#8	1.28169e-19
C650	a_1024_74##16	a_1024_74##7	6.64426e-19
C651	A#8	a_418_74##3	3.82735e-17
C652	VPWR#7	CIN#5	2.41248e-18
C653	VGND#3	a_1024_74##4	3.99932e-20
C654	a_418_74##7	a_418_74##5	2.63833e-18
C655	VPWR#5	a_1024_74##6	5.31976e-21
C656	a_1024_74##4	a_418_74##14	2.51373e-17
C657	CIN#8	B#11	3.89522e-17
C658	VPWR#13	B#12	3.4609e-18
C659	VPWR#5	a_1024_74##12	5.45681e-19
C660	VPWR#5	CIN#8	9.6703e-19
C661	COUT#3	a_418_74##16	6.1158e-20
C662	VGND#7	CIN#5	1.84774e-18
C663	VPWR#7	B#5	6.14401e-19
C664	a_1024_74##11	VGND#12	1.85304e-17
C665	a_418_74##19	a_1024_74##15	6.10843e-17
C666	a_418_74##2	B#11	5.9012e-21
C667	VGND#5	B#11	9.44493e-20
C668	VGND#7	B#5	3.58964e-18
C669	VGND#7	a_1024_74##15	1.95421e-18
C670	VPWR#7	CIN#2	2.73772e-18
C671	SUM#4	a_1024_74##6	2.84317e-20
C672	A#12	a_27_74##2	2.4024e-17
C673	B	a_1024_74##16	9.77266e-17
C674	a_418_74##2	CIN#8	2.52823e-17
C675	VPWR#4	a_1024_74##12	7.60237e-18
C676	A#1	a_1024_74##6	6.64134e-18
C677	B#8	B#11	8.80753e-20
C678	a_1024_74##16	A#2	5.14181e-18
C679	SUM#2	a_1024_74##13	1.22562e-20
C680	VGND#7	CIN#2	1.39694e-19
C681	B#15	VPWR#7	1.49147e-17
C682	VGND#3	VGND#1	6.21194e-17
C683	VPWR#7	B#2	4.21881e-18
C684	B#8	CIN#8	5.6091e-20
C685	A#9	a_535_347#	2.79751e-17
C686	VPWR#13	CIN#9	1.56418e-18
C687	SUM#1	a_1024_74##11	3.59525e-17
C688	A#10	a_532_74#	2.07333e-17
C689	a_1024_74##15	SUM#2	3.93098e-19
C690	a_418_74##19	A#3	3.09234e-20
C691	VGND#7	B#2	7.04669e-18
C692	B#4	a_535_347#	2.82122e-17
C693	B#6	a_532_74#	2.07333e-17
C694	B#9	A#8	1.97731e-17
C695	B#8	a_418_74##2	8.19479e-18
C696	B#14	VPWR#7	1.09876e-17
C697	SUM#4	a_418_74##9	6.77756e-18
C698	VGND#3	COUT#1	1.73874e-17
C699	SUM#4	a_418_74##10	1.22227e-20
C700	VPWR#6	a_418_74##2	1.41015e-19
C701	CIN#10	CIN#15	6.4725e-19
C702	VGND#7	A#6	1.35045e-20
C703	a_418_74##2	CIN#5	1.78458e-20
C704	COUT	VPWR#1	3.66444e-17
C705	a_27_74##2	a_27_392#	6.4477e-19
C706	VGND#6	CIN#8	1.1944e-19
C707	a_1024_74##16	B#12	2.82308e-17
C708	COUT#3	a_418_74##17	1.39629e-20
C709	COUT	COUT#6	3.52983e-19
C710	VPWR#5	a_1024_74##7	9.85983e-18
C711	VGND#3	VGND#10	1.82181e-18
C712	a_418_74##19	a_1024_74##5	4.29424e-18
C713	VPWR#10	COUT	2.90098e-17
C714	VPWR#14	A#2	1.17328e-18
C715	CIN#5	B#8	5.78335e-17
C716	COUT#4	COUT	3.79096e-18
C717	SUM#2	A#1	4.00898e-20
C718	VPWR#13	a_418_74#	4.1366e-19
C719	SUM#4	a_1024_74##4	1.69371e-17
C720	B#5	B#8	1.29027e-18
C721	VGND#3	COUT#5	2.50358e-17
C722	SUM#1	a_1024_74##13	2.46794e-17
C723	VPWR#4	a_1024_74##7	3.00302e-19
C724	VGND#7	B#15	4.59271e-19
C725	B#5	CIN#5	5.99573e-20
C726	a_418_74##20	a_418_74##23	2.36356e-18
C727	CIN	a_418_74##20	1.97867e-17
C728	B	A#1	3.85122e-18
C729	VGND#3	VGND#11	6.85982e-18
C730	a_1024_74##16	CIN#9	6.3312e-17
C731	VGND#7	B#14	1.54821e-18
C732	CIN#6	B#9	3.89267e-17
C733	a_1024_74##16	VPWR#13	8.04495e-18
C734	VPWR#7	CIN#17	1.0645e-18
C735	VPWR#14	B#12	5.29906e-19
C736	a_1024_74##5	SUM#4	4.58385e-17
C737	a_418_74##14	VNB	5.6213e-17
C738	VGND#1	VPWR#1	1.43923e-17
C739	a_418_74##7	VNB	2.11782e-17
C740	CIN#2	B#5	5.85097e-17
C741	VGND#3	SUM#2	8.5797e-18
C742	VPWR#13	A#7	3.48041e-20
C743	SUM	VPWR#11	2.46742e-17
C744	a_418_74##5	VNB	4.02841e-17
C745	CIN	B#15	6.69484e-18
C746	a_1024_74##13	VGND#13	1.34473e-17
C747	a_1024_74##17	a_1024_74##9	3.04558e-19
C748	a_1024_74##6	VNB	2.09521e-17
C749	SUM	SUM#6	2.39581e-19
C750	VPWR#2	a_418_74##5	2.22867e-20
C751	a_1024_74##4	VNB	5.72875e-17
C752	VPWR#12	SUM	2.85338e-17
C753	a_737_347#	CIN#9	1.08402e-18
C754	A#4	VNB	1.29895e-16
C755	A#3	VNB	1.16485e-16
C756	VGND#6	a_418_74##2	9.23179e-20
C757	a_418_74##19	B#11	1.17911e-18
C758	VPWR#5	A#2	3.23743e-17
C759	a_1024_74##15	a_1024_74##5	2.52484e-19
C760	SUM#1	A#1	4.92817e-19
C761	VGND#2	a_418_74##4	8.82519e-19
C762	CIN	CIN#10	1.25283e-17
C763	B#2	CIN#2	7.34942e-17
C764	CIN	A#15	2.7917e-18
C765	a_418_74#	a_1024_74##16	2.32957e-17
C766	VPWR#14	CIN#9	9.56732e-19
C767	a_27_74##2	a_27_392##2	1.72345e-18
C768	VGND#3	SUM#1	5.09374e-18
C769	CIN#16	A#3	9.2306e-19
C770	VPWR#4	A#2	4.81857e-19
C771	A#6	B#2	1.95519e-17
C772	VPWR#4	a_1024_74##4	2.75976e-20
C773	a_1024_74##15	SUM#1	2.35121e-17
C774	a_737_347#	a_418_74#	5.04274e-17
C775	A#10	CIN#6	3.24396e-17
C776	VGND#7	CIN#17	6.11498e-19
C777	a_418_74##19	a_1024_74##17	1.09579e-16
C778	a_1024_74##12	a_1024_74##4	3.55366e-19
C779	a_1024_74##17	a_1024_74##11	2.80944e-19
C780	A#1	VGND#13	1.62169e-17
C781	VPWR#6	A#4	1.00755e-18
C782	SUM#4	a_418_74##16	1.44182e-20
C783	a_1024_74##16	A#7	1.2791e-18
C784	B	a_1024_74##7	6.47684e-19
C785	VPWR#7	A#15	2.90659e-18
C786	VPWR#14	a_418_74#	1.85912e-18
C787	B	A#2	1.08431e-17
C788	B	B#12	8.59659e-18
C789	a_1024_74##15	SUM#4	3.96254e-19
C790	a_1024_74##16	A#3	5.50254e-18
C791	B	CIN#9	1.33642e-17
C792	a_418_74##19	CIN#8	4.90837e-19
C793	VGND#6	B#8	6.85083e-19
C794	B	a_418_74#	1.26413e-17
C795	a_1024_74##15	B#11	1.33054e-18
C796	a_737_347#	A#7	3.23832e-17
C797	B	A#7	1.16751e-19
C798	COUT	a_418_74##10	1.55495e-17
C799	VPWR#6	VNB	4.66853e-17
C800	VGND#2	a_418_74##11	5.1835e-18
C801	VPWR#5	B#12	3.9811e-18
C802	VPWR#5	VNB	4.71898e-17
C803	a_737_347##2	a_418_74#	1.83936e-19
C804	B	B#7	4.75124e-21
C805	VPWR#4	VNB	2.92217e-17
C806	COUT	a_418_74##12	1.52184e-17
C807	VPWR#2	VNB	3.41571e-17
C808	COUT	a_418_74##16	1.21657e-18
C809	VGND#6	VNB	5.9035e-17
C810	VGND#5	VNB	5.93705e-17
C811	VPWR#7	A#14	1.13872e-18
C812	a_1024_74##15	a_1024_74##6	9.3175e-19
C813	VGND#4	VNB	3.6757e-17
C814	VGND#2	VNB	3.30507e-17
C815	a_1024_74##17	a_1024_74##13	5.69511e-19
C816	COUT#3	VNB	1.10179e-17
C817	A#5	VGND#16	1.01316e-19
C818	a_1024_74##16	B#7	5.05317e-19
C819	B#6	A#10	2.59176e-17
C820	COUT#2	VNB	4.98649e-18
C821	VPWR#2	VPWR#1	7.43786e-19
C822	a_1024_74##15	VGND#13	4.37734e-18
C823	VGND#7	CIN#10	2.53609e-18
C824	VPWR#14	A#7	3.9356e-17
C825	a_418_74##20	VNB	8.39988e-18
C826	a_418_74##19	VNB	7.63508e-18
C827	a_418_74##19	a_734_74#	8.73668e-17
C828	SUM#4	VNB	1.08348e-18
C829	VPWR#7	A#12	2.1764e-18
C830	CIN	a_418_74##23	3.97326e-18
C831	a_1024_74##15	VNB	7.42011e-18
C832	CIN#15	A#4	5.07915e-19
C833	B#15	VNB	6.90511e-19
C834	SUM#4	a_418_74##17	1.26838e-18
C835	VGND#7	A#15	3.4111e-18
C836	B#14	VNB	3.01834e-18
C837	SUM	a_418_74##17	5.76491e-19
C838	a_737_347#	B#7	4.81908e-19
C839	SUM	a_1024_74##8	1.45125e-17
C840	a_418_74##20	VGND#14	5.72507e-21
C841	CIN#17	VNB	9.2224e-19
C842	a_737_347##2	A#7	5.39026e-19
C843	SUM	a_1024_74##10	1.13246e-17
C844	B#14	a_737_347#	5.52904e-17
C845	VPWR#6	A#3	6.00434e-17
C846	SUM	a_1024_74##12	5.25316e-19
C847	CIN#10	VNB	1.01548e-18
C848	CIN#16	B	1.52777e-17
C849	CIN#15	A#3	3.24947e-19
C850	A#15	VNB	4.19638e-18
C851	VPWR#6	CIN#9	1.60029e-18
C852	A#12	VNB	2.36928e-17
C853	VGND#1	VNB	7.10189e-17
C854	COUT#1	VNB	2.56431e-18
C855	VGND#10	VNB	2.96238e-19
C856	COUT#5	VNB	2.26291e-18
C857	CIN#8	a_1024_74##15	2.29499e-18
C858	a_1024_74##16	CIN#4	2.56103e-19
C859	SUM#2	VNB	1.38095e-18
C860	VPWR#7	B	7.92911e-18
C861	B#7	VPWR#14	2.73291e-17
C862	a_734_74#	VGND#14	5.48894e-19
C863	a_737_347#	a_1024_74##16	5.9004e-17
C864	a_418_74##20	B#15	3.85742e-18
C865	SUM#1	VNB	6.89399e-19
C866	a_1024_74##17	A#1	1.55213e-18
C867	B#5	a_532_74#	1.42267e-18
C868	VPWR#15	A#7	3.57824e-20
C869	VGND#7	B	7.37864e-18
C870	CIN#16	a_1024_74##17	9.08712e-18
C871	VGND#7	A#14	1.34883e-18
C872	a_734_74#	VNB	2.12343e-18
C873	VGND#2	a_418_74##13	5.53343e-18
C874	VGND#10	a_418_74##14	1.90934e-19
C875	a_734_74##2	VNB	2.11643e-18
C876	VGND#15	VNB	5.85295e-19
C877	VPWR#5	CIN#9	1.28703e-18
C878	VPWR#3	COUT	1.85309e-17
C879	a_1024_74##15	a_1024_74##4	2.46494e-19
C880	CIN#3	B#6	2.24816e-17
C881	a_418_74##7	COUT#1	7.44047e-21
C882	a_27_74#	VNB	4.25599e-18
C883	B	B#11	1.93704e-17
C884	COUT#2	a_418_74##4	5.24334e-18
C885	a_27_74##2	VNB	3.7101e-17
C886	VPWR#1	VNB	8.20729e-17
C887	VGND#7	A#12	2.3519e-18
C888	a_737_347##2	B#7	5.54253e-17
C889	CIN#8	B	6.27944e-17
C890	CIN#16	a_734_74#	4.8959e-18
C891	VPWR#10	VNB	3.0111e-18
C892	COUT#4	VNB	2.35576e-18
C893	VPWR#11	VNB	8.01271e-18
C894	a_418_74##2	B	1.86972e-17
C895	a_737_347#	A#3	5.19779e-18
C896	VPWR#12	VNB	3.0111e-18
C897	a_418_74##19	VGND#14	2.83603e-18
C898	SUM#5	VNB	2.16313e-18
C899	B#8	B	1.37706e-18
C900	VPWR#13	VNB	4.55233e-18
C901	SUM	VPWR#3	2.659e-17
C902	a_1024_74##16	VNB	4.54818e-19
C903	a_737_347#	VNB	3.76102e-19
C904	VPWR#14	VNB	8.03549e-18
C905	a_1024_74##16	A#9	3.14762e-19
C906	a_737_347##2	VNB	4.25901e-19
C907	SUM#4	a_1024_74##8	2.68127e-17
C908	VPWR#14	CIN#4	1.51025e-18
C909	VPWR#15	VNB	5.11676e-18
C910	VGND#4	a_418_74##15	5.90981e-19
C911	VPWR#15	B#7	1.47847e-18
C912	a_418_74##23	VNB	4.24662e-18
C913	B#14	VPWR#14	1.01733e-18
C914	a_27_392#	VNB	4.91394e-18
C915	a_418_74##20	a_734_74##2	2.10106e-18
C916	a_27_392##2	VNB	4.96118e-17
C917	a_418_74##4	VNB	2.87395e-17
C918	a_418_74##11	VNB	2.88114e-17
C919	a_734_74##2	a_734_74#	2.43694e-18
C920	a_418_74##13	VNB	2.61392e-17
C921	a_418_74##15	VNB	3.10511e-17
C922	a_1024_74##17	B#10	2.1055e-17
C923	a_1024_74#	VNB	3.10997e-17
C924	a_1024_74##9	VNB	3.1987e-17
C925	a_1024_74##11	VNB	3.21024e-17
C926	a_1024_74##13	VNB	3.14909e-17
C927	A#1	VNB	4.33522e-17
C928	B#10	VNB	2.66429e-17
C929	a_418_74##19	B#8	3.28503e-17
C930	a_418_74##2	a_1024_74##15	5.73225e-19
C931	a_737_347##2	CIN#4	4.1158e-17
C932	B	a_1235_347#	1.06045e-18
C933	CIN#7	VNB	2.72245e-17
C934	VPWR#6	a_418_74#	4.26436e-18
C935	a_418_74##3	VNB	2.67699e-17
C936	A#8	VNB	3.7747e-17
C937	VGND#5	VGND#4	4.33909e-18
C938	B#9	VNB	2.65224e-17
C939	B	a_1141_347#	4.47308e-19
C940	CIN#6	VNB	2.52233e-17
C941	A#10	VNB	3.29846e-17
C942	B#6	VNB	2.50765e-17
C943	CIN#3	VNB	2.54822e-17
C944	B#1	VNB	3.21182e-17
C945	A#11	VNB	3.46829e-17
C946	COUT#3	VPWR#2	1.38338e-19
C947	B#1	CIN#3	3.80976e-17
C948	a_418_74##10	VNB	4.04221e-17
C949	a_418_74##12	VNB	3.08272e-17
C950	VGND#2	a_418_74##15	6.27248e-19
C951	a_418_74##16	VNB	3.61576e-17
C952	VPWR#14	A#9	3.761e-20
C953	a_418_74##17	VNB	3.47761e-17
C954	A#2	a_1024_74##6	8.94563e-18
C955	VGND#7	CIN	1.9738e-17
C956	a_1024_74##8	VNB	3.36864e-17
C957	a_737_347#	VPWR#14	5.12199e-17
C958	CIN#4	VPWR#15	2.37295e-17
C959	VPWR#5	A#3	1.65885e-18
C960	a_1024_74##10	VNB	3.07939e-17
C961	a_1024_74##12	VNB	3.49265e-17
C962	COUT#2	a_418_74##11	1.80886e-17
C963	a_1024_74##7	VNB	3.92365e-17
C964	VPWR#3	VPWR#1	5.55931e-17
C965	A#2	VNB	9.60797e-17
C966	VPWR#14	A#4	1.62018e-18
C967	B#12	VNB	2.14162e-17
C968	CIN#9	VNB	2.2393e-17
C969	a_1024_74##15	a_1024_74##8	8.69898e-20
C970	a_418_74#	VNB	2.30462e-17
C971	A#7	VNB	2.90265e-17
C972	B#7	VNB	2.46191e-17
C973	CIN#4	VNB	2.4111e-17
C974	a_418_74##19	a_734_74##2	4.90925e-17
C975	A#9	VNB	2.4452e-17
C976	B#4	VNB	2.1607e-17
C977	CIN#1	VNB	2.81781e-17
C978	CIN	B#5	1.54527e-17
C979	a_734_74##2	VGND#14	6.09955e-19
C980	B#3	VNB	2.93697e-17
C981	a_737_347##2	A#9	1.08402e-18
C982	CIN	CIN#2	1.98037e-17
C983	A#5	VNB	1.22518e-16
C984	CIN	B#2	7.60461e-18
C985	SUM#4	a_1024_74##10	3.25215e-17
C986	a_1024_74##17	CIN#7	3.91553e-17
C987	VPWR#3	VNB	2.3879e-16
C988	B#14	a_737_347##2	6.61034e-17
C989	VGND#3	VNB	2.37137e-16
C990	CIN#15	a_734_74##2	3.61199e-18
C991	CIN#16	VNB	3.2075e-18
C992	CIN#15	VNB	7.66863e-18
C993	VPWR#7	VNB	3.21532e-16
C994	VGND#4	a_1024_74#	1.27566e-18
C995	VGND#7	VNB	3.34828e-16
C996	a_418_74##20	VGND#15	4.10661e-17
C997	a_418_74##9	VNB	8.91318e-19
C998	a_418_74##20	CIN#5	2.95657e-17
C999	a_1024_74##5	VNB	3.61056e-17
C1000	COUT#5	a_418_74##14	2.9325e-18
C1001	B#11	VNB	2.97032e-17
C1002	CIN#8	VNB	2.98703e-17
C1003	a_418_74##2	VNB	2.16629e-17
C1004	VGND#10	a_418_74##7	8.36535e-19
C1005	B#8	VNB	2.8964e-17
C1006	CIN#5	VNB	2.35798e-17
C1007	VPWR#15	A#9	4.58409e-17
C1008	a_418_74##9	VGND#10	1.09515e-18
C1009	a_737_347##2	a_737_347#	2.33977e-18
C1010	B#5	VNB	1.88734e-17
C1011	CIN#15	VGND#15	4.20781e-18
C1012	CIN#2	VNB	2.78081e-17
C1013	B#2	VNB	3.30997e-17
C1014	a_418_74##5	COUT#1	4.65774e-19
C1015	B#15	VPWR#15	2.71043e-17
C1016	a_418_74##19	CIN#5	9.91492e-18
C1017	A#6	VNB	7.15814e-17
C1018	VPWR#14	A#3	9.11818e-18
C1019	a_418_74##19	B#14	8.91774e-18
C1020	VGND#3	VPWR#1	4.80797e-18
C1021	A#11	B#1	3.70943e-18
C1022	CIN#17	CIN#8	6.07598e-18
C1023	a_418_74##9	COUT#5	1.00371e-16
C1024	COUT#4	VPWR#3	2.82281e-17
C1025	a_418_74##2	B#14	2.01467e-17
C1026	B	VNB	4.323e-18
C1027	VGND#5	a_1024_74##9	5.90981e-19
C1028	VGND#2	a_1024_74#	2.56028e-19
C1029	COUT	VNB	2.27781e-18
C1030	SUM	VNB	2.32475e-18
C1031	CIN	VNB	3.05653e-19
C1032	a_418_74##9	VGND#11	1.45872e-17
C1033	COUT#2	a_418_74##13	1.72816e-19
C1034	a_418_74##3	a_1024_74##17	2.59862e-17
C1035	VPWR#7	VPWR#8	1.39347e-16
C1036	VPWR#8	B#2	4.51459e-19
C1037	VGND#7	VGND#8	1.50258e-16
C1038	VGND#8	A#11	1.275e-17
C1039	VGND#8	CIN#3	5.50251e-18
C1040	VPWR#8	A#5	4.66546e-17
C1041	VPWR#8	VNB	6.74021e-17
C1042	VGND#8	A#10	2.70813e-19
C1043	a_27_392#	VPWR#8	3.92857e-17
C1044	VGND#8	a_27_74##2	7.12543e-17
C1045	VGND#8	a_27_74#	5.37925e-17
C1046	VPWR#8	A#4	5.14308e-18
C1047	VPWR#8	A#6	1.7785e-19
C1048	VGND#8	A#6	1.47891e-18
C1049	VGND#8	CIN#2	1.17062e-20
C1050	VGND#8	VNB	7.97387e-17
C1051	CIN	VGND#8	8.8015e-19
C1052	VGND#8	a_418_74##20	6.56629e-18
C1053	VGND#8	B#1	9.33193e-18
C1054	VGND#8	B#6	3.72883e-19
C1055	VPWR#8	CIN#2	7.87384e-20
C1056	VGND#8	VGND#16	1.15495e-17
C1057	a_27_392##2	VPWR#8	2.48428e-17
C1058	VPWR#8	B#3	3.02719e-18
C1059	VGND#8	B#2	9.65333e-19
*
*
.ENDS sky130_fd_sc_hs__fa_4
*
