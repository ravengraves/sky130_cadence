* Extracted by Quantus, converted by sky130cad/quantus.py
*
*
*
*                       LINUX           Wed Nov 18 08:11:08 2026
*
*
*
*  PROGRAM  advgen
*
*  Name           : advgen - Quantus - (64-bit)
*  Version        : 25.1.0-p047
*  Build Date     : Thu Dec 11 23:20:30 PST 2025
*
*  HSPICE LIBRARY
*
*  OPERATING_TEMPERATURE 150
*  QRC_TECH_DIR <path>/tech
*
*
*

*
.SUBCKT sky130_fd_sc_hs__a311o_1 VPB VNB VGND VPWR X A1 B1 C1 A3 A2
*
*
*  caps2d version: 10
*
*
*       TRANSISTOR CARDS
*
*
XM7 X#1 a_89_270# VGND#7 VNB sky130_fd_pr__nfet_01v8_lvt l=0.15 w=0.74 ad=0.1961 as=0.2569 pd=2.01 ps=2.2
XM0 VGND#7 A3#1 a_264_120# VNB sky130_fd_pr__nfet_01v8_lvt l=0.15 w=0.64 ad=0.2569 as=0.210625 pd=2.2 ps=1.96
XM4 a_264_120# A2#1 a_359_123# VNB sky130_fd_pr__nfet_01v8_lvt l=0.15 w=0.64 ad=0.210625 as=0.2048 pd=1.96 ps=1.92
XM2 a_359_123# A1#2 a_89_270##9 VNB sky130_fd_pr__nfet_01v8_lvt l=0.15 w=0.64 ad=0.2048 as=0.1792 pd=1.92 ps=1.84
XM1 a_89_270##9 B1#2 VGND#6 VNB sky130_fd_pr__nfet_01v8_lvt l=0.15 w=0.64 ad=0.1792 as=0.272 pd=1.84 ps=2.13
XM9 VGND#6 C1#2 a_89_270##4 VNB sky130_fd_pr__nfet_01v8_lvt l=0.15 w=0.64 ad=0.272 as=0.1696 pd=2.13 ps=1.81
XM5 X#2 a_89_270##3 VPWR#6 VPB sky130_fd_pr__pfet_01v8 l=0.15 w=1.12 ad=0.308 as=0.5618 pd=2.79 ps=3.3
XM6 VPWR#6 A3#3 a_258_392##2 VPB sky130_fd_pr__pfet_01v8 l=0.15 w=1 ad=0.5618 as=0.3 pd=3.3 ps=2.6
XM11 a_258_392##2 A2#3 VPWR#5 VPB sky130_fd_pr__pfet_01v8 l=0.15 w=1 ad=0.3 as=0.39 pd=2.6 ps=2.78
XM3 VPWR#5 A1#1 a_258_392# VPB sky130_fd_pr__pfet_01v8 l=0.15 w=1 ad=0.39 as=0.3 pd=2.78 ps=2.6
XM10 a_258_392# B1#1 a_546_392# VPB sky130_fd_pr__pfet_01v8 l=0.15 w=1 ad=0.3 as=0.24 pd=2.6 ps=2.48
XM8 a_546_392# C1#3 a_89_270##8 VPB sky130_fd_pr__pfet_01v8 l=0.15 w=1 ad=0.24 as=0.275 pd=2.48 ps=2.55
*
*
*       RESISTOR AND CAP/DIODE CARDS
*
Rg1	a_89_270#	a_89_270##2	334.791077
Rg2	a_89_270##2	a_89_270##3	451.603058
Rg3	A3#1	A3#2	349.049408
Rg4	A3#2	A3#3	417.269073
Rg5	A2#1	A2#2	328.022858
Rg6	A2#2	A2#3	409.090576
Rg7	A1#1	A1#2	803.013733
Rg8	A1#2	A1#3	279.244598
Rg9	B1#1	B1#2	796.430786
Rg10	B1#2	B1#3	279.244598
Rg11	C1#1	C1#2	346.188873
Rg12	C1#2	C1#3	798.750732
Rf1	X#1	X	95.695877
Rf2	X	X#3	0.372219
Rf3	X#3	X	13.399889
Rf4	X#2	X#3	5.000000
Rf5	A3	A3#2	162.790939
Rf6	A2#4	A2	0.956614
Rf7	A2#2	A2#6	161.189423
Rf8	A2#4	A2#6	2.362036
Rf9	A1#3	A1	168.929993
Rf10	a_258_392#	a_258_392##2	102.320374
Rf11	B1	B1#3	171.138672
Rf12	a_89_270##4	a_89_270##5	31.715120
Rf13	a_89_270##5	a_89_270##6	72.065117
Rf14	a_89_270##6	a_89_270##2	285.649658
Rf15	a_89_270##5	a_89_270##8	36.859306
Rf16	a_89_270##6	a_89_270##9	22.463814
Rf17	C1#1	C1#5	161.023331
Rf18	C1#6	C1	0.790535
Rf19	C1#5	C1#6	8.463963
Rf21	VGND#2	VGND#3	88.489143
Rf22	VGND#3	VGND#4	70.834450
Rf24	VGND#2	VGND#6	78.460808
Rf25	VGND#4	VGND#7	42.184113
Rf27	VPWR#2	VPWR#3	77.112503
Rf29	VPWR#2	VPWR#5	38.646820
Rf30	VPWR#3	VPWR#6	27.352680
Re1	VPWR#2	VPWR	1.227783
Re2	VGND	VGND#3	1.227829
*
*       CAPACITOR CARDS
*
*
C1	a_89_270##6	a_89_270##5	4.8359e-19
C2	a_89_270##6	a_89_270##4	4.98833e-18
C3	a_89_270##6	VGND#6	3.65763e-17
C4	VGND#6	a_89_270##5	1.78202e-17
C5	a_89_270##6	a_89_270##9	1.20622e-18
C6	VGND#7	a_89_270##6	3.8991e-18
C7	X#1	a_89_270##6	9.3089e-19
C8	a_89_270##5	a_89_270##8	3.61273e-20
C9	VGND#6	a_89_270##4	2.34571e-17
C10	a_89_270##6	a_258_392#	2.94078e-17
C11	a_258_392#	a_89_270##5	1.04551e-18
C12	a_89_270##6	a_258_392##2	9.56551e-19
C13	VGND#7	VGND#6	2.39408e-20
C14	a_89_270##6	C1#2	3.1292e-18
C15	a_89_270##5	C1#2	2.34254e-17
C16	a_89_270##6	B1#2	2.62974e-17
C17	a_89_270##5	B1#2	1.43262e-19
C18	a_89_270##6	A1#2	3.34225e-17
C19	X#1	VGND#7	3.99411e-17
C20	a_89_270##6	A2#1	2.29614e-17
C21	a_89_270##6	A3#1	6.26034e-19
C22	a_89_270##6	a_89_270#	3.83586e-19
C23	a_89_270##4	C1#2	2.38346e-17
C24	VGND#6	C1#2	3.7184e-17
C25	a_258_392#	a_89_270##8	3.46362e-17
C26	a_89_270##4	B1#2	1.45018e-18
C27	B1#2	VGND#6	2.14187e-17
C28	a_89_270##5	C1#3	1.13651e-17
C29	B1#2	a_89_270##9	1.247e-17
C30	VGND#6	A1#2	1.63354e-18
C31	a_89_270##6	B1#1	1.11614e-17
C32	a_258_392#	VPWR#5	7.92708e-17
C33	a_89_270##5	B1#1	1.22918e-18
C34	A1#2	a_89_270##9	1.24668e-17
C35	VGND#6	A2#1	9.24252e-19
C36	VGND#7	C1#2	4.21506e-19
C37	a_89_270##6	A1#1	4.0426e-18
C38	a_258_392##2	a_258_392#	2.67264e-18
C39	a_89_270##5	A1#1	3.14128e-19
C40	VGND#7	B1#2	3.7847e-19
C41	VGND#6	A3#1	6.12913e-19
C42	a_258_392##2	VPWR#5	6.53923e-17
C43	VGND#7	A1#2	1.05443e-18
C44	a_89_270##5	A2#3	5.34953e-21
C45	VGND#6	a_89_270#	6.93388e-19
C46	VPWR#6	VPWR#5	2.50521e-18
C47	X#1	A1#2	1.24472e-19
C48	VGND#7	A2#1	2.86855e-18
C49	VPWR#6	a_258_392##2	9.17969e-17
C50	a_89_270##5	A3#3	5.34422e-21
C51	X#1	A2#1	2.04754e-19
C52	A3#1	VGND#7	2.03623e-17
C53	X#1	A3#1	9.41464e-19
C54	X#2	VPWR#6	4.3599e-17
C55	VGND#7	a_89_270#	3.77896e-17
C56	X#1	a_89_270#	1.85787e-17
C57	VGND#3	a_89_270##6	2.70195e-18
C58	B1#2	C1#2	3.34369e-17
C59	C1#5	C1#1	1.82998e-17
C60	a_89_270##8	C1#3	4.48044e-17
C61	a_89_270##8	B1#1	9.87457e-18
C62	a_258_392#	C1#3	1.00225e-17
C63	A1#2	B1#2	4.70007e-17
C64	VPWR#5	C1#3	5.84794e-19
C65	a_89_270##6	B1#3	2.36587e-19
C66	a_258_392#	B1#1	6.01774e-17
C67	a_89_270##5	B1#3	3.91157e-19
C68	VPWR#5	B1#1	8.49319e-19
C69	A2#1	A1#2	2.50952e-17
C70	a_258_392#	A1#1	6.22019e-17
C71	a_89_270##6	A1#3	2.67485e-18
C72	A1#1	VPWR#5	2.73375e-17
C73	a_258_392#	A2#3	5.20364e-19
C74	a_258_392##2	A1#1	1.53067e-18
C75	A3#1	A2#1	3.19165e-17
C76	A2#3	VPWR#5	3.11765e-17
C77	a_89_270##6	A2#2	3.45164e-17
C78	VPWR#6	A1#1	3.10644e-19
C79	A2#2	a_89_270##5	2.53342e-18
C80	C1#1	a_89_270##4	7.08284e-18
C81	a_258_392##2	A2#3	6.98915e-17
C82	B1#1	C1#2	4.32817e-18
C83	VPWR#5	A3#3	7.72759e-19
C84	a_89_270#	A3#1	2.59606e-17
C85	VPWR#6	A2#3	1.40297e-18
C86	a_89_270##6	A3#2	8.93202e-20
C87	a_258_392##2	A3#3	5.08638e-17
C88	VPWR#5	a_89_270##3	3.30097e-19
C89	a_89_270##5	A3#2	5.07701e-20
C90	A3#3	VPWR#6	3.13739e-17
C91	B1#3	VGND#6	1.40192e-17
C92	a_89_270##2	a_89_270##6	1.44936e-18
C93	a_89_270##3	VPWR#6	4.42956e-17
C94	X#2	a_89_270##3	2.45282e-17
C95	VGND#7	A1#3	4.25941e-19
C96	B1#1	C1#3	8.00177e-17
C97	A1#1	B1#1	5.58969e-17
C98	a_258_392#	A1#3	5.77396e-19
C99	VGND#7	A3#2	7.48906e-19
C100	VPWR#5	A1#3	2.01304e-19
C101	A2#3	A1#1	2.91392e-17
C102	a_89_270##6	a_359_123#	3.97761e-19
C103	a_89_270##2	VGND#7	3.69062e-17
C104	VGND#3	A2#1	3.06212e-18
C105	A2#2	VPWR#5	2.28015e-18
C106	B1#3	C1#2	2.51064e-17
C107	a_89_270##2	X#1	6.26591e-17
C108	A2#2	a_258_392##2	1.84319e-17
C109	VGND#3	a_89_270#	3.431e-20
C110	A3#3	A2#3	4.16116e-17
C111	VPWR#6	A3#2	4.05848e-18
C112	a_89_270##2	a_258_392##2	6.05801e-18
C113	A2#1	A1#3	1.08621e-17
C114	a_89_270##3	A3#3	1.94155e-17
C115	A2#2	A1#2	1.92691e-17
C116	a_89_270##2	VPWR#6	3.79901e-17
C117	A3#1	A1#3	9.28799e-19
C118	a_89_270#	A1#3	6.943e-19
C119	A3#2	A2#1	3.03056e-19
C120	a_89_270##6	A2	1.14462e-17
C121	a_89_270##2	A1#2	8.1258e-20
C122	a_89_270##2	A2#1	9.86189e-21
C123	A2#2	C1#3	3.03872e-19
C124	a_89_270##2	A3#1	2.66598e-17
C125	A2#2	B1#1	5.61427e-19
C126	a_89_270##2	a_89_270#	4.58023e-18
C127	A2#2	A1#1	1.99853e-17
C128	A1#2	a_359_123#	1.34468e-17
C129	a_89_270##3	A3#2	9.25859e-19
C130	C1#3	a_546_392#	2.41308e-17
C131	A2#1	a_359_123#	1.34468e-17
C132	VGND#3	A1#3	8.69375e-18
C133	B1	a_89_270##6	1.68529e-17
C134	B1#1	a_546_392#	2.3145e-17
C135	VGND#3	A2#2	8.23876e-20
C136	C1	a_89_270##4	1.84438e-17
C137	VGND#6	C1	1.70253e-17
C138	A2#1	a_264_120#	1.33812e-17
C139	A2	a_258_392##2	1.9634e-17
C140	A1#3	B1#3	3.01879e-17
C141	A3#1	a_264_120#	1.34103e-17
C142	A1	a_89_270##6	4.1293e-17
C143	VGND#3	a_89_270##2	7.16305e-19
C144	A3	a_258_392##2	2.31307e-17
C145	B1	VGND#6	1.29139e-17
C146	B1	a_89_270##9	3.4357e-19
C147	A3#2	A2#2	2.98336e-17
C148	a_89_270##2	A2#2	1.19718e-19
C149	A1	a_89_270##9	6.1301e-19
C150	C1	C1#2	3.0487e-18
C151	a_89_270##2	A3#2	3.53073e-17
C152	VGND#7	A1	1.16913e-17
C153	B1	C1#2	1.4036e-18
C154	VPWR	a_89_270##6	4.60602e-18
C155	VPWR	a_89_270##5	2.99708e-18
C156	B1	B1#2	4.52743e-18
C157	B1	A1#2	9.88732e-19
C158	X#1	X	7.14686e-18
C159	A2#2	a_359_123#	7.90375e-19
C160	A3	a_89_270##3	7.6516e-19
C161	A1	B1#2	1.49543e-18
C162	A1	A1#2	4.86e-18
C163	VGND	C1#5	1.49584e-17
C164	A1	A2#1	1.47605e-17
C165	VGND	a_89_270##6	1.23444e-17
C166	X	VPWR#6	4.90056e-17
C167	A1	A3#1	4.4791e-18
C168	VGND	a_89_270##5	2.92696e-18
C169	X	X#2	4.41501e-18
C170	A1	a_89_270#	2.17214e-18
C171	a_89_270##2	a_264_120#	2.82928e-18
C172	VPWR	a_89_270##8	2.27398e-17
C173	VPWR	a_258_392#	1.71311e-17
C174	A2	A2#2	6.59079e-18
C175	VGND	a_89_270##4	7.17247e-18
C176	VPWR	a_258_392##2	1.73635e-17
C177	A2	A3#2	2.91082e-18
C178	VGND	VGND#6	6.36866e-18
C179	C1	C1#1	8.97685e-18
C180	VPWR	VPWR#6	3.01709e-17
C181	A3	A2#2	3.24315e-18
C182	C1#5	VNB	7.95936e-18
C183	A3	A3#2	1.61059e-17
C184	VGND	X#1	1.524e-17
C185	a_89_270##6	VNB	5.30212e-18
C186	X	B1#1	2.66476e-19
C187	a_89_270##5	VNB	3.39402e-17
C188	X	A1#1	2.67246e-19
C189	a_89_270##2	A3	5.53132e-17
C190	VGND	a_258_392#	2.93721e-18
C191	B1	B1#3	4.1095e-19
C192	X	A2#3	7.51512e-21
C193	X	A3#3	1.89747e-20
C194	VGND#3	A1	4.79127e-17
C195	X	a_89_270##3	2.47927e-17
C196	VPWR	C1#3	3.39496e-18
C197	a_89_270##4	VNB	1.59305e-17
C198	VGND#6	VNB	7.58268e-18
C199	VGND	C1#2	1.19334e-19
C200	VPWR	B1#1	2.14549e-18
C201	A1	B1#3	2.48151e-17
C202	VPWR	A1#1	3.44676e-19
C203	A1	A1#3	1.86513e-17
C204	VPWR	A2#3	7.51042e-19
C205	VGND#7	VNB	3.97849e-18
C206	A2	a_264_120#	1.59737e-19
C207	X#1	VNB	5.49477e-17
C208	VGND	A3#1	7.04257e-18
C209	VPWR	A3#3	2.25383e-18
C210	A1	A2#2	1.61159e-18
C211	a_89_270##8	VNB	5.30344e-17
C212	VGND	a_89_270#	3.74709e-18
C213	VPWR	a_89_270##3	4.23412e-18
C214	a_258_392#	VNB	6.49526e-18
C215	VPWR#5	VNB	4.12075e-18
C216	a_258_392##2	VNB	5.71338e-18
C217	VPWR#6	VNB	7.2584e-18
C218	X#2	VNB	1.99637e-17
C219	X	A2#2	3.90786e-19
C220	C1#2	VNB	6.51297e-17
C221	B1#2	VNB	2.50531e-17
C222	X	A3#2	1.14899e-18
C223	A1#2	VNB	2.53333e-17
C224	A3	A2	2.42187e-17
C225	A2#1	VNB	2.69351e-17
C226	X	a_89_270##2	2.318e-17
C227	A3#1	VNB	3.00168e-17
C228	a_89_270#	VNB	3.82569e-17
C229	VPWR	A2#2	1.02499e-18
C230	A1	a_359_123#	1.79177e-18
C231	C1#3	VNB	3.65868e-17
C232	VGND	VGND#3	2.6408e-17
C233	VPWR	A3#2	3.24537e-19
C234	B1#1	VNB	3.84646e-17
C235	VGND	C1#1	5.76497e-18
C236	A1#1	VNB	4.08622e-17
C237	VPWR	a_89_270##2	4.4323e-18
C238	VGND	B1#3	1.53555e-17
C239	A2#3	VNB	3.13301e-17
C240	A3#3	VNB	3.77793e-17
C241	VGND	A1#3	4.26445e-18
C242	a_89_270##3	VNB	4.09859e-17
C243	VGND	A2#2	1.05426e-18
C244	VGND#3	VNB	2.02833e-16
C245	VGND	a_89_270##2	1.00213e-17
C246	C1#1	VNB	5.66146e-17
C247	B1#3	VNB	3.48144e-17
C248	A1#3	VNB	3.78042e-17
C249	A2#2	VNB	3.81428e-17
C250	X	A3	3.55892e-18
C251	A3#2	VNB	2.90866e-17
C252	A1	B1	1.12903e-17
C253	VPWR	A2	7.81528e-19
C254	a_89_270##2	VNB	3.84386e-17
C255	VPWR	A3	3.59952e-18
C256	VGND	A2	8.91668e-19
C257	VGND	A3	1.85335e-18
C258	VPWR	X	1.7422e-17
C259	VGND	A1	2.57703e-17
C260	C1	VNB	1.7866e-17
C261	B1	VNB	1.00408e-18
C262	VGND	X	1.52277e-18
C263	A1	VNB	1.00167e-17
C264	X	VNB	4.47891e-17
C265	VPWR	VNB	7.21742e-17
C266	VGND	VNB	6.33176e-17
C267	VGND#2	a_89_270##4	1.59201e-18
C268	VGND#4	B1#3	1.03727e-19
C269	VGND#4	X#1	1.38881e-17
C270	VPWR#2	C1#3	8.05886e-18
C271	VPWR#3	VNB	5.36293e-17
C272	VPWR#2	A1#1	4.49686e-18
C273	VPWR#3	a_89_270##3	4.63569e-18
C274	VGND	VGND#2	5.14334e-17
C275	VPWR#2	A3#3	4.74403e-19
C276	VGND#4	A3#1	3.7612e-18
C277	VGND#4	A1	4.52204e-18
C278	a_89_270##6	VPWR#2	4.60029e-19
C279	VGND#3	VGND#2	5.66866e-17
C280	X	VPWR#3	2.18358e-17
C281	VGND	VGND#4	6.47361e-17
C282	VGND#2	C1#5	4.73117e-17
C283	VPWR#6	VPWR#2	4.97451e-19
C284	VGND#2	A1#3	5.09679e-19
C285	VPWR	VPWR#2	8.46161e-17
C286	VPWR#2	C1#2	1.18744e-19
C287	VPWR#2	VNB	2.55585e-16
C288	VPWR#2	VPWR#3	6.34202e-17
C289	VGND#4	C1#2	6.1367e-20
C290	VPWR#3	A3#3	7.74694e-18
C291	VPWR#2	B1#1	8.34807e-18
C292	VGND#2	B1#3	5.90394e-17
C293	VPWR#2	A2#3	5.29015e-18
C294	VGND#3	VGND#4	6.31842e-17
C295	a_89_270##8	VPWR#2	3.02231e-17
C296	VGND#2	VGND#6	3.14879e-18
C297	VGND#2	C1	2.85482e-18
C298	VPWR#2	a_89_270##3	9.61705e-20
C299	VGND#4	A1#3	2.56877e-18
C300	a_258_392#	VPWR#2	1.95431e-17
C301	A3	VPWR#3	8.36228e-19
C302	VGND#4	a_89_270##2	2.38157e-18
C303	a_89_270##5	VPWR#2	6.6101e-19
C304	VGND#2	C1#2	1.19992e-17
C305	a_89_270##2	VPWR#3	4.82366e-19
C306	a_258_392##2	VPWR#2	8.01136e-18
C307	a_258_392##2	VPWR#3	9.23085e-18
C308	VPWR	VPWR#3	3.93768e-17
C309	VGND#2	VNB	4.66984e-17
C310	VGND#4	a_89_270#	2.76822e-18
C311	VGND#2	C1#1	1.1048e-17
C312	VGND#4	VNB	6.47118e-17
*
*
.ENDS sky130_fd_sc_hs__a311o_1
*
