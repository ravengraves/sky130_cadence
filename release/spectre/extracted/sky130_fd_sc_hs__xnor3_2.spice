* Extracted by Quantus, converted by sky130cad/quantus.py
*
*
*
*                       LINUX           Wed Nov 18 09:14:47 2026
*
*
*
*  PROGRAM  advgen
*
*  Name           : advgen - Quantus - (64-bit)
*  Version        : 25.1.0-p047
*  Build Date     : Thu Dec 11 23:20:30 PST 2025
*
*  HSPICE LIBRARY
*
*  OPERATING_TEMPERATURE 150
*  QRC_TECH_DIR <path>/tech
*
*
*

*
.SUBCKT sky130_fd_sc_hs__xnor3_2 VNB VPB VGND VPWR X B C A
*
*
*  caps2d version: 10
*
*
*       TRANSISTOR CARDS
*
*
XM13 a_27_373# a_83_247# VGND#10 VNB sky130_fd_pr__nfet_01v8_lvt l=0.15 w=0.64 ad=0.1824 as=0.2304 pd=1.85 ps=2
XM1 VGND#10 A#3 a_83_247##9 VNB sky130_fd_pr__nfet_01v8_lvt l=0.15 w=0.64 ad=0.2304 as=0.24 pd=2 ps=2.03
XM4 a_83_247##9 B#8 a_329_81##4 VNB sky130_fd_pr__nfet_01v8_lvt l=0.15 w=0.64 ad=0.24 as=0.2396 pd=2.03 ps=2.4
XM2 a_329_81##4 a_397_21##4 a_27_373##6 VNB sky130_fd_pr__nfet_01v8_lvt l=0.15 w=0.42 ad=0.2396 as=0.2062 pd=2.4 ps=2
XM14 a_27_373##6 B#6 a_332_373# VNB sky130_fd_pr__nfet_01v8_lvt l=0.15 w=0.64 ad=0.2062 as=0.224 pd=2 ps=1.98
XM20 a_332_373# a_397_21##3 a_83_247##11 VNB sky130_fd_pr__nfet_01v8_lvt l=0.15 w=0.64 ad=0.224 as=0.3525 pd=1.98 ps=2.83
XM18 a_397_21##8 B#3 VGND#9 VNB sky130_fd_pr__nfet_01v8_lvt l=0.15 w=0.74 ad=0.2109 as=0.3368 pd=2.05 ps=2.67
XM10 a_329_81##6 a_1027_48##3 a_1057_74##9 VNB sky130_fd_pr__nfet_01v8_lvt l=0.15 w=0.64 ad=0.1824 as=0.224 pd=1.85 ps=1.98
XM5 a_1057_74##9 C#5 a_332_373##5 VNB sky130_fd_pr__nfet_01v8_lvt l=0.15 w=0.64 ad=0.224 as=0.2272 pd=1.98 ps=1.99
XM23 a_1027_48##7 C#6 VGND#8 VNB sky130_fd_pr__nfet_01v8_lvt l=0.15 w=0.42 ad=0.1197 as=0.76425 pd=1.41 ps=3.69
XM0 X#2 a_1057_74##5 VGND#8 VNB sky130_fd_pr__nfet_01v8_lvt l=0.15 w=0.74 ad=0.2072 as=0.76425 pd=2.04 ps=3.69
XM21 VGND#1 a_1057_74# X#2 VNB sky130_fd_pr__nfet_01v8_lvt l=0.15 w=0.74 ad=0.2109 as=0.2072 pd=2.05 ps=2.04
XM6 a_27_373##3 a_83_247##3 VPWR#10 VPB sky130_fd_pr__pfet_01v8 l=0.15 w=1 ad=0.295 as=0.39 pd=2.59 ps=2.78
XM17 VPWR#10 A#1 a_83_247##5 VPB sky130_fd_pr__pfet_01v8 l=0.15 w=1 ad=0.39 as=0.3732 pd=2.78 ps=2.78
XM9 a_83_247##5 B#7 a_332_373##4 VPB sky130_fd_pr__pfet_01v8 l=0.15 w=0.84 ad=0.3732 as=0.3484 pd=2.78 ps=2.6
XM15 a_332_373##4 a_397_21##5 a_27_373##4 VPB sky130_fd_pr__pfet_01v8 l=0.15 w=0.64 ad=0.3484 as=0.2048 pd=2.6 ps=1.92
XM8 a_27_373##4 B#5 a_329_81##5 VPB sky130_fd_pr__pfet_01v8 l=0.15 w=0.64 ad=0.2048 as=0.3086 pd=1.92 ps=2.46
XM16 a_329_81##5 a_397_21# a_83_247##4 VPB sky130_fd_pr__pfet_01v8 l=0.15 w=0.84 ad=0.3086 as=0.3766 pd=2.46 ps=2.89
XM19 a_397_21##6 B#1 VPWR#9 VPB sky130_fd_pr__pfet_01v8 l=0.15 w=1.12 ad=0.3248 as=0.4382 pd=2.82 ps=3.15
XM11 a_332_373##7 a_1027_48# a_1057_74##7 VPB sky130_fd_pr__pfet_01v8 l=0.15 w=0.84 ad=0.2436 as=0.42765 pd=2.26 ps=2.87
XM12 a_1057_74##7 C#7 a_329_81# VPB sky130_fd_pr__pfet_01v8 l=0.15 w=0.84 ad=0.42765 as=0.2436 pd=2.87 ps=2.26
XM3 a_1027_48##4 C#1 VPWR#8 VPB sky130_fd_pr__pfet_01v8 l=0.15 w=0.64 ad=0.1856 as=0.4808 pd=1.86 ps=3.3
XM22 X#1 a_1057_74##6 VPWR#8 VPB sky130_fd_pr__pfet_01v8 l=0.15 w=1.12 ad=0.336 as=0.4808 pd=2.84 ps=3.3
XM7 VPWR#1 a_1057_74##4 X#1 VPB sky130_fd_pr__pfet_01v8 l=0.15 w=1.12 ad=0.3248 as=0.336 pd=2.82 ps=2.84
*
*
*       RESISTOR AND CAP/DIODE CARDS
*
Rg1	a_83_247#	a_83_247##2	325.153564
Rg2	a_83_247##2	a_83_247##3	461.978088
Rg3	A#1	A#2	400.207520
Rg4	A#2	A#3	405.494232
Rg5	a_397_21#	a_397_21##2	345.870300
Rg6	a_397_21##2	a_397_21##3	338.893036
Rg7	a_397_21##3	a_397_21##4	1440.524048
Rg8	a_397_21##4	a_397_21##5	590.650574
Rg9	B#1	B#2	461.445953
Rg10	B#2	B#3	333.987671
Rg11	B#2	B#4	1501.833374
Rg12	B#4	B#5	447.099945
Rg13	B#5	B#6	732.625488
Rg14	B#4	B#7	990.710754
Rg15	B#7	B#8	860.585083
Rg16	a_1027_48#	a_1027_48##2	360.569489
Rg17	a_1027_48##2	a_1027_48##3	528.963867
Rg18	C#1	C#2	291.399933
Rg19	C#2	C#3	41.114601
Rg20	C#3	C#4	387.761658
Rg21	C#4	C#5	476.766693
Rg22	C#3	C#6	206.804398
Rg23	C#4	C#7	496.607727
Rg24	a_1057_74#	a_1057_74##2	313.757446
Rg25	a_1057_74##2	a_1057_74##3	96.765755
Rg26	a_1057_74##2	a_1057_74##4	473.770416
Rg27	a_1057_74##3	a_1057_74##5	328.510162
Rg28	a_1057_74##3	a_1057_74##6	434.500610
Rf1	a_27_373#	a_27_373##2	34.310730
Rf2	a_27_373##2	a_27_373##3	71.111115
Rf3	A#2	A#5	161.527634
Rf4	A#6	A	1.294829
Rf5	A#5	A#6	4.529325
Rf6	a_27_373##4	a_27_373##5	171.929321
Rf7	a_27_373##5	a_27_373##6	48.226162
Rf8	a_332_373##2	a_332_373##3	5.348048
Rf9	a_332_373##3	a_332_373##4	102.529228
Rf10	a_332_373#	a_332_373##2	15.000000
Rf11	a_83_247##4	a_83_247##6	188.557068
Rf12	a_83_247##6	a_83_247##7	27.826826
Rf13	a_83_247##7	a_83_247##8	76.704956
Rf14	a_83_247##8	a_83_247##10	69.090454
Rf15	a_83_247##10	a_83_247##11	184.743240
Rf16	a_83_247##5	a_83_247##6	15.000000
Rf17	a_83_247##5	a_83_247##7	15.000000
Rf18	a_83_247##9	a_83_247##10	7.500000
Rf19	a_397_21##6	a_397_21##7	72.877045
Rf20	a_397_21##7	a_397_21##8	72.494446
Rf21	B	B#2	83.099030
Rf22	a_332_373##5	a_332_373##6	94.761932
Rf23	a_332_373##6	a_332_373##7	59.354053
Rf24	a_329_81#	a_329_81##2	113.089630
Rf25	a_329_81##2	a_329_81##3	108.803749
Rf26	a_329_81##3	a_329_81##4	222.295044
Rf27	a_329_81##2	a_329_81##5	134.935959
Rf28	a_329_81##3	a_329_81##6	17.629738
Rf29	a_1027_48##4	a_1027_48##5	48.910843
Rf30	a_1027_48##5	a_1027_48##2	195.684052
Rf31	a_1027_48##5	a_1027_48##7	40.643497
Rf32	C#8	C#2	160.996811
Rf33	C	C#10	0.764007
Rf34	C#8	C#10	5.905091
Rf35	a_1057_74##7	a_1057_74##8	234.198517
Rf36	a_1057_74##8	a_1057_74##9	216.198761
Rf37	X	X#1	91.164818
Rf38	X	X#3	4.133564
Rf39	X#3	X	10.432326
Rf40	X#2	X#3	7.500000
Rf41	VPWR#1	VPWR#2	99.903412
Rf42	VPWR#2	VPWR#3	15.803900
Rf43	VPWR#3	VPWR#4	207.902176
Rf44	VPWR#4	VPWR#5	92.019096
Rf45	VPWR#5	VPWR#6	188.114243
Rf47	VPWR#3	VPWR#8	53.143215
Rf48	VPWR#4	VPWR#9	28.602406
Rf49	VPWR#6	VPWR#10	48.370590
Rf50	VGND#1	VGND#2	98.456764
Rf51	VGND#2	VGND#3	31.996037
Rf52	VGND#3	VGND#4	205.101181
Rf53	VGND#4	VGND#5	78.504745
Rf54	VGND#5	VGND#6	190.637268
Rf56	VGND#3	VGND#8	9.680208
Rf57	VGND#4	VGND#9	25.846697
Rf58	VGND#6	VGND#10	42.380951
Rf60	a_83_247##2	a_83_247##8	160.232803
Rf61	a_397_21##2	a_397_21##7	160.232803
Rf65	a_1057_74##3	a_1057_74##8	160.232803
Re1	a_27_373##5	a_27_373##2	21.829418
Re2	a_332_373##6	a_332_373##3	23.476074
Re3	VPWR#2	VPWR	3.735117
Re4	VPWR	VPWR#5	1.067176
Re5	VGND#2	VGND	3.735117
Re6	VGND	VGND#5	1.067176
*
*       CAPACITOR CARDS
*
*
C1	a_27_373##4	a_83_247##4	2.4597e-17
C2	a_332_373#	B#6	2.36935e-17
C3	a_329_81##3	a_332_373#	6.7881e-21
C4	a_329_81##4	a_397_21##3	3.64306e-17
C5	a_83_247##11	a_397_21##4	2.92056e-18
C6	a_329_81##2	B#1	3.38669e-17
C7	a_27_373##4	a_329_81##5	5.09599e-17
C8	B#6	a_27_373##6	1.44783e-17
C9	a_329_81##5	B#4	3.9084e-18
C10	a_1057_74##9	C#3	3.98687e-19
C11	a_83_247##9	a_397_21##3	4.32325e-19
C12	a_332_373#	a_397_21##4	5.56981e-19
C13	a_329_81##4	B#6	1.77512e-17
C14	a_332_373##4	a_329_81##5	2.18637e-18
C15	C#7	C#3	8.34539e-20
C16	a_27_373##6	a_397_21##4	3.62619e-17
C17	a_329_81##2	a_397_21#	2.70929e-19
C18	a_83_247##9	B#6	7.72531e-19
C19	a_27_373##4	a_332_373##4	8.45629e-17
C20	a_329_81##4	a_397_21##4	2.18249e-17
C21	a_27_373##6	B#8	6.59938e-19
C22	a_83_247##9	a_397_21##4	2.08188e-17
C23	a_329_81#	C#5	1.0012e-18
C24	a_83_247##5	a_27_373##4	1.07208e-16
C25	a_27_373##4	B#4	2.40012e-18
C26	a_329_81##4	B#8	2.50679e-17
C27	a_397_21##2	B#4	1.44722e-18
C28	a_1057_74##7	C#5	2.80852e-19
C29	a_27_373##6	A#3	1.97554e-19
C30	a_83_247##9	B#8	2.43644e-17
C31	a_329_81##4	A#3	2.32621e-18
C32	a_329_81#	VPWR#4	1.16473e-18
C33	a_83_247##9	A#3	5.31074e-17
C34	a_83_247##5	VPWR#10	8.57311e-17
C35	A#3	VGND#10	1.35254e-17
C36	a_332_373##4	B#4	2.59844e-19
C37	VGND#4	a_329_81##3	2.55303e-17
C38	a_1057_74##7	VPWR#4	4.23507e-17
C39	a_83_247##9	a_83_247#	2.65878e-18
C40	a_27_373#	A#3	1.05932e-18
C41	a_27_373##3	a_83_247##5	3.02977e-17
C42	VGND#10	a_83_247#	2.98085e-17
C43	VGND#2	VGND#3	9.6071e-17
C44	a_1057_74##7	VPWR#3	8.46306e-17
C45	VPWR#2	VPWR#3	6.00782e-17
C46	B#4	B#1	1.25017e-17
C47	a_27_373##3	VPWR#10	4.55093e-17
C48	a_83_247#	a_27_373#	1.5996e-17
C49	C#10	a_1027_48##4	1.26976e-17
C50	a_1027_48##5	C#4	1.55318e-17
C51	VGND#4	a_332_373##6	5.07055e-18
C52	a_83_247##5	B#4	5.74835e-18
C53	VPWR#2	C#10	3.54596e-18
C54	a_332_373##5	a_1027_48##7	2.40551e-17
C55	a_1027_48##5	C#3	1.78478e-17
C56	a_397_21##8	B#4	2.41178e-20
C57	B#4	a_397_21#	1.28019e-17
C58	VPWR#1	a_1057_74##4	3.23496e-17
C59	a_329_81##5	a_397_21##3	1.58828e-19
C60	a_1057_74##5	a_1057_74#	3.7274e-17
C61	a_1057_74##9	a_1027_48##7	1.48403e-17
C62	X#1	a_1057_74##4	5.91592e-17
C63	C#10	a_1057_74##7	7.91494e-19
C64	A#5	B#7	1.34392e-18
C65	a_27_373##4	a_397_21##3	1.15258e-19
C66	VPWR#1	a_1057_74##6	1.26838e-18
C67	VPWR#8	a_1057_74##4	6.54953e-19
C68	a_1027_48##5	a_1027_48##4	2.52286e-19
C69	X#1	a_1057_74##6	5.5664e-17
C70	a_1057_74##9	a_332_373##5	1.02689e-16
C71	C#6	a_1057_74##5	4.32802e-18
C72	a_1057_74##6	VPWR#8	1.60964e-17
C73	B#5	B#4	2.81316e-19
C74	a_27_373##4	a_397_21##4	7.09584e-19
C75	X#1	C#1	8.3992e-19
C76	C#5	a_1057_74##5	3.24246e-19
C77	a_1027_48##4	a_1057_74##6	1.64355e-20
C78	a_329_81##2	VPWR#4	1.24316e-17
C79	a_1027_48##5	a_329_81#	2.87772e-17
C80	a_332_373##4	a_397_21##4	7.50189e-18
C81	C#1	VPWR#8	1.90308e-17
C82	a_332_373##6	a_1027_48##5	1.29716e-18
C83	a_329_81#	a_1057_74##6	8.03778e-19
C84	C#5	C#6	2.08161e-18
C85	a_83_247##11	B#5	1.34291e-20
C86	a_332_373##6	a_329_81##3	1.25567e-16
C87	C#1	a_1027_48##4	1.08002e-17
C88	a_83_247##5	a_397_21##4	4.69971e-19
C89	a_1057_74##7	a_1057_74##6	1.91805e-18
C90	a_329_81##2	a_332_373##6	1.04084e-17
C91	VPWR#5	VPWR#4	1.2412e-16
C92	VPWR#8	C#7	1.86567e-19
C93	a_329_81#	C#1	2.4037e-18
C94	a_1027_48##5	a_1057_74##7	1.93484e-18
C95	VPWR#5	VPWR#3	2.95377e-17
C96	a_1027_48##4	C#7	2.89616e-18
C97	a_329_81##2	a_329_81#	1.69552e-18
C98	a_1027_48##3	C#5	3.09933e-17
C99	a_397_21##5	B#4	5.99161e-18
C100	a_1057_74##7	C#1	2.6591e-18
C101	a_329_81##4	B#5	1.33828e-19
C102	a_332_373##3	a_329_81##3	3.63485e-18
C103	VGND#9	a_1057_74##9	3.33102e-18
C104	a_329_81#	C#7	6.67131e-17
C105	a_332_373##7	C#1	6.38643e-20
C106	a_83_247##9	A#5	2.80312e-17
C107	a_332_373##7	a_1027_48##5	4.84523e-20
C108	VGND#5	VGND#4	1.05225e-16
C109	a_1057_74##7	C#7	3.7305e-17
C110	VGND#5	VGND#3	4.76943e-17
C111	a_329_81#	a_1027_48#	2.08059e-17
C112	B#3	a_1027_48##3	4.43429e-18
C113	a_332_373##7	C#7	2.86953e-18
C114	a_1027_48#	a_1057_74##7	3.17226e-17
C115	a_1027_48##5	C#10	1.89708e-17
C116	VPWR#9	C#7	1.13342e-18
C117	a_329_81##4	B#7	1.50621e-19
C118	a_397_21##3	a_1027_48##3	1.32366e-19
C119	a_329_81#	B#1	8.88763e-19
C120	a_27_373##6	B#4	2.20932e-19
C121	VGND#2	VGND#1	4.6608e-17
C122	a_332_373##7	a_1027_48#	4.30121e-17
C123	VPWR#5	a_1027_48##5	3.08026e-18
C124	B#7	B#4	1.36523e-18
C125	a_329_81##2	a_332_373##7	8.94116e-17
C126	VGND#3	a_1057_74##3	8.06038e-17
C127	a_1057_74##7	B#1	2.78458e-18
C128	a_397_21##3	B#3	5.14665e-18
C129	VPWR#9	a_1027_48#	4.54368e-18
C130	a_329_81##2	VPWR#5	2.69646e-17
C131	a_332_373##7	B#1	6.50903e-19
C132	a_397_21##6	a_1027_48#	3.81345e-19
C133	VGND#2	a_1027_48##7	1.01101e-18
C134	B#1	VPWR#9	2.34375e-17
C135	a_329_81##2	VPWR#9	5.46273e-17
C136	a_83_247##4	a_1027_48#	7.947e-19
C137	a_1057_74##3	VPWR#3	2.61593e-19
C138	a_397_21##3	B#6	3.47884e-17
C139	a_397_21##6	B#1	2.84507e-17
C140	a_83_247##11	VGND#9	7.16117e-18
C141	VPWR#9	a_397_21#	4.5536e-19
C142	a_332_373##6	a_1027_48##7	1.17197e-18
C143	C#4	C#6	4.25681e-18
C144	a_329_81##4	B#4	7.20044e-20
C145	a_83_247##4	B#1	3.84931e-18
C146	a_397_21##4	a_397_21##3	7.24423e-19
C147	VGND#5	a_1027_48##5	1.37708e-18
C148	VGND#3	a_1057_74#	1.49294e-18
C149	C#10	a_1057_74##3	3.4653e-17
C150	a_329_81##2	a_397_21##6	5.18236e-17
C151	VGND#1	VPWR#1	1.15998e-17
C152	a_329_81##5	B#1	1.83898e-19
C153	VGND#4	a_1027_48##2	8.55326e-20
C154	VGND#5	a_329_81##3	4.35111e-17
C155	a_1057_74##9	a_332_373##6	2.8677e-17
C156	a_397_21##4	B#6	3.98798e-17
C157	A#5	a_27_373##5	2.85147e-17
C158	a_397_21#	a_83_247##4	2.0899e-17
C159	a_27_373##4	B#1	2.61993e-19
C160	a_329_81##5	a_397_21#	6.03108e-17
C161	a_332_373##6	VGND#9	3.08599e-18
C162	a_1027_48##5	a_1057_74##3	2.88402e-18
C163	a_83_247##4	B#5	1.40514e-18
C164	VPWR#4	a_1027_48##2	1.00546e-19
C165	a_332_373##6	a_397_21##8	8.15905e-18
C166	a_27_373##4	a_397_21#	2.19978e-18
C167	VGND#3	a_1057_74##5	1.35598e-17
C168	B#8	a_397_21##4	4.04189e-17
C169	VGND#4	B#2	6.94604e-20
C170	B#5	a_329_81##5	1.50052e-17
C171	a_332_373##4	a_397_21#	2.28022e-19
C172	a_27_373##4	B#5	4.28958e-17
C173	a_83_247##5	a_397_21#	3.69236e-19
C174	a_332_373##3	a_397_21##8	7.49421e-18
C175	a_1027_48##5	C#2	2.08965e-17
C176	VPWR#2	VPWR#1	4.88402e-17
C177	a_329_81##5	a_397_21##5	3.72519e-19
C178	a_27_373##2	A#5	2.80077e-18
C179	a_329_81##5	a_329_81##2	1.03123e-18
C180	a_332_373##4	B#5	1.18084e-18
C181	VPWR#4	B#2	7.47963e-20
C182	A#3	B#8	2.50769e-17
C183	a_332_373##3	a_83_247##11	3.20596e-18
C184	VGND#3	C#6	3.25387e-18
C185	a_83_247##4	B#7	5.49002e-19
C186	X#1	VPWR#2	3.72967e-17
C187	a_27_373##4	a_397_21##5	4.06908e-17
C188	a_332_373##3	a_332_373#	1.07722e-18
C189	a_83_247##5	B#5	4.73044e-20
C190	a_329_81##5	B#7	1.65219e-19
C191	VGND#2	VPWR#1	3.54257e-18
C192	a_332_373##4	a_397_21##5	1.5438e-17
C193	a_27_373##6	a_332_373##3	3.85851e-17
C194	VGND#4	C#5	2.82064e-18
C195	VGND#5	A#5	9.79143e-19
C196	VPWR#2	a_1027_48##4	5.04442e-18
C197	a_27_373##4	B#7	1.42459e-17
C198	a_1027_48##5	a_1027_48##2	1.57295e-19
C199	VGND#2	X#1	8.68825e-19
C200	a_329_81##4	a_332_373##3	1.23118e-17
C201	a_83_247##5	a_397_21##5	2.67682e-18
C202	a_83_247#	A#3	2.4175e-17
C203	a_329_81##3	a_1027_48##2	7.15951e-19
C204	B#7	a_332_373##4	2.84445e-17
C205	VGND#3	C#5	2.84526e-18
C206	a_1027_48##2	a_329_81##2	2.56719e-18
C207	a_27_373##6	a_332_373#	2.06993e-17
C208	a_329_81##4	a_83_247##11	7.94082e-17
C209	VPWR#2	a_1057_74##7	2.11492e-17
C210	a_27_373##4	A#1	6.20262e-19
C211	a_83_247##5	B#7	3.90903e-17
C212	a_27_373##5	a_329_81##4	3.34627e-17
C213	VGND#5	a_1027_48##7	4.8012e-18
C214	VGND#4	a_1027_48##3	7.53689e-18
C215	a_83_247##9	a_27_373##5	2.59665e-17
C216	VGND#3	VGND#1	5.79986e-18
C217	VGND#5	a_332_373##5	9.64325e-18
C218	a_329_81##3	B#2	3.2282e-17
C219	a_329_81##4	a_332_373#	4.3664e-17
C220	a_83_247##5	A#1	6.15037e-17
C221	VGND#5	a_1057_74##9	4.43463e-17
C222	a_329_81##2	B#2	1.15004e-17
C223	a_1057_74##3	VGND#8	1.40856e-17
C224	VGND#3	a_1027_48##3	7.75995e-20
C225	VPWR#2	a_1057_74##2	4.03735e-20
C226	a_329_81##3	a_329_81##2	1.06132e-18
C227	A#1	VPWR#10	2.35889e-17
C228	a_1057_74##3	a_1027_48##7	3.231e-17
C229	VGND#5	VGND#9	2.0105e-17
C230	a_83_247##5	a_83_247##3	1.1285e-17
C231	a_27_373##3	A#1	1.95929e-18
C232	a_332_373##5	a_1057_74##3	2.38988e-18
C233	a_27_373##6	a_329_81##4	4.54988e-17
C234	VPWR#4	C#5	5.60981e-20
C235	VGND#5	a_397_21##8	3.25895e-18
C236	VGND#4	B#3	4.41123e-18
C237	a_329_81##3	a_397_21##2	2.51085e-17
C238	a_332_373##6	a_332_373##7	2.5011e-18
C239	a_83_247##3	VPWR#10	3.10748e-17
C240	VGND#5	a_83_247##11	1.23002e-16
C241	C#2	VGND#8	4.29225e-18
C242	a_397_21##2	a_329_81##2	1.45746e-18
C243	a_332_373##6	VPWR#9	2.16954e-18
C244	a_27_373##3	a_83_247##3	3.62502e-17
C245	a_27_373##2	a_83_247##9	2.67601e-18
C246	VGND#5	a_332_373#	3.67265e-18
C247	a_83_247##9	a_27_373##6	2.20648e-18
C248	a_332_373##6	a_397_21##6	4.00024e-18
C249	a_1057_74##6	a_1057_74##4	4.72498e-17
C250	a_27_373##2	VGND#10	7.13466e-18
C251	a_397_21##3	B#5	4.34865e-19
C252	VGND#5	a_27_373##6	3.80667e-18
C253	VGND#5	a_329_81##4	1.80427e-17
C254	a_27_373##2	a_27_373#	3.79257e-19
C255	VGND#5	a_83_247##9	5.40871e-17
C256	VGND#3	VGND#8	2.21839e-17
C257	a_332_373##6	a_329_81##5	4.38078e-20
C258	VPWR#5	a_1027_48##4	4.99706e-18
C259	VGND#2	a_1057_74##2	9.87969e-20
C260	a_332_373##3	a_397_21##6	2.17444e-18
C261	a_83_247##9	a_329_81##4	8.08105e-17
C262	a_397_21##4	B#5	9.13895e-18
C263	a_332_373##5	a_1027_48##2	3.80989e-17
C264	C#1	a_1057_74##6	1.32546e-17
C265	VPWR#5	a_329_81#	1.40004e-17
C266	a_332_373##3	a_83_247##4	8.29816e-18
C267	VGND#5	a_27_373#	1.44797e-17
C268	a_1057_74##9	a_1027_48##2	1.80434e-18
C269	X#1	a_1057_74##2	5.50945e-18
C270	VPWR#5	a_1057_74##7	3.53739e-17
C271	a_332_373##3	a_329_81##5	1.76696e-17
C272	VGND#2	C#3	2.1401e-19
C273	C#7	a_1057_74##6	7.57646e-19
C274	VPWR#5	a_332_373##7	5.21904e-18
C275	a_332_373##3	a_27_373##4	3.34225e-17
C276	VPWR#5	VPWR#9	2.08778e-17
C277	C#7	C#1	5.6589e-18
C278	B#7	a_397_21##4	9.05007e-18
C279	VGND#2	a_1057_74#	1.35653e-17
C280	VPWR#5	a_397_21##6	4.59944e-18
C281	VGND#2	a_1057_74##5	1.27633e-17
C282	a_27_373##5	a_27_373##4	2.03455e-18
C283	a_83_247##4	VPWR#5	1.31963e-16
C284	a_83_247##9	VGND#10	4.76486e-17
C285	a_1057_74##3	X#1	5.07219e-17
C286	B#2	VGND#9	3.72002e-18
C287	a_27_373##5	a_332_373##4	7.59487e-17
C288	A#5	A#2	1.13411e-17
C289	a_1057_74##3	VPWR#8	7.83226e-17
C290	a_329_81##5	VPWR#5	1.47899e-17
C291	B#2	a_397_21##8	2.88497e-17
C292	a_1027_48#	C#7	2.08526e-17
C293	X#1	C#3	3.61706e-20
C294	a_83_247##5	a_27_373##5	4.22579e-17
C295	a_1057_74##3	a_1027_48##4	4.9823e-17
C296	VPWR#5	a_27_373##4	2.04506e-17
C297	VGND#3	C#4	2.57008e-19
C298	a_332_373##6	C#4	1.66553e-18
C299	a_329_81#	a_1057_74##3	5.6981e-18
C300	a_27_373##5	VPWR#10	4.80836e-20
C301	a_27_373#	a_83_247##9	3.45465e-18
C302	VPWR#5	a_332_373##4	4.83257e-18
C303	VGND#4	a_1057_74##9	3.2155e-17
C304	a_1057_74##7	a_1057_74##3	3.14466e-18
C305	a_83_247##5	VPWR#5	5.89758e-17
C306	a_397_21##8	a_397_21##2	1.07172e-18
C307	B#1	a_1027_48#	4.92351e-18
C308	a_83_247##2	A#5	2.11583e-17
C309	a_397_21##2	a_83_247##11	6.79531e-18
C310	VPWR#5	VPWR#10	2.22568e-20
C311	a_332_373##6	a_1027_48##3	1.4138e-17
C312	a_27_373#	VGND#10	4.04224e-17
C313	a_332_373#	a_397_21##2	1.06866e-17
C314	VGND#5	a_329_81##5	1.4687e-18
C315	VPWR#5	a_27_373##3	1.78412e-17
C316	a_332_373##6	B#3	5.65761e-19
C317	a_27_373##2	a_83_247##5	2.71005e-18
C318	VGND#3	C#3	9.00857e-19
C319	VGND#3	a_1057_74##9	7.09159e-17
C320	a_329_81##4	a_397_21##2	2.93329e-18
C321	a_27_373##2	VPWR#10	5.9651e-18
C322	VGND#5	a_332_373##4	2.727e-18
C323	a_1027_48##2	a_329_81#	1.76648e-17
C324	a_332_373##3	B#3	4.919e-20
C325	a_27_373##2	a_27_373##3	2.80062e-18
C326	C#3	VPWR#8	2.55835e-19
C327	a_1027_48##2	a_1057_74##7	2.17851e-18
C328	a_329_81##3	C#5	1.6578e-18
C329	a_332_373##3	a_397_21##3	5.12244e-18
C330	a_332_373##7	a_1027_48##2	2.52235e-17
C331	B#5	a_397_21#	2.62865e-17
C332	a_332_373##3	B#6	6.36236e-18
C333	a_83_247##9	A#2	2.69472e-18
C334	a_332_373##3	a_397_21##4	3.64615e-18
C335	a_332_373##3	B#4	3.12776e-19
C336	VPWR#2	a_1057_74##4	9.2729e-18
C337	a_332_373##7	B#2	6.98234e-20
C338	a_27_373##5	B#6	1.08247e-19
C339	a_332_373##3	B#8	6.52304e-20
C340	a_329_81##3	a_1027_48##3	3.5927e-17
C341	VPWR#2	a_1057_74##6	7.93851e-18
C342	VPWR#9	B#2	1.15015e-18
C343	a_397_21##5	B#5	3.65117e-17
C344	a_27_373##5	a_397_21##4	1.11057e-18
C345	a_1057_74##3	a_1057_74#	4.02896e-19
C346	a_397_21##6	B#2	2.15539e-17
C347	VGND#5	C#5	2.45577e-18
C348	a_27_373##5	B#8	1.98683e-17
C349	a_83_247##2	VGND#10	2.54555e-17
C350	a_1057_74##3	a_1057_74##5	7.79725e-18
C351	B#7	B#5	1.814e-18
C352	a_83_247##4	B#2	5.28147e-18
C353	a_397_21##4	B#4	1.86752e-19
C354	VGND#5	a_1027_48##3	1.07574e-18
C355	a_329_81##5	B#2	1.55141e-17
C356	a_1057_74##3	C#6	2.37805e-17
C357	a_27_373##5	A#3	2.76661e-19
C358	C#3	a_1027_48##4	3.9062e-18
C359	B#7	a_397_21##5	2.09352e-17
C360	VGND#5	B#3	7.68592e-18
C361	a_27_373##4	B#2	6.26929e-19
C362	a_1057_74##3	C#5	2.41817e-19
C363	a_397_21##8	a_397_21##6	4.62114e-19
C364	a_329_81##3	B#3	3.88608e-17
C365	X#1	VPWR#1	9.33129e-17
C366	a_332_373##4	B#2	3.08531e-20
C367	a_397_21##2	a_83_247##4	4.4805e-18
C368	VGND#5	a_397_21##3	1.73824e-17
C369	a_397_21##2	a_329_81##5	6.06514e-17
C370	VGND#5	B#6	1.61e-18
C371	A#1	B#7	3.18385e-17
C372	VGND#5	a_397_21##4	1.43324e-17
C373	a_27_373##5	B#4	6.51989e-21
C374	a_332_373##4	a_397_21##2	9.18266e-19
C375	VPWR#8	VPWR#1	1.94092e-18
C376	a_27_373##2	a_83_247#	2.5462e-18
C377	a_329_81#	C#4	1.3834e-18
C378	C#5	a_1027_48##2	7.3401e-18
C379	a_329_81##3	a_397_21##3	1.00933e-18
C380	VGND#5	A#3	3.13084e-18
C381	a_83_247##3	A#1	2.87645e-17
C382	VGND#5	a_83_247#	4.40615e-18
C383	B#3	a_1027_48##2	7.82041e-20
C384	X	a_1057_74##2	1.52346e-17
C385	A#2	a_83_247##5	3.4268e-18
C386	VPWR#8	X#1	5.22493e-17
C387	VPWR#5	C#7	1.66023e-21
C388	VGND#1	a_1057_74#	2.35564e-17
C389	VPWR#4	C#4	7.60039e-21
C390	VPWR#5	a_1027_48#	8.2294e-18
C391	a_329_81##3	B#6	2.23324e-19
C392	a_332_373##3	B#5	2.4282e-17
C393	a_83_247##2	a_83_247##5	1.07875e-18
C394	a_397_21##3	B#2	3.24588e-19
C395	a_83_247##2	VPWR#10	8.3018e-19
C396	a_397_21##2	a_1027_48##3	6.08396e-20
C397	a_1057_74##3	a_1057_74##4	4.99366e-19
C398	VPWR#5	B#1	1.68298e-18
C399	a_332_373##3	a_397_21##5	2.92604e-18
C400	a_1057_74#	X#2	1.54296e-17
C401	a_397_21##2	B#3	8.23098e-19
C402	VPWR#5	B#4	6.81529e-17
C403	a_1057_74##3	a_1057_74##6	9.95835e-18
C404	VPWR#5	a_397_21#	1.13353e-18
C405	a_332_373##3	B#7	5.25571e-20
C406	a_397_21##2	a_397_21##3	6.49681e-18
C407	a_27_373##5	a_397_21##5	1.02641e-18
C408	a_1057_74##3	C#1	2.56638e-17
C409	VGND#1	a_1057_74##5	1.32566e-18
C410	VPWR#5	B#5	5.09608e-20
C411	B#6	a_397_21##2	7.57813e-18
C412	a_1057_74##7	C#4	4.51701e-19
C413	a_1057_74##3	C#7	1.54521e-18
C414	a_27_373##5	B#7	1.90233e-17
C415	a_1057_74##3	a_1027_48#	2.11043e-19
C416	a_27_373##5	A#1	1.22844e-18
C417	a_1057_74##5	X#2	1.37224e-17
C418	VPWR#5	B#7	5.39965e-18
C419	a_27_373##5	a_83_247##3	2.49091e-19
C420	a_1057_74##7	C#3	7.92041e-19
C421	VPWR#5	A#1	3.03284e-18
C422	A#2	B#8	1.35052e-17
C423	VPWR#3	C#4	7.34025e-20
C424	a_1027_48##2	C#7	1.41018e-17
C425	VPWR#5	a_83_247##3	6.25937e-18
C426	a_1057_74##5	VGND#8	5.35699e-18
C427	VPWR#4	B#4	3.45767e-19
C428	VPWR#3	a_1057_74##4	5.62579e-19
C429	a_329_81##4	a_329_81##5	1.21648e-18
C430	a_27_373##2	a_83_247##3	3.35538e-18
C431	a_83_247##2	B#8	1.60646e-19
C432	B#1	a_1027_48##2	1.04353e-18
C433	a_329_81#	a_1027_48##4	4.8115e-17
C434	a_1057_74##2	X#2	4.26398e-19
C435	a_1057_74##7	VPWR#8	1.65447e-17
C436	a_83_247##2	A#3	2.20045e-18
C437	a_1027_48##7	a_1057_74##5	2.12404e-19
C438	a_83_247##2	a_83_247#	1.95867e-18
C439	B#2	B#1	3.51788e-17
C440	C#6	VGND#8	7.65302e-18
C441	a_397_21#	B#2	2.5979e-17
C442	VPWR#3	C#3	1.21643e-19
C443	a_27_373##5	a_332_373##3	9.55307e-18
C444	a_332_373##5	a_1057_74##5	1.58446e-19
C445	a_1027_48##4	a_1057_74##7	1.8526e-17
C446	a_397_21##2	B#1	3.29169e-19
C447	a_27_373##6	a_332_373##4	2.32427e-17
C448	VPWR#3	a_1057_74##6	2.34972e-18
C449	VPWR#5	a_332_373##3	4.25139e-18
C450	a_397_21##2	a_397_21#	8.43056e-18
C451	a_1027_48##7	C#6	1.84778e-17
C452	a_1057_74##3	VPWR#2	7.21588e-18
C453	B#5	a_397_21##2	2.27299e-17
C454	VGND#5	a_332_373##6	3.95824e-17
C455	a_1057_74##9	a_1057_74##5	3.5671e-19
C456	VGND#2	a_1057_74##3	2.12906e-17
C457	a_397_21##2	a_397_21##5	1.51402e-19
C458	a_329_81#	a_1057_74##7	8.10274e-17
C459	a_332_373##7	a_1027_48##4	7.73004e-19
C460	VGND#5	C#4	1.095e-20
C461	VGND#5	a_332_373##3	3.60173e-17
C462	a_397_21##2	B#7	1.05684e-19
C463	a_332_373##5	C#6	1.77239e-18
C464	B	a_329_81##3	1.07337e-17
C465	VGND#2	C#2	2.4811e-18
C466	B	a_329_81##2	1.26147e-17
C467	VGND#5	C#3	4.99918e-20
C468	VGND#5	a_27_373##5	2.7283e-17
C469	VGND#3	X	3.60231e-17
C470	a_1027_48##7	C#5	1.5256e-19
C471	A#2	B#7	2.12431e-17
C472	VPWR#3	C#1	5.65076e-19
C473	a_1057_74##9	C#6	2.89619e-19
C474	a_332_373##7	a_329_81#	6.36964e-18
C475	a_332_373##6	a_1027_48##2	6.49277e-17
C476	a_332_373##5	a_1027_48##5	1.37438e-17
C477	VGND#5	a_27_373##2	2.20064e-17
C478	a_83_247##2	B#7	3.80876e-19
C479	a_83_247##3	A#2	2.24944e-18
C480	a_332_373##5	C#5	2.3702e-17
C481	a_83_247##2	A#1	1.94484e-18
C482	a_332_373##6	B#2	3.76105e-17
C483	a_83_247##2	a_83_247##3	2.74296e-18
C484	a_332_373##3	B#2	8.19538e-18
C485	C#10	a_1057_74##6	5.35466e-19
C486	VPWR#4	C#7	2.32453e-18
C487	VGND#5	a_1057_74##3	2.91061e-18
C488	a_83_247##9	a_83_247##5	1.72563e-18
C489	VPWR#5	a_1027_48##2	4.99675e-18
C490	a_332_373##3	a_397_21##2	6.65261e-17
C491	a_1057_74##9	C#5	5.54563e-17
C492	a_329_81##3	a_332_373##5	4.93989e-19
C493	VPWR#5	B#2	6.66327e-21
C494	VPWR#3	C#7	7.99222e-19
C495	a_1057_74##9	a_1027_48##5	1.6575e-18
C496	a_1057_74##3	a_1057_74##2	4.59318e-18
C497	a_1057_74##3	C#2	4.83741e-17
C498	VGND#5	a_1027_48##2	4.29324e-18
C499	A	a_83_247##5	3.63512e-17
C500	a_332_373##5	a_1027_48##3	2.51144e-19
C501	X	VGND#1	7.22423e-17
C502	VPWR#5	a_397_21##2	4.75727e-18
C503	X	X#2	7.287e-20
C504	a_1057_74##3	C#4	5.0422e-20
C505	a_27_373##5	A#2	9.22149e-18
C506	VGND#5	B#2	3.95711e-18
C507	VPWR#9	a_1057_74##7	9.57271e-18
C508	C#3	a_1057_74##3	3.61737e-17
C509	a_83_247##2	a_27_373##5	3.58867e-18
C510	C#10	C#1	2.64123e-18
C511	VGND#5	a_397_21##2	2.49385e-18
C512	VPWR#9	B#4	3.18244e-18
C513	VPWR#4	a_1027_48#	6.44047e-18
C514	a_1027_48##3	a_1057_74##9	1.69098e-17
C515	a_329_81##3	a_1057_74##9	5.71925e-17
C516	a_27_373##2	a_83_247##2	1.24872e-16
C517	VGND#9	C#5	5.60833e-19
C518	B	a_397_21##6	4.67522e-17
C519	B#2	a_1027_48##2	5.3229e-18
C520	a_332_373##5	B#3	7.96597e-20
C521	VGND#5	a_83_247##2	2.79268e-18
C522	a_397_21##2	a_1027_48##2	4.60098e-20
C523	X	X#1	2.82217e-18
C524	a_1027_48##3	a_329_81##6	1.94402e-17
C525	a_1027_48##5	a_1057_74##6	2.50753e-19
C526	a_397_21##2	B#2	5.27546e-17
C527	a_1057_74##9	B#3	3.98837e-19
C528	C#10	C#7	1.81051e-20
C529	a_1027_48##7	C#4	2.5199e-18
C530	a_1057_74##2	VNB	3.22239e-17
C531	C#4	VNB	4.15372e-17
C532	C#3	VNB	3.56693e-17
C533	VGND#9	a_1027_48##3	2.70477e-18
C534	B#4	VNB	1.49298e-16
C535	VPWR#4	B#1	6.19667e-18
C536	a_329_81##3	a_329_81##6	4.38648e-18
C537	A#5	B#8	1.45635e-18
C538	X	a_1057_74#	2.30242e-17
C539	X	a_1057_74##5	2.21336e-17
C540	a_83_247##2	A#2	3.90605e-17
C541	X	C#6	4.97161e-19
C542	X	C#5	5.24771e-20
C543	a_1027_48##5	C#1	1.47593e-18
C544	a_397_21##8	a_1027_48##3	4.99757e-19
C545	A	B#7	2.15183e-18
C546	C#2	C#3	1.05077e-17
C547	a_397_21##6	B#4	3.44771e-21
C548	C#3	a_1027_48##7	1.11788e-18
C549	A	a_83_247##3	1.04062e-18
C550	B#3	VGND#9	1.4265e-17
C551	B	B#1	5.41855e-18
C552	a_83_247##11	a_1027_48##3	2.8729e-19
C553	a_329_81##3	VGND#9	5.32688e-17
C554	a_83_247##4	VPWR#9	9.38361e-18
C555	A	a_27_373##5	1.25893e-17
C556	C#3	a_1057_74##6	7.52842e-19
C557	a_397_21##8	B#3	4.00668e-17
C558	VPWR#5	A	2.97156e-18
C559	VGND#4	VNB	5.80108e-17
C560	VGND#3	VNB	6.44722e-17
C561	a_1027_48##5	C#7	3.80988e-18
C562	VPWR#4	VNB	6.82231e-17
C563	VPWR#3	VNB	4.81236e-17
C564	VGND#9	a_397_21##3	1.68828e-18
C565	C#10	VNB	1.99952e-18
C566	a_1027_48##5	VNB	7.66377e-18
C567	a_329_81##3	VNB	1.94912e-17
C568	a_329_81##2	VNB	6.39136e-18
C569	a_332_373##5	C#4	1.65677e-17
C570	a_83_247##11	B#3	3.50475e-18
C571	VPWR#5	B	5.62884e-18
C572	VGND#2	X	2.96741e-17
C573	A#5	VNB	1.90016e-18
C574	VGND#1	VNB	7.04329e-17
C575	a_1027_48##7	VNB	1.68775e-18
C576	a_332_373##5	VNB	6.61747e-18
C577	A	A#2	8.39911e-18
C578	a_1057_74##9	VNB	2.03325e-17
C579	VGND#9	VNB	6.47222e-18
C580	a_329_81##3	a_397_21##8	5.27294e-17
C581	C#4	C#3	2.77535e-18
C582	a_397_21##8	VNB	3.02374e-18
C583	a_83_247##11	VNB	1.16253e-17
C584	a_83_247##2	A	1.45804e-17
C585	C#10	C#4	7.13232e-21
C586	a_83_247##9	VNB	1.17122e-17
C587	B	a_1027_48##2	4.3528e-19
C588	VGND#10	VNB	1.1239e-18
C589	a_27_373#	VNB	3.09775e-17
C590	VPWR#1	VNB	7.72165e-17
C591	B	B#2	1.51913e-17
C592	a_1027_48##2	C#4	2.39277e-17
C593	X#1	VNB	7.97355e-18
C594	VPWR#8	VNB	1.2469e-18
C595	a_1057_74##3	X	5.14084e-17
C596	a_329_81##2	C#7	6.30989e-19
C597	a_1027_48##4	VNB	8.23669e-18
C598	a_332_373#	B#3	3.98708e-19
C599	a_397_21##2	B	2.43598e-17
C600	a_1057_74##7	VNB	2.80293e-17
C601	a_332_373##7	VNB	6.67907e-18
C602	VPWR#9	VNB	5.84832e-18
C603	a_397_21##6	VNB	5.96697e-20
C604	a_83_247##4	VNB	1.40269e-17
C605	a_27_373##4	VNB	3.32815e-18
C606	a_397_21##6	a_329_81##5	1.45737e-17
C607	a_332_373##4	VNB	3.36229e-18
C608	a_83_247##5	VNB	1.57684e-17
C609	VPWR#10	VNB	1.82141e-18
C610	a_27_373##3	VNB	4.4501e-17
C611	a_83_247##4	B#4	4.53255e-17
C612	a_1057_74#	VNB	3.04703e-17
C613	a_1057_74##5	VNB	2.83821e-17
C614	a_83_247##11	a_397_21##3	3.58124e-17
C615	C#6	VNB	3.14788e-17
C616	C#5	VNB	4.55168e-17
C617	a_1027_48##3	VNB	4.18142e-17
C618	B#3	VNB	4.58171e-17
C619	a_397_21##3	VNB	8.11045e-17
C620	B#6	VNB	2.86093e-17
C621	a_397_21##4	VNB	9.24515e-17
C622	B#8	VNB	3.86042e-17
C623	A#3	VNB	2.70829e-17
C624	a_83_247#	VNB	3.34345e-17
C625	a_1057_74##4	VNB	4.50042e-17
C626	a_1057_74##6	VNB	3.8332e-17
C627	a_27_373##6	B#3	3.77927e-19
C628	C#1	VNB	2.6427e-17
C629	C#7	VNB	4.46914e-17
C630	a_1027_48#	VNB	4.01772e-17
C631	B#1	VNB	3.69663e-17
C632	a_397_21#	VNB	3.00648e-17
C633	B#5	VNB	4.62193e-17
C634	a_397_21##5	VNB	2.85404e-17
C635	B#7	VNB	8.20526e-17
C636	A#1	VNB	3.3171e-17
C637	a_83_247##3	VNB	4.57439e-17
C638	VPWR#2	VNB	1.38869e-16
C639	a_329_81##3	a_83_247##11	3.26755e-17
C640	VGND#2	VNB	1.35042e-16
C641	a_397_21##3	a_332_373#	1.60372e-17
C642	a_329_81##5	a_83_247##4	6.54291e-17
C643	a_332_373##6	VNB	1.37589e-17
C644	a_332_373##3	VNB	1.29127e-17
C645	a_27_373##5	VNB	7.78887e-18
C646	VPWR#5	VNB	3.44035e-16
C647	a_27_373##2	VNB	5.48904e-17
C648	VGND#5	VNB	3.29306e-16
C649	C#10	C#3	6.49747e-18
C650	a_1057_74##3	VNB	3.75075e-17
C651	C#2	VNB	3.32193e-21
C652	a_1027_48##2	VNB	6.24537e-17
C653	B#2	VNB	8.87584e-17
C654	a_329_81##2	a_1027_48#	2.48878e-17
C655	a_397_21##2	VNB	3.97123e-17
C656	A#2	VNB	2.96105e-17
C657	a_83_247##2	VNB	4.49194e-17
C658	a_83_247##11	B#6	6.69083e-18
C659	A	VNB	3.71765e-19
C660	VPWR#3	VPWR#1	6.99578e-19
C661	B	VNB	3.17126e-18
C662	X	VNB	1.06202e-17
C663	a_27_373##6	a_397_21##3	8.13746e-19
C664	a_1057_74##9	C#4	1.54659e-18
C665	VPWR#6	A#2	2.55682e-20
C666	VGND#6	VNB	7.79723e-17
C667	VPWR#5	VPWR#6	1.49262e-16
C668	VPWR#6	B#4	3.42624e-18
C669	VPWR#6	B#7	1.43353e-17
C670	VPWR#6	A#1	4.32189e-18
C671	VPWR#6	a_83_247##3	8.86566e-18
C672	VGND#6	a_27_373#	1.86809e-17
C673	VGND#6	a_83_247#	9.38626e-18
C674	VGND#6	a_83_247##2	4.67262e-19
C675	VGND#6	a_83_247##9	8.45282e-17
C676	VGND#6	A#3	4.9239e-18
C677	VGND#6	A#2	3.4279e-20
C678	VGND#6	B#8	4.06011e-18
C679	a_83_247##5	VPWR#6	8.82571e-17
C680	VGND#6	a_397_21##4	4.99752e-18
C681	VPWR#6	VNB	7.6982e-17
C682	VPWR#6	a_397_21##4	4.76791e-19
C683	VGND#5	VGND#6	1.41569e-16
C684	a_27_373##3	VPWR#6	1.62062e-17
C685	a_27_373##2	VGND#6	2.90578e-18
C686	a_27_373##5	VGND#6	2.38901e-18
*
*
.ENDS sky130_fd_sc_hs__xnor3_2
*
