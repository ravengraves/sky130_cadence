* Extracted by Quantus, converted by sky130cad/quantus.py
*
*
*
*                       LINUX           Wed Nov 18 08:37:27 2026
*
*
*
*  PROGRAM  advgen
*
*  Name           : advgen - Quantus - (64-bit)
*  Version        : 25.1.0-p047
*  Build Date     : Thu Dec 11 23:20:30 PST 2025
*
*  HSPICE LIBRARY
*
*  OPERATING_TEMPERATURE 150
*  QRC_TECH_DIR <path>/tech
*
*
*

*
.SUBCKT sky130_fd_sc_hs__einvp_2 VPB VNB VGND VPWR Z TE A
*
*
*  caps2d version: 10
*
*
*       TRANSISTOR CARDS
*
*
XM2 a_36_74##4 A#6 Z#1 VNB sky130_fd_pr__nfet_01v8_lvt l=0.15 w=0.74 ad=0.2109 as=0.2072 pd=2.05 ps=2.04
XM1 Z#1 A#1 a_36_74##2 VNB sky130_fd_pr__nfet_01v8_lvt l=0.15 w=0.74 ad=0.2072 as=0.2072 pd=2.04 ps=2.04
XM4 a_36_74##2 TE#5 VGND#4 VNB sky130_fd_pr__nfet_01v8_lvt l=0.15 w=0.74 ad=0.2072 as=0.2072 pd=2.04 ps=2.04
XM5 VGND#4 TE#6 a_36_74# VNB sky130_fd_pr__nfet_01v8_lvt l=0.15 w=0.74 ad=0.2072 as=0.2109 pd=2.04 ps=2.05
XM8 a_263_323##7 TE#2 VGND#1 VNB sky130_fd_pr__nfet_01v8_lvt l=0.15 w=0.42 ad=0.1197 as=0.126 pd=1.41 ps=1.44
XM0 a_27_368##4 A#7 Z#2 VPB sky130_fd_pr__pfet_01v8 l=0.15 w=1.12 ad=0.3304 as=0.336 pd=2.83 ps=2.84
XM6 Z#2 A#5 a_27_368##2 VPB sky130_fd_pr__pfet_01v8 l=0.15 w=1.12 ad=0.336 as=0.336 pd=2.84 ps=2.84
XM7 VPWR#3 a_263_323##3 a_27_368##2 VPB sky130_fd_pr__pfet_01v8 l=0.15 w=1.12 ad=0.336 as=0.336 pd=2.84 ps=2.84
XM3 a_27_368# a_263_323# VPWR#3 VPB sky130_fd_pr__pfet_01v8 l=0.15 w=1.12 ad=0.3248 as=0.336 pd=2.82 ps=2.84
XM9 a_263_323##5 TE#1 VPWR#1 VPB sky130_fd_pr__pfet_01v8 l=0.15 w=0.64 ad=0.1856 as=0.1888 pd=1.86 ps=1.87
*
*
*       RESISTOR AND CAP/DIODE CARDS
*
Rg1	A#1	A#2	322.953644
Rg2	A#2	A#3	66.369736
Rg3	A#3	A#4	41.678959
Rg4	A#2	A#5	507.075531
Rg5	A#3	A#6	320.892242
Rg6	A#3	A#7	506.023621
Rg7	a_263_323#	a_263_323##2	371.735809
Rg8	a_263_323##2	a_263_323##3	592.600037
Rg9	a_263_323##2	a_263_323##4	495.946533
Rg10	TE#1	TE#2	1015.623108
Rg11	TE#2	TE#3	242.848938
Rg12	TE#3	TE#4	707.233032
Rg13	TE#4	TE#5	473.208221
Rg14	TE#4	TE#6	262.702026
Rf1	A	A#4	163.775864
Rf2	Z#1	Z	38.713638
Rf3	Z	Z#3	9.977883
Rf4	Z#3	Z	5.246104
Rf5	Z#2	Z#3	7.500000
Rf6	a_27_368#	a_27_368##3	161.138367
Rf7	a_27_368##3	a_27_368##4	136.841568
Rf8	a_27_368##2	a_27_368##3	5.000000
Rf9	a_36_74#	a_36_74##3	121.676079
Rf10	a_36_74##3	a_36_74##4	103.198174
Rf11	a_36_74##2	a_36_74##3	7.500000
Rf12	a_263_323##5	a_263_323##4	43.717888
Rf13	a_263_323##4	a_263_323##7	44.517960
Rf14	TE	TE#3	165.350555
Rf15	VPWR#1	VPWR#2	129.952148
Rf16	VPWR#2	VPWR#3	52.877037
Rf18	VGND#1	VGND#2	155.443390
Rf20	VGND#2	VGND#4	34.638962
Re1	VPWR#2	VPWR	1.403190
Re2	VGND	VGND#2	1.403242
*
*       CAPACITOR CARDS
*
*
C1	A#2	TE#5	8.87431e-18
C2	TE#4	a_263_323##3	5.76893e-19
C3	A#2	a_263_323##3	7.24491e-18
C4	a_263_323##7	TE#4	1.38102e-17
C5	TE#4	a_263_323##4	1.03723e-17
C6	a_263_323##4	A#2	8.9669e-19
C7	a_263_323##7	A#2	2.08556e-19
C8	a_36_74#	TE#4	1.93901e-17
C9	a_36_74#	a_263_323##2	4.80133e-18
C10	A#4	A#2	3.89657e-18
C11	a_263_323##7	VGND#1	2.21646e-17
C12	TE#4	VGND#4	2.39854e-18
C13	a_36_74#	VGND#1	3.50132e-18
C14	a_36_74#	a_263_323##7	3.61009e-17
C15	VGND#4	VGND#1	2.01979e-20
C16	VGND#4	a_36_74#	7.24837e-17
C17	a_36_74##2	TE#4	6.17389e-19
C18	a_36_74##2	a_36_74#	2.31625e-18
C19	a_36_74##2	a_263_323##2	6.7661e-20
C20	a_36_74##2	VGND#4	7.39423e-17
C21	VGND#1	VPWR#1	6.3958e-18
C22	a_36_74##2	A#2	4.87958e-18
C23	a_36_74##2	Z#1	4.76899e-17
C24	a_36_74##4	a_36_74##2	3.46146e-18
C25	a_36_74##4	Z#1	5.07291e-17
C26	a_36_74#	a_27_368#	5.08745e-17
C27	A#2	Z#1	5.37936e-19
C28	a_36_74##2	a_27_368#	1.11456e-18
C29	a_263_323##5	VPWR#1	8.00816e-17
C30	a_36_74##2	a_27_368##2	4.32637e-17
C31	TE#2	VGND#1	2.19599e-17
C32	a_36_74##4	A#2	1.75718e-19
C33	a_263_323##7	TE#2	2.50712e-17
C34	VGND#1	TE#6	7.69365e-19
C35	a_27_368#	a_263_323##5	5.65069e-17
C36	a_36_74#	TE#2	2.52637e-18
C37	VPWR#3	VPWR#1	1.1985e-18
C38	a_263_323##7	TE#6	5.63373e-19
C39	a_36_74#	TE#6	2.03626e-17
C40	a_36_74##4	Z#2	1.21851e-19
C41	a_27_368#	VPWR#3	9.85481e-17
C42	VGND#4	TE#6	4.06197e-17
C43	a_36_74#	TE#5	4.51683e-19
C44	a_36_74##2	TE#6	4.01042e-19
C45	a_27_368##2	a_27_368#	2.41228e-18
C46	VGND#4	TE#5	3.54155e-17
C47	a_36_74#	A#1	1.94223e-19
C48	a_27_368##2	VPWR#3	1.03471e-16
C49	a_36_74##2	TE#5	2.65105e-17
C50	VPWR#1	TE#2	1.46077e-19
C51	VGND#4	A#1	1.93734e-18
C52	Z#1	TE#5	8.67849e-19
C53	a_36_74##2	A#1	3.54409e-17
C54	VGND#4	A#6	3.35106e-19
C55	a_36_74##4	TE#5	2.80408e-19
C56	a_27_368##2	Z#2	1.68838e-19
C57	VGND#1	TE#1	1.29877e-19
C58	Z#1	A#1	3.17971e-17
C59	a_27_368#	TE#2	5.0655e-19
C60	a_36_74##2	A#6	9.59615e-19
C61	TE#4	a_263_323##2	2.55674e-17
C62	a_36_74##4	A#1	2.03535e-18
C63	a_27_368##4	a_27_368##2	2.14025e-18
C64	A#6	Z#1	1.45796e-17
C65	a_27_368##4	Z#2	2.56657e-19
C66	a_36_74##4	A#6	5.12177e-17
C67	a_27_368#	TE#4	8.1164e-18
C68	a_27_368#	a_263_323##2	2.68333e-17
C69	Z	A#2	1.627e-17
C70	a_27_368##2	TE#5	3.76916e-18
C71	VPWR#1	TE#1	4.64738e-17
C72	a_36_74##2	a_263_323##3	2.51925e-18
C73	a_263_323##5	TE#1	2.37599e-17
C74	VPWR#1	a_263_323#	1.08654e-18
C75	a_27_368#	TE#1	3.27128e-18
C76	a_263_323##5	a_263_323#	3.27501e-18
C77	VPWR#3	TE#1	5.3887e-19
C78	VPWR#1	a_263_323##3	2.47193e-19
C79	TE#5	TE#6	3.65539e-17
C80	a_27_368#	a_263_323#	6.10892e-17
C81	VPWR	a_263_323##2	3.30478e-19
C82	VPWR#3	a_263_323#	1.98602e-17
C83	VPWR#3	a_263_323##2	4.37014e-18
C84	a_27_368#	a_263_323##3	2.02696e-18
C85	a_27_368##2	a_263_323#	5.99083e-20
C86	A#1	TE#5	3.74482e-17
C87	VPWR#3	a_263_323##3	5.12648e-17
C88	a_27_368#	A#5	2.52686e-19
C89	a_27_368##2	a_263_323##3	3.43981e-17
C90	TE#2	TE#1	2.55229e-18
C91	VPWR#3	A#5	1.92561e-18
C92	A#6	A#1	3.73296e-17
C93	VGND#1	TE#3	1.64346e-17
C94	a_27_368##2	A#5	4.59064e-17
C95	a_263_323##7	TE#3	1.33675e-17
C96	a_27_368##4	a_263_323##3	1.83236e-19
C97	A#5	Z#2	2.34329e-17
C98	a_36_74#	TE#3	1.471e-17
C99	a_27_368##2	A#7	7.58329e-19
C100	a_27_368##2	TE#4	1.32352e-19
C101	VGND#4	TE#3	2.59959e-18
C102	a_27_368##4	A#5	2.00757e-18
C103	A#7	Z#2	5.18119e-18
C104	VGND	TE#4	6.68831e-21
C105	a_36_74##2	TE#3	1.0738e-19
C106	VGND	a_263_323##2	2.90385e-20
C107	a_36_74#	a_263_323##4	1.73629e-18
C108	a_27_368##4	A#7	4.77455e-17
C109	TE#5	a_263_323##3	1.20371e-17
C110	a_27_368##2	A#2	6.50476e-18
C111	a_263_323#	TE#1	6.97661e-18
C112	VPWR#1	a_263_323##4	1.02548e-19
C113	A#4	Z#1	2.84486e-19
C114	A#4	a_36_74##4	7.31191e-18
C115	a_27_368#	a_263_323##4	4.39784e-17
C116	a_263_323##3	a_263_323#	4.6684e-17
C117	TE#4	VNB	3.89672e-17
C118	a_263_323##2	VNB	2.08707e-17
C119	TE#3	TE#2	1.19598e-17
C120	A#2	VNB	2.67279e-17
C121	TE#6	TE#3	2.44592e-17
C122	A#5	a_263_323##3	4.97089e-17
C123	a_263_323##4	TE#2	2.11743e-17
C124	a_27_368##4	A#4	5.45907e-18
C125	A#7	A#5	4.91761e-17
C126	a_263_323##4	TE#1	2.5145e-17
C127	a_263_323#	a_263_323##4	5.14129e-18
C128	VGND#1	TE	5.08571e-17
C129	a_36_74##4	A	4.09234e-17
C130	TE	a_263_323##7	3.16024e-17
C131	a_36_74#	TE	2.04166e-17
C132	VGND#4	TE	2.82186e-18
C133	Z	a_263_323##7	4.00949e-19
C134	A	a_27_368##4	1.73631e-17
C135	Z	a_36_74##2	1.93923e-17
C136	TE#3	a_263_323##4	2.34369e-18
C137	TE	TE#2	5.37453e-18
C138	TE	TE#6	1.90962e-18
C139	Z	a_27_368##2	1.19924e-16
C140	Z	Z#2	2.97347e-18
C141	VPWR	VPWR#1	3.96662e-17
C142	a_27_368##4	Z	7.17498e-17
C143	VPWR	a_263_323##5	1.79131e-17
C144	Z	TE#2	6.39078e-19
C145	VGND	VGND#1	3.36792e-17
C146	VPWR	a_27_368#	1.5255e-17
C147	VGND	a_263_323##7	7.9305e-18
C148	VGND	a_36_74#	1.56355e-17
C149	TE#4	TE#2	1.01766e-17
C150	Z	TE#5	1.31614e-18
C151	TE	TE#1	4.08855e-19
C152	VGND	VGND#4	2.21817e-17
C153	VPWR	a_27_368##2	2.06128e-17
C154	VGND	a_36_74##2	1.85949e-17
C155	Z	A#1	1.27471e-18
C156	VGND	Z#1	7.9235e-18
C157	VPWR	a_27_368##4	2.23319e-17
C158	Z	A#6	2.7039e-19
C159	VGND	a_36_74##4	2.247e-17
C160	VPWR	TE#2	6.60008e-19
C161	VGND	a_27_368#	3.76407e-18
C162	VGND#1	VNB	6.68368e-17
C163	VGND	a_27_368##2	2.61802e-18
C164	a_263_323##7	VNB	9.16185e-18
C165	Z	a_263_323##3	2.59257e-18
C166	a_36_74#	VNB	1.06454e-17
C167	VGND#4	VNB	3.2946e-19
C168	VGND	a_27_368##4	2.65335e-18
C169	Z	A#5	3.35008e-17
C170	a_36_74##2	VNB	4.097e-18
C171	VGND	TE#2	2.34071e-18
C172	VPWR	TE#1	6.16333e-18
C173	Z#1	VNB	2.37756e-19
C174	Z	A#7	2.23804e-17
C175	VGND	TE#6	1.04224e-18
C176	a_36_74##4	VNB	3.96974e-17
C177	VPWR	a_263_323#	4.02816e-18
C178	VPWR#1	VNB	7.1365e-17
C179	VGND	TE#5	9.28604e-19
C180	a_263_323##5	VNB	1.94153e-17
C181	VPWR	a_263_323##3	3.71679e-18
C182	TE	TE#3	2.3533e-17
C183	VGND	A#1	1.48586e-18
C184	A	A#4	2.37511e-17
C185	a_27_368#	VNB	2.72257e-18
C186	VGND	A#6	2.53534e-18
C187	VPWR	A#5	1.49238e-18
C188	VPWR#3	VNB	5.49902e-19
C189	TE	a_263_323##4	1.14357e-18
C190	a_27_368##2	VNB	7.91429e-18
C191	VPWR	A#7	2.34524e-18
C192	VGND	TE#1	4.64174e-19
C193	a_27_368##4	VNB	5.81318e-17
C194	TE#2	VNB	7.07638e-17
C195	TE#6	VNB	2.5092e-17
C196	VGND	a_263_323##3	4.46745e-21
C197	Z	a_263_323##4	1.53963e-18
C198	TE#5	VNB	3.17651e-17
C199	A#1	VNB	2.65201e-17
C200	Z	A#4	1.39025e-17
C201	A#2	TE#2	2.6165e-19
C202	A#6	VNB	3.39192e-17
C203	VPWR	a_263_323##4	1.26807e-18
C204	TE#1	VNB	8.31537e-17
C205	a_263_323#	VNB	3.24273e-17
C206	VPWR	A#4	6.15463e-19
C207	a_263_323##3	VNB	4.36601e-17
C208	A#5	VNB	3.75299e-17
C209	VGND	TE#3	1.02634e-17
C210	A#7	VNB	4.9598e-17
C211	VGND	a_263_323##4	4.17893e-19
C212	VGND	A#4	6.86297e-19
C213	A	Z	3.81912e-17
C214	TE#3	VNB	9.2751e-17
C215	a_263_323##4	VNB	6.26786e-17
C216	VPWR	A	3.39143e-18
C217	A#4	VNB	6.36148e-17
C218	VGND	A	4.72935e-18
C219	VPWR	Z	9.16766e-18
C220	VGND	TE	1.47246e-17
C221	A	VNB	2.3497e-17
C222	TE	VNB	6.7191e-18
C223	Z	VNB	6.71593e-18
C224	TE#6	TE#4	3.56005e-18
C225	VPWR	VNB	7.04766e-17
C226	VGND	VNB	6.18925e-17
C227	VPWR#2	VPWR#1	3.85719e-17
C228	VGND#2	TE#4	1.86243e-19
C229	VPWR#2	A#7	4.77504e-18
C230	VGND#2	A#4	6.55593e-19
C231	VGND#2	a_263_323##7	8.74786e-19
C232	VPWR#2	TE#4	1.10439e-18
C233	VGND	VGND#2	6.17133e-17
C234	VPWR#2	a_263_323##4	4.82726e-19
C235	VGND#2	TE#3	8.61031e-18
C236	VPWR#2	a_263_323##3	4.70866e-18
C237	VGND#2	A#1	4.48038e-18
C238	VGND#2	A	1.15271e-18
C239	VGND#2	a_36_74##4	5.22289e-17
C240	VPWR#2	A#2	2.56643e-20
C241	VGND#2	TE#6	9.67766e-19
C242	VGND#2	A#2	7.77353e-20
C243	VPWR#2	TE#1	3.67748e-19
C244	a_263_323##5	VPWR#2	8.34229e-18
C245	VGND#2	a_36_74##2	3.53063e-17
C246	a_27_368##4	VPWR#2	5.06273e-17
C247	VPWR#2	a_263_323##2	5.7059e-20
C248	VPWR#2	A#4	5.05588e-19
C249	VGND#2	a_36_74#	1.5139e-17
C250	VGND#2	VNB	2.46758e-16
C251	A	VPWR#2	2.79683e-19
C252	VGND#2	a_263_323##4	7.49793e-19
C253	VPWR#2	A#5	5.05454e-18
C254	VGND#2	VGND#1	3.007e-17
C255	VPWR#2	VNB	2.39092e-16
C256	a_27_368##2	VPWR#2	4.12789e-17
C257	VGND#2	A#6	4.44935e-18
C258	VGND#2	TE	1.70302e-17
C259	VPWR#2	a_263_323#	5.64406e-18
C260	VGND#2	TE#5	1.2494e-18
C261	VPWR	VPWR#2	7.2006e-17
C262	a_27_368#	VPWR#2	1.55546e-17
*
*
.ENDS sky130_fd_sc_hs__einvp_2
*
