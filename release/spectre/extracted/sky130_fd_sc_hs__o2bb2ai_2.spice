* Extracted by Quantus, converted by sky130cad/quantus.py
*
*
*
*                       LINUX           Wed Nov 18 09:00:17 2026
*
*
*
*  PROGRAM  advgen
*
*  Name           : advgen - Quantus - (64-bit)
*  Version        : 25.1.0-p047
*  Build Date     : Thu Dec 11 23:20:30 PST 2025
*
*  HSPICE LIBRARY
*
*  OPERATING_TEMPERATURE 150
*  QRC_TECH_DIR <path>/tech
*
*
*

*
.SUBCKT sky130_fd_sc_hs__o2bb2ai_2 VNB VPB VGND VPWR Y B2 A1_N B1 A2_N
*
*
*  caps2d version: 10
*
*
*       TRANSISTOR CARDS
*
*
XM8 VGND#6 A1_N#1 a_134_74##2 VNB sky130_fd_pr__nfet_01v8_lvt l=0.15 w=0.64 ad=0.2272 as=0.1792 pd=1.99 ps=1.84
XM5 a_134_74##2 A2_N#4 a_133_387##12 VNB sky130_fd_pr__nfet_01v8_lvt l=0.15 w=0.64 ad=0.1792 as=0.2272 pd=1.84 ps=1.99
XM19 a_133_387##12 A2_N#5 a_134_74# VNB sky130_fd_pr__nfet_01v8_lvt l=0.15 w=0.64 ad=0.2272 as=0.1792 pd=1.99 ps=1.84
XM15 a_134_74# A1_N#7 VGND#9 VNB sky130_fd_pr__nfet_01v8_lvt l=0.15 w=0.64 ad=0.1792 as=0.1824 pd=1.84 ps=1.85
XM12 a_518_74# a_133_387##6 Y#4 VNB sky130_fd_pr__nfet_01v8_lvt l=0.15 w=0.74 ad=0.2109 as=0.2072 pd=2.05 ps=2.04
XM17 Y#4 a_133_387# a_518_74##2 VNB sky130_fd_pr__nfet_01v8_lvt l=0.15 w=0.74 ad=0.2072 as=0.2294 pd=2.04 ps=2.1
XM9 a_518_74##2 B1#3 VGND#8 VNB sky130_fd_pr__nfet_01v8_lvt l=0.15 w=0.74 ad=0.2294 as=0.259 pd=2.1 ps=2.18
XM2 VGND#8 B2#5 a_518_74##4 VNB sky130_fd_pr__nfet_01v8_lvt l=0.15 w=0.74 ad=0.259 as=0.2442 pd=2.18 ps=2.14
XM1 a_518_74##4 B2#1 VGND#7 VNB sky130_fd_pr__nfet_01v8_lvt l=0.15 w=0.74 ad=0.2442 as=0.2183 pd=2.14 ps=2.07
XM6 VGND#7 B1#4 a_518_74##6 VNB sky130_fd_pr__nfet_01v8_lvt l=0.15 w=0.74 ad=0.2183 as=0.2109 pd=2.07 ps=2.05
XM10 VPWR#8 A1_N#4 a_133_387##10 VPB sky130_fd_pr__pfet_01v8 l=0.15 w=0.84 ad=0.3801 as=0.252 pd=2.86 ps=2.28
XM11 a_133_387##10 A2_N#6 VPWR#7 VPB sky130_fd_pr__pfet_01v8 l=0.15 w=0.84 ad=0.252 as=0.46585 pd=2.28 ps=3.11
XM14 VPWR#7 A2_N#1 a_133_387##13 VPB sky130_fd_pr__pfet_01v8 l=0.15 w=0.84 ad=0.46585 as=0.344625 pd=3.11 ps=2.66
XM16 a_133_387##13 A1_N#5 VPWR#5 VPB sky130_fd_pr__pfet_01v8 l=0.15 w=0.84 ad=0.344625 as=0.5418 pd=2.66 ps=3.33
XM0 VPWR#5 a_133_387##7 Y#3 VPB sky130_fd_pr__pfet_01v8 l=0.15 w=1.12 ad=0.5418 as=0.3528 pd=3.33 ps=2.87
XM18 Y#3 a_133_387##5 VPWR#4 VPB sky130_fd_pr__pfet_01v8 l=0.15 w=1.12 ad=0.3528 as=0.4368 pd=2.87 ps=3.02
XM7 a_796_368##2 B1#1 VPWR#4 VPB sky130_fd_pr__pfet_01v8 l=0.15 w=1.12 ad=0.336 as=0.4368 pd=2.84 ps=3.02
XM4 Y#1 B2#6 a_796_368##2 VPB sky130_fd_pr__pfet_01v8 l=0.15 w=1.12 ad=0.336 as=0.336 pd=2.84 ps=2.84
XM13 a_796_368# B2#4 Y#1 VPB sky130_fd_pr__pfet_01v8 l=0.15 w=1.12 ad=0.336 as=0.336 pd=2.84 ps=2.84
XM3 VPWR#1 B1#6 a_796_368# VPB sky130_fd_pr__pfet_01v8 l=0.15 w=1.12 ad=0.3304 as=0.336 pd=2.83 ps=2.84
*
*
*       RESISTOR AND CAP/DIODE CARDS
*
Rg1	A1_N#1	A1_N#2	399.568359
Rg2	A1_N#2	A1_N#3	36.503117
Rg3	A1_N#2	A1_N#4	435.718567
Rg4	A2_N#1	A2_N#2	351.986145
Rg5	A2_N#2	A2_N#3	77.976372
Rg6	A2_N#3	A2_N#4	480.765717
Rg7	A2_N#2	A2_N#5	463.437347
Rg8	A2_N#3	A2_N#6	369.314545
Rg9	A1_N#5	A1_N#6	354.298584
Rg10	A1_N#6	A1_N#7	449.780304
Rg11	a_133_387#	a_133_387##2	365.319366
Rg12	a_133_387##2	a_133_387##3	75.843170
Rg13	a_133_387##3	a_133_387##4	41.018009
Rg14	a_133_387##2	a_133_387##5	479.423370
Rg15	a_133_387##3	a_133_387##6	370.459167
Rg16	a_133_387##3	a_133_387##7	472.309845
Rg17	B1#1	B1#2	442.817719
Rg18	B1#2	B1#3	394.958344
Rg19	B2#1	B2#2	322.953644
Rg20	B2#2	B2#3	40.440567
Rg21	B2#2	B2#4	507.075531
Rg22	B2#3	B2#5	328.187561
Rg23	B2#3	B2#6	509.023376
Rg24	B1#4	B1#5	382.539734
Rg25	B1#5	B1#6	434.639221
Rf1	A2_N#2	A2_N#8	161.092438
Rf2	A2_N#9	A2_N	0.859639
Rf3	A2_N#8	A2_N#9	5.433131
Rf4	a_134_74#	a_134_74##2	102.965965
Rf5	A1_N#6	A1_N	410.308594
Rf6	A1_N	A1_N#3	168.227554
Rf7	a_133_387##4	a_133_387##9	272.826782
Rf8	a_133_387##9	a_133_387##11	62.917992
Rf9	a_133_387##9	a_133_387##12	26.885429
Rf10	a_133_387##11	a_133_387##13	61.929626
Rf11	a_133_387##10	a_133_387##11	15.000000
Rf12	B2#7	B2	0.882458
Rf13	B2#3	B2#9	161.115265
Rf14	B2#7	B2#9	3.543054
Rf15	Y#1	Y#2	113.754303
Rf16	Y#2	Y#3	16.525021
Rf17	Y#2	Y	4.966200
Rf18	Y	Y#4	17.892277
Rf19	a_796_368#	a_796_368##2	97.790558
Rf20	B1#2	B1	254.878647
Rf21	B1	B1#5	163.723541
Rf22	a_518_74#	a_518_74##3	102.874977
Rf23	a_518_74##3	a_518_74##5	63.476070
Rf24	a_518_74##5	a_518_74##6	48.828468
Rf25	a_518_74##2	a_518_74##3	7.500000
Rf26	a_518_74##4	a_518_74##5	7.500000
Rf27	VPWR#1	VPWR#2	182.022385
Rf28	VPWR#2	VPWR#3	54.398087
Rf29	VPWR#2	VPWR#4	30.747387
Rf30	VPWR#3	VPWR#5	41.783939
Rf31	VPWR#3	VPWR#6	114.482117
Rf32	VPWR#6	VPWR#7	29.586588
Rf33	VPWR#6	VPWR#8	107.004173
Rf35	VGND#2	VGND#3	66.966377
Rf36	VGND#3	VGND#4	90.923332
Rf37	VGND#4	VGND#5	48.968575
Rf38	VGND#5	VGND#6	168.344727
Rf39	VGND#2	VGND#7	31.246290
Rf40	VGND#3	VGND#8	33.326477
Rf41	VGND#5	VGND#9	43.382782
Re1	VPWR#3	VPWR	0.818510
Re2	VGND	VGND#4	0.818540
*
*       CAPACITOR CARDS
*
*
C1	VGND	VNB	7.72044e-17
C2	VPWR	VNB	7.07547e-17
C3	Y	VNB	3.78404e-18
C4	VGND#6	A2_N#5	4.60212e-19
C5	B2	VNB	3.10534e-18
C6	A1_N	VNB	6.23615e-17
C7	B1	VNB	2.40651e-17
C8	A2_N	VNB	1.50214e-18
C9	A1_N#3	VNB	7.13056e-17
C10	VGND	Y	8.35767e-18
C11	A2_N#2	VNB	3.98814e-17
C12	A1_N#6	VNB	2.99266e-17
C13	a_133_387##4	VNB	5.2675e-17
C14	VGND	B2	2.72766e-18
C15	B1#2	VNB	3.67594e-17
C16	B2#3	VNB	5.11103e-17
C17	B1#5	VNB	4.7665e-17
C18	VGND	A1_N	2.85705e-18
C19	VGND#4	VNB	2.61177e-16
C20	A2_N#4	a_133_387##12	1.67039e-17
C21	VPWR#3	VNB	2.73246e-16
C22	VGND	B1	5.92121e-18
C23	A1_N#4	VNB	4.41795e-17
C24	A2_N#6	VNB	3.12926e-17
C25	A2_N#1	VNB	3.57897e-17
C26	VGND	A2_N	1.57031e-18
C27	A1_N#5	VNB	3.6794e-17
C28	VPWR	A1_N	1.98117e-17
C29	a_134_74##2	a_133_387##9	3.35491e-17
C30	a_133_387##7	VNB	3.99395e-17
C31	a_133_387##5	VNB	3.27251e-17
C32	Y	B2	3.75167e-18
C33	a_518_74##2	a_518_74##6	5.35862e-19
C34	B1#1	VNB	3.19199e-17
C35	B2#6	VNB	3.431e-17
C36	VPWR	B1	6.13037e-18
C37	B2#4	VNB	3.4118e-17
C38	VGND#8	VGND#7	2.7215e-18
C39	B1#6	VNB	4.03887e-17
C40	A1_N#1	VNB	3.76334e-17
C41	VPWR	A2_N	9.36717e-19
C42	A2_N#4	VNB	3.13097e-17
C43	A2_N#5	VNB	3.05399e-17
C44	A1_N#7	VNB	3.92272e-17
C45	a_133_387##6	VNB	3.04188e-17
C46	a_133_387#	VNB	2.94659e-17
C47	B1#3	VNB	2.65861e-17
C48	B2#5	VNB	2.25475e-17
C49	a_134_74##2	A2_N#5	1.13221e-18
C50	B2#1	VNB	2.20251e-17
C51	B1#4	VNB	3.18659e-17
C52	VGND	A1_N#3	1.6805e-19
C53	VPWR#8	VNB	5.46398e-17
C54	a_133_387##10	VNB	1.39507e-18
C55	VPWR#8	VPWR#7	6.99469e-18
C56	VPWR#7	VNB	1.16632e-17
C57	VPWR#5	VNB	7.6179e-18
C58	VGND	A1_N#6	3.50869e-18
C59	VPWR#4	VNB	4.02342e-18
C60	a_796_368##2	VNB	4.01971e-18
C61	VGND	a_133_387##4	6.36673e-18
C62	a_796_368#	VNB	2.63014e-18
C63	VPWR#1	VNB	8.615e-17
C64	VGND#6	VNB	8.25693e-17
C65	VGND	B1#2	4.41687e-18
C66	a_134_74##2	VNB	3.52343e-18
C67	a_134_74#	A2_N#4	9.76438e-19
C68	a_134_74#	VNB	3.28363e-18
C69	VGND	B2#3	1.10111e-18
C70	VGND#9	VNB	5.74383e-18
C71	a_518_74#	VNB	1.03247e-17
C72	VGND#6	A1_N#7	7.09349e-20
C73	a_518_74##2	VNB	1.01443e-17
C74	VGND#8	VNB	4.56911e-19
C75	VGND	VGND#4	1.65588e-17
C76	a_518_74##4	VNB	4.78489e-18
C77	VGND#7	VNB	2.28287e-18
C78	a_518_74##6	VNB	4.29466e-17
C79	VPWR	A1_N#6	2.12087e-17
C80	A2_N#8	VNB	1.08202e-18
C81	VPWR	a_133_387##4	2.32841e-18
C82	a_133_387##9	VNB	1.26764e-17
C83	VPWR#6	A2_N#6	5.25124e-18
C84	VPWR	B1#2	3.82277e-18
C85	B2#9	VNB	1.7986e-18
C86	Y#2	VNB	5.36515e-18
C87	A2_N#5	a_133_387##12	1.49153e-17
C88	VPWR#2	VNB	4.62112e-17
C89	A1_N#6	Y	5.17059e-18
C90	VPWR#6	VNB	4.23177e-17
C91	VGND#3	VNB	3.58666e-17
C92	VGND#5	VNB	4.77661e-17
C93	Y	a_133_387##4	6.96513e-17
C94	VPWR	VPWR#3	3.09258e-17
C95	Y	B1#2	2.73024e-17
C96	a_133_387##10	VPWR#7	1.13505e-18
C97	VPWR	A1_N#4	6.87583e-18
C98	Y	B2#3	3.55864e-19
C99	a_518_74##4	VGND#7	4.04226e-17
C100	a_133_387##9	a_133_387##12	1.51603e-18
C101	VPWR	A2_N#6	6.95533e-18
C102	A1_N	A1_N#3	3.08226e-17
C103	VGND	A1_N#1	4.8566e-18
C104	VPWR	A2_N#1	6.74691e-18
C105	B2	a_133_387##4	7.23036e-20
C106	VGND	A2_N#4	1.33733e-18
C107	VPWR	A1_N#5	7.98648e-18
C108	VGND	A2_N#5	1.3446e-18
C109	B2	B1#2	6.07723e-19
C110	VPWR	a_133_387##7	4.42953e-18
C111	VGND	A1_N#7	2.6349e-18
C112	a_134_74#	A2_N#5	3.86049e-17
C113	VGND	a_133_387##6	2.12488e-18
C114	VPWR	a_133_387##5	2.57965e-19
C115	B2	B2#3	1.31325e-17
C116	VGND	a_133_387#	1.49576e-18
C117	VPWR	B1#1	1.83695e-18
C118	VGND	B1#3	5.5189e-19
C119	B2	B1#5	5.72056e-19
C120	VPWR	B2#6	1.47663e-18
C121	VGND	B2#5	5.86976e-19
C122	VGND	B2#1	4.87652e-19
C123	VPWR	B2#4	1.3635e-18
C124	VGND	B1#4	1.31345e-18
C125	VPWR	B1#6	2.98623e-18
C126	a_518_74##2	a_133_387##2	2.18908e-19
C127	Y	A1_N#5	3.81822e-19
C128	a_133_387##12	A1_N#7	4.6821e-19
C129	A2_N	A2_N#2	7.12181e-18
C130	Y	a_133_387##7	6.09924e-18
C131	Y	a_133_387##5	5.76847e-18
C132	VGND	VPWR#5	3.06734e-18
C133	B1#2	B1	2.36759e-18
C134	A2_N	A1_N#6	3.05662e-17
C135	Y	B1#1	1.87246e-18
C136	Y#2	a_133_387##7	1.6698e-17
C137	Y	B2#6	6.61452e-19
C138	B1	B2#3	1.20388e-17
C139	VPWR#6	A2_N#1	5.23695e-18
C140	Y	B2#4	4.12017e-19
C141	a_518_74##4	a_518_74##6	2.26366e-18
C142	B1	B1#5	2.5434e-17
C143	A2_N#3	VNB	3.30866e-17
C144	Y	B1#6	3.71268e-19
C145	VGND	VGND#6	5.22836e-17
C146	a_133_387##2	VNB	2.32714e-17
C147	VGND#5	A2_N#3	2.62634e-20
C148	VGND	a_134_74##2	2.19797e-17
C149	A1_N	A1_N#4	2.61346e-17
C150	VGND	a_133_387##12	7.08712e-18
C151	a_134_74#	a_133_387##9	3.44542e-17
C152	a_134_74#	A1_N#7	3.59173e-17
C153	VGND	a_134_74#	2.10781e-17
C154	A1_N	A2_N#6	2.26477e-17
C155	a_796_368##2	VPWR#2	5.1198e-17
C156	VPWR	VPWR#8	3.55006e-17
C157	Y	A2_N#4	1.05708e-19
C158	VGND	a_518_74#	1.9978e-17
C159	VPWR	a_133_387##10	5.85e-18
C160	A1_N	A2_N#1	2.284e-19
C161	VPWR#5	a_133_387##10	1.23177e-20
C162	Y	A2_N#5	1.45465e-19
C163	a_133_387##13	VPWR#7	1.92743e-18
C164	VPWR	VPWR#7	1.72669e-17
C165	VGND	a_518_74##2	2.53158e-17
C166	VGND	VGND#8	1.62179e-17
C167	Y	A1_N#7	8.72064e-19
C168	VPWR	a_133_387##13	5.20909e-18
C169	A1_N	A1_N#5	1.38892e-19
C170	VGND	a_518_74##4	1.63167e-17
C171	a_133_387##12	a_133_387##6	2.10875e-19
C172	VPWR	VPWR#5	2.11571e-17
C173	Y	a_133_387##6	1.58448e-17
C174	VGND	a_518_74##6	1.59823e-17
C175	Y	a_133_387#	1.12812e-17
C176	VGND	A2_N#8	1.09322e-18
C177	VPWR	VPWR#4	2.17824e-17
C178	Y	B1#3	1.42374e-18
C179	VPWR	a_796_368##2	2.35428e-17
C180	Y	B2#5	1.65637e-19
C181	VPWR	Y#1	8.82643e-18
C182	A1_N#7	VGND#9	1.83381e-17
C183	VPWR	a_796_368#	1.97629e-17
C184	Y	B2#1	8.47673e-20
C185	VPWR	VPWR#1	4.35315e-17
C186	VGND	a_133_387##9	7.92385e-18
C187	Y	B1#4	1.11029e-19
C188	a_518_74##6	VGND#7	4.08194e-17
C189	Y#2	a_133_387##5	3.30426e-17
C190	VPWR#7	VPWR#5	5.95656e-18
C191	B2	a_133_387##6	2.38821e-19
C192	B2	a_133_387#	2.34975e-19
C193	VPWR#5	Y	2.62635e-17
C194	A2_N	A1_N#5	1.48959e-18
C195	B2	B1#3	1.38025e-18
C196	Y	Y#3	6.17079e-18
C197	a_518_74#	A1_N#7	1.07265e-18
C198	B1	B2#4	1.96436e-17
C199	VGND	VGND#3	2.54041e-17
C200	VGND#5	a_133_387##9	6.96237e-19
C201	Y#1	VPWR#2	3.46112e-19
C202	VGND	VGND#5	5.08102e-17
C203	B2	B1#4	1.27759e-18
C204	B1	B1#6	8.83906e-18
C205	A2_N#2	A1_N#6	3.63385e-17
C206	Y	a_796_368#	3.22965e-20
C207	VPWR	A2_N#8	1.24185e-18
C208	VGND#9	a_133_387##6	8.81408e-19
C209	a_133_387##4	A2_N#2	1.60373e-19
C210	VPWR#5	a_133_387##13	9.85416e-21
C211	a_133_387##12	Y	1.00958e-18
C212	A1_N#6	a_133_387##4	1.02432e-16
C213	a_518_74#	Y	3.43601e-17
C214	VPWR	B2#9	1.95826e-18
C215	Y	Y#4	1.36564e-18
C216	Y#2	VPWR#2	4.04981e-18
C217	a_518_74#	a_133_387##6	5.53818e-17
C218	Y#2	B1#1	1.26641e-17
C219	a_518_74##2	Y	7.07534e-17
C220	VPWR	Y#2	1.89526e-17
C221	A1_N	VPWR#8	4.96281e-17
C222	A1_N	a_133_387##10	9.23651e-17
C223	a_518_74##2	A1_N#7	6.88321e-20
C224	A1_N	VPWR#7	1.00892e-17
C225	VPWR	VPWR#2	3.32277e-17
C226	A1_N	a_133_387##13	5.51846e-20
C227	VPWR	VPWR#6	3.23724e-17
C228	a_796_368#	VPWR#2	6.63269e-18
C229	a_133_387##6	Y#4	1.44798e-17
C230	VGND#8	A1_N#7	3.30249e-20
C231	a_133_387##9	Y	3.14091e-20
C232	B1#2	B2#3	3.40167e-17
C233	a_518_74#	a_133_387#	4.23008e-19
C234	A1_N#3	A2_N#3	2.59055e-17
C235	VPWR#2	a_133_387##5	9.69918e-19
C236	Y	B2#9	1.41454e-19
C237	A1_N#6	VPWR#3	4.45852e-18
C238	VGND#4	a_133_387##4	1.00034e-19
C239	a_518_74##4	B2	3.59895e-17
C240	VGND#6	A1_N	2.2755e-17
C241	B1#2	B1#5	2.00339e-19
C242	a_518_74##2	a_133_387##6	1.50507e-18
C243	Y#2	B2#6	1.94916e-19
C244	a_134_74##2	A1_N	7.93768e-19
C245	VPWR#3	a_133_387##4	4.60876e-20
C246	B2#3	B1#5	2.32223e-17
C247	a_133_387#	Y#4	4.57585e-18
C248	A1_N#6	A1_N#4	1.75833e-19
C249	B1	Y#1	2.51966e-17
C250	VPWR#2	VPWR#1	1.89266e-19
C251	VPWR#5	VPWR#4	1.74583e-18
C252	VGND#8	a_133_387##6	9.16989e-20
C253	B1	a_796_368#	4.34298e-17
C254	A2_N	a_133_387##13	1.73764e-17
C255	A1_N#6	A2_N#6	4.75691e-19
C256	a_518_74#	B1#3	1.86404e-19
C257	A2_N#2	A1_N#5	4.75926e-18
C258	B1	VPWR#1	2.78968e-17
C259	A1_N#6	A2_N#1	2.26434e-17
C260	a_518_74##2	a_133_387#	4.78312e-17
C261	VPWR#2	B1#1	4.37402e-18
C262	A1_N#6	A1_N#5	2.35315e-17
C263	Y#2	B2#4	1.17169e-19
C264	A1_N#6	a_133_387##7	2.49728e-18
C265	VGND#8	a_133_387#	3.02766e-19
C266	A1_N#6	a_133_387##5	2.02637e-19
C267	A1_N	a_133_387##9	2.6152e-17
C268	a_518_74##2	B1#3	6.21917e-17
C269	a_518_74##4	B1	1.13167e-17
C270	a_133_387##9	A1_N#1	4.88621e-18
C271	a_133_387##4	a_133_387##5	4.98053e-19
C272	a_518_74##6	B1	3.49742e-17
C273	B1#2	a_133_387##7	3.86347e-19
C274	A1_N#3	A2_N#4	3.18894e-18
C275	A2_N#3	A2_N#2	6.18268e-18
C276	VPWR#2	B2#6	4.47264e-18
C277	B1#3	VGND#8	1.98997e-17
C278	a_133_387##5	B1#2	4.30428e-18
C279	B1#2	B1#1	5.18455e-18
C280	a_518_74##2	B2#5	1.90493e-18
C281	VPWR#4	a_796_368##2	5.87986e-17
C282	A1_N	VPWR#6	5.96902e-18
C283	B1#2	B2#6	2.15198e-17
C284	a_518_74##4	B1#3	3.9335e-19
C285	a_133_387##9	A2_N#4	1.19767e-17
C286	A2_N#2	A1_N#7	4.50333e-18
C287	B2#9	B1	3.16851e-17
C288	VGND#8	B2#5	3.59067e-17
C289	VPWR#3	A1_N#5	4.17855e-18
C290	VPWR#2	B2#4	1.6365e-18
C291	A1_N#4	A2_N#6	3.79044e-17
C292	a_518_74##2	B2#1	4.9738e-19
C293	A1_N#6	A1_N#7	4.45528e-19
C294	VPWR#3	a_133_387##7	4.77925e-18
C295	a_133_387##9	A2_N	1.15196e-17
C296	a_518_74##4	B2#5	3.58199e-17
C297	a_133_387##9	A2_N#5	1.41485e-17
C298	VPWR#8	A1_N#3	1.0208e-18
C299	B2#4	B1#5	2.9691e-18
C300	a_518_74##6	B1#3	1.98648e-19
C301	VGND#8	B2#1	1.66872e-18
C302	a_133_387##2	B1#3	1.20131e-18
C303	Y#1	a_796_368##2	8.89002e-17
C304	a_133_387##4	A1_N#7	1.69915e-17
C305	A2_N#6	A2_N#1	1.8976e-17
C306	a_133_387##10	A1_N#3	5.91409e-18
C307	a_518_74##2	B1#4	1.74174e-19
C308	a_133_387##4	a_133_387##6	2.42839e-18
C309	VGND#7	B2#5	1.23259e-18
C310	A1_N#6	A2_N#3	4.20004e-19
C311	a_518_74##4	B2#1	3.63071e-17
C312	A1_N#6	a_133_387##2	1.79057e-19
C313	VPWR#4	VPWR#1	7.76363e-20
C314	a_133_387##10	A2_N#2	1.89476e-18
C315	a_796_368##2	a_796_368#	3.01982e-18
C316	A2_N#1	A1_N#5	2.84985e-17
C317	a_518_74##6	B2#5	5.00516e-19
C318	a_133_387##9	A1_N#7	1.14051e-17
C319	A2_N#2	VPWR#7	1.00781e-18
C320	A2_N#1	a_133_387##7	7.02209e-19
C321	a_133_387##13	A2_N#2	2.96076e-18
C322	VGND#7	B2#1	2.48902e-17
C323	a_518_74##2	Y#2	6.83219e-18
C324	a_133_387##10	A1_N#6	7.16715e-18
C325	VGND#6	VGND#5	2.91055e-19
C326	a_796_368#	Y#1	6.43788e-17
C327	a_518_74##4	B1#4	8.44792e-19
C328	A1_N#5	a_133_387##7	1.51655e-17
C329	A1_N#6	VPWR#7	3.22896e-17
C330	a_518_74##6	B2#1	2.31972e-18
C331	A1_N#6	a_133_387##13	9.85143e-17
C332	a_133_387##9	a_133_387##6	6.56057e-21
C333	B1#3	B2#3	2.57485e-18
C334	A1_N#6	VPWR#5	8.86622e-17
C335	a_133_387##9	A2_N#8	2.34416e-17
C336	VGND#7	B1#4	2.59206e-17
C337	Y	a_133_387##2	1.8071e-17
C338	VGND#6	A1_N#3	1.1764e-17
C339	a_133_387##7	a_133_387##5	4.51593e-17
C340	VGND#4	a_133_387##6	4.4583e-18
C341	VGND#5	a_134_74##2	9.14727e-18
C342	a_518_74##6	B1#4	3.93047e-17
C343	a_133_387##4	A2_N#3	1.02258e-19
C344	a_133_387##4	VPWR#5	3.66736e-17
C345	B2#3	B1#4	3.29998e-18
C346	VGND#4	a_133_387#	4.48038e-18
C347	a_133_387##4	a_133_387##2	5.41627e-18
C348	a_796_368#	VPWR#1	1.0947e-16
C349	a_133_387##5	B1#1	3.24876e-17
C350	a_134_74#	A2_N#2	7.75551e-19
C351	B1#2	VPWR#4	5.20989e-19
C352	B1#1	B2#6	4.58696e-17
C353	a_518_74#	Y#3	1.14995e-19
C354	B1#2	a_796_368##2	5.35672e-19
C355	B1#2	Y#1	4.37615e-17
C356	B2	a_133_387##2	2.00483e-19
C357	VGND#9	A1_N#6	9.39306e-19
C358	VGND#6	A2_N#3	2.70756e-21
C359	B2#6	B2#4	4.87456e-17
C360	VPWR#3	VPWR#8	3.15443e-17
C361	a_796_368##2	B2#3	1.57772e-19
C362	VGND#5	a_134_74#	5.46689e-17
C363	VGND#5	A1_N#1	8.25159e-20
C364	Y#1	B2#3	6.747e-19
C365	a_133_387##10	A2_N#8	1.04181e-17
C366	a_133_387##2	B1#2	3.54491e-17
C367	VGND#9	a_133_387##4	3.87601e-17
C368	A2_N#8	A2_N#2	1.76847e-17
C369	VPWR#7	VPWR#3	2.45794e-19
C370	a_133_387##4	a_518_74#	2.55338e-17
C371	B2#4	B1#6	4.63634e-17
C372	a_133_387##9	A1_N#3	1.05519e-17
C373	a_133_387##4	Y#4	1.11001e-19
C374	VGND#6	a_134_74##2	1.04631e-16
C375	A1_N#4	VPWR#8	1.76999e-17
C376	VGND#5	A2_N#4	9.52156e-20
C377	a_133_387##10	A1_N#4	2.92094e-17
C378	B1#5	VPWR#1	3.48726e-18
C379	A1_N	A2_N#3	2.5289e-19
C380	VPWR#6	A1_N#7	5.96611e-20
C381	VPWR#3	VPWR#4	6.69899e-20
C382	VPWR#8	A2_N#6	2.28926e-18
C383	VPWR#7	A1_N#4	2.2223e-18
C384	a_133_387##9	A2_N#2	8.48438e-18
C385	VGND#6	a_133_387##12	6.00779e-20
C386	a_518_74##2	B1#2	2.75153e-17
C387	a_134_74##2	A2_N#3	2.22548e-19
C388	A2_N#8	a_133_387##13	2.08277e-17
C389	a_133_387##10	A2_N#6	3.88202e-17
C390	VGND#8	B1#2	4.9628e-19
C391	VPWR#8	A2_N#1	8.86372e-19
C392	A2_N#6	VPWR#7	2.84759e-17
C393	VPWR#5	A1_N#4	4.2234e-19
C394	VGND#4	VGND#6	4.99065e-17
C395	a_518_74##4	B1#2	3.84861e-18
C396	VGND#5	a_518_74#	7.09869e-18
C397	VGND#5	A2_N#5	5.10062e-18
C398	a_134_74##2	a_133_387##12	3.98076e-17
C399	a_133_387##10	A2_N#1	4.46913e-19
C400	a_133_387##9	A1_N#6	1.52507e-17
C401	VPWR#3	VPWR#1	4.35413e-17
C402	VPWR#8	A1_N#5	2.80415e-19
C403	A2_N#1	VPWR#7	2.85526e-17
C404	VPWR#5	A2_N#6	8.00763e-19
C405	a_133_387##10	A1_N#5	1.40667e-19
C406	a_134_74##2	a_134_74#	3.16804e-18
C407	B2#3	a_518_74##4	6.30748e-18
C408	a_133_387##13	A2_N#1	4.16935e-17
C409	A1_N#1	A2_N#4	3.66817e-17
C410	VPWR#7	A1_N#5	1.24588e-18
C411	VGND#5	A1_N#7	8.02974e-18
C412	a_133_387##9	a_133_387##4	2.33034e-18
C413	VPWR#5	A2_N#1	2.36881e-18
C414	VGND#4	a_518_74#	4.23573e-17
C415	a_133_387##9	a_133_387##10	7.67249e-18
C416	A1_N#5	a_133_387##13	1.63168e-17
C417	VGND#3	a_518_74##2	2.60056e-17
C418	a_134_74#	a_133_387##12	3.55967e-17
C419	VPWR#7	a_133_387##7	1.37552e-18
C420	A1_N#5	VPWR#5	3.30123e-17
C421	A2_N#4	A2_N#5	2.89308e-17
C422	VGND#4	a_518_74##2	2.18954e-17
C423	a_518_74##6	B1#5	2.90096e-18
C424	VGND#5	a_133_387##6	1.06804e-18
C425	VGND#5	A2_N#2	4.50741e-20
C426	VPWR#5	a_133_387##7	7.39771e-17
C427	A1_N#6	VPWR#6	5.99216e-18
C428	a_133_387##7	Y#3	1.26587e-17
C429	A2_N#5	A1_N#7	4.00051e-17
C430	B1#2	B2#9	2.62851e-17
C431	a_134_74#	VGND#9	4.24928e-17
C432	VPWR#5	a_133_387##5	2.89177e-18
C433	a_133_387##10	A2_N#3	1.37857e-17
C434	VPWR#4	a_133_387##7	2.05017e-18
C435	a_133_387##9	a_133_387##13	4.25912e-18
C436	B1#2	Y#2	1.89797e-17
C437	VGND#5	VGND#3	2.56306e-19
C438	VGND#5	VGND#8	2.53022e-20
C439	VGND#5	a_133_387#	1.93002e-19
C440	a_133_387##5	Y#3	6.24787e-18
C441	VPWR#5	B1#1	2.99617e-19
C442	VGND#3	a_518_74##4	6.85593e-18
C443	a_134_74#	A2_N#3	3.82056e-20
C444	B2#9	B2#3	1.275e-17
C445	A1_N#7	a_133_387##6	5.31264e-18
C446	a_133_387##5	VPWR#4	3.45676e-17
C447	Y#1	a_133_387##7	1.04506e-19
C448	VGND#3	B1#3	2.42315e-18
C449	a_796_368##2	a_133_387##5	1.02754e-18
C450	VGND#4	a_133_387##2	3.49107e-20
C451	B1#1	VPWR#4	3.07754e-17
C452	VGND#5	B1#3	2.46932e-20
C453	VGND#5	a_133_387##4	1.94617e-18
C454	Y#1	a_133_387##5	1.99855e-19
C455	VGND#9	a_518_74#	3.5351e-17
C456	B2#9	B1#5	1.79519e-18
C457	a_133_387##6	a_133_387#	3.90901e-17
C458	a_796_368##2	B1#1	4.29694e-17
C459	a_518_74##6	VPWR#1	4.59751e-18
C460	VPWR#4	B2#6	3.1393e-19
C461	VGND#3	B2#5	1.22302e-18
C462	Y#1	B1#1	7.45903e-18
C463	VPWR#7	A2_N#3	2.99247e-19
C464	VPWR#1	a_133_387##5	5.51467e-19
C465	VGND#3	B1#2	1.73562e-20
C466	a_796_368##2	B2#6	5.43923e-17
C467	VPWR#2	B2#3	5.27349e-20
C468	VGND#5	B2#5	1.48214e-20
C469	VPWR#4	B2#4	9.4065e-20
C470	a_133_387#	B1#3	3.35864e-17
C471	Y#1	B2#6	3.94264e-17
C472	VPWR#1	B1#1	4.87368e-19
C473	a_518_74#	Y#4	5.55689e-20
C474	a_796_368##2	B2#4	1.12821e-18
C475	a_796_368#	B2#6	1.61928e-18
C476	VPWR#4	B1#6	7.46677e-20
C477	VPWR#3	a_133_387##2	4.84844e-20
C478	VGND#3	B2#3	8.87976e-20
C479	B2#4	Y#1	2.45419e-17
C480	VPWR#1	B2#6	8.45227e-19
C481	VPWR#8	VPWR#6	4.39146e-19
C482	B1#3	B2#5	2.77175e-17
C483	a_518_74#	a_518_74##2	2.58387e-18
C484	a_796_368#	B2#4	6.12242e-17
C485	VPWR#5	Y#2	8.16796e-17
C486	Y#2	VPWR#3	1.26274e-17
C487	VPWR#1	B2#4	4.74782e-18
C488	a_796_368#	B1#6	5.32312e-17
C489	a_518_74##2	Y#4	3.18998e-19
C490	B2#5	B2#1	3.05787e-17
C491	B1#6	VPWR#1	3.61236e-17
C492	a_133_387##13	A1_N#7	1.33488e-18
C493	Y#2	Y#3	2.31177e-17
C494	a_133_387##9	A2_N#3	1.56485e-17
C495	VPWR#3	VPWR#2	6.22087e-17
C496	VGND#4	VGND#3	4.50595e-17
C497	a_518_74#	a_133_387##2	1.14666e-20
C498	VPWR#3	VPWR#6	5.30067e-17
C499	VGND#4	VGND#5	5.73687e-17
C500	B2#1	B1#4	3.49873e-17
C501	Y#2	VPWR#4	9.77272e-17
C502	a_518_74##2	VGND#8	5.67202e-17
C503	VGND#6	A1_N#1	3.05578e-17
C504	a_518_74##2	a_518_74##4	2.41701e-18
C505	a_134_74##2	A1_N#1	3.70869e-17
C506	A1_N#4	A2_N#3	3.31485e-18
C507	VGND#6	A2_N#4	6.59804e-18
C508	VGND#6	a_133_387##9	2.95154e-18
C509	a_133_387##12	A1_N#1	2.31078e-20
C510	a_518_74##4	VGND#8	4.46039e-17
C511	a_133_387##2	Y#4	2.6056e-19
C512	a_134_74##2	A2_N#4	4.65973e-17
C513	Y#2	Y#1	1.27699e-18
C514	VGND#2	B2#1	4.32995e-18
C515	VGND#3	VGND#2	1.52554e-18
C516	VGND#2	B2#5	6.17291e-19
C517	VGND#2	a_518_74##6	1.79876e-17
C518	VGND	VGND#2	4.5823e-17
C519	VGND#4	VGND#2	5.12383e-17
C520	VGND#2	B1#5	7.66236e-20
C521	VGND#2	a_518_74##4	6.86149e-18
C522	VGND#2	VNB	4.5465e-17
C523	VGND#2	B2#3	8.79903e-20
C524	VGND#8	VGND#2	6.48991e-20
C525	VGND#2	B1#4	4.09757e-18
*
*
.ENDS sky130_fd_sc_hs__o2bb2ai_2
*
