* Extracted by Quantus, converted by sky130cad/quantus.py
*
*
*
*                       LINUX           Wed Nov 18 08:16:55 2026
*
*
*
*  PROGRAM  advgen
*
*  Name           : advgen - Quantus - (64-bit)
*  Version        : 25.1.0-p047
*  Build Date     : Thu Dec 11 23:20:30 PST 2025
*
*  HSPICE LIBRARY
*
*  OPERATING_TEMPERATURE 150
*  QRC_TECH_DIR <path>/tech
*
*
*

*
.SUBCKT sky130_fd_sc_hs__and2b_4 VPB VNB VGND VPWR X B A_N
*
*
*  caps2d version: 10
*
*
*       TRANSISTOR CARDS
*
*
XM9 a_27_392##10 A_N#1 VGND#9 VNB sky130_fd_pr__nfet_01v8_lvt l=0.15 w=0.64 ad=0.1824 as=0.224 pd=1.85 ps=1.98
XM6 VGND#9 B#1 a_233_74##2 VNB sky130_fd_pr__nfet_01v8_lvt l=0.15 w=0.64 ad=0.224 as=0.224 pd=1.98 ps=1.98
XM1 a_233_74##2 a_27_392##5 a_218_424##17 VNB sky130_fd_pr__nfet_01v8_lvt l=0.15 w=0.64 ad=0.224 as=0.1792 pd=1.98 ps=1.84
XM13 a_218_424##17 a_27_392# a_233_74# VNB sky130_fd_pr__nfet_01v8_lvt l=0.15 w=0.64 ad=0.1792 as=0.192 pd=1.84 ps=1.88
XM7 a_233_74# B#3 VGND#8 VNB sky130_fd_pr__nfet_01v8_lvt l=0.15 w=0.64 ad=0.192 as=0.2394 pd=1.88 ps=2.15
XM3 X#4 a_218_424##6 VGND#8 VNB sky130_fd_pr__nfet_01v8_lvt l=0.15 w=0.74 ad=0.2146 as=0.2394 pd=2.06 ps=2.15
XM10 X#4 a_218_424##10 VGND#7 VNB sky130_fd_pr__nfet_01v8_lvt l=0.15 w=0.74 ad=0.2146 as=0.2331 pd=2.06 ps=2.11
XM12 VGND#7 a_218_424##8 X#6 VNB sky130_fd_pr__nfet_01v8_lvt l=0.15 w=0.74 ad=0.2331 as=0.2072 pd=2.11 ps=2.04
XM17 VGND#1 a_218_424##7 X#6 VNB sky130_fd_pr__nfet_01v8_lvt l=0.15 w=0.74 ad=0.2109 as=0.2072 pd=2.05 ps=2.04
XM14 a_27_392##9 A_N#3 VPWR#11 VPB sky130_fd_pr__pfet_01v8 l=0.15 w=1 ad=0.285 as=0.3556 pd=2.57 ps=2.74
XM4 a_218_424##16 a_27_392##4 VPWR#11 VPB sky130_fd_pr__pfet_01v8 l=0.15 w=0.84 ad=0.252 as=0.3556 pd=2.28 ps=2.74
XM15 VPWR#10 a_27_392##6 a_218_424##16 VPB sky130_fd_pr__pfet_01v8 l=0.15 w=0.84 ad=0.3108 as=0.252 pd=2.42 ps=2.28
XM5 VPWR#10 B#6 a_218_424##18 VPB sky130_fd_pr__pfet_01v8 l=0.15 w=0.84 ad=0.3108 as=0.252 pd=2.42 ps=2.28
XM16 a_218_424##18 B#7 VPWR#9 VPB sky130_fd_pr__pfet_01v8 l=0.15 w=0.84 ad=0.252 as=0.385 pd=2.28 ps=2.98
XM11 VPWR#9 a_218_424##12 X#5 VPB sky130_fd_pr__pfet_01v8 l=0.15 w=1.12 ad=0.385 as=0.336 pd=2.98 ps=2.84
XM2 X#5 a_218_424##11 VPWR#8 VPB sky130_fd_pr__pfet_01v8 l=0.15 w=1.12 ad=0.336 as=0.336 pd=2.84 ps=2.84
XM8 VPWR#8 a_218_424##9 X#1 VPB sky130_fd_pr__pfet_01v8 l=0.15 w=1.12 ad=0.336 as=0.336 pd=2.84 ps=2.84
XM0 X#1 a_218_424# VPWR#1 VPB sky130_fd_pr__pfet_01v8 l=0.15 w=1.12 ad=0.336 as=0.3192 pd=2.84 ps=2.81
*
*
*       RESISTOR AND CAP/DIODE CARDS
*
Rg1	A_N#1	A_N#2	504.941498
Rg2	A_N#2	A_N#3	426.054413
Rg3	B#1	B#2	414.102173
Rg4	a_27_392#	a_27_392##2	363.369934
Rg5	a_27_392##2	a_27_392##3	335.485992
Rg6	a_27_392##3	a_27_392##4	508.246948
Rg7	a_27_392##2	a_27_392##5	273.732178
Rg8	a_27_392##3	a_27_392##6	297.320953
Rg9	B#3	B#4	377.278778
Rg10	B#4	B#5	266.445984
Rg11	B#5	B#6	465.695831
Rg12	B#5	B#7	310.641998
Rg13	a_218_424#	a_218_424##2	581.298645
Rg14	a_218_424##2	a_218_424##3	222.632965
Rg15	a_218_424##3	a_218_424##4	99.550926
Rg16	a_218_424##4	a_218_424##5	61.522610
Rg17	a_218_424##5	a_218_424##6	434.623047
Rg18	a_218_424##2	a_218_424##7	280.275299
Rg19	a_218_424##3	a_218_424##8	403.580872
Rg20	a_218_424##3	a_218_424##9	563.692139
Rg21	a_218_424##4	a_218_424##10	365.205750
Rg22	a_218_424##4	a_218_424##11	447.845673
Rg23	a_218_424##5	a_218_424##12	517.262939
Rf1	A_N#2	A_N#5	161.093033
Rf2	A_N#6	A_N	0.860229
Rf3	A_N#5	A_N#6	5.511418
Rf4	a_27_392##2	a_27_392##8	241.975586
Rf5	a_27_392##8	a_27_392##9	89.426018
Rf6	a_27_392##8	a_27_392##10	22.283579
Rf7	a_233_74#	a_233_74##2	74.096886
Rf8	B#8	B	6.901752
Rf9	B	B#2	236.325897
Rf10	B	B#8	6.764860
Rf11	a_218_424##4	a_218_424##14	71.539566
Rf12	a_218_424##14	a_218_424##15	82.117455
Rf13	a_218_424##15	a_218_424##16	91.279800
Rf14	a_218_424##14	a_218_424##17	132.936737
Rf15	a_218_424##15	a_218_424##18	23.661278
Rf16	X#1	X#2	41.258038
Rf17	X#2	X	65.042488
Rf18	X	X#3	45.741325
Rf19	X#3	X#4	88.968834
Rf20	X#2	X#5	97.014999
Rf21	X#3	X#6	19.806370
Rf22	VPWR#1	VPWR#2	100.350525
Rf23	VPWR#2	VPWR#3	65.696381
Rf24	VPWR#3	VPWR#4	24.082130
Rf25	VPWR#4	VPWR#5	48.976646
Rf26	VPWR#5	VPWR#6	73.789284
Rf28	VPWR#2	VPWR#8	34.093605
Rf29	VPWR#3	VPWR#9	31.337896
Rf30	VPWR#5	VPWR#10	38.480759
Rf31	VPWR#6	VPWR#11	35.274624
Rf32	VGND#1	VGND#2	101.744965
Rf33	VGND#2	VGND#3	61.005447
Rf34	VGND#3	VGND#4	24.447384
Rf35	VGND#4	VGND#5	111.377472
Rf37	VGND#2	VGND#7	43.678436
Rf38	VGND#3	VGND#8	31.358114
Rf39	VGND#5	VGND#9	30.353714
Rf42	B#4	B#8	160.232803
Re1	VPWR#4	VPWR	0.982218
Re2	VGND	VGND#4	0.982254
*
*       CAPACITOR CARDS
*
*
C1	X#3	VGND#7	1.72349e-17
C2	X#4	X#3	2.05541e-19
C3	VPWR#3	a_218_424##5	7.52006e-21
C4	a_218_424##14	VGND#7	3.08377e-18
C5	a_27_392##3	B#6	1.03615e-17
C6	a_27_392##8	A_N#5	4.8967e-17
C7	a_218_424##14	X#4	7.92104e-17
C8	VPWR#5	a_27_392##3	4.71277e-20
C9	a_218_424##14	VGND#8	4.02635e-17
C10	VPWR#2	a_218_424##3	2.03045e-20
C11	VPWR#2	a_218_424##2	2.00338e-20
C12	VPWR#2	VPWR#1	1.22366e-18
C13	VPWR#8	a_218_424##3	3.86568e-19
C14	X#1	VPWR#2	1.05368e-17
C15	X#5	a_218_424##5	5.32413e-19
C16	X#2	VPWR#1	2.68567e-17
C17	X#6	VGND#1	3.99411e-17
C18	X#5	VPWR#3	5.25841e-18
C19	X#3	a_218_424##3	1.09584e-17
C20	VPWR#5	VPWR#9	2.20328e-19
C21	VGND#7	VGND#1	7.07923e-19
C22	A_N#3	a_27_392##3	1.33674e-18
C23	X#2	X#1	4.4293e-18
C24	X#5	VPWR#2	5.46932e-18
C25	VGND#7	X#6	3.21619e-17
C26	X#3	a_218_424##2	6.0546e-18
C27	a_218_424##18	VPWR#5	1.85275e-18
C28	X#2	VPWR#8	2.90411e-17
C29	X#2	a_218_424##5	4.36846e-20
C30	VGND#9	a_27_392##8	3.01989e-17
C31	X#4	X#6	2.23677e-18
C32	X#5	X#2	1.91926e-18
C33	X#2	a_218_424##3	8.99177e-18
C34	a_218_424##14	VPWR#8	2.35532e-18
C35	X#4	VGND#7	4.28362e-17
C36	a_218_424##16	VPWR#5	8.51009e-18
C37	X#2	a_218_424##2	5.63459e-18
C38	VGND#8	VGND#7	8.27175e-19
C39	a_218_424##14	X#5	6.61233e-17
C40	a_218_424##15	VPWR#9	1.96117e-17
C41	VGND#8	X#4	2.01691e-17
C42	VPWR#11	VPWR#5	2.16835e-19
C43	a_218_424##14	VPWR#9	1.5988e-17
C44	VPWR#4	B#5	9.52158e-20
C45	VGND#2	a_218_424##7	9.65446e-19
C46	a_218_424##15	a_218_424##18	7.58675e-21
C47	B#5	a_218_424##18	9.59645e-19
C48	a_233_74#	VGND#8	2.46145e-17
C49	a_218_424##15	VPWR#10	1.43284e-17
C50	VGND#2	a_218_424##8	8.5598e-18
C51	a_218_424##14	a_218_424##5	1.47639e-17
C52	a_233_74##2	X#4	8.2442e-19
C53	a_218_424##15	B#5	1.20764e-17
C54	VGND#4	B#5	2.92971e-20
C55	a_218_424##14	a_218_424##3	1.13434e-17
C56	VGND#2	a_218_424##10	5.8286e-18
C57	a_233_74#	a_218_424##17	5.53796e-17
C58	VGND#3	a_218_424##6	3.2192e-18
C59	a_218_424##14	a_218_424##2	4.39894e-19
C60	VGND#2	a_218_424##6	7.47844e-19
C61	VGND#9	VGND#8	1.62609e-19
C62	a_218_424##5	a_218_424##4	4.21538e-18
C63	a_27_392##3	VPWR#10	4.47596e-18
C64	a_218_424##4	a_218_424##3	4.24461e-18
C65	X#3	a_218_424##7	1.19968e-17
C66	a_233_74##2	a_218_424##17	3.27374e-17
C67	a_218_424##14	B#5	4.46096e-19
C68	X#3	a_218_424##8	1.36337e-17
C69	a_218_424##14	a_27_392##3	2.42228e-19
C70	VGND#9	a_233_74##2	5.30907e-17
C71	X#3	a_218_424##10	8.01245e-20
C72	B#4	a_218_424##5	3.40956e-17
C73	a_27_392##8	VPWR#11	4.43376e-18
C74	a_218_424##16	a_27_392##3	1.23989e-17
C75	B#4	B#5	6.52892e-18
C76	a_27_392##3	B#4	5.79648e-19
C77	a_27_392##8	a_27_392##9	4.69125e-18
C78	X#3	a_218_424##6	1.65501e-20
C79	a_27_392##10	VGND#9	5.32253e-17
C80	a_218_424##14	a_218_424##10	7.48225e-19
C81	A_N#5	VPWR#11	7.06459e-18
C82	a_218_424##14	a_218_424##6	1.03833e-17
C83	a_27_392##2	a_27_392##3	1.05264e-18
C84	a_218_424##14	B#3	1.1302e-17
C85	X#1	VPWR#1	6.03041e-17
C86	a_27_392##9	B#5	3.5326e-20
C87	a_218_424##14	a_27_392#	3.54457e-19
C88	VPWR#8	VPWR#1	2.06271e-18
C89	VGND#1	a_218_424##7	3.04838e-17
C90	a_27_392##9	a_27_392##3	2.18511e-19
C91	a_218_424##7	X#6	1.30016e-17
C92	VPWR#8	X#1	5.97784e-17
C93	a_218_424##14	a_27_392##5	1.70151e-19
C94	VGND#1	a_218_424##8	2.52276e-18
C95	B#2	a_27_392##3	2.28027e-17
C96	VGND#7	a_218_424##7	1.93819e-19
C97	X#5	X#1	1.32013e-19
C98	X#6	a_218_424##8	3.14881e-17
C99	VGND#1	a_218_424##10	3.21026e-19
C100	a_218_424##14	B#1	1.12248e-19
C101	a_218_424##8	VGND#7	1.44043e-17
C102	X#5	VPWR#8	6.34343e-17
C103	X#6	a_218_424##10	1.75191e-18
C104	X#4	a_218_424##8	3.69653e-19
C105	VPWR#9	VPWR#8	2.06267e-18
C106	VGND#7	a_218_424##10	2.8813e-17
C107	a_218_424##14	A_N#1	1.02e-19
C108	a_27_392##8	B#5	8.90214e-20
C109	X#6	a_218_424##6	1.80103e-19
C110	A_N#2	a_27_392##3	1.7969e-18
C111	X#4	a_218_424##10	2.4864e-17
C112	VPWR#9	X#5	5.13401e-17
C113	VGND#3	VGND#2	1.13266e-18
C114	VGND#7	a_218_424##6	9.66444e-19
C115	a_27_392##8	B#1	2.20716e-18
C116	VPWR#2	a_218_424##9	1.85655e-18
C117	VGND#8	a_218_424##10	1.837e-18
C118	X#2	a_218_424#	1.26474e-17
C119	a_218_424##18	X#5	3.78323e-18
C120	a_218_424##6	X#4	1.96674e-17
C121	a_27_392##8	A_N#1	1.44377e-17
C122	VGND#8	a_218_424##6	3.10714e-17
C123	a_218_424##18	VPWR#9	5.55954e-17
C124	a_218_424##14	a_218_424#	4.32241e-19
C125	VPWR#2	a_218_424##11	1.85935e-18
C126	X#2	a_218_424##9	1.61713e-17
C127	X#4	B#3	3.52708e-19
C128	VPWR#5	a_218_424##12	8.68423e-20
C129	a_233_74#	a_218_424##6	5.44428e-19
C130	VPWR#10	VPWR#9	2.12318e-18
C131	a_218_424##10	a_218_424##3	2.38895e-18
C132	B#3	VGND#8	1.70386e-17
C133	VPWR#3	a_218_424##12	3.32431e-18
C134	a_233_74##2	a_218_424##10	8.3764e-20
C135	a_218_424##14	a_218_424##9	1.34531e-20
C136	X#4	a_27_392#	1.73162e-19
C137	VPWR#10	a_218_424##18	5.47262e-17
C138	X#2	a_218_424##11	4.53049e-18
C139	a_233_74#	B#3	2.72508e-17
C140	VPWR#5	B#7	3.12753e-19
C141	a_233_74##2	a_218_424##6	1.26785e-19
C142	VGND#8	a_27_392#	6.98453e-19
C143	a_218_424##17	B#3	1.0019e-17
C144	X#4	a_27_392##5	1.00449e-19
C145	a_218_424##16	a_218_424##18	4.55486e-18
C146	a_218_424##14	a_218_424##11	4.80711e-19
C147	a_233_74#	a_27_392#	3.25358e-17
C148	VGND#9	a_218_424##6	9.60207e-20
C149	X#2	a_218_424##12	1.63419e-19
C150	a_233_74##2	B#3	2.13742e-19
C151	VGND#8	a_27_392##5	2.6979e-19
C152	a_218_424##3	a_218_424##2	9.92092e-18
C153	B#5	a_218_424##5	5.70164e-19
C154	a_218_424##16	VPWR#10	6.2571e-17
C155	a_218_424##17	a_27_392#	2.7323e-17
C156	VPWR#5	B#6	7.02767e-18
C157	X#4	B#1	7.36716e-20
C158	VGND#9	B#3	1.33019e-19
C159	a_218_424##14	a_218_424##12	7.97065e-18
C160	a_233_74##2	a_27_392#	4.36378e-19
C161	VPWR#11	VPWR#10	2.09311e-18
C162	VGND#8	B#1	1.32181e-19
C163	a_27_392##10	B#3	1.0923e-19
C164	a_218_424##17	a_27_392##5	1.91644e-17
C165	VGND#9	a_27_392#	2.6979e-19
C166	VPWR#5	a_27_392##6	5.32342e-18
C167	a_218_424##15	B#7	1.3489e-17
C168	VPWR#11	a_218_424##16	7.68887e-17
C169	a_233_74##2	a_27_392##5	4.72312e-17
C170	a_27_392##10	a_27_392#	1.37786e-19
C171	a_218_424##17	B#1	4.44055e-19
C172	VGND#9	a_27_392##5	2.40979e-18
C173	a_27_392##9	a_218_424##16	4.54465e-18
C174	B#1	a_233_74##2	1.31644e-17
C175	a_218_424##15	B#6	1.99555e-17
C176	VPWR#5	a_27_392##4	3.00046e-19
C177	a_27_392##10	a_27_392##5	2.85748e-19
C178	a_27_392##9	VPWR#11	6.70912e-17
C179	VGND#9	B#1	3.94701e-17
C180	a_27_392##10	B#1	1.48642e-18
C181	A_N#1	VGND#9	1.899e-17
C182	VPWR#5	A_N#3	1.26083e-19
C183	a_27_392##10	A_N#1	3.14167e-17
C184	a_218_424##8	a_218_424##7	3.68278e-17
C185	VPWR#5	VPWR#3	8.63841e-19
C186	VGND#2	X#3	3.96513e-19
C187	VPWR#4	VPWR#5	3.36639e-17
C188	VGND#4	VGND#3	2.59904e-17
C189	VPWR#1	a_218_424#	5.21818e-17
C190	a_27_392##8	a_27_392##4	4.02475e-19
C191	VPWR#4	VPWR#3	2.6241e-17
C192	a_218_424##10	a_218_424##8	2.90323e-17
C193	VGND#4	VGND#2	4.20327e-17
C194	a_218_424#	X#1	1.83629e-17
C195	VPWR#4	VPWR#2	4.13877e-17
C196	VPWR#1	a_218_424##9	3.32348e-18
C197	VPWR#8	a_218_424#	2.9512e-18
C198	a_218_424##9	X#1	2.54441e-17
C199	VGND#3	a_218_424##4	2.08671e-20
C200	X#5	a_218_424#	1.68241e-19
C201	a_218_424##6	a_218_424##10	3.89956e-17
C202	VGND#2	a_218_424##4	4.89574e-20
C203	VPWR#8	a_218_424##9	5.56854e-17
C204	a_218_424##15	VPWR#4	1.09389e-18
C205	VPWR#3	VPWR#2	1.22166e-18
C206	a_233_74#	B#6	4.61284e-20
C207	X#1	a_218_424##11	2.41831e-20
C208	X#5	a_218_424##9	3.75768e-19
C209	A_N	a_27_392##3	1.97441e-19
C210	VGND#3	a_218_424##14	4.89384e-19
C211	a_218_424##17	B#6	9.03942e-19
C212	VPWR#8	a_218_424##11	4.86727e-17
C213	B#3	a_218_424##6	2.82542e-17
C214	VPWR#3	a_218_424##4	1.27157e-20
C215	X#1	a_218_424##12	1.04315e-20
C216	X#5	a_218_424##11	5.58045e-17
C217	VPWR#2	a_218_424##4	2.02358e-20
C218	VGND#4	a_218_424##14	6.77496e-20
C219	VPWR#8	a_218_424##12	2.34186e-18
C220	VPWR#9	a_218_424##11	2.11591e-18
C221	X#3	a_218_424##4	1.52607e-18
C222	X#5	a_218_424##12	1.62181e-17
C223	X#2	a_218_424##4	1.20812e-18
C224	a_27_392#	B#3	3.33992e-17
C225	a_218_424##18	a_218_424##11	3.25444e-19
C226	VPWR#9	a_218_424##12	5.3766e-17
C227	a_27_392##3	B#5	8.09132e-19
C228	a_218_424##14	a_218_424##4	1.88444e-17
C229	X#5	B#7	6.38512e-19
C230	a_218_424##18	a_218_424##12	1.8818e-18
C231	B	B#5	2.02373e-18
C232	B#7	VPWR#9	2.01229e-17
C233	VGND#9	a_27_392##4	4.9692e-19
C234	a_27_392##5	a_27_392#	3.40358e-17
C235	VPWR#10	a_218_424##12	1.75416e-19
C236	B#4	a_218_424##15	3.12316e-17
C237	a_218_424##18	B#7	4.9217e-17
C238	VGND#7	a_218_424##3	7.54427e-19
C239	a_218_424##14	B#4	7.32796e-17
C240	VPWR#9	B#6	7.14937e-19
C241	a_218_424##15	VPWR#5	1.02925e-18
C242	VPWR#10	B#7	3.83133e-19
C243	VGND#4	VGND#1	2.72657e-17
C244	a_218_424##18	B#6	4.23415e-17
C245	B#1	a_27_392##5	2.5982e-17
C246	a_218_424##15	a_27_392##2	1.14146e-18
C247	VPWR#9	a_27_392##6	2.7403e-19
C248	B#6	VPWR#10	2.1799e-17
C249	a_27_392##2	a_218_424##14	3.9592e-18
C250	a_218_424##18	a_27_392##6	1.86209e-18
C251	X#2	VPWR#2	2.60402e-19
C252	a_218_424##16	B#6	1.89047e-18
C253	A_N#1	B#1	2.85639e-17
C254	a_27_392##6	VPWR#10	2.57744e-17
C255	X#4	a_218_424##5	2.31117e-18
C256	X	a_218_424##5	3.81757e-20
C257	VPWR#11	B#6	2.74605e-19
C258	X	a_218_424##3	1.5206e-19
C259	X	a_218_424##2	1.09731e-17
C260	VGND#4	a_233_74#	2.81326e-17
C261	VGND#7	a_218_424##4	4.77334e-19
C262	a_218_424##16	a_27_392##6	5.8037e-17
C263	a_27_392##8	a_27_392##2	1.37815e-18
C264	VGND#4	a_218_424##17	1.25076e-18
C265	X#4	a_218_424##4	3.19849e-18
C266	VPWR#10	a_27_392##4	3.71054e-19
C267	VPWR#11	a_27_392##6	1.27657e-18
C268	VGND#4	a_233_74##2	6.58551e-18
C269	a_218_424##14	VPWR#3	3.08454e-19
C270	VPWR#4	VPWR#1	2.71908e-17
C271	a_218_424##16	a_27_392##4	4.96889e-17
C272	VPWR#10	A_N#3	2.49813e-19
C273	VPWR#11	a_27_392##4	1.77252e-17
C274	a_27_392##8	B#2	1.10837e-17
C275	a_218_424##16	A_N#3	2.4828e-18
C276	VGND#8	B#4	4.62218e-19
C277	a_27_392##9	a_27_392##4	1.33138e-18
C278	X#3	X#2	1.97608e-17
C279	B#4	a_233_74#	1.14233e-18
C280	VPWR#11	A_N#3	5.31735e-17
C281	a_218_424##17	B#4	1.67178e-17
C282	a_27_392##9	A_N#3	2.53121e-17
C283	a_218_424##18	VPWR#4	1.45117e-17
C284	a_27_392##8	A_N#2	2.3876e-17
C285	a_218_424##9	a_218_424#	4.81807e-17
C286	a_233_74#	a_27_392##2	2.2844e-19
C287	VPWR	B#5	5.91745e-21
C288	VPWR	a_27_392##3	1.2953e-22
C289	VPWR#8	a_218_424##4	3.91792e-19
C290	a_27_392##2	a_218_424##17	3.3936e-17
C291	X#5	a_218_424##4	2.3523e-18
C292	A_N#5	A_N#2	1.13985e-17
C293	a_233_74##2	a_27_392##2	4.13584e-17
C294	VGND#9	a_27_392##2	8.41204e-18
C295	a_218_424##11	a_218_424##9	4.71395e-17
C296	X#3	a_218_424##14	2.75745e-17
C297	a_233_74##2	B#2	7.66417e-19
C298	VPWR#9	B#4	1.0006e-18
C299	a_218_424##12	a_218_424##11	4.82117e-17
C300	VGND#9	A_N#2	4.90718e-19
C301	a_218_424##14	X#2	5.13776e-17
C302	VGND#3	a_218_424##5	2.85772e-20
C303	VGND	a_218_424##5	4.82317e-20
C304	VGND	a_218_424##3	4.34789e-19
C305	B#7	a_218_424##12	2.66902e-17
C306	VPWR#10	a_27_392##2	7.60696e-19
C307	VGND#4	B#3	4.87945e-18
C308	a_218_424##3	a_218_424#	7.27829e-18
C309	VGND#4	a_27_392#	5.16756e-18
C310	B#6	B#7	3.60384e-17
C311	a_218_424##14	a_218_424##15	2.00988e-18
C312	B#2	a_218_424##16	5.53321e-17
C313	B#4	a_218_424##6	4.15007e-18
C314	a_27_392##6	B#6	2.70675e-17
C315	a_27_392##2	a_218_424##6	3.15802e-19
C316	VPWR#11	A_N#2	3.6123e-18
C317	a_27_392##2	B#3	5.39581e-19
C318	a_27_392##9	A_N#2	1.55005e-18
C319	a_27_392##8	A_N	1.34072e-17
C320	a_27_392##2	a_27_392#	3.64974e-18
C321	a_27_392##4	a_27_392##6	3.60865e-17
C322	VGND#2	VGND#1	1.83877e-18
C323	a_233_74#	B#5	9.13341e-20
C324	a_218_424##5	VNB	2.28229e-17
C325	a_218_424##3	VNB	3.53547e-17
C326	a_218_424##2	VNB	2.57764e-17
C327	B#5	VNB	1.99409e-17
C328	B	a_218_424##15	4.70215e-17
C329	a_27_392##3	VNB	2.66946e-17
C330	a_27_392##2	B#1	1.23367e-17
C331	VPWR#4	B#7	7.6192e-18
C332	A_N#3	a_27_392##4	3.54201e-17
C333	VPWR#4	B#6	1.44986e-20
C334	A_N#1	B#2	1.51831e-18
C335	VGND#4	B#6	1.47965e-20
C336	X#3	X	2.76179e-18
C337	VGND#2	X#6	1.36907e-17
C338	VGND#2	a_218_424##3	7.28447e-20
C339	B#4	a_218_424##12	4.70596e-19
C340	a_218_424##14	X	3.67671e-18
C341	VPWR	VPWR#5	3.77781e-17
C342	a_218_424##17	B	1.72283e-17
C343	VPWR	VPWR#3	1.573e-17
C344	VPWR	VPWR#2	2.35431e-17
C345	a_27_392##2	B#6	3.18239e-18
C346	X	VGND#1	3.12603e-17
C347	VPWR	X#2	2.97241e-18
C348	VPWR	a_218_424##15	6.53707e-18
C349	VPWR	a_218_424##14	5.90424e-18
C350	VGND#2	a_218_424##2	6.34177e-20
C351	a_218_424##17	B#5	2.17668e-19
C352	A_N	VPWR#11	1.05605e-17
C353	VGND#3	X#4	4.87739e-18
C354	VGND	VGND#3	1.50221e-17
C355	VGND	VGND#2	3.93626e-17
C356	B#2	a_27_392##4	2.17794e-17
C357	VPWR	A_N#5	2.07068e-18
C358	X	VPWR#1	3.31515e-17
C359	B	a_218_424##16	4.21341e-18
C360	VGND#4	B#4	9.91885e-20
C361	VGND	X#3	2.74189e-18
C362	VGND	X#2	3.14348e-18
C363	VGND	a_218_424##14	9.65204e-18
C364	VGND#4	a_27_392##2	1.6574e-19
C365	VGND#2	X#4	5.87495e-18
C366	VGND	a_27_392##8	2.06023e-18
C367	VPWR	VPWR#1	4.02803e-17
C368	VGND	A_N#5	1.61039e-18
C369	VPWR	X#1	1.18323e-17
C370	a_27_392##2	B#4	1.87552e-17
C371	VGND#3	VNB	2.03158e-17
C372	VGND	VGND#1	3.97205e-17
C373	VPWR	VPWR#8	2.17874e-17
C374	VGND#2	VNB	3.29492e-17
C375	VGND	X#6	1.37718e-17
C376	VPWR	X#5	1.19302e-17
C377	VPWR#5	VNB	2.56853e-17
C378	VPWR	VPWR#9	2.1324e-17
C379	VGND	X#4	1.16678e-17
C380	B#2	B#4	1.52817e-19
C381	VPWR#3	VNB	2.04755e-17
C382	VGND	VGND#8	1.61803e-17
C383	VPWR	a_218_424##18	1.58153e-17
C384	VPWR#2	VNB	3.09032e-17
C385	VGND	a_233_74#	1.79671e-17
C386	X#3	VNB	7.82078e-19
C387	VGND	a_218_424##17	8.79113e-18
C388	X#2	VNB	2.37344e-18
C389	VPWR	a_218_424##16	1.70994e-17
C390	a_27_392##2	B#2	9.46479e-17
C391	VGND	a_233_74##2	2.0026e-17
C392	a_218_424##15	VNB	1.58656e-18
C393	VPWR	VPWR#11	2.08292e-17
C394	a_218_424##14	VNB	2.32424e-18
C395	VGND	VGND#9	2.29018e-17
C396	VGND	a_27_392##10	2.05319e-17
C397	VPWR	a_27_392##9	1.43955e-17
C398	VGND	VPWR#1	2.1678e-18
C399	a_27_392##2	A_N#2	8.10337e-20
C400	a_27_392##8	VNB	4.14638e-17
C401	VGND#8	VGND#2	1.27543e-18
C402	A_N#2	B#2	3.26964e-17
C403	A_N#5	VNB	1.4844e-18
C404	VGND#1	VNB	5.23887e-17
C405	X#6	VNB	2.37153e-18
C406	X	a_218_424#	4.85676e-18
C407	VGND#7	VNB	1.40002e-19
C408	X#4	VNB	4.93102e-18
C409	B	B#6	5.5545e-18
C410	VGND#8	VNB	1.27511e-18
C411	a_233_74#	VNB	3.04651e-18
C412	a_233_74##2	VNB	3.44549e-18
C413	VGND	a_218_424##7	1.6553e-18
C414	VGND#9	VNB	1.98685e-18
C415	VGND	a_218_424##8	7.91024e-21
C416	a_27_392##10	VNB	3.71554e-17
C417	VGND	a_218_424##10	6.28659e-19
C418	VPWR#1	VNB	8.43213e-17
C419	VPWR	a_218_424#	2.28744e-18
C420	X#1	VNB	4.7183e-18
C421	VPWR#8	VNB	2.18818e-19
C422	VGND	B#3	1.47701e-18
C423	VPWR	a_218_424##9	1.17314e-18
C424	X#5	VNB	4.85267e-18
C425	VGND	a_27_392#	9.23768e-19
C426	VPWR#9	VNB	1.14086e-18
C427	VPWR	a_218_424##11	1.2514e-18
C428	a_218_424##18	VNB	2.1411e-18
C429	VGND	a_27_392##5	8.73101e-19
C430	VPWR	a_218_424##12	3.51651e-18
C431	VPWR#10	VNB	3.0396e-18
C432	VGND	B#1	5.483e-19
C433	a_218_424##16	VNB	3.48783e-18
C434	VPWR	B#7	1.60409e-18
C435	VGND	A_N#1	8.89895e-19
C436	VPWR#11	VNB	5.67818e-18
C437	a_233_74##2	a_27_392##3	4.56429e-19
C438	a_27_392##9	VNB	5.40469e-17
C439	VPWR	B#6	1.98693e-18
C440	a_218_424##7	VNB	2.96973e-17
C441	VPWR	a_27_392##6	7.83967e-19
C442	a_218_424##8	VNB	2.62958e-17
C443	A_N	B#2	3.40022e-17
C444	a_218_424##10	VNB	2.48655e-17
C445	VPWR	a_27_392##4	3.2831e-18
C446	a_218_424##6	VNB	2.8034e-17
C447	B#3	VNB	2.61088e-17
C448	VPWR	A_N#3	2.1822e-18
C449	B	a_27_392##2	5.46437e-17
C450	A_N	A_N#2	6.34752e-18
C451	a_27_392#	VNB	2.78385e-17
C452	X	a_218_424##4	6.51271e-20
C453	a_27_392##5	VNB	2.57047e-17
C454	B#2	B	2.97994e-18
C455	B#1	VNB	2.9747e-17
C456	VPWR	VPWR#4	1.17313e-17
C457	A_N#1	VNB	4.03176e-17
C458	X#3	VGND#1	3.51263e-18
C459	a_218_424#	VNB	4.90788e-17
C460	B#5	a_218_424##12	1.07584e-17
C461	a_218_424##9	VNB	2.95729e-17
C462	a_218_424##11	VNB	2.97651e-17
C463	VPWR	B#4	2.11344e-18
C464	a_218_424##12	VNB	3.23309e-17
C465	B#7	VNB	3.03825e-17
C466	B#6	VNB	4.31601e-17
C467	VGND	VGND#4	2.04728e-17
C468	VPWR	B#2	3.96707e-18
C469	a_27_392##6	VNB	2.76179e-17
C470	a_27_392##4	VNB	4.17721e-17
C471	VPWR	A_N#2	7.52286e-21
C472	VGND	B#4	2.90476e-18
C473	A_N#3	VNB	3.91567e-17
C474	VGND	a_27_392##2	5.0598e-18
C475	VPWR#4	VNB	2.1378e-16
C476	VGND	B#2	2.78941e-18
C477	VGND#4	VNB	2.28021e-16
C478	a_218_424##4	VNB	3.92963e-17
C479	B#4	VNB	3.60055e-17
C480	a_27_392##2	VNB	4.83222e-17
C481	B#2	VNB	3.12749e-17
C482	VPWR	A_N	1.30215e-18
C483	A_N#2	VNB	5.27164e-17
C484	VPWR	B	2.60699e-18
C485	VGND	A_N	1.18013e-18
C486	VPWR	X	2.02253e-18
C487	VGND	B	3.69761e-18
C488	A_N	VNB	7.4411e-19
C489	VGND	X	2.72791e-18
C490	B	VNB	9.97853e-18
C491	X#3	X#6	7.54504e-19
C492	X	VNB	3.70647e-17
C493	VPWR	VNB	6.41229e-17
C494	VGND	VNB	6.48418e-17
C495	VGND	VGND#5	4.35399e-17
C496	VPWR#6	A_N#3	4.39965e-18
C497	VGND#5	a_27_392##5	5.16885e-18
C498	a_218_424##16	VPWR#6	8.28153e-18
C499	VPWR	VPWR#6	3.64697e-17
C500	A_N#5	VPWR#6	4.4824e-19
C501	VGND#5	VNB	6.23552e-17
C502	VGND#5	B#1	3.77936e-18
C503	VPWR#6	a_27_392##3	2.32833e-20
C504	VGND#5	a_27_392##3	7.18485e-20
C505	VGND#5	a_27_392##2	3.34698e-19
C506	VGND#5	a_233_74##2	2.33394e-17
C507	VGND#5	A_N#1	2.76321e-18
C508	VGND#5	a_27_392##8	1.97623e-19
C509	VPWR#6	VPWR#5	8.49538e-19
C510	VGND#5	B#2	5.26725e-20
C511	VGND#4	VGND#5	7.13566e-17
C512	VPWR#6	a_27_392##4	5.27279e-18
C513	B#2	VPWR#6	9.71049e-19
C514	VPWR#4	VPWR#6	5.35723e-17
C515	a_27_392##9	VPWR#6	1.8558e-17
C516	VPWR#6	VNB	4.79209e-17
C517	VGND#5	A_N#2	3.88782e-20
C518	VGND#5	VGND#3	1.9812e-19
C519	VGND#5	a_27_392##10	2.69703e-17
*
*
.ENDS sky130_fd_sc_hs__and2b_4
*
