* Extracted by Quantus, converted by sky130cad/quantus.py
*
*
*
*                       LINUX           Wed Nov 18 08:46:21 2026
*
*
*
*  PROGRAM  advgen
*
*  Name           : advgen - Quantus - (64-bit)
*  Version        : 25.1.0-p047
*  Build Date     : Thu Dec 11 23:20:30 PST 2025
*
*  HSPICE LIBRARY
*
*  OPERATING_TEMPERATURE 150
*  QRC_TECH_DIR <path>/tech
*
*
*

*
.SUBCKT sky130_fd_sc_hs__nand3b_1 VPB VNB VGND VPWR Y A_N C B
*
*
*  caps2d version: 10
*
*
*       TRANSISTOR CARDS
*
*
XM3 a_27_116##6 A_N#3 VGND#4 VNB sky130_fd_pr__nfet_01v8_lvt l=0.15 w=0.55 ad=0.15675 as=0.44825 pd=1.67 ps=2.73
XM5 VGND#4 C#1 a_269_78# VNB sky130_fd_pr__nfet_01v8_lvt l=0.15 w=0.74 ad=0.44825 as=0.1776 pd=2.73 ps=1.96
XM4 a_269_78# B#3 a_347_78# VNB sky130_fd_pr__nfet_01v8_lvt l=0.15 w=0.74 ad=0.1776 as=0.2886 pd=1.96 ps=2.26
XM6 a_347_78# a_27_116##3 Y#1 VNB sky130_fd_pr__nfet_01v8_lvt l=0.15 w=0.74 ad=0.2886 as=0.3404 pd=2.26 ps=2.4
XM1 a_27_116##7 A_N#1 VPWR#7 VPB sky130_fd_pr__pfet_01v8 l=0.15 w=0.84 ad=0.2478 as=0.462 pd=2.27 ps=3.11
XM2 VPWR#7 C#3 Y#2 VPB sky130_fd_pr__pfet_01v8 l=0.15 w=1.12 ad=0.462 as=0.336 pd=3.11 ps=2.84
XM0 Y#2 B#1 VPWR#6 VPB sky130_fd_pr__pfet_01v8 l=0.15 w=1.12 ad=0.336 as=0.448 pd=2.84 ps=3.04
XM7 VPWR#6 a_27_116# Y#3 VPB sky130_fd_pr__pfet_01v8 l=0.15 w=1.12 ad=0.448 as=0.3304 pd=3.04 ps=2.83
*
*
*       RESISTOR AND CAP/DIODE CARDS
*
Rg1	A_N#1	A_N#2	351.582520
Rg2	A_N#2	A_N#3	313.829559
Rg3	C#1	C#2	371.062500
Rg4	C#2	C#3	434.639221
Rg5	B#1	B#2	434.639221
Rg6	B#2	B#3	371.062500
Rg7	a_27_116#	a_27_116##2	447.963806
Rg8	a_27_116##2	a_27_116##3	353.846649
Rf1	A_N#2	A_N#5	161.913620
Rf2	A_N#6	A_N	1.680815
Rf3	A_N#5	A_N#6	5.034561
Rf4	C	C#2	166.137894
Rf5	B#4	B#2	161.302414
Rf6	B	B#6	1.069610
Rf7	B#4	B#6	5.583287
Rf8	a_27_116##2	a_27_116##5	313.628418
Rf9	a_27_116##5	a_27_116##6	25.539253
Rf10	a_27_116##5	a_27_116##7	87.665802
Rf11	Y#1	Y	92.381836
Rf12	Y	Y#2	88.001442
Rf13	Y	Y#4	9.913898
Rf14	Y#4	Y	0.134718
Rf15	Y#3	Y#4	5.000000
Rf17	VPWR#2	VPWR#3	38.692230
Rf18	VPWR#3	VPWR#4	34.309200
Rf20	VPWR#2	VPWR#6	31.534731
Rf21	VPWR#4	VPWR#7	37.301857
Rf22	VGND#1	VGND#2	40.753365
Rf24	VGND#2	VGND#4	20.144054
Re1	VPWR#3	VPWR	1.637070
Re2	VGND	VGND#1	1.637131
*
*       CAPACITOR CARDS
*
*
C1	VGND	VNB	6.05894e-17
C2	VPWR	VNB	6.1562e-17
C3	C	VNB	1.82193e-18
C4	B	VNB	2.10492e-18
C5	A_N#2	VNB	4.46096e-17
C6	C#2	VNB	2.64455e-17
C7	VPWR	C	3.05442e-18
C8	B#2	VNB	2.9163e-17
C9	a_27_116##2	VNB	5.65943e-17
C10	VPWR	B	2.61793e-18
C11	VGND#1	VNB	2.00137e-16
C12	VPWR#3	VNB	1.50148e-16
C13	A_N#1	VNB	4.09697e-17
C14	C#3	VNB	3.42083e-17
C15	VGND	C#2	2.92665e-18
C16	B#1	VNB	3.22757e-17
C17	a_27_116#	VNB	3.86806e-17
C18	VGND	a_27_116##2	1.23782e-17
C19	A_N#3	VNB	3.58758e-17
C20	VGND	VGND#1	4.63419e-17
C21	C#1	VNB	3.06177e-17
C22	B#3	VNB	2.49588e-17
C23	a_27_116##3	VNB	3.63386e-17
C24	C	B	1.32451e-17
C25	a_27_116##7	VNB	6.13135e-17
C26	VPWR#7	VNB	1.32914e-17
C27	Y#2	VNB	2.20942e-18
C28	VPWR#6	VNB	3.75816e-18
C29	VPWR	a_27_116##2	2.79985e-18
C30	Y#3	VNB	8.53199e-17
C31	VGND#4	VNB	6.26625e-18
C32	VPWR	VPWR#3	9.84297e-18
C33	VGND	A_N#3	3.52936e-18
C34	Y#1	VNB	4.85505e-17
C35	A_N#5	VNB	3.65282e-18
C36	VGND	C#1	4.0333e-18
C37	VPWR	A_N#1	6.43355e-18
C38	VGND	B#3	1.04654e-17
C39	A_N#6	VNB	3.03589e-18
C40	VPWR	C#3	1.78744e-18
C41	VGND	a_27_116##3	1.04654e-17
C42	B#4	VNB	2.27007e-18
C43	VPWR	B#1	8.40747e-19
C44	C	A_N#2	2.08588e-18
C45	VPWR	a_27_116#	9.77846e-19
C46	a_27_116##5	VNB	5.51761e-17
C47	C	C#2	7.28503e-18
C48	VGND	Y#3	9.07451e-19
C49	C	B#2	1.7504e-18
C50	B	C#2	1.65236e-18
C51	VGND	Y#1	2.42441e-17
C52	VPWR	a_27_116##7	1.82473e-17
C53	VGND	A_N#5	3.52556e-18
C54	VPWR	VPWR#7	2.0801e-17
C55	B	B#2	5.84666e-18
C56	VPWR	Y#2	1.72324e-17
C57	C	VPWR#3	1.80122e-19
C58	VPWR	VPWR#6	2.16404e-17
C59	B	a_27_116##2	8.28929e-18
C60	VGND	B#4	3.33472e-18
C61	VPWR	Y#3	2.55848e-17
C62	C	A_N#1	7.82515e-19
C63	VGND	a_27_116##5	1.85333e-17
C64	C	C#3	3.60056e-18
C65	C	B#1	5.25394e-19
C66	a_27_116##2	a_269_78#	3.04428e-18
C67	VPWR	A_N#6	3.65174e-18
C68	B	C#3	5.95834e-19
C69	B	B#1	1.98382e-18
C70	a_27_116##2	a_347_78#	5.10852e-18
C71	A_N#2	C#2	2.18223e-17
C72	B	a_27_116#	1.74143e-18
C73	a_27_116##2	A_N#2	1.58294e-19
C74	C#2	B#2	2.83669e-17
C75	C	VPWR#7	2.97405e-17
C76	C	Y#2	1.7764e-17
C77	a_27_116##2	C#2	8.42661e-18
C78	B#2	a_27_116##2	4.01702e-17
C79	B	Y#2	3.29718e-17
C80	VGND#1	B#2	2.3137e-19
C81	C#1	a_269_78#	1.65187e-17
C82	B	Y#3	8.6336e-18
C83	B#3	a_269_78#	1.65187e-17
C84	VGND#1	a_27_116##2	7.04548e-18
C85	A_N#5	C	3.37135e-18
C86	A_N#6	C	1.57384e-17
C87	B#3	a_347_78#	2.16982e-17
C88	C	B#4	2.82866e-18
C89	a_27_116##3	a_347_78#	2.20289e-17
C90	B#2	a_27_116#	4.26883e-19
C91	A_N#2	a_27_116##7	8.56614e-18
C92	VPWR#3	C#3	3.33672e-18
C93	VPWR#3	B#1	1.60511e-18
C94	a_27_116##2	A_N#3	6.78401e-20
C95	a_27_116##2	C#1	9.61522e-18
C96	C#2	VPWR#7	3.16206e-18
C97	A_N#1	C#3	2.37245e-17
C98	VGND#1	A_N#3	3.26414e-20
C99	a_27_116##2	B#3	2.47355e-17
C100	VGND#1	C#1	3.6025e-18
C101	a_27_116##2	a_27_116##3	9.92326e-18
C102	VGND#4	A_N#2	9.55073e-19
C103	VGND#1	B#3	8.11942e-18
C104	C#3	B#1	4.58215e-17
C105	Y#2	B#2	4.41022e-19
C106	VGND#1	a_27_116##3	7.14583e-18
C107	B#2	VPWR#6	1.1369e-18
C108	VGND#4	C#2	8.90761e-19
C109	Y#3	B#2	1.35367e-18
C110	a_27_116##2	Y#2	6.64313e-18
C111	B#1	a_27_116#	3.05568e-17
C112	A_N#5	A_N#2	1.07361e-17
C113	a_27_116##5	a_347_78#	1.28253e-19
C114	a_27_116##2	Y#3	7.68353e-17
C115	A_N#6	A_N#2	5.18308e-18
C116	A_N#5	C#2	1.87039e-17
C117	Y#2	VPWR#3	1.66935e-17
C118	A_N#6	C#2	1.75911e-18
C119	a_27_116##7	A_N#1	4.06478e-17
C120	A_N#1	VPWR#7	3.38981e-17
C121	C#2	B#4	1.65501e-17
C122	a_27_116##2	Y#1	4.63725e-17
C123	a_27_116##7	C#3	1.63201e-18
C124	a_27_116##5	A_N#2	9.63118e-18
C125	Y#2	A_N#1	1.40528e-18
C126	C#3	VPWR#7	3.37019e-17
C127	a_27_116##7	B#1	1.32593e-19
C128	B#4	B#2	1.04112e-17
C129	VGND#1	Y#1	3.0441e-17
C130	A_N#3	C#1	9.02744e-18
C131	Y#2	C#3	5.29218e-17
C132	a_27_116##5	C#2	3.00561e-17
C133	Y#3	A_N#1	2.49267e-19
C134	VPWR#7	B#1	1.34947e-18
C135	a_27_116##7	a_27_116#	1.81809e-19
C136	VPWR#6	C#3	1.3945e-18
C137	Y#2	B#1	7.2494e-17
C138	a_27_116##2	B#4	5.74615e-17
C139	VPWR#7	a_27_116#	6.36574e-19
C140	Y#3	C#3	3.32024e-19
C141	C#1	B#3	5.28901e-17
C142	B#1	VPWR#6	3.67823e-17
C143	a_27_116##5	B#2	2.09305e-19
C144	Y#2	a_27_116#	8.39115e-19
C145	Y#3	B#1	1.79067e-18
C146	a_27_116#	VPWR#6	3.55674e-17
C147	a_27_116##5	a_27_116##2	2.92112e-19
C148	B#3	a_27_116##3	2.79519e-17
C149	Y#3	a_27_116#	6.59135e-17
C150	VGND#1	a_27_116##5	1.85171e-19
C151	A_N#6	A_N#1	3.93145e-18
C152	A_N#3	a_27_116##6	1.56442e-18
C153	A_N#6	C#3	4.01706e-19
C154	a_27_116##7	VPWR#7	5.66916e-17
C155	VGND#4	A_N#3	3.45639e-17
C156	VGND#4	C#1	4.16054e-17
C157	a_27_116##7	VPWR#6	2.34519e-20
C158	VPWR#7	Y#2	9.05611e-17
C159	VGND#4	B#3	3.18419e-18
C160	Y#1	A_N#3	4.22315e-19
C161	VPWR#7	VPWR#6	1.69573e-18
C162	VGND#4	a_27_116##3	2.48071e-18
C163	Y#1	C#1	2.91657e-18
C164	Y#2	VPWR#6	7.06645e-17
C165	Y#2	Y#3	2.74524e-18
C166	Y#1	B#3	6.67897e-18
C167	Y#3	VPWR#6	9.10351e-17
C168	Y#1	a_27_116##3	3.68337e-17
C169	a_27_116##7	A_N#5	3.32876e-18
C170	a_27_116##5	A_N#3	3.13568e-17
C171	a_27_116##7	A_N#6	4.12929e-17
C172	a_27_116##5	C#1	1.29737e-17
C173	A_N#6	VPWR#7	2.03658e-17
C174	Y#1	Y#3	4.13483e-18
C175	a_27_116##5	B#3	3.05369e-19
C176	a_27_116##5	a_27_116##3	4.05902e-19
C177	VGND#4	Y#1	9.76503e-18
C178	a_27_116##5	a_27_116##7	2.176e-18
C179	a_27_116##5	VPWR#7	5.00427e-18
C180	a_27_116##5	a_27_116##6	7.04332e-18
C181	a_27_116##5	VGND#4	8.99714e-17
C182	a_27_116##5	A_N#5	5.38522e-17
C183	VPWR	VPWR#2	3.39047e-17
C184	VPWR#4	A_N#2	6.94541e-20
C185	VPWR#4	A_N#1	4.64545e-18
C186	VGND#2	a_27_116##3	1.16464e-18
C187	VGND#2	C#1	7.1257e-18
C188	A_N#6	VPWR#4	4.3576e-19
C189	VPWR	VPWR#4	3.81934e-17
C190	VPWR#3	VPWR#4	5.35723e-17
C191	VPWR#2	VNB	4.66428e-17
C192	VPWR#4	VNB	4.98814e-17
C193	VPWR#2	B#1	2.04357e-18
C194	VGND#2	a_27_116##5	9.88083e-18
C195	C	VPWR#4	1.28223e-19
C196	VGND#2	VNB	5.47313e-17
C197	VPWR#4	VPWR#2	9.53351e-19
C198	VPWR#4	C#3	1.23513e-18
C199	VGND#2	B#3	1.44757e-18
C200	VGND#2	A_N#3	6.18227e-19
C201	VPWR#3	VPWR#2	5.23284e-17
C202	VPWR#2	a_27_116#	2.58469e-18
C203	VGND#1	VGND#2	5.66549e-17
C204	Y#3	VPWR#2	2.89492e-17
C205	VPWR#2	a_27_116##2	3.69167e-20
C206	VGND	VGND#2	7.9255e-17
C207	Y#2	VPWR#2	3.4792e-19
C208	a_27_116##7	VPWR#4	1.22565e-17
*
*
.ENDS sky130_fd_sc_hs__nand3b_1
*
