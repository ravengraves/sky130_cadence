* Extracted by Quantus, converted by sky130cad/quantus.py
*
*
*
*                       LINUX           Wed Nov 18 09:12:59 2026
*
*
*
*  PROGRAM  advgen
*
*  Name           : advgen - Quantus - (64-bit)
*  Version        : 25.1.0-p047
*  Build Date     : Thu Dec 11 23:20:30 PST 2025
*
*  HSPICE LIBRARY
*
*  OPERATING_TEMPERATURE 150
*  QRC_TECH_DIR <path>/tech
*
*
*
*
.SUBCKT sky130_fd_sc_hs__tap_1 VGND VPWR VPB VNB
*
*
*  caps2d version: 10
*
*
*       RESISTOR AND CAP/DIODE CARDS
*
Rf1	VPB	VPB#1	7.972183
Rf2	VPB#1	VPB	7.972183
Rf3	VPB	VPB#1	7.500000
Rf4	VNB	VNB#1	8.295380
Rf5	VNB#1	VNB	7.648986
Rf6	VNB	VNB#1	7.500000
*
*       CAPACITOR CARDS
*
*
C1	VPB	VNB	1.3127e-16
C2	VGND	VPB	4.0163e-18
C3	VGND	VNB	1.85171e-16
C4	VPWR	VPB	5.26522e-17
C5	VPWR	VNB	1.35729e-16
*
*
.ENDS sky130_fd_sc_hs__tap_1
*
