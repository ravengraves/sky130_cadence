* Extracted by Quantus, converted by sky130cad/quantus.py
*
*
*
*                       LINUX           Wed Nov 18 08:34:10 2026
*
*
*
*  PROGRAM  advgen
*
*  Name           : advgen - Quantus - (64-bit)
*  Version        : 25.1.0-p047
*  Build Date     : Thu Dec 11 23:20:30 PST 2025
*
*  HSPICE LIBRARY
*
*  OPERATING_TEMPERATURE 150
*  QRC_TECH_DIR <path>/tech
*
*
*

*
.SUBCKT sky130_fd_sc_hs__dlxtp_1 VPB VNB VGND VPWR Q D GATE
*
*
*  caps2d version: 10
*
*
*       TRANSISTOR CARDS
*
*
XM3 VGND#6 D#1 a_116_424##5 VNB sky130_fd_pr__nfet_01v8_lvt l=0.15 w=0.55 ad=0.1705 as=0.1815 pd=1.72 ps=1.76
XM6 a_239_85##2 a_116_424# VGND#9 VNB sky130_fd_pr__nfet_01v8_lvt l=0.15 w=0.74 ad=0.2238 as=0.3929 pd=2.14 ps=2.97
XM1 VGND#9 a_386_326##2 a_514_149# VNB sky130_fd_pr__nfet_01v8_lvt l=0.15 w=0.42 ad=0.3929 as=0.1008 pd=2.97 ps=1.32
XM13 a_514_149# a_562_123##3 a_592_149##6 VNB sky130_fd_pr__nfet_01v8_lvt l=0.15 w=0.42 ad=0.1008 as=0.2753 pd=1.32 ps=2.41
XM0 a_592_149##6 a_685_59# a_239_85# VNB sky130_fd_pr__nfet_01v8_lvt l=0.15 w=0.74 ad=0.2753 as=0.222 pd=2.41 ps=2.08
XM8 a_386_326##8 a_592_149# VGND#8 VNB sky130_fd_pr__nfet_01v8_lvt l=0.15 w=0.74 ad=0.2109 as=0.3923 pd=2.05 ps=2.82
XM16 VGND#8 a_562_123##7 a_685_59##4 VNB sky130_fd_pr__nfet_01v8_lvt l=0.15 w=0.74 ad=0.3923 as=0.2109 pd=2.82 ps=2.05
XM5 a_562_123##8 GATE#3 VGND#7 VNB sky130_fd_pr__nfet_01v8_lvt l=0.15 w=0.74 ad=0.222 as=0.52325 pd=2.08 ps=3.09
XM4 VGND#7 a_386_326##4 Q#1 VNB sky130_fd_pr__nfet_01v8_lvt l=0.15 w=0.74 ad=0.52325 as=0.2109 pd=3.09 ps=2.05
XM15 VPWR#6 D#3 a_116_424##7 VPB sky130_fd_pr__pfet_01v8 l=0.15 w=0.84 ad=0.2478 as=0.2478 pd=2.27 ps=2.27
XM9 a_229_392# a_116_424##4 VPWR#9 VPB sky130_fd_pr__pfet_01v8 l=0.15 w=1 ad=0.295 as=0.387175 pd=2.59 ps=3.4
XM10 VPWR#9 a_386_326##3 a_419_392##2 VPB sky130_fd_pr__pfet_01v8 l=0.15 w=0.42 ad=0.387175 as=0.1239 pd=3.4 ps=1.43
XM2 a_229_392##2 a_562_123# a_592_149##8 VPB sky130_fd_pr__pfet_01v8 l=0.15 w=1 ad=0.295 as=0.3328 pd=2.59 ps=2.77
XM11 a_592_149##8 a_685_59##3 a_419_392# VPB sky130_fd_pr__pfet_01v8 l=0.15 w=0.42 ad=0.3328 as=0.19295 pd=2.77 ps=1.83
XM12 a_386_326##11 a_592_149##4 VPWR#8 VPB sky130_fd_pr__pfet_01v8 l=0.15 w=1.12 ad=0.3696 as=0.6027 pd=2.9 ps=3.88
XM17 VPWR#8 a_562_123##6 a_685_59##5 VPB sky130_fd_pr__pfet_01v8 l=0.15 w=0.84 ad=0.6027 as=0.2478 pd=3.88 ps=2.27
XM14 a_562_123##12 GATE#1 VPWR#7 VPB sky130_fd_pr__pfet_01v8 l=0.15 w=0.84 ad=0.2478 as=0.462 pd=2.27 ps=3.11
XM7 VPWR#7 a_386_326##6 Q#2 VPB sky130_fd_pr__pfet_01v8 l=0.15 w=1.12 ad=0.462 as=0.3304 pd=3.11 ps=2.83
*
*
*       RESISTOR AND CAP/DIODE CARDS
*
Rg1	D#1	D#2	357.635284
Rg2	D#2	D#3	452.843719
Rg3	a_116_424#	a_116_424##2	369.706848
Rg4	a_116_424##2	a_116_424##3	273.520813
Rg5	a_116_424##2	a_116_424##4	550.395081
Rg6	a_386_326#	a_386_326##2	238.584396
Rg7	a_386_326##2	a_386_326##3	838.186157
Rg8	a_562_123#	a_562_123##2	411.170471
Rg9	a_562_123##2	a_562_123##3	303.355316
Rg10	a_685_59#	a_685_59##2	377.212860
Rg11	a_685_59##2	a_685_59##3	527.708618
Rg12	a_592_149#	a_592_149##2	320.193695
Rg13	a_592_149##2	a_592_149##3	239.943558
Rg14	a_592_149##2	a_592_149##4	471.720459
Rg15	a_562_123##4	a_562_123##5	394.377563
Rg16	a_562_123##5	a_562_123##6	384.306610
Rg17	a_562_123##5	a_562_123##7	340.360596
Rg18	GATE#1	GATE#2	354.298584
Rg19	GATE#2	GATE#3	359.585266
Rg20	a_386_326##4	a_386_326##5	341.787262
Rg21	a_386_326##5	a_386_326##6	447.381653
Rf1	D	D#4	1.888999
Rf2	D#5	D#2	82.005402
Rf3	D#4	D#5	6.171042
Rf4	D	D#7	1.888999
Rf5	D#5	D#7	4.207529
Rf6	a_116_424##5	a_116_424##3	51.346924
Rf7	a_116_424##3	a_116_424##7	68.119537
Rf8	a_229_392#	a_229_392##2	117.990852
Rf9	a_239_85#	a_239_85##2	275.376221
Rf10	a_419_392#	a_419_392##2	177.288116
Rf11	a_592_149##3	a_592_149##7	228.172241
Rf12	a_592_149##7	a_592_149##8	152.152710
Rf13	a_592_149##6	a_592_149##7	15.000000
Rf14	a_685_59##4	a_685_59##6	63.617832
Rf15	a_685_59##6	a_685_59##2	342.326172
Rf16	a_685_59##5	a_685_59##6	7.500000
Rf17	a_562_123##8	a_562_123##4	42.640011
Rf18	a_562_123##4	a_562_123##10	20.711477
Rf19	a_562_123##10	a_562_123##2	411.523682
Rf20	a_562_123##10	a_562_123##12	14.553338
Rf21	GATE#4	GATE#2	161.302414
Rf22	GATE	GATE#6	1.069610
Rf23	GATE#4	GATE#6	5.583287
Rf24	a_386_326##5	a_386_326##9	376.466248
Rf25	a_386_326##9	a_386_326#	343.911621
Rf26	a_386_326##9	a_386_326##11	72.703735
Rf27	a_386_326##8	a_386_326##9	7.500000
Rf28	Q#1	Q	84.936813
Rf29	Q	Q#3	13.052517
Rf30	Q#3	Q	0.178802
Rf31	Q#2	Q#3	5.000000
Rf32	VPWR#1	VPWR#2	22.255869
Rf33	VPWR#2	VPWR#3	138.016373
Rf34	VPWR#3	VPWR#4	120.143532
Rf35	VPWR#4	VPWR#5	111.922455
Rf36	VPWR#5	VPWR#6	146.193069
Rf37	VPWR#2	VPWR#7	43.738586
Rf38	VPWR#3	VPWR#8	24.272007
Rf39	VPWR#5	VPWR#9	22.976044
Rf40	VGND#1	VGND#2	27.511150
Rf41	VGND#2	VGND#3	121.356499
Rf42	VGND#3	VGND#4	131.466354
Rf43	VGND#4	VGND#5	111.012222
Rf44	VGND#5	VGND#6	151.656540
Rf45	VGND#2	VGND#7	21.816568
Rf46	VGND#3	VGND#8	24.468842
Rf47	VGND#5	VGND#9	49.270222
Re1	VPWR#1	VPWR	6.179563
Re2	VPWR	VPWR#4	0.882795
Re3	VGND#1	VGND	6.179563
Re4	VGND	VGND#4	0.882795
*
*       CAPACITOR CARDS
*
*
C1	VPWR#3	a_386_326##6	1.69304e-18
C2	a_239_85#	a_419_392##2	9.54708e-19
C3	VPWR#2	a_386_326##6	7.33148e-18
C4	Q#1	a_386_326##4	3.48815e-17
C5	a_239_85##2	a_116_424##2	3.47842e-17
C6	a_116_424##2	a_386_326##2	2.88947e-18
C7	a_386_326##4	VGND#7	9.47415e-18
C8	VPWR#2	GATE#1	4.64545e-18
C9	VPWR#7	VPWR#8	2.16111e-18
C10	Q#1	GATE#3	2.88176e-18
C11	a_592_149##2	a_562_123##5	1.40778e-17
C12	a_562_123##8	a_386_326##4	2.72238e-18
C13	VPWR#3	a_562_123##6	1.98696e-18
C14	GATE#3	VGND#7	1.71149e-17
C15	Q#1	a_562_123##7	3.48393e-19
C16	a_562_123##10	a_562_123##5	5.77798e-19
C17	a_239_85##2	a_419_392##2	1.38537e-17
C18	a_562_123##8	GATE#3	3.71143e-17
C19	a_685_59##5	VPWR#8	8.82403e-18
C20	VGND#2	Q#1	5.15524e-18
C21	VPWR#3	a_592_149##4	1.39039e-17
C22	a_685_59##4	GATE#3	6.5515e-19
C23	a_562_123##8	a_562_123##7	6.23085e-19
C24	a_562_123##10	a_592_149##2	1.07026e-18
C25	a_685_59##5	a_386_326##11	5.33577e-17
C26	VPWR#5	a_685_59##3	3.99251e-19
C27	VGND#2	VGND#7	9.66001e-18
C28	a_685_59##4	a_562_123##7	4.12299e-17
C29	a_239_85##2	a_229_392#	2.21506e-17
C30	VPWR#3	a_685_59##3	2.17924e-18
C31	a_386_326##8	GATE#3	8.13534e-19
C32	a_562_123##10	a_386_326##6	2.29246e-18
C33	a_562_123##7	VGND#8	1.85908e-17
C34	VGND#5	a_386_326##3	4.73436e-20
C35	VPWR#5	a_562_123#	1.58241e-18
C36	a_685_59##4	a_592_149#	3.18368e-18
C37	a_419_392#	VPWR#8	2.72493e-20
C38	a_116_424##3	a_116_424##2	1.37868e-17
C39	a_386_326##8	a_562_123##7	2.78504e-17
C40	VPWR#3	a_562_123#	2.66652e-19
C41	a_562_123##10	GATE#1	3.33409e-17
C42	a_592_149#	VGND#8	1.31833e-17
C43	a_116_424##5	a_116_424##7	1.21787e-18
C44	a_386_326##8	a_592_149#	5.99571e-17
C45	VPWR#5	a_386_326##3	2.163e-18
C46	a_562_123##10	a_562_123##6	1.40613e-17
C47	a_239_85#	a_592_149#	1.36195e-18
C48	VGND#3	VGND#8	7.62555e-18
C49	VGND#6	VPWR#6	2.54336e-19
C50	a_386_326##8	a_685_59#	1.79304e-18
C51	a_419_392#	a_592_149##8	3.21843e-17
C52	a_592_149##6	a_592_149#	3.25707e-20
C53	VPWR#5	a_116_424##4	1.23027e-17
C54	a_239_85#	a_685_59#	3.15956e-17
C55	a_562_123##10	a_592_149##4	2.85078e-17
C56	a_229_392##2	a_419_392#	2.65655e-17
C57	a_386_326##8	a_562_123##3	1.11681e-19
C58	VGND#3	a_386_326##8	1.15125e-16
C59	a_592_149##6	a_685_59#	3.89096e-17
C60	a_239_85#	a_562_123##3	1.84538e-17
C61	a_592_149##8	a_229_392##2	2.36605e-18
C62	VPWR#5	D#3	1.03379e-18
C63	VGND#2	a_386_326##8	4.09261e-18
C64	a_592_149##6	a_562_123##3	2.56376e-17
C65	a_419_392##2	a_592_149##8	5.92464e-17
C66	VGND#9	a_685_59#	5.4873e-20
C67	a_239_85#	a_386_326##2	1.4926e-17
C68	a_592_149##6	a_386_326##2	1.29479e-17
C69	a_419_392##2	a_229_392##2	7.49594e-17
C70	VGND#9	a_562_123##3	3.24539e-19
C71	a_239_85#	a_116_424#	1.0338e-18
C72	a_592_149##6	a_116_424#	3.90364e-19
C73	a_386_326##2	VGND#9	5.1016e-18
C74	a_229_392#	a_229_392##2	2.86421e-18
C75	a_239_85##2	a_386_326##2	6.91664e-18
C76	VPWR#1	VPWR#2	5.08958e-17
C77	a_116_424#	VGND#9	2.63935e-17
C78	VGND#1	VGND#2	3.98906e-17
C79	a_229_392#	a_419_392##2	1.96713e-17
C80	a_685_59##5	a_562_123##5	1.55015e-18
C81	VGND#5	VGND#9	2.18886e-19
C82	a_116_424#	a_239_85##2	2.21839e-17
C83	a_229_392#	VPWR#9	6.42717e-18
C84	a_685_59##5	a_592_149##2	2.6474e-18
C85	a_116_424##5	a_116_424#	1.5062e-18
C86	a_239_85##2	D#1	2.54543e-18
C87	GATE#4	VGND#7	1.8969e-18
C88	VGND#5	a_239_85##2	2.24629e-17
C89	VGND#6	a_116_424#	1.4576e-18
C90	D#1	a_116_424##5	2.64037e-17
C91	a_116_424##7	a_229_392#	8.38077e-17
C92	a_685_59##4	a_592_149##4	5.62049e-20
C93	VGND#6	D#1	2.98364e-17
C94	a_562_123##8	GATE#4	6.24469e-18
C95	VGND#5	a_116_424##5	5.44937e-18
C96	a_592_149##4	a_562_123##5	1.49311e-18
C97	VPWR#6	a_116_424##7	8.05824e-17
C98	VGND#1	GATE#4	1.5518e-18
C99	VGND#2	a_386_326##5	5.93482e-17
C100	VGND#6	VGND#5	1.95857e-18
C101	Q#2	a_386_326##6	4.94974e-17
C102	a_562_123##8	a_562_123##10	3.38137e-18
C103	a_386_326##11	a_562_123##5	2.31429e-18
C104	a_386_326##5	VPWR#2	7.40934e-20
C105	VGND#2	GATE#2	5.3498e-19
C106	a_386_326##6	VPWR#7	3.12226e-17
C107	a_592_149##8	a_386_326##2	9.34851e-18
C108	a_386_326##11	a_592_149##2	1.94463e-17
C109	Q#2	GATE#1	3.21407e-18
C110	a_685_59##4	a_562_123##10	1.83464e-18
C111	a_229_392##2	a_386_326##2	1.31066e-18
C112	GATE#1	VPWR#7	3.28625e-17
C113	VGND#3	a_562_123##4	1.368e-19
C114	GATE#3	a_386_326##4	1.35609e-17
C115	VPWR#2	GATE#2	5.05937e-20
C116	Q#2	a_562_123##6	1.51079e-19
C117	VGND#2	a_562_123##4	1.48995e-19
C118	GATE#1	a_562_123##12	1.07994e-17
C119	a_419_392##2	a_386_326##2	4.24357e-18
C120	a_685_59##5	GATE#1	5.96535e-19
C121	VPWR#3	a_562_123##4	1.35742e-19
C122	a_386_326##5	GATE#4	3.35889e-17
C123	VPWR#2	a_562_123##4	1.25108e-19
C124	a_562_123##7	GATE#3	5.56598e-18
C125	VGND#3	a_592_149##3	4.479e-19
C126	VPWR#7	a_592_149##4	1.42479e-18
C127	a_685_59##5	a_562_123##6	4.90867e-17
C128	VGND#9	a_386_326##3	1.51698e-18
C129	a_239_85##2	a_386_326##3	1.40202e-17
C130	a_562_123##6	VPWR#8	1.36337e-17
C131	VPWR#3	a_592_149##3	1.78363e-19
C132	GATE#4	GATE#2	1.23915e-17
C133	a_685_59##5	a_592_149##4	1.96616e-17
C134	a_592_149#	a_562_123##7	2.01237e-17
C135	VGND#1	Q#1	3.90009e-17
C136	a_386_326##11	a_562_123##6	5.05288e-18
C137	a_592_149##4	VPWR#8	2.85533e-17
C138	a_562_123##10	GATE#2	1.86168e-18
C139	a_685_59##5	a_685_59##3	6.73361e-20
C140	a_386_326##11	a_592_149##4	3.82737e-17
C141	a_562_123##4	GATE#4	2.28319e-17
C142	VPWR#2	Q#2	2.36926e-18
C143	a_685_59#	a_592_149#	1.48558e-18
C144	a_419_392#	a_592_149##4	2.99438e-18
C145	VPWR#3	VPWR#7	2.73722e-18
C146	a_562_123##10	a_562_123##4	1.03565e-18
C147	a_592_149##8	a_116_424##2	7.68555e-20
C148	a_419_392#	a_685_59##3	3.93007e-17
C149	a_562_123##2	VPWR#3	4.35645e-18
C150	a_116_424##2	a_386_326##3	6.15719e-18
C151	VGND#5	a_386_326#	6.47064e-17
C152	a_562_123##3	a_685_59#	1.27026e-17
C153	a_685_59##3	a_592_149##8	7.27241e-18
C154	a_562_123##10	a_592_149##3	1.02506e-19
C155	a_419_392#	a_562_123#	8.26016e-18
C156	a_229_392##2	a_685_59##3	1.26522e-18
C157	a_386_326##5	Q#1	7.68082e-17
C158	VGND#3	VGND#2	2.18404e-18
C159	a_592_149##8	a_562_123#	3.26635e-17
C160	a_386_326##5	VGND#7	1.73213e-17
C161	a_419_392##2	a_685_59##3	6.95941e-19
C162	a_386_326##2	a_562_123##3	3.18092e-17
C163	VGND#3	a_562_123##5	4.65304e-19
C164	VGND#5	a_116_424##3	2.85107e-18
C165	a_386_326##5	a_562_123##8	3.6434e-17
C166	a_229_392##2	a_562_123#	4.81952e-17
C167	a_685_59##2	a_562_123##10	2.04629e-18
C168	VGND#4	a_386_326##8	4.42057e-17
C169	VGND#5	a_116_424##2	1.32005e-19
C170	a_592_149##8	a_386_326##3	2.91831e-18
C171	Q#1	GATE#2	1.52398e-21
C172	a_419_392##2	a_562_123#	2.39904e-17
C173	Q#2	VPWR#1	4.35261e-17
C174	a_419_392#	a_116_424##4	5.23709e-19
C175	a_116_424##3	VPWR#5	6.36977e-19
C176	a_386_326##5	VGND#8	2.12415e-20
C177	a_229_392##2	a_386_326##3	3.02837e-18
C178	a_116_424#	a_386_326##2	4.02053e-18
C179	a_562_123##8	GATE#2	1.49421e-19
C180	a_592_149##8	a_116_424##4	4.33702e-19
C181	VGND#3	a_592_149##2	1.98516e-19
C182	a_419_392##2	a_386_326##3	3.96912e-17
C183	a_685_59##4	GATE#2	4.5587e-20
C184	VGND#1	Q#2	1.0924e-18
C185	a_229_392#	a_562_123#	2.00895e-19
C186	VPWR#3	VPWR#8	6.91143e-18
C187	a_229_392##2	a_116_424##4	1.34179e-18
C188	a_386_326##3	VPWR#9	1.22101e-17
C189	a_592_149##8	D#3	8.43486e-20
C190	a_419_392##2	a_116_424##4	4.97811e-18
C191	a_562_123##4	a_562_123##8	1.53724e-19
C192	D#1	a_116_424#	3.59814e-18
C193	a_229_392#	a_386_326##3	1.1851e-17
C194	a_685_59##4	a_562_123##4	2.17377e-17
C195	a_116_424##4	VPWR#9	2.27582e-17
C196	a_229_392#	a_116_424##4	8.46886e-17
C197	a_386_326##8	a_562_123##4	5.25212e-18
C198	a_116_424##7	a_116_424##4	1.59987e-18
C199	VPWR#5	a_419_392#	2.14993e-18
C200	a_229_392#	D#3	3.92042e-18
C201	VPWR#6	a_116_424##4	1.13308e-18
C202	a_386_326##5	Q#2	3.36186e-17
C203	a_386_326##8	a_592_149##3	6.50791e-17
C204	a_116_424##7	D#3	1.99503e-17
C205	a_419_392#	VPWR#3	7.07473e-18
C206	a_592_149##3	a_239_85#	2.94347e-17
C207	a_386_326##5	VPWR#7	1.91206e-17
C208	VPWR#6	D#3	4.69468e-17
C209	a_419_392#	VPWR#4	5.652e-17
C210	a_592_149##6	a_592_149##3	9.60934e-19
C211	Q#2	GATE#2	1.19818e-19
C212	a_562_123##10	Q#2	1.01545e-18
C213	a_685_59##2	a_386_326##8	2.42925e-18
C214	a_239_85#	a_685_59##2	1.29036e-18
C215	a_229_392##2	VPWR#4	1.6357e-17
C216	GATE#1	a_386_326##6	2.36461e-17
C217	GATE#2	a_562_123##12	3.83753e-19
C218	a_592_149##6	a_685_59##2	2.3066e-17
C219	a_562_123##4	Q#2	4.18538e-19
C220	a_419_392##2	VPWR#4	1.366e-18
C221	a_685_59##5	GATE#2	1.84732e-20
C222	a_229_392##2	VPWR#5	3.08968e-17
C223	a_685_59##4	a_562_123##8	3.30088e-17
C224	D#5	a_116_424##3	1.68871e-17
C225	a_562_123##10	VPWR#7	5.96155e-17
C226	a_239_85#	a_562_123##2	6.61643e-19
C227	a_592_149##6	a_562_123##2	7.49411e-17
C228	a_562_123##6	GATE#1	3.00668e-18
C229	a_685_59##5	a_562_123##4	2.04968e-17
C230	a_386_326##8	a_386_326#	4.58659e-19
C231	VGND#1	a_386_326##4	1.66095e-17
C232	VPWR#3	a_562_123##5	1.49117e-19
C233	D#5	D#2	9.16104e-18
C234	a_592_149##4	GATE#1	8.21709e-19
C235	a_386_326#	a_239_85#	1.25471e-16
C236	a_562_123##10	a_562_123##12	9.12431e-18
C237	VPWR#3	VPWR#2	7.20835e-19
C238	VPWR#5	a_116_424##2	2.0355e-19
C239	a_386_326#	a_592_149##6	9.21153e-19
C240	a_685_59##5	a_592_149##3	8.73968e-20
C241	a_592_149##4	a_562_123##6	2.02912e-17
C242	a_229_392#	a_116_424##2	1.29417e-18
C243	a_562_123##8	a_562_123##5	4.32282e-20
C244	a_386_326##8	a_562_123##8	2.02255e-17
C245	VGND#9	a_386_326#	2.33248e-17
C246	a_592_149##3	a_386_326##11	1.13512e-17
C247	a_685_59##2	a_685_59##5	1.33623e-18
C248	VPWR#3	a_592_149##2	4.85973e-19
C249	a_116_424##3	a_592_149##6	1.42163e-18
C250	a_562_123##10	a_685_59##5	1.45023e-16
C251	a_685_59##3	a_592_149##4	4.32883e-18
C252	VPWR#5	VPWR#9	6.85692e-18
C253	VGND#6	a_386_326#	1.1269e-18
C254	VGND#9	a_116_424##3	3.89299e-19
C255	a_685_59##2	a_386_326##11	6.07105e-17
C256	a_386_326##5	a_386_326##4	1.19548e-17
C257	a_386_326##8	a_685_59##4	6.11033e-17
C258	a_562_123##2	a_685_59##5	1.56884e-20
C259	a_116_424##3	a_239_85##2	5.05589e-17
C260	a_419_392#	a_685_59##2	1.54784e-18
C261	a_386_326##5	GATE#3	3.51474e-17
C262	a_116_424##3	a_116_424##5	4.33576e-19
C263	a_592_149##8	a_685_59##2	2.02272e-18
C264	a_562_123#	a_685_59##3	3.02319e-17
C265	a_562_123##10	VPWR#8	4.14541e-18
C266	a_386_326##5	a_562_123##7	3.38136e-19
C267	a_562_123##2	a_386_326##11	1.79315e-18
C268	VGND#4	a_685_59#	3.82723e-18
C269	a_386_326##8	VGND#8	5.88726e-18
C270	a_229_392#	VPWR#5	6.08664e-17
C271	a_562_123##2	a_419_392#	6.83569e-17
C272	a_386_326##5	a_592_149#	2.4207e-19
C273	VGND#4	a_562_123##3	7.85899e-19
C274	a_685_59##4	a_562_123##5	2.46734e-17
C275	a_562_123##2	a_592_149##8	8.4693e-17
C276	VPWR#1	a_386_326##6	1.02545e-17
C277	a_386_326##3	a_562_123#	3.29659e-18
C278	D#2	VGND#6	4.83619e-17
C279	a_562_123##2	a_229_392##2	6.83416e-19
C280	a_562_123##10	a_386_326##11	2.74837e-18
C281	a_419_392##2	a_562_123##2	2.72128e-18
C282	a_116_424##4	a_562_123#	8.95695e-19
C283	a_685_59##4	a_592_149##2	2.06214e-18
C284	a_116_424##7	VPWR#5	5.38607e-18
C285	a_116_424##4	a_386_326##3	3.18954e-17
C286	a_419_392##2	a_386_326#	5.09502e-19
C287	a_116_424##3	a_592_149##8	3.78799e-18
C288	a_386_326##8	a_239_85#	3.72086e-17
C289	a_592_149##3	a_592_149#	1.53146e-17
C290	a_685_59#	a_592_149##3	1.34308e-17
C291	D#3	a_116_424##4	6.51226e-18
C292	a_592_149##3	a_562_123##3	5.18477e-19
C293	VGND#3	a_386_326##4	8.00096e-19
C294	a_592_149##8	D#2	9.87568e-20
C295	VPWR#6	VPWR#5	6.82142e-19
C296	a_592_149##6	a_386_326##8	1.34023e-18
C297	a_116_424##3	a_229_392#	2.71884e-17
C298	VPWR#4	a_685_59##3	5.00213e-18
C299	GATE#2	a_386_326##6	4.09688e-19
C300	a_562_123##3	a_685_59##2	2.44933e-18
C301	VGND#2	a_386_326##4	8.8724e-18
C302	VPWR#4	a_562_123#	7.41092e-18
C303	VPWR#6	a_116_424##3	4.77437e-20
C304	a_685_59##2	a_386_326##2	5.49267e-19
C305	a_562_123##6	GATE#2	8.92004e-20
C306	a_239_85#	a_592_149##6	9.98013e-17
C307	VGND#3	GATE#3	1.49832e-18
C308	a_562_123##4	GATE#1	4.45002e-19
C309	a_386_326##2	a_562_123##2	3.26043e-17
C310	VPWR#6	D#2	4.78193e-18
C311	a_386_326#	a_685_59#	2.15883e-17
C312	a_562_123##6	a_562_123##4	4.45744e-18
C313	Q#1	Q#2	3.40738e-18
C314	a_386_326#	a_562_123##3	1.72341e-17
C315	VGND#2	GATE#3	1.3179e-17
C316	a_116_424#	a_386_326#	1.03114e-17
C317	a_386_326##8	a_562_123##5	2.73073e-18
C318	a_116_424##3	a_386_326##2	1.07382e-19
C319	VGND#3	a_562_123##7	1.22205e-17
C320	a_685_59##2	a_562_123##6	3.11319e-19
C321	a_116_424##3	a_116_424#	6.1544e-18
C322	a_685_59##2	a_592_149##4	6.66776e-18
C323	a_239_85#	VGND#9	4.8189e-17
C324	a_239_85#	a_514_149#	1.07059e-18
C325	D#1	a_116_424##3	9.3828e-18
C326	a_562_123##2	a_562_123##6	3.13411e-19
C327	a_685_59##2	a_685_59##3	2.42567e-18
C328	VGND#2	a_562_123##7	1.92103e-18
C329	a_386_326##8	a_592_149##2	1.2453e-17
C330	a_386_326##5	VPWR#1	5.33671e-18
C331	a_562_123##2	a_592_149##4	1.31116e-18
C332	a_562_123#	a_685_59##2	6.70327e-18
C333	a_562_123##2	a_685_59##3	1.61479e-17
C334	VGND#1	a_386_326##5	1.03224e-17
C335	VGND#3	a_592_149#	7.58011e-18
C336	a_562_123##2	a_562_123#	2.84658e-18
C337	a_386_326##5	a_562_123##5	5.01521e-20
C338	GATE	VPWR#2	1.12938e-18
C339	a_386_326##3	a_562_123##2	3.30517e-19
C340	VGND#2	a_592_149#	7.35694e-19
C341	a_386_326#	a_386_326##3	2.05248e-18
C342	a_239_85##2	a_592_149##6	3.85994e-17
C343	VGND	a_562_123##5	6.68782e-19
C344	VGND	a_592_149##2	3.11429e-18
C345	a_116_424##3	a_562_123#	1.13543e-19
C346	VGND	a_116_424##2	5.80543e-19
C347	GATE	a_562_123##10	2.4059e-17
C348	GATE#2	a_386_326##5	3.60639e-17
C349	a_116_424##3	a_386_326##3	1.73456e-18
C350	VPWR#4	a_592_149##3	9.32981e-20
C351	a_116_424##3	a_116_424##4	1.35425e-17
C352	a_562_123##4	a_386_326##5	2.40598e-18
C353	VGND#4	a_592_149##3	4.13723e-19
C354	VPWR#4	a_685_59##2	1.55387e-19
C355	a_116_424##3	D#3	3.24948e-18
C356	a_562_123##4	GATE#2	3.03423e-17
C357	D#2	a_116_424##4	1.37184e-18
C358	VGND#4	a_685_59##2	1.78294e-19
C359	a_562_123##2	VPWR#4	1.99373e-18
C360	a_592_149##2	a_562_123##7	1.46578e-18
C361	VGND#4	a_562_123##2	4.22604e-20
C362	a_562_123##10	VPWR#3	6.66199e-17
C363	a_562_123##5	GATE#2	2.63542e-19
C364	a_239_85##2	VGND#9	1.07764e-16
C365	VGND#4	a_386_326#	7.08093e-17
C366	a_562_123##3	a_514_149#	7.05364e-18
C367	a_685_59##2	a_592_149##3	7.97028e-17
C368	a_562_123##5	VNB	1.76458e-17
C369	a_592_149##2	VNB	2.4146e-17
C370	a_386_326##2	a_514_149#	6.87558e-18
C371	a_116_424##2	VNB	2.79318e-17
C372	a_562_123##2	a_592_149##3	7.72238e-19
C373	a_562_123##10	VPWR#2	1.19309e-17
C374	GATE	Q#2	5.12751e-18
C375	a_562_123##2	a_685_59##2	2.05968e-16
C376	VPWR	VPWR#5	1.09473e-16
C377	VPWR	VPWR#3	1.2487e-16
C378	VPWR	VPWR#2	4.40592e-17
C379	a_386_326#	a_562_123##2	4.51878e-19
C380	a_116_424##5	a_239_85##2	4.66102e-17
C381	VPWR	a_562_123##10	4.98351e-17
C382	a_116_424##3	a_562_123##2	2.64738e-20
C383	VGND#5	a_116_424#	1.09426e-17
C384	a_386_326##8	a_685_59##5	3.73564e-18
C385	a_562_123##5	a_562_123##4	9.487e-19
C386	VGND	VGND#5	1.29142e-16
C387	a_592_149##6	a_116_424##2	4.68689e-19
C388	VGND	VGND#3	1.12494e-16
C389	VGND	VGND#2	4.70162e-17
C390	VPWR#5	a_386_326##2	1.04595e-19
C391	a_386_326##11	a_685_59##4	7.37059e-18
C392	VGND#6	a_239_85##2	2.48748e-18
C393	D#2	a_116_424##3	7.56903e-17
C394	VGND	GATE#4	3.36622e-18
C395	D	VPWR#6	3.02122e-17
C396	VPWR	a_239_85##2	8.90344e-18
C397	VGND#5	D#1	1.27215e-18
C398	GATE	a_386_326##6	1.32221e-18
C399	VGND#6	a_116_424##5	6.11679e-17
C400	GATE	GATE#1	4.45153e-18
C401	GATE	a_562_123##6	2.07705e-20
C402	VPWR	a_685_59##5	1.22535e-17
C403	VGND#5	VNB	6.0955e-17
C404	VGND#3	VNB	6.08349e-17
C405	VGND	a_562_123##8	6.68658e-18
C406	VGND#2	VNB	4.38074e-17
C407	VPWR#5	VNB	5.63473e-17
C408	VGND	a_685_59##4	7.56352e-18
C409	VPWR	a_386_326##11	4.13053e-18
C410	VPWR#3	VNB	7.4376e-17
C411	VPWR	a_419_392#	3.19984e-17
C412	VPWR#2	VNB	4.45054e-17
C413	VGND	a_386_326##8	6.08419e-17
C414	VPWR	a_592_149##8	6.64283e-18
C415	VGND	a_239_85#	2.26541e-17
C416	VPWR	a_229_392##2	2.69252e-17
C417	VGND	a_592_149##6	9.23581e-18
C418	a_386_326##8	a_386_326##11	1.44895e-18
C419	VPWR	a_419_392##2	1.18365e-17
C420	VGND	a_239_85##2	1.99511e-17
C421	VPWR	a_229_392#	2.53285e-17
C422	VGND	a_116_424##5	2.05613e-17
C423	a_562_123##10	VNB	3.28139e-17
C424	VPWR	a_116_424##7	1.9404e-17
C425	VGND	VGND#6	7.99076e-17
C426	VPWR	VPWR#6	8.45865e-17
C427	VPWR#1	GATE	2.64514e-18
C428	D#5	VNB	6.27186e-18
C429	VGND	a_386_326##11	2.44805e-18
C430	D	a_116_424##4	4.38429e-19
C431	Q#1	VNB	5.02575e-17
C432	VGND	a_592_149##8	6.73539e-19
C433	a_562_123##8	VNB	4.63884e-18
C434	a_685_59##4	VNB	3.84962e-18
C435	VGND	a_419_392##2	2.82996e-18
C436	a_386_326##8	VNB	2.13405e-17
C437	a_239_85#	VNB	3.55698e-18
C438	VGND	a_229_392#	2.2493e-18
C439	GATE	a_386_326##5	7.9393e-18
C440	a_592_149##6	VNB	5.83599e-19
C441	GATE	GATE#2	5.58812e-18
C442	VGND#9	VNB	2.67147e-18
C443	a_239_85##2	VNB	2.39041e-17
C444	a_116_424##5	VNB	1.7697e-17
C445	VGND	GATE#3	9.88862e-18
C446	VPWR	GATE#1	7.52511e-18
C447	a_562_123##4	GATE	1.65055e-17
C448	VGND#6	VNB	7.34309e-17
C449	VGND	a_562_123##7	8.90353e-18
C450	Q#2	VNB	6.99864e-17
C451	VPWR#7	VNB	6.00212e-18
C452	VGND	a_592_149#	5.28419e-18
C453	VPWR	a_592_149##4	8.72085e-18
C454	a_685_59##5	VNB	9.14137e-19
C455	VPWR	a_685_59##3	2.19212e-18
C456	a_386_326##11	VNB	3.63862e-18
C457	VPWR	a_562_123#	2.01405e-18
C458	a_419_392#	VNB	8.58643e-18
C459	VGND	a_116_424#	6.5106e-18
C460	a_592_149##8	VNB	3.41663e-18
C461	VGND	D#1	7.23106e-18
C462	a_229_392##2	VNB	1.44163e-17
C463	VPWR	a_116_424##4	1.33662e-20
C464	a_419_392##2	VNB	4.03056e-18
C465	VPWR	D#3	1.18025e-18
C466	a_229_392#	VNB	1.60757e-17
C467	a_116_424##7	VNB	1.54089e-17
C468	VPWR#6	VNB	8.01998e-17
C469	a_386_326##4	VNB	3.66047e-17
C470	GATE#3	VNB	3.3111e-17
C471	a_562_123##7	VNB	3.35698e-17
C472	VPWR	VPWR#4	8.61051e-17
C473	a_592_149#	VNB	2.86273e-17
C474	a_685_59#	VNB	3.24888e-17
C475	D	a_116_424##3	2.95329e-17
C476	a_562_123##3	VNB	2.45847e-17
C477	a_386_326##2	VNB	4.02859e-17
C478	D	D#2	1.74231e-17
C479	a_116_424#	VNB	3.40562e-17
C480	D#1	VNB	4.03951e-17
C481	VPWR	a_562_123##4	9.01029e-22
C482	a_386_326##6	VNB	4.58997e-17
C483	GATE#1	VNB	3.90809e-17
C484	a_562_123##6	VNB	3.92955e-17
C485	VPWR	a_685_59##2	7.48432e-18
C486	a_592_149##4	VNB	5.23845e-17
C487	VGND	VGND#4	8.01286e-17
C488	a_685_59##3	VNB	5.26218e-17
C489	VPWR	a_562_123##2	1.83619e-17
C490	a_562_123#	VNB	4.18008e-17
C491	VGND	a_386_326##5	9.09449e-18
C492	a_386_326##3	VNB	6.23018e-17
C493	a_116_424##4	VNB	5.04511e-17
C494	VGND	a_562_123##4	4.27737e-18
C495	VPWR	a_116_424##3	4.08486e-18
C496	D#3	VNB	5.09405e-17
C497	VGND	a_592_149##3	1.52587e-17
C498	VPWR#1	VNB	1.07034e-16
C499	VGND	a_685_59##2	4.8545e-18
C500	VGND#1	VNB	1.0941e-16
C501	VGND	a_562_123##2	4.88562e-18
C502	VPWR#4	VNB	4.79694e-17
C503	VGND#4	VNB	5.06473e-17
C504	VGND	a_386_326#	5.03819e-17
C505	a_386_326##5	VNB	3.62357e-17
C506	VGND	a_116_424##3	1.14488e-17
C507	GATE#2	VNB	2.02957e-17
C508	VGND	D#2	6.34886e-18
C509	a_562_123##4	VNB	4.59977e-17
C510	a_592_149##3	VNB	7.18385e-17
C511	a_685_59##2	VNB	7.78955e-17
C512	a_562_123##2	VNB	6.3506e-17
C513	a_386_326#	VNB	5.70336e-17
C514	VPWR#7	Q#2	8.91141e-17
C515	a_116_424##3	VNB	7.26724e-17
C516	D#2	VNB	7.60316e-17
C517	a_685_59##2	a_592_149##2	2.35193e-18
C518	VPWR	GATE	3.66746e-18
C519	VPWR	D	6.45305e-18
C520	GATE	VNB	4.01739e-18
C521	D	VNB	1.28807e-17
C522	a_592_149##6	a_592_149##8	1.98188e-18
C523	VPWR	VNB	3.22295e-16
C524	VGND	VNB	3.16858e-16
*
*
.ENDS sky130_fd_sc_hs__dlxtp_1
*
