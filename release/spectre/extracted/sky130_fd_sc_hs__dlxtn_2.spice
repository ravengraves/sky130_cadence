* Extracted by Quantus, converted by sky130cad/quantus.py
*
*
*
*                       LINUX           Wed Nov 18 08:33:39 2026
*
*
*
*  PROGRAM  advgen
*
*  Name           : advgen - Quantus - (64-bit)
*  Version        : 25.1.0-p047
*  Build Date     : Thu Dec 11 23:20:30 PST 2025
*
*  HSPICE LIBRARY
*
*  OPERATING_TEMPERATURE 150
*  QRC_TECH_DIR <path>/tech
*
*
*

*
.SUBCKT sky130_fd_sc_hs__dlxtn_2 VPB VNB VGND VPWR Q D GATE_N
*
*
*  caps2d version: 10
*
*
*       TRANSISTOR CARDS
*
*
XM8 a_27_120##6 D#4 VGND#12 VNB sky130_fd_pr__nfet_01v8_lvt l=0.15 w=0.55 ad=0.15675 as=0.37805 pd=1.67 ps=2.82
XM4 VGND#12 GATE_N#3 a_232_82##13 VNB sky130_fd_pr__nfet_01v8_lvt l=0.15 w=0.74 ad=0.37805 as=0.2109 pd=2.82 ps=2.05
XM10 a_369_392##9 a_232_82# VGND#11 VNB sky130_fd_pr__nfet_01v8_lvt l=0.15 w=0.74 ad=0.2109 as=0.4794 pd=2.05 ps=2.9
XM19 VGND#11 a_27_120# a_658_79# VNB sky130_fd_pr__nfet_01v8_lvt l=0.15 w=0.64 ad=0.4794 as=0.1536 pd=2.9 ps=1.76
XM15 a_658_79# a_232_82##7 a_669_392##5 VNB sky130_fd_pr__nfet_01v8_lvt l=0.15 w=0.64 ad=0.1536 as=0.2803 pd=1.76 ps=2.53
XM1 a_669_392##5 a_369_392##3 a_875_139# VNB sky130_fd_pr__nfet_01v8_lvt l=0.15 w=0.42 ad=0.2803 as=0.1008 pd=2.53 ps=1.32
XM17 a_875_139# a_842_405# VGND#10 VNB sky130_fd_pr__nfet_01v8_lvt l=0.15 w=0.42 ad=0.1008 as=0.2424 pd=1.32 ps=2.2
XM5 VGND#10 a_669_392# a_842_405##16 VNB sky130_fd_pr__nfet_01v8_lvt l=0.15 w=0.74 ad=0.2424 as=0.2109 pd=2.2 ps=2.05
XM6 VGND#9 a_842_405##9 Q#3 VNB sky130_fd_pr__nfet_01v8_lvt l=0.15 w=0.74 ad=0.2109 as=0.2516 pd=2.05 ps=2.16
XM7 Q#3 a_842_405##8 VGND#1 VNB sky130_fd_pr__nfet_01v8_lvt l=0.15 w=0.74 ad=0.2516 as=0.2294 pd=2.16 ps=2.1
XM3 a_27_120##7 D#1 VPWR#12 VPB sky130_fd_pr__pfet_01v8 l=0.15 w=0.84 ad=0.2478 as=0.336 pd=2.27 ps=2.48
XM0 VPWR#12 GATE_N#1 a_232_82##10 VPB sky130_fd_pr__pfet_01v8 l=0.15 w=0.84 ad=0.336 as=0.2478 pd=2.48 ps=2.27
XM16 a_369_392##8 a_232_82##4 VPWR#11 VPB sky130_fd_pr__pfet_01v8 l=0.15 w=0.84 ad=0.2478 as=0.51025 pd=2.27 ps=3.23
XM9 VPWR#11 a_27_120##3 a_585_392# VPB sky130_fd_pr__pfet_01v8 l=0.15 w=1 ad=0.51025 as=0.27 pd=3.23 ps=2.54
XM13 a_585_392# a_369_392# a_669_392##4 VPB sky130_fd_pr__pfet_01v8 l=0.15 w=1 ad=0.27 as=0.405175 pd=2.54 ps=2.92
XM11 a_669_392##4 a_232_82##8 a_791_503# VPB sky130_fd_pr__pfet_01v8 l=0.15 w=0.42 ad=0.405175 as=0.1134 pd=2.92 ps=1.38
XM14 a_791_503# a_842_405##3 VPWR#10 VPB sky130_fd_pr__pfet_01v8 l=0.15 w=0.42 ad=0.1134 as=0.4963 pd=1.38 ps=3.72
XM18 VPWR#10 a_669_392##3 a_842_405##13 VPB sky130_fd_pr__pfet_01v8 l=0.15 w=1.12 ad=0.4963 as=0.3304 pd=3.72 ps=2.83
XM2 VPWR#9 a_842_405##10 Q#1 VPB sky130_fd_pr__pfet_01v8 l=0.15 w=1.12 ad=0.3304 as=0.3864 pd=2.83 ps=2.93
XM12 Q#1 a_842_405##4 VPWR#1 VPB sky130_fd_pr__pfet_01v8 l=0.15 w=1.12 ad=0.3864 as=0.3304 pd=2.93 ps=2.83
*
*
*       RESISTOR AND CAP/DIODE CARDS
*
Rg1	D#1	D#2	511.139404
Rg2	D#2	D#3	36.873295
Rg3	D#2	D#4	264.985596
Rg4	GATE_N#1	GATE_N#2	446.679230
Rg5	GATE_N#2	GATE_N#3	452.116608
Rg6	a_232_82#	a_232_82##2	321.243988
Rg7	a_232_82##2	a_232_82##3	230.171799
Rg8	a_232_82##2	a_232_82##4	528.412537
Rg9	a_27_120#	a_27_120##2	453.931213
Rg10	a_27_120##2	a_27_120##3	475.028809
Rg11	a_369_392#	a_369_392##2	560.440308
Rg12	a_232_82##5	a_232_82##6	42.425991
Rg13	a_232_82##6	a_232_82##7	504.645050
Rg14	a_232_82##6	a_232_82##8	484.596893
Rg15	a_369_392##3	a_369_392##4	216.119781
Rg16	a_842_405#	a_842_405##2	694.063599
Rg17	a_842_405##2	a_842_405##3	266.904297
Rg18	a_669_392#	a_669_392##2	360.526642
Rg19	a_669_392##2	a_669_392##3	456.142303
Rg20	a_842_405##4	a_842_405##5	528.366760
Rg21	a_842_405##5	a_842_405##6	73.137985
Rg22	a_842_405##6	a_842_405##7	48.981556
Rg23	a_842_405##5	a_842_405##8	420.276489
Rg24	a_842_405##6	a_842_405##9	394.096527
Rg25	a_842_405##6	a_842_405##10	440.005463
Rf1	D#5	D#3	160.919952
Rf2	D	D#7	0.687145
Rf3	D#5	D#7	7.873454
Rf4	GATE_N#2	GATE_N#5	161.216980
Rf5	GATE_N#6	GATE_N	0.984182
Rf6	GATE_N#5	GATE_N#6	1.968364
Rf7	a_27_120##2	a_27_120##5	392.689117
Rf8	a_27_120##5	a_27_120##6	25.932501
Rf9	a_27_120##5	a_27_120##7	107.816383
Rf10	a_232_82##5	a_232_82##11	463.369080
Rf11	a_232_82##11	a_232_82##3	63.287655
Rf12	a_232_82##3	a_232_82##13	35.220261
Rf13	a_232_82##10	a_232_82##11	7.500000
Rf14	a_369_392##4	a_369_392##2	269.779724
Rf15	a_369_392##2	a_369_392##7	82.054825
Rf16	a_369_392##7	a_369_392##8	27.529640
Rf17	a_369_392##7	a_369_392##9	67.443802
Rf18	a_669_392##4	a_669_392##6	114.072311
Rf19	a_669_392##6	a_669_392##2	257.486145
Rf20	a_669_392##5	a_669_392##6	15.000000
Rf21	a_842_405##7	a_842_405##12	89.387390
Rf22	a_842_405##12	a_842_405##14	40.872318
Rf23	a_842_405##14	a_842_405##2	190.689087
Rf24	a_842_405##12	a_842_405##16	46.293102
Rf25	a_842_405##13	a_842_405##14	5.000000
Rf26	Q	Q#2	11.151382
Rf27	Q#2	Q	1.742403
Rf28	Q	Q#3	91.782806
Rf29	Q#1	Q#2	15.000000
Rf30	VPWR#1	VPWR#2	52.666801
Rf31	VPWR#2	VPWR#3	74.573433
Rf32	VPWR#3	VPWR#4	90.166389
Rf33	VPWR#4	VPWR#5	99.418404
Rf34	VPWR#5	VPWR#6	60.416367
Rf35	VPWR#6	VPWR#7	117.005966
Rf37	VPWR#3	VPWR#9	54.766842
Rf38	VPWR#4	VPWR#10	15.943003
Rf39	VPWR#6	VPWR#11	26.340607
Rf40	VPWR#7	VPWR#12	32.715752
Rf41	VGND#1	VGND#2	36.772179
Rf42	VGND#2	VGND#3	72.172134
Rf43	VGND#3	VGND#4	73.572090
Rf44	VGND#4	VGND#5	118.682518
Rf45	VGND#5	VGND#6	27.734655
Rf46	VGND#6	VGND#7	159.931519
Rf48	VGND#3	VGND#9	36.091866
Rf49	VGND#4	VGND#10	31.829987
Rf50	VGND#6	VGND#11	32.322075
Rf51	VGND#7	VGND#12	24.468842
Re1	VPWR#2	VPWR	11.068454
Re2	VPWR	VPWR#5	0.790604
Re3	VGND#2	VGND	11.068454
Re4	VGND	VGND#5	0.790604
*
*       CAPACITOR CARDS
*
*
C1	a_842_405##16	a_842_405##9	1.51353e-18
C2	VPWR#4	a_232_82##8	2.9529e-18
C3	VGND#9	a_669_392#	2.95744e-18
C4	a_842_405##13	VPWR#10	6.2289e-19
C5	VGND#10	a_842_405##9	7.69806e-19
C6	a_27_120##2	a_232_82##6	1.66851e-18
C7	a_232_82##2	a_27_120##2	3.48222e-17
C8	a_842_405##16	a_669_392#	1.85754e-17
C9	a_232_82##13	a_232_82##10	2.83179e-18
C10	VGND#4	a_669_392##5	1.51735e-18
C11	VPWR#4	a_369_392#	5.86998e-19
C12	VGND#10	a_669_392#	4.39688e-17
C13	Q#1	a_842_405##5	1.20373e-17
C14	a_27_120##6	a_369_392##8	1.19299e-18
C15	a_842_405##16	a_842_405#	1.03596e-18
C16	a_669_392##5	a_842_405##9	2.06459e-19
C17	VPWR#6	a_27_120##3	4.72202e-18
C18	a_842_405#	VGND#10	1.44915e-17
C19	a_842_405##16	a_369_392##3	4.38613e-19
C20	VPWR#4	a_27_120##3	3.09061e-20
C21	a_669_392##5	a_669_392#	1.10799e-18
C22	a_232_82##3	a_232_82##2	1.5262e-17
C23	a_27_120##6	VPWR#12	1.59792e-18
C24	VGND#10	a_369_392##3	1.74814e-18
C25	VGND#6	VGND#4	1.86722e-19
C26	VPWR#6	a_232_82##4	5.67995e-18
C27	a_669_392##5	a_842_405#	2.68303e-18
C28	VGND#11	a_669_392#	4.17698e-19
C29	a_27_120##6	a_27_120##7	3.31763e-18
C30	VGND#10	a_232_82##7	3.44314e-19
C31	a_669_392##5	a_369_392##3	3.75131e-17
C32	VGND#10	a_27_120#	1.53991e-19
C33	a_842_405##12	Q#3	1.43162e-17
C34	a_669_392##5	a_232_82##7	3.78991e-17
C35	VGND#6	a_232_82##2	1.40148e-19
C36	a_842_405##13	a_842_405##5	1.03819e-19
C37	VGND#4	VGND#3	8.97465e-19
C38	a_669_392##5	a_27_120#	1.30158e-18
C39	a_842_405##12	VGND#9	4.11731e-17
C40	a_369_392##8	a_669_392##4	5.29934e-18
C41	VGND#11	a_232_82##7	1.55102e-18
C42	a_842_405##13	a_232_82##6	8.0078e-19
C43	a_232_82##10	a_669_392##4	2.11741e-17
C44	VGND#3	a_842_405##5	6.93568e-21
C45	VGND#11	a_27_120#	5.28724e-17
C46	a_369_392##8	VPWR#11	2.16468e-18
C47	a_232_82#	VGND#11	4.88017e-18
C48	VGND#6	a_27_120##6	1.414e-17
C49	a_232_82##10	VPWR#11	7.51066e-17
C50	VGND#3	VGND#2	1.10192e-18
C51	a_369_392##9	a_232_82#	3.04397e-17
C52	a_232_82##10	a_369_392##8	9.71771e-17
C53	VPWR#12	VPWR#11	8.04698e-19
C54	VPWR#3	VPWR#2	6.45357e-19
C55	a_369_392##9	GATE_N#3	9.98035e-19
C56	a_27_120##6	a_27_120#	1.49843e-19
C57	a_232_82##13	GATE_N#3	2.77831e-17
C58	a_27_120##6	a_232_82#	2.29425e-18
C59	VPWR#12	a_232_82##10	6.40406e-17
C60	GATE_N#3	VGND#12	7.36912e-18
C61	a_232_82##13	D#4	2.34409e-18
C62	a_27_120##7	a_232_82##10	8.28532e-18
C63	a_27_120##6	GATE_N#3	3.90318e-17
C64	D#4	VGND#12	1.41654e-17
C65	GATE_N#6	a_232_82##4	9.67199e-20
C66	a_27_120##7	VPWR#12	7.03459e-17
C67	a_27_120##6	D#4	4.22233e-17
C68	VGND#3	a_842_405##7	2.4152e-19
C69	a_669_392##4	a_232_82##7	2.82539e-18
C70	a_669_392##4	a_232_82##6	1.45756e-17
C71	VGND#4	a_669_392##2	1.3844e-18
C72	VPWR#3	a_842_405##7	3.44117e-19
C73	VPWR#1	a_842_405##4	2.64177e-17
C74	a_842_405##9	a_842_405##8	3.00465e-17
C75	a_369_392#	a_232_82##6	7.07036e-18
C76	Q#1	a_842_405##4	3.91132e-17
C77	VGND#4	a_842_405##2	3.18731e-19
C78	VPWR#1	a_842_405##10	1.53263e-18
C79	VPWR#4	a_669_392##2	3.93617e-19
C80	VPWR#9	a_842_405##4	1.75921e-18
C81	Q#1	a_842_405##10	3.65019e-17
C82	a_669_392#	a_842_405##9	5.58653e-18
C83	a_842_405##13	a_842_405##4	5.77674e-19
C84	VPWR#1	a_669_392##3	2.85844e-19
C85	a_842_405##12	a_842_405##7	3.91394e-17
C86	a_232_82##10	a_27_120#	2.06686e-19
C87	a_842_405##10	VPWR#9	2.22006e-17
C88	VGND#4	a_369_392##4	2.23692e-17
C89	VPWR#6	VPWR#4	4.11934e-20
C90	VPWR#6	a_232_82##2	3.17227e-20
C91	Q#1	a_669_392##3	4.86207e-19
C92	a_842_405##2	VPWR#4	4.96251e-17
C93	a_842_405##13	a_842_405##10	2.20702e-18
C94	VPWR#9	a_669_392##3	3.44674e-18
C95	VPWR#4	VPWR#9	2.91346e-18
C96	a_842_405#	a_669_392#	2.09359e-17
C97	a_669_392##2	a_842_405##12	4.0659e-17
C98	VPWR#4	a_232_82##6	3.80951e-19
C99	a_842_405##13	a_669_392##3	9.24964e-17
C100	VPWR#9	a_842_405##3	3.39811e-19
C101	a_669_392##3	VPWR#10	1.38083e-17
C102	a_842_405##13	a_842_405##3	9.89806e-19
C103	a_842_405##13	VPWR#4	5.16801e-17
C104	VPWR#3	a_842_405##5	8.4484e-21
C105	a_369_392##3	a_842_405#	3.52995e-17
C106	a_842_405##12	a_842_405##2	5.73451e-20
C107	VPWR#11	a_232_82##2	3.19646e-19
C108	VGND#6	a_369_392##2	7.7921e-19
C109	a_842_405##3	VPWR#10	1.36335e-17
C110	VPWR#4	VPWR#3	1.12917e-18
C111	a_232_82##7	a_842_405#	5.06948e-19
C112	a_232_82##5	VPWR#4	7.30482e-17
C113	a_842_405##13	a_232_82##8	2.90305e-19
C114	a_842_405##13	VPWR#3	6.96233e-18
C115	VGND#2	VGND#1	1.81554e-17
C116	VPWR#4	VPWR#10	1.08975e-17
C117	a_232_82##7	a_369_392##3	1.48316e-17
C118	VGND#2	Q#3	7.83562e-18
C119	a_669_392##4	a_842_405##3	7.92133e-19
C120	VGND#6	a_27_120##2	4.207e-17
C121	a_369_392##8	a_232_82##6	4.76025e-20
C122	VGND#3	a_842_405##12	7.12375e-19
C123	a_669_392##4	a_232_82##8	3.35351e-17
C124	a_842_405##12	Q#1	2.88775e-17
C125	a_369_392##8	a_232_82##2	7.65384e-18
C126	a_232_82##5	a_842_405##12	1.14977e-18
C127	a_27_120#	a_232_82##7	5.08664e-17
C128	a_669_392##4	a_369_392#	4.09065e-17
C129	VGND#6	a_232_82##3	3.88111e-20
C130	a_232_82##10	a_842_405##3	1.12765e-19
C131	a_842_405##12	VPWR#9	2.15588e-17
C132	a_669_392##4	a_27_120##3	3.77727e-18
C133	a_232_82#	a_27_120#	7.15098e-18
C134	VPWR#11	a_369_392#	6.29994e-19
C135	Q#3	a_842_405##5	5.65723e-18
C136	a_232_82##10	a_232_82##8	3.59225e-19
C137	Q#3	VGND#1	7.41665e-17
C138	Q#3	a_842_405##7	3.63723e-18
C139	VPWR#6	a_232_82##3	1.29464e-19
C140	a_369_392##8	a_369_392#	5.06029e-19
C141	a_669_392##4	a_232_82##4	9.46331e-19
C142	VGND#9	a_842_405##7	6.79379e-18
C143	a_27_120##3	VPWR#11	3.08919e-17
C144	a_232_82##10	a_232_82##2	8.91945e-19
C145	a_232_82##10	a_369_392#	1.9098e-17
C146	GATE_N#3	a_232_82#	1.77784e-18
C147	a_842_405##16	a_842_405##7	6.24231e-20
C148	a_369_392##8	a_27_120##3	8.91545e-18
C149	VGND#9	VGND#1	1.76216e-18
C150	a_669_392##4	GATE_N#1	1.59212e-19
C151	Q#3	a_669_392##2	8.34785e-20
C152	a_232_82##4	VPWR#11	2.90514e-17
C153	a_232_82##10	a_27_120##3	3.5679e-17
C154	a_369_392##8	a_232_82##4	3.98194e-17
C155	a_842_405##16	a_669_392##2	1.74086e-17
C156	VGND#2	VPWR#1	4.93889e-18
C157	VPWR#12	a_27_120##3	4.82771e-19
C158	D#4	GATE_N#3	1.84139e-17
C159	VPWR#11	GATE_N#1	1.56954e-18
C160	VGND#9	Q#3	6.29653e-17
C161	a_669_392##2	VGND#10	3.50994e-17
C162	a_232_82##10	a_232_82##4	1.83552e-17
C163	VPWR#11	VPWR#4	1.54107e-19
C164	a_369_392##8	GATE_N#1	1.3372e-18
C165	VPWR#11	D#1	3.29551e-19
C166	a_669_392##5	a_669_392##2	1.57221e-18
C167	a_232_82##10	GATE_N#1	6.04614e-17
C168	a_842_405##16	Q#3	3.74378e-19
C169	a_27_120##7	a_232_82##4	5.22186e-19
C170	GATE_N#1	VPWR#12	2.85528e-17
C171	a_232_82##10	D#1	1.67263e-18
C172	a_27_120##7	GATE_N#1	3.45849e-18
C173	a_669_392##5	a_842_405##2	7.47601e-18
C174	a_842_405##16	VGND#9	6.00801e-17
C175	D#1	VPWR#12	3.30254e-17
C176	a_369_392##4	VGND#10	2.12133e-17
C177	a_842_405##12	VPWR#3	6.04649e-19
C178	a_232_82##10	VPWR#6	1.78516e-17
C179	a_842_405##16	a_842_405##5	2.67344e-20
C180	a_27_120##7	D#1	5.65729e-17
C181	a_369_392##4	a_669_392##5	5.53126e-17
C182	Q#1	a_842_405##7	1.00086e-17
C183	VGND#10	VGND#9	1.65342e-18
C184	VPWR#9	a_842_405##7	5.40843e-18
C185	GATE_N#6	a_232_82##3	1.50831e-17
C186	a_842_405##10	a_842_405##4	3.87298e-17
C187	VGND#11	a_369_392##4	4.9352e-17
C188	a_842_405##13	a_842_405##7	4.2583e-19
C189	VPWR#2	a_842_405##5	7.08931e-20
C190	Q#1	a_669_392##2	1.02788e-19
C191	a_232_82##13	GATE_N#5	1.24084e-17
C192	a_669_392##5	a_232_82##5	3.97693e-17
C193	GATE_N#5	a_232_82##3	2.00804e-17
C194	VGND#10	a_842_405##16	5.26698e-17
C195	a_669_392##2	a_842_405##13	2.63118e-17
C196	a_669_392##3	a_842_405##10	6.61815e-18
C197	GATE_N#6	GATE_N#2	7.83611e-18
C198	a_232_82##10	VPWR#5	2.30536e-17
C199	a_369_392##2	a_669_392##5	6.80618e-17
C200	a_669_392##2	VPWR#10	5.53262e-19
C201	GATE_N#5	GATE_N#2	1.1594e-17
C202	VGND#2	a_842_405##8	3.98227e-18
C203	a_842_405##13	a_842_405##2	6.327e-19
C204	VGND#11	a_369_392##2	2.49597e-17
C205	a_842_405##3	a_669_392##3	5.1219e-18
C206	a_842_405##2	VPWR#10	9.10255e-18
C207	a_842_405##12	a_842_405##5	1.21034e-19
C208	GATE_N#6	D#3	1.9067e-18
C209	a_669_392##5	a_27_120##2	1.18805e-19
C210	VGND#3	a_842_405##9	4.14048e-18
C211	a_27_120##6	GATE_N#5	1.33634e-17
C212	VGND#2	a_842_405##5	3.45333e-19
C213	a_669_392##5	a_842_405##16	3.5217e-18
C214	GATE_N#5	D#3	2.83062e-18
C215	a_669_392##4	a_842_405##2	1.43119e-18
C216	a_27_120##2	VGND#11	1.06182e-16
C217	VGND#4	a_669_392#	3.51375e-18
C218	a_27_120##2	a_369_392##9	8.58068e-17
C219	a_232_82##8	a_842_405##3	2.47034e-17
C220	D#5	D#3	1.68623e-17
C221	a_842_405##12	a_232_82##6	1.57985e-19
C222	a_232_82##5	a_842_405##13	8.24822e-18
C223	a_669_392##5	VGND#10	6.64114e-18
C224	a_369_392##4	a_669_392##4	1.38291e-18
C225	a_27_120##6	a_27_120##2	1.49979e-18
C226	a_232_82##3	a_369_392##9	6.02774e-17
C227	a_369_392#	a_232_82##8	2.02197e-17
C228	a_232_82##3	a_232_82##13	8.75817e-20
C229	VPWR#5	a_232_82##7	5.822e-20
C230	a_232_82##5	a_669_392##4	1.40293e-16
C231	VGND#4	a_842_405#	2.99391e-18
C232	VPWR#5	a_27_120#	2.63848e-20
C233	a_669_392##2	a_842_405##9	1.45747e-19
C234	a_27_120##6	a_232_82##3	4.36161e-17
C235	VGND#5	a_232_82##7	4.42207e-18
C236	D#5	a_27_120##6	5.74891e-17
C237	a_27_120##3	a_369_392#	4.7261e-17
C238	a_669_392##2	a_669_392#	3.26362e-18
C239	a_369_392##2	a_669_392##4	5.92053e-17
C240	a_232_82##13	GATE_N#2	2.37762e-18
C241	VGND#5	a_27_120#	9.9979e-19
C242	a_669_392##2	a_842_405#	5.46631e-17
C243	VPWR#2	a_842_405##4	1.09403e-17
C244	VGND#11	VGND#10	4.41075e-20
C245	a_232_82##10	a_232_82##5	1.50613e-18
C246	a_27_120##6	GATE_N#2	3.04451e-18
C247	VPWR#2	a_842_405##10	5.14116e-19
C248	a_369_392##8	a_369_392##2	2.141e-18
C249	a_232_82##4	a_27_120##3	2.0768e-17
C250	D#3	VGND#12	6.19403e-19
C251	a_369_392##2	a_232_82##10	1.1151e-17
C252	a_369_392##4	a_669_392#	5.86409e-18
C253	a_369_392##3	a_842_405##2	2.2265e-18
C254	VPWR#11	a_27_120##2	3.23147e-19
C255	GATE_N#1	a_27_120##3	3.67551e-19
C256	a_27_120##6	D#3	1.62805e-17
C257	a_27_120##2	a_369_392##8	5.95324e-17
C258	a_369_392##4	a_842_405#	1.08685e-17
C259	VGND#1	VPWR#1	1.16636e-17
C260	GATE_N#1	a_232_82##4	5.01668e-18
C261	a_232_82##10	a_27_120##2	1.25425e-18
C262	a_369_392##4	a_369_392##3	6.96241e-19
C263	a_669_392##5	a_232_82##6	1.39838e-17
C264	a_369_392##4	a_232_82##7	3.9542e-17
C265	a_232_82##5	a_842_405#	2.11557e-18
C266	a_232_82##3	a_369_392##8	5.99127e-17
C267	VGND#5	a_232_82##6	1.7818e-20
C268	a_842_405##7	a_842_405##4	1.20657e-18
C269	a_232_82##5	a_369_392##3	3.24546e-18
C270	a_369_392##4	a_27_120#	8.94083e-18
C271	a_232_82##3	a_232_82##10	4.92345e-18
C272	D#1	GATE_N#1	2.70979e-17
C273	VGND#6	a_27_120#	8.33158e-19
C274	a_232_82##5	a_232_82##7	1.66379e-19
C275	a_232_82#	a_369_392##4	2.18916e-19
C276	VPWR#5	a_232_82##8	2.36492e-18
C277	a_369_392##8	GATE_N#2	1.57633e-19
C278	a_27_120##7	a_232_82##3	2.74966e-18
C279	a_669_392##3	a_842_405##7	7.09862e-19
C280	a_232_82##10	GATE_N#2	1.00267e-19
C281	VPWR#5	a_369_392#	4.41812e-18
C282	a_232_82##6	a_842_405#	6.4451e-18
C283	a_369_392##2	a_232_82##7	5.77458e-18
C284	VPWR#12	GATE_N#2	2.02847e-18
C285	Q#3	Q#1	3.02647e-18
C286	a_27_120#	a_369_392##2	2.37865e-17
C287	a_27_120##7	GATE_N#2	4.08508e-18
C288	a_369_392##2	a_232_82#	8.12499e-20
C289	a_27_120##2	a_232_82##7	3.53328e-19
C290	VGND#6	a_232_82#	4.41432e-18
C291	a_842_405##2	a_669_392##3	2.74943e-17
C292	a_27_120##2	a_27_120#	1.06165e-18
C293	a_842_405##7	a_842_405##5	2.90428e-18
C294	a_27_120##7	D#3	1.288e-17
C295	a_27_120##2	a_232_82#	3.36748e-17
C296	a_232_82##8	a_842_405##2	1.51548e-17
C297	a_27_120##2	GATE_N#3	2.3024e-19
C298	a_232_82##5	a_842_405##10	1.68227e-19
C299	a_232_82##3	a_232_82#	1.40358e-17
C300	a_232_82##5	a_669_392##3	9.93675e-19
C301	GATE_N#3	a_232_82##3	2.04758e-17
C302	a_232_82##5	a_842_405##3	1.11362e-17
C303	a_369_392##3	a_232_82##6	9.03456e-18
C304	a_232_82##3	D#4	6.39754e-19
C305	a_232_82##5	a_232_82##8	1.80398e-17
C306	VPWR	a_842_405##5	1.35341e-22
C307	VPWR	a_232_82##6	4.71661e-19
C308	a_232_82##10	a_585_392#	1.28613e-18
C309	a_232_82##5	a_369_392#	7.51382e-18
C310	a_232_82##5	a_27_120##3	1.21987e-19
C311	D#3	GATE_N#3	3.3647e-19
C312	a_369_392##2	a_369_392#	7.49931e-18
C313	a_369_392##2	a_27_120##3	1.37253e-17
C314	a_669_392##2	a_232_82##6	1.42092e-18
C315	a_842_405##16	a_842_405##13	4.13039e-18
C316	a_369_392##2	a_232_82##4	2.75769e-19
C317	GATE_N#6	a_232_82##10	4.76948e-18
C318	a_232_82##4	a_27_120##2	3.80199e-18
C319	a_232_82##3	a_232_82##4	1.27624e-17
C320	a_669_392##2	a_842_405##7	2.27737e-17
C321	VGND	a_842_405##5	5.13071e-23
C322	a_27_120##6	a_369_392##9	9.98872e-18
C323	VGND	a_232_82##2	1.19351e-18
C324	VGND#5	a_369_392##4	6.41982e-17
C325	GATE_N#2	a_232_82##4	1.6057e-18
C326	a_232_82##5	VPWR#5	4.14782e-17
C327	GATE_N#6	VPWR#12	5.9399e-18
C328	a_842_405#	a_875_139#	8.35249e-18
C329	a_232_82##3	D#1	1.34319e-19
C330	a_842_405##2	a_669_392##2	2.026e-17
C331	a_369_392##3	a_875_139#	8.35249e-18
C332	VPWR#5	a_369_392##2	2.77928e-20
C333	a_842_405##3	a_791_503#	1.99463e-18
C334	D#1	GATE_N#2	2.28772e-18
C335	a_232_82##5	a_842_405##7	6.431e-20
C336	VGND#5	a_369_392##2	3.0015e-19
C337	a_232_82##8	a_791_503#	4.66374e-18
C338	a_27_120##6	a_232_82##13	4.1229e-17
C339	VPWR#5	a_27_120##2	1.05291e-20
C340	a_232_82##6	a_842_405##2	3.50085e-17
C341	a_232_82##5	a_669_392##2	7.91751e-18
C342	a_27_120##7	GATE_N#6	1.20228e-17
C343	a_369_392##9	a_232_82##2	1.65592e-17
C344	a_232_82##5	a_842_405##2	5.24748e-17
C345	Q	VPWR#3	6.9908e-18
C346	a_369_392#	a_585_392#	1.14986e-17
C347	a_232_82##5	a_369_392##4	1.69018e-19
C348	a_27_120##6	VGND#12	5.76155e-18
C349	a_27_120##3	a_585_392#	1.93494e-17
C350	a_232_82##7	a_658_79#	8.64788e-18
C351	a_27_120#	a_658_79#	1.91306e-18
C352	a_842_405##5	VNB	4.23388e-17
C353	a_369_392##2	a_232_82##5	4.52352e-19
C354	a_27_120##2	a_369_392##4	1.6331e-20
C355	a_232_82##6	VNB	6.57296e-17
C356	a_232_82##2	VNB	2.03269e-17
C357	VPWR	VPWR#6	7.22578e-17
C358	a_27_120##7	GATE_N#5	6.37715e-18
C359	VPWR	VPWR#4	1.3196e-16
C360	VPWR	VPWR#3	7.14377e-17
C361	a_27_120##2	a_369_392##2	7.35218e-17
C362	VPWR	a_842_405##12	4.34372e-18
C363	a_369_392##4	a_232_82##6	1.79191e-18
C364	VGND#3	VGND#1	2.64803e-19
C365	VGND	VGND#6	7.73907e-17
C366	VGND	VGND#4	8.30953e-17
C367	VGND	VGND#3	5.6501e-17
C368	VPWR	GATE_N#6	3.7614e-18
C369	GATE_N#2	a_232_82##3	3.61014e-17
C370	a_232_82##5	a_791_503#	1.07613e-17
C371	Q	VPWR#1	4.52836e-17
C372	D#3	a_232_82##3	1.99203e-18
C373	Q	Q#1	2.68417e-18
C374	VGND	a_842_405##12	4.75799e-18
C375	VPWR#9	Q	4.5001e-17
C376	D	a_27_120##7	4.51071e-17
C377	D#3	GATE_N#2	3.19649e-17
C378	a_369_392##2	a_585_392#	1.16794e-18
C379	D#5	a_27_120##7	8.15662e-19
C380	VGND	GATE_N#5	4.49758e-18
C381	VGND#3	Q#3	7.38857e-18
C382	VGND#6	VNB	4.29479e-17
C383	VPWR#3	a_842_405##4	5.19799e-19
C384	VGND#4	VNB	4.34536e-17
C385	VGND#3	VNB	3.03853e-17
C386	VGND	D#5	3.58541e-18
C387	Q#1	VPWR#1	3.59493e-17
C388	VPWR	a_842_405##13	2.09702e-17
C389	VGND	Q#3	1.85807e-17
C390	VPWR#6	VNB	3.91238e-17
C391	VPWR#4	VNB	5.13519e-17
C392	VGND	VGND#9	1.83107e-17
C393	VPWR#3	VNB	3.05801e-17
C394	VGND	a_842_405##16	1.71947e-17
C395	VPWR	a_669_392##4	1.273e-17
C396	VGND	VGND#10	2.22378e-17
C397	a_369_392##4	a_658_79#	6.25283e-18
C398	VGND	a_669_392##5	1.5088e-17
C399	VPWR	VPWR#11	1.76048e-17
C400	a_842_405##12	VNB	8.86138e-18
C401	a_232_82##5	a_232_82##6	2.44831e-17
C402	VPWR	a_369_392##8	9.9717e-18
C403	VGND	VGND#11	1.78484e-17
C404	VPWR	a_232_82##10	5.52171e-17
C405	VGND	a_369_392##9	8.59705e-18
C406	VGND	a_232_82##13	2.92346e-18
C407	VPWR	VPWR#12	1.91142e-17
C408	a_369_392##2	a_658_79#	5.95267e-18
C409	VPWR	a_27_120##7	1.96483e-17
C410	VGND	a_27_120##6	5.23729e-17
C411	VPWR#4	a_842_405##10	8.91193e-19
C412	VGND	Q#1	2.24204e-18
C413	VGND	VPWR#9	2.80707e-18
C414	GATE_N#6	VNB	9.43724e-19
C415	Q	a_842_405##4	2.02678e-17
C416	VGND	a_842_405##13	2.12738e-18
C417	VPWR#9	VPWR#1	3.6322e-18
C418	GATE_N#5	VNB	1.73009e-18
C419	Q	a_842_405##10	1.96327e-17
C420	VPWR	a_369_392##3	2.71877e-20
C421	D#5	VNB	9.06341e-18
C422	VGND#1	VNB	4.19753e-17
C423	Q#3	VNB	1.18089e-17
C424	VGND#9	VNB	1.19486e-18
C425	VGND	a_369_392##8	2.49582e-18
C426	a_842_405##16	VNB	1.57258e-17
C427	VGND#10	VNB	1.1482e-18
C428	VPWR#3	a_842_405##10	8.08419e-18
C429	a_669_392##5	VNB	5.57835e-18
C430	VGND#1	a_842_405##8	3.12024e-17
C431	VGND#11	VNB	1.57787e-18
C432	VGND	a_842_405##8	2.4935e-18
C433	VPWR	a_842_405##4	9.53799e-19
C434	a_369_392##9	VNB	5.08996e-19
C435	VGND	a_842_405##9	8.63467e-19
C436	a_232_82##13	VNB	2.15938e-18
C437	VPWR	a_842_405##10	2.39046e-18
C438	VGND	a_669_392#	4.62741e-18
C439	VPWR	a_669_392##3	9.23282e-18
C440	a_27_120##6	VNB	5.20372e-17
C441	VGND	a_842_405#	8.42817e-18
C442	VPWR#1	VNB	5.28809e-17
C443	VPWR	a_842_405##3	2.77387e-18
C444	Q#1	VNB	1.06997e-17
C445	VGND	a_232_82##7	2.76836e-18
C446	VPWR#9	VNB	2.75711e-18
C447	VPWR	a_232_82##8	1.74366e-21
C448	VGND#4	a_842_405##16	9.15209e-18
C449	a_842_405##13	VNB	1.9279e-17
C450	VGND	a_27_120#	4.10338e-18
C451	Q	VPWR#2	6.90548e-18
C452	VPWR#9	Q#1	3.49267e-17
C453	VPWR	a_369_392#	1.63628e-18
C454	VGND	a_232_82#	5.95203e-18
C455	VPWR	a_27_120##3	9.52155e-20
C456	VGND	GATE_N#3	3.58036e-18
C457	VGND	D#4	9.61371e-18
C458	VPWR	a_232_82##4	8.47542e-18
C459	VPWR#11	VNB	5.02516e-18
C460	VPWR	GATE_N#1	2.14724e-18
C461	a_369_392##8	VNB	5.32217e-18
C462	a_232_82##10	VNB	1.78466e-17
C463	VPWR	D#1	1.09391e-18
C464	VPWR#12	VNB	4.55536e-18
C465	a_842_405##8	Q#3	2.16244e-17
C466	a_27_120##7	VNB	5.08692e-17
C467	VPWR#4	a_669_392##3	1.69749e-17
C468	a_842_405##8	VNB	2.88007e-17
C469	VGND#6	VGND#10	3.38157e-20
C470	VPWR	VPWR#2	1.28748e-17
C471	a_842_405##9	VNB	3.10762e-17
C472	a_669_392#	VNB	3.32988e-17
C473	a_842_405#	VNB	4.0131e-17
C474	a_369_392##3	VNB	1.79699e-17
C475	VPWR	VPWR#5	4.72058e-17
C476	a_232_82##7	VNB	3.65525e-17
C477	a_27_120#	VNB	3.85546e-17
C478	a_232_82#	VNB	3.43879e-17
C479	VGND#1	a_842_405##9	2.86456e-18
C480	VPWR	a_842_405##7	1.36149e-18
C481	GATE_N#3	VNB	3.67421e-17
C482	D#4	VNB	3.67089e-17
C483	VPWR	a_669_392##2	2.96766e-18
C484	D	D#3	9.79844e-18
C485	VPWR	a_842_405##2	7.09851e-18
C486	a_842_405##4	VNB	4.05338e-17
C487	a_842_405##10	VNB	3.55263e-17
C488	a_842_405##13	Q#1	2.43369e-18
C489	VGND	VGND#2	1.15172e-17
C490	a_669_392##3	VNB	4.47921e-17
C491	a_842_405##3	VNB	2.43455e-17
C492	VPWR	a_232_82##5	3.37136e-17
C493	VGND#3	a_842_405##16	6.29045e-18
C494	a_232_82##8	VNB	4.12465e-17
C495	VGND	VGND#5	4.76193e-17
C496	VPWR	a_369_392##2	6.54205e-18
C497	a_369_392#	VNB	3.44938e-17
C498	VGND#9	a_842_405##8	2.69517e-18
C499	VGND	a_842_405##7	3.17011e-18
C500	a_27_120##3	VNB	3.48681e-17
C501	VPWR	a_27_120##2	4.32264e-18
C502	a_369_392##2	a_232_82##6	3.15691e-17
C503	a_232_82##4	VNB	5.54343e-17
C504	VGND	a_669_392##2	7.21934e-18
C505	GATE_N#1	VNB	4.01513e-17
C506	VPWR	a_232_82##3	2.31197e-18
C507	D#1	VNB	4.54501e-17
C508	VGND	a_369_392##4	4.92547e-17
C509	VPWR#2	VNB	9.57015e-17
C510	VGND	a_232_82##5	2.08551e-18
C511	VGND#2	VNB	9.58021e-17
C512	VGND	a_369_392##2	4.7191e-18
C513	VPWR#5	VNB	2.85604e-17
C514	VGND	a_27_120##2	2.55943e-17
C515	a_842_405##9	Q#3	2.34706e-17
C516	VGND#5	VNB	2.82641e-17
C517	a_369_392##2	a_232_82##2	1.55501e-19
C518	a_842_405##7	VNB	8.04538e-17
C519	VGND	a_232_82##3	1.43574e-17
C520	a_669_392##2	VNB	2.76113e-17
C521	a_27_120##6	a_232_82##2	5.7457e-20
C522	a_842_405##2	VNB	6.77169e-17
C523	a_369_392##4	VNB	4.54105e-17
C524	a_232_82##5	VNB	1.84736e-17
C525	a_369_392##2	VNB	2.72251e-17
C526	a_27_120##2	VNB	5.93158e-17
C527	a_232_82##3	VNB	9.40815e-17
C528	VPWR#4	a_842_405##3	2.31728e-17
C529	a_842_405##13	VPWR#9	8.25659e-17
C530	GATE_N#2	VNB	2.91581e-17
C531	a_842_405##16	a_842_405##8	3.90734e-20
C532	D#3	VNB	7.24354e-17
C533	VPWR	D	6.40196e-18
C534	VGND#9	a_842_405##9	5.83301e-17
C535	VPWR	Q	1.92304e-17
C536	D	VNB	1.5341e-17
C537	VPWR	VNB	3.05117e-16
C538	VGND	VNB	3.11383e-16
C539	VGND#10	VGND#3	2.332e-19
C540	Q#3	a_669_392#	3.77641e-20
C541	a_27_120##7	VPWR#7	2.09735e-17
C542	VGND#7	GATE_N#3	9.57832e-18
C543	VGND#7	VGND#12	5.46026e-18
C544	VGND#7	D#4	2.82962e-18
C545	VPWR	VPWR#7	1.09928e-16
C546	VGND#7	a_27_120##6	1.18554e-16
C547	VPWR#7	D#1	2.56951e-18
C548	VGND	VGND#7	1.25409e-16
C549	GATE_N#6	VPWR#7	3.11023e-19
C550	a_232_82##10	VPWR#7	2.07709e-17
C551	VGND#7	a_232_82##3	1.04783e-18
C552	VPWR#7	D#3	7.97592e-19
C553	VGND#7	VNB	8.01255e-17
C554	VGND#7	GATE_N#2	2.92441e-20
C555	D	VPWR#7	1.17184e-18
C556	VPWR#7	VPWR#11	2.75408e-19
C557	VGND#7	D#3	8.92438e-19
C558	VPWR#7	a_232_82##3	7.89876e-20
C559	VPWR#7	VPWR#6	7.23293e-20
C560	VGND#7	a_232_82#	3.97149e-19
C561	VPWR#7	GATE_N#1	4.57086e-18
C562	VPWR#7	VNB	6.41245e-17
*
*
.ENDS sky130_fd_sc_hs__dlxtn_2
*
