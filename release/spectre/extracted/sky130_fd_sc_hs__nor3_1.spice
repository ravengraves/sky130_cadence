* Extracted by Quantus, converted by sky130cad/quantus.py
*
*
*
*                       LINUX           Wed Nov 18 08:49:56 2026
*
*
*
*  PROGRAM  advgen
*
*  Name           : advgen - Quantus - (64-bit)
*  Version        : 25.1.0-p047
*  Build Date     : Thu Dec 11 23:20:30 PST 2025
*
*  HSPICE LIBRARY
*
*  OPERATING_TEMPERATURE 150
*  QRC_TECH_DIR <path>/tech
*
*
*

*
.SUBCKT sky130_fd_sc_hs__nor3_1 VPB VNB VGND VPWR Y A B C
*
*
*  caps2d version: 10
*
*
*       TRANSISTOR CARDS
*
*
XM4 VGND#3 A#4 Y#3 VNB sky130_fd_pr__nfet_01v8_lvt l=0.15 w=0.74 ad=0.2109 as=0.2072 pd=2.05 ps=2.04
XM1 Y#3 B#1 VGND#4 VNB sky130_fd_pr__nfet_01v8_lvt l=0.15 w=0.74 ad=0.2072 as=0.259 pd=2.04 ps=2.18
XM0 VGND#4 C#3 Y#1 VNB sky130_fd_pr__nfet_01v8_lvt l=0.15 w=0.74 ad=0.259 as=0.2109 pd=2.18 ps=2.05
XM2 VPWR#2 A#1 a_114_368# VPB sky130_fd_pr__pfet_01v8 l=0.15 w=1.12 ad=0.3192 as=0.3024 pd=2.81 ps=2.78
XM3 a_114_368# B#3 a_198_368# VPB sky130_fd_pr__pfet_01v8 l=0.15 w=1.12 ad=0.3024 as=0.4032 pd=2.78 ps=2.96
XM5 a_198_368# C#4 Y#4 VPB sky130_fd_pr__pfet_01v8 l=0.15 w=1.12 ad=0.4032 as=0.3192 pd=2.96 ps=2.81
*
*
*       RESISTOR AND CAP/DIODE CARDS
*
Rg1	A#1	A#2	507.075531
Rg2	A#2	A#3	186.892303
Rg3	A#2	A#4	322.953644
Rg4	B#1	B#2	353.846649
Rg5	B#2	B#3	456.846832
Rg6	C#1	C#2	26.676205
Rg7	C#2	C#3	368.862610
Rg8	C#2	C#4	471.862823
Rf1	A	A#3	14.062221
Rf2	A#3	A	4.520000
Rf3	B#2	B#5	163.189606
Rf4	B#6	B	2.956806
Rf5	B#5	B#6	6.596592
Rf6	C	C#1	168.106262
Rf7	Y#1	Y#2	55.383293
Rf8	Y#2	Y#3	23.657215
Rf9	Y#2	Y	83.927963
Rf10	Y	Y#5	5.871251
Rf11	Y#5	Y	0.391417
Rf12	Y#4	Y#5	5.000000
Rf14	VGND#2	VGND#3	71.629517
Rf15	VGND#2	VGND#4	36.037033
Rf16	VPWR#1	VPWR#2	83.936043
Re1	VPWR#1	VPWR	2.455682
Re2	VGND	VGND#2	2.455774
*
*       CAPACITOR CARDS
*
*
C1	C#1	C#2	1.26558e-17
C2	VGND	VNB	5.24759e-17
C3	C#2	Y#4	3.64017e-19
C4	VPWR	VNB	5.4586e-17
C5	Y	VNB	6.59961e-17
C6	A	VNB	2.6286e-17
C7	B	VNB	2.58316e-18
C8	C	VNB	1.1161e-17
C9	VGND	A	2.648e-18
C10	VPWR	Y	4.73957e-17
C11	VGND	B	1.93945e-18
C12	A#3	VNB	5.19555e-17
C13	VPWR	A	2.00148e-18
C14	B#2	VNB	3.07524e-17
C15	C#1	VNB	9.0514e-18
C16	VPWR	B	1.79868e-18
C17	A	Y	2.02265e-17
C18	VPWR#1	VNB	1.81237e-16
C19	VPWR	C	2.66638e-18
C20	B	Y	3.11386e-17
C21	A#1	VNB	4.26917e-17
C22	VGND	A#3	1.2739e-18
C23	B#3	VNB	3.56518e-17
C24	VGND	B#2	3.79238e-19
C25	C#4	VNB	4.398e-17
C26	C	Y	3.90232e-17
C27	VGND	C#1	3.81894e-18
C28	A#4	VNB	3.15738e-17
C29	Y	a_114_368#	4.27973e-18
C30	B#1	VNB	2.32287e-17
C31	C#3	VNB	3.17012e-17
C32	VPWR#2	VNB	4.78933e-17
C33	Y	a_198_368#	3.51362e-18
C34	B	C	2.19592e-17
C35	VGND#3	VNB	5.70263e-17
C36	Y	A#3	2.34001e-18
C37	Y#3	VNB	4.30845e-18
C38	VGND#4	VNB	1.50556e-18
C39	Y#1	VNB	4.18075e-17
C40	VPWR	VPWR#1	4.8445e-17
C41	Y	B#2	4.11366e-18
C42	VGND	A#4	3.17115e-18
C43	B#5	VNB	4.00814e-19
C44	VGND	B#1	4.16546e-19
C45	A	A#3	2.41864e-17
C46	VPWR	A#1	3.60559e-18
C47	VGND	C#3	6.26449e-19
C48	Y#2	VNB	6.42421e-18
C49	VPWR	B#3	3.12633e-19
C50	VPWR	C#4	1.00181e-18
C51	Y	VPWR#1	6.07901e-17
C52	VGND	VGND#3	3.62038e-17
C53	Y	A#1	2.60791e-17
C54	VGND	Y#3	1.15347e-17
C55	B	B#2	5.56892e-18
C56	VGND	VGND#4	1.81414e-17
C57	Y	B#3	5.29277e-17
C58	VGND	Y#1	1.75184e-17
C59	B	C#1	1.92032e-17
C60	VPWR	VPWR#2	2.51612e-17
C61	Y	C#4	6.22797e-17
C62	VGND	B#5	1.47331e-18
C63	C	B#2	4.60754e-19
C64	A	A#1	3.262e-18
C65	VGND	Y#2	3.54095e-18
C66	VPWR#2	Y	9.78925e-17
C67	B#2	a_198_368#	1.9761e-19
C68	VPWR	B#5	1.34005e-18
C69	Y	Y#4	6.2043e-18
C70	B	C#4	2.05052e-18
C71	A	VPWR#2	2.53211e-17
C72	C	B#3	1.5085e-19
C73	A#3	B#2	3.59241e-17
C74	C	C#4	3.25162e-18
C75	Y#1	Y	3.91466e-18
C76	A#1	a_114_368#	5.67542e-18
C77	Y	B#5	4.10976e-17
C78	B#3	a_114_368#	1.98517e-17
C79	VGND#3	A	2.37511e-17
C80	C#1	B#2	4.89787e-19
C81	B#3	a_198_368#	2.65061e-17
C82	Y#2	Y	2.56822e-18
C83	C#4	a_198_368#	2.69666e-17
C84	VPWR#1	B#2	8.22806e-20
C85	B	VGND#4	6.9553e-19
C86	Y#1	B	2.39423e-17
C87	A	Y#2	3.64962e-17
C88	A#1	B#2	2.05413e-18
C89	Y#2	B	4.63233e-18
C90	C#2	VNB	5.85491e-17
C91	VPWR#1	C#2	1.91988e-19
C92	A#3	B#1	1.6864e-18
C93	VPWR#1	A#1	7.55329e-19
C94	VPWR#2	A#3	1.60261e-18
C95	VPWR#1	B#3	5.32509e-18
C96	VPWR#1	C#4	5.3429e-18
C97	A#1	B#3	5.54586e-17
C98	A#3	VGND#3	9.16878e-18
C99	B#3	C#4	3.58338e-17
C100	VGND	C#2	8.2883e-19
C101	VGND#4	B#2	6.53955e-19
C102	B#5	A#3	3.33952e-18
C103	B#5	B#2	1.1447e-17
C104	C#1	Y#1	3.34722e-17
C105	VPWR#2	A#1	3.83446e-17
C106	Y#2	A#3	8.11166e-18
C107	VPWR#2	B#3	2.90059e-18
C108	Y#2	B#2	6.14791e-18
C109	VPWR#2	C#4	1.01987e-18
C110	A#4	B#1	3.85753e-17
C111	Y#1	C#2	7.06118e-18
C112	B#1	C#3	2.78443e-17
C113	C#4	Y#4	1.15424e-17
C114	B#5	A#1	1.03822e-18
C115	VGND#3	A#4	3.13249e-17
C116	B#5	B#3	2.04934e-18
C117	A#4	Y#3	1.77202e-17
C118	VGND#3	B#1	2.5494e-18
C119	Y	C#2	3.4706e-18
C120	VGND#4	A#4	2.37122e-18
C121	B#1	Y#3	1.55056e-17
C122	Y#1	A#4	7.07548e-19
C123	VGND#4	B#1	3.33675e-17
C124	Y#3	C#3	1.04906e-18
C125	VGND#3	VPWR#2	6.99602e-20
C126	Y#1	B#1	1.97328e-18
C127	C#3	VGND#4	2.21444e-17
C128	Y#1	C#3	4.93455e-17
C129	Y#2	A#4	1.15959e-17
C130	VGND#3	Y#3	4.19911e-17
C131	Y#2	B#1	1.86275e-17
C132	VGND#3	VGND#4	2.78418e-18
C133	Y#2	C#3	4.49509e-20
C134	Y#3	VGND#4	3.20084e-17
C135	B	C#2	7.18892e-18
C136	Y#3	Y#1	3.66617e-18
C137	Y#1	VGND#4	5.23225e-17
C138	B#5	VGND#4	3.1615e-19
C139	C	C#2	1.06888e-17
C140	VGND#3	Y#2	2.14232e-17
C141	Y#2	Y#3	2.8628e-19
C142	Y#2	VGND#4	1.41273e-17
C143	Y#2	B#5	4.22045e-17
C144	Y#2	C#2	2.54722e-19
C145	B#2	C#2	2.93335e-17
C146	VGND#2	Y#2	3.94204e-19
C147	VGND#2	Y#3	1.08792e-17
C148	VGND#2	C#2	3.34678e-19
C149	VGND#2	A#4	3.76311e-19
C150	VGND#2	C#1	5.01029e-19
C151	VGND#2	B#1	9.59264e-19
C152	VGND#2	Y#1	2.10579e-17
C153	VGND#2	VNB	1.59494e-16
C154	VGND#2	C#3	2.71842e-18
C155	VGND#2	VGND#3	2.67037e-17
C156	VGND	VGND#2	3.5826e-17
*
*
.ENDS sky130_fd_sc_hs__nor3_1
*
