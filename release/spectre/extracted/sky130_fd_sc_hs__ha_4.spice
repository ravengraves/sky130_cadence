* Extracted by Quantus, converted by sky130cad/quantus.py
*
*
*
*                       LINUX           Wed Nov 18 08:41:09 2026
*
*
*
*  PROGRAM  advgen
*
*  Name           : advgen - Quantus - (64-bit)
*  Version        : 25.1.0-p047
*  Build Date     : Thu Dec 11 23:20:30 PST 2025
*
*  HSPICE LIBRARY
*
*  OPERATING_TEMPERATURE 150
*  QRC_TECH_DIR <path>/tech
*
*
*

*
.SUBCKT sky130_fd_sc_hs__ha_4 VPB VNB VGND SUM VPWR COUT A B
*
*
*  caps2d version: 10
*
*
*       TRANSISTOR CARDS
*
*
XM33 VGND#18 A#9 a_27_125##5 VNB sky130_fd_pr__nfet_01v8_lvt l=0.15 w=0.64 ad=0.1824 as=0.1824 pd=1.85 ps=1.85
XM23 a_27_125##6 A#5 VGND#18 VNB sky130_fd_pr__nfet_01v8_lvt l=0.15 w=0.64 ad=0.1792 as=0.1824 pd=1.84 ps=1.85
XM2 VGND#17 B#5 a_27_125##6 VNB sky130_fd_pr__nfet_01v8_lvt l=0.15 w=0.64 ad=0.1792 as=0.1792 pd=1.84 ps=1.84
XM29 a_27_125##2 B#9 VGND#17 VNB sky130_fd_pr__nfet_01v8_lvt l=0.15 w=0.64 ad=0.1984 as=0.1792 pd=1.9 ps=1.84
XM7 a_294_392##18 a_435_99##7 a_27_125##2 VNB sky130_fd_pr__nfet_01v8_lvt l=0.15 w=0.64 ad=0.2048 as=0.1984 pd=1.92 ps=1.9
XM21 a_27_125# a_435_99##5 a_294_392##18 VNB sky130_fd_pr__nfet_01v8_lvt l=0.15 w=0.64 ad=0.2144 as=0.2048 pd=1.95 ps=1.92
XM5 a_707_119##4 B#8 a_435_99##29 VNB sky130_fd_pr__nfet_01v8_lvt l=0.15 w=0.64 ad=0.1856 as=0.1792 pd=1.86 ps=1.84
XM17 a_435_99##29 B#12 a_707_119##2 VNB sky130_fd_pr__nfet_01v8_lvt l=0.15 w=0.64 ad=0.1792 as=0.224 pd=1.84 ps=1.98
XM26 a_707_119##2 A#4 VGND#16 VNB sky130_fd_pr__nfet_01v8_lvt l=0.15 w=0.64 ad=0.224 as=0.224 pd=1.98 ps=1.98
XM22 VGND#16 A#10 a_707_119# VNB sky130_fd_pr__nfet_01v8_lvt l=0.15 w=0.64 ad=0.224 as=0.176 pd=1.98 ps=1.83
XM27 COUT#6 a_435_99##20 VGND#15 VNB sky130_fd_pr__nfet_01v8_lvt l=0.15 w=0.74 ad=0.2072 as=0.2035 pd=2.04 ps=2.03
XM8 VGND#14 a_435_99##18 COUT#6 VNB sky130_fd_pr__nfet_01v8_lvt l=0.15 w=0.74 ad=0.2072 as=0.2072 pd=2.04 ps=2.04
XM18 COUT#4 a_435_99##16 VGND#14 VNB sky130_fd_pr__nfet_01v8_lvt l=0.15 w=0.74 ad=0.2072 as=0.2072 pd=2.04 ps=2.04
XM15 VGND#13 a_435_99##8 COUT#4 VNB sky130_fd_pr__nfet_01v8_lvt l=0.15 w=0.74 ad=0.2072 as=0.2072 pd=2.04 ps=2.04
XM0 SUM#8 a_294_392##13 VGND#13 VNB sky130_fd_pr__nfet_01v8_lvt l=0.15 w=0.74 ad=0.2072 as=0.2072 pd=2.04 ps=2.04
XM9 VGND#12 a_294_392##11 SUM#8 VNB sky130_fd_pr__nfet_01v8_lvt l=0.15 w=0.74 ad=0.259 as=0.2072 pd=2.18 ps=2.04
XM19 SUM#7 a_294_392##9 VGND#12 VNB sky130_fd_pr__nfet_01v8_lvt l=0.15 w=0.74 ad=0.2997 as=0.259 pd=2.29 ps=2.18
XM12 VGND#1 a_294_392##8 SUM#7 VNB sky130_fd_pr__nfet_01v8_lvt l=0.15 w=0.74 ad=0.2109 as=0.2997 pd=2.05 ps=2.29
XM25 a_27_392##4 A#13 VPWR#17 VPB sky130_fd_pr__pfet_01v8 l=0.15 w=1 ad=0.285 as=0.3 pd=2.57 ps=2.6
XM10 VPWR#17 A#12 a_27_392##2 VPB sky130_fd_pr__pfet_01v8 l=0.15 w=1 ad=0.3 as=0.3 pd=2.6 ps=2.6
XM31 a_27_392##2 B#11 a_294_392##19 VPB sky130_fd_pr__pfet_01v8 l=0.15 w=1 ad=0.3 as=0.3 pd=2.6 ps=2.6
XM13 a_294_392##19 B#10 a_27_392# VPB sky130_fd_pr__pfet_01v8 l=0.15 w=1 ad=0.3 as=0.285 pd=2.6 ps=2.57
XM16 a_294_392##15 a_435_99##6 VPWR#15 VPB sky130_fd_pr__pfet_01v8 l=0.15 w=0.84 ad=0.252 as=0.2394 pd=2.28 ps=2.25
XM34 VPWR#13 a_435_99# a_294_392##15 VPB sky130_fd_pr__pfet_01v8 l=0.15 w=0.84 ad=0.252 as=0.252 pd=2.28 ps=2.28
XM1 VPWR#13 B#6 a_435_99##25 VPB sky130_fd_pr__pfet_01v8 l=0.15 w=0.84 ad=0.252 as=0.445075 pd=2.28 ps=3.16
XM11 a_435_99##25 B#1 VPWR#11 VPB sky130_fd_pr__pfet_01v8 l=0.15 w=0.84 ad=0.445075 as=0.252 pd=3.16 ps=2.28
XM32 VPWR#11 A#11 a_435_99##23 VPB sky130_fd_pr__pfet_01v8 l=0.15 w=0.84 ad=0.252 as=0.35175 pd=2.28 ps=2.85
XM3 a_435_99##23 A#1 VPWR#9 VPB sky130_fd_pr__pfet_01v8 l=0.15 w=0.84 ad=0.35175 as=0.546 pd=2.85 ps=3.26
XM20 COUT#3 a_435_99##21 VPWR#9 VPB sky130_fd_pr__pfet_01v8 l=0.15 w=1.12 ad=0.5152 as=0.546 pd=3.16 ps=3.26
XM24 VPWR#7 a_435_99##19 COUT#3 VPB sky130_fd_pr__pfet_01v8 l=0.15 w=1.12 ad=0.336 as=0.5152 pd=2.84 ps=3.16
XM35 VPWR#7 a_435_99##17 COUT#1 VPB sky130_fd_pr__pfet_01v8 l=0.15 w=1.12 ad=0.336 as=0.336 pd=2.84 ps=2.84
XM4 COUT#1 a_435_99##15 VPWR#5 VPB sky130_fd_pr__pfet_01v8 l=0.15 w=1.12 ad=0.336 as=0.336 pd=2.84 ps=2.84
XM6 SUM#5 a_294_392##7 VPWR#5 VPB sky130_fd_pr__pfet_01v8 l=0.15 w=1.12 ad=0.336 as=0.336 pd=2.84 ps=2.84
XM30 VPWR#3 a_294_392##12 SUM#5 VPB sky130_fd_pr__pfet_01v8 l=0.15 w=1.12 ad=0.336 as=0.336 pd=2.84 ps=2.84
XM14 SUM#1 a_294_392##10 VPWR#3 VPB sky130_fd_pr__pfet_01v8 l=0.15 w=1.12 ad=0.6272 as=0.336 pd=3.36 ps=2.84
XM28 VPWR#1 a_294_392# SUM#1 VPB sky130_fd_pr__pfet_01v8 l=0.15 w=1.12 ad=0.3304 as=0.6272 pd=2.83 ps=3.36
*
*
*       RESISTOR AND CAP/DIODE CARDS
*
Rg1	a_435_99#	a_435_99##2	371.262421
Rg2	a_435_99##2	a_435_99##3	59.971813
Rg3	a_435_99##3	a_435_99##4	36.319874
Rg4	a_435_99##4	a_435_99##5	238.204666
Rg5	a_435_99##3	a_435_99##6	338.338409
Rg6	a_435_99##4	a_435_99##7	464.261322
Rg7	B#1	B#2	624.426514
Rg8	B#2	B#3	1690.349731
Rg9	B#3	B#4	21.821857
Rg10	B#4	B#5	367.866791
Rg11	B#2	B#6	310.442566
Rg12	B#6	B#7	398.583832
Rg13	B#7	B#8	368.195953
Rg14	B#3	B#9	330.644562
Rg15	B#3	B#10	421.013580
Rg16	B#4	B#11	406.048950
Rg17	B#7	B#12	565.947266
Rg18	A#1	A#2	442.188629
Rg19	A#2	A#3	70.680183
Rg20	A#3	A#4	324.841888
Rg21	A#4	A#5	2991.199219
Rg22	A#5	A#6	346.428833
Rg23	A#6	A#7	25.675138
Rg24	A#7	A#8	27.660566
Rg25	A#8	A#9	340.169525
Rg26	A#2	A#10	324.841888
Rg27	A#3	A#11	533.954529
Rg28	A#6	A#12	435.098480
Rg29	A#8	A#13	421.885773
Rg30	a_435_99##8	a_435_99##9	395.797760
Rg31	a_435_99##9	a_435_99##10	59.578423
Rg32	a_435_99##10	a_435_99##11	26.421368
Rg33	a_435_99##11	a_435_99##12	49.178402
Rg34	a_435_99##12	a_435_99##13	26.329714
Rg35	a_435_99##13	a_435_99##14	19.223377
Rg36	a_435_99##9	a_435_99##15	466.045135
Rg37	a_435_99##10	a_435_99##16	390.565155
Rg38	a_435_99##11	a_435_99##17	410.441040
Rg39	a_435_99##12	a_435_99##18	370.797485
Rg40	a_435_99##13	a_435_99##19	398.356903
Rg41	a_435_99##14	a_435_99##20	381.028076
Rg42	a_435_99##14	a_435_99##21	516.875549
Rg43	a_294_392#	a_294_392##2	468.330475
Rg44	a_294_392##2	a_294_392##3	96.205193
Rg45	a_294_392##3	a_294_392##4	30.899055
Rg46	a_294_392##4	a_294_392##5	65.697388
Rg47	a_294_392##5	a_294_392##6	66.386444
Rg48	a_294_392##6	a_294_392##7	467.025726
Rg49	a_294_392##2	a_294_392##8	398.881775
Rg50	a_294_392##3	a_294_392##9	408.965149
Rg51	a_294_392##4	a_294_392##10	443.294220
Rg52	a_294_392##5	a_294_392##11	378.278412
Rg53	a_294_392##5	a_294_392##12	461.927856
Rg54	a_294_392##6	a_294_392##13	394.071777
Rf1	A	A#14	18.699453
Rf2	A#14	A	0.196836
Rf3	a_27_392#	a_27_392##3	106.021561
Rf4	a_27_392##3	a_27_392##4	99.453979
Rf5	a_27_392##2	a_27_392##3	5.000000
Rf6	B	B#13	16.927925
Rf7	B#13	B	1.968364
Rf8	a_27_125#	a_27_125##3	113.677322
Rf9	a_27_125##3	a_27_125##4	68.834961
Rf10	a_27_125##4	a_27_125##5	78.419868
Rf11	a_27_125##4	a_27_125##6	16.224981
Rf12	a_27_125##2	a_27_125##3	7.500000
Rf13	a_707_119#	a_707_119##3	120.043365
Rf14	a_707_119##3	a_707_119##4	110.470856
Rf15	a_707_119##2	a_707_119##3	7.500000
Rf16	a_435_99##14	a_435_99##24	128.771255
Rf17	a_435_99##24	a_435_99##26	70.957848
Rf18	a_435_99##26	a_435_99##27	25.386347
Rf19	a_435_99##27	a_435_99##2	186.235901
Rf20	a_435_99##27	a_435_99##29	40.265877
Rf21	a_435_99##23	a_435_99##24	15.000000
Rf22	a_435_99##25	a_435_99##26	15.000000
Rf23	COUT#2	COUT	6.209292
Rf24	COUT#2	COUT#3	50.627380
Rf25	COUT#2	COUT	12.382339
Rf26	COUT	COUT#5	12.759700
Rf27	COUT#5	COUT#6	62.531143
Rf28	COUT#1	COUT#2	15.000000
Rf29	COUT#4	COUT#5	15.000000
Rf30	a_294_392##4	a_294_392##16	463.426941
Rf31	a_294_392##16	a_294_392##17	27.180025
Rf32	a_294_392##17	a_294_392##18	70.953575
Rf33	a_294_392##17	a_294_392##19	87.855499
Rf34	a_294_392##15	a_294_392##16	15.000000
Rf35	SUM#1	SUM#2	16.000652
Rf36	SUM#2	SUM#3	23.432096
Rf37	SUM#2	SUM#4	13.983953
Rf38	SUM#4	SUM#5	49.302246
Rf39	SUM#3	SUM#6	116.950554
Rf40	SUM#6	SUM#7	16.968842
Rf41	SUM#6	SUM#8	88.883698
Rf42	VPWR#1	VPWR#2	133.894897
Rf43	VPWR#2	VPWR#3	35.623142
Rf44	VPWR#2	VPWR#4	48.188797
Rf45	VPWR#4	VPWR#5	33.326477
Rf46	VPWR#4	VPWR#6	65.696381
Rf47	VPWR#6	VPWR#7	33.326477
Rf48	VPWR#6	VPWR#8	81.909485
Rf49	VPWR#8	VPWR#9	29.485819
Rf50	VPWR#8	VPWR#10	81.909485
Rf51	VPWR#10	VPWR#11	34.704330
Rf52	VPWR#10	VPWR#12	92.713074
Rf53	VPWR#12	VPWR#13	44.304161
Rf54	VPWR#12	VPWR#14	52.571827
Rf55	VPWR#14	VPWR#15	41.593605
Rf56	VPWR#14	VPWR#16	143.187256
Rf57	VPWR#16	VPWR#17	38.992386
Rf59	VGND#1	VGND#2	108.678238
Rf60	VGND#2	VGND#3	24.447384
Rf61	VGND#3	VGND#4	43.440514
Rf62	VGND#4	VGND#5	62.774361
Rf63	VGND#5	VGND#6	65.753731
Rf64	VGND#6	VGND#7	67.945244
Rf65	VGND#7	VGND#8	128.179077
Rf66	VGND#8	VGND#9	133.349976
Rf67	VGND#9	VGND#10	63.254311
Rf69	VGND#2	VGND#12	34.507496
Rf70	VGND#4	VGND#13	32.539131
Rf71	VGND#5	VGND#14	32.539131
Rf72	VGND#6	VGND#15	41.038895
Rf73	VGND#7	VGND#16	40.195534
Rf74	VGND#9	VGND#17	50.329590
Rf75	VGND#10	VGND#18	50.329590
Rf76	A#7	A#14	160.232803
Rf77	B#3	B#13	160.232803
Re2	SUM	SUM#4	11.228309
Re3	VPWR#2	VPWR	2.687498
Re4	VPWR	VPWR#12	1.343749
Re5	VGND#3	VGND	2.687498
Re6	VGND	VGND#8	1.343749
Re7	SUM#3	SUM	9.777782
*
*       CAPACITOR CARDS
*
*
C1	a_27_125#	a_294_392##18	8.07016e-17
C2	a_27_125##6	A#9	1.9426e-18
C3	VGND#2	a_294_392##11	1.75338e-18
C4	a_27_125##5	A#5	9.6949e-19
C5	a_435_99##27	a_294_392##15	5.97641e-18
C6	VGND#18	A#9	3.09534e-17
C7	VGND#9	B#4	4.78152e-21
C8	a_294_392##9	a_294_392##8	2.31463e-17
C9	a_435_99##14	A#3	3.40444e-19
C10	a_435_99##27	B#1	1.25862e-19
C11	a_435_99##25	A#4	1.55811e-19
C12	VGND#4	a_294_392##13	3.83219e-18
C13	A#2	a_435_99##14	1.27168e-17
C14	a_27_125##2	a_27_125#	2.54741e-18
C15	VPWR#14	B#10	4.89722e-18
C16	a_27_125##5	A#9	2.83375e-17
C17	VGND#9	a_27_125##2	5.2057e-17
C18	a_294_392##17	a_435_99#	2.39731e-19
C19	a_435_99##14	B#7	8.79147e-19
C20	VPWR#10	VPWR#8	1.24341e-18
C21	VGND#2	a_294_392##13	2.92905e-19
C22	VGND#2	SUM#6	1.86348e-17
C23	A#2	a_435_99##21	1.17017e-18
C24	a_27_125##2	a_294_392##18	6.97756e-17
C25	a_294_392##11	a_294_392##9	2.37812e-17
C26	a_294_392##15	A#4	7.00684e-19
C27	a_435_99##27	A#3	4.00714e-18
C28	VGND#4	a_435_99##8	3.77092e-18
C29	a_294_392##17	a_435_99##6	7.11447e-18
C30	VPWR#14	B#11	8.07899e-20
C31	a_707_119#	A#2	1.71311e-17
C32	VGND#5	a_435_99##16	3.68327e-18
C33	a_294_392##13	a_294_392##11	3.95891e-17
C34	VPWR#1	a_294_392#	4.25236e-17
C35	SUM#6	a_294_392##8	3.17996e-17
C36	a_435_99##27	A#2	2.1204e-19
C37	a_435_99##2	B#4	1.70401e-18
C38	A#3	A#1	5.10295e-18
C39	a_435_99##2	B#2	5.80575e-19
C40	VGND#16	A#3	7.4955e-18
C41	A#3	A#2	2.03363e-18
C42	VPWR#14	A#12	2.47053e-20
C43	A#8	B#4	2.6962e-17
C44	a_294_392#	SUM#1	3.37379e-17
C45	a_27_125##2	VGND#17	5.99309e-17
C46	VGND#6	a_435_99##18	3.07897e-19
C47	a_435_99##2	a_435_99##4	2.78547e-17
C48	VGND#9	a_27_125##6	2.56677e-18
C49	VPWR#8	VPWR#6	1.09474e-18
C50	VPWR#1	a_294_392##10	1.3268e-18
C51	VPWR#3	a_294_392#	2.34189e-18
C52	VGND#5	a_435_99##18	1.22776e-18
C53	a_435_99##8	a_294_392##13	4.14028e-17
C54	a_435_99##27	B#7	4.432e-17
C55	VGND#7	a_435_99##20	8.51666e-19
C56	a_294_392##10	SUM#1	3.68348e-17
C57	SUM#6	a_294_392##9	2.86501e-17
C58	VGND#16	A#2	3.77157e-18
C59	SUM#5	a_294_392#	2.03089e-19
C60	a_27_125##6	a_27_125##2	3.4412e-18
C61	VPWR#14	A#13	2.44784e-20
C62	VPWR#3	a_294_392##10	5.12008e-17
C63	a_435_99##23	A#3	1.23587e-17
C64	VGND#6	a_435_99##20	7.20075e-18
C65	SUM#1	a_294_392##12	8.80718e-19
C66	SUM#5	a_294_392##10	5.53665e-19
C67	a_27_125##6	VGND#17	2.98988e-17
C68	a_435_99##16	a_435_99##8	4.11117e-17
C69	a_435_99##27	B#4	8.99134e-20
C70	a_707_119##2	A#3	1.92351e-17
C71	B#7	A#3	7.79627e-18
C72	a_435_99##23	A#2	2.06749e-18
C73	SUM#6	a_294_392##11	7.39322e-19
C74	VPWR#3	a_294_392##12	4.43214e-17
C75	VGND#7	A#10	8.18732e-19
C76	a_294_392##17	A#12	2.30763e-20
C77	a_27_125##4	a_27_392#	3.10954e-19
C78	SUM#1	a_294_392##7	2.22128e-19
C79	SUM#5	a_294_392##12	5.8971e-17
C80	VGND#18	VGND#17	5.90919e-18
C81	VPWR#6	VPWR#4	1.55834e-18
C82	VPWR#3	a_294_392##7	2.34914e-18
C83	VPWR#5	a_294_392##12	1.46617e-18
C84	a_707_119##2	A#2	1.88171e-18
C85	a_435_99##27	B#2	1.04885e-20
C86	a_435_99##18	a_435_99##16	3.96603e-17
C87	a_294_392##15	A#5	1.09351e-20
C88	SUM#5	a_294_392##7	1.89596e-17
C89	a_294_392##17	A#13	2.21892e-19
C90	VGND#18	a_27_125##6	2.91773e-17
C91	VGND#7	A#4	2.02689e-17
C92	a_27_125##4	a_294_392##19	4.38143e-18
C93	VPWR#5	a_294_392##7	4.14954e-17
C94	A#4	B#7	1.11763e-18
C95	a_707_119##2	B#7	1.25049e-18
C96	VGND#6	A#4	5.44663e-19
C97	SUM#5	a_435_99##15	1.32282e-18
C98	COUT#1	a_294_392##7	2.16768e-18
C99	a_294_392##17	VPWR#14	6.09318e-19
C100	a_435_99##27	a_435_99##4	2.90341e-19
C101	a_435_99##20	a_435_99##18	3.89006e-17
C102	a_27_125##5	a_27_125##6	3.32196e-18
C103	a_707_119##2	B#1	7.57669e-19
C104	VPWR#5	a_435_99##15	2.83271e-17
C105	VGND#5	A#4	2.18722e-20
C106	a_27_125##4	a_27_392##2	5.7169e-19
C107	a_294_392##19	A#5	7.13481e-20
C108	B#7	B#1	8.4181e-18
C109	B#12	A#3	9.26795e-18
C110	VGND#7	B#12	3.00796e-18
C111	SUM#5	a_435_99##17	7.13137e-19
C112	COUT#1	a_435_99##15	3.8478e-17
C113	a_27_392##2	A#5	7.29822e-19
C114	a_27_125##5	VGND#18	3.60264e-17
C115	VPWR#5	a_435_99##17	2.95157e-18
C116	SUM#6	SUM#3	2.78457e-18
C117	VPWR#7	a_435_99##15	2.95157e-18
C118	A#10	a_435_99##20	4.56865e-18
C119	A#4	a_435_99##4	4.12742e-18
C120	B#2	B#1	9.58142e-18
C121	COUT#1	a_435_99##17	4.66519e-17
C122	SUM#5	a_435_99##19	4.25462e-19
C123	B#7	B#12	6.11701e-18
C124	A#4	a_435_99##20	7.24652e-19
C125	VPWR#7	a_435_99##17	3.90792e-17
C126	B#6	A#3	6.94172e-19
C127	a_707_119#	a_435_99##23	3.93882e-17
C128	VPWR#11	B#2	1.66454e-18
C129	VGND#3	VGND#5	4.61536e-17
C130	A#4	A#10	2.57383e-17
C131	SUM#5	a_435_99##21	3.95876e-19
C132	SUM#4	SUM#6	5.42747e-18
C133	VGND#3	VGND#4	4.87828e-17
C134	SUM#4	SUM#2	1.98574e-17
C135	a_27_125##4	A#8	2.50275e-18
C136	VPWR#7	a_435_99##19	3.90048e-17
C137	VGND#3	VGND#2	7.56885e-17
C138	a_435_99##25	B#7	2.99612e-18
C139	VPWR#2	VPWR#6	4.27478e-17
C140	COUT#3	a_435_99##19	5.3621e-17
C141	COUT#1	a_435_99##21	1.81983e-20
C142	VPWR#2	VPWR#4	5.43322e-17
C143	A#4	B#12	4.01624e-17
C144	VPWR#7	a_435_99##21	4.09158e-18
C145	VPWR#9	a_435_99##19	2.62314e-18
C146	a_435_99##25	B#4	1.12046e-19
C147	a_707_119##2	a_435_99##23	3.55737e-17
C148	a_435_99##4	B#6	1.50689e-18
C149	VPWR#2	SUM#2	9.04797e-19
C150	a_435_99##21	COUT#3	3.0028e-17
C151	a_707_119##4	B#7	2.742e-18
C152	A#4	B#8	1.91975e-17
C153	VPWR#9	a_435_99##21	4.67724e-17
C154	VGND#9	a_435_99##7	1.24225e-18
C155	a_435_99##25	B#2	1.91672e-19
C156	SUM#1	VPWR#1	4.94953e-17
C157	a_294_392##18	A#8	2.95767e-19
C158	B#8	B#12	3.74311e-17
C159	VPWR#14	VPWR#12	2.83685e-18
C160	SUM#6	a_294_392##6	6.58377e-20
C161	VGND#3	SUM#6	2.17083e-17
C162	VPWR#12	VPWR#10	7.01227e-19
C163	a_435_99##25	a_435_99##4	3.57739e-19
C164	a_27_125#	a_294_392##17	7.07432e-19
C165	A#1	VPWR#9	3.00503e-17
C166	VPWR#11	a_435_99##21	1.06115e-18
C167	VGND#3	SUM#2	2.49014e-18
C168	VPWR#3	VPWR#1	9.59046e-19
C169	a_435_99##23	A#1	3.99786e-17
C170	a_435_99##4	B#8	4.47967e-18
C171	VGND#9	a_27_125##4	2.60513e-19
C172	a_435_99#	B#2	2.41299e-17
C173	a_707_119##2	a_435_99##25	1.25595e-17
C174	a_435_99##5	B#8	3.10692e-18
C175	a_294_392##15	A#3	3.39348e-19
C176	VGND#9	B#9	1.47797e-18
C177	VPWR#13	B#4	1.81549e-19
C178	a_707_119##4	B#2	3.54527e-19
C179	VPWR#11	A#1	1.59604e-18
C180	VPWR#9	A#11	3.88668e-18
C181	SUM#6	a_294_392##5	9.79682e-20
C182	VPWR#3	SUM#1	4.01472e-17
C183	a_435_99##23	A#11	3.26638e-17
C184	a_294_392##15	a_435_99##21	3.42387e-19
C185	a_294_392##18	a_294_392##17	4.59614e-18
C186	B#7	B#2	4.76307e-19
C187	a_294_392##15	A#2	3.36331e-19
C188	VPWR#13	B#2	9.06943e-18
C189	VPWR#11	A#11	3.422e-17
C190	VPWR#13	A#1	6.54392e-19
C191	VGND#4	a_294_392##4	4.83764e-19
C192	VPWR#9	B#1	6.68903e-20
C193	a_435_99##7	a_435_99##5	2.71321e-17
C194	VGND#2	a_294_392##4	9.09591e-20
C195	a_294_392##15	A#1	2.25413e-17
C196	a_435_99##23	B#1	6.02656e-19
C197	SUM#5	SUM#1	2.65498e-18
C198	a_294_392##8	VGND#1	2.66306e-17
C199	VGND#12	VGND#1	2.48062e-18
C200	VGND#9	B#5	8.33228e-19
C201	a_294_392##15	B#7	1.43926e-18
C202	a_435_99##27	a_707_119##2	2.99804e-17
C203	VGND#1	a_294_392##2	7.88863e-19
C204	VPWR#13	A#11	1.01647e-18
C205	VPWR#11	B#1	3.10899e-17
C206	B#4	a_435_99##6	3.43305e-17
C207	SUM#4	VGND#12	2.07797e-18
C208	a_27_125##2	a_294_392##17	5.68661e-19
C209	VGND#6	a_435_99##14	4.97037e-19
C210	a_435_99##6	B#2	1.77555e-17
C211	a_294_392##8	SUM#7	7.15031e-18
C212	a_294_392##15	A#11	2.08725e-17
C213	a_435_99##25	B#1	3.11952e-17
C214	a_435_99##23	B#6	3.46426e-19
C215	B#9	a_435_99##7	3.07708e-17
C216	VGND#5	a_435_99##14	1.94907e-19
C217	SUM#5	VPWR#3	5.84992e-17
C218	VPWR#10	A#3	8.85821e-20
C219	a_294_392##15	B#4	1.57118e-18
C220	a_294_392##4	VPWR#8	2.7135e-18
C221	a_27_125#	B#2	7.78508e-20
C222	VGND#4	a_435_99##14	1.1658e-19
C223	a_294_392##4	VPWR#6	5.31135e-18
C224	VPWR#13	B#1	4.0952e-18
C225	VPWR#15	A#11	2.47475e-20
C226	VGND#1	a_294_392##9	1.27648e-18
C227	VPWR#11	B#6	1.06515e-18
C228	a_294_392##4	VPWR#4	2.43643e-18
C229	A#5	a_435_99##5	1.63004e-17
C230	a_27_125##4	B#4	1.34579e-18
C231	VGND#12	a_294_392##8	8.32484e-19
C232	a_294_392##15	B#1	2.82577e-17
C233	B#4	B#2	1.26558e-19
C234	B#6	a_435_99##25	2.33477e-17
C235	a_435_99##4	B#7	1.84656e-17
C236	VGND#9	A#5	5.23171e-17
C237	a_435_99##23	a_435_99#	2.13303e-19
C238	a_294_392##15	B#2	6.0474e-18
C239	SUM#6	a_294_392##2	7.90248e-18
C240	B#4	a_435_99##7	2.58796e-17
C241	VPWR#5	VPWR#3	2.06267e-18
C242	SUM#6	a_294_392##4	9.10799e-17
C243	a_294_392##9	SUM#7	1.10391e-17
C244	VPWR#15	B#1	2.60594e-19
C245	B#5	B#9	3.52816e-17
C246	VPWR#13	B#6	2.81002e-17
C247	A#5	a_435_99##7	1.65766e-17
C248	a_27_125#	a_435_99##4	1.23233e-17
C249	a_294_392##4	SUM#2	5.41857e-17
C250	SUM#8	a_294_392##8	3.86076e-19
C251	VGND#3	VGND#1	6.36162e-17
C252	a_27_392#	B#1	1.79321e-21
C253	a_294_392##18	B#4	2.64372e-18
C254	VPWR#10	A#2	3.2677e-20
C255	a_294_392##15	B#6	2.60396e-17
C256	VPWR#8	a_435_99##14	5.54197e-20
C257	a_435_99##25	a_435_99#	1.32214e-18
C258	a_294_392##15	a_435_99##4	3.48354e-18
C259	A#5	B#9	1.97389e-17
C260	VPWR#6	a_435_99##14	8.2841e-20
C261	VGND#12	a_294_392##9	3.7646e-17
C262	a_707_119##4	a_435_99##27	1.46645e-17
C263	VPWR#5	SUM#5	3.54828e-17
C264	B#10	B#4	3.03005e-17
C265	VPWR#15	B#6	4.45065e-19
C266	VPWR#13	a_435_99#	3.07462e-17
C267	VPWR#4	a_435_99##14	2.76101e-20
C268	VPWR#14	B#4	4.8977e-20
C269	a_27_125#	a_294_392##15	6.45445e-18
C270	A#5	B#5	5.11627e-17
C271	B#10	B#2	9.08044e-18
C272	VGND#3	SUM#8	2.95877e-17
C273	a_27_392#	B#6	2.46639e-21
C274	a_294_392##15	a_435_99#	4.58e-17
C275	a_435_99##25	a_435_99##6	1.68802e-19
C276	VPWR#15	B#4	9.99795e-18
C277	SUM#8	a_294_392##9	1.49465e-18
C278	VGND#3	VGND#13	1.66707e-17
C279	VPWR#15	a_435_99#	3.22908e-18
C280	SUM#8	VGND#12	5.10507e-17
C281	VPWR#13	a_435_99##6	3.87546e-18
C282	a_294_392##11	VGND#12	1.7405e-17
C283	VPWR#10	B#7	1.97658e-19
C284	VGND#3	VGND#14	1.7935e-17
C285	a_27_392#	a_435_99#	2.35249e-19
C286	B#4	a_435_99##4	4.36657e-18
C287	a_294_392##15	a_435_99##6	3.86786e-17
C288	VGND#13	a_294_392##9	3.1607e-19
C289	VPWR#15	B#2	2.28287e-18
C290	A#9	A#5	3.75103e-17
C291	VGND#3	COUT#6	1.39057e-18
C292	SUM#8	a_294_392##6	6.60333e-19
C293	SUM#2	a_294_392##2	4.60755e-18
C294	VPWR#15	a_435_99##6	3.2098e-17
C295	VPWR#14	B#2	2.99059e-17
C296	a_294_392##18	a_435_99##4	1.54997e-17
C297	a_435_99##27	A#4	1.10466e-19
C298	SUM#8	a_294_392##11	5.43296e-17
C299	a_27_392#	a_435_99##6	1.24752e-18
C300	VGND#13	VGND#12	2.81164e-18
C301	a_27_125##2	B#4	4.92619e-18
C302	VPWR#8	A#2	5.43304e-20
C303	a_294_392##15	B#10	5.62488e-19
C304	VPWR#15	a_435_99##4	5.04323e-19
C305	a_435_99##27	a_435_99##14	1.58583e-18
C306	VGND#12	a_294_392##13	4.3363e-19
C307	SUM#3	VPWR#1	3.5355e-17
C308	a_294_392##17	a_435_99##2	1.04445e-17
C309	a_294_392##19	a_435_99##6	1.28274e-19
C310	VPWR#15	B#10	8.91266e-19
C311	VGND#13	a_294_392##11	1.67678e-18
C312	a_294_392##18	a_435_99##27	1.14748e-18
C313	SUM#8	a_294_392##5	2.41446e-18
C314	VPWR#7	VPWR#5	1.03307e-17
C315	a_27_392#	B#10	4.75279e-17
C316	SUM#5	COUT#3	2.87512e-20
C317	a_294_392##15	B#11	1.99302e-19
C318	a_27_392#	B#4	1.2543e-17
C319	SUM#8	a_294_392##13	1.42671e-17
C320	a_435_99##27	B#12	7.9373e-18
C321	VPWR#14	a_435_99##4	1.00713e-19
C322	a_294_392##19	B#10	3.07127e-17
C323	VGND#13	SUM#8	3.19611e-17
C324	a_294_392##4	VGND#1	7.90375e-20
C325	SUM#4	VPWR#1	2.65199e-20
C326	VPWR#1	a_294_392##2	1.4083e-20
C327	a_294_392##4	SUM#7	4.48933e-18
C328	a_27_392##2	B#10	4.00009e-19
C329	a_294_392##17	a_435_99##7	1.22162e-18
C330	a_27_392#	B#11	9.59225e-18
C331	a_435_99##4	B#2	9.47345e-19
C332	VGND#13	a_294_392##13	3.92067e-17
C333	a_294_392##4	VGND#12	5.043e-18
C334	a_27_392#	B#2	4.54908e-18
C335	VPWR#4	VPWR#3	5.09826e-19
C336	SUM#2	VPWR#1	3.29811e-19
C337	SUM#4	VPWR#3	3.14094e-17
C338	a_27_392##2	A#8	1.22085e-18
C339	a_294_392##4	SUM#8	4.90164e-17
C340	a_294_392##19	B#11	4.44181e-17
C341	VPWR#10	B#2	2.48059e-18
C342	VGND#13	a_294_392##6	1.25748e-18
C343	SUM#8	a_435_99##8	1.75097e-18
C344	a_294_392##4	VGND#13	1.16024e-17
C345	VPWR#2	VPWR#1	6.6012e-17
C346	a_27_392##2	B#11	2.54051e-17
C347	VGND#18	A#8	1.46915e-18
C348	a_27_392#	A#12	2.11095e-19
C349	VGND#17	B#4	6.47563e-19
C350	a_435_99##27	B#8	3.49548e-18
C351	SUM#1	VPWR#2	3.00271e-17
C352	a_294_392##10	a_294_392#	1.79493e-17
C353	COUT#6	a_294_392##11	8.50182e-20
C354	SUM#4	COUT#1	2.60983e-18
C355	VGND#8	a_707_119##2	5.34436e-18
C356	a_294_392##19	A#12	1.52627e-18
C357	VPWR#2	VPWR#3	2.15362e-17
C358	VGND#7	VGND#6	1.46428e-18
C359	A#12	B#4	4.73257e-18
C360	VGND#13	a_435_99##8	3.72921e-17
C361	a_27_125##2	a_294_392##19	7.00859e-19
C362	SUM#5	VPWR#2	2.70013e-17
C363	a_27_392##2	A#12	6.26153e-17
C364	VGND#8	a_707_119##4	2.84699e-17
C365	SUM#2	SUM#1	4.1974e-18
C366	SUM#5	VPWR#4	2.78387e-18
C367	A#4	B#1	2.21687e-19
C368	VPWR#2	VPWR#5	1.60353e-17
C369	SUM#8	a_435_99##16	2.06164e-19
C370	a_294_392##19	B#4	6.96972e-18
C371	A#12	VPWR#17	1.92169e-17
C372	VGND#8	a_27_125#	5.02323e-17
C373	COUT#3	VPWR#7	4.23403e-19
C374	a_435_99##8	COUT#4	1.7882e-17
C375	a_435_99##14	COUT#4	2.58434e-19
C376	VPWR#2	COUT#1	6.50321e-18
C377	a_294_392##12	a_294_392##10	4.71328e-17
C378	a_27_392##4	A#12	8.17421e-19
C379	a_435_99##27	a_435_99##5	2.03927e-19
C380	B	B#4	3.78071e-17
C381	a_435_99##14	VGND#14	2.19172e-18
C382	COUT#6	a_294_392##13	1.2407e-19
C383	a_27_392##2	A#13	2.53782e-18
C384	VPWR#2	VPWR#7	1.61913e-17
C385	B	a_435_99##4	6.51317e-19
C386	a_435_99##14	COUT#6	5.47548e-17
C387	VGND#13	a_435_99##16	3.28964e-18
C388	VPWR#2	COUT#3	1.02263e-18
C389	VPWR#17	A#13	4.08008e-17
C390	a_435_99##14	VGND#15	3.85552e-17
C391	VGND#14	a_435_99##8	3.28964e-18
C392	A#5	B#4	1.39538e-18
C393	VPWR#9	VPWR#7	9.28223e-18
C394	VPWR#17	A#8	7.77324e-19
C395	a_707_119#	a_435_99##14	4.50969e-17
C396	a_27_392##4	A#13	3.36854e-17
C397	SUM#8	a_435_99##18	1.2407e-19
C398	VGND#3	COUT#1	1.24236e-18
C399	VPWR#3	a_294_392##5	2.11499e-20
C400	a_294_392##7	a_294_392##12	4.81338e-17
C401	VGND#16	a_435_99##14	1.01375e-19
C402	a_435_99##16	COUT#4	1.7882e-17
C403	VGND#14	VGND#13	1.36989e-17
C404	COUT#6	SUM#8	9.08466e-19
C405	a_27_125##5	A#8	6.45771e-19
C406	a_707_119##2	a_435_99##14	8.13385e-19
C407	COUT#6	a_435_99##8	2.06164e-19
C408	VGND#14	a_435_99##16	3.28653e-17
C409	A#5	a_435_99##4	5.46546e-19
C410	a_435_99##15	a_294_392##7	4.73542e-17
C411	SUM#8	a_435_99##20	8.50182e-20
C412	A	A#8	3.61701e-17
C413	a_294_392##17	A#5	1.80331e-19
C414	VPWR#8	VPWR#7	4.29276e-20
C415	SUM#3	a_294_392##6	5.76779e-20
C416	VGND#6	VGND#5	1.21495e-18
C417	COUT#6	a_435_99##16	4.16657e-19
C418	SUM#3	a_294_392##5	8.16894e-20
C419	A	B#4	1.45002e-17
C420	SUM#5	a_294_392##6	1.46639e-18
C421	a_294_392##4	SUM#1	6.55816e-18
C422	a_707_119##4	a_435_99##2	2.04832e-17
C423	VGND#14	a_435_99##18	2.93937e-17
C424	a_294_392##4	VPWR#3	2.993e-18
C425	a_435_99##17	a_435_99##15	4.90845e-17
C426	a_27_125#	a_435_99##2	1.81231e-17
C427	VPWR#12	VPWR#11	1.8244e-18
C428	SUM#3	a_294_392##2	1.85161e-17
C429	a_294_392##18	a_435_99##2	5.27475e-18
C430	a_294_392##4	SUM#5	1.0011e-16
C431	a_294_392##17	a_435_99##27	3.87369e-19
C432	a_27_392##4	A#8	9.90182e-19
C433	a_435_99##23	VPWR#9	2.41809e-18
C434	a_294_392##4	VPWR#5	3.78032e-17
C435	SUM#5	a_294_392##5	1.43268e-18
C436	COUT#6	a_435_99##18	3.32809e-17
C437	a_294_392##4	COUT#1	9.95217e-17
C438	a_707_119#	a_435_99##16	2.01636e-20
C439	VGND#2	VGND#1	9.28173e-19
C440	a_294_392##15	VPWR#12	5.21915e-18
C441	COUT	a_294_392##6	5.4526e-18
C442	a_294_392##4	VPWR#7	4.3871e-17
C443	a_435_99##19	a_435_99##17	4.63431e-17
C444	COUT	a_294_392##5	2.24995e-19
C445	VGND#14	a_435_99##20	2.24769e-18
C446	COUT	a_294_392##2	1.45638e-19
C447	a_294_392##4	COUT#3	6.63983e-17
C448	VGND#15	a_435_99##18	3.76767e-19
C449	VPWR#11	VPWR#9	9.01664e-18
C450	a_294_392##4	VPWR#9	1.81514e-17
C451	COUT#6	VGND#14	4.08224e-17
C452	a_435_99##14	COUT#1	1.22425e-17
C453	COUT#6	a_435_99##20	4.04865e-17
C454	a_435_99##14	VPWR#7	2.89681e-18
C455	a_435_99##21	a_435_99##19	2.57926e-17
C456	a_27_125##4	VGND#17	1.08418e-17
C457	COUT	A#2	5.50766e-20
C458	VGND#3	a_294_392##8	4.47656e-19
C459	a_707_119#	a_435_99##18	3.30471e-20
C460	a_435_99##14	COUT#3	1.02593e-16
C461	SUM#4	a_294_392##5	8.25279e-20
C462	VGND#3	a_294_392##9	5.01021e-19
C463	a_435_99##20	VGND#15	2.24724e-17
C464	VGND#5	VGND#4	1.51765e-18
C465	a_27_125##5	a_27_392##4	3.96665e-19
C466	VGND#3	a_294_392##11	5.49438e-18
C467	A#1	a_435_99##21	1.76538e-17
C468	VGND#15	VGND#14	2.49656e-18
C469	VGND#3	a_294_392##13	4.0288e-19
C470	SUM#2	a_294_392#	1.30804e-17
C471	VGND#3	a_435_99##8	2.98678e-18
C472	a_707_119#	a_435_99##20	1.16942e-18
C473	a_27_125##4	a_27_125##6	3.22492e-19
C474	A#11	a_435_99##21	1.08165e-18
C475	VGND#3	a_435_99##16	2.43812e-19
C476	a_435_99##14	a_294_392##15	2.15414e-18
C477	VGND#14	A#4	1.65749e-19
C478	VGND#3	a_435_99##18	7.29386e-19
C479	VGND#15	A#10	2.85072e-18
C480	A#11	A#1	3.1853e-17
C481	B#1	a_435_99##21	3.27117e-19
C482	VGND#16	a_435_99##20	1.40127e-18
C483	VGND#15	COUT#6	6.44102e-17
C484	a_294_392##17	A#8	3.65347e-19
C485	a_294_392##15	VPWR#9	4.04538e-17
C486	a_27_125##4	B#5	1.75997e-17
C487	a_435_99##2	a_294_392##15	3.17706e-17
C488	A#10	a_707_119#	2.40587e-17
C489	a_27_125##4	VGND#18	1.47332e-17
C490	B#1	A#11	5.08721e-17
C491	a_707_119##2	a_435_99##20	1.42146e-19
C492	VPWR	B#4	3.90101e-20
C493	VPWR#2	a_294_392##6	1.9576e-20
C494	VPWR	B#2	1.59517e-17
C495	VGND#15	A#4	1.2828e-18
C496	VPWR#2	a_294_392##5	2.02358e-20
C497	VPWR#13	VPWR#11	8.65719e-18
C498	a_294_392##15	a_435_99##23	9.66532e-17
C499	B#6	A#11	4.23688e-19
C500	VGND#16	A#10	4.4303e-17
C501	VPWR#11	VPWR#8	1.24266e-18
C502	B#6	B#1	1.95364e-17
C503	VPWR#2	a_294_392##2	2.63886e-20
C504	a_27_125##4	A#5	1.8511e-17
C505	a_707_119#	A#4	6.94006e-20
C506	SUM#3	a_294_392#	1.16726e-17
C507	a_707_119##2	A#10	1.2436e-18
C508	VGND#4	VGND#2	1.26545e-18
C509	a_294_392##15	VPWR#11	3.93073e-17
C510	VGND#8	A#4	3.17859e-17
C511	VPWR#4	a_294_392##7	4.21475e-18
C512	SUM#3	a_294_392##10	4.47559e-20
C513	VGND#16	A#4	1.62725e-17
C514	a_435_99#	B#6	3.35922e-17
C515	SUM#3	a_294_392##12	2.19933e-20
C516	a_707_119#	VGND#15	4.39177e-17
C517	VGND#8	B#8	3.15331e-18
C518	SUM#4	a_294_392##10	2.29216e-17
C519	VGND#8	a_435_99##5	2.04797e-18
C520	SUM#3	a_294_392##7	1.55287e-20
C521	VPWR#14	VPWR#13	3.40625e-19
C522	B	a_294_392##17	3.89031e-17
C523	a_294_392##15	a_435_99##25	5.46333e-17
C524	SUM#4	a_294_392##12	6.79338e-18
C525	a_707_119##2	A#4	6.11797e-17
C526	VGND#6	VGND#14	5.91997e-20
C527	A#10	a_435_99##14	4.23306e-19
C528	a_294_392##17	A#3	8.23395e-20
C529	VPWR#2	a_294_392##10	3.04893e-18
C530	a_435_99##6	a_435_99#	3.77154e-17
C531	VGND#13	VGND#2	6.17123e-20
C532	VPWR#2	a_294_392##12	4.42588e-18
C533	VGND#3	a_294_392##6	1.87269e-20
C534	VPWR#4	a_435_99##15	3.97876e-18
C535	VGND#16	VGND#15	6.15768e-18
C536	a_435_99##29	A#4	1.40662e-18
C537	a_294_392##15	VPWR#13	4.10806e-17
C538	VGND#8	A#5	8.17877e-18
C539	VPWR#2	a_294_392##7	3.01893e-18
C540	VGND#3	a_294_392##5	6.57519e-20
C541	a_435_99##2	A#4	2.48331e-18
C542	VPWR#2	a_435_99##15	3.84966e-19
C543	a_707_119##2	B#12	2.23053e-17
C544	a_294_392##15	VPWR#14	1.51039e-18
C545	a_707_119##4	A#4	9.46614e-18
C546	VPWR#2	a_435_99##17	5.04412e-19
C547	VPWR#6	a_435_99##17	3.94703e-18
C548	VPWR#15	VPWR#13	1.48997e-17
C549	VGND#5	COUT	1.93226e-18
C550	VPWR#2	a_435_99##19	4.43691e-21
C551	VGND#6	COUT#6	5.36914e-18
C552	VGND#4	COUT	2.49795e-18
C553	B#11	B#10	3.89484e-17
C554	a_435_99##29	B#12	3.30173e-17
C555	VGND#16	a_707_119#	6.98249e-17
C556	a_27_125#	A#4	8.41068e-18
C557	a_294_392##4	a_294_392#	1.72902e-20
C558	VGND#7	VGND#15	2.37368e-18
C559	a_294_392##15	VPWR#10	4.6179e-18
C560	a_707_119##2	B#8	7.89486e-19
C561	a_27_125##4	A	6.44823e-17
C562	a_294_392##4	a_294_392##10	3.03561e-20
C563	VPWR#15	a_294_392##15	5.61952e-18
C564	A#12	B#11	4.21054e-17
C565	a_707_119##4	B#12	4.49118e-19
C566	a_294_392##4	a_294_392##12	1.23481e-18
C567	VPWR#8	a_435_99##19	8.16548e-19
C568	VGND	A#3	3.50665e-19
C569	VGND	A#2	9.573e-21
C570	a_294_392##4	a_294_392##7	1.37274e-17
C571	VGND	B#4	7.05408e-19
C572	VGND#5	COUT#6	7.53625e-18
C573	a_435_99##29	B#8	2.73348e-17
C574	VGND	a_435_99##4	2.72121e-18
C575	a_707_119##2	a_707_119#	2.42898e-18
C576	a_294_392##4	a_435_99##15	2.28126e-17
C577	a_294_392##15	VPWR#8	2.90801e-18
C578	a_294_392##17	B#7	8.15175e-20
C579	VPWR#6	a_435_99##19	3.94703e-18
C580	A#13	A#12	4.22602e-17
C581	B	a_294_392##18	7.53476e-18
C582	a_27_125##2	B	6.1628e-17
C583	a_294_392##4	a_435_99##17	1.66016e-17
C584	a_27_392#	a_294_392##15	5.25442e-18
C585	a_707_119##2	a_435_99##5	6.46326e-20
C586	a_294_392##4	a_435_99##19	1.87192e-17
C587	a_435_99##14	a_435_99##15	9.37928e-19
C588	a_707_119##4	B#8	2.68982e-17
C589	VPWR	VPWR#14	1.04636e-16
C590	VPWR#12	B#1	1.04035e-19
C591	VPWR	VPWR#10	8.5939e-17
C592	VPWR#10	a_435_99##21	1.00917e-19
C593	VPWR	VPWR#8	9.98393e-17
C594	a_294_392##4	a_435_99##21	2.40387e-17
C595	VGND#7	a_707_119#	4.12727e-18
C596	VPWR	VPWR#6	2.10972e-17
C597	a_435_99##14	a_435_99##19	5.22281e-19
C598	a_435_99##29	a_435_99##5	2.5923e-20
C599	a_707_119##2	VGND#16	1.01779e-16
C600	a_27_392#	VPWR#15	3.86469e-17
C601	a_294_392##19	a_294_392##15	2.45342e-18
C602	VPWR#8	a_435_99##21	9.44592e-18
C603	VPWR	a_294_392##17	6.03614e-18
C604	VPWR#12	a_435_99#	1.73287e-18
C605	a_27_125#	B#8	3.63541e-18
C606	a_435_99##14	a_435_99##21	1.76898e-17
C607	COUT	SUM#8	1.31547e-17
C608	a_435_99##14	A#1	1.38819e-18
C609	a_27_392#	VPWR#14	5.13806e-17
C610	COUT	COUT#4	3.45135e-18
C611	a_294_392##17	B#4	3.43492e-17
C612	COUT	VGND#14	2.66926e-17
C613	VPWR	a_435_99##27	1.69753e-18
C614	A	VGND#18	3.31957e-18
C615	a_707_119##4	a_435_99##5	1.37373e-18
C616	a_27_125##5	A	4.3928e-17
C617	a_707_119#	COUT	1.29376e-18
C618	a_294_392##18	B#8	2.63144e-19
C619	a_294_392##6	VNB	2.56176e-17
C620	a_294_392##5	VNB	2.59268e-17
C621	VGND#6	a_707_119#	3.19955e-18
C622	VGND#7	B#1	3.9191e-19
C623	a_294_392##2	VNB	5.35674e-17
C624	A#8	VNB	6.66013e-17
C625	A#3	VNB	3.42819e-17
C626	a_294_392##17	a_435_99##25	7.7885e-19
C627	A#2	VNB	3.16585e-17
C628	a_435_99##5	a_27_125#	3.49249e-17
C629	B#7	VNB	4.55422e-17
C630	B#4	VNB	1.27308e-16
C631	B#2	VNB	1.16893e-16
C632	VPWR#2	SUM#3	2.00497e-18
C633	a_435_99##4	VNB	7.02341e-17
C634	SUM#6	VGND#1	8.10723e-17
C635	a_27_125##2	B#8	6.67723e-20
C636	SUM	SUM#6	2.87712e-18
C637	B	a_294_392##19	4.96126e-17
C638	SUM	SUM#2	1.11125e-17
C639	SUM#4	VPWR#2	2.59465e-17
C640	VPWR#8	A#1	4.52667e-18
C641	VGND#3	SUM#3	7.31192e-19
C642	a_27_392#	a_294_392##19	8.14844e-17
C643	a_294_392##18	a_435_99##5	4.01139e-17
C644	VPWR	a_707_119#	4.29458e-18
C645	VGND#3	SUM#4	1.06721e-18
C646	a_294_392##17	B#2	4.71521e-19
C647	VPWR	a_707_119##2	4.86831e-18
C648	COUT	COUT#1	4.26975e-18
C649	VGND	VGND#9	9.90417e-17
C650	VGND	VGND#7	1.06888e-16
C651	a_707_119##2	a_435_99##29	7.05282e-17
C652	a_27_125#	a_435_99##7	4.54154e-19
C653	VGND	VGND#6	7.18518e-17
C654	VGND	VGND#5	9.75149e-18
C655	A	a_27_392##2	5.43554e-17
C656	a_27_125##2	a_435_99##5	1.99802e-18
C657	A	VPWR#17	2.37112e-18
C658	SUM	VGND#1	3.83871e-18
C659	a_27_392##2	a_27_392#	2.59773e-18
C660	VPWR#12	B#7	3.39119e-19
C661	A	a_27_392##4	5.10498e-17
C662	a_294_392##4	SUM#3	4.11827e-17
C663	VPWR#10	A#11	3.4704e-18
C664	a_294_392##4	SUM#4	6.27116e-17
C665	SUM#6	SUM#7	2.06042e-17
C666	a_435_99##7	a_294_392##18	2.92247e-17
C667	VGND#7	a_707_119##2	3.26851e-17
C668	VGND	a_294_392##17	5.73112e-19
C669	VPWR#2	a_294_392##4	2.02999e-17
C670	VPWR#12	B#2	3.51568e-17
C671	VPWR	COUT#3	2.80729e-18
C672	VGND	a_435_99##27	2.02956e-18
C673	VGND#3	a_294_392##4	1.38389e-17
C674	B	a_435_99##7	1.48985e-17
C675	a_27_392##2	a_294_392##19	6.00423e-17
C676	VPWR#2	a_435_99##14	2.20366e-18
C677	VPWR#12	a_435_99##4	3.09683e-19
C678	a_294_392##17	a_435_99##4	4.34533e-18
C679	a_27_125#	B#9	1.98073e-19
C680	VPWR	a_435_99##23	6.40874e-18
C681	a_707_119##4	a_707_119##2	2.49187e-18
C682	VGND	a_27_125##4	2.96937e-18
C683	a_27_125##2	a_435_99##7	1.9046e-17
C684	VPWR	a_435_99##25	4.05173e-18
C685	VGND#3	a_435_99##14	1.80268e-18
C686	COUT	a_294_392##11	7.41772e-19
C687	B	A#5	4.83915e-19
C688	COUT	a_294_392##13	1.8806e-18
C689	VPWR	a_294_392##15	3.56256e-17
C690	SUM	VPWR#1	1.23183e-17
C691	COUT	a_435_99##8	1.80418e-17
C692	VPWR	a_27_392#	2.99908e-17
C693	COUT	a_435_99##16	2.17648e-17
C694	VGND#9	VNB	3.25457e-17
C695	VGND#7	VNB	4.25861e-17
C696	VPWR	a_294_392##19	9.14648e-18
C697	COUT	a_435_99##18	1.86336e-19
C698	VGND#6	VNB	2.96511e-17
C699	VGND#5	VNB	2.88411e-17
C700	VPWR	a_27_392##2	1.88266e-17
C701	a_294_392##18	B#9	1.15311e-18
C702	VGND#4	VNB	2.45035e-17
C703	COUT	a_435_99##20	8.96108e-20
C704	VGND#2	VNB	2.9654e-17
C705	VGND	COUT#6	1.42027e-17
C706	COUT	A#10	1.10908e-19
C707	VPWR	a_27_392##4	1.68725e-17
C708	VPWR#14	VNB	3.88804e-17
C709	VPWR#10	VNB	3.2797e-17
C710	VGND	a_707_119#	1.36558e-17
C711	A	A#5	3.35709e-19
C712	VPWR#8	VNB	4.0993e-17
C713	VPWR#10	B#1	1.19522e-17
C714	a_435_99##14	a_294_392##4	4.36477e-17
C715	VPWR#6	VNB	3.3212e-17
C716	VGND#8	a_435_99##2	1.59275e-18
C717	VGND	a_707_119##2	2.53294e-17
C718	VPWR#4	VNB	2.64905e-17
C719	VGND	a_435_99##29	8.51284e-18
C720	SUM#6	VGND#12	6.38591e-17
C721	SUM#6	VNB	2.61319e-17
C722	VGND	a_707_119##4	1.9734e-17
C723	SUM#2	VNB	1.49019e-18
C724	VGND	a_27_125#	2.62915e-17
C725	a_294_392##17	VNB	4.71465e-18
C726	a_294_392##4	a_294_392##6	1.69652e-17
C727	VGND	a_294_392##18	1.0075e-17
C728	a_707_119##4	a_435_99##29	6.37673e-17
C729	VGND	a_27_125##2	2.29998e-17
C730	a_27_125##2	B#9	4.79813e-17
C731	VGND	a_27_125##6	1.15428e-17
C732	VGND#2	a_294_392##2	6.09961e-20
C733	VPWR#8	B#1	6.15517e-19
C734	a_435_99##27	VNB	1.30684e-19
C735	a_294_392##4	a_294_392##5	1.90914e-17
C736	VGND	a_27_125##5	1.29461e-17
C737	a_27_125##4	VNB	2.32811e-18
C738	a_27_392##2	VPWR#17	6.69628e-17
C739	a_294_392##6	a_294_392##5	4.33014e-18
C740	VGND#1	VNB	5.61395e-17
C741	VGND#8	B#7	4.84641e-20
C742	a_294_392##18	B#5	2.63516e-20
C743	VGND#12	VNB	5.61793e-19
C744	SUM#8	VNB	2.41038e-18
C745	VPWR	a_435_99##7	2.51581e-19
C746	a_294_392##4	a_294_392##2	2.03819e-17
C747	B#9	VGND#17	1.46304e-17
C748	VGND	a_435_99##23	7.19164e-18
C749	COUT#6	VNB	2.27449e-18
C750	VGND	a_435_99##25	1.55862e-18
C751	VGND#15	VNB	1.14281e-17
C752	a_707_119#	VNB	1.4727e-17
C753	VGND#16	VNB	3.73467e-18
C754	VGND	a_294_392##15	1.31702e-18
C755	a_707_119##2	VNB	4.60292e-18
C756	a_435_99##29	VNB	3.1164e-21
C757	a_707_119##4	VNB	1.45267e-17
C758	a_27_125#	VNB	1.88769e-17
C759	a_294_392##17	VPWR#15	2.29922e-17
C760	a_435_99##27	a_435_99##21	4.24646e-19
C761	a_27_125#	A#5	5.93649e-18
C762	a_27_125##2	VNB	1.04988e-17
C763	COUT	a_435_99##21	5.68697e-20
C764	VGND#17	VNB	2.09525e-18
C765	a_27_125##2	B#5	1.57005e-18
C766	a_27_125##6	VNB	5.66618e-19
C767	VGND#18	VNB	7.52709e-18
C768	a_27_392##4	a_27_392##2	2.65861e-18
C769	a_27_125##5	VNB	3.97573e-17
C770	VPWR#1	VNB	6.55253e-17
C771	a_27_125##6	B#9	5.19327e-19
C772	VGND#2	a_294_392##8	5.46479e-19
C773	SUM#1	VNB	5.47364e-18
C774	SUM#8	SUM#6	2.52447e-18
C775	VGND#8	a_435_99##4	2.2342e-18
C776	VPWR#3	VNB	5.60135e-19
C777	SUM#5	VNB	5.40047e-18
C778	COUT#1	VNB	6.0196e-19
C779	VPWR	a_435_99##19	4.36811e-19
C780	COUT#3	VNB	5.64735e-19
C781	VPWR#9	VNB	1.00382e-18
C782	VGND	a_435_99##20	1.50286e-18
C783	VPWR	a_435_99##21	3.67275e-19
C784	a_435_99##23	VNB	2.25093e-18
C785	SUM	a_294_392#	1.68936e-20
C786	VGND	A#10	4.5459e-18
C787	VPWR#11	VNB	1.53952e-18
C788	VPWR	A#1	7.59686e-18
C789	a_294_392##18	A#5	1.25129e-18
C790	VGND	A#4	2.21649e-17
C791	a_435_99##25	VNB	2.69064e-18
C792	VPWR#13	VNB	1.80583e-18
C793	VPWR	A#11	4.63569e-18
C794	a_294_392##15	VNB	6.03241e-19
C795	VGND#17	B#5	2.68921e-17
C796	VPWR#15	VNB	3.06936e-18
C797	VPWR	B#1	4.02244e-18
C798	VGND	a_435_99##5	2.84237e-18
C799	a_27_392#	VNB	4.70227e-18
C800	a_294_392##19	VNB	1.31503e-19
C801	VGND	a_435_99##7	2.62537e-18
C802	a_27_392##2	VNB	4.30937e-18
C803	VGND	B#9	2.27218e-18
C804	VPWR#17	VNB	2.67111e-18
C805	VPWR	a_435_99#	2.77414e-18
C806	a_435_99##27	a_435_99##25	1.45441e-19
C807	VGND	B#5	2.99514e-18
C808	a_27_392##4	VNB	5.44968e-17
C809	a_294_392##8	VNB	3.23954e-17
C810	VGND	A#5	1.54677e-17
C811	VPWR	a_435_99##6	2.77475e-18
C812	a_27_392##4	VPWR#17	7.36806e-17
C813	a_294_392##9	VNB	2.5761e-17
C814	VGND	A#9	4.46592e-18
C815	a_294_392##11	VNB	2.95348e-17
C816	VPWR	B#10	2.02144e-18
C817	a_294_392##13	VNB	2.69362e-17
C818	a_435_99##8	VNB	2.42361e-17
C819	VPWR	B#11	1.44878e-18
C820	a_435_99##16	VNB	2.51476e-17
C821	a_435_99##18	VNB	2.51549e-17
C822	VPWR	A#12	1.18901e-18
C823	a_27_125#	a_707_119##4	5.06641e-17
C824	a_27_125##2	A#5	1.01592e-17
C825	a_294_392##18	a_435_99##29	9.55362e-20
C826	a_435_99##20	VNB	3.14018e-17
C827	VGND#9	a_27_125#	3.08708e-18
C828	A#10	VNB	3.09006e-17
C829	VPWR	A#13	1.52089e-18
C830	A#4	VNB	1.6818e-16
C831	B#5	a_27_125##6	1.12077e-17
C832	B#12	VNB	2.83058e-17
C833	VGND#3	COUT	1.28059e-17
C834	B#8	VNB	2.6985e-17
C835	a_435_99##5	VNB	2.60083e-17
C836	a_435_99##27	A#1	7.97343e-19
C837	a_435_99##7	VNB	3.3562e-17
C838	a_294_392##17	a_27_392#	2.1188e-17
C839	B#9	VNB	2.21546e-17
C840	B#5	VNB	2.06197e-17
C841	A#5	VNB	1.54174e-16
C842	A#9	VNB	3.64072e-17
C843	COUT	a_294_392##4	4.07834e-17
C844	a_435_99##14	a_294_392##6	3.33709e-17
C845	a_294_392#	VNB	3.56736e-17
C846	COUT	a_435_99##14	6.44765e-17
C847	a_294_392##10	VNB	3.30111e-17
C848	VPWR	VPWR#12	8.61082e-17
C849	a_294_392##18	A#9	1.4779e-20
C850	SUM	SUM#3	5.48403e-17
C851	a_294_392##12	VNB	3.03821e-17
C852	a_294_392##7	VNB	3.18312e-17
C853	VGND#17	A#5	3.08546e-18
C854	a_435_99##15	VNB	3.0417e-17
C855	a_435_99##17	VNB	2.82731e-17
C856	SUM	VPWR#2	1.70664e-17
C857	VPWR	a_294_392##4	1.01422e-17
C858	VGND#2	a_294_392##9	3.88593e-18
C859	a_435_99##19	VNB	2.9169e-17
C860	VGND#18	B#5	1.3347e-18
C861	a_435_99##21	VNB	3.87539e-17
C862	VPWR	a_435_99##14	5.85394e-18
C863	A#1	VNB	3.53353e-17
C864	A#11	VNB	4.07363e-17
C865	VPWR	a_435_99##2	3.05257e-18
C866	B#1	VNB	5.38099e-17
C867	B#6	VNB	1.94399e-17
C868	SUM	a_294_392##4	3.51497e-18
C869	a_435_99#	VNB	1.84641e-17
C870	a_435_99##6	VNB	2.15953e-17
C871	B#10	VNB	3.19706e-17
C872	B#11	VNB	3.04704e-17
C873	A#12	VNB	2.88539e-17
C874	A#13	VNB	3.6562e-17
C875	VGND	VGND#8	1.06658e-16
C876	SUM#3	VNB	3.7144e-17
C877	a_27_125##6	A#5	3.55782e-17
C878	VGND	a_435_99##14	5.66114e-18
C879	SUM#4	VNB	3.11939e-19
C880	VPWR#2	VNB	1.96236e-16
C881	VGND	a_435_99##2	6.97428e-18
C882	A	B	2.25191e-17
C883	VGND#3	VNB	1.74151e-16
C884	VPWR#12	VNB	2.39702e-17
C885	VGND#8	VNB	4.47653e-17
C886	a_294_392##4	VNB	6.2276e-17
C887	a_435_99##14	VNB	1.37598e-16
C888	a_435_99##2	VNB	4.59209e-18
C889	VPWR	B	3.60687e-18
C890	VPWR	A	4.4542e-18
C891	VGND#17	A#9	3.8674e-19
C892	VGND	B	3.83043e-18
C893	VGND	A	5.49408e-18
C894	VPWR#14	a_435_99##6	1.67279e-18
C895	A#5	VGND#18	1.85394e-17
C896	B	VNB	2.71407e-18
C897	a_435_99##23	A#4	1.60515e-19
C898	A	VNB	2.47894e-17
C899	COUT	VNB	1.63878e-18
C900	VPWR	VNB	2.7952e-16
C901	SUM	VNB	1.43388e-17
C902	a_294_392##17	B#6	3.40421e-19
C903	VGND	VNB	2.8226e-16
C904	VPWR#16	A#12	5.35296e-18
C905	VGND#10	a_27_125##6	2.44988e-18
C906	VGND	VGND#10	9.07122e-17
C907	VPWR#16	VPWR#14	1.76187e-19
C908	VGND#10	VNB	5.15909e-17
C909	a_27_392#	VPWR#16	1.59914e-17
C910	a_27_392##2	VPWR#16	3.26478e-17
C911	a_27_392##4	VPWR#16	1.82202e-17
C912	VPWR#16	B#2	2.46163e-19
C913	VGND#10	A#5	1.34392e-17
C914	VPWR#16	VNB	5.97929e-17
C915	VGND#10	a_27_125##4	2.68404e-19
C916	VGND#10	a_27_125##5	8.28449e-18
C917	VPWR#16	B#11	5.06846e-18
C918	VPWR#16	A#13	3.99584e-18
C919	VGND#10	A#9	7.35784e-19
C920	VPWR	VPWR#16	1.17465e-16
C921	VPWR#16	B#4	1.6634e-20
C922	VGND#10	VGND#9	4.5471e-18
C923	VPWR#16	B#10	8.68429e-20
*
*
.ENDS sky130_fd_sc_hs__ha_4
*
