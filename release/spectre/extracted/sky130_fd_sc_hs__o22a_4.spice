* Extracted by Quantus, converted by sky130cad/quantus.py
*
*
*
*                       LINUX           Wed Nov 18 08:58:46 2026
*
*
*
*  PROGRAM  advgen
*
*  Name           : advgen - Quantus - (64-bit)
*  Version        : 25.1.0-p047
*  Build Date     : Thu Dec 11 23:20:30 PST 2025
*
*  HSPICE LIBRARY
*
*  OPERATING_TEMPERATURE 150
*  QRC_TECH_DIR <path>/tech
*
*
*

*
.SUBCKT sky130_fd_sc_hs__o22a_4 VNB VPB VGND VPWR X B1 A2 A1 B2
*
*
*  caps2d version: 10
*
*
*       TRANSISTOR CARDS
*
*
XM3 VGND#11 A1#4 a_27_136##3 VNB sky130_fd_pr__nfet_01v8_lvt l=0.15 w=0.64 ad=0.224 as=0.1824 pd=1.98 ps=1.85
XM8 VGND#11 A2#7 a_27_136# VNB sky130_fd_pr__nfet_01v8_lvt l=0.15 w=0.64 ad=0.224 as=0.1792 pd=1.98 ps=1.84
XM14 a_27_136# A2#6 VGND#10 VNB sky130_fd_pr__nfet_01v8_lvt l=0.15 w=0.64 ad=0.1792 as=0.2496 pd=1.84 ps=2.06
XM4 a_27_136##4 A1#3 VGND#10 VNB sky130_fd_pr__nfet_01v8_lvt l=0.15 w=0.64 ad=0.24 as=0.2496 pd=2.03 ps=2.06
XM22 a_27_136##4 B1#4 a_206_392##21 VNB sky130_fd_pr__nfet_01v8_lvt l=0.15 w=0.64 ad=0.24 as=0.1824 pd=2.03 ps=1.85
XM6 a_206_392##21 B2#5 a_27_136##6 VNB sky130_fd_pr__nfet_01v8_lvt l=0.15 w=0.64 ad=0.1824 as=0.2272 pd=1.85 ps=1.99
XM13 a_27_136##6 B2#6 a_206_392##18 VNB sky130_fd_pr__nfet_01v8_lvt l=0.15 w=0.64 ad=0.2272 as=0.1792 pd=1.99 ps=1.84
XM12 a_206_392##18 B1#2 a_27_136##8 VNB sky130_fd_pr__nfet_01v8_lvt l=0.15 w=0.64 ad=0.1792 as=0.1824 pd=1.84 ps=1.85
XM18 X#7 a_206_392##11 VGND#9 VNB sky130_fd_pr__nfet_01v8_lvt l=0.15 w=0.74 ad=0.2072 as=0.2991 pd=2.04 ps=2.41
XM9 VGND#8 a_206_392##10 X#7 VNB sky130_fd_pr__nfet_01v8_lvt l=0.15 w=0.74 ad=0.2072 as=0.2072 pd=2.04 ps=2.04
XM17 X#5 a_206_392##8 VGND#8 VNB sky130_fd_pr__nfet_01v8_lvt l=0.15 w=0.74 ad=0.2072 as=0.2072 pd=2.04 ps=2.04
XM21 VGND#1 a_206_392# X#5 VNB sky130_fd_pr__nfet_01v8_lvt l=0.15 w=0.74 ad=0.2146 as=0.2072 pd=2.06 ps=2.04
XM10 VPWR#6 A1#5 a_116_392##2 VPB sky130_fd_pr__pfet_01v8 l=0.15 w=1 ad=0.295 as=0.3 pd=2.59 ps=2.6
XM2 a_206_392##16 A2#5 a_116_392##2 VPB sky130_fd_pr__pfet_01v8 l=0.15 w=1 ad=0.35 as=0.3 pd=2.7 ps=2.6
XM23 a_116_392# A2#1 a_206_392##16 VPB sky130_fd_pr__pfet_01v8 l=0.15 w=1 ad=0.35 as=0.35 pd=2.7 ps=2.7
XM11 a_116_392# A1#1 VPWR#9 VPB sky130_fd_pr__pfet_01v8 l=0.15 w=1 ad=0.35 as=0.4 pd=2.7 ps=2.8
XM5 a_516_392##2 B1#5 VPWR#9 VPB sky130_fd_pr__pfet_01v8 l=0.15 w=1 ad=0.3 as=0.4 pd=2.6 ps=2.8
XM0 a_206_392##14 B2#7 a_516_392##2 VPB sky130_fd_pr__pfet_01v8 l=0.15 w=1 ad=0.35 as=0.3 pd=2.7 ps=2.6
XM20 a_516_392# B2#1 a_206_392##14 VPB sky130_fd_pr__pfet_01v8 l=0.15 w=1 ad=0.35 as=0.35 pd=2.7 ps=2.7
XM7 VPWR#8 B1#1 a_516_392# VPB sky130_fd_pr__pfet_01v8 l=0.15 w=1 ad=0.4372 as=0.35 pd=3.04 ps=2.7
XM1 X#3 a_206_392##12 VPWR#8 VPB sky130_fd_pr__pfet_01v8 l=0.15 w=1.12 ad=0.3752 as=0.4372 pd=2.91 ps=3.04
XM15 X#3 a_206_392##13 VPWR#7 VPB sky130_fd_pr__pfet_01v8 l=0.15 w=1.12 ad=0.3752 as=0.644 pd=2.91 ps=3.39
XM16 VPWR#7 a_206_392##9 X#6 VPB sky130_fd_pr__pfet_01v8 l=0.15 w=1.12 ad=0.644 as=0.336 pd=3.39 ps=2.84
XM19 VPWR#1 a_206_392##7 X#6 VPB sky130_fd_pr__pfet_01v8 l=0.15 w=1.12 ad=0.3864 as=0.336 pd=2.93 ps=2.84
*
*
*       RESISTOR AND CAP/DIODE CARDS
*
Rg1	A2#1	A2#2	472.523376
Rg2	A2#2	A2#3	33.550034
Rg3	A2#3	A2#4	26.676205
Rg4	A2#4	A2#5	425.854218
Rg5	A2#2	A2#6	349.447449
Rg6	A2#4	A2#7	310.215057
Rg7	A1#1	A1#2	409.090576
Rg8	A1#2	A1#3	290.721832
Rg9	A1#3	A1#4	1613.930420
Rg10	A1#4	A1#5	790.462036
Rg11	B2#1	B2#2	420.356995
Rg12	B2#2	B2#3	36.503117
Rg13	B2#3	B2#4	24.707481
Rg14	B2#4	B2#5	303.138580
Rg15	B2#2	B2#6	293.588776
Rg16	B2#4	B2#7	423.711304
Rg17	B1#1	B1#2	830.824219
Rg18	B1#2	B1#3	1154.826782
Rg19	B1#3	B1#4	289.028961
Rg20	B1#4	B1#5	774.737183
Rg21	a_206_392#	a_206_392##2	401.054016
Rg22	a_206_392##2	a_206_392##3	76.116005
Rg23	a_206_392##3	a_206_392##4	9.511579
Rg24	a_206_392##4	a_206_392##5	56.184708
Rg25	a_206_392##5	a_206_392##6	50.045280
Rg26	a_206_392##2	a_206_392##7	450.571655
Rg27	a_206_392##3	a_206_392##8	418.854218
Rg28	a_206_392##4	a_206_392##9	433.200775
Rg29	a_206_392##5	a_206_392##10	370.752045
Rg30	a_206_392##6	a_206_392##11	409.771759
Rg31	a_206_392##6	a_206_392##12	532.282410
Rg32	a_206_392##6	a_206_392##13	429.126801
Rf1	A2#3	A2	81.110611
Rf2	a_116_392#	a_116_392##2	106.670296
Rf3	A1#2	A1#7	160.996811
Rf4	A1#8	A1	0.764007
Rf5	A1#7	A1#8	5.905091
Rf6	B1#3	B1	171.289017
Rf7	B2#3	B2	82.084763
Rf8	a_516_392#	a_516_392##2	102.477859
Rf9	a_27_136#	a_27_136##2	22.188360
Rf10	a_27_136##2	a_27_136##3	79.526970
Rf11	a_27_136##2	a_27_136##5	63.040066
Rf12	a_27_136##5	a_27_136##7	57.726089
Rf13	a_27_136##7	a_27_136##8	71.946320
Rf14	a_27_136##4	a_27_136##5	15.000000
Rf15	a_27_136##6	a_27_136##7	15.000000
Rf16	a_206_392##14	a_206_392##15	16.278900
Rf17	a_206_392##15	a_206_392##16	159.140427
Rf18	a_206_392##15	a_206_392##17	115.989746
Rf19	a_206_392##17	a_206_392##19	94.681732
Rf20	a_206_392##17	a_206_392##6	63.887482
Rf21	a_206_392##19	a_206_392##21	76.530701
Rf22	a_206_392##18	a_206_392##19	15.000000
Rf23	X	X#1	20.767191
Rf24	X#1	X#2	44.541199
Rf25	X#2	X#3	94.418221
Rf26	X#1	X#4	14.516582
Rf27	X#4	X#5	31.728157
Rf28	X#2	X#6	24.498878
Rf29	X#4	X#7	81.195251
Rf30	VPWR#1	VPWR#2	113.134361
Rf31	VPWR#2	VPWR#3	80.306480
Rf32	VPWR#3	VPWR#4	66.086166
Rf33	VPWR#4	VPWR#5	82.522530
Rf34	VPWR#5	VPWR#6	190.574768
Rf35	VPWR#2	VPWR#7	33.503098
Rf36	VPWR#3	VPWR#8	37.695530
Rf37	VPWR#5	VPWR#9	31.534731
Rf38	VGND#1	VGND#2	92.026627
Rf39	VGND#2	VGND#3	68.618401
Rf40	VGND#3	VGND#4	93.114845
Rf41	VGND#4	VGND#5	120.508781
Rf42	VGND#5	VGND#6	67.887894
Rf44	VGND#2	VGND#8	36.279022
Rf45	VGND#3	VGND#9	28.011898
Rf46	VGND#5	VGND#10	44.742989
Rf47	VGND#6	VGND#11	44.742989
Re1	VPWR#4	VPWR	0.701577
Re2	VGND	VGND#4	0.701602
*
*       CAPACITOR CARDS
*
*
C1	VGND	VNB	6.0253e-17
C2	VPWR	VNB	7.56986e-17
C3	X	VNB	1.56289e-17
C4	B1	VNB	1.26332e-17
C5	A1	VNB	5.32665e-20
C6	B2	VNB	2.67079e-18
C7	VGND#9	VGND#2	9.2952e-19
C8	VGND#1	VPWR#1	3.49688e-19
C9	A2#3	VNB	3.38092e-18
C10	VGND	X	1.96189e-18
C11	A1#2	VNB	3.31585e-17
C12	B1#3	VNB	6.67802e-17
C13	VGND	B1	2.1701e-17
C14	a_206_392##6	VNB	5.30707e-17
C15	A1#4	VGND#11	2.45702e-17
C16	VGND#4	VNB	3.04768e-16
C17	VPWR	X	2.09337e-18
C18	VPWR#4	VNB	2.94e-16
C19	VGND#1	X#4	1.2983e-17
C20	A1#5	VNB	5.58924e-17
C21	A2#5	VNB	3.13345e-17
C22	VGND	A1	1.14205e-18
C23	A2#1	VNB	3.13047e-17
C24	A1#1	VNB	3.17696e-17
C25	a_206_392##15	a_516_392##2	9.37356e-17
C26	B1#5	VNB	4.00603e-17
C27	VGND	B2	4.24516e-18
C28	B2#7	VNB	3.09112e-17
C29	B2#1	VNB	3.22329e-17
C30	B1#1	VNB	4.47391e-17
C31	a_206_392##12	VNB	5.63998e-17
C32	a_206_392##13	VNB	3.56011e-17
C33	VPWR	A1	1.07349e-18
C34	a_206_392##9	VNB	3.4291e-17
C35	a_206_392##7	VNB	3.7402e-17
C36	A1#4	VNB	1.11671e-16
C37	VPWR	B2	3.96927e-18
C38	A2#7	VNB	2.01248e-17
C39	A2#6	VNB	2.24472e-17
C40	VPWR#6	VPWR#5	1.76248e-19
C41	A1#3	VNB	6.63648e-17
C42	VGND#2	a_206_392#	8.18611e-19
C43	B1#4	VNB	2.88995e-17
C44	B2#5	VNB	1.76782e-17
C45	B2#6	VNB	1.63062e-17
C46	B1#2	VNB	9.74958e-17
C47	a_206_392##11	VNB	3.09911e-17
C48	a_27_136##3	A2#7	1.42705e-18
C49	a_206_392##10	VNB	2.50264e-17
C50	VGND	A2#3	3.25134e-18
C51	a_206_392##8	VNB	2.45628e-17
C52	a_206_392#	VNB	3.07815e-17
C53	VPWR#6	VNB	9.18512e-17
C54	a_116_392##2	VNB	6.40066e-18
C55	a_206_392##16	VNB	5.00544e-18
C56	a_116_392#	VNB	3.4063e-18
C57	VGND	B1#3	1.37634e-17
C58	VPWR#9	VNB	4.05082e-18
C59	a_516_392##2	VNB	3.58982e-18
C60	a_516_392#	VNB	3.40049e-18
C61	a_206_392##15	B1#5	2.31008e-17
C62	VPWR#8	VNB	4.07679e-18
C63	X#3	VNB	2.79688e-18
C64	VGND	a_206_392##6	5.9486e-18
C65	VPWR#7	VNB	4.06901e-18
C66	X#6	VNB	2.37144e-18
C67	a_27_136##4	a_27_136##8	1.20992e-20
C68	VGND	VGND#4	4.12582e-17
C69	VPWR#1	VNB	8.60616e-17
C70	VPWR	A2#3	3.17512e-18
C71	a_27_136##3	VNB	3.9893e-17
C72	VGND#11	VNB	6.05292e-18
C73	VGND#10	VNB	8.16322e-18
C74	a_27_136##4	VNB	3.93225e-20
C75	a_206_392##18	VNB	3.65982e-18
C76	a_27_136##8	VNB	4.26762e-18
C77	VGND#9	VNB	1.06961e-17
C78	X#7	VNB	2.16317e-18
C79	VGND#8	VNB	4.05133e-20
C80	A1	B2	2.18031e-17
C81	X#5	VNB	4.87971e-18
C82	VGND#1	VNB	5.95571e-17
C83	VPWR	a_206_392##6	4.80907e-18
C84	a_27_136##2	VNB	3.81863e-19
C85	VGND#11	A2#7	3.29346e-17
C86	a_206_392##15	VNB	9.12712e-18
C87	VPWR	VPWR#4	1.74863e-17
C88	a_206_392##17	VNB	9.96893e-18
C89	X#2	VNB	5.02235e-18
C90	X#4	VNB	4.62809e-18
C91	VPWR#2	VNB	3.81222e-17
C92	VGND#10	A1#4	1.14677e-18
C93	VPWR	A1#5	5.93254e-18
C94	VPWR#3	VNB	3.16353e-17
C95	VPWR#5	VNB	5.4661e-17
C96	VGND#2	VNB	3.16327e-17
C97	VPWR	A2#5	1.35872e-18
C98	VGND#3	VNB	3.65364e-17
C99	B1	A1#2	4.80982e-19
C100	VGND#5	VNB	3.64689e-17
C101	A1#7	A2#4	5.17641e-18
C102	VPWR	A2#1	1.44282e-18
C103	B1	B1#3	2.49121e-17
C104	VPWR	A1#1	1.92347e-18
C105	a_27_136##3	A2#6	2.02452e-19
C106	VGND#2	X#7	7.46705e-18
C107	VGND	A1#4	4.94827e-18
C108	VPWR	B1#5	1.8454e-18
C109	a_206_392##15	a_206_392##14	3.41731e-18
C110	VGND	A2#7	2.09146e-18
C111	VPWR	B2#7	1.37988e-18
C112	VPWR#5	A2#1	4.4496e-18
C113	VGND	A2#6	3.73439e-18
C114	VPWR	B2#1	1.42781e-18
C115	VGND	A1#3	4.12958e-18
C116	A2#7	a_27_136#	4.24533e-18
C117	VPWR	B1#1	2.55646e-18
C118	VGND#4	B1	8.13955e-18
C119	VGND	B2#5	4.6358e-18
C120	VPWR	a_206_392##12	2.47117e-18
C121	a_116_392#	A2#4	1.88424e-19
C122	VGND	B2#6	4.6358e-18
C123	A1	A1#2	5.22141e-18
C124	VPWR	a_206_392##13	2.62419e-19
C125	VGND	B1#2	7.29556e-18
C126	a_206_392##18	a_27_136##6	3.69296e-17
C127	a_116_392##2	VPWR#5	1.35934e-17
C128	VGND	a_206_392##11	1.47568e-18
C129	VPWR	a_206_392##9	2.05458e-19
C130	VGND	a_206_392##10	6.79644e-19
C131	VPWR	a_206_392##7	4.79564e-18
C132	VGND	a_206_392##8	6.67333e-19
C133	a_206_392##15	B2#7	2.43966e-17
C134	VPWR#6	a_116_392##2	1.19055e-16
C135	VGND	a_206_392#	4.34749e-19
C136	VGND#11	A2#6	2.26869e-18
C137	VGND	VPWR#6	3.59497e-18
C138	B2	A1#2	2.4518e-18
C139	a_516_392#	B1#2	8.92547e-19
C140	B2	B1#3	4.74396e-19
C141	VGND#10	A2#7	8.02215e-19
C142	A2#4	VNB	5.50655e-17
C143	VGND#3	X#7	5.3707e-18
C144	B2#4	VNB	5.84701e-17
C145	a_206_392##2	VNB	3.97047e-17
C146	VGND	VPWR#1	4.24182e-18
C147	a_206_392##4	VNB	2.56611e-17
C148	A2#6	a_27_136#	1.29482e-17
C149	VGND	a_27_136##3	1.41153e-17
C150	VPWR	VPWR#6	4.14689e-17
C151	a_206_392##15	a_516_392#	8.82031e-17
C152	VGND	a_27_136##4	7.53551e-18
C153	VPWR	a_116_392##2	2.33636e-17
C154	VGND	a_206_392##21	1.00264e-17
C155	VPWR	a_206_392##16	1.16201e-17
C156	VGND	a_27_136##6	4.78861e-18
C157	VPWR	a_116_392#	2.28475e-17
C158	VGND	a_206_392##18	2.236e-17
C159	VGND#11	A1#3	1.47248e-18
C160	VPWR#5	A1#1	4.25135e-18
C161	VGND	a_27_136##8	4.65584e-18
C162	VPWR	VPWR#9	2.17196e-17
C163	VGND	VGND#9	2.01534e-17
C164	VPWR	a_516_392##2	2.28324e-17
C165	VGND	X#7	1.4106e-17
C166	B1	A1#4	2.32891e-19
C167	A1	B1#5	2.70568e-18
C168	VGND	X#5	1.27202e-17
C169	A2#6	VGND#10	2.23433e-17
C170	VPWR	a_516_392#	2.2813e-17
C171	VGND	VGND#1	4.01876e-17
C172	a_206_392##15	B2#1	4.09618e-17
C173	VPWR	VPWR#8	2.06179e-17
C174	a_206_392##16	VPWR#5	4.99829e-19
C175	A1#3	A2#4	2.5229e-19
C176	VGND	A1#7	1.18314e-18
C177	VPWR	X#3	1.80345e-17
C178	B1	A2#6	5.26269e-19
C179	VPWR	VPWR#7	2.12714e-17
C180	B1	A1#3	1.06168e-17
C181	X	a_206_392#	3.0805e-18
C182	VPWR	X#6	1.71783e-17
C183	a_116_392##2	a_206_392##16	8.75756e-17
C184	B1	B1#4	7.42393e-18
C185	VPWR	VPWR#1	4.03077e-17
C186	A2#3	A1#2	2.68425e-18
C187	B2	B1#5	8.01573e-18
C188	VGND	a_27_136##2	1.20192e-17
C189	B1	B2#5	3.00974e-18
C190	a_206_392##17	a_516_392#	1.45862e-18
C191	VGND	a_206_392##15	9.97575e-19
C192	B1	B2#6	1.68051e-18
C193	VGND	a_206_392##17	6.82568e-18
C194	a_27_136##4	A2#6	1.18129e-18
C195	B1	B1#2	2.01508e-18
C196	a_27_136##8	a_206_392##18	6.11876e-17
C197	VGND	X#2	9.88203e-19
C198	VGND#3	VGND#2	2.35227e-19
C199	VGND	X#4	2.99445e-18
C200	B2	B1#1	3.81114e-19
C201	a_206_392##15	VPWR#8	2.31252e-17
C202	A1#3	VGND#10	2.16101e-17
C203	VPWR#6	VPWR#9	4.27417e-20
C204	VGND	VGND#2	4.29084e-17
C205	a_116_392##2	a_116_392#	2.59148e-18
C206	VGND	VGND#3	2.63363e-17
C207	VGND	VGND#5	5.33282e-17
C208	a_206_392##21	A2#6	3.6827e-19
C209	VGND#2	X#5	1.12972e-17
C210	VPWR#5	B1#5	4.284e-18
C211	X	VPWR#1	1.51666e-17
C212	VPWR	A1#7	1.08768e-18
C213	a_206_392##15	B1#1	8.63112e-18
C214	a_116_392#	VPWR#5	4.86475e-17
C215	A1	B1#4	3.29492e-18
C216	a_27_136##4	A1#3	4.28426e-17
C217	a_206_392##17	VPWR#8	4.25098e-17
C218	VPWR	a_206_392##15	1.43739e-17
C219	a_116_392#	a_206_392##16	9.283e-17
C220	VPWR	a_206_392##17	4.54718e-18
C221	VGND#4	B1#3	2.07531e-17
C222	A2#3	A1#5	5.17778e-18
C223	VGND#10	B1#4	9.7946e-19
C224	VPWR	X#2	2.55818e-18
C225	B2	B1#4	8.78754e-18
C226	VPWR	X#4	4.39791e-19
C227	a_206_392##21	A1#3	1.30154e-18
C228	VPWR	VPWR#2	2.96128e-17
C229	VPWR	VPWR#3	2.762e-17
C230	VGND#1	X	2.75133e-17
C231	a_206_392##18	A2#6	1.90785e-21
C232	VPWR	VPWR#5	4.01946e-17
C233	B1#5	B2#4	1.33818e-17
C234	VGND#10	B1	3.19788e-17
C235	B2	B1#2	1.04131e-18
C236	a_206_392##16	VPWR#9	1.89388e-17
C237	a_27_136##4	B1#4	3.67646e-17
C238	B1	a_27_136##4	3.59605e-17
C239	a_206_392##15	a_206_392##12	1.30396e-18
C240	VGND#2	VGND#1	1.12503e-18
C241	B1	a_206_392##21	1.41229e-17
C242	A1	a_206_392##16	9.17347e-18
C243	a_206_392##18	X#7	2.26216e-18
C244	B1	a_206_392##18	2.32858e-18
C245	VGND#10	B2#5	4.06144e-21
C246	A1	VPWR#9	1.10652e-18
C247	a_206_392##17	X#3	2.33145e-17
C248	a_206_392##17	a_206_392##12	1.79061e-17
C249	A2#3	A2#4	3.3757e-17
C250	a_206_392##21	B1#4	2.33861e-17
C251	A1#2	B1#5	1.30461e-17
C252	a_116_392#	VPWR#9	6.7779e-17
C253	a_206_392##18	A1#3	1.3182e-19
C254	X#2	a_206_392##2	6.26441e-18
C255	a_27_136##4	B2#5	2.93794e-19
C256	X#2	B1#1	3.31559e-20
C257	VGND#10	B2#6	2.51594e-21
C258	a_206_392##15	a_206_392##13	2.9395e-19
C259	B1#4	B2#4	1.43962e-17
C260	B2	a_206_392##14	3.95187e-18
C261	a_206_392##21	B2#5	3.08628e-17
C262	a_516_392##2	VPWR#5	2.14794e-17
C263	a_206_392##18	B1#4	2.00424e-19
C264	a_27_136##4	A1#7	2.68918e-17
C265	a_27_136##3	a_27_136##2	2.49329e-18
C266	a_27_136##4	B2#6	1.79581e-19
C267	A1	a_27_136##4	2.58117e-17
C268	a_27_136##6	B2#5	3.2867e-17
C269	VGND	a_206_392##2	1.05879e-19
C270	A2#3	A1#4	6.74026e-18
C271	VPWR#9	a_516_392##2	6.78067e-17
C272	VGND#9	X#7	2.16596e-17
C273	X#2	a_206_392##12	2.62379e-19
C274	VPWR#3	B1#1	7.56545e-18
C275	A1#5	A2#5	4.22146e-17
C276	a_206_392##18	B2#5	9.11605e-19
C277	VGND#5	B1	5.18565e-17
C278	a_27_136##4	B1#2	9.63746e-20
C279	a_516_392##2	B2#4	1.97925e-19
C280	a_27_136##4	B2	2.44047e-17
C281	A2#3	A1#3	5.52288e-20
C282	VGND#9	B1#4	2.69091e-19
C283	VPWR#4	B2#7	4.44973e-18
C284	a_206_392##12	a_206_392##6	9.65988e-19
C285	a_27_136##2	VGND#11	4.13751e-17
C286	A2#5	A2#1	3.3479e-17
C287	a_27_136##6	B2#6	3.18399e-17
C288	a_27_136##6	B2	7.04312e-17
C289	A2#4	A1#2	2.19577e-17
C290	VPWR#4	B2#1	4.4496e-18
C291	VGND#9	VGND#8	2.14881e-18
C292	X#2	a_206_392##4	4.00847e-18
C293	X#4	a_206_392##2	1.64083e-17
C294	a_516_392#	VPWR#3	1.01756e-17
C295	X#2	a_206_392##13	8.37669e-19
C296	VPWR#3	a_206_392##12	4.61722e-18
C297	A1#2	B1#4	1.48303e-17
C298	a_206_392##18	B2#6	3.31634e-17
C299	X#3	X#2	9.42319e-19
C300	a_516_392##2	a_206_392##14	7.06526e-19
C301	A2#1	A1#1	3.1055e-17
C302	VGND#9	B2#5	2.38052e-19
C303	A1#3	B1#3	2.12709e-17
C304	a_27_136##6	B1#2	9.61013e-20
C305	A1	a_206_392##15	1.39909e-17
C306	a_27_136##2	a_27_136#	1.99376e-18
C307	a_206_392##21	B2#4	3.19714e-19
C308	X#7	VGND#8	4.35525e-17
C309	B1#3	B2#5	1.73104e-17
C310	X#7	B2#5	1.70842e-19
C311	VPWR#2	a_206_392##13	5.72045e-18
C312	A1#1	B1#5	2.8533e-17
C313	a_516_392##2	a_516_392#	2.59148e-18
C314	a_27_136##2	A1#4	2.8769e-18
C315	a_206_392##18	B1#2	5.03909e-17
C316	a_27_136##3	VPWR#6	1.46611e-17
C317	X#2	a_206_392##9	2.3249e-17
C318	VGND#9	B2#6	3.85967e-19
C319	B1#3	B1#2	9.52716e-19
C320	A2#3	a_116_392##2	2.09192e-17
C321	X#2	VPWR#7	2.65434e-17
C322	A2#3	a_206_392##16	5.85115e-17
C323	a_27_136##8	B1#2	3.61105e-17
C324	B1#5	B2#7	4.21684e-17
C325	B2	a_206_392##15	1.21545e-16
C326	a_516_392#	a_206_392##14	2.69038e-19
C327	X#7	X#5	2.85734e-18
C328	a_27_136##2	VGND#10	4.70965e-17
C329	X#3	VPWR#2	6.36194e-18
C330	X#7	B2#6	1.61792e-19
C331	a_27_136##3	a_116_392##2	7.71442e-18
C332	a_206_392##18	a_206_392##11	1.10048e-18
C333	a_27_136##2	A2#7	2.4121e-17
C334	VPWR#2	a_206_392##9	5.6723e-18
C335	VGND#9	B1#2	6.77855e-18
C336	VPWR#2	a_206_392##2	2.22453e-20
C337	X#4	a_206_392##4	4.68186e-18
C338	a_206_392##16	A1#2	1.94884e-18
C339	B2#7	B2#1	3.05041e-17
C340	X#2	a_206_392##7	8.62925e-18
C341	B1#3	B2#4	1.21471e-18
C342	B1#2	a_206_392##6	3.3009e-19
C343	X#3	VPWR#3	1.16903e-17
C344	VGND#4	B2#5	4.98472e-18
C345	a_27_136##8	a_206_392##11	3.86416e-19
C346	X#2	X#6	1.63694e-19
C347	VGND#8	X#5	3.77975e-17
C348	VPWR#9	A1#2	7.84532e-19
C349	a_27_136##2	a_27_136##4	3.69779e-18
C350	VGND#4	B2#6	3.80621e-18
C351	X#7	B1#2	1.60299e-18
C352	VGND#4	B1#2	1.52235e-17
C353	a_27_136##6	B2#4	4.74454e-18
C354	a_27_136##2	A2#6	3.63217e-17
C355	a_206_392##11	VGND#9	1.95705e-17
C356	a_516_392#	VPWR#8	5.90771e-17
C357	B2#1	B1#1	3.13316e-17
C358	VPWR#5	A2#4	5.03844e-20
C359	VGND#8	B1#2	1.44373e-19
C360	X	a_206_392##2	6.70353e-18
C361	a_516_392##2	B1#3	2.51651e-19
C362	VGND#8	VGND#1	2.42964e-18
C363	X#7	a_206_392##11	4.16511e-17
C364	B2#4	B1#1	5.81365e-18
C365	X#2	VPWR#1	2.95792e-17
C366	B1#1	a_206_392##12	3.66658e-17
C367	VGND#9	a_206_392##10	1.21499e-18
C368	a_516_392#	B2#4	1.96341e-19
C369	X#6	VPWR#2	1.1696e-17
C370	a_27_136##2	A1#3	3.94629e-18
C371	VGND#8	a_206_392##11	1.55114e-18
C372	X#4	VPWR#1	1.76336e-18
C373	X#5	VGND#1	4.85769e-17
C374	a_27_136##2	A2#4	4.68328e-18
C375	VPWR#8	X#3	9.90339e-17
C376	VPWR#2	a_206_392##4	1.81221e-20
C377	X#7	a_206_392##10	2.92048e-17
C378	a_206_392##12	a_206_392##13	3.93287e-17
C379	X#5	a_206_392##11	2.16399e-19
C380	VPWR#4	VPWR#6	4.54873e-17
C381	a_206_392##17	X#4	4.13238e-19
C382	B2#4	B1#2	2.23271e-17
C383	VGND#8	a_206_392##10	2.79635e-17
C384	a_27_136##2	B1#4	2.68075e-19
C385	a_27_136##4	a_206_392##15	6.04254e-18
C386	VPWR#2	VPWR#1	8.24648e-19
C387	VPWR#8	VPWR#7	1.24537e-18
C388	a_27_136##4	a_206_392##16	3.32245e-18
C389	a_206_392##18	B2#4	6.54573e-19
C390	a_27_136##4	A1#2	2.51908e-18
C391	X#7	a_206_392##8	6.41798e-19
C392	a_206_392##13	a_206_392##9	1.69254e-17
C393	X#5	a_206_392##10	5.09334e-19
C394	a_206_392##6	X#3	4.78413e-17
C395	VGND#10	B1#3	4.36173e-19
C396	X#3	VPWR#7	5.24207e-17
C397	VGND#8	a_206_392##8	3.21079e-17
C398	a_206_392##6	VPWR#7	9.19096e-18
C399	VPWR#6	A1#5	2.98145e-17
C400	a_27_136##4	B1#3	1.41917e-19
C401	a_516_392##2	VPWR#4	2.71886e-17
C402	VPWR#8	B2#4	1.52238e-19
C403	a_206_392##9	a_206_392##7	4.61618e-17
C404	a_206_392##21	B1#3	5.4211e-18
C405	X#7	a_206_392#	2.80474e-19
C406	a_116_392##2	A1#5	5.32916e-17
C407	a_27_136##6	B1#3	7.78095e-19
C408	A2#3	A1#7	1.7484e-17
C409	a_206_392##8	X#5	1.76009e-17
C410	a_206_392##15	B1#4	2.43745e-19
C411	X#3	X#6	1.12669e-18
C412	VPWR#6	A2#5	5.03466e-18
C413	a_516_392#	VPWR#4	3.85708e-17
C414	a_206_392##18	B1#3	2.72094e-18
C415	VGND#8	a_206_392#	1.54932e-18
C416	a_206_392##15	VPWR#5	4.99829e-19
C417	a_116_392##2	A2#5	7.13714e-17
C418	a_206_392##17	VPWR#3	6.48259e-19
C419	a_206_392##17	a_206_392##21	3.74129e-21
C420	a_206_392##17	B1#4	1.32452e-19
C421	VGND#9	B1#3	7.70427e-19
C422	VGND#1	a_206_392##8	2.61996e-18
C423	VPWR#9	A1#5	8.51599e-20
C424	A2#5	a_206_392##16	2.03968e-17
C425	VPWR#6	A2#1	8.5308e-20
C426	a_27_136##6	a_206_392##15	1.95816e-18
C427	VPWR#7	X#6	5.15685e-17
C428	a_27_136##2	A2#3	7.06496e-17
C429	A1#7	A1#2	1.2792e-17
C430	a_206_392#	X#5	1.2771e-17
C431	VGND#5	a_27_136##2	2.43628e-18
C432	a_116_392#	A2#5	4.35441e-19
C433	a_116_392##2	A2#1	1.6408e-18
C434	a_206_392##6	a_206_392##4	1.77293e-17
C435	VPWR#9	A2#5	8.29344e-20
C436	VPWR#6	A1#1	2.26776e-20
C437	a_206_392##16	A2#1	5.90305e-17
C438	VPWR#4	VPWR#1	3.11029e-17
C439	VGND#1	a_206_392#	3.78019e-17
C440	VPWR#7	VPWR#1	1.35515e-18
C441	a_206_392##17	B2#5	1.96049e-19
C442	a_116_392##2	A1#1	1.98955e-19
C443	a_116_392#	A2#1	3.44292e-17
C444	VGND#5	A1#4	7.15401e-20
C445	VPWR#6	B1#5	1.34115e-20
C446	a_206_392##16	A1#1	2.19609e-17
C447	VPWR#9	A2#1	5.87128e-19
C448	a_27_136##8	a_206_392##6	1.43122e-19
C449	VGND#4	a_206_392##21	6.27961e-18
C450	a_116_392#	A1#1	5.53682e-17
C451	X#6	VPWR#1	7.7337e-17
C452	VGND#9	a_206_392##6	3.35316e-18
C453	A1#4	A2#7	4.04875e-17
C454	B1#2	a_206_392##12	1.34116e-17
C455	a_206_392##15	A1#2	6.88566e-20
C456	VGND#4	B2#4	4.53317e-19
C457	X#7	a_206_392##6	4.79414e-17
C458	a_206_392##16	B1#5	2.28498e-19
C459	A1#1	VPWR#9	3.28111e-17
C460	a_206_392##18	a_206_392##17	2.61827e-18
C461	a_206_392##17	B2#6	3.27434e-19
C462	VGND#4	a_206_392##18	1.09991e-17
C463	a_206_392##13	a_206_392##4	1.4211e-19
C464	VGND#4	a_206_392##2	2.96665e-20
C465	VGND#8	a_206_392##6	2.1671e-19
C466	a_27_136##8	a_206_392##15	1.2578e-17
C467	X#4	X#2	4.12441e-18
C468	a_206_392##15	B1#2	5.62939e-18
C469	a_206_392##16	B2#7	1.23159e-19
C470	A1#4	A1#3	4.349e-19
C471	B1#5	VPWR#9	2.8385e-17
C472	A2#7	A2#6	3.39804e-17
C473	a_206_392##4	a_206_392##2	3.49329e-18
C474	a_206_392##15	B1#3	1.45783e-19
C475	a_516_392##2	B1#5	4.3162e-17
C476	a_27_136##8	a_206_392##17	6.34503e-17
C477	a_206_392##17	B1#2	2.01529e-17
C478	a_206_392##16	B2#1	8.9255e-20
C479	VPWR#8	A1#1	4.53998e-20
C480	VPWR#9	B2#7	5.09322e-19
C481	X#2	VPWR#2	2.84424e-19
C482	VGND#5	A2#6	2.21044e-18
C483	VGND#4	VGND#1	2.70639e-17
C484	A1#3	A2#6	3.92244e-17
C485	a_516_392##2	B2#7	5.70959e-17
C486	VPWR#9	B2#1	2.29631e-19
C487	B2#7	a_206_392##14	8.91869e-18
C488	VPWR#8	B1#5	5.48632e-20
C489	VGND#2	a_206_392##2	6.78016e-20
C490	VGND#3	a_206_392##17	1.1278e-18
C491	a_206_392##17	VGND#9	2.46427e-17
C492	VPWR#4	B2#4	4.03842e-20
C493	a_206_392##17	a_206_392##11	6.79098e-18
C494	a_516_392##2	B2#1	1.19957e-18
C495	a_516_392#	B2#7	4.35441e-19
C496	VGND#5	A1#2	2.69692e-20
C497	A1#3	B1#4	2.66325e-17
C498	VPWR#9	B1#1	6.40059e-20
C499	B2#1	a_206_392##14	2.26517e-17
C500	VPWR#8	B2#7	1.7253e-19
C501	a_27_136##3	VGND#11	4.76325e-17
C502	VGND#5	A1#3	2.71985e-17
C503	VGND#5	A2#4	6.89866e-20
C504	A1#7	a_206_392##16	2.67077e-17
C505	a_516_392##2	B1#1	1.98955e-19
C506	a_516_392#	B2#1	3.44335e-17
C507	a_206_392##15	a_206_392##6	4.04181e-20
C508	B2	B2#4	3.56927e-17
C509	a_206_392##17	X#7	2.12836e-17
C510	VPWR#9	a_206_392##12	4.88434e-20
C511	a_206_392##17	a_206_392##6	3.78053e-18
C512	VPWR#8	B2#1	1.21819e-18
C513	B1#4	B2#5	3.63801e-17
C514	VGND#5	B1#3	9.92283e-18
C515	a_516_392#	B1#1	5.40732e-17
C516	X#4	B1#2	6.12264e-20
C517	a_206_392##15	B2#4	1.16308e-17
C518	B1#1	VPWR#8	3.57493e-17
C519	a_206_392##6	X#2	5.40936e-17
C520	VGND#2	a_206_392##4	3.40045e-21
C521	a_516_392#	a_206_392##12	1.23121e-18
C522	a_206_392##2	X#6	2.55731e-19
C523	X#4	a_206_392##6	5.30205e-17
C524	B1#4	B1#2	3.87733e-20
C525	B2#5	B2#6	2.53393e-17
C526	a_206_392##4	a_206_392##7	2.33506e-19
C527	VPWR#2	a_206_392##6	1.0645e-20
C528	VPWR#3	VPWR#2	7.87344e-19
C529	a_206_392##12	VPWR#8	3.28635e-17
C530	VPWR#7	B1#1	2.18352e-19
C531	VPWR#3	B1#2	7.93763e-20
C532	X#4	a_206_392##11	3.98852e-20
C533	VPWR#3	a_206_392##6	3.9987e-20
C534	VGND#11	VGND#10	7.99213e-18
C535	a_27_136##2	a_116_392##2	1.92015e-18
C536	a_116_392##2	A1#4	6.18256e-19
C537	a_206_392##12	X#3	2.05929e-17
C538	VPWR#8	a_206_392##13	2.9016e-18
C539	VPWR#7	a_206_392##12	9.35782e-19
C540	VGND#2	a_206_392##6	5.39539e-20
C541	B1#2	B2#6	4.71456e-17
C542	X#3	a_206_392##13	7.84056e-17
C543	VGND#3	a_206_392##6	4.6976e-19
C544	A1#5	A2#4	1.31044e-17
C545	a_27_136##2	a_206_392##16	5.65947e-18
C546	X#4	a_206_392##10	9.38773e-20
C547	VPWR#8	a_206_392##9	2.30589e-19
C548	a_206_392##17	B2#4	6.71629e-19
C549	a_206_392##13	VPWR#7	4.1215e-17
C550	VGND#2	B1#2	1.47248e-19
C551	VGND#5	a_27_136##4	1.899e-19
C552	X#3	a_206_392##9	1.63184e-18
C553	X#6	a_206_392##13	1.33912e-18
C554	B1#2	a_206_392##11	5.36629e-18
C555	VGND#4	VGND#2	4.173e-17
C556	A1#4	A2#4	1.54094e-17
C557	VPWR#4	VPWR#2	4.8911e-17
C558	VGND#2	X#4	2.91756e-19
C559	a_206_392##9	VPWR#7	3.54981e-17
C560	VGND#3	B1#2	1.48263e-18
C561	VGND#4	VGND#3	4.62703e-17
C562	VPWR#1	a_206_392##13	2.29213e-19
C563	a_206_392##15	a_206_392##4	1.97265e-19
C564	X#4	a_206_392##8	1.69474e-17
C565	VPWR#4	VPWR#3	4.1789e-17
C566	a_206_392##17	a_206_392##2	3.01454e-20
C567	VGND#4	VGND#5	5.36356e-17
C568	X#6	a_206_392##9	4.79463e-17
C569	a_27_136##4	VGND#10	3.71769e-17
C570	a_206_392##16	A1#3	4.55124e-19
C571	VPWR#4	VPWR#5	7.18818e-17
C572	X#7	X#4	5.26646e-19
C573	VGND#2	a_206_392##11	8.26931e-19
C574	VGND#8	a_206_392##4	8.53486e-19
C575	VPWR#7	a_206_392##7	1.20483e-18
C576	a_206_392##11	a_206_392##10	3.92301e-17
C577	VPWR#1	a_206_392##9	1.43451e-18
C578	a_116_392##2	A2#4	3.7029e-19
C579	a_206_392##16	a_206_392##15	9.09445e-19
C580	a_116_392#	A1#3	5.56683e-19
C581	X#6	a_206_392##7	4.88106e-17
C582	VGND#10	a_206_392##21	3.79907e-18
C583	VGND#3	a_206_392##11	4.99651e-18
C584	X#4	a_206_392#	7.92621e-18
C585	VPWR#1	a_206_392##7	3.2891e-17
C586	X#4	VGND#8	1.94095e-17
C587	VGND#11	A2#4	2.5244e-19
C588	VGND#2	a_206_392##10	4.72727e-18
C589	a_206_392##10	a_206_392##8	3.9861e-17
C590	a_27_136##4	a_206_392##21	2.90203e-17
C591	VPWR#9	B1#4	8.9448e-20
C592	a_206_392##15	A2#1	1.237e-19
C593	VGND#3	a_206_392##18	5.66201e-18
C594	a_206_392##17	a_206_392##4	4.23344e-20
C595	a_516_392##2	B1#4	1.39019e-19
C596	X#4	X#5	5.50029e-18
C597	a_206_392##15	VPWR#9	2.67025e-17
C598	VGND#2	a_206_392##8	4.79552e-18
C599	a_206_392##16	A2#4	7.11826e-18
C600	a_206_392##8	a_206_392#	4.13691e-17
C601	VGND#9	a_206_392##12	1.03238e-18
C602	a_206_392##15	A1#1	4.32773e-19
C603	a_27_136##3	A1#4	5.34349e-17
C604	a_27_136##6	a_206_392##21	3.30898e-17
C605	VGND#6	a_27_136##3	8.14327e-18
C606	VGND#6	VNB	4.66318e-17
C607	VGND#6	VGND#5	2.78944e-18
C608	VGND#6	A2#7	4.47995e-19
C609	VGND#6	a_27_136##2	2.36698e-18
C610	VGND	VGND#6	5.51407e-17
C611	VGND#6	A1#3	4.40417e-19
C612	VGND#6	A1#4	2.70667e-17
C613	VGND#4	VGND#6	5.39019e-17
C614	VGND#6	A2#4	1.78738e-19
*
*
.ENDS sky130_fd_sc_hs__o22a_4
*
