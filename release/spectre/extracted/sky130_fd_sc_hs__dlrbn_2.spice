* Extracted by Quantus, converted by sky130cad/quantus.py
*
*
*
*                       LINUX           Wed Nov 18 08:31:04 2026
*
*
*
*  PROGRAM  advgen
*
*  Name           : advgen - Quantus - (64-bit)
*  Version        : 25.1.0-p047
*  Build Date     : Thu Dec 11 23:20:30 PST 2025
*
*  HSPICE LIBRARY
*
*  OPERATING_TEMPERATURE 150
*  QRC_TECH_DIR <path>/tech
*
*
*

*
.SUBCKT sky130_fd_sc_hs__dlrbn_2 VPB VNB VGND VPWR Q Q_N RESET_B D GATE_N
*
*
*  caps2d version: 10
*
*
*       TRANSISTOR CARDS
*
*
XM15 a_27_112##6 D#3 VGND#15 VNB sky130_fd_pr__nfet_01v8_lvt l=0.15 w=0.55 ad=0.15675 as=0.30395 pd=1.67 ps=2.34
XM19 VGND#15 GATE_N#3 a_230_74##13 VNB sky130_fd_pr__nfet_01v8_lvt l=0.15 w=0.74 ad=0.30395 as=0.2109 pd=2.34 ps=2.05
XM6 a_363_74##6 a_230_74##3 VGND#14 VNB sky130_fd_pr__nfet_01v8_lvt l=0.15 w=0.74 ad=0.2109 as=0.3834 pd=2.05 ps=2.6
XM1 VGND#14 a_27_112##3 a_592_74# VNB sky130_fd_pr__nfet_01v8_lvt l=0.15 w=0.64 ad=0.3834 as=0.1536 pd=2.6 ps=1.76
XM26 a_592_74# a_230_74##5 a_670_74##8 VNB sky130_fd_pr__nfet_01v8_lvt l=0.15 w=0.64 ad=0.1536 as=0.244 pd=1.76 ps=2.18
XM22 a_670_74##8 a_363_74# a_790_74# VNB sky130_fd_pr__nfet_01v8_lvt l=0.15 w=0.42 ad=0.244 as=0.1008 pd=2.18 ps=1.32
XM9 a_790_74# a_838_48# VGND#13 VNB sky130_fd_pr__nfet_01v8_lvt l=0.15 w=0.42 ad=0.1008 as=0.1197 pd=1.32 ps=1.41
XM16 a_838_48##16 a_670_74# a_1066_74# VNB sky130_fd_pr__nfet_01v8_lvt l=0.15 w=0.74 ad=0.2109 as=0.1776 pd=2.05 ps=1.96
XM12 a_1066_74# RESET_B#3 VGND#12 VNB sky130_fd_pr__nfet_01v8_lvt l=0.15 w=0.74 ad=0.1776 as=0.3256 pd=1.96 ps=2.36
XM14 Q#1 a_838_48##12 VGND#12 VNB sky130_fd_pr__nfet_01v8_lvt l=0.15 w=0.74 ad=0.2072 as=0.3256 pd=2.04 ps=2.36
XM17 VGND#11 a_838_48##10 Q#1 VNB sky130_fd_pr__nfet_01v8_lvt l=0.15 w=0.74 ad=0.249 as=0.2072 pd=2.18 ps=2.04
XM8 VGND#11 a_838_48##4 a_1446_368##10 VNB sky130_fd_pr__nfet_01v8_lvt l=0.15 w=0.64 ad=0.249 as=0.1824 pd=2.18 ps=1.85
XM4 VGND#10 a_1446_368##6 Q_N#3 VNB sky130_fd_pr__nfet_01v8_lvt l=0.15 w=0.74 ad=0.2109 as=0.2368 pd=2.05 ps=2.12
XM20 Q_N#3 a_1446_368# VGND#1 VNB sky130_fd_pr__nfet_01v8_lvt l=0.15 w=0.74 ad=0.2368 as=0.2109 pd=2.12 ps=2.05
XM21 a_27_112##7 D#1 VPWR#15 VPB sky130_fd_pr__pfet_01v8 l=0.15 w=0.84 ad=0.2478 as=0.4452 pd=2.27 ps=2.74
XM0 VPWR#15 GATE_N#1 a_230_74##11 VPB sky130_fd_pr__pfet_01v8 l=0.15 w=0.84 ad=0.4452 as=0.2478 pd=2.74 ps=2.27
XM11 a_363_74##7 a_230_74# VPWR#14 VPB sky130_fd_pr__pfet_01v8 l=0.15 w=0.84 ad=0.383 as=0.5049 pd=2.88 ps=3.28
XM5 VPWR#14 a_27_112# a_595_392# VPB sky130_fd_pr__pfet_01v8 l=0.15 w=1 ad=0.5049 as=0.24 pd=3.28 ps=2.48
XM13 a_595_392# a_363_74##3 a_670_74##7 VPB sky130_fd_pr__pfet_01v8 l=0.15 w=1 ad=0.24 as=0.3478 pd=2.48 ps=2.8
XM2 a_670_74##7 a_230_74##6 a_783_508# VPB sky130_fd_pr__pfet_01v8 l=0.15 w=0.42 ad=0.3478 as=0.1995 pd=2.8 ps=1.79
XM18 a_783_508# a_838_48##3 VPWR#13 VPB sky130_fd_pr__pfet_01v8 l=0.15 w=0.42 ad=0.1995 as=0.448 pd=1.79 ps=3.49
XM27 VPWR#13 a_670_74##4 a_838_48##14 VPB sky130_fd_pr__pfet_01v8 l=0.15 w=1.12 ad=0.448 as=0.3472 pd=3.49 ps=2.86
XM3 a_838_48##14 RESET_B#1 VPWR#12 VPB sky130_fd_pr__pfet_01v8 l=0.15 w=1.12 ad=0.3472 as=0.392 pd=2.86 ps=2.94
XM7 VPWR#12 a_838_48##8 Q#3 VPB sky130_fd_pr__pfet_01v8 l=0.15 w=1.12 ad=0.392 as=0.336 pd=2.94 ps=2.84
XM23 Q#3 a_838_48##11 VPWR#11 VPB sky130_fd_pr__pfet_01v8 l=0.15 w=1.12 ad=0.336 as=0.3868 pd=2.84 ps=2.95
XM24 VPWR#11 a_838_48##9 a_1446_368##11 VPB sky130_fd_pr__pfet_01v8 l=0.15 w=1 ad=0.3868 as=0.295 pd=2.95 ps=2.59
XM10 Q_N#1 a_1446_368##7 VPWR#10 VPB sky130_fd_pr__pfet_01v8 l=0.15 w=1.12 ad=0.336 as=0.3304 pd=2.84 ps=2.83
XM25 VPWR#1 a_1446_368##5 Q_N#1 VPB sky130_fd_pr__pfet_01v8 l=0.15 w=1.12 ad=0.3304 as=0.336 pd=2.83 ps=2.84
*
*
*       RESISTOR AND CAP/DIODE CARDS
*
Rg1	D#1	D#2	398.769165
Rg2	D#2	D#3	307.521332
Rg3	GATE_N#1	GATE_N#2	401.091431
Rg4	GATE_N#2	GATE_N#3	364.360474
Rg5	a_230_74#	a_230_74##2	465.670959
Rg6	a_230_74##2	a_230_74##3	384.376617
Rg7	a_27_112#	a_27_112##2	400.207520
Rg8	a_27_112##2	a_27_112##3	480.096283
Rg9	a_230_74##4	a_230_74##5	439.477417
Rg10	a_363_74#	a_363_74##2	402.624939
Rg11	a_363_74##2	a_363_74##3	763.680298
Rg12	a_230_74##6	a_230_74##7	226.096359
Rg13	a_838_48#	a_838_48##2	877.919739
Rg14	a_838_48##2	a_838_48##3	240.449829
Rg15	a_670_74#	a_670_74##2	397.555725
Rg16	a_670_74##2	a_670_74##3	49.299824
Rg17	a_670_74##2	a_670_74##4	449.655212
Rg18	RESET_B#1	RESET_B#2	492.059540
Rg19	RESET_B#2	RESET_B#3	307.937683
Rg20	a_838_48##4	a_838_48##5	409.032959
Rg21	a_838_48##5	a_838_48##6	48.709202
Rg22	a_838_48##6	a_838_48##7	201.384872
Rg23	a_838_48##7	a_838_48##8	517.366577
Rg24	a_838_48##5	a_838_48##9	428.548065
Rg25	a_838_48##6	a_838_48##10	355.373108
Rg26	a_838_48##6	a_838_48##11	438.013031
Rg27	a_838_48##7	a_838_48##12	358.420502
Rg28	a_1446_368#	a_1446_368##2	297.977020
Rg29	a_1446_368##2	a_1446_368##3	217.126083
Rg30	a_1446_368##3	a_1446_368##4	49.210812
Rg31	a_1446_368##2	a_1446_368##5	560.530823
Rg32	a_1446_368##3	a_1446_368##6	325.003235
Rg33	a_1446_368##3	a_1446_368##7	517.509521
Rf1	D#2	D#5	81.320724
Rf2	D#6	D	1.204321
Rf3	D#5	D#6	2.584945
Rf4	GATE_N#2	GATE_N#5	80.812347
Rf5	GATE_N#6	GATE_N	0.695947
Rf6	GATE_N#5	GATE_N#6	2.924254
Rf7	a_27_112##2	a_27_112##5	425.882019
Rf8	a_27_112##5	a_27_112##6	105.907722
Rf9	a_27_112##5	a_27_112##7	20.975370
Rf10	a_363_74##2	a_363_74##5	316.814270
Rf11	a_363_74##5	a_363_74##6	14.176468
Rf12	a_363_74##5	a_363_74##7	82.910385
Rf13	a_230_74##7	a_230_74##4	361.226257
Rf14	a_230_74##4	a_230_74##10	72.561409
Rf15	a_230_74##10	a_230_74##12	116.738731
Rf16	a_230_74##12	a_230_74##13	105.461777
Rf17	a_230_74##11	a_230_74##12	15.000000
Rf18	a_670_74##3	a_670_74##6	202.064087
Rf19	a_670_74##6	a_670_74##7	123.074524
Rf20	a_670_74##6	a_670_74##8	137.498322
Rf21	RESET_B#4	RESET_B#2	161.326614
Rf22	RESET_B	RESET_B#6	1.093808
Rf23	RESET_B#4	RESET_B#6	9.354051
Rf24	Q	Q#2	0.984182
Rf25	Q#2	Q#3	81.872101
Rf26	Q#1	Q#2	15.000000
Rf27	a_838_48##6	a_838_48##15	304.356110
Rf28	a_838_48##15	a_838_48##16	77.092018
Rf29	a_838_48##15	a_838_48##2	196.982422
Rf30	a_838_48##14	a_838_48##15	5.000000
Rf31	a_1446_368##4	a_1446_368##9	95.053780
Rf32	a_1446_368##9	a_1446_368##10	34.671989
Rf33	a_1446_368##9	a_1446_368##11	42.407478
Rf34	Q_N	Q_N#2	0.186110
Rf35	Q_N#2	Q_N	13.585999
Rf36	Q_N	Q_N#3	85.529976
Rf37	Q_N#1	Q_N#2	5.000000
Rf38	VPWR#1	VPWR#2	117.837311
Rf39	VPWR#2	VPWR#3	77.372467
Rf40	VPWR#3	VPWR#4	65.696381
Rf41	VPWR#4	VPWR#5	83.418648
Rf42	VPWR#5	VPWR#6	107.549843
Rf43	VPWR#6	VPWR#7	56.224350
Rf44	VPWR#7	VPWR#8	135.947433
Rf46	VPWR#2	VPWR#10	52.877037
Rf47	VPWR#3	VPWR#11	37.263206
Rf48	VPWR#4	VPWR#12	33.326477
Rf49	VPWR#5	VPWR#13	24.305393
Rf50	VPWR#7	VPWR#14	25.256187
Rf51	VPWR#8	VPWR#15	55.164429
Rf52	VGND#1	VGND#2	109.178635
Rf53	VGND#2	VGND#3	74.499725
Rf54	VGND#3	VGND#4	77.068489
Rf55	VGND#4	VGND#5	97.895943
Rf56	VGND#5	VGND#6	84.771393
Rf57	VGND#6	VGND#7	58.021996
Rf58	VGND#7	VGND#8	129.586945
Rf60	VGND#2	VGND#10	42.664925
Rf61	VGND#3	VGND#11	37.855408
Rf62	VGND#4	VGND#12	32.223660
Rf63	VGND#5	VGND#13	37.794724
Rf64	VGND#7	VGND#14	25.558413
Rf65	VGND#8	VGND#15	32.814167
Rf72	a_230_74##2	a_230_74##10	160.232803
Re1	VPWR#2	VPWR	3.246228
Re2	VPWR	VPWR#6	1.159367
Re3	VGND#2	VGND	3.246228
Re4	VGND	VGND#6	1.159367
*
*       CAPACITOR CARDS
*
*
C1	a_1446_368##9	a_838_48##12	3.55506e-20
C2	Q#3	a_838_48##9	4.78013e-19
C3	VPWR#11	a_838_48##11	3.6088e-17
C4	a_670_74##8	a_363_74##3	1.08285e-19
C5	a_363_74##5	a_363_74##7	1.67746e-18
C6	RESET_B#3	a_838_48##12	1.97182e-17
C7	VGND#5	a_230_74##7	3.08612e-20
C8	Q#3	a_670_74##2	2.79793e-19
C9	VGND#7	a_27_112##3	2.2733e-17
C10	a_1446_368##11	a_838_48##8	2.17815e-19
C11	Q#3	a_838_48##11	3.65067e-17
C12	a_838_48##2	VPWR#5	3.10298e-17
C13	RESET_B#4	a_670_74##2	3.07064e-18
C14	VGND#15	VGND#7	5.37571e-19
C15	a_838_48##14	a_838_48##9	2.70535e-19
C16	VPWR#11	a_838_48##8	2.81247e-18
C17	VGND#5	a_27_112##3	3.32873e-20
C18	VGND#6	a_363_74##5	2.17564e-20
C19	VPWR#12	a_838_48##11	3.35555e-18
C20	a_1446_368##11	RESET_B#1	1.31616e-19
C21	VGND#11	VPWR#11	1.34597e-18
C22	Q#3	a_838_48##8	3.65701e-17
C23	a_670_74#	RESET_B#3	4.67214e-17
C24	GATE_N#6	a_27_112##5	3.34484e-17
C25	a_838_48##14	a_838_48##11	4.2024e-19
C26	VGND#11	a_838_48##5	7.20746e-19
C27	VGND#5	a_363_74##2	1.48195e-19
C28	a_230_74##7	VPWR#7	2.00917e-18
C29	VGND#7	a_230_74##3	1.50562e-17
C30	VPWR#12	a_838_48##8	4.77639e-17
C31	a_230_74##7	VPWR#5	3.869e-17
C32	RESET_B#4	RESET_B#2	1.71618e-17
C33	Q#3	RESET_B#1	1.87237e-18
C34	VGND#4	a_838_48##7	4.59862e-20
C35	a_838_48##14	a_838_48##8	1.78448e-17
C36	VGND#2	VGND#1	5.66689e-17
C37	Q#1	a_838_48##7	5.07446e-18
C38	RESET_B#1	VPWR#12	2.94238e-17
C39	a_27_112##5	a_230_74##11	7.76674e-17
C40	a_838_48#	a_670_74#	8.10302e-18
C41	a_670_74##6	a_670_74##2	3.45217e-19
C42	VGND#2	Q_N#3	1.3498e-17
C43	a_838_48##14	a_838_48##7	3.13406e-19
C44	VPWR#2	a_1446_368##2	2.42022e-20
C45	VGND#5	a_670_74##2	5.14666e-21
C46	a_838_48##14	RESET_B#1	8.0494e-17
C47	VGND#7	GATE_N#3	9.17241e-19
C48	Q#1	Q#3	1.672e-18
C49	VPWR#12	a_670_74##4	1.24452e-18
C50	VGND#2	a_1446_368##10	2.86108e-17
C51	Q#1	a_838_48##5	2.28605e-19
C52	a_670_74##6	a_670_74##3	2.35713e-17
C53	a_27_112##5	VPWR#15	1.00105e-16
C54	a_838_48##14	a_670_74##4	7.39958e-17
C55	VGND#11	VGND#2	1.53964e-19
C56	a_363_74#	a_838_48#	3.96229e-17
C57	GATE_N#6	a_230_74##11	2.63856e-17
C58	VGND#7	a_27_112##2	6.19981e-19
C59	VPWR#12	a_838_48##3	1.84079e-19
C60	VGND#3	a_838_48##7	2.4964e-20
C61	a_670_74##4	VPWR#13	1.46793e-17
C62	a_838_48##14	a_670_74##2	6.27099e-18
C63	a_838_48##14	a_838_48##3	1.4246e-18
C64	a_670_74##6	a_838_48##2	4.64522e-17
C65	D#6	a_27_112##5	1.97948e-17
C66	VGND#2	a_1446_368##2	6.29764e-19
C67	a_27_112##5	a_27_112##7	4.3243e-18
C68	VGND#15	a_230_74##13	6.59916e-17
C69	a_838_48##3	VPWR#13	1.28925e-17
C70	a_230_74##5	a_363_74#	1.60255e-17
C71	GATE_N#6	VPWR#15	9.7907e-19
C72	a_670_74##6	VPWR#5	1.21741e-18
C73	a_670_74##7	a_670_74##4	3.52794e-20
C74	VGND#7	a_363_74##5	9.49117e-17
C75	a_838_48##14	a_230_74##6	3.07341e-19
C76	VGND#7	a_230_74##2	8.76322e-19
C77	VGND#2	a_838_48##5	3.83845e-19
C78	a_27_112##2	VPWR#7	1.4712e-17
C79	a_27_112##6	a_230_74##13	1.21938e-18
C80	Q_N#3	a_1446_368##4	4.08963e-17
C81	a_838_48##14	VGND#12	3.62167e-19
C82	a_670_74##6	a_230_74##7	4.53049e-17
C83	VGND#12	RESET_B#4	1.75106e-17
C84	a_1446_368##4	VGND#10	4.59822e-17
C85	a_838_48##14	a_363_74##3	5.68352e-20
C86	a_27_112##3	a_230_74##5	4.32247e-17
C87	a_27_112##6	VGND#15	4.63127e-17
C88	a_230_74##6	a_670_74##7	1.07328e-17
C89	VPWR#14	a_838_48##3	7.16055e-20
C90	D#6	GATE_N#6	2.56969e-17
C91	VPWR#7	a_230_74##2	7.64563e-20
C92	a_27_112##5	D#5	5.64896e-17
C93	RESET_B#4	a_670_74#	8.08853e-19
C94	a_670_74##6	a_363_74##2	8.54913e-17
C95	D#6	VPWR#15	1.61547e-18
C96	a_838_48##16	a_838_48##14	2.13431e-18
C97	a_230_74##3	a_27_112##3	1.33701e-17
C98	a_670_74##7	a_363_74##3	4.02605e-17
C99	VPWR#14	a_230_74##6	2.41554e-19
C100	a_670_74##6	a_670_74#	1.37841e-18
C101	a_838_48##6	VGND#11	2.13183e-17
C102	Q#1	a_838_48##6	2.31767e-17
C103	VPWR#2	VPWR#1	5.52787e-17
C104	a_670_74##7	a_27_112#	1.13465e-18
C105	VGND#6	a_670_74##8	2.56662e-17
C106	a_230_74##4	a_670_74##6	1.60656e-18
C107	VPWR#14	a_363_74##3	1.97182e-18
C108	a_838_48##16	RESET_B#4	3.12692e-17
C109	GATE_N#3	a_230_74##3	3.40484e-18
C110	a_363_74##5	a_363_74##2	6.55554e-20
C111	a_670_74##6	a_838_48#	1.85418e-17
C112	VGND#2	VPWR#1	4.93889e-18
C113	a_27_112#	VPWR#14	3.29441e-17
C114	Q#1	RESET_B#2	3.11216e-19
C115	a_1446_368##11	VPWR#2	2.33523e-17
C116	a_670_74##6	a_838_48##16	1.55514e-17
C117	RESET_B#2	VGND#12	4.42708e-18
C118	a_670_74##6	a_27_112##2	1.87654e-19
C119	D#3	GATE_N#3	1.92048e-17
C120	VGND#2	VPWR#10	3.40291e-18
C121	a_230_74#	VPWR#14	2.55748e-17
C122	VGND#7	VGND#5	6.04577e-20
C123	a_230_74##11	a_27_112#	2.06977e-19
C124	a_363_74##5	a_230_74##4	1.79037e-17
C125	Q_N#1	VPWR#1	4.01504e-17
C126	a_838_48##16	RESET_B#2	2.85209e-18
C127	a_230_74#	a_363_74##7	1.37063e-17
C128	VPWR#15	a_27_112#	2.43782e-19
C129	VPWR#14	GATE_N#1	1.70025e-18
C130	VGND#13	a_670_74##6	1.21242e-17
C131	a_838_48##16	a_670_74##2	6.03534e-18
C132	a_230_74##11	a_230_74#	6.75134e-18
C133	VPWR#10	VPWR#1	2.00319e-18
C134	a_838_48##16	a_670_74##3	3.40796e-17
C135	VPWR#15	a_230_74#	3.79262e-19
C136	a_1446_368##4	a_1446_368##2	9.06381e-18
C137	a_363_74##5	a_27_112##2	6.2221e-19
C138	VPWR#14	D#1	9.06289e-19
C139	VGND#13	a_670_74##3	1.69247e-18
C140	GATE_N#1	a_230_74##11	2.37258e-17
C141	VGND#1	a_1446_368#	3.29243e-17
C142	a_27_112##5	a_27_112##2	3.70248e-18
C143	VPWR#10	Q_N#1	3.66157e-17
C144	a_838_48##5	a_1446_368##4	1.96399e-17
C145	GATE_N#1	VPWR#15	3.13798e-17
C146	a_230_74##11	D#1	4.11497e-20
C147	Q_N#3	a_1446_368#	3.38782e-17
C148	a_363_74##5	a_230_74##2	7.67564e-17
C149	a_1446_368##4	VPWR#10	2.86098e-17
C150	VGND#13	a_838_48##2	1.02044e-18
C151	VGND#1	a_1446_368##6	5.60509e-18
C152	D#1	VPWR#15	1.66101e-17
C153	a_363_74##5	a_838_48#	6.3178e-20
C154	a_1446_368##11	a_1446_368##4	1.01675e-19
C155	VGND#5	VGND#4	4.81514e-19
C156	VGND#10	a_1446_368#	4.87637e-18
C157	D#1	a_27_112##7	9.00376e-18
C158	a_1446_368##7	a_1446_368##5	4.94009e-17
C159	a_670_74##8	a_670_74##6	3.63591e-18
C160	Q_N#3	a_1446_368##6	3.34619e-17
C161	VPWR#3	a_1446_368##7	2.68958e-19
C162	a_363_74##5	GATE_N#2	2.67874e-19
C163	a_1446_368##11	VPWR#10	7.54903e-17
C164	a_838_48##6	a_1446_368##11	4.46635e-17
C165	a_1446_368##10	a_1446_368#	3.03147e-20
C166	a_838_48##7	a_838_48##6	8.68797e-18
C167	VGND#1	a_838_48##4	4.34046e-19
C168	a_1446_368##9	a_1446_368##5	2.12772e-19
C169	a_363_74##5	a_363_74#	8.12483e-20
C170	VPWR#3	VPWR#10	7.95203e-19
C171	a_838_48##6	VPWR#11	4.58397e-17
C172	a_670_74##8	a_230_74##7	8.43687e-19
C173	VGND#10	a_1446_368##6	1.95544e-17
C174	a_838_48##6	a_838_48##5	3.45871e-18
C175	a_27_112##5	GATE_N#2	1.41244e-18
C176	a_838_48##9	a_1446_368##7	6.28484e-18
C177	Q#3	a_838_48##6	5.44772e-17
C178	Q_N#3	a_838_48##4	1.19488e-19
C179	VPWR#11	VPWR#10	4.89534e-18
C180	GATE_N#6	GATE_N#2	1.00877e-17
C181	a_1446_368##10	a_1446_368##6	1.3017e-18
C182	a_838_48##11	a_1446_368##7	3.5707e-19
C183	VPWR#4	a_838_48##7	5.16772e-20
C184	VPWR#3	a_838_48##9	4.10393e-18
C185	a_27_112##5	VPWR#7	2.61936e-18
C186	a_363_74##2	a_670_74##8	9.78319e-17
C187	a_838_48##14	a_838_48##6	1.82976e-18
C188	a_363_74##5	a_230_74##5	2.16729e-19
C189	VGND#10	a_838_48##4	2.14117e-18
C190	Q#3	RESET_B#2	3.63253e-19
C191	a_27_112##5	D#2	1.16345e-17
C192	a_838_48##11	a_838_48##9	3.6965e-17
C193	a_1446_368##11	VPWR#3	6.45807e-18
C194	D#6	GATE_N#2	3.88961e-17
C195	VPWR#11	a_1446_368##11	3.19871e-17
C196	VGND#11	a_1446_368##6	3.74534e-19
C197	VPWR#12	RESET_B#2	3.49074e-19
C198	VGND#2	a_1446_368#	7.87647e-18
C199	VGND#4	VGND#3	7.8775e-19
C200	GATE_N#6	D#2	2.70455e-18
C201	a_1446_368##10	a_838_48##4	4.60457e-17
C202	a_838_48##14	RESET_B#2	3.85752e-18
C203	RESET_B#2	a_838_48##7	3.22219e-17
C204	a_363_74##2	a_363_74##6	5.42925e-21
C205	a_230_74##4	a_670_74##8	2.49485e-18
C206	VGND#2	a_1446_368##6	9.3332e-18
C207	VGND#10	a_838_48##10	1.65484e-19
C208	a_838_48##5	a_1446_368##7	3.146e-19
C209	a_363_74##5	a_27_112##3	1.81281e-17
C210	VPWR#3	a_838_48##11	7.84846e-18
C211	a_838_48##8	a_838_48##11	4.9334e-17
C212	VGND#2	a_838_48##4	5.73918e-18
C213	D#6	D#2	7.65644e-18
C214	a_838_48##4	VGND#11	1.87253e-17
C215	a_670_74##2	RESET_B#2	2.57248e-17
C216	VPWR#5	a_838_48##8	3.38118e-19
C217	a_670_74##3	a_838_48##14	4.98465e-17
C218	VGND#2	a_838_48##10	7.84894e-19
C219	a_1446_368##10	a_838_48##10	1.59351e-18
C220	D#5	D#2	1.81206e-17
C221	a_670_74##3	VPWR#13	4.50435e-19
C222	VPWR#4	a_838_48##8	4.01091e-18
C223	Q#1	a_838_48##4	1.73442e-18
C224	RESET_B#1	a_838_48##8	4.00499e-17
C225	a_363_74##5	a_230_74##3	3.94127e-17
C226	a_838_48##14	a_838_48##2	4.21217e-19
C227	a_838_48##10	VGND#11	2.53581e-17
C228	VPWR#3	a_838_48##8	7.80588e-19
C229	a_838_48##2	VPWR#13	1.22727e-18
C230	VPWR#5	VPWR#12	1.72823e-18
C231	VGND#1	Q_N#3	2.97323e-17
C232	VGND#12	a_838_48##4	9.98485e-19
C233	VPWR#12	VPWR#11	1.37668e-17
C234	a_838_48##14	a_1446_368##11	1.00684e-18
C235	VPWR#5	RESET_B#1	8.62481e-19
C236	Q#1	a_838_48##10	4.05011e-17
C237	a_230_74##7	a_838_48##14	3.50076e-18
C238	a_670_74##4	RESET_B#1	4.32829e-17
C239	a_230_74##2	VGND#14	1.07618e-18
C240	a_670_74##7	a_838_48##2	2.87952e-19
C241	VPWR#4	RESET_B#1	2.56818e-18
C242	VGND#11	a_838_48##12	2.31045e-18
C243	a_230_74##13	a_363_74##7	2.23569e-17
C244	a_363_74##5	GATE_N#3	1.19364e-18
C245	a_670_74##3	a_670_74##2	2.62345e-19
C246	VGND#12	a_838_48##10	2.07156e-18
C247	VGND#10	VGND#1	1.38971e-17
C248	a_230_74##13	a_230_74##2	6.67108e-19
C249	a_363_74##5	a_670_74##8	1.49729e-18
C250	a_838_48##14	VPWR#5	5.34263e-17
C251	a_230_74##7	a_670_74##7	9.97063e-17
C252	Q#1	a_838_48##12	3.3247e-17
C253	a_838_48##3	a_670_74##4	8.53407e-18
C254	VPWR#5	a_670_74##4	1.56422e-17
C255	VPWR#12	VPWR#3	1.08668e-19
C256	a_27_112##6	a_230_74##2	1.32908e-19
C257	a_230_74##13	a_230_74##11	2.93489e-18
C258	a_838_48##14	Q#3	3.59268e-17
C259	VGND#11	RESET_B#3	1.01458e-18
C260	VPWR#14	a_230_74##7	1.8545e-17
C261	GATE_N#2	a_230_74##13	6.59736e-17
C262	a_838_48##12	VGND#12	2.01175e-17
C263	VGND#10	Q_N#3	1.61149e-17
C264	a_670_74##7	a_363_74##2	8.31232e-18
C265	VGND#6	a_363_74#	3.55887e-18
C266	a_838_48##14	VPWR#4	1.05773e-17
C267	Q#1	RESET_B#3	1.39023e-18
C268	a_230_74##6	a_838_48##3	1.01587e-17
C269	VGND#6	a_230_74##5	7.37995e-18
C270	a_27_112##6	GATE_N#2	1.05914e-19
C271	a_838_48##14	VPWR#12	7.87018e-17
C272	RESET_B#2	a_838_48##12	7.7023e-19
C273	VPWR#5	VPWR#13	1.03971e-17
C274	a_230_74##4	a_670_74##7	8.95737e-17
C275	a_230_74##13	D#2	8.12924e-20
C276	a_838_48##2	a_670_74##2	2.36995e-19
C277	a_838_48##14	VPWR#3	7.74264e-19
C278	VPWR#5	a_838_48##3	2.41364e-17
C279	VPWR#2	a_1446_368##5	6.66866e-18
C280	VGND#12	RESET_B#3	4.64405e-17
C281	a_1446_368##10	Q_N#3	1.42257e-19
C282	VGND#15	D#2	8.97956e-18
C283	a_670_74#	RESET_B#2	3.39988e-18
C284	a_838_48##16	a_838_48##12	7.25979e-19
C285	a_363_74##3	a_230_74##6	1.51975e-17
C286	a_27_112##6	D#2	6.03673e-18
C287	Q#1	a_670_74#	2.80368e-19
C288	VPWR#2	a_1446_368##7	1.02186e-17
C289	a_363_74##5	VGND#14	2.0069e-18
C290	VPWR#2	a_838_48##9	8.55559e-18
C291	VGND#12	a_670_74#	5.92254e-18
C292	a_838_48##14	VPWR#13	1.36302e-18
C293	a_1446_368##10	VGND#10	5.19426e-17
C294	VPWR#2	a_838_48##11	1.88594e-19
C295	a_27_112##2	VPWR#14	4.57298e-17
C296	a_27_112#	a_363_74##3	5.70533e-17
C297	a_838_48#	a_670_74##3	1.37375e-17
C298	VPWR#5	a_230_74##6	2.60301e-18
C299	a_838_48##16	RESET_B#3	1.14694e-17
C300	a_27_112##2	a_363_74##7	4.94195e-18
C301	a_363_74##5	a_363_74##6	7.13531e-18
C302	a_230_74##11	a_27_112##2	4.62755e-17
C303	a_230_74##2	VPWR#14	2.89779e-18
C304	VGND#13	RESET_B#3	2.91751e-19
C305	VGND#12	a_838_48#	3.53076e-19
C306	a_230_74#	a_27_112#	2.03609e-17
C307	a_1446_368##4	a_1446_368##5	4.80393e-18
C308	VGND#11	VGND#10	2.13181e-18
C309	a_363_74##7	a_230_74##2	5.50866e-17
C310	a_838_48##16	a_670_74#	4.4706e-17
C311	a_230_74##2	a_230_74##11	8.25171e-18
C312	a_1446_368##9	a_838_48##7	8.6332e-20
C313	GATE_N#1	a_27_112#	3.32167e-19
C314	VPWR#5	a_363_74##3	1.71209e-19
C315	a_670_74##7	a_838_48##14	3.55455e-19
C316	a_230_74##13	a_363_74##5	9.12093e-17
C317	VGND#13	a_670_74#	1.71512e-18
C318	a_363_74##7	GATE_N#2	8.24727e-19
C319	GATE_N#1	a_230_74#	5.36683e-18
C320	a_363_74##2	a_838_48#	2.75484e-17
C321	GATE_N#2	a_230_74##11	7.60056e-18
C322	VGND#11	a_1446_368##10	6.75709e-17
C323	a_838_48##16	a_838_48#	6.8785e-18
C324	a_838_48##6	a_838_48##9	1.03552e-17
C325	a_363_74##2	a_363_74#	7.44314e-18
C326	VPWR#7	a_27_112#	6.52745e-18
C327	a_363_74##2	a_230_74##5	1.97771e-17
C328	a_838_48##6	a_838_48##11	1.70438e-17
C329	RESET_B	a_838_48##7	9.76834e-18
C330	a_1446_368##9	a_838_48##5	1.48503e-17
C331	D#1	GATE_N#1	1.54984e-17
C332	a_838_48#	VGND#13	1.78016e-17
C333	a_230_74##11	D#2	2.4004e-19
C334	a_363_74##2	a_27_112##3	3.84747e-19
C335	VPWR#5	a_27_112#	6.1215e-20
C336	VPWR#6	a_230_74##6	4.61111e-18
C337	a_838_48##8	a_838_48##6	4.61095e-18
C338	VPWR#15	D#2	9.92827e-19
C339	a_670_74##8	a_670_74#	2.84068e-19
C340	Q#1	a_1446_368##10	2.13617e-18
C341	a_363_74##2	a_230_74##3	2.77824e-19
C342	a_670_74##2	RESET_B#1	2.82312e-18
C343	a_838_48##6	RESET_B#1	1.73006e-19
C344	VPWR#6	a_363_74##3	4.49538e-18
C345	a_363_74##5	a_592_74#	1.19298e-18
C346	a_230_74##13	a_27_112##5	4.52467e-19
C347	RESET_B#2	a_838_48##8	1.85407e-18
C348	a_230_74##4	a_27_112##3	1.68917e-17
C349	VGND#13	a_363_74#	8.56487e-19
C350	VGND#6	a_363_74##3	3.84836e-20
C351	VPWR#7	a_230_74#	5.44479e-18
C352	a_670_74##8	a_838_48#	1.9543e-17
C353	Q#1	VGND#11	2.70105e-17
C354	a_670_74##8	a_790_74#	8.30013e-19
C355	VGND#15	a_27_112##5	3.29335e-18
C356	a_670_74##3	a_670_74##4	2.82408e-18
C357	a_230_74##2	a_27_112##3	5.23422e-18
C358	Q_N	a_1446_368##2	1.75872e-18
C359	VGND#13	a_230_74##5	2.12094e-19
C360	Q_N	a_838_48##5	5.43286e-19
C361	a_230_74##2	a_230_74##3	2.41874e-18
C362	a_670_74##8	a_363_74#	3.40283e-17
C363	a_838_48##2	a_670_74##4	1.39233e-17
C364	VGND#12	VGND#11	1.11796e-17
C365	VGND#3	a_1446_368##10	1.00161e-17
C366	GATE_N#3	a_230_74##2	1.03397e-19
C367	a_230_74##7	a_670_74##4	5.21868e-19
C368	VGND#13	a_27_112##3	1.03792e-19
C369	a_27_112##6	a_27_112##5	2.33437e-18
C370	a_230_74##7	a_838_48##3	1.06151e-17
C371	a_670_74##8	a_230_74##5	2.99155e-17
C372	a_363_74##3	a_838_48##2	5.72632e-19
C373	VGND#12	Q#1	1.66686e-17
C374	a_230_74##7	a_230_74##6	2.10106e-17
C375	a_1446_368##4	VPWR#2	1.11418e-17
C376	a_230_74##7	a_363_74##3	2.97776e-17
C377	VGND#2	a_1446_368##4	1.50757e-17
C378	VPWR#2	a_838_48##6	4.37706e-18
C379	a_230_74##7	a_27_112#	6.72238e-18
C380	a_670_74##8	a_27_112##3	2.11374e-18
C381	a_363_74##2	a_363_74##3	7.23917e-19
C382	VGND#4	Q#1	4.77403e-19
C383	VGND#2	a_838_48##6	4.10101e-18
C384	a_230_74##7	a_230_74#	7.4235e-19
C385	a_230_74##4	a_230_74##6	1.11464e-19
C386	a_230_74##7	GATE_N#1	2.09369e-19
C387	a_230_74##4	a_363_74##3	5.02883e-17
C388	VGND#5	VGND#12	2.31615e-20
C389	a_838_48##14	RESET_B#4	2.36829e-17
C390	a_230_74##4	a_27_112#	1.15725e-17
C391	VPWR#5	VPWR#4	1.25976e-18
C392	a_670_74##8	a_230_74##3	4.35761e-19
C393	a_27_112##2	a_363_74##3	2.1359e-17
C394	a_230_74##4	a_230_74#	2.26899e-19
C395	VGND#3	Q#1	2.88178e-18
C396	a_27_112##3	VGND#14	1.80732e-17
C397	a_27_112##2	a_27_112#	2.56657e-17
C398	a_670_74#	a_1066_74#	1.32517e-17
C399	a_838_48##16	Q#1	3.29198e-18
C400	a_230_74##4	GATE_N#1	4.45694e-20
C401	VGND#4	RESET_B	8.81003e-19
C402	a_27_112##2	a_230_74#	3.87955e-17
C403	a_230_74##2	a_27_112#	2.65674e-18
C404	a_27_112##2	GATE_N#1	1.87905e-18
C405	a_230_74##2	a_230_74#	9.32525e-18
C406	a_230_74##7	VPWR#6	6.77583e-17
C407	a_230_74##3	VGND#14	1.39338e-17
C408	a_838_48##10	a_838_48##5	2.11433e-18
C409	a_230_74##2	GATE_N#1	2.65481e-19
C410	D#6	VGND#15	2.4401e-17
C411	a_838_48##16	VGND#12	3.85627e-17
C412	a_230_74##11	a_363_74##7	7.28123e-17
C413	VPWR#15	VPWR#14	2.50267e-18
C414	GATE_N#2	a_230_74#	1.38295e-18
C415	VPWR#6	a_363_74##2	2.43016e-20
C416	VGND#12	VGND#3	3.16182e-19
C417	VGND#3	a_1446_368##6	1.83431e-19
C418	VGND#6	a_363_74##2	2.96323e-18
C419	a_838_48#	a_790_74#	7.43895e-18
C420	a_230_74##3	a_363_74##6	2.56386e-17
C421	VGND#2	VGND#3	6.37546e-17
C422	a_363_74#	a_790_74#	4.2339e-18
C423	VGND#15	a_27_112##3	2.7959e-19
C424	a_230_74##6	a_783_508#	1.13814e-17
C425	VGND#6	a_230_74##4	2.02229e-19
C426	a_838_48##2	a_670_74##3	5.22555e-17
C427	VGND#13	VGND#12	1.39266e-18
C428	a_230_74##13	a_230_74##3	1.58748e-18
C429	VGND#5	a_838_48##16	1.56183e-17
C430	a_1446_368##9	Q_N	1.32525e-18
C431	VPWR#4	VPWR#3	1.55834e-18
C432	a_363_74##3	a_595_392#	1.5013e-17
C433	VPWR#2	VPWR#3	6.67622e-17
C434	a_230_74##7	a_838_48##2	7.09057e-17
C435	VGND#7	VGND#13	9.62875e-19
C436	a_27_112#	a_595_392#	1.9337e-18
C437	VGND#15	a_230_74##3	8.14892e-19
C438	D#5	VGND#15	1.20141e-17
C439	VGND#3	a_838_48##4	7.12307e-18
C440	a_363_74##2	a_838_48##2	1.29627e-17
C441	a_230_74##13	GATE_N#3	5.32126e-17
C442	a_230_74##5	a_592_74#	1.22404e-17
C443	VGND	a_838_48##7	4.4531e-23
C444	VGND#4	a_838_48##16	1.0535e-17
C445	a_27_112##3	a_592_74#	1.22404e-17
C446	a_363_74##2	a_230_74##7	2.38682e-17
C447	a_230_74##4	a_838_48##2	1.36943e-19
C448	a_27_112##6	a_230_74##3	1.75539e-20
C449	RESET_B	Q#1	2.95237e-17
C450	a_230_74##4	a_230_74##7	3.4212e-18
C451	VGND#12	RESET_B	1.77681e-17
C452	GATE_N#3	VGND#15	2.63702e-17
C453	a_1446_368##9	Q_N#3	5.28382e-19
C454	a_230_74##4	a_363_74##2	1.06649e-16
C455	a_27_112##2	a_230_74##7	2.5823e-18
C456	a_27_112##6	D#5	3.52341e-17
C457	a_230_74##13	D#3	1.84477e-18
C458	VGND#13	a_838_48##16	3.3652e-17
C459	a_27_112##2	a_363_74##2	2.60116e-18
C460	a_27_112##6	GATE_N#3	2.04262e-19
C461	Q_N#3	Q_N	2.51864e-18
C462	VGND#3	a_838_48##10	7.67759e-18
C463	a_230_74##4	a_27_112##2	1.35632e-16
C464	D#3	VGND#15	2.48183e-17
C465	a_230_74##2	a_230_74##4	3.3611e-18
C466	VPWR	VPWR#7	7.77232e-17
C467	VPWR	VPWR#5	1.23271e-16
C468	VPWR	VPWR#4	5.98193e-17
C469	VPWR	VPWR#3	1.49135e-17
C470	a_230_74##2	a_27_112##2	1.42509e-16
C471	RESET_B	Q#3	9.51598e-18
C472	VGND#4	a_838_48##12	8.43503e-18
C473	a_27_112##6	D#3	2.88262e-17
C474	RESET_B	a_838_48##14	6.32659e-18
C475	a_1446_368##2	VNB	3.54143e-17
C476	Q_N#3	a_1446_368##2	1.83994e-17
C477	a_838_48##7	VNB	1.75312e-17
C478	a_838_48##5	VNB	2.4314e-17
C479	a_670_74##2	VNB	1.95739e-17
C480	a_230_74##7	a_783_508#	3.07164e-18
C481	VPWR	RESET_B#4	2.27698e-18
C482	GATE_N#2	a_230_74##2	4.48554e-18
C483	VPWR	a_670_74##6	6.71767e-18
C484	Q_N	VPWR#1	5.68661e-17
C485	Q_N	Q_N#1	4.90344e-19
C486	VGND#7	a_670_74##8	1.00811e-17
C487	VPWR#10	Q_N	4.9057e-17
C488	a_230_74##7	a_595_392#	3.95726e-18
C489	a_1446_368##11	Q_N	1.3471e-18
C490	VGND#3	a_838_48##12	3.17705e-19
C491	a_27_112##5	a_230_74#	6.46527e-19
C492	VGND	VGND#7	1.14012e-16
C493	VGND#5	RESET_B#3	1.96926e-19
C494	VGND#1	VPWR#1	1.03343e-17
C495	VGND	VGND#5	8.85929e-17
C496	VPWR	a_27_112##5	4.30639e-17
C497	VGND	VGND#4	7.4544e-17
C498	D#2	GATE_N#2	4.85515e-17
C499	VGND	VGND#3	1.65117e-17
C500	VPWR	GATE_N#6	4.01803e-18
C501	a_670_74##8	a_838_48##16	2.80105e-18
C502	a_230_74##4	a_595_392#	1.48254e-17
C503	VPWR	D#6	2.06735e-18
C504	VPWR	D#5	2.17614e-18
C505	RESET_B	a_838_48##12	2.10238e-18
C506	a_1446_368##9	a_1446_368#	1.1757e-19
C507	VGND#4	RESET_B#3	3.75761e-18
C508	VGND#5	a_670_74##8	1.38533e-17
C509	VGND	RESET_B#4	3.59294e-18
C510	VGND	a_670_74##6	5.4221e-18
C511	a_1446_368##6	a_1446_368#	3.33871e-17
C512	VGND	a_363_74##5	2.55296e-17
C513	a_27_112##5	GATE_N#1	4.48636e-17
C514	a_670_74##8	VGND#13	3.4081e-17
C515	VGND#3	RESET_B#3	8.4433e-20
C516	VGND	D#6	1.90525e-18
C517	VGND#3	a_838_48##6	8.83768e-19
C518	VGND#7	VNB	5.1033e-17
C519	VGND#5	a_670_74#	9.98564e-19
C520	VGND#5	VNB	4.16861e-17
C521	VGND	D#5	2.77892e-18
C522	VGND#4	VNB	3.82917e-17
C523	a_1446_368##11	a_838_48##5	1.9339e-18
C524	VGND#3	VNB	3.30493e-17
C525	VPWR#1	a_1446_368##5	3.26715e-17
C526	VPWR#7	VNB	4.23068e-17
C527	VPWR	Q#3	3.09691e-18
C528	VPWR#5	VNB	5.05452e-17
C529	VPWR#4	VNB	3.08241e-17
C530	VPWR	VPWR#12	1.81165e-17
C531	VPWR#3	VNB	3.29649e-17
C532	VGND	Q#1	1.19583e-17
C533	a_363_74##2	a_592_74#	1.8733e-18
C534	VPWR	a_838_48##14	2.88654e-17
C535	VGND	VGND#12	2.20212e-17
C536	a_1446_368##9	VNB	4.00205e-18
C537	VGND	a_838_48##16	2.50498e-17
C538	a_1446_368##9	a_1446_368##6	3.01128e-19
C539	VPWR	a_670_74##7	7.9762e-18
C540	Q_N	a_1446_368##5	2.5977e-17
C541	VGND	a_670_74##8	3.01932e-17
C542	VPWR	VPWR#14	1.9231e-17
C543	Q_N	a_1446_368##7	2.517e-17
C544	RESET_B#4	VNB	3.1853e-19
C545	VPWR	a_363_74##7	3.36868e-18
C546	VGND#4	a_670_74#	5.36658e-18
C547	a_670_74##6	VNB	9.20691e-18
C548	Q_N	a_838_48##9	3.41753e-19
C549	VPWR	a_230_74##11	1.13004e-17
C550	Q_N#1	a_1446_368##5	3.67165e-17
C551	VGND	a_230_74##13	2.43012e-17
C552	Q_N	a_838_48##11	5.09349e-20
C553	VGND	VGND#15	1.98899e-17
C554	VGND	a_27_112##6	1.63949e-17
C555	VGND#7	a_838_48#	2.59761e-19
C556	a_27_112##5	D#1	4.3267e-17
C557	a_363_74##5	VNB	1.2444e-17
C558	a_27_112##5	VNB	7.57642e-17
C559	GATE_N#6	VNB	1.78161e-19
C560	a_838_48##4	a_1446_368##6	5.01162e-18
C561	VPWR#1	a_1446_368##7	1.26838e-18
C562	VGND	Q#3	9.75072e-19
C563	D#5	VNB	1.9865e-18
C564	VGND	a_838_48##14	3.22616e-18
C565	VGND#1	VNB	6.85203e-17
C566	Q_N#3	VNB	9.72191e-18
C567	VGND#7	VGND#14	5.48721e-18
C568	VGND#10	VNB	8.80824e-18
C569	a_1446_368##10	VNB	1.08397e-17
C570	VGND	a_670_74##7	2.46042e-18
C571	VPWR#10	a_1446_368##5	7.37579e-19
C572	VGND#11	VNB	4.59735e-18
C573	Q#1	VNB	4.22665e-19
C574	VGND#12	VNB	1.22485e-18
C575	VGND	a_363_74##7	8.54647e-19
C576	a_838_48##16	VNB	6.59927e-18
C577	VGND#13	VNB	6.43824e-18
C578	VGND#5	a_838_48#	6.61183e-18
C579	a_670_74##8	VNB	6.7095e-18
C580	Q_N#1	a_1446_368##7	3.54034e-17
C581	Q_N	VPWR#2	3.57657e-17
C582	a_230_74##13	VNB	2.14235e-17
C583	VGND#15	VNB	1.00055e-17
C584	VGND	a_838_48##10	8.57326e-19
C585	VGND#2	Q_N	1.41439e-18
C586	a_27_112##6	VNB	4.80592e-17
C587	VGND	a_838_48##12	4.49157e-18
C588	RESET_B	RESET_B#2	5.60599e-18
C589	VPWR#1	VNB	7.99393e-17
C590	a_1446_368##9	a_1446_368##4	7.45617e-19
C591	VGND	RESET_B#3	4.01148e-19
C592	VPWR	a_838_48##11	4.34167e-19
C593	a_1446_368##9	a_838_48##4	8.90343e-19
C594	VPWR#10	VNB	1.45268e-17
C595	Q#1	a_1446_368##9	5.44509e-18
C596	a_1446_368##11	a_1446_368##5	2.12772e-19
C597	a_1446_368##11	VNB	1.56372e-17
C598	VPWR	a_838_48##8	4.37435e-19
C599	VGND	a_838_48#	2.0706e-18
C600	VPWR#11	VNB	1.60892e-18
C601	Q#3	VNB	8.35015e-19
C602	VGND	a_363_74#	5.41062e-19
C603	VPWR	RESET_B#1	5.37781e-20
C604	a_1446_368##4	Q_N	1.18864e-17
C605	VPWR#12	VNB	5.73724e-19
C606	VGND	a_230_74##5	9.84479e-19
C607	a_838_48##14	VNB	4.8664e-18
C608	VGND	a_27_112##3	5.13351e-19
C609	VPWR	a_838_48##3	9.62398e-19
C610	VGND	a_230_74##3	6.85008e-19
C611	a_670_74##7	VNB	1.52968e-18
C612	VPWR	a_230_74##6	9.27531e-19
C613	VGND	GATE_N#3	1.14097e-18
C614	a_838_48##6	VPWR#3	1.1073e-18
C615	VGND	D#3	9.10762e-18
C616	VPWR	a_363_74##3	4.81998e-18
C617	VPWR#14	VNB	7.51378e-18
C618	a_1446_368##7	VPWR#10	2.24048e-17
C619	a_363_74##7	VNB	8.99746e-18
C620	VPWR	a_27_112#	8.39782e-19
C621	a_230_74##11	VNB	1.82539e-17
C622	VPWR#15	VNB	2.01285e-18
C623	VPWR	a_230_74#	8.62337e-18
C624	VGND#5	a_670_74##3	1.51067e-18
C625	VPWR	GATE_N#1	1.43833e-18
C626	a_1446_368#	VNB	2.66471e-17
C627	VGND#7	a_363_74#	4.62316e-19
C628	a_1446_368##6	VNB	2.65576e-17
C629	VPWR	D#1	1.67678e-18
C630	a_838_48##4	VNB	3.78884e-17
C631	a_838_48##10	VNB	2.93216e-17
C632	a_838_48##12	VNB	3.01644e-17
C633	a_838_48##10	a_838_48##4	2.80902e-17
C634	RESET_B#3	VNB	2.58373e-17
C635	a_670_74#	VNB	3.41624e-17
C636	a_838_48#	VNB	6.2399e-17
C637	a_363_74#	VNB	2.95726e-17
C638	VPWR	VPWR#6	5.18777e-17
C639	a_230_74##5	VNB	2.46659e-17
C640	a_27_112##3	VNB	2.98674e-17
C641	a_230_74##3	VNB	2.77618e-17
C642	GATE_N#3	VNB	3.56459e-17
C643	D#3	VNB	3.57586e-17
C644	VPWR	a_838_48##6	3.19789e-18
C645	a_1446_368##11	a_1446_368##7	2.34645e-18
C646	VGND#4	RESET_B#4	7.32415e-19
C647	a_1446_368##5	VNB	5.20393e-17
C648	a_1446_368##7	VNB	3.78771e-17
C649	VPWR	a_670_74##3	3.27368e-18
C650	a_838_48##9	VNB	4.1775e-17
C651	VPWR#1	a_838_48##11	1.61425e-19
C652	a_838_48##11	VNB	3.18739e-17
C653	VPWR	a_838_48##2	5.68145e-18
C654	a_838_48##8	VNB	3.27529e-17
C655	a_838_48#	a_670_74##2	4.30534e-19
C656	VPWR	a_230_74##7	4.49762e-17
C657	VGND#5	a_670_74##6	5.78396e-19
C658	RESET_B#1	VNB	3.27497e-17
C659	VGND#5	a_363_74#	2.61336e-18
C660	a_670_74##4	VNB	3.17952e-17
C661	VGND	VGND#6	5.17942e-17
C662	VPWR	a_363_74##2	3.12847e-18
C663	a_838_48##3	VNB	2.53483e-17
C664	a_230_74##6	VNB	2.16755e-17
C665	VPWR	a_230_74##4	4.05524e-18
C666	VPWR#10	a_838_48##9	3.43374e-18
C667	a_363_74##3	VNB	4.31446e-17
C668	VGND	a_838_48##6	3.08932e-18
C669	VPWR	a_27_112##2	2.3094e-17
C670	a_27_112#	VNB	3.4058e-17
C671	VGND	RESET_B#2	1.03352e-19
C672	a_230_74#	VNB	4.91361e-17
C673	VPWR	a_230_74##2	3.43014e-18
C674	a_838_48##6	a_1446_368##9	2.3858e-17
C675	VGND	a_670_74##3	8.70653e-18
C676	GATE_N#1	VNB	4.39556e-17
C677	a_1446_368##9	a_838_48##10	1.69609e-19
C678	D#1	VNB	3.47038e-17
C679	VGND	a_838_48##2	6.30534e-19
C680	VGND	a_230_74##7	2.32767e-19
C681	VPWR#2	VNB	1.73483e-16
C682	VPWR#11	a_1446_368##7	5.84216e-19
C683	VGND	a_363_74##2	1.31161e-17
C684	VGND#2	VNB	1.71383e-16
C685	VPWR#6	VNB	2.93987e-17
C686	VGND	a_230_74##4	7.42882e-18
C687	VGND#6	VNB	2.75108e-17
C688	VGND	a_27_112##2	3.27375e-18
C689	a_1446_368##4	VNB	7.79098e-17
C690	VGND	a_230_74##2	5.55451e-18
C691	a_838_48##6	VNB	2.88175e-17
C692	RESET_B#2	VNB	2.39857e-17
C693	VGND	GATE_N#2	6.6606e-18
C694	a_670_74##3	VNB	4.48351e-17
C695	VGND	D#2	2.68556e-19
C696	a_838_48##2	VNB	5.89235e-17
C697	a_230_74##7	VNB	3.94767e-17
C698	a_363_74##2	VNB	5.76553e-17
C699	Q#3	a_838_48##7	5.74861e-18
C700	a_1446_368##11	a_838_48##9	6.53253e-17
C701	a_670_74##8	VGND#14	4.51328e-20
C702	a_230_74##4	VNB	2.59614e-17
C703	a_27_112##2	VNB	3.98598e-17
C704	a_230_74##2	VNB	4.76977e-17
C705	GATE_N#2	VNB	5.92681e-17
C706	D#2	VNB	6.70917e-17
C707	VGND#7	a_230_74##5	4.00585e-18
C708	a_838_48##12	a_838_48##10	4.20113e-17
C709	VPWR#10	a_838_48##11	5.18368e-19
C710	VPWR	RESET_B	3.0945e-18
C711	VGND	RESET_B	3.39066e-18
C712	a_838_48##9	VPWR#11	1.78073e-17
C713	RESET_B	VNB	2.75e-18
C714	VPWR#5	a_670_74##3	1.64414e-18
C715	Q_N	VNB	8.80066e-18
C716	VPWR	VNB	2.95717e-16
C717	VGND	VNB	3.1345e-16
C718	Q#3	a_838_48##5	8.35739e-20
C719	VGND#5	a_230_74##5	1.24395e-19
C720	a_1446_368##11	a_838_48##11	3.26425e-18
C721	VGND#8	a_27_112##6	1.1898e-17
C722	VPWR#8	a_27_112#	3.02055e-19
C723	VPWR#8	D#1	7.58193e-18
C724	VPWR	VPWR#8	1.14213e-16
C725	VGND#8	GATE_N#3	7.49558e-18
C726	VGND#8	D#3	3.56886e-18
C727	VGND	VGND#8	1.07638e-16
C728	VGND#8	VNB	6.25181e-17
C729	VGND#8	D#5	5.36328e-19
C730	VGND#8	VGND#7	3.60029e-19
C731	VGND#8	GATE_N#2	1.29924e-18
C732	a_27_112##5	VPWR#8	3.95636e-17
C733	VPWR#8	GATE_N#2	1.6894e-20
C734	VPWR#8	VPWR#14	2.39466e-19
C735	VGND#8	a_230_74##13	2.91445e-17
C736	VPWR#8	GATE_N#1	9.34083e-18
C737	VPWR#8	VNB	6.23297e-17
*
*
.ENDS sky130_fd_sc_hs__dlrbn_2
*
