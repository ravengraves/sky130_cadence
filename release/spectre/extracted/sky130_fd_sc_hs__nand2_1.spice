* Extracted by Quantus, converted by sky130cad/quantus.py
*
*
*
*                       LINUX           Wed Nov 18 08:44:45 2026
*
*
*
*  PROGRAM  advgen
*
*  Name           : advgen - Quantus - (64-bit)
*  Version        : 25.1.0-p047
*  Build Date     : Thu Dec 11 23:20:30 PST 2025
*
*  HSPICE LIBRARY
*
*  OPERATING_TEMPERATURE 150
*  QRC_TECH_DIR <path>/tech
*
*
*

*
.SUBCKT sky130_fd_sc_hs__nand2_1 VPB VNB VGND VPWR Y B A
*
*
*  caps2d version: 10
*
*
*       TRANSISTOR CARDS
*
*
XM3 VGND#2 B#1 a_117_74# VNB sky130_fd_pr__nfet_01v8_lvt l=0.15 w=0.74 ad=0.2109 as=0.1776 pd=2.05 ps=1.96
XM2 a_117_74# A#3 Y#1 VNB sky130_fd_pr__nfet_01v8_lvt l=0.15 w=0.74 ad=0.1776 as=0.2109 pd=1.96 ps=2.05
XM1 VPWR#3 B#4 Y#2 VPB sky130_fd_pr__pfet_01v8 l=0.15 w=1.12 ad=0.3192 as=0.336 pd=2.81 ps=2.84
XM0 Y#2 A#4 VPWR#1 VPB sky130_fd_pr__pfet_01v8 l=0.15 w=1.12 ad=0.336 as=0.3192 pd=2.84 ps=2.81
*
*
*       RESISTOR AND CAP/DIODE CARDS
*
Rg1	B#1	B#2	322.953644
Rg2	B#2	B#3	26.659500
Rg3	B#2	B#4	507.075531
Rg4	A#1	A#2	26.676205
Rg5	A#2	A#3	320.354431
Rg6	A#2	A#4	506.680298
Rf1	B	B#3	163.775864
Rf2	Y#1	Y	56.314621
Rf3	Y	Y#3	20.186483
Rf4	Y#3	Y	0.276527
Rf5	Y#2	Y#3	5.000000
Rf6	A	A#1	163.775864
Rf7	VPWR#1	VPWR#2	67.502335
Rf8	VPWR#2	VPWR#3	68.962791
Rf9	VGND#1	VGND#2	61.609093
Re1	VPWR#2	VPWR	3.274347
Re2	VGND	VGND#1	3.274471
*
*       CAPACITOR CARDS
*
*
C1	VGND	VNB	4.99155e-17
C2	VPWR	VNB	4.63967e-17
C3	Y	VNB	1.96851e-17
C4	B	VNB	1.86739e-17
C5	A	VNB	2.09445e-17
C6	VGND	B	2.27453e-18
C7	B#3	VNB	5.69481e-17
C8	VPWR	Y	1.43592e-17
C9	VGND	A	4.44634e-18
C10	VGND#1	VNB	1.48944e-16
C11	VPWR	B	2.63526e-18
C12	VPWR#2	VNB	1.45472e-16
C13	VPWR	A	2.63526e-18
C14	B#4	VNB	4.57363e-17
C15	B	Y	3.77933e-17
C16	VGND	B#3	5.53466e-20
C17	A#4	VNB	3.84317e-17
C18	Y	A	3.92951e-17
C19	B#1	VNB	2.90965e-17
C20	VGND	VGND#1	3.23719e-17
C21	A#3	VNB	2.81622e-17
C22	VPWR#3	VNB	5.53473e-17
C23	Y	a_117_74#	5.10161e-19
C24	VPWR#1	VNB	5.6014e-17
C25	VGND#2	VNB	3.51901e-17
C26	Y#1	VNB	3.46865e-17
C27	Y	B#3	1.00841e-17
C28	VPWR	VPWR#2	2.67271e-17
C29	VGND	B#1	4.26123e-18
C30	VGND	A#3	1.19812e-18
C31	B	B#3	2.3531e-17
C32	VPWR	B#4	4.33358e-18
C33	VGND	VPWR#3	3.28873e-18
C34	VPWR	A#4	4.65917e-18
C35	Y	VPWR#2	1.35314e-17
C36	VGND	VPWR#1	3.28873e-18
C37	VGND	VGND#2	2.99166e-17
C38	VGND	Y#1	2.01764e-17
C39	Y	B#4	2.3737e-17
C40	VPWR	VPWR#3	2.93568e-17
C41	Y	A#4	2.3737e-17
C42	VGND#1	A	1.15271e-18
C43	VPWR	VPWR#1	2.92932e-17
C44	Y	B#1	3.67969e-19
C45	Y	A#3	1.72239e-18
C46	VPWR#3	Y	1.05158e-16
C47	Y	Y#2	3.3443e-17
C48	Y	VPWR#1	1.05195e-16
C49	B	VPWR#3	2.15415e-17
C50	VGND#2	B	2.8892e-17
C51	B#1	a_117_74#	1.07753e-17
C52	A#3	a_117_74#	1.5548e-17
C53	A	VPWR#1	2.15415e-17
C54	Y#1	A	3.56736e-17
C55	VPWR#2	B#4	3.81134e-18
C56	Y#1	a_117_74#	5.84252e-18
C57	VPWR#3	B#3	4.02123e-18
C58	VPWR#2	A#4	1.53591e-18
C59	VGND#1	B#1	4.32219e-18
C60	VGND#1	A#3	5.43974e-18
C61	B#3	VGND#2	8.3001e-18
C62	B#4	A#4	5.05957e-17
C63	A#2	VNB	6.06909e-17
C64	VPWR#3	B#4	5.26331e-17
C65	VGND#1	Y#1	2.31271e-17
C66	B#4	Y#2	1.2351e-17
C67	VPWR#3	A#4	4.34941e-18
C68	VPWR#1	B#4	4.35335e-18
C69	A#4	Y#2	6.21594e-18
C70	B#1	A#3	5.07274e-17
C71	VPWR#1	A#4	4.78381e-17
C72	VGND	A#2	6.64159e-19
C73	VGND#2	B#1	3.75001e-17
C74	VGND#2	A#3	7.50391e-18
C75	VPWR#3	VPWR#1	2.8266e-18
C76	Y#1	B#1	1.09176e-17
C77	Y#1	A#3	4.43244e-17
C78	VGND#2	Y#1	3.56104e-17
C79	Y	A#2	1.15105e-17
C80	B	A#2	1.36833e-18
C81	A	A#2	2.40028e-17
C82	VPWR#1	A#2	4.02123e-18
C83	B#3	A#2	2.91323e-17
C84	A#2	Y#1	6.87746e-18
C85	VGND#1	A#2	6.54157e-19
*
*
.ENDS sky130_fd_sc_hs__nand2_1
*
