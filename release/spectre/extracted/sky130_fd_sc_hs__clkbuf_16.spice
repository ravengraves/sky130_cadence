* Extracted by Quantus, converted by sky130cad/quantus.py
*
*
*
*                       LINUX           Wed Nov 18 08:21:47 2026
*
*
*
*  PROGRAM  advgen
*
*  Name           : advgen - Quantus - (64-bit)
*  Version        : 25.1.0-p047
*  Build Date     : Thu Dec 11 23:20:30 PST 2025
*
*  HSPICE LIBRARY
*
*  OPERATING_TEMPERATURE 150
*  QRC_TECH_DIR <path>/tech
*
*
*

*
.SUBCKT sky130_fd_sc_hs__clkbuf_16 VPB VNB VGND X VPWR A
*
*
*  caps2d version: 10
*
*
*       TRANSISTOR CARDS
*
*
XM30 a_114_74##61 A#6 VGND#12 VNB sky130_fd_pr__nfet_01v8_lvt l=0.15 w=0.42 ad=0.1176 as=0.1197 pd=1.4 ps=1.41
XM37 VGND#21 A#10 a_114_74##61 VNB sky130_fd_pr__nfet_01v8_lvt l=0.15 w=0.42 ad=0.126 as=0.1176 pd=1.44 ps=1.4
XM33 VGND#21 A#8 a_114_74##63 VNB sky130_fd_pr__nfet_01v8_lvt l=0.15 w=0.42 ad=0.126 as=0.1176 pd=1.44 ps=1.4
XM7 a_114_74##63 A#7 VGND#20 VNB sky130_fd_pr__nfet_01v8_lvt l=0.15 w=0.42 ad=0.1176 as=0.147 pd=1.4 ps=1.54
XM34 X#3 a_114_74##54 VGND#20 VNB sky130_fd_pr__nfet_01v8_lvt l=0.15 w=0.42 ad=0.1176 as=0.147 pd=1.4 ps=1.54
XM18 X#3 a_114_74##51 VGND#19 VNB sky130_fd_pr__nfet_01v8_lvt l=0.15 w=0.42 ad=0.1176 as=0.1176 pd=1.4 ps=1.4
XM39 X#6 a_114_74##47 VGND#19 VNB sky130_fd_pr__nfet_01v8_lvt l=0.15 w=0.42 ad=0.1176 as=0.1176 pd=1.4 ps=1.4
XM32 X#6 a_114_74##45 VGND#18 VNB sky130_fd_pr__nfet_01v8_lvt l=0.15 w=0.42 ad=0.1176 as=0.1176 pd=1.4 ps=1.4
XM17 VGND#18 a_114_74##41 X#9 VNB sky130_fd_pr__nfet_01v8_lvt l=0.15 w=0.42 ad=0.1176 as=0.1176 pd=1.4 ps=1.4
XM16 VGND#17 a_114_74##36 X#9 VNB sky130_fd_pr__nfet_01v8_lvt l=0.15 w=0.42 ad=0.147 as=0.1176 pd=1.54 ps=1.4
XM38 VGND#17 a_114_74##33 X#12 VNB sky130_fd_pr__nfet_01v8_lvt l=0.15 w=0.42 ad=0.147 as=0.1176 pd=1.54 ps=1.4
XM35 X#12 a_114_74##29 VGND#16 VNB sky130_fd_pr__nfet_01v8_lvt l=0.15 w=0.42 ad=0.1176 as=0.147 pd=1.4 ps=1.54
XM22 VGND#16 a_114_74##25 X#15 VNB sky130_fd_pr__nfet_01v8_lvt l=0.15 w=0.42 ad=0.147 as=0.1176 pd=1.54 ps=1.4
XM21 VGND#15 a_114_74##23 X#15 VNB sky130_fd_pr__nfet_01v8_lvt l=0.15 w=0.42 ad=0.147 as=0.1176 pd=1.54 ps=1.4
XM23 VGND#15 a_114_74##20 X#18 VNB sky130_fd_pr__nfet_01v8_lvt l=0.15 w=0.42 ad=0.147 as=0.1176 pd=1.54 ps=1.4
XM26 VGND#14 a_114_74##18 X#18 VNB sky130_fd_pr__nfet_01v8_lvt l=0.15 w=0.42 ad=0.147 as=0.1176 pd=1.54 ps=1.4
XM8 X#19 a_114_74##16 VGND#14 VNB sky130_fd_pr__nfet_01v8_lvt l=0.15 w=0.42 ad=0.1176 as=0.147 pd=1.4 ps=1.54
XM0 X#19 a_114_74##14 VGND#13 VNB sky130_fd_pr__nfet_01v8_lvt l=0.15 w=0.42 ad=0.1176 as=0.147 pd=1.4 ps=1.54
XM1 VGND#13 a_114_74##12 X#22 VNB sky130_fd_pr__nfet_01v8_lvt l=0.15 w=0.42 ad=0.147 as=0.1176 pd=1.54 ps=1.4
XM31 X#22 a_114_74# VGND#1 VNB sky130_fd_pr__nfet_01v8_lvt l=0.15 w=0.42 ad=0.1176 as=0.1197 pd=1.4 ps=1.41
XM12 a_114_74##62 A#12 VPWR#21 VPB sky130_fd_pr__pfet_01v8 l=0.15 w=1.12 ad=0.336 as=0.3304 pd=2.84 ps=2.83
XM27 VPWR#20 A#11 a_114_74##62 VPB sky130_fd_pr__pfet_01v8 l=0.15 w=1.12 ad=0.336 as=0.336 pd=2.84 ps=2.84
XM10 a_114_74##57 A#9 VPWR#20 VPB sky130_fd_pr__pfet_01v8 l=0.15 w=1.12 ad=0.336 as=0.336 pd=2.84 ps=2.84
XM36 VPWR#18 A#1 a_114_74##57 VPB sky130_fd_pr__pfet_01v8 l=0.15 w=1.12 ad=0.3472 as=0.336 pd=2.86 ps=2.84
XM3 VPWR#18 a_114_74##56 X#1 VPB sky130_fd_pr__pfet_01v8 l=0.15 w=1.12 ad=0.3472 as=0.336 pd=2.86 ps=2.84
XM24 VPWR#16 a_114_74##55 X#1 VPB sky130_fd_pr__pfet_01v8 l=0.15 w=1.12 ad=0.336 as=0.336 pd=2.84 ps=2.84
XM14 X#4 a_114_74##52 VPWR#16 VPB sky130_fd_pr__pfet_01v8 l=0.15 w=1.12 ad=0.336 as=0.336 pd=2.84 ps=2.84
XM25 X#4 a_114_74##48 VPWR#13 VPB sky130_fd_pr__pfet_01v8 l=0.15 w=1.12 ad=0.336 as=0.336 pd=2.84 ps=2.84
XM5 X#7 a_114_74##42 VPWR#13 VPB sky130_fd_pr__pfet_01v8 l=0.15 w=1.12 ad=0.336 as=0.336 pd=2.84 ps=2.84
XM15 X#7 a_114_74##38 VPWR#11 VPB sky130_fd_pr__pfet_01v8 l=0.15 w=1.12 ad=0.336 as=0.336 pd=2.84 ps=2.84
XM6 VPWR#11 a_114_74##37 X#10 VPB sky130_fd_pr__pfet_01v8 l=0.15 w=1.12 ad=0.336 as=0.336 pd=2.84 ps=2.84
XM11 VPWR#9 a_114_74##31 X#10 VPB sky130_fd_pr__pfet_01v8 l=0.15 w=1.12 ad=0.336 as=0.336 pd=2.84 ps=2.84
XM9 X#13 a_114_74##30 VPWR#9 VPB sky130_fd_pr__pfet_01v8 l=0.15 w=1.12 ad=0.336 as=0.336 pd=2.84 ps=2.84
XM2 VPWR#7 a_114_74##26 X#13 VPB sky130_fd_pr__pfet_01v8 l=0.15 w=1.12 ad=0.336 as=0.336 pd=2.84 ps=2.84
XM28 VPWR#7 a_114_74##21 X#16 VPB sky130_fd_pr__pfet_01v8 l=0.15 w=1.12 ad=0.336 as=0.336 pd=2.84 ps=2.84
XM19 X#16 a_114_74##19 VPWR#5 VPB sky130_fd_pr__pfet_01v8 l=0.15 w=1.12 ad=0.336 as=0.336 pd=2.84 ps=2.84
XM29 X#21 a_114_74##17 VPWR#5 VPB sky130_fd_pr__pfet_01v8 l=0.15 w=1.12 ad=0.336 as=0.336 pd=2.84 ps=2.84
XM4 VPWR#3 a_114_74##15 X#21 VPB sky130_fd_pr__pfet_01v8 l=0.15 w=1.12 ad=0.3584 as=0.336 pd=2.88 ps=2.84
XM13 X#24 a_114_74##13 VPWR#3 VPB sky130_fd_pr__pfet_01v8 l=0.15 w=1.12 ad=0.336 as=0.3584 pd=2.84 ps=2.88
XM20 VPWR#1 a_114_74##11 X#24 VPB sky130_fd_pr__pfet_01v8 l=0.15 w=1.12 ad=0.3304 as=0.336 pd=2.83 ps=2.84
*
*
*       RESISTOR AND CAP/DIODE CARDS
*
Rg1	A#1	A#2	453.701172
Rg2	A#2	A#3	66.369736
Rg3	A#3	A#4	51.916321
Rg4	A#4	A#5	90.033310
Rg5	A#5	A#6	489.373627
Rg6	A#2	A#7	503.105560
Rg7	A#3	A#8	487.312225
Rg8	A#3	A#9	448.603302
Rg9	A#4	A#10	466.174072
Rg10	A#4	A#11	424.977325
Rg11	A#5	A#12	449.655212
Rg12	a_114_74#	a_114_74##2	397.555725
Rg13	a_114_74##2	a_114_74##3	66.369736
Rg14	a_114_74##3	a_114_74##4	44.632042
Rg15	a_114_74##4	a_114_74##5	33.834415
Rg16	a_114_74##5	a_114_74##6	75.152679
Rg17	a_114_74##6	a_114_74##7	46.600769
Rg18	a_114_74##7	a_114_74##8	30.209223
Rg19	a_114_74##8	a_114_74##9	69.423874
Rg20	a_114_74##9	a_114_74##10	47.615482
Rg21	a_114_74##2	a_114_74##11	520.126282
Rg22	a_114_74##3	a_114_74##12	395.494293
Rg23	a_114_74##3	a_114_74##13	519.074341
Rg24	a_114_74##5	a_114_74##14	441.926941
Rg25	a_114_74##5	a_114_74##15	456.273468
Rg26	a_114_74##6	a_114_74##16	394.514160
Rg27	a_114_74##6	a_114_74##17	518.081543
Rg28	a_114_74##8	a_114_74##18	450.111023
Rg29	a_114_74##8	a_114_74##19	464.457550
Rg30	a_114_74##9	a_114_74##20	441.926941
Rg31	a_114_74##9	a_114_74##21	456.273468
Rg32	a_114_74##10	a_114_74##22	18.807051
Rg33	a_114_74##22	a_114_74##23	472.930756
Rg34	a_114_74##22	a_114_74##24	70.629135
Rg35	a_114_74##24	a_114_74##25	456.223694
Rg36	a_114_74##22	a_114_74##26	487.277283
Rg37	a_114_74##24	a_114_74##27	48.717937
Rg38	a_114_74##27	a_114_74##28	39.889557
Rg39	a_114_74##28	a_114_74##29	426.181030
Rg40	a_114_74##24	a_114_74##30	470.570251
Rg41	a_114_74##27	a_114_74##31	496.361267
Rg42	a_114_74##28	a_114_74##32	58.739525
Rg43	a_114_74##32	a_114_74##33	485.224518
Rg44	a_114_74##32	a_114_74##34	50.385254
Rg45	a_114_74##34	a_114_74##35	39.747246
Rg46	a_114_74##35	a_114_74##36	388.013367
Rg47	a_114_74##32	a_114_74##37	499.571075
Rg48	a_114_74##34	a_114_74##38	497.350220
Rg49	a_114_74##35	a_114_74##39	47.566833
Rg50	a_114_74##39	a_114_74##40	29.925255
Rg51	a_114_74##40	a_114_74##41	407.781036
Rg52	a_114_74##39	a_114_74##42	414.238342
Rg53	a_114_74##40	a_114_74##43	28.976315
Rg54	a_114_74##43	a_114_74##44	20.538694
Rg55	a_114_74##44	a_114_74##45	501.849182
Rg56	a_114_74##44	a_114_74##46	71.402962
Rg57	a_114_74##46	a_114_74##47	472.930756
Rg58	a_114_74##44	a_114_74##48	516.195740
Rg59	a_114_74##46	a_114_74##49	36.642159
Rg60	a_114_74##49	a_114_74##50	33.986977
Rg61	a_114_74##50	a_114_74##51	456.223694
Rg62	a_114_74##46	a_114_74##52	487.277283
Rg63	a_114_74##50	a_114_74##53	60.234970
Rg64	a_114_74##53	a_114_74##54	397.555725
Rg65	a_114_74##50	a_114_74##55	470.570251
Rg66	a_114_74##53	a_114_74##56	520.126282
Rf1	A	A#13	3.208829
Rf2	A#13	A	11.460103
Rf3	a_114_74##57	a_114_74##58	18.601391
Rf4	a_114_74##58	a_114_74##59	77.180412
Rf5	a_114_74##59	a_114_74##60	46.191299
Rf6	a_114_74##60	a_114_74##61	98.783043
Rf7	a_114_74##58	a_114_74##62	81.107391
Rf8	a_114_74##60	a_114_74##63	35.492405
Rf9	X#1	X#2	24.834568
Rf10	X#2	X#3	84.254166
Rf11	a_114_74##49	a_114_74##65	172.866425
Rf12	X#4	X#5	27.459736
Rf13	X#5	X#6	97.217468
Rf14	a_114_74##43	a_114_74##67	172.372620
Rf15	X#7	X#8	27.977242
Rf16	X#8	X#9	114.368950
Rf17	a_114_74##34	a_114_74##69	172.372620
Rf18	X#10	X#11	26.965029
Rf19	X#11	X#12	95.083000
Rf20	a_114_74##27	a_114_74##71	172.372620
Rf21	X#13	X#14	27.459736
Rf22	X#14	X#15	90.711800
Rf23	a_114_74##10	a_114_74##73	172.372620
Rf24	X#16	X#17	27.459736
Rf25	X#17	X#18	90.965858
Rf26	a_114_74##7	a_114_74##75	172.372620
Rf27	X#19	X#20	91.140808
Rf28	X#20	X#21	26.965029
Rf29	a_114_74##4	a_114_74##77	162.594833
Rf30	X#22	X#23	90.631126
Rf31	X#23	X#24	26.038235
Rf32	VGND#1	VGND#2	118.475136
Rf33	VGND#2	VGND#3	51.110813
Rf34	VGND#3	VGND#4	67.887894
Rf35	VGND#4	VGND#5	67.887894
Rf36	VGND#5	VGND#6	67.708260
Rf37	VGND#6	VGND#7	65.046944
Rf38	VGND#7	VGND#8	30.917385
Rf39	VGND#8	VGND#9	30.048746
Rf40	VGND#9	VGND#10	68.010475
Rf41	VGND#10	VGND#11	67.214737
Rf42	VGND#11	VGND#12	103.247864
Rf43	VGND#2	VGND#13	35.446526
Rf44	VGND#3	VGND#14	31.948624
Rf45	VGND#4	VGND#15	31.948624
Rf46	VGND#5	VGND#16	31.948624
Rf47	VGND#6	VGND#17	34.592995
Rf48	VGND#7	VGND#18	41.843208
Rf49	VGND#9	VGND#19	47.494125
Rf50	VGND#10	VGND#20	34.507496
Rf51	VGND#11	VGND#21	40.352859
Rf52	VPWR#1	VPWR#2	119.366081
Rf53	VPWR#2	VPWR#3	39.225067
Rf54	VPWR#2	VPWR#4	48.554047
Rf55	VPWR#4	VPWR#5	35.727165
Rf56	VPWR#4	VPWR#6	65.696381
Rf57	VPWR#6	VPWR#7	35.727165
Rf58	VPWR#6	VPWR#8	65.696381
Rf59	VPWR#8	VPWR#9	35.727165
Rf60	VPWR#8	VPWR#10	65.696381
Rf61	VPWR#10	VPWR#11	35.727165
Rf62	VPWR#10	VPWR#12	65.696381
Rf63	VPWR#12	VPWR#13	35.727165
Rf64	VPWR#12	VPWR#14	39.057484
Rf65	VPWR#14	VPWR#15	26.638899
Rf66	VPWR#15	VPWR#16	35.727165
Rf67	VPWR#15	VPWR#17	63.562214
Rf68	VPWR#17	VPWR#18	38.736572
Rf69	VPWR#17	VPWR#19	68.798325
Rf70	VPWR#19	VPWR#20	53.143215
Rf71	VPWR#19	VPWR#21	113.787254
Rf72	A#4	A#13	40.058201
Re1	a_114_74##77	a_114_74##75	10.621317
Re2	a_114_74##75	a_114_74##73	0.843534
Re3	a_114_74##73	a_114_74##71	0.852604
Re4	a_114_74##71	a_114_74##69	0.829929
Re5	a_114_74##69	a_114_74##67	0.761902
Re6	a_114_74##67	a_114_74##65	0.780042
Re7	a_114_74##65	a_114_74##59	10.575965
Re8	X#23	X#26	10.612247
Re9	X#26	X#27	0.816323
Re10	X#27	X#28	0.816323
Re11	X#28	X	0.367345
Re12	X	X#29	0.448978
Re13	X#29	X#30	0.829929
Re14	X#30	X#31	0.802718
Re15	X#31	X#2	10.594106
Re16	VPWR#2	VPWR	2.920302
Re17	VPWR	VPWR#14	1.251558
Re18	VGND#2	VGND	2.920302
Re19	VGND	VGND#8	1.251558
Re29	X#20	X#26	9.777782
Re30	X#17	X#27	9.777782
Re31	X#14	X#28	9.777782
Re32	X#11	X#29	9.777782
Re33	X#8	X#30	9.777782
Re34	X#5	X#31	9.777782
*
*       CAPACITOR CARDS
*
*
C1	VGND#2	VGND#3	5.1605e-17
C2	VPWR#11	X#10	6.16402e-17
C3	X#14	VPWR#6	8.37909e-19
C4	a_114_74##77	a_114_74##5	1.01362e-17
C5	VGND#15	a_114_74##29	3.18276e-19
C6	VPWR#13	a_114_74##48	5.3764e-17
C7	a_114_74##25	VGND#16	1.33086e-17
C8	A#7	a_114_74##54	2.32714e-17
C9	a_114_74##73	VGND#5	1.22583e-20
C10	X#9	VGND#17	4.15857e-17
C11	a_114_74##75	X#19	2.34298e-17
C12	a_114_74##57	VPWR#19	8.48902e-18
C13	a_114_74##48	X#4	1.73145e-17
C14	a_114_74##77	a_114_74##2	7.08162e-18
C15	X#15	a_114_74##29	2.11029e-18
C16	a_114_74##73	VGND#4	1.73851e-18
C17	X#20	a_114_74##22	3.92171e-19
C18	VGND#12	VPWR#21	1.21029e-19
C19	VGND#14	a_114_74##75	1.30737e-17
C20	X#12	a_114_74##25	1.20808e-18
C21	a_114_74##60	a_114_74##51	1.56499e-19
C22	VPWR#13	a_114_74##52	2.3776e-18
C23	VPWR#16	a_114_74##48	2.34779e-18
C24	a_114_74##75	X#18	2.52256e-17
C25	VGND#16	a_114_74##29	2.94497e-17
C26	a_114_74##57	VPWR#17	8.43957e-18
C27	X#20	a_114_74##8	1.1953e-17
C28	a_114_74##52	X#4	2.38557e-17
C29	X#7	VPWR#11	5.55175e-17
C30	VPWR#10	VPWR#8	1.22166e-18
C31	A#8	A#7	3.47403e-17
C32	VGND#1	VPWR#1	5.63277e-18
C33	VGND#18	VGND#17	1.85457e-18
C34	X#15	a_114_74##33	5.96399e-19
C35	VPWR#6	a_114_74##22	7.92109e-20
C36	VPWR#16	a_114_74##52	6.31202e-17
C37	X#11	VPWR#10	1.23237e-18
C38	a_114_74##5	a_114_74##4	5.21968e-18
C39	X#12	a_114_74##29	1.16056e-17
C40	X#20	a_114_74##5	1.20055e-17
C41	a_114_74##60	a_114_74##54	3.52447e-19
C42	X#11	VPWR#8	1.32927e-18
C43	a_114_74##50	a_114_74##44	1.4747e-17
C44	a_114_74##4	a_114_74##2	1.07303e-17
C45	VPWR#13	VPWR#11	2.06267e-18
C46	VGND#16	a_114_74##33	1.62789e-18
C47	VGND#18	X#9	3.09071e-17
C48	VPWR#16	a_114_74##55	5.46763e-17
C49	A#10	A#8	2.9586e-17
C50	VGND#17	a_114_74##29	3.80568e-19
C51	a_114_74##71	VGND#6	6.5619e-21
C52	a_114_74##75	a_114_74##22	2.1032e-21
C53	a_114_74##71	VGND#5	1.97443e-18
C54	VGND#2	VGND#1	5.79607e-17
C55	X#12	a_114_74##33	2.6543e-17
C56	a_114_74##55	X#1	1.65857e-17
C57	VPWR#13	X#7	6.41403e-17
C58	VGND#2	X#22	2.92325e-17
C59	VPWR#17	A#2	1.98672e-20
C60	a_114_74##60	A#7	7.36992e-18
C61	a_114_74##22	a_114_74##8	1.47419e-17
C62	a_114_74##62	VPWR#19	1.71122e-17
C63	a_114_74##44	a_114_74##31	3.95181e-18
C64	X#23	VPWR#1	8.88006e-17
C65	VPWR#16	a_114_74##56	2.28779e-18
C66	VGND#16	a_114_74##36	3.1607e-19
C67	VPWR#18	a_114_74##55	1.51731e-18
C68	VGND#2	VGND#13	9.58246e-18
C69	a_114_74##75	a_114_74##8	2.84894e-17
C70	X#6	X#9	1.00132e-17
C71	VGND#7	a_114_74##44	3.81271e-20
C72	a_114_74##33	VGND#17	1.06875e-17
C73	X#23	X#24	2.83391e-17
C74	A#6	A#10	3.47481e-17
C75	VGND#2	X#19	2.53897e-17
C76	a_114_74##56	X#1	2.77461e-17
C77	a_114_74##57	a_114_74##55	1.60218e-19
C78	X#12	a_114_74##36	1.76085e-18
C79	VGND#2	VGND#14	9.5824e-18
C80	VPWR#8	VPWR#6	1.22166e-18
C81	X#23	VPWR#3	8.71055e-17
C82	VGND#5	X#11	2.79021e-19
C83	VPWR#18	a_114_74##56	5.11666e-17
C84	VPWR#4	a_114_74##17	4.62913e-18
C85	X#9	a_114_74##33	9.56211e-19
C86	X#8	VPWR#12	7.22345e-19
C87	VGND#2	X#18	1.63883e-17
C88	VPWR#6	a_114_74##8	8.40615e-22
C89	X#17	a_114_74##28	4.1679e-19
C90	a_114_74##60	A#8	1.24091e-17
C91	X#8	VPWR#10	8.041e-19
C92	X#6	VGND#18	3.91666e-17
C93	X#1	A#1	3.54958e-19
C94	a_114_74##57	a_114_74##56	1.63122e-18
C95	VGND#2	VGND#15	1.38785e-18
C96	VPWR#21	VPWR#19	7.0017e-19
C97	VGND#17	a_114_74##36	2.76021e-17
C98	X#4	VPWR#13	6.01229e-17
C99	a_114_74##77	VPWR#3	1.21154e-17
C100	A#1	VPWR#18	2.13186e-17
C101	VPWR#20	a_114_74##56	1.53854e-19
C102	X#17	a_114_74##22	1.74685e-17
C103	X#12	a_114_74##41	4.58687e-19
C104	a_114_74##69	VGND#6	2.17746e-18
C105	a_114_74##36	X#9	1.16296e-17
C106	a_114_74##57	A#1	5.23689e-17
C107	a_114_74##73	X#18	2.61008e-17
C108	VPWR#16	VPWR#13	2.06267e-18
C109	VGND#19	VGND#18	1.6682e-18
C110	a_114_74##60	A#10	2.85154e-18
C111	VPWR#4	a_114_74##19	3.49862e-18
C112	X#17	a_114_74##8	1.23866e-17
C113	a_114_74##31	a_114_74##28	4.28259e-18
C114	VGND#15	a_114_74##73	1.30621e-17
C115	VGND#17	a_114_74##41	1.20337e-18
C116	VPWR#18	A#9	3.71489e-19
C117	VPWR#20	A#1	3.44144e-19
C118	VGND#6	a_114_74##44	1.43612e-19
C119	X#20	VPWR#3	8.73584e-17
C120	VGND#18	a_114_74##36	2.79238e-19
C121	a_114_74##73	X#15	2.546e-17
C122	a_114_74##57	A#9	4.59173e-17
C123	X#20	X#21	2.64876e-17
C124	VPWR#16	X#4	6.15758e-17
C125	X#9	a_114_74##41	2.80713e-17
C126	VGND#6	X#8	2.66564e-19
C127	VPWR#6	a_114_74##21	1.54529e-18
C128	VPWR#4	a_114_74##8	4.14704e-20
C129	A#9	VPWR#20	2.47104e-17
C130	X#20	VPWR#5	9.06053e-17
C131	VPWR#18	A#11	1.72497e-19
C132	VGND#19	X#6	2.20315e-17
C133	X#6	a_114_74##36	3.44016e-19
C134	VPWR#6	VPWR#4	1.22166e-18
C135	a_114_74##60	A#6	2.8582e-19
C136	VGND#17	a_114_74##45	1.8944e-19
C137	a_114_74##62	A#9	1.77076e-18
C138	a_114_74##57	A#11	1.65826e-18
C139	a_114_74##41	VGND#18	1.07807e-17
C140	X#5	VPWR#12	1.24223e-19
C141	a_114_74##13	a_114_74##11	5.00719e-17
C142	A#11	VPWR#20	2.84583e-17
C143	VPWR#21	A#9	2.59902e-19
C144	VGND#3	X#19	3.0651e-18
C145	X#9	a_114_74##45	1.95158e-18
C146	VGND#7	a_114_74##67	2.20455e-18
C147	a_114_74##75	VPWR#5	1.11902e-17
C148	X#3	X#6	1.15925e-17
C149	X#6	a_114_74##41	1.48774e-18
C150	a_114_74##67	VGND#6	2.25292e-19
C151	a_114_74##62	A#11	7.01254e-17
C152	VPWR#6	a_114_74##26	2.49417e-18
C153	VPWR#2	a_114_74##8	4.77852e-20
C154	a_114_74##44	a_114_74##38	8.25072e-18
C155	X#1	VPWR#16	6.6431e-17
C156	a_114_74##45	VGND#18	1.77565e-17
C157	VPWR#2	VPWR#1	6.43877e-17
C158	VPWR#21	A#11	1.23306e-18
C159	VGND#5	a_114_74##44	3.02229e-20
C160	VPWR#20	A#12	6.79311e-19
C161	a_114_74##71	X#15	2.09615e-17
C162	a_114_74##15	a_114_74##13	4.40477e-17
C163	VGND#19	a_114_74##41	1.54501e-19
C164	X#17	VPWR#5	2.70791e-17
C165	VPWR#2	a_114_74##5	3.58663e-20
C166	VGND#16	a_114_74##71	1.59066e-17
C167	X#9	a_114_74##47	5.09156e-19
C168	a_114_74##62	A#12	5.42959e-17
C169	X#3	VGND#19	2.55702e-17
C170	VPWR#8	a_114_74##30	1.3008e-18
C171	a_114_74##45	X#6	1.26858e-17
C172	a_114_74##71	X#12	2.58412e-17
C173	VPWR#2	VPWR#3	1.51702e-17
C174	X#17	X#16	3.18522e-18
C175	VGND#4	X#18	6.78589e-18
C176	VPWR#18	VPWR#16	2.623e-18
C177	A#12	VPWR#21	3.3666e-17
C178	X#17	VPWR#7	3.07233e-17
C179	VPWR#2	a_114_74##2	4.14704e-20
C180	VGND#18	a_114_74##47	9.53792e-19
C181	a_114_74##17	a_114_74##15	4.69401e-17
C182	VPWR#2	VPWR#5	1.55653e-17
C183	VGND#19	a_114_74##45	9.02118e-19
C184	X#2	VPWR#17	4.81206e-19
C185	VGND#2	a_114_74##22	1.6377e-19
C186	X#2	VPWR#15	1.42747e-18
C187	VPWR#18	X#1	6.1917e-17
C188	VPWR#2	X#16	1.45831e-17
C189	VGND#20	VGND#19	2.15693e-18
C190	X#3	A#2	2.04338e-19
C191	a_114_74##47	X#6	1.66577e-17
C192	VGND#3	X#18	6.965e-18
C193	a_114_74##65	VGND#9	1.84296e-18
C194	VPWR#2	VPWR#7	4.66435e-18
C195	X#3	a_114_74##45	6.34544e-19
C196	VPWR#8	a_114_74##31	4.65473e-18
C197	VGND#2	a_114_74##8	9.00123e-20
C198	VGND#18	a_114_74##51	1.37946e-19
C199	VGND#5	X#15	6.78589e-18
C200	a_114_74##19	a_114_74##17	4.81056e-17
C201	a_114_74##47	VGND#19	1.14513e-17
C202	VGND#6	VGND#16	6.89236e-20
C203	a_114_74##57	X#1	2.04912e-18
C204	a_114_74##60	a_114_74##58	7.14608e-19
C205	VGND#2	a_114_74##5	8.81464e-20
C206	a_114_74##60	A#2	7.48455e-18
C207	VGND#20	X#3	3.58038e-17
C208	X#6	a_114_74##51	2.59975e-18
C209	a_114_74##69	X#12	2.37066e-17
C210	VPWR#10	a_114_74##37	1.36434e-18
C211	X#3	a_114_74##47	2.23199e-18
C212	a_114_74##73	a_114_74##28	3.00779e-21
C213	VGND#17	a_114_74##69	1.52339e-17
C214	A#7	a_114_74##53	2.59927e-18
C215	X#22	a_114_74##8	2.70818e-19
C216	VGND#2	a_114_74##2	9.25673e-20
C217	a_114_74##57	VPWR#18	5.29637e-17
C218	VGND#4	X#15	6.965e-18
C219	a_114_74##21	a_114_74##19	4.80704e-17
C220	a_114_74##69	X#9	2.48929e-17
C221	a_114_74##51	VGND#19	1.29122e-17
C222	a_114_74##73	a_114_74##22	2.83037e-17
C223	VGND#20	a_114_74##47	2.03624e-19
C224	a_114_74##63	X#3	2.77486e-19
C225	VGND#6	X#12	5.94609e-18
C226	a_114_74##73	VPWR#7	1.02202e-17
C227	VGND#20	A#2	4.08127e-19
C228	X#6	a_114_74##54	5.70512e-19
C229	X#14	a_114_74##44	4.3854e-19
C230	VGND#7	VGND#17	4.50395e-19
C231	a_114_74##8	a_114_74##5	1.07376e-17
C232	VPWR#14	VPWR#19	7.19332e-17
C233	a_114_74##51	X#3	1.82733e-17
C234	VPWR#20	VPWR#18	1.94092e-18
C235	VGND#11	VGND#10	1.07851e-18
C236	VPWR#14	VPWR#17	6.64852e-17
C237	VPWR#10	a_114_74##38	1.69517e-18
C238	a_114_74##59	VGND#10	1.72734e-18
C239	a_114_74##26	a_114_74##21	4.80575e-17
C240	VPWR#14	VPWR#15	4.16822e-17
C241	X#8	X#9	3.3177e-19
C242	VGND#19	a_114_74##54	8.54829e-19
C243	a_114_74##59	VGND#9	4.59135e-20
C244	VPWR#14	VPWR#12	4.40908e-17
C245	VGND#20	a_114_74##51	1.23492e-18
C246	X#14	VPWR#7	2.67775e-17
C247	a_114_74##63	VGND#20	3.8252e-17
C248	VPWR#14	VPWR#10	5.29804e-17
C249	a_114_74##58	A#2	1.19906e-18
C250	VGND#5	X#12	6.965e-18
C251	VPWR#20	a_114_74##57	5.21059e-17
C252	VPWR#14	VPWR#8	5.36629e-17
C253	X#14	X#13	3.1683e-18
C254	a_114_74##54	X#3	1.53669e-17
C255	VPWR#14	VPWR#6	3.0582e-17
C256	VPWR#12	a_114_74##42	8.82828e-19
C257	VPWR#9	X#14	1.7654e-17
C258	X#19	a_114_74##22	2.70818e-19
C259	VGND#7	X#9	6.66393e-18
C260	a_114_74##63	a_114_74##51	2.21044e-20
C261	X#14	a_114_74##28	1.64793e-17
C262	a_114_74##30	a_114_74##26	4.80711e-17
C263	X#22	a_114_74##5	1.21813e-18
C264	VGND#19	A#7	1.59372e-19
C265	a_114_74##67	X#9	2.65284e-17
C266	a_114_74##62	a_114_74##57	2.33888e-18
C267	VGND#20	a_114_74##54	1.08999e-17
C268	VGND#21	VGND#20	1.57555e-18
C269	VGND#18	a_114_74##67	1.11964e-17
C270	X#14	a_114_74##22	1.29259e-17
C271	a_114_74##67	X#6	2.56059e-17
C272	a_114_74##58	X#2	2.81673e-17
C273	X#3	A#7	1.31052e-18
C274	a_114_74##71	VPWR#9	1.15463e-17
C275	a_114_74##71	a_114_74##44	1.6509e-21
C276	a_114_74##63	a_114_74##54	4.97807e-20
C277	VGND#6	X#9	7.83403e-18
C278	a_114_74##31	a_114_74##30	4.79912e-17
C279	a_114_74##62	VPWR#20	5.2514e-17
C280	X#15	a_114_74##44	2.70818e-19
C281	VGND#5	a_114_74##28	1.10225e-19
C282	VPWR#12	a_114_74##48	2.65613e-18
C283	VGND#20	A#7	2.55541e-17
C284	VGND#21	a_114_74##63	3.42627e-17
C285	VGND#10	VGND#9	1.27648e-18
C286	VGND#8	VGND#11	8.10998e-17
C287	VGND#8	VGND#10	7.58401e-17
C288	X#11	VPWR#9	1.81586e-17
C289	X#3	A#8	1.94343e-19
C290	VGND#8	VGND#9	4.22625e-17
C291	VPWR#21	VPWR#20	1.94092e-18
C292	a_114_74##59	a_114_74##58	1.00933e-18
C293	X#11	X#10	3.10756e-18
C294	a_114_74##63	A#7	7.52451e-18
C295	a_114_74##37	a_114_74##31	4.80569e-17
C296	VGND#2	a_114_74#	4.24299e-18
C297	VGND#8	VGND#7	4.70077e-17
C298	VGND#11	A#5	4.76064e-20
C299	X#18	a_114_74##28	2.70818e-19
C300	VGND#8	VGND#6	6.47985e-17
C301	X#11	VPWR#11	3.21032e-17
C302	X#19	a_114_74##8	8.19803e-18
C303	a_114_74##71	a_114_74##28	2.87466e-17
C304	VGND#2	a_114_74##12	8.79053e-18
C305	VGND#8	VGND#5	5.52584e-17
C306	VGND#20	A#8	1.44749e-18
C307	a_114_74##61	a_114_74##63	3.18479e-19
C308	X#22	a_114_74##2	7.70563e-18
C309	VPWR#17	a_114_74##53	3.92287e-20
C310	VGND#8	VGND#4	3.56596e-17
C311	VGND#21	A#7	2.31495e-19
C312	VGND#2	a_114_74##14	5.71987e-18
C313	VPWR#21	a_114_74##62	7.73583e-17
C314	a_114_74##65	X#6	2.70029e-17
C315	VGND#2	a_114_74##16	1.93416e-18
C316	VGND#19	a_114_74##65	8.80383e-18
C317	a_114_74##61	A#5	1.0563e-17
C318	a_114_74##38	a_114_74##37	4.80296e-17
C319	a_114_74##63	A#8	2.29304e-17
C320	a_114_74##69	VPWR#11	1.29402e-17
C321	VPWR#14	a_114_74##58	3.82983e-18
C322	a_114_74##65	X#3	2.7624e-17
C323	VGND#10	X#3	7.76117e-18
C324	X#11	a_114_74##44	1.54798e-17
C325	VPWR#17	a_114_74##55	3.80427e-19
C326	VGND#2	a_114_74##18	1.39472e-18
C327	a_114_74##61	VGND#21	3.92789e-17
C328	VGND#20	A#10	2.19126e-19
C329	VGND#11	VGND#20	1.02411e-18
C330	VGND#4	a_114_74##28	5.4668e-20
C331	VGND#2	a_114_74##20	2.10999e-18
C332	VGND#21	A#8	8.47633e-18
C333	VPWR#15	a_114_74##55	4.64302e-18
C334	a_114_74##58	X#1	1.68598e-19
C335	a_114_74##42	a_114_74##38	4.80867e-17
C336	VGND#19	VGND#7	5.12376e-19
C337	X#8	VPWR#11	2.59889e-17
C338	a_114_74##63	A#10	9.38355e-19
C339	A#5	A#4	1.09221e-17
C340	VGND#9	VGND#7	1.39615e-18
C341	VGND#8	a_114_74##60	3.34865e-18
C342	VGND#9	X#3	7.71149e-18
C343	a_114_74##61	A#8	7.17085e-19
C344	X#8	X#7	3.4585e-18
C345	X#22	VGND#1	3.98417e-17
C346	VPWR#19	a_114_74##56	8.09218e-20
C347	A#4	A#2	1.08917e-17
C348	VGND#12	VGND#21	1.57518e-18
C349	X#18	a_114_74##22	9.36184e-18
C350	X#8	VPWR#13	3.33268e-17
C351	VGND#14	a_114_74##8	4.93346e-18
C352	VGND#16	VPWR#9	3.81173e-19
C353	X#11	a_114_74##28	8.34952e-18
C354	X#19	a_114_74##5	5.873e-18
C355	VGND#21	A#10	2.24075e-17
C356	VPWR#17	a_114_74##56	5.39919e-18
C357	a_114_74##44	a_114_74##28	1.076e-17
C358	a_114_74##48	a_114_74##42	4.80586e-17
C359	VGND#11	a_114_74##63	4.87585e-18
C360	VPWR#15	a_114_74##53	6.44472e-21
C361	X#23	a_114_74##11	3.74305e-17
C362	a_114_74##63	A#6	4.037e-20
C363	a_114_74##58	VPWR#18	2.33235e-17
C364	a_114_74##61	A#10	1.4915e-17
C365	a_114_74##56	a_114_74##50	3.94729e-18
C366	a_114_74##59	X#3	4.35777e-17
C367	a_114_74##67	VPWR#13	1.35636e-17
C368	X#23	a_114_74##13	2.75063e-17
C369	VGND#12	a_114_74##61	3.92789e-17
C370	VGND#13	VGND#1	1.89182e-18
C371	VGND#20	a_114_74##59	2.93473e-17
C372	a_114_74##69	a_114_74##44	2.94632e-17
C373	VGND#20	VGND#9	1.51568e-19
C374	VGND#21	A#6	1.42284e-18
C375	VPWR#19	A#1	2.85183e-19
C376	X#23	a_114_74##15	3.02031e-18
C377	VGND#8	VGND#15	8.16908e-18
C378	a_114_74##52	a_114_74##48	4.80711e-17
C379	a_114_74##12	a_114_74#	3.11833e-17
C380	VGND#12	A#10	1.21536e-18
C381	X#12	a_114_74##44	8.76021e-18
C382	VGND#10	a_114_74##63	7.668e-18
C383	VGND#8	X#15	1.63493e-17
C384	X#22	a_114_74##4	7.70623e-18
C385	X#23	a_114_74##17	6.43589e-19
C386	VGND#8	VGND#16	9.5824e-18
C387	VPWR#17	A#1	5.28009e-18
C388	VGND#4	a_114_74##22	8.57798e-20
C389	A#2	a_114_74##57	2.70455e-19
C390	X#20	a_114_74##11	2.28523e-19
C391	X#5	VPWR#13	2.62583e-17
C392	VGND#13	a_114_74##4	3.95571e-18
C393	a_114_74##61	A#6	3.04181e-17
C394	VGND#8	X#12	1.60392e-17
C395	a_114_74##58	a_114_74##57	1.36305e-18
C396	VPWR#15	a_114_74##50	3.72673e-20
C397	X#19	a_114_74##4	5.51239e-19
C398	X#5	X#4	3.18731e-18
C399	X#20	a_114_74##13	1.56682e-18
C400	VGND#13	X#22	3.64864e-17
C401	VGND#8	X#9	1.74106e-17
C402	a_114_74##55	a_114_74##52	4.80504e-17
C403	X#5	VPWR#16	3.16335e-17
C404	VGND#15	a_114_74##22	4.40531e-18
C405	X#18	a_114_74##8	6.35862e-18
C406	X#15	a_114_74##28	9.889e-18
C407	VGND#7	VGND#6	1.12618e-18
C408	VGND#12	A#6	1.76343e-17
C409	X#20	a_114_74##15	2.14767e-17
C410	VGND#8	X#6	2.86504e-17
C411	VGND#10	A#2	1.54154e-20
C412	VPWR#19	A#9	5.10765e-18
C413	X#20	a_114_74##17	2.76764e-17
C414	VGND#8	X#3	1.61625e-17
C415	a_114_74##14	a_114_74##12	2.38996e-17
C416	X#8	a_114_74##50	3.95696e-19
C417	a_114_74##65	VPWR#16	1.44342e-17
C418	a_114_74##56	a_114_74##55	4.80045e-17
C419	X#20	a_114_74##19	1.04429e-18
C420	a_114_74##58	VPWR#20	1.61031e-17
C421	VPWR#17	A#9	3.00302e-19
C422	VGND#11	a_114_74##61	1.43133e-17
C423	VGND#8	a_114_74##63	1.45137e-17
C424	X#19	X#22	1.12872e-17
C425	VPWR#2	a_114_74##11	2.57388e-18
C426	X#20	a_114_74##21	3.61627e-19
C427	X#8	a_114_74##44	2.12513e-17
C428	X#17	a_114_74##15	1.94768e-19
C429	VGND#8	a_114_74##61	1.52934e-17
C430	VGND#3	a_114_74##16	3.9472e-18
C431	VGND#17	a_114_74##44	3.32504e-18
C432	VPWR#2	a_114_74##13	6.54045e-18
C433	VGND#8	VGND#12	5.20918e-17
C434	X#17	a_114_74##17	1.62501e-18
C435	X#9	a_114_74##50	2.32929e-19
C436	X#2	VPWR#16	3.17911e-17
C437	A#1	a_114_74##56	4.49608e-17
C438	VGND#3	a_114_74##22	4.13343e-20
C439	VPWR#2	a_114_74##15	5.90948e-18
C440	VPWR#14	VPWR#7	1.0857e-17
C441	X#2	X#1	3.04196e-18
C442	X#17	a_114_74##19	9.89933e-18
C443	VPWR#19	A#11	7.35276e-18
C444	VPWR#14	X#13	1.40471e-17
C445	a_114_74##62	a_114_74##58	6.51334e-19
C446	VPWR#2	a_114_74##17	1.45107e-18
C447	a_114_74##16	a_114_74##14	3.12338e-17
C448	X#17	a_114_74##21	1.24958e-17
C449	A#5	a_114_74##62	1.46925e-18
C450	VPWR#14	VPWR#9	1.55653e-17
C451	X#19	VGND#13	3.46752e-17
C452	VGND#12	VGND#11	1.14907e-18
C453	VPWR#17	A#11	8.74044e-20
C454	X#15	a_114_74##22	5.90425e-18
C455	VGND#16	a_114_74##28	4.17588e-18
C456	VPWR#14	X#10	1.42333e-17
C457	VPWR#2	a_114_74##19	1.65221e-18
C458	A#9	A#1	4.58176e-17
C459	X#17	a_114_74##26	1.12497e-18
C460	VPWR#14	VPWR#11	1.55653e-17
C461	VGND#3	a_114_74##18	4.27793e-18
C462	VPWR#1	a_114_74##11	5.2297e-17
C463	VPWR#2	a_114_74##21	1.42228e-18
C464	VGND#6	VGND#5	1.13068e-18
C465	VPWR#14	X#7	1.42943e-17
C466	A	a_114_74##53	1.12893e-18
C467	a_114_74##58	VPWR#19	3.13618e-19
C468	X#17	a_114_74##30	3.8001e-19
C469	a_114_74##59	VPWR#18	7.46043e-18
C470	VPWR#14	VPWR#13	1.55653e-17
C471	VPWR#3	a_114_74##4	3.2634e-18
C472	a_114_74##67	a_114_74##50	5.20145e-22
C473	X#4	VPWR#14	2.72883e-17
C474	VGND#4	a_114_74##20	2.96979e-18
C475	a_114_74##11	X#24	6.18903e-18
C476	a_114_74##58	VPWR#21	7.36748e-21
C477	A#11	A#9	4.75303e-17
C478	VPWR#19	A#12	2.33898e-18
C479	VPWR#14	VPWR#16	1.55698e-17
C480	VGND#14	VGND#13	1.89091e-18
C481	VPWR#14	X#1	1.51141e-17
C482	a_114_74##67	a_114_74##44	2.9216e-17
C483	VPWR#3	VPWR#1	2.21155e-18
C484	VPWR#1	a_114_74##13	2.90229e-18
C485	a_114_74##18	a_114_74##16	2.39261e-17
C486	VPWR#14	VPWR#18	1.11284e-20
C487	X#9	a_114_74##44	1.35985e-17
C488	VPWR#3	a_114_74##11	2.86392e-18
C489	VPWR#14	a_114_74##57	1.72175e-17
C490	A	A#5	2.33428e-17
C491	X#14	a_114_74##19	8.22326e-20
C492	a_114_74##58	VPWR#17	3.18945e-19
C493	A#12	A#11	4.57353e-17
C494	A	A#2	1.34593e-17
C495	a_114_74##13	X#24	1.22997e-17
C496	VPWR#14	a_114_74##62	1.89755e-17
C497	X#14	a_114_74##21	5.74942e-19
C498	VGND#3	a_114_74##8	5.91125e-20
C499	VPWR#14	VPWR#21	5.73195e-17
C500	VGND#4	a_114_74##23	1.68525e-18
C501	VGND#14	X#19	3.64864e-17
C502	X#14	a_114_74##26	9.52024e-18
C503	X#12	a_114_74##28	6.55404e-18
C504	VPWR#1	a_114_74##15	2.9867e-19
C505	VPWR#5	a_114_74##8	1.40375e-18
C506	a_114_74##13	VPWR#3	2.57823e-17
C507	VPWR#12	a_114_74##44	4.20308e-20
C508	X#14	a_114_74##30	1.19226e-17
C509	VPWR#19	A#4	4.06694e-20
C510	a_114_74##20	a_114_74##18	3.12338e-17
C511	VGND#5	a_114_74##25	2.87256e-18
C512	X#14	a_114_74##31	2.13551e-18
C513	X#5	a_114_74##53	1.97124e-19
C514	X#6	a_114_74##53	2.59008e-19
C515	VGND#5	VGND#4	1.13178e-18
C516	X#14	a_114_74##37	3.86662e-19
C517	X#5	a_114_74##50	1.71079e-17
C518	X#11	a_114_74##26	8.36977e-20
C519	X#18	X#19	1.06279e-17
C520	VGND#11	A#4	3.78487e-20
C521	VPWR#3	a_114_74##15	5.53772e-17
C522	VGND#6	a_114_74##29	3.44562e-19
C523	VGND#10	A#4	4.18783e-20
C524	X#11	a_114_74##30	5.84274e-19
C525	X#5	a_114_74##44	1.33204e-17
C526	VGND#1	a_114_74#	3.31228e-17
C527	X#11	a_114_74##31	1.41024e-17
C528	VGND#18	a_114_74##44	2.29316e-18
C529	A#2	a_114_74##56	3.56438e-18
C530	a_114_74##15	X#21	6.18937e-18
C531	a_114_74##77	X#23	4.329e-17
C532	X#6	a_114_74##50	8.19346e-18
C533	X#11	a_114_74##37	1.28913e-17
C534	VGND#5	a_114_74##29	3.22641e-18
C535	VGND#8	a_114_74##23	1.77644e-18
C536	a_114_74##58	a_114_74##55	4.25897e-20
C537	a_114_74##23	a_114_74##20	2.39261e-17
C538	a_114_74##59	a_114_74##51	1.50462e-19
C539	VGND#8	a_114_74##25	2.12431e-18
C540	X#11	a_114_74##38	2.22733e-18
C541	X#20	X#23	1.11345e-17
C542	VPWR#3	a_114_74##17	2.34929e-18
C543	X#22	a_114_74#	1.2817e-17
C544	a_114_74##59	a_114_74##54	1.29315e-18
C545	VGND#8	a_114_74##29	9.38434e-19
C546	VPWR#5	a_114_74##15	2.34929e-18
C547	X#18	VGND#14	3.46752e-17
C548	X#11	a_114_74##42	3.96749e-19
C549	VGND#8	a_114_74##33	1.02186e-18
C550	a_114_74##59	A#7	3.69652e-18
C551	a_114_74##77	X#20	5.78481e-17
C552	VGND#6	a_114_74##33	8.45126e-18
C553	X#8	a_114_74##31	7.81588e-20
C554	VPWR#10	a_114_74##44	4.09159e-20
C555	VGND#8	a_114_74##36	1.38453e-18
C556	VGND#1	a_114_74##12	2.3359e-18
C557	a_114_74##60	A#4	2.12836e-17
C558	a_114_74##17	X#21	1.23727e-17
C559	a_114_74##58	A#4	3.55146e-18
C560	X#8	a_114_74##37	5.34263e-19
C561	VGND#8	a_114_74##41	1.1836e-18
C562	VPWR#7	a_114_74##22	1.40375e-18
C563	VPWR#5	VPWR#3	2.06267e-18
C564	VGND#8	a_114_74##45	2.20432e-18
C565	VGND#13	a_114_74#	1.33422e-18
C566	a_114_74##65	a_114_74##53	7.46295e-22
C567	X#8	a_114_74##38	1.35268e-17
C568	a_114_74##75	X#20	5.11047e-17
C569	a_114_74##58	a_114_74##56	6.14321e-18
C570	VGND#8	a_114_74##47	4.40161e-18
C571	VGND#7	a_114_74##36	3.89655e-19
C572	X#23	VPWR#2	4.75064e-17
C573	a_114_74##65	a_114_74##50	2.01551e-17
C574	VPWR#5	a_114_74##17	6.16942e-17
C575	X#8	a_114_74##42	1.03713e-17
C576	VGND#8	a_114_74##51	1.43926e-18
C577	X	a_114_74##28	1.46742e-18
C578	X#22	a_114_74##12	2.75009e-17
C579	VGND#4	VGND#3	1.13178e-18
C580	VGND#15	VGND#14	1.89091e-18
C581	a_114_74##25	a_114_74##23	3.12338e-17
C582	X#17	X#20	1.16174e-17
C583	VGND#8	a_114_74##54	2.31227e-18
C584	X#8	a_114_74##48	1.11812e-18
C585	VGND#8	A#7	1.57772e-18
C586	X#8	a_114_74##52	3.73171e-19
C587	a_114_74##75	X#17	5.5846e-17
C588	X#20	VPWR#2	4.53549e-17
C589	VGND#1	a_114_74##14	3.18276e-19
C590	VGND#9	a_114_74##41	8.67248e-20
C591	VGND#6	a_114_74##36	4.24377e-18
C592	VGND#2	a_114_74##77	2.38928e-17
C593	X#6	a_114_74##44	6.44463e-18
C594	X#5	a_114_74##38	8.20182e-20
C595	VGND#8	A#10	1.40827e-18
C596	X#16	VPWR#6	6.02266e-18
C597	VGND#19	a_114_74##50	3.33006e-18
C598	VPWR#5	a_114_74##19	5.36735e-17
C599	a_114_74##12	VGND#13	1.33086e-17
C600	X#5	a_114_74##42	5.73977e-19
C601	VGND#8	A#6	9.67353e-19
C602	a_114_74##58	A#1	2.11843e-17
C603	X#5	a_114_74##48	9.57471e-18
C604	X#17	VPWR#2	1.86907e-17
C605	VGND#2	a_114_74##75	2.49843e-17
C606	VGND#7	a_114_74##41	6.88013e-18
C607	VGND#15	X#18	3.64864e-17
C608	X#22	a_114_74##14	3.28845e-18
C609	X#5	a_114_74##52	1.05393e-17
C610	a_114_74##19	X#16	1.73576e-17
C611	VGND#21	A#4	1.27025e-18
C612	A	VPWR#19	1.9844e-20
C613	a_114_74##61	A#4	7.00788e-18
C614	a_114_74##29	a_114_74##25	2.39208e-17
C615	X#5	a_114_74##55	1.09255e-18
C616	X#19	a_114_74##12	1.22938e-18
C617	X#16	VPWR#4	6.20325e-18
C618	a_114_74##73	X#17	4.69213e-17
C619	X#5	a_114_74##56	7.07361e-19
C620	VPWR#5	a_114_74##21	2.34779e-18
C621	VPWR#14	a_114_74##26	1.79059e-18
C622	VGND#6	a_114_74##41	4.58219e-19
C623	VGND#9	a_114_74##45	2.96759e-19
C624	VPWR#7	a_114_74##19	2.3776e-18
C625	VGND#11	A	3.19246e-19
C626	a_114_74##4	a_114_74##13	4.01098e-18
C627	VPWR#14	a_114_74##30	2.112e-18
C628	VPWR#19	VPWR#17	6.99578e-19
C629	X#2	a_114_74##48	8.94653e-20
C630	VGND#13	a_114_74##14	2.97856e-17
C631	X#2	a_114_74##53	8.97581e-18
C632	X#14	X#17	1.22056e-17
C633	X#3	a_114_74##53	7.77344e-18
C634	VPWR#14	a_114_74##31	1.05722e-18
C635	X#2	a_114_74##52	6.21558e-19
C636	a_114_74##58	A#9	1.79868e-17
C637	VPWR#9	a_114_74##28	1.39766e-18
C638	X#2	a_114_74##50	1.23412e-17
C639	a_114_74##21	X#16	2.38311e-17
C640	VPWR#14	a_114_74##37	1.1395e-18
C641	VGND#2	a_114_74##73	8.49125e-18
C642	X#15	X#18	1.06279e-17
C643	VPWR#11	a_114_74##44	1.77816e-18
C644	X#2	a_114_74##55	1.03292e-17
C645	X#22	a_114_74##16	5.96399e-19
C646	X#16	VPWR#5	6.16088e-17
C647	VGND#7	a_114_74##45	5.52444e-18
C648	VPWR#14	a_114_74##38	1.43062e-18
C649	VGND#10	a_114_74##47	8.4955e-20
C650	X#13	VPWR#8	6.27102e-18
C651	X#2	a_114_74##56	1.25658e-17
C652	VPWR#14	a_114_74##42	2.02974e-18
C653	X#19	a_114_74##14	1.18737e-17
C654	VPWR#7	a_114_74##21	6.13662e-17
C655	X#2	A#1	2.34637e-18
C656	VPWR#14	a_114_74##48	1.76679e-18
C657	a_114_74##33	a_114_74##29	3.12365e-17
C658	a_114_74##73	X#14	5.73743e-17
C659	a_114_74##60	A	6.19638e-17
C660	A	a_114_74##58	6.44482e-17
C661	X#2	A#9	4.15475e-19
C662	a_114_74##59	a_114_74##56	1.03114e-18
C663	VPWR#14	a_114_74##52	3.73268e-18
C664	VGND#6	a_114_74##45	1.23551e-19
C665	a_114_74##60	X#3	1.9646e-18
C666	X#3	a_114_74##50	7.06102e-18
C667	VGND#13	a_114_74##16	1.63341e-18
C668	VGND#9	a_114_74##47	3.293e-18
C669	VGND#11	a_114_74##60	3.96513e-19
C670	a_114_74##59	A#1	2.05591e-20
C671	X#2	A#11	6.38128e-19
C672	VPWR#14	a_114_74##55	1.49214e-18
C673	A#4	a_114_74##57	2.74109e-19
C674	VPWR#7	VPWR#5	2.06267e-18
C675	a_114_74##58	A#11	3.34226e-19
C676	A#4	VPWR#20	1.83138e-18
C677	VPWR#14	a_114_74##56	5.12273e-18
C678	X#13	VPWR#6	5.95561e-18
C679	X#15	VGND#15	3.46752e-17
C680	a_114_74##71	X#14	3.32123e-17
C681	VGND#14	a_114_74##14	7.30871e-19
C682	A#4	a_114_74##62	1.44966e-18
C683	X#20	VPWR#4	3.08589e-18
C684	VPWR#14	A#1	7.19004e-19
C685	VPWR#7	a_114_74##26	5.3764e-17
C686	X#11	X#14	1.28546e-17
C687	VPWR#14	A#9	8.27752e-19
C688	VGND#7	a_114_74##47	4.93853e-19
C689	VGND#10	a_114_74##51	3.08178e-19
C690	X#19	a_114_74##16	2.74787e-17
C691	VPWR#14	A#11	1.72214e-19
C692	a_114_74##71	X#11	5.68438e-17
C693	VPWR#14	A#12	2.47835e-18
C694	a_114_74##26	X#13	1.73145e-17
C695	VPWR#7	X#16	6.00818e-17
C696	a_114_74##36	a_114_74##33	2.31135e-17
C697	VGND#13	a_114_74##18	3.18276e-19
C698	a_114_74##53	VNB	3.34067e-17
C699	a_114_74##59	a_114_74##53	1.95302e-17
C700	a_114_74##50	VNB	7.42122e-17
C701	VGND#10	a_114_74##60	6.39986e-19
C702	X#10	VPWR#10	6.27102e-18
C703	a_114_74##44	VNB	1.39658e-16
C704	a_114_74##61	A	3.74304e-17
C705	VGND#9	a_114_74##51	7.36724e-18
C706	VGND#12	A	1.01907e-17
C707	a_114_74##69	X#11	4.21928e-17
C708	a_114_74##59	a_114_74##50	2.2015e-19
C709	a_114_74##28	VNB	6.80568e-17
C710	VGND#16	VGND#15	1.89091e-18
C711	a_114_74##58	A#12	1.76726e-19
C712	VPWR#7	a_114_74##30	2.3776e-18
C713	a_114_74##16	VGND#14	1.33086e-17
C714	a_114_74##22	VNB	7.19629e-17
C715	a_114_74##8	VNB	6.76797e-17
C716	VPWR#9	a_114_74##26	2.34779e-18
C717	a_114_74##5	VNB	2.80239e-17
C718	a_114_74##2	VNB	5.48027e-17
C719	X#8	X#11	1.24496e-17
C720	VPWR#17	VPWR#15	1.17237e-18
C721	A#5	VNB	5.12779e-17
C722	A#2	VNB	3.49618e-17
C723	X#19	a_114_74##18	2.11029e-18
C724	a_114_74##69	X#8	6.12078e-17
C725	a_114_74##30	X#13	2.38557e-17
C726	VGND#7	a_114_74##51	1.47337e-19
C727	X#3	a_114_74##44	2.88e-19
C728	VGND#10	a_114_74##54	9.33582e-18
C729	X#23	a_114_74##4	1.28847e-17
C730	X#17	VPWR#14	1.57637e-18
C731	X#10	VPWR#8	6.20325e-18
C732	X#18	a_114_74##16	1.22938e-18
C733	a_114_74##77	a_114_74##4	2.33738e-17
C734	a_114_74##67	X#8	4.27341e-17
C735	X#20	a_114_74##4	2.43678e-18
C736	VPWR#9	a_114_74##30	6.31481e-17
C737	a_114_74##41	a_114_74##36	3.12652e-17
C738	VGND#16	X#15	3.64864e-17
C739	VGND#14	a_114_74##18	2.97856e-17
C740	X#5	X#8	1.17625e-17
C741	VGND#9	a_114_74##54	3.01685e-19
C742	A	a_114_74##62	5.24979e-17
C743	X	VGND#16	2.41931e-19
C744	X#2	A#2	2.88109e-18
C745	A	VPWR#21	3.39837e-17
C746	VGND#11	A#7	4.08056e-19
C747	X#17	VPWR#6	1.14927e-18
C748	a_114_74##67	X#5	5.40007e-17
C749	X#14	VPWR#14	1.74849e-17
C750	X#13	VPWR#7	6.01229e-17
C751	VPWR#2	a_114_74##4	4.20308e-20
C752	VGND#8	a_114_74##73	1.63908e-17
C753	a_114_74##28	a_114_74##22	1.47512e-17
C754	X#19	a_114_74##20	5.96399e-19
C755	VPWR#14	a_114_74##71	8.55616e-19
C756	VPWR#10	a_114_74##28	3.85811e-20
C757	VGND#2	a_114_74##4	4.88901e-20
C758	X#17	VPWR#4	1.18128e-18
C759	X#7	VPWR#12	6.74804e-18
C760	X#11	VPWR#14	1.7481e-17
C761	a_114_74##65	X#5	4.61365e-17
C762	VGND#8	a_114_74##71	2.41689e-17
C763	X#18	a_114_74##18	1.18737e-17
C764	VPWR#9	a_114_74##31	5.36735e-17
C765	VGND#10	A#7	5.49204e-18
C766	VPWR#14	a_114_74##69	9.60814e-19
C767	VGND#8	X#11	9.95263e-19
C768	X#2	X#5	1.19137e-17
C769	VPWR#14	a_114_74##53	1.50327e-22
C770	X#8	VPWR#14	1.80431e-17
C771	VGND#21	a_114_74##60	1.94697e-17
C772	X#12	X#15	1.05366e-17
C773	VGND#8	a_114_74##69	2.12965e-17
C774	VGND#10	a_114_74##53	7.55574e-20
C775	a_114_74##65	X#2	4.49239e-17
C776	VPWR#14	a_114_74##50	2.66195e-20
C777	VGND#14	a_114_74##20	1.63341e-18
C778	X	VPWR#9	2.26485e-17
C779	a_114_74##45	a_114_74##41	3.34348e-17
C780	a_114_74##53	a_114_74##50	1.07181e-17
C781	a_114_74##31	X#10	1.74282e-17
C782	VPWR#9	VPWR#7	2.06267e-18
C783	VGND#8	X#8	9.50831e-19
C784	VPWR#13	a_114_74##44	1.40429e-18
C785	VPWR#19	VNB	3.22798e-17
C786	VPWR#17	VNB	2.73258e-17
C787	X#5	VPWR#14	2.09952e-17
C788	VPWR#15	VNB	2.16343e-17
C789	VGND#9	A#7	8.35579e-20
C790	VPWR#12	VNB	2.34944e-17
C791	VGND#8	a_114_74##67	2.32781e-17
C792	X#7	VPWR#10	5.21271e-18
C793	VPWR#10	VNB	2.75249e-17
C794	VGND#15	a_114_74##18	7.30871e-19
C795	VPWR#8	VNB	2.79399e-17
C796	VPWR#6	VNB	2.78127e-17
C797	VPWR#14	a_114_74##44	5.29187e-20
C798	VGND#11	A#8	7.83414e-18
C799	VPWR#4	VNB	2.56454e-17
C800	a_114_74##59	X#2	4.42319e-17
C801	VGND#11	VNB	3.34068e-17
C802	VGND#10	VNB	3.13104e-17
C803	VPWR#2	VPWR#6	2.17636e-17
C804	VGND#9	VNB	2.09283e-17
C805	VPWR#9	a_114_74##37	2.34779e-18
C806	VGND#7	VNB	2.15688e-17
C807	VGND#6	VNB	2.93391e-17
C808	VGND#5	VNB	2.92279e-17
C809	VPWR#11	a_114_74##31	2.34779e-18
C810	VGND#4	VNB	2.92602e-17
C811	X#2	VPWR#14	1.50621e-17
C812	VGND#3	VNB	2.68164e-17
C813	VGND#8	a_114_74##65	2.10301e-17
C814	a_114_74##75	VGND#3	1.93746e-18
C815	X#18	a_114_74##20	2.75053e-17
C816	VPWR#15	VPWR#12	1.22166e-18
C817	a_114_74##59	A#5	7.10239e-19
C818	VPWR#2	VPWR#4	4.98044e-17
C819	VPWR#14	a_114_74##59	8.05918e-19
C820	a_114_74##60	VNB	1.54557e-18
C821	a_114_74##58	VNB	9.61335e-19
C822	VGND#1	VNB	5.01165e-17
C823	X#22	VNB	1.04927e-17
C824	VGND#8	a_114_74##59	1.68455e-17
C825	a_114_74##37	X#10	2.39262e-17
C826	X#12	VGND#16	2.94829e-17
C827	VGND#10	A#8	4.05047e-19
C828	VPWR#9	X#13	6.15758e-17
C829	VGND#13	VNB	9.03539e-19
C830	X#19	VNB	3.8501e-18
C831	VGND#14	VNB	8.97376e-19
C832	a_114_74##61	a_114_74##60	2.25483e-18
C833	X#18	VNB	3.89119e-18
C834	VGND#15	VNB	8.97376e-19
C835	VGND#14	a_114_74##23	3.18276e-19
C836	X#15	VNB	3.88385e-18
C837	a_114_74##59	A#2	1.71247e-17
C838	X#23	X#22	4.07814e-19
C839	VGND#16	VNB	8.97376e-19
C840	X#12	VNB	4.10024e-18
C841	VGND#17	VNB	5.16439e-19
C842	X#9	VNB	1.12268e-17
C843	VPWR#14	a_114_74##28	1.50327e-22
C844	VGND#18	VNB	2.32888e-18
C845	X#6	VNB	1.40149e-17
C846	a_114_74##47	a_114_74##45	3.21831e-17
C847	VGND#19	VNB	2.88964e-18
C848	X#3	VNB	1.18651e-17
C849	VGND#20	VNB	1.70969e-19
C850	a_114_74##20	VGND#15	1.33086e-17
C851	a_114_74##63	VNB	2.22606e-18
C852	VPWR#11	a_114_74##37	6.31481e-17
C853	VGND#21	VNB	5.45185e-19
C854	a_114_74##61	VNB	1.44777e-17
C855	VGND#12	VNB	5.48587e-17
C856	A	a_114_74##56	2.58279e-19
C857	VPWR#1	VNB	7.22911e-17
C858	a_114_74##8	a_114_74##17	4.43869e-18
C859	VPWR#3	VNB	9.03437e-19
C860	A	A#1	6.02996e-19
C861	VPWR#8	a_114_74##28	7.08047e-20
C862	VPWR#14	a_114_74##22	1.50327e-22
C863	VPWR#5	VNB	2.18882e-19
C864	A	A#9	2.04646e-18
C865	X#16	VNB	4.8175e-18
C866	VPWR#7	VNB	2.20208e-19
C867	VGND#11	A#10	6.3562e-18
C868	A	A#11	2.04678e-18
C869	X#13	VNB	4.81669e-18
C870	VPWR#9	VNB	2.19622e-19
C871	X#23	a_114_74##8	8.28893e-20
C872	X#10	VNB	4.83878e-18
C873	A	A#12	5.89699e-18
C874	X#18	a_114_74##23	2.11029e-18
C875	VPWR#11	VNB	2.19622e-19
C876	X#7	VNB	4.82504e-18
C877	VPWR#13	VNB	2.19469e-19
C878	X#4	VNB	4.8546e-18
C879	VPWR#17	VPWR#16	6.38692e-20
C880	VPWR#16	VNB	2.20378e-19
C881	X#1	VNB	4.89236e-18
C882	X	a_114_74##30	1.54178e-18
C883	VPWR#18	VNB	4.50586e-19
C884	a_114_74##57	VNB	2.1429e-18
C885	VPWR#20	VNB	2.92383e-18
C886	VGND#17	VGND#16	2.47043e-18
C887	a_114_74##62	VNB	2.19739e-18
C888	VPWR#21	VNB	7.27927e-17
C889	VGND#8	a_114_74##53	3.62318e-22
C890	X#15	a_114_74##20	1.22938e-18
C891	a_114_74#	VNB	3.40626e-17
C892	a_114_74##12	VNB	2.6093e-17
C893	a_114_74##14	VNB	2.62451e-17
C894	a_114_74##16	VNB	2.54584e-17
C895	a_114_74##18	VNB	2.6788e-17
C896	VGND#9	a_114_74##53	2.35561e-20
C897	a_114_74##20	VNB	2.46209e-17
C898	VGND#8	a_114_74##50	2.49541e-19
C899	a_114_74##77	X#22	1.76781e-17
C900	VPWR#11	a_114_74##38	5.3994e-17
C901	VGND#10	A#10	9.88639e-20
C902	a_114_74##23	VNB	2.46703e-17
C903	a_114_74##25	VNB	2.45512e-17
C904	A#2	a_114_74##53	2.55064e-17
C905	a_114_74##29	VNB	2.60056e-17
C906	a_114_74##33	VNB	2.73488e-17
C907	a_114_74##36	VNB	2.57747e-17
C908	a_114_74##41	VNB	3.1078e-17
C909	a_114_74##45	VNB	2.72484e-17
C910	a_114_74##59	A#4	1.9096e-18
C911	a_114_74##47	VNB	3.03519e-17
C912	VGND#15	a_114_74##23	2.97985e-17
C913	a_114_74##51	VNB	3.09433e-17
C914	a_114_74##54	VNB	2.98227e-17
C915	a_114_74##51	a_114_74##47	3.36798e-17
C916	A#7	VNB	2.80793e-17
C917	a_114_74##17	a_114_74##5	3.94955e-18
C918	A#8	VNB	3.03686e-17
C919	VGND#8	a_114_74##44	3.76144e-20
C920	VGND#13	a_114_74##77	1.30509e-17
C921	A#10	VNB	2.75321e-17
C922	A#6	VNB	4.24053e-17
C923	X#10	VPWR#9	6.16741e-17
C924	a_114_74##11	VNB	4.57839e-17
C925	a_114_74##38	X#7	1.70213e-17
C926	a_114_74##13	VNB	3.36473e-17
C927	a_114_74##15	VNB	2.84424e-17
C928	a_114_74##17	VNB	3.40944e-17
C929	a_114_74##19	VNB	2.96251e-17
C930	a_114_74##21	VNB	2.79835e-17
C931	a_114_74##26	VNB	2.87208e-17
C932	X#18	a_114_74##25	5.96399e-19
C933	a_114_74##30	VNB	2.79225e-17
C934	a_114_74##31	VNB	3.6272e-17
C935	a_114_74##77	X#19	2.87092e-17
C936	a_114_74##37	VNB	2.80517e-17
C937	VPWR#16	a_114_74##50	1.58977e-18
C938	a_114_74##38	VNB	3.36847e-17
C939	VGND#11	A#6	5.09877e-18
C940	a_114_74##42	VNB	2.73836e-17
C941	a_114_74##71	X	1.91176e-17
C942	A	a_114_74##59	4.46733e-17
C943	a_114_74##48	VNB	2.88527e-17
C944	VPWR#19	A#5	2.04712e-20
C945	a_114_74##52	VNB	2.82012e-17
C946	VGND#17	X#12	3.2575e-17
C947	VPWR#14	A	1.20209e-17
C948	a_114_74##55	VNB	3.05746e-17
C949	VPWR#11	a_114_74##42	2.46702e-18
C950	a_114_74##56	VNB	3.49237e-17
C951	X#23	a_114_74##2	1.14808e-17
C952	A#1	VNB	3.22118e-17
C953	VGND#8	A	1.17962e-17
C954	VPWR#13	a_114_74##38	2.28817e-18
C955	X#15	a_114_74##23	1.18737e-17
C956	A#9	VNB	3.19854e-17
C957	A#11	VNB	3.44416e-17
C958	A#12	VNB	4.04005e-17
C959	X#1	VPWR#17	6.51938e-18
C960	X#23	VNB	3.12714e-17
C961	a_114_74##77	VNB	1.46439e-17
C962	X#20	VNB	7.16898e-18
C963	a_114_74##75	VNB	7.05109e-18
C964	X#17	VNB	1.38849e-18
C965	VPWR#12	VPWR#10	1.22166e-18
C966	VPWR#2	VNB	1.81698e-16
C967	X	VPWR#14	7.01996e-18
C968	VGND#8	a_114_74##28	3.62318e-22
C969	VGND#2	VNB	1.87458e-16
C970	a_114_74##73	VNB	6.62499e-18
C971	VGND#9	a_114_74##50	4.13343e-20
C972	X#14	VNB	9.57859e-19
C973	a_114_74##71	VNB	6.23684e-18
C974	a_114_74##42	X#7	2.37327e-17
C975	VGND#15	a_114_74##25	1.63341e-18
C976	VPWR#11	VPWR#9	2.06267e-18
C977	X#11	VNB	7.42618e-19
C978	a_114_74##69	VNB	5.67381e-18
C979	X#8	VNB	7.9915e-19
C980	a_114_74##67	VNB	5.29799e-18
C981	A	A#4	3.80073e-17
C982	X#5	VNB	1.35253e-18
C983	a_114_74##65	VNB	6.79158e-18
C984	X#2	VNB	1.85306e-18
C985	a_114_74##54	a_114_74##51	3.21841e-17
C986	a_114_74##59	VNB	8.73276e-18
C987	VPWR#14	VNB	2.92577e-16
C988	VGND#8	VNB	2.87466e-16
C989	a_114_74##4	VNB	3.90488e-17
C990	VGND#16	a_114_74##23	7.30871e-19
C991	a_114_74##77	a_114_74##8	1.31167e-21
C992	VPWR#13	a_114_74##42	6.33496e-17
C993	A#4	VNB	6.89526e-17
C994	X#1	VPWR#15	6.96642e-18
C995	VGND#2	VGND#4	1.84804e-17
C996	X#9	X#12	8.68638e-18
C997	A	VNB	4.13378e-17
C998	X#14	VPWR#8	1.18586e-18
C999	VPWR#8	a_114_74##22	8.60255e-21
C1000	X#15	a_114_74##25	2.75053e-17
*
*
.ENDS sky130_fd_sc_hs__clkbuf_16
*
