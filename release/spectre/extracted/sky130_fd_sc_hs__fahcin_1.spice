* Extracted by Quantus, converted by sky130cad/quantus.py
*
*
*
*                       LINUX           Wed Nov 18 08:39:27 2026
*
*
*
*  PROGRAM  advgen
*
*  Name           : advgen - Quantus - (64-bit)
*  Version        : 25.1.0-p047
*  Build Date     : Thu Dec 11 23:20:30 PST 2025
*
*  HSPICE LIBRARY
*
*  OPERATING_TEMPERATURE 150
*  QRC_TECH_DIR <path>/tech
*
*
*

*
.SUBCKT sky130_fd_sc_hs__fahcin_1 VPB VNB VGND VPWR COUT SUM CIN B A
*
*
*  caps2d version: 10
*
*
*       TRANSISTOR CARDS
*
*
XM25 a_28_74##8 A#3 VGND#12 VNB sky130_fd_pr__nfet_01v8_lvt l=0.15 w=0.74 ad=0.2109 as=0.5219 pd=2.05 ps=3
XM8 VGND#12 a_28_74# a_256_368##6 VNB sky130_fd_pr__nfet_01v8_lvt l=0.15 w=0.64 ad=0.5219 as=0.1824 pd=3 ps=1.85
XM9 a_430_418##7 a_492_48##4 a_28_74##9 VNB sky130_fd_pr__nfet_01v8_lvt l=0.15 w=0.64 ad=0.1696 as=0.1792 pd=1.81 ps=1.84
XM4 a_28_74##9 B#6 a_608_74##15 VNB sky130_fd_pr__nfet_01v8_lvt l=0.15 w=0.64 ad=0.1792 as=0.340325 pd=1.84 ps=2.79
XM6 a_608_74##15 a_492_48# a_256_368# VNB sky130_fd_pr__nfet_01v8_lvt l=0.15 w=0.64 ad=0.340325 as=0.3264 pd=2.79 ps=2.3
XM30 a_256_368# B#10 a_430_418##12 VNB sky130_fd_pr__nfet_01v8_lvt l=0.15 w=0.64 ad=0.3264 as=0.1952 pd=2.3 ps=1.89
XM26 a_492_48##13 B#1 VGND#11 VNB sky130_fd_pr__nfet_01v8_lvt l=0.15 w=0.74 ad=0.222 as=0.3962 pd=2.08 ps=2.64
XM17 VGND#11 a_492_48##8 a_1197_368# VNB sky130_fd_pr__nfet_01v8_lvt l=0.15 w=0.64 ad=0.3962 as=0.1792 pd=2.64 ps=1.84
XM3 a_1197_368# a_430_418##3 COUT#1 VNB sky130_fd_pr__nfet_01v8_lvt l=0.15 w=0.64 ad=0.1792 as=0.9056 pd=1.84 ps=4.11
XM27 COUT#1 a_608_74##3 a_1595_400# VNB sky130_fd_pr__nfet_01v8_lvt l=0.15 w=0.64 ad=0.9056 as=0.224 pd=4.11 ps=1.98
XM18 a_1595_400# CIN#7 VGND#10 VNB sky130_fd_pr__nfet_01v8_lvt l=0.15 w=0.64 ad=0.224 as=0.4744 pd=1.98 ps=3.3
XM31 VGND#10 CIN#1 a_1854_368##9 VNB sky130_fd_pr__nfet_01v8_lvt l=0.15 w=0.74 ad=0.4744 as=0.233 pd=3.3 ps=2.13
XM5 a_1854_368##9 a_608_74##6 a_2004_136##5 VNB sky130_fd_pr__nfet_01v8_lvt l=0.15 w=0.64 ad=0.233 as=0.5088 pd=2.13 ps=2.87
XM23 a_2004_136##5 a_430_418##4 a_1967_384##5 VNB sky130_fd_pr__nfet_01v8_lvt l=0.15 w=0.64 ad=0.5088 as=0.2808 pd=2.87 ps=2.29
XM12 a_1967_384##5 a_1854_368##3 VGND#9 VNB sky130_fd_pr__nfet_01v8_lvt l=0.15 w=0.64 ad=0.2808 as=0.5965 pd=2.29 ps=3.18
XM14 VGND#9 a_2004_136# SUM#3 VNB sky130_fd_pr__nfet_01v8_lvt l=0.15 w=0.74 ad=0.5965 as=0.2109 pd=3.18 ps=2.05
XM16 a_28_74##10 A#4 VPWR#13 VPB sky130_fd_pr__pfet_01v8 l=0.15 w=1.12 ad=0.3304 as=0.5754 pd=2.83 ps=3.32
XM11 VPWR#13 a_28_74##3 a_256_368##5 VPB sky130_fd_pr__pfet_01v8 l=0.15 w=1 ad=0.5754 as=0.295 pd=3.32 ps=2.59
XM24 a_430_418##9 a_492_48##7 a_256_368##2 VPB sky130_fd_pr__pfet_01v8 l=0.15 w=0.84 ad=0.273 as=0.2856 pd=2.33 ps=2.36
XM7 a_256_368##2 B#11 a_608_74##12 VPB sky130_fd_pr__pfet_01v8 l=0.15 w=0.84 ad=0.2856 as=0.357525 pd=2.36 ps=2.84
XM13 a_608_74##12 a_492_48##5 a_28_74##4 VPB sky130_fd_pr__pfet_01v8 l=0.15 w=0.84 ad=0.357525 as=0.4746 pd=2.84 ps=2.81
XM28 a_28_74##4 B#9 a_430_418##11 VPB sky130_fd_pr__pfet_01v8 l=0.15 w=0.84 ad=0.4746 as=0.2604 pd=2.81 ps=2.3
XM1 a_492_48##11 B#7 VPWR#12 VPB sky130_fd_pr__pfet_01v8 l=0.15 w=1.12 ad=0.3304 as=0.454 pd=2.83 ps=3.07
XM10 VPWR#12 a_492_48##10 a_1197_368##2 VPB sky130_fd_pr__pfet_01v8 l=0.15 w=1 ad=0.454 as=0.4126 pd=3.07 ps=2.87
XM29 a_1197_368##2 a_608_74# COUT#3 VPB sky130_fd_pr__pfet_01v8 l=0.15 w=0.84 ad=0.4126 as=1.0542 pd=2.87 ps=4.19
XM0 COUT#3 a_430_418# a_1595_400##2 VPB sky130_fd_pr__pfet_01v8 l=0.15 w=0.84 ad=1.0542 as=0.4256 pd=4.19 ps=2.88
XM15 a_1595_400##2 CIN#5 VPWR#10 VPB sky130_fd_pr__pfet_01v8 l=0.15 w=1 ad=0.4256 as=0.5904 pd=2.88 ps=3.35
XM21 VPWR#10 CIN#6 a_1854_368##8 VPB sky130_fd_pr__pfet_01v8 l=0.15 w=1.12 ad=0.5904 as=0.3304 pd=3.35 ps=2.83
XM2 a_1967_384# a_608_74##7 a_2004_136##7 VPB sky130_fd_pr__pfet_01v8 l=0.15 w=0.84 ad=0.2478 as=0.252 pd=2.27 ps=2.28
XM19 a_2004_136##7 a_430_418##6 a_1854_368##5 VPB sky130_fd_pr__pfet_01v8 l=0.15 w=0.84 ad=0.252 as=0.43155 pd=2.28 ps=3.07
XM20 a_1967_384##3 a_1854_368# VPWR#9 VPB sky130_fd_pr__pfet_01v8 l=0.15 w=1 ad=0.295 as=0.5654 pd=2.59 ps=3.3
XM22 VPWR#9 a_2004_136##3 SUM#1 VPB sky130_fd_pr__pfet_01v8 l=0.15 w=1.12 ad=0.5654 as=0.3304 pd=3.3 ps=2.83
*
*
*       RESISTOR AND CAP/DIODE CARDS
*
Rg1	A#1	A#2	20.770033
Rg2	A#2	A#3	397.555725
Rg3	A#2	A#4	449.655212
Rg4	a_28_74#	a_28_74##2	352.006958
Rg5	a_28_74##2	a_28_74##3	439.378967
Rg6	a_492_48#	a_492_48##2	326.004944
Rg7	a_492_48##2	a_492_48##3	214.493408
Rg8	a_492_48##3	a_492_48##4	437.092743
Rg9	a_492_48##2	a_492_48##5	382.970520
Rg10	a_492_48##2	a_492_48##6	45.214165
Rg11	a_492_48##3	a_492_48##7	479.091248
Rg12	B#1	B#2	322.953644
Rg13	B#2	B#3	42.409290
Rg14	B#3	B#4	40.088982
Rg15	B#4	B#5	901.628418
Rg16	B#5	B#6	989.684021
Rg17	B#2	B#7	491.849670
Rg18	B#4	B#8	1188.353027
Rg19	B#8	B#9	404.430542
Rg20	B#5	B#10	386.082367
Rg21	B#8	B#11	989.382690
Rg22	a_492_48##8	a_492_48##9	366.873840
Rg23	a_492_48##9	a_492_48##10	437.304504
Rg24	a_608_74#	a_608_74##2	350.619171
Rg25	a_430_418#	a_430_418##2	573.264526
Rg26	a_430_418##2	a_430_418##3	699.551819
Rg27	a_608_74##3	a_608_74##4	300.067566
Rg28	CIN#1	CIN#2	380.449188
Rg29	CIN#2	CIN#3	126.511124
Rg30	CIN#3	CIN#4	39.299274
Rg31	CIN#4	CIN#5	474.791901
Rg32	CIN#2	CIN#6	465.195099
Rg33	CIN#4	CIN#7	306.792053
Rg34	a_608_74##5	a_608_74##6	334.376526
Rg35	a_608_74##6	a_608_74##7	760.149841
Rg36	a_430_418##4	a_430_418##5	297.761749
Rg37	a_430_418##5	a_430_418##6	381.509155
Rg38	a_1854_368#	a_1854_368##2	417.171356
Rg39	a_1854_368##2	a_1854_368##3	322.564178
Rg40	a_2004_136#	a_2004_136##2	299.574615
Rg41	a_2004_136##2	a_2004_136##3	426.276154
Rf1	A	A#1	166.907288
Rf2	a_430_418##7	a_430_418##8	77.202827
Rf3	a_430_418##8	a_430_418##9	24.045429
Rf4	a_28_74##4	a_28_74##5	336.226166
Rf5	a_28_74##5	a_28_74##6	14.770389
Rf6	a_28_74##6	a_28_74##7	47.031349
Rf7	a_28_74##7	a_28_74##8	21.722044
Rf8	a_28_74##6	a_28_74##9	178.927597
Rf9	a_28_74##7	a_28_74##10	70.539551
Rf10	a_256_368#	a_256_368##3	234.307068
Rf11	a_256_368##3	a_256_368##4	86.263023
Rf12	a_256_368##4	a_256_368##5	12.377458
Rf13	a_256_368##4	a_256_368##6	76.487686
Rf14	a_256_368##2	a_256_368##3	7.500000
Rf15	a_430_418##10	a_430_418##11	20.815231
Rf16	a_430_418##10	a_430_418##12	71.777328
Rf17	B	B#3	165.153717
Rf18	a_492_48##11	a_492_48##12	76.743164
Rf19	a_492_48##12	a_492_48##14	68.542274
Rf20	a_492_48##14	a_492_48##6	332.016113
Rf21	a_492_48##13	a_492_48##14	7.500000
Rf22	a_1197_368#	a_1197_368##2	105.998840
Rf23	a_430_418##13	a_430_418##2	111.701523
Rf24	COUT	COUT#2	2.491451
Rf25	COUT#2	COUT#3	124.489639
Rf26	COUT#1	COUT#2	1.875000
Rf27	a_1595_400#	a_1595_400##2	111.072433
Rf28	CIN	CIN#3	161.216980
Rf29	a_608_74##5	a_608_74##9	390.644135
Rf30	a_608_74##9	a_608_74##10	111.664871
Rf31	a_608_74##10	a_608_74##11	294.819031
Rf32	a_608_74##11	a_608_74##12	20.868904
Rf33	a_608_74##9	a_608_74##4	272.388855
Rf34	a_608_74##10	a_608_74##2	212.928909
Rf35	a_608_74##11	a_608_74##15	80.103523
Rf36	a_430_418##15	a_430_418##5	177.554398
Rf37	a_1967_384##2	a_1967_384##4	102.137352
Rf38	a_1967_384##4	a_1967_384##5	82.781097
Rf39	a_1967_384#	a_1967_384##2	7.500000
Rf40	a_1967_384##3	a_1967_384##4	7.500000
Rf41	a_1854_368##2	a_1854_368##6	327.378784
Rf42	a_1854_368##6	a_1854_368##7	101.869209
Rf43	a_1854_368##7	a_1854_368##8	8.133781
Rf44	a_1854_368##7	a_1854_368##9	79.481445
Rf45	a_1854_368##5	a_1854_368##6	15.000000
Rf46	a_2004_136##2	a_2004_136##6	358.428589
Rf47	a_2004_136##6	a_2004_136##7	66.734009
Rf48	a_2004_136##5	a_2004_136##6	3.750000
Rf49	SUM	SUM#2	0.255814
Rf50	SUM#2	SUM	18.674389
Rf51	SUM	SUM#4	2.430228
Rf52	SUM#4	SUM	12.695945
Rf53	SUM#1	SUM#2	5.000000
Rf54	SUM#3	SUM#4	7.500000
Rf56	VPWR#2	VPWR#3	177.545517
Rf57	VPWR#3	VPWR#4	63.651974
Rf58	VPWR#4	VPWR#5	247.333557
Rf59	VPWR#5	VPWR#6	162.496948
Rf60	VPWR#6	VPWR#7	194.347137
Rf62	VPWR#2	VPWR#9	47.492367
Rf63	VPWR#4	VPWR#11	32.494125
Rf64	VPWR#11	VPWR#10	62.848076
Rf65	VPWR#5	VPWR#12	30.599850
Rf66	VPWR#7	VPWR#13	44.934231
Rf67	VPWR#10	VPWR#11	15.000000
Rf69	VGND#2	VGND#3	167.590179
Rf70	VGND#3	VGND#4	70.463509
Rf71	VGND#4	VGND#5	230.564774
Rf72	VGND#5	VGND#6	172.154602
Rf73	VGND#6	VGND#7	188.080490
Rf75	VGND#2	VGND#9	32.521637
Rf76	VGND#4	VGND#10	31.818075
Rf77	VGND#5	VGND#11	27.182310
Rf78	VGND#7	VGND#12	38.247387
Rf80	a_28_74##2	a_28_74##5	160.232803
Rf82	a_492_48##9	a_492_48##12	160.232803
Re1	a_430_418##15	a_430_418##13	15.344948
Re2	a_430_418##13	a_430_418##19	4.743838
Re3	a_430_418##19	a_430_418##8	13.698293
Re4	VPWR#3	VPWR	2.042809
Re5	VPWR	VPWR#6	1.896894
Re6	VGND#3	VGND	2.042809
Re7	VGND	VGND#6	1.896894
Re10	a_430_418##10	a_430_418##19	9.777782
*
*       CAPACITOR CARDS
*
*
C1	VPWR#4	CIN#6	8.18107e-18
C2	a_492_48##4	a_492_48#	2.77393e-19
C3	VPWR#10	a_1854_368##8	7.65039e-17
C4	a_430_418##7	a_256_368##2	1.98294e-17
C5	a_1854_368##9	a_608_74##6	4.73199e-17
C6	B#9	a_28_74##4	2.87977e-17
C7	a_430_418##10	VGND#11	5.77016e-18
C8	CIN#2	a_608_74##6	2.8197e-19
C9	VPWR#5	a_608_74##2	3.35336e-20
C10	VGND#4	a_608_74##9	4.98323e-19
C11	a_2004_136##5	CIN#1	9.09645e-19
C12	a_430_418##15	VPWR#9	1.1615e-18
C13	a_492_48##4	B#6	4.265e-17
C14	a_430_418##10	a_492_48##13	1.07146e-17
C15	a_608_74##12	B#9	7.68779e-19
C16	a_1595_400#	VGND#10	6.01098e-17
C17	a_430_418##8	a_492_48##3	1.3544e-17
C18	a_430_418##10	a_430_418##12	4.45424e-19
C19	a_430_418##15	a_1967_384##3	6.61162e-17
C20	a_1854_368##8	CIN#2	5.60892e-19
C21	a_492_48##5	a_28_74##4	1.81113e-17
C22	a_430_418##8	a_492_48##2	1.93546e-18
C23	CIN#1	a_1854_368##9	3.43786e-17
C24	a_430_418##10	a_256_368#	6.09884e-18
C25	a_430_418##15	a_1854_368##5	7.85508e-18
C26	VPWR#4	CIN#5	3.18958e-18
C27	a_2004_136##2	SUM#3	2.3378e-17
C28	a_28_74##6	a_28_74##9	1.33998e-18
C29	a_608_74##12	a_492_48##5	4.34618e-17
C30	VPWR#6	B#8	1.71129e-17
C31	a_2004_136##5	CIN#7	3.06811e-20
C32	a_430_418##10	a_608_74##15	5.31944e-20
C33	a_2004_136##2	VGND#9	1.01164e-16
C34	a_430_418##15	a_2004_136##7	6.20544e-17
C35	a_28_74#	a_492_48##4	3.81061e-18
C36	CIN#4	CIN#1	8.38183e-18
C37	a_28_74##4	B#11	3.13746e-17
C38	VPWR#5	a_492_48##9	9.08561e-20
C39	CIN#1	VGND#10	1.53649e-17
C40	a_256_368##2	a_492_48##5	1.1982e-18
C41	a_256_368##5	a_430_418##7	5.39266e-19
C42	a_1967_384##5	a_2004_136##2	4.98047e-17
C43	a_430_418##15	a_1967_384#	3.38965e-17
C44	B#11	a_608_74##12	1.57946e-17
C45	VPWR#10	CIN#4	1.46359e-18
C46	a_430_418##8	a_256_368#	7.67425e-19
C47	A#3	a_492_48##4	1.05865e-19
C48	a_2004_136##5	a_2004_136##2	2.32104e-18
C49	a_430_418##15	a_1854_368##8	5.71556e-17
C50	a_1595_400#	CIN#1	7.89255e-19
C51	a_28_74##4	a_492_48##7	1.26318e-17
C52	a_430_418##8	a_608_74##15	1.23805e-18
C53	a_256_368##2	B#11	4.65989e-17
C54	a_256_368##6	a_256_368##5	1.70621e-18
C55	VPWR#3	a_1967_384##3	1.46236e-17
C56	a_608_74##4	a_608_74##9	1.45659e-18
C57	VPWR#4	a_430_418#	3.19737e-18
C58	a_1854_368##2	VGND#9	4.21321e-18
C59	VPWR#6	a_492_48##3	3.62238e-20
C60	A#3	a_28_74#	6.26485e-18
C61	CIN#7	VGND#10	1.80509e-17
C62	VGND#6	a_1197_368#	1.64214e-17
C63	a_28_74##9	a_430_418##8	8.12599e-18
C64	a_1967_384##5	a_1854_368##2	4.16879e-17
C65	a_1854_368##5	VPWR#3	1.11441e-16
C66	VPWR#6	a_492_48##2	6.1874e-19
C67	VGND#6	VGND#11	1.39776e-19
C68	a_2004_136##5	a_1854_368##2	2.02817e-18
C69	a_256_368##2	a_492_48##7	3.29517e-17
C70	a_608_74##9	a_1854_368##8	6.61569e-19
C71	VPWR#3	a_2004_136##7	2.06084e-18
C72	a_256_368##5	B#11	1.97254e-19
C73	VPWR#6	A#2	6.3935e-19
C74	a_1595_400#	CIN#7	4.39418e-17
C75	VGND#6	a_492_48##13	7.19578e-17
C76	VGND#3	a_1967_384##3	1.41217e-18
C77	a_28_74##6	a_256_368##6	5.76967e-17
C78	VPWR#5	a_608_74#	3.1698e-18
C79	a_608_74##10	a_430_418##2	1.47132e-19
C80	a_430_418##13	VPWR#10	2.29788e-17
C81	a_28_74##7	VGND#12	1.00264e-17
C82	VPWR#3	a_1967_384#	1.16046e-17
C83	a_492_48##7	a_430_418##9	2.99512e-17
C84	VGND#6	a_430_418##12	9.16385e-18
C85	VGND#6	B#5	3.33015e-17
C86	VGND#10	a_608_74##3	1.61419e-18
C87	a_608_74##9	a_430_418##2	1.67635e-18
C88	a_430_418##13	a_1595_400##2	4.08118e-17
C89	a_430_418##5	a_1967_384##5	3.27382e-17
C90	a_256_368##2	a_28_74##3	3.36834e-19
C91	VGND#6	a_256_368#	1.11229e-16
C92	a_1854_368##8	VPWR#3	1.07489e-16
C93	VGND#6	B#4	1.19213e-18
C94	a_256_368##5	a_492_48##7	1.57415e-18
C95	a_1595_400##2	CIN#4	1.74583e-18
C96	a_430_418##5	a_2004_136##5	5.63283e-17
C97	a_430_418##13	COUT#3	1.22599e-16
C98	VGND#6	a_608_74##15	7.68944e-18
C99	a_1595_400#	a_608_74##3	1.43865e-17
C100	a_608_74##9	VPWR#10	1.00099e-16
C101	VGND#3	a_1967_384#	3.06789e-18
C102	VPWR#13	a_492_48##7	6.98689e-20
C103	a_28_74##6	VGND#12	8.02622e-17
C104	VGND#6	a_28_74##9	9.68192e-17
C105	a_1197_368#	CIN#7	3.26599e-19
C106	a_430_418##13	a_1197_368##2	3.17087e-17
C107	VGND#6	a_492_48##3	3.80458e-19
C108	a_608_74##5	VGND#9	9.18102e-19
C109	a_608_74##2	a_608_74##10	1.18299e-18
C110	a_28_74##7	a_28_74##8	7.89715e-19
C111	VPWR#3	a_1595_400##2	6.84604e-18
C112	a_28_74##3	a_256_368##5	2.32372e-17
C113	a_608_74##11	VPWR#5	1.01663e-17
C114	VPWR#5	a_492_48##10	6.55652e-18
C115	VGND#6	a_430_418##7	8.94705e-18
C116	VGND#6	a_492_48##2	2.50924e-18
C117	a_608_74##3	COUT#1	2.3613e-17
C118	a_492_48##2	B#8	1.67651e-18
C119	VPWR#3	COUT#3	1.27897e-17
C120	a_28_74##3	VPWR#13	3.97079e-17
C121	a_608_74##5	a_2004_136##5	1.01704e-16
C122	VGND#6	a_256_368##6	1.04622e-17
C123	a_1595_400#	a_430_418##3	7.02592e-19
C124	a_608_74##5	a_1854_368##9	1.0831e-16
C125	VGND#3	a_1595_400##2	1.4952e-18
C126	a_28_74##10	a_28_74##3	8.46051e-19
C127	a_28_74##8	a_28_74##6	2.98888e-18
C128	a_608_74##9	a_1595_400##2	1.67224e-16
C129	a_1197_368#	a_608_74##3	6.87543e-19
C130	a_608_74##5	VGND#10	8.01434e-17
C131	a_492_48##9	a_608_74##10	9.58007e-18
C132	VPWR#13	A#4	5.57371e-17
C133	VGND#6	a_28_74##8	1.92707e-17
C134	a_1854_368#	a_2004_136##3	1.84044e-17
C135	a_430_418##3	COUT#1	3.15771e-18
C136	a_608_74##10	COUT#3	7.67689e-17
C137	a_1595_400#	a_608_74##5	5.49272e-18
C138	a_608_74##10	VPWR#5	1.07649e-16
C139	VPWR#5	B#7	3.74526e-18
C140	a_28_74##6	a_492_48##4	4.31355e-19
C141	VGND#11	a_608_74##3	7.58985e-19
C142	a_28_74##10	A#4	3.05644e-17
C143	VGND#11	a_1197_368#	3.08998e-17
C144	a_1197_368#	a_430_418##3	4.26059e-17
C145	a_608_74##9	COUT#3	8.46059e-17
C146	B#5	a_492_48##2	1.65506e-18
C147	a_430_418##10	a_1197_368##2	8.13962e-18
C148	a_430_418##6	a_1854_368#	4.79867e-18
C149	a_492_48##11	a_1197_368##2	2.18222e-18
C150	a_608_74##10	a_1197_368##2	5.61852e-17
C151	VGND#11	a_430_418##3	1.8953e-18
C152	a_28_74##6	a_28_74#	3.29435e-17
C153	a_2004_136##2	VPWR#9	3.15341e-17
C154	a_608_74##9	VPWR#5	2.03354e-17
C155	a_492_48##13	a_1197_368#	2.80868e-18
C156	a_1197_368#	a_492_48##8	3.46058e-17
C157	a_608_74##9	a_608_74##7	3.1674e-20
C158	B#10	B#9	7.13946e-18
C159	a_430_418##10	a_492_48##11	5.96317e-17
C160	a_28_74##7	A#3	2.497e-17
C161	a_492_48##11	VPWR#12	1.32775e-18
C162	a_430_418##11	a_1197_368##2	1.332e-19
C163	a_608_74##11	a_492_48##6	5.7378e-17
C164	a_430_418##10	a_430_418##11	9.11521e-18
C165	a_608_74##7	a_430_418##6	3.90132e-17
C166	a_608_74##4	a_1595_400#	4.64429e-17
C167	a_492_48##8	VGND#11	2.05701e-17
C168	a_1854_368##2	VPWR#9	8.07389e-17
C169	a_608_74##4	COUT#1	3.24054e-18
C170	a_28_74##6	A#3	3.03755e-18
C171	a_430_418##10	a_28_74##4	1.06405e-17
C172	a_608_74##10	VPWR#12	7.42885e-17
C173	a_492_48##13	VGND#11	4.71943e-17
C174	a_1197_368#	B#1	1.22376e-18
C175	a_1854_368##2	a_1967_384##3	9.4822e-17
C176	VPWR#6	a_1197_368##2	3.59212e-18
C177	a_608_74##9	VPWR#4	1.0517e-16
C178	a_430_418##10	a_608_74##12	1.16382e-17
C179	a_492_48##13	a_492_48##8	9.49645e-19
C180	a_608_74##9	CIN#6	2.8488e-18
C181	a_1854_368##2	a_1854_368##5	1.92922e-18
C182	VPWR#6	VPWR#12	3.77809e-18
C183	a_492_48##2	B#4	3.94674e-18
C184	CIN#6	a_608_74##7	6.77714e-18
C185	a_430_418##8	a_28_74##4	6.41118e-18
C186	B#1	VGND#11	2.5746e-17
C187	a_430_418##15	a_608_74##6	8.38288e-19
C188	VPWR#6	a_492_48##11	3.21714e-18
C189	a_430_418##2	COUT#1	1.05287e-18
C190	VGND#6	a_1197_368##2	1.62764e-18
C191	a_430_418##12	a_492_48##8	1.08413e-19
C192	a_430_418##11	a_492_48##11	3.36746e-18
C193	a_430_418##5	a_1967_384##3	9.84539e-18
C194	a_492_48##13	B#5	3.95186e-17
C195	a_430_418##8	a_608_74##12	1.1368e-17
C196	VGND#4	CIN#1	3.25764e-19
C197	a_1197_368#	a_430_418##2	1.00948e-19
C198	VPWR#6	a_430_418##11	7.0146e-18
C199	a_430_418##15	CIN#1	1.71074e-18
C200	a_608_74##10	a_492_48##11	4.45492e-17
C201	a_430_418##5	a_1854_368##5	1.48229e-18
C202	a_492_48##13	B#1	5.73432e-17
C203	a_430_418##8	a_256_368##2	1.288e-16
C204	a_28_74##4	VPWR#6	1.99276e-16
C205	a_2004_136##7	a_430_418##5	1.98671e-17
C206	VGND#6	a_492_48##11	4.94433e-18
C207	a_608_74##9	CIN#5	4.44233e-17
C208	a_608_74##11	a_430_418##11	5.95458e-17
C209	CIN#5	CIN#6	1.81167e-17
C210	VGND#3	a_2004_136#	6.69847e-18
C211	VPWR#6	a_608_74##12	3.54302e-18
C212	B#8	B#7	2.0265e-17
C213	a_430_418##12	B#1	9.70241e-19
C214	a_492_48##13	a_430_418##12	4.23467e-17
C215	B#4	a_492_48##13	1.64147e-17
C216	a_256_368##5	a_430_418##8	9.94461e-17
C217	VPWR#3	a_608_74##6	6.69394e-20
C218	a_1197_368#	a_608_74##2	3.77038e-18
C219	VPWR#6	a_256_368##2	9.60791e-18
C220	a_608_74##10	a_430_418#	9.56967e-19
C221	a_492_48##13	B#10	9.54951e-18
C222	a_430_418##11	a_608_74##10	5.18985e-17
C223	a_430_418##8	VPWR#13	1.96483e-18
C224	VGND#3	a_430_418##4	1.29928e-18
C225	VPWR#3	CIN#1	6.85632e-20
C226	VGND#4	CIN#7	6.99396e-18
C227	a_608_74##5	CIN#4	4.6403e-18
C228	a_430_418#	CIN#5	2.83637e-17
C229	a_608_74##5	a_1967_384#	4.83387e-18
C230	B#4	B#7	2.68048e-17
C231	a_430_418##8	a_28_74##10	7.22354e-19
C232	VGND#3	a_608_74##6	5.08653e-19
C233	a_608_74##5	CIN#2	1.85324e-17
C234	VPWR#6	a_256_368##5	1.72709e-17
C235	a_608_74##9	a_430_418#	2.21989e-17
C236	a_608_74##11	a_28_74##4	1.01749e-16
C237	VGND#6	a_256_368##2	3.58509e-18
C238	a_1197_368##2	B#4	6.79502e-20
C239	B#10	a_430_418##12	1.80888e-17
C240	a_430_418##13	a_430_418##3	8.2671e-19
C241	a_256_368#	a_492_48##13	2.8047e-17
C242	a_608_74##5	a_1854_368##8	3.94003e-17
C243	a_430_418##12	B#5	4.62552e-18
C244	a_1197_368#	a_492_48##9	4.04321e-17
C245	VGND#3	CIN#1	4.88827e-18
C246	a_492_48##13	a_492_48#	2.56494e-19
C247	a_608_74##5	VPWR#10	1.48238e-17
C248	a_492_48##9	VGND#11	3.01491e-17
C249	VPWR#12	B#8	2.60513e-18
C250	VPWR#6	a_28_74##10	1.81552e-17
C251	VGND#3	CIN#7	9.02972e-18
C252	VGND#6	a_256_368##5	2.30734e-18
C253	a_608_74##10	a_608_74#	2.83421e-17
C254	B#10	a_256_368#	2.22648e-17
C255	a_28_74##7	a_28_74##2	3.00277e-18
C256	a_1595_400##2	a_608_74##5	7.7059e-19
C257	a_492_48##13	a_492_48##9	2.25791e-19
C258	a_608_74#	a_430_418#	2.76128e-18
C259	a_28_74##6	a_28_74##2	3.48138e-18
C260	a_430_418##12	a_492_48##9	1.68027e-18
C261	VGND#3	a_608_74##3	1.10546e-17
C262	B#9	B#8	1.31925e-17
C263	VGND#4	a_608_74##3	4.98599e-18
C264	a_608_74##9	a_608_74#	7.37955e-19
C265	a_430_418##12	B#4	1.4641e-17
C266	a_608_74##11	a_608_74##12	4.72836e-18
C267	a_28_74##4	a_608_74##12	8.22414e-17
C268	a_608_74##15	B#10	7.51368e-19
C269	a_2004_136##7	a_608_74##6	5.57275e-19
C270	a_492_48##13	B#6	1.02739e-19
C271	a_256_368#	a_492_48#	3.93467e-17
C272	a_492_48##3	a_492_48##2	6.94062e-19
C273	a_492_48##10	a_608_74#	2.27082e-17
C274	VGND#5	a_430_418##3	7.18691e-18
C275	a_608_74##10	a_492_48##10	3.73503e-17
C276	a_1967_384##5	a_1967_384##3	5.27382e-18
C277	B#9	B#4	2.23066e-17
C278	a_28_74##4	a_256_368##2	6.45994e-17
C279	a_1967_384#	a_608_74##6	5.4096e-18
C280	a_492_48#	a_608_74##15	1.36184e-17
C281	a_256_368#	B#5	1.14912e-17
C282	a_2004_136##2	a_2004_136#	9.8556e-18
C283	a_608_74##4	a_1595_400##2	5.03107e-17
C284	B#5	B#1	1.0811e-17
C285	a_256_368##2	a_608_74##11	3.10791e-17
C286	a_256_368#	B#6	2.62576e-17
C287	a_608_74##4	COUT#3	1.97272e-18
C288	a_1854_368##3	a_2004_136##2	1.27342e-17
C289	B#7	a_492_48##10	2.98125e-17
C290	a_1854_368##8	a_608_74##6	7.95011e-19
C291	a_492_48##6	a_492_48##13	3.0344e-18
C292	a_256_368##2	a_608_74##12	4.54155e-17
C293	a_28_74##4	a_430_418##9	8.24991e-19
C294	a_2004_136##5	a_1967_384##3	1.5821e-18
C295	VPWR#4	CIN#1	8.4903e-21
C296	a_492_48##6	a_430_418##12	6.53916e-17
C297	a_2004_136##2	a_430_418##4	5.93384e-19
C298	a_256_368#	a_608_74##15	8.68094e-17
C299	B#4	B#1	1.88538e-17
C300	a_430_418##10	B#10	1.17809e-18
C301	a_492_48##5	B#8	4.814e-18
C302	a_608_74##10	B#7	2.76488e-17
C303	a_492_48##6	a_256_368#	7.27852e-17
C304	B#6	a_608_74##15	2.03685e-17
C305	a_1595_400##2	a_430_418##2	2.07324e-19
C306	a_492_48##2	B#9	2.86148e-18
C307	VGND#5	a_492_48##8	2.76637e-18
C308	a_608_74##15	a_492_48##6	2.38702e-17
C309	a_430_418##7	a_492_48#	1.41744e-19
C310	a_430_418##2	COUT#3	1.18596e-17
C311	a_256_368##5	a_28_74##4	2.18311e-17
C312	a_256_368#	a_492_48##4	1.73391e-18
C313	a_1854_368##8	CIN#1	6.40312e-19
C314	a_430_418##4	a_1854_368##2	1.67826e-18
C315	a_1197_368##2	a_430_418##2	4.17648e-19
C316	a_430_418##15	a_1854_368#	3.79496e-19
C317	B#6	a_28_74##9	1.51918e-17
C318	a_608_74##4	CIN#4	2.83052e-17
C319	a_608_74##11	B#9	3.41808e-17
C320	VGND#6	a_430_418##3	1.05002e-17
C321	a_28_74##9	a_256_368#	4.46632e-17
C322	a_430_418##12	a_492_48##2	1.22827e-19
C323	a_430_418##15	a_430_418##6	9.2035e-18
C324	a_608_74##15	a_492_48##4	5.0579e-20
C325	a_492_48##11	B#4	1.30768e-17
C326	a_256_368##2	a_430_418##9	1.82211e-18
C327	VGND#6	a_492_48##8	9.1128e-18
C328	a_608_74##2	COUT#3	3.63666e-17
C329	a_608_74##10	B#9	1.0562e-18
C330	a_430_418##8	B#6	1.68273e-18
C331	a_430_418##7	B#6	1.4978e-18
C332	VPWR#3	a_2004_136##3	5.27138e-18
C333	a_608_74##5	a_2004_136#	4.5257e-19
C334	B#10	B#5	5.24211e-18
C335	a_430_418##15	a_608_74##7	1.60289e-18
C336	a_492_48##5	B#9	1.65671e-17
C337	a_256_368#	a_28_74#	4.75605e-20
C338	a_1197_368##2	a_608_74##2	5.70766e-17
C339	VGND#6	B#1	3.51861e-18
C340	a_430_418##11	B#8	7.14982e-18
C341	a_608_74##6	a_430_418##5	1.44315e-17
C342	a_28_74##9	a_492_48##4	5.01006e-17
C343	a_608_74##5	a_1854_368##3	1.39177e-18
C344	a_430_418##7	a_28_74##2	3.25137e-19
C345	VGND#5	B#1	2.04555e-18
C346	a_492_48##3	a_492_48##5	6.37914e-19
C347	VGND#6	B#10	1.84451e-18
C348	a_430_418##15	CIN#6	4.87242e-18
C349	VGND#4	CIN#4	1.25618e-19
C350	a_430_418##7	a_256_368#	2.34085e-18
C351	B#11	B#9	1.68886e-19
C352	a_256_368##5	a_256_368##2	2.3976e-18
C353	a_28_74##2	a_256_368##6	1.65463e-17
C354	a_608_74##5	a_430_418##4	1.07563e-17
C355	B#10	B#4	2.5871e-17
C356	a_608_74##11	a_492_48##5	2.22112e-17
C357	B#11	B#8	4.94262e-19
C358	VPWR#3	a_430_418##6	1.23067e-18
C359	a_28_74##2	VGND#12	5.45668e-20
C360	VGND#6	a_492_48#	1.69821e-18
C361	a_492_48##4	a_430_418##7	2.06112e-17
C362	a_608_74##5	a_608_74##6	3.27315e-18
C363	a_1197_368##2	a_492_48##9	5.19831e-17
C364	B#11	a_492_48##5	3.26827e-17
C365	VGND#6	B#6	2.56637e-17
C366	VPWR#3	a_608_74##7	1.23688e-18
C367	a_492_48##9	VPWR#12	2.10688e-18
C368	a_608_74##5	CIN#1	4.7267e-17
C369	a_28_74##9	a_28_74#	4.28438e-19
C370	a_256_368##5	a_430_418##9	8.1736e-19
C371	a_430_418##13	CIN#5	2.60251e-18
C372	a_492_48##7	a_492_48##5	5.24423e-19
C373	VGND#6	a_492_48##4	7.46798e-18
C374	a_430_418##2	CIN#4	1.64121e-18
C375	a_256_368##6	a_492_48##4	2.33788e-18
C376	CIN#7	a_608_74##5	2.41879e-18
C377	VPWR#3	CIN#6	2.25214e-18
C378	a_2004_136##5	a_1967_384#	1.46018e-18
C379	a_256_368#	a_492_48##2	4.98815e-18
C380	a_430_418##13	a_430_418#	2.48735e-18
C381	A	A#2	1.62348e-17
C382	VGND#6	a_28_74#	1.0518e-18
C383	a_430_418##11	B#4	4.8828e-18
C384	a_430_418##7	a_28_74#	1.03758e-18
C385	a_492_48##7	B#11	3.91129e-17
C386	a_430_418##15	VPWR#4	1.0501e-18
C387	VGND#4	CIN#2	1.11689e-19
C388	a_608_74##11	B#11	3.01398e-18
C389	VPWR#5	a_430_418##3	3.19166e-20
C390	VGND#12	a_492_48##4	2.12863e-20
C391	VGND#6	A#3	1.07838e-18
C392	B#5	a_492_48#	1.02411e-17
C393	a_430_418##13	a_608_74#	1.36401e-18
C394	a_28_74##9	A#3	2.54671e-19
C395	a_28_74##4	B#8	1.09301e-17
C396	a_28_74##9	a_430_418##7	4.87271e-17
C397	a_256_368##6	a_28_74#	3.85934e-17
C398	a_492_48##3	B#11	4.75623e-18
C399	a_492_48##2	B#10	2.49489e-18
C400	a_1854_368##8	a_2004_136##5	1.11988e-18
C401	a_28_74##3	a_492_48##7	3.2942e-18
C402	VGND#5	B#5	1.36857e-17
C403	a_608_74##15	a_492_48##3	1.72416e-19
C404	a_430_418##13	VPWR#5	3.14747e-18
C405	a_492_48##2	B#11	4.54581e-18
C406	a_28_74#	VGND#12	1.4721e-17
C407	VGND#3	VGND#5	3.9844e-17
C408	A#4	a_492_48##7	1.73248e-19
C409	a_608_74##11	a_492_48##7	2.77759e-19
C410	a_430_418##13	VPWR#4	4.94653e-18
C411	a_28_74##9	a_256_368##6	2.07291e-17
C412	a_256_368##6	A#3	1.174e-18
C413	a_1854_368##9	a_1854_368##8	5.3906e-19
C414	B	B#4	2.96221e-17
C415	VGND#3	VGND#4	1.24182e-16
C416	A#4	a_28_74##3	1.78254e-17
C417	a_28_74##8	a_28_74#	8.17259e-19
C418	COUT#3	a_430_418##3	3.6242e-19
C419	a_1197_368#	a_608_74##10	8.12577e-19
C420	a_608_74##15	a_492_48##2	1.16463e-17
C421	a_1854_368##2	a_2004_136##3	2.42847e-18
C422	A#3	VGND#12	1.99742e-17
C423	a_492_48##3	a_492_48#	5.57308e-19
C424	a_430_418##10	a_492_48##10	2.71764e-18
C425	a_1854_368##2	a_1854_368#	1.7127e-17
C426	B#6	B#5	3.51266e-19
C427	a_28_74##10	VPWR#13	7.60448e-17
C428	VGND#5	B#4	1.57658e-19
C429	a_256_368##6	a_430_418##7	4.16299e-17
C430	VPWR#3	VPWR#5	3.34114e-17
C431	a_430_418##10	B#7	1.35046e-18
C432	a_1854_368##2	a_430_418##6	2.77191e-19
C433	a_28_74##8	A#3	2.90572e-17
C434	a_256_368##2	a_28_74##2	4.22875e-19
C435	a_430_418##3	a_608_74##2	2.82533e-17
C436	a_430_418##10	B#9	8.276e-18
C437	VPWR#3	VPWR#4	1.22932e-16
C438	a_430_418##5	a_1854_368#	6.00196e-19
C439	a_28_74##9	a_492_48##3	1.99424e-18
C440	VPWR#6	a_492_48##10	7.28101e-18
C441	a_430_418##10	a_492_48##5	3.19941e-18
C442	a_28_74##2	a_256_368##5	1.92355e-16
C443	CIN	CIN#4	2.20501e-17
C444	a_28_74##2	VPWR#13	1.02445e-16
C445	a_492_48##9	a_430_418##3	5.94018e-18
C446	a_608_74##7	a_430_418##5	9.27638e-18
C447	a_28_74##4	a_492_48##3	2.84093e-19
C448	a_430_418##8	a_492_48##5	1.74028e-19
C449	a_28_74##10	a_28_74##2	4.31074e-18
C450	a_492_48##9	a_492_48##8	5.54093e-18
C451	B#1	a_492_48##9	2.72234e-18
C452	a_430_418##8	B#11	3.12355e-18
C453	a_608_74##5	a_608_74##7	1.8019e-19
C454	VPWR#6	a_492_48##5	1.60109e-18
C455	B#6	a_492_48##3	9.40456e-18
C456	a_492_48##9	B#10	1.31441e-19
C457	VGND#6	B#9	5.33741e-19
C458	a_608_74##5	CIN#6	1.62815e-17
C459	a_430_418##8	a_492_48##7	2.41192e-17
C460	a_28_74##4	a_492_48##2	6.52753e-19
C461	VPWR#6	B#11	1.64324e-17
C462	a_430_418##15	VPWR#3	4.67336e-17
C463	a_430_418##8	a_28_74##3	7.45805e-19
C464	a_28_74##3	a_492_48##3	5.43388e-19
C465	VPWR#6	a_492_48##7	4.07325e-18
C466	B#6	a_492_48##2	1.93062e-18
C467	B#4	a_492_48##9	3.53633e-17
C468	VGND#6	B#11	8.4022e-19
C469	a_430_418##13	VPWR#3	5.42139e-17
C470	a_430_418##7	a_492_48##3	5.04937e-18
C471	a_492_48##6	B#1	2.24461e-19
C472	a_430_418##10	VPWR#5	4.04239e-18
C473	a_1854_368##3	a_2004_136#	4.25657e-18
C474	a_492_48##6	B#10	2.84778e-17
C475	VPWR#6	A#4	5.26432e-18
C476	a_492_48##9	a_492_48##2	6.35657e-19
C477	A#2	a_28_74##3	4.51806e-19
C478	a_608_74##4	CIN#5	4.53479e-19
C479	VPWR#9	a_2004_136##3	5.95487e-17
C480	a_492_48##6	a_492_48#	2.85811e-18
C481	a_608_74##4	a_430_418#	3.83773e-17
C482	a_492_48##6	B#6	1.67775e-19
C483	a_256_368#	a_608_74##11	2.06625e-18
C484	a_430_418##7	a_492_48##2	1.07058e-20
C485	a_492_48##6	a_492_48##4	2.96653e-20
C486	a_608_74##4	a_608_74#	1.11933e-19
C487	a_28_74##8	VGND#12	4.52314e-17
C488	a_430_418##13	VPWR#6	1.49901e-17
C489	a_1854_368#	VPWR#9	3.96255e-17
C490	a_28_74##6	a_492_48##3	3.58799e-20
C491	a_430_418##4	a_1854_368##3	1.93962e-17
C492	a_1854_368##5	a_2004_136##3	1.99987e-18
C493	a_28_74##7	A#2	1.0421e-17
C494	a_608_74##2	a_430_418#	7.0903e-20
C495	a_1854_368#	a_1967_384##3	2.11232e-17
C496	a_256_368##6	a_492_48##3	1.12797e-18
C497	a_608_74##2	a_608_74#	2.48526e-18
C498	A#3	a_28_74##2	2.22138e-19
C499	VGND#6	VGND#5	1.5451e-16
C500	a_430_418##15	a_1854_368##2	1.28125e-18
C501	a_492_48##10	a_608_74##2	6.29365e-18
C502	a_430_418##10	VPWR#6	6.56243e-17
C503	VPWR#3	a_2004_136##2	2.82477e-18
C504	a_1854_368##5	a_1854_368#	1.39318e-17
C505	a_430_418##15	a_430_418##5	3.88014e-18
C506	a_256_368##2	a_492_48##3	3.28395e-17
C507	a_430_418##8	VPWR#6	3.68938e-17
C508	a_492_48##9	a_492_48##10	4.69571e-18
C509	VGND#3	a_2004_136##2	1.27977e-17
C510	VPWR#3	a_1854_368##2	2.35129e-18
C511	a_1967_384##3	a_430_418##6	2.36608e-17
C512	a_430_418##13	a_608_74##10	2.17437e-17
C513	a_608_74##6	a_430_418##4	4.40916e-18
C514	a_430_418##15	a_608_74##5	1.93181e-17
C515	VPWR#6	VPWR#5	1.27732e-16
C516	a_492_48##9	B#7	6.42683e-19
C517	a_2004_136##7	a_1854_368#	3.12115e-19
C518	VGND#6	a_430_418##8	1.73498e-18
C519	VGND#3	a_1854_368##2	5.47426e-18
C520	a_28_74#	a_492_48##3	3.82403e-20
C521	VPWR#3	a_430_418##5	4.44933e-20
C522	a_430_418##13	a_608_74##9	3.60453e-17
C523	a_430_418##13	a_608_74##5	2.13271e-18
C524	VPWR#4	a_1854_368##8	1.42647e-17
C525	a_256_368##2	a_492_48##2	6.44418e-18
C526	a_430_418##6	a_1854_368##5	3.92835e-17
C527	a_492_48##6	B#8	3.80353e-19
C528	VGND#3	a_430_418##5	4.40478e-18
C529	VPWR#3	a_608_74##5	1.17812e-18
C530	a_1967_384#	a_1854_368#	4.42589e-19
C531	a_28_74##6	A#2	5.57042e-18
C532	a_492_48##6	B#5	1.00304e-18
C533	a_1967_384##3	a_608_74##7	7.1148e-19
C534	CIN#4	CIN#2	1.09088e-18
C535	VGND#3	a_608_74##5	1.64143e-16
C536	a_256_368##6	A#2	1.16663e-20
C537	a_492_48##6	B#4	2.88971e-18
C538	a_28_74##6	a_256_368##5	3.33795e-19
C539	a_430_418##6	a_2004_136##7	1.94232e-17
C540	a_28_74##7	A	3.43576e-17
C541	a_28_74##6	A	1.07053e-17
C542	a_430_418##13	a_608_74##4	6.40315e-17
C543	B	a_608_74##10	7.27072e-19
C544	VPWR#3	a_608_74##10	1.23699e-17
C545	a_1854_368##8	a_1854_368#	1.72134e-19
C546	a_492_48##6	B#9	8.65114e-19
C547	a_256_368##2	a_492_48#	1.12201e-18
C548	a_1854_368##5	a_608_74##7	1.3661e-18
C549	VPWR#3	a_608_74##4	7.70479e-19
C550	a_608_74##11	a_608_74##10	2.61174e-18
C551	a_492_48##6	a_492_48##3	6.40686e-20
C552	CIN#1	a_608_74##6	3.29642e-17
C553	a_430_418##13	a_430_418##2	1.56671e-17
C554	a_1967_384#	a_430_418##6	1.71006e-17
C555	VPWR#3	a_608_74##9	6.24061e-17
C556	a_492_48##6	a_492_48##2	2.09054e-17
C557	VGND#3	a_608_74##4	4.10999e-18
C558	a_1967_384##3	CIN#6	1.42454e-19
C559	a_1854_368##2	a_2004_136##2	1.10604e-16
C560	a_2004_136##7	a_608_74##7	3.09142e-17
C561	a_430_418##13	a_608_74##2	2.27527e-17
C562	a_492_48##13	B#9	6.88743e-19
C563	VGND#3	a_430_418##2	5.26359e-18
C564	a_1854_368##8	a_430_418##6	2.77031e-19
C565	a_256_368##2	B#6	1.70995e-17
C566	a_28_74##6	VPWR#13	4.78103e-19
C567	a_28_74##2	B#11	1.67355e-19
C568	VPWR#3	a_608_74##2	8.5731e-19
C569	a_1854_368##5	CIN#6	3.31582e-19
C570	a_430_418##13	a_492_48##9	3.5368e-18
C571	a_28_74##2	a_492_48##7	4.16117e-19
C572	a_430_418##5	a_1854_368##2	1.5172e-17
C573	VGND#3	a_608_74##2	9.94371e-19
C574	a_1967_384#	a_608_74##7	2.78349e-17
C575	CIN	a_608_74##9	2.20048e-17
C576	VGND#9	SUM#3	4.3392e-18
C577	a_28_74##2	a_28_74##3	3.58186e-17
C578	a_430_418##13	CIN#4	2.87105e-18
C579	a_2004_136##7	CIN#6	4.72099e-19
C580	CIN#7	CIN#1	5.36048e-18
C581	a_28_74##2	A#4	5.62266e-18
C582	VGND#3	a_608_74##9	3.83611e-18
C583	a_256_368##2	a_492_48##4	4.786e-18
C584	a_1854_368##8	a_608_74##7	1.48256e-17
C585	a_608_74##5	a_430_418##5	1.61295e-18
C586	VGND#12	A#2	2.06254e-18
C587	a_430_418##10	a_492_48##9	2.73593e-17
C588	a_608_74##11	B#8	1.54982e-17
C589	a_1967_384#	CIN#6	8.31844e-19
C590	a_430_418##10	a_608_74##11	7.49278e-17
C591	a_492_48##13	B	2.82726e-17
C592	a_430_418##12	B	2.54118e-17
C593	VGND#6	a_608_74##2	5.08302e-18
C594	VGND#5	COUT	2.62647e-17
C595	a_28_74##2	a_492_48##3	2.69644e-18
C596	VGND#4	COUT	2.51596e-17
C597	VPWR#6	a_492_48##9	1.79262e-18
C598	a_256_368##2	a_28_74#	2.65762e-19
C599	a_430_418##10	a_608_74##10	2.10571e-17
C600	a_492_48##6	a_430_418##10	3.19799e-17
C601	VGND#6	a_492_48##9	5.16927e-18
C602	a_608_74##10	a_430_418##3	6.31428e-19
C603	a_1854_368##8	CIN#6	6.87722e-17
C604	a_256_368##5	a_492_48##3	2.34944e-18
C605	a_608_74##10	a_608_74##9	2.92859e-18
C606	A#2	a_28_74##2	3.31266e-17
C607	CIN	VGND#10	3.63546e-17
C608	a_1595_400#	CIN	2.0128e-17
C609	a_608_74##3	CIN#7	2.47294e-17
C610	a_608_74##5	a_430_418##2	8.22238e-20
C611	a_430_418##8	a_28_74##2	2.25741e-18
C612	VPWR#10	CIN#6	1.86151e-17
C613	VGND#6	a_492_48##6	3.43677e-18
C614	a_608_74##11	B#5	3.56357e-19
C615	VPWR#6	a_28_74##2	3.72597e-17
C616	a_1854_368##5	VPWR#9	3.99783e-17
C617	a_430_418##8	a_608_74##11	1.1004e-17
C618	a_1854_368##8	CIN#5	8.27124e-20
C619	SUM	SUM#3	2.59775e-18
C620	a_430_418##2	a_608_74##4	7.8495e-17
C621	a_492_48##13	a_492_48##11	7.47336e-18
C622	VGND#9	SUM	2.91929e-17
C623	VGND#6	a_28_74##2	1.96584e-18
C624	VPWR#3	CIN#4	4.94071e-19
C625	COUT	a_608_74##10	3.63006e-19
C626	a_608_74##9	CIN#4	1.12834e-17
C627	A	VPWR#13	2.41956e-17
C628	a_28_74##10	A	2.69195e-17
C629	B	a_492_48##11	1.94603e-17
C630	VGND#4	a_1595_400#	1.82171e-17
C631	CIN#5	VPWR#10	3.37222e-17
C632	a_608_74##2	a_430_418##2	1.21089e-17
C633	a_608_74##10	B#8	2.93855e-17
C634	VGND#4	a_608_74##5	1.59042e-17
C635	VPWR#4	CIN#4	8.23692e-20
C636	a_1967_384##3	a_1854_368##5	9.70528e-17
C637	a_430_418##3	a_608_74##3	2.11114e-18
C638	a_492_48##9	a_430_418##2	1.12177e-18
C639	a_2004_136##5	CIN#2	3.97326e-20
C640	CIN#5	a_1595_400##2	2.49199e-17
C641	a_492_48##9	a_608_74##2	1.60519e-17
C642	a_608_74##11	B#4	8.22578e-19
C643	a_608_74##11	VPWR#6	4.78447e-17
C644	SUM	SUM#1	1.56755e-17
C645	CIN#4	VNB	5.62444e-17
C646	CIN#2	VNB	1.47188e-17
C647	VPWR#9	SUM	8.33167e-17
C648	B#8	VNB	1.09917e-16
C649	B#5	VNB	1.04164e-16
C650	B#4	VNB	1.32282e-16
C651	COUT	a_1595_400#	6.1283e-17
C652	VPWR#5	B#8	1.31756e-17
C653	a_492_48##3	VNB	5.48195e-17
C654	a_492_48##2	VNB	6.5605e-17
C655	COUT	COUT#1	3.122e-17
C656	VPWR#6	a_608_74##10	5.34419e-17
C657	A#2	VNB	5.18821e-17
C658	a_1197_368#	COUT	7.59579e-17
C659	a_430_418##15	a_2004_136##5	8.35189e-18
C660	a_2004_136##7	a_1967_384##3	2.67727e-18
C661	SUM#3	a_2004_136#	1.43382e-17
C662	a_430_418#	a_1595_400##2	2.79512e-17
C663	a_430_418##15	a_1854_368##9	4.20079e-18
C664	B	B#1	2.02117e-18
C665	B	B#10	4.56398e-19
C666	a_492_48##8	a_430_418##3	3.55091e-17
C667	a_2004_136##5	a_1967_384##5	8.73326e-17
C668	VPWR#4	CIN#2	1.04126e-20
C669	a_608_74##11	B#10	2.2365e-18
C670	VGND#3	CIN#4	1.53293e-19
C671	CIN	CIN#1	5.27508e-19
C672	a_430_418#	COUT#3	3.60196e-17
C673	VGND#5	a_1197_368#	1.70016e-17
C674	VGND#6	a_608_74##11	5.9837e-18
C675	a_2004_136#	VGND#9	2.24521e-17
C676	a_1967_384#	a_1967_384##3	2.58621e-18
C677	VGND#3	CIN#2	1.0015e-18
C678	SUM	a_2004_136#	1.52407e-17
C679	A#2	VPWR#13	4.83763e-18
C680	COUT	COUT#3	2.02594e-18
C681	a_1197_368##2	COUT	2.8412e-18
C682	a_608_74##5	VPWR#4	4.17171e-19
C683	SUM#3	a_1854_368##3	8.50447e-19
C684	a_608_74##10	B#4	1.42838e-17
C685	a_608_74#	COUT#3	3.66315e-17
C686	VGND#5	VNB	9.14656e-17
C687	VGND#4	VNB	6.73425e-17
C688	a_1967_384##5	a_2004_136#	8.43413e-19
C689	B#1	a_492_48##8	1.16121e-17
C690	a_430_418##13	VGND#10	6.298e-18
C691	VPWR#5	VNB	8.7322e-17
C692	A	a_28_74##3	9.82622e-19
C693	a_1967_384#	a_1854_368##5	1.63018e-17
C694	VPWR#4	VNB	6.45328e-17
C695	A	A#4	9.19845e-19
C696	a_608_74##11	a_492_48##3	4.96952e-19
C697	a_1854_368##3	VGND#9	1.11707e-17
C698	COUT	CIN#7	1.00233e-18
C699	VGND#4	a_608_74##4	2.88246e-19
C700	a_608_74#	a_1197_368##2	2.20812e-17
C701	COUT	a_608_74##3	3.31011e-17
C702	COUT	a_430_418##3	2.44175e-17
C703	SUM	a_2004_136##3	3.04726e-17
C704	a_430_418##13	a_1595_400#	4.44097e-18
C705	COUT	a_492_48##8	1.06971e-19
C706	SUM	a_1854_368#	7.30244e-19
C707	a_608_74##11	VNB	7.22066e-18
C708	a_608_74##10	VNB	1.29637e-17
C709	a_608_74##9	VNB	2.70612e-17
C710	a_2004_136##5	a_2004_136#	8.01423e-20
C711	VGND#10	CIN#4	1.07131e-17
C712	VPWR#12	a_608_74#	1.65021e-18
C713	a_430_418##13	COUT#1	4.30419e-21
C714	a_28_74##7	VNB	2.69784e-17
C715	VPWR#6	A	1.63788e-18
C716	a_1854_368##9	a_2004_136##5	5.90914e-17
C717	a_1967_384#	a_2004_136##7	5.42949e-17
C718	a_28_74##6	VNB	1.12679e-17
C719	a_1854_368##8	a_1854_368##5	3.11429e-18
C720	a_1967_384##5	a_1854_368##3	4.20338e-17
C721	VGND#6	A	2.40626e-18
C722	SUM#3	VNB	1.47062e-17
C723	VGND#3	a_1967_384##5	8.44017e-18
C724	VGND#9	VNB	8.27053e-18
C725	a_1967_384##5	VNB	4.15167e-18
C726	a_430_418##10	B	2.66958e-17
C727	a_2004_136##5	VNB	1.54954e-17
C728	a_1197_368##2	a_492_48##10	2.97188e-17
C729	a_2004_136##7	CIN#2	2.00082e-19
C730	a_1854_368##9	VNB	3.81848e-18
C731	VGND#10	VNB	6.4042e-18
C732	a_1595_400#	VNB	5.61642e-18
C733	a_430_418##13	a_1197_368#	2.8623e-18
C734	a_430_418##13	CIN	4.8543e-18
C735	a_1197_368#	VNB	3.69493e-18
C736	VPWR#6	B	1.04454e-18
C737	VGND#11	VNB	5.80039e-18
C738	a_492_48##13	VNB	7.08112e-18
C739	COUT	a_430_418#	7.45213e-19
C740	a_430_418##12	VNB	8.74477e-18
C741	VGND#6	B	3.18699e-18
C742	a_608_74##11	B#6	8.60781e-19
C743	a_28_74##10	A#2	5.62217e-18
C744	a_256_368#	VNB	9.31174e-18
C745	VGND#3	CIN	2.86535e-18
C746	a_608_74##15	VNB	1.67623e-18
C747	VGND#3	a_2004_136##5	5.21483e-17
C748	a_28_74##9	VNB	1.47908e-17
C749	a_430_418##7	VNB	1.1891e-17
C750	a_608_74##11	a_492_48##2	2.30334e-17
C751	a_256_368##6	VNB	1.02308e-17
C752	VGND#12	VNB	1.90849e-18
C753	VGND#5	a_430_418##2	5.71742e-19
C754	a_28_74##8	VNB	2.85945e-17
C755	VPWR#9	VNB	3.1699e-18
C756	a_430_418##13	VGND#11	1.49902e-19
C757	a_492_48##10	VPWR#12	2.60711e-17
C758	a_1967_384##3	VNB	1.11093e-17
C759	a_1854_368##5	VNB	2.45963e-17
C760	VPWR#3	SUM	1.79385e-17
C761	a_2004_136##7	VNB	6.56265e-19
C762	a_2004_136##5	a_1854_368##3	1.50493e-17
C763	a_1967_384#	VNB	1.54121e-18
C764	a_430_418##10	B#8	5.74033e-19
C765	a_1854_368##8	VNB	2.38565e-17
C766	VGND#3	SUM	1.98789e-17
C767	VPWR#10	VNB	1.02745e-18
C768	CIN#2	VGND#10	9.70491e-19
C769	VGND#4	a_430_418##2	4.422e-19
C770	VGND#3	a_1854_368##9	8.09891e-18
C771	a_430_418##11	a_608_74#	2.78423e-19
C772	a_1595_400##2	VNB	5.06072e-18
C773	a_1854_368##8	a_2004_136##7	8.2292e-18
C774	COUT#3	VNB	3.39949e-18
C775	a_1197_368##2	VNB	4.14647e-18
C776	VPWR#12	VNB	2.19324e-18
C777	a_492_48##11	VNB	1.92719e-18
C778	a_430_418##11	VNB	5.49481e-18
C779	a_1197_368##2	B#7	1.29523e-18
C780	a_28_74##4	VNB	2.03694e-17
C781	CIN	a_608_74##5	3.80951e-17
C782	CIN#2	a_608_74##7	2.98956e-19
C783	a_430_418##13	COUT	1.39348e-17
C784	VGND#5	a_492_48##13	6.5172e-17
C785	a_256_368##2	VNB	8.69802e-18
C786	a_2004_136##2	SUM	6.3786e-17
C787	a_430_418##4	a_1967_384##5	1.2096e-17
C788	a_256_368##5	VNB	2.99172e-17
C789	a_492_48##11	a_492_48##10	1.24485e-18
C790	VPWR#13	VNB	2.90028e-18
C791	VGND#3	COUT	4.32432e-17
C792	B	a_492_48##9	1.96296e-17
C793	CIN	a_608_74##4	1.48941e-18
C794	a_28_74##10	VNB	6.36816e-17
C795	a_1854_368##2	SUM	4.61644e-18
C796	A	a_28_74##2	4.85585e-17
C797	VGND#3	VGND#10	2.13591e-17
C798	a_2004_136#	VNB	3.39441e-17
C799	a_1854_368##3	VNB	3.40096e-17
C800	a_430_418##4	VNB	2.79408e-17
C801	VPWR#4	a_608_74##4	1.76419e-19
C802	a_608_74##6	VNB	3.86922e-17
C803	CIN#1	VNB	3.93903e-17
C804	CIN#7	VNB	2.69202e-17
C805	a_608_74##3	VNB	3.08825e-17
C806	VGND#6	COUT	3.72724e-18
C807	a_430_418##3	VNB	4.59348e-17
C808	a_492_48##8	VNB	3.10603e-17
C809	B#1	VNB	2.81814e-17
C810	VPWR#12	B#7	4.0309e-17
C811	a_430_418##10	B#4	1.69522e-17
C812	B#10	VNB	3.38813e-17
C813	a_492_48#	VNB	2.22007e-17
C814	B#6	VNB	7.13522e-17
C815	VGND#3	a_1595_400#	1.71479e-17
C816	a_492_48#	B#10	1.41048e-17
C817	a_492_48##4	VNB	3.96535e-17
C818	a_28_74#	VNB	3.64317e-17
C819	a_430_418##11	a_492_48##10	4.25203e-19
C820	A#3	VNB	3.60016e-17
C821	a_2004_136##3	VNB	4.27894e-17
C822	a_1854_368#	VNB	3.78412e-17
C823	COUT	a_608_74##4	3.29692e-17
C824	a_1854_368##8	a_1967_384#	1.10599e-16
C825	a_430_418##6	VNB	3.66854e-17
C826	a_608_74##7	VNB	3.8963e-17
C827	COUT	a_430_418##2	1.09008e-16
C828	CIN#6	VNB	4.5048e-17
C829	a_2004_136##5	a_430_418##4	4.78509e-17
C830	CIN#5	VNB	3.89823e-17
C831	COUT	a_608_74##2	3.19005e-17
C832	a_430_418#	VNB	4.30781e-17
C833	a_608_74#	VNB	3.16607e-17
C834	COUT	a_492_48##9	1.27991e-18
C835	a_1595_400#	CIN#4	1.07785e-17
C836	a_492_48##10	VNB	3.76914e-17
C837	a_492_48##11	B#7	3.41633e-17
C838	B#7	VNB	4.07394e-17
C839	B#9	VNB	3.59483e-17
C840	a_256_368##2	a_608_74##15	4.58229e-17
C841	a_492_48##5	VNB	2.69112e-17
C842	B#11	VNB	7.5474e-17
C843	VGND#5	a_608_74##2	1.51054e-18
C844	a_492_48##7	VNB	4.18863e-17
C845	a_28_74##3	VNB	4.03327e-17
C846	A#4	VNB	4.31282e-17
C847	a_430_418##15	VNB	5.18251e-18
C848	B#6	B#10	1.61021e-19
C849	a_1967_384##5	a_608_74##6	8.18059e-20
C850	a_430_418##13	VNB	2.25831e-18
C851	VPWR#3	VNB	3.31468e-16
C852	VGND#3	VNB	3.37517e-16
C853	a_430_418##10	VNB	6.95183e-18
C854	a_430_418##8	VNB	3.02733e-17
C855	VPWR#6	VNB	3.53571e-16
C856	VGND#6	VNB	3.68856e-16
C857	a_2004_136##2	VNB	4.43231e-17
C858	VPWR#5	a_430_418##2	9.61822e-20
C859	VGND#6	a_28_74##7	1.12344e-18
C860	a_430_418##11	B#7	7.32485e-19
C861	a_1854_368##2	VNB	3.31057e-17
C862	a_430_418##5	VNB	2.42106e-17
C863	a_608_74##5	VNB	8.7669e-17
C864	a_1854_368##9	a_430_418##4	1.15442e-19
C865	a_608_74##4	VNB	3.12305e-17
C866	a_430_418##10	a_492_48##2	3.35605e-18
C867	a_430_418##2	VNB	6.15621e-17
C868	a_608_74##2	VNB	4.24153e-17
C869	a_492_48##9	VNB	4.91927e-17
C870	VPWR#4	a_430_418##2	6.5647e-20
C871	a_492_48##6	VNB	4.53075e-18
C872	VGND#4	a_430_418#	2.47584e-20
C873	a_28_74##2	VNB	6.05818e-17
C874	VGND#6	a_28_74##6	2.46701e-17
C875	a_492_48##11	B#9	7.20226e-19
C876	a_256_368##2	a_28_74##9	6.20802e-18
C877	B#6	a_492_48#	1.30557e-17
C878	a_2004_136##5	a_608_74##6	2.45256e-17
C879	A	VNB	6.47529e-18
C880	B	VNB	7.0704e-18
C881	CIN	VNB	9.77753e-19
C882	SUM	VNB	9.9603e-17
C883	COUT	VNB	7.40615e-18
C884	B#9	a_430_418##11	1.52276e-17
C885	VGND#3	VGND#2	1.54478e-16
C886	VGND#7	a_28_74##9	3.26168e-17
C887	VPWR#2	a_1854_368##2	4.51086e-20
C888	VGND#7	a_28_74##8	2.08579e-17
C889	VPWR#7	a_28_74##3	3.18989e-18
C890	VPWR#7	A#2	3.08965e-19
C891	VGND#2	a_2004_136#	4.07341e-18
C892	VGND#6	VGND#7	1.44836e-16
C893	VGND#2	a_1854_368##3	2.61515e-18
C894	VPWR#7	A#4	6.84095e-18
C895	VPWR#2	VNB	7.06594e-17
C896	a_28_74##10	VPWR#7	1.78941e-17
C897	VGND#2	a_430_418##4	8.00636e-19
C898	VGND#2	a_2004_136##2	1.21763e-17
C899	a_28_74##4	VPWR#7	4.48253e-18
C900	VGND#2	SUM	1.54003e-17
C901	VGND#2	a_2004_136##5	3.33937e-17
C902	a_1854_368##5	VPWR#2	7.21331e-17
C903	VGND#2	a_1854_368##2	9.6881e-20
C904	VPWR#7	a_28_74##2	7.51926e-17
C905	VPWR#7	VNB	7.50603e-17
C906	SUM	VPWR#2	1.76457e-17
C907	VPWR#6	VPWR#7	1.38069e-16
C908	VGND#7	a_28_74##2	4.30934e-20
C909	a_608_74##5	VGND#2	3.15913e-18
C910	VPWR#3	VPWR#2	1.30799e-16
C911	VGND#7	a_28_74##7	2.25484e-19
C912	VPWR#2	a_2004_136##3	6.98681e-18
C913	VGND#7	a_28_74##6	4.88143e-17
C914	VGND#2	VNB	7.96386e-17
C915	VGND#7	B#6	2.48707e-19
C916	VGND#7	a_492_48##4	2.49142e-19
C917	VGND#7	a_28_74#	3.39208e-18
C918	VGND#7	A#3	7.30511e-18
C919	VGND#7	VNB	7.92488e-17
C920	VPWR#2	a_1854_368#	3.18708e-18
*
*
.ENDS sky130_fd_sc_hs__fahcin_1
*
