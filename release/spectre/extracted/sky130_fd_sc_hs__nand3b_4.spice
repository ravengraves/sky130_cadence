* Extracted by Quantus, converted by sky130cad/quantus.py
*
*
*
*                       LINUX           Wed Nov 18 08:46:51 2026
*
*
*
*  PROGRAM  advgen
*
*  Name           : advgen - Quantus - (64-bit)
*  Version        : 25.1.0-p047
*  Build Date     : Thu Dec 11 23:20:30 PST 2025
*
*  HSPICE LIBRARY
*
*  OPERATING_TEMPERATURE 150
*  QRC_TECH_DIR <path>/tech
*
*
*

*
.SUBCKT sky130_fd_sc_hs__nand3b_4 VPB VNB VGND VPWR Y B A_N C
*
*
*  caps2d version: 10
*
*
*       TRANSISTOR CARDS
*
*
XM10 a_89_172##12 A_N#5 VGND#8 VNB sky130_fd_pr__nfet_01v8_lvt l=0.15 w=0.74 ad=0.19515 as=0.40685 pd=2.05 ps=2.85
XM4 VGND#8 C#6 a_297_82##3 VNB sky130_fd_pr__nfet_01v8_lvt l=0.15 w=0.74 ad=0.40685 as=0.2072 pd=2.85 ps=2.04
XM9 a_297_82##3 C#10 VGND#7 VNB sky130_fd_pr__nfet_01v8_lvt l=0.15 w=0.74 ad=0.2072 as=0.543 pd=2.04 ps=3.12
XM16 VGND#7 C#8 a_297_82##6 VNB sky130_fd_pr__nfet_01v8_lvt l=0.15 w=0.74 ad=0.543 as=0.259 pd=3.12 ps=2.18
XM13 a_297_82##6 C#1 VGND#6 VNB sky130_fd_pr__nfet_01v8_lvt l=0.15 w=0.74 ad=0.259 as=0.19935 pd=2.18 ps=2.05
XM0 Y#1 a_89_172##9 a_744_74##8 VNB sky130_fd_pr__nfet_01v8_lvt l=0.15 w=0.74 ad=0.2257 as=0.1962 pd=2.09 ps=2.05
XM11 a_744_74##6 a_89_172##7 Y#1 VNB sky130_fd_pr__nfet_01v8_lvt l=0.15 w=0.74 ad=0.2072 as=0.2257 pd=2.04 ps=2.09
XM6 a_744_74##6 a_89_172##6 Y#2 VNB sky130_fd_pr__nfet_01v8_lvt l=0.15 w=0.74 ad=0.2072 as=0.2072 pd=2.04 ps=2.04
XM14 Y#2 a_89_172# a_744_74##4 VNB sky130_fd_pr__nfet_01v8_lvt l=0.15 w=0.74 ad=0.2072 as=0.259 pd=2.04 ps=2.18
XM17 a_744_74##4 B#7 a_297_82##5 VNB sky130_fd_pr__nfet_01v8_lvt l=0.15 w=0.74 ad=0.259 as=0.2072 pd=2.18 ps=2.04
XM1 a_297_82##5 B#5 a_744_74##2 VNB sky130_fd_pr__nfet_01v8_lvt l=0.15 w=0.74 ad=0.2072 as=0.2072 pd=2.04 ps=2.04
XM5 a_297_82# B#4 a_744_74##2 VNB sky130_fd_pr__nfet_01v8_lvt l=0.15 w=0.74 ad=0.2072 as=0.2072 pd=2.04 ps=2.04
XM20 a_744_74# B#1 a_297_82# VNB sky130_fd_pr__nfet_01v8_lvt l=0.15 w=0.74 ad=0.1976 as=0.2072 pd=2.05 ps=2.04
XM8 VPWR#5 A_N#4 a_89_172##13 VPB sky130_fd_pr__pfet_01v8 l=0.15 w=0.84 ad=0.5754 as=0.252 pd=3.05 ps=2.28
XM18 a_89_172##13 A_N#1 VPWR#10 VPB sky130_fd_pr__pfet_01v8 l=0.15 w=0.84 ad=0.252 as=1.2404 pd=2.28 ps=4.5
XM2 Y#7 C#9 VPWR#10 VPB sky130_fd_pr__pfet_01v8 l=0.15 w=1.12 ad=0.336 as=1.2404 pd=2.84 ps=4.5
XM15 VPWR#9 C#7 Y#7 VPB sky130_fd_pr__pfet_01v8 l=0.15 w=1.12 ad=0.5208 as=0.336 pd=3.17 ps=2.84
XM3 VPWR#9 a_89_172##5 Y#5 VPB sky130_fd_pr__pfet_01v8 l=0.15 w=1.12 ad=0.5208 as=0.7616 pd=3.17 ps=3.6
XM7 Y#5 a_89_172##8 VPWR#1 VPB sky130_fd_pr__pfet_01v8 l=0.15 w=1.12 ad=0.7616 as=0.8848 pd=3.6 ps=3.82
XM12 Y#8 B#8 VPWR#1 VPB sky130_fd_pr__pfet_01v8 l=0.15 w=1.12 ad=0.336 as=0.8848 pd=2.84 ps=3.82
XM19 VPWR#7 B#9 Y#8 VPB sky130_fd_pr__pfet_01v8 l=0.15 w=1.12 ad=1.7472 as=0.336 pd=5.36 ps=2.84
*
*
*       RESISTOR AND CAP/DIODE CARDS
*
Rg1	A_N#1	A_N#2	444.026947
Rg2	A_N#2	A_N#3	16.634237
Rg3	A_N#2	A_N#4	317.636047
Rg4	A_N#3	A_N#5	341.597412
Rg5	C#1	C#2	320.737152
Rg6	C#2	C#3	46.293034
Rg7	C#3	C#4	22.574533
Rg8	C#4	C#5	81.898705
Rg9	C#5	C#6	496.241608
Rg10	C#2	C#7	467.523865
Rg11	C#3	C#8	317.515900
Rg12	C#3	C#9	466.857391
Rg13	C#5	C#10	277.154449
Rg14	a_89_172#	a_89_172##2	473.208221
Rg15	a_89_172##2	a_89_172##3	234.317429
Rg16	a_89_172##3	a_89_172##4	55.871525
Rg17	a_89_172##4	a_89_172##5	512.450256
Rg18	a_89_172##2	a_89_172##6	262.702026
Rg19	a_89_172##3	a_89_172##7	315.878845
Rg20	a_89_172##3	a_89_172##8	484.873199
Rg21	a_89_172##4	a_89_172##9	295.808380
Rg22	B#1	B#2	469.814972
Rg23	B#2	B#3	44.339203
Rg24	B#2	B#4	356.843109
Rg25	B#3	B#5	354.816742
Rg26	B#3	B#6	76.794800
Rg27	B#6	B#7	387.723480
Rg28	B#6	B#8	551.353577
Rg29	B#6	B#9	437.051971
Rf1	A_N#3	A_N	83.099030
Rf2	C	C#11	6.112055
Rf3	C#11	C	8.556877
Rf4	a_89_172##4	a_89_172##11	255.899307
Rf5	a_89_172##11	a_89_172##12	68.148849
Rf6	a_89_172##11	a_89_172##13	89.628700
Rf7	Y#1	Y	43.881641
Rf8	Y	Y#3	5.312395
Rf9	Y	Y#4	11.197071
Rf10	Y#4	Y#6	37.828236
Rf11	Y#6	Y#7	90.802567
Rf12	Y#4	Y#8	41.072960
Rf13	Y#2	Y#3	15.000000
Rf14	Y#5	Y#6	7.500000
Rf15	B	B#10	0.701255
Rf16	B#10	B	12.762836
Rf17	a_297_82##2	a_297_82##4	845.488953
Rf18	a_297_82##2	a_297_82##5	77.823425
Rf19	a_297_82##4	a_297_82##6	100.549789
Rf20	a_297_82#	a_297_82##2	15.000000
Rf21	a_297_82##3	a_297_82##4	15.000000
Rf22	a_744_74#	a_744_74##3	49.860477
Rf23	a_744_74##3	a_744_74##5	34.860477
Rf24	a_744_74##5	a_744_74##7	46.455723
Rf25	a_744_74##7	a_744_74##8	59.595711
Rf26	a_744_74##2	a_744_74##3	15.000000
Rf27	a_744_74##4	a_744_74##5	15.000000
Rf28	a_744_74##6	a_744_74##7	15.000000
Rf29	VPWR#1	VPWR#2	14.526070
Rf30	VPWR#2	VPWR#3	121.231148
Rf31	VPWR#3	VPWR#4	99.585945
Rf32	VPWR#4	VPWR#5	170.704651
Rf33	VPWR#2	VPWR#6	170.613281
Rf34	VPWR#6	VPWR#8	4.322942
Rf35	VPWR#8	VPWR#7	5.826184
Rf36	VPWR#3	VPWR#9	28.818371
Rf37	VPWR#4	VPWR#10	10.385466
Rf38	VPWR#7	VPWR#8	5.000000
Rf39	VGND#1	VGND#2	281.317444
Rf40	VGND#2	VGND#3	85.185852
Rf41	VGND#3	VGND#4	80.806419
Rf43	VGND#2	VGND#6	39.383251
Rf44	VGND#3	VGND#7	21.749857
Rf45	VGND#4	VGND#8	24.076445
Rf47	C#4	C#11	40.058201
Rf49	B#3	B#10	40.058201
Re1	VPWR#6	VPWR	6.179563
Re2	VPWR	VPWR#3	0.882795
Re3	VGND#1	VGND	6.179563
Re4	VGND	VGND#2	0.882795
*
*       CAPACITOR CARDS
*
*
C1	VPWR#4	VPWR#9	1.30921e-17
C2	a_89_172##11	a_297_82##3	9.10444e-17
C3	a_744_74##4	Y#2	2.07203e-19
C4	VPWR#9	VPWR#2	7.4605e-18
C5	C#5	VPWR#10	1.50189e-18
C6	a_89_172##11	A_N#2	6.83989e-18
C7	a_89_172##11	VGND#8	2.27677e-18
C8	a_744_74##6	Y#2	5.5253e-19
C9	VPWR#4	VPWR#10	2.10177e-17
C10	a_744_74##4	a_744_74##8	3.46812e-20
C11	a_89_172##13	C#5	1.88567e-18
C12	a_744_74##6	Y#1	2.66836e-17
C13	Y#4	VPWR#1	7.53882e-18
C14	VPWR#5	VPWR#4	1.07007e-17
C15	VGND#6	Y#2	2.38175e-20
C16	VPWR#6	B#6	2.85663e-19
C17	A_N#2	a_89_172##13	3.79991e-18
C18	a_744_74##8	Y#1	1.55762e-17
C19	VGND#6	Y#1	2.58967e-18
C20	a_297_82#	B#6	4.06344e-18
C21	a_297_82#	VPWR#7	2.38679e-17
C22	VGND#6	a_744_74##8	2.72626e-17
C23	VGND#1	B#6	1.15402e-19
C24	A_N#2	VPWR#5	3.70881e-18
C25	a_297_82#	Y#8	7.36119e-17
C26	VGND#1	a_89_172##2	3.68508e-20
C27	a_297_82##6	VGND#6	4.17324e-17
C28	a_744_74##2	B#6	4.87811e-20
C29	a_297_82#	VPWR#1	4.1398e-18
C30	a_297_82#	a_89_172##2	1.91928e-18
C31	a_297_82#	Y#5	1.04378e-16
C32	a_744_74##4	Y#8	7.01266e-18
C33	a_89_172##11	a_89_172##13	2.15858e-18
C34	a_297_82##6	VGND#7	1.46456e-18
C35	a_297_82#	VPWR#9	5.25962e-17
C36	VPWR#2	a_89_172#	3.72449e-19
C37	a_297_82##3	a_297_82##6	2.19337e-18
C38	B#6	a_297_82##5	1.14606e-18
C39	Y#7	a_297_82#	2.78484e-17
C40	a_297_82##3	VGND#7	1.45707e-18
C41	VGND#3	a_89_172##9	8.80855e-20
C42	VGND#2	a_89_172##2	1.29835e-19
C43	VGND#3	C#1	1.29041e-18
C44	a_297_82##3	VGND#8	3.89389e-18
C45	a_744_74##4	B#6	2.42355e-18
C46	a_297_82##3	a_89_172##12	8.2098e-17
C47	VGND#3	C#8	1.10831e-17
C48	B#6	B#3	1.93632e-18
C49	a_744_74#	B#1	3.22507e-17
C50	Y#4	a_89_172#	2.25729e-18
C51	a_297_82#	B#1	6.2498e-17
C52	a_89_172#	B#6	9.202e-18
C53	VGND#3	C#10	1.11052e-17
C54	a_297_82#	B#4	2.68924e-17
C55	a_744_74##4	a_89_172##2	5.41395e-20
C56	VGND#3	C#6	8.82712e-19
C57	a_744_74##2	B#4	3.65991e-17
C58	a_89_172##4	B#6	9.72834e-19
C59	a_297_82#	B#5	2.16129e-19
C60	a_744_74##2	B#5	3.6598e-17
C61	VGND#3	A_N#5	5.5636e-19
C62	a_297_82#	B#7	1.23401e-19
C63	VPWR#4	C#6	4.5652e-19
C64	a_297_82##5	B#5	2.61053e-17
C65	a_89_172##2	Y#2	3.50988e-19
C66	a_297_82##3	Y#7	4.53672e-17
C67	a_297_82#	a_89_172#	3.32112e-19
C68	a_297_82##5	B#7	2.1895e-17
C69	a_297_82##3	VPWR#10	1.41679e-17
C70	a_744_74##4	B#7	4.43653e-17
C71	a_297_82##5	a_89_172#	1.55839e-18
C72	a_297_82##3	a_89_172##13	7.21085e-17
C73	a_744_74##4	a_89_172#	4.39816e-17
C74	a_744_74##6	a_89_172##2	5.39635e-19
C75	a_89_172##11	C#8	1.01118e-17
C76	a_89_172#	Y#2	1.44708e-17
C77	a_297_82##3	VPWR#5	7.55467e-17
C78	a_744_74##4	a_89_172##6	1.01958e-18
C79	VGND#3	C#5	7.40392e-19
C80	VPWR#2	B#9	5.25694e-18
C81	a_89_172##6	Y#2	1.44708e-17
C82	Y#5	VPWR#9	1.0064e-18
C83	a_89_172##11	C#10	1.35766e-17
C84	a_744_74##4	a_89_172##7	5.79765e-19
C85	a_744_74##6	a_89_172##6	3.28637e-17
C86	VPWR#2	B#8	2.48372e-17
C87	a_89_172##11	C#6	2.64485e-17
C88	a_744_74##4	a_89_172##9	4.24766e-19
C89	VGND#6	a_89_172#	4.02442e-19
C90	a_744_74##6	a_89_172##7	3.46188e-17
C91	Y#7	VPWR#9	5.00986e-18
C92	Y#1	a_89_172##7	3.52304e-17
C93	a_89_172##11	A_N#5	3.11425e-20
C94	VGND#6	a_89_172##6	5.20716e-19
C95	VPWR#2	a_89_172##8	2.42033e-17
C96	Y#1	a_89_172##9	2.59189e-17
C97	VGND#6	a_89_172##7	9.43928e-19
C98	a_744_74##8	a_89_172##9	4.45381e-17
C99	VPWR#2	a_89_172##5	3.35773e-18
C100	a_89_172##13	Y#7	5.98145e-18
C101	Y#1	C#1	1.44099e-18
C102	VGND#6	a_89_172##9	4.71576e-18
C103	a_89_172##13	VPWR#10	2.85205e-18
C104	a_744_74##8	C#1	6.29621e-19
C105	VPWR#4	C#7	3.54134e-18
C106	Y#4	B#8	2.05448e-19
C107	VPWR#2	B#6	4.10773e-20
C108	Y#1	C#8	3.32324e-19
C109	VGND#6	C#1	4.72084e-17
C110	VPWR#5	VPWR#10	6.44435e-19
C111	C#1	a_297_82##6	1.69367e-17
C112	Y#8	a_89_172#	8.84003e-19
C113	VPWR#4	C#9	2.82242e-17
C114	Y#4	a_89_172##8	1.08844e-17
C115	VGND#6	C#8	2.47123e-18
C116	a_297_82##6	C#8	4.67648e-17
C117	a_297_82#	B#9	3.03698e-17
C118	VGND#6	C#10	3.12641e-19
C119	Y#4	a_89_172##5	5.13364e-19
C120	C#8	VGND#7	1.97177e-17
C121	VPWR#4	A_N#1	1.2237e-17
C122	VPWR#4	C#5	2.09563e-18
C123	a_297_82##6	C#10	5.61158e-19
C124	a_297_82##3	C#8	8.46431e-19
C125	a_297_82#	B#8	1.91736e-17
C126	C#10	VGND#7	2.04244e-17
C127	Y#4	C#7	1.57308e-19
C128	VPWR#4	A_N#4	6.90899e-18
C129	a_297_82##3	C#10	4.24236e-17
C130	B#4	B#1	3.98948e-17
C131	a_89_172##12	C#8	2.76752e-19
C132	VPWR#2	a_89_172##2	1.25955e-18
C133	a_297_82#	a_89_172##8	2.29038e-17
C134	a_744_74##4	B#8	2.65859e-18
C135	a_297_82##3	C#6	4.33104e-17
C136	a_89_172##12	C#10	4.76803e-19
C137	C#6	VGND#8	1.90482e-17
C138	a_297_82#	a_89_172##5	2.12844e-17
C139	B#5	B#4	3.97887e-17
C140	a_297_82##3	A_N#5	3.21357e-17
C141	a_89_172##12	C#6	9.4423e-19
C142	A_N#5	VGND#8	1.92394e-17
C143	a_297_82#	C#7	5.79398e-18
C144	VPWR#4	A_N#2	2.13401e-19
C145	a_89_172##12	A_N#5	2.44169e-17
C146	VPWR#2	VPWR#6	1.57457e-17
C147	B#7	B#5	3.97887e-17
C148	a_89_172#	B#7	2.93958e-17
C149	a_89_172##5	a_744_74##8	1.66243e-18
C150	B#9	VPWR#7	1.68058e-17
C151	VPWR#4	VPWR#3	1.613e-18
C152	Y#8	B#9	3.80504e-17
C153	a_89_172##6	a_89_172#	3.69593e-17
C154	VPWR#3	VPWR#2	7.55533e-19
C155	C	C#5	2.20303e-17
C156	VGND#3	VGND#2	1.24986e-18
C157	C	A_N#2	4.15356e-19
C158	Y#8	B#8	4.92184e-17
C159	a_89_172##7	a_89_172##6	3.63721e-17
C160	B#8	VPWR#1	3.54425e-17
C161	A_N#2	C#6	7.50282e-18
C162	a_297_82##3	C#7	1.28571e-17
C163	a_297_82##3	C#5	8.71877e-18
C164	a_744_74#	VPWR#6	2.19988e-18
C165	a_89_172##8	VPWR#1	3.54425e-17
C166	a_297_82#	VPWR#6	1.6785e-16
C167	a_89_172##9	a_89_172##7	3.23022e-17
C168	a_297_82##3	C#9	2.43987e-17
C169	Y#5	a_89_172##8	5.40041e-17
C170	a_297_82#	VPWR#2	9.41264e-17
C171	A_N	C#5	3.62064e-19
C172	VPWR#9	a_89_172##8	3.6043e-18
C173	VGND#1	a_744_74#	5.17879e-17
C174	A_N	A_N#2	3.4327e-17
C175	Y#5	a_89_172##5	6.29337e-17
C176	a_297_82##3	A_N#1	2.45739e-17
C177	VGND#1	a_297_82#	8.92056e-18
C178	C#1	a_89_172##9	4.93782e-18
C179	VPWR#9	a_89_172##5	4.77338e-17
C180	VGND#1	a_744_74##2	4.52048e-17
C181	VPWR#2	a_89_172##4	4.08779e-19
C182	Y#5	C#7	4.92193e-19
C183	VGND#3	C#4	1.48468e-18
C184	a_297_82##3	A_N#4	3.08304e-17
C185	VGND#1	a_744_74##4	3.99074e-17
C186	VPWR#9	C#7	4.47856e-17
C187	a_297_82#	VPWR#3	4.29915e-18
C188	a_297_82##3	A_N#2	2.09951e-17
C189	C#8	C#1	2.61456e-17
C190	Y#5	C#9	2.95198e-19
C191	Y#7	C#7	4.04357e-17
C192	VPWR#4	C#4	1.3737e-18
C193	VGND#1	a_744_74##6	1.1328e-18
C194	B	B#6	2.06811e-17
C195	VPWR#9	C#9	5.1161e-18
C196	Y#7	C#9	3.36805e-17
C197	a_89_172##13	C#7	1.29888e-19
C198	C#10	C#8	1.02725e-17
C199	a_89_172##4	Y#4	4.90718e-18
C200	C#9	VPWR#10	2.64073e-17
C201	a_89_172#	B#8	1.2352e-17
C202	a_744_74#	B#3	4.40772e-19
C203	Y#7	A_N#1	1.17894e-18
C204	a_89_172##13	C#9	1.66424e-18
C205	B#3	a_297_82#	2.77169e-17
C206	A_N#1	VPWR#10	2.88035e-17
C207	B#3	a_744_74##2	1.33367e-18
C208	C#6	C#10	3.54039e-17
C209	VGND#2	a_744_74##6	3.6843e-17
C210	VPWR#6	VPWR#7	5.40891e-17
C211	Y#4	C#4	3.14617e-20
C212	B#3	a_297_82##5	1.59822e-18
C213	a_89_172##13	A_N#1	4.36331e-17
C214	a_89_172##11	C#4	7.53099e-18
C215	VGND#2	a_744_74##8	2.83294e-17
C216	VPWR#5	A_N#1	2.68846e-18
C217	a_297_82#	a_89_172##4	2.7386e-18
C218	VPWR#6	VPWR#1	4.1626e-19
C219	a_297_82##3	VPWR#3	2.50322e-18
C220	a_89_172##13	A_N#4	2.65979e-17
C221	Y	B#6	2.93716e-18
C222	A_N#5	C#6	2.02986e-17
C223	VGND#2	a_297_82##6	8.00549e-18
C224	Y	a_89_172##2	2.28925e-17
C225	A_N#4	VPWR#5	1.40105e-17
C226	a_744_74##6	a_89_172##4	7.24263e-19
C227	a_89_172##4	Y#1	6.12082e-17
C228	VGND#3	VGND#6	2.80301e-18
C229	C#1	a_89_172##5	2.1598e-18
C230	a_89_172##4	a_744_74##8	1.40094e-17
C231	Y#8	B#6	4.31778e-18
C232	a_89_172##4	VGND#6	3.9336e-17
C233	a_89_172##12	A_N#2	4.22308e-18
C234	a_89_172##4	a_297_82##6	3.0348e-17
C235	VPWR#6	B#1	1.70028e-18
C236	VGND#3	a_297_82##6	4.392e-17
C237	VGND#1	B#1	7.93401e-18
C238	a_297_82##6	C#4	3.08734e-18
C239	B#8	B#9	5.02209e-17
C240	VGND#1	B#4	6.0723e-18
C241	Y#4	a_297_82#	6.65679e-17
C242	a_297_82##3	C#4	4.67117e-18
C243	VGND#1	B#5	5.36401e-18
C244	VGND#1	B#7	5.31202e-18
C245	a_89_172##8	B#8	6.64067e-18
C246	VGND#3	VGND#7	1.46901e-17
C247	a_89_172##4	Y#5	9.70593e-17
C248	VGND#1	a_89_172#	5.35194e-18
C249	C#6	A_N#1	7.46479e-18
C250	a_89_172##4	Y#7	4.78974e-18
C251	a_89_172##5	a_89_172##8	1.21582e-17
C252	B#3	B#1	1.93939e-18
C253	C#4	Y#7	2.31327e-18
C254	VGND#2	a_89_172#	6.17256e-20
C255	VGND#3	a_297_82##3	4.43611e-17
C256	C#4	VPWR#10	1.38474e-18
C257	VGND#2	a_89_172##6	5.38448e-18
C258	C#7	a_89_172##5	2.35364e-17
C259	VGND	a_89_172##2	2.07183e-18
C260	a_89_172##13	C#4	1.18446e-19
C261	VGND	C#5	1.68957e-18
C262	VGND#2	a_89_172##7	5.61163e-18
C263	C	Y#4	1.45621e-18
C264	VGND#2	a_89_172##9	6.81639e-18
C265	C#9	C#7	4.93013e-17
C266	a_89_172##11	C	8.92746e-17
C267	VGND#2	C#1	3.49381e-18
C268	a_744_74##4	Y#4	1.62198e-19
C269	VPWR#6	B#9	3.19613e-17
C270	VPWR#6	B#8	4.87411e-18
C271	A_N#1	C#9	2.27047e-18
C272	a_89_172##4	a_89_172##9	2.50541e-18
C273	VPWR#6	a_89_172##8	3.26403e-19
C274	VGND#1	B#8	4.37883e-20
C275	a_89_172##11	A_N	3.45692e-17
C276	a_89_172##4	C#1	2.20479e-17
C277	a_89_172##4	C#8	3.97728e-18
C278	A_N#4	A_N#1	3.90817e-17
C279	a_297_82##3	VPWR#4	1.20565e-16
C280	B#6	VNB	3.29496e-17
C281	a_89_172##2	VNB	1.71017e-17
C282	C#5	VNB	3.54933e-17
C283	VPWR#3	a_89_172##5	3.95039e-18
C284	A_N#2	VNB	7.34979e-17
C285	Y#4	a_89_172##2	1.98738e-18
C286	C	a_297_82##3	2.79842e-17
C287	VPWR#3	C#7	5.25533e-18
C288	VGND#2	a_89_172##5	7.35673e-19
C289	B	a_297_82#	1.88947e-16
C290	a_89_172##4	B#8	3.01389e-18
C291	a_744_74#	a_297_82#	4.53347e-17
C292	a_297_82##5	B	4.96654e-17
C293	a_744_74##4	B	6.8258e-18
C294	a_297_82##3	A_N	8.71595e-17
C295	Y	Y#4	6.96506e-18
C296	A_N	VGND#8	2.47102e-18
C297	A_N	a_89_172##12	4.93967e-17
C298	C	Y#7	5.8658e-17
C299	a_89_172##4	a_89_172##5	1.9206e-17
C300	Y#1	Y#4	2.25139e-18
C301	VPWR	VPWR#4	1.94303e-16
C302	a_89_172##13	C	1.10647e-17
C303	VPWR	VPWR#2	1.44502e-16
C304	C#4	a_89_172##5	1.49894e-17
C305	Y	a_297_82##5	8.04397e-18
C306	a_744_74##4	Y	1.88938e-17
C307	A_N#2	C#5	1.51185e-18
C308	Y	a_744_74##6	4.31687e-17
C309	VPWR	Y#4	3.55032e-18
C310	A_N	a_89_172##13	3.61945e-17
C311	B	Y#8	1.17089e-17
C312	A_N#1	C#4	7.56209e-19
C313	VPWR#6	B#3	6.69869e-18
C314	VGND	VGND#3	8.92257e-17
C315	VGND#1	B#3	2.30247e-19
C316	VPWR	a_297_82#	3.51507e-17
C317	a_297_82#	a_744_74##2	3.47955e-17
C318	B	B#1	2.59613e-18
C319	VPWR#3	a_89_172##4	2.55201e-19
C320	B	B#4	2.94814e-18
C321	VGND	Y#4	2.6905e-18
C322	B	B#5	2.98578e-18
C323	VGND	a_89_172##11	1.24188e-17
C324	VGND#2	a_89_172##4	2.50595e-18
C325	B	B#7	7.00022e-18
C326	VPWR#3	C#4	2.7761e-20
C327	VPWR	a_297_82##3	3.75687e-17
C328	B	a_89_172#	3.85667e-18
C329	VGND#2	C#4	1.80876e-19
C330	VGND	a_297_82#	9.46374e-19
C331	VGND	a_744_74##2	1.53673e-17
C332	Y	B#1	8.79441e-19
C333	A_N	C#6	2.09962e-18
C334	VGND	a_297_82##5	4.8656e-18
C335	VPWR	Y#8	4.04564e-18
C336	VGND#3	VNB	4.00601e-17
C337	Y	B#4	8.40846e-19
C338	VGND	a_744_74##4	2.77938e-17
C339	Y	B#5	1.36009e-18
C340	C	a_89_172##8	2.34394e-19
C341	VPWR	Y#5	6.1468e-18
C342	VPWR#4	VNB	8.0394e-17
C343	VGND	a_744_74##6	2.33265e-17
C344	VPWR#2	VNB	5.41623e-17
C345	Y	B#7	3.99123e-18
C346	VPWR	VPWR#9	2.47882e-17
C347	VGND	Y#1	6.79485e-18
C348	C	a_89_172##5	7.95244e-18
C349	VGND	a_744_74##8	2.04477e-17
C350	VPWR	Y#7	4.39082e-18
C351	Y	a_89_172#	1.59214e-17
C352	a_89_172##4	C#4	1.32428e-17
C353	Y	a_89_172##6	1.80785e-17
C354	C	C#7	2.0984e-18
C355	VGND	a_297_82##6	1.75425e-17
C356	VPWR	a_89_172##13	4.66028e-18
C357	VPWR	VPWR#5	7.07863e-17
C358	C	C#9	3.94856e-18
C359	VGND	a_297_82##3	4.45014e-17
C360	Y#4	VNB	2.08449e-18
C361	a_89_172##11	VNB	3.37367e-18
C362	VGND	a_89_172##12	4.6557e-18
C363	C	A_N#1	5.30563e-18
C364	VGND	Y#8	3.91976e-18
C365	a_744_74#	VNB	2.6103e-17
C366	a_297_82#	VNB	5.05348e-17
C367	VGND	Y#5	4.71401e-18
C368	a_744_74##2	VNB	3.93602e-18
C369	a_744_74##4	VNB	4.58006e-18
C370	a_744_74##2	a_297_82##5	3.47923e-17
C371	a_744_74##6	VNB	4.12807e-18
C372	Y#1	VNB	1.47967e-19
C373	a_744_74##8	VNB	6.39277e-18
C374	VGND#6	VNB	5.94549e-18
C375	a_297_82##6	VNB	2.79817e-18
C376	Y	B#8	8.10402e-18
C377	a_297_82##3	VNB	8.89801e-17
C378	VGND	B#5	7.08146e-19
C379	Y	a_89_172##8	1.53213e-19
C380	VGND	B#7	8.21916e-19
C381	a_89_172##12	VNB	3.59019e-18
C382	Y	a_89_172##5	2.69913e-19
C383	VGND	a_89_172#	2.09062e-18
C384	Y#8	VNB	3.71116e-19
C385	VGND	a_89_172##6	1.11465e-18
C386	VGND	a_89_172##7	7.25465e-19
C387	Y#5	VNB	1.19665e-18
C388	VPWR	B#9	3.24031e-19
C389	VGND	a_89_172##9	1.20029e-18
C390	VPWR#9	VNB	1.76122e-19
C391	VPWR#6	B	2.93961e-18
C392	VPWR	B#8	3.69314e-19
C393	VGND	C#1	4.89264e-18
C394	a_89_172##4	C	6.63348e-17
C395	VGND	C#8	9.88862e-18
C396	VPWR	a_89_172##8	3.84275e-19
C397	VGND#1	B	2.88262e-18
C398	VGND	C#10	9.2755e-18
C399	VPWR#5	VNB	7.63217e-17
C400	VPWR	a_89_172##5	3.9832e-19
C401	C	C#4	5.38919e-17
C402	B#1	VNB	6.69305e-17
C403	VGND	C#6	1.02929e-17
C404	VPWR	C#7	1.07446e-18
C405	B#4	VNB	2.94666e-17
C406	VGND	A_N#5	9.88862e-18
C407	B#5	VNB	2.91432e-17
C408	VPWR	C#9	3.36301e-19
C409	B#7	VNB	2.84203e-17
C410	a_89_172#	VNB	4.07292e-17
C411	VPWR	A_N#1	7.90155e-18
C412	B	B#3	5.07175e-17
C413	a_89_172##6	VNB	2.67699e-17
C414	VGND	B#8	8.62715e-19
C415	VPWR	A_N#4	1.04056e-17
C416	a_89_172##7	VNB	2.68352e-17
C417	B	a_89_172##4	1.22339e-18
C418	a_89_172##9	VNB	3.63228e-17
C419	C#1	VNB	2.77365e-17
C420	VGND	a_89_172##5	2.76143e-21
C421	C#8	VNB	2.94429e-17
C422	VPWR	VPWR#6	1.01666e-16
C423	C#10	VNB	2.96667e-17
C424	C#6	VNB	3.92263e-17
C425	A_N#5	VNB	4.5482e-17
C426	VGND	A_N#1	3.43842e-20
C427	a_89_172##4	Y	2.71072e-17
C428	VPWR	VPWR#3	8.37021e-17
C429	B#9	VNB	3.0338e-17
C430	Y	C#4	4.14765e-19
C431	B#8	VNB	4.26654e-17
C432	a_89_172##11	C#5	9.01855e-18
C433	a_89_172##8	VNB	3.5158e-17
C434	VPWR#2	VPWR#1	8.69994e-18
C435	a_89_172##5	VNB	5.89077e-17
C436	VGND	VGND#1	8.57918e-17
C437	VPWR	a_89_172##4	6.45989e-18
C438	C#7	VNB	3.06453e-17
C439	a_297_82##6	a_89_172##11	3.57507e-17
C440	C#9	VNB	3.16522e-17
C441	A_N#1	VNB	3.74105e-17
C442	VGND	VGND#2	1.64087e-16
C443	A_N#4	VNB	3.49103e-17
C444	VGND	a_89_172##4	1.64922e-17
C445	VPWR#6	VNB	2.01859e-16
C446	a_744_74##4	a_297_82##5	1.51849e-17
C447	VGND#1	VNB	1.76008e-16
C448	VPWR#3	VNB	4.28439e-17
C449	VGND#2	VNB	7.81173e-17
C450	C	Y	1.33189e-18
C451	B#3	VNB	7.92978e-17
C452	a_89_172##4	VNB	9.39492e-17
C453	C#4	VNB	8.93691e-17
C454	VPWR	C	1.32969e-17
C455	Y	B	1.70824e-17
C456	VPWR	A_N	5.19511e-18
C457	VGND	C	8.4992e-18
C458	VPWR	B	5.40534e-18
C459	VGND	A_N	4.76124e-18
C460	A_N#1	C#5	5.9453e-18
C461	VGND	B	6.08948e-18
C462	C	VNB	1.6653e-17
C463	A_N	VNB	1.20378e-17
C464	VGND	Y	9.85547e-18
C465	B	VNB	7.84952e-18
C466	Y	VNB	4.1245e-18
C467	VPWR	VNB	2.63778e-16
C468	VGND	VNB	3.13781e-16
C469	a_89_172##11	VGND#7	1.31393e-18
C470	VGND#4	A_N#2	9.87421e-19
C471	VGND#4	VNB	6.69553e-17
C472	VGND#4	VGND#8	7.93669e-18
C473	VGND#4	C#5	2.83537e-20
C474	VGND#4	A_N#5	1.34199e-17
C475	VGND#4	C#8	3.10064e-19
C476	VGND#4	C#10	1.54833e-18
C477	VGND#4	VGND#3	4.15769e-18
C478	VGND#4	A_N#1	2.21793e-19
C479	VGND	VGND#4	1.16996e-16
C480	VGND#4	a_297_82##3	7.25107e-17
C481	VGND#4	C#6	9.15536e-18
*
*
.ENDS sky130_fd_sc_hs__nand3b_4
*
