* Extracted by Quantus, converted by sky130cad/quantus.py
*
*
*
*                       LINUX           Wed Nov 18 08:56:35 2026
*
*
*
*  PROGRAM  advgen
*
*  Name           : advgen - Quantus - (64-bit)
*  Version        : 25.1.0-p047
*  Build Date     : Thu Dec 11 23:20:30 PST 2025
*
*  HSPICE LIBRARY
*
*  OPERATING_TEMPERATURE 150
*  QRC_TECH_DIR <path>/tech
*
*
*

*
.SUBCKT sky130_fd_sc_hs__o21bai_1 VNB VPB VGND VPWR Y A2 A1 B1_N
*
*
*  caps2d version: 10
*
*
*       TRANSISTOR CARDS
*
*
XM1 a_27_74##7 B1_N#3 VGND#7 VNB sky130_fd_pr__nfet_01v8_lvt l=0.15 w=0.55 ad=0.154 as=0.15125 pd=1.66 ps=1.65
XM7 Y#3 a_27_74# a_308_74##2 VNB sky130_fd_pr__nfet_01v8_lvt l=0.15 w=0.74 ad=0.2072 as=0.2442 pd=2.04 ps=2.14
XM3 a_308_74##2 A2#1 VGND#6 VNB sky130_fd_pr__nfet_01v8_lvt l=0.15 w=0.74 ad=0.2442 as=0.2146 pd=2.14 ps=2.06
XM2 VGND#6 A1#4 a_308_74# VNB sky130_fd_pr__nfet_01v8_lvt l=0.15 w=0.74 ad=0.2146 as=0.2109 pd=2.06 ps=2.05
XM6 a_27_74##5 B1_N#1 VPWR#5 VPB sky130_fd_pr__pfet_01v8 l=0.15 w=0.84 ad=0.2478 as=0.7252 pd=2.27 ps=3.79
XM0 VPWR#5 a_27_74##4 Y#1 VPB sky130_fd_pr__pfet_01v8 l=0.15 w=1.12 ad=0.7252 as=0.336 pd=3.79 ps=2.84
XM5 Y#1 A2#3 a_395_368# VPB sky130_fd_pr__pfet_01v8 l=0.15 w=1.12 ad=0.336 as=0.3696 pd=2.84 ps=2.9
XM4 a_395_368# A1#3 VPWR#1 VPB sky130_fd_pr__pfet_01v8 l=0.15 w=1.12 ad=0.3696 as=0.3248 pd=2.9 ps=2.82
*
*
*       RESISTOR AND CAP/DIODE CARDS
*
Rg1	B1_N#1	B1_N#2	441.253784
Rg2	B1_N#2	B1_N#3	494.442841
Rg3	a_27_74#	a_27_74##2	343.439178
Rg4	a_27_74##2	a_27_74##3	331.431641
Rg5	a_27_74##2	a_27_74##4	525.154541
Rg6	A2#1	A2#2	366.265259
Rg7	A2#2	A2#3	465.025360
Rg8	A1#1	A1#2	27.660566
Rg9	A1#2	A1#3	471.862823
Rg10	A1#2	A1#4	368.862610
Rf1	B1_N#4	B1_N	0.747289
Rf2	B1_N#2	B1_N#6	160.980087
Rf3	B1_N#4	B1_N#6	6.298763
Rf4	a_27_74##5	a_27_74##3	89.475182
Rf5	a_27_74##3	a_27_74##7	89.701164
Rf6	Y	Y#2	0.178802
Rf7	Y#2	Y	13.052517
Rf8	Y	Y#3	94.059708
Rf9	Y#1	Y#2	5.000000
Rf10	A2	A2#2	175.334122
Rf11	a_308_74#	a_308_74##2	108.957901
Rf12	A1	A1#1	168.106262
Rf13	VPWR#1	VPWR#2	131.642075
Rf14	VPWR#2	VPWR#3	34.357212
Rf16	VPWR#3	VPWR#5	15.889553
Rf18	VGND#2	VGND#3	52.931389
Rf19	VGND#3	VGND#4	53.667580
Rf21	VGND#2	VGND#6	31.473843
Rf22	VGND#4	VGND#7	37.066368
Re1	VPWR#2	VPWR	1.637070
Re2	VGND	VGND#3	1.637131
*
*       CAPACITOR CARDS
*
*
C1	VGND#3	a_27_74##2	4.77407e-20
C2	A1#1	A1#2	1.40212e-17
C3	A2#2	A1#2	3.64282e-17
C4	a_27_74##2	A2#2	3.82818e-17
C5	a_27_74##3	a_27_74##2	1.31491e-17
C6	B1_N#2	a_27_74##2	3.80606e-19
C7	a_308_74#	A1#2	6.99472e-18
C8	a_308_74#	VGND#6	4.01604e-17
C9	a_308_74##2	a_308_74#	4.64926e-18
C10	a_308_74##2	VGND#6	3.97198e-17
C11	Y#3	a_308_74##2	6.81495e-17
C12	VGND#7	VGND#6	1.05355e-18
C13	VGND#7	Y#3	4.7926e-17
C14	a_27_74##7	Y#3	2.52083e-18
C15	a_27_74##7	VGND#7	5.02741e-17
C16	a_308_74#	A1#4	3.64492e-17
C17	Y#3	A1#2	1.96687e-19
C18	Y#3	VPWR#5	2.13891e-18
C19	A1	A1#2	1.07629e-17
C20	VGND#6	A1#4	3.08767e-17
C21	a_308_74#	A2#1	1.74137e-18
C22	Y#3	a_27_74##2	7.70553e-18
C23	a_308_74##2	A1#4	1.66109e-18
C24	VGND#6	A2#1	3.01558e-17
C25	a_308_74#	a_27_74#	5.7644e-19
C26	Y#3	A1#4	4.28084e-19
C27	a_308_74##2	A2#1	2.6133e-17
C28	VPWR#5	VPWR#1	6.53548e-19
C29	VGND#6	a_27_74#	2.25355e-18
C30	Y#3	A2#1	2.16384e-18
C31	a_27_74#	a_308_74##2	2.03563e-17
C32	VGND#6	B1_N#3	4.76005e-19
C33	VGND#7	A2#1	2.27475e-19
C34	Y#3	a_27_74#	5.08053e-17
C35	A2	A1#2	7.74429e-19
C36	VPWR#5	Y#1	3.9947e-17
C37	VGND#7	a_27_74#	1.93482e-18
C38	Y#3	B1_N#3	2.74032e-18
C39	a_27_74##5	Y#1	2.36444e-18
C40	a_27_74##7	a_27_74#	5.54862e-19
C41	VGND#7	B1_N#3	3.86565e-17
C42	a_27_74##5	VPWR#5	9.43199e-17
C43	a_27_74##7	B1_N#3	1.83255e-17
C44	Y	A1#2	8.95276e-20
C45	Y	a_27_74##2	9.70758e-18
C46	A1#3	VPWR#1	3.91892e-17
C47	A2#1	A1#4	3.70329e-17
C48	VPWR#1	A2#3	3.13744e-18
C49	Y#1	A1#3	1.02168e-18
C50	a_27_74#	A2#1	3.27974e-17
C51	VPWR#1	a_27_74##4	4.83429e-19
C52	VPWR#5	A1#3	8.18258e-19
C53	Y#1	A2#3	3.95957e-17
C54	A1#2	VPWR#1	5.76769e-18
C55	VPWR#1	B1_N#1	2.91115e-19
C56	VPWR#5	A2#3	1.39645e-18
C57	Y#1	a_27_74##4	3.66442e-17
C58	B1_N#3	a_27_74#	5.4119e-18
C59	VGND#3	a_308_74##2	9.87716e-18
C60	a_27_74##4	VPWR#5	3.54059e-17
C61	A1#1	a_308_74#	3.97924e-17
C62	Y#1	B1_N#1	1.17185e-18
C63	VGND#3	Y#3	2.04568e-17
C64	a_27_74##5	a_27_74##4	2.84768e-18
C65	B1_N#1	VPWR#5	4.20361e-17
C66	VPWR#2	VPWR#1	3.11029e-17
C67	a_308_74#	A2#2	1.71622e-17
C68	a_27_74##5	B1_N#1	5.30627e-17
C69	A2#2	a_308_74##2	4.0347e-17
C70	Y#3	A2#2	6.31436e-18
C71	VGND	A1#2	8.2883e-19
C72	VGND	a_27_74##2	6.32898e-19
C73	a_27_74##3	Y#3	3.85874e-17
C74	A2#3	A1#3	4.31045e-17
C75	VGND#7	a_27_74##3	3.3368e-17
C76	Y#3	B1_N#2	2.88674e-19
C77	a_27_74##4	A2#3	4.80788e-17
C78	a_27_74##7	B1_N#2	8.26111e-18
C79	VGND#3	a_27_74#	2.86218e-18
C80	a_308_74#	a_395_368#	1.41272e-19
C81	a_27_74##3	VPWR#5	1.31552e-17
C82	B1_N#1	a_27_74##4	7.40517e-18
C83	a_27_74##3	a_27_74##5	2.90941e-18
C84	VPWR#2	A2#3	7.84669e-18
C85	B1_N#2	a_27_74##5	2.74604e-17
C86	VPWR#2	a_27_74##4	5.34665e-18
C87	a_27_74##3	a_27_74#	2.4483e-19
C88	a_27_74##3	B1_N#3	9.15259e-18
C89	B1_N#2	a_27_74#	1.25508e-19
C90	a_27_74##4	A2#2	4.72651e-18
C91	a_27_74##3	a_27_74##4	1.61454e-18
C92	a_27_74##7	B1_N	1.73997e-17
C93	B1_N#2	a_27_74##4	3.54667e-18
C94	A2#2	VPWR#2	4.12734e-19
C95	A1#3	a_395_368#	8.10617e-18
C96	VGND#3	A2#2	4.9791e-20
C97	A1#2	VNB	5.9151e-17
C98	a_27_74##2	VNB	1.73768e-17
C99	A2#3	a_395_368#	1.44024e-17
C100	A1	VPWR#1	2.63638e-17
C101	A2#2	A1#1	1.98531e-17
C102	B1_N	a_27_74##5	1.66195e-17
C103	VGND#3	a_27_74##3	7.56874e-20
C104	A2	VPWR#1	6.19935e-17
C105	a_308_74##2	Y	5.00042e-18
C106	Y#1	A2	3.56905e-17
C107	a_27_74##3	B1_N#2	9.60229e-17
C108	Y	VPWR#1	2.74588e-18
C109	Y	Y#1	4.90344e-19
C110	A1	A1#3	6.10406e-18
C111	A2#2	a_395_368#	1.30483e-19
C112	Y	VPWR#5	3.43182e-17
C113	A1	A2#3	2.13578e-19
C114	a_27_74##5	Y	9.89529e-18
C115	VPWR	VPWR#1	3.91425e-17
C116	A2	A1#3	2.35059e-17
C117	A2	A2#3	1.64109e-17
C118	VGND	a_308_74#	1.51909e-17
C119	VGND	VGND#6	1.88111e-17
C120	VPWR	VPWR#5	3.77653e-17
C121	A2	a_27_74##4	6.12243e-19
C122	VGND	a_308_74##2	1.26195e-17
C123	VPWR	a_27_74##5	1.82359e-17
C124	VGND	Y#3	1.86794e-17
C125	Y	A1#3	2.79951e-18
C126	VGND	a_27_74##7	1.37166e-17
C127	Y	A2#3	2.54338e-17
C128	A2	VPWR#2	6.33881e-18
C129	Y	a_27_74##4	3.10868e-17
C130	A2#2	A1	1.1104e-17
C131	Y	B1_N#1	9.75209e-19
C132	B1_N	B1_N#2	9.83165e-18
C133	VPWR	A1#3	5.43617e-18
C134	VGND	A1#4	1.47119e-18
C135	VPWR	A2#3	2.1189e-18
C136	Y	VPWR#2	1.83106e-17
C137	VGND	A2#1	7.9465e-19
C138	A2	A2#2	8.82174e-19
C139	VGND	a_27_74#	3.02876e-18
C140	VPWR	B1_N#1	1.29416e-18
C141	VGND	B1_N#3	1.26708e-18
C142	Y	A2#2	2.91629e-17
C143	VPWR	VPWR#2	2.05071e-17
C144	a_27_74##3	Y	3.57554e-17
C145	Y	B1_N#2	1.72772e-18
C146	A2	a_395_368#	3.80158e-17
C147	a_308_74#	VNB	4.10543e-17
C148	VPWR	A2#2	2.29558e-18
C149	VGND#6	VNB	2.45884e-18
C150	a_308_74##2	VNB	6.47218e-18
C151	VPWR	a_27_74##3	1.59953e-18
C152	Y#3	VNB	1.08274e-17
C153	VGND#7	VNB	9.6704e-18
C154	VGND	VGND#3	1.43206e-17
C155	a_27_74##7	VNB	5.33619e-17
C156	VPWR	B1_N#2	1.05749e-18
C157	VPWR#1	VNB	7.89912e-17
C158	VGND	A1#1	3.97608e-18
C159	VGND	A2#2	5.09008e-18
C160	VPWR#5	VNB	5.24886e-18
C161	a_27_74##5	VNB	5.27879e-17
C162	VGND	a_27_74##3	8.96012e-18
C163	A1#4	VNB	2.95446e-17
C164	A2#1	VNB	2.42762e-17
C165	VGND	B1_N#2	1.12201e-18
C166	A2	A1	1.79835e-17
C167	a_27_74#	VNB	3.02727e-17
C168	B1_N#3	VNB	4.34529e-17
C169	A1#3	VNB	4.23505e-17
C170	A2#3	VNB	3.39851e-17
C171	VPWR	B1_N	2.06983e-18
C172	a_27_74##4	VNB	4.4646e-17
C173	B1_N#1	VNB	4.3033e-17
C174	Y	A2	4.60619e-17
C175	VPWR	A1	2.58286e-18
C176	VPWR#2	VNB	1.62927e-16
C177	VGND#3	VNB	1.58368e-16
C178	VGND	B1_N	1.16949e-18
C179	VPWR	A2	1.30695e-17
C180	A1#1	VNB	9.06625e-18
C181	A2#2	VNB	3.19563e-17
C182	a_27_74##3	VNB	4.98679e-17
C183	VPWR	Y	1.88587e-17
C184	B1_N#2	VNB	6.88243e-17
C185	VGND	Y	3.88212e-18
C186	B1_N	VNB	2.08953e-17
C187	A1	VNB	1.1602e-17
C188	A2	VNB	4.26549e-18
C189	Y	VNB	7.54967e-18
C190	VPWR	VNB	5.97244e-17
C191	VGND	VNB	6.22975e-17
C192	VGND#4	Y#3	2.40756e-18
C193	VPWR#3	VPWR#1	3.88813e-19
C194	VGND#4	B1_N#2	6.28006e-20
C195	VGND#4	A2#1	2.392e-19
C196	VGND#4	a_27_74##7	1.7559e-17
C197	VPWR#2	VPWR#3	5.81922e-17
C198	VGND#2	a_308_74#	1.78605e-17
C199	VGND#4	B1_N#3	7.71256e-18
C200	VGND#3	VGND#2	4.88168e-17
C201	VGND#2	A2#1	1.24484e-18
C202	VGND#2	a_308_74##2	4.03245e-18
C203	VGND#4	a_27_74##3	1.07426e-18
C204	VGND#2	A2#2	2.8703e-20
C205	VGND#4	VGND#2	4.18515e-19
C206	VPWR#3	B1_N#2	5.78763e-20
C207	VGND#2	A1#2	3.11098e-19
C208	VGND	VGND#2	3.0444e-17
C209	VPWR	VPWR#3	3.74275e-17
C210	VPWR#3	VNB	5.24289e-17
C211	VGND#4	a_27_74#	1.28333e-18
C212	VGND	VGND#4	5.41121e-17
C213	a_27_74##5	VPWR#3	2.09699e-17
C214	VGND#2	A1#4	1.24864e-18
C215	VGND#3	VGND#4	4.85545e-17
C216	VGND#2	VNB	4.48549e-17
C217	VPWR#3	B1_N#1	2.57793e-18
C218	VGND#4	VNB	4.68583e-17
C219	VGND#4	VGND#6	2.09789e-20
C220	VGND#2	A1#1	5.01029e-19
C221	B1_N	VPWR#3	4.90802e-19
*
*
.ENDS sky130_fd_sc_hs__o21bai_1
*
