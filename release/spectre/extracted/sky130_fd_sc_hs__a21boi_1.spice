* Extracted by Quantus, converted by sky130cad/quantus.py
*
*
*
*                       LINUX           Wed Nov 18 08:04:18 2026
*
*
*
*  PROGRAM  advgen
*
*  Name           : advgen - Quantus - (64-bit)
*  Version        : 25.1.0-p047
*  Build Date     : Thu Dec 11 23:20:30 PST 2025
*
*  HSPICE LIBRARY
*
*  OPERATING_TEMPERATURE 150
*  QRC_TECH_DIR <path>/tech
*
*
*

*
.SUBCKT sky130_fd_sc_hs__a21boi_1 VPB VNB VGND VPWR Y B1_N A2 A1
*
*
*  caps2d version: 10
*
*
*       TRANSISTOR CARDS
*
*
XM6 a_29_424##8 B1_N#1 VGND#6 VNB sky130_fd_pr__nfet_01v8_lvt l=0.15 w=0.55 ad=0.14575 as=0.34185 pd=1.63 ps=2.54
XM4 VGND#6 a_29_424# Y#3 VNB sky130_fd_pr__nfet_01v8_lvt l=0.15 w=0.74 ad=0.34185 as=0.2072 pd=2.54 ps=2.04
XM3 Y#3 A1#3 a_437_74# VNB sky130_fd_pr__nfet_01v8_lvt l=0.15 w=0.74 ad=0.2072 as=0.2368 pd=2.04 ps=2.12
XM7 a_437_74# A2#3 VGND#4 VNB sky130_fd_pr__nfet_01v8_lvt l=0.15 w=0.74 ad=0.2368 as=0.2109 pd=2.12 ps=2.05
XM1 a_29_424##7 B1_N#4 VPWR#7 VPB sky130_fd_pr__pfet_01v8 l=0.15 w=0.84 ad=0.231 as=0.231 pd=2.23 ps=2.23
XM5 Y#1 a_29_424##4 a_348_368##2 VPB sky130_fd_pr__pfet_01v8 l=0.15 w=1.12 ad=0.308 as=0.336 pd=2.79 ps=2.84
XM2 a_348_368##2 A1#1 VPWR#6 VPB sky130_fd_pr__pfet_01v8 l=0.15 w=1.12 ad=0.336 as=0.3696 pd=2.84 ps=2.9
XM0 VPWR#6 A2#1 a_348_368# VPB sky130_fd_pr__pfet_01v8 l=0.15 w=1.12 ad=0.3696 as=0.308 pd=2.9 ps=2.79
*
*
*       RESISTOR AND CAP/DIODE CARDS
*
Rg1	B1_N#1	B1_N#2	500.607422
Rg2	B1_N#2	B1_N#3	87.676392
Rg3	B1_N#2	B1_N#4	520.505798
Rg4	a_29_424#	a_29_424##2	322.953644
Rg5	a_29_424##2	a_29_424##3	24.690777
Rg6	a_29_424##2	a_29_424##4	507.075531
Rg7	A1#1	A1#2	434.639221
Rg8	A1#2	A1#3	382.539734
Rg9	A2#1	A2#2	492.059540
Rg10	A2#2	A2#3	307.937683
Rf1	B1_N	B1_N#3	14.369054
Rf2	B1_N#3	B1_N	0.196836
Rf3	a_29_424##3	a_29_424##6	179.936127
Rf4	a_29_424##6	a_29_424##7	97.516273
Rf5	a_29_424##6	a_29_424##8	47.884468
Rf6	Y	Y#2	10.910419
Rf7	Y#2	Y	0.149458
Rf8	Y#2	Y#3	125.558876
Rf9	Y#1	Y#2	5.000000
Rf10	A1#2	A1#5	160.691208
Rf11	A1#6	A1	0.458404
Rf12	A1#5	A1#6	7.674406
Rf13	a_348_368#	a_348_368##2	97.018173
Rf14	A2	A2#4	15.884235
Rf15	A2#4	A2	1.058949
Rf17	VGND#2	VGND#3	81.426765
Rf18	VGND#2	VGND#4	32.026825
Rf20	VGND#3	VGND#6	22.996525
Rf22	VPWR#2	VPWR#3	49.284554
Rf23	VPWR#3	VPWR#4	67.239273
Rf25	VPWR#2	VPWR#6	30.747387
Rf26	VPWR#4	VPWR#7	43.213310
Rf30	A2#2	A2#4	160.232803
Re1	VPWR#3	VPWR	1.403190
Re2	VGND	VGND#3	1.403242
*
*       CAPACITOR CARDS
*
*
C1	B1_N#2	a_29_424##4	9.92516e-19
C2	B1_N#2	a_29_424##3	2.99086e-18
C3	a_29_424##6	B1_N#2	1.73454e-17
C4	Y#3	A1#5	1.47921e-17
C5	a_29_424##6	Y#3	1.98365e-18
C6	A1#6	a_348_368##2	1.32601e-17
C7	a_29_424##6	a_29_424##8	8.07282e-19
C8	Y#3	VGND#4	2.03533e-17
C9	VGND#6	VGND#4	2.14391e-19
C10	VGND#6	Y#3	5.40268e-17
C11	a_29_424##8	Y#3	8.91077e-19
C12	a_29_424##6	VPWR#7	2.70812e-17
C13	a_29_424##8	VGND#6	4.55526e-17
C14	Y#3	a_348_368##2	2.40673e-18
C15	a_348_368#	VPWR#6	8.40509e-17
C16	a_29_424##6	a_29_424#	3.85164e-19
C17	VGND#4	A2#3	3.75242e-17
C18	a_348_368##2	a_348_368#	2.48431e-18
C19	A1#6	A2#1	2.50106e-18
C20	a_348_368##2	VPWR#6	6.44785e-17
C21	VGND#4	A1#3	7.9095e-18
C22	a_29_424##6	B1_N#1	1.8881e-17
C23	Y#3	A2#3	8.08735e-18
C24	A1#6	A1#1	2.64459e-18
C25	VGND#4	a_29_424#	5.52967e-19
C26	a_29_424##8	a_29_424##7	6.48697e-19
C27	VGND#6	A2#3	5.22207e-20
C28	Y#3	A1#3	4.72234e-17
C29	VPWR#7	VPWR#6	1.15725e-18
C30	VGND#6	A1#3	1.29326e-18
C31	A1#6	a_29_424##4	1.07748e-18
C32	Y#3	a_29_424#	2.04086e-17
C33	VGND#6	a_29_424#	5.17083e-17
C34	Y#3	B1_N#1	1.4418e-18
C35	B1_N	B1_N#2	2.68065e-17
C36	B1_N#2	a_29_424##8	4.87914e-18
C37	a_29_424##8	a_29_424#	2.11049e-19
C38	B1_N#1	VGND#6	1.66067e-17
C39	a_29_424##6	a_29_424##4	1.61816e-18
C40	a_29_424##8	B1_N#1	3.26679e-17
C41	a_29_424##7	VPWR#7	6.56171e-17
C42	Y	B1_N#2	1.50993e-18
C43	a_348_368#	A2#1	4.6294e-17
C44	A2#1	VPWR#6	3.68007e-17
C45	A1#3	A2#3	3.5581e-17
C46	VPWR#7	B1_N#1	8.74604e-19
C47	a_348_368#	A1#1	2.97876e-18
C48	A1#6	A2#2	1.80217e-18
C49	a_348_368##2	A2#1	1.67835e-18
C50	A1#1	VPWR#6	3.68256e-17
C51	a_348_368#	a_29_424##4	8.67598e-19
C52	A1#5	A2#2	3.56874e-18
C53	a_348_368##2	A1#1	3.53431e-17
C54	a_29_424#	A1#3	3.78389e-17
C55	A1#6	A1#2	5.0872e-18
C56	VPWR#6	a_29_424##4	2.66682e-18
C57	VPWR#7	A2#1	2.41605e-19
C58	a_348_368#	B1_N#4	1.7807e-19
C59	a_348_368##2	a_29_424##4	4.93031e-17
C60	A1#5	A1#2	9.4987e-18
C61	VPWR#6	B1_N#4	5.39727e-19
C62	VPWR#7	A1#1	3.37167e-19
C63	VPWR	B1_N#2	3.75011e-21
C64	A1#6	a_29_424##3	6.01979e-19
C65	a_29_424##4	Y#1	1.1235e-17
C66	B1_N#1	a_29_424#	1.25395e-17
C67	a_348_368##2	B1_N#4	8.80222e-20
C68	VPWR#7	a_29_424##4	2.07888e-18
C69	A2#2	VGND#4	4.65144e-18
C70	A1#5	a_29_424##3	1.94916e-18
C71	a_29_424##7	a_29_424##4	1.81925e-19
C72	B1_N#4	VPWR#7	3.71536e-17
C73	Y#3	A2#2	1.34607e-18
C74	a_29_424##6	a_29_424##3	3.76128e-19
C75	a_29_424##7	B1_N#4	5.16715e-17
C76	a_348_368##2	VPWR#3	1.54444e-17
C77	Y#3	A1#2	5.08052e-18
C78	a_29_424##6	B1_N#3	5.28323e-19
C79	a_348_368#	A2#2	2.71701e-18
C80	Y#3	a_29_424##3	1.76744e-17
C81	VGND	B1_N#2	1.83637e-18
C82	a_29_424##3	VGND#6	4.49036e-17
C83	A1#1	A2#1	4.16018e-17
C84	A1#2	VPWR#6	7.83709e-19
C85	a_348_368##2	A1#2	1.18066e-18
C86	VGND#6	B1_N#3	2.19188e-18
C87	a_29_424##4	A1#1	4.70418e-17
C88	a_29_424##8	B1_N#3	1.33711e-17
C89	A1#3	A2#2	2.13066e-18
C90	B1_N#4	a_29_424##4	4.46651e-18
C91	B1_N#2	VNB	8.17635e-17
C92	a_29_424##3	A1#3	2.88821e-18
C93	VPWR#3	a_29_424##4	5.46685e-18
C94	B1_N#1	a_29_424##3	1.76601e-17
C95	A1#2	A2#1	2.62477e-18
C96	B1_N#3	a_29_424#	9.85505e-19
C97	B1_N#3	B1_N#1	2.4049e-17
C98	A1#5	A2	2.10001e-17
C99	a_29_424##4	A1#2	3.03975e-18
C100	VGND#4	A2	4.16151e-17
C101	A2#3	a_437_74#	2.11762e-17
C102	A1#3	a_437_74#	2.06918e-17
C103	Y#3	A2	5.33253e-18
C104	B1_N	a_29_424##6	2.90212e-17
C105	VPWR#3	a_29_424##3	1.75027e-19
C106	Y	A1#6	1.74535e-17
C107	A2	a_348_368#	3.44737e-17
C108	A1#2	A2#2	3.35847e-17
C109	VPWR#7	B1_N#2	1.03902e-18
C110	Y	A1#5	1.71296e-17
C111	B1_N	VGND#6	5.52961e-18
C112	a_29_424##6	Y	2.72909e-17
C113	B1_N	a_29_424##8	4.69302e-17
C114	a_29_424##3	A1#2	3.36793e-17
C115	VPWR	A1#6	2.53807e-18
C116	VGND#6	Y	3.03591e-18
C117	VPWR	a_29_424##6	3.82964e-18
C118	Y	a_348_368#	5.23415e-18
C119	B1_N	a_29_424##7	3.3998e-17
C120	Y	a_348_368##2	8.65391e-17
C121	Y	Y#1	1.1365e-17
C122	B1_N	a_29_424#	1.36568e-18
C123	VPWR#7	Y	7.14486e-17
C124	B1_N	B1_N#1	2.557e-18
C125	VGND	A1#5	5.29958e-18
C126	a_29_424##7	Y	2.87903e-18
C127	VPWR	a_348_368#	1.77016e-17
C128	VGND	a_29_424##6	1.77335e-18
C129	VPWR	VPWR#6	2.19714e-17
C130	VPWR	a_348_368##2	1.64957e-17
C131	VGND	VGND#4	2.23155e-17
C132	VGND	Y#3	1.57791e-17
C133	VPWR	a_29_424##7	1.81384e-17
C134	VGND	a_29_424##8	1.32506e-17
C135	Y	A2#1	1.4135e-18
C136	A1#6	VNB	3.52872e-18
C137	VGND	a_348_368#	2.87363e-18
C138	Y	A1#1	4.01575e-18
C139	A2	A2#2	3.01322e-17
C140	A1#5	VNB	1.57829e-18
C141	Y	a_29_424##4	3.24762e-17
C142	a_29_424##7	B1_N#2	1.63201e-17
C143	VPWR	B1_N#1	1.29254e-18
C144	a_29_424##6	VNB	1.22838e-17
C145	A2	A1#2	5.08495e-18
C146	Y	B1_N#4	4.13002e-18
C147	VGND#4	VNB	3.28948e-17
C148	VGND	a_29_424##7	4.80112e-18
C149	VPWR	A2#1	1.7383e-18
C150	A2	a_29_424##3	5.62029e-19
C151	VGND	A2#3	3.48023e-19
C152	VPWR	A1#1	2.91945e-19
C153	Y#3	VNB	2.8488e-18
C154	Y	VPWR#3	1.874e-17
C155	VGND	A1#3	1.09258e-18
C156	VGND#6	VNB	1.45874e-18
C157	VPWR	a_29_424##4	2.7821e-18
C158	VGND	a_29_424#	3.25294e-18
C159	a_348_368#	VNB	5.61796e-17
C160	VPWR	B1_N#4	1.37152e-18
C161	B1_N	a_29_424##3	3.72903e-19
C162	VGND	B1_N#1	7.41082e-18
C163	VPWR#6	VNB	3.83388e-18
C164	a_348_368##2	VNB	2.51612e-18
C165	B1_N	B1_N#3	4.69128e-17
C166	Y	A1#2	5.27852e-18
C167	VPWR	VPWR#3	1.73806e-17
C168	VPWR#7	VNB	1.31727e-17
C169	a_29_424##7	VNB	5.92907e-17
C170	Y	a_29_424##3	5.80137e-17
C171	A2#3	VNB	2.31755e-17
C172	A1#3	VNB	2.50187e-17
C173	a_29_424#	VNB	2.58367e-17
C174	B1_N#1	VNB	5.02025e-17
C175	VPWR	a_29_424##3	1.91897e-18
C176	A2#1	VNB	4.49267e-17
C177	A1#1	VNB	2.91144e-17
C178	a_29_424##4	VNB	3.79301e-17
C179	VGND	A1#2	1.18618e-18
C180	B1_N#4	VNB	5.64568e-17
C181	VGND	a_29_424##3	4.41434e-18
C182	VPWR#3	VNB	1.75782e-16
C183	VGND	B1_N#3	8.52149e-18
C184	A2#2	VNB	4.58642e-17
C185	A1#2	VNB	3.36589e-17
C186	a_29_424##3	VNB	4.85316e-17
C187	B1_N#3	VNB	9.70877e-17
C188	VPWR	A2	7.33967e-18
C189	VPWR	B1_N	2.97691e-18
C190	VGND	A2	9.44325e-18
C191	VPWR	Y	2.36706e-17
C192	VGND	B1_N	1.72009e-17
C193	A2	VNB	3.51945e-17
C194	VGND	Y	4.04706e-18
C195	B1_N	VNB	4.73626e-17
C196	Y	VNB	2.59767e-17
C197	VPWR	VNB	6.96202e-17
C198	VGND	VNB	6.66069e-17
C199	VGND#3	VNB	2.33084e-16
C200	VPWR#4	VPWR#2	2.99877e-19
C201	VPWR#2	VNB	5.49725e-17
C202	VPWR	VPWR#2	3.90058e-17
C203	VPWR#4	VNB	5.01443e-17
C204	a_29_424##7	VPWR#4	2.11485e-17
C205	A2	VPWR#2	1.3201e-18
C206	VGND#3	a_29_424#	8.45106e-18
C207	VPWR	VPWR#4	5.26476e-17
C208	VGND#3	a_29_424##7	7.86174e-19
C209	Y	VPWR#4	8.7179e-18
C210	VGND#3	a_29_424##8	9.3027e-18
C211	VGND#3	A1#5	6.93147e-19
C212	VPWR#4	VPWR#6	1.0459e-19
C213	VGND#2	A1#5	7.71832e-19
C214	VGND#3	VGND#2	5.00443e-17
C215	VPWR#2	A2#2	9.46869e-20
C216	VPWR#4	B1_N#2	2.56113e-19
C217	VGND	VGND#3	8.99092e-17
C218	VPWR#3	VPWR#2	5.90492e-17
C219	VGND#3	B1_N	3.28829e-17
C220	VGND#2	A1#2	1.69171e-19
C221	VGND#3	A1#2	3.85719e-20
C222	VPWR#2	A1#1	9.69944e-19
C223	VPWR#2	A2#1	1.91692e-18
C224	VGND#3	A1#3	9.05678e-18
C225	VGND#3	VGND#4	6.69686e-19
C226	VGND#3	a_29_424##6	2.87847e-19
C227	a_348_368##2	VPWR#2	3.29752e-18
C228	a_29_424##6	VPWR#4	4.01011e-19
C229	a_348_368#	VPWR#2	2.01952e-17
C230	VGND#2	A2	3.12841e-18
C231	VPWR#3	VPWR#4	5.33716e-17
C232	VGND#3	B1_N#3	1.32484e-17
C233	VPWR#4	B1_N#4	8.62875e-18
C234	VGND#3	B1_N#1	4.08215e-18
C235	VPWR#4	a_29_424##4	7.76983e-19
C236	VGND	VGND#2	3.5587e-17
C237	VGND#3	A2#3	7.7998e-19
C238	VPWR#4	A1#1	1.5157e-19
C239	VGND#2	VNB	4.79733e-17
C240	VGND#3	B1_N#2	2.26366e-19
C241	VGND#3	Y#3	1.45708e-17
C242	VPWR#4	A2#1	6.4066e-20
C243	VGND#2	A2#3	3.75761e-18
C244	VPWR#4	B1_N#1	4.14544e-19
*
*
.ENDS sky130_fd_sc_hs__a21boi_1
*
