* Extracted by Quantus, converted by sky130cad/quantus.py
*
*
*
*                       LINUX           Wed Nov 18 08:27:35 2026
*
*
*
*  PROGRAM  advgen
*
*  Name           : advgen - Quantus - (64-bit)
*  Version        : 25.1.0-p047
*  Build Date     : Thu Dec 11 23:20:30 PST 2025
*
*  HSPICE LIBRARY
*
*  OPERATING_TEMPERATURE 150
*  QRC_TECH_DIR <path>/tech
*
*
*

*
.SUBCKT sky130_fd_sc_hs__dfrtp_4 VPB VNB VGND RESET_B VPWR Q D CLK
*
*
*  caps2d version: 10
*
*
*       TRANSISTOR CARDS
*
*
XM10 a_37_78##5 D#1 a_124_78# VNB sky130_fd_pr__nfet_01v8_lvt l=0.15 w=0.42 ad=0.1197 as=0.1008 pd=1.41 ps=1.32
XM8 a_124_78# RESET_B#3 VGND#17 VNB sky130_fd_pr__nfet_01v8_lvt l=0.15 w=0.42 ad=0.1008 as=0.1197 pd=1.32 ps=1.41
XM29 a_313_74##15 CLK#3 VGND#16 VNB sky130_fd_pr__nfet_01v8_lvt l=0.15 w=0.74 ad=0.2109 as=0.3108 pd=2.05 ps=2.32
XM2 VGND#16 a_313_74##7 a_494_366##13 VNB sky130_fd_pr__nfet_01v8_lvt l=0.15 w=0.74 ad=0.3108 as=0.2109 pd=2.32 ps=2.05
XM36 a_37_78# a_313_74##8 a_699_463##9 VNB sky130_fd_pr__nfet_01v8_lvt l=0.15 w=0.42 ad=0.1197 as=0.147 pd=1.41 ps=1.54
XM5 a_699_463##9 a_494_366# a_812_138# VNB sky130_fd_pr__nfet_01v8_lvt l=0.15 w=0.42 ad=0.147 as=0.1008 pd=1.54 ps=1.32
XM26 a_812_138# a_834_355# a_890_138# VNB sky130_fd_pr__nfet_01v8_lvt l=0.15 w=0.42 ad=0.1008 as=0.1008 pd=1.32 ps=1.32
XM1 a_890_138# RESET_B#7 VGND#15 VNB sky130_fd_pr__nfet_01v8_lvt l=0.15 w=0.42 ad=0.1008 as=0.6125 pd=1.32 ps=3.48
XM33 VGND#15 a_699_463##3 a_834_355##5 VNB sky130_fd_pr__nfet_01v8_lvt l=0.15 w=0.74 ad=0.6125 as=0.9435 pd=3.48 ps=4.03
XM15 a_834_355##5 a_494_366##5 a_1350_392##12 VNB sky130_fd_pr__nfet_01v8_lvt l=0.15 w=0.74 ad=0.9435 as=0.458 pd=4.03 ps=3.28
XM11 a_1350_392##12 a_313_74##9 a_1647_81# VNB sky130_fd_pr__nfet_01v8_lvt l=0.15 w=0.42 ad=0.458 as=0.1008 pd=3.28 ps=1.32
XM34 a_1647_81# a_1678_395# VGND#14 VNB sky130_fd_pr__nfet_01v8_lvt l=0.15 w=0.42 ad=0.1008 as=0.1512 pd=1.32 ps=1.56
XM16 VGND#14 RESET_B#9 a_1827_81# VNB sky130_fd_pr__nfet_01v8_lvt l=0.15 w=0.42 ad=0.1512 as=0.1008 pd=1.56 ps=1.32
XM14 a_1827_81# a_1350_392##5 a_1678_395##7 VNB sky130_fd_pr__nfet_01v8_lvt l=0.15 w=0.42 ad=0.1008 as=0.1197 pd=1.32 ps=1.41
XM37 VGND#13 a_1350_392# a_2010_409##15 VNB sky130_fd_pr__nfet_01v8_lvt l=0.15 w=0.74 ad=0.2627 as=0.2109 pd=2.19 ps=2.05
XM35 Q#1 a_2010_409##13 VGND#6 VNB sky130_fd_pr__nfet_01v8_lvt l=0.15 w=0.74 ad=0.2775 as=0.2109 pd=2.23 ps=2.05
XM27 VGND#5 a_2010_409##12 Q#1 VNB sky130_fd_pr__nfet_01v8_lvt l=0.15 w=0.74 ad=0.259 as=0.2775 pd=2.18 ps=2.23
XM38 VGND#5 a_2010_409##10 Q#6 VNB sky130_fd_pr__nfet_01v8_lvt l=0.15 w=0.74 ad=0.259 as=0.2072 pd=2.18 ps=2.04
XM9 Q#6 a_2010_409# VGND#1 VNB sky130_fd_pr__nfet_01v8_lvt l=0.15 w=0.74 ad=0.2072 as=0.2035 pd=2.04 ps=2.03
XM4 VPWR#12 D#3 a_37_78##6 VPB sky130_fd_pr__pfet_01v8 l=0.15 w=0.42 ad=0.1218 as=0.126 pd=1.42 ps=1.44
XM28 a_37_78##6 RESET_B#4 VPWR#20 VPB sky130_fd_pr__pfet_01v8 l=0.15 w=0.42 ad=0.126 as=0.1197 pd=1.44 ps=1.41
XM17 a_313_74##16 CLK#1 VPWR#19 VPB sky130_fd_pr__pfet_01v8 l=0.15 w=1.12 ad=0.3248 as=0.336 pd=2.82 ps=2.84
XM0 VPWR#19 a_313_74##6 a_494_366##12 VPB sky130_fd_pr__pfet_01v8 l=0.15 w=1.12 ad=0.336 as=0.3192 pd=2.84 ps=2.81
XM25 a_37_78##2 a_494_366##3 a_699_463##7 VPB sky130_fd_pr__pfet_01v8 l=0.15 w=0.42 ad=0.1218 as=0.126 pd=1.42 ps=1.44
XM12 a_699_463##7 a_313_74##5 a_789_463# VPB sky130_fd_pr__pfet_01v8 l=0.15 w=0.42 ad=0.126 as=0.1008 pd=1.44 ps=1.32
XM19 a_789_463# a_834_355##3 VPWR#18 VPB sky130_fd_pr__pfet_01v8 l=0.15 w=0.42 ad=0.1008 as=0.259 pd=1.32 ps=2.23
XM23 VPWR#18 RESET_B#8 a_699_463##8 VPB sky130_fd_pr__pfet_01v8 l=0.15 w=0.42 ad=0.259 as=0.1218 pd=2.23 ps=1.42
XM13 VPWR#17 a_699_463# a_834_355##4 VPB sky130_fd_pr__pfet_01v8 l=0.15 w=1 ad=0.2845 as=0.3 pd=2.68 ps=2.6
XM30 a_834_355##4 a_313_74##12 a_1350_392##10 VPB sky130_fd_pr__pfet_01v8 l=0.15 w=1 ad=0.3 as=0.6724 pd=2.6 ps=4.47
XM31 a_1350_392##10 a_494_366##6 a_1627_493# VPB sky130_fd_pr__pfet_01v8 l=0.15 w=0.42 ad=0.6724 as=0.1134 pd=4.47 ps=1.38
XM18 a_1627_493# a_1678_395##3 VPWR#16 VPB sky130_fd_pr__pfet_01v8 l=0.15 w=0.42 ad=0.1134 as=0.1638 pd=1.38 ps=1.62
XM6 VPWR#16 RESET_B#11 a_1678_395##4 VPB sky130_fd_pr__pfet_01v8 l=0.15 w=0.42 ad=0.1638 as=0.126 pd=1.62 ps=1.44
XM24 a_1678_395##4 a_1350_392##8 VPWR#15 VPB sky130_fd_pr__pfet_01v8 l=0.15 w=0.42 ad=0.126 as=0.2604 pd=1.44 ps=2.39
XM32 a_2010_409##17 a_1350_392##7 VPWR#15 VPB sky130_fd_pr__pfet_01v8 l=0.15 w=0.84 ad=0.252 as=0.2604 pd=2.28 ps=2.39
XM21 VPWR#14 a_1350_392##6 a_2010_409##17 VPB sky130_fd_pr__pfet_01v8 l=0.15 w=0.84 ad=0.3724 as=0.252 pd=2.95 ps=2.28
XM20 Q#5 a_2010_409##8 VPWR#14 VPB sky130_fd_pr__pfet_01v8 l=0.15 w=1.12 ad=0.3864 as=0.3724 pd=2.93 ps=2.95
XM22 VPWR#13 a_2010_409##14 Q#5 VPB sky130_fd_pr__pfet_01v8 l=0.15 w=1.12 ad=0.868 as=0.3864 pd=3.79 ps=2.93
XM7 Q#7 a_2010_409##11 VPWR#13 VPB sky130_fd_pr__pfet_01v8 l=0.15 w=1.12 ad=0.336 as=0.868 pd=2.84 ps=3.79
XM3 VPWR#1 a_2010_409##9 Q#7 VPB sky130_fd_pr__pfet_01v8 l=0.15 w=1.12 ad=0.3864 as=0.336 pd=2.93 ps=2.84
*
*
*       RESISTOR AND CAP/DIODE CARDS
*
Rg1	D#1	D#2	308.734436
Rg2	D#2	D#3	415.116791
Rg3	RESET_B#1	RESET_B#2	6.530838
Rg4	RESET_B#2	RESET_B#3	451.728088
Rg5	RESET_B#2	RESET_B#4	454.157837
Rg6	CLK#1	CLK#2	456.142303
Rg7	CLK#2	CLK#3	372.003876
Rg8	a_494_366#	a_494_366##2	629.741333
Rg9	a_494_366##2	a_494_366##3	353.152527
Rg10	a_834_355#	a_834_355##2	528.003052
Rg11	a_834_355##2	a_834_355##3	249.385071
Rg12	RESET_B#5	RESET_B#6	57.191422
Rg13	RESET_B#6	RESET_B#7	460.260254
Rg14	RESET_B#6	RESET_B#8	317.099457
Rg15	a_313_74#	a_313_74##2	1207.676758
Rg16	a_313_74##2	a_313_74##3	1400.837524
Rg17	a_313_74##3	a_313_74##4	41.704071
Rg18	a_313_74##2	a_313_74##5	283.919525
Rg19	a_313_74##3	a_313_74##6	407.448334
Rg20	a_313_74##4	a_313_74##7	304.735077
Rg21	a_313_74##4	a_313_74##8	618.697510
Rg22	a_699_463#	a_699_463##2	600.573486
Rg23	a_699_463##2	a_699_463##3	314.734314
Rg24	a_494_366##4	a_494_366##5	692.665833
Rg25	a_494_366##6	a_494_366##7	226.446548
Rg26	a_313_74##9	a_313_74##10	1329.804199
Rg27	a_313_74##10	a_313_74##11	55.549946
Rg28	a_313_74##10	a_313_74##12	419.578857
Rg29	a_1678_395#	a_1678_395##2	273.505981
Rg30	a_1678_395##2	a_1678_395##3	723.900574
Rg31	RESET_B#9	RESET_B#10	795.720337
Rg32	RESET_B#10	RESET_B#11	247.112122
Rg33	a_1350_392#	a_1350_392##2	520.580261
Rg34	a_1350_392##2	a_1350_392##3	194.242920
Rg35	a_1350_392##3	a_1350_392##4	177.186752
Rg36	a_1350_392##4	a_1350_392##5	463.106628
Rg37	a_1350_392##2	a_1350_392##6	423.062653
Rg38	a_1350_392##3	a_1350_392##7	404.430542
Rg39	a_1350_392##4	a_1350_392##8	490.156952
Rg40	a_2010_409#	a_2010_409##2	487.348328
Rg41	a_2010_409##2	a_2010_409##3	117.735756
Rg42	a_2010_409##3	a_2010_409##4	60.349560
Rg43	a_2010_409##4	a_2010_409##5	90.935768
Rg44	a_2010_409##5	a_2010_409##6	53.982727
Rg45	a_2010_409##6	a_2010_409##7	56.444386
Rg46	a_2010_409##7	a_2010_409##8	617.074585
Rg47	a_2010_409##2	a_2010_409##9	427.807281
Rg48	a_2010_409##3	a_2010_409##10	431.991302
Rg49	a_2010_409##4	a_2010_409##11	427.807281
Rg50	a_2010_409##5	a_2010_409##12	342.058960
Rg51	a_2010_409##7	a_2010_409##13	384.320526
Rg52	a_2010_409##7	a_2010_409##14	474.928162
Rf1	D	D#4	5.370198
Rf2	D#4	D	7.048386
Rf3	RESET_B	RESET_B#1	82.914993
Rf4	CLK	CLK#2	174.190552
Rf5	a_313_74##4	a_313_74##14	227.318909
Rf6	a_313_74##14	a_313_74##15	17.957924
Rf7	a_313_74##14	a_313_74##16	84.373528
Rf8	a_37_78#	a_37_78##3	157.551178
Rf9	a_37_78##3	a_37_78##4	162.212982
Rf10	a_37_78##4	a_37_78##5	154.955963
Rf11	a_37_78##4	a_37_78##6	33.863968
Rf12	a_37_78##2	a_37_78##3	15.000000
Rf13	RESET_B#5	RESET_B#15	162.642059
Rf14	RESET_B#16	RESET_B#17	12.187032
Rf15	RESET_B#15	RESET_B#16	7.897900
Rf16	a_699_463##2	a_699_463##5	270.613586
Rf17	a_699_463##5	a_699_463##6	57.154053
Rf18	a_699_463##6	a_699_463##7	41.065601
Rf19	a_699_463##5	a_699_463##8	24.680048
Rf20	a_699_463##6	a_699_463##9	130.224625
Rf21	a_313_74##11	a_313_74#	487.860962
Rf22	a_834_355##4	a_834_355##6	96.328964
Rf23	a_834_355##6	a_834_355##2	324.717041
Rf24	a_834_355##5	a_834_355##6	5.000000
Rf25	a_494_366##7	a_494_366##4	195.823059
Rf26	a_494_366##4	a_494_366##10	472.766144
Rf27	a_494_366##10	a_494_366##11	72.870224
Rf28	a_494_366##11	a_494_366##12	34.104980
Rf29	a_494_366##10	a_494_366##13	21.769102
Rf30	a_494_366##11	a_494_366##2	185.819580
Rf31	RESET_B#18	RESET_B#19	1.306803
Rf32	RESET_B#20	RESET_B#10	161.539612
Rf33	RESET_B#19	RESET_B#20	3.488554
Rf34	a_1350_392##4	a_1350_392##11	335.349701
Rf35	a_1350_392##11	a_1350_392##12	162.118088
Rf36	a_1350_392##10	a_1350_392##11	7.500000
Rf37	a_1678_395##4	a_1678_395##5	150.241135
Rf38	a_1678_395##5	a_1678_395##2	223.554703
Rf39	a_1678_395##5	a_1678_395##7	35.017193
Rf40	a_2010_409##15	a_2010_409##16	29.871801
Rf41	a_2010_409##16	a_2010_409##17	82.966026
Rf42	a_2010_409##16	a_2010_409##6	94.159019
Rf43	Q#1	Q#2	55.807873
Rf44	Q#2	Q#3	33.050732
Rf45	Q#3	Q#4	24.266657
Rf46	Q#4	Q#5	111.195877
Rf47	Q#2	Q#6	20.970114
Rf48	Q#3	Q	9.733822
Rf49	Q#4	Q#7	25.258175
Rf50	VGND#1	VGND#2	96.792114
Rf51	VGND#2	VGND#3	71.387146
Rf52	VGND#3	VGND#4	88.831230
Rf53	VGND#2	VGND#5	32.795570
Rf54	VGND#3	VGND#6	37.002518
Rf55	VGND#4	VGND#7	94.210602
Rf56	VGND#7	VGND#8	272.429291
Rf57	VGND#8	VGND#9	124.161308
Rf58	VGND#9	VGND#10	83.983536
Rf59	VGND#10	VGND#11	77.507034
Rf61	VGND#4	VGND#13	42.364750
Rf62	VGND#7	VGND#14	35.885353
Rf63	VGND#8	VGND#15	22.894152
Rf64	VGND#10	VGND#16	34.310661
Rf65	VGND#11	VGND#17	53.703419
Rf66	VPWR#1	VPWR#2	118.873154
Rf67	VPWR#2	VPWR#3	86.777885
Rf68	VPWR#3	VPWR#4	45.266777
Rf69	VPWR#4	VPWR#5	22.313217
Rf70	VPWR#5	VPWR#6	75.250298
Rf71	VPWR#6	VPWR#7	200.654282
Rf72	VPWR#7	VPWR#8	104.592873
Rf73	VPWR#8	VPWR#9	88.001312
Rf74	VPWR#9	VPWR#10	86.905563
Rf75	VPWR#10	VPWR#11	69.771507
Rf76	VPWR#11	VPWR#12	111.965210
Rf77	VPWR#2	VPWR#13	16.720081
Rf78	VPWR#3	VPWR#14	38.227169
Rf79	VPWR#5	VPWR#15	44.190063
Rf80	VPWR#6	VPWR#16	37.460041
Rf81	VPWR#7	VPWR#17	31.125740
Rf82	VPWR#8	VPWR#18	31.554951
Rf83	VPWR#10	VPWR#19	33.129639
Rf84	VPWR#11	VPWR#20	37.027283
Rf85	D#2	D#4	53.410934
Re1	RESET_B#18	RESET_B#17	15.344948
Re2	RESET_B#17	RESET_B	7.213822
Re4	VPWR#4	VPWR	1.989084
Re5	VPWR	VPWR#9	1.989084
Re6	VGND#4	VGND	1.989084
Re7	VGND	VGND#9	1.989084
*
*       CAPACITOR CARDS
*
*
C1	a_699_463##5	a_313_74##5	2.35831e-19
C2	VPWR#16	RESET_B#10	2.58308e-18
C3	VGND#4	a_2010_409#	4.47153e-19
C4	VPWR#12	a_37_78##6	3.39417e-17
C5	a_494_366##13	a_313_74##3	1.51195e-17
C6	VPWR#9	a_494_366##12	3.04287e-18
C7	a_313_74##2	a_890_138#	6.51778e-19
C8	a_494_366##13	a_699_463##2	4.62955e-19
C9	RESET_B#4	a_313_74##2	8.27313e-20
C10	VPWR#3	a_2010_409##11	1.74375e-20
C11	VPWR#9	VPWR#19	1.18401e-18
C12	CLK#2	a_37_78##4	1.90421e-18
C13	a_1350_392##8	a_1350_392##7	2.93541e-17
C14	a_1678_395##4	a_1678_395##2	5.1119e-19
C15	a_699_463##2	RESET_B#6	1.02049e-17
C16	a_1350_392##10	RESET_B#10	1.96339e-18
C17	Q#5	VPWR#13	9.80758e-17
C18	VGND#4	a_2010_409##12	4.97738e-19
C19	a_699_463##6	a_494_366##3	4.16667e-19
C20	a_834_355##5	RESET_B#5	1.33292e-18
C21	VPWR#9	a_313_74##16	3.39118e-18
C22	VGND#4	VGND#8	7.68893e-18
C23	VGND#1	a_2010_409#	3.91373e-17
C24	a_37_78##5	D#1	3.63584e-17
C25	VPWR#16	a_1678_395##2	6.94851e-19
C26	VGND#9	a_494_366##12	2.34278e-18
C27	a_313_74##14	CLK#2	6.25461e-17
C28	VPWR#2	a_2010_409##11	2.59085e-18
C29	VGND#4	a_2010_409##13	1.57057e-18
C30	VGND#4	VGND#7	1.64483e-16
C31	a_699_463##5	a_494_366##3	5.76944e-20
C32	VPWR#4	Q#4	2.5068e-18
C33	a_494_366##13	a_313_74#	3.26719e-19
C34	a_1350_392##10	a_1678_395##2	7.6892e-20
C35	VPWR#9	a_37_78##6	1.64859e-17
C36	VGND#4	a_1350_392#	5.56465e-18
C37	a_2010_409#	Q#6	8.85829e-18
C38	VGND#9	a_313_74##16	1.29317e-18
C39	RESET_B#11	a_1350_392##8	2.08167e-17
C40	VGND#4	VGND#3	8.06732e-17
C41	VPWR#14	VPWR#13	2.6255e-18
C42	VPWR#9	VPWR#11	6.8362e-17
C43	a_37_78##5	a_313_74##14	9.06404e-18
C44	VPWR#4	Q#3	1.23266e-18
C45	RESET_B#18	a_313_74##9	3.55042e-18
C46	VPWR#5	VPWR#3	1.47621e-18
C47	a_834_355##4	RESET_B#6	3.65004e-19
C48	a_834_355##2	a_834_355##5	9.06259e-19
C49	VPWR#9	VPWR#12	5.36433e-17
C50	VGND#4	a_1350_392##5	1.40226e-17
C51	VPWR#3	a_2010_409##14	5.76037e-19
C52	VGND#4	VGND#2	6.59334e-17
C53	VGND#1	a_2010_409##10	2.92449e-18
C54	a_2010_409##16	a_1350_392##3	7.54983e-18
C55	VPWR#9	VPWR#10	7.41823e-17
C56	a_494_366##13	RESET_B#6	4.68119e-21
C57	VGND#16	a_313_74##3	1.09222e-18
C58	VPWR#2	VPWR#1	1.34851e-18
C59	VPWR#3	a_2010_409##7	7.15474e-20
C60	a_313_74##2	a_313_74#	3.36797e-19
C61	RESET_B#17	VGND#8	1.7654e-18
C62	VGND#4	RESET_B#9	7.91417e-18
C63	VGND#5	a_2010_409#	1.33271e-18
C64	VPWR#6	a_2010_409##8	8.08733e-20
C65	VPWR#9	VPWR#8	8.81077e-17
C66	a_494_366##7	a_1350_392##10	1.05757e-16
C67	a_494_366##13	RESET_B#5	8.57835e-19
C68	a_2010_409##16	Q#3	5.06732e-19
C69	VPWR#2	a_2010_409##14	2.59085e-18
C70	VPWR#14	Q#5	8.47292e-17
C71	RESET_B#6	a_313_74#	1.14688e-20
C72	a_1678_395##3	RESET_B#11	1.5134e-17
C73	VGND#4	a_1678_395#	6.5665e-18
C74	Q#6	a_2010_409##10	3.05704e-17
C75	VPWR#9	VPWR#7	1.01679e-16
C76	VGND#4	Q#4	2.4689e-18
C77	a_699_463##9	a_834_355##2	7.29054e-17
C78	VPWR#4	a_2010_409##16	6.43772e-18
C79	VPWR#5	a_2010_409##8	8.84044e-19
C80	VPWR#17	a_313_74##2	3.76803e-19
C81	a_37_78##4	D#2	1.22e-17
C82	a_1350_392##2	a_2010_409##8	2.01436e-17
C83	a_2010_409##10	a_2010_409#	4.323e-17
C84	VGND#1	a_2010_409##12	3.18276e-19
C85	VGND#4	Q#3	3.72511e-18
C86	a_37_78#	a_834_355##2	1.39771e-19
C87	a_494_366##4	a_1350_392##10	4.00704e-18
C88	D#3	RESET_B#2	3.46157e-18
C89	a_2010_409##9	VPWR#1	3.3206e-17
C90	a_313_74##14	D#2	1.18286e-18
C91	a_2010_409##16	a_1350_392##2	2.02664e-17
C92	a_494_366##13	a_834_355##2	5.37524e-17
C93	VPWR#3	a_2010_409##8	9.00638e-18
C94	a_2010_409##10	VGND#5	1.99643e-17
C95	a_2010_409##17	Q#5	6.5353e-18
C96	VGND#4	a_494_366##5	2.79391e-18
C97	VGND#4	Q#2	2.21637e-18
C98	a_494_366##6	a_1678_395##3	2.57323e-17
C99	VPWR#4	a_1678_395##5	1.51876e-18
C100	Q#7	VPWR#2	1.50001e-17
C101	VPWR#11	a_313_74##2	5.86412e-20
C102	Q#6	a_2010_409##12	1.2852e-18
C103	a_699_463##9	a_494_366##2	3.28228e-18
C104	Q#7	a_2010_409##9	4.95829e-17
C105	VPWR#18	RESET_B#7	3.69465e-19
C106	a_313_74##11	a_1350_392##10	1.05565e-16
C107	Q#4	a_2010_409##9	8.21233e-18
C108	a_37_78#	a_494_366##2	5.35743e-17
C109	RESET_B#17	a_494_366##5	9.06619e-19
C110	VPWR#10	a_313_74##3	8.60442e-20
C111	Q#1	a_2010_409##10	5.93363e-19
C112	VPWR#1	a_2010_409##11	1.3945e-18
C113	VPWR#3	VPWR#13	5.09329e-20
C114	VGND#4	a_2010_409##16	7.04925e-18
C115	VPWR#2	a_2010_409##7	4.3829e-20
C116	RESET_B#18	RESET_B#19	1.15279e-17
C117	a_2010_409##17	VPWR#14	7.71059e-17
C118	a_494_366##13	a_494_366##2	1.55783e-18
C119	a_834_355##4	a_313_74##11	5.44739e-17
C120	VPWR#5	a_1350_392##6	6.6778e-19
C121	VPWR#13	a_2010_409##9	1.5418e-18
C122	a_2010_409##12	a_2010_409##10	2.79955e-17
C123	VGND#5	a_2010_409##12	3.34135e-17
C124	a_313_74##12	a_494_366##6	2.90617e-18
C125	a_699_463##9	a_699_463##7	3.75976e-19
C126	a_37_78##4	a_313_74##6	2.19332e-19
C127	Q#3	a_2010_409##9	1.26317e-17
C128	VPWR#3	VPWR#2	1.34747e-18
C129	Q#7	a_2010_409##11	4.79251e-17
C130	RESET_B#17	RESET_B#7	2.91623e-18
C131	VPWR#3	a_1350_392##6	1.11524e-18
C132	Q#6	a_2010_409##13	2.70184e-19
C133	VGND#4	a_1678_395##5	8.72012e-18
C134	VPWR#1	a_2010_409##14	1.18435e-19
C135	a_834_355##4	a_699_463##2	1.16063e-17
C136	VPWR#15	VPWR#14	2.48387e-18
C137	Q#1	a_2010_409##12	2.86125e-17
C138	a_834_355##5	a_1350_392##12	4.39572e-17
C139	a_313_74##4	a_494_366##13	4.58657e-17
C140	a_699_463##6	a_789_463#	1.47384e-18
C141	a_2010_409##11	VPWR#13	4.06151e-17
C142	VPWR#17	a_699_463##2	5.99319e-19
C143	Q#4	a_2010_409##11	2.04382e-17
C144	a_313_74##4	VGND#16	2.05175e-17
C145	a_699_463#	a_313_74##12	4.73286e-17
C146	VPWR#4	RESET_B#19	6.20167e-19
C147	RESET_B#17	a_494_366#	4.79104e-19
C148	a_2010_409##15	a_2010_409##10	1.67079e-20
C149	a_37_78##2	a_699_463##9	7.951e-19
C150	VGND#5	a_2010_409##13	1.94918e-18
C151	VPWR#10	a_313_74##2	1.4079e-18
C152	Q#7	a_2010_409##14	1.66881e-19
C153	Q#5	VPWR#3	9.21872e-18
C154	a_1350_392##4	a_1350_392#	3.07793e-18
C155	a_1350_392##10	a_313_74#	4.66329e-19
C156	a_37_78##4	CLK#1	1.86804e-17
C157	VPWR#5	a_1350_392##7	4.88528e-18
C158	a_2010_409##13	a_2010_409##12	2.66607e-17
C159	Q#5	a_2010_409##11	4.49465e-19
C160	a_2010_409##4	a_2010_409##3	1.26965e-17
C161	VGND#6	a_2010_409##12	1.56751e-18
C162	a_1678_395##5	a_1350_392##3	1.28434e-17
C163	a_313_74#	a_834_355##4	4.94628e-17
C164	Q#3	a_2010_409##11	1.36057e-18
C165	VPWR#15	a_2010_409##17	3.34928e-17
C166	a_834_355##2	a_313_74##2	1.58773e-18
C167	a_2010_409##14	VPWR#13	4.75578e-17
C168	VGND#9	VGND#10	9.32309e-17
C169	VPWR#5	VPWR#14	2.31207e-18
C170	a_313_74#	VPWR#17	4.66947e-17
C171	a_2010_409##13	Q#1	2.46518e-17
C172	a_37_78#	a_37_78##2	1.1287e-18
C173	RESET_B#9	a_1350_392##4	1.82594e-17
C174	VGND#9	a_699_463##3	1.16695e-18
C175	VPWR#14	a_2010_409##11	6.72411e-20
C176	a_834_355##2	RESET_B#6	4.45287e-17
C177	RESET_B#8	a_699_463#	2.97368e-19
C178	CLK#2	VGND#16	1.09433e-18
C179	Q#5	VPWR#2	8.58066e-18
C180	VGND#9	VGND#8	1.50812e-16
C181	VGND#3	a_2010_409##8	1.76372e-19
C182	a_2010_409##15	a_2010_409##12	1.25784e-20
C183	VGND#5	a_1350_392#	1.28137e-19
C184	VGND#9	RESET_B#7	6.53358e-19
C185	VGND#13	a_1350_392##3	2.49425e-18
C186	Q#5	a_2010_409##14	8.1221e-17
C187	VPWR#4	a_1350_392##3	2.45537e-20
C188	VPWR#18	a_313_74#	2.97147e-18
C189	VPWR#18	a_313_74##2	2.20607e-17
C190	a_834_355##4	RESET_B#5	1.9637e-18
C191	VGND#4	RESET_B#19	1.29143e-18
C192	Q#4	a_2010_409##14	2.82585e-19
C193	VGND#4	a_2010_409##7	2.37422e-19
C194	a_1678_395##4	a_2010_409##17	8.19741e-18
C195	a_37_78##4	RESET_B#4	1.54177e-17
C196	VPWR#4	a_2010_409##9	1.26922e-19
C197	VGND#6	a_2010_409##13	1.92593e-17
C198	a_1350_392##4	a_313_74##9	8.11875e-18
C199	a_1678_395##2	a_1350_392#	1.15794e-19
C200	VPWR#13	a_2010_409##8	8.02647e-19
C201	VPWR#9	a_313_74##8	9.33539e-20
C202	VPWR#4	a_1350_392##2	2.42263e-20
C203	a_1350_392#	a_2010_409##13	5.15963e-18
C204	a_699_463##6	a_313_74##2	3.44583e-18
C205	VGND#2	VGND#1	1.52567e-18
C206	VPWR#5	a_1350_392##8	4.41164e-18
C207	a_1678_395##5	a_1350_392##2	2.92892e-19
C208	VPWR#14	a_2010_409##14	2.07364e-18
C209	a_834_355##5	VGND#15	1.0968e-17
C210	a_494_366##12	a_37_78#	1.4209e-17
C211	Q#3	a_2010_409##14	1.01498e-18
C212	VGND#9	a_494_366#	2.33153e-18
C213	a_834_355##3	RESET_B#8	1.23863e-17
C214	a_1350_392##4	VPWR#6	8.93255e-20
C215	VPWR#8	a_313_74##2	2.60098e-17
C216	VGND#4	a_2010_409##4	2.29506e-20
C217	Q#5	a_2010_409##8	2.03527e-17
C218	a_2010_409##16	a_2010_409##11	2.47971e-19
C219	a_2010_409##15	a_2010_409##13	1.42681e-18
C220	a_1678_395##2	RESET_B#9	5.68423e-17
C221	VGND#9	a_313_74##8	3.86642e-18
C222	a_1678_395##4	VPWR#15	4.72544e-17
C223	VGND#13	a_1350_392##2	1.67448e-18
C224	a_2010_409##17	a_2010_409##14	3.67271e-19
C225	a_313_74##3	a_494_366##2	2.96614e-17
C226	a_2010_409##4	a_2010_409##2	2.03991e-18
C227	a_494_366##12	a_494_366#	5.73382e-19
C228	a_1350_392##2	a_2010_409##7	1.16212e-19
C229	VGND#9	a_313_74##7	2.37635e-18
C230	VGND#6	a_1350_392#	2.55034e-18
C231	a_494_366##13	a_494_366##12	2.28034e-18
C232	VPWR#4	a_2010_409##8	1.82138e-18
C233	a_494_366##2	a_313_74##2	1.1112e-18
C234	a_37_78##4	D#3	1.22652e-17
C235	a_37_78##2	a_313_74##8	2.00618e-19
C236	VPWR#14	a_2010_409##8	6.16943e-17
C237	a_2010_409##2	VPWR#1	2.89166e-18
C238	VPWR#6	RESET_B#11	6.84368e-18
C239	a_313_74##5	a_834_355##3	3.91126e-17
C240	a_313_74##9	a_1678_395##2	6.09346e-17
C241	RESET_B#18	a_1350_392##7	4.10458e-19
C242	VGND#4	a_2010_409##2	4.26474e-20
C243	VPWR#18	a_834_355##2	7.849e-19
C244	VGND#13	a_2010_409##13	5.79667e-19
C245	VGND#9	CLK#3	3.45224e-19
C246	VPWR#4	a_1350_392##6	8.79653e-18
C247	Q#5	a_1350_392##6	6.694e-19
C248	a_699_463##5	a_1350_392##10	4.48443e-20
C249	VPWR#13	a_2010_409##7	3.34117e-18
C250	VPWR#2	a_2010_409##3	1.04343e-19
C251	a_2010_409##17	VPWR#3	1.11374e-18
C252	a_1350_392##5	a_1350_392#	4.75908e-18
C253	VPWR#16	VPWR#15	2.14585e-18
C254	VGND#4	a_2010_409##8	4.33165e-20
C255	VGND#3	a_2010_409##6	5.25452e-19
C256	VGND#2	Q#6	1.37359e-17
C257	a_2010_409##17	a_2010_409##8	1.81629e-18
C258	VGND#4	a_1350_392##3	1.71425e-18
C259	a_494_366##4	a_1350_392##5	2.03042e-19
C260	VGND#9	RESET_B#3	9.99256e-18
C261	VPWR#5	RESET_B#11	3.11426e-19
C262	a_2010_409##15	a_1350_392#	5.10769e-17
C263	Q#3	a_2010_409##8	5.3698e-19
C264	VGND#17	RESET_B#2	6.44509e-18
C265	VPWR#4	a_1350_392##7	9.3318e-18
C266	a_699_463##6	VPWR#8	4.58627e-18
C267	RESET_B#10	VPWR#6	9.72824e-19
C268	a_494_366##7	a_313_74##9	2.9933e-17
C269	VGND#3	VGND#5	3.95492e-20
C270	a_2010_409##16	a_2010_409##14	4.64424e-19
C271	a_494_366##4	RESET_B#9	1.48941e-18
C272	VPWR#14	a_1350_392##6	1.77608e-17
C273	VPWR#8	RESET_B#6	5.26137e-21
C274	VGND#9	D#1	1.24914e-17
C275	a_37_78##2	a_834_355##2	9.88141e-19
C276	VGND#6	a_1350_392##5	1.05799e-19
C277	a_494_366##3	a_313_74##5	3.16904e-17
C278	a_699_463##5	a_313_74##2	1.73817e-18
C279	a_37_78##5	D#2	1.38286e-17
C280	VPWR#15	a_2010_409##8	1.95021e-19
C281	VPWR#4	a_1350_392##8	1.0893e-17
C282	a_1678_395##5	a_2010_409##16	4.02716e-17
C283	a_2010_409##3	Q#7	3.19714e-19
C284	a_494_366##4	a_1678_395#	7.46172e-18
C285	a_494_366##12	a_834_355##2	2.46411e-20
C286	a_1350_392#	VGND#13	2.11248e-17
C287	VPWR#16	a_1678_395##4	4.12485e-17
C288	RESET_B#18	a_1678_395##3	3.93055e-18
C289	VGND#2	a_2010_409##10	2.73934e-18
C290	Q#4	VPWR#1	1.46736e-17
C291	a_2010_409##17	a_1350_392##6	5.2528e-17
C292	a_494_366##4	a_313_74##9	7.84437e-17
C293	VPWR#4	RESET_B#11	7.01346e-18
C294	a_2010_409##6	Q#4	4.16911e-17
C295	a_699_463##7	a_494_366##2	8.73621e-19
C296	VPWR#6	a_1678_395##3	2.37254e-18
C297	a_699_463##5	a_834_355##4	4.39025e-18
C298	VGND#7	a_1350_392##4	9.09416e-19
C299	a_1678_395##4	VPWR#6	7.73892e-18
C300	a_313_74##4	a_313_74##3	2.72533e-17
C301	a_2010_409##3	a_2010_409##2	5.45418e-18
C302	a_37_78##2	a_494_366##2	5.88907e-17
C303	a_494_366##4	a_494_366##5	2.1712e-17
C304	VPWR#14	a_1350_392##7	8.19011e-19
C305	RESET_B#9	a_1350_392##5	4.67563e-17
C306	a_2010_409##6	Q#3	2.15224e-17
C307	VPWR#4	a_1678_395##3	5.55515e-18
C308	VPWR#15	a_1350_392##6	1.5948e-18
C309	a_1678_395##7	a_1350_392#	9.03408e-19
C310	a_494_366##12	a_494_366##2	9.86238e-18
C311	VPWR#5	a_1678_395##3	1.53289e-19
C312	VGND#3	a_2010_409##12	2.9393e-19
C313	a_313_74##11	a_313_74##9	8.36308e-19
C314	Q#3	a_2010_409#	3.49413e-18
C315	VPWR#16	a_2010_409##8	3.9445e-20
C316	a_2010_409##16	a_2010_409##8	1.4766e-17
C317	VPWR#13	a_2010_409##4	9.83456e-20
C318	a_699_463##5	VPWR#8	7.19244e-18
C319	VGND#3	Q#1	8.01315e-18
C320	VPWR#4	a_494_366##6	7.99172e-18
C321	a_699_463##5	RESET_B#6	1.44138e-17
C322	Q#3	VPWR#1	1.26687e-17
C323	a_2010_409##17	a_1350_392##7	1.66065e-17
C324	VGND#13	a_1350_392##5	2.88433e-18
C325	a_313_74##4	RESET_B#2	1.09428e-19
C326	a_313_74##11	a_494_366##5	3.27761e-17
C327	Q#5	a_2010_409##7	6.22385e-18
C328	VGND#1	Q#3	2.75972e-18
C329	a_1678_395##4	a_1350_392##6	5.9543e-19
C330	a_1678_395##4	VPWR#5	7.3513e-18
C331	a_699_463##7	a_313_74##2	2.59781e-18
C332	a_313_74##4	a_37_78##2	7.9571e-19
C333	VPWR#14	a_1350_392##8	3.6965e-19
C334	Q#4	Q#7	2.08835e-19
C335	CLK#1	a_313_74##6	5.03419e-17
C336	a_313_74##4	a_494_366##12	4.63968e-17
C337	VGND#2	a_2010_409##12	9.56478e-19
C338	a_699_463##5	VPWR#17	3.12303e-18
C339	a_1350_392##7	VPWR#15	2.2906e-17
C340	Q#2	a_2010_409#	6.25712e-18
C341	VPWR#6	a_494_366##6	6.59398e-18
C342	a_1678_395##7	a_1350_392##5	3.43609e-17
C343	a_1350_392##10	a_1678_395##4	2.26526e-18
C344	a_699_463##2	a_494_366##5	1.22327e-18
C345	a_1678_395#	RESET_B#9	1.98014e-17
C346	a_2010_409##17	a_1350_392##8	1.9163e-18
C347	a_494_366##13	a_1350_392##12	3.82868e-18
C348	CLK#2	a_37_78##2	1.51879e-19
C349	VGND#2	Q#1	8.94871e-18
C350	a_1678_395##4	a_1350_392##7	2.39733e-18
C351	VGND#14	a_1350_392#	2.48093e-19
C352	VGND#13	RESET_B#9	2.94051e-19
C353	VGND#3	a_2010_409##13	6.98253e-18
C354	Q#3	a_2010_409##10	2.33177e-18
C355	CLK#2	a_494_366##12	3.18844e-18
C356	Q#2	VGND#1	2.30273e-17
C357	RESET_B#17	a_313_74##12	1.27481e-18
C358	a_699_463##2	RESET_B#7	1.64803e-17
C359	RESET_B#4	CLK#1	5.60817e-18
C360	RESET_B#17	a_699_463##6	3.35533e-17
C361	CLK#2	a_313_74##3	4.35957e-17
C362	a_1350_392##8	VPWR#15	1.29792e-17
C363	a_37_78##2	a_313_74##3	3.11584e-17
C364	VPWR#6	a_494_366##7	4.59465e-19
C365	VPWR#16	a_1350_392##7	3.78514e-19
C366	a_699_463##2	a_834_355#	1.11236e-18
C367	a_1350_392##10	VPWR#16	3.7754e-17
C368	RESET_B#17	a_699_463#	5.79343e-18
C369	VPWR#16	VPWR#5	1.04355e-18
C370	RESET_B#17	a_699_463##5	3.9403e-17
C371	a_313_74##16	CLK#2	2.73767e-17
C372	a_699_463##5	a_699_463##8	1.94525e-18
C373	RESET_B#17	a_313_74##2	6.26754e-19
C374	VPWR#7	a_313_74##12	8.86049e-18
C375	a_1678_395##7	RESET_B#9	3.37777e-18
C376	Q#4	VPWR#13	4.29533e-17
C377	a_2010_409##16	a_1350_392##4	1.43375e-18
C378	a_1678_395##4	a_1350_392##8	3.54211e-17
C379	VGND#7	a_1350_392#	1.99871e-19
C380	a_494_366##13	a_834_355##5	7.45039e-17
C381	Q#2	a_2010_409##10	2.15609e-17
C382	RESET_B#2	CLK#2	1.41918e-17
C383	a_1350_392##4	a_1350_392##7	7.49418e-18
C384	RESET_B#17	RESET_B#6	3.09083e-19
C385	a_699_463##9	a_313_74##5	2.70037e-19
C386	VGND#14	a_1350_392##5	3.35187e-18
C387	a_699_463##6	VPWR#18	4.99005e-18
C388	VGND#7	a_1678_395##2	2.11582e-18
C389	D#3	RESET_B#4	2.80351e-17
C390	a_37_78##2	a_313_74##2	5.98794e-18
C391	VGND#13	a_1678_395#	2.21408e-19
C392	a_313_74##9	a_1678_395#	3.34747e-17
C393	VPWR#6	a_313_74##12	4.02781e-19
C394	a_37_78##5	RESET_B#2	8.5776e-18
C395	VPWR#15	RESET_B#11	3.51029e-19
C396	a_1678_395##5	a_1350_392##6	5.58488e-19
C397	VPWR#16	a_1350_392##8	1.51243e-18
C398	a_1678_395##5	a_1350_392##4	9.39843e-17
C399	VGND#3	a_1350_392#	7.27596e-19
C400	Q#3	a_2010_409##12	5.17538e-20
C401	Q#2	Q#6	1.00116e-18
C402	RESET_B#17	a_313_74##5	2.34744e-18
C403	VGND#3	a_2010_409##15	7.68862e-18
C404	a_1678_395##4	RESET_B#11	2.44778e-17
C405	a_1350_392##10	a_1627_493#	1.76978e-18
C406	a_494_366##12	D#2	1.84264e-19
C407	a_1678_395##7	a_1678_395#	1.38316e-18
C408	a_494_366##13	VGND#15	1.17273e-17
C409	RESET_B#10	a_1350_392##8	1.77145e-17
C410	a_699_463##5	VPWR#18	3.16979e-17
C411	a_1350_392##10	VPWR#7	9.40867e-18
C412	a_313_74##14	a_313_74##8	5.85047e-20
C413	VPWR#9	RESET_B#8	3.94393e-18
C414	a_834_355##2	a_699_463##3	2.35647e-19
C415	VPWR#6	a_313_74##9	6.82852e-20
C416	VGND#7	VGND#13	3.68645e-19
C417	RESET_B#17	a_494_366##3	2.19026e-19
C418	VPWR#15	a_1678_395##3	1.72782e-19
C419	RESET_B#17	RESET_B#15	2.1844e-17
C420	RESET_B#9	VGND#14	1.84525e-17
C421	Q#1	Q#4	3.67795e-20
C422	a_834_355##2	RESET_B#7	2.43535e-17
C423	VPWR#7	a_699_463#	8.1604e-18
C424	Q#5	Q#4	1.02221e-18
C425	RESET_B#11	VPWR#16	1.45794e-17
C426	VPWR#9	a_834_355##3	3.26758e-18
C427	Q#2	a_2010_409##12	1.03508e-20
C428	VGND#7	a_1350_392##5	4.62919e-18
C429	a_494_366##12	a_313_74##3	4.88992e-17
C430	a_2010_409##16	a_2010_409##10	6.56382e-20
C431	a_1350_392##10	a_1350_392##8	6.57702e-20
C432	a_834_355##2	a_834_355#	1.21786e-17
C433	a_494_366##5	a_313_74##9	3.63426e-18
C434	a_1678_395##3	RESET_B#10	3.11235e-17
C435	a_1678_395##4	a_1678_395##3	8.14408e-19
C436	a_1678_395##5	a_1350_392##7	7.19479e-18
C437	a_1350_392##4	a_313_74##12	4.78787e-20
C438	a_494_366#	a_834_355##2	1.39473e-17
C439	a_37_78##2	RESET_B#2	1.608e-19
C440	a_699_463##6	VPWR#9	9.3726e-18
C441	a_1350_392##10	VPWR#6	2.61425e-17
C442	VPWR#7	a_494_366##5	3.84178e-19
C443	VPWR#12	D#2	3.27608e-18
C444	a_1678_395##5	RESET_B#10	8.24381e-20
C445	VGND#3	a_2010_409##7	6.52034e-20
C446	a_1678_395##7	a_313_74##9	8.28347e-20
C447	RESET_B#7	a_313_74##2	1.71565e-19
C448	Q#3	a_2010_409##13	2.14813e-20
C449	VPWR#9	a_494_366##3	6.68701e-18
C450	Q#2	VGND#5	1.7777e-17
C451	a_313_74##14	a_313_74##7	3.13109e-19
C452	VGND#9	a_313_74##5	6.26891e-19
C453	VPWR#9	a_699_463##5	1.46641e-17
C454	a_313_74##11	VPWR#7	4.62145e-18
C455	a_1678_395##3	VPWR#16	1.8082e-17
C456	a_494_366##12	a_313_74##2	3.66953e-20
C457	a_1350_392##4	RESET_B#19	1.1824e-17
C458	a_1678_395#	VGND#14	2.60407e-17
C459	VPWR#8	RESET_B#8	2.70042e-18
C460	a_1350_392##10	RESET_B#11	5.25339e-20
C461	a_494_366##2	a_494_366#	1.19059e-18
C462	VPWR#9	a_313_74##6	5.0922e-18
C463	VPWR#6	a_313_74##11	1.18126e-19
C464	a_494_366##7	a_1678_395##3	2.4373e-17
C465	RESET_B#18	VPWR#4	4.46718e-17
C466	a_313_74##8	a_494_366##2	2.90374e-17
C467	a_313_74##12	a_1678_395##2	1.2741e-19
C468	Q#2	a_2010_409##13	4.29626e-21
C469	VGND#8	a_494_366##4	6.97525e-17
C470	Q#6	VGND#1	4.16301e-17
C471	VPWR#9	CLK#1	4.6571e-18
C472	VGND#7	RESET_B#9	4.94716e-18
C473	a_37_78#	a_699_463##9	9.76593e-17
C474	a_699_463##3	a_494_366##5	1.44265e-18
C475	VPWR#17	a_1350_392##10	5.00109e-18
C476	a_313_74##4	a_494_366#	2.13193e-19
C477	VGND#4	VGND#1	6.63045e-17
C478	VGND#7	a_494_366##4	1.00696e-16
C479	VPWR#16	a_494_366##6	2.83155e-18
C480	VPWR#9	RESET_B#4	5.13749e-19
C481	a_37_78##4	VPWR#11	4.36645e-18
C482	a_1350_392##10	a_1678_395##3	2.21632e-17
C483	a_313_74##12	a_494_366##7	3.46166e-18
C484	a_313_74##4	a_313_74##8	2.47887e-19
C485	a_1678_395##2	a_1678_395##5	3.32064e-18
C486	VGND#14	a_313_74##9	4.11289e-18
C487	CLK	a_313_74##3	1.61884e-18
C488	a_313_74##14	CLK#3	3.9394e-17
C489	VPWR#9	a_313_74##3	8.61265e-20
C490	VPWR#19	a_313_74##3	7.95248e-19
C491	VGND#4	Q#6	1.53449e-17
C492	a_699_463##7	a_699_463##5	1.45555e-18
C493	Q#3	a_1350_392#	9.00162e-20
C494	VPWR#9	D#3	3.00395e-18
C495	a_313_74##4	a_313_74##7	1.00496e-17
C496	CLK	RESET_B#2	2.24457e-19
C497	RESET_B#19	RESET_B#10	6.08329e-18
C498	VPWR#9	RESET_B#15	2.66757e-18
C499	Q#5	a_1350_392##2	1.94069e-19
C500	CLK#2	a_494_366#	8.03746e-21
C501	VPWR#7	a_699_463##2	3.04179e-20
C502	VPWR#9	a_313_74##2	3.52615e-17
C503	a_313_74##4	CLK#3	1.01873e-20
C504	a_494_366##12	RESET_B#2	9.34128e-19
C505	RESET_B#17	VPWR#4	9.53951e-18
C506	VGND#4	VGND#5	1.65071e-17
C507	VPWR#8	a_834_355##3	2.35275e-18
C508	a_37_78##2	a_699_463##6	4.32452e-17
C509	a_494_366##13	a_699_463##9	5.40558e-17
C510	a_313_74##11	a_494_366##6	1.92625e-19
C511	VGND#5	VGND#1	1.87873e-18
C512	VPWR#16	a_313_74##12	8.76812e-19
C513	VPWR#9	a_37_78##4	1.12055e-17
C514	D#2	RESET_B#2	7.17282e-17
C515	VGND#2	a_2010_409##7	8.53572e-20
C516	RESET_B#15	VPWR#8	5.77408e-19
C517	a_1350_392##10	a_494_366##6	3.90778e-17
C518	Q#2	a_1350_392#	2.36885e-21
C519	VPWR#19	a_313_74##2	3.77763e-18
C520	VGND#4	Q#1	1.81608e-17
C521	a_313_74##11	a_313_74##12	1.56799e-17
C522	RESET_B#7	a_699_463##3	4.45517e-18
C523	VGND#8	a_313_74##11	2.67607e-19
C524	VPWR#8	RESET_B#7	5.3254e-20
C525	VGND#7	a_1678_395#	4.15572e-18
C526	a_37_78##4	VPWR#10	3.09473e-18
C527	RESET_B#18	VGND#14	4.23376e-18
C528	VGND#14	a_494_366##5	1.34737e-20
C529	a_699_463#	a_313_74##11	1.06052e-17
C530	VGND#7	a_313_74##11	1.61869e-20
C531	a_313_74##14	RESET_B#3	2.95578e-18
C532	a_494_366##13	a_890_138#	3.46571e-19
C533	a_2010_409##6	a_2010_409##7	3.63142e-17
C534	a_313_74##9	a_1350_392##12	1.32912e-17
C535	a_834_355#	RESET_B#6	1.60858e-18
C536	a_313_74##11	RESET_B#8	1.28257e-19
C537	VGND#9	RESET_B#15	1.9674e-18
C538	a_494_366##13	a_37_78#	8.46301e-17
C539	RESET_B#19	a_1678_395##2	5.90764e-19
C540	a_313_74##12	a_1350_392##10	1.77047e-17
C541	a_2010_409##16	Q#5	2.21231e-17
C542	VPWR#8	a_313_74#	1.09283e-17
C543	VGND#4	a_2010_409##15	2.70908e-17
C544	VGND#5	Q#6	3.36303e-17
C545	VPWR#17	a_494_366##6	1.4456e-18
C546	RESET_B#18	a_1350_392##12	5.00821e-18
C547	a_313_74#	a_313_74##12	3.68629e-18
C548	a_2010_409##15	Q#3	1.29801e-19
C549	RESET_B#15	VPWR#7	5.34354e-19
C550	a_313_74#	VPWR#7	2.22162e-17
C551	RESET_B#17	VPWR#9	8.55078e-17
C552	a_2010_409##6	a_2010_409##4	3.48904e-18
C553	VPWR#4	a_2010_409##6	6.32149e-18
C554	VGND#9	a_313_74##3	2.82318e-18
C555	a_313_74##3	a_494_366#	9.92784e-19
C556	RESET_B#18	a_1350_392##4	1.21302e-17
C557	a_834_355##4	a_313_74##12	3.16908e-17
C558	a_313_74##16	a_313_74##3	3.10413e-19
C559	Q#4	VPWR#2	1.34496e-19
C560	a_313_74#	a_699_463#	4.13805e-17
C561	a_37_78##4	a_313_74##3	1.7875e-19
C562	a_834_355#	RESET_B#7	4.37095e-17
C563	a_1350_392##3	a_1350_392##2	5.02352e-18
C564	D	RESET_B#2	3.51504e-18
C565	a_2010_409##16	a_1350_392#	5.91599e-18
C566	VGND#9	RESET_B#17	2.10633e-18
C567	a_2010_409##6	a_2010_409##3	2.36446e-18
C568	VGND#4	a_2010_409##6	6.29357e-18
C569	VGND#8	a_699_463##2	3.30809e-19
C570	a_313_74##14	D#1	3.77051e-19
C571	a_1350_392##12	a_494_366##5	4.95839e-17
C572	VGND#4	a_1678_395##7	3.3975e-17
C573	RESET_B#8	a_313_74#	2.8085e-17
C574	VPWR#4	a_1350_392##4	3.90835e-18
C575	VGND#7	a_313_74##9	4.08596e-18
C576	a_1350_392##10	a_699_463#	1.41339e-18
C577	D#2	RESET_B#3	3.48376e-18
C578	RESET_B#18	RESET_B#10	1.36081e-17
C579	VGND#9	a_313_74##14	2.30004e-17
C580	RESET_B#15	RESET_B#6	2.43705e-18
C581	VPWR#17	a_313_74##12	4.45323e-18
C582	RESET_B#5	a_699_463#	4.73098e-18
C583	a_699_463##6	a_699_463##5	5.86955e-18
C584	a_494_366#	a_313_74##2	1.72918e-19
C585	a_494_366##4	a_1678_395##5	1.32796e-18
C586	VGND#4	a_1350_392##4	1.01368e-17
C587	VPWR#4	RESET_B#10	2.62213e-18
C588	Q#1	Q#6	3.53138e-18
C589	RESET_B#18	a_1678_395##2	6.51194e-18
C590	a_834_355##4	a_699_463#	4.25344e-17
C591	a_699_463##9	a_812_138#	2.05633e-19
C592	a_313_74##5	a_313_74#	1.23595e-19
C593	a_2010_409##15	Q#2	9.21331e-21
C594	a_2010_409##16	VPWR#14	1.90774e-17
C595	a_494_366##5	a_834_355##5	2.29244e-17
C596	VPWR#18	VPWR#17	5.329e-18
C597	VGND#9	RESET_B#2	1.77244e-18
C598	VGND#4	RESET_B#10	4.38502e-19
C599	VPWR#8	RESET_B#5	7.28164e-19
C600	VGND#8	a_494_366##5	1.40952e-19
C601	RESET_B#18	a_494_366##7	4.7508e-17
C602	a_834_355##2	RESET_B#8	1.29183e-18
C603	a_1350_392##5	a_1827_81#	9.87534e-18
C604	VPWR#17	a_699_463#	3.05009e-17
C605	a_2010_409##17	a_1350_392##3	1.53788e-18
C606	VPWR#7	RESET_B#5	2.56348e-19
C607	a_1350_392##12	a_699_463##3	1.32934e-18
C608	a_699_463##9	a_699_463##6	1.82774e-19
C609	a_494_366#	a_834_355#	4.67062e-17
C610	VGND#4	a_1678_395##2	5.9171e-18
C611	VGND#16	a_494_366##13	4.38683e-17
C612	RESET_B#9	a_1827_81#	9.87534e-18
C613	VPWR#4	a_494_366##7	2.0069e-18
C614	a_1678_395##5	a_1350_392#	3.69412e-18
C615	RESET_B#18	a_494_366##4	1.10427e-17
C616	VPWR#18	VPWR#7	1.39361e-19
C617	VGND#6	a_2010_409##16	1.08924e-17
C618	a_834_355##4	RESET_B#8	4.35382e-19
C619	Q	a_2010_409##2	9.95439e-18
C620	a_313_74##5	a_834_355##2	2.48692e-18
C621	VGND#7	a_494_366##5	4.80842e-18
C622	VGND#4	a_494_366##7	2.94828e-19
C623	VGND#4	a_1350_392##12	1.6014e-17
C624	Q#1	VGND#5	4.65006e-17
C625	VPWR#8	a_494_366#	3.25469e-19
C626	RESET_B#18	a_313_74##11	5.84445e-18
C627	a_834_355##5	a_699_463##3	5.59262e-17
C628	VPWR#20	a_313_74##3	1.27863e-19
C629	a_494_366##3	a_834_355##2	1.87687e-18
C630	VGND#10	a_313_74##3	1.56603e-19
C631	VPWR#17	RESET_B#8	9.73884e-19
C632	VGND#4	a_494_366##4	5.60724e-17
C633	VGND#4	a_834_355##5	4.86331e-18
C634	a_2010_409##17	a_1350_392##2	2.98452e-18
C635	a_494_366##2	a_313_74##5	5.77741e-18
C636	VPWR#4	a_313_74##11	5.27727e-18
C637	VPWR#18	a_699_463#	7.55414e-19
C638	a_313_74##16	RESET_B#2	8.34165e-18
C639	RESET_B#17	a_494_366##4	6.40779e-18
C640	VPWR#11	VPWR#10	1.17639e-18
C641	VGND#4	a_313_74##11	4.31481e-18
C642	VPWR#10	a_313_74##6	3.86853e-18
C643	VGND#8	a_699_463##3	7.28755e-18
C644	a_313_74##8	a_313_74##2	1.0471e-19
C645	RESET_B#8	a_699_463##8	4.64674e-18
C646	a_313_74##8	a_494_366#	2.6099e-17
C647	a_699_463##3	VGND#15	1.45517e-17
C648	Q#4	a_2010_409##7	5.69888e-18
C649	RESET_B#17	a_313_74##11	3.90043e-17
C650	RESET_B#6	a_699_463#	4.23111e-19
C651	a_1678_395##5	a_1350_392##5	1.30369e-17
C652	a_1350_392##4	a_1350_392##3	4.06163e-18
C653	RESET_B#19	a_1678_395##3	4.99004e-18
C654	a_1350_392##4	RESET_B#10	8.05582e-17
C655	VGND#6	VGND#5	2.99849e-18
C656	VPWR#17	a_834_355##3	2.55728e-19
C657	a_834_355##5	RESET_B#7	2.0591e-18
C658	RESET_B#8	VPWR#18	1.74817e-17
C659	a_313_74##9	a_1647_81#	7.54101e-18
C660	VGND#8	RESET_B#5	4.58175e-19
C661	a_699_463##2	RESET_B#17	4.81021e-17
C662	RESET_B#17	a_834_355##5	1.41887e-17
C663	a_1350_392##4	a_1350_392##2	1.15564e-18
C664	a_1350_392##4	a_1678_395##2	7.06133e-17
C665	VPWR#15	a_1350_392##3	4.0187e-19
C666	VGND#9	a_494_366##4	1.90096e-17
C667	VPWR#9	a_313_74##11	1.96174e-18
C668	RESET_B#17	a_313_74#	5.52639e-17
C669	a_1678_395##2	RESET_B#10	1.68068e-17
C670	RESET_B#17	VGND#15	3.93502e-24
C671	a_37_78##4	RESET_B#2	2.70854e-17
C672	a_494_366##7	a_1350_392##4	1.90982e-17
C673	VPWR#11	CLK#1	8.51904e-19
C674	RESET_B#7	VGND#15	1.31119e-17
C675	VGND#9	a_313_74##11	2.6425e-18
C676	a_1678_395##3	a_1627_493#	8.26036e-18
C677	VPWR#9	a_699_463##2	2.86419e-18
C678	VPWR#17	a_313_74##5	1.38276e-19
C679	a_313_74##7	a_313_74##8	3.44947e-18
C680	a_834_355##3	VPWR#18	1.58626e-17
C681	a_494_366##6	a_1627_493#	8.06292e-18
C682	RESET_B#17	RESET_B#5	8.86424e-18
C683	a_494_366##4	a_1350_392##4	2.25622e-17
C684	a_37_78##6	a_313_74##3	1.80454e-19
C685	a_2010_409##6	VGND#5	1.20174e-18
C686	VGND#8	RESET_B#7	2.60764e-18
C687	a_313_74##14	a_313_74##3	2.80945e-19
C688	a_699_463##7	RESET_B#8	4.8806e-19
C689	VGND#9	a_699_463##2	1.17413e-17
C690	a_834_355##5	a_834_355#	5.32338e-19
C691	VGND#6	Q#1	6.27956e-17
C692	a_1678_395##5	a_2010_409##17	3.04762e-17
C693	VPWR#10	CLK#1	4.53685e-18
C694	VPWR#9	a_313_74#	1.65889e-17
C695	a_2010_409##7	a_2010_409##10	3.85181e-18
C696	VGND#3	VGND#2	1.27212e-18
C697	a_494_366##7	a_1678_395##2	2.69535e-19
C698	a_699_463##7	VPWR#18	3.37416e-18
C699	a_494_366##4	RESET_B#10	2.04913e-19
C700	VPWR#20	RESET_B#2	1.74911e-18
C701	a_1350_392##4	a_313_74##11	2.19178e-20
C702	a_1678_395##5	RESET_B#9	6.88684e-19
C703	VGND#2	a_2010_409##2	4.88124e-20
C704	RESET_B#17	a_834_355##2	3.75853e-17
C705	a_2010_409##6	Q#1	6.74555e-17
C706	VGND#17	VGND#16	1.07194e-18
C707	VGND#9	a_313_74#	1.79221e-19
C708	RESET_B#8	a_313_74##2	1.37126e-17
C709	a_37_78##4	a_494_366##12	9.80473e-19
C710	VGND#13	a_2010_409##16	1.65393e-17
C711	VPWR#9	RESET_B#5	1.3101e-19
C712	a_494_366##4	a_1678_395##2	4.38191e-17
C713	a_2010_409##16	VPWR#3	4.64979e-19
C714	a_37_78##2	VPWR#10	4.63654e-18
C715	a_699_463##9	a_699_463##3	3.62196e-19
C716	VGND#8	a_834_355##2	1.05262e-19
C717	a_2010_409##6	VGND#6	2.65129e-17
C718	RESET_B#17	a_494_366##2	8.48462e-18
C719	RESET_B#17	a_699_463##9	3.71304e-18
C720	VPWR#18	a_313_74##5	2.48371e-18
C721	Q#3	a_2010_409##7	1.14187e-18
C722	VPWR#9	a_834_355##2	2.06406e-18
C723	a_699_463##7	a_834_355##3	5.79584e-19
C724	a_494_366##4	a_494_366##7	1.69442e-19
C725	a_313_74##11	a_1678_395##2	9.49898e-20
C726	VGND#8	VGND#15	6.01655e-18
C727	RESET_B#7	a_890_138#	5.99352e-18
C728	a_494_366##13	a_494_366##5	1.59226e-18
C729	a_834_355#	a_890_138#	7.06328e-18
C730	CLK#3	a_313_74##7	2.07569e-17
C731	a_834_355##5	a_494_366#	3.7683e-19
C732	VGND#9	a_834_355##2	7.73333e-18
C733	RESET_B#17	a_37_78#	2.49979e-18
C734	a_494_366##7	a_313_74##11	1.31005e-17
C735	VPWR#9	a_494_366##2	4.77529e-19
C736	VPWR#11	RESET_B#4	5.69303e-18
C737	a_834_355##3	a_789_463#	6.38974e-18
C738	a_1678_395##5	a_2010_409##15	2.78885e-18
C739	a_37_78##2	a_834_355##3	3.23099e-19
C740	a_313_74##5	a_789_463#	6.76931e-18
C741	VGND#9	a_494_366##2	2.25819e-18
C742	a_494_366##4	a_313_74##11	4.16709e-17
C743	a_1678_395##5	VPWR#15	1.15868e-17
C744	RESET_B#17	a_494_366##13	8.96595e-18
C745	VGND#8	a_834_355#	2.0979e-18
C746	a_37_78##5	a_124_78#	2.79278e-18
C747	Q#4	a_2010_409##4	2.45667e-19
C748	VPWR#9	a_313_74##4	5.46072e-19
C749	VPWR#18	a_494_366##3	6.35264e-19
C750	a_699_463##9	RESET_B#7	5.64006e-19
C751	a_699_463##7	a_313_74##5	2.39374e-17
C752	a_1678_395##5	a_1678_395#	5.02136e-20
C753	a_494_366##4	a_699_463##2	1.20084e-18
C754	a_313_74#	a_494_366##7	3.03629e-19
C755	VGND#9	a_313_74##4	5.00367e-18
C756	VPWR#4	VPWR#1	7.2614e-17
C757	VPWR#18	a_494_366##12	2.10497e-20
C758	VPWR#9	CLK#2	7.75241e-19
C759	a_494_366##13	a_699_463##3	3.0188e-17
C760	CLK#3	a_313_74##3	4.90517e-18
C761	a_699_463##2	a_313_74##11	3.62314e-17
C762	a_834_355##5	RESET_B#6	7.63104e-21
C763	a_2010_409##15	a_1350_392##4	1.48606e-19
C764	a_37_78##2	a_313_74##5	8.42343e-18
C765	VGND#9	CLK#2	4.94632e-18
C766	VPWR#4	Q#7	2.05396e-17
C767	VPWR#19	a_834_355##3	2.0926e-19
C768	a_2010_409##15	VGND#6	5.80801e-17
C769	RESET_B#3	CLK#3	4.63496e-18
C770	a_834_355#	a_812_138#	4.13345e-18
C771	a_313_74##11	a_313_74#	2.67494e-18
C772	D	a_37_78##4	6.52989e-17
C773	VGND#9	a_834_355##5	2.22124e-17
C774	VPWR#18	a_313_74##6	7.87988e-19
C775	a_834_355##3	a_313_74##2	1.75068e-17
C776	VGND#13	a_1350_392##4	2.90955e-20
C777	a_494_366#	a_812_138#	7.56152e-18
C778	a_494_366##3	a_699_463##7	8.47903e-18
C779	RESET_B#18	VPWR#14	1.32602e-18
C780	a_699_463##2	a_313_74#	1.22684e-17
C781	a_1678_395##5	VGND#13	2.81569e-17
C782	a_699_463##9	a_834_355#	7.12129e-18
C783	VPWR#4	VPWR#13	4.25455e-17
C784	a_37_78##2	a_699_463##7	5.4322e-17
C785	a_699_463##5	RESET_B#15	4.90118e-17
C786	VPWR#11	D#3	3.38183e-18
C787	VPWR	VPWR#7	3.92206e-18
C788	a_37_78##4	a_313_74##16	4.4317e-17
C789	a_1678_395##5	a_1678_395##4	2.9793e-18
C790	VPWR#11	VPWR#19	3.5834e-19
C791	a_699_463##2	RESET_B#5	7.87034e-18
C792	RESET_B#18	a_2010_409##17	1.64541e-18
C793	a_37_78##2	a_494_366##3	3.63473e-17
C794	a_494_366##13	RESET_B#7	1.33943e-17
C795	VPWR#10	CLK#2	8.19929e-20
C796	VGND#8	RESET_B#6	4.05006e-21
C797	VPWR#4	Q#5	1.91826e-17
C798	VPWR#19	a_313_74##5	5.09467e-19
C799	a_1678_395##5	a_313_74##9	1.07158e-19
C800	VPWR#14	a_1350_392#	1.29334e-18
C801	RESET_B#5	a_313_74#	1.48963e-17
C802	a_834_355##2	a_699_463##2	4.75333e-17
C803	VGND#10	a_313_74##4	7.15943e-19
C804	a_494_366##12	a_494_366##3	2.7089e-19
C805	VGND#13	VGND#6	2.53166e-18
C806	D#1	RESET_B#3	3.54363e-17
C807	a_313_74##14	RESET_B#2	6.74512e-18
C808	Q#3	a_2010_409##4	4.28175e-18
C809	a_699_463##9	a_494_366#	4.66845e-17
C810	RESET_B#18	a_1678_395##4	5.95748e-18
C811	a_37_78##2	a_313_74##6	2.49883e-17
C812	VGND#9	a_699_463##9	1.13938e-17
C813	RESET_B#2	CLK#3	3.26575e-18
C814	a_2010_409##17	VPWR#4	2.45594e-17
C815	VPWR#19	a_494_366##3	1.22679e-18
C816	a_699_463##2	a_699_463##5	1.92599e-18
C817	a_494_366##13	a_834_355#	8.22656e-18
C818	VGND#4	Q#5	3.94117e-18
C819	VGND#1	Q	2.89493e-17
C820	a_37_78##4	VPWR#20	3.22352e-17
C821	VGND#9	a_37_78#	1.06884e-17
C822	RESET_B#18	VPWR#16	1.29487e-17
C823	a_494_366##12	a_313_74##6	2.86022e-17
C824	a_494_366##2	a_834_355##2	1.3298e-17
C825	a_37_78##5	VGND#17	2.19358e-17
C826	a_37_78#	a_494_366#	9.04472e-18
C827	a_37_78##2	a_494_366##12	5.78415e-17
C828	D	a_37_78##5	7.6624e-17
C829	RESET_B#18	a_1647_81#	2.59076e-18
C830	a_313_74##14	a_313_74##16	3.222e-18
C831	a_313_74##2	a_313_74##5	7.35462e-19
C832	VGND#9	a_494_366##13	1.59943e-16
C833	VGND#13	a_2010_409##15	6.91454e-17
C834	VGND#14	RESET_B#10	5.6784e-19
C835	a_37_78##2	CLK#1	1.0436e-17
C836	VPWR#4	a_1678_395##4	1.86881e-17
C837	VPWR#19	a_313_74##6	3.98246e-17
C838	VPWR#8	VPWR#7	2.5085e-19
C839	a_313_74##8	a_699_463##9	1.19489e-17
C840	VPWR#20	a_494_366##3	9.94794e-20
C841	CLK	a_37_78##2	5.74371e-18
C842	VGND#10	CLK#2	5.62273e-20
C843	CLK	a_494_366##12	8.60282e-18
C844	a_494_366##13	a_494_366#	1.35579e-17
C845	RESET_B#18	a_1350_392##10	6.29396e-17
C846	a_494_366##12	CLK#1	3.12905e-18
C847	a_313_74##16	CLK	5.41101e-18
C848	a_699_463##2	RESET_B#15	2.77247e-17
C849	Q#3	a_2010_409##3	1.06277e-17
C850	a_313_74##16	a_313_74##6	1.92048e-18
C851	a_37_78##2	VPWR#19	3.97434e-17
C852	VGND#5	a_2010_409##7	9.34221e-20
C853	a_699_463##5	a_313_74#	4.03103e-17
C854	a_313_74##4	CLK#2	3.10831e-17
C855	a_37_78#	a_313_74##8	5.37707e-17
C856	VGND#10	a_313_74##7	6.80671e-18
C857	a_37_78##2	RESET_B#4	4.49704e-19
C858	RESET_B#3	a_124_78#	6.24915e-18
C859	Q	VPWR#1	3.2649e-17
C860	VPWR#19	CLK#1	3.6349e-17
C861	D#1	a_124_78#	8.20925e-18
C862	VGND#4	a_1678_395##4	6.91126e-19
C863	VPWR#20	a_313_74##6	2.25727e-19
C864	a_1678_395##2	VGND#14	3.81618e-17
C865	Q#2	a_2010_409##4	2.41583e-18
C866	a_2010_409##7	VNB	9.43901e-17
C867	VPWR#4	a_1350_392##10	3.84606e-17
C868	a_2010_409##4	VNB	2.01574e-17
C869	a_2010_409##3	VNB	9.33327e-18
C870	CLK#1	a_313_74##16	2.6397e-17
C871	a_2010_409##2	VNB	2.98109e-17
C872	a_1350_392##3	VNB	2.3056e-17
C873	a_1350_392##2	VNB	2.04977e-17
C874	a_494_366##13	a_313_74##8	1.20311e-17
C875	a_37_78##6	a_313_74##6	3.10301e-19
C876	a_313_74##3	VNB	1.1166e-16
C877	a_313_74##2	VNB	1.35172e-16
C878	D	VPWR#12	1.99173e-17
C879	RESET_B#6	VNB	3.22417e-17
C880	a_313_74##3	a_494_366##3	2.33672e-17
C881	RESET_B#2	VNB	1.26233e-16
C882	VGND	VGND#8	3.09949e-18
C883	VPWR#19	RESET_B#4	3.29726e-18
C884	VGND#9	a_37_78##5	2.78085e-17
C885	RESET_B#15	a_313_74#	5.56311e-18
C886	VPWR#20	CLK#1	5.42386e-18
C887	a_37_78#	a_313_74##7	6.28165e-19
C888	a_1350_392##12	a_1350_392##10	4.28803e-19
C889	a_1350_392#	a_2010_409##7	2.50844e-18
C890	a_699_463##5	RESET_B#5	3.93383e-18
C891	a_313_74##2	a_494_366##3	1.84466e-17
C892	VPWR#12	a_37_78##4	8.32703e-19
C893	Q#3	a_2010_409##2	1.62364e-17
C894	a_313_74##16	a_494_366##12	5.49476e-18
C895	a_1678_395##7	VGND#13	3.26888e-17
C896	VPWR#20	a_37_78##2	1.02203e-18
C897	a_37_78##6	CLK#1	1.21416e-18
C898	VGND#10	CLK#3	4.71694e-18
C899	Q	a_2010_409#	2.8071e-18
C900	a_494_366##13	a_313_74##7	3.89554e-17
C901	a_699_463##5	a_313_74##12	7.56234e-19
C902	RESET_B#4	VPWR#20	1.94479e-17
C903	a_2010_409##11	a_2010_409##9	4.65552e-17
C904	a_2010_409##16	a_2010_409##7	3.20304e-18
C905	RESET_B#18	VPWR#7	9.13426e-19
C906	a_494_366##4	a_1678_395##7	7.78651e-19
C907	VPWR#12	CLK#1	1.75495e-19
C908	Q#1	a_2010_409##7	5.11429e-18
C909	VGND#10	a_494_366##13	1.50912e-17
C910	VPWR#11	VNB	3.65482e-17
C911	VPWR#10	VNB	3.80299e-17
C912	VGND#5	a_2010_409##4	1.34287e-18
C913	VPWR#8	VNB	3.3146e-17
C914	a_699_463##6	a_834_355##2	4.65667e-17
C915	VPWR#7	VNB	6.7516e-17
C916	VPWR#6	VNB	6.33419e-17
C917	VGND#2	Q#2	2.80471e-19
C918	VPWR#5	VNB	2.40738e-17
C919	a_37_78##6	RESET_B#4	2.69874e-17
C920	RESET_B#15	RESET_B#5	1.45873e-17
C921	VGND#10	a_313_74##14	1.21289e-17
C922	VPWR#3	VNB	2.65704e-17
C923	RESET_B#18	VPWR#6	6.90891e-18
C924	VPWR#2	VNB	4.79399e-17
C925	RESET_B#17	a_1350_392##10	1.22401e-17
C926	a_313_74##7	VGND#16	2.27449e-17
C927	VGND#10	VNB	3.83438e-17
C928	a_37_78##6	VPWR#11	1.65854e-17
C929	VGND#8	VNB	9.13624e-17
C930	a_834_355##2	a_890_138#	5.2584e-19
C931	VGND#7	VNB	8.41436e-17
C932	VGND#3	VNB	3.26495e-17
C933	a_834_355##2	a_699_463##5	6.21e-17
C934	VGND#2	VNB	3.51717e-17
C935	Q#4	VNB	5.56839e-18
C936	Q#3	VNB	1.28848e-18
C937	a_494_366##4	VGND#14	2.85258e-17
C938	Q#2	VNB	1.54258e-18
C939	a_313_74##14	a_494_366##13	5.79861e-19
C940	a_2010_409##16	VNB	1.085e-17
C941	VPWR#20	D#3	7.14071e-19
C942	a_1678_395##5	VNB	1.44998e-17
C943	RESET_B#17	a_834_355##4	5.64595e-17
C944	VPWR#12	RESET_B#4	1.26838e-18
C945	a_494_366##13	CLK#3	9.19763e-20
C946	a_313_74##6	a_313_74##3	3.04182e-17
C947	CLK	CLK#1	1.76405e-18
C948	a_699_463##9	a_313_74##3	1.21502e-19
C949	a_2010_409##14	a_2010_409##11	8.00005e-18
C950	a_313_74##3	a_313_74##2	9.52321e-20
C951	a_834_355##5	a_834_355##4	2.08104e-18
C952	a_2010_409##6	VPWR#13	1.03638e-17
C953	a_37_78##6	D#3	2.35212e-17
C954	VPWR#20	VPWR#19	1.03267e-17
C955	a_699_463##6	VNB	7.09914e-18
C956	VGND#8	a_494_366##13	1.18604e-16
C957	a_699_463##5	VNB	2.43079e-18
C958	RESET_B#17	VPWR#17	7.59131e-18
C959	a_699_463##5	a_699_463#	1.80843e-18
C960	a_1350_392##12	a_494_366##4	2.01308e-16
C961	RESET_B#15	VNB	5.8187e-18
C962	a_37_78##4	VNB	2.00013e-17
C963	a_313_74##14	VNB	1.53988e-17
C964	a_313_74##6	a_313_74##2	1.79954e-17
C965	CLK#3	VGND#16	2.49422e-17
C966	VGND#1	VNB	6.83899e-17
C967	a_2010_409##6	Q#5	4.50961e-17
C968	Q#6	VNB	2.24153e-18
C969	VGND#5	VNB	3.9939e-19
C970	RESET_B#19	VPWR#16	1.52597e-17
C971	VPWR#4	VPWR#7	3.74697e-17
C972	Q#1	VNB	5.22812e-18
C973	a_699_463##6	a_494_366##2	2.51725e-18
C974	a_494_366##4	a_834_355##5	6.6593e-17
C975	VPWR#12	D#3	1.75345e-17
C976	VGND#6	VNB	1.14934e-17
C977	a_2010_409##15	VNB	1.15174e-17
C978	VGND#13	VNB	4.24444e-18
C979	a_1678_395##7	VNB	9.7253e-18
C980	VPWR#9	CLK	1.2712e-18
C981	VGND#17	a_313_74##7	1.31506e-19
C982	VGND#14	VNB	5.10976e-18
C983	a_1350_392##12	VNB	1.98467e-18
C984	a_834_355##5	VNB	1.63444e-18
C985	VGND#14	VGND#13	1.7067e-18
C986	VGND#3	a_2010_409##16	6.60172e-19
C987	a_699_463##9	VNB	9.64636e-19
C988	a_313_74##14	VGND#16	6.00882e-17
C989	a_37_78#	VNB	4.85862e-18
C990	Q#7	VPWR#1	7.82376e-17
C991	a_494_366##13	VNB	4.54768e-17
C992	VPWR#4	VPWR#6	1.27278e-16
C993	RESET_B#17	VPWR#18	3.85903e-18
C994	VGND#16	VNB	5.22118e-18
C995	a_699_463##6	RESET_B#8	8.24704e-19
C996	VGND#17	VNB	3.88018e-18
C997	VPWR#9	D	7.82402e-18
C998	VPWR#12	VPWR#11	7.06672e-19
C999	CLK#3	a_313_74##15	1.04365e-17
C1000	a_37_78##5	VNB	3.55272e-17
C1001	VPWR#1	VNB	8.0445e-17
C1002	Q#7	VNB	2.36407e-18
C1003	VGND#9	D	8.01831e-18
C1004	VPWR#13	VNB	3.33035e-18
C1005	Q#5	VNB	4.09237e-18
C1006	VPWR#4	Q	3.43817e-18
C1007	VPWR#14	VNB	2.26374e-18
C1008	VGND#6	a_2010_409##7	5.31856e-18
C1009	a_2010_409##17	VNB	3.87464e-18
C1010	a_2010_409##8	a_2010_409##14	3.86872e-17
C1011	VGND#4	Q	3.15318e-18
C1012	VPWR#15	VNB	2.4289e-18
C1013	Q#3	a_1350_392##2	1.99194e-19
C1014	a_1678_395##4	VNB	5.73585e-18
C1015	VPWR#16	VNB	8.89248e-18
C1016	a_1350_392##12	a_313_74##11	3.48436e-17
C1017	VPWR#4	VPWR#5	5.75065e-17
C1018	a_1350_392##10	VNB	9.11244e-18
C1019	a_37_78##4	VGND#17	8.61002e-20
C1020	a_834_355##4	VNB	2.4028e-18
C1021	Q#1	a_2010_409##4	2.14366e-18
C1022	VPWR#17	VNB	1.04246e-18
C1023	VGND#16	RESET_B#3	8.48581e-19
C1024	VPWR#18	VNB	7.74521e-18
C1025	a_699_463##5	RESET_B#8	2.79104e-17
C1026	a_699_463##7	VNB	6.39671e-19
C1027	a_37_78##2	VNB	1.04091e-17
C1028	VPWR#9	a_834_355##4	3.74944e-18
C1029	a_494_366##12	VNB	2.39311e-18
C1030	a_313_74##16	VNB	4.00004e-18
C1031	VPWR#20	VNB	3.68044e-18
C1032	a_313_74##11	a_834_355##5	7.49767e-17
C1033	a_37_78##6	VNB	2.15803e-18
C1034	VGND#17	CLK#3	1.1383e-18
C1035	VPWR#12	VNB	5.66434e-17
C1036	RESET_B#17	VPWR	1.34629e-18
C1037	a_2010_409#	VNB	3.37553e-17
C1038	RESET_B#17	a_699_463##7	6.75187e-18
C1039	a_2010_409##10	VNB	3.0422e-17
C1040	VPWR#4	VPWR#3	7.23801e-17
C1041	a_2010_409##12	VNB	2.49545e-17
C1042	a_2010_409##16	a_2010_409##4	8.50186e-20
C1043	a_2010_409##13	VNB	3.02882e-17
C1044	a_1350_392#	VNB	5.26791e-17
C1045	a_1350_392##5	VNB	3.91221e-17
C1046	CLK	CLK#2	6.56826e-19
C1047	RESET_B#9	VNB	3.95385e-17
C1048	a_1678_395#	VNB	2.78517e-17
C1049	VPWR#13	VPWR#1	1.73469e-18
C1050	VGND#14	a_1678_395##7	1.53976e-17
C1051	a_313_74##9	VNB	6.72845e-17
C1052	a_494_366##5	VNB	4.35689e-17
C1053	a_699_463##3	VNB	3.21343e-17
C1054	CLK#1	a_313_74##3	8.85904e-19
C1055	RESET_B#7	VNB	4.00571e-17
C1056	a_834_355#	VNB	2.85041e-17
C1057	a_494_366#	VNB	4.39002e-17
C1058	a_37_78#	a_313_74##3	6.61403e-19
C1059	a_313_74##8	VNB	4.54108e-17
C1060	a_313_74##7	VNB	2.99918e-17
C1061	RESET_B#17	a_37_78##2	3.38785e-17
C1062	CLK#3	VNB	3.28289e-17
C1063	a_313_74##14	a_313_74##15	8.01341e-18
C1064	RESET_B#3	VNB	3.25984e-17
C1065	VPWR#4	VPWR#2	9.48909e-17
C1066	D#1	VNB	3.29374e-17
C1067	D	D#2	6.80446e-17
C1068	a_2010_409##9	VNB	3.90118e-17
C1069	Q#2	Q#4	2.36607e-18
C1070	a_2010_409##11	VNB	3.29835e-17
C1071	a_699_463##6	a_834_355##3	2.14472e-17
C1072	a_2010_409##14	VNB	3.31729e-17
C1073	a_2010_409##8	VNB	5.70582e-17
C1074	a_1350_392##6	VNB	3.6092e-17
C1075	a_1350_392##7	VNB	3.61788e-17
C1076	a_1350_392##6	a_2010_409##8	3.68542e-17
C1077	a_1350_392##8	VNB	4.2935e-17
C1078	RESET_B#11	VNB	2.62292e-17
C1079	a_1350_392##12	a_699_463##2	6.37603e-19
C1080	VGND#9	a_834_355##4	2.01811e-18
C1081	a_1678_395##3	VNB	4.05881e-17
C1082	VGND#7	a_1678_395##5	2.48615e-18
C1083	VPWR#15	a_1350_392##4	2.05361e-18
C1084	a_494_366##6	VNB	3.12012e-17
C1085	a_313_74##12	VNB	3.6437e-17
C1086	a_699_463#	VNB	4.62457e-17
C1087	a_37_78##6	VPWR#20	2.69337e-17
C1088	RESET_B#8	VNB	2.53551e-17
C1089	a_834_355##3	VNB	2.20942e-17
C1090	a_313_74##5	VNB	2.60144e-17
C1091	a_494_366##3	VNB	2.77046e-17
C1092	a_313_74##6	VNB	3.0518e-17
C1093	VPWR#9	VPWR#18	7.5332e-18
C1094	CLK#1	VNB	4.6553e-17
C1095	RESET_B#3	VGND#17	1.75696e-17
C1096	RESET_B#4	VNB	3.16317e-17
C1097	a_834_355##5	a_699_463##2	1.31735e-16
C1098	D#3	VNB	4.60093e-17
C1099	VPWR#6	VPWR#5	1.16713e-18
C1100	a_699_463##5	a_834_355##3	2.54413e-18
C1101	a_1350_392##10	a_313_74##9	2.49077e-19
C1102	RESET_B#18	VNB	9.83604e-18
C1103	VGND	a_494_366##4	1.37953e-18
C1104	VPWR#4	VNB	3.00689e-16
C1105	a_1678_395##4	a_1350_392##4	5.4618e-17
C1106	VGND	a_313_74##11	4.48084e-19
C1107	VGND#4	VNB	3.49615e-16
C1108	RESET_B#17	VNB	1.47586e-17
C1109	VPWR#13	Q#7	7.61942e-17
C1110	VPWR#9	VNB	2.97651e-16
C1111	VGND#9	VNB	3.70734e-16
C1112	a_37_78##5	CLK#3	1.2077e-18
C1113	a_2010_409##6	VNB	6.3986e-20
C1114	a_1350_392##4	VNB	6.82472e-17
C1115	RESET_B#10	VNB	5.20216e-17
C1116	a_1678_395##2	VNB	5.6646e-17
C1117	a_494_366##7	VNB	3.79283e-17
C1118	a_494_366##4	VNB	6.59557e-17
C1119	a_313_74##11	VNB	8.06584e-17
C1120	a_699_463##2	VNB	6.21603e-17
C1121	a_1350_392##4	VPWR#16	2.50684e-18
C1122	a_313_74#	VNB	1.0146e-16
C1123	RESET_B#5	VNB	4.73767e-17
C1124	a_834_355##2	VNB	4.53763e-17
C1125	a_494_366##2	VNB	5.28696e-17
C1126	a_313_74##4	VNB	1.26751e-18
C1127	CLK#2	VNB	4.23987e-17
C1128	a_1350_392##10	RESET_B#19	1.32391e-17
C1129	RESET_B#17	VPWR#8	5.39172e-18
C1130	VPWR#12	VPWR#20	2.00319e-18
C1131	RESET_B#2	CLK#1	9.61525e-18
C1132	D#2	VNB	1.4032e-16
C1133	a_2010_409##15	a_2010_409##7	1.19994e-19
C1134	VGND#17	a_313_74##14	3.61295e-17
C1135	a_699_463##7	VPWR#9	1.76631e-17
C1136	a_1350_392##7	a_1350_392##6	4.03378e-17
C1137	a_699_463##6	a_313_74##5	1.04839e-17
C1138	a_2010_409##8	a_2010_409##7	2.16896e-18
C1139	VGND#17	D#1	2.78791e-18
C1140	Q#2	Q#3	4.29258e-18
C1141	RESET_B#17	VPWR#7	1.05834e-17
C1142	RESET_B#10	a_1678_395##4	5.54188e-17
C1143	a_37_78##2	VPWR#9	3.74243e-17
C1144	CLK	VNB	3.05586e-18
C1145	a_834_355##5	a_313_74#	9.43215e-19
C1146	D	VNB	4.77225e-17
C1147	Q#5	Q#7	6.0367e-19
C1148	Q	VNB	3.18571e-17
C1149	a_37_78##5	a_37_78##4	9.95581e-19
C1150	a_313_74##14	a_313_74##4	1.94811e-18
C1151	VPWR	VNB	1.73872e-18
C1152	a_2010_409##7	a_2010_409##4	8.01285e-19
C1153	VGND	VNB	2.48361e-18
C1154	a_37_78##5	RESET_B#3	1.0873e-17
C1155	RESET_B	a_313_74##4	7.8666e-18
C1156	VGND#17	RESET_B	1.52626e-17
C1157	RESET_B	RESET_B#2	4.16904e-17
C1158	RESET_B	a_313_74##16	8.86794e-17
C1159	VGND#11	CLK#3	1.43057e-18
C1160	RESET_B	VPWR#11	1.46916e-18
C1161	VGND#11	D	1.36779e-18
C1162	RESET_B	a_313_74##6	1.85744e-18
C1163	RESET_B	a_494_366##2	8.10509e-18
C1164	RESET_B	VPWR#19	9.47245e-18
C1165	VGND#11	a_313_74##7	1.94729e-19
C1166	VGND#9	RESET_B	2.1797e-18
C1167	VGND#11	VGND#16	1.1041e-18
C1168	RESET_B	a_494_366##3	1.84594e-19
C1169	RESET_B	VGND#16	4.81682e-18
C1170	RESET_B	D	4.25796e-18
C1171	RESET_B	a_494_366##12	3.93587e-17
C1172	RESET_B	a_313_74##2	2.69406e-20
C1173	VGND#11	VNB	6.61992e-17
C1174	VPWR#9	RESET_B	6.18284e-17
C1175	VGND#11	VGND#10	1.00534e-18
C1176	RESET_B	D#2	2.23314e-18
C1177	RESET_B	a_313_74##14	4.00508e-17
C1178	RESET_B	VNB	2.0318e-17
C1179	RESET_B	a_494_366##13	3.1514e-18
C1180	RESET_B	CLK	1.42272e-17
C1181	RESET_B	a_37_78##2	3.40699e-17
C1182	RESET_B	a_313_74##3	4.6118e-18
C1183	VGND#11	D#2	4.45776e-19
C1184	VGND#11	a_313_74##14	1.02352e-17
C1185	RESET_B	CLK#3	7.92071e-20
C1186	a_37_78##5	RESET_B	3.48464e-17
C1187	RESET_B	a_37_78#	1.96994e-18
C1188	VGND#11	a_37_78##5	2.47466e-17
C1189	VGND#9	VGND#11	1.17945e-16
C1190	VGND#11	D#1	6.72532e-18
C1191	RESET_B	CLK#2	6.75382e-18
C1192	VGND#11	RESET_B#2	8.168e-19
C1193	a_37_78##4	RESET_B	1.11242e-16
C1194	RESET_B	VPWR#20	3.73809e-18
C1195	RESET_B	VPWR#10	4.77381e-18
C1196	RESET_B	a_313_74##8	1.95215e-19
C1197	VGND#11	RESET_B#3	9.123e-18
C1198	RESET_B	CLK#1	2.33655e-18
*
*
.ENDS sky130_fd_sc_hs__dfrtp_4
*
