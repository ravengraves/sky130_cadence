* Extracted by Quantus, converted by sky130cad/quantus.py
*
*
*
*                       LINUX           Wed Nov 18 08:40:58 2026
*
*
*
*  PROGRAM  advgen
*
*  Name           : advgen - Quantus - (64-bit)
*  Version        : 25.1.0-p047
*  Build Date     : Thu Dec 11 23:20:30 PST 2025
*
*  HSPICE LIBRARY
*
*  OPERATING_TEMPERATURE 150
*  QRC_TECH_DIR <path>/tech
*
*
*

*
.SUBCKT sky130_fd_sc_hs__ha_1 VPB VNB VGND VPWR SUM COUT A B
*
*
*  caps2d version: 10
*
*
*       TRANSISTOR CARDS
*
*
XM12 SUM#3 a_83_260##3 VGND#9 VNB sky130_fd_pr__nfet_01v8_lvt l=0.15 w=0.74 ad=0.2109 as=0.19515 pd=2.05 ps=2.05
XM11 a_83_260##7 a_239_294# a_305_130# VNB sky130_fd_pr__nfet_01v8_lvt l=0.15 w=0.64 ad=0.1726 as=0.1792 pd=1.85 ps=1.84
XM7 a_305_130# B#1 VGND#8 VNB sky130_fd_pr__nfet_01v8_lvt l=0.15 w=0.64 ad=0.1792 as=0.251075 pd=1.84 ps=2.13
XM3 VGND#8 A#4 a_305_130##2 VNB sky130_fd_pr__nfet_01v8_lvt l=0.15 w=0.64 ad=0.251075 as=0.1824 pd=2.13 ps=1.85
XM4 a_239_294##11 B#4 a_695_119# VNB sky130_fd_pr__nfet_01v8_lvt l=0.15 w=0.64 ad=0.1824 as=0.1344 pd=1.85 ps=1.7
XM6 a_695_119# A#2 VGND#7 VNB sky130_fd_pr__nfet_01v8_lvt l=0.15 w=0.64 ad=0.1344 as=0.249 pd=1.7 ps=2.18
XM13 VGND#7 a_239_294##4 COUT#3 VNB sky130_fd_pr__nfet_01v8_lvt l=0.15 w=0.74 ad=0.249 as=0.2109 pd=2.18 ps=2.05
XM0 SUM#1 a_83_260##4 VPWR#9 VPB sky130_fd_pr__pfet_01v8 l=0.15 w=1.12 ad=0.3304 as=0.7124 pd=2.83 ps=3.63
XM1 VPWR#9 a_239_294##3 a_83_260##5 VPB sky130_fd_pr__pfet_01v8 l=0.15 w=0.84 ad=0.7124 as=0.3406 pd=3.63 ps=2.71
XM5 a_83_260##5 B#3 a_386_392# VPB sky130_fd_pr__pfet_01v8 l=0.15 w=1 ad=0.3406 as=0.42 pd=2.71 ps=2.84
XM10 a_386_392# A#5 VPWR#8 VPB sky130_fd_pr__pfet_01v8 l=0.15 w=1 ad=0.42 as=0.6094 pd=2.84 ps=3.35
XM2 VPWR#8 B#6 a_239_294##12 VPB sky130_fd_pr__pfet_01v8 l=0.15 w=0.84 ad=0.6094 as=0.252 pd=3.35 ps=2.28
XM8 a_239_294##12 A#1 VPWR#7 VPB sky130_fd_pr__pfet_01v8 l=0.15 w=0.84 ad=0.252 as=0.4102 pd=2.28 ps=3.04
XM9 VPWR#7 a_239_294##6 COUT#1 VPB sky130_fd_pr__pfet_01v8 l=0.15 w=1.12 ad=0.4102 as=0.3304 pd=3.04 ps=2.83
*
*
*       RESISTOR AND CAP/DIODE CARDS
*
Rg1	a_83_260#	a_83_260##2	179.034119
Rg2	a_83_260##2	a_83_260##3	368.862610
Rg3	a_83_260##2	a_83_260##4	471.862823
Rg4	a_239_294#	a_239_294##2	319.414948
Rg5	a_239_294##2	a_239_294##3	354.298584
Rg6	B#1	B#2	319.414948
Rg7	B#2	B#3	400.207520
Rg8	B#4	B#5	385.786316
Rg9	B#5	B#6	416.341370
Rg10	A#1	A#2	899.431213
Rg11	A#2	A#3	991.808594
Rg12	A#3	A#4	269.641388
Rg13	A#4	A#5	768.211792
Rg14	a_239_294##4	a_239_294##5	323.225616
Rg15	a_239_294##5	a_239_294##6	442.817719
Rf1	SUM	SUM#2	0.196836
Rf2	SUM#2	SUM	14.369054
Rf3	SUM	SUM#4	7.282945
Rf4	SUM#4	SUM	7.282945
Rf5	SUM#1	SUM#2	5.000000
Rf6	SUM#3	SUM#4	7.500000
Rf7	a_83_260##5	a_83_260#	123.813683
Rf8	a_83_260#	a_83_260##7	51.157074
Rf9	A	A#3	165.547379
Rf10	a_305_130#	a_305_130##2	98.310997
Rf11	B#5	B	160.823318
Rf12	B	B#2	218.161896
Rf13	a_239_294##5	a_239_294##8	182.691833
Rf14	a_239_294##8	a_239_294##9	37.684841
Rf15	a_239_294##9	a_239_294##2	319.029907
Rf16	a_239_294##8	a_239_294##11	58.440212
Rf17	a_239_294##9	a_239_294##12	30.369299
Rf18	COUT#2	COUT	0.323707
Rf19	COUT	COUT#3	82.442558
Rf20	COUT#2	COUT	11.653459
Rf21	COUT#1	COUT#2	5.000000
Rf23	VPWR#2	VPWR#3	83.125359
Rf24	VPWR#3	VPWR#4	32.014545
Rf25	VPWR#4	VPWR#5	108.813644
Rf27	VPWR#2	VPWR#7	35.274624
Rf28	VPWR#3	VPWR#8	15.868668
Rf29	VPWR#5	VPWR#9	25.588856
Rf31	VGND#2	VGND#3	115.029991
Rf32	VGND#3	VGND#4	21.514380
Rf33	VGND#4	VGND#5	98.980721
Rf35	VGND#2	VGND#7	39.211349
Rf36	VGND#4	VGND#8	41.447075
Rf37	VGND#5	VGND#9	37.027283
Re1	VPWR#4	VPWR	0.982218
Re2	VGND	VGND#3	0.982254
*
*       CAPACITOR CARDS
*
*
C1	VPWR#7	COUT#1	4.99759e-17
C2	COUT#3	A#2	1.91192e-18
C3	VGND	VNB	6.56351e-17
C4	VPWR	VNB	5.90972e-17
C5	SUM	VNB	1.17331e-16
C6	COUT	VNB	1.96357e-17
C7	A	VNB	2.26828e-18
C8	VGND	SUM	1.94813e-17
C9	B	VNB	9.66264e-18
C10	VPWR	SUM	1.88121e-17
C11	a_239_294##4	VGND#7	2.07314e-17
C12	VGND	B	6.29053e-18
C13	VPWR	COUT	2.19117e-17
C14	a_83_260#	VNB	8.07395e-18
C15	a_239_294##2	VNB	3.46296e-17
C16	VPWR	B	3.23578e-18
C17	B#2	VNB	3.00286e-17
C18	A#3	VNB	9.36559e-17
C19	B#5	VNB	5.22901e-17
C20	a_239_294##5	VNB	4.24301e-17
C21	VGND#3	VNB	2.24858e-16
C22	a_239_294##8	a_239_294#	4.9566e-20
C23	VPWR#4	VNB	2.57704e-16
C24	VGND	a_83_260#	3.82794e-18
C25	a_83_260##4	VNB	4.05618e-17
C26	VGND	a_239_294##2	4.66485e-18
C27	a_239_294##3	VNB	3.44171e-17
C28	VGND	B#2	3.09154e-18
C29	B#3	VNB	3.52691e-17
C30	A#5	VNB	3.96267e-17
C31	VGND	A#3	2.701e-17
C32	B#6	VNB	3.02499e-17
C33	VGND	B#5	1.39455e-18
C34	A#1	VNB	4.97345e-17
C35	COUT#3	a_239_294##4	3.31193e-17
C36	a_239_294##6	VNB	4.02194e-17
C37	VPWR	a_83_260#	1.17599e-18
C38	VGND	a_239_294##5	3.70884e-18
C39	VGND	VGND#3	2.33953e-17
C40	a_83_260##3	VNB	4.05291e-17
C41	VPWR	a_239_294##2	1.21873e-17
C42	a_239_294#	VNB	3.70691e-17
C43	B#1	VNB	2.83846e-17
C44	VPWR	B#2	2.87562e-18
C45	A#4	VNB	2.72901e-17
C46	B#4	VNB	1.9996e-17
C47	a_83_260##2	VPWR#9	2.50798e-19
C48	A#2	VNB	6.51073e-17
C49	SUM	a_83_260#	7.67311e-17
C50	a_239_294##4	VNB	3.71814e-17
C51	VPWR	a_239_294##5	3.8032e-18
C52	SUM	a_239_294##2	9.21245e-20
C53	a_83_260##5	VNB	1.19668e-20
C54	VPWR#8	VNB	1.20955e-18
C55	VPWR	VPWR#4	4.62839e-17
C56	a_239_294##12	VNB	2.59091e-18
C57	VPWR#7	VNB	5.04087e-18
C58	SUM	A#3	3.28989e-19
C59	COUT#1	VNB	4.90322e-17
C60	VGND	a_83_260##3	4.4917e-18
C61	VPWR	a_83_260##4	5.66171e-18
C62	VGND#9	VNB	9.93525e-18
C63	a_83_260##7	VNB	8.96182e-18
C64	VGND	a_239_294#	8.45024e-18
C65	a_305_130#	VNB	9.58277e-18
C66	VPWR	a_239_294##3	6.83119e-18
C67	VGND#8	VNB	5.29148e-18
C68	VGND	B#1	3.44269e-18
C69	VPWR	B#3	1.72793e-18
C70	a_305_130##2	VNB	5.60677e-18
C71	a_239_294##11	VNB	4.99879e-18
C72	a_239_294##8	B#1	6.16394e-20
C73	VPWR	A#5	6.58296e-19
C74	VGND	B#4	5.62025e-18
C75	VGND#7	VNB	3.34741e-18
C76	VGND	A#2	6.53852e-18
C77	VPWR	B#6	5.39752e-19
C78	COUT#3	VNB	5.01822e-17
C79	VGND	a_239_294##4	7.59509e-18
C80	VPWR	A#1	4.94808e-18
C81	SUM	a_83_260##4	3.6434e-17
C82	VPWR	a_239_294##6	4.02615e-18
C83	SUM	a_239_294##3	2.63846e-18
C84	A	A#3	7.96617e-18
C85	a_239_294##8	VNB	7.62575e-19
C86	a_239_294##9	VNB	4.41578e-18
C87	SUM	B#3	1.3967e-19
C88	B#2	B	2.77802e-19
C89	VGND	COUT#1	8.79856e-19
C90	B	A#3	2.5651e-18
C91	VGND	a_83_260##7	8.54881e-18
C92	VGND	a_305_130#	1.01769e-17
C93	VGND#4	VNB	3.18808e-17
C94	B	B#5	2.27204e-17
C95	VGND	a_305_130##2	8.52175e-18
C96	VGND	a_239_294##11	1.31917e-17
C97	SUM	a_83_260##3	2.79125e-17
C98	VPWR	a_83_260##5	1.98121e-17
C99	SUM	a_239_294#	2.89855e-18
C100	VGND#3	B	9.95551e-19
C101	VGND	COUT#3	1.85012e-17
C102	SUM	B#1	2.26122e-19
C103	a_239_294##8	A#4	1.99895e-19
C104	VPWR	VPWR#8	4.51136e-17
C105	VPWR	a_239_294##12	1.58761e-17
C106	VPWR	VPWR#7	1.93184e-17
C107	COUT	a_239_294##6	1.27531e-17
C108	VGND	a_239_294##8	3.71608e-18
C109	SUM	SUM#1	5.93035e-18
C110	SUM	a_83_260##5	1.84277e-17
C111	a_239_294##2	a_386_392#	8.16184e-18
C112	B#2	a_386_392#	1.42267e-18
C113	A	a_83_260##3	6.05132e-20
C114	VGND	VGND#4	4.61983e-17
C115	B	A#1	3.45153e-19
C116	SUM	SUM#3	3.85214e-18
C117	a_239_294##8	B#4	7.44851e-18
C118	A	B#1	4.08774e-19
C119	SUM	VGND#9	3.86313e-17
C120	a_83_260#	a_239_294##2	4.01989e-17
C121	A	A#4	1.16127e-18
C122	SUM	a_83_260##7	8.12355e-18
C123	SUM	a_305_130#	1.53702e-18
C124	A	B#4	1.9601e-18
C125	a_83_260#	B#2	1.23876e-19
C126	VPWR	a_239_294##8	5.60216e-19
C127	A	A#2	2.88935e-19
C128	VPWR	a_239_294##9	4.3488e-18
C129	VPWR#7	COUT	2.90508e-17
C130	a_239_294##2	B#2	1.1457e-16
C131	COUT	COUT#1	1.45959e-18
C132	B	A#4	1.04444e-18
C133	a_83_260#	a_83_260##2	2.85304e-17
C134	a_239_294##8	A#2	1.85881e-17
C135	a_239_294##2	B#5	7.11019e-20
C136	B#2	A#3	5.1831e-20
C137	a_83_260##2	VNB	4.46088e-17
C138	B#2	B#5	4.92638e-20
C139	VGND#9	a_305_130#	7.99584e-18
C140	B#3	a_386_392#	2.98515e-17
C141	A#3	B#5	1.45212e-18
C142	A#5	a_386_392#	2.98515e-17
C143	a_239_294##2	VPWR#4	2.73382e-18
C144	VGND#8	A	2.07874e-17
C145	a_83_260#	a_83_260##4	6.5038e-18
C146	VGND#4	a_83_260##3	6.29503e-19
C147	a_239_294##8	a_239_294##4	2.58694e-19
C148	A	a_305_130##2	2.83928e-17
C149	A	a_239_294##11	9.04856e-18
C150	VPWR#4	B#2	1.80874e-19
C151	a_83_260#	a_239_294##3	2.15998e-18
C152	VGND#3	A#3	5.39894e-17
C153	VGND#9	VGND#8	3.90756e-18
C154	a_83_260##7	a_305_130#	3.41385e-17
C155	a_83_260##4	a_239_294##2	4.29764e-18
C156	A	VGND#7	2.1531e-18
C157	a_83_260#	B#3	1.85837e-19
C158	VGND#3	B#5	9.27723e-19
C159	a_239_294##2	a_239_294##3	1.18002e-17
C160	a_83_260#	A#5	9.90017e-20
C161	a_239_294##2	B#3	2.81226e-17
C162	a_305_130##2	B	2.25063e-17
C163	VPWR#4	B#5	1.27847e-19
C164	a_239_294##11	B	2.36194e-17
C165	a_239_294##2	A#5	1.15163e-17
C166	B#4	a_695_119#	1.25998e-17
C167	VGND#4	a_239_294#	3.27468e-18
C168	a_83_260##2	a_239_294##2	1.58093e-17
C169	A#2	a_695_119#	1.032e-17
C170	B#2	A#5	2.74792e-17
C171	a_239_294##2	A#1	2.3486e-19
C172	VGND	a_83_260##2	2.10497e-19
C173	a_83_260#	a_83_260##3	2.31563e-18
C174	a_305_130#	VGND#8	4.10948e-17
C175	a_83_260#	a_239_294#	2.54113e-19
C176	COUT#3	COUT#1	3.89695e-18
C177	a_83_260#	B#1	9.9101e-20
C178	B	a_239_294##8	3.24942e-17
C179	A#5	B#5	7.81337e-18
C180	VGND#4	B#1	6.96949e-19
C181	B	a_239_294##9	6.70347e-17
C182	a_83_260#	A#4	1.51437e-19
C183	a_305_130#	a_305_130##2	2.31067e-18
C184	B#5	A#1	1.23177e-17
C185	VPWR#4	B#3	8.57727e-18
C186	a_83_260##3	A#3	5.50217e-19
C187	A#1	a_239_294##5	5.75178e-18
C188	a_305_130##2	VGND#8	3.596e-17
C189	VPWR#4	A#5	4.06411e-18
C190	B#2	A#4	2.53871e-17
C191	a_239_294##9	a_83_260##5	6.52091e-21
C192	a_83_260#	VPWR#9	5.44822e-18
C193	a_83_260##4	a_239_294##3	1.06101e-17
C194	B#1	A#3	5.70464e-18
C195	a_83_260#	a_83_260##5	6.9038e-19
C196	VPWR#4	B#6	9.69652e-19
C197	a_83_260##4	B#3	5.42457e-19
C198	VGND#8	a_239_294##11	4.20216e-18
C199	a_239_294##2	VPWR#9	1.30764e-18
C200	a_83_260#	VPWR#8	7.48851e-21
C201	A#3	B#4	1.1381e-17
C202	a_239_294##3	B#3	3.29257e-17
C203	a_239_294##2	a_83_260##5	5.84038e-17
C204	A#4	B#5	6.29297e-18
C205	A#3	A#2	2.01899e-18
C206	a_305_130##2	a_239_294##11	3.52193e-17
C207	B#3	A#5	2.83462e-17
C208	B#5	A#2	2.17895e-17
C209	VGND#3	B#1	3.11814e-20
C210	a_83_260#	VGND#9	1.74382e-17
C211	a_239_294##9	VPWR#8	7.27412e-17
C212	A#2	a_239_294##5	2.57e-17
C213	A#5	B#6	9.92595e-18
C214	a_239_294##8	a_695_119#	6.48375e-19
C215	VPWR#8	A#3	8.40406e-19
C216	a_239_294##2	a_83_260##7	3.3105e-17
C217	SUM	a_83_260##2	1.22947e-17
C218	a_239_294##9	a_239_294##12	1.68187e-18
C219	a_305_130#	a_239_294##2	8.36842e-18
C220	a_239_294##8	VPWR#7	2.00747e-18
C221	B#6	A#1	3.99891e-17
C222	VPWR#8	B#5	9.88599e-19
C223	a_239_294##11	VGND#7	1.65849e-17
C224	a_305_130#	B#2	2.52748e-17
C225	a_239_294##9	VPWR#7	1.69355e-17
C226	VGND#9	A#3	1.06824e-18
C227	B#2	VGND#8	2.04609e-18
C228	A#1	a_239_294##6	3.61831e-17
C229	COUT#1	B#5	9.10407e-20
C230	a_239_294##8	COUT#1	1.2298e-18
C231	a_305_130##2	B#2	3.48552e-17
C232	a_239_294##5	VPWR#7	1.82483e-17
C233	VGND#8	A#3	1.45018e-17
C234	a_239_294##5	COUT#1	3.10788e-17
C235	a_239_294##9	COUT#1	6.14392e-18
C236	a_83_260##4	SUM#1	1.20601e-17
C237	a_305_130##2	A#3	5.3211e-18
C238	a_239_294##11	A#3	9.91977e-18
C239	a_83_260##4	VPWR#9	1.54292e-17
C240	a_239_294##12	VPWR#4	8.00481e-18
C241	a_83_260##5	a_83_260##4	6.96358e-18
C242	A#3	VGND#7	3.86038e-18
C243	a_239_294##3	VPWR#9	1.84252e-17
C244	a_239_294##11	B#5	6.61684e-18
C245	VGND#7	COUT#3	6.22988e-17
C246	a_239_294##8	a_239_294##2	5.21265e-20
C247	a_83_260##5	a_239_294##3	5.06599e-17
C248	VPWR#8	a_83_260##4	8.13929e-19
C249	a_239_294##9	a_239_294##2	4.06496e-20
C250	a_83_260##2	a_239_294#	3.58282e-18
C251	a_83_260##3	a_239_294#	4.64339e-18
C252	B#3	a_83_260##5	2.51126e-17
C253	A#2	A#1	1.19125e-19
C254	VPWR#8	a_239_294##3	1.94937e-18
C255	a_239_294##8	B#2	7.70492e-20
C256	VGND#3	a_305_130##2	9.25369e-19
C257	a_239_294##5	VGND#7	4.04951e-17
C258	B#2	a_239_294##9	1.36559e-17
C259	a_83_260##5	A#5	3.85303e-18
C260	VGND#3	a_239_294##11	2.8219e-18
C261	VPWR#8	B#3	5.54357e-18
C262	COUT#3	a_239_294##5	3.29725e-17
C263	a_239_294#	B#1	3.67198e-17
C264	VPWR#8	A#5	6.02741e-17
C265	a_239_294##9	A#3	5.05155e-19
C266	B#1	A#4	1.89605e-17
C267	VPWR#8	B#6	5.98569e-17
C268	a_239_294##8	B#5	1.13254e-17
C269	VGND#4	a_239_294##2	7.46852e-19
C270	B#6	a_239_294##12	1.2033e-17
C271	a_239_294##9	B#5	5.49019e-18
C272	VPWR#8	A#1	3.02194e-18
C273	a_305_130##2	a_239_294##8	1.99156e-18
C274	A#4	B#4	3.41887e-18
C275	VPWR#7	B#6	1.30581e-18
C276	a_239_294##12	A#1	4.44078e-17
C277	a_239_294##8	a_239_294##5	8.33934e-20
C278	VPWR#8	a_239_294##6	7.57858e-19
C279	A#1	VPWR#7	2.90225e-17
C280	a_83_260##2	VGND#9	3.27226e-18
C281	A#2	B#4	6.33469e-17
C282	COUT#1	A#1	2.92567e-18
C283	a_239_294##6	VPWR#7	3.04266e-17
C284	VGND#4	A#3	1.65958e-17
C285	a_239_294##11	a_239_294##9	3.71141e-18
C286	COUT#1	a_239_294##6	3.68979e-17
C287	A#2	a_239_294##4	3.08495e-17
C288	a_239_294##9	VPWR#4	4.667e-19
C289	a_239_294##8	VGND#7	2.18568e-17
C290	a_83_260##3	SUM#3	7.72986e-18
C291	a_239_294##8	COUT#3	5.68683e-19
C292	a_83_260##3	VGND#9	2.50939e-17
C293	a_83_260##7	a_83_260##3	3.46867e-18
C294	VGND#9	VGND#4	1.72029e-18
C295	VGND#9	a_239_294#	4.9113e-18
C296	VGND#3	VGND#4	3.60799e-17
C297	a_305_130#	a_83_260##3	1.99243e-18
C298	a_83_260##7	a_239_294#	3.78362e-17
C299	a_239_294##9	a_239_294##3	3.13487e-19
C300	VGND#8	a_83_260##3	1.13081e-18
C301	VGND#9	B#1	8.03868e-19
C302	a_83_260##5	VPWR#9	9.55381e-18
C303	a_239_294#	a_305_130#	1.99957e-17
C304	a_83_260##7	B#1	1.03276e-18
C305	VGND#8	a_239_294#	1.89137e-18
C306	a_239_294##9	B#3	3.87842e-19
C307	a_305_130#	B#1	2.30236e-17
C308	a_305_130##2	a_239_294#	1.95794e-19
C309	VGND#4	a_305_130#	6.12027e-18
C310	VGND#8	B#1	3.44425e-17
C311	a_305_130#	A#4	3.98627e-19
C312	a_239_294##9	A#5	1.16077e-17
C313	a_83_260##5	VPWR#8	1.48701e-17
C314	a_305_130##2	B#1	8.06737e-19
C315	A#4	VGND#8	1.62675e-17
C316	a_239_294##11	B#1	3.17591e-19
C317	a_305_130##2	A#4	4.4689e-17
C318	a_239_294##9	B#6	1.91863e-17
C319	VGND#8	B#4	5.36282e-19
C320	a_239_294##11	A#4	2.74127e-18
C321	a_239_294##8	A#1	7.78092e-18
C322	a_305_130##2	B#4	1.3435e-18
C323	a_239_294##9	A#1	1.4018e-17
C324	VPWR#8	a_239_294##12	6.05433e-17
C325	a_239_294##11	B#4	5.22723e-17
C326	a_239_294##8	a_239_294##6	6.06498e-19
C327	VPWR#8	VPWR#7	2.0186e-18
C328	a_239_294##9	a_239_294##6	1.09504e-18
C329	a_239_294##11	A#2	2.93311e-18
C330	a_239_294##12	VPWR#7	6.04417e-17
C331	VGND#7	B#4	5.01178e-18
C332	a_83_260##7	a_83_260##5	4.3454e-18
C333	VGND#7	A#2	3.86897e-17
C334	VGND#5	a_239_294##2	1.86635e-19
C335	VPWR#2	VNB	4.9234e-17
C336	VGND#2	A#1	3.17606e-19
C337	a_83_260#	VPWR#5	2.64219e-19
C338	VGND#5	a_239_294#	1.57224e-18
C339	VGND#2	B#4	2.87503e-18
C340	a_239_294##8	VPWR#2	9.01123e-20
C341	VGND#2	a_239_294##5	4.21973e-19
C342	a_239_294##5	VPWR#2	2.70337e-19
C343	VPWR#5	VNB	7.18844e-17
C344	VPWR#2	A#1	2.60508e-18
C345	VPWR#5	B#3	3.28105e-18
C346	VGND#2	a_239_294##8	1.79076e-18
C347	A#3	VGND#2	8.50293e-18
C348	SUM	VPWR#5	5.89381e-17
C349	a_239_294##12	VPWR#2	7.22838e-18
C350	VGND#2	VNB	5.94374e-17
C351	VGND#5	VGND#4	6.95731e-19
C352	VGND#3	VGND#5	6.02582e-17
C353	COUT	VPWR#2	2.45874e-17
C354	VGND#4	VGND#2	1.87926e-19
C355	a_239_294##2	VPWR#5	5.06438e-19
C356	VGND#5	VNB	5.70287e-17
C357	VGND#2	a_239_294##11	4.45369e-18
C358	VPWR#5	a_83_260##4	2.15702e-17
C359	VPWR#5	VPWR#9	1.33243e-17
C360	VGND#2	A#2	1.72495e-17
C361	VPWR#2	a_239_294##6	4.62136e-18
C362	VGND#3	VGND#2	7.03073e-17
C363	VGND#5	a_83_260#	6.65037e-19
C364	VPWR#5	A#5	7.217e-19
C365	VGND#5	a_83_260##3	8.18394e-18
C366	VGND#5	a_83_260##7	5.00831e-18
C367	VPWR#5	VPWR#8	3.78057e-18
C368	VPWR#5	a_83_260##2	7.48555e-19
C369	VPWR#4	VPWR#5	7.54223e-17
C370	VGND#2	B#5	1.15573e-19
C371	VPWR	VPWR#2	3.62067e-17
C372	VGND	VGND#2	6.97106e-17
C373	VGND#2	COUT#3	1.60516e-17
C374	VPWR#5	a_239_294##3	1.45791e-17
C375	VPWR#4	VPWR#2	5.68621e-17
C376	VGND#5	SUM	2.08582e-17
C377	a_83_260##5	VPWR#5	8.01846e-17
C378	VPWR	VPWR#5	7.80084e-17
C379	VGND	VGND#5	5.56441e-17
C380	VGND#2	a_239_294##4	3.88631e-18
C381	VGND#5	A#3	2.27998e-19
*
*
.ENDS sky130_fd_sc_hs__ha_1
*
