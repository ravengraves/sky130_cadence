* Extracted by Quantus, converted by sky130cad/quantus.py
*
*
*
*                       LINUX           Wed Nov 18 08:49:24 2026
*
*
*
*  PROGRAM  advgen
*
*  Name           : advgen - Quantus - (64-bit)
*  Version        : 25.1.0-p047
*  Build Date     : Thu Dec 11 23:20:30 PST 2025
*
*  HSPICE LIBRARY
*
*  OPERATING_TEMPERATURE 150
*  QRC_TECH_DIR <path>/tech
*
*
*

*
.SUBCKT sky130_fd_sc_hs__nor2b_2 VPB VNB VGND VPWR Y A B_N
*
*
*  caps2d version: 10
*
*
*       TRANSISTOR CARDS
*
*
XM1 a_27_392##10 B_N#1 VGND#7 VNB sky130_fd_pr__nfet_01v8_lvt l=0.15 w=0.64 ad=0.1824 as=0.3267 pd=1.85 ps=2.39
XM7 VGND#7 a_27_392##5 Y#3 VNB sky130_fd_pr__nfet_01v8_lvt l=0.15 w=0.74 ad=0.3267 as=0.2442 pd=2.39 ps=2.14
XM5 Y#3 a_27_392##4 VGND#6 VNB sky130_fd_pr__nfet_01v8_lvt l=0.15 w=0.74 ad=0.2442 as=0.222 pd=2.14 ps=2.08
XM3 VGND#6 A#4 Y#4 VNB sky130_fd_pr__nfet_01v8_lvt l=0.15 w=0.74 ad=0.222 as=0.2442 pd=2.08 ps=2.14
XM6 Y#4 A#5 VGND#1 VNB sky130_fd_pr__nfet_01v8_lvt l=0.15 w=0.74 ad=0.2442 as=0.2257 pd=2.14 ps=2.09
XM4 a_27_392##9 B_N#3 VPWR#7 VPB sky130_fd_pr__pfet_01v8 l=0.15 w=1 ad=0.29 as=0.295 pd=2.58 ps=2.59
XM0 a_228_368##4 a_27_392##6 Y#5 VPB sky130_fd_pr__pfet_01v8 l=0.15 w=1.12 ad=0.3304 as=0.336 pd=2.83 ps=2.84
XM8 Y#5 a_27_392# a_228_368##2 VPB sky130_fd_pr__pfet_01v8 l=0.15 w=1.12 ad=0.336 as=0.336 pd=2.84 ps=2.84
XM9 VPWR#6 A#6 a_228_368##2 VPB sky130_fd_pr__pfet_01v8 l=0.15 w=1.12 ad=0.336 as=0.336 pd=2.84 ps=2.84
XM2 a_228_368# A#1 VPWR#6 VPB sky130_fd_pr__pfet_01v8 l=0.15 w=1.12 ad=0.3248 as=0.336 pd=2.82 ps=2.84
*
*
*       RESISTOR AND CAP/DIODE CARDS
*
Rg1	B_N#1	B_N#2	449.563477
Rg2	B_N#2	B_N#3	427.418121
Rg3	a_27_392#	a_27_392##2	492.777435
Rg4	a_27_392##2	a_27_392##3	49.164734
Rg5	a_27_392##2	a_27_392##4	340.513855
Rg6	a_27_392##3	a_27_392##5	313.525024
Rg7	a_27_392##3	a_27_392##6	456.678406
Rg8	A#1	A#2	503.938385
Rg9	A#2	A#3	56.584099
Rg10	A#3	A#4	377.027313
Rg11	A#2	A#5	451.838898
Rg12	A#3	A#6	429.126801
Rf1	B_N#2	B_N	161.413818
Rf2	a_27_392##3	a_27_392##8	204.835648
Rf3	a_27_392##8	a_27_392##9	71.759552
Rf4	a_27_392##8	a_27_392##10	16.367132
Rf5	A#7	A	1.409262
Rf6	A#3	A#9	161.642059
Rf7	A#7	A#9	9.015281
Rf8	A#10	A	1.409262
Rf9	A#9	A#10	5.653651
Rf10	Y	Y#1	41.451450
Rf11	Y#1	Y#2	46.936893
Rf12	Y#2	Y#3	28.911177
Rf13	Y#1	Y#4	18.909372
Rf14	Y#2	Y#5	93.692993
Rf15	a_228_368#	a_228_368##3	95.445419
Rf16	a_228_368##3	a_228_368##4	102.691246
Rf17	a_228_368##2	a_228_368##3	5.000000
Rf18	VGND#1	VGND#2	102.503380
Rf19	VGND#2	VGND#3	34.309200
Rf20	VGND#3	VGND#4	38.692230
Rf22	VGND#2	VGND#6	36.279022
Rf23	VGND#4	VGND#7	31.928406
Rf25	VPWR#2	VPWR#3	72.718063
Rf26	VPWR#3	VPWR#4	69.738693
Rf28	VPWR#2	VPWR#6	38.736572
Rf29	VPWR#4	VPWR#7	35.333496
Re1	VPWR#3	VPWR	1.403190
Re2	VGND	VGND#3	1.403242
*
*       CAPACITOR CARDS
*
*
C1	VGND	VNB	5.8567e-17
C2	VPWR	VNB	7.15453e-17
C3	Y	VNB	2.60336e-17
C4	A	VNB	1.78147e-17
C5	B_N	VNB	3.66768e-18
C6	VGND	Y	2.9484e-18
C7	VGND	A	3.46382e-18
C8	VPWR	Y	2.33228e-18
C9	VGND	B_N	1.8333e-18
C10	B_N#2	VNB	5.51686e-17
C11	a_27_392##3	VNB	5.45412e-17
C12	VPWR	A	3.50085e-18
C13	VGND#3	a_27_392##2	4.03262e-20
C14	A#3	VNB	3.2664e-17
C15	VGND#3	VNB	1.66959e-16
C16	VPWR	B_N	1.45758e-18
C17	VPWR#3	VNB	1.81604e-16
C18	A	Y	6.39267e-18
C19	B_N#3	VNB	4.00335e-17
C20	a_27_392##6	VNB	4.15377e-17
C21	VGND	a_27_392##3	5.52965e-18
C22	a_27_392#	VNB	3.56647e-17
C23	VGND	A#3	1.17055e-18
C24	A#6	VNB	2.9692e-17
C25	VGND	VGND#3	9.97211e-18
C26	A#1	VNB	3.86536e-17
C27	VPWR	B_N#2	8.02714e-19
C28	B_N#1	VNB	4.42276e-17
C29	a_27_392##5	VNB	2.90522e-17
C30	VPWR	a_27_392##3	2.03485e-18
C31	a_27_392##4	VNB	2.49557e-17
C32	A#4	VNB	2.51254e-17
C33	VPWR	A#3	1.08151e-18
C34	A#5	VNB	2.95869e-17
C35	a_27_392##9	VNB	5.93682e-17
C36	VPWR#7	VNB	1.37415e-17
C37	a_228_368##4	VNB	1.68515e-17
C38	VPWR	VPWR#3	1.70991e-17
C39	Y#5	VNB	2.49443e-18
C40	a_228_368##2	VNB	2.31306e-18
C41	Y	A#3	3.05291e-19
C42	VPWR#6	VNB	2.56509e-18
C43	VPWR	B_N#3	5.24862e-18
C44	a_228_368#	VNB	5.56963e-17
C45	VGND	B_N#1	9.60164e-18
C46	VGND#7	VNB	6.50205e-18
C47	VGND	a_27_392##5	1.65752e-18
C48	VPWR	a_27_392##6	1.64149e-18
C49	A	a_27_392##3	2.49787e-19
C50	Y#3	VNB	2.83653e-18
C51	VGND	a_27_392##4	5.55247e-19
C52	VPWR	a_27_392#	1.35247e-18
C53	VGND#6	VNB	5.1362e-20
C54	B_N	B_N#2	1.88153e-17
C55	A	A#3	1.05507e-17
C56	VGND	A#4	6.26104e-19
C57	Y#4	VNB	5.07048e-18
C58	VGND#2	Y#4	1.44494e-17
C59	VPWR	A#6	1.19532e-18
C60	VGND#1	VNB	5.35208e-17
C61	VGND	A#5	4.2028e-19
C62	VPWR	A#1	1.91663e-18
C63	B_N	a_27_392##3	9.70459e-18
C64	a_27_392##8	VNB	7.30016e-17
C65	VGND	a_228_368##4	2.23349e-18
C66	Y#1	VNB	5.42575e-19
C67	Y#2	VNB	1.83794e-18
C68	VGND	a_228_368#	1.81478e-18
C69	VGND#2	VNB	2.97952e-17
C70	VGND	VGND#7	2.1363e-17
C71	A	a_27_392##6	5.15486e-19
C72	VGND	Y#3	1.76917e-17
C73	VPWR	a_27_392##9	1.75129e-17
C74	A	a_27_392#	9.08711e-19
C75	VPWR	VPWR#7	2.13776e-17
C76	VGND	Y#4	1.38229e-17
C77	VGND	VGND#1	4.03155e-17
C78	VPWR	a_228_368##4	2.73989e-17
C79	VPWR	Y#5	6.72908e-18
C80	B_N	a_27_392##6	8.13603e-19
C81	A	A#1	2.26379e-18
C82	VPWR	a_228_368##2	1.95116e-17
C83	VGND	a_27_392##8	2.93419e-17
C84	VGND#2	VGND#1	8.27728e-19
C85	B_N#2	a_27_392##3	2.57837e-17
C86	B_N	a_27_392#	2.26724e-19
C87	VPWR	a_228_368#	1.51876e-17
C88	VGND	Y#1	1.95703e-18
C89	VGND	Y#2	2.46077e-18
C90	VGND	VGND#2	4.20407e-17
C91	a_27_392##8	Y#2	1.35888e-18
C92	VPWR#3	a_27_392##2	2.57509e-20
C93	VGND#3	a_27_392##3	7.19553e-19
C94	Y	a_228_368#	1.15982e-17
C95	VPWR#3	a_27_392##3	4.74574e-20
C96	Y#5	A	7.698e-18
C97	A	a_228_368##2	3.87654e-17
C98	a_27_392##9	B_N	1.8821e-17
C99	B_N#2	a_27_392##6	3.62131e-18
C100	Y	VGND#1	3.07956e-17
C101	B_N	VPWR#7	3.29094e-17
C102	A	a_228_368#	1.1869e-17
C103	B_N	Y#5	2.78595e-18
C104	Y#2	Y	1.22914e-18
C105	a_27_392#	A#3	1.53082e-18
C106	A#3	A#6	2.02746e-18
C107	VPWR#3	a_27_392##6	4.47739e-18
C108	B_N#1	a_27_392##3	7.8196e-18
C109	a_27_392##2	VNB	2.47538e-17
C110	A#2	VNB	3.60632e-17
C111	VPWR#3	a_27_392#	4.45369e-18
C112	a_27_392##3	a_27_392##5	6.19786e-18
C113	Y#1	A	3.30166e-17
C114	Y#2	A	3.46895e-17
C115	a_27_392##3	a_27_392##4	2.11619e-19
C116	a_27_392##8	B_N	5.01681e-17
C117	B_N#3	a_27_392##6	5.57752e-18
C118	a_27_392##9	B_N#2	6.65816e-18
C119	VPWR#7	B_N#2	1.18575e-17
C120	a_228_368##4	B_N#2	2.30705e-19
C121	a_228_368##4	a_27_392##2	7.09926e-20
C122	VGND#3	a_27_392##5	2.63375e-18
C123	Y#5	B_N#2	5.43191e-19
C124	a_27_392##6	a_27_392#	4.84441e-17
C125	B_N	Y#2	2.83109e-18
C126	VGND#3	a_27_392##4	3.0836e-18
C127	a_27_392##3	a_228_368##4	2.33665e-17
C128	Y#5	a_27_392##3	8.11616e-19
C129	a_27_392#	A#6	4.65412e-17
C130	A#3	a_228_368##2	1.94454e-17
C131	A#6	A#1	4.6748e-17
C132	VGND	a_27_392##2	5.63477e-19
C133	VGND	A#2	1.61907e-20
C134	A#3	VPWR#6	1.16568e-18
C135	a_27_392##3	VGND#7	4.59214e-17
C136	a_27_392##3	Y#3	4.52721e-19
C137	a_228_368##4	VPWR#3	4.56637e-17
C138	a_27_392##8	B_N#2	2.3092e-17
C139	Y#5	a_27_392##2	5.65656e-19
C140	a_27_392##9	B_N#3	2.79891e-17
C141	a_228_368##2	VPWR#3	1.84345e-17
C142	VPWR#7	B_N#3	6.48208e-17
C143	a_27_392##9	a_27_392##6	2.48322e-19
C144	a_228_368##4	B_N#3	3.4703e-18
C145	a_27_392##8	a_27_392##3	2.99089e-18
C146	VGND#3	Y#3	1.76177e-17
C147	VPWR#7	a_27_392##6	2.77484e-18
C148	Y#2	B_N#2	5.35801e-19
C149	a_228_368##4	a_27_392##6	9.23001e-17
C150	VGND#2	Y#1	4.13057e-19
C151	VPWR#7	a_27_392#	1.8466e-19
C152	B_N#1	a_27_392##5	1.881e-17
C153	a_27_392##6	Y#5	3.01809e-17
C154	VGND#3	VGND#1	2.51469e-17
C155	a_228_368##4	a_27_392#	1.24573e-17
C156	a_228_368##2	a_27_392##6	1.92717e-18
C157	VPWR#7	A#6	2.49606e-20
C158	Y#2	a_27_392##3	6.32813e-17
C159	a_27_392#	Y#5	2.34637e-17
C160	VGND#2	Y#2	2.95327e-19
C161	a_27_392##5	a_27_392##4	2.93735e-17
C162	a_228_368##2	a_27_392#	6.05186e-17
C163	VPWR#7	A#1	3.67736e-20
C164	a_228_368#	a_27_392##6	1.10348e-19
C165	Y#5	A#6	1.98879e-19
C166	Y#1	A#3	2.41214e-17
C167	Y#2	A#3	3.56497e-19
C168	a_228_368##2	A#6	7.05922e-17
C169	a_228_368#	a_27_392#	1.06865e-19
C170	a_228_368##2	A#2	7.51279e-20
C171	a_27_392##4	A#4	3.37157e-17
C172	Y#5	A#1	9.58912e-20
C173	A#6	VPWR#6	2.19775e-17
C174	a_228_368##2	A#1	2.66745e-18
C175	VGND#2	A#3	8.84118e-20
C176	a_228_368#	A#6	1.22456e-18
C177	VGND#3	Y#2	2.52108e-19
C178	VPWR#6	A#1	4.4741e-17
C179	A#4	A#5	3.19583e-17
C180	Y	a_27_392##2	2.96963e-19
C181	Y	A#2	7.25028e-18
C182	a_228_368#	A#1	4.18548e-17
C183	VGND#3	VGND#2	3.84005e-17
C184	A#2	VPWR#6	1.13626e-19
C185	B_N#1	a_27_392##10	6.36846e-18
C186	a_27_392##9	VPWR#7	7.62104e-17
C187	B_N#1	VGND#7	2.79993e-17
C188	a_27_392##9	a_228_368##4	5.45637e-18
C189	A	a_27_392##2	1.15387e-17
C190	Y#3	B_N#1	1.22228e-18
C191	A	A#2	8.84404e-18
C192	a_27_392##5	VGND#7	2.53542e-17
C193	a_27_392##9	Y#5	2.17415e-19
C194	VPWR#7	a_228_368##4	8.18369e-17
C195	VGND#6	B_N#1	2.32954e-19
C196	Y#3	a_27_392##5	3.09492e-17
C197	VGND#7	a_27_392##4	1.17717e-18
C198	VGND#6	a_27_392##5	1.07152e-18
C199	a_27_392##4	Y#3	1.42756e-17
C200	a_228_368##4	Y#5	8.91857e-17
C201	a_228_368#	A#2	7.51279e-20
C202	Y#4	a_27_392##5	1.84142e-19
C203	VGND#6	a_27_392##4	2.82195e-17
C204	a_228_368##4	a_228_368##2	3.01982e-18
C205	Y#3	A#4	5.61491e-19
C206	Y#1	A#2	2.64873e-19
C207	Y#4	a_27_392##4	7.22751e-19
C208	B_N	a_27_392##2	1.05407e-19
C209	VGND#6	A#4	3.29639e-17
C210	a_27_392##8	B_N#1	3.87652e-17
C211	Y#5	a_228_368##2	6.00285e-17
C212	Y#3	A#5	2.34796e-19
C213	A#4	Y#4	2.00478e-17
C214	VGND#6	A#5	1.43819e-18
C215	a_27_392##8	a_27_392##5	1.47527e-18
C216	VGND#1	A#4	2.05301e-18
C217	A#5	Y#4	1.69826e-17
C218	Y#5	a_228_368#	1.77792e-18
C219	a_228_368##2	VPWR#6	7.51453e-17
C220	Y#2	a_27_392##2	1.41157e-17
C221	a_27_392##8	a_27_392##4	1.24392e-19
C222	VGND#1	A#5	3.01207e-17
C223	a_228_368##2	a_228_368#	2.59773e-18
C224	Y#2	A#2	7.50398e-20
C225	a_228_368#	VPWR#6	6.16005e-17
C226	Y#2	B_N#1	3.74506e-19
C227	Y#1	a_27_392##5	2.96424e-20
C228	Y#2	a_27_392##5	6.87795e-18
C229	Y#1	a_27_392##4	1.31214e-19
C230	Y#2	a_27_392##4	1.04563e-17
C231	a_27_392##8	VPWR#7	1.44254e-18
C232	Y#1	A#4	1.6819e-17
C233	VGND#2	a_27_392##5	4.60488e-19
C234	Y#1	A#5	2.14702e-17
C235	VGND#2	a_27_392##4	4.5671e-18
C236	a_27_392##2	Y#3	2.2133e-19
C237	VGND#7	Y#3	4.94035e-17
C238	VGND#2	A#4	4.80612e-18
C239	VGND#1	a_228_368#	2.54292e-19
C240	VGND#7	VGND#6	1.96902e-18
C241	VGND#2	A#5	1.20947e-18
C242	Y#3	VGND#6	4.09923e-17
C243	Y#3	Y#4	2.45955e-18
C244	VGND#6	Y#4	3.83136e-17
C245	a_27_392##8	a_27_392##10	2.16687e-18
C246	VGND#6	VGND#1	2.19734e-18
C247	VGND#2	A#2	6.34752e-21
C248	a_27_392##8	VGND#7	4.14698e-17
C249	Y#4	VGND#1	4.4517e-17
C250	Y#2	a_228_368##2	1.11366e-18
C251	Y#1	a_228_368#	3.31718e-18
C252	a_27_392##3	a_27_392##2	2.54402e-18
C253	a_27_392##2	A#4	5.47184e-18
C254	VGND#7	Y#2	4.16477e-18
C255	Y#3	Y#1	3.95928e-19
C256	Y#2	Y#3	6.32045e-19
C257	Y#1	VGND#6	1.53195e-17
C258	a_27_392##2	A#3	2.98828e-17
C259	A#3	A#2	3.5255e-18
C260	Y#2	VGND#6	1.65264e-17
C261	Y#1	Y#4	3.32997e-18
C262	VGND#7	VGND#2	4.90972e-20
C263	Y#1	VGND#1	1.66793e-18
C264	VGND#4	B_N#1	4.73966e-18
C265	VPWR#3	VPWR#4	5.34719e-17
C266	VPWR#7	VPWR#2	4.88591e-20
C267	VPWR#4	B_N#3	3.29266e-18
C268	VGND#4	a_27_392##8	2.72751e-17
C269	VPWR#2	a_27_392##6	1.9796e-19
C270	VPWR#4	VPWR#2	1.88131e-19
C271	VPWR#2	A#6	5.24037e-18
C272	VGND#4	VGND#2	1.10752e-18
C273	VPWR#4	a_27_392##3	6.06452e-20
C274	VGND#4	VNB	5.67564e-17
C275	a_27_392##9	VPWR#4	1.76455e-17
C276	VGND#4	a_27_392##5	2.0425e-18
C277	VGND#4	B_N#2	1.37608e-19
C278	a_228_368##4	VPWR#4	1.10097e-17
C279	VPWR#2	VNB	4.60539e-17
C280	VPWR#3	VPWR#2	5.18269e-17
C281	VPWR	VPWR#2	4.87485e-17
C282	VPWR#4	VNB	5.13334e-17
C283	VPWR#2	B_N#3	6.85138e-20
C284	VPWR#2	a_27_392#	5.95982e-19
C285	a_228_368##2	VPWR#2	1.76352e-17
C286	VPWR	VPWR#4	3.58665e-17
C287	VGND	VGND#4	4.29204e-17
C288	VPWR#2	A#1	4.64294e-18
C289	VGND#3	VGND#4	6.2377e-17
C290	a_228_368#	VPWR#2	1.78953e-17
C291	VGND#4	a_27_392##3	4.00372e-19
*
*
.ENDS sky130_fd_sc_hs__nor2b_2
*
