* Extracted by Quantus, converted by sky130cad/quantus.py
*
*
*
*                       LINUX           Wed Nov 18 08:58:55 2026
*
*
*
*  PROGRAM  advgen
*
*  Name           : advgen - Quantus - (64-bit)
*  Version        : 25.1.0-p047
*  Build Date     : Thu Dec 11 23:20:30 PST 2025
*
*  HSPICE LIBRARY
*
*  OPERATING_TEMPERATURE 150
*  QRC_TECH_DIR <path>/tech
*
*
*

*
.SUBCKT sky130_fd_sc_hs__o22ai_1 VNB VPB VGND VPWR Y B1 A1 B2 A2
*
*
*  caps2d version: 10
*
*
*       TRANSISTOR CARDS
*
*
XM6 a_27_74##4 B1#4 Y#2 VNB sky130_fd_pr__nfet_01v8_lvt l=0.15 w=0.74 ad=0.2109 as=0.4255 pd=2.05 ps=2.63
XM5 Y#2 B2#1 a_27_74##2 VNB sky130_fd_pr__nfet_01v8_lvt l=0.15 w=0.74 ad=0.4255 as=0.259 pd=2.63 ps=2.18
XM4 a_27_74##2 A2#1 VGND#4 VNB sky130_fd_pr__nfet_01v8_lvt l=0.15 w=0.74 ad=0.259 as=0.3108 pd=2.18 ps=2.32
XM0 VGND#4 A1#1 a_27_74# VNB sky130_fd_pr__nfet_01v8_lvt l=0.15 w=0.74 ad=0.3108 as=0.2109 pd=2.32 ps=2.05
XM3 VPWR#4 B1#1 a_142_368# VPB sky130_fd_pr__pfet_01v8 l=0.15 w=1.12 ad=0.4648 as=0.3024 pd=3.07 ps=2.78
XM7 a_142_368# B2#3 Y#1 VPB sky130_fd_pr__pfet_01v8 l=0.15 w=1.12 ad=0.3024 as=0.4704 pd=2.78 ps=3.08
XM1 Y#1 A2#3 a_340_368# VPB sky130_fd_pr__pfet_01v8 l=0.15 w=1.12 ad=0.4704 as=0.4704 pd=3.08 ps=3.08
XM2 a_340_368# A1#3 VPWR#5 VPB sky130_fd_pr__pfet_01v8 l=0.15 w=1.12 ad=0.4704 as=0.3304 pd=3.08 ps=2.83
*
*
*       RESISTOR AND CAP/DIODE CARDS
*
Rg1	B1#1	B1#2	502.967712
Rg2	B1#2	B1#3	37.334541
Rg3	B1#2	B1#4	301.010986
Rg4	B2#1	B2#2	382.539734
Rg5	B2#2	B2#3	434.639221
Rg6	A2#1	A2#2	382.539734
Rg7	A2#2	A2#3	434.639221
Rg8	A1#1	A1#2	371.626007
Rg9	A1#2	A1#3	488.722717
Rf1	B1	B1#5	0.705966
Rf2	B1#6	B1#3	160.938766
Rf3	B1#5	B1#6	3.543054
Rf4	B2#2	B2#5	161.302414
Rf5	B2#6	B2	1.069610
Rf6	B2#5	B2#6	5.583287
Rf7	Y#1	Y	6.761375
Rf8	Y	Y#2	105.068161
Rf9	A2	A2#2	166.137894
Rf10	a_27_74#	a_27_74##3	91.041138
Rf11	a_27_74##3	a_27_74##4	109.445869
Rf12	a_27_74##2	a_27_74##3	7.500000
Rf13	A1#4	A1	1.828707
Rf14	A1#2	A1#6	81.945107
Rf15	A1#4	A1#6	7.696024
Rf16	A1#7	A1	1.828707
Rf17	A1#6	A1#7	5.497160
Rf19	VPWR#2	VPWR#3	71.564949
Rf20	VPWR#3	VPWR#4	120.290108
Rf21	VPWR#2	VPWR#5	35.727165
Rf23	VGND#2	VGND#3	41.248997
Rf24	VGND#2	VGND#4	36.279022
Re1	VPWR#3	VPWR	1.637070
Re2	VGND	VGND#3	1.637131
*
*       CAPACITOR CARDS
*
*
C1	VGND	VNB	6.76626e-17
C2	VPWR	VNB	6.25973e-17
C3	Y	VNB	8.25032e-18
C4	A1	VNB	2.67207e-17
C5	A2	VNB	9.48648e-19
C6	B1#3	VNB	6.60644e-17
C7	B2#2	VNB	2.83358e-17
C8	A2#2	VNB	2.4553e-17
C9	A1#2	VNB	7.57744e-17
C10	VGND#3	VNB	2.01468e-16
C11	VPWR#3	VNB	1.70118e-16
C12	VPWR	Y	3.60486e-17
C13	B1#1	VNB	4.52327e-17
C14	VGND	A1	6.57949e-18
C15	B2#3	VNB	3.37195e-17
C16	A2#3	VNB	2.93138e-17
C17	A1#3	VNB	3.07047e-17
C18	B1#4	VNB	3.69852e-17
C19	B2#1	VNB	3.17455e-17
C20	A2#1	VNB	3.15306e-17
C21	VPWR	A1	7.49003e-18
C22	A1#1	VNB	3.26943e-17
C23	VPWR#4	VNB	9.01681e-17
C24	VPWR#5	VNB	4.65276e-17
C25	a_27_74##4	VNB	3.87112e-17
C26	Y#2	VNB	1.17806e-17
C27	VPWR	A2	6.4782e-18
C28	a_27_74##2	VNB	1.37637e-17
C29	VGND#4	VNB	3.07514e-18
C30	a_27_74#	VNB	4.18286e-17
C31	B1#5	VNB	7.0501e-18
C32	B1#6	VNB	1.22558e-17
C33	VGND	B1#3	7.30575e-19
C34	B2#5	VNB	2.22862e-18
C35	B2#6	VNB	1.55544e-18
C36	A2	Y	1.78652e-17
C37	VGND	A2#2	3.15651e-18
C38	A1#6	VNB	2.72281e-18
C39	VGND	A1#2	1.76781e-18
C40	VGND	VGND#3	4.05486e-17
C41	Y	a_142_368#	3.11506e-18
C42	VPWR	B1#3	7.8541e-19
C43	A2	A1	1.99475e-17
C44	VPWR	A1#2	1.62686e-21
C45	Y	B2#2	3.40102e-18
C46	VPWR	VPWR#3	2.8693e-17
C47	VGND	B1#4	4.7746e-18
C48	VGND	B2#1	1.18693e-18
C49	VPWR	B1#1	1.92046e-18
C50	VGND	A2#1	1.37167e-18
C51	VGND	A1#1	1.01567e-18
C52	VPWR	B2#3	2.9055e-19
C53	VGND	VPWR#4	2.7893e-18
C54	VPWR	A2#3	2.082e-18
C55	Y	VPWR#3	3.70933e-17
C56	VPWR	A1#3	9.9153e-19
C57	Y	B1#1	3.23785e-17
C58	VGND	a_27_74##4	2.52368e-17
C59	VGND	Y#2	1.0022e-17
C60	Y	B2#3	5.5252e-17
C61	VGND	a_27_74##2	2.72867e-17
C62	A2#2	A1	2.40986e-17
C63	Y	A2#3	2.99629e-17
C64	VGND	a_27_74#	1.71976e-17
C65	A1	A1#2	2.47494e-17
C66	VPWR	VPWR#4	4.59019e-17
C67	VGND	B1#5	3.0254e-18
C68	Y	A1#3	9.30977e-18
C69	VGND	B2#5	4.19093e-18
C70	A2	B2#2	1.71166e-18
C71	VPWR	VPWR#5	2.22055e-17
C72	A2	A2#2	8.24994e-18
C73	VGND	A1#6	1.32728e-18
C74	VPWR#4	Y	1.18827e-16
C75	A2	A1#2	1.2224e-18
C76	Y	Y#1	1.66466e-17
C77	A1	A2#3	4.58433e-19
C78	VPWR	B1#6	2.18566e-18
C79	A1	A1#3	5.19576e-18
C80	Y	VPWR#5	2.84022e-17
C81	A2	VPWR#3	1.39778e-18
C82	Y#2	Y	2.92123e-18
C83	VPWR	B2#6	2.62342e-18
C84	a_27_74##2	Y	8.4332e-18
C85	A2#2	a_340_368#	5.02555e-19
C86	VPWR	A1#6	1.3476e-18
C87	A2	B2#3	3.68939e-19
C88	A2	A2#3	5.04151e-18
C89	B1#3	B2#2	2.14206e-17
C90	A2	A1#3	1.09327e-18
C91	Y	B2#6	4.63386e-17
C92	B1#1	a_142_368#	2.27629e-17
C93	A1	VPWR#5	2.13214e-17
C94	B2#2	A2#2	3.21251e-17
C95	B2#3	a_142_368#	1.98156e-17
C96	Y#2	A1	1.89269e-18
C97	VGND#3	B1#3	3.06489e-19
C98	A1	VGND#4	8.01062e-19
C99	VGND#3	B2#2	6.88673e-20
C100	A2#2	A1#2	2.97971e-17
C101	A1	a_27_74#	4.2063e-17
C102	A2#3	a_340_368#	3.51708e-17
C103	VPWR#3	B2#2	6.67361e-20
C104	A1#3	a_340_368#	3.5639e-17
C105	VGND#3	A2#2	4.41457e-20
C106	VPWR#3	A2#2	1.98301e-19
C107	B1#1	B2#2	3.41335e-18
C108	B1#3	B2#1	9.9171e-19
C109	A2#2	A1#3	6.87191e-19
C110	B2#5	A2	2.82866e-18
C111	B2#6	A2	1.25431e-17
C112	VPWR#3	B2#3	5.33885e-18
C113	VPWR#4	B1#3	9.74443e-18
C114	VPWR#3	A2#3	8.82236e-18
C115	B1#1	B2#3	5.31206e-17
C116	VGND#3	B1#4	4.98864e-18
C117	A2#1	A1#2	8.63616e-19
C118	B2#2	Y#1	5.29945e-19
C119	VGND#3	B2#1	5.03022e-18
C120	B1#3	a_27_74##4	5.66999e-18
C121	Y#2	B1#3	1.39043e-17
C122	VGND#3	A2#1	1.67674e-18
C123	B2#3	A2#3	2.8775e-17
C124	Y#2	B2#2	8.48293e-18
C125	A2#3	A1#3	3.46893e-17
C126	a_27_74##2	B2#2	4.54744e-19
C127	B1#5	B1#3	9.81355e-18
C128	VPWR#3	VPWR#4	3.46539e-17
C129	B1#6	B1#3	1.37716e-17
C130	Y#2	A2#2	3.12066e-19
C131	A1#2	VPWR#5	5.73479e-18
C132	a_27_74##2	A2#2	3.36419e-17
C133	B1#5	B2#2	1.31896e-19
C134	B2#5	B1#3	2.59732e-18
C135	VGND#4	A2#2	4.12191e-19
C136	Y#2	A1#2	1.10718e-19
C137	VGND#3	a_27_74##4	4.61474e-17
C138	VPWR#4	B1#1	3.1287e-17
C139	B2#6	B1#3	8.5566e-19
C140	B2#5	B2#2	1.35309e-17
C141	VGND#4	A1#2	5.76976e-19
C142	VPWR#4	B2#3	1.07165e-18
C143	a_27_74#	A1#2	8.06128e-18
C144	VGND#3	a_27_74##2	4.08492e-17
C145	B2#6	B2#2	6.09991e-18
C146	B2#5	A2#2	1.5792e-17
C147	VPWR#4	A2#3	6.12641e-19
C148	B1#4	B2#1	1.18005e-17
C149	B2#3	Y#1	2.82351e-17
C150	VPWR#5	B1#1	3.96462e-19
C151	B2#6	A2#2	9.89097e-19
C152	VPWR#4	A1#3	4.39688e-19
C153	A2#3	Y#1	3.28818e-18
C154	VPWR#5	B2#3	2.54482e-18
C155	Y#2	B1#1	1.34411e-18
C156	B2#1	A2#1	2.84567e-17
C157	VPWR#5	A2#3	1.06794e-17
C158	A2#1	A1#1	2.14039e-17
C159	VPWR#5	A1#3	5.36143e-17
C160	A1#6	A1#2	9.76214e-18
C161	a_27_74##4	B1#4	5.05738e-17
C162	B1#4	Y#2	3.11929e-17
C163	B2#6	B1#1	1.16831e-18
C164	a_27_74##4	B2#1	8.81355e-19
C165	a_27_74##2	B1#4	1.9492e-18
C166	B2#1	Y#2	2.53113e-17
C167	a_27_74##4	A2#1	2.26154e-19
C168	VGND#4	B1#4	2.10071e-19
C169	B2#6	B2#3	1.47626e-18
C170	a_27_74##2	B2#1	4.28774e-17
C171	Y#2	A2#1	1.10694e-18
C172	VGND#4	B2#1	3.71004e-19
C173	B2#6	A2#3	8.22384e-19
C174	a_27_74##2	A2#1	6.36965e-17
C175	Y#2	A1#1	1.95384e-20
C176	a_27_74##4	VPWR#4	2.2632e-19
C177	A2#1	VGND#4	2.36701e-17
C178	a_27_74##2	A1#1	1.43777e-18
C179	B1#5	B2#1	2.94568e-19
C180	a_27_74#	A2#1	8.45626e-19
C181	A1#1	VGND#4	2.31493e-17
C182	a_27_74#	A1#1	4.63581e-17
C183	B1#6	VPWR#4	2.3597e-17
C184	a_27_74##4	Y#2	7.02975e-17
C185	a_27_74##4	a_27_74##2	1.91105e-18
C186	a_27_74##2	Y#2	4.61712e-17
C187	a_27_74##4	B1#5	3.00044e-17
C188	a_27_74##2	VGND#4	6.20362e-17
C189	B1#5	Y#2	1.9132e-17
C190	a_27_74##2	a_27_74#	2.65318e-18
C191	B1#6	Y#2	1.78656e-17
C192	a_27_74#	VGND#4	5.70236e-17
C193	Y#2	B2#5	3.63516e-17
C194	a_27_74##2	B2#5	4.63416e-18
C195	Y#2	B2#6	1.18354e-17
C196	A1#6	VPWR#5	2.44787e-17
C197	A1#6	a_27_74#	2.31803e-17
C198	VGND#2	A2#1	4.94418e-18
C199	VGND#2	B2#1	6.38878e-19
C200	VGND#2	B1#4	2.07217e-19
C201	VPWR#3	VPWR#2	4.33006e-17
C202	VGND#2	a_27_74#	1.98859e-17
C203	VPWR	VPWR#2	3.23752e-17
C204	VGND#2	a_27_74##2	6.35932e-19
C205	VGND#2	A1	1.00206e-18
C206	VPWR#2	A1#2	5.985e-19
C207	VPWR#2	A1#3	4.17976e-18
C208	VGND#3	VGND#2	5.19445e-17
C209	VGND	VGND#2	5.46363e-17
C210	VPWR#2	VNB	4.16572e-17
C211	VGND#2	A1#2	4.91796e-19
C212	VGND#2	VNB	4.85428e-17
C213	A1	VPWR#2	1.78766e-18
C214	VGND#2	A1#1	5.91145e-18
*
*
.ENDS sky130_fd_sc_hs__o22ai_1
*
