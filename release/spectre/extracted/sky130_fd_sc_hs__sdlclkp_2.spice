* Extracted by Quantus, converted by sky130cad/quantus.py
*
*
*
*                       LINUX           Wed Nov 18 09:12:06 2026
*
*
*
*  PROGRAM  advgen
*
*  Name           : advgen - Quantus - (64-bit)
*  Version        : 25.1.0-p047
*  Build Date     : Thu Dec 11 23:20:30 PST 2025
*
*  HSPICE LIBRARY
*
*  OPERATING_TEMPERATURE 150
*  QRC_TECH_DIR <path>/tech
*
*
*

*
.SUBCKT sky130_fd_sc_hs__sdlclkp_2 VNB VPB VGND VPWR GCLK CLK SCE GATE
*
*
*  caps2d version: 10
*
*
*       TRANSISTOR CARDS
*
*
XM12 VGND#8 SCE#3 a_114_112##2 VNB sky130_fd_pr__nfet_01v8_lvt l=0.15 w=0.55 ad=0.15675 as=0.154 pd=1.67 ps=1.66
XM20 a_114_112##2 GATE#1 VGND#12 VNB sky130_fd_pr__nfet_01v8_lvt l=0.15 w=0.55 ad=0.154 as=0.37805 pd=1.66 ps=2.82
XM0 VGND#12 a_288_48##5 a_318_74##6 VNB sky130_fd_pr__nfet_01v8_lvt l=0.15 w=0.74 ad=0.37805 as=0.2109 pd=2.82 ps=2.05
XM5 a_114_112# a_288_48##6 a_580_74##6 VNB sky130_fd_pr__nfet_01v8_lvt l=0.15 w=0.55 ad=0.33275 as=0.19475 pd=2.31 ps=1.85
XM13 a_580_74##6 a_318_74# a_685_81# VNB sky130_fd_pr__nfet_01v8_lvt l=0.15 w=0.42 ad=0.19475 as=0.1008 pd=1.85 ps=1.32
XM11 a_685_81# a_706_317# VGND#11 VNB sky130_fd_pr__nfet_01v8_lvt l=0.15 w=0.42 ad=0.1008 as=0.3026 pd=1.32 ps=2.54
XM18 VGND#11 a_580_74# a_706_317##12 VNB sky130_fd_pr__nfet_01v8_lvt l=0.15 w=0.74 ad=0.3026 as=0.2109 pd=2.54 ps=2.05
XM16 a_288_48##8 CLK#5 VGND#10 VNB sky130_fd_pr__nfet_01v8_lvt l=0.15 w=0.74 ad=0.2109 as=0.2627 pd=2.05 ps=2.19
XM8 VGND#10 CLK#1 a_1198_74# VNB sky130_fd_pr__nfet_01v8_lvt l=0.15 w=0.74 ad=0.2627 as=0.1554 pd=2.19 ps=1.9
XM23 a_1198_74# a_706_317##6 a_1195_374##8 VNB sky130_fd_pr__nfet_01v8_lvt l=0.15 w=0.74 ad=0.1554 as=0.2035 pd=1.9 ps=2.03
XM4 GCLK#1 a_1195_374##6 VGND#9 VNB sky130_fd_pr__nfet_01v8_lvt l=0.15 w=0.74 ad=0.2072 as=0.2035 pd=2.04 ps=2.03
XM22 VGND#1 a_1195_374# GCLK#1 VNB sky130_fd_pr__nfet_01v8_lvt l=0.15 w=0.74 ad=0.2035 as=0.2072 pd=2.03 ps=2.04
XM3 VPWR#8 SCE#1 a_114_424# VPB sky130_fd_pr__pfet_01v8 l=0.15 w=0.84 ad=0.2394 as=0.2016 pd=2.25 ps=2.16
XM10 a_114_424# GATE#3 a_114_112##5 VPB sky130_fd_pr__pfet_01v8 l=0.15 w=0.84 ad=0.2016 as=0.2394 pd=2.16 ps=2.25
XM6 VPWR#12 a_288_48##2 a_318_74##7 VPB sky130_fd_pr__pfet_01v8 l=0.15 w=0.84 ad=0.3807 as=0.2394 pd=2.98 ps=2.25
XM7 a_114_112##6 a_318_74##3 a_580_74##7 VPB sky130_fd_pr__pfet_01v8 l=0.15 w=0.84 ad=0.2394 as=0.2772 pd=2.25 ps=2.43
XM21 a_580_74##7 a_288_48# a_708_451# VPB sky130_fd_pr__pfet_01v8 l=0.15 w=0.42 ad=0.2772 as=0.1008 pd=2.43 ps=1.32
XM2 a_708_451# a_706_317##3 VPWR#11 VPB sky130_fd_pr__pfet_01v8 l=0.15 w=0.42 ad=0.1008 as=0.357 pd=1.32 ps=2.99
XM17 VPWR#11 a_580_74##3 a_706_317##8 VPB sky130_fd_pr__pfet_01v8 l=0.15 w=1.12 ad=0.357 as=0.3192 pd=2.99 ps=2.81
XM19 a_288_48##7 CLK#6 VPWR#10 VPB sky130_fd_pr__pfet_01v8 l=0.15 w=0.84 ad=0.2394 as=0.38835 pd=2.25 ps=3.02
XM14 VPWR#10 CLK#4 a_1195_374##10 VPB sky130_fd_pr__pfet_01v8 l=0.15 w=1 ad=0.38835 as=0.515 pd=3.02 ps=3.03
XM9 a_1195_374##10 a_706_317##4 VPWR#9 VPB sky130_fd_pr__pfet_01v8 l=0.15 w=1 ad=0.515 as=0.474 pd=3.03 ps=3.11
XM15 GCLK#2 a_1195_374##7 VPWR#9 VPB sky130_fd_pr__pfet_01v8 l=0.15 w=1.12 ad=0.336 as=0.474 pd=2.84 ps=3.11
XM1 VPWR#1 a_1195_374##5 GCLK#2 VPB sky130_fd_pr__pfet_01v8 l=0.15 w=1.12 ad=0.3304 as=0.336 pd=2.83 ps=2.84
*
*
*       RESISTOR AND CAP/DIODE CARDS
*
Rg1	SCE#1	SCE#2	380.296570
Rg2	SCE#2	SCE#3	319.589111
Rg3	GATE#1	GATE#2	488.704193
Rg4	GATE#2	GATE#3	354.298584
Rg5	a_318_74#	a_318_74##2	505.710663
Rg6	a_318_74##2	a_318_74##3	356.875916
Rg7	a_288_48#	a_288_48##2	1560.340332
Rg8	a_288_48##2	a_288_48##3	465.333984
Rg9	a_288_48##3	a_288_48##4	152.166367
Rg10	a_288_48##3	a_288_48##5	486.613647
Rg11	a_288_48##4	a_288_48##6	447.383331
Rg12	a_706_317#	a_706_317##2	581.438904
Rg13	a_706_317##2	a_706_317##3	305.267914
Rg14	a_580_74#	a_580_74##2	306.793884
Rg15	a_580_74##2	a_580_74##3	449.040771
Rg16	CLK#1	CLK#2	322.953644
Rg17	CLK#2	CLK#3	61.112164
Rg18	CLK#2	CLK#4	485.694550
Rg19	CLK#3	CLK#5	326.187012
Rg20	CLK#3	CLK#6	380.234528
Rg21	a_706_317##4	a_706_317##5	458.531433
Rg22	a_706_317##5	a_706_317##6	380.700043
Rg23	a_1195_374#	a_1195_374##2	384.320526
Rg24	a_1195_374##2	a_1195_374##3	59.578423
Rg25	a_1195_374##3	a_1195_374##4	35.759460
Rg26	a_1195_374##2	a_1195_374##5	474.928162
Rg27	a_1195_374##3	a_1195_374##6	379.087921
Rg28	a_1195_374##4	a_1195_374##7	450.161743
Rf1	SCE	SCE#2	82.999611
Rf2	GATE#2	GATE#5	163.285416
Rf3	GATE#6	GATE	3.052613
Rf4	GATE#5	GATE#6	6.280663
Rf5	a_114_112#	a_114_112##3	124.727310
Rf6	a_114_112##3	a_114_112##4	148.128113
Rf7	a_114_112##4	a_114_112##5	41.634357
Rf8	a_114_112##4	a_114_112##6	82.824402
Rf9	a_114_112##2	a_114_112##3	15.000000
Rf10	a_318_74##2	a_318_74##5	197.333588
Rf11	a_318_74##5	a_318_74##6	56.548676
Rf12	a_318_74##5	a_318_74##7	24.443676
Rf13	a_580_74##2	a_580_74##5	225.704010
Rf14	a_580_74##5	a_580_74##6	65.822334
Rf15	a_580_74##5	a_580_74##7	93.012878
Rf16	a_288_48##7	a_288_48##9	90.175133
Rf17	a_288_48##9	a_288_48##4	492.711182
Rf18	a_288_48##8	a_288_48##9	7.500000
Rf19	CLK	CLK#3	163.775864
Rf20	a_706_317##5	a_706_317##9	320.178650
Rf21	a_706_317##9	a_706_317##10	17.786634
Rf22	a_706_317##10	a_706_317##2	212.752014
Rf23	a_706_317##10	a_706_317##12	81.167236
Rf24	a_706_317##8	a_706_317##9	5.000000
Rf25	a_1195_374##8	a_1195_374##9	66.416924
Rf26	a_1195_374##9	a_1195_374##10	82.401108
Rf27	GCLK#1	GCLK	84.527672
Rf28	GCLK	GCLK#3	13.403392
Rf29	GCLK#3	GCLK	0.183608
Rf30	GCLK#2	GCLK#3	5.000000
Rf31	VGND#1	VGND#2	75.515633
Rf32	VGND#2	VGND#3	32.905540
Rf33	VGND#3	VGND#4	94.608673
Rf34	VGND#4	VGND#5	127.181374
Rf35	VGND#5	VGND#6	43.563087
Rf36	VGND#6	VGND#7	156.303528
Rf37	VGND#7	VGND#8	124.747253
Rf38	VGND#3	VGND#9	39.841232
Rf39	VGND#4	VGND#10	32.518913
Rf40	VGND#5	VGND#11	50.781399
Rf41	VGND#7	VGND#12	22.894152
Rf42	VPWR#1	VPWR#2	77.988266
Rf43	VPWR#2	VPWR#3	41.248997
Rf44	VPWR#3	VPWR#4	87.611526
Rf45	VPWR#4	VPWR#5	113.967056
Rf46	VPWR#5	VPWR#6	55.185940
Rf47	VPWR#6	VPWR#7	124.891815
Rf48	VPWR#7	VPWR#8	133.273285
Rf49	VPWR#3	VPWR#9	34.487274
Rf50	VPWR#4	VPWR#10	35.491676
Rf51	VPWR#5	VPWR#11	45.259815
Rf52	VPWR#7	VPWR#12	31.554951
Rf61	a_1195_374##4	a_1195_374##9	160.232803
Re1	VPWR#2	VPWR	4.549932
Re2	VPWR	VPWR#6	0.974985
Re3	VGND#2	VGND	4.549932
Re4	VGND	VGND#6	0.974985
*
*       CAPACITOR CARDS
*
*
C1	VPWR#12	a_114_112##6	4.83873e-18
C2	GCLK#1	VGND#1	6.36245e-17
C3	a_288_48##6	a_114_112#	8.94622e-18
C4	a_706_317##10	a_318_74##3	1.40157e-19
C5	a_580_74##6	a_288_48##5	2.99513e-19
C6	a_114_112##5	a_114_112##6	1.46447e-18
C7	a_318_74##6	a_288_48##6	6.69987e-19
C8	CLK#6	CLK#2	4.17581e-18
C9	VGND#9	VGND#1	1.49391e-18
C10	a_114_112#	a_288_48##5	1.73563e-17
C11	a_706_317##8	VPWR#5	1.64585e-17
C12	a_318_74##6	a_288_48##5	2.29712e-17
C13	a_580_74##5	a_288_48#	3.0423e-18
C14	a_114_112##2	a_288_48##6	1.72247e-19
C15	a_114_112#	GATE#1	4.33781e-19
C16	VGND#9	GCLK#1	3.83514e-17
C17	a_114_112##5	VPWR#12	2.83206e-17
C18	a_706_317##8	VPWR#4	5.32415e-18
C19	a_288_48##5	VGND#12	1.70668e-17
C20	VPWR#12	a_288_48##3	2.69165e-19
C21	a_318_74##6	GATE#1	2.01526e-18
C22	a_114_112##2	a_288_48##5	3.79386e-17
C23	a_114_112#	SCE#3	3.06596e-19
C24	a_580_74##5	a_318_74##3	1.79349e-18
C25	GATE#1	VGND#12	1.4581e-17
C26	a_114_112#	a_318_74##5	2.33869e-18
C27	a_1195_374##8	GCLK#1	2.85229e-18
C28	VGND#8	a_288_48##5	2.23979e-18
C29	VPWR#2	VPWR#3	3.54775e-17
C30	VPWR#8	VPWR#12	8.1434e-19
C31	a_114_112##2	GATE#1	5.02382e-17
C32	a_318_74##5	a_318_74##3	1.77097e-18
C33	a_580_74##5	a_288_48##2	3.38525e-20
C34	a_1195_374##8	VGND#9	3.60565e-17
C35	VGND#8	GATE#1	8.64893e-19
C36	VPWR#8	a_114_112##5	2.41434e-17
C37	a_114_112##2	SCE#3	3.16069e-17
C38	a_114_112##4	a_318_74##3	2.8554e-19
C39	a_318_74##5	a_288_48##2	2.50121e-17
C40	VGND#8	SCE#3	1.78491e-17
C41	a_114_112##4	a_288_48##2	3.12787e-17
C42	a_114_112##6	VPWR#7	4.40427e-18
C43	a_318_74##6	a_114_112##4	4.37681e-19
C44	a_318_74##5	GATE#3	2.28726e-19
C45	VGND#10	VGND#9	1.11558e-18
C46	VGND#2	VGND#3	5.33838e-17
C47	a_114_112##2	a_318_74##5	9.67206e-18
C48	a_114_112##4	GATE#3	1.4044e-18
C49	VGND#10	a_1195_374##8	2.5072e-17
C50	VPWR#1	a_1195_374##5	2.90297e-17
C51	a_1195_374##6	a_1195_374#	3.84163e-17
C52	a_1195_374##5	GCLK#2	2.44089e-17
C53	a_114_112##4	SCE#1	4.9841e-19
C54	a_706_317##10	a_288_48##7	6.25547e-17
C55	a_288_48##8	a_1195_374##8	2.02647e-18
C56	VPWR#1	a_1195_374##7	1.23062e-18
C57	a_114_112##2	a_114_112##4	6.19114e-19
C58	VPWR#9	a_1195_374##5	1.48739e-18
C59	a_1195_374##4	VPWR#3	2.21006e-19
C60	a_1195_374##7	GCLK#2	2.37354e-17
C61	a_114_112##6	a_288_48##6	1.13126e-19
C62	a_706_317##6	a_1195_374##6	5.33668e-18
C63	VPWR#1	a_706_317##4	1.75076e-19
C64	a_1195_374##7	VPWR#9	3.08651e-17
C65	a_706_317##10	a_706_317##8	6.82339e-19
C66	a_706_317##5	VPWR#4	1.89855e-18
C67	a_114_112##4	VPWR#7	2.48952e-18
C68	a_1195_374##10	a_1195_374##7	1.58726e-18
C69	VPWR#3	a_706_317##5	9.2908e-20
C70	VGND#3	a_1195_374##4	5.50105e-19
C71	a_114_112##5	VPWR#7	1.79589e-17
C72	a_706_317##4	VPWR#9	3.41984e-17
C73	a_288_48##8	VGND#10	6.53221e-17
C74	VPWR#10	a_1195_374##7	4.90194e-19
C75	CLK#1	a_706_317##6	5.90117e-17
C76	a_706_317##10	VPWR#11	8.21396e-18
C77	a_1195_374##10	a_706_317##4	8.09641e-17
C78	VPWR#12	a_288_48##5	7.02718e-19
C79	VPWR#9	CLK#4	1.09332e-18
C80	VGND#4	a_706_317##5	1.83338e-18
C81	VPWR#10	a_706_317##4	2.53872e-18
C82	VGND#3	a_706_317##5	1.84564e-19
C83	CLK#4	a_1195_374##10	2.77516e-17
C84	CLK#5	CLK#1	2.78858e-17
C85	a_114_112#	a_288_48##3	1.83137e-18
C86	VPWR#10	CLK#4	4.73957e-17
C87	a_288_48##8	a_706_317##12	1.35218e-16
C88	a_706_317##8	a_706_317##4	1.33214e-19
C89	VGND#4	CLK#3	5.26101e-19
C90	a_1195_374##10	CLK#6	3.32626e-19
C91	a_288_48##7	CLK#4	2.48424e-18
C92	a_706_317##10	a_706_317##5	3.82665e-19
C93	CLK#6	VPWR#10	2.51461e-17
C94	VPWR#8	VPWR#7	4.50484e-19
C95	a_580_74#	CLK#5	4.39752e-18
C96	a_706_317##8	CLK#4	1.8128e-18
C97	a_580_74##7	a_706_317##10	1.20835e-18
C98	a_288_48##8	VGND#11	6.52731e-17
C99	a_1195_374##10	a_580_74##3	1.60933e-19
C100	a_288_48##7	CLK#6	3.04874e-17
C101	VGND#5	a_580_74##2	4.09629e-20
C102	a_706_317##2	VPWR#5	6.26076e-19
C103	VPWR#11	CLK#4	6.07923e-19
C104	VGND#2	VGND#1	2.17943e-17
C105	VPWR#10	a_580_74##3	2.78197e-18
C106	a_706_317##8	CLK#6	3.74719e-17
C107	a_706_317##10	CLK#3	4.65767e-19
C108	VGND#2	GCLK#1	3.37533e-17
C109	a_318_74##6	a_288_48##3	6.90705e-18
C110	a_288_48##7	a_580_74##3	6.14129e-19
C111	a_706_317#	a_580_74#	1.53558e-17
C112	a_706_317##8	a_580_74##3	6.59263e-17
C113	VGND#2	a_1195_374##8	1.60911e-18
C114	CLK#2	a_706_317##6	2.85141e-18
C115	a_580_74##3	VPWR#11	2.89773e-17
C116	a_580_74##6	a_288_48##8	1.78339e-17
C117	a_580_74##2	a_706_317##10	5.94952e-17
C118	VPWR#10	a_288_48#	4.403e-19
C119	a_706_317##8	a_706_317##3	1.48782e-18
C120	a_318_74#	a_706_317#	4.12154e-17
C121	a_580_74##5	CLK#3	1.22923e-20
C122	VGND#1	VPWR#1	1.49949e-17
C123	a_706_317##3	VPWR#11	2.40706e-17
C124	VPWR#7	a_288_48##4	6.48137e-19
C125	a_580_74##7	a_580_74##3	1.54921e-18
C126	a_706_317##8	a_288_48#	4.13371e-19
C127	a_706_317##2	a_706_317##10	3.35012e-18
C128	a_114_112##6	a_580_74##3	1.65856e-19
C129	VPWR#11	a_288_48#	7.76095e-18
C130	a_288_48##6	a_318_74#	2.43043e-17
C131	a_580_74##7	a_706_317##3	3.30346e-18
C132	a_580_74##5	a_580_74##2	2.95056e-18
C133	VGND#7	a_288_48##4	3.81326e-18
C134	a_706_317##8	a_318_74##3	5.74336e-20
C135	a_318_74##5	a_288_48##3	1.43177e-17
C136	GCLK#1	a_1195_374##4	6.26076e-17
C137	a_114_112##6	a_706_317##3	1.7784e-19
C138	VGND#5	a_288_48##4	8.13245e-18
C139	VPWR#7	GATE#2	6.98052e-20
C140	VPWR#11	a_318_74##3	2.46813e-18
C141	a_1195_374##4	VGND#9	2.14512e-17
C142	a_580_74##7	a_288_48#	1.82886e-17
C143	a_1195_374##8	a_1195_374##4	4.95253e-18
C144	a_288_48##5	a_288_48##6	1.96754e-18
C145	a_114_112##6	a_288_48#	2.96192e-18
C146	a_580_74##5	a_706_317##2	5.8823e-17
C147	GCLK#1	a_706_317##5	4.90657e-20
C148	VPWR#12	a_706_317##3	2.65388e-19
C149	VPWR#11	a_288_48##2	1.21487e-18
C150	VGND#7	GATE#2	2.48802e-19
C151	a_580_74##7	a_318_74##3	3.70705e-17
C152	a_114_112##2	a_288_48##3	6.31033e-19
C153	VPWR#2	VPWR#1	2.09183e-17
C154	a_318_74##5	a_706_317##2	1.20594e-19
C155	a_318_74##3	a_114_112##6	1.86249e-17
C156	a_706_317##5	a_1195_374##8	3.87901e-17
C157	VPWR#12	a_288_48#	1.08151e-18
C158	VGND#3	a_1195_374#	8.64522e-19
C159	GATE#1	a_288_48##5	2.56855e-17
C160	a_580_74##7	a_288_48##2	9.92481e-19
C161	a_318_74##5	a_580_74##7	2.82638e-19
C162	a_580_74##5	a_318_74##2	5.95458e-17
C163	VPWR#2	VPWR#9	2.16106e-17
C164	VGND#10	a_706_317##5	4.96852e-18
C165	a_114_112##6	a_288_48##2	1.24228e-17
C166	VGND#6	a_114_112#	3.14023e-18
C167	VGND#2	VPWR#1	3.175e-18
C168	VGND#7	SCE#2	4.90829e-20
C169	VPWR#12	a_318_74##3	1.57858e-18
C170	a_318_74##5	a_318_74##2	3.80001e-18
C171	a_288_48##2	a_318_74##7	2.15604e-17
C172	a_114_112##5	a_318_74##3	1.74941e-19
C173	SCE#3	GATE#1	3.08144e-17
C174	a_114_112##6	GATE#3	3.58654e-19
C175	VGND#3	a_1195_374##6	4.55806e-18
C176	a_318_74##5	a_114_112##6	4.97716e-17
C177	a_288_48##2	VPWR#12	3.02874e-17
C178	a_288_48##4	a_580_74##5	1.30483e-17
C179	CLK#3	VGND#10	3.53029e-17
C180	a_288_48##8	CLK#3	2.60577e-17
C181	a_114_112##5	a_288_48##2	2.43807e-18
C182	VGND#4	a_706_317##6	7.57734e-18
C183	a_318_74##5	a_288_48##4	4.44955e-17
C184	a_706_317##12	CLK#3	4.15717e-19
C185	VPWR#12	GATE#3	3.32772e-18
C186	a_318_74##5	a_318_74##7	2.16957e-18
C187	a_1195_374##8	a_1195_374##10	3.27985e-18
C188	a_114_112##5	GATE#3	4.85588e-17
C189	VGND#5	CLK#1	3.67108e-20
C190	VGND#3	a_706_317##6	1.21515e-18
C191	a_114_112##4	a_288_48##3	2.40188e-18
C192	a_114_112#	a_318_74##6	3.94589e-17
C193	VPWR#8	a_288_48##2	9.56356e-19
C194	a_288_48##8	a_580_74##2	6.3396e-17
C195	a_114_112##4	a_114_112##6	1.89986e-18
C196	VPWR#12	SCE#1	7.83026e-19
C197	a_580_74##2	a_706_317##12	1.14824e-17
C198	a_318_74##5	GATE#2	9.90685e-19
C199	VGND#4	CLK#1	3.98381e-18
C200	a_114_112##5	SCE#1	7.44548e-18
C201	VPWR#8	GATE#3	1.22662e-17
C202	a_580_74##2	VGND#11	1.04058e-18
C203	a_1195_374##4	GCLK#2	8.41351e-20
C204	a_318_74##5	VPWR#12	2.36505e-18
C205	GATE#2	a_114_112##4	2.96777e-17
C206	a_288_48##8	a_706_317##2	8.88217e-19
C207	VGND#3	CLK#1	1.12562e-19
C208	a_1195_374##4	VPWR#9	3.40319e-17
C209	VGND#5	CLK#5	2.59561e-19
C210	VPWR#8	SCE#1	4.85867e-17
C211	VGND#11	a_706_317##2	5.36694e-19
C212	a_1195_374##7	a_1195_374##5	4.74736e-17
C213	VGND#4	CLK#5	4.40653e-18
C214	a_114_112#	a_114_112##2	1.69063e-18
C215	a_580_74##7	VPWR#6	7.42248e-18
C216	a_114_112##4	SCE#2	5.11934e-19
C217	a_706_317##12	a_318_74##2	3.694e-20
C218	a_706_317##5	a_1195_374##10	1.09269e-16
C219	a_114_112##6	VPWR#6	7.99188e-18
C220	a_114_112##4	VPWR#12	4.13323e-17
C221	VGND#5	a_580_74#	4.35782e-18
C222	a_706_317##5	VPWR#10	1.09268e-17
C223	a_114_112##2	a_318_74##6	2.47674e-17
C224	a_706_317##4	a_1195_374##7	2.87823e-17
C225	a_288_48##7	a_706_317##5	1.61306e-17
C226	a_288_48##4	a_288_48##8	2.11196e-18
C227	a_580_74##6	a_318_74##2	8.60983e-18
C228	a_706_317##8	a_706_317##5	1.33507e-18
C229	CLK#3	VPWR#10	3.78625e-18
C230	a_288_48##4	VGND#11	3.90777e-17
C231	a_114_112##2	VGND#12	3.24868e-18
C232	VGND#3	VGND#1	1.7336e-18
C233	CLK#4	a_706_317##4	1.8212e-17
C234	VGND#5	a_706_317#	3.44791e-18
C235	a_288_48##7	CLK#3	2.69136e-17
C236	VGND#2	a_1195_374#	8.15899e-18
C237	a_288_48##6	a_288_48##2	4.18367e-20
C238	a_288_48##4	a_580_74##6	9.03963e-17
C239	CLK#3	a_706_317##8	1.15316e-17
C240	VGND#2	a_1195_374##6	7.84366e-18
C241	a_288_48##8	a_288_48##7	4.34619e-18
C242	a_288_48##4	a_114_112#	6.31419e-17
C243	VGND#10	a_706_317##8	9.34516e-19
C244	a_288_48##7	a_580_74##2	5.89494e-19
C245	a_318_74##6	a_288_48##4	2.9863e-17
C246	CLK#6	CLK#4	2.88671e-17
C247	a_318_74##5	a_580_74##5	2.30554e-18
C248	a_706_317##12	a_288_48##7	2.92359e-18
C249	a_114_112##2	a_288_48##4	1.07672e-18
C250	a_580_74##2	VPWR#11	1.98135e-18
C251	a_288_48##8	a_706_317##8	3.25321e-19
C252	a_580_74##3	CLK#4	8.58879e-19
C253	VGND#8	a_114_112##2	4.94907e-17
C254	a_706_317##8	a_706_317##2	9.40132e-20
C255	a_580_74##3	CLK#6	5.24393e-18
C256	VPWR#8	a_114_112##4	1.6312e-18
C257	VGND#7	a_288_48##6	5.99278e-19
C258	a_1195_374##4	a_1195_374#	2.45754e-20
C259	a_706_317##2	VPWR#11	1.82242e-17
C260	a_114_112##2	GATE#2	4.60133e-17
C261	a_1195_374##4	a_1195_374##6	4.94236e-18
C262	VGND#5	a_288_48##6	8.07943e-19
C263	VGND#4	a_1195_374##8	1.94492e-18
C264	a_1195_374##4	a_706_317##6	2.73796e-19
C265	a_580_74##7	a_706_317##2	1.52061e-17
C266	a_706_317##3	a_580_74##3	2.30088e-17
C267	a_114_112##6	a_706_317##2	8.18246e-19
C268	a_114_112##2	SCE#2	4.59416e-18
C269	VGND#7	a_288_48##5	1.42618e-17
C270	a_288_48#	a_580_74##3	2.77966e-18
C271	SCE#2	VGND#8	9.95986e-18
C272	a_318_74##2	a_580_74##7	2.59927e-18
C273	VPWR#6	a_288_48##6	4.02959e-20
C274	VGND#3	a_1195_374##8	1.64897e-17
C275	CLK#3	a_1195_374##6	1.9436e-19
C276	a_318_74##2	a_114_112##6	2.75371e-17
C277	VGND#6	a_318_74#	4.02817e-18
C278	a_288_48#	a_706_317##3	4.87575e-17
C279	CLK#3	a_706_317##6	3.40678e-19
C280	SCE	a_288_48##3	6.2177e-19
C281	VGND#6	a_288_48##6	4.41794e-18
C282	VGND#5	VGND#10	9.84439e-20
C283	a_318_74##3	a_706_317##3	3.77799e-19
C284	VPWR#2	a_1195_374##5	7.94824e-18
C285	a_1195_374##4	CLK#2	2.63992e-19
C286	a_114_112##6	a_288_48##4	2.36218e-18
C287	VGND#7	GATE#1	2.94292e-18
C288	VPWR#2	a_1195_374##7	5.1045e-18
C289	a_318_74##3	a_288_48#	4.51738e-17
C290	a_580_74#	CLK#3	3.08441e-19
C291	a_580_74##5	CLK#5	2.44012e-20
C292	a_288_48##2	a_288_48#	1.47138e-18
C293	VGND#5	a_288_48##8	4.87941e-17
C294	a_288_48##2	a_318_74##3	8.9745e-18
C295	VPWR#10	CLK#2	7.43562e-20
C296	a_114_112##4	a_318_74##5	9.07251e-17
C297	VGND#7	a_288_48##3	4.11896e-19
C298	a_114_112##2	a_114_424#	8.74745e-20
C299	a_706_317#	a_580_74##2	1.14483e-19
C300	VPWR#9	VPWR#1	1.47906e-18
C301	VGND#7	SCE#3	5.30364e-18
C302	GATE#2	a_114_112##5	1.54785e-18
C303	a_580_74##5	a_580_74#	1.37641e-19
C304	VGND#10	VGND#3	2.48374e-20
C305	a_1195_374##4	a_1195_374##5	5.49956e-19
C306	GATE#3	a_288_48##2	5.88038e-18
C307	VGND#4	a_288_48##8	4.41926e-17
C308	a_706_317##5	CLK#2	5.22672e-17
C309	a_1195_374##4	a_1195_374##7	5.3734e-18
C310	VPWR#5	VPWR#4	4.9791e-19
C311	a_318_74##2	a_706_317#	7.43236e-18
C312	VGND#1	a_1195_374#	2.35531e-17
C313	a_288_48##4	CLK#5	2.35581e-19
C314	VPWR#8	SCE#2	6.56311e-18
C315	a_706_317##5	a_1195_374##7	4.08738e-19
C316	SCE#1	GATE#3	5.58192e-17
C317	a_580_74##5	a_706_317#	4.12762e-19
C318	a_580_74##6	a_580_74##7	1.31482e-18
C319	a_1195_374##4	CLK#4	6.49783e-20
C320	a_288_48##4	a_580_74#	3.17339e-19
C321	a_706_317##5	a_706_317##4	7.44088e-19
C322	a_288_48##6	a_318_74##2	1.99962e-17
C323	a_288_48##4	a_706_317#	1.50403e-17
C324	a_288_48##7	CLK#2	1.28724e-19
C325	GCLK#1	a_1195_374#	3.84251e-17
C326	VPWR#6	a_288_48#	2.70128e-17
C327	a_706_317##5	CLK#4	3.17461e-17
C328	a_288_48##4	a_318_74#	1.44665e-17
C329	VGND#1	a_1195_374##6	1.37822e-18
C330	VPWR#6	a_318_74##3	3.812e-18
C331	a_706_317##5	CLK#6	2.61465e-18
C332	a_288_48##4	a_288_48##6	2.64508e-17
C333	VGND#6	a_288_48#	6.33255e-20
C334	a_1195_374##10	VPWR#9	5.70326e-17
C335	a_580_74##5	a_318_74#	1.70883e-18
C336	VGND#9	a_1195_374#	5.57198e-19
C337	a_288_48##5	a_288_48##4	6.26135e-18
C338	a_706_317##5	a_580_74##3	1.65315e-19
C339	VPWR#6	a_288_48##2	5.01509e-18
C340	a_288_48##4	GATE#1	1.13486e-19
C341	VPWR#4	a_1195_374##7	2.14756e-19
C342	GCLK#1	a_1195_374##6	3.85617e-17
C343	CLK#3	CLK#2	1.23469e-18
C344	a_580_74##2	CLK#6	6.84336e-19
C345	VGND#1	a_706_317##6	1.43368e-19
C346	VPWR#10	VPWR#9	3.11445e-18
C347	VPWR#3	a_1195_374##7	2.66106e-18
C348	VGND#9	a_1195_374##6	1.04012e-17
C349	GATE	VPWR#7	6.02518e-19
C350	a_580_74##5	a_288_48##6	2.5202e-18
C351	a_706_317##2	CLK#6	1.82878e-19
C352	VPWR#4	VPWR#3	6.57006e-19
C353	GCLK#1	a_706_317##6	6.0224e-19
C354	SCE#2	GATE#1	8.72324e-18
C355	a_706_317##2	a_580_74##3	1.50644e-17
C356	VPWR#10	a_1195_374##10	1.79092e-17
C357	a_1195_374##8	a_1195_374##6	1.90876e-18
C358	a_706_317##2	a_288_48#	7.25612e-18
C359	VGND#9	a_706_317##6	1.54227e-18
C360	VPWR#3	a_706_317##4	9.41735e-18
C361	a_1195_374##4	VPWR#2	5.20612e-18
C362	a_318_74##3	a_706_317##2	4.15555e-18
C363	a_318_74##2	a_288_48#	2.88356e-18
C364	VGND#2	a_1195_374##4	6.16237e-18
C365	VGND#7	a_114_112#	2.5245e-17
C366	a_1195_374##8	a_706_317##6	5.76804e-17
C367	VGND#7	SCE	7.81966e-19
C368	a_706_317##6	a_1198_74#	1.55853e-17
C369	a_288_48##4	a_288_48#	1.35202e-19
C370	a_288_48##8	a_706_317##10	3.93303e-19
C371	CLK#1	a_1198_74#	1.55853e-17
C372	VPWR#4	CLK#4	3.36981e-18
C373	VGND#10	a_1195_374##6	2.96595e-19
C374	a_288_48##2	a_318_74##2	2.6332e-18
C375	VGND#9	CLK#1	1.03386e-19
C376	GATE	a_114_112##4	2.32047e-17
C377	a_706_317##8	a_1195_374##10	1.28255e-18
C378	a_288_48##4	a_288_48##2	1.18019e-18
C379	a_1195_374##8	CLK#1	4.91491e-18
C380	GATE#2	a_288_48##2	5.49506e-18
C381	a_706_317##5	a_1195_374##4	5.25281e-17
C382	VGND#10	a_706_317##6	5.44017e-18
C383	a_706_317##8	VPWR#10	3.47436e-17
C384	a_706_317##12	a_706_317##10	4.25445e-18
C385	CLK#3	a_1195_374##4	2.7528e-18
C386	SCE	a_114_112##4	3.8164e-18
C387	a_706_317##2	VPWR#6	1.92719e-18
C388	VPWR#4	CLK#6	2.53948e-18
C389	VGND	CLK#2	1.57706e-18
C390	VGND	a_288_48##3	1.62277e-18
C391	a_706_317##3	a_708_451#	9.87534e-18
C392	CLK#3	a_706_317##5	2.56609e-17
C393	VGND#6	a_706_317##2	2.40953e-20
C394	a_288_48##8	a_706_317##6	6.2689e-20
C395	a_318_74##2	VPWR#6	1.32318e-18
C396	a_706_317#	a_685_81#	7.4729e-18
C397	a_288_48#	a_708_451#	9.87534e-18
C398	a_1195_374##8	CLK#5	4.45238e-19
C399	a_706_317##8	a_288_48##7	3.36363e-17
C400	VPWR#11	VPWR#10	1.79337e-18
C401	a_318_74#	a_685_81#	3.7458e-19
C402	a_706_317##5	a_580_74##2	1.44329e-19
C403	VGND#6	a_318_74##2	1.31705e-19
C404	VGND#10	CLK#1	4.82837e-17
C405	VPWR#6	a_288_48##4	1.09068e-19
C406	a_580_74##2	CLK#3	4.08759e-18
C407	VPWR#5	a_580_74##3	5.10771e-18
C408	VGND#7	VGND#12	6.52143e-18
C409	VGND#6	a_288_48##4	8.82187e-17
C410	a_114_112##2	a_114_112##5	1.57494e-18
C411	a_288_48##8	CLK#1	1.39009e-18
C412	a_1195_374##8	a_580_74#	2.62228e-19
C413	a_580_74##2	a_706_317##2	5.02007e-17
C414	GATE#3	a_114_424#	1.92873e-17
C415	CLK#5	VGND#10	1.87041e-17
C416	SCE#1	a_114_424#	1.95459e-17
C417	a_580_74##2	a_318_74##2	1.60806e-19
C418	a_114_112##2	SCE	2.88482e-17
C419	SCE	VGND#8	3.43155e-17
C420	a_318_74##2	a_706_317##2	3.43875e-17
C421	VPWR#11	a_706_317##8	6.28928e-17
C422	VPWR	VPWR#7	1.0843e-16
C423	VPWR	VPWR#5	8.64486e-17
C424	VPWR#5	a_706_317##3	3.71885e-18
C425	VPWR	VPWR#4	1.076e-16
C426	VGND#7	a_114_112##2	4.49894e-17
C427	a_288_48##8	CLK#5	6.17129e-17
C428	VPWR	VPWR#3	2.18675e-17
C429	GATE	a_114_112##5	3.49763e-17
C430	a_288_48##4	a_318_74##2	2.40069e-17
C431	GCLK#1	GCLK	1.61558e-18
C432	VPWR#8	GATE	6.43046e-18
C433	VPWR	a_706_317##10	1.07796e-18
C434	a_706_317##12	CLK#5	9.11014e-19
C435	a_288_48##3	a_318_74##2	4.80134e-18
C436	VPWR	a_580_74##5	1.11477e-18
C437	a_706_317##10	CLK#4	5.26213e-20
C438	VPWR	a_318_74##5	6.76498e-18
C439	a_288_48##8	a_580_74#	3.94207e-17
C440	VPWR	a_114_112##4	9.00171e-18
C441	SCE	VPWR#8	3.4605e-17
C442	VGND#8	VGND#7	4.20654e-18
C443	VPWR#5	a_288_48#	3.16211e-18
C444	SCE#2	GATE#2	4.67297e-17
C445	VGND#8	VPWR#8	2.76382e-19
C446	VGND	VGND#7	1.27839e-16
C447	a_580_74##7	a_706_317##8	3.27595e-19
C448	VGND	VGND#5	7.18109e-17
C449	GCLK	VPWR#1	1.03343e-16
C450	VGND	VGND#4	9.56383e-17
C451	VGND	VGND#3	1.69118e-17
C452	GCLK	GCLK#2	8.92839e-19
C453	VPWR#9	GCLK	8.05293e-17
C454	a_580_74#	a_706_317##12	1.32308e-17
C455	a_1195_374##10	GCLK	2.53484e-18
C456	VGND	a_706_317##10	2.84447e-18
C457	VPWR#3	VPWR#1	9.10721e-19
C458	VPWR#4	a_288_48#	2.14752e-19
C459	a_288_48##8	a_706_317#	1.98701e-17
C460	VGND	a_580_74##5	1.45238e-18
C461	VGND	a_318_74##5	2.97964e-18
C462	a_706_317##10	CLK#6	9.01408e-19
C463	SCE	GATE#1	1.10368e-18
C464	a_580_74##7	VPWR#11	1.8111e-17
C465	a_580_74##5	a_288_48##8	2.68933e-17
C466	CLK#2	VNB	1.97494e-17
C467	VPWR	a_114_112##2	4.05614e-18
C468	a_288_48##3	VNB	2.57966e-17
C469	a_580_74#	VGND#11	2.04757e-17
C470	VPWR	a_1195_374##10	1.76319e-17
C471	VGND#5	VGND#4	2.41602e-19
C472	a_706_317##12	a_706_317#	1.21521e-19
C473	VGND	a_1195_374##8	1.72499e-17
C474	VPWR	a_288_48##7	3.31986e-18
C475	VPWR	a_706_317##8	3.13181e-17
C476	VGND	VGND#10	1.8886e-17
C477	VGND	a_288_48##8	4.81338e-17
C478	VGND	a_706_317##12	9.81129e-18
C479	GATE	a_288_48##2	2.95603e-19
C480	VPWR	a_580_74##7	1.48247e-17
C481	VPWR	a_114_112##6	1.96219e-17
C482	VGND	a_580_74##6	1.12262e-17
C483	GATE	GATE#3	7.42352e-18
C484	a_288_48##4	a_685_81#	4.68129e-19
C485	a_288_48##8	a_318_74#	4.0677e-18
C486	a_114_112##6	VPWR#11	1.79487e-18
C487	VGND	a_114_112#	2.37731e-17
C488	VGND	a_318_74##6	6.81187e-18
C489	VPWR	VPWR#12	1.84934e-17
C490	GATE	SCE#1	3.49587e-18
C491	VPWR	a_114_112##5	1.7349e-17
C492	VGND	a_114_112##2	2.83455e-17
C493	VGND	VGND#8	4.81747e-17
C494	VPWR	VPWR#8	7.91024e-17
C495	VGND#11	a_706_317#	7.35065e-18
C496	VGND	a_1195_374##10	3.32085e-18
C497	a_706_317##10	a_580_74##3	2.05878e-17
C498	a_580_74##5	a_706_317##12	3.68344e-19
C499	VGND	a_288_48##7	1.3426e-18
C500	GCLK	a_1195_374##5	3.48173e-17
C501	GCLK	a_1195_374##7	3.26873e-17
C502	VPWR#4	VPWR#9	2.8453e-19
C503	VPWR#7	a_288_48##2	2.42406e-17
C504	GCLK	a_706_317##4	1.06303e-18
C505	VPWR#7	VNB	4.90372e-17
C506	a_288_48##8	a_288_48##6	2.73817e-19
C507	VPWR#5	VNB	3.83511e-17
C508	VPWR#4	VNB	4.93328e-17
C509	VPWR#3	VNB	2.8581e-17
C510	VGND#7	VNB	6.51646e-17
C511	VGND	a_706_317##6	1.36899e-18
C512	VGND#5	VNB	3.62121e-17
C513	VGND#4	VNB	4.97196e-17
C514	VGND	CLK#1	4.1812e-19
C515	VGND#3	VNB	3.03691e-17
C516	a_706_317##10	VPWR#5	2.40601e-19
C517	VGND	CLK#5	2.31937e-18
C518	VPWR	a_706_317##4	8.737e-18
C519	VGND	a_580_74#	2.90938e-19
C520	VPWR	CLK#4	4.70343e-18
C521	a_706_317##10	VNB	1.17179e-17
C522	VGND	a_706_317#	3.24789e-18
C523	VPWR	CLK#6	7.13044e-18
C524	VPWR	a_580_74##3	9.0699e-18
C525	VGND	a_288_48##6	2.4515e-18
C526	a_580_74##5	VNB	3.59992e-18
C527	VGND#10	CLK#2	1.68269e-18
C528	VGND	a_288_48##5	1.17732e-18
C529	VPWR	a_706_317##3	6.90839e-18
C530	a_318_74##5	VNB	1.2752e-17
C531	GCLK	VPWR#2	3.93761e-17
C532	GATE	GATE#2	6.21226e-18
C533	VGND	GATE#1	8.72706e-18
C534	VPWR	a_288_48#	1.96022e-17
C535	a_114_112##4	VNB	9.48028e-18
C536	a_580_74##6	a_706_317#	2.17487e-18
C537	VGND	SCE#3	9.10762e-18
C538	VGND#2	GCLK	2.00158e-18
C539	a_114_112##6	a_580_74##7	4.92484e-17
C540	VPWR	a_318_74##3	4.93154e-18
C541	GATE	SCE#2	2.32496e-18
C542	VPWR	a_288_48##2	1.43818e-17
C543	VGND#1	VNB	4.69854e-17
C544	GCLK#1	VNB	1.11301e-17
C545	VPWR	GATE#3	1.67862e-18
C546	VGND#9	VNB	6.22946e-18
C547	a_1195_374##8	VNB	1.29775e-17
C548	SCE	GATE#2	2.71213e-17
C549	VPWR	SCE#1	1.46331e-18
C550	GCLK	a_1195_374##4	4.63981e-17
C551	VGND#10	VNB	1.08056e-18
C552	a_288_48##8	VNB	2.10558e-17
C553	a_706_317##12	VNB	7.27485e-18
C554	GCLK	a_706_317##5	9.84606e-20
C555	SCE	SCE#2	4.24771e-17
C556	VGND#11	VNB	2.18615e-18
C557	GATE	a_114_424#	1.71373e-18
C558	a_114_112#	VNB	9.39224e-18
C559	a_318_74##6	VNB	2.64757e-18
C560	VPWR	VPWR#6	7.37245e-17
C561	a_114_112##2	VNB	1.69941e-17
C562	a_1195_374##10	VPWR#4	4.46234e-18
C563	VGND#8	VNB	6.50783e-17
C564	VPWR#1	VNB	5.75659e-17
C565	VPWR#7	GATE#3	4.90002e-18
C566	VPWR#9	VNB	5.20387e-18
C567	a_1195_374##10	VNB	4.80791e-18
C568	VPWR#10	VNB	6.2774e-18
C569	a_288_48##7	VNB	7.33138e-18
C570	VPWR	a_706_317##5	8.52643e-18
C571	a_706_317##8	VNB	1.38702e-17
C572	VPWR#11	VNB	1.14184e-17
C573	VPWR	CLK#3	4.15425e-18
C574	VGND#4	VGND#3	5.17263e-19
C575	a_580_74##7	VNB	2.64925e-18
C576	a_114_112##6	VNB	1.3051e-17
C577	VPWR	a_580_74##2	4.26182e-18
C578	VPWR#12	VNB	9.38828e-18
C579	VPWR	a_706_317##2	7.37385e-18
C580	GATE#2	a_288_48##3	1.43979e-18
C581	a_114_112##5	VNB	8.95253e-18
C582	VPWR#8	VNB	7.45047e-17
C583	VGND	VGND#6	6.90933e-17
C584	VPWR	a_318_74##2	5.24496e-18
C585	a_1195_374#	VNB	3.12554e-17
C586	a_1195_374##6	VNB	3.22954e-17
C587	VGND	a_1195_374##4	8.22865e-20
C588	a_706_317##6	VNB	3.18256e-17
C589	a_580_74##6	a_318_74#	2.39424e-17
C590	CLK#1	VNB	2.22956e-17
C591	VGND	a_706_317##5	1.0308e-17
C592	CLK#5	VNB	2.98338e-17
C593	VPWR#5	VPWR#10	3.99488e-19
C594	a_580_74#	VNB	3.18808e-17
C595	VGND	CLK#3	5.00174e-18
C596	a_706_317#	VNB	3.46297e-17
C597	a_318_74#	VNB	3.01119e-17
C598	VGND	a_580_74##2	4.44878e-18
C599	a_288_48##6	VNB	4.34843e-17
C600	a_288_48##5	VNB	4.96633e-17
C601	VGND	a_706_317##2	3.98242e-18
C602	GATE#1	VNB	3.41203e-17
C603	SCE#3	VNB	3.05774e-17
C604	VGND	a_318_74##2	5.17095e-18
C605	a_1195_374##5	VNB	4.01225e-17
C606	VGND	a_288_48##4	4.94462e-17
C607	a_1195_374##7	VNB	3.8457e-17
C608	a_706_317##4	VNB	3.6835e-17
C609	VGND	GATE#2	4.68657e-18
C610	CLK#4	VNB	3.94933e-17
C611	CLK#6	VNB	4.15054e-17
C612	VGND	SCE#2	3.39009e-19
C613	a_580_74##3	VNB	4.534e-17
C614	a_1195_374##10	VPWR#3	8.75525e-18
C615	a_706_317##3	VNB	3.44931e-17
C616	a_288_48#	VNB	9.07719e-17
C617	a_318_74##3	VNB	2.95847e-17
C618	a_288_48##2	VNB	1.12356e-16
C619	GATE#3	VNB	3.53001e-17
C620	SCE	GATE	8.40176e-18
C621	SCE#1	VNB	2.9065e-17
C622	VPWR#2	VNB	1.34378e-16
C623	VGND#2	VNB	1.3582e-16
C624	VPWR#6	VNB	3.30512e-17
C625	a_114_112##6	a_318_74##7	4.94117e-18
C626	VGND#6	VNB	4.13393e-17
C627	a_1195_374##4	VNB	7.71086e-17
C628	a_706_317##5	VNB	6.1663e-17
C629	CLK#3	VNB	3.04603e-17
C630	a_580_74##2	VNB	4.31728e-17
C631	a_706_317##2	VNB	5.71466e-17
C632	a_318_74##2	VNB	6.91322e-17
C633	a_288_48##4	VNB	4.59534e-17
C634	VPWR	GATE	8.13648e-18
C635	GATE#2	VNB	4.85817e-17
C636	SCE#2	VNB	7.92449e-17
C637	VPWR	SCE	5.72851e-18
C638	VGND	SCE	6.77819e-18
C639	a_580_74##6	a_288_48##6	2.33985e-17
C640	GATE	VNB	5.99211e-18
C641	SCE	VNB	2.72638e-17
C642	GCLK	VNB	8.05374e-18
C643	VPWR	VNB	3.06447e-16
C644	VGND	VNB	3.14694e-16
*
*
.ENDS sky130_fd_sc_hs__sdlclkp_2
*
