* Extracted by Quantus, converted by sky130cad/quantus.py
*
*
*
*                       LINUX           Wed Nov 18 08:51:24 2026
*
*
*
*  PROGRAM  advgen
*
*  Name           : advgen - Quantus - (64-bit)
*  Version        : 25.1.0-p047
*  Build Date     : Thu Dec 11 23:20:30 PST 2025
*
*  HSPICE LIBRARY
*
*  OPERATING_TEMPERATURE 150
*  QRC_TECH_DIR <path>/tech
*
*
*

*
.SUBCKT sky130_fd_sc_hs__nor4_4 VNB VPB VGND VPWR Y A D C B
*
*
*  caps2d version: 10
*
*
*       TRANSISTOR CARDS
*
*
XM3 VGND#8 D#7 Y#5 VNB sky130_fd_pr__nfet_01v8_lvt l=0.15 w=0.74 ad=0.2442 as=0.8658 pd=2.14 ps=3.82
XM22 Y#5 D#8 VGND#12 VNB sky130_fd_pr__nfet_01v8_lvt l=0.15 w=0.74 ad=0.8658 as=0.259 pd=3.82 ps=2.18
XM13 VGND#12 C#7 Y#3 VNB sky130_fd_pr__nfet_01v8_lvt l=0.15 w=0.74 ad=0.259 as=0.888 pd=2.18 ps=3.88
XM19 Y#3 C#8 VGND#11 VNB sky130_fd_pr__nfet_01v8_lvt l=0.15 w=0.74 ad=0.888 as=0.259 pd=3.88 ps=2.18
XM12 VGND#11 B#10 Y#1 VNB sky130_fd_pr__nfet_01v8_lvt l=0.15 w=0.74 ad=0.259 as=0.2072 pd=2.18 ps=2.04
XM21 Y#1 B#7 VGND#10 VNB sky130_fd_pr__nfet_01v8_lvt l=0.15 w=0.74 ad=0.2072 as=1.7242 pd=2.04 ps=6.14
XM11 Y#7 A#6 VGND#10 VNB sky130_fd_pr__nfet_01v8_lvt l=0.15 w=0.74 ad=0.5254 as=1.7242 pd=2.9 ps=6.14
XM4 VGND#9 A#4 Y#7 VNB sky130_fd_pr__nfet_01v8_lvt l=0.15 w=0.74 ad=0.2109 as=0.5254 pd=2.05 ps=2.9
XM17 a_27_368##6 D#11 Y#10 VPB sky130_fd_pr__pfet_01v8 l=0.15 w=1.12 ad=0.3864 as=0.336 pd=2.93 ps=2.84
XM23 a_27_368##8 D#10 Y#10 VPB sky130_fd_pr__pfet_01v8 l=0.15 w=1.12 ad=0.336 as=0.336 pd=2.84 ps=2.84
XM9 Y#11 D#9 a_27_368##8 VPB sky130_fd_pr__pfet_01v8 l=0.15 w=1.12 ad=0.392 as=0.336 pd=2.94 ps=2.84
XM0 Y#11 D#1 a_27_368##3 VPB sky130_fd_pr__pfet_01v8 l=0.15 w=1.12 ad=0.392 as=0.336 pd=2.94 ps=2.84
XM2 a_496_368##4 C#11 a_27_368##3 VPB sky130_fd_pr__pfet_01v8 l=0.15 w=1.12 ad=0.336 as=0.336 pd=2.84 ps=2.84
XM16 a_27_368##7 C#10 a_496_368##4 VPB sky130_fd_pr__pfet_01v8 l=0.15 w=1.12 ad=0.336 as=0.336 pd=2.84 ps=2.84
XM14 a_27_368##7 C#9 a_496_368##6 VPB sky130_fd_pr__pfet_01v8 l=0.15 w=1.12 ad=0.336 as=0.336 pd=2.84 ps=2.84
XM6 a_496_368##6 C#1 a_27_368# VPB sky130_fd_pr__pfet_01v8 l=0.15 w=1.12 ad=0.336 as=0.3304 pd=2.84 ps=2.83
XM10 a_496_368##5 B#9 a_879_368##5 VPB sky130_fd_pr__pfet_01v8 l=0.15 w=1.12 ad=0.336 as=0.3304 pd=2.84 ps=2.83
XM7 a_496_368##5 B#8 a_879_368##8 VPB sky130_fd_pr__pfet_01v8 l=0.15 w=1.12 ad=0.336 as=0.3584 pd=2.84 ps=2.88
XM18 a_879_368##8 B#4 a_496_368# VPB sky130_fd_pr__pfet_01v8 l=0.15 w=1.12 ad=0.3584 as=0.336 pd=2.88 ps=2.84
XM8 a_879_368##7 B#1 a_496_368# VPB sky130_fd_pr__pfet_01v8 l=0.15 w=1.12 ad=0.336 as=0.336 pd=2.84 ps=2.84
XM5 a_879_368##7 A#8 VPWR#5 VPB sky130_fd_pr__pfet_01v8 l=0.15 w=1.12 ad=0.336 as=0.448 pd=2.84 ps=3.04
XM20 a_879_368##6 A#9 VPWR#5 VPB sky130_fd_pr__pfet_01v8 l=0.15 w=1.12 ad=0.336 as=0.448 pd=2.84 ps=3.04
XM1 VPWR#3 A#7 a_879_368##6 VPB sky130_fd_pr__pfet_01v8 l=0.15 w=1.12 ad=0.448 as=0.336 pd=3.04 ps=2.84
XM15 VPWR#3 A#1 a_879_368# VPB sky130_fd_pr__pfet_01v8 l=0.15 w=1.12 ad=0.448 as=0.3304 pd=3.04 ps=2.83
*
*
*       RESISTOR AND CAP/DIODE CARDS
*
Rg1	D#1	D#2	442.110962
Rg2	D#2	D#3	67.480652
Rg3	D#3	D#4	46.379230
Rg4	D#4	D#5	34.566891
Rg5	D#5	D#6	67.149261
Rg6	D#6	D#7	397.555725
Rg7	D#2	D#8	407.781006
Rg8	D#3	D#9	419.554810
Rg9	D#5	D#10	419.554810
Rg10	D#6	D#11	449.655212
Rg11	C#1	C#2	511.438293
Rg12	C#2	C#3	67.132561
Rg13	C#3	C#4	34.566891
Rg14	C#4	C#5	46.379230
Rg15	C#5	C#6	67.149261
Rg16	C#6	C#7	394.956482
Rg17	C#2	C#8	464.867432
Rg18	C#3	C#9	419.554810
Rg19	C#5	C#10	419.554810
Rg20	C#6	C#11	449.259979
Rg21	B#1	B#2	502.825806
Rg22	B#2	B#3	96.325157
Rg23	B#2	B#4	419.554810
Rg24	B#3	B#5	71.972641
Rg25	B#5	B#6	22.529716
Rg26	B#6	B#7	381.948395
Rg27	B#3	B#8	429.126801
Rg28	B#5	B#9	419.554810
Rg29	B#6	B#10	458.118439
Rg30	A#1	A#2	468.886597
Rg31	A#2	A#3	76.617599
Rg32	A#2	A#4	343.169220
Rg33	A#3	A#5	79.820198
Rg34	A#5	A#6	365.868195
Rg35	A#3	A#7	451.334412
Rg36	A#5	A#8	707.859619
Rg37	A#5	A#9	468.868408
Rf3	C	C#12	0.305603
Rf4	C#12	C	14.363330
Rf5	a_27_368#	a_27_368##2	86.318230
Rf6	a_27_368##2	a_27_368##4	87.703056
Rf7	a_27_368##4	a_27_368##5	104.844994
Rf8	a_27_368##5	a_27_368##6	87.286743
Rf9	a_27_368##2	a_27_368##7	18.050163
Rf10	a_27_368##5	a_27_368##8	21.341251
Rf11	a_27_368##3	a_27_368##4	5.000000
Rf12	a_496_368#	a_496_368##2	83.053207
Rf13	a_496_368##2	a_496_368##3	106.604660
Rf14	a_496_368##3	a_496_368##4	82.229538
Rf15	a_496_368##2	a_496_368##5	19.527714
Rf16	a_496_368##3	a_496_368##6	19.724552
Rf17	B	B#11	3.361630
Rf18	B#11	B	11.307302
Rf19	Y#1	Y#2	18.148846
Rf20	Y#2	Y#4	71.244041
Rf21	Y#4	Y#6	77.652451
Rf22	Y#6	Y	52.683521
Rf23	Y#2	Y#8	229.619003
Rf24	Y#8	Y#7	16.168768
Rf25	Y	Y#9	74.985504
Rf26	Y#9	Y#10	16.279915
Rf27	Y#9	Y#11	82.437431
Rf28	Y#3	Y#4	2.500000
Rf29	Y#5	Y#6	2.500000
Rf30	Y#7	Y#8	7.500000
Rf31	A	A#3	72.409706
Rf32	a_879_368#	a_879_368##2	84.631958
Rf33	a_879_368##2	a_879_368##3	70.851311
Rf34	a_879_368##3	a_879_368##4	68.742073
Rf35	a_879_368##4	a_879_368##5	85.293617
Rf36	a_879_368##2	a_879_368##6	17.027714
Rf37	a_879_368##3	a_879_368##7	19.542492
Rf38	a_879_368##4	a_879_368##8	18.050163
Rf40	VGND#2	VGND#3	37.596474
Rf41	VGND#3	VGND#4	132.749924
Rf42	VGND#4	VGND#5	149.161758
Rf43	VGND#5	VGND#6	41.248997
Rf44	VGND#6	VGND#7	93.845360
Rf45	VGND#7	VGND#8	167.248718
Rf46	VGND#2	VGND#9	32.518913
Rf47	VGND#4	VGND#10	5.672978
Rf48	VGND#5	VGND#11	38.247387
Rf49	VGND#7	VGND#12	38.247387
Rf51	VPWR#2	VPWR#3	36.607323
Rf52	VPWR#2	VPWR#4	59.876873
Rf53	VPWR#4	VPWR#5	33.109421
Rf54	VPWR#4	VPWR#6	255.652206
Rf55	D#4	D	40.058201
Rf56	C#4	C#12	40.058201
Rf57	B#3	B#11	26.705467
Re1	VPWR#2	VPWR	3.735117
Re2	VPWR	VPWR#6	1.067176
Re3	VGND#3	VGND	3.735117
Re4	VGND	VGND#6	1.067176
*
*       CAPACITOR CARDS
*
*
C1	VPWR#5	VPWR#3	1.69608e-18
C2	a_879_368##3	a_879_368##2	2.53598e-20
C3	a_27_368##5	a_27_368##8	5.24145e-20
C4	VGND#7	D#8	5.13439e-18
C5	C#5	C#2	8.81379e-19
C6	VGND#5	D#8	1.31531e-19
C7	VPWR#5	a_879_368##6	6.22435e-17
C8	C#2	B#10	2.23578e-17
C9	a_27_368##5	Y#10	2.51107e-19
C10	Y#3	a_27_368#	3.09303e-18
C11	VGND#7	D#7	4.28258e-19
C12	Y#5	D#6	1.98655e-18
C13	a_879_368##7	a_879_368##6	1.77519e-18
C14	VGND#5	Y#2	2.25448e-19
C15	VPWR#3	A#2	8.32487e-19
C16	VGND#3	A#5	3.47941e-20
C17	VGND#12	D#2	4.57491e-19
C18	VGND#3	A#2	1.19713e-19
C19	Y#5	D#5	1.6502e-17
C20	a_879_368##7	VPWR#5	6.14737e-17
C21	VGND#4	Y#2	9.65628e-17
C22	Y#2	B#7	2.84822e-17
C23	a_496_368#	VPWR#5	3.49673e-18
C24	VGND#8	D#6	4.76064e-20
C25	a_496_368#	a_879_368##7	5.87767e-17
C26	Y#2	B#10	1.83555e-17
C27	Y#5	D#2	1.81484e-18
C28	VGND#8	D#5	8.25064e-20
C29	VPWR#6	B#6	4.9191e-20
C30	a_879_368##8	a_879_368##7	1.81509e-18
C31	Y#3	a_27_368##3	1.0948e-17
C32	Y#2	C#8	2.45371e-20
C33	a_496_368##3	B#10	8.10265e-19
C34	VPWR#6	B#2	3.61872e-20
C35	VPWR#4	A#9	2.5854e-18
C36	VPWR#6	C#6	1.13558e-20
C37	a_496_368#	a_879_368##8	4.93651e-17
C38	VPWR#5	A#5	1.04011e-18
C39	a_496_368##2	B#10	2.71691e-19
C40	VPWR#6	C#5	4.51204e-20
C41	Y#2	C#7	2.22388e-21
C42	Y#5	a_27_368##3	3.39516e-18
C43	VPWR#6	C#2	1.09861e-20
C44	VGND#9	A#4	3.41498e-17
C45	a_496_368##5	a_496_368#	4.87409e-18
C46	VPWR#6	D#6	1.13558e-20
C47	VPWR#6	D#5	4.28493e-20
C48	A#4	Y#7	2.6868e-17
C49	a_496_368##5	a_879_368##8	3.67678e-17
C50	Y#5	Y#11	8.31495e-19
C51	VGND#9	A#6	3.22275e-18
C52	VPWR#6	D#2	2.06361e-20
C53	D#2	C#6	3.16107e-17
C54	a_879_368##2	A#1	8.42228e-21
C55	a_879_368##5	a_879_368##8	3.14841e-18
C56	Y#7	A#6	4.64064e-17
C57	VGND#6	C#5	3.43183e-19
C58	Y#9	D#6	1.24256e-18
C59	A#6	VGND#10	2.78473e-17
C60	a_879_368##5	a_496_368##5	4.28487e-17
C61	VGND#6	C#2	1.99493e-20
C62	VGND#4	A#8	1.46654e-18
C63	a_879_368##2	A#7	2.37392e-17
C64	A#3	A#5	2.22356e-17
C65	a_879_368##3	A#9	1.5234e-19
C66	Y#9	D#5	2.6659e-18
C67	A#3	A#2	1.82797e-18
C68	B#7	VGND#10	1.37132e-17
C69	a_879_368##4	a_496_368##2	2.97246e-18
C70	a_879_368##2	A#9	2.38771e-17
C71	Y#2	B#6	5.91834e-18
C72	VGND#4	B#1	1.49843e-18
C73	Y#1	B#7	3.87477e-17
C74	a_27_368#	a_879_368##5	5.84934e-17
C75	a_496_368##6	a_496_368##5	2.49247e-18
C76	VGND#8	a_27_368##6	1.67211e-19
C77	a_879_368##3	A#8	2.21642e-17
C78	VGND#11	B#7	4.79578e-19
C79	a_879_368##2	A#8	5.14339e-21
C80	Y#1	B#10	3.32726e-17
C81	B#3	A#5	3.12729e-18
C82	B#10	VGND#11	1.6225e-17
C83	a_27_368#	a_496_368##6	4.31712e-17
C84	a_879_368##3	B#1	1.5518e-17
C85	B#3	A#2	1.89832e-19
C86	D#6	D#5	8.80869e-19
C87	Y#1	C#8	1.90872e-18
C88	B#3	B#6	2.53433e-17
C89	Y#2	B#2	5.80458e-18
C90	Y#3	B#10	4.29233e-19
C91	a_27_368##7	a_27_368#	2.97259e-18
C92	B#3	B#2	2.16088e-17
C93	a_879_368##4	B#4	1.27114e-17
C94	VGND#11	C#8	3.24083e-17
C95	Y#1	C#7	1.03633e-19
C96	a_879_368##3	B#4	2.74225e-19
C97	Y#3	C#8	3.37391e-17
C98	a_27_368##7	a_496_368##6	3.94729e-17
C99	VGND#11	C#7	1.68519e-19
C100	a_879_368##4	B#8	1.46931e-17
C101	VGND#12	C#8	2.44287e-19
C102	VGND#4	VGND#9	1.30328e-18
C103	B#2	a_496_368#	1.31131e-18
C104	a_496_368##4	a_496_368##6	5.01824e-18
C105	a_27_368##3	a_27_368#	4.6216e-21
C106	Y#3	C#7	7.73712e-17
C107	a_879_368##3	B#8	1.18197e-19
C108	VGND#11	D#8	1.10203e-19
C109	a_496_368##4	a_27_368##7	5.12865e-17
C110	C#7	VGND#12	1.74068e-17
C111	Y#9	a_27_368##5	1.43054e-17
C112	Y#3	D#8	1.51882e-18
C113	VGND#4	Y#7	1.55167e-16
C114	Y#5	C#7	6.68859e-19
C115	a_27_368##3	a_27_368##7	2.87994e-18
C116	VGND#12	D#8	3.23526e-17
C117	Y#3	D#7	1.33947e-19
C118	a_27_368##3	a_496_368##4	6.51173e-17
C119	Y#5	D#8	4.20005e-17
C120	B#2	a_879_368##8	3.07002e-19
C121	VGND#4	VGND#10	4.98799e-17
C122	VGND#12	D#7	3.13879e-19
C123	VGND#8	D#8	5.93015e-19
C124	VGND#5	Y#1	8.48245e-18
C125	D#6	D#2	5.77736e-19
C126	Y#5	D#7	6.20188e-17
C127	B#6	a_496_368##5	1.51271e-19
C128	a_496_368##2	B#6	6.91124e-19
C129	Y#11	a_27_368##3	6.25073e-17
C130	D#7	VGND#8	2.81299e-17
C131	VGND#4	Y#1	5.41743e-17
C132	a_27_368##8	a_27_368##3	3.73701e-18
C133	VGND#7	Y#3	1.75801e-17
C134	a_496_368##2	B#8	2.08737e-17
C135	A#8	A#5	1.86036e-18
C136	Y#7	A#8	5.06093e-18
C137	Y#11	a_27_368##8	5.07023e-17
C138	VGND#11	VGND#4	1.70141e-18
C139	D#5	D#2	7.05493e-19
C140	Y#7	a_879_368##3	5.12825e-18
C141	a_496_368##3	C#5	8.46999e-20
C142	VGND#5	Y#3	3.77957e-19
C143	a_27_368##3	a_27_368##6	2.58965e-21
C144	a_496_368##2	B#9	2.66448e-17
C145	Y#7	B#1	3.77135e-18
C146	B#6	a_879_368##5	6.03381e-18
C147	a_879_368#	A#1	6.16677e-17
C148	a_27_368#	B#10	2.71222e-18
C149	Y#7	a_879_368##2	3.655e-18
C150	a_496_368##3	C#1	2.61208e-17
C151	A#1	VPWR#3	3.55674e-17
C152	a_879_368#	A#7	1.31766e-18
C153	a_27_368##6	a_27_368##8	3.90094e-18
C154	VGND#7	Y#5	3.95105e-17
C155	a_879_368##6	A#1	8.42228e-19
C156	B#1	A#5	1.065e-18
C157	A#7	VPWR#3	3.67823e-17
C158	Y#9	C#11	1.52096e-19
C159	a_496_368##3	C#9	2.02756e-17
C160	VPWR#5	A#1	6.16532e-19
C161	a_27_368##6	Y#10	3.8487e-19
C162	a_879_368#	A#9	2.38093e-19
C163	a_879_368##6	A#7	5.36956e-17
C164	VPWR#3	A#9	1.34947e-18
C165	VGND#8	VGND#7	8.43364e-20
C166	VPWR#5	A#7	1.25159e-18
C167	Y#9	D#1	3.43419e-19
C168	a_879_368#	A#8	1.43971e-19
C169	a_879_368##6	A#9	4.61676e-17
C170	A#5	A#2	3.52222e-19
C171	B#2	B#1	8.81379e-19
C172	VPWR#3	A#8	2.8528e-19
C173	a_27_368##2	C#9	1.4079e-17
C174	A#9	VPWR#5	3.20987e-17
C175	a_879_368#	B#1	1.60117e-19
C176	a_879_368##6	A#8	5.09195e-19
C177	a_27_368##2	a_496_368##3	2.82531e-18
C178	a_879_368##7	A#9	3.55459e-19
C179	Y#9	D#9	2.00225e-18
C180	A#8	VPWR#5	3.6338e-17
C181	a_27_368##2	C#10	1.1954e-17
C182	a_496_368#	A#9	4.76894e-19
C183	A#6	A#4	7.21753e-18
C184	a_879_368##6	VPWR#4	5.56197e-18
C185	a_879_368##7	A#8	5.19202e-17
C186	VPWR#4	A#5	1.52371e-20
C187	VPWR#5	B#1	9.38177e-19
C188	Y#9	D#10	3.39261e-17
C189	a_496_368#	A#8	2.07857e-18
C190	B#1	a_879_368##7	1.86795e-17
C191	a_27_368##5	D#1	9.8157e-18
C192	a_879_368##8	A#8	2.49978e-19
C193	VPWR#5	B#4	2.11221e-19
C194	a_496_368#	B#1	5.26714e-17
C195	Y#9	D#11	3.66587e-17
C196	a_879_368##7	B#4	3.48222e-19
C197	a_879_368##8	B#1	5.84964e-19
C198	a_27_368##5	D#9	1.62924e-17
C199	VPWR#5	B#8	7.00996e-20
C200	a_496_368#	B#4	5.55141e-17
C201	B#10	B#7	3.90255e-17
C202	a_879_368##7	B#8	1.50091e-19
C203	B#4	a_879_368##8	2.48252e-17
C204	Y#2	VGND#10	4.79396e-18
C205	VPWR#5	B#9	4.3135e-20
C206	a_496_368#	B#8	1.60561e-18
C207	a_496_368##5	B#4	2.00006e-18
C208	a_27_368##5	D#10	1.57331e-17
C209	VGND#3	VGND#4	6.59139e-17
C210	C#5	a_496_368##6	5.91569e-19
C211	B#8	a_879_368##8	2.83801e-17
C212	C#8	B#10	2.4822e-17
C213	a_27_368##2	C#6	9.05954e-19
C214	a_879_368##5	B#4	2.57386e-19
C215	Y#2	Y#1	9.65385e-20
C216	a_496_368##5	B#8	4.40172e-17
C217	a_27_368##5	D#5	1.36207e-19
C218	a_879_368##8	B#9	1.02063e-18
C219	a_879_368##5	B#8	5.77301e-19
C220	a_27_368##2	C#5	4.16968e-18
C221	C#7	C#8	1.59775e-18
C222	a_496_368##5	B#9	3.97428e-17
C223	Y#5	Y#9	1.11533e-18
C224	C#2	a_496_368##6	5.68598e-19
C225	Y#2	VGND#11	1.76529e-17
C226	a_879_368##8	C#1	8.84987e-20
C227	a_879_368##5	B#9	5.18681e-17
C228	a_879_368##2	a_879_368#	2.58831e-20
C229	a_496_368##5	C#1	6.78366e-19
C230	a_27_368#	B#9	1.36796e-18
C231	a_879_368##3	VPWR#6	7.30143e-19
C232	C#5	a_27_368##7	5.48219e-19
C233	D#8	C#7	2.4958e-17
C234	B	C#2	9.8598e-18
C235	a_879_368##5	C#1	1.35826e-18
C236	a_496_368##6	B#9	6.78366e-19
C237	a_27_368##5	D#2	1.44781e-19
C238	Y#3	Y#2	7.35468e-20
C239	a_27_368#	C#1	5.89207e-17
C240	a_27_368##7	B#9	8.17043e-20
C241	a_879_368##2	VPWR#3	2.16912e-17
C242	a_27_368##2	C#2	8.60074e-19
C243	a_496_368##6	C#1	4.43464e-17
C244	VGND#9	A#2	9.3306e-19
C245	a_879_368##3	a_879_368##6	7.35434e-19
C246	D#7	D#8	2.69888e-18
C247	VGND#4	A#3	7.04779e-21
C248	a_27_368#	C#9	5.3658e-19
C249	a_27_368##7	C#1	9.72103e-19
C250	C#6	a_496_368##4	5.91569e-19
C251	a_496_368##6	C#9	3.92801e-17
C252	a_879_368##2	a_879_368##6	8.10962e-19
C253	a_27_368#	C#10	2.39543e-19
C254	C#9	a_27_368##7	2.40871e-17
C255	C	C#6	7.13362e-18
C256	a_27_368##3	C#1	1.89404e-19
C257	a_496_368##3	VPWR#6	8.21259e-17
C258	C	C#5	3.29603e-17
C259	a_879_368##3	VPWR#5	1.61852e-17
C260	C#5	a_496_368##4	6.69526e-19
C261	a_496_368##6	C#10	2.04373e-18
C262	C	C#2	1.32365e-17
C263	A#3	a_879_368##2	4.0366e-17
C264	a_496_368##2	VPWR#6	8.28548e-17
C265	a_496_368##4	C#9	1.64723e-18
C266	Y#7	A#5	6.01012e-18
C267	VGND#4	B#3	2.42212e-18
C268	a_27_368##5	VPWR#6	8.07512e-17
C269	C#10	a_27_368##7	2.74698e-17
C270	a_27_368##3	C#9	4.27111e-19
C271	C	D#2	6.49512e-18
C272	VGND#3	VGND#9	2.23093e-17
C273	a_879_368##2	VPWR#5	1.59795e-17
C274	a_496_368##4	C#10	6.00767e-17
C275	B#3	a_879_368##4	8.36633e-17
C276	VGND#3	Y#7	5.92717e-17
C277	B#3	a_879_368##3	6.40494e-17
C278	a_879_368##3	a_879_368##7	1.6675e-18
C279	A#2	Y#7	6.70622e-19
C280	a_27_368##7	C#11	5.67627e-19
C281	a_27_368##3	C#10	8.79006e-19
C282	a_879_368##4	a_496_368#	1.34543e-17
C283	a_496_368##4	C#11	4.55803e-17
C284	a_27_368##7	D#1	2.3796e-19
C285	a_27_368##3	C#11	3.57043e-17
C286	A#7	A#1	3.16415e-17
C287	D	C#6	5.42252e-18
C288	VGND#4	A#5	1.04038e-18
C289	VGND#5	B#6	5.39539e-20
C290	a_496_368##4	D#1	1.61392e-18
C291	Y#11	C#11	1.5437e-18
C292	a_879_368##3	a_496_368#	1.40254e-17
C293	Y#7	VGND#9	6.12033e-17
C294	D	D#6	1.18537e-17
C295	a_27_368##3	D#1	3.66054e-17
C296	Y#2	B#3	1.36942e-16
C297	a_27_368##8	C#11	3.11421e-19
C298	D	D#5	3.2416e-17
C299	a_879_368##4	a_879_368##8	2.90575e-18
C300	D	D#2	1.25231e-17
C301	A#9	A#7	4.72838e-17
C302	Y#11	D#1	5.74246e-17
C303	B#3	a_496_368##3	1.75332e-18
C304	VGND#3	a_879_368#	5.00092e-18
C305	a_27_368##3	D#9	9.81008e-19
C306	B#3	a_496_368##2	1.88993e-18
C307	a_27_368##8	D#1	1.47478e-18
C308	a_879_368##8	a_879_368##3	1.42938e-18
C309	VGND#7	C#6	6.01444e-20
C310	Y#11	D#9	3.41785e-17
C311	A#3	Y#7	8.33711e-17
C312	A#8	A#9	3.19077e-17
C313	VGND#6	Y#3	4.21255e-17
C314	a_879_368##4	a_496_368##5	1.99229e-17
C315	a_27_368##8	D#9	4.47684e-17
C316	a_27_368##3	D#10	2.00892e-19
C317	Y#7	B#2	9.15376e-19
C318	A	A#5	4.12424e-19
C319	A	A#2	2.6594e-17
C320	Y#7	VGND#10	6.97367e-18
C321	Y#11	D#10	4.50208e-19
C322	D#10	a_27_368##8	2.14275e-17
C323	a_27_368##6	D#9	3.28804e-19
C324	VGND#4	B#6	7.42823e-19
C325	a_27_368##3	D#11	2.14896e-19
C326	B#1	A#8	6.33909e-17
C327	Y#7	B#3	4.79417e-17
C328	VGND#7	C#5	5.73543e-20
C329	D#10	Y#10	2.35577e-17
C330	a_879_368##7	VPWR#6	1.46868e-17
C331	a_27_368##6	D#10	1.43044e-18
C332	a_27_368##8	D#11	1.34445e-18
C333	a_496_368#	VPWR#6	4.55117e-17
C334	D#11	Y#10	2.42165e-17
C335	B#4	B#1	4.61205e-17
C336	a_27_368##6	D#11	3.75451e-17
C337	A#3	VPWR#3	6.92295e-19
C338	Y#1	VGND#10	4.14045e-18
C339	A#3	a_879_368##6	2.35532e-18
C340	B#8	B#4	4.23763e-17
C341	VGND#7	VGND#5	6.68319e-20
C342	Y	C#6	2.61991e-19
C343	VGND#4	B#2	2.53608e-18
C344	a_496_368##4	VPWR#6	4.92349e-17
C345	Y	D#6	1.59826e-17
C346	a_27_368##3	VPWR#6	2.85142e-17
C347	D#5	Y#11	1.39178e-18
C348	Y	D#2	1.84346e-19
C349	B#9	B#8	4.61457e-17
C350	B#3	a_879_368##8	3.10657e-19
C351	VGND#11	Y#1	4.526e-17
C352	VGND#3	A#4	3.47095e-19
C353	B#3	a_496_368##5	9.94163e-19
C354	C#1	B#9	4.80127e-18
C355	VGND#3	A#6	4.45735e-19
C356	B#3	a_879_368##5	5.52908e-17
C357	a_27_368##6	VPWR#6	5.55973e-17
C358	D#2	Y#11	2.54646e-18
C359	Y#3	Y#1	3.42728e-18
C360	C#9	C#1	4.60539e-17
C361	VGND#5	VGND#4	1.98212e-18
C362	VPWR#6	B#10	3.69443e-20
C363	D#5	a_27_368##8	1.17883e-18
C364	Y#3	VGND#11	6.38003e-17
C365	C#10	C#9	4.66783e-17
C366	VGND#7	D#5	3.11249e-19
C367	Y#2	B	1.4707e-17
C368	B	a_496_368##3	3.93122e-20
C369	C#11	C#10	4.60957e-17
C370	VGND#12	VGND#11	5.28052e-19
C371	B#3	B#10	6.59385e-18
C372	a_496_368##2	a_879_368##8	1.18357e-17
C373	D#1	C#11	4.63994e-17
C374	D#6	Y#10	2.74109e-19
C375	Y#3	VGND#12	6.24203e-17
C376	VPWR#6	A#8	2.6852e-18
C377	a_879_368##3	A#5	2.23966e-18
C378	a_879_368##2	VPWR#4	1.6661e-19
C379	Y#9	D	7.12112e-17
C380	C	a_27_368##2	9.08077e-17
C381	D#9	D#1	3.36806e-17
C382	D#5	Y#10	2.70455e-19
C383	VPWR#6	B#1	4.52581e-18
C384	Y#2	a_27_368#	9.64704e-19
C385	C#2	B#6	1.15453e-19
C386	a_496_368##2	a_496_368##5	4.35239e-20
C387	VPWR#6	B#4	4.4526e-18
C388	VGND#7	D#2	2.67502e-20
C389	B#3	A#1	4.48695e-19
C390	Y#5	Y#3	3.3845e-18
C391	VPWR#6	B#8	4.4526e-18
C392	D#10	D#9	4.42364e-17
C393	B#3	A#7	4.92381e-19
C394	VPWR#6	B#9	4.4526e-18
C395	A	a_879_368##2	7.57682e-18
C396	Y#3	C	1.27591e-16
C397	A#3	B#1	1.46991e-18
C398	B#3	A#9	1.02365e-18
C399	VPWR#6	C#1	4.464e-18
C400	B#3	A#8	2.06852e-17
C401	VPWR#6	C#9	4.4526e-18
C402	D#11	D#10	4.58475e-17
C403	a_496_368##2	a_879_368##5	3.51437e-17
C404	B#3	B#1	1.66375e-17
C405	Y#5	VGND#12	6.70919e-17
C406	VPWR#6	C#10	4.4526e-18
C407	B#3	B#4	2.10672e-18
C408	a_496_368##3	a_27_368#	3.54985e-17
C409	a_27_368##6	D#6	8.58444e-20
C410	B	a_27_368#	2.38452e-17
C411	Y#9	a_27_368##3	4.01117e-22
C412	B#3	B#8	2.10672e-18
C413	VPWR#6	C#11	5.13866e-18
C414	Y#5	D	1.28973e-16
C415	B#3	B#9	2.12556e-18
C416	VPWR#6	D#1	4.45873e-18
C417	a_879_368##4	B#2	2.20287e-18
C418	Y	Y#9	5.89007e-19
C419	VGND#9	A	4.78213e-17
C420	VGND#8	VGND#12	5.50614e-19
C421	a_879_368##2	A#5	3.30446e-18
C422	a_27_368##6	D#5	1.60243e-20
C423	VPWR#6	D#9	4.4526e-18
C424	A	Y#7	2.27288e-17
C425	C#6	C#5	8.81379e-19
C426	C	a_27_368#	2.004e-17
C427	Y#3	C#6	2.49609e-18
C428	VPWR#6	D#10	4.4526e-18
C429	VPWR	VPWR#4	1.44562e-18
C430	a_496_368##3	a_496_368##6	4.35239e-20
C431	VPWR#6	D#11	4.46413e-18
C432	C	a_27_368##3	1.28334e-17
C433	Y#9	Y#11	2.7787e-18
C434	A	a_879_368#	4.44694e-17
C435	VGND#4	A#4	1.29775e-18
C436	VPWR	a_879_368##4	3.15049e-18
C437	Y#5	VGND#8	6.64519e-17
C438	VPWR	a_879_368##3	2.65761e-18
C439	A	VPWR#3	3.49346e-18
C440	B	B#10	3.75671e-18
C441	Y#3	C#5	1.67858e-17
C442	VPWR	Y#9	1.39066e-17
C443	a_879_368##2	A#2	1.52953e-18
C444	D	Y#11	5.18148e-17
C445	a_496_368##3	a_27_368##7	1.25658e-17
C446	VPWR	a_496_368##3	3.33039e-17
C447	VPWR	a_496_368##2	3.31187e-17
C448	C	B#10	5.39204e-18
C449	Y	VGND#8	3.38509e-17
C450	VPWR	a_27_368##5	3.55106e-17
C451	VPWR	a_27_368##2	3.62117e-18
C452	Y#9	a_27_368##8	4.87426e-17
C453	VGND	VGND#7	1.26452e-16
C454	VGND	VGND#5	7.25226e-17
C455	VGND	VGND#4	2.56136e-16
C456	VGND#3	A#3	4.13856e-18
C457	A#5	VNB	3.42272e-17
C458	A#2	VNB	3.81567e-17
C459	B#6	VNB	4.50684e-17
C460	B#2	VNB	3.85364e-17
C461	C#6	VNB	2.87868e-17
C462	VGND#4	A#6	3.02065e-17
C463	C#5	VNB	6.49215e-17
C464	C#2	VNB	2.23474e-17
C465	D#6	VNB	3.61591e-17
C466	D#5	VNB	6.39252e-17
C467	D#2	VNB	2.57029e-17
C468	a_879_368##3	B#2	9.8447e-19
C469	VPWR#6	B#3	3.24776e-20
C470	VGND	Y#2	9.05637e-18
C471	A	A#4	2.79844e-18
C472	A	A#6	1.74487e-18
C473	VGND#5	B#7	1.02372e-18
C474	VPWR	a_879_368##7	1.54382e-17
C475	B	C#1	1.04626e-18
C476	B#3	A#3	1.732e-17
C477	VPWR	a_496_368#	2.4262e-17
C478	Y#3	C#2	8.32459e-19
C479	Y#9	Y#10	6.16604e-19
C480	VPWR	a_879_368##8	7.05184e-18
C481	VGND	Y#7	6.16266e-18
C482	VPWR	a_879_368##5	9.27456e-18
C483	VGND	Y#1	1.6766e-17
C484	VPWR	a_27_368#	9.33118e-18
C485	VGND	Y#3	5.06574e-17
C486	C	C#1	2.42976e-18
C487	VPWR	a_27_368##7	7.05184e-18
C488	VGND	Y#5	4.87037e-17
C489	VGND#4	B#7	1.55343e-17
C490	VPWR	a_496_368##4	2.35191e-17
C491	C	C#9	2.09146e-18
C492	a_27_368##2	a_496_368##6	2.14193e-17
C493	VGND	VGND#8	8.76213e-17
C494	VPWR	a_27_368##3	1.43206e-17
C495	C	C#10	2.1032e-18
C496	VPWR	Y#11	9.60098e-18
C497	C	C#11	1.85959e-18
C498	VPWR	a_27_368##6	2.60855e-17
C499	C	D#1	4.15196e-19
C500	D	C#11	3.51373e-19
C501	VGND#5	B#10	5.74923e-18
C502	D	D#1	1.36218e-19
C503	Y#9	a_27_368##6	9.38371e-17
C504	VGND	a_27_368##3	3.65392e-18
C505	D	D#9	2.09784e-18
C506	D	D#10	2.06457e-18
C507	VPWR#4	VNB	2.13956e-17
C508	VGND#7	VNB	5.90733e-17
C509	VGND#5	VNB	2.64765e-17
C510	D	D#11	1.71657e-18
C511	a_27_368##2	a_27_368##7	2.82735e-18
C512	a_879_368#	VPWR#3	7.34417e-17
C513	VGND#4	VNB	1.02128e-16
C514	VGND	B#10	1.48572e-19
C515	VPWR	A#8	3.32586e-19
C516	Y#9	VNB	2.11767e-17
C517	VGND	C#8	4.14951e-19
C518	VGND#4	B#10	1.00372e-18
C519	VPWR	B#1	2.14426e-18
C520	VGND	C#7	3.36394e-19
C521	B#10	B#6	3.15868e-18
C522	VPWR	B#4	1.4962e-18
C523	VGND#7	C#8	3.47502e-19
C524	Y#2	VNB	4.06085e-18
C525	VGND	D#8	6.51495e-19
C526	VPWR	B#8	1.64335e-18
C527	a_496_368##3	VNB	9.00609e-18
C528	VGND	D#7	6.04326e-19
C529	a_496_368##2	VNB	9.07115e-18
C530	a_27_368##5	VNB	5.81471e-18
C531	VPWR	B#9	1.67281e-18
C532	VPWR	C#1	1.67279e-18
C533	VGND#9	VNB	3.29269e-17
C534	VPWR	C#9	1.64171e-18
C535	Y#7	VNB	1.21543e-17
C536	C#6	C#2	5.23317e-19
C537	VGND#3	A	8.06069e-18
C538	VPWR	C#10	1.57704e-18
C539	Y#1	VNB	2.025e-18
C540	VGND#11	VNB	3.82765e-19
C541	Y#3	VNB	1.44915e-17
C542	VPWR	C#11	2.65696e-18
C543	VGND#12	VNB	3.99437e-19
C544	Y#5	VNB	1.28346e-17
C545	VPWR	D#1	1.68086e-18
C546	VGND#8	VNB	6.8378e-17
C547	a_879_368#	VNB	5.72359e-17
C548	VPWR#3	VNB	3.77786e-18
C549	VPWR	D#9	1.5808e-18
C550	a_879_368##6	VNB	2.1429e-18
C551	VPWR#5	VNB	4.04508e-18
C552	A	A#3	8.99239e-19
C553	VPWR	D#10	1.64174e-18
C554	VGND#5	C#8	7.9946e-18
C555	a_879_368##6	a_879_368#	2.58831e-18
C556	a_879_368##7	VNB	2.38306e-18
C557	a_496_368#	VNB	3.23811e-18
C558	VPWR	D#11	2.46614e-18
C559	a_879_368##5	VNB	8.01433e-18
C560	a_27_368#	VNB	7.04403e-18
C561	a_27_368##2	a_496_368##4	2.4638e-17
C562	a_496_368##4	VNB	3.1856e-18
C563	a_27_368##3	VNB	6.34079e-18
C564	VPWR	VPWR#6	3.57412e-16
C565	a_27_368##6	VNB	4.18609e-17
C566	A#4	VNB	3.33171e-17
C567	A#6	VNB	2.98365e-17
C568	B#7	VNB	3.2002e-17
C569	B#10	VNB	5.18121e-17
C570	C	B	4.28951e-17
C571	C#8	VNB	3.19345e-17
C572	C#7	VNB	3.12774e-17
C573	VPWR	B#3	1.73436e-17
C574	D#8	VNB	2.94855e-17
C575	D#7	VNB	4.17325e-17
C576	VGND#4	C#8	4.6257e-19
C577	A#1	VNB	4.04131e-17
C578	A#7	VNB	3.26342e-17
C579	VGND	VGND#6	4.75096e-17
C580	A#9	VNB	3.21851e-17
C581	A#8	VNB	5.23155e-17
C582	D	C	1.74815e-17
C583	VGND#7	C#7	6.34176e-18
C584	B#1	VNB	5.86207e-17
C585	B#4	VNB	3.20231e-17
C586	VGND	B#3	1.41365e-17
C587	B#8	VNB	3.23134e-17
C588	B#9	VNB	3.32872e-17
C589	C#1	VNB	3.46943e-17
C590	a_27_368##5	Y#11	3.17132e-17
C591	a_879_368##6	VPWR#3	6.22197e-17
C592	C#9	VNB	3.21683e-17
C593	C#10	VNB	3.1919e-17
C594	C#11	VNB	3.06763e-17
C595	D#1	VNB	3.28244e-17
C596	D#9	VNB	3.20758e-17
C597	D#10	VNB	3.17901e-17
C598	VPWR	B	1.80708e-18
C599	D#11	VNB	4.44666e-17
C600	Y	D	3.81862e-17
C601	VPWR	C	8.8993e-18
C602	a_879_368#	A#2	8.68823e-19
C603	VGND#3	VNB	1.36481e-16
C604	VPWR#6	VNB	2.10062e-16
C605	VGND	B	1.22183e-18
C606	VPWR	D	9.16304e-18
C607	VGND#6	VNB	2.83858e-17
C608	A#3	VNB	3.33985e-17
C609	VGND	C	8.13666e-18
C610	B#3	VNB	8.03669e-17
C611	VGND	D	8.00438e-18
C612	VGND#5	C#7	2.4501e-19
C613	VGND	Y	4.75621e-18
C614	B	VNB	1.89561e-18
C615	C	VNB	2.36681e-17
C616	D	VNB	2.41795e-17
C617	A	VNB	3.38447e-17
C618	Y	VNB	4.07344e-17
C619	VPWR	VNB	3.22363e-16
C620	VGND	VNB	2.90233e-16
C621	VPWR#2	a_879_368##3	1.11975e-18
C622	VPWR#2	A#9	5.26146e-20
C623	VGND#3	VGND#2	5.46207e-17
C624	a_879_368#	VPWR#2	3.97146e-17
C625	VPWR#2	VPWR#4	4.15979e-17
C626	a_879_368##2	VPWR#2	3.14598e-18
C627	VPWR#2	A	5.18743e-18
C628	VPWR#2	VPWR#3	2.1627e-17
C629	VGND#2	VNB	3.42263e-17
C630	VPWR#2	VNB	1.66773e-16
C631	a_879_368##6	VPWR#2	2.82121e-17
C632	VGND#2	A#4	3.79618e-18
C633	VPWR#2	A#1	3.44155e-18
C634	VPWR#2	A#5	5.18063e-21
C635	VPWR#2	A#3	5.19755e-18
C636	VGND#2	A	1.70938e-18
C637	VPWR#2	VPWR#5	2.16952e-17
C638	VPWR#2	A#7	2.64693e-18
C639	VGND#4	VGND#2	6.24344e-19
*
*
.ENDS sky130_fd_sc_hs__nor4_4
*
