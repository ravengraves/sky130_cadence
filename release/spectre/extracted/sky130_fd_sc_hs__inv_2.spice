* Extracted by Quantus, converted by sky130cad/quantus.py
*
*
*
*                       LINUX           Wed Nov 18 08:41:50 2026
*
*
*
*  PROGRAM  advgen
*
*  Name           : advgen - Quantus - (64-bit)
*  Version        : 25.1.0-p047
*  Build Date     : Thu Dec 11 23:20:30 PST 2025
*
*  HSPICE LIBRARY
*
*  OPERATING_TEMPERATURE 150
*  QRC_TECH_DIR <path>/tech
*
*
*

*
.SUBCKT sky130_fd_sc_hs__inv_2 VPB VNB VGND VPWR Y A
*
*
*  caps2d version: 10
*
*
*       TRANSISTOR CARDS
*
*
XM2 VGND#3 A#6 Y#3 VNB sky130_fd_pr__nfet_01v8_lvt l=0.15 w=0.74 ad=0.2109 as=0.2072 pd=2.05 ps=2.04
XM3 Y#3 A#5 VGND#1 VNB sky130_fd_pr__nfet_01v8_lvt l=0.15 w=0.74 ad=0.2072 as=0.2109 pd=2.04 ps=2.05
XM0 Y#1 A#7 VPWR#3 VPB sky130_fd_pr__pfet_01v8 l=0.15 w=1.12 ad=0.336 as=0.3192 pd=2.84 ps=2.81
XM1 VPWR#1 A#1 Y#1 VPB sky130_fd_pr__pfet_01v8 l=0.15 w=1.12 ad=0.3192 as=0.336 pd=2.81 ps=2.84
*
*
*       RESISTOR AND CAP/DIODE CARDS
*
Rg1	A#1	A#2	525.154541
Rg2	A#2	A#3	205.212585
Rg3	A#3	A#4	42.414452
Rg4	A#2	A#5	343.439178
Rg5	A#3	A#6	365.868195
Rg6	A#3	A#7	468.868408
Rf1	A	A#4	168.106262
Rf2	Y	Y#2	0.226166
Rf3	Y#2	Y	16.510138
Rf4	Y	Y#4	7.282945
Rf5	Y#4	Y	7.282945
Rf6	Y#1	Y#2	5.000000
Rf7	Y#3	Y#4	7.500000
Rf8	VPWR#1	VPWR#2	82.736549
Rf9	VPWR#2	VPWR#3	66.403915
Rf10	VGND#1	VGND#2	74.419876
Rf11	VGND#2	VGND#3	75.192451
Re1	VPWR#2	VPWR	3.274347
Re2	VGND	VGND#2	3.274471
*
*       CAPACITOR CARDS
*
*
C1	A#2	Y#3	1.91769e-19
C2	VPWR#2	A#2	3.6317e-20
C3	VGND#2	A#2	5.38103e-20
C4	A#4	A#2	7.83561e-18
C5	A	A#2	3.54227e-19
C6	Y	A#2	1.61814e-17
C7	VGND#3	VGND#1	2.80021e-18
C8	VGND#1	VPWR#1	9.9262e-18
C9	VGND#1	A#5	2.35835e-17
C10	A#5	Y#3	1.49295e-17
C11	A#2	VNB	3.40944e-17
C12	VGND#1	A#6	1.46284e-18
C13	VPWR#3	VPWR#1	1.87559e-18
C14	VGND#3	A#5	1.46284e-18
C15	A#6	Y#3	1.49295e-17
C16	VGND#3	A#6	2.35835e-17
C17	VPWR#1	A#1	2.95064e-17
C18	A#6	A#5	3.85959e-17
C19	A#1	Y#1	2.37714e-17
C20	VPWR#1	A#7	1.27595e-18
C21	VPWR#3	A#1	4.42164e-18
C22	VPWR#3	A#7	5.13391e-17
C23	VGND#2	VGND#1	4.17374e-20
C24	A#4	Y#3	1.71222e-19
C25	A#4	VGND#3	4.35302e-17
C26	A#7	A#1	4.77759e-17
C27	VGND#2	A#5	5.40043e-18
C28	A#4	VPWR#3	4.13502e-18
C29	VGND#2	A#6	3.65526e-18
C30	VPWR#2	A#1	5.35575e-18
C31	VPWR#2	A#7	1.85318e-18
C32	Y	VGND#1	7.0374e-17
C33	VGND#3	Y	6.36871e-17
C34	A	VPWR#3	3.18702e-17
C35	A#4	A#1	4.0866e-18
C36	Y	VPWR#1	8.80638e-17
C37	Y	Y#1	8.98446e-18
C38	VPWR#3	Y	9.56469e-17
C39	Y	A#5	2.49519e-17
C40	VPWR	VPWR#1	2.4344e-17
C41	VPWR#2	A#4	3.68078e-20
C42	A	A#1	5.65006e-19
C43	Y	A#6	2.19832e-17
C44	VGND	VGND#1	2.1785e-17
C45	A	A#7	3.43702e-18
C46	VPWR	VPWR#3	3.03274e-17
C47	VGND#2	A#4	4.55709e-20
C48	VGND	VGND#3	2.43214e-17
C49	Y	A#1	3.61477e-17
C50	VGND	VPWR#1	3.12218e-18
C51	Y	A#7	2.3607e-17
C52	VPWR	A#1	4.98251e-18
C53	VGND#1	VNB	4.56791e-17
C54	VGND	A#5	4.82017e-18
C55	Y	VPWR#2	1.53976e-17
C56	VPWR	A#7	4.57337e-18
C57	VGND	A#6	5.12419e-18
C58	VGND#3	VNB	4.24952e-17
C59	A	A#4	1.09278e-17
C60	VPWR#1	VNB	5.90136e-17
C61	VGND#2	Y	1.63437e-17
C62	VPWR	VPWR#2	2.79976e-17
C63	VPWR#3	VNB	5.00427e-17
C64	Y	A#4	3.78009e-17
C65	A#5	VNB	3.35488e-17
C66	A#6	VNB	3.11795e-17
C67	A#1	VNB	4.82199e-17
C68	A	Y	2.85363e-17
C69	VGND	VGND#2	2.86991e-17
C70	A#7	VNB	4.02488e-17
C71	VGND	A#4	2.52465e-18
C72	VPWR	A	2.66638e-18
C73	VPWR#2	VNB	1.45776e-16
C74	VGND#2	VNB	1.46817e-16
C75	VPWR	Y	1.86211e-17
C76	A#4	VNB	6.777e-17
C77	VGND	Y	1.91624e-17
C78	A	VNB	1.10003e-17
C79	Y	VNB	2.66206e-17
C80	VPWR	VNB	4.60417e-17
C81	VGND	VNB	4.87568e-17
*
*
.ENDS sky130_fd_sc_hs__inv_2
*
