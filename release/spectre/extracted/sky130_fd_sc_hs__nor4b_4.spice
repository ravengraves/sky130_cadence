* Extracted by Quantus, converted by sky130cad/quantus.py
*
*
*
*                       LINUX           Wed Nov 18 08:51:59 2026
*
*
*
*  PROGRAM  advgen
*
*  Name           : advgen - Quantus - (64-bit)
*  Version        : 25.1.0-p047
*  Build Date     : Thu Dec 11 23:20:30 PST 2025
*
*  HSPICE LIBRARY
*
*  OPERATING_TEMPERATURE 150
*  QRC_TECH_DIR <path>/tech
*
*
*

*
.SUBCKT sky130_fd_sc_hs__nor4b_4 VNB VPB VGND VPWR Y D_N C B A
*
*
*  caps2d version: 10
*
*
*       TRANSISTOR CARDS
*
*
XM28 a_47_88##14 D_N#1 VGND#19 VNB sky130_fd_pr__nfet_01v8_lvt l=0.15 w=0.74 ad=0.31115 as=0.2183 pd=2.85 ps=2.07
XM3 Y#9 a_47_88##5 VGND#19 VNB sky130_fd_pr__nfet_01v8_lvt l=0.15 w=0.74 ad=0.2664 as=0.2183 pd=2.2 ps=2.07
XM32 VGND#18 a_47_88##10 Y#9 VNB sky130_fd_pr__nfet_01v8_lvt l=0.15 w=0.74 ad=0.259 as=0.2664 pd=2.18 ps=2.2
XM4 Y#17 a_47_88##8 VGND#18 VNB sky130_fd_pr__nfet_01v8_lvt l=0.15 w=0.74 ad=0.2072 as=0.259 pd=2.04 ps=2.18
XM20 VGND#17 a_47_88##6 Y#17 VNB sky130_fd_pr__nfet_01v8_lvt l=0.15 w=0.74 ad=0.3108 as=0.2072 pd=2.32 ps=2.04
XM5 Y#16 C#6 VGND#17 VNB sky130_fd_pr__nfet_01v8_lvt l=0.15 w=0.74 ad=0.2072 as=0.3108 pd=2.04 ps=2.32
XM19 VGND#13 C#11 Y#16 VNB sky130_fd_pr__nfet_01v8_lvt l=0.15 w=0.74 ad=0.6105 as=0.2072 pd=3.13 ps=2.04
XM15 VGND#13 C#8 Y#15 VNB sky130_fd_pr__nfet_01v8_lvt l=0.15 w=0.74 ad=0.6105 as=0.2072 pd=3.13 ps=2.04
XM23 Y#15 C#7 VGND#12 VNB sky130_fd_pr__nfet_01v8_lvt l=0.15 w=0.74 ad=0.2072 as=0.5661 pd=2.04 ps=3.01
XM8 VGND#12 B#7 Y#12 VNB sky130_fd_pr__nfet_01v8_lvt l=0.15 w=0.74 ad=0.5661 as=0.259 pd=3.01 ps=2.18
XM29 VGND#11 B#11 Y#12 VNB sky130_fd_pr__nfet_01v8_lvt l=0.15 w=0.74 ad=0.259 as=0.259 pd=2.18 ps=2.18
XM0 Y#11 B#10 VGND#11 VNB sky130_fd_pr__nfet_01v8_lvt l=0.15 w=0.74 ad=0.2072 as=0.259 pd=2.04 ps=2.18
XM1 Y#11 B#8 VGND#10 VNB sky130_fd_pr__nfet_01v8_lvt l=0.15 w=0.74 ad=0.2072 as=0.3293 pd=2.04 ps=2.37
XM6 VGND#10 A#6 Y#10 VNB sky130_fd_pr__nfet_01v8_lvt l=0.15 w=0.74 ad=0.3293 as=0.2072 pd=2.37 ps=2.04
XM26 Y#10 A#10 VGND#9 VNB sky130_fd_pr__nfet_01v8_lvt l=0.15 w=0.74 ad=0.2072 as=0.2072 pd=2.04 ps=2.04
XM2 VGND#9 A#8 Y#1 VNB sky130_fd_pr__nfet_01v8_lvt l=0.15 w=0.74 ad=0.2072 as=0.2072 pd=2.04 ps=2.04
XM33 Y#1 A#7 VGND#1 VNB sky130_fd_pr__nfet_01v8_lvt l=0.15 w=0.74 ad=0.2072 as=0.2627 pd=2.04 ps=2.19
XM13 a_47_88##15 D_N#5 VPWR#6 VPB sky130_fd_pr__pfet_01v8 l=0.15 w=0.84 ad=0.252 as=0.2478 pd=2.28 ps=2.27
XM30 VPWR#9 D_N#4 a_47_88##15 VPB sky130_fd_pr__pfet_01v8 l=0.15 w=0.84 ad=0.2478 as=0.252 pd=2.27 ps=2.28
XM14 a_319_368##3 a_47_88##11 Y#14 VPB sky130_fd_pr__pfet_01v8 l=0.15 w=1.12 ad=0.3304 as=0.336 pd=2.83 ps=2.84
XM34 Y#14 a_47_88##9 a_319_368# VPB sky130_fd_pr__pfet_01v8 l=0.15 w=1.12 ad=0.336 as=0.392 pd=2.84 ps=2.94
XM21 a_319_368# a_47_88##7 Y#18 VPB sky130_fd_pr__pfet_01v8 l=0.15 w=1.12 ad=0.392 as=0.336 pd=2.94 ps=2.84
XM7 Y#18 a_47_88# a_319_368##4 VPB sky130_fd_pr__pfet_01v8 l=0.15 w=1.12 ad=0.336 as=0.336 pd=2.84 ps=2.84
XM16 a_319_368##4 C#12 a_778_368##4 VPB sky130_fd_pr__pfet_01v8 l=0.15 w=1.12 ad=0.336 as=0.392 pd=2.84 ps=2.94
XM18 a_319_368##6 C#10 a_778_368##4 VPB sky130_fd_pr__pfet_01v8 l=0.15 w=1.12 ad=0.42 as=0.392 pd=2.99 ps=2.94
XM24 a_778_368##6 C#9 a_319_368##6 VPB sky130_fd_pr__pfet_01v8 l=0.15 w=1.12 ad=0.364 as=0.42 pd=2.89 ps=2.99
XM22 a_778_368##6 C#1 a_319_368##8 VPB sky130_fd_pr__pfet_01v8 l=0.15 w=1.12 ad=0.364 as=0.3304 pd=2.89 ps=2.83
XM17 a_778_368##5 B#13 a_1191_368##5 VPB sky130_fd_pr__pfet_01v8 l=0.15 w=1.12 ad=0.392 as=0.3304 pd=2.94 ps=2.83
XM9 a_778_368##5 B#12 a_1191_368##8 VPB sky130_fd_pr__pfet_01v8 l=0.15 w=1.12 ad=0.392 as=0.392 pd=2.94 ps=2.94
XM10 a_1191_368##8 B#9 a_778_368# VPB sky130_fd_pr__pfet_01v8 l=0.15 w=1.12 ad=0.392 as=0.336 pd=2.94 ps=2.84
XM25 a_1191_368##7 B#1 a_778_368# VPB sky130_fd_pr__pfet_01v8 l=0.15 w=1.12 ad=0.336 as=0.336 pd=2.84 ps=2.84
XM11 VPWR#8 A#12 a_1191_368##7 VPB sky130_fd_pr__pfet_01v8 l=0.15 w=1.12 ad=0.336 as=0.336 pd=2.84 ps=2.84
XM12 VPWR#8 A#11 a_1191_368##6 VPB sky130_fd_pr__pfet_01v8 l=0.15 w=1.12 ad=0.336 as=0.336 pd=2.84 ps=2.84
XM27 a_1191_368##6 A#9 VPWR#7 VPB sky130_fd_pr__pfet_01v8 l=0.15 w=1.12 ad=0.336 as=0.336 pd=2.84 ps=2.84
XM31 a_1191_368# A#1 VPWR#7 VPB sky130_fd_pr__pfet_01v8 l=0.15 w=1.12 ad=0.3304 as=0.336 pd=2.83 ps=2.84
*
*
*       RESISTOR AND CAP/DIODE CARDS
*
Rg1	D_N#1	D_N#2	352.136932
Rg2	D_N#2	D_N#3	47.652981
Rg3	D_N#2	D_N#4	458.082794
Rg4	D_N#3	D_N#5	411.431702
Rg5	a_47_88#	a_47_88##2	624.076050
Rg6	a_47_88##2	a_47_88##3	80.178055
Rg7	a_47_88##3	a_47_88##4	85.897408
Rg8	a_47_88##4	a_47_88##5	418.488251
Rg9	a_47_88##2	a_47_88##6	467.818115
Rg10	a_47_88##2	a_47_88##7	514.555054
Rg11	a_47_88##3	a_47_88##8	415.552856
Rg12	a_47_88##3	a_47_88##9	447.115234
Rg13	a_47_88##4	a_47_88##10	369.204346
Rg14	a_47_88##4	a_47_88##11	434.197662
Rg15	C#1	C#2	575.826355
Rg16	C#2	C#3	230.055405
Rg17	C#3	C#4	49.558250
Rg18	C#4	C#5	66.493263
Rg19	C#5	C#6	420.780396
Rg20	C#2	C#7	279.620361
Rg21	C#3	C#8	322.990906
Rg22	C#3	C#9	469.777618
Rg23	C#4	C#10	437.133423
Rg24	C#5	C#11	391.527222
Rg25	C#5	C#12	500.561005
Rg26	B#1	B#2	445.925262
Rg27	B#2	B#3	51.607704
Rg28	B#3	B#4	22.529716
Rg29	B#4	B#5	68.775940
Rg30	B#5	B#6	83.844635
Rg31	B#6	B#7	431.053864
Rg32	B#2	B#8	374.096069
Rg33	B#3	B#9	419.554810
Rg34	B#4	B#10	381.948395
Rg35	B#5	B#11	380.747528
Rg36	B#5	B#12	432.847015
Rg37	B#6	B#13	419.554810
Rg38	A#1	A#2	454.195099
Rg39	A#2	A#3	68.597641
Rg40	A#3	A#4	44.876480
Rg41	A#4	A#5	92.485268
Rg42	A#5	A#6	451.838898
Rg43	A#2	A#7	414.404694
Rg44	A#3	A#8	430.496918
Rg45	A#3	A#9	444.843445
Rg46	A#4	A#10	371.974945
Rg47	A#4	A#11	424.132080
Rg48	A#5	A#12	503.938385
Rf1	D_N	D_N#6	0.964345
Rf2	D_N#7	D_N#3	54.375278
Rf3	D_N#6	D_N#7	4.017777
Rf4	D_N	D_N#9	0.964345
Rf5	D_N#7	D_N#9	7.417435
Rf6	a_47_88##4	a_47_88##13	90.239014
Rf7	a_47_88##13	a_47_88##14	74.356087
Rf8	a_47_88##13	a_47_88##15	69.723122
Rf9	C	C#13	4.125637
Rf10	C#13	C	10.543295
Rf11	a_319_368#	a_319_368##2	22.471292
Rf12	a_319_368##2	a_319_368##3	100.340820
Rf13	a_319_368##2	a_319_368##5	78.839401
Rf14	a_319_368##5	a_319_368##7	69.838272
Rf15	a_319_368##7	a_319_368##8	76.440247
Rf16	a_319_368##4	a_319_368##5	7.500000
Rf17	a_319_368##6	a_319_368##7	15.000000
Rf18	B	B#14	4.889644
Rf19	B#14	B	9.779288
Rf20	a_778_368#	a_778_368##2	92.830330
Rf21	a_778_368##2	a_778_368##3	110.257187
Rf22	a_778_368##3	a_778_368##4	89.751648
Rf23	a_778_368##2	a_778_368##5	18.149860
Rf24	a_778_368##3	a_778_368##6	20.532116
Rf25	Y#1	Y#2	88.723526
Rf26	Y#2	Y#3	71.963020
Rf27	Y#3	Y#4	73.001427
Rf28	Y#4	Y#5	65.405022
Rf29	Y#5	Y#6	32.897556
Rf30	Y#6	Y#7	99.233002
Rf31	Y#7	Y#8	85.368294
Rf32	Y#8	Y#9	81.657486
Rf33	Y#2	Y#10	21.341251
Rf34	Y#3	Y#11	18.149860
Rf35	Y#4	Y#12	18.149860
Rf36	Y#5	Y	6.389822
Rf37	Y	Y#13	188.827209
Rf38	Y#13	Y#14	83.667542
Rf39	Y#6	Y#15	18.149860
Rf40	Y#7	Y#16	25.664793
Rf41	Y#8	Y#17	20.278393
Rf42	Y#13	Y#18	12.500479
Rf43	A	A#13	1.680815
Rf44	A#13	A	12.988117
Rf45	a_1191_368#	a_1191_368##2	86.609100
Rf46	a_1191_368##2	a_1191_368##3	65.770279
Rf47	a_1191_368##3	a_1191_368##4	65.770279
Rf48	a_1191_368##4	a_1191_368##5	84.515259
Rf49	a_1191_368##2	a_1191_368##6	17.027714
Rf50	a_1191_368##3	a_1191_368##7	21.897854
Rf51	a_1191_368##4	a_1191_368##8	14.705224
Rf52	VGND#1	VGND#2	97.562263
Rf53	VGND#2	VGND#3	34.309200
Rf54	VGND#3	VGND#4	34.478344
Rf55	VGND#4	VGND#5	73.901077
Rf56	VGND#5	VGND#6	85.654884
Rf57	VGND#6	VGND#7	103.195961
Rf58	VGND#7	VGND#8	71.208656
Rf59	VGND#2	VGND#9	36.869534
Rf60	VGND#4	VGND#10	35.399742
Rf61	VGND#5	VGND#11	36.869534
Rf62	VGND#6	VGND#12	19.157028
Rf63	VGND#7	VGND#13	17.313427
Rf64	VGND#8	VGND#14	89.900627
Rf65	VGND#14	VGND#15	68.618401
Rf67	VGND#8	VGND#17	36.804161
Rf68	VGND#14	VGND#18	36.279022
Rf69	VGND#15	VGND#19	33.306259
Rf71	VPWR#2	VPWR#3	73.338989
Rf72	VPWR#3	VPWR#4	369.014587
Rf73	VPWR#4	VPWR#5	157.075424
Rf74	VPWR#5	VPWR#6	114.511635
Rf75	VPWR#2	VPWR#7	38.736572
Rf76	VPWR#3	VPWR#8	43.353802
Rf77	VPWR#5	VPWR#9	41.676403
Rf82	A#4	A#13	40.058201
Rf80	C#4	C#13	53.410934
Rf81	B#5	B#14	40.058201
Re1	VPWR#3	VPWR	2.687498
Re2	VPWR	VPWR#4	1.343749
Re3	VGND#3	VGND	2.687498
Re4	VGND	VGND#8	1.343749
*
*       CAPACITOR CARDS
*
*
C1	a_47_88##15	a_319_368##3	3.74759e-18
C2	VPWR#5	a_47_88##7	6.61479e-20
C3	Y#9	a_47_88##8	4.83821e-19
C4	a_778_368##3	B#13	1.31243e-18
C5	Y#13	a_47_88##3	1.62801e-18
C6	VGND#5	Y#11	8.48245e-18
C7	VGND#18	a_47_88##10	3.19945e-17
C8	a_778_368##3	a_778_368##6	3.62555e-18
C9	a_778_368##2	B#13	1.82838e-17
C10	a_47_88##15	VPWR#9	7.18617e-17
C11	VGND#6	VGND#11	1.93064e-18
C12	Y#7	C#5	2.35083e-17
C13	Y#13	a_319_368#	7.11811e-17
C14	Y#16	Y#15	1.05062e-18
C15	Y#9	a_47_88##10	2.72883e-17
C16	Y#13	C#10	1.49303e-17
C17	B#6	B#5	3.28573e-18
C18	B#5	B#4	3.28573e-18
C19	VPWR#6	VPWR#9	2.0207e-18
C20	VGND#4	Y#11	8.44746e-18
C21	VGND#4	VGND#2	1.22476e-18
C22	VGND#18	a_47_88##5	1.10095e-18
C23	a_778_368##3	C#1	2.94786e-17
C24	VGND#19	a_47_88##10	2.51119e-18
C25	Y#13	a_47_88##2	5.9748e-18
C26	VPWR#5	a_47_88##9	1.87468e-19
C27	a_778_368##3	a_319_368##6	4.48061e-17
C28	a_47_88##5	Y#9	2.34236e-17
C29	VPWR#6	a_47_88##15	6.52585e-17
C30	VGND#6	Y#12	5.55167e-17
C31	Y#14	Y#13	3.40022e-18
C32	Y#13	C#12	2.24332e-17
C33	Y#4	B#6	3.29111e-18
C34	Y#8	a_47_88##3	1.51172e-17
C35	VGND#19	a_47_88##5	4.78972e-17
C36	a_778_368##3	C#9	2.12639e-17
C37	VGND#11	VGND#4	3.40487e-19
C38	Y#9	D_N#1	1.03436e-19
C39	Y#8	Y#14	7.6065e-18
C40	a_778_368##4	a_778_368##3	2.9655e-18
C41	VPWR#5	a_47_88##11	5.44314e-18
C42	VGND#5	Y#12	9.15128e-18
C43	B#4	a_778_368#	9.36344e-19
C44	Y#2	A#5	1.70276e-18
C45	VGND#19	D_N#1	4.05162e-17
C46	VGND#6	VGND#12	1.95408e-17
C47	Y#13	a_47_88#	3.893e-17
C48	Y#8	a_47_88##2	2.76235e-17
C49	D_N#1	a_47_88##14	1.58696e-17
C50	VGND#17	Y#16	4.9241e-17
C51	a_778_368##3	C#10	8.42911e-19
C52	VGND#7	Y#15	5.58598e-17
C53	C#5	C#4	7.06252e-19
C54	Y#7	a_47_88#	5.21378e-18
C55	C#4	C#2	8.09724e-18
C56	VPWR#5	D_N#4	7.37371e-18
C57	VGND#10	B#4	8.89811e-19
C58	A#8	A#7	3.90852e-17
C59	VGND#2	A#7	2.81134e-18
C60	VGND#6	Y#15	5.545e-17
C61	Y#13	a_47_88##7	3.40673e-17
C62	VGND#7	VGND#13	1.46825e-17
C63	B#4	a_1191_368##8	5.62838e-19
C64	Y#6	C#2	5.10524e-18
C65	VGND#14	Y#8	8.73122e-18
C66	Y#7	a_47_88##2	1.10694e-18
C67	A#10	A#8	3.98305e-17
C68	Y#3	B#4	6.68719e-18
C69	VPWR#5	D_N#5	2.76422e-18
C70	B#4	A#5	2.50707e-17
C71	a_1191_368#	A#1	3.89428e-17
C72	VGND#2	A#8	5.00299e-18
C73	Y#13	a_47_88##9	1.4869e-18
C74	a_47_88##4	C#5	1.21161e-18
C75	VPWR#7	A#1	4.48082e-17
C76	VGND#18	VGND#17	1.94088e-18
C77	VGND#7	Y#16	4.72366e-17
C78	a_319_368##2	C#12	5.18045e-20
C79	VGND#4	A#10	4.85262e-19
C80	B#6	a_778_368##5	3.54941e-19
C81	a_47_88##4	a_47_88##3	1.95567e-17
C82	a_319_368##4	C#6	7.26298e-19
C83	a_1191_368#	A#9	1.79052e-18
C84	a_1191_368##6	A#1	2.27487e-18
C85	A#6	A#10	4.0041e-17
C86	VGND#14	VGND#17	3.82144e-19
C87	A#9	VPWR#7	2.25963e-17
C88	VPWR#8	A#1	2.70458e-19
C89	VGND#2	A#10	4.81893e-18
C90	VGND#5	A#6	1.40073e-19
C91	a_1191_368#	A#11	5.89003e-19
C92	a_1191_368##6	A#9	5.30329e-17
C93	a_319_368##2	a_319_368##4	6.5176e-19
C94	a_319_368##2	a_47_88#	1.28925e-19
C95	VGND#17	VGND#7	2.19433e-18
C96	VGND#4	A#6	3.8845e-18
C97	VPWR#7	A#11	6.87375e-19
C98	VPWR#8	A#9	3.71489e-19
C99	B#8	A#6	2.00329e-17
C100	VGND#7	Y#7	3.34327e-17
C101	a_1191_368#	A#12	1.42355e-19
C102	a_1191_368##6	A#11	4.65149e-17
C103	VGND#2	A#6	5.64318e-19
C104	VGND#5	B#8	4.41667e-19
C105	C#1	B#6	1.83826e-18
C106	VGND#11	B#4	2.26104e-19
C107	a_319_368##2	Y#18	5.58756e-19
C108	B#6	a_1191_368##5	2.77437e-18
C109	a_319_368##2	a_47_88##7	1.53566e-17
C110	VPWR#7	A#12	1.72497e-19
C111	A#11	VPWR#8	2.21054e-17
C112	Y#9	VGND#18	4.36222e-17
C113	a_1191_368##4	a_1191_368##3	6.84376e-19
C114	a_1191_368##6	A#12	1.7739e-18
C115	a_1191_368#	B#1	9.41412e-20
C116	a_1191_368##7	A#11	3.14282e-19
C117	VGND#4	B#8	5.66137e-18
C118	B#10	B#8	3.91219e-17
C119	a_47_88##13	a_47_88##7	7.28974e-20
C120	VGND#7	Y#6	3.4093e-17
C121	VPWR#8	A#12	4.24685e-17
C122	VGND#2	B#8	1.67852e-19
C123	a_319_368##2	a_319_368#	1.70255e-18
C124	a_319_368##2	a_47_88##9	1.52968e-17
C125	VGND#5	B#10	5.21176e-18
C126	VGND#19	VGND#18	2.17722e-18
C127	a_1191_368##6	B#1	2.02745e-19
C128	A#12	a_1191_368##7	2.2844e-17
C129	Y#2	Y#1	1.70573e-19
C130	VPWR#8	B#1	1.52137e-18
C131	a_778_368#	A#12	1.99273e-18
C132	B#11	B#10	2.48282e-17
C133	a_47_88##13	a_47_88##9	3.72314e-20
C134	VGND#4	B#10	5.0636e-19
C135	VGND#6	B#11	7.76991e-19
C136	VGND#6	Y#6	1.12724e-19
C137	B#1	a_1191_368##7	2.74452e-17
C138	VGND#19	Y#9	6.47274e-17
C139	a_319_368##2	Y#14	1.7036e-17
C140	a_778_368##2	B#6	1.13653e-19
C141	a_319_368##2	a_47_88##11	2.06101e-19
C142	VGND#14	Y#9	7.48017e-18
C143	VPWR#5	a_47_88##3	7.70558e-21
C144	a_778_368#	B#1	5.37469e-17
C145	VPWR#3	a_1191_368##4	1.11522e-17
C146	VGND#5	B#11	4.68992e-18
C147	a_1191_368##3	VPWR#3	4.08306e-18
C148	VGND#7	B#7	1.22065e-19
C149	Y#2	VGND#9	1.99134e-17
C150	B#7	B#11	2.84337e-17
C151	a_47_88##13	a_47_88##11	3.9447e-19
C152	VGND#3	VGND#5	6.63733e-17
C153	a_1191_368##7	B#9	3.14282e-19
C154	a_1191_368##3	a_1191_368##2	2.63221e-20
C155	a_1191_368##2	VPWR#3	3.42232e-18
C156	VGND#3	VGND#4	7.12727e-17
C157	VGND#4	B#11	1.71544e-19
C158	a_778_368#	B#9	3.74702e-17
C159	a_778_368##5	B#1	3.3273e-19
C160	VGND#3	VGND#2	7.30699e-17
C161	VGND#6	B#7	1.90866e-17
C162	a_319_368##3	a_319_368##2	6.17457e-19
C163	a_319_368##2	D_N#4	1.78756e-20
C164	a_778_368##2	B#4	9.9959e-20
C165	VGND#19	VGND#14	5.87817e-20
C166	B#9	a_1191_368##8	2.54251e-17
C167	a_47_88##14	VGND#19	5.42559e-17
C168	VGND#5	B#7	8.02139e-19
C169	C#7	B#7	5.26253e-18
C170	Y#2	Y#10	5.26243e-19
C171	Y#2	A#7	6.83523e-20
C172	a_778_368##5	B#9	2.20365e-18
C173	a_778_368#	B#12	6.59755e-19
C174	VGND#7	C#7	1.13159e-18
C175	Y#3	VGND#10	1.53957e-17
C176	C#2	B#7	1.22743e-18
C177	B#12	a_1191_368##8	1.16921e-17
C178	a_1191_368##5	B#9	1.98955e-19
C179	VGND#6	C#7	1.90878e-17
C180	a_47_88##13	a_319_368##3	1.80773e-18
C181	VGND#6	Y#4	1.49214e-17
C182	a_778_368##5	B#12	4.87544e-17
C183	VGND#14	VGND#8	9.53351e-19
C184	C#8	C#7	3.59599e-17
C185	VGND#8	VGND#7	1.18423e-18
C186	Y#2	VGND#10	1.63468e-17
C187	Y#2	A#8	9.98825e-20
C188	a_1191_368##5	B#12	1.58292e-18
C189	VGND#5	C#7	3.56239e-20
C190	VGND#17	a_47_88#	1.28452e-18
C191	Y#3	Y#11	9.59055e-20
C192	VGND#7	C#8	1.80421e-17
C193	VGND#6	B#6	3.50108e-20
C194	Y#4	VGND#11	1.27658e-17
C195	B#13	a_778_368##5	2.46391e-17
C196	C#5	C#10	1.85856e-19
C197	a_778_368##2	VPWR#3	1.00788e-16
C198	a_47_88##13	VPWR#9	5.70242e-18
C199	VGND#3	Y#4	1.14894e-18
C200	VGND#5	Y#4	2.18817e-19
C201	a_1191_368##5	B#13	7.58888e-17
C202	VGND#6	C#8	1.38505e-18
C203	C#11	C#8	3.53625e-18
C204	VGND#3	Y#3	2.92878e-18
C205	Y#11	Y#2	9.52036e-19
C206	Y#7	Y#15	5.28699e-19
C207	a_319_368##8	B#13	5.90909e-19
C208	Y#2	A#10	1.72376e-17
C209	a_778_368##5	C#1	6.159e-19
C210	VGND#3	Y#2	3.51448e-18
C211	Y#3	VGND#11	1.43783e-17
C212	a_319_368##8	C#2	1.12543e-19
C213	a_1191_368##5	C#1	5.46422e-18
C214	Y#4	Y#12	5.33767e-19
C215	VGND#7	C#11	2.59201e-17
C216	a_778_368##3	C#2	9.73429e-20
C217	a_319_368##6	B#13	2.00407e-19
C218	a_319_368##8	C#1	3.9236e-17
C219	C#6	C#11	3.68685e-17
C220	a_1191_368#	VPWR#7	5.43453e-17
C221	Y#6	Y#15	9.59055e-20
C222	VGND#2	A#4	4.64729e-20
C223	VGND#5	Y#3	2.25448e-19
C224	VGND#6	C#11	1.11413e-19
C225	VGND#8	Y#8	8.59162e-18
C226	C#1	a_778_368##6	2.38688e-17
C227	a_1191_368##5	C#9	6.21747e-19
C228	Y#2	A#6	2.07414e-17
C229	Y#7	VGND#13	1.13012e-19
C230	D_N#6	a_47_88##13	2.7302e-17
C231	VGND#14	C#6	1.2699e-19
C232	VGND#8	Y#7	1.46399e-19
C233	VGND#5	B#6	4.5514e-20
C234	a_778_368##3	VPWR#4	8.86114e-17
C235	a_319_368##6	C#1	1.35996e-18
C236	a_319_368##8	C#9	5.51153e-19
C237	a_778_368##2	VPWR#4	1.39613e-18
C238	a_1191_368##6	a_1191_368#	2.54679e-18
C239	a_1191_368##2	A#4	4.60528e-18
C240	Y#3	B#8	2.55081e-17
C241	VGND#7	C#6	2.13763e-18
C242	VGND#5	B#5	1.99493e-20
C243	a_778_368##4	C#1	2.20162e-19
C244	a_47_88##6	C#6	2.23265e-17
C245	C#9	a_778_368##6	2.44861e-17
C246	a_1191_368##5	C#10	3.83381e-19
C247	VGND#4	Y#3	2.25448e-19
C248	Y#6	VGND#13	1.15997e-18
C249	a_319_368##6	C#9	4.25467e-17
C250	a_319_368##8	C#10	2.43021e-19
C251	Y#2	B#8	2.08094e-19
C252	VGND#7	C#5	3.61636e-19
C253	a_319_368##2	VPWR#5	9.94902e-18
C254	a_1191_368##6	VPWR#7	5.29637e-17
C255	a_778_368##4	C#9	7.75379e-19
C256	a_319_368##2	VPWR#4	6.2826e-17
C257	a_1191_368##4	B#5	1.56277e-18
C258	VGND#14	a_47_88##6	4.07818e-19
C259	a_1191_368##5	C#12	2.57737e-19
C260	VGND#5	B#4	3.56411e-20
C261	Y#8	VGND#17	8.51268e-17
C262	VGND#7	C#4	5.88575e-18
C263	a_47_88##8	a_47_88##6	3.89159e-17
C264	a_319_368##4	C#9	1.97822e-19
C265	a_319_368##6	C#10	4.05748e-17
C266	Y#3	B#10	2.09204e-17
C267	VGND#6	C#4	5.57048e-21
C268	VGND#7	a_47_88##6	4.04003e-19
C269	a_47_88##4	VPWR#5	8.74627e-19
C270	a_778_368##4	C#10	5.0169e-17
C271	VPWR#8	VPWR#7	2.00319e-18
C272	VGND#3	VGND#1	6.25972e-17
C273	a_1191_368#	a_1191_368##7	4.75919e-21
C274	VGND#4	Y#2	2.45341e-19
C275	a_47_88#	C#5	1.39866e-17
C276	Y#4	B#11	1.7478e-17
C277	Y#2	A#4	3.96028e-18
C278	VGND#3	Y#1	1.52473e-17
C279	a_319_368##4	C#10	1.15501e-18
C280	VGND#17	Y#7	3.50382e-17
C281	a_319_368##6	C#12	6.95087e-19
C282	a_47_88##10	a_47_88##8	2.40255e-17
C283	VGND#14	a_47_88##4	6.36455e-20
C284	Y#8	Y#17	4.65576e-19
C285	C#12	a_778_368##4	2.76525e-17
C286	VGND#14	a_47_88##8	5.06957e-18
C287	VGND#3	Y#10	2.80365e-17
C288	Y#8	Y#13	2.607e-17
C289	VPWR#8	a_1191_368##6	5.30395e-17
C290	a_319_368##4	C#12	6.00165e-17
C291	Y#4	B#5	1.90775e-18
C292	VGND#2	A#2	2.56168e-20
C293	VGND#14	a_47_88##3	3.87756e-20
C294	a_319_368##6	C#2	3.00116e-20
C295	Y#3	B#5	1.54131e-18
C296	VGND#3	Y#11	1.72013e-17
C297	VGND#2	Y#2	2.71864e-19
C298	Y#13	C#4	1.62012e-18
C299	VPWR#5	D_N#3	4.9064e-20
C300	Y#4	B#7	2.50596e-17
C301	a_47_88##5	a_47_88##10	2.81545e-17
C302	VGND#4	B#4	3.51956e-20
C303	Y#6	C#7	4.1517e-18
C304	a_319_368#	C#12	1.41983e-19
C305	Y#7	C#4	6.50262e-18
C306	a_1191_368##7	a_1191_368##6	1.97416e-18
C307	a_319_368##4	a_47_88#	3.52614e-17
C308	A	A#5	1.81677e-17
C309	a_778_368##2	B#5	5.15067e-20
C310	Y#6	C#4	1.48909e-17
C311	C#5	a_778_368##4	5.71435e-19
C312	Y#8	VGND#18	6.33177e-17
C313	a_47_88##13	VPWR#5	2.84524e-19
C314	A	A#2	1.66699e-17
C315	a_47_88#	Y#18	2.32319e-17
C316	VGND#14	a_47_88##10	4.73625e-18
C317	Y#7	Y#13	2.85747e-17
C318	A	B#4	1.40394e-17
C319	Y#7	C#8	1.36422e-19
C320	Y#3	a_1191_368##4	4.44956e-19
C321	a_319_368#	a_47_88#	3.33635e-19
C322	VGND#14	a_47_88##2	3.47644e-21
C323	a_319_368##4	a_47_88##7	4.55367e-19
C324	D_N#1	a_47_88##5	3.35101e-17
C325	a_1191_368##7	VPWR#8	6.00023e-17
C326	Y#8	a_47_88##4	4.31857e-17
C327	a_47_88##7	Y#18	2.32319e-17
C328	Y#6	C#8	1.62807e-17
C329	a_778_368##3	C#4	2.58215e-19
C330	a_47_88##7	a_319_368#	2.5132e-17
C331	Y#9	Y#8	2.98218e-18
C332	VGND#1	A#7	2.65278e-17
C333	a_319_368##4	a_47_88##9	1.93917e-19
C334	a_47_88##3	a_47_88##7	8.30923e-19
C335	a_778_368#	VPWR#8	3.56367e-18
C336	Y#8	Y#7	2.8362e-18
C337	Y#1	A#4	1.93925e-18
C338	Y#14	a_47_88##7	1.3544e-18
C339	VGND#14	a_47_88##5	4.73791e-19
C340	Y#7	C#11	1.0697e-17
C341	VPWR#3	a_1191_368#	1.65757e-17
C342	Y#3	a_1191_368##3	4.28946e-18
C343	VGND#9	A#4	1.0208e-18
C344	Y#13	C#6	2.80236e-18
C345	a_319_368##3	a_47_88##7	1.80352e-19
C346	a_47_88##9	a_319_368#	2.95877e-17
C347	Y#1	A#7	4.29972e-17
C348	C#5	Y#16	7.23564e-19
C349	VGND#6	C#2	6.12752e-20
C350	Y#8	D_N#3	3.34355e-19
C351	a_1191_368##6	VPWR#3	2.57065e-17
C352	a_319_368##4	C#5	4.0721e-19
C353	Y#14	a_47_88##9	6.32544e-17
C354	a_778_368#	a_1191_368##7	6.1293e-17
C355	a_47_88##2	C#6	4.07095e-18
C356	Y#8	C#6	1.09668e-18
C357	VGND#1	A#8	1.24092e-18
C358	B	B#6	2.22436e-17
C359	a_1191_368##2	a_1191_368#	2.54679e-20
C360	VGND#3	a_1191_368#	4.62047e-18
C361	a_319_368##3	a_47_88##9	4.04199e-19
C362	B	B#4	2.73733e-17
C363	VGND#9	A#7	1.56224e-18
C364	a_319_368#	a_47_88##11	5.64869e-19
C365	a_1191_368##7	VPWR#3	2.78166e-17
C366	VGND#8	Y#16	9.73397e-18
C367	Y#7	C#6	2.00439e-17
C368	C#2	B#6	3.64631e-18
C369	a_778_368#	VPWR#3	6.57393e-17
C370	Y#14	a_47_88##11	4.78479e-17
C371	Y#1	A#8	2.8553e-17
C372	B	C#2	1.20648e-18
C373	a_319_368##2	a_47_88##4	6.52275e-20
C374	a_319_368##3	a_47_88##11	4.43486e-17
C375	Y#10	A#7	3.27218e-19
C376	a_1191_368##3	A#5	6.0397e-19
C377	a_319_368#	D_N#4	4.89923e-20
C378	A#9	A#1	4.77265e-17
C379	a_47_88##13	a_47_88##4	2.00302e-18
C380	VPWR#9	a_47_88##11	1.44225e-18
C381	VGND#11	B#5	8.93722e-19
C382	Y#8	a_47_88##6	3.13748e-17
C383	VGND#9	A#8	3.23159e-17
C384	a_1191_368##2	VPWR#7	2.29514e-17
C385	a_47_88##15	a_47_88##11	5.92735e-19
C386	a_319_368##3	D_N#4	1.82283e-18
C387	a_778_368#	a_1191_368##8	1.50377e-19
C388	Y#1	A#10	5.78043e-19
C389	VPWR#6	a_47_88##11	9.62517e-20
C390	Y#7	a_47_88##6	6.7943e-19
C391	D_N#4	VPWR#9	3.21089e-17
C392	A#11	A#9	4.67827e-17
C393	a_1191_368##3	a_1191_368##6	6.31731e-19
C394	Y#10	A#8	4.78161e-19
C395	a_1191_368##4	a_778_368##2	2.1316e-17
C396	Y#1	VGND#1	7.07423e-17
C397	a_47_88##15	D_N#4	5.1084e-17
C398	a_47_88##13	D_N#3	6.22235e-17
C399	VGND#9	A#10	2.80299e-17
C400	C	B#6	1.79914e-18
C401	a_778_368##5	a_778_368#	4.01887e-18
C402	VPWR#6	D_N#4	1.26135e-18
C403	VPWR#9	D_N#5	7.2475e-19
C404	Y#8	a_47_88##8	3.66162e-17
C405	C	C#5	1.6115e-17
C406	Y#1	A#6	2.52612e-19
C407	a_1191_368##2	a_1191_368##6	1.34628e-18
C408	A#12	A#11	4.69757e-17
C409	a_47_88##15	D_N#5	4.7307e-17
C410	C	C#2	7.32633e-18
C411	A#10	Y#10	1.15192e-17
C412	A#4	VPWR#7	4.10148e-19
C413	C	a_47_88##2	4.38753e-19
C414	D_N#6	D_N#3	2.45866e-17
C415	VPWR#6	D_N#5	2.7062e-17
C416	a_1191_368##2	A#5	3.02415e-19
C417	VGND#9	VGND#1	1.96815e-18
C418	A#4	a_1191_368##6	6.76136e-19
C419	a_1191_368##3	VPWR#8	1.23873e-17
C420	a_47_88##11	a_47_88##3	9.64071e-19
C421	VGND#9	A#6	1.26178e-18
C422	A#4	VPWR#8	6.13865e-19
C423	VGND#10	A#10	2.43899e-19
C424	B#1	A#12	4.75392e-17
C425	a_1191_368##4	a_1191_368##7	1.97416e-18
C426	C#6	a_47_88#	6.41215e-18
C427	Y#8	a_47_88##10	1.34185e-18
C428	a_778_368##4	VPWR#4	5.40143e-17
C429	a_1191_368##4	B#4	3.58114e-18
C430	Y#10	A#6	3.16952e-17
C431	a_1191_368##2	VPWR#8	1.17186e-17
C432	a_319_368##4	VPWR#4	4.51912e-17
C433	Y#1	VGND#9	4.50726e-17
C434	VGND#9	B#8	1.58516e-19
C435	B#9	B#1	4.42249e-17
C436	a_1191_368##3	a_1191_368##7	3.2398e-18
C437	A#6	VGND#10	2.09519e-17
C438	a_47_88##4	VGND#18	5.15746e-18
C439	a_1191_368##5	a_778_368##5	5.66318e-17
C440	a_47_88##4	Y#9	5.48144e-17
C441	B#5	a_1191_368##8	1.64466e-19
C442	Y#10	B#8	6.00272e-19
C443	a_319_368##2	a_47_88##3	7.70155e-20
C444	VGND#19	a_47_88##4	2.66182e-17
C445	a_1191_368##4	a_778_368#	5.95653e-17
C446	B#5	a_778_368##5	1.13807e-18
C447	Y#8	a_47_88##5	4.25006e-19
C448	Y#11	A#6	8.29862e-19
C449	a_1191_368##5	B#5	7.87194e-19
C450	B#12	B#9	3.37112e-17
C451	Y#10	Y#1	2.5856e-18
C452	VGND#3	A#7	4.53866e-18
C453	VGND#17	a_47_88##2	1.1956e-18
C454	VGND#3	A#8	6.47037e-19
C455	B#8	VGND#10	2.39268e-17
C456	Y#9	D_N#3	3.84611e-19
C457	a_1191_368##2	A#2	1.1797e-18
C458	VGND#3	A#10	7.73954e-19
C459	VGND#11	A#6	1.4222e-19
C460	a_1191_368##3	a_778_368#	1.19363e-17
C461	VGND#19	D_N#3	8.25868e-19
C462	VGND#3	A#6	1.97584e-18
C463	B#13	B#12	3.4024e-17
C464	D_N#3	a_47_88##14	1.4041e-17
C465	a_1191_368##3	B#4	1.21419e-18
C466	a_319_368##2	a_47_88##2	1.73299e-19
C467	Y#11	B#8	3.83796e-17
C468	VGND#3	B#8	1.73464e-19
C469	Y#10	VGND#9	3.95436e-17
C470	a_319_368#	a_47_88##3	5.63353e-19
C471	a_319_368##8	a_1191_368##5	2.65358e-17
C472	a_1191_368##4	a_1191_368##8	4.4294e-18
C473	VGND#3	B#10	1.85104e-19
C474	C#4	a_319_368##6	2.17949e-18
C475	VGND#10	B#10	2.53729e-19
C476	VGND#2	A	1.01027e-20
C477	a_47_88##3	Y#17	1.12849e-19
C478	VGND#3	B#11	3.00108e-19
C479	Y	B#6	5.64322e-18
C480	C#4	a_778_368##4	8.69695e-19
C481	C#1	B#13	4.26493e-18
C482	VGND#11	B#8	3.11416e-19
C483	Y	B#4	1.63474e-19
C484	a_319_368##4	C#4	9.97206e-21
C485	A	a_1191_368##3	5.84042e-17
C486	a_319_368#	a_47_88##2	6.55705e-19
C487	A	a_1191_368##2	8.93638e-17
C488	Y	C#2	1.09967e-17
C489	Y#11	B#10	3.34968e-17
C490	VGND#10	VGND#9	1.57066e-18
C491	a_1191_368##2	A#1	1.02058e-20
C492	C#9	C#1	3.96936e-17
C493	VGND#10	B#11	1.16221e-19
C494	a_47_88##2	Y#17	1.34669e-19
C495	a_1191_368##4	a_778_368##5	5.75251e-17
C496	B#10	VGND#11	1.68195e-17
C497	a_319_368##8	a_778_368##6	3.26529e-19
C498	a_319_368##6	a_1191_368##5	1.27917e-18
C499	Y#3	A	1.70463e-17
C500	Y#2	A	8.68825e-17
C501	a_47_88##14	a_47_88##15	2.2669e-18
C502	Y#11	B#11	1.51858e-18
C503	B	a_1191_368##4	7.94103e-17
C504	a_47_88##4	Y#14	3.70597e-17
C505	C#10	C#9	3.39247e-17
C506	VGND#10	Y#10	4.17628e-17
C507	Y#12	B#10	1.01445e-18
C508	a_47_88##4	a_319_368##3	4.24982e-17
C509	Y#14	a_47_88##3	1.81166e-18
C510	VPWR#4	C#6	4.60668e-20
C511	a_47_88##4	VPWR#9	1.68128e-17
C512	a_319_368##6	a_319_368##8	3.22701e-18
C513	a_1191_368##5	a_778_368##4	1.89435e-23
C514	VGND#11	B#11	3.21433e-17
C515	a_1191_368##2	A#9	1.69072e-17
C516	VGND#18	a_47_88##3	7.07215e-19
C517	Y#14	D_N#3	8.5085e-19
C518	C#12	C#10	3.76564e-17
C519	a_1191_368##5	a_1191_368##4	2.59148e-18
C520	VGND#8	C#6	2.78648e-18
C521	Y#4	B	8.21181e-17
C522	a_319_368##3	D_N#3	3.15158e-18
C523	Y#3	B	5.55915e-17
C524	VPWR#3	A#1	2.17085e-18
C525	Y#11	B#7	3.01514e-19
C526	VGND#8	a_47_88##6	2.74659e-18
C527	a_47_88##13	a_47_88##3	8.28607e-20
C528	Y#11	Y#10	2.74626e-18
C529	B#11	Y#12	1.40229e-17
C530	a_319_368##6	a_778_368##6	1.11593e-18
C531	B	a_778_368##2	7.86244e-19
C532	a_47_88##15	D_N#3	6.41316e-18
C533	VPWR#3	A#9	1.27896e-18
C534	VGND#1	A	3.6976e-19
C535	VPWR#6	D_N#3	7.3612e-18
C536	a_47_88#	C#12	4.58428e-17
C537	Y#1	A	4.3171e-17
C538	a_1191_368##3	A#11	1.04761e-19
C539	VPWR#3	A#11	6.07211e-18
C540	VGND#11	B#7	1.28024e-18
C541	C	Y#13	5.40115e-17
C542	VPWR#3	A#12	4.51119e-18
C543	D_N	VPWR#5	3.27641e-19
C544	Y#7	C	5.12099e-17
C545	a_1191_368##2	A#11	1.69951e-17
C546	Y#6	C	7.19536e-17
C547	VPWR#3	B#6	2.43712e-20
C548	VPWR#3	B#1	6.7826e-18
C549	a_47_88##7	a_47_88#	4.57935e-17
C550	Y#12	B#7	3.67908e-17
C551	Y#11	VGND#10	4.24132e-17
C552	VPWR#3	B#4	4.45325e-20
C553	VPWR#3	B#9	6.25511e-18
C554	a_1191_368##4	A#12	2.06841e-19
C555	VPWR#3	B#12	6.1508e-18
C556	a_47_88##13	a_47_88##10	3.52222e-20
C557	VGND#11	C#7	4.99836e-20
C558	a_319_368##6	a_778_368##4	4.36031e-17
C559	a_47_88##9	a_47_88##7	3.69943e-17
C560	B#7	VGND#12	1.29556e-17
C561	VPWR#3	B#13	4.52113e-18
C562	a_1191_368##3	A#12	1.22666e-17
C563	A#4	A#1	1.85551e-19
C564	Y#12	C#7	5.40814e-19
C565	VGND#11	VGND#10	1.39978e-18
C566	VGND	C#5	1.63856e-20
C567	a_1191_368##2	A#12	5.24866e-21
C568	A#11	A#4	2.31942e-19
C569	VGND	C#2	6.49864e-19
C570	Y#15	B#7	9.29953e-19
C571	a_47_88##11	a_47_88##9	4.58313e-17
C572	a_47_88##13	Y#9	1.13716e-18
C573	VGND	a_47_88##2	9.6036e-21
C574	VGND#3	A#5	4.08055e-20
C575	a_319_368##4	a_319_368##6	2.54741e-18
C576	a_47_88##5	a_47_88##4	3.62798e-18
C577	VGND#6	Y	5.28339e-17
C578	a_47_88##13	a_47_88##5	4.11064e-19
C579	C#7	VGND#12	1.69477e-17
C580	a_1191_368##4	B#1	1.38551e-18
C581	Y#13	a_319_368##2	2.08054e-17
C582	VPWR#4	C#1	4.47897e-18
C583	D_N#4	a_47_88##11	5.03276e-18
C584	VGND#3	A#2	2.87134e-19
C585	VPWR#4	C#9	4.4526e-18
C586	D_N	a_47_88##13	2.82411e-17
C587	a_1191_368##3	B#1	1.8716e-17
C588	D_N#3	a_47_88##5	8.45051e-18
C589	VGND#11	Y#11	4.22852e-17
C590	a_319_368##4	a_778_368##4	5.5383e-17
C591	VPWR#4	C#10	4.4526e-18
C592	Y#15	C#7	3.85338e-17
C593	D_N#3	D_N#1	1.12035e-17
C594	Y#7	Y	8.46362e-19
C595	Y#6	Y	3.39489e-18
C596	a_47_88##13	VGND#19	1.39374e-17
C597	VPWR#4	C#12	5.27731e-18
C598	D_N#5	D_N#4	3.7112e-17
C599	a_1191_368##2	B#1	2.04793e-21
C600	A#2	VPWR#7	8.55734e-19
C601	VPWR#4	a_47_88#	4.49269e-18
C602	VPWR	VPWR#5	1.16685e-16
C603	a_47_88##13	D_N#1	1.57729e-18
C604	B	a_1191_368##5	5.93696e-17
C605	VPWR#4	a_47_88##7	4.4864e-18
C606	a_1191_368##4	B#9	3.58595e-17
C607	VPWR#5	a_319_368##3	4.65485e-17
C608	VPWR#4	a_47_88##9	4.43427e-18
C609	Y#12	Y#11	3.88217e-18
C610	VGND#7	VGND#6	3.6022e-18
C611	Y#15	C#8	3.35159e-17
C612	C#4	C#1	7.13135e-18
C613	VPWR	a_1191_368##4	3.38188e-19
C614	a_47_88##2	C#5	7.97108e-19
C615	a_1191_368##3	B#9	1.08951e-19
C616	VPWR	Y#13	1.63025e-17
C617	VPWR	Y#8	5.1648e-18
C618	a_47_88##13	a_47_88##14	7.72018e-19
C619	VPWR	Y#7	4.22518e-18
C620	a_319_368##4	Y#18	2.47612e-20
C621	C#8	VGND#13	9.15871e-18
C622	VPWR	a_778_368##3	3.59834e-17
C623	VPWR	a_778_368##2	2.29597e-17
C624	Y	VGND#12	1.66133e-18
C625	Y#12	VGND#11	4.22852e-17
C626	Y#15	C#11	6.30721e-19
C627	VPWR	a_319_368##2	3.20858e-17
C628	VPWR	a_47_88##13	1.65441e-18
C629	Y#16	C#8	2.71094e-19
C630	VGND	VGND#14	7.80796e-17
C631	a_1191_368##4	B#12	2.50813e-17
C632	VGND	VGND#7	1.35572e-16
C633	a_319_368#	a_319_368##4	1.7863e-18
C634	VGND	VGND#6	1.25794e-16
C635	VGND	VGND#5	1.3292e-17
C636	C#11	VGND#13	2.38859e-17
C637	VGND	Y#13	5.06146e-18
C638	VGND	Y#8	2.03783e-17
C639	VPWR#3	A#4	2.04712e-20
C640	VGND	Y#7	4.28192e-18
C641	VGND	Y#6	3.0968e-18
C642	VGND	Y#4	1.41547e-18
C643	VGND#3	A#4	3.12842e-20
C644	VPWR#3	B#5	3.01991e-20
C645	Y#15	C#6	1.395e-19
C646	D_N#3	a_47_88##11	1.95734e-18
C647	D_N#6	D_N#1	6.906e-19
C648	Y	a_1191_368##5	1.81715e-17
C649	D_N	a_47_88##15	1.16792e-17
C650	C#11	Y#16	1.17285e-17
C651	Y	a_319_368##8	5.02556e-17
C652	D_N	VPWR#6	3.44867e-17
C653	VPWR#4	C#5	2.34727e-20
C654	Y	a_778_368##6	1.12692e-18
C655	A#5	VPWR#8	6.34406e-19
C656	A	A#1	2.44427e-18
C657	A#5	VNB	2.56866e-17
C658	Y	a_319_368##6	4.95359e-17
C659	VGND	a_47_88##13	8.60328e-19
C660	a_47_88##13	Y#8	7.2554e-19
C661	A#2	VNB	4.41673e-17
C662	B#6	VNB	3.86574e-17
C663	B#4	VNB	5.94579e-17
C664	Y	a_319_368##4	3.18746e-22
C665	C#5	VNB	3.05433e-17
C666	A	A#11	2.0582e-18
C667	C#2	VNB	2.77327e-17
C668	a_47_88##3	VNB	3.21153e-17
C669	a_47_88##2	VNB	3.78793e-17
C670	VGND	D_N#6	9.57706e-18
C671	VGND#2	VGND#1	1.22239e-18
C672	a_1191_368##4	B#13	6.9917e-19
C673	A	A#12	2.09146e-18
C674	VPWR#4	C#4	7.38396e-20
C675	Y#1	A#2	1.06895e-18
C676	Y#13	a_319_368##6	3.36192e-17
C677	A	B#1	2.46788e-18
C678	VPWR#4	C#2	2.31002e-20
C679	VGND#17	C#11	1.16637e-18
C680	A	B#9	4.29528e-19
C681	VGND#6	VGND#5	1.01806e-18
C682	VGND	Y#12	1.71053e-17
C683	VPWR	a_1191_368##5	1.05131e-17
C684	a_47_88##15	VPWR#5	1.66803e-17
C685	VPWR#4	a_47_88##3	1.45462e-20
C686	VPWR	a_319_368##8	8.36693e-18
C687	VGND	Y#15	1.72013e-17
C688	VGND	Y#16	1.51696e-17
C689	VPWR	a_319_368##6	1.05252e-17
C690	VGND	VGND#17	2.20541e-17
C691	B	B#1	9.74311e-19
C692	Y#16	C#6	3.13092e-17
C693	VPWR	a_778_368##4	2.14131e-17
C694	VPWR	a_319_368##4	2.36985e-17
C695	VPWR#4	a_47_88##2	3.60925e-20
C696	B	B#9	2.04414e-18
C697	VGND	Y#9	1.55592e-17
C698	VGND	VGND#19	2.2021e-17
C699	B	B#12	2.10602e-18
C700	Y#13	C#5	1.35641e-18
C701	VGND	a_47_88##14	2.56118e-17
C702	VPWR	Y#14	9.3957e-18
C703	VPWR	a_319_368##3	2.40055e-17
C704	B	B#13	2.0906e-18
C705	Y#14	a_319_368#	5.85911e-17
C706	Y	C#7	1.11557e-17
C707	VPWR	a_47_88##15	1.75663e-17
C708	B	C#1	7.12664e-19
C709	a_778_368##2	a_1191_368##8	8.73021e-19
C710	VPWR	VPWR#6	5.6259e-17
C711	C#6	VGND#17	2.26309e-17
C712	C	B#13	7.44483e-20
C713	C	C#1	4.03004e-18
C714	a_778_368##3	a_778_368##5	2.30551e-18
C715	VGND#2	Y#1	1.39846e-17
C716	VPWR#5	VNB	5.55416e-17
C717	C	C#9	2.10813e-18
C718	D_N#3	a_47_88##4	3.00864e-17
C719	Y#13	a_778_368##4	1.38467e-18
C720	Y#15	Y#12	1.96192e-18
C721	VGND#14	VNB	3.08292e-17
C722	VGND	Y#14	1.03836e-18
C723	C	C#10	2.12017e-18
C724	VGND#7	VNB	4.5928e-17
C725	VGND#6	VNB	4.64693e-17
C726	VGND#5	VNB	3.17567e-17
C727	VGND#4	VNB	2.6718e-17
C728	a_319_368##3	a_319_368#	1.69229e-18
C729	VGND#2	VNB	2.69732e-17
C730	C	a_47_88#	2.97942e-18
C731	VGND#4	VGND#9	3.82052e-19
C732	Y#13	VNB	5.36624e-19
C733	Y#8	VNB	4.06278e-18
C734	VPWR#3	A	1.11195e-17
C735	Y#7	VNB	5.52654e-18
C736	Y#6	VNB	1.39912e-18
C737	VPWR#6	VPWR#5	7.3202e-19
C738	Y#4	VNB	1.04612e-18
C739	Y#3	VNB	1.76674e-18
C740	VGND#3	A	1.13052e-17
C741	Y#2	VNB	1.49698e-18
C742	Y	B#9	2.80535e-19
C743	VGND#8	C#5	9.00073e-20
C744	a_778_368##3	VNB	1.2558e-17
C745	a_778_368##2	VNB	1.00844e-17
C746	Y	B#12	4.33785e-19
C747	VGND	B#11	2.33714e-19
C748	a_319_368##2	VNB	5.61494e-18
C749	Y	B#13	2.07595e-18
C750	VPWR#3	B	5.89548e-18
C751	a_47_88##6	VGND#17	2.75564e-17
C752	a_47_88##13	VNB	3.51846e-19
C753	Y	C#1	2.33124e-17
C754	VGND#3	B	5.07586e-18
C755	VGND	C#11	6.88296e-19
C756	Y	C#9	1.39175e-17
C757	D_N#6	VNB	2.04835e-17
C758	a_778_368##2	a_778_368##5	1.26724e-18
C759	VGND#18	C#6	1.61089e-19
C760	VGND#1	VNB	7.18898e-17
C761	VGND	C#6	2.36587e-19
C762	A	A#4	3.78126e-17
C763	Y#1	VNB	6.06269e-18
C764	Y	C#10	2.59632e-19
C765	VGND#9	VNB	3.73967e-20
C766	VGND	a_47_88##6	1.7884e-19
C767	Y#10	VNB	2.1281e-18
C768	VGND#10	VNB	2.17653e-18
C769	VGND	a_47_88##8	1.40704e-19
C770	Y	C#12	1.85128e-19
C771	a_319_368##3	Y#14	8.25364e-17
C772	Y#11	VNB	1.96561e-18
C773	VGND#11	VNB	4.23556e-19
C774	VGND	a_47_88##10	6.25755e-19
C775	Y#12	VNB	2.63465e-18
C776	Y	a_47_88#	2.19237e-19
C777	D_N#6	a_47_88##14	5.1285e-17
C778	VGND	a_47_88##5	4.74522e-19
C779	Y#15	VNB	1.96561e-18
C780	VGND	D_N#1	1.56002e-18
C781	VPWR	B#13	1.67648e-18
C782	Y#16	VNB	2.17406e-18
C783	VGND#17	VNB	8.14263e-18
C784	VPWR	C#1	1.64264e-18
C785	VGND#18	VNB	4.56457e-19
C786	B	B#5	2.01825e-17
C787	Y#9	VNB	5.18997e-18
C788	VPWR	C#9	1.64891e-18
C789	VGND#19	VNB	5.70233e-18
C790	a_47_88##14	VNB	2.54647e-17
C791	VPWR	C#10	1.61474e-18
C792	a_1191_368#	VNB	5.74647e-17
C793	a_778_368##3	a_1191_368##5	3.91726e-18
C794	a_47_88##6	Y#17	1.49295e-17
C795	VPWR#7	VNB	2.60465e-18
C796	A#5	A#4	4.0818e-18
C797	a_1191_368##6	VNB	2.1429e-18
C798	VPWR	C#12	7.33843e-19
C799	VPWR#8	VNB	4.09278e-19
C800	a_1191_368##7	VNB	4.87443e-18
C801	VPWR	a_47_88#	1.64379e-18
C802	a_778_368#	VNB	2.80701e-18
C803	Y#13	a_319_368##4	9.46889e-17
C804	VPWR	a_47_88##7	1.64756e-18
C805	a_1191_368##5	VNB	5.24124e-18
C806	a_319_368##8	VNB	2.54333e-18
C807	VPWR	a_47_88##9	1.58913e-18
C808	C	C#4	4.85176e-17
C809	VGND#8	a_47_88##2	4.22521e-20
C810	a_778_368##4	VNB	4.31388e-18
C811	VPWR	a_47_88##11	1.99198e-18
C812	a_319_368##4	VNB	2.52968e-18
C813	a_47_88##4	C	3.31477e-18
C814	Y#13	C#1	3.32815e-19
C815	VPWR	D_N#4	2.36873e-18
C816	Y#14	VNB	9.43624e-20
C817	a_319_368##3	VNB	1.55029e-17
C818	VPWR	D_N#5	2.65347e-18
C819	VPWR#9	VNB	1.49548e-17
C820	a_47_88##15	VNB	4.12978e-18
C821	VGND#17	a_47_88##8	7.57597e-19
C822	VPWR#6	VNB	7.18712e-17
C823	A#7	VNB	3.52413e-17
C824	A#4	A#2	4.08644e-18
C825	A#8	VNB	2.52657e-17
C826	VPWR	VPWR#3	4.15341e-17
C827	A#10	VNB	2.53263e-17
C828	VPWR#5	a_47_88#	3.79709e-20
C829	A#6	VNB	2.8933e-17
C830	VGND#5	VGND#4	1.35555e-18
C831	VGND#18	a_47_88##6	3.49779e-19
C832	B#8	VNB	2.95677e-17
C833	Y	B#5	1.84553e-19
C834	B#10	VNB	2.71715e-17
C835	D_N	D_N#3	2.68729e-17
C836	B#11	VNB	2.58476e-17
C837	VPWR	VPWR#4	1.8692e-16
C838	B#7	VNB	2.81096e-17
C839	Y	C#4	4.97046e-18
C840	C#7	VNB	2.58133e-17
C841	C#8	VNB	2.48309e-17
C842	C#11	VNB	2.27195e-17
C843	C#6	VNB	3.74361e-17
C844	a_47_88##6	VNB	2.88539e-17
C845	a_47_88##8	VNB	2.67204e-17
C846	a_47_88##10	VNB	2.54241e-17
C847	a_47_88##5	VNB	3.30178e-17
C848	D_N#1	VNB	2.85852e-17
C849	B	A	3.2089e-17
C850	a_778_368##2	a_1191_368##5	3.3733e-17
C851	A#1	VNB	3.87211e-17
C852	VPWR	a_47_88##4	1.14812e-17
C853	A#9	VNB	2.99565e-17
C854	VGND	VGND#8	6.17643e-17
C855	A#11	VNB	3.06996e-17
C856	a_778_368##3	B#12	1.97856e-19
C857	A#12	VNB	2.79373e-17
C858	B#1	VNB	3.10565e-17
C859	a_47_88##8	Y#17	1.49295e-17
C860	B#9	VNB	3.1899e-17
C861	B#12	VNB	3.22882e-17
C862	B#13	VNB	3.35856e-17
C863	C#1	VNB	5.08265e-17
C864	C#9	VNB	3.19895e-17
C865	VGND	a_47_88##4	8.80642e-18
C866	C#10	VNB	3.21019e-17
C867	C#12	VNB	2.95935e-17
C868	VGND	D_N#3	2.05811e-18
C869	a_47_88#	VNB	4.71285e-17
C870	VPWR#9	a_319_368##3	7.04827e-17
C871	a_47_88##7	VNB	3.33763e-17
C872	a_47_88##9	VNB	3.22869e-17
C873	a_47_88##11	VNB	3.56919e-17
C874	D_N#4	VNB	3.38816e-17
C875	Y	B	4.74529e-17
C876	D_N#5	VNB	3.84821e-17
C877	a_778_368##3	a_319_368##8	3.62815e-17
C878	VPWR#3	VNB	2.68268e-16
C879	C	Y	8.61389e-17
C880	VGND#3	VNB	1.76371e-16
C881	VPWR	B	6.66779e-18
C882	a_778_368##2	B#12	2.11859e-17
C883	VPWR#4	VNB	1.0868e-16
C884	VGND#8	VNB	3.27746e-17
C885	A#4	VNB	5.55108e-17
C886	VPWR	C	8.76502e-18
C887	B#5	VNB	3.07795e-17
C888	VGND#17	a_47_88##10	2.84905e-19
C889	C#4	VNB	8.60724e-17
C890	VGND	B	4.76276e-18
C891	VPWR	D_N	6.5255e-18
C892	a_47_88##4	VNB	8.58842e-17
C893	D_N#3	VNB	1.69962e-16
C894	VGND	C	5.75357e-18
C895	VPWR	Y	7.51564e-18
C896	a_47_88##8	VGND#18	1.71329e-17
C897	VGND	Y	5.56054e-18
C898	A	VNB	3.22056e-17
C899	B	VNB	2.2116e-17
C900	C	VNB	9.87157e-18
C901	a_47_88##3	a_47_88##2	1.93632e-18
C902	Y#13	C#9	4.27753e-19
C903	D_N	VNB	1.49661e-17
C904	Y	VNB	1.45351e-17
C905	VPWR	VNB	3.19793e-16
C906	VGND	VNB	2.84798e-16
C907	VGND#1	a_1191_368#	1.43673e-17
C908	VPWR#2	A#4	2.97514e-20
C909	VGND#15	a_47_88##13	1.4314e-19
C910	VGND#15	VNB	6.2874e-17
C911	VPWR#2	A#1	4.64289e-18
C912	VGND#15	D_N#6	2.32155e-18
C913	VPWR#2	A#12	8.74044e-20
C914	VPWR#2	VNB	4.3596e-17
C915	VGND	VGND#15	1.06751e-16
C916	VGND#15	VGND#14	1.10644e-18
C917	VGND#15	D_N#1	9.76757e-19
C918	VGND#15	D_N#3	1.94317e-18
C919	a_1191_368##6	VPWR#2	8.43957e-18
C920	VPWR#2	A#9	5.34378e-18
C921	a_1191_368##2	VPWR#2	3.13618e-19
C922	VGND#15	a_47_88##14	2.75343e-17
C923	a_1191_368#	VPWR#2	1.78954e-17
C924	VPWR#3	VPWR#2	9.05268e-17
C925	VGND#15	Y#9	7.22348e-18
C926	VPWR#2	A#11	5.45681e-19
C927	VGND#15	a_47_88##5	3.84173e-18
C928	VGND#15	a_47_88##4	5.86439e-19
*
*
.ENDS sky130_fd_sc_hs__nor4b_4
*
