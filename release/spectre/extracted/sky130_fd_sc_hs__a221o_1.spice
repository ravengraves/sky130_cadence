* Extracted by Quantus, converted by sky130cad/quantus.py
*
*
*
*                       LINUX           Wed Nov 18 08:06:42 2026
*
*
*
*  PROGRAM  advgen
*
*  Name           : advgen - Quantus - (64-bit)
*  Version        : 25.1.0-p047
*  Build Date     : Thu Dec 11 23:20:30 PST 2025
*
*  HSPICE LIBRARY
*
*  OPERATING_TEMPERATURE 150
*  QRC_TECH_DIR <path>/tech
*
*
*

*
.SUBCKT sky130_fd_sc_hs__a221o_1 VPB VNB VGND VPWR X C1 A2 B1 B2 A1
*
*
*  caps2d version: 10
*
*
*       TRANSISTOR CARDS
*
*
XM9 X#3 a_148_260# VGND#7 VNB sky130_fd_pr__nfet_01v8_lvt l=0.15 w=0.74 ad=0.1961 as=0.578975 pd=2.01 ps=3.21
XM1 VGND#7 A2#1 a_417_79# VNB sky130_fd_pr__nfet_01v8_lvt l=0.15 w=0.64 ad=0.578975 as=0.1344 pd=3.21 ps=1.7
XM3 a_417_79# A1#1 a_148_260##9 VNB sky130_fd_pr__nfet_01v8_lvt l=0.15 w=0.64 ad=0.1344 as=0.2496 pd=1.7 ps=2.06
XM5 a_148_260##9 B1#1 a_597_79# VNB sky130_fd_pr__nfet_01v8_lvt l=0.15 w=0.64 ad=0.2496 as=0.1344 pd=2.06 ps=1.7
XM10 a_597_79# B2#3 VGND#6 VNB sky130_fd_pr__nfet_01v8_lvt l=0.15 w=0.64 ad=0.1344 as=0.2859 pd=1.7 ps=2.5
XM8 VGND#6 C1#2 a_148_260##8 VNB sky130_fd_pr__nfet_01v8_lvt l=0.15 w=0.64 ad=0.2859 as=0.1696 pd=2.5 ps=1.81
XM4 X#1 a_148_260##3 VPWR#6 VPB sky130_fd_pr__pfet_01v8 l=0.15 w=1.12 ad=0.308 as=0.398 pd=2.79 ps=2.97
XM11 VPWR#6 A2#3 a_310_392##2 VPB sky130_fd_pr__pfet_01v8 l=0.15 w=1 ad=0.398 as=0.3 pd=2.97 ps=2.6
XM6 a_310_392##2 A1#3 VPWR#5 VPB sky130_fd_pr__pfet_01v8 l=0.15 w=1 ad=0.3 as=0.275 pd=2.6 ps=2.55
XM7 a_509_392##2 B1#3 a_310_392# VPB sky130_fd_pr__pfet_01v8 l=0.15 w=1 ad=0.275 as=0.3 pd=2.55 ps=2.6
XM2 a_310_392# B2#1 a_509_392# VPB sky130_fd_pr__pfet_01v8 l=0.15 w=1 ad=0.3 as=0.33 pd=2.6 ps=2.66
XM0 a_509_392# C1#3 a_148_260##4 VPB sky130_fd_pr__pfet_01v8 l=0.15 w=1 ad=0.33 as=0.275 pd=2.66 ps=2.55
*
*
*       RESISTOR AND CAP/DIODE CARDS
*
Rg1	a_148_260#	a_148_260##2	353.846649
Rg2	a_148_260##2	a_148_260##3	456.846832
Rg3	A2#1	A2#2	544.115540
Rg4	A2#2	A2#3	453.277618
Rg5	A1#1	A1#2	499.369446
Rg6	A1#2	A1#3	429.386841
Rg7	B1#1	B1#2	454.272491
Rg8	B1#2	B1#3	409.090576
Rg9	B2#1	B2#2	409.090576
Rg10	B2#2	B2#3	454.272491
Rg11	C1#1	C1#2	319.611084
Rg12	C1#2	C1#3	803.013733
Rf1	X#2	X	0.174092
Rf2	X	X#3	53.172504
Rf3	X#1	X#2	5.000000
Rf4	A2#2	A2#5	162.577271
Rf5	A2#6	A2	2.344470
Rf6	A2#5	A2#6	6.723260
Rf7	A1#2	A1	161.413818
Rf8	B1#4	B1	0.715956
Rf9	B1#2	B1#6	160.948761
Rf10	B1#4	B1#6	7.189707
Rf11	a_310_392#	a_310_392##2	139.850189
Rf12	a_509_392#	a_509_392##2	119.326836
Rf13	B2#2	B2#5	160.868759
Rf14	B2#6	B2	0.635961
Rf15	B2#5	B2#6	9.586276
Rf16	C1#1	C1#5	161.023331
Rf17	C1#6	C1	0.790535
Rf18	C1#5	C1#6	8.463963
Rf19	a_148_260##4	a_148_260##5	53.331226
Rf20	a_148_260##5	a_148_260##6	91.087021
Rf21	a_148_260##6	a_148_260##2	286.857239
Rf22	a_148_260##5	a_148_260##8	23.419731
Rf23	a_148_260##6	a_148_260##9	17.898088
Rf25	VGND#2	VGND#3	98.208038
Rf26	VGND#3	VGND#4	48.179596
Rf28	VGND#2	VGND#6	28.873934
Rf29	VGND#4	VGND#7	16.108984
Rf31	VPWR#2	VPWR#3	69.613411
Rf33	VPWR#2	VPWR#5	34.638962
Rf34	VPWR#3	VPWR#6	44.934231
Re1	VPWR#2	VPWR	1.091357
Re2	VGND	VGND#3	1.091398
*
*       CAPACITOR CARDS
*
*
C1	a_148_260##5	a_148_260##8	6.64958e-19
C2	a_148_260##6	VGND#6	2.67429e-17
C3	a_148_260##5	VGND#6	4.49586e-17
C4	a_148_260##6	a_148_260##9	9.87936e-19
C5	VGND#6	C1#5	1.77994e-17
C6	X#3	a_148_260##6	1.17256e-18
C7	a_148_260##6	a_310_392#	1.33585e-17
C8	a_148_260##6	a_310_392##2	3.33008e-18
C9	B2#5	a_509_392#	2.61022e-18
C10	B2#5	a_310_392#	2.28829e-17
C11	a_148_260##6	C1#2	5.27532e-19
C12	a_148_260##5	C1#2	4.6931e-17
C13	a_148_260##6	B2#3	1.57581e-17
C14	a_148_260##5	B2#3	1.33238e-18
C15	a_148_260##6	B1#1	3.78254e-17
C16	a_148_260##5	B1#1	1.786e-19
C17	a_148_260##6	A1#1	4.22451e-17
C18	C1#5	B2#3	5.42604e-19
C19	a_148_260##6	A2#1	2.53125e-17
C20	a_148_260##6	a_148_260#	4.7394e-19
C21	A2#5	a_310_392##2	1.01432e-17
C22	a_148_260##5	C1#3	1.76306e-19
C23	a_509_392#	a_148_260##4	7.75317e-17
C24	C1#2	a_148_260##8	6.01031e-18
C25	a_509_392#	a_310_392#	7.26467e-17
C26	C1#2	VGND#6	1.6914e-17
C27	a_509_392##2	a_509_392#	2.28829e-18
C28	VGND#6	B2#3	4.0299e-17
C29	a_310_392#	a_509_392##2	8.92148e-17
C30	VGND#6	B1#1	4.60033e-18
C31	a_310_392#	VPWR#5	9.92919e-18
C32	VGND#6	A1#1	5.08696e-19
C33	VPWR#5	a_509_392##2	6.40874e-17
C34	a_310_392##2	a_310_392#	1.36184e-18
C35	B1#1	a_148_260##9	1.56562e-17
C36	VGND#6	A2#1	2.57455e-19
C37	A1#1	a_148_260##9	1.56562e-17
C38	a_310_392##2	VPWR#5	7.7399e-17
C39	VPWR#6	VPWR#5	2.40284e-18
C40	X#3	A1#1	2.42333e-19
C41	VPWR#6	a_310_392##2	8.17715e-17
C42	A2#1	VGND#7	2.15793e-17
C43	VGND#3	a_148_260##6	1.83567e-17
C44	X#3	A2#1	8.18518e-19
C45	a_148_260#	VGND#7	2.17103e-17
C46	X#3	a_148_260#	2.36235e-17
C47	a_148_260##5	C1#1	6.15688e-18
C48	a_148_260##6	B2#2	6.00266e-18
C49	a_148_260##5	B2#2	5.18898e-18
C50	C1#5	C1#1	1.70422e-17
C51	A2#5	a_148_260##3	1.58267e-18
C52	a_148_260##4	C1#3	5.25786e-17
C53	B2#3	C1#2	1.75715e-17
C54	C1#3	a_509_392#	2.76546e-17
C55	a_148_260##6	B1#2	3.8181e-17
C56	a_310_392##2	A2#1	1.73037e-18
C57	a_148_260##4	B2#1	2.50213e-18
C58	a_148_260##5	B1#2	6.4924e-19
C59	a_310_392#	C1#3	1.8501e-18
C60	a_509_392#	B2#1	4.4234e-17
C61	a_148_260##4	B1#3	5.59229e-19
C62	a_509_392##2	C1#3	1.96226e-19
C63	B1#1	B2#3	6.13827e-17
C64	a_148_260##6	A1#2	7.85927e-18
C65	a_310_392#	B2#1	4.93717e-17
C66	B2#5	B2#2	1.68536e-17
C67	a_148_260##5	A1#2	3.30576e-19
C68	a_509_392#	B1#3	3.89455e-19
C69	VPWR#5	C1#3	8.35611e-20
C70	a_509_392##2	B2#1	4.6339e-19
C71	a_148_260##4	A1#3	2.40494e-19
C72	a_310_392#	B1#3	5.54394e-17
C73	a_509_392#	A1#3	5.9961e-20
C74	VPWR#5	B2#1	2.03279e-19
C75	A1#1	B1#1	2.40403e-17
C76	a_148_260##6	A2#2	4.85689e-19
C77	B1#2	B2#5	2.88861e-17
C78	a_509_392##2	B1#3	3.60847e-17
C79	a_310_392#	A1#3	4.3165e-19
C80	VPWR#5	B1#3	2.33083e-18
C81	a_509_392##2	A1#3	1.37284e-18
C82	a_148_260##2	a_148_260##6	2.16536e-18
C83	a_310_392#	A2#3	1.2214e-19
C84	a_310_392##2	B1#3	3.52044e-19
C85	A2#1	A1#1	6.0915e-17
C86	VPWR#5	A1#3	5.8158e-17
C87	VGND#6	C1#1	8.65872e-18
C88	a_310_392##2	A1#3	3.16728e-17
C89	VPWR#5	A2#3	2.39751e-18
C90	a_148_260#	A2#1	2.99585e-18
C91	VPWR#6	A1#3	6.9665e-19
C92	a_310_392##2	A2#3	4.84595e-17
C93	VGND#6	B2#2	1.03473e-18
C94	VPWR#5	a_148_260##3	4.5341e-19
C95	A2#3	VPWR#6	2.49629e-17
C96	a_310_392##2	a_148_260##3	2.07885e-18
C97	a_148_260##3	VPWR#6	3.41931e-17
C98	a_148_260##3	X#1	1.06253e-17
C99	A2#5	A2#2	1.57924e-17
C100	a_148_260##4	B2#2	7.9944e-19
C101	a_509_392#	B2#2	2.02894e-18
C102	a_148_260##2	A2#5	4.91349e-17
C103	B2#1	C1#3	3.73132e-17
C104	a_148_260##4	B1#2	1.73174e-19
C105	B1#2	a_310_392#	3.11554e-17
C106	a_148_260##4	A1#2	5.10385e-20
C107	A2#2	VGND#7	2.38369e-18
C108	B1#3	B2#1	4.18813e-17
C109	B1#2	a_509_392##2	9.58286e-19
C110	VGND#3	B2#3	3.65e-20
C111	a_148_260##6	a_417_79#	2.66266e-18
C112	a_310_392#	A1#2	5.54976e-18
C113	a_148_260##2	VGND#7	1.27192e-18
C114	B2#3	C1#1	1.04735e-17
C115	A1#3	B1#3	5.61176e-18
C116	a_148_260##2	X#3	5.80794e-17
C117	VGND#3	A1#1	5.33431e-18
C118	VPWR#5	A1#2	1.8702e-18
C119	B2#2	C1#2	1.94984e-17
C120	a_310_392##2	A1#2	2.89068e-18
C121	VGND#3	A2#1	7.23941e-18
C122	A2#3	A1#3	4.20219e-17
C123	a_310_392##2	A2#2	3.96097e-19
C124	VPWR#6	A2#2	3.49983e-18
C125	a_148_260##6	A1	1.95115e-17
C126	A1#1	B1#2	2.51893e-19
C127	a_148_260##3	A2#3	3.77899e-17
C128	a_148_260##2	VPWR#6	1.4126e-17
C129	a_148_260##6	a_148_260##5	1.95761e-18
C130	a_148_260##2	X#1	1.10652e-18
C131	B2#2	C1#3	1.73894e-17
C132	A2#1	A1#2	2.18818e-17
C133	a_148_260##5	B2	3.72745e-17
C134	a_148_260##2	A1#1	4.05449e-21
C135	a_148_260#	A2#2	4.5591e-18
C136	a_148_260##6	B1	2.03313e-17
C137	a_148_260##2	a_148_260#	4.73482e-18
C138	A1#2	B1#3	1.53605e-19
C139	a_148_260##6	A2	1.04666e-17
C140	A2#3	A1#2	3.37233e-18
C141	B2#3	a_597_79#	1.34792e-17
C142	B1#1	a_597_79#	1.34792e-17
C143	A1	a_148_260##4	1.01959e-18
C144	a_148_260##3	A2#2	3.75491e-18
C145	VGND#3	B1#2	7.77593e-20
C146	A1	a_310_392#	8.06125e-18
C147	C1	a_148_260##5	3.01083e-17
C148	VGND#3	A1#2	1.51283e-19
C149	A1	VPWR#5	3.1615e-18
C150	B2	a_148_260##4	2.18356e-17
C151	A1#1	a_417_79#	1.33303e-17
C152	A1	a_310_392##2	3.30711e-17
C153	B1#2	B2#2	4.50483e-17
C154	B2	a_509_392#	1.86597e-17
C155	A2#1	a_417_79#	1.33303e-17
C156	A1#2	B1#2	3.60853e-17
C157	B1	a_310_392#	1.73629e-17
C158	B1	a_509_392##2	1.18556e-18
C159	a_148_260##2	B2#2	9.26026e-20
C160	B2	C1#2	4.03715e-18
C161	A1	A2#1	3.70189e-18
C162	A2#2	A1#2	2.42149e-17
C163	C1	a_148_260##8	1.01527e-18
C164	a_148_260##2	B1#2	1.62119e-19
C165	VGND#6	C1	2.01311e-17
C166	a_148_260##2	A1#2	1.80153e-19
C167	a_148_260##2	A2#2	5.48499e-17
C168	X	A2#5	5.08384e-18
C169	A2	a_310_392##2	2.06656e-17
C170	B2	C1#3	4.37856e-18
C171	VPWR	B2#5	2.26388e-18
C172	A2	C1#2	3.74751e-19
C173	a_148_260##6	B2#5	2.04184e-17
C174	X#3	X	6.81245e-18
C175	VGND	a_148_260##6	2.90539e-17
C176	VPWR	A2#5	3.61606e-18
C177	A2	A2#1	2.09788e-18
C178	VGND	a_148_260##5	1.05598e-17
C179	C1	C1#2	3.22682e-18
C180	C1	B2#3	5.8592e-19
C181	VGND	C1#5	1.49566e-17
C182	VGND	B2#5	1.4355e-18
C183	a_148_260##5	B2#5	9.82886e-18
C184	X	VPWR#6	8.14426e-17
C185	X	X#1	2.9248e-18
C186	VPWR	a_148_260##4	1.76746e-17
C187	A1	B1#2	2.4237e-18
C188	VPWR	a_509_392#	1.92149e-17
C189	VPWR	a_310_392#	1.16046e-17
C190	VGND	A2#5	1.63009e-18
C191	VPWR	a_509_392##2	2.17e-17
C192	B2	B2#2	4.46171e-18
C193	A1	A1#2	2.1288e-17
C194	VPWR	VPWR#5	2.19381e-17
C195	VGND	VGND#6	2.51649e-17
C196	a_148_260##6	VNB	1.23579e-17
C197	VPWR	a_310_392##2	1.55925e-17
C198	A1	A2#2	2.15137e-18
C199	a_148_260##5	VNB	3.79293e-17
C200	C1#5	VNB	7.98857e-18
C201	VGND	X#3	3.39004e-17
C202	B2#5	VNB	2.22701e-19
C203	B1	B1#2	4.42384e-18
C204	X	B1#3	3.27744e-19
C205	B1	A1#2	9.07977e-18
C206	A2	B2#2	4.46342e-19
C207	X	A1#3	5.60784e-19
C208	A2#5	VNB	4.04762e-20
C209	X	A2#3	4.26271e-18
C210	A2	B1#2	1.09012e-18
C211	X	a_148_260##3	4.71879e-17
C212	C1	C1#1	4.13506e-18
C213	VPWR	C1#3	5.92617e-18
C214	A2	A1#2	9.65209e-18
C215	VGND#6	VNB	3.77284e-19
C216	VPWR	B2#1	1.59867e-18
C217	VGND	B2#3	4.25447e-18
C218	A2	A2#2	7.01272e-18
C219	VPWR	B1#3	2.03255e-18
C220	VGND	B1#1	1.03634e-17
C221	VPWR	A1#3	1.01212e-18
C222	X#3	VNB	7.57749e-17
C223	VGND	A1#1	1.02055e-17
C224	a_148_260##2	A2	1.49673e-17
C225	a_148_260##4	VNB	5.89489e-17
C226	VGND	A2#1	2.38337e-18
C227	VPWR	A2#3	2.45493e-18
C228	a_509_392#	VNB	7.17897e-18
C229	VGND	a_148_260#	1.28638e-18
C230	a_310_392#	VNB	8.04068e-18
C231	VPWR	a_148_260##3	3.20258e-18
C232	a_509_392##2	VNB	1.30954e-17
C233	VPWR#5	VNB	8.3427e-18
C234	a_310_392##2	VNB	3.77695e-18
C235	X	B1#2	3.14083e-20
C236	VPWR#6	VNB	3.83e-18
C237	X	A1#2	1.00043e-18
C238	C1#2	VNB	3.89262e-17
C239	B2#3	VNB	2.76172e-17
C240	X	A2#2	1.55064e-19
C241	B1#1	VNB	2.96029e-17
C242	A1#1	VNB	2.97287e-17
C243	X	a_148_260##2	4.67001e-17
C244	A2#1	VNB	3.28161e-17
C245	VPWR	B1#2	9.70566e-19
C246	a_148_260#	VNB	3.59615e-17
C247	A1	B1	2.05555e-17
C248	C1#3	VNB	5.40001e-17
C249	VGND	VGND#3	1.86311e-17
C250	B2#1	VNB	3.14734e-17
C251	VGND	C1#1	3.49432e-18
C252	B1#3	VNB	3.22371e-17
C253	VPWR	a_148_260##2	3.97716e-18
C254	A2	A1	2.84584e-17
C255	A1#3	VNB	2.72892e-17
C256	A2#3	VNB	3.94593e-17
C257	VGND	B1#2	1.15784e-18
C258	a_148_260##3	VNB	4.79837e-17
C259	VGND	A1#2	6.59955e-19
C260	VGND#3	VNB	2.10133e-16
C261	VGND	a_148_260##2	7.49052e-18
C262	A2	B1	9.52234e-19
C263	C1#1	VNB	5.82839e-17
C264	B2#2	VNB	4.0783e-17
C265	X	A1	1.18178e-18
C266	B1#2	VNB	3.65415e-17
C267	A1#2	VNB	5.15435e-17
C268	A2#2	VNB	4.51168e-17
C269	VPWR	A1	1.80912e-18
C270	a_148_260##2	VNB	5.68354e-17
C271	VPWR	B2	2.35717e-18
C272	VPWR	B1	1.36645e-18
C273	VGND	A1	2.80528e-18
C274	VGND	B2	1.33359e-18
C275	VPWR	A2	1.17946e-18
C276	VGND	B1	1.2053e-18
C277	A1	VNB	3.06958e-18
C278	VGND	A2	1.62048e-18
C279	B2	VNB	4.18976e-19
C280	VPWR	X	3.5267e-17
C281	A2	VNB	2.62494e-18
C282	VGND	X	2.87492e-18
C283	C1	VNB	1.0182e-17
C284	X	VNB	1.01808e-16
C285	VPWR	VNB	7.25139e-17
C286	VGND	VNB	6.78631e-17
C287	VGND#4	VGND#6	1.71726e-18
C288	VGND#4	a_148_260##6	3.90704e-17
C289	VGND#2	B2#3	3.57661e-18
C290	VPWR#2	C1#3	7.68286e-18
C291	VGND#2	C1#1	1.31697e-17
C292	VGND#4	a_148_260#	2.80895e-17
C293	VPWR#2	B1#3	4.43469e-18
C294	VGND#2	C1#5	2.98769e-17
C295	a_148_260##4	VPWR#2	2.07645e-17
C296	VGND#2	VNB	5.61549e-17
C297	VPWR#3	A2#3	9.78028e-18
C298	a_310_392#	VPWR#2	9.63515e-19
C299	VGND#4	VNB	8.01822e-17
C300	VPWR#3	VPWR#5	3.00237e-19
C301	VGND#2	a_148_260##5	1.92285e-18
C302	VGND#4	VGND#7	1.10229e-17
C303	VPWR	VPWR#2	6.1326e-17
C304	VPWR	VPWR#3	6.36266e-17
C305	VGND#4	B1#1	4.65524e-19
C306	VPWR#2	B2#2	1.73883e-20
C307	VPWR#2	VNB	2.78276e-16
C308	VPWR#3	VNB	6.15736e-17
C309	A2#5	VPWR#3	6.77447e-19
C310	VPWR#2	A1#2	1.92111e-19
C311	VGND#4	a_148_260##2	5.94513e-17
C312	a_148_260##2	VPWR#3	4.21736e-19
C313	VPWR#2	A2#1	2.88884e-21
C314	VGND#3	VGND#2	6.56662e-17
C315	VGND#4	A2#1	3.15546e-17
C316	VGND#4	C1#1	3.51615e-19
C317	VGND	VGND#2	4.17503e-17
C318	VPWR#2	B2#1	4.44729e-18
C319	VGND	VGND#4	1.11358e-16
C320	VGND#2	B1#1	5.36719e-18
C321	VPWR#2	A1#3	1.82982e-18
C322	VPWR#3	A1#3	5.50237e-19
C323	a_509_392#	VPWR#2	4.55525e-17
C324	B2	VPWR#2	5.93736e-19
C325	VGND#4	VGND#2	2.86431e-19
C326	VGND#2	a_148_260##6	5.39623e-18
C327	VPWR#3	a_148_260##3	1.01299e-17
C328	a_509_392##2	VPWR#2	4.69008e-17
C329	VGND#4	B2#3	2.63149e-19
C330	VPWR#2	VPWR#3	7.15459e-17
C331	a_310_392##2	VPWR#2	7.13533e-18
C332	a_310_392##2	VPWR#3	6.88174e-18
C333	X	VPWR#3	4.27526e-17
C334	VGND#4	A2#2	6.62614e-18
C335	VPWR#2	B1#2	2.73245e-20
C336	VGND#4	X#3	8.91848e-17
C337	VGND#4	A1#1	4.25607e-18
C338	VPWR#2	A2#2	2.19803e-20
C339	VGND#3	VGND#4	8.61698e-17
*
*
.ENDS sky130_fd_sc_hs__a221o_1
*
