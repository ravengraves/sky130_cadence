* Extracted by Quantus, converted by sky130cad/quantus.py
*
*
*
*                       LINUX           Wed Nov 18 08:18:26 2026
*
*
*
*  PROGRAM  advgen
*
*  Name           : advgen - Quantus - (64-bit)
*  Version        : 25.1.0-p047
*  Build Date     : Thu Dec 11 23:20:30 PST 2025
*
*  HSPICE LIBRARY
*
*  OPERATING_TEMPERATURE 150
*  QRC_TECH_DIR <path>/tech
*
*
*

*
.SUBCKT sky130_fd_sc_hs__and4_2 VPB VNB VGND VPWR X B C D A
*
*
*  caps2d version: 10
*
*
*       TRANSISTOR CARDS
*
*
XM5 a_56_74##12 A#1 a_143_74# VNB sky130_fd_pr__nfet_01v8_lvt l=0.15 w=0.74 ad=0.2109 as=0.1776 pd=2.05 ps=1.96
XM3 a_143_74# B#3 a_221_74# VNB sky130_fd_pr__nfet_01v8_lvt l=0.15 w=0.74 ad=0.1776 as=0.3108 pd=1.96 ps=2.32
XM11 a_221_74# C#3 a_335_74# VNB sky130_fd_pr__nfet_01v8_lvt l=0.15 w=0.74 ad=0.3108 as=0.3108 pd=2.32 ps=2.32
XM1 a_335_74# D#1 VGND#6 VNB sky130_fd_pr__nfet_01v8_lvt l=0.15 w=0.74 ad=0.3108 as=0.3108 pd=2.32 ps=2.32
XM8 X#3 a_56_74##4 VGND#6 VNB sky130_fd_pr__nfet_01v8_lvt l=0.15 w=0.74 ad=0.2072 as=0.3108 pd=2.04 ps=2.32
XM10 VGND#2 a_56_74##5 X#3 VNB sky130_fd_pr__nfet_01v8_lvt l=0.15 w=0.74 ad=0.2738 as=0.2072 pd=2.22 ps=2.04
XM7 VPWR#5 A#4 a_56_74##13 VPB sky130_fd_pr__pfet_01v8 l=0.15 w=1 ad=0.385 as=0.3 pd=2.77 ps=2.6
XM9 a_56_74##13 B#1 VPWR#7 VPB sky130_fd_pr__pfet_01v8 l=0.15 w=1 ad=0.3 as=0.51 pd=2.6 ps=3.02
XM0 VPWR#7 C#1 a_56_74##9 VPB sky130_fd_pr__pfet_01v8 l=0.15 w=1 ad=0.51 as=0.3 pd=3.02 ps=2.6
XM4 a_56_74##9 D#3 VPWR#6 VPB sky130_fd_pr__pfet_01v8 l=0.15 w=1 ad=0.3 as=0.5018 pd=2.6 ps=3.18
XM2 X#1 a_56_74##7 VPWR#6 VPB sky130_fd_pr__pfet_01v8 l=0.15 w=1.12 ad=0.336 as=0.5018 pd=2.84 ps=3.18
XM6 VPWR#1 a_56_74# X#1 VPB sky130_fd_pr__pfet_01v8 l=0.15 w=1.12 ad=0.4536 as=0.336 pd=3.05 ps=2.84
*
*
*       RESISTOR AND CAP/DIODE CARDS
*
Rg1	A#1	A#2	368.897400
Rg2	A#2	A#3	60.132961
Rg3	A#2	A#4	489.880371
Rg4	B#1	B#2	509.830780
Rg5	B#2	B#3	307.937683
Rg6	C#1	C#2	509.830780
Rg7	C#2	C#3	307.937683
Rg8	D#1	D#2	307.937683
Rg9	D#2	D#3	548.543640
Rg10	a_56_74#	a_56_74##2	472.779266
Rg11	a_56_74##2	a_56_74##3	74.090141
Rg12	a_56_74##3	a_56_74##4	363.049255
Rg13	a_56_74##2	a_56_74##5	372.360931
Rg14	a_56_74##2	a_56_74##6	63.717129
Rg15	a_56_74##3	a_56_74##7	480.564056
Rf1	A#5	A#3	160.782516
Rf2	A	A#7	0.549716
Rf3	A#5	A#7	7.873454
Rf4	B	B#2	163.493912
Rf5	C	C#2	163.775864
Rf6	D	D#4	1.548413
Rf7	D#5	D#2	161.781219
Rf8	D#4	D#5	3.529830
Rf9	X	X#2	1.637943
Rf10	X#2	X	10.482834
Rf11	X	X#3	15.443521
Rf12	X#1	X#2	15.000000
Rf13	a_56_74##6	a_56_74##10	301.420654
Rf14	a_56_74##10	a_56_74##11	91.811630
Rf15	a_56_74##11	a_56_74##12	81.215698
Rf16	a_56_74##11	a_56_74##13	28.735754
Rf17	a_56_74##9	a_56_74##10	5.000000
Rf18	VPWR#1	VPWR#2	106.238174
Rf19	VPWR#2	VPWR#3	39.787987
Rf20	VPWR#3	VPWR#4	39.422733
Rf21	VPWR#4	VPWR#5	113.958405
Rf22	VPWR#2	VPWR#6	32.735970
Rf23	VPWR#4	VPWR#8	16.948624
Rf24	VPWR#8	VPWR#7	39.407707
Rf25	VPWR#7	VPWR#8	15.000000
Rf27	VGND#3	VGND#4	63.151726
Rf28	VGND#4	VGND#5	37.231220
Rf29	VGND#4	VGND#6	32.125244
Rf30	VGND#2	VGND#3	7.500000
Re1	VPWR#3	VPWR	1.227783
Re2	VGND	VGND#5	1.227829
*
*       CAPACITOR CARDS
*
*
C1	VPWR#4	VPWR#2	8.06295e-19
C2	a_56_74##11	VPWR#4	2.3697e-19
C3	VGND#4	D#4	3.81681e-19
C4	VGND#2	a_56_74##3	1.77198e-20
C5	VGND#2	a_56_74##2	7.78641e-19
C6	VGND#4	VGND#2	9.07644e-19
C7	a_56_74##3	X#3	4.21658e-19
C8	X#3	a_56_74##2	3.10786e-19
C9	VGND#4	X#3	2.91918e-18
C10	VGND#5	a_56_74##3	8.10486e-21
C11	VGND#5	a_56_74##2	2.20452e-21
C12	A#5	a_56_74##11	1.46003e-17
C13	a_56_74##6	a_56_74##2	8.48197e-19
C14	D#2	a_56_74##3	2.90999e-17
C15	D#5	X#3	2.20923e-18
C16	a_56_74##3	a_56_74##2	5.57943e-18
C17	VGND#6	D#5	2.00973e-17
C18	VPWR#2	VPWR#1	9.67163e-19
C19	a_56_74##9	VPWR#4	2.12212e-19
C20	a_56_74##9	VPWR#2	4.76263e-18
C21	a_56_74##11	a_56_74##9	2.29521e-18
C22	VPWR#7	VPWR#2	1.14278e-19
C23	VGND#2	X#3	1.4437e-17
C24	a_56_74##13	VPWR#4	1.44068e-17
C25	a_56_74##11	VPWR#7	3.72708e-17
C26	VGND#6	VGND#2	1.16101e-17
C27	VGND#4	a_56_74##4	9.2475e-18
C28	VPWR#5	VPWR#4	7.87344e-19
C29	a_56_74##11	a_56_74##13	1.16596e-19
C30	VGND#6	X#3	2.64699e-17
C31	VGND#4	D#1	2.13479e-18
C32	VPWR#5	a_56_74##11	2.06157e-17
C33	D#5	a_56_74##9	7.04553e-18
C34	A#5	a_56_74##12	3.78759e-17
C35	D#4	a_56_74##9	1.58173e-17
C36	VGND#4	a_56_74##3	1.8203e-19
C37	VGND#2	VPWR#1	1.13429e-19
C38	a_56_74##12	VGND#6	1.55331e-18
C39	D#5	a_56_74##5	2.86196e-19
C40	a_56_74##9	a_56_74##3	2.30454e-19
C41	D#5	a_56_74##4	1.34452e-18
C42	a_56_74##9	a_56_74##2	2.15364e-19
C43	VGND#6	a_56_74##9	3.64937e-18
C44	VPWR#2	a_56_74#	2.31548e-18
C45	VGND#2	a_56_74##5	2.87101e-17
C46	VPWR#2	a_56_74##7	8.42274e-18
C47	X#3	a_56_74##5	3.40434e-17
C48	VPWR#6	VPWR#1	8.62012e-18
C49	VGND#2	a_56_74##4	5.71544e-18
C50	VGND#6	a_56_74##5	4.22019e-18
C51	X#3	a_56_74##4	3.29531e-17
C52	VPWR#2	D#3	4.24007e-18
C53	VGND#2	D#1	1.32951e-18
C54	a_56_74##4	VGND#6	2.41387e-17
C55	a_56_74##9	X#1	3.78411e-18
C56	X#3	D#1	1.63333e-18
C57	VPWR#4	C#1	3.95274e-18
C58	a_56_74##9	VPWR#6	7.10475e-17
C59	D#1	VGND#6	3.17695e-17
C60	a_56_74##12	VPWR#5	6.30232e-20
C61	X#3	C#3	4.35831e-19
C62	a_56_74##11	C#1	6.25979e-19
C63	VPWR#4	B#1	5.75756e-18
C64	VPWR#7	VPWR#6	1.23931e-18
C65	VGND#6	C#3	4.39353e-18
C66	VPWR#7	a_56_74##9	6.66658e-17
C67	a_56_74##11	B#1	1.98617e-17
C68	a_56_74##12	a_56_74##4	1.58528e-19
C69	VGND#6	B#3	7.32595e-19
C70	a_56_74##12	D#1	2.43039e-19
C71	a_56_74##11	A#4	8.39348e-18
C72	VGND#6	A#1	5.04005e-19
C73	a_56_74##13	VPWR#7	5.854e-17
C74	a_56_74##12	C#3	4.68567e-19
C75	VPWR#5	VPWR#7	1.25519e-18
C76	VPWR#2	a_56_74##3	5.75109e-20
C77	VGND#5	VGND#4	3.43849e-17
C78	VPWR#3	VPWR#4	3.97828e-17
C79	a_56_74##12	B#3	8.13714e-18
C80	VPWR#5	a_56_74##13	8.0621e-17
C81	VPWR#3	VPWR#2	4.02843e-17
C82	VPWR#2	a_56_74##2	5.35108e-20
C83	a_56_74##12	A#1	4.29843e-17
C84	VGND#5	a_56_74##11	1.30941e-18
C85	a_56_74##6	VPWR#2	3.80893e-19
C86	a_56_74##4	a_56_74##5	4.16893e-17
C87	a_56_74#	VPWR#1	2.74873e-17
C88	a_56_74#	X#1	2.68567e-17
C89	VPWR#1	a_56_74##7	4.36173e-18
C90	D#1	a_56_74##4	2.18697e-17
C91	VPWR#6	a_56_74#	4.53554e-18
C92	a_56_74##11	D#2	9.58525e-20
C93	VGND#5	D#4	9.39016e-19
C94	a_56_74##7	X#1	2.61416e-17
C95	VPWR#1	D#3	1.01343e-18
C96	a_56_74##9	a_56_74#	7.0393e-19
C97	a_56_74##7	VPWR#6	3.5549e-17
C98	C#3	D#1	2.20738e-17
C99	a_56_74##9	a_56_74##7	1.94718e-17
C100	C#2	a_56_74##11	1.5027e-17
C101	D#3	VPWR#6	3.46764e-17
C102	VPWR#7	a_56_74##7	2.44826e-19
C103	D#5	D#2	1.2449e-17
C104	a_56_74##9	D#3	7.69251e-17
C105	VGND#5	A#5	1.21302e-18
C106	VPWR#6	C#1	1.17149e-18
C107	D#4	D#2	8.52798e-18
C108	B#3	C#3	2.19932e-17
C109	a_56_74##11	B#2	1.14313e-17
C110	VPWR#7	D#3	1.12499e-18
C111	VGND#5	VGND#2	3.80413e-17
C112	a_56_74##9	C#1	6.53756e-17
C113	VPWR#6	B#1	2.38607e-19
C114	C#1	VPWR#7	3.08761e-17
C115	C#2	D#4	4.00383e-17
C116	a_56_74##6	VGND#2	4.12068e-18
C117	a_56_74##9	B#1	1.91869e-18
C118	a_56_74##11	A#3	9.21261e-18
C119	A#1	B#3	4.83358e-17
C120	a_56_74##13	C#1	1.21806e-18
C121	B#1	VPWR#7	3.73433e-17
C122	VPWR#5	C#1	2.35992e-19
C123	a_56_74##13	B#1	5.25288e-17
C124	VPWR#3	VPWR#1	3.10026e-17
C125	VPWR#7	A#4	1.23399e-18
C126	X#3	D#2	1.37448e-19
C127	VPWR#5	B#1	1.20541e-18
C128	VGND#5	a_56_74##12	2.51791e-17
C129	X	a_56_74##3	1.37567e-17
C130	X	a_56_74##2	1.81651e-17
C131	D#2	VGND#6	4.65144e-18
C132	a_56_74##13	A#4	4.67862e-17
C133	VPWR#5	A#4	3.46613e-17
C134	C#2	X#3	3.88416e-18
C135	a_56_74##9	VPWR#3	1.67351e-17
C136	C#2	VGND#6	2.47441e-17
C137	a_56_74##6	VPWR#1	5.74203e-17
C138	a_56_74##6	X#1	4.58629e-20
C139	VGND#5	a_56_74##9	8.19933e-19
C140	A#5	A#3	1.6329e-17
C141	VPWR#3	VPWR#5	3.16446e-17
C142	a_56_74##7	a_56_74#	5.12253e-17
C143	a_56_74##9	a_56_74##6	1.23782e-18
C144	VPWR#6	D#2	4.92792e-19
C145	a_56_74##9	D#2	4.55577e-18
C146	D#3	a_56_74##7	2.99102e-17
C147	a_56_74##12	B#2	2.12761e-18
C148	a_56_74##9	C#2	3.74303e-17
C149	VGND#5	D#1	3.31759e-18
C150	a_56_74##12	A#3	9.77084e-18
C151	VPWR#7	C#2	8.93176e-19
C152	C#1	D#3	5.16028e-17
C153	VGND#5	C#3	6.10598e-18
C154	VGND#5	B#3	6.10598e-18
C155	D#2	a_56_74##4	6.70123e-19
C156	VPWR#7	B#2	1.25542e-18
C157	VGND#5	A#1	5.48918e-18
C158	B#1	C#1	2.15591e-17
C159	C#2	a_56_74##4	2.15671e-18
C160	A	a_56_74##11	2.60339e-17
C161	C#2	D#1	9.6564e-18
C162	VGND	a_56_74##2	2.71431e-18
C163	A#4	B#1	4.50751e-17
C164	C#2	C#3	2.95165e-17
C165	VPWR#3	D#3	1.60019e-18
C166	VPWR#5	A#3	7.13087e-18
C167	a_56_74##6	a_56_74#	2.41089e-17
C168	C#2	B#3	1.53619e-18
C169	VPWR#3	C#1	1.78386e-18
C170	a_56_74##6	a_56_74##7	8.09826e-19
C171	a_56_74##6	D#3	2.04513e-19
C172	D#2	a_56_74##7	8.35347e-19
C173	a_56_74##12	a_143_74#	1.84526e-18
C174	A#1	B#2	2.04568e-18
C175	D#5	a_56_74##3	5.19301e-18
C176	D#1	a_335_74#	2.09248e-18
C177	D#5	a_56_74##2	8.58586e-20
C178	C#3	a_335_74#	1.86562e-17
C179	a_56_74##3	VNB	2.30264e-17
C180	a_56_74##2	VNB	2.05144e-17
C181	a_56_74##11	B	5.52054e-17
C182	C#3	a_221_74#	1.74373e-18
C183	B#3	a_221_74#	1.87333e-17
C184	A#3	B#1	1.76174e-18
C185	B#3	a_143_74#	1.07192e-17
C186	VGND#5	C#2	1.41332e-17
C187	A#1	a_143_74#	4.41478e-18
C188	A	VPWR#5	2.67523e-17
C189	VGND#5	B#2	1.69024e-19
C190	D#5	X	1.76375e-17
C191	C#2	D#2	3.61519e-17
C192	VGND#5	A#3	5.6971e-19
C193	VPWR	VPWR#4	2.55278e-17
C194	VPWR	VPWR#2	2.95559e-17
C195	VPWR	a_56_74##11	2.47295e-18
C196	a_56_74##12	B	6.37835e-17
C197	B#2	C#2	2.89005e-17
C198	VPWR	D#5	2.29999e-18
C199	VPWR	D#4	8.34416e-19
C200	VGND	VGND#4	2.22681e-17
C201	A#3	B#2	2.92615e-17
C202	C#2	a_335_74#	4.2519e-18
C203	VGND	a_56_74##11	5.45822e-18
C204	a_56_74##9	X	3.50503e-17
C205	C#2	a_221_74#	1.3462e-19
C206	B	C#3	8.34797e-18
C207	VGND	D#5	1.65401e-18
C208	VGND	D#4	3.91077e-18
C209	B	B#3	2.34751e-17
C210	B#2	a_221_74#	8.66223e-19
C211	B	A#1	8.27651e-18
C212	VPWR	VPWR#1	4.27639e-17
C213	VPWR	VPWR#6	1.62654e-17
C214	VGND#4	VNB	2.71027e-17
C215	VGND	A#5	5.36282e-18
C216	VGND	VGND#2	4.92686e-17
C217	VPWR	a_56_74##9	2.80846e-17
C218	VGND	X#3	1.12898e-17
C219	VPWR	VPWR#7	2.117e-17
C220	VPWR#4	VNB	3.09799e-17
C221	VGND	VGND#6	2.03527e-17
C222	VPWR	a_56_74##13	1.78766e-17
C223	VPWR#2	VNB	3.28864e-17
C224	a_56_74##11	VNB	1.62355e-17
C225	VPWR	VPWR#5	4.21629e-17
C226	VGND	a_56_74##12	1.98993e-17
C227	X	a_56_74#	1.17832e-17
C228	D#5	VNB	2.50058e-18
C229	D#4	VNB	1.18603e-18
C230	X	a_56_74##7	1.31532e-17
C231	X	D#3	2.62093e-18
C232	VGND	a_56_74##9	5.06807e-18
C233	A	A#3	1.15871e-17
C234	a_56_74##7	a_56_74##2	6.95423e-19
C235	A#5	VNB	1.16435e-17
C236	VGND#2	VNB	6.12066e-17
C237	X#3	VNB	4.01764e-18
C238	VGND#5	B	1.55332e-17
C239	VPWR	a_56_74#	7.75601e-19
C240	VGND#6	VNB	4.4375e-18
C241	VGND	a_56_74##5	4.05237e-19
C242	VGND	a_56_74##4	4.35638e-18
C243	VPWR	a_56_74##7	9.03578e-19
C244	VGND	D#1	1.34244e-18
C245	VPWR	D#3	1.32558e-19
C246	a_56_74##12	VNB	4.10478e-17
C247	VGND	C#3	9.41552e-19
C248	VPWR	C#1	3.60709e-19
C249	VPWR#1	VNB	5.26715e-17
C250	VGND	B#3	1.0542e-18
C251	B	C#2	8.26963e-17
C252	VPWR	B#1	3.70108e-19
C253	VGND	A#1	1.14289e-18
C254	VPWR#6	VNB	3.7523e-18
C255	a_56_74##9	VNB	5.72655e-18
C256	VPWR	A#4	3.3598e-18
C257	X	a_56_74##6	9.37407e-17
C258	B	B#2	1.76614e-17
C259	VPWR#7	VNB	4.03593e-18
C260	a_56_74##13	VNB	2.2573e-18
C261	X	D#2	2.78726e-18
C262	B	A#3	4.2096e-18
C263	VPWR#5	VNB	8.06229e-17
C264	VPWR	VPWR#3	8.68364e-18
C265	a_56_74##5	VNB	2.61976e-17
C266	X	C#2	2.41256e-19
C267	a_56_74##4	VNB	2.95263e-17
C268	D#1	VNB	2.73589e-17
C269	X	B#2	1.04331e-19
C270	VPWR	a_56_74##6	7.50194e-18
C271	C#3	VNB	2.67328e-17
C272	B#3	VNB	2.60124e-17
C273	A#1	VNB	4.05737e-17
C274	B	a_221_74#	5.75133e-18
C275	VPWR	C#2	2.50923e-18
C276	a_56_74#	VNB	4.38815e-17
C277	a_56_74##7	VNB	3.71253e-17
C278	VGND	VGND#5	5.63069e-17
C279	B	a_143_74#	1.92314e-20
C280	D#3	VNB	4.10449e-17
C281	VGND	a_56_74##6	7.25606e-18
C282	C#1	VNB	4.02388e-17
C283	VGND	D#2	4.42773e-20
C284	B#1	VNB	3.98485e-17
C285	A#4	VNB	4.64695e-17
C286	VGND	C#2	1.48372e-17
C287	VGND	B#2	3.32079e-19
C288	VPWR#3	VNB	1.82807e-16
C289	VGND	A#3	2.90368e-18
C290	VGND#5	VNB	2.50449e-16
C291	a_56_74##6	VNB	8.72105e-17
C292	D#2	VNB	3.1132e-17
C293	C#2	VNB	2.48285e-17
C294	B#2	VNB	3.24633e-17
C295	VPWR	A	2.83167e-18
C296	A#3	VNB	7.07247e-17
C297	VPWR	B	2.62651e-18
C298	A	VNB	1.11861e-17
C299	VPWR	X	4.75999e-18
C300	VGND	B	1.5405e-17
C301	B	VNB	2.05309e-18
C302	X	VNB	4.29135e-18
C303	VPWR	VNB	5.30292e-17
C304	VGND	VNB	6.98622e-17
C305	VGND#3	a_56_74##6	3.38566e-17
C306	VGND#3	VNB	1.21701e-17
C307	VGND#3	a_56_74##5	4.80736e-18
C308	X#3	VGND#3	2.8394e-17
C309	VGND#3	VGND#2	4.47638e-18
*
*
.ENDS sky130_fd_sc_hs__and4_2
*
