* Extracted by Quantus, converted by sky130cad/quantus.py
*
*
*
*                       LINUX           Wed Nov 18 08:14:14 2026
*
*
*
*  PROGRAM  advgen
*
*  Name           : advgen - Quantus - (64-bit)
*  Version        : 25.1.0-p047
*  Build Date     : Thu Dec 11 23:20:30 PST 2025
*
*  HSPICE LIBRARY
*
*  OPERATING_TEMPERATURE 150
*  QRC_TECH_DIR <path>/tech
*
*
*

*
.SUBCKT sky130_fd_sc_hs__a32oi_1 VPB VNB VGND VPWR Y A2 B2 B1 A1 A3
*
*
*  caps2d version: 10
*
*
*       TRANSISTOR CARDS
*
*
XM5 VGND#3 B2#1 a_119_74# VNB sky130_fd_pr__nfet_01v8_lvt l=0.15 w=0.74 ad=0.2294 as=0.1776 pd=2.1 ps=1.96
XM3 a_119_74# B1#3 Y#3 VNB sky130_fd_pr__nfet_01v8_lvt l=0.15 w=0.74 ad=0.1776 as=0.6068 pd=1.96 ps=3.12
XM7 Y#3 A1#1 a_391_74# VNB sky130_fd_pr__nfet_01v8_lvt l=0.15 w=0.74 ad=0.6068 as=0.1776 pd=3.12 ps=1.96
XM2 a_391_74# A2#3 a_469_74# VNB sky130_fd_pr__nfet_01v8_lvt l=0.15 w=0.74 ad=0.1776 as=0.3108 pd=1.96 ps=2.32
XM8 a_469_74# A3#3 VGND#1 VNB sky130_fd_pr__nfet_01v8_lvt l=0.15 w=0.74 ad=0.3108 as=0.2109 pd=2.32 ps=2.05
XM0 a_27_368# B2#4 Y#2 VPB sky130_fd_pr__pfet_01v8 l=0.15 w=1.12 ad=0.3304 as=0.392 pd=2.83 ps=2.94
XM4 Y#2 B1#1 a_27_368##4 VPB sky130_fd_pr__pfet_01v8 l=0.15 w=1.12 ad=0.392 as=0.5152 pd=2.94 ps=3.16
XM9 a_27_368##4 A1#3 VPWR#3 VPB sky130_fd_pr__pfet_01v8 l=0.15 w=1.12 ad=0.5152 as=0.7168 pd=3.16 ps=3.52
XM6 VPWR#3 A2#1 a_27_368##2 VPB sky130_fd_pr__pfet_01v8 l=0.15 w=1.12 ad=0.7168 as=0.336 pd=3.52 ps=2.84
XM1 a_27_368##2 A3#1 VPWR#1 VPB sky130_fd_pr__pfet_01v8 l=0.15 w=1.12 ad=0.336 as=0.3304 pd=2.84 ps=2.83
*
*
*       RESISTOR AND CAP/DIODE CARDS
*
Rg1	B2#1	B2#2	322.953644
Rg2	B2#2	B2#3	26.659500
Rg3	B2#2	B2#4	507.075531
Rg4	B1#1	B1#2	483.631287
Rg5	B1#2	B1#3	423.939575
Rg6	A1#1	A1#2	331.713745
Rg7	A1#2	A1#3	509.023376
Rg8	A2#1	A2#2	492.059540
Rg9	A2#2	A2#3	307.937683
Rg10	A3#1	A3#2	492.059540
Rg11	A3#2	A3#3	307.937683
Rf1	B2	B2#5	0.705966
Rf2	B2#6	B2#3	160.938766
Rf3	B2#5	B2#6	3.543054
Rf4	B1#4	B1	1.411932
Rf5	B1#2	B1#6	161.644730
Rf6	B1#4	B1#6	3.261114
Rf7	A1#2	A1	163.775864
Rf8	Y	Y#1	64.667633
Rf9	Y#1	Y#2	26.703623
Rf10	Y#1	Y#3	83.779831
Rf11	A2	A2#4	1.212107
Rf12	A2	A2#5	1.212107
Rf13	A2#4	A2#5	10.169745
Rf14	A2	A2#6	1.212107
Rf15	A2#5	A2#6	10.169745
Rf16	A2#7	A2#2	161.444916
Rf17	A2#6	A2#7	2.473722
Rf19	a_27_368##3	a_27_368##5	82.066711
Rf20	a_27_368##5	a_27_368#	106.591026
Rf21	a_27_368##2	a_27_368##3	5.000000
Rf22	a_27_368##4	a_27_368##5	7.500000
Rf23	A3#4	A3#2	161.495056
Rf24	A3	A3#6	1.262259
Rf25	A3#4	A3#6	6.706677
Rf26	VPWR#1	VPWR#2	156.992371
Rf27	VPWR#2	VPWR#3	18.578613
Rf28	VGND#1	VGND#2	128.716400
Rf29	VGND#2	VGND#3	132.099319
Re1	VPWR#2	VPWR	1.403190
Re2	VGND	VGND#2	1.403242
*
*       CAPACITOR CARDS
*
*
C1	A2#7	A3#4	1.39604e-17
C2	VGND#1	A3#6	1.92537e-17
C3	VGND#1	A3#4	1.45213e-17
C4	Y#1	B1#6	4.694e-17
C5	A3#6	VPWR#1	1.47103e-17
C6	B2#6	Y#1	2.41744e-17
C7	B2#5	Y#1	6.49584e-18
C8	VGND#1	A2#4	1.79075e-17
C9	A3#4	VPWR#1	8.66408e-18
C10	A3#4	a_27_368##2	1.20742e-17
C11	Y#3	A2#4	2.44075e-17
C12	Y#3	Y#1	3.36037e-18
C13	A2#7	a_27_368##2	1.40957e-17
C14	B2#5	Y#3	1.35681e-17
C15	Y#1	a_27_368##4	1.9409e-17
C16	Y#3	VGND#1	3.31833e-18
C17	Y#1	Y#2	8.71537e-19
C18	VGND#3	B2#5	3.24887e-17
C19	a_27_368#	Y#1	2.37561e-17
C20	A2#4	A3#3	5.47258e-18
C21	A2#4	A2#3	1.351e-17
C22	A2#4	A1#1	5.2388e-18
C23	VGND#3	Y#3	8.34251e-17
C24	B2#6	a_27_368#	2.10828e-17
C25	VGND#1	A3#3	3.80202e-17
C26	a_27_368##2	VPWR#1	6.72944e-17
C27	VGND#1	A2#3	5.38862e-18
C28	a_27_368##2	VPWR#3	1.89939e-18
C29	VGND#1	A1#1	1.03407e-18
C30	Y#3	A3#3	4.36267e-19
C31	a_27_368##4	a_27_368##2	3.10218e-18
C32	VGND#1	B1#3	3.31922e-19
C33	Y#3	A2#3	3.79616e-18
C34	Y#1	A1#3	2.23228e-19
C35	a_27_368##4	VPWR#3	8.47422e-19
C36	A3#4	VPWR#2	1.04624e-19
C37	Y#3	A1#1	6.00382e-17
C38	Y#1	B1#1	1.96045e-17
C39	VGND#3	A2#3	1.78979e-19
C40	Y#3	B1#3	7.0545e-17
C41	a_27_368##4	Y#2	6.76286e-17
C42	A3#6	A3#2	1.08967e-17
C43	VGND#3	A1#1	4.80729e-19
C44	Y#1	B2#4	7.62575e-18
C45	a_27_368#	a_27_368##4	2.59148e-18
C46	Y#3	B2#1	1.57679e-17
C47	A3#4	A3#2	1.73526e-17
C48	VGND#3	B1#3	5.43131e-18
C49	a_27_368#	Y#2	9.16996e-17
C50	B2#1	VGND#3	3.28981e-17
C51	A2#2	A3#4	1.99806e-17
C52	A2#7	A3#2	3.17602e-18
C53	VGND#2	A2#4	1.41888e-17
C54	A2#3	A3#3	2.17354e-17
C55	VPWR#1	A3#1	3.21123e-17
C56	A2#7	A2#2	1.16377e-17
C57	a_27_368##2	A3#1	4.8711e-17
C58	VPWR#1	A2#1	1.20836e-18
C59	A1#1	A2#3	4.76855e-17
C60	A1#2	A2#7	1.63377e-17
C61	a_27_368##2	A2#1	4.92782e-17
C62	a_27_368##4	A3#1	2.11642e-19
C63	Y#1	A2#2	1.38591e-19
C64	A2#1	VPWR#3	2.44157e-17
C65	a_27_368##2	A1#3	1.27195e-18
C66	a_27_368##4	A2#1	8.21368e-19
C67	B1#3	A1#1	3.75134e-18
C68	A1#3	VPWR#3	3.31828e-17
C69	Y#1	A1#2	3.35809e-19
C70	a_27_368##2	B1#1	2.76208e-19
C71	VGND#2	VGND#1	3.99784e-17
C72	a_27_368##4	A1#3	4.13818e-17
C73	Y#2	A1#3	9.80307e-19
C74	B2#1	B1#3	4.62926e-17
C75	Y#1	B1#2	8.99965e-18
C76	B1#6	A1#2	1.47578e-17
C77	a_27_368##4	B1#1	4.95215e-17
C78	A3#2	VGND#1	4.62701e-18
C79	a_27_368#	A1#3	2.51359e-19
C80	VGND#2	Y#3	4.71999e-17
C81	Y#2	B1#1	5.04875e-17
C82	a_27_368##4	B2#4	7.78931e-19
C83	VPWR#2	VPWR#1	2.61712e-17
C84	VGND#1	A2#2	1.1712e-19
C85	B1#6	B1#2	1.03918e-17
C86	a_27_368#	B1#1	2.12791e-18
C87	Y#1	B2#3	7.10529e-18
C88	B2#4	Y#2	2.02049e-17
C89	VGND#2	VGND#3	3.95143e-17
C90	a_27_368##2	VPWR#2	4.27087e-17
C91	a_27_368#	B2#4	6.54608e-17
C92	VPWR#2	VPWR#3	5.80589e-18
C93	B1#6	B2#3	7.4128e-19
C94	B2#6	B1#2	4.68557e-19
C95	Y#3	A2#2	8.68242e-19
C96	a_27_368##4	VPWR#2	1.03196e-16
C97	B2#5	B1#2	5.2775e-19
C98	VPWR#1	A3#2	3.97201e-18
C99	A1#2	Y#3	6.08818e-18
C100	B2#6	B2#3	1.454e-17
C101	a_27_368#	VPWR#2	6.21575e-17
C102	B2#5	B2#3	9.11847e-18
C103	A2#1	A3#1	5.04739e-17
C104	a_27_368##2	A2#2	3.01686e-19
C105	B1#2	Y#3	8.22484e-18
C106	A2#4	a_469_74#	2.22065e-18
C107	A1#3	A2#1	1.23354e-17
C108	Y#3	B2#3	1.59118e-18
C109	VGND#2	A2#3	6.10598e-18
C110	A2#4	a_391_74#	6.04067e-19
C111	VGND#2	A1#1	7.69596e-18
C112	a_27_368##4	A1#2	1.9447e-18
C113	B2#3	VGND#3	7.23394e-18
C114	VGND#2	B1#3	3.0367e-18
C115	B1#1	A1#3	2.4991e-17
C116	A2#2	A3#3	1.21507e-18
C117	a_27_368##4	B1#2	1.00932e-18
C118	A2#2	A2#3	1.97055e-18
C119	VPWR#2	A3#1	5.55738e-18
C120	A2#2	A1#1	1.31004e-18
C121	B2#4	B1#1	3.88978e-17
C122	a_27_368#	B1#2	7.31305e-20
C123	VPWR#2	A2#1	2.19672e-17
C124	A2#2	B1#3	3.45258e-19
C125	VPWR#2	A1#3	2.02943e-17
C126	A2#2	B2#1	1.48545e-19
C127	a_27_368#	B2#3	3.97306e-18
C128	VPWR#2	B1#1	5.8975e-18
C129	A1	A2#7	3.25277e-18
C130	VPWR#2	B2#4	4.65799e-18
C131	Y#3	a_119_74#	6.18803e-18
C132	B1#6	A1	2.98121e-18
C133	Y#1	B1	6.52708e-18
C134	A3#3	a_469_74#	2.25926e-18
C135	A2#3	a_469_74#	1.87458e-17
C136	VPWR#2	A2#2	3.56973e-19
C137	A2#3	a_391_74#	1.29934e-17
C138	Y#3	A1	3.61221e-17
C139	VGND#2	A2#2	6.06532e-20
C140	VPWR#2	A1#2	1.09153e-18
C141	A1#1	a_391_74#	1.54461e-18
C142	A2#2	A3#2	3.28321e-17
C143	VGND#2	A1#2	2.34329e-19
C144	VPWR#2	B1#2	1.01837e-19
C145	Y#3	B1	5.14874e-17
C146	VGND#2	B1#2	2.53537e-19
C147	VPWR#2	B2#3	1.10743e-19
C148	B1#3	a_119_74#	1.30831e-17
C149	A1#2	A2#2	2.68574e-17
C150	A2#7	Y	3.73232e-17
C151	B1#2	A1#2	2.69933e-17
C152	A2#2	B2#3	3.92384e-20
C153	VPWR	A3#6	1.58662e-18
C154	Y#1	Y	1.23192e-18
C155	A2	VGND#1	1.33443e-17
C156	VPWR	A3#4	1.95396e-18
C157	Y#3	A2	2.24413e-17
C158	B2#3	B1#2	2.84902e-17
C159	VPWR	A2#7	3.51713e-18
C160	A2#2	a_469_74#	4.43988e-19
C161	VPWR	Y#1	9.88657e-19
C162	VGND	A3#6	1.13397e-18
C163	Y#3	Y	5.41726e-18
C164	VPWR	B1#6	2.06782e-18
C165	VGND	A3#4	2.90617e-18
C166	VPWR	B2#6	2.63526e-18
C167	A2	A3#3	5.96789e-18
C168	Y	a_27_368##2	5.74972e-17
C169	A2	A2#3	1.33839e-17
C170	Y	VPWR#3	5.30441e-18
C171	A2	A1#1	4.42817e-18
C172	Y	a_27_368##4	5.79953e-17
C173	VGND	A2#4	1.91533e-17
C174	A2	B1#3	2.18881e-19
C175	Y#2	Y	1.73056e-18
C176	VGND	Y#1	1.89473e-18
C177	VGND#2	A1	5.67364e-19
C178	A2	B2#1	8.54494e-20
C179	VPWR	VPWR#1	3.42734e-17
C180	VPWR	a_27_368##2	3.5153e-18
C181	A1	A2#2	2.05606e-17
C182	A3#6	VNB	2.04359e-17
C183	A3#4	VNB	7.17857e-19
C184	VGND	B2#5	3.17281e-18
C185	VPWR	a_27_368##4	2.42263e-17
C186	A1	A1#2	1.33596e-17
C187	VGND	VGND#1	4.91175e-17
C188	VPWR	Y#2	8.41665e-18
C189	VPWR	a_27_368#	2.69425e-17
C190	A1	B1#2	1.90933e-18
C191	A2#7	VNB	5.07348e-20
C192	VGND	Y#3	4.39611e-17
C193	Y	A3#1	2.20061e-18
C194	B1	A1#2	1.86153e-18
C195	VGND	VGND#3	4.7992e-17
C196	Y	A2#1	1.44651e-17
C197	Y#1	VNB	1.1096e-17
C198	VGND	VPWR#1	4.23687e-18
C199	Y	A1#3	2.3269e-17
C200	B1	B1#2	7.99166e-18
C201	VGND	a_27_368##2	5.91863e-18
C202	B1#6	VNB	1.52638e-18
C203	Y	B1#1	1.04669e-18
C204	B1	B2#3	5.28858e-19
C205	B2#6	VNB	1.07268e-17
C206	VPWR	A3#1	2.52368e-18
C207	B2#5	VNB	7.75323e-18
C208	VGND	a_27_368#	3.00739e-18
C209	VGND#1	VNB	7.03068e-17
C210	VGND	A3#3	4.89516e-19
C211	VPWR	A2#1	6.87599e-19
C212	VGND	A2#3	9.14475e-19
C213	VPWR	A1#3	5.76761e-19
C214	Y#3	VNB	1.17083e-17
C215	VGND	A1#1	6.02113e-18
C216	VGND#2	Y	6.30672e-19
C217	VPWR	B1#1	1.47581e-18
C218	VGND	B1#3	1.75944e-18
C219	VGND#3	VNB	7.2691e-17
C220	VPWR	B2#4	2.31253e-18
C221	VGND	B2#1	4.30485e-18
C222	VPWR#1	VNB	8.12139e-17
C223	a_27_368##2	VNB	5.713e-18
C224	Y	A2#2	2.14546e-18
C225	VPWR	VPWR#2	9.7303e-17
C226	a_27_368##4	VNB	3.33922e-18
C227	A1#2	Y	5.14427e-17
C228	a_27_368#	VNB	6.05259e-17
C229	A3#3	VNB	3.01821e-17
C230	A2#3	VNB	2.67546e-17
C231	A1#1	VNB	2.90809e-17
C232	A2	a_469_74#	4.0053e-18
C233	B1#3	VNB	3.00503e-17
C234	VPWR	A1#2	1.92839e-18
C235	B2#1	VNB	3.16847e-17
C236	B1	A1	1.12519e-17
C237	VGND	VGND#2	3.87651e-17
C238	A3#1	VNB	4.42669e-17
C239	A2#1	VNB	3.47145e-17
C240	VGND	A3#2	1.47979e-20
C241	A1#3	VNB	3.54322e-17
C242	VGND	A2#2	3.32079e-19
C243	B1#1	VNB	3.53579e-17
C244	VGND	A1#2	3.32079e-19
C245	B2#4	VNB	4.89134e-17
C246	VGND	B1#2	4.20634e-19
C247	VPWR#2	VNB	2.49898e-16
C248	VGND#2	VNB	2.04847e-16
C249	A3#2	VNB	4.64331e-17
C250	A2#2	VNB	3.50338e-17
C251	A1#2	VNB	3.64913e-17
C252	B1#2	VNB	4.25215e-17
C253	B2#3	VNB	6.05017e-17
C254	VGND	A1	3.88222e-18
C255	VGND	B1	2.94919e-18
C256	A1	VNB	1.60061e-18
C257	VPWR	Y	6.1159e-18
C258	B1	VNB	1.9569e-18
C259	VGND	Y	6.34602e-18
C260	A2	VNB	4.55783e-19
C261	Y	VNB	9.36556e-18
C262	VPWR	VNB	6.04894e-17
C263	VGND	VNB	6.35144e-17
C264	a_27_368##3	VNB	2.5244e-18
C265	a_27_368##3	A3#1	1.01246e-17
C266	a_27_368##3	A2#1	5.05398e-18
C267	a_27_368##3	VPWR#1	1.89724e-17
C268	VPWR#2	a_27_368##3	3.83044e-17
C269	a_27_368##3	a_27_368##2	1.12683e-18
C270	VPWR	a_27_368##3	1.46937e-17
*
*
.ENDS sky130_fd_sc_hs__a32oi_1
*
