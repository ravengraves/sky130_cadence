* Extracted by Quantus, converted by sky130cad/quantus.py
*
*
*
*                       LINUX           Wed Nov 18 08:20:08 2026
*
*
*
*  PROGRAM  advgen
*
*  Name           : advgen - Quantus - (64-bit)
*  Version        : 25.1.0-p047
*  Build Date     : Thu Dec 11 23:20:30 PST 2025
*
*  HSPICE LIBRARY
*
*  OPERATING_TEMPERATURE 150
*  QRC_TECH_DIR <path>/tech
*
*
*

*
.SUBCKT sky130_fd_sc_hs__buf_16 VPB VNB VGND X VPWR A
*
*
*  caps2d version: 10
*
*
*       TRANSISTOR CARDS
*
*
XM30 VGND#14 a_83_260##58 X#4 VNB sky130_fd_pr__nfet_01v8_lvt l=0.15 w=0.74 ad=0.2109 as=0.2072 pd=2.05 ps=2.04
XM43 X#4 a_83_260##55 VGND#23 VNB sky130_fd_pr__nfet_01v8_lvt l=0.15 w=0.74 ad=0.2072 as=0.2072 pd=2.04 ps=2.04
XM17 X#8 a_83_260##51 VGND#23 VNB sky130_fd_pr__nfet_01v8_lvt l=0.15 w=0.74 ad=0.2072 as=0.2072 pd=2.04 ps=2.04
XM34 VGND#22 a_83_260##49 X#8 VNB sky130_fd_pr__nfet_01v8_lvt l=0.15 w=0.74 ad=0.2072 as=0.2072 pd=2.04 ps=2.04
XM2 X#11 a_83_260##45 VGND#22 VNB sky130_fd_pr__nfet_01v8_lvt l=0.15 w=0.74 ad=0.2072 as=0.2072 pd=2.04 ps=2.04
XM9 VGND#21 a_83_260##41 X#11 VNB sky130_fd_pr__nfet_01v8_lvt l=0.15 w=0.74 ad=0.2072 as=0.2072 pd=2.04 ps=2.04
XM39 X#14 a_83_260##37 VGND#21 VNB sky130_fd_pr__nfet_01v8_lvt l=0.15 w=0.74 ad=0.2072 as=0.2072 pd=2.04 ps=2.04
XM8 VGND#20 a_83_260##33 X#14 VNB sky130_fd_pr__nfet_01v8_lvt l=0.15 w=0.74 ad=0.2072 as=0.2072 pd=2.04 ps=2.04
XM5 X#16 a_83_260##30 VGND#20 VNB sky130_fd_pr__nfet_01v8_lvt l=0.15 w=0.74 ad=0.2072 as=0.2072 pd=2.04 ps=2.04
XM19 X#16 a_83_260##26 VGND#19 VNB sky130_fd_pr__nfet_01v8_lvt l=0.15 w=0.74 ad=0.2072 as=0.3108 pd=2.04 ps=2.32
XM20 X#20 a_83_260##24 VGND#19 VNB sky130_fd_pr__nfet_01v8_lvt l=0.15 w=0.74 ad=0.2072 as=0.3108 pd=2.04 ps=2.32
XM15 VGND#18 a_83_260##22 X#20 VNB sky130_fd_pr__nfet_01v8_lvt l=0.15 w=0.74 ad=0.3108 as=0.2072 pd=2.32 ps=2.04
XM11 VGND#18 a_83_260##19 X#24 VNB sky130_fd_pr__nfet_01v8_lvt l=0.15 w=0.74 ad=0.3108 as=0.2072 pd=2.32 ps=2.04
XM36 VGND#17 a_83_260##17 X#24 VNB sky130_fd_pr__nfet_01v8_lvt l=0.15 w=0.74 ad=0.3108 as=0.2072 pd=2.32 ps=2.04
XM23 VGND#17 a_83_260##15 X#25 VNB sky130_fd_pr__nfet_01v8_lvt l=0.15 w=0.74 ad=0.3108 as=0.2072 pd=2.32 ps=2.04
XM42 X#25 a_83_260# VGND#16 VNB sky130_fd_pr__nfet_01v8_lvt l=0.15 w=0.74 ad=0.2072 as=0.2072 pd=2.04 ps=2.04
XM16 VGND#16 A#19 a_83_260##82 VNB sky130_fd_pr__nfet_01v8_lvt l=0.15 w=0.74 ad=0.2072 as=0.2072 pd=2.04 ps=2.04
XM22 VGND#15 A#17 a_83_260##82 VNB sky130_fd_pr__nfet_01v8_lvt l=0.15 w=0.74 ad=0.2072 as=0.2072 pd=2.04 ps=2.04
XM25 a_83_260##84 A#15 VGND#15 VNB sky130_fd_pr__nfet_01v8_lvt l=0.15 w=0.74 ad=0.2072 as=0.2072 pd=2.04 ps=2.04
XM35 a_83_260##84 A#13 VGND#4 VNB sky130_fd_pr__nfet_01v8_lvt l=0.15 w=0.74 ad=0.2072 as=0.2331 pd=2.04 ps=2.11
XM37 VGND#4 A#11 a_83_260##85 VNB sky130_fd_pr__nfet_01v8_lvt l=0.15 w=0.74 ad=0.2331 as=0.259 pd=2.11 ps=2.18
XM27 a_83_260##85 A#1 VGND#1 VNB sky130_fd_pr__nfet_01v8_lvt l=0.15 w=0.74 ad=0.259 as=0.2109 pd=2.18 ps=2.05
XM41 X#1 a_83_260##60 VPWR#23 VPB sky130_fd_pr__pfet_01v8 l=0.15 w=1.12 ad=0.336 as=0.3304 pd=2.84 ps=2.83
XM6 VPWR#22 a_83_260##59 X#1 VPB sky130_fd_pr__pfet_01v8 l=0.15 w=1.12 ad=0.336 as=0.336 pd=2.84 ps=2.84
XM14 VPWR#22 a_83_260##56 X#5 VPB sky130_fd_pr__pfet_01v8 l=0.15 w=1.12 ad=0.336 as=0.336 pd=2.84 ps=2.84
XM1 VPWR#20 a_83_260##52 X#5 VPB sky130_fd_pr__pfet_01v8 l=0.15 w=1.12 ad=0.392 as=0.336 pd=2.94 ps=2.84
XM26 X#9 a_83_260##46 VPWR#20 VPB sky130_fd_pr__pfet_01v8 l=0.15 w=1.12 ad=0.336 as=0.392 pd=2.84 ps=2.94
XM12 VPWR#18 a_83_260##42 X#9 VPB sky130_fd_pr__pfet_01v8 l=0.15 w=1.12 ad=0.336 as=0.336 pd=2.84 ps=2.84
XM33 X#12 a_83_260##38 VPWR#18 VPB sky130_fd_pr__pfet_01v8 l=0.15 w=1.12 ad=0.336 as=0.336 pd=2.84 ps=2.84
XM18 X#12 a_83_260##34 VPWR#15 VPB sky130_fd_pr__pfet_01v8 l=0.15 w=1.12 ad=0.336 as=0.336 pd=2.84 ps=2.84
XM28 VPWR#15 a_83_260##31 X#17 VPB sky130_fd_pr__pfet_01v8 l=0.15 w=1.12 ad=0.336 as=0.336 pd=2.84 ps=2.84
XM31 X#17 a_83_260##27 VPWR#13 VPB sky130_fd_pr__pfet_01v8 l=0.15 w=1.12 ad=0.336 as=0.336 pd=2.84 ps=2.84
XM38 X#18 a_83_260##23 VPWR#13 VPB sky130_fd_pr__pfet_01v8 l=0.15 w=1.12 ad=0.336 as=0.336 pd=2.84 ps=2.84
XM3 VPWR#11 a_83_260##21 X#18 VPB sky130_fd_pr__pfet_01v8 l=0.15 w=1.12 ad=0.336 as=0.336 pd=2.84 ps=2.84
XM21 X#21 a_83_260##20 VPWR#11 VPB sky130_fd_pr__pfet_01v8 l=0.15 w=1.12 ad=0.336 as=0.336 pd=2.84 ps=2.84
XM40 VPWR#9 a_83_260##18 X#21 VPB sky130_fd_pr__pfet_01v8 l=0.15 w=1.12 ad=0.336 as=0.336 pd=2.84 ps=2.84
XM0 VPWR#9 a_83_260##16 X#27 VPB sky130_fd_pr__pfet_01v8 l=0.15 w=1.12 ad=0.336 as=0.336 pd=2.84 ps=2.84
XM24 X#27 a_83_260##14 VPWR#7 VPB sky130_fd_pr__pfet_01v8 l=0.15 w=1.12 ad=0.336 as=0.392 pd=2.84 ps=2.94
XM4 VPWR#7 A#9 a_83_260##80 VPB sky130_fd_pr__pfet_01v8 l=0.15 w=1.12 ad=0.392 as=0.336 pd=2.94 ps=2.84
XM32 a_83_260##80 A#18 VPWR#5 VPB sky130_fd_pr__pfet_01v8 l=0.15 w=1.12 ad=0.336 as=0.336 pd=2.84 ps=2.84
XM29 a_83_260##79 A#16 VPWR#5 VPB sky130_fd_pr__pfet_01v8 l=0.15 w=1.12 ad=0.336 as=0.336 pd=2.84 ps=2.84
XM13 a_83_260##79 A#14 VPWR#4 VPB sky130_fd_pr__pfet_01v8 l=0.15 w=1.12 ad=0.336 as=0.336 pd=2.84 ps=2.84
XM7 VPWR#4 A#12 a_83_260##75 VPB sky130_fd_pr__pfet_01v8 l=0.15 w=1.12 ad=0.336 as=0.336 pd=2.84 ps=2.84
XM10 VPWR#1 A#10 a_83_260##75 VPB sky130_fd_pr__pfet_01v8 l=0.15 w=1.12 ad=0.3304 as=0.336 pd=2.83 ps=2.84
*
*
*       RESISTOR AND CAP/DIODE CARDS
*
Rg1	a_83_260#	a_83_260##2	363.941650
Rg2	a_83_260##2	a_83_260##3	43.823471
Rg3	a_83_260##3	a_83_260##4	20.231285
Rg4	a_83_260##4	a_83_260##5	33.582527
Rg5	a_83_260##5	a_83_260##6	46.600769
Rg6	a_83_260##6	a_83_260##7	76.963417
Rg7	a_83_260##7	a_83_260##8	34.561615
Rg8	a_83_260##8	a_83_260##9	37.721687
Rg9	a_83_260##9	a_83_260##10	26.812361
Rg10	a_83_260##10	a_83_260##11	48.214691
Rg11	a_83_260##11	a_83_260##12	26.827013
Rg12	a_83_260##12	a_83_260##13	37.620987
Rg13	a_83_260##2	a_83_260##14	472.702087
Rg14	a_83_260##3	a_83_260##15	379.087921
Rg15	a_83_260##4	a_83_260##16	441.762421
Rg16	a_83_260##6	a_83_260##17	365.821045
Rg17	a_83_260##6	a_83_260##18	469.818115
Rg18	a_83_260##7	a_83_260##19	394.814545
Rg19	a_83_260##7	a_83_260##20	437.854187
Rg20	a_83_260##9	a_83_260##21	395.231140
Rg21	a_83_260##10	a_83_260##22	353.255280
Rg22	a_83_260##11	a_83_260##23	404.167816
Rg23	a_83_260##12	a_83_260##24	367.508545
Rg24	a_83_260##13	a_83_260##25	56.977573
Rg25	a_83_260##25	a_83_260##26	342.058960
Rg26	a_83_260##13	a_83_260##27	451.334412
Rg27	a_83_260##25	a_83_260##28	37.362804
Rg28	a_83_260##28	a_83_260##29	48.741699
Rg29	a_83_260##29	a_83_260##30	348.334229
Rg30	a_83_260##28	a_83_260##31	441.762421
Rg31	a_83_260##29	a_83_260##32	55.641228
Rg32	a_83_260##32	a_83_260##33	342.058960
Rg33	a_83_260##29	a_83_260##34	451.334412
Rg34	a_83_260##32	a_83_260##35	45.237701
Rg35	a_83_260##35	a_83_260##36	41.684124
Rg36	a_83_260##36	a_83_260##37	354.327881
Rg37	a_83_260##35	a_83_260##38	441.762421
Rg38	a_83_260##36	a_83_260##39	32.313965
Rg39	a_83_260##39	a_83_260##40	26.777325
Rg40	a_83_260##40	a_83_260##41	345.402954
Rg41	a_83_260##39	a_83_260##42	390.978424
Rg42	a_83_260##40	a_83_260##43	46.887600
Rg43	a_83_260##43	a_83_260##44	26.812361
Rg44	a_83_260##44	a_83_260##45	353.255280
Rg45	a_83_260##43	a_83_260##46	395.231140
Rg46	a_83_260##44	a_83_260##47	32.259106
Rg47	a_83_260##47	a_83_260##48	33.053131
Rg48	a_83_260##48	a_83_260##49	423.278687
Rg49	a_83_260##48	a_83_260##50	74.020889
Rg50	a_83_260##50	a_83_260##51	407.645752
Rg51	a_83_260##48	a_83_260##52	466.318329
Rg52	a_83_260##50	a_83_260##53	40.906048
Rg53	a_83_260##53	a_83_260##54	32.285915
Rg54	a_83_260##54	a_83_260##55	397.730652
Rg55	a_83_260##50	a_83_260##56	450.685394
Rg56	a_83_260##54	a_83_260##57	62.699757
Rg57	a_83_260##57	a_83_260##58	368.862610
Rg58	a_83_260##54	a_83_260##59	440.770294
Rg59	a_83_260##57	a_83_260##60	471.862823
Rg60	A#1	A#2	397.555725
Rg61	A#2	A#3	68.597641
Rg62	A#3	A#4	79.063156
Rg63	A#4	A#5	28.850843
Rg64	A#5	A#6	47.341503
Rg65	A#6	A#7	75.323730
Rg66	A#7	A#8	63.721939
Rg67	A#8	A#9	449.655212
Rg68	A#2	A#10	449.655212
Rg69	A#3	A#11	430.496918
Rg70	A#3	A#12	444.843445
Rg71	A#4	A#13	442.592041
Rg72	A#4	A#14	456.938599
Rg73	A#6	A#15	427.444397
Rg74	A#6	A#16	441.790924
Rg75	A#7	A#17	418.002014
Rg76	A#7	A#18	432.348541
Rg77	A#8	A#19	397.555725
Rf1	X#2	X#3	18.331110
Rf2	X#3	X#4	72.537766
Rf3	X#1	X#2	5.000000
Rf4	a_83_260##53	a_83_260##62	168.587814
Rf5	X#6	X#7	18.331110
Rf6	X#7	X#8	72.537773
Rf7	X#5	X#6	5.000000
Rf8	a_83_260##63	a_83_260##47	179.057236
Rf9	X#9	X#10	23.000223
Rf10	X#10	X#11	69.857635
Rf11	a_83_260##65	a_83_260##36	178.767288
Rf12	X#12	X#13	23.331110
Rf13	X#13	X#14	90.729469
Rf14	a_83_260##67	a_83_260##29	170.697739
Rf15	X#15	X#16	86.254303
Rf16	X#15	X#17	19.369053
Rf17	a_83_260##69	a_83_260##13	171.247452
Rf18	X#18	X#19	20.980967
Rf19	X#19	X#20	61.830074
Rf20	a_83_260##8	a_83_260##72	178.365601
Rf21	X#22	X#23	17.373037
Rf22	X#23	X#24	65.928848
Rf23	X#21	X#22	5.000000
Rf24	a_83_260##5	a_83_260##74	178.365601
Rf25	X#25	X#26	71.716934
Rf26	X#26	X#27	22.681070
Rf27	a_83_260##75	a_83_260##76	80.666893
Rf28	a_83_260##76	a_83_260##77	65.696381
Rf29	a_83_260##77	a_83_260##78	60.592094
Rf30	a_83_260##76	a_83_260##79	18.602406
Rf31	a_83_260##77	a_83_260##80	18.602406
Rf32	a_83_260##78	a_83_260##81	74.959518
Rf33	a_83_260##81	a_83_260##82	28.306047
Rf34	a_83_260##81	a_83_260##83	63.019512
Rf35	a_83_260##83	a_83_260##84	28.306047
Rf36	a_83_260##83	a_83_260##85	88.714897
Rf37	A	A#5	23.655834
Rf38	VPWR#1	VPWR#2	112.381737
Rf39	VPWR#2	VPWR#3	54.155411
Rf40	VPWR#2	VPWR#4	53.143215
Rf41	VPWR#3	VPWR#5	58.891026
Rf42	VPWR#3	VPWR#6	79.986580
Rf43	VPWR#6	VPWR#7	38.736572
Rf44	VPWR#6	VPWR#8	68.798325
Rf45	VPWR#8	VPWR#9	62.513924
Rf46	VPWR#8	VPWR#10	65.941528
Rf47	VPWR#10	VPWR#11	62.696548
Rf48	VPWR#10	VPWR#12	65.941528
Rf49	VPWR#12	VPWR#13	62.513924
Rf50	VPWR#12	VPWR#14	65.941528
Rf51	VPWR#14	VPWR#15	62.696548
Rf52	VPWR#14	VPWR#16	41.736824
Rf53	VPWR#16	VPWR#17	24.204706
Rf54	VPWR#17	VPWR#18	62.513924
Rf55	VPWR#17	VPWR#19	68.798325
Rf56	VPWR#19	VPWR#20	44.678417
Rf57	VPWR#19	VPWR#21	66.606812
Rf58	VPWR#21	VPWR#22	62.696548
Rf59	VPWR#21	VPWR#23	117.064072
Rf60	VGND#1	VGND#2	100.119026
Rf61	VGND#2	VGND#3	49.284554
Rf62	VGND#2	VGND#4	38.247387
Rf63	VGND#3	VGND#5	78.870003
Rf64	VGND#5	VGND#6	67.887894
Rf65	VGND#6	VGND#7	73.001427
Rf66	VGND#7	VGND#8	71.030083
Rf67	VGND#8	VGND#9	70.056900
Rf68	VGND#9	VGND#10	27.491980
Rf69	VGND#10	VGND#11	35.527534
Rf70	VGND#11	VGND#12	64.270119
Rf71	VGND#12	VGND#13	62.891941
Rf72	VGND#13	VGND#14	105.689278
Rf73	VGND#3	VGND#15	41.745289
Rf74	VGND#5	VGND#16	38.247387
Rf75	VGND#6	VGND#17	32.912586
Rf76	VGND#7	VGND#18	31.042643
Rf77	VGND#8	VGND#19	37.699448
Rf78	VGND#9	VGND#20	55.699982
Rf79	VGND#11	VGND#21	51.499580
Rf80	VGND#12	VGND#22	47.423557
Rf81	VGND#13	VGND#23	35.763493
Re1	X#26	X#29	10.621317
Re2	X#29	X#30	0.816323
Re3	X#30	X#31	0.811788
Re4	X#31	X	0.426302
Re5	X	X#32	0.426302
Re6	X#32	X#33	0.807253
Re7	X#33	X#34	0.866210
Re8	X#34	X#3	10.575965
Re9	a_83_260##78	a_83_260##74	10.553289
Re10	a_83_260##74	a_83_260##72	0.829929
Re11	a_83_260##72	a_83_260##69	0.879815
Re12	a_83_260##69	a_83_260##67	0.798183
Re13	a_83_260##67	a_83_260##65	0.807253
Re14	a_83_260##65	a_83_260##63	0.870745
Re15	a_83_260##63	a_83_260##62	10.589570
Re16	VPWR#3	VPWR	2.512894
Re17	VPWR	VPWR#16	1.435940
Re18	VGND#3	VGND	2.512894
Re19	VGND	VGND#10	1.435940
Re21	X#23	X#29	9.777782
Re22	X#19	X#30	9.777782
Re23	X#15	X#31	9.777782
Re24	X#13	X#32	9.777782
Re25	X#10	X#33	9.777782
Re26	X#7	X#34	9.777782
*
*       CAPACITOR CARDS
*
*
C1	A#5	a_83_260##77	6.27845e-17
C2	VGND#6	a_83_260##5	2.65272e-20
C3	X#12	a_83_260##38	4.39002e-17
C4	X#8	a_83_260##54	1.60296e-19
C5	VGND#19	a_83_260##30	6.23207e-19
C6	VPWR#18	X#12	5.47716e-17
C7	a_83_260##77	VPWR#5	9.55251e-18
C8	VGND#4	VGND#1	1.39771e-18
C9	VGND#5	a_83_260##5	6.66509e-20
C10	A#5	a_83_260##76	8.42897e-17
C11	X#19	a_83_260##10	1.15862e-17
C12	VGND#2	VGND#1	1.30745e-18
C13	VGND#20	a_83_260##26	4.05276e-19
C14	a_83_260##69	a_83_260##28	1.38002e-18
C15	VPWR#14	a_83_260##23	8.1728e-20
C16	a_83_260##74	VPWR#8	3.07056e-19
C17	a_83_260##38	VPWR#18	2.38219e-17
C18	VPWR#15	a_83_260##42	1.49819e-19
C19	a_83_260##55	a_83_260##51	3.91291e-17
C20	X#24	a_83_260##10	1.55604e-19
C21	X#16	a_83_260##30	3.94214e-17
C22	VGND#22	a_83_260##48	3.62482e-18
C23	X#8	VGND#22	6.53337e-17
C24	X#9	a_83_260##38	2.52416e-18
C25	X#12	a_83_260##42	1.28544e-18
C26	VPWR#12	a_83_260##23	5.32718e-18
C27	a_83_260##69	a_83_260##12	3.68436e-18
C28	X#14	a_83_260##26	1.39031e-20
C29	a_83_260##74	VGND#17	8.17675e-18
C30	X#20	a_83_260##12	9.24256e-18
C31	a_83_260##76	VPWR#5	9.42755e-18
C32	VGND#19	a_83_260##33	2.62699e-19
C33	a_83_260##67	a_83_260##48	2.27612e-18
C34	a_83_260##42	VPWR#18	3.07827e-17
C35	VPWR#20	a_83_260##38	1.67835e-19
C36	a_83_260##85	VGND#4	4.29445e-17
C37	X#27	VPWR#8	6.02266e-18
C38	VPWR#10	a_83_260##23	2.85183e-19
C39	a_83_260##5	VPWR#8	3.92949e-19
C40	a_83_260##30	VGND#20	1.63129e-17
C41	VGND#13	a_83_260##58	3.27871e-18
C42	X#16	a_83_260##28	1.26896e-17
C43	VPWR#6	a_83_260##5	4.5102e-20
C44	VGND#2	A#15	6.3656e-19
C45	X#15	a_83_260##28	1.22739e-17
C46	a_83_260##42	X#9	1.29969e-17
C47	X#9	VPWR#18	4.15112e-17
C48	a_83_260##58	a_83_260##55	3.93793e-17
C49	X#16	a_83_260##33	1.6396e-18
C50	X#4	a_83_260##57	1.02277e-17
C51	VGND#23	VGND#22	2.63418e-18
C52	VGND#18	a_83_260##10	2.79061e-18
C53	X#14	a_83_260##30	1.3868e-18
C54	X#8	a_83_260##48	5.98427e-18
C55	VPWR#20	a_83_260##42	3.61449e-19
C56	VPWR#18	a_83_260##46	3.05054e-18
C57	VPWR#10	VPWR#8	6.93111e-19
C58	a_83_260##72	VGND#7	1.83465e-18
C59	X#27	VPWR#6	8.4779e-18
C60	VGND#23	VGND#12	3.06168e-19
C61	VGND#7	a_83_260##8	4.71594e-20
C62	a_83_260##78	VPWR#4	9.08199e-22
C63	a_83_260##77	a_83_260##80	1.36226e-18
C64	VGND#6	a_83_260##8	2.35797e-21
C65	a_83_260##72	VGND#6	3.16175e-20
C66	X#23	VPWR#10	8.42937e-18
C67	a_83_260##33	VGND#20	2.00997e-17
C68	a_83_260##84	a_83_260##85	1.63554e-18
C69	X#9	a_83_260##46	4.41185e-17
C70	X#13	a_83_260##48	1.56674e-17
C71	VPWR#20	VPWR#18	1.88846e-18
C72	VGND#2	a_83_260##85	1.31825e-17
C73	VGND#21	a_83_260##30	1.76533e-19
C74	X#23	VPWR#8	9.45412e-18
C75	VPWR#14	a_83_260##27	2.85183e-19
C76	VGND#6	VGND#5	9.53543e-19
C77	X#4	a_83_260##54	5.84668e-18
C78	VGND#23	X#8	6.49166e-17
C79	a_83_260##46	VPWR#20	2.71722e-17
C80	a_83_260##67	a_83_260##28	1.07402e-18
C81	VPWR#18	a_83_260##52	1.49999e-19
C82	a_83_260##83	A#1	5.6009e-20
C83	X#14	a_83_260##33	4.32692e-17
C84	VPWR#12	a_83_260##27	4.85788e-18
C85	X#20	a_83_260##10	5.56682e-18
C86	VGND#5	A#17	6.3656e-19
C87	X#9	a_83_260##52	1.13926e-18
C88	VPWR#20	X#9	5.49348e-17
C89	VGND#20	a_83_260##37	4.0342e-19
C90	a_83_260##8	VPWR#10	3.20628e-19
C91	A#6	VPWR#4	3.94035e-19
C92	X#16	a_83_260##12	1.94363e-19
C93	VPWR#3	VPWR#1	5.70035e-17
C94	VPWR#10	a_83_260##27	8.1728e-20
C95	a_83_260##84	VGND#4	4.16102e-17
C96	VGND#13	X#4	1.40166e-17
C97	a_83_260##78	VPWR#7	2.48711e-17
C98	VPWR#22	a_83_260##46	1.48984e-19
C99	VGND#21	a_83_260##33	2.52424e-18
C100	a_83_260##52	VPWR#20	3.52072e-17
C101	a_83_260##72	VGND#18	5.5341e-18
C102	a_83_260##76	A#3	1.22606e-18
C103	A#8	A#7	4.0818e-18
C104	X#4	X#8	4.15047e-18
C105	a_83_260##65	a_83_260##48	4.20918e-18
C106	VPWR#3	a_83_260##75	1.89605e-17
C107	A#3	a_83_260##75	9.30524e-19
C108	X#14	a_83_260##28	6.75292e-20
C109	X#24	a_83_260##6	8.02578e-18
C110	X#14	a_83_260##37	1.54101e-17
C111	X#26	a_83_260##80	5.80462e-19
C112	X#11	a_83_260##33	4.93146e-19
C113	VGND#8	a_83_260##13	2.58067e-19
C114	VPWR#22	a_83_260##52	3.33713e-19
C115	VPWR#20	a_83_260##56	3.50417e-18
C116	VGND#20	a_83_260##41	1.76533e-19
C117	a_83_260##79	VPWR#3	3.0878e-17
C118	a_83_260##77	VPWR#7	1.02761e-17
C119	VPWR#17	a_83_260##31	8.1728e-20
C120	a_83_260##72	VPWR#10	3.73116e-19
C121	a_83_260##37	VGND#21	1.77507e-17
C122	X#4	a_83_260##48	6.55215e-20
C123	VGND#15	VGND#4	1.66094e-18
C124	X#4	VGND#23	6.66333e-17
C125	X#19	VGND#18	5.08244e-19
C126	a_83_260##56	X#5	2.38001e-17
C127	A#6	a_83_260##79	6.21314e-19
C128	X#26	X#27	1.82349e-18
C129	A#2	a_83_260##75	1.98838e-18
C130	VPWR#14	a_83_260##31	7.87992e-18
C131	X#19	X#20	4.41049e-19
C132	A#12	A#10	4.66291e-17
C133	X#14	a_83_260##41	3.24371e-18
C134	a_83_260##80	VPWR#3	2.49152e-17
C135	a_83_260##83	A#11	8.83271e-20
C136	X#10	a_83_260##48	2.07244e-17
C137	X#26	VPWR#9	2.42758e-17
C138	a_83_260##56	VPWR#22	2.39253e-17
C139	VPWR#20	a_83_260##59	1.73487e-19
C140	X#11	a_83_260##37	2.57124e-18
C141	A#7	VPWR#5	5.82842e-19
C142	A#3	VPWR#4	8.4199e-19
C143	VPWR#12	a_83_260##31	2.85183e-19
C144	VGND#5	A#19	5.5016e-18
C145	a_83_260##13	VPWR#12	3.86201e-19
C146	X#16	a_83_260##10	5.73445e-20
C147	a_83_260##41	VGND#21	2.01656e-17
C148	VPWR#22	VPWR#20	1.97214e-18
C149	VGND#9	a_83_260##28	8.11623e-20
C150	VGND#14	VGND#23	1.72421e-18
C151	VPWR#3	X#27	1.61166e-17
C152	A#8	a_83_260##80	3.0152e-19
C153	VGND#15	a_83_260##84	4.15829e-17
C154	VGND#22	a_83_260##37	1.85684e-19
C155	VPWR#23	a_83_260##56	2.59902e-19
C156	a_83_260##59	VPWR#22	3.09825e-17
C157	VGND#14	VGND#13	1.20738e-18
C158	a_83_260##69	X#20	3.46937e-18
C159	A#14	A#12	4.844e-17
C160	A#6	VPWR#5	6.7357e-19
C161	X#11	a_83_260##41	4.52491e-17
C162	X#20	a_83_260##6	7.30332e-20
C163	a_83_260##69	VGND#19	4.97543e-18
C164	a_83_260##69	VGND#8	1.97197e-18
C165	a_83_260##63	a_83_260##48	5.36329e-18
C166	VPWR#8	VPWR#6	6.99578e-19
C167	A#7	A#6	4.36013e-18
C168	X#19	VPWR#12	1.14191e-18
C169	VGND#9	a_83_260##29	6.53992e-19
C170	VPWR#23	a_83_260##59	1.23306e-18
C171	VGND#21	a_83_260##45	4.0342e-19
C172	VGND#14	X#4	6.93498e-17
C173	A#7	a_83_260##80	2.43044e-19
C174	VPWR#22	a_83_260##60	4.19748e-18
C175	a_83_260##69	VGND#7	3.26486e-19
C176	VPWR#17	a_83_260##34	2.85183e-19
C177	X#19	VPWR#10	1.34855e-18
C178	VGND#22	a_83_260##41	2.86622e-18
C179	VGND#8	a_83_260##28	3.22682e-20
C180	a_83_260##82	a_83_260##84	1.67195e-18
C181	a_83_260##60	X#1	2.43399e-17
C182	VGND#2	a_83_260##84	1.34614e-18
C183	A#16	A#14	4.67642e-17
C184	VPWR#14	a_83_260##34	3.41539e-18
C185	X#11	a_83_260##45	1.48282e-17
C186	a_83_260##83	A#13	1.73695e-17
C187	VPWR#23	a_83_260##60	3.307e-17
C188	X#8	a_83_260##41	1.52039e-19
C189	VPWR#12	a_83_260##34	8.1728e-20
C190	a_83_260##29	VPWR#14	6.30106e-19
C191	X#15	X#16	1.50336e-19
C192	VGND#21	a_83_260##49	1.76533e-19
C193	VGND#5	a_83_260#	1.02994e-17
C194	X#7	a_83_260##48	6.5914e-18
C195	a_83_260##74	VPWR#9	5.03252e-18
C196	a_83_260##45	VGND#22	1.78578e-17
C197	a_83_260##81	A#13	3.90164e-20
C198	a_83_260##82	VGND#15	4.16102e-17
C199	A#18	A#16	4.844e-17
C200	X#11	a_83_260##49	3.10129e-18
C201	VGND#4	A#6	6.08518e-19
C202	X#8	a_83_260##45	1.57627e-18
C203	X#18	VPWR#12	8.52757e-18
C204	a_83_260##62	a_83_260##57	1.4179e-18
C205	VPWR#19	a_83_260##38	8.74044e-20
C206	X#23	VPWR#9	7.70031e-17
C207	a_83_260##67	X#16	3.29355e-18
C208	a_83_260##62	a_83_260##54	3.85499e-18
C209	VPWR#23	VPWR#22	1.88846e-18
C210	a_83_260##69	VPWR#12	1.60363e-19
C211	VGND#11	a_83_260##36	3.88581e-19
C212	a_83_260##49	VGND#22	2.15465e-17
C213	a_83_260##67	VGND#20	5.61408e-18
C214	X#23	X#21	1.68504e-17
C215	VPWR#17	a_83_260##38	4.58644e-18
C216	VGND#23	a_83_260##45	3.00999e-19
C217	VGND#1	A#2	3.34148e-20
C218	A#9	A#18	4.67323e-17
C219	VGND#16	VGND#15	1.66094e-18
C220	X#23	VPWR#11	6.90291e-17
C221	X#11	a_83_260##51	1.48431e-19
C222	X#18	VPWR#10	7.45888e-18
C223	VGND#6	a_83_260##15	4.45341e-18
C224	a_83_260##85	A#3	2.01555e-18
C225	VPWR#14	a_83_260##38	2.85183e-19
C226	a_83_260##49	X#8	1.84755e-17
C227	a_83_260##83	A#15	1.69132e-17
C228	a_83_260##78	A#11	3.45046e-20
C229	a_83_260##36	VPWR#17	3.57373e-19
C230	VGND#22	a_83_260##51	1.52827e-18
C231	X#3	a_83_260##57	9.5422e-18
C232	a_83_260##78	A#13	4.42268e-20
C233	X#13	VGND#20	7.15045e-19
C234	VGND#23	a_83_260##49	2.12006e-18
C235	VGND#5	a_83_260##15	6.60951e-19
C236	X#3	a_83_260##54	6.23473e-18
C237	VGND#15	A#7	4.93321e-19
C238	a_83_260##72	VPWR#11	5.03252e-18
C239	a_83_260##14	A#9	3.80006e-17
C240	X#13	X#14	3.03509e-19
C241	a_83_260##81	A#15	9.24914e-20
C242	a_83_260##78	A#15	8.13249e-20
C243	VGND#16	a_83_260##82	4.15829e-17
C244	a_83_260##51	X#8	2.19664e-17
C245	a_83_260##85	A#2	4.28527e-18
C246	a_83_260##75	VPWR#1	7.81108e-17
C247	VGND#5	a_83_260##82	5.24871e-18
C248	a_83_260##28	a_83_260##12	9.6785e-19
C249	a_83_260##78	A#17	1.39025e-19
C250	X#4	a_83_260##49	1.44533e-19
C251	A#6	A#3	4.01558e-18
C252	VGND#4	A#3	3.89165e-19
C253	X#15	VPWR#14	1.05669e-18
C254	a_83_260##67	VGND#9	1.91919e-18
C255	VGND#22	a_83_260##55	1.89206e-19
C256	VPWR#19	a_83_260##42	3.00302e-19
C257	VGND#5	A#8	3.62715e-20
C258	a_83_260##78	A#19	3.54953e-19
C259	X#19	VPWR#11	2.57514e-17
C260	VGND#23	a_83_260##51	1.76462e-17
C261	X#15	VPWR#12	6.02129e-19
C262	VGND#12	a_83_260##47	3.99435e-19
C263	a_83_260##67	VGND#8	5.08815e-19
C264	a_83_260##16	a_83_260##14	4.7752e-17
C265	VGND#15	A#6	2.95869e-19
C266	a_83_260##65	X#14	2.79906e-18
C267	X#19	X#18	1.55202e-18
C268	VPWR#17	a_83_260##42	4.37017e-18
C269	X#25	a_83_260##82	1.72657e-18
C270	X#8	a_83_260##55	1.53168e-18
C271	VPWR#4	VPWR#1	1.94092e-18
C272	a_83_260##65	VGND#21	4.18092e-18
C273	VGND#3	A#1	2.68833e-19
C274	X#19	VPWR#13	3.22444e-17
C275	X#4	a_83_260##51	5.86702e-19
C276	VGND#8	a_83_260##12	4.71594e-20
C277	VGND#6	a_83_260##17	5.07635e-18
C278	VPWR#14	a_83_260##42	8.1728e-20
C279	a_83_260##83	A#17	9.24914e-20
C280	VGND#13	VGND#12	1.19575e-18
C281	VPWR#16	a_83_260##48	7.57232e-19
C282	VGND#3	A#11	9.53283e-19
C283	a_83_260##47	VPWR#19	2.81011e-19
C284	VGND#23	a_83_260##55	3.76213e-17
C285	a_83_260##18	a_83_260##16	4.8989e-17
C286	X#17	VPWR#14	8.52757e-18
C287	VGND#3	A#13	1.33655e-18
C288	VGND#5	a_83_260##17	2.08841e-19
C289	a_83_260##69	VPWR#13	8.05575e-18
C290	a_83_260##81	A#17	1.70261e-17
C291	a_83_260##75	VPWR#4	5.25446e-17
C292	X#8	a_83_260##58	2.37858e-19
C293	VGND#3	A#15	6.1862e-18
C294	X#10	VGND#21	4.26486e-19
C295	X#25	VGND#16	4.23256e-17
C296	A#11	A#1	2.97428e-17
C297	X#4	a_83_260##55	1.33315e-17
C298	X#10	X#11	3.8496e-19
C299	VGND#3	A#17	6.02102e-18
C300	VPWR#21	a_83_260##46	8.22565e-20
C301	VGND#7	a_83_260##12	3.03589e-20
C302	X#17	VPWR#12	8.44177e-18
C303	VPWR#16	a_83_260##28	2.15472e-23
C304	VGND#23	a_83_260##58	3.07206e-18
C305	A#5	A#8	1.39208e-17
C306	VGND#3	A#19	1.36196e-18
C307	a_83_260##20	a_83_260##18	4.81847e-17
C308	a_83_260##67	VPWR#14	2.02526e-19
C309	VGND#10	a_83_260##48	9.21614e-20
C310	VGND#14	a_83_260##55	1.22264e-18
C311	VPWR#19	a_83_260##46	5.56734e-18
C312	A#5	A#7	1.97414e-17
C313	X#15	VPWR#13	2.69101e-17
C314	VGND#7	a_83_260##19	5.33562e-18
C315	VGND#13	a_83_260##53	5.01069e-20
C316	A#5	A#6	4.00646e-17
C317	VGND#3	a_83_260#	2.25552e-18
C318	a_83_260##79	a_83_260##75	2.36849e-18
C319	VGND#12	a_83_260##53	1.26741e-20
C320	X#15	X#17	1.14787e-18
C321	X#4	a_83_260##58	3.82447e-17
C322	VPWR#17	a_83_260##46	2.85183e-19
C323	VGND#17	VGND#16	1.47611e-18
C324	A#5	A#3	2.03074e-17
C325	VPWR#16	a_83_260##10	2.15472e-23
C326	VGND#3	a_83_260##15	1.69168e-18
C327	a_83_260##63	X#11	3.03054e-18
C328	VPWR#15	X#15	1.44931e-17
C329	A#5	A#2	2.44285e-17
C330	a_83_260##83	A#19	3.90164e-20
C331	a_83_260##63	VGND#22	2.57658e-18
C332	a_83_260##21	a_83_260##20	4.86704e-17
C333	A#13	A#11	3.01457e-17
C334	VGND#6	X#25	6.79046e-18
C335	VGND#14	a_83_260##58	2.55608e-17
C336	a_83_260##53	VPWR#21	4.22963e-19
C337	VPWR#16	a_83_260##6	2.15472e-23
C338	a_83_260##27	a_83_260##12	1.39919e-18
C339	a_83_260##48	a_83_260##38	1.39354e-18
C340	a_83_260##79	VPWR#4	5.20507e-17
C341	VGND#1	A#1	4.15223e-17
C342	a_83_260##5	A#8	2.65469e-17
C343	VGND#10	a_83_260##12	4.74935e-23
C344	a_83_260##67	VPWR#15	5.04736e-18
C345	a_83_260##81	A#19	1.57603e-17
C346	VGND#17	X#25	7.41228e-17
C347	A#3	A#2	3.41818e-18
C348	a_83_260##23	a_83_260##21	4.71775e-17
C349	VPWR#21	a_83_260##52	2.93767e-19
C350	X#13	VPWR#17	5.07834e-19
C351	A#1	a_83_260##85	2.2956e-17
C352	VGND#5	X#25	6.96257e-18
C353	a_83_260##83	a_83_260##85	4.95938e-19
C354	VPWR#5	VPWR#4	1.87864e-18
C355	VGND#13	a_83_260##57	5.45281e-20
C356	VPWR#2	A#10	2.36459e-18
C357	a_83_260##65	VGND#11	1.10791e-18
C358	X#13	VPWR#14	1.39467e-19
C359	X#13	VPWR#15	1.12318e-17
C360	VPWR#19	a_83_260##52	8.26385e-18
C361	A#15	A#13	4.09634e-17
C362	VGND#1	A#11	2.55785e-18
C363	a_83_260##12	a_83_260##10	4.97718e-18
C364	X#13	X#12	1.91031e-18
C365	VGND#7	a_83_260##22	2.82585e-18
C366	a_83_260##27	a_83_260##23	4.86622e-17
C367	VPWR#17	a_83_260##52	7.86402e-20
C368	X#24	X#25	4.75635e-18
C369	VGND#4	A#1	1.19821e-18
C370	X#13	VPWR#18	3.13215e-17
C371	VPWR#5	a_83_260##79	5.21059e-17
C372	a_83_260##85	A#11	3.96755e-17
C373	a_83_260##62	VGND#23	3.19462e-18
C374	VGND#12	VGND#11	1.2198e-18
C375	VPWR#21	VPWR#19	7.35961e-19
C376	A#10	VPWR#1	3.36307e-17
C377	a_83_260##84	A#1	1.84711e-19
C378	a_83_260##31	a_83_260##27	4.67028e-17
C379	VGND#9	a_83_260##24	6.8612e-20
C380	VGND#1	A#13	2.82072e-19
C381	a_83_260##65	VPWR#18	5.03252e-18
C382	a_83_260##81	a_83_260#	5.07976e-18
C383	VGND#2	A#6	4.53394e-22
C384	X#24	VGND#17	7.52794e-17
C385	A#17	A#15	3.97309e-17
C386	A#11	VGND#4	1.67507e-17
C387	VPWR#14	a_83_260##28	4.18069e-20
C388	a_83_260##80	a_83_260##79	2.36849e-18
C389	a_83_260##75	A#10	5.53366e-17
C390	VGND#1	A#5	2.75072e-17
C391	a_83_260##78	A#12	1.1259e-19
C392	VGND#8	a_83_260##24	7.51879e-18
C393	VGND#10	VGND#17	9.16456e-18
C394	a_83_260##65	VPWR#17	3.16835e-19
C395	a_83_260##85	A#5	5.24989e-17
C396	VPWR#21	a_83_260##56	1.0093e-17
C397	a_83_260##85	A#13	1.12155e-18
C398	a_83_260##83	VGND#4	2.2473e-17
C399	a_83_260##34	a_83_260##31	4.89771e-17
C400	VGND#17	VGND#5	5.64916e-19
C401	VGND#7	a_83_260##10	1.56216e-20
C402	VGND#10	X#24	1.88537e-17
C403	X#3	X#4	1.75808e-19
C404	X#10	VPWR#18	2.31782e-17
C405	VPWR#2	A#12	7.3008e-18
C406	VPWR#1	A#12	1.23306e-18
C407	VGND#13	a_83_260##54	3.92013e-20
C408	VGND#7	X#24	7.40157e-18
C409	a_83_260##78	A#14	1.69998e-19
C410	VGND#10	VGND#18	1.71605e-17
C411	VPWR#4	A#10	6.79311e-19
C412	X#10	X#9	1.84778e-18
C413	VPWR#19	a_83_260##56	3.51097e-19
C414	a_83_260##84	A#11	2.91292e-19
C415	a_83_260##6	a_83_260##5	3.99192e-18
C416	VGND#10	X#20	2.06186e-17
C417	X#10	VPWR#20	3.67543e-17
C418	a_83_260##78	A#16	2.68914e-19
C419	VGND#10	VGND#19	1.32254e-17
C420	a_83_260##80	VPWR#5	5.20507e-17
C421	VGND#18	VGND#17	1.98916e-18
C422	VPWR#3	A#10	2.47835e-18
C423	a_83_260##75	A#12	6.36917e-17
C424	VGND#4	A#13	3.14085e-17
C425	VGND#10	X#16	2.16166e-17
C426	a_83_260##78	A#18	4.75053e-19
C427	a_83_260##8	a_83_260##12	1.56516e-19
C428	a_83_260##38	a_83_260##34	4.77979e-17
C429	VPWR#12	a_83_260##28	5.79723e-20
C430	VPWR#3	A#12	3.11413e-19
C431	A#19	A#17	4.09634e-17
C432	VGND#10	X#14	3.07145e-17
C433	X#26	A#16	6.29558e-19
C434	VPWR#1	A#14	2.59902e-19
C435	a_83_260##85	A#15	1.80254e-19
C436	a_83_260##8	a_83_260##10	5.5794e-18
C437	A#12	VPWR#4	2.47104e-17
C438	a_83_260##78	A#9	2.41901e-18
C439	VPWR#3	A#14	1.15295e-18
C440	VGND#6	X#24	8.47929e-18
C441	a_83_260##63	VPWR#20	9.22352e-18
C442	VGND#10	X#11	1.79086e-17
C443	X#26	A#18	4.1119e-19
C444	VGND#8	VGND#18	3.93488e-19
C445	A#13	a_83_260##84	1.38215e-17
C446	VPWR#7	VPWR#5	2.02693e-18
C447	a_83_260##78	a_83_260##14	9.85044e-18
C448	a_83_260##81	a_83_260##15	5.60241e-19
C449	a_83_260##8	a_83_260##6	3.59021e-18
C450	VPWR#3	A#16	5.94079e-18
C451	VGND#9	a_83_260##26	2.67285e-19
C452	a_83_260##75	A#14	1.77076e-18
C453	VGND#18	X#24	6.18341e-17
C454	VGND#10	X#8	1.62821e-17
C455	X#26	A#9	1.33489e-18
C456	a_83_260##42	a_83_260##38	4.86154e-17
C457	a_83_260##79	A#12	1.66337e-18
C458	VGND#4	A#15	1.21722e-18
C459	VGND#10	VGND#23	1.48297e-17
C460	a_83_260##28	a_83_260##13	2.52275e-18
C461	VPWR#3	A#18	5.92792e-18
C462	X#25	a_83_260##5	1.63436e-17
C463	X#10	VPWR#19	1.14191e-18
C464	VGND#10	X#4	1.77431e-17
C465	X#26	a_83_260##14	1.25045e-17
C466	a_83_260##5	VGND#17	4.46311e-17
C467	X#7	VPWR#20	7.1234e-17
C468	A#14	VPWR#4	2.84583e-17
C469	X#9	VPWR#19	8.52757e-18
C470	a_83_260##13	a_83_260##12	3.92938e-18
C471	a_83_260##63	VGND#13	5.83011e-21
C472	VGND#15	A#13	1.21722e-18
C473	VGND#10	VGND#14	5.20848e-17
C474	X#10	VPWR#17	1.48364e-18
C475	VPWR#3	A#9	4.88571e-19
C476	a_83_260##83	a_83_260##84	1.24483e-18
C477	VGND#8	a_83_260##26	5.27114e-18
C478	VPWR#21	a_83_260##59	8.75638e-18
C479	X#24	a_83_260##5	2.3574e-17
C480	VPWR#5	A#12	1.53981e-19
C481	X#7	X#5	5.01399e-18
C482	VPWR#2	A#14	5.07729e-18
C483	a_83_260##48	a_83_260##29	3.8756e-18
C484	X#26	a_83_260##16	1.14013e-17
C485	a_83_260#	A#19	3.90184e-17
C486	a_83_260##63	VGND#12	2.39579e-18
C487	VPWR#7	a_83_260##80	6.12484e-17
C488	a_83_260##77	VPWR#6	1.6661e-19
C489	X#7	VPWR#22	8.15679e-17
C490	a_83_260##46	a_83_260##42	4.72861e-17
C491	VPWR#3	a_83_260##14	2.18233e-18
C492	VPWR#19	a_83_260##59	9.91208e-20
C493	A#15	a_83_260##84	1.72195e-17
C494	a_83_260##63	VGND#11	2.68185e-19
C495	a_83_260##79	A#14	5.23881e-17
C496	X#26	a_83_260##18	1.22179e-18
C497	a_83_260##76	A#12	1.07385e-19
C498	X#20	X#24	9.45503e-18
C499	VPWR#3	a_83_260##16	9.98361e-19
C500	a_83_260##57	a_83_260##54	3.54562e-18
C501	a_83_260##82	A#13	1.28671e-19
C502	X#9	VPWR#17	5.72145e-18
C503	X#26	a_83_260##20	2.54789e-19
C504	VPWR#4	A#16	3.44144e-19
C505	a_83_260##29	a_83_260##28	4.23051e-18
C506	VPWR#5	A#14	3.44144e-19
C507	a_83_260##62	VPWR#22	5.03252e-18
C508	a_83_260##52	a_83_260##46	3.86878e-17
C509	VPWR#16	X#18	1.79595e-17
C510	VGND#11	a_83_260##30	7.22286e-20
C511	VGND#15	A#15	3.27157e-17
C512	A#5	VPWR#1	3.34715e-17
C513	X#27	a_83_260##80	1.5524e-18
C514	X#24	a_83_260##8	3.05072e-17
C515	a_83_260##8	VGND#18	2.77996e-17
C516	A#5	a_83_260##75	5.24109e-17
C517	a_83_260##79	A#16	4.59447e-17
C518	X#20	a_83_260##8	9.45692e-18
C519	VPWR#19	VPWR#17	6.99578e-19
C520	VPWR#16	X#17	1.80036e-17
C521	a_83_260##36	a_83_260##48	2.56852e-17
C522	a_83_260##84	A#17	3.05025e-19
C523	VGND#11	VGND#9	1.21087e-18
C524	a_83_260##15	a_83_260#	3.9376e-17
C525	VGND#8	X#20	7.50175e-18
C526	a_83_260##74	a_83_260##16	3.63485e-19
C527	X#20	VGND#18	6.67399e-17
C528	VGND#9	a_83_260##30	6.49127e-18
C529	X#12	VPWR#16	3.04249e-17
C530	X#23	a_83_260##14	2.31707e-19
C531	VPWR#4	A#18	1.53981e-19
C532	VPWR#6	A#16	9.43017e-20
C533	a_83_260##82	A#15	3.05025e-19
C534	a_83_260##56	a_83_260##52	4.72888e-17
C535	X#3	VPWR#22	6.13515e-17
C536	VGND#2	A#3	4.64729e-20
C537	a_83_260##74	a_83_260##18	1.84655e-19
C538	A#16	VPWR#5	2.47104e-17
C539	a_83_260##60	a_83_260##54	1.39477e-18
C540	X#27	VPWR#7	5.22219e-17
C541	X#3	X#1	4.63702e-18
C542	a_83_260##63	VPWR#19	4.17025e-19
C543	X#23	a_83_260##16	2.44088e-18
C544	VPWR#16	X#9	1.65171e-17
C545	a_83_260##83	VGND#15	1.47891e-17
C546	VPWR#23	X#3	9.93688e-17
C547	VGND#15	A#17	2.81866e-17
C548	a_83_260##78	A#8	1.17338e-17
C549	a_83_260##79	A#18	1.66337e-18
C550	VPWR#21	a_83_260##60	2.30142e-18
C551	VPWR#2	A#16	2.85183e-19
C552	X#23	a_83_260##18	2.68756e-17
C553	a_83_260##80	A#16	1.66337e-18
C554	a_83_260##13	X#20	2.08088e-17
C555	a_83_260##59	a_83_260##56	4.86479e-17
C556	a_83_260##13	VGND#19	4.06082e-17
C557	a_83_260##78	A#7	3.41769e-19
C558	VGND#7	X#20	8.93167e-18
C559	X#23	a_83_260##20	2.38741e-17
C560	a_83_260##84	A#19	1.28671e-19
C561	VGND#19	VGND#18	1.52488e-18
C562	X#16	a_83_260##13	1.40841e-17
C563	a_83_260##76	A#14	1.75321e-17
C564	a_83_260##47	a_83_260##48	2.60475e-17
C565	A#18	VPWR#5	2.84561e-17
C566	VGND#9	VGND#19	1.01104e-19
C567	VPWR#9	VPWR#7	1.94092e-18
C568	VPWR#7	A#16	1.78306e-19
C569	a_83_260##17	a_83_260##15	2.20876e-17
C570	X#23	a_83_260##21	3.99635e-18
C571	a_83_260##78	A#6	3.08648e-19
C572	A#17	a_83_260##82	1.38198e-17
C573	VPWR#16	VPWR#23	5.44994e-17
C574	a_83_260##5	X#27	2.29472e-19
C575	VPWR#12	a_83_260##12	7.61857e-21
C576	a_83_260##5	VPWR#9	1.80923e-17
C577	X#23	a_83_260##23	2.64589e-19
C578	X#19	a_83_260##18	2.76705e-19
C579	a_83_260##60	a_83_260##59	4.72814e-17
C580	a_83_260##81	VGND#15	1.34605e-17
C581	a_83_260##80	A#18	5.23881e-17
C582	VGND#15	A#19	1.21722e-18
C583	VGND#11	a_83_260##33	2.66478e-19
C584	X#19	a_83_260##20	1.06657e-18
C585	a_83_260##78	A#3	8.48239e-20
C586	VGND#16	A#17	1.21722e-18
C587	X#26	A#8	7.12351e-20
C588	VGND#10	VPWR#23	3.76296e-18
C589	VPWR#5	A#9	3.42982e-19
C590	VGND#19	X#20	5.82515e-17
C591	X#16	a_83_260##29	2.27545e-17
C592	VPWR#9	X#27	4.22157e-17
C593	VPWR#7	A#18	4.09291e-19
C594	a_83_260##53	a_83_260##57	1.11573e-19
C595	X#19	a_83_260##21	9.88441e-18
C596	a_83_260##29	VGND#20	3.35644e-17
C597	a_83_260##53	a_83_260##54	1.05241e-17
C598	VPWR#6	A#8	2.25183e-20
C599	X#14	a_83_260##29	7.3094e-18
C600	VPWR#6	A#18	3.40035e-19
C601	VGND#12	a_83_260##48	7.75183e-20
C602	VGND#9	a_83_260##33	5.41922e-18
C603	A#19	a_83_260##82	1.72195e-17
C604	a_83_260##53	a_83_260##48	4.98602e-18
C605	X#19	a_83_260##23	1.05372e-17
C606	X#7	VPWR#21	9.78728e-18
C607	VGND#2	A#2	5.73543e-20
C608	a_83_260##80	A#9	4.55831e-17
C609	a_83_260##8	X#21	9.94324e-20
C610	a_83_260##19	a_83_260##17	3.84804e-17
C611	X#7	VPWR#19	7.8539e-18
C612	X#25	A#17	1.87602e-19
C613	a_83_260##8	VPWR#11	1.75796e-17
C614	X#19	a_83_260##27	1.14535e-18
C615	a_83_260##77	A#16	1.07385e-19
C616	VPWR#2	A#18	8.1728e-20
C617	a_83_260##81	a_83_260##83	5.06977e-19
C618	a_83_260##76	VPWR#2	3.13618e-19
C619	X#19	a_83_260##31	1.53607e-20
C620	VPWR#5	a_83_260##14	1.53123e-19
C621	a_83_260##62	VGND#13	1.61211e-18
C622	A#9	VPWR#7	2.34314e-17
C623	VGND#16	A#19	3.27157e-17
C624	a_83_260##69	a_83_260##27	8.42245e-19
C625	X#16	X#20	4.21546e-18
C626	a_83_260##76	A#16	1.75418e-17
C627	VGND#1	VPWR#1	3.45202e-19
C628	VPWR#2	VPWR#1	7.0017e-19
C629	X#15	a_83_260##23	1.12721e-18
C630	a_83_260##36	X#14	1.25871e-17
C631	a_83_260##36	VGND#21	1.08507e-17
C632	a_83_260##80	a_83_260##14	1.39238e-18
C633	VGND#12	a_83_260##37	7.40023e-20
C634	VGND#9	X#16	9.60816e-18
C635	a_83_260##82	a_83_260#	3.05025e-19
C636	VGND#10	a_83_260##17	2.21821e-18
C637	X#27	A#9	1.34469e-18
C638	X#11	a_83_260##36	8.29085e-18
C639	X#15	a_83_260##27	1.43531e-17
C640	VGND#10	a_83_260##19	1.73895e-18
C641	a_83_260##78	X#26	1.18677e-16
C642	VGND#11	a_83_260##48	4.65699e-20
C643	VPWR#3	A#7	1.6104e-20
C644	X#25	A#19	4.29282e-19
C645	a_83_260##13	VPWR#13	1.30788e-17
C646	X#15	a_83_260##31	1.19615e-17
C647	a_83_260##81	a_83_260##82	1.24483e-18
C648	VGND#10	a_83_260##22	2.52438e-19
C649	a_83_260##22	a_83_260##19	2.2545e-17
C650	a_83_260##14	VPWR#7	2.94722e-17
C651	VGND#10	a_83_260##24	2.79583e-18
C652	a_83_260##78	VPWR#3	9.22065e-18
C653	VPWR#3	A#6	4.64013e-20
C654	VPWR#9	A#9	1.54166e-19
C655	X#15	a_83_260##34	1.08168e-18
C656	VPWR#8	A#9	7.86402e-20
C657	VGND#11	a_83_260##37	4.05528e-18
C658	VGND#10	a_83_260##26	3.58253e-19
C659	X#16	VGND#19	7.52449e-17
C660	a_83_260##78	VGND#6	2.34598e-19
C661	VGND#16	a_83_260#	2.78741e-17
C662	a_83_260##67	a_83_260##31	2.81159e-19
C663	VPWR#17	VPWR#14	6.93111e-19
C664	X#15	a_83_260##38	2.20073e-19
C665	X#26	VPWR#3	1.11405e-17
C666	VGND#3	a_83_260##78	1.08851e-17
C667	VGND#6	a_83_260##6	4.36225e-20
C668	X	VPWR#14	7.11903e-19
C669	a_83_260##5	A#19	1.10941e-18
C670	X#27	a_83_260##14	5.08022e-17
C671	VGND#10	a_83_260##33	3.32751e-18
C672	a_83_260##67	a_83_260##34	4.21992e-19
C673	VPWR#6	A#7	1.77417e-21
C674	VGND#9	VGND#8	1.02195e-18
C675	a_83_260##78	VGND#5	1.79161e-18
C676	VGND#8	X#16	9.67997e-18
C677	VPWR#6	A#9	4.55094e-18
C678	a_83_260##47	X#11	1.89056e-17
C679	a_83_260##82	a_83_260##15	1.28671e-19
C680	VGND#10	a_83_260##37	3.72677e-18
C681	X#13	a_83_260##31	1.17859e-18
C682	a_83_260##47	VGND#22	2.3554e-17
C683	VGND#9	a_83_260##37	2.66478e-19
C684	a_83_260##62	VPWR#21	4.44967e-19
C685	VPWR#11	VPWR#9	1.82787e-18
C686	X#8	a_83_260##47	2.27708e-17
C687	VGND#10	a_83_260##41	7.66403e-19
C688	VGND#3	A#8	5.21403e-21
C689	VPWR#7	a_83_260##16	3.71489e-19
C690	a_83_260##77	A#18	1.75321e-17
C691	X#25	a_83_260#	1.22044e-17
C692	a_83_260##29	VPWR#15	1.7981e-17
C693	X#13	a_83_260##34	1.08498e-17
C694	VPWR#9	a_83_260##14	3.02031e-18
C695	VGND#10	a_83_260##45	2.7347e-18
C696	a_83_260##74	X#26	6.90413e-17
C697	VGND#3	A#7	3.01507e-20
C698	VGND#10	a_83_260##49	2.48747e-18
C699	X#13	a_83_260##38	1.24771e-17
C700	VGND#20	VGND#19	2.16128e-18
C701	a_83_260##24	a_83_260##22	3.94178e-17
C702	VGND#10	a_83_260##51	2.43456e-18
C703	X#23	X#26	2.69286e-18
C704	VGND#16	a_83_260##15	1.22771e-18
C705	a_83_260##16	X#27	1.31214e-17
C706	X#13	a_83_260##42	1.1632e-18
C707	a_83_260##76	A#18	1.07385e-19
C708	VGND#3	A#6	7.39032e-20
C709	VGND#10	a_83_260##55	4.52476e-18
C710	a_83_260##75	VPWR#2	1.71045e-17
C711	a_83_260##65	a_83_260##38	2.30234e-19
C712	VGND#3	a_83_260##74	5.72937e-18
C713	X#11	a_83_260##53	6.90374e-20
C714	VGND#17	a_83_260#	7.26534e-19
C715	X#13	a_83_260##46	2.76421e-19
C716	VGND#10	a_83_260##58	4.70994e-18
C717	VPWR#7	a_83_260##18	1.72497e-19
C718	X#8	a_83_260##53	3.04706e-17
C719	a_83_260##16	VPWR#9	2.51712e-17
C720	VGND#12	a_83_260##41	2.72377e-19
C721	a_83_260##53	VGND#23	3.40294e-17
C722	X#4	a_83_260##53	2.19711e-17
C723	a_83_260##36	VPWR#18	1.55263e-17
C724	X#10	a_83_260##38	1.28422e-18
C725	a_83_260##48	X#12	1.1473e-19
C726	X#25	a_83_260##15	3.68911e-17
C727	a_83_260##81	VGND#16	2.98905e-17
C728	VPWR#12	a_83_260##10	3.42817e-20
C729	VPWR#21	a_83_260##57	5.02826e-20
C730	X#10	a_83_260##42	1.02843e-17
C731	a_83_260##74	X#23	7.62152e-17
C732	X#27	a_83_260##18	2.54799e-18
C733	VGND#20	X#16	6.30772e-17
C734	VPWR#8	a_83_260##14	2.85183e-19
C735	VGND#3	A#2	2.17276e-19
C736	X#10	a_83_260##46	1.17444e-17
C737	VGND#16	a_83_260##17	1.20595e-19
C738	VGND#11	a_83_260##41	4.75613e-18
C739	A#5	A#10	5.88819e-18
C740	a_83_260##26	a_83_260##24	2.19512e-17
C741	X#10	a_83_260##52	1.06217e-18
C742	a_83_260##15	VGND#17	2.26243e-17
C743	a_83_260##18	VPWR#9	2.97724e-17
C744	a_83_260##72	X#23	7.68043e-17
C745	VPWR#11	a_83_260##16	1.49819e-19
C746	VPWR#16	a_83_260##18	1.46865e-18
C747	VPWR#6	a_83_260##14	1.0156e-17
C748	X#10	a_83_260##56	2.63031e-19
C749	VPWR#16	a_83_260##20	1.32219e-18
C750	a_83_260##47	VPWR#20	1.84523e-17
C751	X#3	VPWR#21	1.70846e-17
C752	X#19	X#23	2.74472e-18
C753	a_83_260##77	A#9	1.80665e-17
C754	VGND#9	a_83_260##41	7.22286e-20
C755	X#25	a_83_260##17	2.71113e-19
C756	VPWR#16	a_83_260##21	1.20114e-18
C757	X#7	a_83_260##46	1.89105e-18
C758	a_83_260##18	X#21	6.02091e-18
C759	a_83_260##81	a_83_260##77	3.14168e-18
C760	VPWR#10	a_83_260##10	4.12495e-20
C761	A#5	A#9	1.83096e-18
C762	a_83_260##48	VPWR#18	1.69194e-18
C763	VPWR#16	a_83_260##23	2.45415e-18
C764	a_83_260##72	X#19	7.82271e-17
C765	X#14	X#16	2.10748e-18
C766	X#7	a_83_260##52	2.17769e-17
C767	A#3	A#10	2.31808e-19
C768	X#24	a_83_260##15	2.75137e-19
C769	X#18	VPWR#11	4.78783e-17
C770	A#5	a_83_260##14	1.34298e-19
C771	VPWR#16	a_83_260##27	1.49791e-18
C772	a_83_260##78	VPWR#6	1.38189e-18
C773	X#7	a_83_260##56	3.17408e-17
C774	VPWR#9	a_83_260##20	1.47642e-18
C775	VPWR#16	a_83_260##31	2.04433e-18
C776	VPWR#11	a_83_260##18	1.5951e-18
C777	X#7	a_83_260##59	2.45095e-18
C778	a_83_260##17	VGND#17	2.75797e-17
C779	VPWR#16	a_83_260##34	4.695e-18
C780	a_83_260##30	a_83_260##26	3.85422e-17
C781	a_83_260##53	X#5	8.79595e-20
C782	a_83_260##69	X#19	7.42379e-17
C783	a_83_260##5	a_83_260##14	1.26665e-19
C784	a_83_260##81	A#8	1.75005e-18
C785	a_83_260##53	VPWR#22	1.80676e-17
C786	X#7	a_83_260##60	4.34297e-19
C787	VPWR#16	a_83_260##38	5.11498e-18
C788	a_83_260##5	a_83_260##16	2.64282e-18
C789	a_83_260##20	X#21	1.22652e-17
C790	VPWR#10	a_83_260##16	8.1728e-20
C791	VGND#18	a_83_260##15	2.90158e-19
C792	X#15	X#19	3.70155e-18
C793	VPWR#16	a_83_260##42	1.26572e-18
C794	a_83_260##5	a_83_260##18	1.67435e-18
C795	X#25	a_83_260##81	2.65008e-17
C796	VGND#12	a_83_260##45	6.16193e-18
C797	VPWR#13	VPWR#11	1.82787e-18
C798	X#3	a_83_260##56	3.7341e-18
C799	a_83_260##62	a_83_260##60	2.39025e-18
C800	VPWR#16	a_83_260##46	2.38983e-18
C801	a_83_260##12	X#18	1.91216e-20
C802	X#14	VGND#20	7.18196e-17
C803	a_83_260##69	X#15	7.84911e-17
C804	VPWR#21	a_83_260##54	4.05308e-20
C805	X#24	a_83_260##17	4.56862e-17
C806	VPWR#9	a_83_260##21	1.49819e-19
C807	X#3	a_83_260##59	2.34724e-17
C808	VPWR#16	a_83_260##52	9.14653e-19
C809	a_83_260##20	VPWR#11	2.47651e-17
C810	VPWR#8	a_83_260##16	6.58412e-18
C811	VGND#14	VPWR#23	9.71428e-18
C812	VGND#13	VNB	3.45444e-17
C813	a_83_260##48	X#9	2.29472e-19
C814	VGND#12	VNB	2.75421e-17
C815	VGND#11	VNB	2.13339e-17
C816	a_83_260##8	a_83_260##18	1.50778e-18
C817	X#3	a_83_260##60	3.10761e-17
C818	VPWR#16	a_83_260##56	1.74355e-18
C819	VGND#9	VNB	2.0614e-17
C820	VGND#8	VNB	3.12954e-17
C821	a_83_260##83	A#7	2.67062e-19
C822	VGND#7	VNB	3.10343e-17
C823	VGND#6	VNB	3.03426e-17
C824	VPWR#14	VPWR#12	6.93111e-19
C825	VGND#5	VNB	2.77983e-17
C826	VGND#11	a_83_260##45	2.66478e-19
C827	VGND#2	VNB	3.04411e-17
C828	VPWR#16	a_83_260##59	4.5721e-19
C829	VPWR#21	VNB	3.17585e-17
C830	VPWR#23	VPWR#21	7.0017e-19
C831	a_83_260##78	a_83_260##81	1.82734e-18
C832	VGND#17	a_83_260##19	7.6211e-19
C833	VPWR#19	VNB	2.90795e-17
C834	a_83_260##67	X#15	4.52409e-17
C835	VPWR#17	VNB	1.81323e-17
C836	VPWR#14	VNB	2.15404e-17
C837	VPWR#12	VNB	2.68093e-17
C838	X#18	a_83_260##20	1.3718e-18
C839	VPWR#10	VNB	2.68963e-17
C840	VPWR#8	VNB	2.67248e-17
C841	VPWR#16	a_83_260##60	4.92639e-18
C842	VPWR#6	a_83_260##16	3.00302e-19
C843	VPWR#6	VNB	2.91379e-17
C844	VPWR#2	VNB	2.90137e-17
C845	VPWR#13	X#18	5.52651e-17
C846	a_83_260##33	a_83_260##30	4.0446e-17
C847	a_83_260##83	VNB	1.30578e-18
C848	X#13	X#15	4.43552e-18
C849	VGND#18	a_83_260##17	7.6211e-19
C850	a_83_260##81	VNB	1.95396e-18
C851	a_83_260##28	X#17	1.22391e-19
C852	VGND#8	VGND#7	7.94401e-19
C853	a_83_260##78	a_83_260##77	2.93942e-18
C854	a_83_260##77	a_83_260##14	1.0374e-19
C855	VPWR#16	VPWR#21	6.62617e-17
C856	a_83_260##77	A#8	1.38201e-18
C857	a_83_260##67	X#13	5.0166e-17
C858	a_83_260##21	VPWR#11	3.01317e-17
C859	VGND#21	VGND#20	2.21128e-18
C860	VPWR#13	a_83_260##20	1.49819e-19
C861	X#26	VPWR#8	1.47941e-18
C862	VPWR#16	VPWR#19	6.35968e-17
C863	X#26	VPWR#16	3.98062e-19
C864	X#24	a_83_260##19	3.85387e-17
C865	VPWR#13	a_83_260##12	8.43777e-19
C866	a_83_260##13	a_83_260##27	1.45196e-18
C867	VPWR#16	VPWR#17	3.94404e-17
C868	X#26	VPWR#6	1.22313e-18
C869	X#16	a_83_260##48	9.5722e-20
C870	VPWR#16	VPWR#14	4.71297e-17
C871	a_83_260##21	X#18	1.42813e-17
C872	a_83_260##65	X#13	7.41995e-17
C873	a_83_260##79	VPWR#2	3.22207e-18
C874	a_83_260##48	VPWR#20	2.51367e-18
C875	VGND#17	a_83_260##22	2.90158e-19
C876	VPWR#16	VPWR#12	5.62948e-17
C877	a_83_260##78	A#5	4.64679e-17
C878	X#10	X#13	2.86488e-18
C879	a_83_260##10	X#18	2.08821e-19
C880	a_83_260##81	A#7	2.39183e-18
C881	VGND#10	VGND#13	6.54012e-17
C882	VPWR#16	VPWR#10	5.55277e-17
C883	a_83_260##29	a_83_260##31	1.60964e-18
C884	a_83_260##19	VGND#18	2.30127e-17
C885	X#23	VPWR#16	3.13651e-17
C886	a_83_260##76	a_83_260##75	6.21728e-19
C887	VPWR#11	a_83_260##23	1.55436e-18
C888	a_83_260##6	X#21	1.2851e-19
C889	VPWR#13	a_83_260##21	3.34843e-19
C890	a_83_260##65	X#10	7.96215e-17
C891	VPWR#10	a_83_260##18	2.85183e-19
C892	VGND#10	VGND#12	6.13313e-17
C893	a_83_260##29	a_83_260##34	3.68217e-18
C894	VPWR#3	A#5	1.78364e-17
C895	VGND#10	a_83_260##74	7.22333e-18
C896	VPWR#16	VPWR#8	3.18839e-17
C897	a_83_260##37	a_83_260##33	3.95127e-17
C898	a_83_260##78	a_83_260##5	1.08894e-17
C899	VGND#2	A#1	8.88022e-19
C900	a_83_260##29	a_83_260##38	4.15646e-19
C901	VGND#21	X#14	3.93974e-17
C902	VGND#10	VGND#11	4.86934e-17
C903	X	X#16	1.64497e-19
C904	VGND#3	A#5	1.66883e-17
C905	X#26	a_83_260##5	5.59031e-17
C906	X#19	VPWR#16	1.50897e-17
C907	VGND#12	a_83_260##49	1.12777e-17
C908	VGND#10	VGND#9	5.16298e-17
C909	X#24	a_83_260##22	9.6409e-19
C910	VPWR#3	a_83_260##5	9.79227e-19
C911	VGND#10	a_83_260##72	1.28428e-17
C912	X#18	a_83_260##23	4.52554e-17
C913	a_83_260##63	X#10	7.43254e-17
C914	VPWR#8	a_83_260##18	7.43568e-18
C915	VGND#10	VGND#8	5.93223e-17
C916	X#17	VPWR#13	5.67584e-17
C917	VGND#3	a_83_260##5	1.19466e-18
C918	a_83_260##36	a_83_260##38	1.57468e-18
C919	VGND#12	X#11	6.01215e-18
C920	X#20	a_83_260##19	5.11844e-19
C921	X#15	VPWR#16	1.35698e-17
C922	a_83_260##83	A#6	6.19087e-18
C923	a_83_260##74	a_83_260##5	2.7413e-17
C924	X#7	X#10	2.4639e-18
C925	VGND#10	VGND#7	5.86441e-17
C926	VGND#10	a_83_260##69	1.36856e-17
C927	a_83_260##67	VPWR#16	1.39413e-19
C928	X#23	a_83_260##5	2.66977e-17
C929	VGND#10	VGND#6	2.96228e-17
C930	VPWR#11	a_83_260##27	1.49819e-19
C931	a_83_260##23	VPWR#13	2.39149e-17
C932	VGND#3	VGND#6	2.72445e-17
C933	a_83_260##63	X#7	8.03697e-17
C934	VGND#10	X#15	1.5165e-18
C935	VGND#11	a_83_260##49	7.22286e-20
C936	VPWR#6	a_83_260##18	8.74044e-20
C937	X#13	VPWR#16	1.7372e-17
C938	a_83_260##48	X#5	1.39983e-19
C939	a_83_260##22	VGND#18	2.73263e-17
C940	VGND#10	a_83_260##67	1.41114e-17
C941	X#23	a_83_260##8	3.44143e-17
C942	X#26	a_83_260##77	5.66963e-19
C943	a_83_260##65	VPWR#16	5.61983e-20
C944	VGND#3	VGND#5	7.32364e-17
C945	X#11	X#14	1.04142e-17
C946	A#8	VNB	2.48736e-17
C947	VGND#10	X#13	9.67294e-19
C948	A#7	VNB	2.7395e-17
C949	a_83_260##72	a_83_260##8	2.64054e-17
C950	a_83_260##77	A#7	1.96453e-18
C951	A#6	VNB	5.70181e-17
C952	a_83_260##62	X#7	7.18548e-17
C953	X#18	a_83_260##27	1.37871e-18
C954	VGND#19	a_83_260##19	2.85826e-19
C955	X	VPWR#15	2.61602e-17
C956	X#17	a_83_260##23	1.39551e-18
C957	a_83_260##41	a_83_260##37	4.07733e-17
C958	A#3	VNB	2.8863e-17
C959	X#10	VPWR#16	1.6016e-17
C960	a_83_260##77	a_83_260##76	6.21728e-19
C961	A#2	VNB	4.10393e-17
C962	a_83_260##57	X#1	1.26203e-19
C963	a_83_260##78	VGND#16	2.96795e-18
C964	VPWR#15	VPWR#13	1.82787e-18
C965	a_83_260##57	VNB	3.98408e-17
C966	X#19	a_83_260##8	3.61318e-17
C967	VGND#10	a_83_260##65	1.56725e-17
C968	a_83_260##54	VNB	1.7264e-17
C969	VPWR#3	VPWR#8	2.35693e-17
C970	a_83_260##48	VNB	1.11698e-16
C971	X#3	X#7	2.75635e-18
C972	VGND#3	VGND#2	8.0721e-17
C973	VGND#11	X#11	8.44134e-18
C974	a_83_260##28	VNB	2.39679e-17
C975	a_83_260##13	X#19	2.14215e-17
C976	a_83_260##62	X#3	4.52562e-17
C977	X#7	VPWR#16	3.17151e-17
C978	X#20	a_83_260##22	4.48984e-17
C979	X#25	a_83_260##78	1.40412e-17
C980	a_83_260##12	VNB	2.13265e-17
C981	VGND#10	a_83_260##63	1.29183e-17
C982	a_83_260##27	VPWR#13	2.94808e-17
C983	VPWR#3	VPWR#6	6.30886e-17
C984	VPWR#15	a_83_260##23	1.49819e-19
C985	a_83_260##10	VNB	2.00197e-17
C986	a_83_260##69	a_83_260##13	2.4616e-17
C987	VPWR#12	a_83_260##20	8.1728e-20
C988	a_83_260##6	VNB	1.77467e-17
C989	X#15	a_83_260##13	3.57659e-17
C990	a_83_260##53	a_83_260##60	2.66254e-19
C991	VGND#1	VNB	6.87823e-17
C992	a_83_260##85	VNB	5.35597e-18
C993	VGND#4	VNB	3.65607e-19
C994	X#3	VPWR#16	2.7227e-17
C995	a_83_260##84	VNB	4.55126e-18
C996	VGND#10	a_83_260##62	9.02874e-18
C997	VPWR#3	VPWR#2	6.65616e-17
C998	VGND#15	VNB	3.01253e-20
C999	a_83_260##82	VNB	4.55126e-18
C1000	VGND#13	a_83_260##51	9.72257e-18
C1001	VGND#18	a_83_260##24	7.6211e-19
C1002	VGND#16	VNB	3.01253e-20
C1003	a_83_260##54	X#1	1.01727e-19
C1004	X#25	VNB	3.29767e-18
C1005	a_83_260##76	VPWR#4	1.74636e-17
C1006	X#17	a_83_260##27	5.1374e-17
C1007	a_83_260##29	X#15	3.35763e-17
C1008	VGND#17	VNB	7.64877e-18
C1009	X#14	a_83_260##48	8.56438e-18
C1010	X#24	VNB	3.23792e-18
C1011	X#11	VGND#21	5.94018e-17
C1012	VPWR#15	X#17	5.68186e-17
C1013	VGND#18	VNB	4.4927e-18
C1014	X#20	VNB	4.71788e-18
C1015	VGND#19	VNB	6.45255e-18
C1016	a_83_260##67	a_83_260##29	2.95768e-17
C1017	VPWR#10	a_83_260##20	5.42333e-18
C1018	VPWR#2	A#3	1.29651e-20
C1019	X#16	VNB	2.75664e-18
C1020	VGND#20	VNB	6.26383e-18
C1021	VGND#19	a_83_260##22	2.49804e-18
C1022	X#14	VNB	2.58325e-18
C1023	VGND#21	VNB	3.15711e-18
C1024	X#13	a_83_260##29	3.49541e-17
C1025	X#11	VNB	3.6232e-18
C1026	VGND#22	VNB	5.48432e-18
C1027	VGND#2	A#11	5.13166e-18
C1028	X#8	VNB	9.00573e-18
C1029	VGND#23	VNB	8.64197e-19
C1030	A#9	A#7	2.31942e-19
C1031	X#4	VNB	1.1377e-17
C1032	a_83_260##45	a_83_260##41	3.947e-17
C1033	VGND#14	VNB	6.75431e-17
C1034	VPWR#13	a_83_260##31	3.34843e-19
C1035	VPWR#1	VNB	7.2672e-17
C1036	VPWR#15	a_83_260##27	3.34843e-19
C1037	a_83_260##75	VNB	2.19739e-18
C1038	VPWR#4	VNB	2.92383e-18
C1039	a_83_260##36	X#13	3.65185e-17
C1040	a_83_260##79	VNB	2.1429e-18
C1041	VGND#12	a_83_260##51	3.03246e-19
C1042	VPWR#5	VNB	2.92383e-18
C1043	VPWR#16	a_83_260##5	1.39787e-19
C1044	a_83_260##80	VNB	2.1429e-18
C1045	VPWR#7	VNB	3.0111e-18
C1046	a_83_260##65	a_83_260##36	1.90868e-17
C1047	VPWR#21	a_83_260##48	8.61975e-22
C1048	VPWR#8	a_83_260##20	2.85183e-19
C1049	a_83_260##24	X#20	3.09194e-17
C1050	X#27	VNB	2.36376e-18
C1051	VPWR#9	VNB	2.89918e-18
C1052	a_83_260##74	a_83_260##6	2.87086e-18
C1053	VPWR#11	VNB	2.85886e-18
C1054	X#10	a_83_260##36	3.82657e-17
C1055	VGND#10	a_83_260##5	1.31742e-18
C1056	VGND#3	VGND#1	6.72527e-17
C1057	X#18	VNB	2.5915e-18
C1058	VPWR#16	a_83_260##8	1.09205e-18
C1059	VPWR#13	VNB	2.87454e-18
C1060	X#17	VNB	2.1527e-18
C1061	VPWR#15	VNB	2.85886e-18
C1062	X#12	VNB	2.27099e-18
C1063	A#5	a_83_260##5	6.16655e-18
C1064	X#17	a_83_260##31	4.57842e-17
C1065	VPWR#18	VNB	2.87454e-18
C1066	VGND#10	a_83_260##8	1.73005e-18
C1067	X#16	a_83_260##22	1.26495e-19
C1068	X#9	VNB	2.35467e-18
C1069	VPWR#12	VPWR#10	6.93111e-19
C1070	VPWR#16	a_83_260##13	1.89626e-18
C1071	VPWR#20	VNB	2.94418e-18
C1072	a_83_260##47	X#10	2.33739e-17
C1073	VPWR#22	VNB	2.85886e-18
C1074	X#26	VGND#17	8.34219e-19
C1075	a_83_260##63	a_83_260##47	2.19858e-17
C1076	VGND#3	a_83_260##85	1.58783e-17
C1077	VPWR#23	VNB	8.03222e-17
C1078	VGND#10	a_83_260##13	2.18299e-18
C1079	a_83_260##80	VPWR#6	9.23085e-18
C1080	VGND#18	a_83_260##26	2.90158e-19
C1081	a_83_260##74	VGND#6	1.65884e-18
C1082	A#1	VNB	3.21234e-17
C1083	VPWR#16	a_83_260##29	1.9206e-18
C1084	A#11	VNB	2.66034e-17
C1085	VGND#22	VGND#21	2.24289e-18
C1086	A#13	VNB	2.58161e-17
C1087	X#7	a_83_260##47	2.90288e-17
C1088	A#15	VNB	2.56e-17
C1089	A#17	VNB	2.55213e-17
C1090	a_83_260##77	VPWR#3	2.3944e-18
C1091	VGND#2	a_83_260##83	2.91756e-19
C1092	X	a_83_260##31	2.67017e-21
C1093	A#19	VNB	2.53482e-17
C1094	VGND#10	a_83_260##29	3.32755e-18
C1095	a_83_260#	VNB	2.81356e-17
C1096	X	a_83_260##34	1.56275e-18
C1097	a_83_260##15	VNB	2.9538e-17
C1098	VPWR#16	a_83_260##36	1.02292e-18
C1099	a_83_260##14	A#8	9.00744e-19
C1100	a_83_260##24	VGND#19	2.34711e-17
C1101	a_83_260##17	VNB	3.11287e-17
C1102	VPWR#13	a_83_260##34	1.49819e-19
C1103	a_83_260##31	VPWR#15	2.39149e-17
C1104	VGND#5	a_83_260##81	2.91756e-19
C1105	a_83_260##77	A#6	8.19042e-20
C1106	a_83_260##19	VNB	2.90512e-17
C1107	X#7	a_83_260##53	3.41289e-17
C1108	a_83_260##22	VNB	2.76499e-17
C1109	a_83_260##24	VNB	3.29452e-17
C1110	VGND#10	a_83_260##36	4.38172e-18
C1111	VGND#21	a_83_260##48	3.59695e-18
C1112	a_83_260##26	VNB	3.22145e-17
C1113	a_83_260##30	VNB	2.99317e-17
C1114	a_83_260##62	a_83_260##53	2.52039e-17
C1115	VPWR#16	a_83_260##47	8.04347e-19
C1116	VGND#7	VGND#6	8.03217e-19
C1117	a_83_260##33	VNB	3.16298e-17
C1118	a_83_260##37	VNB	2.92616e-17
C1119	a_83_260##76	VPWR#3	3.06328e-18
C1120	a_83_260##41	VNB	2.78004e-17
C1121	X#3	a_83_260##53	3.20212e-17
C1122	a_83_260##45	VNB	2.9178e-17
C1123	VGND#10	a_83_260##47	1.62458e-18
C1124	a_83_260##49	VNB	3.43906e-17
C1125	a_83_260##51	VNB	3.26209e-17
C1126	VPWR#10	a_83_260##6	5.48537e-21
C1127	a_83_260##49	a_83_260##45	4.01853e-17
C1128	VPWR#16	a_83_260##53	1.20053e-18
C1129	a_83_260##55	VNB	2.87319e-17
C1130	a_83_260##58	VNB	3.33219e-17
C1131	VGND#3	a_83_260##84	2.09531e-17
C1132	A#10	VNB	4.08112e-17
C1133	VGND#10	a_83_260##53	8.92781e-19
C1134	X#20	a_83_260##26	1.42674e-18
C1135	X#17	a_83_260##34	1.39551e-18
C1136	X#12	a_83_260##31	2.4639e-18
C1137	A#12	VNB	3.42395e-17
C1138	A#14	VNB	3.24499e-17
C1139	X#12	VPWR#15	3.99659e-17
C1140	A#16	VNB	3.17253e-17
C1141	A#18	VNB	3.20232e-17
C1142	A#9	VNB	3.22108e-17
C1143	a_83_260##14	VNB	3.90952e-17
C1144	a_83_260##16	VNB	3.44418e-17
C1145	X#23	a_83_260##6	6.12477e-18
C1146	a_83_260##18	VNB	3.66977e-17
C1147	X#16	a_83_260##24	1.66096e-18
C1148	a_83_260##20	VNB	3.16448e-17
C1149	VPWR#19	a_83_260##48	9.42426e-20
C1150	VPWR#12	a_83_260##21	2.85183e-19
C1151	a_83_260##21	VNB	3.48198e-17
C1152	a_83_260##23	VNB	3.18672e-17
C1153	a_83_260##27	VNB	3.34543e-17
C1154	a_83_260##31	VNB	3.61782e-17
C1155	a_83_260##34	VNB	3.49592e-17
C1156	a_83_260##38	VNB	3.6419e-17
C1157	a_83_260##67	X	4.65615e-17
C1158	VGND#22	X#11	4.87213e-17
C1159	a_83_260##34	VPWR#15	3.09687e-17
C1160	a_83_260##42	VNB	3.08998e-17
C1161	VPWR#18	a_83_260##31	1.49819e-19
C1162	a_83_260##46	VNB	3.2046e-17
C1163	VGND#13	X#8	7.29708e-18
C1164	a_83_260##52	VNB	3.39474e-17
C1165	a_83_260##76	a_83_260##79	1.36226e-18
C1166	X#20	a_83_260##28	1.69919e-19
C1167	a_83_260##56	VNB	3.58027e-17
C1168	a_83_260##59	VNB	3.45119e-17
C1169	a_83_260##60	VNB	4.16424e-17
C1170	a_83_260##72	a_83_260##10	1.99835e-18
C1171	VGND#3	a_83_260##82	1.70505e-17
C1172	VGND#1	a_83_260##85	7.22131e-17
C1173	a_83_260##78	VNB	2.58456e-18
C1174	a_83_260##47	a_83_260##53	1.87105e-19
C1175	VGND#13	a_83_260##55	6.31967e-18
C1176	a_83_260##26	VGND#19	2.57628e-17
C1177	X#26	VNB	1.18008e-18
C1178	VPWR#3	VNB	2.16799e-16
C1179	VPWR#2	A#2	2.77043e-20
C1180	X#8	a_83_260##57	1.07829e-19
C1181	VPWR#10	a_83_260##21	9.15445e-18
C1182	VGND#3	VNB	2.06969e-16
C1183	a_83_260##74	VNB	3.22063e-19
C1184	X#23	VNB	5.71078e-18
C1185	X	VPWR#16	5.81174e-18
C1186	a_83_260##72	VNB	3.94241e-19
C1187	X#19	VNB	1.24728e-18
C1188	a_83_260##69	VNB	1.53559e-18
C1189	a_83_260##34	X#12	1.27027e-17
C1190	X#15	VNB	6.43065e-19
C1191	VGND#20	a_83_260##24	1.81365e-19
C1192	VPWR#18	VPWR#15	1.82787e-18
C1193	a_83_260##67	VNB	1.07475e-18
C1194	VGND#2	A#13	5.36666e-18
C1195	X#13	VNB	2.00542e-18
C1196	a_83_260##65	VNB	4.1789e-19
C1197	X#10	VNB	1.02721e-18
C1198	a_83_260##63	VNB	7.53114e-19
C1199	a_83_260##76	A#6	4.354e-18
C1200	X#11	a_83_260##48	1.38494e-17
C1201	X#7	VNB	3.3142e-18
C1202	A#5	VPWR#2	2.28969e-20
C1203	X	a_83_260##29	3.28352e-18
C1204	VGND#3	a_83_260##83	3.90484e-18
C1205	a_83_260##62	VNB	6.66535e-18
C1206	a_83_260##51	a_83_260##49	4.02902e-17
C1207	X#3	VNB	1.13599e-17
C1208	VPWR#8	a_83_260##6	4.5102e-20
C1209	VPWR#16	VNB	3.02423e-16
C1210	VGND#10	VNB	2.80377e-16
C1211	VPWR#8	a_83_260##21	8.1728e-20
C1212	A#5	VNB	5.03211e-17
C1213	VGND#3	X#25	1.64625e-17
C1214	a_83_260##5	VNB	6.29795e-17
C1215	VGND#12	a_83_260##55	7.79526e-20
C1216	a_83_260##8	VNB	3.11382e-17
C1217	a_83_260##83	A#3	1.01171e-18
C1218	a_83_260##13	VNB	2.81009e-17
C1219	X#19	a_83_260##12	9.31635e-18
C1220	VPWR#15	a_83_260##38	3.12958e-18
C1221	VPWR#18	a_83_260##34	3.34843e-19
C1222	a_83_260##29	VNB	2.78525e-17
C1223	X#16	a_83_260##26	4.41531e-17
C1224	a_83_260##36	VNB	7.30148e-19
C1225	a_83_260##47	VNB	1.17282e-18
C1226	a_83_260##83	A#5	8.12004e-17
C1227	a_83_260##53	VNB	3.85322e-17
C1228	VGND#3	a_83_260##81	5.22717e-18
C1229	X#8	X#11	4.38151e-18
C1230	VGND#12	X#8	7.46314e-18
C1231	a_83_260##81	A#5	5.88224e-17
C1232	VGND#3	VGND#17	8.80635e-18
C1233	VPWR#17	a_83_260##48	2.25052e-19
*
*
.ENDS sky130_fd_sc_hs__buf_16
*
