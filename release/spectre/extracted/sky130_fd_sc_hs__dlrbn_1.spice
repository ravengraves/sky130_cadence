* Extracted by Quantus, converted by sky130cad/quantus.py
*
*
*
*                       LINUX           Wed Nov 18 08:30:57 2026
*
*
*
*  PROGRAM  advgen
*
*  Name           : advgen - Quantus - (64-bit)
*  Version        : 25.1.0-p047
*  Build Date     : Thu Dec 11 23:20:30 PST 2025
*
*  HSPICE LIBRARY
*
*  OPERATING_TEMPERATURE 150
*  QRC_TECH_DIR <path>/tech
*
*
*

*
.SUBCKT sky130_fd_sc_hs__dlrbn_1 VPB VNB VGND VPWR Q Q_N RESET_B D GATE_N
*
*
*  caps2d version: 10
*
*
*       TRANSISTOR CARDS
*
*
XM20 a_27_424##7 D#3 VGND#13 VNB sky130_fd_pr__nfet_01v8_lvt l=0.15 w=0.55 ad=0.15675 as=0.30395 pd=1.67 ps=2.34
XM14 VGND#13 GATE_N#3 a_231_74##13 VNB sky130_fd_pr__nfet_01v8_lvt l=0.15 w=0.74 ad=0.30395 as=0.2109 pd=2.34 ps=2.05
XM9 a_373_74##6 a_231_74##3 VGND#12 VNB sky130_fd_pr__nfet_01v8_lvt l=0.15 w=0.74 ad=0.2109 as=0.4026 pd=2.05 ps=2.66
XM7 VGND#12 a_27_424##3 a_608_74# VNB sky130_fd_pr__nfet_01v8_lvt l=0.15 w=0.64 ad=0.4026 as=0.1536 pd=2.66 ps=1.76
XM5 a_608_74# a_231_74##5 a_686_74##8 VNB sky130_fd_pr__nfet_01v8_lvt l=0.15 w=0.64 ad=0.1536 as=0.3835 pd=1.76 ps=2.53
XM19 a_686_74##8 a_373_74# a_841_118# VNB sky130_fd_pr__nfet_01v8_lvt l=0.15 w=0.42 ad=0.3835 as=0.1008 pd=2.53 ps=1.32
XM10 a_841_118# a_889_92# VGND#11 VNB sky130_fd_pr__nfet_01v8_lvt l=0.15 w=0.42 ad=0.1008 as=0.1533 pd=1.32 ps=1.57
XM21 a_889_92##15 a_686_74# a_1133_74# VNB sky130_fd_pr__nfet_01v8_lvt l=0.15 w=0.74 ad=0.2109 as=0.1776 pd=2.05 ps=1.96
XM6 a_1133_74# RESET_B#3 VGND#10 VNB sky130_fd_pr__nfet_01v8_lvt l=0.15 w=0.74 ad=0.1776 as=0.2886 pd=1.96 ps=2.26
XM1 VGND#10 a_889_92##7 Q#2 VNB sky130_fd_pr__nfet_01v8_lvt l=0.15 w=0.74 ad=0.2886 as=0.2109 pd=2.26 ps=2.05
XM15 a_1437_112##7 a_889_92##4 VGND#9 VNB sky130_fd_pr__nfet_01v8_lvt l=0.15 w=0.55 ad=0.1925 as=0.25585 pd=1.8 ps=2.21
XM23 VGND#9 a_1437_112##3 Q_N#3 VNB sky130_fd_pr__nfet_01v8_lvt l=0.15 w=0.74 ad=0.25585 as=0.2109 pd=2.21 ps=2.05
XM22 a_27_424##6 D#1 VPWR#12 VPB sky130_fd_pr__pfet_01v8 l=0.15 w=0.84 ad=0.2478 as=0.5124 pd=2.27 ps=2.9
XM16 VPWR#12 GATE_N#1 a_231_74##11 VPB sky130_fd_pr__pfet_01v8 l=0.15 w=0.84 ad=0.5124 as=0.2478 pd=2.9 ps=2.27
XM2 a_373_74##7 a_231_74# VPWR#10 VPB sky130_fd_pr__pfet_01v8 l=0.15 w=0.84 ad=0.383 as=0.5049 pd=2.88 ps=3.28
XM11 VPWR#10 a_27_424# a_611_392# VPB sky130_fd_pr__pfet_01v8 l=0.15 w=1 ad=0.5049 as=0.27 pd=3.28 ps=2.54
XM13 a_611_392# a_373_74##3 a_686_74##7 VPB sky130_fd_pr__pfet_01v8 l=0.15 w=1 ad=0.27 as=0.3328 pd=2.54 ps=2.77
XM17 a_686_74##7 a_231_74##7 a_802_508# VPB sky130_fd_pr__pfet_01v8 l=0.15 w=0.42 ad=0.3328 as=0.2247 pd=2.77 ps=1.91
XM0 a_802_508# a_889_92##3 VPWR#7 VPB sky130_fd_pr__pfet_01v8 l=0.15 w=0.42 ad=0.2247 as=0.47915 pd=1.91 ps=4.05
XM12 VPWR#7 a_686_74##4 a_889_92##12 VPB sky130_fd_pr__pfet_01v8 l=0.15 w=1.12 ad=0.47915 as=0.3472 pd=4.05 ps=2.86
XM18 a_889_92##12 RESET_B#1 VPWR#5 VPB sky130_fd_pr__pfet_01v8 l=0.15 w=1.12 ad=0.3472 as=0.4256 pd=2.86 ps=3
XM4 VPWR#5 a_889_92##9 Q#1 VPB sky130_fd_pr__pfet_01v8 l=0.15 w=1.12 ad=0.4256 as=0.3248 pd=3 ps=2.82
XM8 a_1437_112##6 a_889_92##8 VPWR#3 VPB sky130_fd_pr__pfet_01v8 l=0.15 w=0.84 ad=0.231 as=0.4046 pd=2.23 ps=3.02
XM3 VPWR#3 a_1437_112# Q_N#1 VPB sky130_fd_pr__pfet_01v8 l=0.15 w=1.12 ad=0.4046 as=0.3304 pd=3.02 ps=2.83
*
*
*       RESISTOR AND CAP/DIODE CARDS
*
Rg1	D#1	D#2	396.604889
Rg2	D#2	D#3	305.357025
Rg3	GATE_N#1	GATE_N#2	435.533173
Rg4	GATE_N#2	GATE_N#3	418.880981
Rg5	a_231_74#	a_231_74##2	460.242432
Rg6	a_231_74##2	a_231_74##3	304.258270
Rg7	a_27_424#	a_27_424##2	400.207520
Rg8	a_27_424##2	a_27_424##3	480.096283
Rg9	a_231_74##4	a_231_74##5	439.477417
Rg10	a_373_74#	a_373_74##2	242.973175
Rg11	a_373_74##2	a_373_74##3	830.703979
Rg12	a_231_74##6	a_231_74##7	260.013794
Rg13	a_889_92#	a_889_92##2	704.807312
Rg14	a_889_92##2	a_889_92##3	273.761261
Rg15	a_686_74#	a_686_74##2	322.988434
Rg16	a_686_74##2	a_686_74##3	104.429245
Rg17	a_686_74##2	a_686_74##4	449.490784
Rg18	RESET_B#1	RESET_B#2	434.639221
Rg19	RESET_B#2	RESET_B#3	307.937683
Rg20	a_889_92##4	a_889_92##5	298.612640
Rg21	a_889_92##5	a_889_92##6	136.881638
Rg22	a_889_92##6	a_889_92##7	327.466217
Rg23	a_889_92##5	a_889_92##8	399.490417
Rg24	a_889_92##6	a_889_92##9	437.134064
Rg25	a_1437_112#	a_1437_112##2	456.846832
Rg26	a_1437_112##2	a_1437_112##3	353.846649
Rf1	D#2	D#5	81.262962
Rf2	D#6	D	1.146560
Rf3	D#5	D#6	2.495058
Rf4	GATE_N#2	GATE_N	82.872108
Rf5	a_27_424##2	a_27_424##5	447.555786
Rf6	a_27_424##5	a_27_424##6	26.368792
Rf7	a_27_424##5	a_27_424##7	104.651962
Rf8	a_373_74##2	a_373_74##5	310.096375
Rf9	a_373_74##5	a_373_74##6	14.176468
Rf10	a_373_74##5	a_373_74##7	80.153961
Rf11	a_231_74##6	a_231_74##4	362.778198
Rf12	a_231_74##4	a_231_74##10	72.038338
Rf13	a_231_74##10	a_231_74##12	127.277565
Rf14	a_231_74##12	a_231_74##13	109.635551
Rf15	a_231_74##11	a_231_74##12	15.000000
Rf16	a_686_74##3	a_686_74##6	178.701935
Rf17	a_686_74##6	a_686_74##7	126.239326
Rf18	a_686_74##6	a_686_74##8	106.519897
Rf19	RESET_B	RESET_B#4	0.705966
Rf20	RESET_B#5	RESET_B#2	160.938766
Rf21	RESET_B#4	RESET_B#5	3.818136
Rf22	a_889_92##6	a_889_92##11	230.123383
Rf23	a_889_92##11	a_889_92##13	9.037687
Rf24	a_889_92##13	a_889_92##2	196.604370
Rf25	a_889_92##11	a_889_92##15	76.610382
Rf26	a_889_92##12	a_889_92##13	5.000000
Rf27	Q#1	Q	7.205985
Rf28	Q	Q#2	11.793690
Rf29	a_1437_112##2	a_1437_112##5	180.065399
Rf30	a_1437_112##5	a_1437_112##6	51.705738
Rf31	a_1437_112##5	a_1437_112##7	44.508278
Rf32	Q_N	Q_N#2	0.194040
Rf33	Q_N#2	Q_N	14.164948
Rf34	Q_N	Q_N#3	88.842873
Rf35	Q_N#1	Q_N#2	5.000000
Rf37	VGND#2	VGND#3	108.455452
Rf38	VGND#3	VGND#4	97.895943
Rf39	VGND#4	VGND#5	109.243309
Rf40	VGND#5	VGND#6	53.285408
Rf41	VGND#6	VGND#7	133.981674
Rf43	VGND#2	VGND#9	36.410488
Rf44	VGND#3	VGND#10	31.633152
Rf45	VGND#4	VGND#11	51.608658
Rf46	VGND#6	VGND#12	25.018780
Rf47	VGND#7	VGND#13	32.518913
Rf49	VPWR#2	VPWR#3	50.314537
Rf50	VPWR#2	VPWR#4	102.246162
Rf51	VPWR#4	VPWR#5	40.884460
Rf52	VPWR#4	VPWR#6	89.032906
Rf53	VPWR#6	VPWR#7	17.291342
Rf54	VPWR#6	VPWR#8	124.486931
Rf55	VPWR#8	VPWR#9	50.380310
Rf56	VPWR#9	VPWR#10	25.256187
Rf57	VPWR#9	VPWR#11	141.668900
Rf58	VPWR#11	VPWR#12	30.353714
Rf66	a_231_74##2	a_231_74##10	160.232803
Re1	VPWR#2	VPWR	3.735117
Re2	VPWR	VPWR#8	1.067176
Re3	VGND#2	VGND	3.735117
Re4	VGND	VGND#5	1.067176
*
*       CAPACITOR CARDS
*
*
C1	a_889_92##15	Q#2	2.49853e-18
C2	VGND#13	a_27_424##5	4.74906e-18
C3	a_27_424##5	D#1	1.86581e-17
C4	a_889_92##4	a_1437_112##3	2.21145e-17
C5	a_1437_112#	Q_N#1	1.20508e-17
C6	VGND#3	a_889_92##6	8.70008e-19
C7	a_1437_112##5	a_1437_112##2	5.42963e-19
C8	a_889_92##15	VGND#10	2.01795e-17
C9	VPWR#6	a_686_74##3	1.79357e-18
C10	a_686_74##7	a_889_92##11	1.17856e-18
C11	a_27_424##7	a_27_424##5	2.21856e-18
C12	a_1437_112#	VPWR#3	3.00347e-17
C13	a_889_92##7	a_1437_112##3	3.96625e-19
C14	a_1437_112##6	a_1437_112#	1.24117e-18
C15	a_889_92##7	a_889_92##4	3.23879e-18
C16	a_889_92##8	VPWR#3	3.0123e-17
C17	a_889_92##2	VPWR#6	3.59055e-17
C18	a_1437_112##6	a_889_92##8	6.41713e-17
C19	VPWR#5	a_1437_112#	7.61214e-19
C20	VPWR#3	a_889_92##9	9.86991e-19
C21	VGND#4	a_686_74##3	1.97025e-18
C22	a_686_74##8	a_373_74##3	2.12559e-19
C23	RESET_B#3	a_889_92##7	2.41263e-17
C24	a_1437_112##6	a_889_92##9	9.95627e-19
C25	a_889_92##11	a_889_92##6	1.96656e-18
C26	VPWR#5	a_889_92##8	1.09036e-18
C27	VPWR#3	RESET_B#1	1.97427e-19
C28	a_231_74##6	VPWR#6	4.7163e-17
C29	VGND#11	a_889_92##15	4.31975e-17
C30	a_889_92##9	Q#1	5.84429e-19
C31	VGND#4	a_889_92##2	2.45777e-19
C32	D#5	VGND#13	1.20957e-17
C33	a_889_92##9	VPWR#5	3.45053e-17
C34	RESET_B#5	a_889_92##6	2.21098e-17
C35	a_686_74#	RESET_B#3	5.25625e-17
C36	a_889_92##11	RESET_B#2	4.26781e-18
C37	RESET_B#4	a_889_92##6	1.12679e-17
C38	VGND#4	a_686_74##2	1.12898e-19
C39	VGND#5	a_373_74##5	2.0306e-19
C40	RESET_B#1	VPWR#5	3.61208e-17
C41	a_27_424##7	D#5	3.35533e-17
C42	Q#2	VPWR#4	1.13461e-17
C43	VGND#4	a_231_74##6	4.48891e-20
C44	RESET_B#5	RESET_B#2	8.68063e-18
C45	RESET_B#1	a_889_92##12	2.42443e-17
C46	a_889_92#	a_686_74#	3.57702e-18
C47	a_889_92##11	a_686_74##3	3.51373e-17
C48	VPWR#5	a_686_74##4	1.50033e-18
C49	RESET_B#4	RESET_B#2	6.0295e-18
C50	a_686_74##4	a_889_92##12	2.42443e-17
C51	a_686_74##8	VGND#11	1.84965e-17
C52	VGND#3	a_889_92##7	7.4256e-18
C53	a_1437_112##5	a_1437_112##3	7.15008e-20
C54	VPWR#5	a_889_92##3	2.04259e-19
C55	a_686_74##4	VPWR#7	1.36924e-17
C56	a_373_74#	a_889_92#	3.06358e-17
C57	a_889_92##11	a_889_92##2	2.72695e-18
C58	a_231_74##5	a_686_74#	1.32503e-19
C59	VGND#4	RESET_B#3	6.83535e-19
C60	a_27_424##2	VPWR#9	2.13196e-17
C61	a_889_92##3	VPWR#7	1.26436e-17
C62	VGND#3	RESET_B#3	3.75761e-18
C63	a_686_74##7	a_686_74##4	1.06942e-19
C64	a_1437_112##5	a_889_92##4	2.01927e-19
C65	a_231_74##6	a_889_92##11	2.23778e-18
C66	a_231_74##5	a_373_74#	7.29803e-18
C67	VGND#4	a_686_74#	2.57914e-18
C68	a_686_74##6	a_889_92##2	3.59309e-17
C69	VPWR#9	a_231_74##2	8.57448e-20
C70	a_1437_112##2	Q_N#3	2.34592e-17
C71	VGND#6	a_27_424##2	6.19981e-19
C72	VGND#3	a_686_74#	8.85262e-18
C73	a_1437_112##5	a_889_92##7	4.31958e-20
C74	a_1437_112##2	VGND#9	4.36759e-17
C75	a_231_74##7	a_686_74##7	1.10502e-17
C76	a_889_92##11	a_373_74##2	5.30554e-19
C77	a_27_424##3	a_231_74##5	4.35205e-17
C78	VPWR#10	a_889_92##3	7.27602e-20
C79	a_686_74##6	a_231_74##6	2.79481e-17
C80	VGND#4	a_889_92#	1.67729e-18
C81	a_686_74##7	a_373_74##3	3.76905e-17
C82	VPWR#10	a_231_74##7	2.26083e-19
C83	VGND#6	a_231_74##2	9.37461e-19
C84	a_231_74##3	a_27_424##3	1.21033e-17
C85	Q#2	VPWR#3	4.36459e-18
C86	VPWR#3	a_889_92##5	2.33553e-19
C87	a_686_74##7	a_27_424#	1.07355e-18
C88	a_686_74##6	a_373_74##2	1.29371e-16
C89	Q#2	a_889_92##6	1.36878e-16
C90	VPWR#10	a_373_74##3	1.55596e-18
C91	VGND#4	a_373_74#	1.83383e-18
C92	VGND#3	Q#2	2.01491e-17
C93	a_1437_112##5	Q_N#3	6.75172e-19
C94	VGND#5	a_686_74##8	3.09018e-17
C95	VGND#10	a_889_92##6	6.05023e-18
C96	VGND#4	VGND#10	7.66155e-19
C97	Q#2	a_1437_112##6	8.9269e-17
C98	GATE_N#3	a_231_74##3	3.09623e-18
C99	VGND#6	a_231_74##5	3.93037e-18
C100	a_27_424#	VPWR#10	3.32016e-17
C101	a_231_74##4	a_686_74##6	1.82174e-17
C102	RESET_B#2	VGND#10	5.07147e-18
C103	VGND#4	a_231_74##5	1.14071e-18
C104	a_373_74##5	a_373_74##7	1.73561e-18
C105	a_231_74#	VPWR#10	2.3515e-17
C106	a_1437_112##5	VGND#9	2.16153e-18
C107	Q#2	Q#1	1.2593e-17
C108	a_231_74##11	a_27_424#	1.80112e-18
C109	a_1437_112##6	a_889_92##5	1.23189e-18
C110	D#3	GATE_N#3	1.92063e-17
C111	a_231_74#	a_373_74##7	1.63772e-17
C112	a_889_92##15	RESET_B#2	9.27693e-19
C113	VGND#6	a_27_424##3	2.22536e-17
C114	VPWR#12	a_27_424#	5.85685e-19
C115	a_686_74##6	a_27_424##2	3.4816e-19
C116	VPWR#10	GATE_N#1	1.62214e-18
C117	a_231_74##11	a_231_74#	8.93864e-18
C118	VPWR#5	Q#2	5.21001e-17
C119	VGND#4	a_27_424##3	2.62447e-19
C120	a_373_74##7	GATE_N#1	1.54708e-19
C121	a_373_74##5	a_231_74##4	1.39569e-17
C122	VPWR#12	a_231_74#	3.97247e-19
C123	VPWR#10	D#1	7.3253e-19
C124	a_889_92##15	a_686_74##3	2.84777e-17
C125	a_1437_112##5	a_889_92##5	5.06441e-17
C126	VGND#4	a_889_92##15	1.94882e-17
C127	GATE_N#1	a_231_74##11	2.38537e-17
C128	a_686_74##3	VGND#11	3.0285e-17
C129	VGND#6	a_231_74##3	1.53511e-17
C130	VGND#4	VGND#3	4.06448e-19
C131	GATE_N#1	VPWR#12	3.47526e-17
C132	a_373_74##5	a_27_424##2	6.2221e-19
C133	a_27_424##5	a_231_74##11	7.27529e-17
C134	a_27_424##6	GATE_N#1	4.31675e-19
C135	Q#2	a_1437_112##5	5.67338e-17
C136	a_1437_112##2	VPWR#3	3.51602e-17
C137	VGND#11	a_889_92##2	3.99359e-19
C138	VPWR#12	D#1	4.36644e-17
C139	a_27_424##5	a_27_424##2	3.85815e-18
C140	D#1	a_27_424##6	1.81388e-17
C141	a_889_92##5	a_1437_112##2	3.44825e-17
C142	VGND#6	GATE_N#3	8.48267e-19
C143	a_373_74##5	a_231_74##2	8.13956e-17
C144	a_27_424##5	VPWR#12	8.49749e-17
C145	a_889_92##8	a_1437_112#	2.91407e-17
C146	VGND#13	a_231_74##13	6.63186e-17
C147	a_889_92##9	a_1437_112#	3.87781e-19
C148	a_686_74##8	a_231_74##6	7.1815e-19
C149	a_889_92##6	VPWR#5	2.33081e-17
C150	a_373_74##5	GATE_N#2	2.66221e-19
C151	VGND#6	a_686_74##8	1.03794e-17
C152	a_27_424##5	a_27_424##6	3.45671e-18
C153	a_27_424##7	a_231_74##13	1.1785e-18
C154	a_889_92##9	a_889_92##8	6.45316e-18
C155	a_686_74##6	a_686_74#	1.77507e-19
C156	VPWR#4	a_1437_112#	3.79107e-19
C157	a_27_424##5	GATE_N#2	4.37628e-18
C158	a_889_92##11	VPWR#6	6.8399e-17
C159	a_373_74##2	a_686_74##8	7.75873e-17
C160	a_889_92##6	a_889_92##5	3.54088e-20
C161	VPWR#5	RESET_B#2	7.09626e-19
C162	a_27_424##7	VGND#13	4.62863e-17
C163	VGND#4	a_686_74##8	2.7325e-17
C164	a_889_92##6	a_686_74##2	4.34182e-20
C165	RESET_B#1	a_889_92##9	3.45045e-17
C166	a_686_74##6	a_889_92#	2.237e-17
C167	a_27_424##5	D#2	1.2774e-17
C168	a_231_74##4	a_686_74##8	2.49485e-18
C169	Q_N#3	a_889_92##5	2.57994e-19
C170	a_889_92##11	VPWR#4	5.39483e-18
C171	a_889_92##11	Q#2	2.79912e-18
C172	a_686_74##3	VPWR#7	7.4155e-20
C173	a_686_74##4	RESET_B#1	4.28449e-17
C174	a_686_74##6	a_373_74#	3.43845e-18
C175	VPWR#6	a_889_92##9	4.95199e-19
C176	VGND#6	VGND#12	6.06327e-18
C177	D#5	D#2	1.77941e-17
C178	VGND#10	a_889_92##11	1.45672e-18
C179	a_686_74##2	RESET_B#2	3.18485e-17
C180	VPWR#4	a_889_92##9	5.86754e-18
C181	a_889_92##3	a_686_74##4	5.43242e-18
C182	a_686_74##7	a_889_92##2	4.43033e-18
C183	a_686_74##6	a_231_74##5	5.22016e-19
C184	a_231_74##2	VGND#12	1.15897e-18
C185	VPWR#6	RESET_B#1	8.72511e-19
C186	a_231_74##7	a_889_92##3	8.19989e-18
C187	a_231_74##6	a_686_74##7	9.97312e-17
C188	a_231_74##13	a_231_74##2	6.98383e-19
C189	VPWR#4	RESET_B#1	2.15672e-18
C190	VGND#5	a_373_74#	1.02943e-18
C191	a_686_74##2	VPWR#7	2.68606e-19
C192	a_686_74##6	a_27_424##3	1.82143e-19
C193	VPWR#10	a_231_74##6	1.27823e-17
C194	a_27_424##7	a_231_74##2	1.45358e-19
C195	VGND#5	a_231_74##5	7.37995e-18
C196	a_686_74##7	a_373_74##2	7.48602e-18
C197	Q_N#3	a_1437_112##3	2.21203e-17
C198	a_373_74##3	a_231_74##7	1.63278e-17
C199	a_686_74##3	a_686_74##2	6.08207e-20
C200	VGND#6	a_231_74##13	5.28869e-18
C201	a_231_74##13	GATE_N#2	1.3187e-17
C202	VPWR#6	a_686_74##4	1.33519e-17
C203	a_889_92##15	a_889_92##11	2.0454e-18
C204	a_889_92##5	a_1437_112##7	1.1276e-18
C205	RESET_B#4	Q#2	1.36769e-18
C206	a_27_424##7	GATE_N#2	1.07811e-19
C207	a_1437_112##5	a_1437_112#	1.14479e-19
C208	VGND#9	a_1437_112##3	4.53628e-17
C209	a_231_74##4	a_686_74##7	7.31833e-17
C210	a_1437_112##6	VPWR#3	6.69254e-17
C211	a_686_74##6	a_231_74##3	1.8383e-19
C212	a_27_424#	a_373_74##3	4.87864e-17
C213	a_231_74##13	D#2	7.71848e-20
C214	a_373_74##5	a_373_74#	2.57296e-19
C215	VGND#13	D#2	9.13491e-18
C216	a_1437_112##7	a_1437_112##3	8.86707e-19
C217	a_889_92##5	a_1437_112#	4.72937e-18
C218	a_889_92##11	a_686_74##2	8.67135e-18
C219	VGND#13	VGND#6	5.51635e-19
C220	a_27_424##7	D#2	5.94388e-18
C221	VPWR#6	a_889_92##3	2.65623e-17
C222	a_889_92#	a_686_74##3	1.39851e-17
C223	VGND#9	a_889_92##4	1.55858e-17
C224	VGND#10	RESET_B#4	1.73866e-17
C225	a_231_74#	a_27_424#	2.04028e-17
C226	a_27_424##2	VPWR#10	4.57626e-17
C227	VPWR#4	a_889_92##3	1.33094e-19
C228	Q#2	a_1437_112##3	1.88812e-18
C229	VPWR#4	VPWR#3	8.00435e-19
C230	a_889_92##2	a_686_74##2	1.28011e-19
C231	a_373_74##5	a_231_74##5	4.14239e-19
C232	a_27_424##2	a_373_74##7	5.35393e-18
C233	a_686_74##6	VPWR#6	8.56369e-19
C234	GATE_N#1	a_27_424#	3.32167e-19
C235	a_1437_112##7	a_889_92##4	4.27289e-17
C236	VPWR#5	VPWR#3	2.33278e-18
C237	a_686_74##6	a_841_118#	1.16161e-18
C238	a_231_74##11	a_27_424##2	8.81869e-17
C239	VGND#9	a_889_92##7	1.40529e-18
C240	Q#2	a_889_92##5	3.12357e-18
C241	VGND#10	a_1437_112##3	5.8271e-19
C242	a_231_74##2	VPWR#10	1.79003e-18
C243	GATE_N#1	a_231_74#	4.62439e-18
C244	VPWR#6	a_231_74##7	2.88203e-18
C245	a_231_74##2	a_373_74##7	6.87212e-17
C246	Q#2	a_889_92##4	3.79453e-18
C247	a_889_92##15	RESET_B#5	1.65151e-18
C248	a_231_74##2	a_231_74##11	6.39526e-18
C249	a_373_74##5	a_27_424##3	1.86745e-17
C250	a_1437_112##7	a_889_92##7	6.89463e-19
C251	a_373_74##2	a_889_92#	2.3438e-17
C252	D#1	GATE_N#1	1.14869e-17
C253	VGND#9	RESET_B#3	2.74141e-19
C254	a_373_74##7	GATE_N#2	1.00059e-18
C255	a_373_74##2	a_373_74#	1.10023e-17
C256	VPWR#8	a_231_74##7	4.61092e-18
C257	a_889_92##6	a_889_92##9	1.08478e-17
C258	VGND#3	a_889_92##11	1.04953e-18
C259	a_231_74##11	GATE_N#2	5.35768e-18
C260	Q#2	a_889_92##7	5.32585e-17
C261	a_889_92##11	a_889_92##8	7.66567e-20
C262	a_373_74##2	a_231_74##5	1.90714e-17
C263	a_889_92##15	RESET_B#4	9.23079e-18
C264	RESET_B#1	a_889_92##6	1.30236e-18
C265	VPWR#8	a_373_74##3	4.49388e-18
C266	VPWR#6	a_373_74##3	1.40546e-19
C267	a_373_74##2	a_27_424##3	4.47132e-19
C268	a_373_74##5	a_231_74##3	4.04696e-17
C269	a_889_92##6	a_686_74##4	1.80528e-19
C270	a_889_92##7	VGND#10	2.00973e-17
C271	a_231_74##11	D#2	6.10031e-19
C272	a_373_74##2	a_231_74##3	3.07538e-19
C273	VGND#5	a_373_74##3	7.55418e-20
C274	VPWR#12	D#2	1.21627e-18
C275	Q#2	RESET_B#3	2.09508e-18
C276	a_231_74##4	a_27_424##3	1.65674e-17
C277	a_889_92##15	a_889_92##4	5.25073e-20
C278	a_686_74##6	a_889_92##15	3.39129e-18
C279	a_27_424##5	D#5	5.44099e-17
C280	VPWR#9	a_27_424#	6.38206e-18
C281	a_889_92##11	a_889_92##9	6.92208e-19
C282	a_231_74##13	a_373_74##7	2.55814e-17
C283	VPWR#6	VPWR#5	5.18071e-18
C284	a_373_74##5	GATE_N#3	1.12452e-18
C285	a_686_74##3	a_686_74##4	1.2772e-18
C286	a_889_92##9	a_889_92##5	2.37414e-18
C287	VGND#10	RESET_B#3	4.6675e-17
C288	VPWR#6	a_27_424#	6.94547e-20
C289	a_373_74##5	a_608_74#	6.17441e-19
C290	Q#2	a_686_74#	3.47557e-19
C291	a_889_92##15	a_889_92##7	2.69345e-19
C292	a_889_92##2	a_686_74##4	1.04074e-17
C293	a_231_74##2	a_27_424##3	5.60603e-18
C294	a_231_74##13	a_231_74##11	2.3743e-18
C295	a_686_74##6	VGND#11	3.16035e-17
C296	Q_N	a_889_92##5	5.07693e-19
C297	a_686_74##8	a_841_118#	2.17025e-18
C298	a_231_74##2	a_231_74##3	2.4363e-18
C299	a_889_92##11	RESET_B#1	5.199e-17
C300	a_231_74##6	a_686_74##4	2.65064e-19
C301	VPWR#9	a_231_74#	4.91312e-18
C302	VGND#10	a_686_74#	8.68865e-18
C303	GATE_N#3	a_231_74##2	9.63201e-20
C304	a_231_74##6	a_889_92##3	1.17437e-17
C305	a_889_92##15	RESET_B#3	3.62817e-18
C306	Q#2	a_889_92#	1.92571e-19
C307	a_373_74##3	a_889_92##2	1.38098e-18
C308	a_231_74##6	a_231_74##7	2.15408e-17
C309	a_231_74##6	a_373_74##3	3.03097e-17
C310	VGND#10	a_889_92#	4.76118e-19
C311	RESET_B#5	a_686_74##2	3.90394e-18
C312	a_889_92##11	a_686_74##4	5.34917e-17
C313	a_231_74##6	a_27_424#	6.73373e-18
C314	a_686_74#	a_889_92##15	2.45862e-17
C315	a_373_74##2	a_373_74##3	1.2166e-18
C316	VPWR#6	VPWR#7	9.78651e-18
C317	a_231_74##6	a_231_74#	9.39569e-19
C318	a_231_74##4	a_231_74##7	2.54199e-19
C319	a_231_74##6	GATE_N#1	3.4302e-19
C320	a_231_74##4	a_373_74##3	5.36554e-17
C321	VGND#11	a_686_74#	1.05567e-18
C322	a_686_74##8	a_686_74##6	1.88579e-18
C323	a_231_74##4	a_27_424#	1.19012e-17
C324	a_889_92##15	a_889_92#	2.06986e-18
C325	a_889_92##11	a_889_92##3	6.00643e-19
C326	a_27_424##2	a_373_74##3	1.73728e-17
C327	VGND#3	RESET_B#4	8.62026e-19
C328	a_27_424##2	a_27_424#	2.72588e-17
C329	VGND#4	a_686_74##6	6.28523e-19
C330	RESET_B#3	a_1133_74#	1.73994e-17
C331	a_889_92#	VGND#11	1.82027e-17
C332	a_27_424##2	a_231_74#	3.88401e-17
C333	a_686_74#	a_1133_74#	1.73994e-17
C334	a_231_74##2	a_27_424#	1.36146e-18
C335	a_27_424##2	GATE_N#1	2.01393e-18
C336	RESET_B#4	a_686_74##2	1.5902e-18
C337	a_686_74##8	a_686_74#	1.4954e-19
C338	RESET_B#2	a_889_92##6	3.37802e-17
C339	a_231_74##2	a_231_74#	7.70316e-18
C340	a_889_92##15	a_686_74##2	8.98682e-18
C341	a_231_74##6	VPWR#8	6.74027e-17
C342	a_889_92##11	a_231_74##7	1.19351e-19
C343	a_231_74##2	GATE_N#1	2.56045e-19
C344	GATE_N	a_27_424##5	3.10396e-17
C345	GATE_N#2	a_231_74#	1.6204e-18
C346	VPWR#8	a_373_74##2	1.62813e-20
C347	VGND#5	a_373_74##2	3.52729e-18
C348	a_686_74##8	a_889_92#	6.13616e-18
C349	a_889_92##15	a_231_74##5	8.04718e-20
C350	VPWR#8	a_231_74##4	8.0651e-20
C351	a_686_74##6	VGND#12	2.29008e-20
C352	a_231_74##7	a_802_508#	1.2049e-17
C353	VGND#5	a_231_74##4	2.02229e-19
C354	a_889_92#	a_841_118#	7.51356e-18
C355	a_27_424##2	VPWR#8	3.86932e-19
C356	a_889_92##2	a_686_74##3	3.35347e-17
C357	a_373_74#	a_841_118#	3.7458e-19
C358	VGND#11	a_231_74##5	3.28795e-20
C359	D	a_27_424##5	2.19256e-17
C360	a_686_74##8	a_373_74#	2.454e-17
C361	a_373_74##3	a_611_392#	1.7017e-17
C362	a_231_74##6	a_889_92##2	5.89342e-17
C363	a_27_424#	a_611_392#	1.94599e-18
C364	a_373_74##2	a_889_92##2	1.09634e-17
C365	a_1437_112##5	Q_N	2.00066e-18
C366	GATE_N	a_231_74##13	6.38607e-17
C367	a_373_74##2	a_231_74##6	2.46607e-17
C368	a_231_74##4	a_889_92##2	1.54926e-19
C369	a_686_74##8	a_231_74##5	3.50425e-17
C370	a_231_74##5	a_608_74#	1.22404e-17
C371	a_27_424##3	a_608_74#	1.22404e-17
C372	a_231_74##4	a_231_74##6	4.33157e-18
C373	a_231_74##4	a_373_74##2	9.3587e-17
C374	a_27_424##2	a_231_74##6	3.36944e-18
C375	VGND#9	Q_N#3	6.74474e-17
C376	D	VGND#13	2.69714e-17
C377	a_27_424##2	a_373_74##2	2.02251e-18
C378	a_686_74##8	a_27_424##3	2.01804e-18
C379	a_231_74##4	a_27_424##2	1.25014e-16
C380	a_686_74##6	a_373_74##3	5.76952e-18
C381	VPWR#6	a_686_74##2	3.03722e-19
C382	a_231_74##2	a_231_74##4	3.17078e-18
C383	GATE_N	a_231_74##11	2.37621e-17
C384	Q_N#3	Q_N	5.22816e-18
C385	a_373_74##5	a_686_74##8	1.51604e-18
C386	VPWR	VPWR#9	7.47233e-17
C387	a_231_74##2	a_27_424##2	1.14858e-16
C388	VPWR	VPWR#6	1.51907e-16
C389	VPWR	VPWR#4	7.44705e-17
C390	a_686_74##8	a_231_74##3	3.50303e-19
C391	a_231_74##6	a_802_508#	3.89049e-18
C392	a_27_424##3	VGND#12	1.84757e-17
C393	GATE_N#2	a_231_74##2	4.45507e-18
C394	Q#2	a_1437_112#	5.24693e-19
C395	a_889_92##5	VNB	4.98041e-17
C396	a_686_74##2	VNB	2.01851e-17
C397	a_231_74##6	a_611_392#	3.37951e-18
C398	VPWR	a_889_92##11	2.18985e-17
C399	VPWR	RESET_B#5	2.28023e-18
C400	Q_N	Q_N#1	5.90563e-18
C401	D#2	GATE_N#2	4.11336e-17
C402	VPWR#3	Q_N	9.18371e-17
C403	VPWR	a_686_74##6	7.94451e-18
C404	a_1437_112##7	VGND#9	4.70278e-17
C405	a_231_74##4	a_611_392#	1.58206e-17
C406	a_231_74##11	VPWR#10	8.84116e-19
C407	a_231_74##3	VGND#12	1.42675e-17
C408	VPWR	a_27_424##5	2.38582e-17
C409	Q#2	a_889_92##8	4.06129e-18
C410	VGND	VGND#6	1.13926e-16
C411	VGND	VGND#4	1.01244e-16
C412	VGND	VGND#3	7.45199e-17
C413	VPWR	D#5	2.09601e-18
C414	VGND#6	a_373_74##5	9.68473e-17
C415	a_231_74##3	a_373_74##6	2.59161e-17
C416	a_231_74##11	a_373_74##7	8.00939e-17
C417	VGND	a_889_92##11	7.93833e-18
C418	VPWR#12	VPWR#10	1.91301e-18
C419	a_373_74##5	VGND#12	2.20833e-18
C420	Q#2	VGND#9	6.27737e-18
C421	a_373_74##2	a_841_118#	6.60182e-21
C422	VGND	RESET_B#4	4.63092e-18
C423	VGND#13	a_27_424##3	2.70878e-19
C424	VGND	a_686_74##6	7.3763e-18
C425	VGND	a_373_74##5	2.53306e-17
C426	a_231_74##13	a_231_74##3	1.64121e-18
C427	Q#2	a_889_92##9	2.14484e-17
C428	a_373_74##2	a_608_74#	2.77345e-18
C429	VPWR#9	VNB	4.07423e-17
C430	VPWR#6	VNB	6.71525e-17
C431	VPWR#4	VNB	4.21154e-17
C432	VGND	D#5	2.72644e-18
C433	VGND#6	VNB	4.98531e-17
C434	VGND#4	VNB	5.26048e-17
C435	VGND	Q#2	6.12097e-18
C436	VGND#3	VNB	4.80979e-17
C437	VGND	VGND#10	2.05763e-17
C438	Q#2	a_1437_112##7	5.47998e-17
C439	Q_N	a_1437_112#	3.6676e-17
C440	a_889_92##11	RESET_B#5	3.65149e-17
C441	VGND	a_889_92##15	1.65304e-17
C442	VGND#10	VGND#9	7.90558e-19
C443	VGND#13	a_231_74##3	7.88055e-19
C444	VPWR	a_686_74##7	9.5614e-18
C445	a_1437_112##5	VNB	2.44332e-18
C446	a_889_92##11	VPWR#5	8.4067e-17
C447	a_373_74##5	a_373_74##6	7.23333e-18
C448	Q_N	a_889_92##8	2.16312e-18
C449	VPWR	VPWR#10	1.92614e-17
C450	VGND	a_686_74##8	3.87262e-17
C451	Q_N	a_889_92##9	8.54004e-20
C452	a_889_92##11	VNB	1.10668e-17
C453	VPWR	a_373_74##7	4.85557e-18
C454	VPWR	a_231_74##11	1.64502e-17
C455	RESET_B#4	VNB	5.93669e-19
C456	VPWR	VPWR#12	2.22211e-17
C457	a_231_74##13	GATE_N#3	5.38661e-17
C458	VGND	a_231_74##13	2.58234e-17
C459	a_686_74##6	VNB	1.20183e-17
C460	VPWR	a_27_424##6	1.59026e-17
C461	VGND	VGND#13	2.09937e-17
C462	VGND	a_27_424##7	1.6244e-17
C463	Q#2	RESET_B#1	1.60194e-18
C464	a_889_92##5	a_1437_112##3	1.63036e-18
C465	a_373_74##5	VNB	1.28624e-17
C466	a_27_424##5	VNB	4.37934e-17
C467	a_27_424##7	a_231_74##3	1.91982e-20
C468	D#5	VNB	1.91226e-18
C469	Q_N#3	VNB	5.2469e-17
C470	VGND#9	VNB	6.28775e-18
C471	a_1437_112##7	VNB	3.34833e-18
C472	Q#2	VNB	4.37755e-17
C473	GATE_N#3	VGND#13	2.63756e-17
C474	VGND#10	VNB	1.65449e-18
C475	VGND	a_373_74##7	1.51299e-18
C476	a_889_92##15	VNB	1.31577e-17
C477	VGND#11	VNB	1.02127e-17
C478	a_686_74##8	VNB	1.07734e-17
C479	VGND	a_889_92##7	1.53785e-18
C480	a_231_74##13	a_373_74##5	9.1663e-17
C481	a_231_74##13	D#3	1.87856e-18
C482	a_231_74##13	VNB	2.3414e-17
C483	VPWR	a_889_92##9	6.93596e-18
C484	VGND	RESET_B#3	3.65157e-19
C485	VGND#13	VNB	1.03106e-17
C486	a_27_424##7	VNB	4.71141e-17
C487	VGND	a_686_74#	3.17136e-18
C488	VPWR	RESET_B#1	8.86705e-18
C489	GATE_N	GATE_N#2	2.80551e-17
C490	a_1437_112##2	Q_N	3.13999e-17
C491	a_889_92##11	a_889_92##12	9.7834e-19
C492	VGND	a_889_92#	2.84611e-18
C493	VPWR	a_686_74##4	6.60594e-18
C494	VPWR#3	VNB	8.02118e-18
C495	VGND	a_373_74#	1.66857e-21
C496	a_1437_112##6	VNB	4.45384e-18
C497	VPWR	a_889_92##3	9.57103e-19
C498	GATE_N	D#2	6.56592e-18
C499	VGND	a_231_74##5	1.98422e-18
C500	VPWR#5	VNB	6.74927e-18
C501	VPWR	a_231_74##7	1.04916e-18
C502	VGND	a_27_424##3	5.15958e-19
C503	a_27_424##7	GATE_N#3	2.07922e-19
C504	VGND	a_231_74##3	6.90926e-19
C505	VPWR	a_373_74##3	4.58791e-18
C506	VGND	GATE_N#3	1.195e-18
C507	D	GATE_N#2	8.83203e-18
C508	VPWR	a_27_424#	8.89384e-19
C509	a_686_74##7	VNB	1.47294e-18
C510	VGND	D#3	9.10762e-18
C511	VPWR	a_231_74#	8.28041e-18
C512	VPWR#10	VNB	7.63499e-18
C513	D	D#2	9.49405e-18
C514	VPWR	GATE_N#1	1.40842e-18
C515	a_373_74##7	VNB	9.74301e-18
C516	a_231_74##11	VNB	1.50999e-17
C517	VPWR	D#1	2.06059e-18
C518	VPWR#12	VNB	3.7862e-18
C519	a_27_424##6	VNB	3.04434e-17
C520	D#3	VGND#13	2.48183e-17
C521	a_1437_112##3	VNB	3.39106e-17
C522	a_27_424##6	VPWR#12	4.45456e-17
C523	a_889_92##4	VNB	3.01787e-17
C524	a_889_92##7	VNB	3.49885e-17
C525	RESET_B#3	VNB	2.27584e-17
C526	a_686_74#	VNB	2.88297e-17
C527	VPWR	VPWR#8	5.42891e-17
C528	a_889_92#	VNB	4.02886e-17
C529	a_373_74#	VNB	2.32822e-17
C530	VGND#10	Q#2	5.05572e-17
C531	a_231_74##5	VNB	2.94549e-17
C532	a_27_424##3	VNB	2.96542e-17
C533	a_231_74##3	VNB	2.78991e-17
C534	VPWR	a_889_92##6	3.42231e-18
C535	GATE_N#3	VNB	3.57587e-17
C536	D#3	VNB	3.57633e-17
C537	VPWR	a_686_74##3	3.82598e-18
C538	a_1437_112#	VNB	4.39153e-17
C539	a_889_92##8	VNB	4.30411e-17
C540	VPWR	a_889_92##2	5.87045e-18
C541	a_889_92##9	VNB	4.21715e-17
C542	VPWR	a_231_74##6	4.65133e-17
C543	RESET_B#1	VNB	3.78573e-17
C544	a_27_424##5	a_231_74#	7.27259e-19
C545	a_686_74##4	VNB	3.51725e-17
C546	a_27_424##7	D#3	2.89945e-17
C547	VGND	VGND#5	5.88665e-17
C548	VPWR	a_373_74##2	2.36759e-19
C549	a_889_92##3	VNB	3.2343e-17
C550	a_231_74##7	VNB	2.28414e-17
C551	VPWR	a_231_74##4	4.62611e-18
C552	a_373_74##3	VNB	4.72763e-17
C553	VGND	a_889_92##6	4.51111e-18
C554	VPWR	a_27_424##2	2.70671e-17
C555	a_27_424#	VNB	3.44927e-17
C556	VGND	RESET_B#2	4.93592e-19
C557	RESET_B#5	VPWR#5	3.95187e-19
C558	a_231_74#	VNB	4.83369e-17
C559	VPWR	a_231_74##2	1.45265e-18
C560	a_889_92##6	VPWR#4	8.63156e-19
C561	VGND	a_686_74##3	7.87007e-18
C562	a_889_92##11	VPWR#7	3.88064e-18
C563	GATE_N#1	VNB	4.20002e-17
C564	D#1	VNB	3.2178e-17
C565	VPWR#6	VPWR#4	1.70066e-18
C566	VGND	a_373_74##2	1.46697e-17
C567	VPWR#8	VNB	3.05716e-17
C568	VGND	a_231_74##4	6.34145e-18
C569	VGND#5	VNB	3.22207e-17
C570	VGND	a_27_424##2	2.31169e-18
C571	a_1437_112##2	VNB	4.80004e-17
C572	VGND	a_231_74##2	7.23555e-18
C573	a_889_92##6	VNB	4.41818e-17
C574	RESET_B#2	VNB	2.45797e-17
C575	a_686_74##3	VNB	5.73509e-17
C576	VGND	D#2	3.11578e-19
C577	a_889_92##2	VNB	7.07336e-17
C578	D	GATE_N	5.53555e-17
C579	a_231_74##6	VNB	5.43508e-17
C580	a_373_74##2	VNB	3.91753e-17
C581	a_231_74##13	a_27_424##5	7.30446e-19
C582	a_231_74##4	VNB	3.24719e-17
C583	a_27_424##2	VNB	3.60506e-17
C584	a_231_74##2	VNB	4.94576e-17
C585	GATE_N#2	VNB	5.9105e-17
C586	D#2	VNB	7.01007e-17
C587	VPWR	GATE_N	3.84563e-18
C588	VPWR	D	2.2333e-18
C589	a_27_424##5	GATE_N#1	4.04908e-17
C590	VGND	GATE_N	5.87857e-18
C591	VGND	D	2.08964e-18
C592	GATE_N	VNB	3.26629e-19
C593	D	VNB	3.19634e-19
C594	Q_N	VNB	6.83748e-17
C595	VPWR	VNB	3.00154e-16
C596	VGND	VNB	3.16783e-16
C597	VGND#7	D#3	3.56886e-18
C598	Q_N	VPWR#2	4.10571e-17
C599	VGND#2	a_889_92##6	4.75749e-18
C600	VGND#7	VNB	6.28836e-17
C601	VGND#2	VNB	1.9004e-16
C602	VPWR#2	VNB	1.89693e-16
C603	VGND#2	VGND#3	1.78212e-17
C604	a_1437_112##6	VPWR#2	2.07428e-17
C605	VGND#2	Q#2	3.05137e-17
C606	VPWR#2	a_889_92##5	2.38761e-18
C607	a_27_424##2	VPWR#11	4.07054e-19
C608	VPWR#11	GATE_N#2	2.01533e-20
C609	VGND#2	Q_N#3	3.73237e-17
C610	VPWR#11	GATE_N#1	6.02939e-18
C611	VPWR	VPWR#11	1.08555e-16
C612	VGND#7	GATE_N#3	7.58932e-18
C613	VGND#2	a_1437_112##5	2.11845e-18
C614	a_1437_112##2	VPWR#2	4.48723e-18
C615	VGND#7	a_231_74##13	2.59763e-17
C616	VPWR#11	VNB	6.27873e-17
C617	VGND#7	D#5	5.36103e-19
C618	VGND	VGND#7	1.08636e-16
C619	VGND#2	VPWR#3	3.34723e-18
C620	VGND#7	VGND#6	3.0121e-19
C621	VGND#2	a_889_92##5	2.75235e-18
C622	VPWR#11	VPWR#10	2.40669e-19
C623	VPWR#2	a_1437_112#	1.14305e-17
C624	VGND#7	GATE_N	9.6788e-19
C625	a_1437_112##5	VPWR#2	1.97677e-18
C626	VGND#7	GATE_N#2	1.75002e-19
C627	VGND#2	VGND#9	2.33196e-17
C628	a_27_424##5	VPWR#11	2.2114e-17
C629	VPWR#2	a_889_92##6	1.76326e-18
C630	a_27_424##6	VPWR#11	1.85455e-17
C631	VGND#7	a_27_424##7	1.17657e-17
C632	VGND#2	a_1437_112##3	5.53388e-18
C633	VGND#2	a_1437_112##2	5.07107e-18
C634	VPWR#2	VPWR#4	2.17041e-17
C635	VPWR#2	a_889_92##8	1.19641e-17
C636	VPWR#11	D#1	1.81519e-18
C637	VGND#2	Q_N	2.76986e-18
C638	VGND#2	a_1437_112##7	2.1244e-17
C639	Q#2	VPWR#2	2.71548e-17
C640	VGND#2	a_889_92##4	1.26746e-17
*
*
.ENDS sky130_fd_sc_hs__dlrbn_1
*
