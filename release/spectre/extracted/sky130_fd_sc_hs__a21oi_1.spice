* Extracted by Quantus, converted by sky130cad/quantus.py
*
*
*
*                       LINUX           Wed Nov 18 08:05:53 2026
*
*
*
*  PROGRAM  advgen
*
*  Name           : advgen - Quantus - (64-bit)
*  Version        : 25.1.0-p047
*  Build Date     : Thu Dec 11 23:20:30 PST 2025
*
*  HSPICE LIBRARY
*
*  OPERATING_TEMPERATURE 150
*  QRC_TECH_DIR <path>/tech
*
*
*

*
.SUBCKT sky130_fd_sc_hs__a21oi_1 VPB VNB VGND VPWR Y A2 B1 A1
*
*
*  caps2d version: 10
*
*
*       TRANSISTOR CARDS
*
*
XM3 VGND#3 A2#1 a_117_74# VNB sky130_fd_pr__nfet_01v8_lvt l=0.15 w=0.74 ad=0.1961 as=0.1554 pd=2.01 ps=1.9
XM5 a_117_74# A1#3 Y#3 VNB sky130_fd_pr__nfet_01v8_lvt l=0.15 w=0.74 ad=0.1554 as=0.2886 pd=1.9 ps=2.26
XM0 Y#3 B1#3 VGND#1 VNB sky130_fd_pr__nfet_01v8_lvt l=0.15 w=0.74 ad=0.2886 as=0.2109 pd=2.26 ps=2.05
XM1 a_29_368##2 A2#4 VPWR#1 VPB sky130_fd_pr__pfet_01v8 l=0.15 w=1.12 ad=0.308 as=0.3696 pd=2.79 ps=2.9
XM2 VPWR#1 A1#1 a_29_368# VPB sky130_fd_pr__pfet_01v8 l=0.15 w=1.12 ad=0.3696 as=0.336 pd=2.9 ps=2.84
XM4 a_29_368# B1#4 Y#1 VPB sky130_fd_pr__pfet_01v8 l=0.15 w=1.12 ad=0.336 as=0.308 pd=2.84 ps=2.79
*
*
*       RESISTOR AND CAP/DIODE CARDS
*
Rg1	A2#1	A2#2	322.953644
Rg2	A2#2	A2#3	26.659500
Rg3	A2#2	A2#4	507.075531
Rg4	A1#1	A1#2	434.639221
Rg5	A1#2	A1#3	382.539734
Rg6	B1#1	B1#2	26.676205
Rg7	B1#2	B1#3	322.953644
Rg8	B1#2	B1#4	507.075531
Rf1	A2	A2#3	163.775864
Rf2	A1#4	A1	2.217604
Rf3	A1#2	A1#6	162.450409
Rf4	A1#4	A1#6	7.334466
Rf5	a_29_368#	a_29_368##2	87.254723
Rf6	Y	Y#2	0.255814
Rf7	Y#2	Y	18.674389
Rf8	Y	Y#3	97.731850
Rf9	Y#1	Y#2	5.000000
Rf10	B1#5	B1	0.543519
Rf11	B1#1	B1#7	160.776321
Rf12	B1#5	B1#7	4.519999
Rf13	VGND#1	VGND#2	92.252075
Rf14	VGND#2	VGND#3	78.550705
Rf15	VPWR#1	VPWR#2	34.048454
Re1	VPWR#2	VPWR	2.455682
Re2	VGND	VGND#2	2.455774
*
*       CAPACITOR CARDS
*
*
C1	VGND	VNB	5.3612e-17
C2	VPWR	VNB	5.54313e-17
C3	Y	VNB	6.08396e-17
C4	A2	VNB	1.86132e-17
C5	B1	VNB	6.84403e-18
C6	VGND	Y	2.33151e-18
C7	A1	VNB	1.09575e-17
C8	VGND	A2	2.27958e-18
C9	VPWR	Y	1.7268e-17
C10	VGND	B1	1.88262e-18
C11	A2#3	VNB	5.94297e-17
C12	VPWR	A2	2.63526e-18
C13	VGND	A1	5.04704e-18
C14	A1#2	VNB	3.26032e-17
C15	VGND#2	VNB	1.36182e-16
C16	VPWR	A1	1.9417e-18
C17	A2#4	VNB	4.74496e-17
C18	VGND	A2#3	5.53466e-20
C19	A1#1	VNB	3.01017e-17
C20	B1#4	VNB	4.08064e-17
C21	A2#1	VNB	2.61459e-17
C22	VGND	VGND#2	2.23069e-17
C23	A1#3	VNB	2.54863e-17
C24	B1#3	VNB	3.18844e-17
C25	A2	A1	3.18572e-17
C26	a_29_368##2	VNB	5.54358e-17
C27	VPWR#1	VNB	6.32222e-18
C28	a_29_368#	VNB	2.57055e-18
C29	VGND#3	VNB	5.93491e-17
C30	Y#3	VNB	7.5431e-18
C31	VGND#1	VNB	5.79308e-17
C32	Y	A1#2	3.5109e-18
C33	VGND	A2#1	4.26996e-18
C34	VGND	A1#3	1.12567e-18
C35	A1#6	VNB	4.70177e-19
C36	A2	A2#3	2.41135e-17
C37	VPWR	A2#4	1.79974e-18
C38	VGND	B1#3	3.06643e-18
C39	VGND#2	Y	4.06527e-20
C40	VGND	a_29_368##2	2.80936e-18
C41	VPWR	A1#1	3.92624e-19
C42	B1#7	VNB	1.02699e-17
C43	A2	A1#2	2.47553e-18
C44	VPWR	B1#4	3.27821e-18
C45	VGND	VGND#3	4.01095e-17
C46	Y	A2#4	1.22966e-18
C47	VGND	Y#3	1.91321e-17
C48	Y	A1#1	3.90325e-18
C49	VGND	VGND#1	3.27277e-17
C50	A1	A2#3	8.66923e-18
C51	Y	B1#4	3.55977e-17
C52	VPWR	a_29_368##2	1.7601e-17
C53	A1	A1#2	6.37473e-18
C54	VPWR	VPWR#1	2.33901e-17
C55	VGND	A1#6	2.16422e-18
C56	VPWR	a_29_368#	1.62413e-17
C57	VGND#2	A1	1.6713e-18
C58	a_29_368##2	Y	4.1359e-18
C59	Y	a_29_368#	8.46618e-17
C60	Y	Y#1	1.36209e-17
C61	VPWR	A1#6	1.20765e-18
C62	A1	A2#4	3.95584e-18
C63	A2	a_29_368##2	2.07872e-17
C64	A2#3	A1#2	3.4948e-17
C65	VPWR	B1#7	1.7233e-18
C66	VGND#1	Y	4.18018e-20
C67	VGND#3	A2	2.86295e-17
C68	A1#6	Y	2.19731e-17
C69	A2	Y#3	2.57779e-18
C70	Y	B1#7	2.75202e-17
C71	VGND#2	A1#2	8.53388e-20
C72	A2#1	a_117_74#	1.596e-17
C73	A1	a_29_368##2	2.18073e-17
C74	A1#3	a_117_74#	1.50905e-17
C75	A1	a_29_368#	3.48917e-18
C76	Y#3	B1	1.89424e-17
C77	VGND#1	B1	2.14269e-17
C78	A2#4	A1#2	2.62924e-18
C79	A1#2	B1#4	3.03983e-18
C80	B1#2	VNB	5.77087e-17
C81	A2#3	A1#3	4.66638e-18
C82	a_29_368##2	A2#3	3.95202e-18
C83	VGND#2	A2#1	4.06024e-18
C84	A1#2	VPWR#1	4.17913e-19
C85	A2#4	A1#1	4.10879e-17
C86	VGND#2	A1#3	7.50229e-18
C87	A2#3	VGND#3	8.20611e-18
C88	a_29_368#	A1#2	3.31234e-19
C89	VGND#2	B1#3	1.40225e-18
C90	Y#3	A2#3	1.61556e-18
C91	A1#1	B1#4	4.67432e-17
C92	VGND	B1#2	3.40343e-19
C93	Y#3	A1#2	9.64394e-18
C94	Y#3	B1#2	8.56438e-18
C95	VGND#2	VGND#3	2.52869e-17
C96	a_29_368##2	A2#4	4.5182e-17
C97	A1#6	A1#2	1.28314e-17
C98	VGND#2	Y#3	2.03665e-17
C99	A2#4	VPWR#1	3.97215e-17
C100	a_29_368##2	A1#1	2.28023e-18
C101	VGND#2	VGND#1	2.16143e-17
C102	a_29_368#	A2#4	1.67835e-18
C103	A1#1	VPWR#1	3.33241e-17
C104	a_29_368##2	B1#4	7.50089e-19
C105	A2#1	A1#3	5.96678e-17
C106	a_29_368#	A1#1	3.53146e-17
C107	VPWR#1	B1#4	2.67207e-18
C108	VGND#2	A1#6	3.19246e-19
C109	a_29_368#	B1#4	5.22149e-17
C110	B1#2	VGND#1	8.94396e-18
C111	A1#3	B1#3	2.3e-17
C112	B1#4	Y#1	5.04462e-19
C113	VGND#3	A2#1	4.09014e-17
C114	a_29_368##2	VPWR#1	7.8997e-17
C115	A1#6	A1#1	1.48746e-18
C116	VGND#3	A1#3	8.37923e-18
C117	Y	B1#2	8.55875e-18
C118	a_29_368##2	a_29_368#	2.48431e-18
C119	Y#3	A2#1	8.82488e-18
C120	VGND#3	B1#3	9.69476e-19
C121	A1#6	B1#4	1.22454e-18
C122	a_29_368#	VPWR#1	6.45814e-17
C123	VGND#1	A2#1	6.10033e-19
C124	Y#3	A1#3	5.1287e-17
C125	VGND#1	A1#3	2.2571e-18
C126	Y#3	B1#3	2.66486e-17
C127	B1#3	VGND#1	2.35417e-17
C128	A2	B1#2	8.1846e-19
C129	Y#3	a_29_368#	2.45429e-18
C130	VGND#3	Y#3	2.76708e-17
C131	VGND#3	VGND#1	7.98923e-19
C132	B1	B1#2	7.94177e-18
C133	A1#6	B1#2	3.35646e-18
C134	A1#6	a_29_368#	1.04164e-17
C135	Y#3	VGND#1	4.96299e-17
C136	Y#3	A1#6	3.91927e-17
C137	Y#3	B1#7	1.61752e-17
C138	A1#3	B1#2	1.8088e-18
C139	B1#7	B1#2	1.1622e-17
C140	A1#2	B1#2	3.27072e-17
C141	a_29_368##2	VPWR#2	2.01966e-17
C142	VPWR#2	A2#3	1.80192e-19
C143	VPWR#2	A1#1	9.72506e-19
C144	VPWR#2	B1#4	5.47437e-18
C145	VPWR#2	B1#2	1.80766e-19
C146	VPWR	VPWR#2	5.41702e-17
C147	a_29_368#	VPWR#2	1.87283e-17
C148	VPWR#2	A2#4	1.91461e-18
C149	Y	VPWR#2	2.12657e-17
C150	VPWR#2	VNB	1.83092e-16
*
*
.ENDS sky130_fd_sc_hs__a21oi_1
*
