* Extracted by Quantus, converted by sky130cad/quantus.py
*
*
*
*                       LINUX           Wed Nov 18 08:05:11 2026
*
*
*
*  PROGRAM  advgen
*
*  Name           : advgen - Quantus - (64-bit)
*  Version        : 25.1.0-p047
*  Build Date     : Thu Dec 11 23:20:30 PST 2025
*
*  HSPICE LIBRARY
*
*  OPERATING_TEMPERATURE 150
*  QRC_TECH_DIR <path>/tech
*
*
*

*
.SUBCKT sky130_fd_sc_hs__a21o_1 VPB VNB VGND VPWR X A2 B1 A1
*
*
*  caps2d version: 10
*
*
*       TRANSISTOR CARDS
*
*
XM5 X#1 a_81_264# VGND#7 VNB sky130_fd_pr__nfet_01v8_lvt l=0.15 w=0.74 ad=0.1961 as=0.2845 pd=2.01 ps=2.28
XM7 VGND#7 B1#1 a_81_264##4 VNB sky130_fd_pr__nfet_01v8_lvt l=0.15 w=0.64 ad=0.2845 as=0.1792 pd=2.28 ps=1.84
XM1 a_81_264##4 A1#3 a_452_136# VNB sky130_fd_pr__nfet_01v8_lvt l=0.15 w=0.64 ad=0.1792 as=0.208 pd=1.84 ps=1.93
XM6 a_452_136# A2#2 VGND#6 VNB sky130_fd_pr__nfet_01v8_lvt l=0.15 w=0.64 ad=0.208 as=0.1696 pd=1.93 ps=1.81
XM2 X#2 a_81_264##3 VPWR#7 VPB sky130_fd_pr__pfet_01v8 l=0.15 w=1.12 ad=0.308 as=0.308 pd=2.79 ps=2.79
XM0 a_81_264##7 B1#3 a_364_392##2 VPB sky130_fd_pr__pfet_01v8 l=0.15 w=1 ad=0.275 as=0.3 pd=2.55 ps=2.6
XM4 a_364_392##2 A1#1 VPWR#6 VPB sky130_fd_pr__pfet_01v8 l=0.15 w=1 ad=0.3 as=0.33 pd=2.6 ps=2.66
XM3 VPWR#6 A2#1 a_364_392# VPB sky130_fd_pr__pfet_01v8 l=0.15 w=1 ad=0.33 as=0.275 pd=2.66 ps=2.55
*
*
*       RESISTOR AND CAP/DIODE CARDS
*
Rg1	a_81_264#	a_81_264##2	541.699768
Rg2	a_81_264##2	a_81_264##3	455.487152
Rg3	B1#1	B1#2	290.721832
Rg4	B1#2	B1#3	409.090576
Rg5	A1#1	A1#2	409.090576
Rg6	A1#2	A1#3	290.721832
Rg7	A2#1	A2#2	774.737183
Rg8	A2#2	A2#3	273.409149
Rf1	X#1	X	137.219452
Rf2	X	X#3	13.585999
Rf3	X#3	X	0.186110
Rf4	X#2	X#3	5.000000
Rf5	B1#2	B1	162.790939
Rf6	a_81_264##4	a_81_264##5	72.327705
Rf7	a_81_264##5	a_81_264##2	186.039062
Rf8	a_81_264##5	a_81_264##7	54.905556
Rf9	A1#4	A1#2	161.216980
Rf10	A1	A1#6	0.984182
Rf11	A1#4	A1#6	1.968364
Rf12	a_364_392#	a_364_392##2	97.937347
Rf13	A2#3	A2	172.317673
Rf15	VPWR#2	VPWR#3	55.227528
Rf16	VPWR#3	VPWR#4	67.239273
Rf18	VPWR#2	VPWR#6	46.248783
Rf19	VPWR#4	VPWR#7	48.259808
Rf21	VGND#2	VGND#3	51.963894
Rf22	VGND#3	VGND#4	18.968596
Rf24	VGND#2	VGND#6	100.417137
Rf25	VGND#4	VGND#7	42.184113
Re1	VPWR#3	VPWR	1.403190
Re2	VGND	VGND#3	1.403242
*
*       CAPACITOR CARDS
*
*
C1	VGND	VNB	7.1414e-17
C2	VPWR	VNB	6.83093e-17
C3	X	VNB	5.61162e-17
C4	B1	VNB	4.45298e-20
C5	VGND	X	8.63794e-19
C6	A1	VNB	4.67493e-18
C7	VPWR	X	1.736e-17
C8	VGND	B1	1.76106e-18
C9	a_81_264##2	VNB	7.0478e-17
C10	B1#2	VNB	2.84974e-17
C11	VPWR	B1	3.0851e-18
C12	A1#2	VNB	2.86044e-17
C13	A2#3	VNB	9.44843e-17
C14	VPWR	A1	1.75338e-18
C15	VGND#3	VNB	1.69077e-16
C16	VPWR#3	VNB	1.78381e-16
C17	VGND	a_81_264##2	3.86647e-18
C18	a_81_264##3	VNB	4.84258e-17
C19	B1#3	VNB	3.76878e-17
C20	VGND	B1#2	6.38283e-21
C21	A1#1	VNB	3.13953e-17
C22	A2#1	VNB	5.67831e-17
C23	VGND	A2#3	2.68881e-17
C24	a_81_264#	VNB	7.28586e-17
C25	VGND	VGND#3	1.08181e-17
C26	B1#1	VNB	3.02114e-17
C27	VPWR	a_81_264##2	3.85273e-18
C28	A1#3	VNB	2.92911e-17
C29	A2#2	VNB	4.30336e-17
C30	B1	A1	9.77223e-18
C31	X#2	VNB	1.99637e-17
C32	VPWR#7	VNB	1.74407e-17
C33	a_81_264##7	VNB	2.25381e-17
C34	a_364_392##2	VNB	6.22748e-18
C35	X	a_81_264##2	4.88301e-17
C36	VPWR#6	VNB	3.85433e-18
C37	a_364_392#	VNB	5.54292e-17
C38	X#1	VNB	4.87225e-17
C39	X	B1#2	1.86903e-19
C40	VGND#7	VNB	1.20852e-17
C41	VPWR	VPWR#3	1.89224e-17
C42	a_81_264##4	VNB	2.96518e-18
C43	VGND	a_81_264#	3.66861e-18
C44	VGND#6	VNB	3.19078e-17
C45	VGND	B1#1	8.42023e-18
C46	VPWR	a_81_264##3	3.5e-18
C47	VGND	A1#3	7.31457e-18
C48	a_81_264##5	VNB	1.00461e-17
C49	VPWR	B1#3	2.7984e-18
C50	VPWR	A1#1	1.04224e-18
C51	A1#4	VNB	5.73992e-18
C52	B1	a_81_264##2	6.15143e-20
C53	VPWR	A2#1	1.69256e-18
C54	B1	B1#2	1.51858e-17
C55	X	a_81_264##3	2.74779e-17
C56	VPWR	a_81_264#	2.47687e-18
C57	VGND	a_364_392#	3.84219e-18
C58	VGND	X#1	2.12062e-17
C59	B1	A1#2	2.66816e-18
C60	VGND	a_81_264##4	1.40614e-17
C61	A1	B1#2	2.54133e-18
C62	VGND	VGND#6	6.25377e-18
C63	A1	A1#2	6.30806e-18
C64	VPWR	a_81_264##7	1.82803e-17
C65	B1	VPWR#3	6.62133e-19
C66	VGND	a_81_264##5	4.61776e-18
C67	VPWR	a_364_392##2	1.72198e-17
C68	VGND	A1#4	2.94093e-18
C69	VPWR	a_364_392#	1.76996e-17
C70	B1	a_81_264##3	1.86465e-19
C71	X	X#2	3.00557e-18
C72	X	VPWR#7	4.89897e-17
C73	VPWR	a_81_264##5	3.62617e-18
C74	X#1	X	3.14385e-18
C75	B1	a_81_264#	1.89562e-18
C76	a_81_264##2	B1#2	1.20675e-18
C77	A1	A2#1	4.80752e-18
C78	B1#2	A1#2	2.83218e-17
C79	X	a_81_264##5	1.32959e-18
C80	B1	a_81_264##7	1.1639e-17
C81	B1	a_364_392##2	1.75932e-17
C82	VGND#3	B1#2	3.22282e-20
C83	B1	VGND#7	5.43107e-19
C84	VPWR#3	B1#2	4.92247e-20
C85	A1	a_364_392##2	4.26278e-17
C86	a_81_264##4	B1	2.77436e-17
C87	A1	VPWR#6	4.74225e-19
C88	A1#3	a_452_136#	1.25556e-17
C89	a_81_264##3	B1#2	7.37062e-19
C90	A2#2	a_452_136#	9.42383e-18
C91	a_81_264##5	B1	3.23227e-17
C92	B1	A1#4	1.33577e-17
C93	a_81_264##2	a_81_264#	5.1778e-18
C94	A1#2	A2#1	1.54793e-17
C95	a_81_264#	B1#2	1.4955e-17
C96	VPWR#3	B1#3	7.74694e-18
C97	VGND#6	a_452_136#	1.05227e-17
C98	a_81_264##2	VPWR#7	3.87347e-17
C99	a_81_264#	A2#3	8.00669e-19
C100	a_81_264##3	B1#3	3.71071e-18
C101	A1#2	A2#2	1.76922e-17
C102	VPWR#7	B1#2	4.02776e-20
C103	VGND#3	a_81_264#	3.26414e-20
C104	A1#3	A2#3	6.80876e-18
C105	a_81_264##7	B1#2	6.54238e-18
C106	A1#4	a_452_136#	8.69412e-19
C107	VGND#3	B1#1	3.13764e-18
C108	A2#3	A2#2	2.84716e-18
C109	VPWR#3	a_81_264#	9.11219e-20
C110	a_81_264##2	X#1	6.18797e-17
C111	B1#3	A1#1	4.18552e-17
C112	a_81_264##7	A1#2	1.56676e-19
C113	a_364_392##2	A1#2	1.60237e-18
C114	VPWR#6	A1#2	5.6811e-19
C115	B1#2	VGND#7	1.25181e-18
C116	A1#1	A2#1	3.74401e-17
C117	a_81_264##4	B1#2	4.26041e-19
C118	A2#3	a_364_392#	2.70779e-18
C119	a_81_264##5	a_81_264##2	2.45806e-19
C120	a_81_264##4	A1#2	1.51136e-18
C121	a_81_264##7	VPWR#3	2.3095e-17
C122	a_364_392##2	VPWR#3	1.45813e-17
C123	VGND#7	A2#3	2.28654e-18
C124	X#2	a_81_264##3	2.50414e-17
C125	VGND#6	A1#2	2.49214e-18
C126	a_81_264##5	B1#2	9.20633e-18
C127	a_81_264##3	VPWR#7	4.37579e-17
C128	A1#4	B1#2	2.1556e-18
C129	a_81_264##7	a_81_264##3	8.34842e-18
C130	A2#3	VGND#6	3.84028e-17
C131	VGND#3	a_81_264##4	5.06781e-18
C132	VPWR#7	B1#3	2.49802e-18
C133	a_81_264##5	A1#2	2.40667e-20
C134	a_81_264#	B1#1	2.18647e-17
C135	B1#3	a_81_264##7	3.28421e-17
C136	A1#4	A1#2	8.81957e-18
C137	VPWR#6	a_81_264##3	4.0513e-19
C138	VPWR#7	A1#1	2.93282e-19
C139	a_364_392##2	B1#3	5.12175e-17
C140	a_81_264##7	A1#1	4.80834e-19
C141	VPWR#7	A2#1	2.42606e-19
C142	VPWR#6	B1#3	8.90395e-19
C143	B1#1	A1#3	3.315e-17
C144	a_364_392##2	A1#1	6.89998e-17
C145	a_81_264##7	A2#1	4.45052e-19
C146	A1#1	VPWR#6	2.83108e-17
C147	a_364_392##2	A2#1	2.05218e-18
C148	a_364_392#	A1#1	2.01028e-18
C149	A1#3	A2#2	2.63739e-17
C150	A2#1	VPWR#6	2.6315e-17
C151	a_364_392#	A2#1	5.37135e-17
C152	a_81_264##5	a_81_264##3	9.93466e-19
C153	X#2	VPWR#7	3.65655e-17
C154	a_81_264#	X#1	1.81805e-17
C155	VGND#7	a_81_264#	3.8695e-17
C156	X#1	B1#1	7.14539e-19
C157	a_81_264##4	a_81_264#	1.41408e-18
C158	VPWR#7	a_81_264##7	5.96263e-17
C159	B1#1	VGND#7	1.81958e-17
C160	a_81_264##4	B1#1	4.64262e-17
C161	VGND#7	A1#3	1.30216e-18
C162	VGND#6	a_81_264#	5.31693e-19
C163	VPWR#7	VPWR#6	9.8225e-19
C164	a_81_264##7	a_364_392##2	7.72087e-17
C165	a_81_264##4	A1#3	3.59786e-17
C166	VGND#7	A2#2	1.51598e-19
C167	VGND#6	B1#1	5.53037e-19
C168	a_81_264##4	A2#2	3.67025e-18
C169	a_81_264##5	a_81_264#	1.66356e-17
C170	VGND#6	A1#3	1.1337e-17
C171	a_364_392##2	VPWR#6	6.22708e-17
C172	a_364_392##2	a_364_392#	2.89198e-18
C173	VGND#6	A2#2	4.07012e-17
C174	a_81_264##5	B1#1	1.03019e-18
C175	a_364_392#	VPWR#6	6.41987e-17
C176	a_81_264##5	A1#3	3.13376e-19
C177	a_81_264##5	A2#2	2.95601e-19
C178	a_81_264##4	a_364_392##2	8.23916e-18
C179	A1#4	A2#2	5.90209e-18
C180	VGND#6	a_364_392##2	1.3078e-18
C181	X#1	VGND#7	2.4839e-17
C182	X#1	a_81_264##4	2.54763e-18
C183	a_81_264##5	a_81_264##7	2.916e-18
C184	VGND#6	a_364_392#	1.33302e-17
C185	a_81_264##4	VGND#7	2.22017e-17
C186	VGND#7	VGND#6	1.75891e-18
C187	a_81_264##4	VGND#6	4.06598e-17
C188	X#1	a_81_264##5	2.47117e-17
C189	a_81_264##5	VGND#7	2.9837e-17
C190	A1#4	a_81_264##4	1.74375e-17
C191	a_81_264##5	VGND#6	1.55084e-18
C192	VGND#6	A1#4	9.11611e-18
C193	VGND#2	B1#1	4.24589e-19
C194	VGND#3	VGND#4	6.78253e-17
C195	VGND#4	X#1	1.49815e-17
C196	VPWR#4	VPWR#2	2.36006e-19
C197	VGND#2	A1#3	4.73131e-18
C198	VPWR#2	A2#1	5.57508e-18
C199	VGND#4	VGND#2	2.56066e-18
C200	VGND#2	VNB	5.75989e-17
C201	VPWR#2	A1#1	5.26615e-18
C202	VGND	VGND#2	4.81368e-17
C203	VPWR#2	B1#3	5.38969e-19
C204	VGND#4	VNB	7.04235e-17
C205	a_81_264##5	VPWR#4	1.05772e-18
C206	VPWR#2	a_81_264##3	8.93822e-20
C207	VGND	VGND#4	6.97694e-17
C208	VPWR#3	VPWR#2	5.61402e-17
C209	VPWR#4	VPWR#6	6.90229e-20
C210	VGND#7	VGND#2	5.94452e-18
C211	VGND#4	a_81_264##5	2.39448e-19
C212	VGND#2	a_81_264##4	1.75682e-18
C213	VGND#4	a_81_264#	2.40622e-18
C214	VPWR#4	a_81_264#	8.54587e-19
C215	VGND#2	VGND#6	6.86219e-19
C216	VPWR#4	A2#1	6.27047e-20
C217	VPWR#4	A1#1	1.01355e-19
C218	VPWR#4	B1#3	7.04065e-19
C219	VPWR#4	a_81_264##3	8.43951e-18
C220	VGND#2	A1#2	3.98856e-20
C221	VPWR#3	VPWR#4	5.33716e-17
C222	VGND#2	A2#3	9.67953e-17
C223	a_364_392#	VPWR#2	2.11181e-17
C224	VGND#3	VGND#2	5.70902e-17
C225	VGND#2	A1#4	3.80117e-19
C226	a_81_264##2	VPWR#4	5.43335e-19
C227	a_364_392##2	VPWR#2	4.79679e-18
C228	VGND#4	a_81_264##2	9.64256e-19
C229	VPWR	VPWR#2	5.00064e-17
C230	X	VPWR#4	2.18435e-17
C231	VPWR#2	VNB	5.20604e-17
C232	VPWR	VPWR#4	5.19436e-17
C233	VPWR#4	VNB	5.0303e-17
C234	VGND#4	A2#3	1.40351e-18
C235	VGND#2	a_81_264#	1.07936e-18
*
*
.ENDS sky130_fd_sc_hs__a21o_1
*
