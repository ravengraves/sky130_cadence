* Extracted by Quantus, converted by sky130cad/quantus.py
*
*
*
*                       LINUX           Wed Nov 18 08:14:43 2026
*
*
*
*  PROGRAM  advgen
*
*  Name           : advgen - Quantus - (64-bit)
*  Version        : 25.1.0-p047
*  Build Date     : Thu Dec 11 23:20:30 PST 2025
*
*  HSPICE LIBRARY
*
*  OPERATING_TEMPERATURE 150
*  QRC_TECH_DIR <path>/tech
*
*
*

*
.SUBCKT sky130_fd_sc_hs__a32oi_4 VPB VNB VGND VPWR Y B2 B1 A1 A2 A3
*
*
*  caps2d version: 10
*
*
*       TRANSISTOR CARDS
*
*
XM17 VGND#11 B2#6 a_27_74##6 VNB sky130_fd_pr__nfet_01v8_lvt l=0.15 w=0.74 ad=0.259 as=0.2109 pd=2.18 ps=2.05
XM36 a_27_74##8 B2#10 VGND#11 VNB sky130_fd_pr__nfet_01v8_lvt l=0.15 w=0.74 ad=0.2072 as=0.259 pd=2.04 ps=2.18
XM25 VGND#10 B2#8 a_27_74##8 VNB sky130_fd_pr__nfet_01v8_lvt l=0.15 w=0.74 ad=0.2553 as=0.2072 pd=2.17 ps=2.04
XM1 a_27_74##3 B2#1 VGND#10 VNB sky130_fd_pr__nfet_01v8_lvt l=0.15 w=0.74 ad=0.2072 as=0.2553 pd=2.04 ps=2.17
XM31 a_27_74##3 B1#9 Y#12 VNB sky130_fd_pr__nfet_01v8_lvt l=0.15 w=0.74 ad=0.2072 as=0.2072 pd=2.04 ps=2.04
XM32 a_27_74##7 B1#14 Y#12 VNB sky130_fd_pr__nfet_01v8_lvt l=0.15 w=0.74 ad=0.259 as=0.2072 pd=2.18 ps=2.04
XM23 Y#10 B1#12 a_27_74##7 VNB sky130_fd_pr__nfet_01v8_lvt l=0.15 w=0.74 ad=0.2072 as=0.259 pd=2.04 ps=2.18
XM5 Y#10 B1#10 a_27_74# VNB sky130_fd_pr__nfet_01v8_lvt l=0.15 w=0.74 ad=0.2072 as=0.2109 pd=2.04 ps=2.05
XM16 Y#8 A1#13 a_868_74# VNB sky130_fd_pr__nfet_01v8_lvt l=0.15 w=0.74 ad=0.259 as=0.2109 pd=2.18 ps=2.05
XM15 a_868_74##2 A1#11 Y#8 VNB sky130_fd_pr__nfet_01v8_lvt l=0.15 w=0.74 ad=0.2072 as=0.259 pd=2.04 ps=2.18
XM37 a_868_74##2 A1#9 Y#6 VNB sky130_fd_pr__nfet_01v8_lvt l=0.15 w=0.74 ad=0.2072 as=0.2072 pd=2.04 ps=2.04
XM21 Y#6 A1#1 a_868_74##4 VNB sky130_fd_pr__nfet_01v8_lvt l=0.15 w=0.74 ad=0.2072 as=0.2072 pd=2.04 ps=2.04
XM26 a_868_74##4 A2#7 a_1313_74##5 VNB sky130_fd_pr__nfet_01v8_lvt l=0.15 w=0.74 ad=0.2072 as=0.2072 pd=2.04 ps=2.04
XM4 a_1313_74##5 A2#12 a_868_74##6 VNB sky130_fd_pr__nfet_01v8_lvt l=0.15 w=0.74 ad=0.2072 as=0.2109 pd=2.04 ps=2.05
XM27 a_868_74##6 A2#9 a_1313_74##3 VNB sky130_fd_pr__nfet_01v8_lvt l=0.15 w=0.74 ad=0.2109 as=0.2072 pd=2.05 ps=2.04
XM22 a_1313_74##3 A2#8 a_868_74##8 VNB sky130_fd_pr__nfet_01v8_lvt l=0.15 w=0.74 ad=0.2072 as=0.2109 pd=2.04 ps=2.05
XM35 VGND#9 A3#12 a_1313_74##6 VNB sky130_fd_pr__nfet_01v8_lvt l=0.15 w=0.74 ad=0.2109 as=0.2072 pd=2.05 ps=2.04
XM39 VGND#8 A3#8 a_1313_74##6 VNB sky130_fd_pr__nfet_01v8_lvt l=0.15 w=0.74 ad=0.2072 as=0.2072 pd=2.04 ps=2.04
XM20 a_1313_74# A3#6 VGND#8 VNB sky130_fd_pr__nfet_01v8_lvt l=0.15 w=0.74 ad=0.2072 as=0.2072 pd=2.04 ps=2.04
XM24 a_1313_74# A3#1 VGND#1 VNB sky130_fd_pr__nfet_01v8_lvt l=0.15 w=0.74 ad=0.2072 as=0.2109 pd=2.04 ps=2.05
XM10 Y#5 B2#12 a_27_368##13 VPB sky130_fd_pr__pfet_01v8 l=0.15 w=1.12 ad=0.3864 as=0.336 pd=2.93 ps=2.84
XM28 a_27_368##20 B2#11 Y#5 VPB sky130_fd_pr__pfet_01v8 l=0.15 w=1.12 ad=0.336 as=0.3864 pd=2.84 ps=2.93
XM33 a_27_368##20 B2#9 Y#14 VPB sky130_fd_pr__pfet_01v8 l=0.15 w=1.12 ad=0.336 as=0.336 pd=2.84 ps=2.84
XM11 Y#14 B2#7 a_27_368##19 VPB sky130_fd_pr__pfet_01v8 l=0.15 w=1.12 ad=0.336 as=0.392 pd=2.84 ps=2.94
XM18 a_27_368##19 B1#15 Y#13 VPB sky130_fd_pr__pfet_01v8 l=0.15 w=1.12 ad=0.392 as=0.392 pd=2.94 ps=2.94
XM9 Y#13 B1#13 a_27_368##18 VPB sky130_fd_pr__pfet_01v8 l=0.15 w=1.12 ad=0.392 as=0.392 pd=2.94 ps=2.94
XM0 a_27_368##18 B1#11 Y#1 VPB sky130_fd_pr__pfet_01v8 l=0.15 w=1.12 ad=0.392 as=0.392 pd=2.94 ps=2.94
XM29 Y#1 B1#1 a_27_368##8 VPB sky130_fd_pr__pfet_01v8 l=0.15 w=1.12 ad=0.392 as=0.5488 pd=2.94 ps=3.22
XM3 VPWR#13 A1#7 a_27_368##8 VPB sky130_fd_pr__pfet_01v8 l=0.15 w=1.12 ad=0.392 as=0.5488 pd=2.94 ps=3.22
XM6 a_27_368##17 A1#12 VPWR#13 VPB sky130_fd_pr__pfet_01v8 l=0.15 w=1.12 ad=0.336 as=0.392 pd=2.84 ps=2.94
XM34 a_27_368##17 A1#10 VPWR#11 VPB sky130_fd_pr__pfet_01v8 l=0.15 w=1.12 ad=0.336 as=0.448 pd=2.84 ps=3.04
XM2 VPWR#11 A1#8 a_27_368##16 VPB sky130_fd_pr__pfet_01v8 l=0.15 w=1.12 ad=0.448 as=0.3472 pd=3.04 ps=2.86
XM38 a_27_368##16 A2#13 VPWR#9 VPB sky130_fd_pr__pfet_01v8 l=0.15 w=1.12 ad=0.3472 as=0.4368 pd=2.86 ps=3.02
XM8 VPWR#9 A2#11 a_27_368##4 VPB sky130_fd_pr__pfet_01v8 l=0.15 w=1.12 ad=0.4368 as=0.336 pd=3.02 ps=2.84
XM13 VPWR#7 A2#10 a_27_368##4 VPB sky130_fd_pr__pfet_01v8 l=0.15 w=1.12 ad=0.392 as=0.336 pd=2.94 ps=2.84
XM7 a_27_368##15 A2#1 VPWR#7 VPB sky130_fd_pr__pfet_01v8 l=0.15 w=1.12 ad=0.392 as=0.392 pd=2.94 ps=2.94
XM19 VPWR#5 A3#14 a_27_368##15 VPB sky130_fd_pr__pfet_01v8 l=0.15 w=1.12 ad=0.392 as=0.392 pd=2.94 ps=2.94
XM12 a_27_368##14 A3#13 VPWR#5 VPB sky130_fd_pr__pfet_01v8 l=0.15 w=1.12 ad=0.392 as=0.392 pd=2.94 ps=2.94
XM30 a_27_368##14 A3#9 VPWR#4 VPB sky130_fd_pr__pfet_01v8 l=0.15 w=1.12 ad=0.392 as=0.4536 pd=2.94 ps=3.05
XM14 VPWR#4 A3#5 a_27_368# VPB sky130_fd_pr__pfet_01v8 l=0.15 w=1.12 ad=0.4536 as=0.3304 pd=3.05 ps=2.83
*
*
*       RESISTOR AND CAP/DIODE CARDS
*
Rg1	B2#1	B2#2	397.555725
Rg2	B2#2	B2#3	66.369736
Rg3	B2#3	B2#4	60.775578
Rg4	B2#4	B2#5	91.536705
Rg5	B2#5	B2#6	397.555725
Rg6	B2#2	B2#7	449.655212
Rg7	B2#3	B2#8	394.805237
Rg8	B2#3	B2#9	448.030548
Rg9	B2#4	B2#10	375.854645
Rg10	B2#4	B2#11	427.954132
Rg11	B2#5	B2#12	449.655212
Rg12	B1#1	B1#2	453.336334
Rg13	B1#2	B1#3	53.112595
Rg14	B1#3	B1#4	22.529716
Rg15	B1#4	B1#5	25.368574
Rg16	B1#5	B1#6	38.504337
Rg17	B1#6	B1#7	22.529716
Rg18	B1#7	B1#8	50.076050
Rg19	B1#8	B1#9	394.232941
Rg20	B1#2	B1#10	370.752045
Rg21	B1#3	B1#11	419.554810
Rg22	B1#4	B1#12	381.948395
Rg23	B1#6	B1#13	419.554810
Rg24	B1#7	B1#14	381.948395
Rg25	B1#8	B1#15	449.668243
Rg26	A1#1	A1#2	397.555725
Rg27	A1#2	A1#3	58.693653
Rg28	A1#3	A1#4	23.289124
Rg29	A1#4	A1#5	63.190937
Rg30	A1#5	A1#6	74.947166
Rg31	A1#6	A1#7	452.082214
Rg32	A1#2	A1#8	449.655212
Rg33	A1#3	A1#9	377.411346
Rg34	A1#4	A1#10	419.554810
Rg35	A1#5	A1#11	377.870178
Rg36	A1#5	A1#12	429.969666
Rg37	A1#6	A1#13	371.862305
Rg38	A2#1	A2#2	456.289429
Rg39	A2#2	A2#3	64.870361
Rg40	A2#3	A2#4	63.692070
Rg41	A2#4	A2#5	22.529716
Rg42	A2#5	A2#6	57.950947
Rg43	A2#6	A2#7	397.555725
Rg44	A2#2	A2#8	370.752045
Rg45	A2#3	A2#9	379.238098
Rg46	A2#3	A2#10	431.337585
Rg47	A2#4	A2#11	419.554810
Rg48	A2#5	A2#12	381.948395
Rg49	A2#6	A2#13	449.655212
Rg50	A3#1	A3#2	397.555725
Rg51	A3#2	A3#3	59.072231
Rg52	A3#3	A3#4	33.474648
Rg53	A3#2	A3#5	449.655212
Rg54	A3#3	A3#6	375.613068
Rg55	A3#4	A3#7	43.154751
Rg56	A3#7	A3#8	370.752045
Rg57	A3#4	A3#9	429.126801
Rg58	A3#7	A3#10	34.409721
Rg59	A3#10	A3#11	38.866360
Rg60	A3#11	A3#12	367.485718
Rg61	A3#10	A3#13	419.554810
Rg62	A3#11	A3#14	537.623596
Rf1	B2	B2#13	3.208829
Rf2	B2#13	B2	11.460103
Rf3	a_27_74#	a_27_74##2	78.296722
Rf4	a_27_74##2	a_27_74##4	92.369064
Rf5	a_27_74##4	a_27_74##5	88.839111
Rf6	a_27_74##5	a_27_74##6	82.968941
Rf7	a_27_74##2	a_27_74##7	19.154261
Rf8	a_27_74##5	a_27_74##8	28.306047
Rf9	a_27_74##3	a_27_74##4	7.500000
Rf12	A1	A1#14	11.918507
Rf13	A1#14	A1	2.750425
Rf14	Y#1	Y#2	16.278900
Rf15	Y#2	Y#3	73.001427
Rf16	Y#3	Y#4	73.001427
Rf17	Y#4	Y#5	78.784904
Rf18	Y#2	Y	265.829010
Rf19	Y	Y#7	5.616363
Rf20	Y#7	Y	11.776244
Rf21	Y	Y#9	1.759542
Rf22	Y#9	Y#11	102.938126
Rf23	Y#11	Y#12	51.710194
Rf24	Y#3	Y#13	16.279915
Rf25	Y#4	Y#14	16.279915
Rf26	Y#6	Y#7	15.000000
Rf27	Y#8	Y#9	15.000000
Rf28	Y#10	Y#11	15.000000
Rf29	a_868_74#	a_868_74##3	58.585178
Rf30	a_868_74##3	a_868_74##5	43.999928
Rf31	a_868_74##5	a_868_74##7	43.999928
Rf32	a_868_74##7	a_868_74##8	57.309494
Rf33	a_868_74##2	a_868_74##3	15.000000
Rf34	a_868_74##4	a_868_74##5	15.000000
Rf35	a_868_74##6	a_868_74##7	15.000000
Rf36	A2	A2#14	0.916808
Rf37	A2#14	A2	13.752123
Rf38	a_1313_74#	a_1313_74##2	91.590828
Rf39	a_1313_74##2	a_1313_74##4	101.157562
Rf40	a_1313_74##4	a_1313_74##5	47.835716
Rf41	a_1313_74##2	a_1313_74##6	28.306047
Rf42	a_1313_74##3	a_1313_74##4	15.000000
Rf43	A3	A3#15	12.224110
Rf44	A3#15	A3	2.444822
Rf45	a_27_368#	a_27_368##2	88.337189
Rf46	a_27_368##2	a_27_368##3	73.001427
Rf47	a_27_368##3	a_27_368##5	83.767342
Rf48	a_27_368##5	a_27_368##6	64.239258
Rf49	a_27_368##6	a_27_368##7	73.001427
Rf50	a_27_368##7	a_27_368##9	83.294556
Rf51	a_27_368##9	a_27_368##10	80.019394
Rf52	a_27_368##10	a_27_368##11	73.001427
Rf53	a_27_368##11	a_27_368##12	69.471481
Rf54	a_27_368##12	a_27_368##13	88.622383
Rf55	a_27_368##2	a_27_368##14	18.602406
Rf56	a_27_368##3	a_27_368##15	18.602406
Rf57	a_27_368##6	a_27_368##16	14.409969
Rf58	a_27_368##7	a_27_368##17	14.409969
Rf59	a_27_368##10	a_27_368##18	18.149860
Rf60	a_27_368##11	a_27_368##19	18.149860
Rf61	a_27_368##12	a_27_368##20	28.306047
Rf62	a_27_368##4	a_27_368##5	5.000000
Rf63	a_27_368##8	a_27_368##9	7.500000
Rf64	VGND#1	VGND#2	92.448723
Rf65	VGND#2	VGND#3	57.575783
Rf66	VGND#3	VGND#4	387.496368
Rf67	VGND#4	VGND#5	125.622314
Rf68	VGND#5	VGND#6	62.774361
Rf70	VGND#2	VGND#8	35.098007
Rf71	VGND#3	VGND#9	38.595905
Rf72	VGND#5	VGND#10	35.098007
Rf73	VGND#6	VGND#11	35.098007
Rf75	VPWR#2	VPWR#3	84.677513
Rf76	VPWR#2	VPWR#4	31.534731
Rf77	VPWR#3	VPWR#5	35.032631
Rf78	VPWR#3	VPWR#6	63.529400
Rf79	VPWR#6	VPWR#7	31.534731
Rf80	VPWR#6	VPWR#8	73.001427
Rf81	VPWR#8	VPWR#9	32.342297
Rf82	VPWR#8	VPWR#10	73.001427
Rf83	VPWR#10	VPWR#11	32.342297
Rf84	VPWR#10	VPWR#12	73.001427
Rf85	VPWR#12	VPWR#13	32.342297
Rf86	VPWR#12	VPWR#14	102.976662
Rf88	B1#5	B1	32.046562
Rf89	A1#5	A1#14	40.058201
Rf90	A2#3	A2#14	40.058201
Rf91	A3#4	A3#15	40.058201
Rf87	B2#4	B2#13	40.058201
Re1	VPWR#3	VPWR	2.512894
Re2	VPWR	VPWR#14	1.435940
Re3	VGND#3	VGND	2.512894
Re4	VGND	VGND#4	1.435940
*
*       CAPACITOR CARDS
*
*
C1	a_1313_74##2	A3#12	2.31645e-17
C2	VGND#11	a_27_74##8	4.15829e-17
C3	a_27_368##15	VPWR#6	7.97461e-18
C4	a_27_368#	A3#5	5.66765e-17
C5	Y#3	B1#1	1.98955e-19
C6	Y#6	A2#11	2.20205e-18
C7	VGND#5	a_27_74##5	2.91756e-19
C8	B1#5	A1#6	6.3439e-18
C9	A2#8	A3#12	3.12941e-18
C10	a_27_368##12	B2#9	1.58461e-17
C11	Y#2	B1#1	3.39333e-17
C12	a_1313_74#	VGND#1	6.64174e-17
C13	Y#3	a_27_368##10	1.70406e-17
C14	VPWR#8	VPWR#7	6.00536e-20
C15	A3#5	VPWR#4	3.55899e-17
C16	a_27_74##6	a_27_74##8	1.8378e-18
C17	a_27_74##5	B2#3	1.72206e-18
C18	Y#6	a_27_368##16	2.58574e-18
C19	B1#7	A1#6	9.96182e-18
C20	a_1313_74##2	A2#8	7.4614e-20
C21	B1#5	B1#8	2.06297e-17
C22	a_27_368#	A3#9	8.25684e-19
C23	a_27_368##14	A3#5	6.73208e-19
C24	B1#5	B1#7	6.0912e-17
C25	Y#6	A2#13	7.72136e-18
C26	Y#3	B1#11	1.19957e-18
C27	A3#9	VPWR#4	3.69295e-17
C28	a_27_74##6	VGND#11	5.58209e-17
C29	VPWR#5	A3#5	3.95462e-19
C30	B1#7	a_27_368##18	1.54631e-18
C31	A2#9	A2#8	4.05123e-17
C32	VGND#8	VGND#1	2.92642e-18
C33	Y#2	B1#11	2.51876e-17
C34	a_27_368##12	B2#11	1.61058e-17
C35	a_27_74##5	B2#2	1.23344e-18
C36	Y#6	VPWR#11	1.37891e-18
C37	VGND#2	A3#7	2.94706e-20
C38	a_27_368##14	A3#9	5.61546e-17
C39	Y#2	a_27_368##10	2.34873e-17
C40	a_27_368##4	VPWR#8	8.77327e-18
C41	Y#4	B1#13	1.98955e-19
C42	Y#6	A1#8	2.12593e-17
C43	VPWR#4	A3#13	1.17163e-18
C44	VPWR#5	A3#9	1.86694e-18
C45	Y#3	B1#13	3.7224e-17
C46	a_1313_74#	VGND#8	4.83358e-17
C47	A3#13	a_27_368##14	2.03884e-17
C48	A2#12	A2#9	3.94863e-17
C49	a_27_368##15	A3#9	1.56043e-19
C50	Y#2	B1#13	7.53191e-19
C51	a_27_368##4	VPWR#6	8.60618e-18
C52	B1#8	Y#13	1.64466e-19
C53	a_27_368#	A3#2	4.59923e-19
C54	VGND#5	a_27_74##2	6.85134e-18
C55	VPWR#5	A3#13	5.68901e-17
C56	Y#6	A1#10	7.05668e-18
C57	Y#4	B1#15	1.19957e-18
C58	a_27_368##7	VPWR#12	8.75823e-18
C59	VGND#5	B1#10	4.40142e-20
C60	A3#7	A3#2	3.72491e-18
C61	A3#7	VPWR#4	1.60187e-18
C62	a_27_368##14	A3#14	3.41523e-19
C63	a_27_368##15	A3#13	1.40728e-18
C64	B1#7	Y#13	5.62838e-19
C65	Y#3	B1#15	2.50894e-17
C66	a_1313_74##6	a_1313_74#	1.67195e-18
C67	VPWR#3	VPWR#8	3.63868e-17
C68	A2#7	A2#12	4.01656e-17
C69	A3#14	VPWR#5	2.66236e-17
C70	VPWR#7	A3#13	2.81672e-19
C71	VPWR#3	VPWR#6	5.862e-17
C72	B2#5	B2#4	3.25764e-18
C73	Y#6	A1#12	1.89862e-19
C74	Y#2	a_27_368##7	6.25254e-17
C75	B2#4	B2#3	4.0818e-18
C76	a_27_368##15	A3#14	5.6154e-17
C77	Y#4	B2#7	4.27499e-17
C78	VGND#2	A3#2	4.20683e-20
C79	a_27_368##7	VPWR#10	8.70886e-18
C80	a_1313_74##6	VGND#8	4.16102e-17
C81	Y#3	B2#7	4.35441e-19
C82	VPWR#5	A2#1	7.17622e-19
C83	VPWR#7	A3#14	1.86694e-18
C84	VGND#5	B1#12	7.07539e-20
C85	a_27_368#	VPWR#4	6.8756e-17
C86	A1#1	A2#7	3.94646e-17
C87	Y#6	A1#7	1.20753e-19
C88	A2#1	a_27_368##15	2.03884e-17
C89	A3#2	VPWR#4	5.35184e-19
C90	a_27_368##4	A3#14	1.97004e-19
C91	B1#1	A1#6	2.92599e-19
C92	VPWR#7	A2#1	5.68901e-17
C93	Y#4	B2#9	2.92306e-17
C94	A3#7	a_27_368##14	8.64358e-19
C95	a_27_368##14	a_27_368#	2.05817e-18
C96	VGND#9	VGND#8	2.92642e-18
C97	a_27_368##15	A2#10	3.41523e-19
C98	a_27_368##4	A2#1	1.93406e-18
C99	a_27_368##6	VPWR#10	8.75823e-18
C100	VGND#5	B1#14	2.18949e-19
C101	A1#9	A1#1	4.06232e-17
C102	A3#11	VPWR#5	1.1982e-18
C103	A2#10	VPWR#7	2.66236e-17
C104	VPWR#9	A2#1	2.81672e-19
C105	VGND#3	VGND#2	8.01038e-17
C106	a_27_368##14	VPWR#4	6.22197e-17
C107	a_27_368##4	A2#10	7.06147e-17
C108	Y#4	B2#11	1.37698e-18
C109	VGND#9	a_1313_74##6	4.15829e-17
C110	a_868_74##8	A2#2	9.50277e-19
C111	VGND#2	VGND#1	1.15097e-18
C112	VPWR#3	a_27_368##6	1.03356e-18
C113	B1#7	B1#1	4.82705e-19
C114	a_1313_74##3	A2#5	5.59884e-19
C115	VGND#1	A3#1	4.08805e-17
C116	a_27_368##2	a_27_368#	5.40269e-19
C117	VPWR#9	A2#10	7.67963e-19
C118	VPWR#7	A2#11	7.67963e-19
C119	a_27_74##3	B2#2	2.6327e-19
C120	A1#11	A1#9	4.06774e-17
C121	a_27_368##6	VPWR#8	8.78202e-18
C122	a_27_368##3	VPWR#3	3.32555e-18
C123	VPWR#5	VPWR#4	1.54435e-18
C124	VGND#5	B1#9	4.96721e-18
C125	a_27_368##4	A2#11	6.57467e-17
C126	a_27_368##2	VPWR#3	2.9405e-18
C127	A3#1	a_1313_74#	1.97264e-17
C128	A2#11	VPWR#9	3.50571e-17
C129	VPWR#7	A2#13	2.85428e-19
C130	A2#2	A3#11	1.27143e-17
C131	VGND#1	A3#6	2.81783e-18
C132	a_868_74##6	A2#6	4.40426e-20
C133	VGND#2	a_1313_74#	1.07892e-17
C134	VPWR#5	a_27_368##14	6.22197e-17
C135	VGND#8	A3#1	1.7593e-18
C136	VGND#10	B2#3	6.21465e-19
C137	a_27_368##2	VPWR#4	2.57677e-17
C138	a_27_368##4	A2#13	2.1215e-18
C139	a_27_368##12	VPWR#14	6.06745e-17
C140	A1#13	A1#11	2.70035e-17
C141	a_27_368##11	VPWR#14	7.04913e-17
C142	a_1313_74#	A3#6	3.07579e-17
C143	VPWR#11	A2#11	2.79583e-19
C144	A2#13	VPWR#9	3.73242e-17
C145	a_27_368##10	VPWR#14	7.31855e-17
C146	a_868_74##8	VGND#9	2.80698e-17
C147	VGND#5	B2#1	5.0017e-18
C148	a_1313_74##3	a_1313_74##6	2.39182e-18
C149	a_1313_74##6	A3#1	3.25327e-19
C150	a_1313_74##3	A2#2	3.54569e-18
C151	Y#10	Y#2	1.18991e-19
C152	a_27_368##8	VPWR#12	2.6886e-17
C153	a_27_368##15	a_27_368##14	2.03253e-18
C154	A2#13	a_27_368##16	1.88249e-17
C155	a_27_368##4	A1#8	7.32104e-19
C156	a_868_74##6	A2#5	6.08466e-19
C157	VGND#10	B2#2	5.26964e-19
C158	VGND#8	A3#6	3.38568e-17
C159	B1#8	B1#7	3.90592e-18
C160	VPWR#11	A2#13	7.55472e-19
C161	B1#10	A1#13	3.27248e-18
C162	VPWR#9	A1#8	7.84568e-19
C163	VGND#3	a_1313_74##2	6.34249e-18
C164	a_27_368##2	a_27_368##14	2.61053e-18
C165	a_1313_74#	A3#8	3.97516e-19
C166	a_27_368##15	VPWR#5	6.22197e-17
C167	A1#8	a_27_368##16	2.26089e-17
C168	a_27_368##4	A1#10	9.43761e-20
C169	a_1313_74##6	A3#6	6.19928e-19
C170	a_27_368##3	VPWR#5	1.62756e-17
C171	A1#8	VPWR#11	3.2136e-17
C172	VGND#5	B2#8	4.33499e-18
C173	VPWR#9	A1#10	2.8528e-19
C174	a_1313_74##5	A2#6	3.33803e-18
C175	VGND#8	A3#8	2.91738e-17
C176	B1#12	B1#10	3.76111e-17
C177	a_27_74##3	Y#4	4.16045e-18
C178	VPWR#7	VPWR#5	1.54433e-18
C179	a_27_368##4	A1#12	8.74011e-20
C180	a_1313_74#	A3#12	1.67688e-19
C181	VPWR#8	A2#3	1.62361e-20
C182	a_27_368##2	VPWR#5	1.53362e-17
C183	a_868_74##8	a_1313_74##3	3.81547e-17
C184	VGND#2	a_1313_74##6	5.19931e-18
C185	VPWR#13	A1#8	2.8528e-19
C186	A1#10	VPWR#11	3.4228e-17
C187	A3#8	a_1313_74##6	1.39762e-17
C188	VPWR#6	A2#3	1.95361e-20
C189	a_27_368##3	a_27_368##15	2.08719e-18
C190	A1#10	a_27_368##17	2.32435e-17
C191	a_1313_74##5	A2#5	3.11699e-18
C192	VGND#8	A3#12	1.65107e-18
C193	a_27_368##3	VPWR#6	1.6661e-19
C194	VPWR#7	a_27_368##15	6.22197e-17
C195	VGND#11	B2#5	1.16418e-18
C196	B1#14	B1#12	2.61153e-17
C197	VGND#5	B2#10	6.4128e-19
C198	VGND#9	A3#8	1.70046e-18
C199	VPWR#13	A1#10	7.67963e-19
C200	VPWR#11	A1#12	7.67963e-19
C201	VPWR#12	A1#5	1.98001e-20
C202	B2#3	Y#14	2.74109e-19
C203	a_1313_74##5	VGND#9	2.61187e-18
C204	A3#12	a_1313_74##6	1.75175e-17
C205	VPWR#10	A1#5	1.82161e-20
C206	A1#12	a_27_368##17	2.32435e-17
C207	a_27_368##6	a_27_368##4	2.63376e-18
C208	a_27_368##4	a_27_368##15	2.03253e-18
C209	A3#4	a_27_368##3	7.8257e-18
C210	A1#12	VPWR#13	2.86443e-17
C211	VPWR#11	A1#7	2.81672e-19
C212	a_27_74##2	a_27_74#	6.86522e-18
C213	a_868_74##4	A2#6	2.31958e-19
C214	a_27_368##3	VPWR#7	2.29834e-17
C215	B1#9	B1#14	3.84334e-17
C216	B2#2	Y#14	2.70455e-19
C217	A3#4	a_27_368##2	6.78908e-17
C218	VGND#9	A3#12	4.80639e-17
C219	a_27_368##8	A1#12	3.67779e-19
C220	a_1313_74##3	A3#8	2.32578e-19
C221	a_1313_74##3	a_868_74##6	2.02875e-17
C222	a_27_368##4	VPWR#7	7.38862e-17
C223	a_1313_74##6	A2#8	2.14317e-19
C224	VPWR#13	A1#7	4.00039e-17
C225	a_1313_74##2	A3#4	6.97748e-17
C226	a_868_74##8	A3#12	7.0762e-19
C227	VGND#3	VGND#1	6.43292e-17
C228	a_27_368##8	A1#7	6.37915e-17
C229	a_27_368##6	VPWR#9	5.12526e-17
C230	B2#1	B1#9	4.02524e-17
C231	a_27_74##2	Y#10	2.62166e-17
C232	a_27_74##6	B2#5	1.90144e-18
C233	VGND#9	A2#8	4.82557e-18
C234	VGND#3	a_1313_74#	1.27907e-17
C235	a_27_368##4	a_27_368##3	5.3354e-19
C236	VPWR#9	VPWR#7	1.65163e-18
C237	a_1313_74##3	A3#12	7.31489e-19
C238	VPWR#13	B1#1	1.27638e-18
C239	VGND#3	a_1313_74##6	1.70999e-17
C240	a_27_368##18	A1#7	3.18898e-19
C241	a_27_368##8	B1#1	4.28322e-17
C242	a_868_74##8	A2#8	4.63533e-17
C243	A2#6	A2#5	3.80746e-18
C244	a_27_368##7	A1#5	6.31373e-19
C245	B1#1	Y#1	2.54251e-17
C246	B2#8	B2#1	2.55647e-17
C247	VGND#5	B1#8	1.09811e-20
C248	VGND#3	a_868_74##8	4.93471e-17
C249	a_27_368##4	VPWR#9	5.17877e-17
C250	A3	A3#7	1.09063e-17
C251	VPWR#13	B1#11	1.43911e-19
C252	a_27_74##2	a_27_74##7	3.00535e-18
C253	VGND#9	A2#9	1.09737e-18
C254	Y#6	A2#6	1.26148e-17
C255	a_27_368##6	a_27_368##16	3.52951e-18
C256	VGND#3	a_1313_74##3	1.17508e-17
C257	A3	A3#2	2.13869e-17
C258	a_1313_74##3	A2#8	4.0942e-17
C259	a_27_368##18	B1#1	1.54142e-18
C260	a_868_74##6	a_1313_74##5	3.48789e-17
C261	a_27_368##8	B1#11	7.23601e-19
C262	a_27_74##5	a_27_74##3	4.59022e-19
C263	VGND#3	a_868_74##6	5.69072e-17
C264	a_1313_74##5	A3#12	2.31303e-19
C265	VGND#4	a_27_74##2	6.70373e-17
C266	B1#11	Y#1	1.16921e-17
C267	a_868_74##8	A2#9	9.23622e-19
C268	VGND#3	a_1313_74##5	5.2782e-18
C269	B2#5	Y#5	1.83962e-18
C270	a_27_368##7	VPWR#11	5.13738e-17
C271	VPWR#13	B1#13	5.98911e-20
C272	B2#10	B2#8	4.09582e-17
C273	VGND#3	a_868_74##4	3.44785e-17
C274	a_27_368##18	B1#11	4.87232e-17
C275	Y#6	A2#5	4.50005e-19
C276	VGND#9	A2#12	6.90233e-19
C277	a_27_74##2	Y#12	5.68683e-17
C278	VGND#5	B2#4	3.80851e-20
C279	a_1313_74##3	A2#9	3.85591e-17
C280	a_1313_74##5	A2#8	3.59281e-19
C281	a_27_368##6	VPWR#11	5.12975e-17
C282	a_27_74##5	VGND#10	2.49667e-17
C283	a_27_368##19	B1#11	3.30616e-19
C284	B1#13	a_27_368##18	2.37687e-17
C285	a_868_74##8	A2#12	5.32147e-19
C286	a_27_368##12	B2#4	6.7531e-20
C287	B2#6	B2#10	2.46505e-17
C288	a_868_74##6	A2#9	3.51668e-17
C289	B1#13	Y#13	2.54251e-17
C290	a_27_368##7	a_27_368##17	1.09261e-18
C291	A2	A3#11	1.73926e-17
C292	VGND#9	A2#7	3.35308e-19
C293	a_27_74##3	a_27_74##2	2.37845e-18
C294	a_1313_74#	A3#4	5.74255e-18
C295	a_868_74##4	a_1313_74##5	2.13588e-17
C296	a_27_368##19	B1#13	1.54142e-18
C297	VPWR#11	VPWR#9	1.64929e-18
C298	a_27_368##18	B1#15	7.23601e-19
C299	a_1313_74##5	A2#9	8.47919e-19
C300	A2	A2#6	2.98251e-19
C301	A2#2	VPWR#7	1.53536e-18
C302	A2	A2#5	2.69154e-17
C303	a_27_74##5	a_27_74##8	1.24483e-18
C304	Y#6	A2#8	1.63261e-19
C305	B1#15	Y#13	1.16921e-17
C306	a_868_74##8	A2#7	2.76296e-19
C307	a_27_368##13	B2#5	1.11598e-19
C308	A2	A2#2	2.4104e-17
C309	a_868_74##6	A2#12	3.37094e-17
C310	VGND#4	a_868_74##4	3.53999e-18
C311	Y#2	A1#5	1.87866e-18
C312	a_27_368##19	B1#15	4.87232e-17
C313	Y#6	A2#2	1.92648e-19
C314	A2#5	a_27_368##4	1.45959e-18
C315	A2	A1#2	4.45348e-18
C316	Y#6	a_1313_74##5	4.50744e-17
C317	VGND#4	a_868_74##2	3.6725e-17
C318	VPWR#3	a_27_368#	1.83639e-17
C319	a_27_368##7	VPWR#13	5.65876e-17
C320	a_1313_74##5	A2#12	4.22126e-17
C321	VPWR#3	VPWR#4	2.22355e-17
C322	a_27_368##20	B1#15	2.6824e-19
C323	Y#6	A2#9	1.85282e-19
C324	B2#7	a_27_368##19	2.37432e-17
C325	VGND#4	a_868_74#	3.12624e-17
C326	a_868_74##8	A1#1	1.93015e-19
C327	a_27_74##5	VGND#11	1.78617e-17
C328	a_27_368##14	VPWR#3	2.67644e-17
C329	B1#5	Y#3	7.70036e-17
C330	VGND#4	a_27_74#	4.88716e-17
C331	B2#7	Y#14	2.32435e-17
C332	Y#6	A1#6	1.92714e-19
C333	VPWR#3	VPWR#5	2.19079e-17
C334	B1#5	Y#2	9.24376e-17
C335	a_868_74##8	A2#3	3.52917e-19
C336	a_27_74##2	B1#10	2.32869e-18
C337	VGND#4	Y#10	1.11212e-18
C338	a_868_74##4	Y#6	5.15334e-17
C339	a_1313_74##3	A2#3	2.66631e-18
C340	a_27_368##15	VPWR#3	2.72293e-17
C341	a_27_368##20	B2#7	6.21076e-19
C342	a_27_368##19	B2#9	7.65936e-19
C343	a_1313_74##5	A2#7	3.30882e-17
C344	a_868_74##6	A2#3	1.37036e-19
C345	a_27_368##10	Y#1	1.02438e-18
C346	VPWR#3	VPWR#7	2.14188e-17
C347	VPWR#9	A2#6	2.11076e-19
C348	A3#9	A3#5	2.99942e-17
C349	a_27_368##3	A3#11	2.68926e-18
C350	Y#6	A2#12	3.32819e-19
C351	a_27_368##8	a_27_368##7	2.30006e-18
C352	B2#9	Y#14	2.32435e-17
C353	a_27_368##4	A2#2	3.88528e-19
C354	A1	A2#6	4.02913e-18
C355	VPWR#3	a_27_368##4	2.00519e-17
C356	a_868_74##4	A1#2	2.35065e-19
C357	Y#4	B2#4	1.32873e-18
C358	a_27_74##6	a_27_74##5	5.57268e-19
C359	VPWR#6	A2#1	9.76872e-19
C360	B2#9	a_27_368##20	2.39003e-17
C361	Y#6	A1#4	4.24641e-18
C362	VPWR#3	VPWR#9	1.39532e-17
C363	a_868_74##4	A2#7	3.49658e-17
C364	Y#6	A2#3	2.18633e-19
C365	A1	A1#6	1.98893e-17
C366	a_27_368##19	B2#11	3.28804e-19
C367	A1	A1#4	3.04227e-17
C368	a_27_74##2	B1#12	2.65536e-17
C369	Y#5	B2#9	1.37698e-18
C370	A2#5	VPWR#9	1.06767e-18
C371	A1	A1#2	2.95443e-19
C372	VPWR#13	VPWR#11	1.65163e-18
C373	Y#4	Y#3	2.59148e-18
C374	A3#13	A3#9	3.68668e-17
C375	a_1313_74##5	A1#1	1.05376e-18
C376	a_27_368##13	B2#9	3.28804e-19
C377	A1	B1#7	4.09625e-18
C378	Y#6	A2#7	6.94981e-18
C379	B2#11	a_27_368##20	2.73349e-17
C380	a_27_74##5	B2#4	6.31357e-18
C381	a_27_74##6	a_27_368##13	3.23355e-19
C382	a_27_368##10	a_27_368##18	1.26724e-18
C383	Y#5	B2#11	6.29493e-17
C384	a_27_368##2	A3#5	1.76717e-19
C385	a_868_74##4	A1#1	3.37634e-17
C386	Y#6	A1#5	2.23661e-19
C387	a_27_368##13	B2#11	2.60269e-18
C388	a_868_74##2	Y#6	1.95228e-17
C389	a_868_74##2	A1#5	2.10011e-19
C390	A3#14	A3#13	3.73142e-17
C391	a_27_74##2	B1#14	1.98431e-17
C392	a_27_368##20	B2#12	1.18373e-18
C393	VPWR#6	A2#10	2.57874e-18
C394	a_27_74##5	B1#9	3.608e-20
C395	a_27_368##11	Y#13	7.06526e-19
C396	B2#12	Y#5	2.6546e-17
C397	a_868_74#	A1#5	3.50535e-19
C398	Y#6	A1#1	4.08973e-17
C399	a_27_368##6	A2#6	1.05861e-18
C400	a_27_368##3	A3#9	4.09613e-20
C401	Y#2	A1#6	1.80958e-18
C402	a_27_368##13	B2#12	6.12835e-17
C403	a_27_368##2	A3#11	7.45095e-19
C404	Y#6	A1#2	1.76462e-17
C405	A3#14	A3#11	2.12502e-18
C406	A2#1	A3#14	3.76807e-17
C407	a_868_74##2	A1#4	6.19148e-19
C408	a_27_368##10	Y#13	2.69038e-19
C409	a_27_368##2	A3#9	1.88193e-17
C410	a_1313_74##2	a_1313_74#	5.06977e-19
C411	VPWR#8	A2#11	2.55596e-18
C412	a_868_74#	A2#7	1.99593e-19
C413	a_27_74##2	B1#9	4.62933e-19
C414	a_27_74##5	B2#1	8.65465e-20
C415	Y#6	A1#9	2.82039e-17
C416	a_27_368##8	VPWR#13	4.05248e-17
C417	a_27_368##8	VPWR#14	1.96483e-17
C418	Y#3	Y#2	2.59148e-18
C419	a_27_368##11	a_27_368##19	1.26724e-18
C420	Y#10	B1#5	9.51897e-17
C421	a_27_368##6	A2#5	5.50353e-19
C422	A2#10	A2#1	3.7303e-17
C423	Y#2	A1#4	4.62326e-20
C424	a_27_368##3	A3#13	1.06354e-19
C425	B1	B2#3	3.3499e-20
C426	a_868_74##2	Y#8	1.69265e-19
C427	a_868_74##2	A1#9	3.37277e-17
C428	B1	B2#2	1.2779e-17
C429	a_27_368##7	a_27_368##6	2.64007e-18
C430	Y#12	B1#5	6.61604e-17
C431	a_868_74#	A1#1	3.22341e-19
C432	VPWR#3	A3#7	4.26363e-20
C433	a_27_74##3	B1#5	1.66128e-18
C434	a_27_368##12	Y#14	2.55422e-19
C435	a_27_368##11	B1#8	5.15067e-20
C436	a_27_368##2	A3#13	1.29207e-17
C437	a_27_74##2	B2#1	2.02452e-19
C438	A2#3	VPWR#7	2.15867e-20
C439	Y#6	A1#11	1.89543e-19
C440	a_1313_74##2	VGND#8	2.26289e-17
C441	VGND#2	a_1313_74##2	2.91756e-19
C442	a_27_74##5	B2#8	1.76239e-17
C443	A2#3	a_27_368##4	2.55329e-18
C444	A2#11	A2#10	4.58384e-17
C445	VPWR#8	A2#13	2.3826e-18
C446	a_27_74#	A1#1	3.43232e-19
C447	VGND#3	A3#1	2.55583e-19
C448	a_868_74##2	A1#2	3.81981e-20
C449	a_868_74##2	A1#11	3.46233e-17
C450	a_27_368##8	Y#1	4.25029e-20
C451	a_27_368##11	Y#14	3.80555e-19
C452	Y#3	B1#8	6.84592e-19
C453	a_868_74#	A1#9	5.1487e-19
C454	VGND#3	A3#6	6.66995e-19
C455	a_27_368##3	A3#14	2.14541e-17
C456	VGND#1	a_27_368#	1.70278e-19
C457	a_27_368##2	A3#7	5.81178e-18
C458	a_27_368##13	VPWR#14	5.53723e-17
C459	VGND#3	A3#8	1.30813e-18
C460	A2#13	A2#11	3.29505e-17
C461	Y#6	A1#13	1.63317e-19
C462	VPWR#12	VPWR#10	1.03218e-18
C463	B2#2	B1#8	2.54622e-17
C464	VGND#2	A3	2.35013e-19
C465	a_27_368##7	A1#6	4.14123e-19
C466	A1#11	Y#8	1.66074e-17
C467	B2	B1#8	6.40293e-18
C468	a_27_74##5	B2#10	1.75911e-17
C469	VGND#3	A3#12	5.17652e-18
C470	a_27_368##2	A3#14	8.96497e-20
C471	a_27_368##12	a_27_368##20	5.47123e-20
C472	VGND#11	B2#4	7.52903e-19
C473	a_27_368##11	B1#7	7.4148e-20
C474	a_27_74#	A1#9	4.12871e-19
C475	a_1313_74##2	a_1313_74##6	1.24483e-18
C476	VPWR#10	A1#8	2.55596e-18
C477	a_27_368##18	a_27_368##8	4.30643e-18
C478	VGND#3	A2#8	7.51199e-18
C479	a_1313_74##5	a_27_368##6	3.70357e-18
C480	a_868_74#	Y#8	1.50263e-18
C481	B2	B2#5	2.3423e-17
C482	VGND#3	A3#11	3.69778e-20
C483	B2	B2#3	1.51173e-17
C484	VGND#3	A2#9	6.33661e-18
C485	a_868_74#	A1#11	1.19182e-18
C486	B2	B2#2	8.61296e-18
C487	A1#5	a_27_368##17	5.29945e-19
C488	A1#8	A2#13	4.2137e-17
C489	A2#2	A3#14	1.29959e-18
C490	Y#3	B1#7	3.68393e-18
C491	VGND#3	A2#12	6.28566e-18
C492	A1#5	VPWR#13	1.91073e-19
C493	a_868_74#	A1#6	7.96228e-19
C494	a_27_368##3	A2#1	1.29207e-17
C495	A1#13	Y#8	1.15885e-17
C496	A3	a_27_368##2	2.42162e-17
C497	VGND#3	A2#7	5.35547e-18
C498	a_27_74#	A1#11	8.09854e-19
C499	a_27_74##5	B2#6	1.74119e-19
C500	VGND#3	A1#1	5.36658e-18
C501	a_27_368##7	A1#4	3.97189e-19
C502	A1#10	A1#8	3.06156e-17
C503	a_1313_74##2	VGND#9	3.87462e-17
C504	a_27_368##12	Y#5	1.45144e-17
C505	a_868_74#	A1#13	5.44739e-17
C506	VPWR#10	A1#10	2.55596e-18
C507	VGND#3	A2#6	4.44556e-20
C508	Y#10	A1#11	1.96282e-19
C509	a_868_74##4	a_27_368##6	9.93773e-19
C510	VGND#3	A2#5	9.57565e-20
C511	Y	A1#6	2.91795e-18
C512	A2	a_27_368##6	1.81374e-18
C513	Y#6	a_27_368##7	2.06603e-17
C514	Y	A1#4	2.47587e-18
C515	a_27_74#	A1#13	3.74317e-18
C516	A1#12	A1#10	4.57205e-17
C517	A2	a_27_368##3	7.6531e-17
C518	a_27_368##3	A2#10	8.96497e-20
C519	a_27_368##10	B1#7	2.54337e-19
C520	a_27_74#	a_868_74#	3.39576e-17
C521	a_27_368##2	A3#2	3.06291e-19
C522	VGND#3	A2#2	1.11613e-19
C523	a_868_74#	B1#10	3.53808e-18
C524	a_1313_74##2	A2	2.68956e-17
C525	Y#10	A1#13	6.11341e-19
C526	VGND#4	A1#9	5.35671e-18
C527	VPWR#12	A1#12	2.55596e-18
C528	a_27_368##6	A2#11	5.06789e-19
C529	VPWR#10	VPWR#8	1.02842e-18
C530	A1#7	A1#12	3.74283e-17
C531	VGND#4	A1#11	5.35671e-18
C532	VGND#2	A3#1	6.7947e-19
C533	Y#2	B1#7	3.77807e-18
C534	Y#6	a_27_368##6	5.17746e-17
C535	a_27_74#	B1#10	4.84078e-17
C536	VGND#4	A1#13	5.35671e-18
C537	a_27_368##19	a_27_368##18	4.30643e-18
C538	VGND#1	A3	2.65339e-17
C539	A1#4	VPWR#11	1.13404e-18
C540	a_1313_74#	A3	3.78433e-17
C541	VGND#4	B1#10	4.47052e-18
C542	VGND#3	A1#2	1.79014e-21
C543	A1#2	A2#6	2.38241e-17
C544	a_868_74#	B1#12	4.37771e-19
C545	B2#4	a_27_368##20	1.23799e-18
C546	B1#1	A1#7	2.18602e-17
C547	a_27_368##6	A1#4	1.79697e-19
C548	VGND#4	B1#12	4.43427e-18
C549	Y#10	B1#10	4.1336e-17
C550	B2#4	Y#5	2.38245e-18
C551	VGND#4	B1#14	4.43427e-18
C552	Y#12	A1#13	1.86843e-19
C553	a_27_368##13	B2#4	4.17776e-20
C554	VPWR#3	A3#5	9.70056e-19
C555	a_1313_74##3	a_1313_74##2	3.68576e-19
C556	a_27_74#	B1#12	1.60728e-18
C557	a_1313_74##2	A3#11	7.11847e-18
C558	a_27_368##6	A2#13	4.90222e-17
C559	VPWR#3	A3#9	1.26521e-19
C560	B1#11	B1#1	3.35965e-17
C561	VPWR#12	A1#7	3.98563e-18
C562	a_27_74#	Y#10	2.87368e-17
C563	VGND#2	A3#6	4.37202e-18
C564	VPWR#3	A3#13	1.51208e-18
C565	a_868_74#	B1#14	2.72745e-19
C566	Y#10	B1#12	3.79398e-17
C567	VPWR#3	A3#14	2.72842e-18
C568	Y#12	B1#10	2.81966e-19
C569	VPWR#11	A1#2	1.87772e-19
C570	A1	Y#2	9.34041e-17
C571	B1#13	B1#11	3.39924e-17
C572	a_1313_74##3	A2	9.39398e-17
C573	VPWR#3	A2#1	5.99649e-19
C574	a_27_368##7	A1#8	7.71085e-19
C575	B1#12	a_27_74##7	1.6609e-17
C576	a_1313_74##5	A2	3.95971e-17
C577	VPWR#3	A2#10	1.399e-19
C578	Y#12	a_868_74#	2.21087e-18
C579	Y#6	A2	2.21921e-17
C580	a_27_368##3	A2#2	1.77537e-18
C581	Y#2	a_27_368##17	4.76058e-19
C582	VPWR#3	A2#11	2.54545e-20
C583	A1#4	a_27_368##17	1.46192e-20
C584	a_27_368##6	A1#8	3.24474e-17
C585	B1#15	B1#13	3.35965e-17
C586	Y#12	B1#12	9.35644e-19
C587	A3	a_27_368#	4.92467e-17
C588	VPWR#8	VPWR#6	9.53351e-19
C589	VGND#2	A3#8	4.33514e-18
C590	Y#4	B2#3	1.14099e-18
C591	VPWR#14	B1#8	6.81349e-21
C592	B1	Y#4	1.91295e-17
C593	B1	Y#3	6.65184e-18
C594	A3#4	A3#9	2.00656e-18
C595	a_27_368##20	a_27_368##19	3.78447e-18
C596	VPWR#14	B1#7	8.15418e-20
C597	B1#14	a_27_74##7	1.05438e-17
C598	B2#7	B1#15	3.40009e-17
C599	A3#4	A3#13	2.09378e-18
C600	a_27_74##3	B1#12	1.7013e-19
C601	a_27_368##6	A1#2	2.05796e-19
C602	a_27_368##12	B2#3	6.86756e-20
C603	VGND#5	a_27_74##3	3.17143e-17
C604	Y#6	A1	6.23486e-17
C605	A3#4	A3#14	1.47352e-18
C606	a_27_368##3	a_27_368##2	5.3354e-19
C607	a_27_368##7	A1#10	3.61628e-17
C608	Y#2	VPWR#13	1.3433e-18
C609	Y#12	B1#14	4.6726e-17
C610	a_1313_74##2	A3#7	2.2445e-18
C611	B2#9	B2#7	4.60019e-17
C612	a_27_368##6	A1#10	5.24626e-19
C613	A1#6	VPWR#13	1.07035e-18
C614	Y#4	B2#2	1.12577e-18
C615	B2	Y#4	5.9505e-17
C616	A2#3	A2#1	7.61189e-19
C617	a_27_74##3	B1#14	4.01042e-19
C618	VGND#4	A1#6	9.40829e-20
C619	VGND#2	A3#12	6.01371e-19
C620	VPWR#14	B2#5	1.47626e-20
C621	A2	a_27_368##4	5.94754e-17
C622	a_1313_74#	A3#7	1.22977e-18
C623	B2#11	B2#9	4.70897e-17
C624	VGND#4	A1#4	9.74284e-20
C625	a_27_74##5	B2	8.63541e-17
C626	VPWR#14	B2#3	1.12044e-20
C627	A3#4	A3#11	1.79971e-17
C628	Y#12	B1#9	3.30007e-17
C629	VPWR#14	B1#1	4.45488e-18
C630	VPWR#14	B2#2	1.12044e-20
C631	Y#2	a_27_368##8	1.19847e-16
C632	VGND#4	A1#2	3.93831e-20
C633	a_27_368##7	A1#12	3.14963e-17
C634	VPWR#14	B1#11	4.4526e-18
C635	B2#12	B2#11	3.78613e-17
C636	A3#4	A3#7	1.98121e-17
C637	a_27_74#	B1#7	1.26793e-18
C638	VPWR	VPWR#12	7.28105e-17
C639	a_27_74##3	B1	2.4224e-17
C640	VGND#4	B1#8	1.17797e-20
C641	VPWR	VPWR#10	5.95237e-17
C642	a_27_74##3	B1#9	4.66866e-17
C643	VPWR#14	B1#13	4.4526e-18
C644	VPWR	VPWR#8	2.30116e-17
C645	Y#12	a_27_74##7	8.41992e-19
C646	Y#5	a_27_368##20	4.11152e-17
C647	VGND#4	B1#7	1.34795e-19
C648	VPWR#14	B1#15	4.46413e-18
C649	Y	Y#2	5.80677e-18
C650	a_27_368##11	B2#3	1.60243e-20
C651	A3#11	VNB	4.65208e-17
C652	VPWR	a_27_368##12	2.64444e-17
C653	Y#12	B2#1	1.33e-18
C654	A3#7	VNB	4.28905e-17
C655	VPWR	a_27_368##11	2.79197e-17
C656	VPWR#14	B2#7	4.4526e-18
C657	A3#2	VNB	3.83538e-17
C658	VPWR	a_27_368##10	2.90295e-17
C659	VGND#10	B1#9	2.1979e-18
C660	A2#6	VNB	2.82643e-17
C661	A2#5	VNB	2.9699e-17
C662	A2#2	VNB	3.64474e-17
C663	VPWR	a_27_368##7	2.01711e-17
C664	A1#6	VNB	3.57084e-17
C665	VPWR	a_27_368##6	1.96775e-17
C666	A1#4	VNB	2.99495e-17
C667	VPWR#14	B2#9	4.46413e-18
C668	A1#2	VNB	2.9943e-17
C669	a_27_368##13	a_27_368##20	3.84991e-18
C670	B1#8	VNB	2.78864e-17
C671	B1#7	VNB	9.68631e-17
C672	Y#2	Y#1	4.60178e-18
C673	a_27_74##3	B2	9.55308e-18
C674	VPWR#14	B2#11	4.46413e-18
C675	a_27_74##3	B2#1	4.10028e-17
C676	B2#5	VNB	4.18497e-17
C677	B2#3	VNB	2.30515e-17
C678	B2#2	VNB	2.48578e-17
C679	a_27_74##8	B1#9	1.18987e-19
C680	B1#5	A1#7	5.87744e-19
C681	a_27_368##8	A1#6	7.18964e-20
C682	A3#4	A2#2	5.72512e-19
C683	a_27_368##7	A1#7	1.087e-18
C684	VGND#5	a_27_74##8	5.19931e-18
C685	a_27_74##6	B2	5.33716e-17
C686	VPWR#14	B2#12	4.46413e-18
C687	B1#5	B1#1	2.6188e-18
C688	Y#3	a_27_368##18	5.73572e-17
C689	VPWR	Y#4	1.15264e-17
C690	Y	a_868_74##2	5.20164e-17
C691	a_1313_74#	A3#2	1.82321e-18
C692	VPWR	Y#3	1.20945e-17
C693	Y	Y#8	1.1413e-18
C694	B1#5	B1#11	2.11916e-18
C695	B2#1	VGND#10	1.74112e-17
C696	a_27_368##13	Y#5	8.93396e-17
C697	VPWR	Y#2	1.77722e-17
C698	Y	a_868_74#	6.338e-17
C699	VGND#8	A3#7	7.89376e-19
C700	VPWR#8	A2#5	3.41186e-21
C701	Y#10	Y	3.02494e-18
C702	B1#5	B1#13	2.0805e-18
C703	VGND	VGND#5	9.89115e-17
C704	a_27_368##11	B2#2	8.46999e-20
C705	B1#5	B1#15	2.11197e-18
C706	a_27_74##3	B2#8	1.1883e-18
C707	a_27_74##3	Y#12	5.58143e-17
C708	a_27_74##8	B2#1	2.85419e-19
C709	A3#11	A3#7	3.90592e-18
C710	Y#2	a_27_368##18	5.67786e-17
C711	Y#10	B1#7	7.23119e-18
C712	VPWR#3	A3#4	5.42326e-18
C713	A3	A3#5	2.9884e-18
C714	VPWR	Y#6	6.36535e-18
C715	VGND#3	A3#4	5.4506e-18
C716	VGND#10	B2#8	3.32369e-17
C717	a_1313_74##2	a_27_368##3	4.97543e-18
C718	A3	A3#9	7.34923e-20
C719	a_27_368##7	B1#1	1.94989e-19
C720	Y#3	Y#13	4.3383e-18
C721	B2	Y#5	5.93974e-17
C722	VGND#3	A2#3	7.44442e-20
C723	B2	a_27_368##13	3.74507e-17
C724	VGND	a_27_74##5	3.99398e-18
C725	a_27_74##3	B2#10	1.55067e-19
C726	VGND	a_27_74##2	2.84613e-17
C727	B2#8	a_27_74##8	1.3823e-17
C728	VPWR#12	VNB	3.86155e-17
C729	VPWR#10	VNB	3.09491e-17
C730	Y#4	a_27_368##19	5.96858e-17
C731	VPWR#8	VNB	3.0998e-17
C732	A2#5	A2#3	4.0274e-18
C733	A2	A3#13	3.94815e-19
C734	VPWR#6	VNB	2.98592e-17
C735	A2	A3#14	4.74662e-18
C736	VGND#5	VNB	4.1139e-17
C737	VGND#2	VNB	3.00326e-17
C738	a_27_368##10	B1#11	2.11859e-17
C739	A2	A2#1	3.03869e-18
C740	VGND#4	A1#5	9.00376e-20
C741	a_27_368##12	VNB	4.08016e-18
C742	a_27_368##11	VNB	5.33184e-18
C743	VGND	a_1313_74##5	2.50132e-18
C744	a_27_368##10	VNB	5.61685e-18
C745	A2	A2#10	2.05474e-18
C746	VGND#10	B2#10	1.43011e-18
C747	VGND	a_868_74##4	2.40799e-17
C748	a_27_368##7	VNB	2.08637e-18
C749	VPWR	VPWR#9	3.23078e-18
C750	VGND	Y#6	1.02767e-17
C751	a_27_368##6	VNB	2.15691e-18
C752	A2#3	A2#2	3.20043e-18
C753	VGND#11	B2#8	1.70046e-18
C754	VGND	a_868_74##2	2.26121e-17
C755	A2	A2#11	2.17304e-18
C756	VPWR	VPWR#11	1.72365e-17
C757	VGND	a_868_74#	2.25325e-17
C758	VPWR#14	B2#4	3.83069e-20
C759	A2	A2#13	1.25579e-18
C760	VGND	a_27_74#	2.08132e-17
C761	VPWR	VPWR#13	1.75911e-17
C762	a_1313_74##2	VNB	3.97774e-18
C763	VGND	Y#10	1.01713e-17
C764	VPWR	a_27_368##8	2.63158e-17
C765	A2	A1#8	2.46591e-19
C766	a_1313_74##2	A3#1	9.86477e-20
C767	VGND	Y#12	9.87022e-18
C768	VGND	a_27_74##3	1.83005e-17
C769	Y#3	a_27_368##19	5.76308e-17
C770	VGND	a_27_74##8	1.18512e-17
C771	B2#10	a_27_74##8	1.73046e-17
C772	a_27_74##3	VGND#10	4.28559e-17
C773	VGND	a_27_74##6	1.82067e-17
C774	A1	A2#13	2.42312e-19
C775	a_27_74##6	B2#8	2.00467e-19
C776	Y	A1#9	1.18787e-17
C777	a_27_74##5	VNB	1.79819e-18
C778	VPWR	Y#5	9.59701e-18
C779	Y	A1#11	2.8037e-17
C780	A1	A1#8	1.24397e-18
C781	VPWR	a_27_368##13	2.64311e-17
C782	a_27_74##2	VNB	5.83059e-18
C783	VGND#9	A3#11	1.08489e-18
C784	Y	A1#13	2.20442e-17
C785	VGND#1	VNB	6.89412e-17
C786	A1	A1#10	2.10572e-18
C787	a_1313_74#	VNB	4.59061e-18
C788	Y	B1#10	2.24182e-19
C789	VGND#8	VNB	4.67461e-20
C790	a_1313_74##6	VNB	4.55126e-18
C791	A1	A1#12	2.11118e-18
C792	A3#6	A3#1	4.13783e-17
C793	Y#4	Y#14	7.55555e-19
C794	VGND#9	VNB	5.99931e-18
C795	a_868_74##8	VNB	7.94449e-18
C796	a_1313_74##3	VNB	4.33438e-18
C797	A1	A1#7	2.08704e-18
C798	a_868_74##6	VNB	3.67144e-18
C799	VGND#11	B2#10	3.83917e-17
C800	a_1313_74##5	VNB	6.80267e-19
C801	a_868_74##4	VNB	3.96335e-18
C802	A1	B1#1	5.55104e-19
C803	Y#6	VNB	1.18309e-17
C804	a_868_74##2	VNB	3.90636e-18
C805	a_868_74#	VNB	8.78255e-18
C806	a_27_74#	VNB	9.41482e-18
C807	Y#10	VNB	4.1743e-18
C808	a_27_368##10	B1#13	1.60053e-17
C809	Y#4	a_27_368##12	1.31878e-17
C810	Y#12	VNB	6.91929e-19
C811	a_27_74##3	VNB	3.66385e-18
C812	VGND#10	VNB	5.32235e-19
C813	VPWR#3	A3	5.94316e-18
C814	a_27_74##8	VNB	4.55126e-18
C815	VGND#11	VNB	1.46972e-18
C816	a_27_74##8	B2#6	5.74223e-19
C817	a_27_74##6	VNB	4.32966e-17
C818	Y#2	A1#10	6.74642e-18
C819	a_27_74##2	B1#8	2.22386e-19
C820	a_27_74##8	a_27_74##3	1.5138e-18
C821	a_27_368#	VNB	4.97991e-17
C822	VGND#3	A3	5.79038e-18
C823	a_27_74##6	B2#10	1.69609e-18
C824	VPWR#4	VNB	3.99451e-18
C825	a_27_368##14	VNB	2.77013e-18
C826	VPWR#5	VNB	1.08958e-18
C827	a_27_368##15	VNB	2.77013e-18
C828	VPWR#3	A2	1.25386e-17
C829	a_1313_74##2	A3#6	1.87978e-19
C830	VPWR#7	VNB	9.1913e-19
C831	a_27_368##8	B1#7	2.23941e-20
C832	a_27_368##4	VNB	2.1429e-18
C833	VPWR#9	VNB	3.66461e-18
C834	VGND	A2#7	8.98877e-19
C835	B1	B2#7	1.35673e-18
C836	VGND#3	A2	1.234e-17
C837	VPWR#11	VNB	3.68318e-18
C838	VGND	A1#1	7.97032e-19
C839	VGND	A1#9	7.87598e-19
C840	B1	B2#9	1.41049e-19
C841	VPWR#13	VNB	7.99539e-19
C842	a_27_368##8	VNB	4.21468e-18
C843	VGND	A1#11	7.93245e-19
C844	VGND	A1#13	7.84722e-19
C845	B2#6	VGND#11	1.90897e-17
C846	VGND	B1#10	1.60371e-18
C847	B2	B1#15	1.33675e-19
C848	VGND	B1#12	1.59212e-18
C849	VGND	B1#14	1.57348e-18
C850	VPWR#10	A1#4	1.0918e-21
C851	B2	B2#7	1.32969e-18
C852	A2	A3#4	3.26241e-17
C853	VGND	B1#9	1.48546e-18
C854	a_27_368##13	VNB	5.47277e-17
C855	VGND	B2#1	1.40582e-18
C856	B2	B2#9	2.06134e-18
C857	Y#4	a_27_368##20	4.59211e-17
C858	A3#1	VNB	3.15277e-17
C859	VGND	B2#8	6.36564e-19
C860	A2	A2#3	1.78995e-17
C861	A3#6	VNB	2.51937e-17
C862	VGND	B2#10	6.36564e-19
C863	B2	B2#11	2.07187e-18
C864	A3#8	VNB	2.51594e-17
C865	A3#12	VNB	2.80684e-17
C866	VGND	B2#6	7.48256e-19
C867	A3#8	A3#6	3.97303e-17
C868	VPWR	A1#8	3.84493e-20
C869	A2#8	VNB	3.95188e-17
C870	B2	B2#12	4.44321e-18
C871	A2#9	VNB	2.92219e-17
C872	VPWR	A1#10	4.05848e-20
C873	Y#12	B1#8	2.04742e-18
C874	A2#12	VNB	3.00346e-17
C875	A2#7	VNB	3.13417e-17
C876	VPWR	A1#12	4.05848e-20
C877	a_27_368##11	B1#15	2.11859e-17
C878	A1#1	VNB	3.08324e-17
C879	VPWR	A1#7	5.62758e-19
C880	A1#9	VNB	3.07143e-17
C881	a_27_74##8	VGND#10	4.16102e-17
C882	a_27_74##6	B2#6	5.12999e-17
C883	A1#11	VNB	3.05609e-17
C884	A1	A1#5	1.87731e-17
C885	VPWR	B1#1	1.44251e-18
C886	A1#13	VNB	3.34725e-17
C887	B1#10	VNB	3.46799e-17
C888	VPWR	B1#11	1.59601e-18
C889	Y#4	a_27_368##11	1.87209e-17
C890	B1#12	VNB	2.87545e-17
C891	B1#5	A1	3.54711e-17
C892	VPWR	B1#13	1.64914e-18
C893	B1#14	VNB	2.97013e-17
C894	A1#6	A1#5	3.28573e-18
C895	B1#9	VNB	2.95486e-17
C896	VPWR	B1#15	1.64924e-18
C897	B2#1	VNB	2.64384e-17
C898	a_27_74##2	B1#7	1.14862e-18
C899	B2#8	VNB	2.55586e-17
C900	VPWR	B2#7	1.64538e-18
C901	Y#2	A1#12	1.28544e-17
C902	B2#10	VNB	2.55637e-17
C903	VPWR	B2#9	1.64161e-18
C904	B2#6	VNB	3.5726e-17
C905	Y#6	A2#1	2.65185e-19
C906	VPWR	B2#11	1.64515e-18
C907	A3#5	VNB	3.87973e-17
C908	A1#5	A1#4	4.0818e-18
C909	A3#9	VNB	3.20254e-17
C910	VPWR	B2#12	2.38562e-18
C911	A3#13	VNB	2.8003e-17
C912	VGND#4	Y	1.20311e-18
C913	A3#14	VNB	3.40916e-17
C914	A2#1	VNB	2.89627e-17
C915	A2#10	VNB	2.99904e-17
C916	a_1313_74##2	A3#8	1.70735e-17
C917	A2#11	VNB	3.06377e-17
C918	B2	B2#4	2.23028e-17
C919	A2#13	VNB	3.38679e-17
C920	VPWR	VPWR#14	2.19509e-16
C921	A1#8	VNB	3.44471e-17
C922	Y	A1#5	3.35809e-18
C923	A1#10	VNB	3.17126e-17
C924	A1#12	VNB	3.00236e-17
C925	A1#7	VNB	3.13723e-17
C926	B1#1	VNB	3.37278e-17
C927	B1#11	VNB	3.2628e-17
C928	B1#13	VNB	3.24843e-17
C929	VGND	VGND#3	4.30422e-17
C930	A1#4	A1#2	3.77757e-18
C931	B1#15	VNB	3.27002e-17
C932	Y#12	B1#7	3.23464e-18
C933	B2#7	VNB	3.46096e-17
C934	VPWR	B1#5	1.22906e-17
C935	VGND	VGND#4	1.87745e-16
C936	B2#9	VNB	3.23465e-17
C937	B2#11	VNB	3.21621e-17
C938	Y#6	a_27_368##4	8.54155e-18
C939	Y#5	Y#4	3.01982e-18
C940	VGND#11	VGND#10	2.92642e-18
C941	B2#12	VNB	4.13171e-17
C942	VPWR#3	VNB	2.18575e-16
C943	VGND#3	VNB	2.87894e-16
C944	VGND	B1#5	1.13873e-17
C945	VPWR#14	VNB	1.33712e-16
C946	B2#3	B2#2	3.49852e-18
C947	VGND#4	VNB	1.07831e-16
C948	A3#4	VNB	9.10952e-18
C949	A3#12	A3#8	4.10132e-17
C950	VGND#2	A3#11	3.65427e-20
C951	A2#3	VNB	2.6723e-17
C952	A1#5	VNB	2.92203e-17
C953	B2	B1	3.29898e-17
C954	B1#5	VNB	2.02406e-17
C955	Y	A1	1.00985e-16
C956	B2#4	VNB	3.83276e-17
C957	VPWR	A1	9.31082e-18
C958	Y#6	A2#10	4.13827e-19
C959	a_27_368##11	B2#7	1.55939e-17
C960	VPWR	B1	1.97771e-18
C961	VGND	A1	7.65082e-18
C962	VPWR	B2	1.17933e-17
C963	A3	VNB	3.20121e-17
C964	VGND	B1	1.50183e-18
C965	Y#2	A1#7	1.48308e-17
C966	A2	VNB	1.81211e-17
C967	B1#7	Y#1	7.30958e-19
C968	VGND	B2	1.01584e-17
C969	A1	VNB	1.69199e-17
C970	Y#3	a_27_368##11	1.89277e-17
C971	B1	VNB	3.34007e-18
C972	VGND	Y	1.35617e-17
C973	B2	VNB	4.40854e-17
C974	Y	VNB	7.69909e-18
C975	a_27_74##5	B2#5	3.66256e-19
C976	VPWR	VNB	3.08938e-16
C977	VGND	VNB	3.14063e-16
C978	a_27_368##14	VPWR#2	8.43957e-18
C979	VPWR#2	VNB	4.81161e-17
C980	a_27_368#	VPWR#2	2.09944e-17
C981	VPWR#2	A3#7	1.95361e-20
C982	VPWR#2	A3#9	2.57874e-18
C983	VPWR#2	A3#5	2.72243e-18
C984	a_27_368##2	VPWR#2	1.6661e-19
C985	VPWR#3	VPWR#2	8.25063e-17
C986	VGND#6	a_27_74##5	2.91756e-19
C987	VGND#6	VGND#5	1.14921e-18
C988	VGND#6	B2#8	6.41281e-19
C989	VGND#6	B2#10	4.37187e-18
C990	VGND#6	B2#6	4.94812e-18
C991	VGND	VGND#6	9.94367e-17
C992	VGND#6	a_27_74##8	5.24871e-18
C993	VGND#6	VNB	4.74914e-17
C994	VGND#6	B2#4	3.85385e-20
C995	VGND#6	a_27_74##6	2.10084e-17
*
*
.ENDS sky130_fd_sc_hs__a32oi_4
*
