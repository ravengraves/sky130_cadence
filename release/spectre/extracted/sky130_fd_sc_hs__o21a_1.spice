* Extracted by Quantus, converted by sky130cad/quantus.py
*
*
*
*                       LINUX           Wed Nov 18 08:54:48 2026
*
*
*
*  PROGRAM  advgen
*
*  Name           : advgen - Quantus - (64-bit)
*  Version        : 25.1.0-p047
*  Build Date     : Thu Dec 11 23:20:30 PST 2025
*
*  HSPICE LIBRARY
*
*  OPERATING_TEMPERATURE 150
*  QRC_TECH_DIR <path>/tech
*
*
*

*
.SUBCKT sky130_fd_sc_hs__o21a_1 VNB VPB VGND VPWR X A1 B1 A2
*
*
*  caps2d version: 10
*
*
*       TRANSISTOR CARDS
*
*
XM7 X#1 a_83_244##3 VGND#7 VNB sky130_fd_pr__nfet_01v8_lvt l=0.15 w=0.74 ad=0.2109 as=0.2109 pd=2.05 ps=2.05
XM4 a_83_244##7 B1#1 a_320_74##2 VNB sky130_fd_pr__nfet_01v8_lvt l=0.15 w=0.64 ad=0.1824 as=0.1792 pd=1.85 ps=1.84
XM2 a_320_74##2 A2#1 VGND#6 VNB sky130_fd_pr__nfet_01v8_lvt l=0.15 w=0.64 ad=0.1792 as=0.1792 pd=1.84 ps=1.84
XM5 VGND#6 A1#4 a_320_74# VNB sky130_fd_pr__nfet_01v8_lvt l=0.15 w=0.64 ad=0.1792 as=0.1824 pd=1.84 ps=1.85
XM0 X#3 a_83_244##4 VPWR#5 VPB sky130_fd_pr__pfet_01v8 l=0.15 w=1.12 ad=0.3304 as=0.66965 pd=2.83 ps=3.53
XM1 VPWR#5 B1#3 a_83_244##5 VPB sky130_fd_pr__pfet_01v8 l=0.15 w=0.84 ad=0.66965 as=0.3406 pd=3.53 ps=2.71
XM3 a_83_244##5 A2#3 a_376_387# VPB sky130_fd_pr__pfet_01v8 l=0.15 w=1 ad=0.3406 as=0.42 pd=2.71 ps=2.84
XM6 a_376_387# A1#3 VPWR#1 VPB sky130_fd_pr__pfet_01v8 l=0.15 w=1 ad=0.42 as=0.295 pd=2.84 ps=2.59
*
*
*       RESISTOR AND CAP/DIODE CARDS
*
Rg1	a_83_244#	a_83_244##2	181.002838
Rg2	a_83_244##2	a_83_244##3	322.953644
Rg3	a_83_244##2	a_83_244##4	507.075531
Rg4	B1#1	B1#2	374.981812
Rg5	B1#2	B1#3	362.477081
Rg6	A2#1	A2#2	465.749756
Rg7	A2#2	A2#3	400.207520
Rg8	A1#1	A1#2	28.644930
Rg9	A1#2	A1#3	486.730408
Rg10	A1#2	A1#4	402.769623
Rf1	X	X#2	9.465101
Rf2	X#2	X	9.465101
Rf3	X	X#4	14.369054
Rf4	X#4	X	0.196836
Rf5	X#1	X#2	7.500000
Rf6	X#3	X#4	5.000000
Rf7	B1#4	B1	1.023603
Rf8	B1#2	B1#6	161.256409
Rf9	B1#4	B1#6	2.716565
Rf10	a_83_244##5	a_83_244#	105.388649
Rf11	a_83_244#	a_83_244##7	70.066681
Rf12	A2	A2#2	171.099060
Rf13	a_320_74#	a_320_74##2	109.005348
Rf14	A1	A1#1	168.106262
Rf15	VPWR#1	VPWR#2	117.399818
Rf16	VPWR#2	VPWR#3	39.586227
Rf18	VPWR#3	VPWR#5	23.554613
Rf20	VGND#2	VGND#3	53.302330
Rf21	VGND#3	VGND#4	53.302330
Rf23	VGND#2	VGND#6	34.113823
Rf24	VGND#4	VGND#7	30.944223
Re1	VPWR#2	VPWR	1.637070
Re2	VGND	VGND#3	1.637131
*
*       CAPACITOR CARDS
*
*
C1	VGND	VNB	6.41601e-17
C2	VPWR	VNB	5.52421e-17
C3	X	VNB	1.18722e-16
C4	A1	VNB	1.12283e-17
C5	B1	VNB	2.2301e-18
C6	A2	VNB	3.692e-19
C7	a_83_244#	VNB	1.24035e-17
C8	B1#2	VNB	2.51051e-17
C9	A2#2	VNB	4.08897e-17
C10	VGND	X	1.88848e-17
C11	A1#1	VNB	1.28033e-17
C12	VGND#3	VNB	1.57328e-16
C13	VPWR#2	VNB	1.65534e-16
C14	a_83_244##4	VNB	4.33102e-17
C15	VPWR	X	1.93916e-17
C16	B1#3	VNB	3.80129e-17
C17	VGND	B1	8.63826e-19
C18	A2#3	VNB	3.33295e-17
C19	A1#3	VNB	3.24598e-17
C20	VGND	A2	2.7439e-18
C21	VPWR	A1	2.12659e-18
C22	a_83_244##3	VNB	3.4822e-17
C23	B1#1	VNB	5.58189e-17
C24	A2#1	VNB	2.70936e-17
C25	A1#4	VNB	2.81936e-17
C26	VPWR	B1	9.28102e-19
C27	a_83_244##2	B1#2	1.55229e-17
C28	VPWR#5	VNB	6.57578e-19
C29	a_83_244##5	VNB	9.09888e-19
C30	VPWR	A2	5.20888e-18
C31	VPWR#1	VNB	8.2185e-17
C32	VGND#7	VNB	9.74961e-18
C33	a_83_244##7	VNB	1.04698e-17
C34	a_320_74##2	VNB	5.35605e-18
C35	VGND#6	VNB	2.5533e-18
C36	a_320_74#	VNB	4.19944e-17
C37	VGND	a_83_244#	4.38949e-18
C38	VGND	B1#2	1.9549e-18
C39	VGND	A2#2	2.32572e-18
C40	A2	A1	2.23246e-17
C41	VGND	A1#1	3.81894e-18
C42	VGND	VGND#3	1.40406e-17
C43	VPWR	a_83_244#	2.71363e-18
C44	VPWR	B1#2	1.05489e-18
C45	VPWR	A2#2	4.3216e-18
C46	X	a_83_244#	8.33079e-17
C47	X	B1#2	2.03864e-19
C48	VPWR	VPWR#2	2.25488e-17
C49	VGND	a_83_244##3	5.35775e-18
C50	VGND	B1#1	5.55126e-18
C51	VPWR	a_83_244##4	5.60317e-18
C52	VGND	A2#1	7.90329e-19
C53	VGND	A1#4	1.47496e-18
C54	VPWR	B1#3	6.89443e-18
C55	VPWR	A2#3	9.36013e-18
C56	A1	A2#2	5.32244e-19
C57	a_83_244#	B1	2.71555e-17
C58	VPWR	A1#3	4.15225e-18
C59	B1	B1#2	6.54346e-18
C60	X	a_83_244##4	3.65666e-17
C61	VGND	VGND#7	2.24931e-17
C62	X	B1#3	1.6348e-18
C63	VGND	a_83_244##7	1.42068e-17
C64	X	A2#3	1.66554e-19
C65	VGND	a_320_74##2	1.47774e-17
C66	VGND	a_320_74#	1.49844e-17
C67	A2	A2#2	8.69896e-18
C68	VPWR	a_83_244##5	1.5476e-17
C69	X	a_83_244##3	1.9429e-17
C70	A2	A1#1	8.65765e-18
C71	X	B1#1	4.5626e-19
C72	VPWR	VPWR#1	4.79024e-17
C73	a_83_244##2	VNB	4.35042e-17
C74	B1	a_83_244##4	2.72434e-19
C75	A1#2	VNB	6.83504e-17
C76	A2	VPWR#2	7.54785e-19
C77	X	X#3	5.94628e-18
C78	B1	B1#3	8.49374e-19
C79	X	VPWR#5	5.08776e-17
C80	X	a_83_244##5	1.91053e-18
C81	A2#2	a_376_387#	5.05098e-19
C82	X	X#1	1.04652e-17
C83	X	VGND#7	4.98767e-17
C84	X	a_83_244##7	2.26449e-18
C85	a_83_244#	B1#2	3.1346e-18
C86	A2#2	A1#2	3.45225e-17
C87	a_83_244#	A2#2	2.97468e-19
C88	A1	VPWR#1	3.00874e-17
C89	a_83_244#	A1#1	2.31049e-18
C90	B1#2	A2#2	4.50498e-17
C91	B1	a_83_244##5	1.45195e-17
C92	A1#1	B1#2	2.43232e-20
C93	VGND#3	B1#2	5.17034e-19
C94	A1#1	A2#2	2.15045e-18
C95	A2#3	a_376_387#	3.14025e-17
C96	a_83_244##7	B1	1.17106e-17
C97	A1#3	a_376_387#	3.18205e-17
C98	VGND#3	A2#2	3.89267e-20
C99	a_83_244#	a_83_244##4	6.60497e-18
C100	A2	VPWR#1	1.20972e-18
C101	A2#2	VPWR#2	1.31167e-18
C102	a_83_244#	B1#3	2.34248e-18
C103	a_83_244##4	B1#2	2.84394e-18
C104	a_83_244#	A2#3	3.87938e-19
C105	B1#2	B1#3	1.77554e-18
C106	a_320_74##2	A2	9.60473e-18
C107	a_83_244#	A1#3	4.67604e-19
C108	A1#1	a_83_244##2	6.68793e-19
C109	a_320_74#	A2	6.99123e-18
C110	B1#3	A2#2	1.6145e-18
C111	a_83_244#	a_83_244##3	2.32155e-18
C112	A1#1	A1#2	1.59061e-17
C113	a_83_244#	B1#1	1.21032e-18
C114	VPWR#5	a_83_244##2	1.12276e-18
C115	A2#2	A1#3	2.82283e-18
C116	VPWR#2	B1#3	1.70593e-18
C117	a_83_244#	VPWR#5	2.99881e-17
C118	B1#1	A2#2	7.32496e-18
C119	VPWR#2	A2#3	1.69968e-17
C120	a_83_244#	a_83_244##5	3.37335e-18
C121	A1#1	B1#1	4.89505e-19
C122	a_83_244##4	B1#3	1.2525e-17
C123	VGND	A1#2	8.2883e-19
C124	a_320_74#	a_376_387#	1.17318e-19
C125	B1#2	a_83_244##5	2.44871e-17
C126	a_83_244##4	A2#3	8.82986e-19
C127	VGND#3	B1#1	8.84236e-18
C128	a_83_244#	VGND#7	2.81778e-17
C129	B1#3	A2#3	3.22579e-17
C130	VPWR#2	B1#1	8.67796e-20
C131	a_83_244##7	B1#2	1.36744e-17
C132	A2#3	A1#3	3.25739e-17
C133	a_83_244##7	A2#2	7.067e-20
C134	a_320_74##2	A2#2	2.09749e-17
C135	a_83_244##5	VPWR#2	1.13397e-17
C136	a_83_244##4	X#3	1.206e-17
C137	VPWR#2	VPWR#1	3.39116e-17
C138	a_83_244##4	VPWR#5	3.44033e-17
C139	VGND#3	a_83_244##7	1.7608e-17
C140	a_83_244##5	a_83_244##4	9.3767e-19
C141	a_320_74#	A1#1	3.55085e-17
C142	VGND#3	a_320_74##2	1.20172e-17
C143	B1#3	VPWR#5	2.43586e-17
C144	a_83_244##3	B1#1	6.37425e-18
C145	a_83_244##5	B1#3	5.6395e-17
C146	VPWR#1	a_83_244##4	1.11671e-18
C147	VPWR#5	A2#3	2.63273e-19
C148	A2#3	a_83_244##5	2.50519e-17
C149	VPWR#5	A1#3	1.43425e-19
C150	VPWR#1	B1#3	3.02332e-18
C151	X	a_83_244##2	1.51507e-17
C152	B1#1	A2#1	4.11734e-17
C153	a_83_244##5	A1#3	8.14833e-18
C154	VPWR#1	A2#3	1.10913e-17
C155	A2#1	A1#4	3.64777e-17
C156	VPWR#1	A1#3	5.71255e-17
C157	VPWR#1	A1#2	5.57533e-18
C158	a_83_244##5	B1#1	3.13286e-18
C159	A1	A1#2	1.25632e-17
C160	VGND#7	a_83_244##3	4.70327e-17
C161	a_83_244##7	a_83_244##3	1.99389e-18
C162	VGND#7	B1#1	3.05271e-18
C163	a_320_74##2	a_83_244##3	1.26698e-19
C164	a_83_244##5	VPWR#5	7.10166e-17
C165	a_83_244##7	B1#1	3.84092e-17
C166	VGND#7	A2#1	4.5485e-19
C167	VGND#6	a_83_244##3	4.35952e-19
C168	a_320_74##2	B1#1	3.64589e-17
C169	a_83_244##7	A2#1	9.09287e-19
C170	B1	a_83_244##2	3.09461e-18
C171	VGND#6	B1#1	1.98379e-18
C172	VPWR#5	VPWR#1	7.75803e-19
C173	a_320_74##2	A2#1	2.92567e-17
C174	a_83_244##7	A1#4	1.70317e-19
C175	a_320_74#	B1#1	2.97688e-19
C176	a_83_244##5	VPWR#1	2.1718e-17
C177	VGND#6	A2#1	2.68481e-17
C178	a_320_74##2	A1#4	8.62722e-19
C179	a_83_244##2	VGND#7	7.10846e-18
C180	a_320_74#	A2#1	8.56418e-19
C181	VGND#6	A1#4	2.78517e-17
C182	a_320_74#	A1#4	3.19124e-17
C183	a_83_244##7	a_83_244##5	6.80111e-20
C184	A2	A1#2	8.34247e-18
C185	a_320_74##2	a_83_244##5	5.75177e-18
C186	a_83_244##7	A1#2	1.38298e-18
C187	VGND#7	a_83_244##7	3.88878e-17
C188	a_320_74#	VPWR#1	2.09552e-18
C189	VGND#7	VGND#6	1.64119e-18
C190	a_83_244##7	a_320_74##2	6.4225e-17
C191	a_320_74##2	VGND#6	5.40019e-17
C192	a_320_74##2	a_320_74#	2.34428e-18
C193	a_320_74#	VGND#6	5.39164e-17
C194	a_320_74#	A1#2	7.07103e-18
C195	a_83_244##2	B1#1	1.28862e-17
C196	a_83_244#	a_83_244##2	2.59356e-17
C197	a_83_244#	A1#2	1.62252e-19
C198	A2#1	A1#2	3.77436e-18
C199	VGND#4	a_83_244##7	6.7557e-20
C200	VPWR#3	A2#3	3.70272e-18
C201	VGND#2	A2#1	4.02463e-18
C202	X	VPWR#3	3.38176e-17
C203	a_83_244##5	VPWR#3	9.92211e-20
C204	VGND#2	a_83_244##3	6.7356e-20
C205	VGND#3	VGND#4	4.86554e-17
C206	VGND#2	a_320_74#	1.78605e-17
C207	VGND#4	VGND#2	4.14506e-19
C208	VGND#2	A1#1	5.01029e-19
C209	VPWR#3	a_83_244##4	1.52697e-17
C210	VGND#2	A1#2	3.11098e-19
C211	VGND#4	B1#1	4.58565e-19
C212	VGND#2	a_320_74##2	4.27938e-18
C213	VPWR#3	A1#3	1.47019e-18
C214	VGND#4	a_83_244#	1.22561e-18
C215	VGND#2	A1#4	4.01565e-18
C216	VGND#7	VGND#2	1.64921e-20
C217	VGND#2	B1#1	6.72751e-19
C218	VPWR#2	VPWR#3	5.54137e-17
C219	VPWR#3	VNB	5.63749e-17
C220	VPWR#3	B1#3	4.1231e-18
C221	VGND	VGND#2	5.09621e-17
C222	VGND#4	X	1.76458e-17
C223	VPWR	VPWR#3	7.20763e-17
C224	VGND#3	VGND#2	4.8615e-17
C225	VGND	VGND#4	3.22361e-17
C226	VGND#2	VNB	4.47782e-17
C227	VPWR#3	VPWR#5	3.03396e-18
C228	VGND#2	A2#2	1.68163e-20
C229	a_83_244#	VPWR#3	2.1375e-19
C230	VGND#4	VNB	4.68467e-17
C231	VPWR#3	VPWR#1	3.00245e-18
C232	VGND#4	a_83_244##3	3.30567e-18
*
*
.ENDS sky130_fd_sc_hs__o21a_1
*
