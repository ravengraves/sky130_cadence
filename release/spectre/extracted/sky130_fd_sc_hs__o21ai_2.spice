* Extracted by Quantus, converted by sky130cad/quantus.py
*
*
*
*                       LINUX           Wed Nov 18 08:55:30 2026
*
*
*
*  PROGRAM  advgen
*
*  Name           : advgen - Quantus - (64-bit)
*  Version        : 25.1.0-p047
*  Build Date     : Thu Dec 11 23:20:30 PST 2025
*
*  HSPICE LIBRARY
*
*  OPERATING_TEMPERATURE 150
*  QRC_TECH_DIR <path>/tech
*
*
*

*
.SUBCKT sky130_fd_sc_hs__o21ai_2 VNB VPB VGND VPWR Y B1 A1 A2
*
*
*  caps2d version: 10
*
*
*       TRANSISTOR CARDS
*
*
XM8 VGND#6 A1#3 a_27_74##5 VNB sky130_fd_pr__nfet_01v8_lvt l=0.15 w=0.74 ad=0.259 as=0.2109 pd=2.18 ps=2.05
XM6 a_27_74##6 A2#7 VGND#6 VNB sky130_fd_pr__nfet_01v8_lvt l=0.15 w=0.74 ad=0.2183 as=0.259 pd=2.07 ps=2.18
XM7 VGND#5 A2#6 a_27_74##6 VNB sky130_fd_pr__nfet_01v8_lvt l=0.15 w=0.74 ad=0.2479 as=0.2183 pd=2.15 ps=2.07
XM11 a_27_74##2 A1#6 VGND#5 VNB sky130_fd_pr__nfet_01v8_lvt l=0.15 w=0.74 ad=0.2405 as=0.2479 pd=2.13 ps=2.15
XM10 a_27_74##2 B1#4 Y#4 VNB sky130_fd_pr__nfet_01v8_lvt l=0.15 w=0.74 ad=0.2405 as=0.2331 pd=2.13 ps=2.11
XM3 Y#4 B1#1 a_27_74# VNB sky130_fd_pr__nfet_01v8_lvt l=0.15 w=0.74 ad=0.2331 as=0.2109 pd=2.11 ps=2.05
XM0 VPWR#4 A1#1 a_116_368##2 VPB sky130_fd_pr__pfet_01v8 l=0.15 w=1.12 ad=0.3304 as=0.336 pd=2.83 ps=2.84
XM5 a_116_368##2 A2#5 Y#3 VPB sky130_fd_pr__pfet_01v8 l=0.15 w=1.12 ad=0.336 as=0.392 pd=2.84 ps=2.94
XM9 Y#3 A2#1 a_116_368# VPB sky130_fd_pr__pfet_01v8 l=0.15 w=1.12 ad=0.392 as=0.392 pd=2.94 ps=2.94
XM1 a_116_368# A1#4 VPWR#5 VPB sky130_fd_pr__pfet_01v8 l=0.15 w=1.12 ad=0.392 as=0.336 pd=2.94 ps=2.84
XM4 VPWR#5 B1#7 Y#1 VPB sky130_fd_pr__pfet_01v8 l=0.15 w=1.12 ad=0.336 as=0.336 pd=2.84 ps=2.84
XM2 Y#1 B1#5 VPWR#1 VPB sky130_fd_pr__pfet_01v8 l=0.15 w=1.12 ad=0.336 as=0.3304 pd=2.84 ps=2.83
*
*
*       RESISTOR AND CAP/DIODE CARDS
*
Rg1	A1#1	A1#2	434.639221
Rg2	A1#2	A1#3	382.539734
Rg3	A2#1	A2#2	503.938385
Rg4	A2#2	A2#3	36.503117
Rg5	A2#3	A2#4	26.676205
Rg6	A2#4	A2#5	451.402863
Rg7	A2#2	A2#6	451.838898
Rg8	A2#4	A2#7	402.032959
Rg9	A1#4	A1#5	442.817719
Rg10	A1#5	A1#6	394.958344
Rg11	B1#1	B1#2	397.766174
Rg12	B1#2	B1#3	109.529457
Rg13	B1#3	B1#4	433.064667
Rg14	B1#2	B1#5	553.337646
Rg15	B1#2	B1#6	48.597046
Rg16	B1#3	B1#7	502.556824
Rf1	A2	A2#3	83.099030
Rf2	a_116_368#	a_116_368##2	103.285423
Rf3	A1	A1#2	288.281189
Rf4	A1	A1#5	164.048569
Rf5	Y	Y#2	0.252971
Rf6	Y#2	Y#3	108.291924
Rf7	Y#2	Y	17.702692
Rf8	Y	Y#4	80.206146
Rf9	Y#1	Y#2	5.000000
Rf10	B1#8	B1	0.882458
Rf11	B1#6	B1#10	161.115265
Rf12	B1#8	B1#10	3.543054
Rf13	a_27_74#	a_27_74##3	87.739670
Rf14	a_27_74##3	a_27_74##4	80.493027
Rf15	a_27_74##4	a_27_74##5	85.825729
Rf16	a_27_74##4	a_27_74##6	21.341251
Rf17	a_27_74##2	a_27_74##3	7.500000
Rf18	VPWR#1	VPWR#2	112.720070
Rf19	VPWR#2	VPWR#3	39.480083
Rf20	VPWR#3	VPWR#4	143.968033
Rf21	VPWR#2	VPWR#5	37.538910
Rf23	VGND#2	VGND#3	66.707092
Rf25	VGND#2	VGND#5	41.351616
Rf26	VGND#3	VGND#6	37.853714
Re1	VPWR#3	VPWR	1.403190
Re2	VGND	VGND#2	1.403242
*
*       CAPACITOR CARDS
*
*
C1	a_27_74#	Y#4	4.31546e-17
C2	VGND	VNB	6.48068e-17
C3	VPWR	VNB	5.88638e-17
C4	Y	VNB	7.59574e-18
C5	B1	VNB	7.03681e-18
C6	A1	VNB	1.88092e-18
C7	A2	VNB	3.31498e-18
C8	A1#2	VNB	7.60408e-17
C9	A2#3	VNB	3.0998e-18
C10	A1#5	VNB	3.46249e-17
C11	VPWR#3	VNB	1.87897e-16
C12	VGND	B1	2.53934e-18
C13	A1#1	VNB	4.30753e-17
C14	A2#5	VNB	3.25059e-17
C15	VPWR	Y	1.79939e-17
C16	A2#1	VNB	3.33963e-17
C17	VGND	A1	5.1891e-18
C18	A1#4	VNB	3.13016e-17
C19	a_27_74##4	A2#4	4.6675e-18
C20	B1#7	VNB	3.26346e-17
C21	B1#5	VNB	4.20825e-17
C22	A1#3	VNB	3.56054e-17
C23	A2#7	VNB	2.54713e-17
C24	A2#6	VNB	2.64675e-17
C25	VPWR	A1	7.56079e-18
C26	A1#6	VNB	2.63593e-17
C27	B1#4	VNB	3.09917e-17
C28	B1#1	VNB	3.46774e-17
C29	VPWR#4	VNB	6.8487e-17
C30	VPWR	A2	4.0366e-18
C31	a_116_368##2	VNB	3.86213e-18
C32	a_116_368#	VNB	3.38211e-18
C33	A1	Y	6.28649e-17
C34	VPWR#5	VNB	3.91088e-19
C35	VGND	A1#2	3.62166e-18
C36	VPWR#1	VNB	7.82582e-17
C37	a_27_74##5	VNB	4.66157e-17
C38	VGND	A2#3	4.30883e-18
C39	VGND#6	VNB	9.49039e-19
C40	a_27_74##6	VNB	2.25269e-18
C41	VGND#5	VNB	4.22728e-19
C42	a_27_74##2	VNB	6.9406e-18
C43	Y#4	VNB	6.08393e-18
C44	a_27_74#	VNB	3.62972e-17
C45	VPWR	A1#2	6.9146e-18
C46	B1#10	VNB	1.07077e-17
C47	a_27_74##4	VNB	5.10577e-18
C48	VPWR#2	VNB	2.85341e-17
C49	A2	A1	4.70208e-17
C50	VPWR	VPWR#3	2.1292e-17
C51	Y	A1#5	9.96819e-19
C52	VPWR	A1#1	2.053e-18
C53	VGND	A1#3	8.18924e-19
C54	A2#4	A1#5	3.44944e-17
C55	VPWR	A2#5	1.39799e-18
C56	VGND	A2#7	6.65615e-19
C57	VGND	A2#6	4.04622e-20
C58	VPWR	A2#1	1.4427e-18
C59	A1#2	A1	1.56269e-18
C60	VGND	A1#6	8.43454e-19
C61	VPWR	A1#4	1.71628e-18
C62	VGND	B1#4	1.04458e-18
C63	A2#3	A1	1.36003e-17
C64	VPWR	B1#7	5.92407e-19
C65	VGND	B1#1	1.58395e-18
C66	Y	A1#1	2.19251e-19
C67	VPWR	B1#5	4.6957e-18
C68	A1#2	A2	4.70276e-17
C69	A1	A1#5	1.91152e-17
C70	Y	A2#5	2.55637e-19
C71	Y	A2#1	6.84803e-19
C72	A1#5	B1#3	3.03894e-17
C73	Y	A1#4	1.26141e-17
C74	VPWR#2	VPWR#1	5.14699e-20
C75	A2	A1#5	1.88812e-18
C76	VGND	VPWR#1	3.21427e-18
C77	Y	B1#7	3.57085e-17
C78	VGND	a_27_74##5	1.74347e-17
C79	Y	B1#5	3.16389e-17
C80	VGND	a_27_74##6	1.32948e-17
C81	a_27_74##5	a_27_74##4	5.74436e-19
C82	VPWR	VPWR#4	3.95737e-17
C83	VGND	a_27_74##2	1.8238e-17
C84	VPWR	a_116_368##2	2.28324e-17
C85	VGND	Y#4	7.17794e-18
C86	A1	A1#1	1.07928e-19
C87	VGND	a_27_74#	2.28018e-17
C88	VPWR	Y#3	1.05525e-17
C89	VPWR	a_116_368#	2.10947e-17
C90	A1	A2#5	1.89226e-19
C91	A2#4	VNB	5.47051e-17
C92	A1	A2#1	1.62077e-17
C93	B1#2	VNB	6.27691e-17
C94	B1#3	VNB	2.11841e-17
C95	VPWR	VPWR#1	3.34142e-17
C96	A2	A1#1	8.41077e-19
C97	A1	A1#4	1.33059e-17
C98	A1#2	A2#3	1.50727e-17
C99	A2	A2#5	2.49636e-18
C100	A1	B1#7	8.01096e-18
C101	VGND	a_27_74##4	3.92535e-18
C102	Y	a_116_368##2	1.89944e-21
C103	A2	A2#1	2.20728e-18
C104	A1	B1#5	1.45685e-18
C105	Y#3	Y	1.42701e-18
C106	A2	A1#4	4.87284e-19
C107	Y	VPWR#5	6.33402e-17
C108	B1	B1#4	3.32638e-19
C109	a_27_74##4	VGND#6	1.82674e-17
C110	A2#3	A1#5	1.25458e-18
C111	Y	Y#1	6.03534e-18
C112	Y	VPWR#1	8.5749e-17
C113	VPWR	B1#10	2.84272e-18
C114	a_27_74##2	Y	1.98271e-18
C115	VPWR	VPWR#2	3.73857e-17
C116	VPWR#2	B1#2	4.32338e-20
C117	A1#2	A1#1	1.66173e-17
C118	a_27_74##4	a_27_74##6	5.84663e-19
C119	A1	Y#3	6.20096e-17
C120	VPWR#3	A1#5	1.89264e-20
C121	A1#2	A2#5	1.97571e-17
C122	A1	a_116_368#	2.80712e-18
C123	A1	VPWR#5	5.57757e-19
C124	A1#2	A2#1	1.52761e-19
C125	Y#4	B1	1.50379e-17
C126	A1#2	A1#4	8.30057e-20
C127	Y#4	B1#10	1.7212e-17
C128	a_27_74#	B1	2.83002e-17
C129	Y	VPWR#2	1.56167e-17
C130	VPWR#2	B1#3	4.38181e-20
C131	B1#3	B1#2	5.05788e-18
C132	a_27_74##4	VGND#5	2.49654e-17
C133	a_27_74##2	A1	4.21381e-17
C134	A1	Y#4	1.53683e-17
C135	A1#5	B1#7	1.51089e-18
C136	VPWR#3	A2#5	4.4526e-18
C137	a_27_74##4	a_27_74##2	5.57042e-19
C138	VPWR#3	A2#1	4.464e-18
C139	VPWR#3	A1#4	2.32309e-18
C140	a_27_74##4	A1	1.55221e-17
C141	A1#1	A2#5	4.5965e-17
C142	A1#2	VPWR#4	2.97648e-17
C143	A1#2	a_116_368##2	4.49743e-17
C144	A1#2	Y#3	1.70941e-17
C145	A2#5	A2#1	3.12973e-17
C146	A1#5	B1#4	4.22705e-19
C147	VGND	B1#2	1.46259e-18
C148	VGND	B1#3	3.75639e-19
C149	A2#1	A1#4	3.52908e-17
C150	a_27_74##5	A1#2	4.93001e-17
C151	a_27_74##2	B1#3	5.96844e-20
C152	Y#3	A1#5	4.01945e-19
C153	B1#4	B1#2	2.86002e-18
C154	A1#5	a_116_368#	6.72834e-19
C155	A1#4	B1#7	4.72086e-17
C156	VPWR#3	A2#4	4.0133e-20
C157	Y#4	A1#2	1.28167e-19
C158	Y#4	A2#4	3.48839e-19
C159	VPWR#3	VPWR#4	3.60582e-17
C160	B1#7	B1#5	4.78948e-17
C161	a_116_368##2	VPWR#3	2.92906e-17
C162	Y#4	B1#2	9.10994e-18
C163	Y#3	VPWR#3	2.92612e-19
C164	VGND#5	A1#5	6.24394e-19
C165	a_116_368#	VPWR#3	4.85296e-17
C166	a_27_74##2	A1#5	1.84896e-18
C167	A1#1	VPWR#4	3.09265e-17
C168	Y#4	A1#5	1.36338e-18
C169	Y#4	B1#3	8.48987e-18
C170	a_116_368##2	A1#1	4.71659e-17
C171	VPWR#4	A2#5	4.4454e-19
C172	VPWR#3	VPWR#1	2.43822e-17
C173	a_27_74##4	A1#2	2.38815e-18
C174	a_116_368##2	A2#5	5.62835e-17
C175	VPWR#4	A2#1	2.10102e-19
C176	A2#5	Y#3	2.47586e-17
C177	a_116_368##2	A2#1	1.19957e-18
C178	a_116_368#	A2#5	4.35441e-19
C179	A1#3	A2#7	2.48372e-17
C180	a_27_74##4	A2#3	7.08611e-17
C181	VPWR#4	A1#4	6.06766e-20
C182	Y#3	A2#1	5.06573e-17
C183	B1#2	a_27_74#	8.00672e-18
C184	a_116_368##2	A1#4	1.98955e-19
C185	a_116_368#	A2#1	3.64532e-17
C186	VPWR#4	B1#7	4.9791e-20
C187	Y	B1#2	4.17231e-18
C188	Y	B1#3	3.51015e-18
C189	Y#3	A1#4	8.19724e-18
C190	A2#7	A2#6	3.70739e-17
C191	a_27_74##4	A1#5	1.47843e-18
C192	a_27_74#	B1#3	1.64729e-19
C193	a_116_368#	A1#4	4.63384e-17
C194	Y#3	B1#7	2.07908e-19
C195	A1#4	VPWR#5	2.35167e-17
C196	a_116_368#	B1#7	9.99861e-19
C197	A2#6	A1#6	2.69792e-17
C198	Y#3	B1#5	1.23828e-19
C199	VPWR#5	B1#7	3.32285e-17
C200	B1#7	Y#1	3.63027e-18
C201	VPWR#5	B1#5	1.42121e-18
C202	A1#6	B1#4	3.32218e-17
C203	VPWR#1	B1#7	1.16752e-18
C204	B1	B1#2	9.24824e-18
C205	B1#5	Y#1	2.43681e-17
C206	a_116_368##2	A2#4	2.89241e-19
C207	B1	B1#3	1.5829e-19
C208	VPWR#1	B1#5	3.22357e-17
C209	B1#4	B1#1	3.23668e-17
C210	VPWR#3	VPWR#2	3.65729e-17
C211	a_27_74##5	A1#3	4.86366e-17
C212	A1	A2#4	6.21399e-18
C213	A1	B1#2	2.51689e-19
C214	A1#3	VGND#6	1.82291e-17
C215	A2#4	Y#3	2.19218e-18
C216	A1	B1#3	8.42896e-18
C217	VPWR#2	A1#1	6.21125e-20
C218	a_27_74##5	A2#7	1.775e-18
C219	VPWR#4	a_116_368##2	7.89446e-17
C220	a_27_74##6	A1#3	6.52415e-19
C221	VGND#6	A2#7	3.71462e-17
C222	a_27_74##5	A2#6	2.20067e-19
C223	VPWR#2	A2#5	1.68639e-19
C224	A2#7	a_27_74##6	1.16061e-17
C225	VGND#6	A2#6	1.39356e-18
C226	a_116_368##2	Y#3	5.83011e-17
C227	VGND#5	A2#7	4.32002e-19
C228	Y#4	A1#3	1.08616e-19
C229	a_27_74##6	A2#6	3.73444e-17
C230	a_116_368##2	a_116_368#	2.59148e-18
C231	VPWR#2	A2#1	4.37913e-19
C232	VGND#6	A1#6	1.23019e-19
C233	A2	A2#4	1.47282e-17
C234	A2#6	VGND#5	1.64527e-17
C235	a_116_368#	A2#4	8.46999e-20
C236	Y#4	A2#7	1.11834e-19
C237	a_27_74##6	A1#6	1.13058e-18
C238	a_116_368#	Y#3	6.52265e-17
C239	a_27_74##2	A2#6	4.32233e-19
C240	VPWR#2	A1#4	4.41397e-18
C241	VGND#5	A1#6	3.4327e-17
C242	a_27_74##6	B1#4	1.63848e-19
C243	Y#4	A2#6	1.83793e-19
C244	a_27_74##2	A1#6	2.61186e-17
C245	a_27_74##5	VPWR#4	3.33835e-18
C246	a_116_368#	VPWR#5	3.26391e-17
C247	VGND#5	B1#4	1.34327e-18
C248	VPWR#2	B1#7	4.44267e-18
C249	Y#4	A1#6	1.24012e-18
C250	a_27_74##2	B1#4	4.82628e-17
C251	VGND#5	B1#1	3.75352e-19
C252	a_27_74#	A1#6	2.57094e-19
C253	B1#4	Y#4	2.57895e-17
C254	VPWR#2	B1#5	3.94124e-18
C255	a_27_74##2	B1#1	1.76184e-18
C256	a_27_74#	B1#4	1.71326e-18
C257	B1#1	Y#4	2.00968e-17
C258	VPWR#5	VPWR#1	2.16574e-18
C259	a_27_74#	B1#1	4.84882e-17
C260	a_27_74##4	A1#3	1.7522e-19
C261	a_27_74##4	A2#7	1.78014e-17
C262	a_27_74##4	A2#6	2.09791e-17
C263	a_27_74##5	VGND#6	5.67931e-17
C264	a_27_74##4	A1#6	1.14786e-19
C265	a_27_74##5	a_27_74##6	2.13886e-18
C266	B1#10	B1#2	1.53129e-17
C267	a_27_74##4	B1#4	4.40049e-20
C268	VGND#6	a_27_74##6	4.14899e-17
C269	VPWR#1	B1#2	7.38698e-18
C270	VGND#6	VGND#5	1.61434e-18
C271	a_27_74#	VPWR#1	3.09931e-19
C272	a_27_74##6	VGND#5	4.36725e-17
C273	a_27_74##6	a_27_74##2	2.07409e-18
C274	A1#2	A2#4	3.15154e-17
C275	a_27_74##2	VGND#5	4.86426e-17
C276	Y#3	VPWR#2	2.4245e-19
C277	a_27_74##2	Y#4	5.34091e-17
C278	A2#3	A2#4	1.70215e-17
C279	VGND#6	A2#4	4.56584e-19
C280	a_116_368#	VPWR#2	2.17818e-18
C281	a_27_74##2	a_27_74#	3.41585e-18
C282	B1#10	VPWR#1	2.42013e-17
C283	VGND#3	A2#6	9.96055e-19
C284	VGND#2	A2#6	5.27774e-18
C285	VGND#3	A1#6	1.81326e-19
C286	VGND#3	VNB	4.77532e-17
C287	VGND#3	A2#4	5.21403e-20
C288	VGND	VGND#3	5.21627e-17
C289	VGND#2	B1#4	6.2534e-18
C290	VGND#2	VNB	2.2874e-16
C291	VGND#2	a_27_74##4	2.25448e-19
C292	VGND#2	B1#2	3.36475e-19
C293	VGND	VGND#2	7.28334e-17
C294	VGND#3	a_27_74##5	2.10084e-17
C295	VGND#2	A2#7	8.26868e-19
C296	VGND#3	A1#2	7.669e-20
C297	VGND#3	a_27_74##6	6.9777e-18
C298	VGND#2	VGND#3	5.52959e-17
C299	VGND#2	A1#6	5.14031e-18
C300	VGND#2	a_27_74##6	6.81422e-18
C301	VGND#2	B1#1	5.89815e-18
C302	VGND#2	A2#4	2.67502e-20
C303	VGND#2	a_27_74##2	2.39803e-17
C304	VGND#2	A1#5	4.45515e-20
C305	VGND#3	a_27_74##4	2.91756e-19
C306	VGND#3	A1#3	5.88231e-18
C307	VGND#2	B1#3	3.85316e-20
C308	VGND#3	A2#7	5.40065e-18
C309	VGND#2	a_27_74#	3.50729e-17
*
*
.ENDS sky130_fd_sc_hs__o21ai_2
*
