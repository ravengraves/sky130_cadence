* Extracted by Quantus, converted by sky130cad/quantus.py
*
*
*
*                       LINUX           Wed Nov 18 08:52:10 2026
*
*
*
*  PROGRAM  advgen
*
*  Name           : advgen - Quantus - (64-bit)
*  Version        : 25.1.0-p047
*  Build Date     : Thu Dec 11 23:20:30 PST 2025
*
*  HSPICE LIBRARY
*
*  OPERATING_TEMPERATURE 150
*  QRC_TECH_DIR <path>/tech
*
*
*

*
.SUBCKT sky130_fd_sc_hs__nor4bb_1 VNB VPB VGND VPWR Y C_N A B D_N
*
*
*  caps2d version: 10
*
*
*       TRANSISTOR CARDS
*
*
XM11 a_27_112##7 C_N#1 VGND#8 VNB sky130_fd_pr__nfet_01v8_lvt l=0.15 w=0.55 ad=0.3025 as=0.3342 pd=2.2 ps=2.45
XM7 VGND#8 A#3 Y#3 VNB sky130_fd_pr__nfet_01v8_lvt l=0.15 w=0.74 ad=0.3342 as=0.259 pd=2.45 ps=2.18
XM4 Y#3 B#3 VGND#7 VNB sky130_fd_pr__nfet_01v8_lvt l=0.15 w=0.74 ad=0.259 as=0.5143 pd=2.18 ps=2.87
XM9 VGND#7 a_27_112# Y#4 VNB sky130_fd_pr__nfet_01v8_lvt l=0.15 w=0.74 ad=0.5143 as=0.259 pd=2.87 ps=2.18
XM8 Y#4 a_611_244# VGND#6 VNB sky130_fd_pr__nfet_01v8_lvt l=0.15 w=0.74 ad=0.259 as=0.66285 pd=2.18 ps=3.31
XM6 VGND#6 D_N#1 a_611_244##8 VNB sky130_fd_pr__nfet_01v8_lvt l=0.15 w=0.55 ad=0.66285 as=0.15675 pd=3.31 ps=1.67
XM0 a_27_112##6 C_N#4 VPWR#7 VPB sky130_fd_pr__pfet_01v8 l=0.15 w=0.84 ad=0.2478 as=1.02135 pd=2.27 ps=4.25
XM2 VPWR#7 A#1 a_313_368# VPB sky130_fd_pr__pfet_01v8 l=0.15 w=1.12 ad=1.02135 as=0.3024 pd=4.25 ps=2.78
XM3 a_313_368# B#1 a_397_368# VPB sky130_fd_pr__pfet_01v8 l=0.15 w=1.12 ad=0.3024 as=0.5768 pd=2.78 ps=3.27
XM10 a_397_368# a_27_112##3 a_530_368# VPB sky130_fd_pr__pfet_01v8 l=0.15 w=1.12 ad=0.5768 as=0.4704 pd=3.27 ps=3.08
XM1 a_530_368# a_611_244##3 Y#1 VPB sky130_fd_pr__pfet_01v8 l=0.15 w=1.12 ad=0.4704 as=0.3304 pd=3.08 ps=2.83
XM5 VPWR#6 D_N#3 a_611_244##5 VPB sky130_fd_pr__pfet_01v8 l=0.15 w=0.84 ad=0.231 as=0.2478 pd=2.23 ps=2.27
*
*
*       RESISTOR AND CAP/DIODE CARDS
*
Rg1	C_N#1	C_N#2	284.102539
Rg2	C_N#2	C_N#3	42.891197
Rg3	C_N#2	C_N#4	372.187988
Rg4	A#1	A#2	461.929169
Rg5	A#2	A#3	406.958313
Rg6	B#1	B#2	426.276154
Rg7	B#2	B#3	374.176666
Rg8	a_27_112#	a_27_112##2	382.539734
Rg9	a_27_112##2	a_27_112##3	434.639221
Rg10	a_611_244#	a_611_244##2	330.519348
Rg11	a_611_244##2	a_611_244##3	510.253723
Rg12	a_611_244##3	a_611_244##4	1613.974487
Rg13	a_611_244##4	a_611_244##2	29.373684
Rg14	D_N#1	D_N#2	381.729645
Rg15	D_N#2	D_N#3	429.906006
Rf1	C_N	C_N#3	163.775864
Rf2	A	A#2	166.137894
Rf3	B#2	B#5	161.455215
Rf4	B#6	B	1.222411
Rf5	B#5	B#6	5.435189
Rf6	Y#1	Y#2	162.155777
Rf7	Y#2	Y#3	16.341667
Rf8	Y#2	Y#5	98.899437
Rf9	Y#5	Y	5.052970
Rf10	Y#4	Y#5	7.500000
Rf11	a_27_112##2	a_27_112##5	520.714783
Rf12	a_27_112##5	a_27_112##6	13.983870
Rf13	a_27_112##5	a_27_112##7	84.665810
Rf14	D_N#4	D_N	0.860229
Rf15	D_N#2	D_N#6	161.093033
Rf16	D_N#4	D_N#6	3.936727
Rf17	a_611_244##5	a_611_244##6	95.903923
Rf18	a_611_244##6	a_611_244##4	142.799805
Rf19	a_611_244##6	a_611_244##8	28.987461
Rf21	VPWR#2	VPWR#3	122.417328
Rf22	VPWR#3	VPWR#4	102.498848
Rf24	VPWR#2	VPWR#6	48.166538
Rf25	VPWR#4	VPWR#7	12.498192
Rf27	VGND#2	VGND#3	103.782921
Rf28	VGND#3	VGND#4	97.534401
Rf30	VGND#2	VGND#6	13.826286
Rf31	VGND#3	VGND#7	16.767223
Rf32	VGND#4	VGND#8	33.306259
Re1	VPWR#3	VPWR	0.982218
Re2	VGND	VGND#3	0.982254
*
*       CAPACITOR CARDS
*
*
C1	a_611_244##2	VGND#6	1.23175e-18
C2	a_611_244##6	a_611_244##8	3.33609e-19
C3	Y#2	B#6	2.15547e-17
C4	a_611_244##2	D_N#2	2.73989e-17
C5	Y#2	B#5	4.55456e-17
C6	a_611_244##4	a_611_244##2	3.72279e-17
C7	a_27_112##2	a_611_244##2	6.74091e-17
C8	Y#2	VGND#6	4.93006e-21
C9	a_611_244##6	a_611_244##5	2.01125e-18
C10	a_611_244##5	a_611_244##2	1.95658e-18
C11	Y#2	VGND#7	7.49653e-17
C12	Y#2	Y#3	3.81658e-18
C13	VPWR#6	a_611_244##2	2.6114e-18
C14	VGND#8	Y#2	6.9543e-17
C15	a_27_112##7	Y#2	2.88741e-18
C16	Y#1	a_611_244##2	5.80931e-18
C17	Y#2	Y#1	1.05096e-18
C18	B#6	Y#1	1.96736e-17
C19	a_611_244##6	D_N#1	2.43243e-17
C20	a_611_244##6	a_611_244#	2.73144e-20
C21	VGND#8	VGND#7	1.80205e-18
C22	Y#2	a_27_112##6	4.40774e-17
C23	a_27_112##7	VGND#8	4.79839e-17
C24	Y#2	a_611_244#	5.80675e-19
C25	Y#2	a_27_112#	1.61598e-18
C26	VPWR#6	a_611_244##5	7.48953e-17
C27	Y#2	B#3	3.27891e-17
C28	a_611_244##6	a_611_244##2	4.70162e-19
C29	a_611_244##8	D_N#1	2.34946e-17
C30	Y#2	A#3	2.89375e-17
C31	D_N#1	VGND#6	1.00942e-17
C32	a_611_244##8	a_611_244#	8.53575e-19
C33	Y#2	C_N#1	1.32289e-18
C34	a_611_244#	VGND#6	1.57097e-17
C35	a_611_244#	Y#4	1.71903e-17
C36	VGND#8	a_27_112##6	3.27576e-18
C37	VGND#7	a_611_244#	2.30894e-18
C38	a_27_112#	Y#4	5.33276e-18
C39	a_27_112##7	a_27_112##6	2.31991e-18
C40	VGND#7	a_27_112#	4.54069e-17
C41	a_611_244##2	D_N#1	2.743e-18
C42	Y#2	a_611_244##3	8.28821e-20
C43	VGND#7	B#3	4.16907e-17
C44	Y#1	a_27_112##6	8.09563e-17
C45	B#3	Y#3	3.94664e-18
C46	Y#2	a_27_112##3	4.97392e-19
C47	VGND#7	A#3	2.23308e-18
C48	B#6	a_27_112##3	9.45266e-19
C49	VGND#8	B#3	1.1851e-18
C50	A#3	Y#3	1.71992e-17
C51	Y#2	B#1	1.48078e-17
C52	a_27_112##7	B#3	5.19037e-20
C53	A#3	VGND#8	2.49631e-17
C54	B#6	B#1	1.86307e-18
C55	a_27_112##7	A#3	1.87473e-19
C56	Y#2	A#1	1.19845e-17
C57	C_N#1	VGND#8	2.5783e-17
C58	B#6	A#1	3.37474e-19
C59	a_27_112##6	VPWR#7	1.59049e-17
C60	a_27_112##7	C_N#1	3.17573e-17
C61	D_N	a_611_244##2	4.65902e-18
C62	Y#2	C_N#4	2.01824e-18
C63	a_27_112#	a_611_244##2	5.24775e-18
C64	a_611_244##6	D_N#2	5.84101e-17
C65	a_611_244##5	D_N#3	3.82953e-17
C66	a_611_244#	D_N#1	3.50216e-18
C67	D_N#3	VPWR#6	2.02966e-17
C68	a_611_244##4	a_611_244##6	2.82392e-18
C69	a_611_244##5	a_611_244##3	1.01693e-18
C70	VPWR#6	a_611_244##3	9.84861e-18
C71	a_27_112#	a_611_244#	2.71796e-17
C72	a_27_112##2	a_611_244##6	1.04158e-18
C73	Y#1	a_611_244##3	4.11352e-17
C74	VPWR#6	a_27_112##3	8.26161e-19
C75	Y#1	a_27_112##3	2.23295e-17
C76	VPWR#6	B#1	8.74041e-19
C77	B#3	a_27_112#	8.37866e-18
C78	Y#2	a_611_244##4	3.00183e-18
C79	Y#1	B#1	9.29724e-18
C80	A#3	B#3	2.89279e-17
C81	Y#2	a_27_112##2	3.78885e-18
C82	B#6	a_27_112##2	1.60901e-17
C83	VGND#3	VGND#7	5.90067e-17
C84	a_27_112##6	a_27_112##3	1.25194e-17
C85	C_N#1	A#3	1.62837e-17
C86	Y#2	B#2	9.90127e-18
C87	B#5	a_27_112##2	1.94441e-17
C88	B#6	B#2	7.35243e-18
C89	a_611_244##4	VGND#6	5.09505e-18
C90	a_27_112##6	B#1	2.30149e-17
C91	A#1	VPWR#7	9.34006e-18
C92	a_611_244##4	Y#4	5.65177e-19
C93	B#5	B#2	1.14549e-17
C94	Y#2	A#2	1.11575e-17
C95	a_27_112##6	A#1	4.06429e-17
C96	B#6	A#2	8.28846e-19
C97	C_N#4	VPWR#7	2.85562e-17
C98	a_27_112##6	C_N#4	5.90728e-17
C99	a_611_244##5	D_N#2	3.61177e-18
C100	B#5	A#2	1.31353e-18
C101	Y#2	C_N#3	6.52608e-19
C102	VGND#7	a_27_112##2	8.35885e-19
C103	D_N#2	VPWR#6	1.24541e-17
C104	VGND#7	B#2	1.42643e-18
C105	Y#2	a_611_244##2	4.04012e-19
C106	a_27_112##6	VPWR#3	2.04447e-17
C107	Y	a_611_244##2	3.7699e-18
C108	a_611_244##3	D_N#3	1.33494e-17
C109	a_27_112##2	a_611_244##5	5.12083e-18
C110	a_27_112##2	VPWR#6	6.56166e-17
C111	a_27_112##7	B#2	9.56974e-20
C112	a_27_112##2	Y#1	1.66222e-16
C113	a_27_112##3	a_611_244##3	3.39504e-17
C114	VGND#8	A#2	4.58391e-18
C115	a_27_112##7	A#2	1.27677e-18
C116	Y#1	B#2	3.12736e-18
C117	B#1	a_27_112##3	2.26762e-17
C118	a_27_112##7	C_N#3	2.20781e-17
C119	a_27_112##6	a_27_112##2	1.26427e-18
C120	a_611_244##4	a_611_244#	2.98419e-18
C121	Y#2	a_313_368#	6.8271e-18
C122	a_611_244##4	a_27_112#	1.78885e-18
C123	A#1	B#1	5.70082e-17
C124	a_27_112##6	B#2	5.94617e-19
C125	a_611_244##4	B#3	6.22929e-19
C126	A#2	VPWR#7	1.08243e-18
C127	VPWR#3	a_611_244##3	5.90429e-18
C128	a_611_244##4	A#3	4.43296e-19
C129	a_611_244##2	D_N#3	1.28652e-17
C130	a_27_112##6	A#2	3.66872e-18
C131	C_N#4	A#1	5.97265e-18
C132	VPWR#3	a_27_112##3	7.23251e-18
C133	VPWR#3	B#1	7.24475e-18
C134	a_27_112##6	C_N#3	1.64128e-17
C135	a_611_244##6	D_N	6.11457e-18
C136	Y#1	a_530_368#	1.51535e-18
C137	VPWR#6	a_397_368#	7.96155e-20
C138	a_611_244##4	a_611_244##3	1.66095e-19
C139	VGND	a_611_244##2	5.66354e-19
C140	a_27_112##2	D_N#3	3.04181e-18
C141	Y#1	a_397_368#	8.1414e-18
C142	a_27_112##2	a_611_244##3	6.94047e-17
C143	a_27_112##6	a_530_368#	4.00793e-18
C144	a_27_112##2	a_27_112##3	5.72852e-18
C145	C_N#3	A#3	5.37586e-19
C146	a_27_112##2	B#1	2.02858e-18
C147	a_611_244##2	a_611_244##3	2.72723e-17
C148	a_27_112##6	a_397_368#	7.31178e-18
C149	a_27_112##2	A#1	5.08342e-19
C150	a_27_112##6	a_313_368#	2.60614e-18
C151	a_27_112##2	VPWR#3	4.87112e-18
C152	A	Y#2	7.54384e-17
C153	C_N#4	A#2	2.69111e-19
C154	a_611_244##4	D_N#2	4.89639e-18
C155	VPWR#3	B#2	7.40255e-20
C156	D_N	VPWR#6	1.00578e-17
C157	a_611_244##3	a_530_368#	2.68724e-17
C158	a_27_112##2	D_N#2	4.51301e-18
C159	a_27_112##3	a_530_368#	2.68724e-17
C160	a_27_112##2	a_611_244##4	7.90635e-17
C161	a_27_112##3	a_397_368#	3.02078e-17
C162	a_611_244##4	B#2	2.17526e-19
C163	Y	a_611_244##6	1.72734e-18
C164	B#1	a_397_368#	2.96391e-17
C165	VGND#8	A	2.3918e-17
C166	B#2	a_27_112##2	2.76019e-17
C167	a_611_244##4	A#2	8.61102e-20
C168	a_27_112##7	A	4.37604e-18
C169	B#1	a_313_368#	1.37285e-17
C170	Y#2	Y	1.96599e-18
C171	A#1	a_313_368#	1.68151e-17
C172	A#2	B#2	2.8712e-17
C173	a_27_112##7	C_N	5.12713e-17
C174	A	VPWR#7	8.40637e-18
C175	Y	a_611_244##8	2.42604e-18
C176	a_27_112##6	A	5.90972e-17
C177	a_611_244##2	VNB	8.27123e-17
C178	Y	Y#4	5.62784e-18
C179	C_N#3	A#2	2.67918e-17
C180	Y	VGND#7	7.45874e-17
C181	a_27_112##2	a_530_368#	1.44285e-18
C182	VPWR	Y#2	4.91698e-18
C183	VPWR	B#6	3.41867e-18
C184	C_N	a_27_112##6	3.38382e-17
C185	B#2	a_397_368#	8.70851e-19
C186	VGND	a_611_244##6	1.16944e-18
C187	Y	Y#1	2.36893e-18
C188	VGND	Y#2	1.9315e-17
C189	C_N	C_N#1	1.33464e-18
C190	VPWR	a_611_244##5	1.69413e-17
C191	Y	D_N#1	2.75061e-18
C192	VGND	B#5	3.50072e-18
C193	A	B#1	5.91948e-19
C194	Y	a_611_244#	3.38616e-17
C195	VPWR	Y#1	1.22197e-17
C196	D_N	D_N#2	6.06747e-18
C197	Y	a_27_112#	3.16191e-17
C198	A	A#1	7.88237e-18
C199	VGND	a_611_244##8	1.43922e-17
C200	Y	B#3	5.93104e-19
C201	a_611_244##4	D_N	1.78092e-17
C202	A	C_N#4	4.40051e-18
C203	Y	A#3	1.82344e-19
C204	VGND	VGND#7	7.10633e-17
C205	a_27_112##2	D_N	1.85531e-17
C206	VPWR	a_27_112##6	5.75215e-17
C207	VGND	VGND#8	2.09221e-17
C208	VGND	a_27_112##7	1.95635e-17
C209	VGND	a_27_112##6	3.18873e-18
C210	VPWR	D_N#3	2.85011e-18
C211	VGND	D_N#1	7.71343e-18
C212	VPWR	a_611_244##3	1.09512e-17
C213	VGND	a_611_244#	2.53537e-19
C214	VPWR	a_27_112##3	1.5892e-18
C215	VGND	a_27_112#	4.82684e-19
C216	A	A#2	2.53793e-17
C217	VGND	B#3	4.56403e-19
C218	VPWR	B#1	8.85074e-19
C219	VGND	A#3	2.27913e-18
C220	A	C_N#3	5.08496e-18
C221	VPWR	A#1	4.57387e-19
C222	a_611_244##6	VNB	3.58057e-17
C223	VGND	C_N#1	8.64266e-18
C224	VPWR	C_N#4	4.92479e-18
C225	Y	a_611_244##4	2.93376e-17
C226	VPWR	VPWR#3	4.09125e-17
C227	Y	a_27_112##2	3.06501e-17
C228	C_N	C_N#3	2.39922e-17
C229	Y#2	VNB	7.34413e-18
C230	B#6	VNB	2.61903e-18
C231	B#5	VNB	3.86626e-18
C232	VPWR	D_N#2	2.21296e-18
C233	a_611_244##8	VNB	2.56835e-17
C234	VPWR	a_611_244##4	3.21352e-18
C235	VGND#7	VNB	4.69037e-17
C236	VPWR	a_27_112##2	2.51866e-17
C237	VGND#8	VNB	1.88407e-17
C238	a_27_112##7	VNB	2.32332e-17
C239	a_611_244##5	VNB	5.37006e-17
C240	VPWR#6	VNB	6.65767e-18
C241	VGND	D_N#2	1.4396e-18
C242	VPWR	C_N#3	1.00712e-18
C243	VGND	a_611_244##4	7.43511e-18
C244	VGND	a_27_112##2	6.24005e-18
C245	a_27_112##6	VNB	5.63778e-17
C246	D_N#1	VNB	3.63464e-17
C247	a_611_244#	VNB	3.10861e-17
C248	a_27_112#	VNB	2.48914e-17
C249	B#3	VNB	2.61461e-17
C250	A#3	VNB	3.3612e-17
C251	VGND	C_N#3	8.40193e-19
C252	C_N#1	VNB	4.51194e-17
C253	D_N#3	VNB	3.84923e-17
C254	a_611_244##3	VNB	9.52078e-17
C255	a_27_112##3	VNB	3.30574e-17
C256	B#1	VNB	3.29761e-17
C257	A#1	VNB	4.02648e-17
C258	C_N#4	VNB	4.4772e-17
C259	VPWR	D_N	1.39439e-18
C260	VPWR#3	VNB	2.47297e-16
C261	VGND#3	VNB	2.0064e-16
C262	D_N#2	VNB	6.67963e-17
C263	a_611_244##4	VNB	5.57754e-18
C264	a_27_112##2	VNB	3.58198e-17
C265	VGND	D_N	1.2408e-18
C266	VPWR	A	5.57131e-18
C267	B#2	VNB	3.11022e-17
C268	A#2	VNB	4.52089e-17
C269	VPWR	C_N	3.48574e-18
C270	C_N#3	VNB	7.38116e-17
C271	VGND	A	4.46797e-18
C272	VGND	C_N	4.18724e-18
C273	VGND	Y	2.0229e-17
C274	D_N	VNB	3.90391e-18
C275	A	VNB	5.42419e-18
C276	C_N	VNB	2.31681e-17
C277	Y	VNB	2.57652e-18
C278	VPWR	VNB	6.01881e-17
C279	VGND	VNB	6.57963e-17
C280	VGND#2	a_611_244##8	4.68846e-17
C281	VGND#4	C_N#3	1.51581e-18
C282	D_N#2	VPWR#2	5.39717e-19
C283	VGND#2	D_N#1	1.837e-17
C284	VPWR#4	a_530_368#	3.32541e-19
C285	VPWR#4	A#2	6.41445e-19
C286	VGND#3	VGND#2	7.55922e-17
C287	VGND#4	A#3	4.85274e-18
C288	VGND#2	a_611_244##6	1.14025e-17
C289	VPWR#3	VPWR#4	7.77641e-17
C290	VPWR#4	A#1	1.90814e-17
C291	VPWR#4	a_611_244##3	1.43737e-18
C292	a_27_112##6	VPWR#4	1.00084e-16
C293	VGND#2	a_27_112#	1.04202e-18
C294	VPWR#2	a_27_112##3	4.85817e-20
C295	VGND#4	A	5.9663e-19
C296	VGND#2	a_611_244##4	5.82675e-17
C297	VGND#2	Y	6.45072e-17
C298	C_N	VPWR#4	2.79683e-19
C299	a_27_112##2	VPWR#2	1.00731e-17
C300	VGND#2	a_611_244##2	9.28996e-18
C301	VGND#4	A#2	5.43791e-20
C302	VGND#4	Y#2	8.48034e-18
C303	VPWR#4	B#1	2.86091e-18
C304	VGND#4	a_27_112##7	1.32556e-17
C305	VGND#3	VGND#4	6.86325e-17
C306	VGND	VGND#2	9.75585e-17
C307	VPWR#4	VPWR#7	1.55142e-17
C308	VPWR	VPWR#2	6.46358e-17
C309	VGND#2	VGND#6	2.18159e-17
C310	VPWR#2	a_611_244##3	1.94744e-17
C311	VPWR#2	VNB	5.90253e-17
C312	VGND	VGND#4	4.56794e-17
C313	VGND#2	a_611_244#	2.28592e-17
C314	VPWR#4	VNB	8.19442e-17
C315	VPWR	VPWR#4	7.42593e-17
C316	VPWR#3	VPWR#2	6.6773e-17
C317	VGND#4	C_N#1	2.75392e-18
C318	VGND#2	D_N#2	1.63405e-18
C319	VPWR#2	a_611_244##2	4.1214e-19
C320	a_611_244##5	VPWR#2	2.08566e-17
C321	VGND#4	VGND#7	9.97832e-19
C322	VPWR#4	C_N#3	1.21767e-18
C323	VGND#2	VNB	7.79323e-17
C324	VGND#7	VGND#2	2.8623e-18
C325	VGND#4	VNB	6.22718e-17
C326	VPWR#4	C_N#4	3.59945e-18
C327	VPWR#4	a_27_112##3	1.54831e-18
C328	VGND#4	C_N	7.82199e-19
C329	VPWR#2	D_N#3	6.97107e-18
C330	VPWR#2	B#1	3.22223e-20
*
*
.ENDS sky130_fd_sc_hs__nor4bb_1
*
