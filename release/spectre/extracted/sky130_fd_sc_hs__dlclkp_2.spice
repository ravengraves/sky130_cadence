* Extracted by Quantus, converted by sky130cad/quantus.py
*
*
*
*                       LINUX           Wed Nov 18 08:30:24 2026
*
*
*
*  PROGRAM  advgen
*
*  Name           : advgen - Quantus - (64-bit)
*  Version        : 25.1.0-p047
*  Build Date     : Thu Dec 11 23:20:30 PST 2025
*
*  HSPICE LIBRARY
*
*  OPERATING_TEMPERATURE 150
*  QRC_TECH_DIR <path>/tech
*
*
*

*
.SUBCKT sky130_fd_sc_hs__dlclkp_2 VPB VNB VGND VPWR GCLK CLK GATE
*
*
*  caps2d version: 10
*
*
*       TRANSISTOR CARDS
*
*
XM19 a_27_74##8 a_83_244##3 VGND#11 VNB sky130_fd_pr__nfet_01v8_lvt l=0.15 w=0.74 ad=0.2109 as=0.4186 pd=2.05 ps=2.71
XM18 VGND#11 GATE#1 a_267_74# VNB sky130_fd_pr__nfet_01v8_lvt l=0.15 w=0.64 ad=0.4186 as=0.1536 pd=2.71 ps=1.76
XM14 a_267_74# a_315_48##2 a_83_244##4 VNB sky130_fd_pr__nfet_01v8_lvt l=0.15 w=0.64 ad=0.1536 as=0.3049 pd=1.76 ps=2.47
XM9 a_83_244##4 a_315_338# a_494_118# VNB sky130_fd_pr__nfet_01v8_lvt l=0.15 w=0.42 ad=0.3049 as=0.154875 pd=2.47 ps=1.7
XM5 a_494_118# a_27_74##4 VGND#10 VNB sky130_fd_pr__nfet_01v8_lvt l=0.15 w=0.42 ad=0.154875 as=0.3467 pd=1.7 ps=2.75
XM15 VGND#10 a_315_48##8 a_315_338##7 VNB sky130_fd_pr__nfet_01v8_lvt l=0.15 w=0.74 ad=0.3467 as=0.2109 pd=2.75 ps=2.05
XM11 a_315_48##13 CLK#7 VGND#7 VNB sky130_fd_pr__nfet_01v8_lvt l=0.15 w=0.74 ad=0.2109 as=0.259 pd=2.05 ps=2.18
XM10 VGND#7 CLK#1 a_1044_119# VNB sky130_fd_pr__nfet_01v8_lvt l=0.15 w=0.74 ad=0.259 as=0.1554 pd=2.18 ps=1.9
XM2 a_1044_119# a_27_74##2 a_1041_387##9 VNB sky130_fd_pr__nfet_01v8_lvt l=0.15 w=0.74 ad=0.1554 as=0.2109 pd=1.9 ps=2.05
XM7 VGND#6 a_1041_387##6 GCLK#3 VNB sky130_fd_pr__nfet_01v8_lvt l=0.15 w=0.74 ad=0.21835 as=0.2072 pd=2.21 ps=2.04
XM17 GCLK#3 a_1041_387# VGND#1 VNB sky130_fd_pr__nfet_01v8_lvt l=0.15 w=0.74 ad=0.2072 as=0.2109 pd=2.04 ps=2.05
XM0 a_27_74##9 a_83_244# VPWR#12 VPB sky130_fd_pr__pfet_01v8 l=0.15 w=1.12 ad=0.3304 as=0.6218 pd=2.83 ps=3.42
XM12 VPWR#12 GATE#3 a_264_392# VPB sky130_fd_pr__pfet_01v8 l=0.15 w=1 ad=0.6218 as=0.27 pd=3.42 ps=2.54
XM20 a_264_392# a_315_338##3 a_83_244##6 VPB sky130_fd_pr__pfet_01v8 l=0.15 w=1 ad=0.27 as=0.4267 pd=2.54 ps=3.3
XM13 a_83_244##6 a_315_48##3 a_508_508# VPB sky130_fd_pr__pfet_01v8 l=0.15 w=0.42 ad=0.4267 as=0.1134 pd=3.3 ps=1.38
XM4 a_508_508# a_27_74##5 VPWR#11 VPB sky130_fd_pr__pfet_01v8 l=0.15 w=0.42 ad=0.1134 as=0.3465 pd=1.38 ps=2.8
XM3 VPWR#11 a_315_48##9 a_315_338##6 VPB sky130_fd_pr__pfet_01v8 l=0.15 w=0.84 ad=0.3465 as=0.2478 pd=2.8 ps=2.27
XM16 a_315_48##15 CLK#5 VPWR#10 VPB sky130_fd_pr__pfet_01v8 l=0.15 w=0.84 ad=0.2646 as=0.3406 pd=2.31 ps=2.71
XM21 VPWR#10 CLK#6 a_1041_387##11 VPB sky130_fd_pr__pfet_01v8 l=0.15 w=1 ad=0.3406 as=0.325 pd=2.71 ps=2.65
XM6 a_1041_387##11 a_27_74# VPWR#8 VPB sky130_fd_pr__pfet_01v8 l=0.15 w=1 ad=0.325 as=1.0033 pd=2.65 ps=4.18
XM8 GCLK#1 a_1041_387##7 VPWR#8 VPB sky130_fd_pr__pfet_01v8 l=0.15 w=1.12 ad=0.336 as=1.0033 pd=2.84 ps=4.18
XM1 VPWR#1 a_1041_387##5 GCLK#1 VPB sky130_fd_pr__pfet_01v8 l=0.15 w=1.12 ad=0.3304 as=0.336 pd=2.83 ps=2.84
*
*
*       RESISTOR AND CAP/DIODE CARDS
*
Rg1	a_83_244#	a_83_244##2	489.849762
Rg2	a_83_244##2	a_83_244##3	305.727875
Rg3	GATE#1	GATE#2	468.619049
Rg4	GATE#2	GATE#3	409.090576
Rg5	a_315_48#	a_315_48##2	321.579834
Rg6	a_315_48##3	a_315_48##4	394.020355
Rg7	a_315_338#	a_315_338##2	434.413513
Rg8	a_315_338##2	a_315_338##3	694.353882
Rg9	a_315_48##5	a_315_48##6	426.026062
Rg10	a_315_48##6	a_315_48##7	49.780437
Rg11	a_315_48##6	a_315_48##8	406.691284
Rg12	a_315_48##6	a_315_48##9	430.448853
Rg13	CLK#1	CLK#2	322.953644
Rg14	CLK#2	CLK#3	30.596949
Rg15	CLK#3	CLK#4	33.566738
Rg16	CLK#4	CLK#5	440.343231
Rg17	CLK#2	CLK#6	415.223511
Rg18	CLK#4	CLK#7	323.721649
Rg19	a_27_74#	a_27_74##2	831.131836
Rg20	a_27_74##2	a_27_74##3	1806.265747
Rg21	a_27_74##3	a_27_74##4	212.440369
Rg22	a_27_74##4	a_27_74##5	1016.499634
Rg23	a_1041_387#	a_1041_387##2	342.702667
Rg24	a_1041_387##2	a_1041_387##3	96.950562
Rg25	a_1041_387##3	a_1041_387##4	163.442551
Rg26	a_1041_387##2	a_1041_387##5	467.727966
Rg27	a_1041_387##3	a_1041_387##6	342.895050
Rg28	a_1041_387##3	a_1041_387##7	466.597504
Rf1	GATE#2	GATE	162.201172
Rf2	a_83_244##4	a_83_244##5	116.647057
Rf3	a_83_244##5	a_83_244##6	169.930511
Rf4	a_27_74##3	a_27_74##7	377.473175
Rf5	a_27_74##7	a_27_74##8	25.539253
Rf6	a_27_74##7	a_27_74##9	100.397408
Rf7	a_315_48##7	a_315_48##4	236.762650
Rf8	a_315_48##4	a_315_48#	240.736389
Rf9	a_315_338##2	a_315_338##5	261.772461
Rf10	a_315_338##5	a_315_338##6	87.518738
Rf11	a_315_338##5	a_315_338##7	19.895288
Rf12	a_315_48##13	a_315_48##5	49.392628
Rf13	a_315_48##5	a_315_48##15	47.046707
Rf14	CLK#3	CLK#9	80.663216
Rf15	CLK#10	CLK	0.546815
Rf16	CLK#9	CLK#10	6.015252
Rf17	a_1041_387##4	a_1041_387##10	87.845398
Rf18	a_1041_387##10	a_1041_387##11	67.952599
Rf19	a_1041_387##9	a_1041_387##10	7.500000
Rf20	GCLK	GCLK#2	0.196836
Rf21	GCLK#2	GCLK	14.369054
Rf22	GCLK	GCLK#4	3.739891
Rf23	GCLK#4	GCLK	10.825999
Rf24	GCLK#1	GCLK#2	5.000000
Rf25	GCLK#3	GCLK#4	7.500000
Rf26	VPWR#1	VPWR#2	64.473923
Rf27	VPWR#2	VPWR#3	74.637016
Rf28	VPWR#3	VPWR#4	95.431877
Rf29	VPWR#4	VPWR#5	111.925346
Rf30	VPWR#5	VPWR#6	184.144287
Rf32	VPWR#3	VPWR#9	11.601144
Rf33	VPWR#9	VPWR#8	5.000000
Rf34	VPWR#4	VPWR#10	36.258804
Rf35	VPWR#5	VPWR#11	27.696018
Rf36	VPWR#6	VPWR#12	29.166126
Rf37	VPWR#8	VPWR#9	5.000000
Rf38	VGND#1	VGND#2	61.857651
Rf39	VGND#2	VGND#3	53.302330
Rf40	VGND#3	VGND#4	112.448700
Rf41	VGND#4	VGND#5	115.943123
Rf42	VGND#3	VGND#6	35.491676
Rf43	VGND#4	VGND#7	40.589203
Rf44	VGND#5	VGND#8	193.373764
Rf46	VGND#5	VGND#10	61.093941
Rf47	VGND#8	VGND#11	31.707861
Rf49	a_83_244##2	a_83_244##5	160.232803
Re1	VPWR#2	VPWR	6.179563
Re2	VPWR	VPWR#5	0.882795
Re3	VGND#2	VGND	6.179563
Re4	VGND	VGND#5	0.882795
*
*       CAPACITOR CARDS
*
*
C1	a_315_48##13	a_315_48##8	2.55378e-18
C2	VPWR#11	a_315_338##6	5.54853e-17
C3	a_27_74#	a_1041_387##3	1.12371e-19
C4	VGND#10	CLK#7	8.77012e-19
C5	a_315_48##8	a_315_338##7	2.46484e-17
C6	a_315_48##8	VGND#10	2.20731e-17
C7	CLK#4	a_27_74#	6.01761e-18
C8	a_83_244##6	a_315_338##6	2.7639e-18
C9	VGND#10	a_27_74##4	2.79812e-17
C10	a_83_244##4	a_315_48##8	4.28605e-19
C11	a_83_244##6	VPWR#11	2.29462e-17
C12	VGND#10	a_315_338#	1.99773e-18
C13	a_83_244##4	a_27_74##4	1.72536e-18
C14	CLK#4	CLK#6	4.38148e-18
C15	VGND#10	a_315_48##2	7.92264e-19
C16	a_315_338#	a_83_244##4	1.51783e-17
C17	a_1041_387##11	a_27_74##2	1.5001e-18
C18	VGND#10	GATE#1	6.70275e-20
C19	a_1041_387##9	a_1041_387##5	3.18669e-19
C20	a_83_244##4	a_315_48##2	4.32709e-17
C21	a_83_244##6	VPWR#12	2.43741e-17
C22	VGND#4	VGND#3	4.50286e-19
C23	a_1041_387##9	a_1041_387##7	7.82502e-19
C24	a_83_244##4	GATE#1	1.13397e-17
C25	a_27_74##9	a_83_244##6	1.47153e-18
C26	a_1041_387##9	a_27_74#	6.49409e-18
C27	a_83_244##4	a_83_244##3	8.02515e-19
C28	VGND#2	VGND#3	1.31712e-17
C29	GATE#1	VGND#11	2.25465e-17
C30	a_27_74##9	VPWR#12	4.65787e-17
C31	VGND#7	CLK#9	2.76739e-17
C32	a_1041_387##9	CLK#6	2.14888e-18
C33	VPWR#2	VPWR#3	1.24795e-17
C34	a_1041_387##3	GCLK#3	1.78571e-19
C35	VGND#11	a_83_244##3	2.79872e-17
C36	a_83_244##3	a_27_74##8	1.7703e-18
C37	a_1041_387##9	CLK#5	9.51582e-20
C38	a_315_48##13	CLK#9	1.31204e-17
C39	a_1041_387##2	GCLK#3	2.94643e-19
C40	VGND#5	VGND#4	2.94413e-19
C41	VGND#6	a_1041_387##3	4.25698e-18
C42	a_1041_387##6	a_1041_387#	3.78351e-17
C43	a_315_338##5	a_315_48##13	6.2598e-17
C44	VPWR#1	a_1041_387##5	2.70816e-17
C45	VGND#3	a_1041_387##4	1.9412e-18
C46	VPWR#3	VPWR#1	1.66463e-18
C47	a_1041_387##5	GCLK#1	2.44073e-17
C48	VPWR#1	a_1041_387##7	8.30933e-19
C49	a_27_74##2	a_1041_387##6	2.64817e-18
C50	VPWR#3	a_1041_387##3	2.8806e-18
C51	a_315_338##5	a_315_338##7	2.9235e-18
C52	a_1041_387##7	GCLK#1	2.40761e-17
C53	a_1041_387##9	a_1041_387##3	3.94277e-19
C54	VPWR#1	a_27_74#	1.57783e-19
C55	a_1041_387##7	VPWR#8	1.05975e-17
C56	VPWR#3	a_1041_387##4	1.56441e-17
C57	a_27_74##2	CLK#1	7.48459e-17
C58	a_315_338##5	VGND#10	7.65786e-17
C59	VGND#4	a_315_48##5	3.96139e-19
C60	a_27_74#	VPWR#8	1.8488e-17
C61	a_27_74##2	CLK#7	2.31182e-17
C62	VPWR#3	VPWR#8	4.20187e-17
C63	VPWR#10	a_1041_387##7	1.3489e-19
C64	a_1041_387##11	a_27_74#	5.95279e-17
C65	a_1041_387##11	VPWR#4	8.79015e-18
C66	CLK#7	CLK#1	2.80112e-17
C67	a_1041_387##9	CLK#4	5.76132e-18
C68	VPWR#10	a_27_74#	2.75289e-18
C69	CLK#6	a_1041_387##11	4.10689e-17
C70	a_315_48##5	VPWR#4	3.0658e-19
C71	a_1041_387##11	VPWR#3	9.97966e-17
C72	VGND#5	a_315_338##5	6.78731e-18
C73	VGND#6	VGND#1	3.87495e-18
C74	a_315_48##5	VPWR#3	1.0793e-18
C75	CLK#6	VPWR#10	2.57023e-17
C76	a_315_48##8	CLK#7	4.41164e-18
C77	a_1041_387##11	CLK#5	6.89326e-19
C78	a_1041_387##3	a_1041_387##2	3.53603e-18
C79	a_83_244##4	a_315_338##3	1.97937e-19
C80	a_315_48##15	CLK#6	1.10729e-18
C81	VGND#4	a_27_74##3	7.64182e-18
C82	CLK#5	VPWR#10	2.97016e-17
C83	VPWR#10	VPWR#3	3.10009e-18
C84	a_315_338##6	CLK#6	2.03224e-19
C85	a_1041_387##11	a_315_48##9	7.72887e-21
C86	VPWR#3	a_315_48##7	1.66587e-19
C87	a_315_48##15	CLK#5	1.74336e-17
C88	a_315_48##15	VPWR#4	1.70802e-17
C89	a_27_74##4	a_315_48##8	6.98371e-18
C90	VPWR#11	CLK#6	3.63398e-19
C91	VPWR#10	a_315_48##9	9.14239e-19
C92	VGND#6	VGND#2	7.41879e-19
C93	a_315_338##6	CLK#5	3.00188e-18
C94	a_315_48##15	a_315_48##9	1.39601e-18
C95	VPWR#11	CLK#5	1.08182e-18
C96	VPWR#10	a_27_74##5	1.44111e-19
C97	a_315_48##5	CLK#9	4.26903e-17
C98	a_315_338##6	a_315_48##9	5.61265e-17
C99	a_315_338#	a_27_74##4	2.48921e-17
C100	a_1041_387##9	VGND#6	1.42767e-17
C101	a_315_48##9	VPWR#11	2.68788e-17
C102	VPWR#4	VPWR#3	1.16387e-18
C103	a_315_338##5	a_315_48##5	5.2923e-17
C104	a_315_338##6	a_27_74##5	3.39414e-18
C105	VGND#7	CLK#4	5.70783e-18
C106	VPWR#11	a_27_74##5	3.86466e-17
C107	VPWR#11	VPWR#4	4.55395e-19
C108	a_315_48##2	a_315_338#	1.11269e-17
C109	a_83_244##6	a_315_48##9	9.51335e-19
C110	a_315_338##6	a_315_48##3	4.63401e-19
C111	a_315_338##5	a_315_48##7	8.41501e-17
C112	a_27_74##7	a_83_244##4	4.54618e-17
C113	VPWR#11	a_315_48##3	1.26719e-17
C114	VGND#7	VGND#6	3.73647e-18
C115	a_83_244##6	a_27_74##5	3.54083e-18
C116	VGND#6	a_1041_387##4	1.88085e-18
C117	VGND#5	VGND#7	1.3941e-18
C118	a_315_338##6	a_315_338##3	4.90969e-20
C119	GATE#1	a_315_48##2	4.13665e-17
C120	a_1041_387##9	a_1041_387##4	4.30594e-17
C121	VPWR#11	a_315_338##3	1.1659e-18
C122	a_315_338##5	a_27_74##3	7.83344e-18
C123	a_83_244##6	a_315_48##3	3.74267e-17
C124	VPWR#2	VPWR#1	1.43113e-17
C125	VPWR#12	a_27_74##5	5.09294e-19
C126	VGND#7	a_1041_387##9	3.65889e-17
C127	VGND#5	VGND#10	1.2816e-18
C128	VPWR#11	GATE#3	6.58128e-19
C129	a_83_244##6	a_315_338##3	6.39737e-17
C130	a_83_244##3	GATE#1	1.01105e-17
C131	VPWR#12	a_315_48##3	8.37312e-19
C132	VGND#2	VPWR#1	4.62766e-18
C133	a_27_74##7	VGND#11	9.34819e-17
C134	a_315_338##2	a_315_338##5	1.71281e-18
C135	a_27_74##7	a_27_74##3	1.79941e-18
C136	a_27_74##2	a_1041_387##3	3.76683e-19
C137	a_83_244##6	GATE#3	3.40151e-17
C138	a_315_48##5	a_1041_387##9	5.02052e-18
C139	VPWR#12	a_315_338##3	4.50387e-18
C140	CLK#9	VPWR#10	2.17724e-17
C141	VGND#4	CLK#9	3.5034e-19
C142	a_27_74##7	a_27_74##8	9.47586e-18
C143	a_27_74##9	a_315_338##3	2.71995e-19
C144	VPWR#2	a_1041_387##3	4.31044e-20
C145	a_83_244##6	a_83_244#	1.95084e-18
C146	GATE#3	VPWR#12	3.36577e-17
C147	a_1041_387##9	a_315_48##7	3.09926e-19
C148	a_315_48##5	a_315_48##13	5.51709e-18
C149	VPWR#2	a_1041_387##2	4.29783e-20
C150	a_27_74##9	GATE#3	2.5809e-18
C151	a_27_74##2	CLK#4	2.05352e-17
C152	a_83_244#	VPWR#12	4.17312e-17
C153	a_315_48##13	VGND#7	6.16923e-17
C154	a_315_48#	a_315_338##5	1.21886e-18
C155	a_27_74##9	a_83_244#	4.99314e-17
C156	a_1041_387##7	a_1041_387##5	4.79971e-17
C157	VGND#10	a_315_48##7	1.54109e-18
C158	VGND#7	a_27_74##3	1.16975e-18
C159	a_315_48##13	a_27_74##3	6.88771e-18
C160	VGND#2	a_1041_387##3	2.85897e-20
C161	VGND#3	a_1041_387##6	4.48353e-18
C162	VGND#2	a_1041_387##2	4.80133e-20
C163	VGND#10	VGND#7	2.09688e-18
C164	a_27_74##3	VGND#10	4.72064e-17
C165	VGND#4	a_27_74##2	5.34058e-17
C166	a_27_74#	a_1041_387##7	6.47928e-18
C167	a_315_338##5	a_315_338##6	3.45767e-18
C168	a_27_74##3	a_83_244##4	6.26996e-17
C169	a_27_74##7	GATE#2	7.8562e-19
C170	VGND#3	a_27_74##2	1.28719e-18
C171	VGND#10	a_315_48##13	2.95541e-18
C172	VGND#10	a_315_338##2	1.4484e-17
C173	VGND#2	a_1041_387#	1.38566e-17
C174	a_315_48##5	a_1041_387##11	1.45701e-18
C175	CLK#6	a_27_74#	3.71069e-17
C176	VGND#2	a_1041_387##6	8.79779e-18
C177	VGND#4	CLK#1	1.98772e-18
C178	a_315_48##5	VPWR#10	4.7619e-18
C179	VGND#1	VPWR#1	1.18252e-17
C180	a_83_244##4	a_315_338##2	1.23948e-18
C181	a_27_74##7	a_83_244##2	1.18833e-16
C182	VGND#2	a_27_74##2	1.61846e-19
C183	a_315_48##5	a_315_48##15	7.53273e-19
C184	a_1041_387##11	a_315_48##7	2.32725e-19
C185	a_315_338##6	a_315_48##5	1.87649e-17
C186	CLK#5	CLK#6	3.48434e-17
C187	a_83_244##4	a_315_48##4	4.32791e-18
C188	a_315_48##5	VPWR#11	1.09101e-18
C189	CLK#9	VPWR#4	5.5789e-19
C190	VGND#4	CLK#7	2.29417e-18
C191	a_315_338##6	a_315_48##7	2.41373e-17
C192	VGND#5	a_27_74##2	3.43471e-19
C193	a_315_48##9	CLK#5	5.5833e-18
C194	a_315_48##7	VPWR#11	2.47773e-17
C195	a_315_48#	a_83_244##4	7.21181e-17
C196	a_1041_387##4	a_1041_387##6	1.42412e-17
C197	a_315_338##6	a_27_74##3	2.20548e-19
C198	a_27_74##2	a_1041_387##4	2.98483e-17
C199	VPWR#11	a_27_74##3	4.34135e-19
C200	VPWR#3	a_27_74##2	8.48557e-20
C201	VGND#5	a_315_48##8	1.80116e-18
C202	a_27_74##5	a_315_48##9	2.1091e-17
C203	a_83_244##4	GATE#2	3.80413e-18
C204	a_315_48##8	CLK#4	7.15269e-19
C205	a_83_244##4	VGND#10	1.16556e-17
C206	VPWR#11	a_315_338##2	7.57797e-20
C207	VGND#5	a_315_338#	1.19805e-18
C208	a_315_48##5	a_27_74##2	1.6491e-19
C209	VPWR#2	a_1041_387##5	1.20213e-17
C210	a_315_48##3	a_27_74##5	2.85654e-17
C211	a_315_48##4	a_315_338##6	3.24065e-18
C212	VGND#5	a_315_48##2	1.22624e-19
C213	a_315_338##2	a_83_244##6	1.011e-18
C214	a_315_48##5	CLK#1	2.38331e-19
C215	VPWR#2	a_1041_387##7	5.70081e-18
C216	a_315_48##4	VPWR#11	4.08174e-18
C217	a_315_338##3	a_27_74##5	5.3227e-19
C218	a_83_244##2	VGND#11	3.82013e-18
C219	VGND#5	GATE#1	3.52446e-20
C220	a_315_48##5	CLK#7	1.60073e-18
C221	a_315_338##3	a_315_48##3	8.73942e-18
C222	a_315_48##5	a_315_48##8	1.60375e-19
C223	a_315_48##4	a_83_244##6	8.52343e-17
C224	a_1041_387##4	a_1041_387##3	8.13783e-19
C225	CLK#9	CLK#4	2.16422e-17
C226	a_315_48#	a_83_244##6	2.93891e-18
C227	GATE#3	a_315_338##3	5.14077e-17
C228	a_27_74##4	a_315_48##7	2.76072e-17
C229	a_27_74##3	CLK#7	3.45534e-19
C230	CLK	CLK#4	1.40275e-17
C231	a_27_74##3	a_315_48##8	2.24273e-17
C232	a_83_244#	GATE#3	1.62496e-17
C233	a_315_338#	a_27_74##3	2.77321e-17
C234	a_315_338##2	a_315_48##8	2.26593e-20
C235	VPWR#12	GATE#2	1.16407e-18
C236	a_27_74##3	a_315_48##2	1.95304e-17
C237	a_315_338##2	a_27_74##4	6.3067e-17
C238	a_27_74##9	GATE#2	2.89555e-19
C239	a_315_338##2	a_315_338#	5.83424e-18
C240	a_27_74##3	GATE#1	1.9278e-19
C241	a_83_244##2	VPWR#12	4.51178e-17
C242	a_315_48##5	a_27_74#	3.94311e-19
C243	a_83_244##2	a_27_74##9	4.68939e-17
C244	a_315_48#	a_315_48##8	1.71068e-19
C245	GCLK	a_1041_387##3	1.32793e-17
C246	a_315_48##5	CLK#6	5.61565e-19
C247	GCLK	a_1041_387##2	1.70198e-17
C248	CLK#9	a_27_74##2	5.68103e-19
C249	a_315_48#	a_27_74##4	3.09864e-19
C250	a_315_48##5	CLK#5	4.037e-18
C251	a_315_48#	a_315_338#	1.17968e-17
C252	a_315_48##5	a_315_48##9	4.02147e-19
C253	a_315_48##7	CLK#5	8.75714e-19
C254	VPWR#12	a_508_508#	4.6008e-20
C255	GATE#1	a_315_48#	9.12993e-18
C256	a_315_48##7	a_315_48##9	4.32569e-18
C257	a_83_244##6	a_264_392#	1.99765e-18
C258	a_315_48##7	a_27_74##5	2.27522e-17
C259	a_27_74##7	a_27_74##9	2.68768e-18
C260	a_315_338##5	CLK#4	2.05023e-19
C261	a_27_74##7	a_267_74#	6.9578e-19
C262	a_315_48##7	a_315_338##3	7.76898e-20
C263	a_83_244##2	GATE#1	6.20464e-18
C264	a_315_48##5	CLK#4	3.88708e-17
C265	a_83_244##2	a_83_244##3	3.19255e-18
C266	a_315_338##2	a_27_74##5	6.92439e-18
C267	VPWR	CLK#4	7.02691e-21
C268	a_315_48##4	a_315_48##9	7.62665e-19
C269	a_315_48##4	a_27_74##5	4.61402e-17
C270	a_315_48##4	a_315_338##3	1.61841e-17
C271	a_315_338##5	CLK#7	1.26566e-18
C272	a_315_48##4	GATE#3	8.09799e-20
C273	a_27_74##2	a_1044_119#	1.22745e-17
C274	a_83_244##4	a_267_74#	1.14213e-18
C275	a_315_48#	a_315_338##3	3.29254e-17
C276	CLK#1	a_1044_119#	7.26611e-18
C277	VGND#5	a_315_48##5	1.47606e-18
C278	a_315_48##4	a_83_244#	9.9325e-20
C279	VGND#5	a_315_48##7	1.47765e-19
C280	GATE#2	a_315_338##3	1.54097e-17
C281	a_315_48##7	CLK#4	5.49178e-19
C282	VGND#4	CLK	4.87729e-19
C283	VGND	a_1041_387##3	3.4778e-18
C284	VGND#5	a_27_74##3	1.4942e-16
C285	VGND	CLK#4	6.63458e-21
C286	a_83_244##2	a_315_338##3	3.79431e-19
C287	VGND#4	VGND#6	1.03693e-18
C288	a_315_338##5	a_315_48##8	4.02896e-17
C289	a_83_244#	GATE#2	4.4134e-18
C290	CLK	VPWR#4	3.20201e-19
C291	a_83_244##2	GATE#3	1.59381e-19
C292	VGND#5	a_315_338##2	7.42515e-20
C293	a_27_74##4	a_494_118#	9.79631e-18
C294	a_27_74##5	a_508_508#	1.06762e-17
C295	a_315_48##7	a_315_48##5	8.44827e-18
C296	a_315_338#	a_494_118#	1.01444e-17
C297	a_83_244##2	a_83_244#	6.62275e-18
C298	VGND#1	a_1041_387#	2.38332e-17
C299	a_315_48##3	a_508_508#	1.06762e-17
C300	a_27_74##3	a_315_48##5	2.69477e-18
C301	a_27_74##3	a_315_48##7	3.03087e-18
C302	VGND#3	GCLK	2.65815e-18
C303	a_315_338##5	a_27_74##4	1.79858e-18
C304	a_1041_387#	GCLK#3	1.5442e-17
C305	VGND#4	a_1041_387##9	4.89686e-18
C306	a_315_338##3	a_264_392#	1.98387e-17
C307	a_315_338##2	a_315_48##7	1.63202e-17
C308	VPWR#3	GCLK	1.0613e-16
C309	GATE#3	a_264_392#	5.04709e-18
C310	VGND#1	a_1041_387##6	1.52635e-18
C311	a_27_74##3	a_315_338##2	1.64091e-17
C312	a_315_48##4	a_315_48##7	2.42848e-18
C313	a_83_244##4	GATE	4.71717e-18
C314	a_27_74##3	a_315_48##4	1.29769e-19
C315	VGND#6	a_1041_387#	1.70946e-18
C316	a_1041_387##3	VNB	1.93608e-17
C317	CLK	a_1041_387##9	3.98917e-17
C318	a_1041_387##2	VNB	3.53378e-17
C319	CLK#4	VNB	4.1968e-17
C320	VGND#7	CLK	1.41095e-17
C321	a_315_48##4	a_315_338##2	7.66791e-17
C322	a_315_338##5	a_315_338#	3.52949e-19
C323	a_27_74##3	a_315_48#	8.3459e-19
C324	VGND#3	a_1041_387##9	8.07335e-18
C325	a_1041_387##6	GCLK#3	1.4935e-17
C326	a_315_48##2	a_267_74#	1.09141e-17
C327	VPWR#3	a_1041_387##5	2.74235e-18
C328	GATE#1	a_267_74#	4.50546e-18
C329	a_315_48#	a_315_338##2	7.73806e-17
C330	VGND#1	a_27_74##2	2.35642e-19
C331	VPWR	VPWR#4	7.93216e-17
C332	VPWR	VPWR#3	1.34629e-16
C333	GCLK	VGND#1	6.36245e-17
C334	GATE#2	a_315_338##2	1.45754e-18
C335	a_1041_387##6	VGND#6	1.34507e-17
C336	VGND#6	GCLK	3.70792e-17
C337	GATE	a_83_244##6	1.64665e-17
C338	a_1041_387##9	GCLK	3.37035e-17
C339	a_315_48##4	GATE#2	2.34794e-19
C340	VPWR	CLK#9	4.24488e-18
C341	GATE	VPWR#12	1.42267e-18
C342	CLK	a_1041_387##11	4.2632e-18
C343	VPWR	a_315_338##5	1.61648e-18
C344	CLK	VPWR#10	6.22577e-18
C345	GATE#2	a_315_48#	2.03289e-17
C346	a_83_244##2	a_315_48##4	7.51188e-19
C347	a_315_338##5	a_315_48##2	1.62626e-19
C348	a_83_244##2	a_315_48#	4.76651e-18
C349	a_1041_387##9	a_1041_387##6	5.68387e-18
C350	VGND	VGND#4	1.17714e-16
C351	VPWR#3	a_1041_387##7	2.79046e-17
C352	VGND	VGND#3	7.37802e-17
C353	GCLK	VPWR#1	1.00548e-16
C354	a_83_244##2	GATE#2	3.40475e-17
C355	a_83_244##4	a_83_244##6	9.87196e-18
C356	GCLK	GCLK#1	6.01739e-18
C357	VGND#6	a_27_74##2	4.306e-18
C358	VPWR	a_1041_387##9	6.19062e-18
C359	CLK	a_27_74##2	3.27255e-18
C360	VGND	CLK#9	3.49231e-18
C361	VGND	a_315_338##5	1.84879e-17
C362	a_1041_387##9	a_27_74##2	6.88965e-17
C363	VGND	a_27_74##7	3.75866e-17
C364	GCLK	a_1041_387#	2.40268e-17
C365	GCLK	a_1041_387##6	2.07105e-17
C366	VPWR	a_1041_387##11	1.86948e-17
C367	VPWR	VPWR#10	2.07371e-17
C368	GCLK	a_27_74##2	7.17704e-19
C369	VPWR#3	a_27_74#	2.48504e-17
C370	VGND#6	CLK#1	2.67559e-19
C371	VGND#4	VNB	4.21204e-17
C372	VPWR	a_315_48##15	1.80375e-17
C373	VGND#7	a_1041_387##6	1.13611e-18
C374	VGND#3	VNB	3.85853e-17
C375	VGND	a_1041_387##9	2.66572e-17
C376	VPWR#10	a_1041_387##11	7.85678e-17
C377	VPWR	a_315_338##6	1.76158e-17
C378	VPWR	VPWR#11	1.57985e-16
C379	VPWR#4	VNB	4.0272e-17
C380	VGND	a_315_48##13	1.6682e-17
C381	VPWR#3	VNB	5.29257e-17
C382	VPWR	a_83_244##6	3.45942e-17
C383	VGND	VGND#10	5.17376e-18
C384	VGND#4	a_315_48##13	9.38973e-18
C385	CLK	a_27_74#	1.12376e-18
C386	a_27_74##7	a_315_338#	3.89836e-19
C387	VGND	a_83_244##4	1.71993e-17
C388	GATE	a_315_338##3	3.7627e-18
C389	VPWR	VPWR#12	2.79449e-17
C390	VPWR	a_27_74##9	2.03976e-17
C391	CLK#9	VNB	1.76317e-18
C392	GATE	a_83_244#	1.00551e-18
C393	a_315_338##5	VNB	1.35586e-17
C394	a_27_74##3	a_267_74#	1.57575e-19
C395	a_1041_387##9	CLK#1	7.00496e-18
C396	GCLK	a_1041_387##5	3.54688e-17
C397	VPWR#4	CLK#6	9.46156e-18
C398	a_27_74##7	VNB	6.23128e-17
C399	GCLK	a_1041_387##7	2.39592e-17
C400	GCLK	a_27_74#	8.24206e-19
C401	VGND#1	VNB	4.42336e-17
C402	VGND#6	VPWR#3	8.77888e-18
C403	VGND#6	VNB	8.75486e-18
C404	VGND#7	a_27_74##2	8.33967e-18
C405	a_1041_387##9	VNB	1.78317e-17
C406	VGND#7	VNB	6.26273e-18
C407	a_315_48##13	VNB	7.42558e-18
C408	VGND	a_27_74##9	1.67105e-18
C409	VGND#10	VNB	3.90123e-18
C410	VPWR#3	CLK#6	9.45015e-19
C411	a_83_244##4	VNB	4.38915e-18
C412	VGND	a_27_74##2	9.31832e-18
C413	VPWR	a_1041_387##7	7.9639e-20
C414	VGND#11	VNB	2.68079e-18
C415	VGND	CLK#1	2.84271e-18
C416	VPWR	a_27_74#	9.2517e-18
C417	a_27_74##7	a_315_48##2	1.88798e-18
C418	VGND	CLK#7	3.93453e-18
C419	VPWR#1	VNB	5.25024e-17
C420	VPWR	CLK#6	6.78932e-18
C421	VGND	a_315_48##8	3.99348e-18
C422	VPWR	CLK#5	6.66198e-18
C423	a_1041_387##11	VNB	2.94404e-18
C424	VPWR	a_315_48##9	4.88263e-18
C425	VPWR#10	VNB	5.99514e-18
C426	GCLK	VPWR#2	3.38662e-17
C427	VGND	a_315_48##2	4.80561e-18
C428	a_315_48##15	VNB	1.27442e-17
C429	VPWR	a_27_74##5	2.03742e-18
C430	a_1041_387##9	CLK#7	3.86977e-19
C431	a_315_338##6	VNB	1.38583e-17
C432	VGND	GATE#1	1.45693e-18
C433	VGND#2	GCLK	2.9026e-17
C434	GATE	a_315_338##2	7.68594e-19
C435	a_315_48##13	a_27_74##2	2.56885e-18
C436	a_315_48##15	VPWR#10	7.1786e-17
C437	VPWR	a_315_48##3	1.77969e-18
C438	VPWR#11	VNB	6.87932e-17
C439	VGND	a_83_244##3	1.55592e-18
C440	VPWR	a_315_338##3	5.3087e-18
C441	a_83_244##6	VNB	3.30789e-18
C442	VPWR	GATE#3	1.55312e-18
C443	VPWR#12	VNB	6.19871e-18
C444	GATE	a_315_48#	9.32536e-18
C445	VPWR	a_83_244#	4.15527e-18
C446	a_27_74##9	VNB	6.2603e-17
C447	GCLK	a_1041_387##4	2.6576e-18
C448	a_1041_387#	VNB	3.47869e-17
C449	a_1041_387##6	VNB	3.9739e-17
C450	GATE	GATE#2	1.66704e-17
C451	VGND#7	CLK#1	4.47789e-17
C452	a_27_74##2	VNB	1.1404e-16
C453	VPWR#4	CLK#5	4.81084e-18
C454	CLK#1	VNB	1.84322e-17
C455	a_83_244##2	GATE	6.81496e-17
C456	CLK#7	VNB	2.76118e-17
C457	a_315_48##8	VNB	2.71096e-17
C458	a_27_74##4	VNB	3.98366e-17
C459	a_315_338#	VNB	3.33742e-17
C460	VGND	a_315_338##3	8.50595e-19
C461	a_315_48##2	VNB	2.8603e-17
C462	a_1041_387##9	VPWR#3	4.36898e-17
C463	GATE#1	VNB	3.43721e-17
C464	a_83_244##3	VNB	3.03593e-17
C465	a_1041_387##5	VNB	4.26633e-17
C466	VPWR	a_315_48##5	7.23119e-18
C467	a_1041_387##7	VNB	3.90636e-17
C468	VPWR	a_315_48##7	6.46819e-18
C469	a_27_74#	VNB	4.66174e-17
C470	CLK#6	VNB	3.61011e-17
C471	a_27_74##7	GATE#1	3.19902e-17
C472	a_315_338##6	VPWR#10	1.15026e-18
C473	VPWR#3	CLK#5	5.92866e-19
C474	CLK#5	VNB	3.85748e-17
C475	a_315_48##9	VNB	3.54309e-17
C476	VGND	VGND#5	1.35339e-16
C477	VPWR	a_315_338##2	8.33428e-18
C478	a_27_74##5	VNB	5.11895e-17
C479	VGND	a_1041_387##4	1.0882e-17
C480	VPWR	a_315_48##4	1.49691e-17
C481	a_315_48##3	VNB	2.22089e-17
C482	a_1041_387##9	a_315_48##8	1.65589e-19
C483	a_315_48##13	CLK#1	1.2141e-18
C484	a_315_338##3	VNB	4.67419e-17
C485	VPWR	a_315_48#	3.26722e-18
C486	GATE#3	VNB	3.41898e-17
C487	VGND	a_315_48##5	5.07689e-18
C488	a_83_244#	VNB	4.31462e-17
C489	VGND	a_315_48##7	2.63429e-18
C490	VGND	a_27_74##3	6.64091e-17
C491	VPWR	a_83_244##2	6.84456e-18
C492	VPWR#2	VNB	1.16014e-16
C493	VGND#2	VNB	1.22397e-16
C494	VGND	a_315_338##2	9.78435e-18
C495	VGND#5	VNB	6.19937e-17
C496	VGND	a_315_48#	5.79751e-18
C497	CLK#7	VGND#7	1.915e-17
C498	a_1041_387##4	VNB	6.10405e-17
C499	a_315_48##5	VNB	5.26347e-17
C500	VGND#10	a_27_74##2	1.4694e-19
C501	VGND	a_83_244##2	6.39341e-18
C502	a_315_48##7	VNB	5.76354e-17
C503	a_27_74##3	VNB	1.5189e-16
C504	a_315_338##2	VNB	5.58136e-17
C505	a_315_48##4	VNB	3.76896e-17
C506	a_315_48#	VNB	3.213e-17
C507	GATE#2	VNB	3.93166e-17
C508	a_315_338##6	a_315_48##15	5.9873e-17
C509	a_83_244##2	VNB	5.35034e-17
C510	VPWR#11	VPWR#10	5.8143e-19
C511	CLK#4	VPWR#10	5.56044e-18
C512	VPWR	GATE	1.67939e-18
C513	a_27_74##7	a_83_244##3	3.42482e-17
C514	VPWR	CLK	2.31022e-18
C515	a_315_48##13	CLK#7	5.44458e-17
C516	VGND	GATE	1.8134e-18
C517	VGND	CLK	3.45431e-18
C518	GATE	VNB	2.4472e-18
C519	CLK	VNB	4.56271e-19
C520	VPWR#3	a_315_48##9	5.76464e-20
C521	GCLK	VNB	2.14088e-17
C522	VPWR	VNB	2.93107e-16
C523	VGND	VNB	3.02976e-16
C524	VGND#7	a_315_48##8	1.07022e-18
C525	VGND#10	CLK#1	1.86767e-19
C526	a_27_74##9	VPWR#6	2.18539e-17
C527	VGND#8	a_315_338##2	1.11825e-20
C528	VGND#8	GATE#1	5.98318e-18
C529	VPWR	VPWR#6	1.28721e-16
C530	VGND	VGND#8	1.38126e-16
C531	VGND#8	a_83_244##3	4.18977e-18
C532	VPWR#6	GATE#3	8.59144e-18
C533	VGND#8	VNB	7.53609e-17
C534	a_83_244##2	VPWR#6	3.09394e-19
C535	VGND#8	a_315_48#	2.55989e-19
C536	VGND#8	GATE#2	1.34751e-20
C537	VPWR#6	a_83_244#	4.66494e-18
C538	VGND#8	a_27_74##7	5.57254e-17
C539	VGND#8	a_27_74##3	3.97439e-17
C540	VPWR#6	VNB	7.17313e-17
C541	VGND#8	a_315_48##2	4.8011e-18
C542	a_83_244##6	VPWR#6	1.66924e-17
C543	VPWR#6	a_315_338##2	2.26631e-20
C544	VPWR#6	a_315_338##3	6.27175e-18
*
*
.ENDS sky130_fd_sc_hs__dlclkp_2
*
