* Extracted by Quantus, converted by sky130cad/quantus.py
*
*
*
*                       LINUX           Wed Nov 18 08:20:31 2026
*
*
*
*  PROGRAM  advgen
*
*  Name           : advgen - Quantus - (64-bit)
*  Version        : 25.1.0-p047
*  Build Date     : Thu Dec 11 23:20:30 PST 2025
*
*  HSPICE LIBRARY
*
*  OPERATING_TEMPERATURE 150
*  QRC_TECH_DIR <path>/tech
*
*
*

*
.SUBCKT sky130_fd_sc_hs__buf_4 VPB VNB VGND VPWR X A
*
*
*  caps2d version: 10
*
*
*       TRANSISTOR CARDS
*
*
XM1 VGND#5 a_86_260##10 X#5 VNB sky130_fd_pr__nfet_01v8_lvt l=0.15 w=0.74 ad=0.2627 as=0.2072 pd=2.19 ps=2.04
XM5 X#5 a_86_260##7 VGND#7 VNB sky130_fd_pr__nfet_01v8_lvt l=0.15 w=0.74 ad=0.2072 as=0.3108 pd=2.04 ps=2.32
XM7 VGND#7 a_86_260##5 X#1 VNB sky130_fd_pr__nfet_01v8_lvt l=0.15 w=0.74 ad=0.3108 as=0.2072 pd=2.32 ps=2.04
XM10 X#1 a_86_260# VGND#6 VNB sky130_fd_pr__nfet_01v8_lvt l=0.15 w=0.74 ad=0.2072 as=0.5328 pd=2.04 ps=2.92
XM4 VGND#6 A#1 a_86_260##16 VNB sky130_fd_pr__nfet_01v8_lvt l=0.15 w=0.74 ad=0.5328 as=0.2109 pd=2.92 ps=2.05
XM0 X#4 a_86_260##12 VPWR#5 VPB sky130_fd_pr__pfet_01v8 l=0.15 w=1.12 ad=0.336 as=0.3304 pd=2.84 ps=2.83
XM3 X#4 a_86_260##11 VPWR#7 VPB sky130_fd_pr__pfet_01v8 l=0.15 w=1.12 ad=0.336 as=0.336 pd=2.84 ps=2.84
XM6 VPWR#7 a_86_260##8 X#6 VPB sky130_fd_pr__pfet_01v8 l=0.15 w=1.12 ad=0.336 as=0.336 pd=2.84 ps=2.84
XM8 VPWR#6 a_86_260##4 X#6 VPB sky130_fd_pr__pfet_01v8 l=0.15 w=1.12 ad=0.406 as=0.336 pd=3.01 ps=2.84
XM9 VPWR#6 A#3 a_86_260##13 VPB sky130_fd_pr__pfet_01v8 l=0.15 w=0.84 ad=0.406 as=0.252 pd=3.01 ps=2.28
XM2 a_86_260##13 A#4 VPWR#1 VPB sky130_fd_pr__pfet_01v8 l=0.15 w=0.84 ad=0.252 as=0.2478 pd=2.28 ps=2.27
*
*
*       RESISTOR AND CAP/DIODE CARDS
*
Rg1	a_86_260#	a_86_260##2	378.563629
Rg2	a_86_260##2	a_86_260##3	56.222851
Rg3	a_86_260##2	a_86_260##4	441.762421
Rg4	a_86_260##3	a_86_260##5	370.795044
Rg5	a_86_260##3	a_86_260##6	100.505219
Rg6	a_86_260##6	a_86_260##7	402.070007
Rg7	a_86_260##3	a_86_260##8	465.491180
Rg8	a_86_260##6	a_86_260##9	178.751389
Rg9	a_86_260##9	a_86_260##10	350.295563
Rg10	a_86_260##6	a_86_260##11	445.109619
Rg11	a_86_260##9	a_86_260##12	526.482239
Rg12	A#1	A#2	374.111481
Rg13	A#2	A#3	425.188965
Rg14	A#2	A#4	345.870300
Rf1	X#1	X#2	77.063744
Rf2	X#2	X	14.391277
Rf3	X	X#3	40.955070
Rf4	X#3	X#4	41.727165
Rf5	X#2	X#5	19.895288
Rf6	X#3	X#6	98.243813
Rf7	A#5	A#2	161.760818
Rf8	A	A#7	1.528014
Rf9	A#5	A#7	5.161376
Rf10	a_86_260##13	a_86_260##14	112.343796
Rf11	a_86_260##14	a_86_260##3	153.298828
Rf12	a_86_260##14	a_86_260##16	20.109606
Rf13	VPWR#1	VPWR#2	111.245232
Rf14	VPWR#2	VPWR#3	30.291424
Rf15	VPWR#3	VPWR#4	35.404957
Rf16	VPWR#4	VPWR#5	102.050674
Rf17	VPWR#2	VPWR#6	38.286041
Rf18	VPWR#4	VPWR#7	36.061966
Rf20	VGND#2	VGND#3	54.780773
Rf21	VGND#3	VGND#4	29.195665
Rf22	VGND#4	VGND#5	109.370407
Rf23	VGND#2	VGND#6	24.089653
Rf24	VGND#4	VGND#7	34.113823
Re1	VPWR#3	VPWR	1.403190
Re2	VGND	VGND#3	1.403242
*
*       CAPACITOR CARDS
*
*
C1	VPWR#7	a_86_260##6	3.54302e-19
C2	a_86_260##9	a_86_260##6	7.83605e-18
C3	VGND#4	a_86_260##9	3.64077e-20
C4	VGND#4	a_86_260##6	6.59208e-20
C5	VPWR#4	a_86_260##9	4.22158e-20
C6	VPWR#4	a_86_260##6	2.65016e-20
C7	a_86_260##6	a_86_260##8	1.69471e-18
C8	VPWR#4	VPWR#2	1.22166e-18
C9	a_86_260##12	a_86_260##6	5.59318e-18
C10	VGND#4	X#2	1.72693e-17
C11	X#3	VPWR#4	2.33391e-19
C12	a_86_260##14	A#5	4.64511e-17
C13	VGND#4	X#1	5.02997e-20
C14	a_86_260##14	a_86_260##16	3.85735e-18
C15	VGND#5	VGND#4	1.34647e-18
C16	X#3	a_86_260##9	1.06793e-18
C17	a_86_260##14	VGND#6	6.5969e-19
C18	VGND#3	a_86_260##9	3.08707e-21
C19	VGND#3	a_86_260##6	3.27705e-21
C20	X#3	a_86_260##6	1.10478e-17
C21	X#1	a_86_260##14	3.72805e-18
C22	X#2	X#3	3.51762e-18
C23	VPWR#2	VPWR#1	9.9167e-19
C24	X#2	a_86_260##6	7.72815e-19
C25	a_86_260##13	VPWR#2	2.59214e-18
C26	X#2	X#1	2.25148e-18
C27	X#6	VPWR#4	4.25246e-19
C28	a_86_260##14	a_86_260##13	2.88119e-18
C29	X#2	VGND#7	5.92734e-17
C30	a_86_260##3	a_86_260##9	6.17261e-19
C31	a_86_260##3	a_86_260##6	1.30598e-17
C32	X#2	X#5	4.68449e-19
C33	VGND#5	X#2	6.01717e-17
C34	X#4	VPWR#4	1.07449e-17
C35	X#1	VGND#7	5.43428e-17
C36	VGND#4	A#1	1.37644e-20
C37	VPWR#5	VPWR#4	1.22366e-18
C38	VGND#4	a_86_260#	4.8294e-19
C39	X#3	X#6	2.09072e-18
C40	VGND#4	a_86_260##5	1.94754e-18
C41	VGND#5	VGND#7	2.62958e-18
C42	X#3	VPWR#7	3.10045e-17
C43	VGND#4	a_86_260##7	4.49428e-18
C44	a_86_260##14	A#1	4.59752e-17
C45	X#3	X#4	3.92638e-18
C46	a_86_260##14	a_86_260#	1.76095e-18
C47	VGND#4	a_86_260##10	3.57294e-18
C48	VPWR#5	X#3	3.06573e-17
C49	a_86_260##13	VPWR#1	3.79524e-17
C50	VPWR#6	VPWR#1	1.86239e-17
C51	A#1	a_86_260##16	7.72968e-18
C52	A	a_86_260##9	1.38286e-20
C53	VPWR#6	a_86_260##13	3.34122e-17
C54	A#1	VGND#6	1.69537e-17
C55	A	a_86_260##6	1.99795e-19
C56	VGND#7	a_86_260##6	2.94455e-19
C57	X#1	A#1	1.84172e-18
C58	X#2	a_86_260##5	5.46317e-19
C59	X#6	a_86_260##13	1.36636e-18
C60	a_86_260#	VGND#6	1.65519e-17
C61	VPWR#2	A#4	2.44315e-18
C62	VGND#7	A#1	1.31062e-19
C63	X#6	VPWR#6	8.51563e-17
C64	X#1	a_86_260#	4.55863e-17
C65	X#2	a_86_260##7	4.37201e-17
C66	VGND#5	VPWR#5	1.09286e-17
C67	VGND#7	a_86_260#	7.99406e-19
C68	VPWR#7	VPWR#6	2.06267e-18
C69	VPWR#2	A#3	3.64203e-18
C70	X#1	a_86_260##5	5.39947e-17
C71	X#2	a_86_260##10	2.35393e-17
C72	a_86_260##9	X#5	1.48392e-19
C73	VPWR#7	X#6	6.27096e-17
C74	a_86_260##5	VGND#7	2.1537e-17
C75	X	a_86_260##9	1.32539e-17
C76	X#1	a_86_260##7	7.78741e-19
C77	X	a_86_260##6	8.8297e-18
C78	VPWR#2	a_86_260##4	4.01388e-19
C79	a_86_260##6	X#5	1.57524e-19
C80	a_86_260##7	VGND#7	2.42614e-17
C81	X#3	A#4	1.39472e-19
C82	VPWR#4	a_86_260##8	3.12374e-18
C83	VGND#5	a_86_260##5	2.89259e-19
C84	X#4	VPWR#7	6.25393e-17
C85	a_86_260##7	X#5	1.4935e-17
C86	VGND#7	a_86_260##10	9.17295e-19
C87	VPWR#5	VPWR#7	2.06271e-18
C88	VGND#5	a_86_260##7	1.36631e-18
C89	X#3	A#3	1.29444e-19
C90	a_86_260##10	X#5	1.5442e-17
C91	VPWR#4	a_86_260##11	1.70049e-18
C92	VPWR#5	X#4	6.10888e-17
C93	a_86_260##10	VGND#5	2.33193e-17
C94	X#3	a_86_260##4	3.59387e-19
C95	X#3	a_86_260##8	5.38514e-18
C96	VPWR#1	A#4	2.92532e-17
C97	X#3	a_86_260##11	1.35217e-17
C98	a_86_260#	A#1	7.90541e-18
C99	a_86_260##13	A#4	4.61855e-17
C100	VPWR#1	A#3	5.63904e-18
C101	VPWR#3	VPWR#4	3.4667e-17
C102	VPWR#6	A#4	5.89761e-18
C103	X#3	a_86_260##12	1.06564e-17
C104	VGND#3	VGND#4	3.85014e-17
C105	VPWR#3	VPWR#2	4.05853e-17
C106	a_86_260##13	A#3	3.96708e-17
C107	a_86_260##5	a_86_260#	3.73439e-17
C108	VPWR#1	a_86_260##4	3.5448e-18
C109	VPWR#6	A#3	1.95976e-17
C110	a_86_260##13	a_86_260##4	8.07644e-19
C111	VGND	a_86_260##9	4.38237e-19
C112	VGND	a_86_260##6	5.24328e-19
C113	VPWR#6	a_86_260##4	6.02633e-17
C114	a_86_260##7	a_86_260##5	2.14679e-17
C115	a_86_260##4	X#6	2.17652e-17
C116	VPWR#6	a_86_260##8	2.74585e-18
C117	VPWR#7	a_86_260##4	2.7875e-18
C118	VPWR#2	A#2	1.40297e-19
C119	X#6	a_86_260##8	3.66154e-17
C120	a_86_260##10	a_86_260##7	3.83767e-17
C121	a_86_260##14	A#2	1.3677e-17
C122	VPWR#7	a_86_260##8	5.64577e-17
C123	X#6	a_86_260##11	3.79275e-19
C124	a_86_260##3	VPWR#2	3.3336e-20
C125	VPWR#7	a_86_260##11	4.90041e-17
C126	A#5	A#2	1.27319e-17
C127	X#3	A#2	1.10415e-19
C128	a_86_260##3	a_86_260##14	3.8782e-18
C129	X#6	a_86_260##12	1.63529e-19
C130	a_86_260##11	X#4	2.262e-17
C131	VGND#3	X#1	1.58592e-17
C132	VPWR#7	a_86_260##12	2.95574e-18
C133	VPWR#5	a_86_260##11	3.47528e-18
C134	VPWR#3	VPWR#1	2.368e-17
C135	a_86_260##9	VNB	3.64334e-17
C136	a_86_260##6	VNB	3.31212e-17
C137	a_86_260##3	A#5	2.0675e-17
C138	a_86_260##12	X#4	2.23169e-17
C139	X#3	a_86_260##3	3.19878e-17
C140	VGND#3	VGND#5	2.64989e-17
C141	VPWR#5	a_86_260##12	5.59448e-17
C142	X#2	a_86_260##3	2.37057e-17
C143	X#6	VPWR#3	1.05714e-17
C144	a_86_260##3	VGND#6	1.29668e-18
C145	A#3	A#4	3.89789e-17
C146	a_86_260##3	X#1	9.07118e-17
C147	a_86_260##3	VGND#7	5.92088e-18
C148	A#2	a_86_260##13	3.10751e-18
C149	VPWR#3	VPWR#5	2.82341e-17
C150	a_86_260##4	A#3	2.82769e-17
C151	a_86_260##3	a_86_260##13	2.12979e-18
C152	A	a_86_260##14	1.07129e-17
C153	a_86_260##3	VPWR#6	3.75431e-17
C154	a_86_260##8	a_86_260##4	4.89871e-17
C155	a_86_260##3	X#6	4.42766e-17
C156	VGND#3	a_86_260#	1.69372e-18
C157	a_86_260##3	VPWR#7	2.7831e-18
C158	VGND#3	a_86_260##5	2.51845e-18
C159	X#3	A	1.92456e-18
C160	a_86_260##11	a_86_260##8	4.68979e-17
C161	a_86_260##3	A#1	6.41485e-19
C162	a_86_260##3	a_86_260#	4.89495e-18
C163	VPWR	VPWR#4	2.21061e-17
C164	a_86_260##3	a_86_260##5	3.80378e-19
C165	a_86_260##12	a_86_260##11	4.81195e-17
C166	VPWR	VPWR#2	2.67569e-17
C167	VPWR#3	a_86_260##4	3.79089e-18
C168	a_86_260##3	a_86_260##7	9.33467e-20
C169	A	a_86_260##13	4.92534e-17
C170	VPWR#3	a_86_260##8	3.92284e-19
C171	a_86_260##3	a_86_260##10	1.11007e-19
C172	A#3	A#2	1.81116e-18
C173	VPWR	X#3	2.03784e-18
C174	VGND	VGND#4	4.31574e-17
C175	a_86_260##3	A#3	6.09717e-19
C176	VGND	a_86_260##14	1.92615e-17
C177	VGND	A#5	2.83764e-18
C178	VPWR	VPWR#1	3.87018e-17
C179	VGND	X#3	1.74113e-18
C180	VGND	X#2	2.00179e-17
C181	VPWR	a_86_260##13	1.05237e-17
C182	X	A#1	1.72549e-19
C183	VPWR	VPWR#6	2.10748e-17
C184	VGND#4	VNB	3.08119e-17
C185	VPWR	X#6	1.25777e-17
C186	X	a_86_260#	1.51043e-19
C187	VGND	X#1	1.66812e-17
C188	VPWR	VPWR#7	2.17985e-17
C189	VPWR#4	VNB	2.62005e-17
C190	X	a_86_260##5	3.95285e-19
C191	VPWR#2	VNB	3.38314e-17
C192	VPWR	X#4	1.13673e-17
C193	A	A#4	2.02994e-18
C194	X	a_86_260##7	1.14251e-18
C195	VGND	VGND#5	3.49131e-17
C196	a_86_260##14	VNB	6.41031e-17
C197	VPWR	VPWR#5	3.95101e-17
C198	A	A#3	2.92506e-18
C199	X	a_86_260##10	2.23903e-18
C200	a_86_260##3	VPWR#3	4.25118e-19
C201	A#5	VNB	3.82661e-18
C202	A	a_86_260##4	4.55553e-19
C203	VGND	VPWR#6	3.23195e-18
C204	X#3	VNB	6.56309e-18
C205	X#2	VNB	6.65429e-18
C206	VGND	X#6	1.80526e-18
C207	VGND#3	a_86_260##3	9.37242e-20
C208	A	a_86_260##8	2.23887e-19
C209	X#1	VNB	2.5708e-18
C210	a_86_260##3	A#2	3.28392e-17
C211	VGND#7	VNB	3.5176e-18
C212	VGND	VPWR#5	4.06447e-18
C213	A	a_86_260##12	1.92612e-19
C214	VGND	A#1	8.41539e-19
C215	VGND#5	VNB	6.11063e-17
C216	VGND	a_86_260#	1.12151e-18
C217	VPWR	A#4	3.43601e-18
C218	VPWR#1	VNB	5.99688e-17
C219	a_86_260##13	VNB	2.23005e-17
C220	VGND	a_86_260##5	1.59135e-19
C221	VPWR	A#3	6.49986e-18
C222	VPWR#6	VNB	6.22714e-18
C223	VGND	a_86_260##7	1.65944e-19
C224	X#6	VNB	5.1074e-18
C225	VPWR	a_86_260##4	2.92019e-18
C226	X	a_86_260##12	2.00107e-18
C227	VGND	a_86_260##10	4.46601e-18
C228	VPWR#7	VNB	2.15458e-19
C229	VPWR	a_86_260##8	2.48616e-18
C230	X#4	VNB	4.60374e-18
C231	VPWR#5	VNB	8.4932e-17
C232	VPWR	a_86_260##11	1.06766e-18
C233	A#1	VNB	3.14594e-17
C234	A	A#2	7.28832e-18
C235	a_86_260#	VNB	2.97876e-17
C236	VPWR	a_86_260##12	4.22127e-18
C237	a_86_260##5	VNB	2.76577e-17
C238	a_86_260##3	A	9.56916e-18
C239	a_86_260##7	VNB	2.82983e-17
C240	a_86_260##10	VNB	3.53506e-17
C241	X	A#2	4.74221e-21
C242	VPWR	VPWR#3	7.20272e-18
C243	A#4	VNB	3.05656e-17
C244	X	a_86_260##3	2.37544e-17
C245	A#3	VNB	3.18748e-17
C246	a_86_260##4	VNB	3.25266e-17
C247	a_86_260##8	VNB	3.15627e-17
C248	VPWR	a_86_260##3	6.81335e-18
C249	a_86_260##11	VNB	2.817e-17
C250	VGND	VGND#3	8.74818e-18
C251	a_86_260##12	VNB	5.24351e-17
C252	VGND	A#2	2.03794e-20
C253	VGND	a_86_260##3	1.10851e-17
C254	VPWR#3	VNB	1.6334e-16
C255	VGND#3	VNB	1.66191e-16
C256	VPWR	A	2.69606e-18
C257	A#2	VNB	6.135e-17
C258	a_86_260##3	VNB	7.93605e-17
C259	VPWR	X	1.41375e-18
C260	A	VNB	2.28166e-18
C261	X	VNB	1.16916e-17
C262	VPWR	VNB	5.72028e-17
C263	VGND	VNB	5.80342e-17
C264	VGND#2	A#1	1.86846e-17
C265	VGND#2	a_86_260##14	6.97187e-17
C266	VGND#3	VGND#2	6.17974e-17
C267	VGND#2	a_86_260#	1.62707e-17
C268	VGND#2	VGND#6	1.48709e-17
C269	VGND#4	VGND#2	1.39171e-18
C270	VGND#2	A#2	2.57997e-18
C271	VGND#2	a_86_260##5	1.45273e-18
C272	VGND#2	X#1	3.93836e-17
C273	VGND	VGND#2	7.08089e-17
C274	VGND#2	a_86_260##3	2.44942e-17
C275	VGND#2	a_86_260##7	3.46898e-19
C276	VGND#7	VGND#2	2.8254e-18
C277	VGND#2	VNB	5.77847e-17
*
*
.ENDS sky130_fd_sc_hs__buf_4
*
