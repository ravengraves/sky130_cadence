* Extracted by Quantus, converted by sky130cad/quantus.py
*
*
*
*                       LINUX           Wed Nov 18 08:29:20 2026
*
*
*
*  PROGRAM  advgen
*
*  Name           : advgen - Quantus - (64-bit)
*  Version        : 25.1.0-p047
*  Build Date     : Thu Dec 11 23:20:30 PST 2025
*
*  HSPICE LIBRARY
*
*  OPERATING_TEMPERATURE 150
*  QRC_TECH_DIR <path>/tech
*
*
*

*
.SUBCKT sky130_fd_sc_hs__dfxtp_2 VPB VNB VGND VPWR Q D CLK
*
*
*  caps2d version: 10
*
*
*       TRANSISTOR CARDS
*
*
XM24 a_27_74##13 CLK#3 VGND#14 VNB sky130_fd_pr__nfet_01v8_lvt l=0.15 w=0.74 ad=0.2109 as=0.3256 pd=2.05 ps=2.36
XM11 VGND#14 a_27_74# a_206_368##14 VNB sky130_fd_pr__nfet_01v8_lvt l=0.15 w=0.74 ad=0.3256 as=0.2775 pd=2.36 ps=2.23
XM25 VGND#13 D#3 a_431_508# VNB sky130_fd_pr__nfet_01v8_lvt l=0.15 w=0.42 ad=0.318675 as=0.1176 pd=2.49 ps=1.4
XM7 a_431_508# a_27_74##6 a_538_429##7 VNB sky130_fd_pr__nfet_01v8_lvt l=0.15 w=0.42 ad=0.1176 as=0.15225 pd=1.4 ps=1.67
XM22 a_538_429##7 a_206_368# a_708_101# VNB sky130_fd_pr__nfet_01v8_lvt l=0.15 w=0.42 ad=0.15225 as=0.1008 pd=1.67 ps=1.32
XM8 a_708_101# a_695_459##3 VGND#12 VNB sky130_fd_pr__nfet_01v8_lvt l=0.15 w=0.42 ad=0.1008 as=0.4176 pd=1.32 ps=2.81
XM14 VGND#12 a_538_429# a_695_459##5 VNB sky130_fd_pr__nfet_01v8_lvt l=0.15 w=0.55 ad=0.4176 as=0.154 pd=2.81 ps=1.66
XM3 a_695_459##5 a_206_368##5 a_1019_424##4 VNB sky130_fd_pr__nfet_01v8_lvt l=0.15 w=0.55 ad=0.154 as=0.24555 pd=1.66 ps=2.35
XM23 a_1019_424##4 a_27_74##8 a_1172_124# VNB sky130_fd_pr__nfet_01v8_lvt l=0.15 w=0.42 ad=0.24555 as=0.1008 pd=2.35 ps=1.32
XM10 a_1172_124# a_1217_314##3 VGND#11 VNB sky130_fd_pr__nfet_01v8_lvt l=0.15 w=0.42 ad=0.1008 as=0.1197 pd=1.32 ps=1.41
XM9 a_1217_314##14 a_1019_424##3 VGND#10 VNB sky130_fd_pr__nfet_01v8_lvt l=0.15 w=0.64 ad=0.1824 as=0.281 pd=1.85 ps=2.28
XM4 VGND#10 a_1217_314##9 Q#3 VNB sky130_fd_pr__nfet_01v8_lvt l=0.15 w=0.74 ad=0.281 as=0.2072 pd=2.28 ps=2.04
XM12 Q#3 a_1217_314##4 VGND#1 VNB sky130_fd_pr__nfet_01v8_lvt l=0.15 w=0.74 ad=0.2072 as=0.2109 pd=2.04 ps=2.05
XM0 a_27_74##16 CLK#1 VPWR#14 VPB sky130_fd_pr__pfet_01v8 l=0.15 w=1.12 ad=0.3304 as=0.336 pd=2.83 ps=2.84
XM20 VPWR#14 a_27_74##3 a_206_368##11 VPB sky130_fd_pr__pfet_01v8 l=0.15 w=1.12 ad=0.336 as=0.3304 pd=2.84 ps=2.83
XM13 VPWR#13 D#1 a_431_508##2 VPB sky130_fd_pr__pfet_01v8 l=0.15 w=0.42 ad=0.2474 as=0.230825 pd=2.13 ps=2.4
XM18 a_431_508##2 a_206_368##3 a_538_429##5 VPB sky130_fd_pr__pfet_01v8 l=0.15 w=0.42 ad=0.230825 as=0.225225 pd=2.4 ps=2.35
XM1 a_538_429##5 a_27_74##4 a_644_504# VPB sky130_fd_pr__pfet_01v8 l=0.15 w=0.42 ad=0.225225 as=0.1134 pd=2.35 ps=1.38
XM21 a_644_504# a_695_459# VPWR#12 VPB sky130_fd_pr__pfet_01v8 l=0.15 w=0.42 ad=0.1134 as=0.41965 pd=1.38 ps=3.21
XM19 VPWR#12 a_538_429##3 a_695_459##8 VPB sky130_fd_pr__pfet_01v8 l=0.15 w=0.84 ad=0.41965 as=0.525 pd=3.21 ps=2.93
XM5 a_695_459##8 a_27_74##7 a_1019_424##6 VPB sky130_fd_pr__pfet_01v8 l=0.15 w=0.84 ad=0.525 as=0.2814 pd=2.93 ps=2.44
XM17 a_1019_424##6 a_206_368##6 a_1125_508# VPB sky130_fd_pr__pfet_01v8 l=0.15 w=0.42 ad=0.2814 as=0.1995 pd=2.44 ps=1.79
XM6 a_1125_508# a_1217_314# VPWR#11 VPB sky130_fd_pr__pfet_01v8 l=0.15 w=0.42 ad=0.1995 as=0.1218 pd=1.79 ps=1.42
XM15 a_1217_314##10 a_1019_424# VPWR#10 VPB sky130_fd_pr__pfet_01v8 l=0.15 w=1 ad=0.295 as=0.3868 pd=2.59 ps=2.95
XM16 VPWR#10 a_1217_314##7 Q#1 VPB sky130_fd_pr__pfet_01v8 l=0.15 w=1.12 ad=0.3868 as=0.336 pd=2.95 ps=2.84
XM2 Q#1 a_1217_314##8 VPWR#1 VPB sky130_fd_pr__pfet_01v8 l=0.15 w=1.12 ad=0.336 as=0.3304 pd=2.84 ps=2.83
*
*
*       RESISTOR AND CAP/DIODE CARDS
*
Rg1	CLK#1	CLK#2	448.815094
Rg2	CLK#2	CLK#3	345.814911
Rg3	a_27_74#	a_27_74##2	305.221649
Rg4	a_27_74##2	a_27_74##3	489.343506
Rg5	D#1	D#2	254.610550
Rg6	D#3	D#4	351.666504
Rg7	a_27_74##4	a_27_74##5	343.249695
Rg8	a_27_74##5	a_27_74##6	620.137207
Rg9	a_206_368#	a_206_368##2	1948.114746
Rg10	a_206_368##2	a_206_368##3	811.958069
Rg11	a_695_459#	a_695_459##2	842.608337
Rg12	a_695_459##2	a_695_459##3	229.758881
Rg13	a_695_459##2	a_695_459##4	45.642662
Rg14	a_538_429#	a_538_429##2	628.228455
Rg15	a_538_429##2	a_538_429##3	354.206909
Rg16	a_206_368##4	a_206_368##5	315.735504
Rg17	a_206_368##6	a_206_368##7	226.096359
Rg18	a_27_74##7	a_27_74##8	1277.226318
Rg19	a_27_74##8	a_27_74##9	216.119781
Rg20	a_1217_314#	a_1217_314##2	345.383423
Rg21	a_1217_314##2	a_1217_314##3	503.028717
Rg22	a_1019_424#	a_1019_424##2	467.472931
Rg23	a_1019_424##2	a_1019_424##3	316.209290
Rg24	a_1217_314##4	a_1217_314##5	398.540497
Rg25	a_1217_314##5	a_1217_314##6	74.487549
Rg26	a_1217_314##6	a_1217_314##7	444.766602
Rg27	a_1217_314##5	a_1217_314##8	452.032623
Rg28	a_1217_314##6	a_1217_314##9	402.759521
Rf1	CLK#4	CLK#2	161.607086
Rf2	CLK	CLK#6	1.374290
Rf3	CLK#4	CLK#6	6.881835
Rf4	D#4	D	160.429642
Rf5	D	D#2	220.918350
Rf6	a_431_508#	a_431_508##2	125.478722
Rf7	a_538_429##2	a_538_429##6	277.456421
Rf8	a_538_429##6	a_538_429##7	130.384872
Rf9	a_538_429##5	a_538_429##6	15.000000
Rf10	a_695_459##5	a_695_459##6	53.021481
Rf11	a_695_459##6	a_695_459##4	176.989853
Rf12	a_695_459##6	a_695_459##8	76.928574
Rf13	a_206_368##7	a_206_368##9	258.354767
Rf14	a_206_368##9	a_206_368##10	254.771896
Rf15	a_206_368##10	a_206_368##11	7.923862
Rf16	a_206_368##9	a_206_368##4	265.932739
Rf17	a_206_368##10	a_206_368##13	21.803570
Rf18	a_206_368##13	a_206_368##14	64.264206
Rf19	a_206_368##13	a_206_368##2	163.428116
Rf20	a_27_74##9	a_27_74##11	325.052917
Rf21	a_27_74##11	a_27_74##12	324.101044
Rf22	a_27_74##12	a_27_74##13	54.029877
Rf23	a_27_74##11	a_27_74##5	249.210266
Rf24	a_27_74##12	a_27_74##15	10.340556
Rf25	a_27_74##15	a_27_74##16	90.623344
Rf26	a_1019_424##4	a_1019_424##5	54.827812
Rf27	a_1019_424##5	a_1019_424##6	122.816956
Rf28	a_1019_424##5	a_1019_424##2	252.184143
Rf29	a_1217_314##10	a_1217_314##11	29.583679
Rf30	a_1217_314##11	a_1217_314##2	119.955353
Rf31	a_1217_314##11	a_1217_314##13	52.939377
Rf32	a_1217_314##13	a_1217_314##14	95.732506
Rf33	Q	Q#2	10.870378
Rf34	Q#2	Q	2.536422
Rf35	Q	Q#3	108.309883
Rf36	Q#1	Q#2	5.000000
Rf37	VPWR#1	VPWR#2	99.538162
Rf38	VPWR#2	VPWR#3	20.064354
Rf39	VPWR#3	VPWR#4	73.366684
Rf40	VPWR#4	VPWR#5	182.183914
Rf41	VPWR#5	VPWR#6	39.759983
Rf42	VPWR#6	VPWR#7	117.205635
Rf43	VPWR#7	VPWR#8	74.934395
Rf45	VPWR#3	VPWR#10	39.014511
Rf46	VPWR#4	VPWR#11	34.507496
Rf47	VPWR#5	VPWR#12	21.562443
Rf48	VPWR#7	VPWR#13	22.084719
Rf49	VPWR#8	VPWR#14	53.143215
Rf50	VGND#1	VGND#2	92.317253
Rf51	VGND#2	VGND#3	16.982487
Rf52	VGND#3	VGND#4	77.224617
Rf53	VGND#4	VGND#5	166.563416
Rf54	VGND#5	VGND#6	54.820686
Rf55	VGND#6	VGND#7	93.400505
Rf56	VGND#7	VGND#8	103.295143
Rf58	VGND#3	VGND#10	33.850044
Rf59	VGND#4	VGND#11	44.349312
Rf60	VGND#5	VGND#12	28.841251
Rf61	VGND#7	VGND#13	40.594666
Rf62	VGND#8	VGND#14	39.841232
Rf73	a_27_74##2	a_27_74##15	160.232803
Rf76	a_1217_314##6	a_1217_314##13	160.232803
Re1	VPWR#2	VPWR	3.735117
Re2	VPWR	VPWR#6	1.067176
Re3	VGND#2	VGND	3.735117
Re4	VGND	VGND#6	1.067176
*
*       CAPACITOR CARDS
*
*
C1	VGND#3	a_27_74##9	1.50102e-19
C2	a_1217_314##7	VPWR#10	2.24723e-17
C3	a_206_368##9	a_695_459##8	8.67321e-17
C4	VGND#5	a_206_368##5	4.38778e-18
C5	a_27_74##11	a_431_508##2	2.78054e-18
C6	a_1217_314##2	VPWR#4	1.06936e-18
C7	a_1019_424##5	a_1217_314##6	1.32412e-18
C8	CLK#6	CLK#1	3.76208e-18
C9	a_1217_314##3	a_1019_424##3	3.37106e-18
C10	a_1217_314##10	a_1217_314##7	3.2582e-19
C11	VGND#6	a_27_74##11	6.73106e-17
C12	VPWR#1	a_1217_314#	1.27514e-19
C13	VGND#4	a_206_368##5	4.30825e-19
C14	VPWR#10	a_1019_424#	5.26534e-17
C15	a_1019_424##2	a_1217_314##11	5.55166e-17
C16	a_27_74##11	a_695_459##6	2.26899e-17
C17	VPWR#11	a_1217_314##7	3.4113e-19
C18	a_206_368##9	VPWR#12	3.53791e-18
C19	a_1019_424#	a_1217_314##10	1.70819e-17
C20	VGND#5	a_538_429#	4.56647e-18
C21	VGND#1	VPWR#1	1.03343e-17
C22	a_1019_424##5	a_1019_424##2	2.24747e-18
C23	a_206_368##9	VPWR#6	1.91135e-17
C24	VPWR#10	a_1217_314#	1.12647e-18
C25	a_27_74##8	a_1217_314##3	4.55269e-17
C26	a_27_74##12	a_206_368##11	7.94762e-17
C27	a_1217_314##5	Q#1	1.59832e-19
C28	VPWR#11	a_1019_424#	2.41209e-18
C29	VGND#4	a_538_429#	2.41853e-19
C30	a_1217_314##10	a_1217_314#	3.21329e-18
C31	VGND#4	a_206_368##4	1.63265e-19
C32	a_695_459##6	a_695_459##8	1.42915e-18
C33	VPWR#11	a_1217_314#	2.76068e-17
C34	a_206_368##7	VPWR#4	3.06536e-17
C35	a_1019_424##5	a_1217_314##2	5.04501e-17
C36	VGND#5	a_695_459##3	1.82682e-18
C37	a_206_368##11	a_27_74#	1.77784e-19
C38	a_1217_314##10	a_206_368##6	1.46951e-19
C39	a_27_74##12	VPWR#14	4.45838e-18
C40	a_206_368##5	a_27_74##8	8.4159e-18
C41	VGND#5	a_538_429##2	1.61592e-20
C42	a_206_368##9	a_538_429##5	3.22759e-17
C43	VPWR#11	a_206_368##6	1.8917e-18
C44	a_695_459##2	a_538_429#	2.35993e-17
C45	a_431_508#	a_206_368##3	2.05174e-18
C46	VGND#7	a_206_368#	1.29992e-17
C47	VPWR#4	VPWR#3	1.36997e-18
C48	a_27_74##9	a_1019_424##5	4.35484e-18
C49	VGND#5	a_206_368#	4.8316e-19
C50	a_27_74##12	a_27_74##16	1.85326e-18
C51	VPWR#11	a_27_74##7	2.05768e-20
C52	a_538_429#	a_206_368##5	3.20076e-17
C53	a_206_368##6	a_1019_424##6	1.04786e-17
C54	a_1019_424##5	a_1217_314##9	3.65356e-20
C55	VGND#2	VGND#1	4.86955e-17
C56	VGND#2	Q#3	2.08866e-17
C57	VPWR#11	a_538_429##3	1.1102e-20
C58	VPWR#5	a_538_429##2	4.44868e-19
C59	VPWR#5	a_538_429#	2.64558e-20
C60	a_1019_424##6	a_27_74##7	3.09454e-17
C61	a_1019_424##5	a_206_368##7	3.17918e-17
C62	a_27_74##11	a_27_74##9	1.85131e-18
C63	a_431_508#	a_538_429##7	6.07961e-17
C64	a_695_459##3	a_538_429#	7.85376e-18
C65	VGND#4	a_1019_424##5	1.49607e-18
C66	a_27_74##7	a_695_459##8	3.03386e-17
C67	CLK#6	a_27_74##12	1.93947e-17
C68	a_1019_424##5	a_1019_424##3	3.35657e-20
C69	VGND#2	a_1217_314##14	2.19382e-17
C70	VPWR#2	a_1217_314##5	2.01982e-20
C71	a_206_368#	a_538_429#	9.51195e-19
C72	VGND#7	D#3	7.50298e-19
C73	a_206_368##4	a_1019_424##5	5.35206e-17
C74	a_695_459##8	a_538_429##3	2.85772e-17
C75	a_206_368##11	a_206_368##9	1.38691e-18
C76	a_206_368#	a_695_459##3	3.60177e-17
C77	a_538_429##3	VPWR#12	1.35475e-17
C78	a_1019_424##5	a_1217_314##3	1.70465e-17
C79	a_538_429##5	a_27_74##7	5.60729e-19
C80	VGND#7	D#4	4.02792e-19
C81	a_695_459##8	a_695_459#	6.14579e-19
C82	VGND#7	a_27_74##12	3.14397e-17
C83	a_695_459##6	a_206_368##9	4.86654e-19
C84	a_206_368#	a_695_459##2	6.64973e-18
C85	a_1019_424##5	a_538_429##2	1.80796e-19
C86	a_695_459#	VPWR#12	1.20871e-17
C87	a_538_429##5	a_538_429##3	8.95959e-19
C88	a_206_368#	a_27_74##6	3.95199e-17
C89	a_1217_314##6	Q#3	4.7894e-17
C90	a_1217_314##14	a_1217_314##11	4.18684e-19
C91	a_206_368##14	a_431_508#	1.89615e-18
C92	a_27_74##9	a_695_459##6	2.10868e-18
C93	a_1019_424##5	a_27_74##8	3.03885e-17
C94	a_206_368##9	a_206_368##7	4.14954e-18
C95	a_1217_314##6	VGND#10	2.67243e-18
C96	a_206_368#	D#3	1.91953e-17
C97	a_538_429##5	a_695_459#	9.85617e-18
C98	a_1217_314##14	a_1217_314##6	2.04011e-18
C99	VGND#7	a_27_74##11	2.76578e-17
C100	a_27_74##11	a_538_429##2	1.55504e-18
C101	Q#3	a_1019_424##2	5.06782e-19
C102	VGND#11	a_1217_314##6	2.24039e-18
C103	D#3	a_27_74##6	3.73996e-17
C104	a_538_429##5	a_27_74##4	2.34572e-17
C105	a_206_368##4	a_206_368##9	1.74839e-18
C106	a_27_74##11	a_1217_314##3	2.43471e-20
C107	a_27_74##6	a_695_459##2	4.32009e-18
C108	a_1019_424##2	a_1217_314##14	4.90092e-17
C109	a_1019_424##4	a_1217_314##6	1.67398e-19
C110	a_431_508##2	a_27_74##4	3.7337e-19
C111	VPWR#2	VPWR#1	4.85029e-17
C112	VGND#5	a_27_74##11	2.51105e-17
C113	VGND#7	a_206_368##2	1.27244e-17
C114	a_27_74##11	a_695_459##4	5.94357e-17
C115	a_206_368##11	a_695_459#	2.19358e-19
C116	VGND#11	a_1019_424##2	2.75145e-17
C117	VPWR#7	D#2	1.05207e-18
C118	a_206_368##3	a_538_429##5	1.74208e-17
C119	a_695_459##6	a_206_368##4	6.3973e-17
C120	a_1217_314##11	VPWR#4	6.5381e-19
C121	a_431_508##2	a_206_368##3	4.14171e-17
C122	a_538_429##2	a_206_368##9	4.34374e-17
C123	a_1019_424##5	a_538_429#	3.31275e-19
C124	a_206_368##11	a_27_74##4	6.21162e-19
C125	VGND#2	VPWR#1	4.93889e-18
C126	a_27_74##11	a_27_74##8	5.38005e-20
C127	a_538_429##5	D#1	1.90648e-18
C128	VGND#11	a_1217_314##2	1.13308e-18
C129	Q#3	a_1217_314##5	1.70618e-17
C130	VPWR#2	a_1217_314##10	1.40144e-17
C131	a_27_74##11	a_27_74##5	2.18429e-18
C132	VGND#11	a_1019_424##5	8.94525e-18
C133	D#1	a_431_508##2	1.17639e-17
C134	VGND#10	a_27_74##9	2.17289e-19
C135	CLK#3	a_27_74#	1.91911e-17
C136	a_695_459##6	a_538_429##2	2.66018e-17
C137	VPWR#7	a_206_368##2	8.56835e-19
C138	a_206_368##11	a_206_368##3	9.47899e-18
C139	a_538_429##5	a_27_74##3	4.09301e-19
C140	a_1217_314##11	VPWR#3	2.22431e-19
C141	a_1217_314##14	a_27_74##9	2.8313e-19
C142	D#1	VPWR#13	5.74048e-18
C143	a_27_74##11	a_206_368##5	3.9585e-19
C144	a_27_74##9	VGND#11	1.32453e-17
C145	a_431_508##2	a_27_74##3	3.1694e-19
C146	a_27_74##12	D#4	4.44693e-18
C147	a_206_368##11	D#1	3.17687e-17
C148	a_27_74##11	D#4	3.39504e-18
C149	a_27_74##13	VGND#14	3.77155e-17
C150	VGND#6	a_695_459##2	8.60972e-20
C151	VPWR#14	D#1	3.73687e-19
C152	a_27_74##9	a_1019_424##4	4.52023e-17
C153	a_206_368##9	a_27_74##5	1.03913e-18
C154	a_206_368##11	a_27_74##3	6.73806e-17
C155	a_27_74##9	a_695_459##5	3.6021e-17
C156	a_27_74##11	a_538_429#	1.98294e-17
C157	VGND#12	a_27_74##9	4.56167e-19
C158	a_27_74##3	VPWR#14	2.16417e-17
C159	a_27_74##12	D#2	3.46814e-18
C160	a_206_368##11	CLK#1	3.86452e-18
C161	a_27_74##5	a_695_459##6	1.89556e-18
C162	a_1019_424##4	a_1019_424##5	2.27336e-18
C163	a_27_74##16	a_27_74##3	7.5405e-18
C164	a_1217_314##6	VPWR#10	3.29453e-17
C165	CLK#1	VPWR#14	2.97094e-17
C166	a_1217_314##6	a_1217_314##5	3.93448e-18
C167	a_27_74##11	a_695_459##3	2.57336e-17
C168	a_27_74##16	CLK#1	6.14081e-17
C169	a_27_74##12	a_206_368##2	5.41953e-17
C170	a_1019_424##4	a_206_368##4	2.37423e-17
C171	CLK#6	a_27_74##16	3.72726e-17
C172	a_1217_314##7	a_1217_314##8	4.55384e-17
C173	a_27_74##11	a_206_368##2	9.18768e-19
C174	a_695_459##5	a_206_368##4	2.60774e-18
C175	a_27_74##12	a_206_368#	1.47665e-19
C176	a_27_74##11	VGND#11	7.14131e-19
C177	a_206_368#	a_695_459#	8.00601e-19
C178	a_27_74##11	a_206_368#	5.36902e-17
C179	VPWR#10	a_1217_314##2	4.45786e-19
C180	a_27_74##12	a_27_74##2	2.01299e-17
C181	a_1019_424#	a_1217_314##7	3.56164e-17
C182	a_1217_314##2	a_1217_314##10	2.23811e-17
C183	a_1217_314#	a_1217_314##7	3.62144e-19
C184	a_1217_314##2	VPWR#11	2.18561e-17
C185	a_206_368#	a_206_368##3	3.15052e-19
C186	a_206_368##11	VPWR#6	1.75026e-17
C187	a_695_459##6	a_27_74##8	3.00409e-19
C188	VPWR#10	VPWR#1	1.67619e-18
C189	a_27_74##11	a_27_74##6	9.85262e-18
C190	VPWR#3	a_1217_314##8	8.07062e-19
C191	a_1217_314#	a_1019_424#	4.51795e-18
C192	VGND#2	a_1217_314##4	4.3428e-18
C193	a_206_368##9	a_538_429#	3.11244e-19
C194	a_27_74##12	CLK#2	3.78719e-17
C195	a_1019_424##6	a_1217_314##2	3.19869e-18
C196	D#3	a_206_368##3	5.06084e-18
C197	VGND#2	a_1217_314##9	1.21744e-18
C198	a_27_74##12	D#3	7.07722e-19
C199	a_27_74##11	a_695_459##2	1.1276e-17
C200	VPWR#4	a_1217_314##7	3.18633e-19
C201	a_206_368##7	a_1217_314##10	6.01352e-18
C202	VGND#1	a_1217_314##4	2.38063e-17
C203	VGND#2	a_1019_424##3	4.50822e-19
C204	a_695_459##6	a_206_368##5	1.1091e-19
C205	a_206_368##6	a_1217_314#	1.01587e-17
C206	a_27_74##11	D#3	2.33802e-17
C207	a_206_368##7	VPWR#11	2.67849e-17
C208	VPWR#3	a_1217_314##7	2.85702e-18
C209	Q#3	a_1217_314##4	4.10222e-17
C210	a_538_429##7	a_27_74##5	6.06004e-17
C211	a_27_74##12	a_27_74#	2.70501e-17
C212	a_1019_424##6	a_206_368##7	5.51959e-17
C213	VGND#1	a_1217_314##9	1.33717e-18
C214	a_27_74##11	a_695_459##5	2.82191e-17
C215	a_431_508#	a_27_74##5	7.19623e-19
C216	a_695_459##6	a_538_429#	2.03304e-17
C217	a_27_74##7	a_206_368##6	1.74241e-17
C218	a_1217_314##6	a_1217_314##4	1.45443e-19
C219	VGND#10	a_1217_314##4	9.26244e-19
C220	a_538_429##7	a_538_429##5	4.33848e-18
C221	a_206_368##9	a_206_368#	8.08166e-21
C222	CLK#6	a_27_74##2	1.65244e-19
C223	a_1217_314##10	VPWR#10	6.31768e-17
C224	a_1217_314##6	a_1217_314##9	2.05974e-18
C225	Q#3	a_1217_314##9	3.94355e-17
C226	a_206_368##4	a_1019_424##6	4.8486e-17
C227	VPWR#3	a_1019_424#	3.65415e-18
C228	a_538_429##7	D#4	1.30599e-19
C229	VGND#5	a_27_74##7	1.48165e-19
C230	a_1217_314##6	a_1019_424##3	1.20604e-18
C231	a_431_508#	D#4	6.79886e-18
C232	a_695_459##8	a_206_368##4	2.27868e-17
C233	VPWR#5	a_1217_314#	5.61278e-20
C234	VGND#1	a_1019_424##3	4.18169e-19
C235	a_27_74##12	CLK#3	1.42424e-17
C236	a_431_508#	a_538_429##5	1.85148e-17
C237	a_538_429##3	a_27_74##7	1.06007e-17
C238	a_27_74##11	VGND#12	8.22825e-17
C239	VGND#4	a_27_74##7	4.31952e-20
C240	VGND#13	D#4	7.60985e-19
C241	a_1019_424##2	a_1217_314##9	4.6145e-18
C242	a_1217_314##6	a_1217_314##3	2.32594e-19
C243	a_1217_314##9	VGND#10	1.65329e-17
C244	VPWR#11	VPWR#10	5.15868e-18
C245	VPWR#3	VPWR#1	7.44308e-19
C246	VPWR#4	a_1217_314#	6.74637e-18
C247	CLK#6	CLK#2	9.21835e-18
C248	Q#3	a_1019_424##3	9.17047e-19
C249	a_1217_314##6	a_27_74##8	1.05354e-19
C250	a_695_459##8	a_538_429##2	6.14827e-17
C251	a_1217_314##3	a_1019_424##2	3.94058e-18
C252	a_1217_314##14	a_1217_314##9	5.23063e-18
C253	VPWR#3	a_1217_314#	2.80793e-19
C254	a_538_429##2	VPWR#12	4.32489e-18
C255	VGND#5	a_695_459##2	3.13081e-21
C256	a_695_459#	a_538_429##3	2.86556e-17
C257	VPWR#11	a_1217_314##10	2.79586e-17
C258	a_1019_424##2	a_27_74##8	6.47555e-20
C259	VPWR#5	a_206_368##6	6.9041e-20
C260	a_1019_424##3	VGND#10	2.17791e-17
C261	VGND#6	a_206_368#	1.90536e-17
C262	a_695_459##4	a_695_459##8	1.0733e-18
C263	a_538_429##5	a_538_429##2	1.46039e-18
C264	VGND#11	a_1217_314##9	2.11474e-19
C265	a_431_508#	a_206_368##2	4.52326e-19
C266	VPWR#4	a_206_368##6	3.95686e-18
C267	VGND#6	a_27_74##6	1.58322e-18
C268	a_27_74##9	a_1019_424##3	1.70404e-18
C269	a_27_74##8	a_1217_314##2	3.41694e-17
C270	a_1217_314##14	a_1019_424##3	5.34058e-17
C271	a_27_74##4	a_695_459#	3.28125e-17
C272	VGND#13	a_206_368##2	7.93732e-18
C273	VPWR#2	a_1217_314##8	8.89519e-18
C274	a_206_368##9	a_644_504#	3.20259e-18
C275	a_206_368##14	a_206_368##2	8.93383e-18
C276	a_27_74##9	a_1217_314##3	1.28932e-17
C277	a_1217_314##11	a_1019_424#	1.23859e-17
C278	VPWR#2	a_1217_314##7	9.54184e-18
C279	D#1	a_538_429##3	1.83494e-20
C280	a_27_74##11	a_538_429##7	7.62109e-17
C281	a_27_74##9	a_27_74##8	2.35927e-19
C282	VPWR#5	a_27_74##7	6.31415e-18
C283	VGND#11	a_1019_424##3	2.24303e-18
C284	a_431_508#	a_206_368##11	7.8087e-19
C285	VPWR#2	a_1019_424#	4.72517e-18
C286	a_206_368##3	a_27_74##4	1.61929e-17
C287	a_27_74##9	a_206_368##5	3.49993e-17
C288	a_1217_314##14	a_1217_314##3	1.14328e-18
C289	a_1019_424##4	a_1217_314##9	1.64721e-20
C290	a_538_429##5	a_27_74##5	9.05364e-17
C291	VPWR#4	a_27_74##7	1.71763e-19
C292	a_27_74##8	a_206_368##7	2.28824e-17
C293	a_27_74##9	a_538_429#	1.07821e-17
C294	a_27_74##2	VGND#14	1.03597e-18
C295	D#1	a_27_74##4	2.66044e-18
C296	a_431_508##2	a_27_74##5	2.51781e-18
C297	a_1217_314##10	VPWR#4	4.45403e-18
C298	a_27_74##9	a_695_459##3	1.28912e-19
C299	VGND#11	a_1217_314##3	3.8428e-17
C300	a_27_74##11	a_431_508#	7.11141e-17
C301	D#1	a_206_368##3	1.06708e-17
C302	VGND#3	a_1217_314##5	4.49249e-20
C303	a_206_368##4	a_27_74##8	2.17889e-17
C304	a_206_368#	a_27_74##9	1.2631e-19
C305	a_206_368##11	a_27_74##5	2.58141e-19
C306	VPWR#5	a_538_429##3	1.47036e-17
C307	a_1019_424##4	a_1019_424##3	4.12379e-20
C308	a_27_74##12	VGND#13	6.0185e-17
C309	a_431_508##2	D#4	4.45225e-18
C310	a_1217_314##6	a_1217_314##8	1.92265e-18
C311	a_27_74##3	a_206_368##3	3.28087e-19
C312	a_1217_314##10	VPWR#3	5.25325e-18
C313	VPWR#4	a_538_429##3	3.80087e-20
C314	CLK#2	a_27_74##13	3.82131e-17
C315	a_538_429#	a_206_368##4	1.59299e-17
C316	a_538_429##2	a_27_74##8	7.56589e-19
C317	a_1217_314##6	a_1217_314##7	6.20657e-18
C318	VGND#11	a_27_74##8	3.11541e-18
C319	a_538_429##5	D#2	3.96912e-20
C320	a_206_368##11	D#4	2.64685e-18
C321	a_27_74##3	D#1	2.49138e-18
C322	a_695_459##5	a_695_459##2	7.40449e-20
C323	VGND#7	a_206_368##3	1.55671e-19
C324	VPWR#7	a_695_459#	6.0788e-19
C325	D#2	a_431_508##2	6.43132e-17
C326	a_1217_314##6	a_1019_424#	7.19862e-18
C327	a_1019_424##4	a_1217_314##3	3.18252e-18
C328	a_27_74##11	VGND#13	3.83552e-17
C329	D#2	VPWR#13	3.24054e-18
C330	a_27_74##12	a_206_368##14	1.04946e-16
C331	VPWR#5	a_695_459#	1.23016e-17
C332	a_538_429##5	a_206_368##2	2.39919e-19
C333	a_206_368##11	D#2	7.113e-17
C334	a_206_368##9	VPWR#5	8.75708e-17
C335	CLK#1	a_27_74##3	4.86488e-17
C336	VGND#11	a_206_368##5	3.4137e-19
C337	a_695_459##5	a_1217_314##3	2.9103e-19
C338	a_431_508##2	a_206_368##2	7.84949e-18
C339	VPWR#11	VPWR#3	8.92791e-19
C340	VPWR#6	a_695_459#	2.34716e-18
C341	a_1019_424##4	a_27_74##8	2.89894e-17
C342	a_1217_314##2	a_1019_424#	8.93974e-18
C343	a_206_368##11	a_206_368##2	3.49162e-17
C344	VPWR#6	a_27_74##4	5.57611e-18
C345	VPWR#7	a_27_74##4	1.54448e-18
C346	a_695_459##4	a_206_368#	3.0569e-19
C347	a_695_459##6	a_1019_424##4	1.47538e-18
C348	VPWR#6	a_206_368##3	9.37457e-19
C349	a_206_368##9	VPWR#4	2.23397e-17
C350	a_27_74##12	VGND#14	7.58239e-17
C351	a_695_459##5	a_27_74##8	1.51212e-18
C352	VGND#11	a_538_429#	1.02896e-19
C353	VPWR#5	a_27_74##4	2.37933e-18
C354	a_206_368##11	a_27_74##2	5.95702e-18
C355	a_695_459##2	VGND#12	2.43736e-18
C356	a_206_368##5	a_1019_424##4	1.24379e-17
C357	a_206_368#	a_27_74##5	8.33157e-18
C358	a_27_74##7	a_1217_314##2	2.01076e-18
C359	a_206_368##7	a_1019_424#	3.77404e-19
C360	a_27_74##11	a_708_101#	6.76277e-18
C361	a_1019_424##5	a_27_74##7	1.279e-17
C362	a_27_74##5	a_27_74##6	9.26779e-19
C363	a_1217_314##11	VPWR#10	3.06129e-18
C364	a_695_459##2	a_538_429##2	4.9483e-17
C365	a_206_368##7	a_1217_314#	2.17698e-17
C366	a_27_74##13	a_27_74##16	3.00164e-19
C367	a_27_74##9	a_27_74##7	1.43464e-18
C368	a_695_459##5	a_206_368##5	2.85838e-17
C369	a_206_368#	D#4	1.63089e-18
C370	a_206_368##11	CLK#2	3.68373e-19
C371	VPWR#7	a_206_368##3	8.88007e-19
C372	a_206_368##7	a_206_368##6	1.88564e-17
C373	a_27_74##13	a_27_74##12	2.74505e-18
C374	D#4	a_27_74##6	3.86539e-19
C375	a_1019_424##4	a_538_429#	1.54595e-19
C376	a_27_74##7	a_206_368##7	2.65416e-17
C377	CLK#2	a_27_74##16	4.07047e-18
C378	VGND#12	a_206_368##5	4.3592e-19
C379	a_206_368##4	a_27_74##7	4.37459e-17
C380	a_695_459##5	a_538_429#	2.18319e-17
C381	a_1217_314##11	a_1217_314##10	2.57237e-19
C382	a_206_368##2	a_206_368#	2.46855e-19
C383	VPWR#7	D#1	1.38203e-17
C384	a_538_429##2	a_27_74##7	1.76162e-17
C385	Q#3	VGND#1	7.42264e-17
C386	a_538_429#	VGND#12	9.63404e-18
C387	a_538_429##5	a_695_459##8	1.95182e-19
C388	a_1217_314##6	VPWR#2	5.75557e-18
C389	a_206_368##2	D#3	6.87465e-18
C390	a_538_429##2	a_538_429##3	7.18861e-18
C391	VPWR#5	D#1	1.2572e-18
C392	a_695_459##4	a_695_459##2	2.15462e-17
C393	VPWR#5	VPWR#12	6.83601e-18
C394	a_695_459##5	a_695_459##3	3.68075e-19
C395	a_27_74#	a_206_368##2	2.19243e-17
C396	a_538_429##2	a_695_459#	2.81937e-17
C397	VGND#2	a_1217_314##6	3.79301e-18
C398	VPWR#2	a_1019_424##2	3.31381e-18
C399	VGND#2	a_1019_424##2	5.30723e-18
C400	a_695_459##3	VGND#12	1.63405e-17
C401	VGND#10	VGND#1	2.43267e-18
C402	a_538_429##2	a_206_368##3	1.27028e-19
C403	Q	a_1217_314##5	7.9761e-18
C404	a_27_74##5	a_538_429##3	2.65543e-19
C405	a_206_368##9	a_695_459##2	3.7119e-19
C406	VPWR#7	a_27_74##3	2.14846e-18
C407	CLK#3	a_27_74##2	9.33609e-19
C408	a_695_459##5	a_206_368#	1.1377e-19
C409	a_27_74##5	a_695_459#	3.02376e-17
C410	VGND#4	VGND#3	1.16362e-18
C411	a_206_368##9	a_206_368##6	1.10447e-18
C412	a_1019_424##2	a_1217_314##6	7.22724e-17
C413	VGND#12	a_206_368#	3.44386e-18
C414	a_206_368##3	a_27_74##5	3.6718e-17
C415	a_538_429##7	a_695_459##2	2.08779e-18
C416	VGND#10	Q#3	3.68971e-17
C417	a_538_429##7	a_695_459##3	9.03637e-19
C418	a_1217_314##2	a_1217_314##6	3.18617e-18
C419	a_27_74##11	a_695_459#	7.08109e-20
C420	a_27_74##5	a_695_459##2	3.88397e-17
C421	D#4	a_206_368##3	7.11808e-18
C422	VPWR#7	CLK#1	6.79139e-19
C423	a_1217_314##2	a_1019_424##2	3.11917e-17
C424	a_27_74##12	a_27_74##11	2.95068e-18
C425	a_431_508#	a_695_459##3	1.52162e-19
C426	D#2	a_206_368##3	1.44203e-17
C427	a_206_368##9	a_27_74##7	4.67173e-17
C428	a_1217_314##14	Q#3	2.64941e-17
C429	a_431_508##2	a_538_429##5	6.72721e-17
C430	a_1217_314##3	a_1172_124#	9.87534e-18
C431	a_538_429##7	a_206_368#	2.88429e-17
C432	a_27_74##8	a_1172_124#	9.87534e-18
C433	a_27_74##3	D#2	5.94034e-18
C434	a_206_368##7	a_1217_314##2	4.92135e-17
C435	a_431_508#	a_206_368#	2.74998e-18
C436	a_27_74##3	a_206_368##2	7.50159e-18
C437	VPWR#6	a_27_74##5	2.49045e-19
C438	a_206_368##4	a_1217_314##2	9.68949e-20
C439	a_1217_314##14	VGND#10	5.86752e-17
C440	a_538_429##7	a_27_74##6	2.72468e-17
C441	a_206_368##9	a_538_429##3	3.93451e-17
C442	a_206_368##6	a_1125_508#	1.13814e-17
C443	VGND#6	a_27_74##5	2.11876e-19
C444	a_27_74##9	a_206_368##4	4.44527e-18
C445	VGND#13	a_206_368#	3.36671e-18
C446	a_695_459##6	a_27_74##7	1.03667e-18
C447	VPWR#5	a_695_459##2	2.54484e-19
C448	a_206_368##11	a_538_429##5	4.05809e-17
C449	CLK#2	a_27_74##3	1.86491e-18
C450	a_27_74##6	a_431_508#	1.2934e-17
C451	a_27_74##11	a_206_368##3	3.40374e-19
C452	VPWR#7	VPWR#13	6.21699e-18
C453	a_538_429##7	D#3	1.4214e-18
C454	VGND#2	VGND#4	1.54939e-17
C455	a_27_74##12	D	3.0411e-17
C456	a_538_429##2	a_206_368##4	6.66253e-18
C457	a_695_459#	a_644_504#	8.29449e-18
C458	a_206_368##9	a_695_459#	3.59986e-17
C459	a_27_74##11	D	1.1079e-17
C460	a_206_368##11	a_431_508##2	3.20821e-17
C461	VGND	a_695_459##2	1.95379e-19
C462	a_27_74##4	a_644_504#	6.13814e-18
C463	VGND#2	VGND#3	9.24609e-17
C464	a_431_508#	D#3	2.23629e-17
C465	a_695_459##3	a_708_101#	1.93272e-18
C466	a_695_459##4	a_538_429##2	3.22863e-17
C467	a_206_368#	a_708_101#	3.93084e-18
C468	a_206_368##14	a_27_74##6	1.59219e-19
C469	VGND#11	a_1217_314##14	4.66348e-17
C470	a_206_368##11	VPWR#13	2.18226e-18
C471	a_27_74##5	a_538_429##2	2.62376e-17
C472	VPWR#2	VPWR#4	1.31818e-17
C473	D#3	VGND#13	9.62321e-18
C474	a_206_368##11	VPWR#7	7.74325e-17
C475	a_27_74##5	a_695_459##4	1.18005e-17
C476	a_206_368##9	a_27_74##4	2.78911e-17
C477	VPWR#2	VPWR#3	6.25512e-17
C478	a_431_508#	a_27_74#	1.80564e-19
C479	a_1019_424##5	a_206_368##9	2.19003e-18
C480	a_206_368##14	D#3	3.37653e-19
C481	a_27_74##12	a_27_74##3	3.52937e-18
C482	D#4	a_27_74##5	1.74329e-18
C483	VPWR	VPWR#7	9.1494e-17
C484	VPWR	VPWR#5	1.07885e-16
C485	VGND#3	VGND#1	1.29067e-18
C486	VPWR	VPWR#4	1.09702e-16
C487	VGND#13	a_27_74#	4.16404e-19
C488	D	a_431_508#	3.02597e-17
C489	VPWR	a_1217_314##11	8.51427e-19
C490	a_1217_314##5	VNB	3.8213e-17
C491	a_695_459##6	a_695_459##2	3.1911e-19
C492	a_206_368##2	a_27_74##5	5.61938e-19
C493	a_695_459##2	VNB	6.53483e-17
C494	VPWR	a_1019_424##5	7.60909e-18
C495	VPWR#14	a_206_368##11	5.37212e-17
C496	a_206_368##9	a_206_368##3	4.83507e-19
C497	Q#3	Q	2.41297e-18
C498	VPWR	a_27_74##12	2.41247e-18
C499	a_27_74#	a_206_368##14	1.67836e-17
C500	a_206_368##2	D#4	4.31714e-17
C501	VPWR#14	VPWR#7	2.11116e-18
C502	a_206_368##7	a_1125_508#	3.09806e-18
C503	D#2	a_206_368##2	4.68702e-17
C504	VPWR	a_206_368##9	5.91067e-17
C505	VGND#13	CLK#3	6.91152e-20
C506	a_27_74##12	CLK#1	3.75658e-18
C507	VGND	VGND#7	7.85079e-17
C508	VGND	VGND#5	8.10426e-17
C509	VGND	VGND#4	1.08683e-16
C510	VPWR	a_695_459##6	3.60638e-19
C511	a_27_74##16	a_206_368##11	2.68268e-17
C512	a_27_74#	VGND#14	2.31921e-17
C513	VGND#3	a_1217_314##4	5.40664e-18
C514	VGND#3	Q#3	1.72959e-17
C515	a_27_74##2	a_206_368##2	2.51474e-17
C516	VPWR	CLK#6	3.43457e-18
C517	VPWR#2	a_1217_314##11	1.51196e-18
C518	D	a_431_508##2	1.94826e-17
C519	Q	VPWR#1	1.05385e-16
C520	Q	Q#1	7.76816e-19
C521	VGND	a_1217_314##11	4.24355e-19
C522	a_206_368##11	D	4.67627e-17
C523	VPWR#10	Q	8.07758e-17
C524	a_206_368##9	D#1	2.4284e-19
C525	VGND	a_1019_424##5	7.4113e-18
C526	a_1217_314##10	Q	1.37275e-18
C527	VGND#4	VGND#10	2.47918e-18
C528	a_27_74##13	a_27_74#	6.50473e-19
C529	VGND	a_27_74##12	4.02055e-17
C530	CLK#2	a_27_74##2	3.82683e-17
C531	VGND	a_27_74##11	6.28509e-17
C532	a_27_74##16	VPWR#14	7.28878e-17
C533	a_1019_424##4	VGND#11	1.37741e-17
C534	VGND#4	a_1217_314##9	3.42768e-19
C535	VPWR	a_538_429##7	1.36832e-18
C536	VGND#14	CLK#3	2.90884e-17
C537	VGND	a_695_459##6	3.76301e-18
C538	D	a_206_368#	4.19936e-19
C539	VGND#7	VNB	3.5167e-17
C540	VGND#5	VNB	4.56729e-17
C541	VGND#4	VNB	5.87007e-17
C542	VGND#3	VNB	4.0016e-17
C543	VGND#3	a_1217_314##6	7.83692e-19
C544	VPWR#7	VNB	4.77543e-17
C545	D	a_27_74#	3.35836e-19
C546	VPWR#5	VNB	5.49735e-17
C547	a_27_74##13	CLK#3	2.0587e-17
C548	VGND#3	a_1217_314##9	6.6528e-18
C549	VPWR#4	VNB	5.54268e-17
C550	VPWR	a_1019_424##6	6.46523e-18
C551	VPWR#3	VNB	2.23667e-17
C552	VGND#2	a_1217_314##11	3.1264e-18
C553	VPWR	a_695_459##8	6.35071e-18
C554	VGND	a_1019_424##4	9.91451e-18
C555	VGND	a_695_459##5	7.67817e-18
C556	a_1217_314##11	VNB	5.81124e-18
C557	VGND	VGND#12	1.47047e-17
C558	VPWR	a_538_429##5	9.51224e-18
C559	a_1019_424##5	VNB	1.13701e-17
C560	a_695_459##5	VGND#11	2.67354e-18
C561	VPWR	a_431_508##2	5.72976e-18
C562	VGND	a_538_429##7	9.48181e-18
C563	a_27_74##12	VNB	1.69902e-17
C564	VGND	a_431_508#	8.44876e-18
C565	a_27_74##11	VNB	2.82365e-17
C566	VPWR	a_206_368##11	5.8407e-17
C567	VGND	VGND#13	9.50796e-18
C568	VGND	a_206_368##14	7.46631e-18
C569	VGND#4	a_1217_314##14	1.14111e-17
C570	VPWR	a_27_74##16	2.02859e-17
C571	VGND	a_27_74##13	1.47973e-17
C572	a_206_368##9	VNB	5.67012e-18
C573	a_695_459##6	VNB	4.54561e-18
C574	a_695_459##6	a_1019_424##5	1.92436e-18
C575	VGND#4	a_1019_424##3	2.00235e-18
C576	Q	a_1217_314##8	3.31093e-17
C577	Q	a_1217_314##7	3.16283e-17
C578	VGND	a_1019_424##6	7.96115e-19
C579	CLK#6	VNB	1.21755e-17
C580	Q	a_1019_424#	1.71274e-18
C581	VGND#1	VNB	6.59168e-17
C582	Q#3	VNB	1.32245e-17
C583	VGND#4	a_1019_424##2	1.28924e-18
C584	VGND#10	VNB	3.36304e-18
C585	VGND	a_538_429##5	2.31313e-18
C586	a_1217_314##14	VNB	1.15486e-17
C587	VGND	a_431_508##2	1.82354e-18
C588	VGND#11	VNB	9.81674e-18
C589	VPWR	D#3	2.42659e-19
C590	a_1019_424##4	VNB	9.37273e-20
C591	VGND	a_206_368##11	3.45464e-18
C592	a_695_459##5	VNB	1.6144e-19
C593	VGND#12	VNB	1.62032e-18
C594	a_538_429##7	VNB	5.08344e-18
C595	a_431_508#	VNB	7.71484e-18
C596	VGND#13	VNB	8.64045e-19
C597	VGND#3	a_1019_424##2	9.02244e-20
C598	a_206_368##14	VNB	1.03571e-18
C599	VGND#14	VNB	1.79688e-18
C600	VGND	a_1217_314##3	4.47925e-18
C601	VGND#3	a_1019_424##3	5.08294e-18
C602	a_27_74##13	VNB	4.03291e-17
C603	VPWR#1	VNB	7.67506e-17
C604	VPWR	a_1217_314#	1.0591e-18
C605	VGND	a_206_368##5	4.7117e-18
C606	VGND#3	a_1217_314##14	9.95472e-18
C607	VPWR#10	VNB	1.54605e-18
C608	VGND	a_538_429#	4.64878e-18
C609	VPWR	a_206_368##6	1.04157e-18
C610	a_1217_314##10	VNB	7.71098e-18
C611	VGND	a_695_459##3	7.75917e-18
C612	VPWR	a_27_74##7	6.49343e-18
C613	VPWR#11	VNB	6.99373e-18
C614	VGND	a_206_368#	1.57758e-17
C615	VPWR	a_538_429##3	7.83361e-19
C616	a_1019_424##6	VNB	2.85257e-18
C617	Q	VPWR#2	3.84382e-17
C618	a_695_459##8	VNB	2.91204e-18
C619	VPWR	a_695_459#	8.95943e-18
C620	a_1019_424##4	a_27_74##7	1.02037e-18
C621	VGND	a_27_74#	1.98085e-18
C622	VPWR	a_27_74##4	1.12382e-17
C623	a_538_429##5	VNB	1.05169e-17
C624	VGND	CLK#3	1.60056e-18
C625	VPWR	a_206_368##3	2.37875e-18
C626	a_431_508##2	VNB	1.71686e-18
C627	VPWR	D#1	7.57234e-19
C628	a_206_368##11	VNB	2.39301e-17
C629	VPWR	a_27_74##3	3.35393e-18
C630	VPWR#14	VNB	3.10958e-18
C631	a_1217_314##6	Q	3.352e-17
C632	a_27_74##16	VNB	4.83707e-17
C633	VPWR	CLK#1	1.7165e-18
C634	a_1217_314##4	VNB	3.56465e-17
C635	a_1217_314##9	VNB	2.95284e-17
C636	a_1019_424##3	VNB	3.15271e-17
C637	a_1217_314##9	a_1217_314##4	3.94977e-17
C638	a_1217_314##3	VNB	3.33494e-17
C639	a_27_74##8	VNB	4.60369e-17
C640	a_206_368##5	VNB	2.09043e-17
C641	D	a_27_74##5	4.15737e-20
C642	VGND#4	a_1217_314##3	2.26909e-18
C643	a_538_429#	VNB	4.78238e-17
C644	VPWR	VPWR#6	5.69042e-17
C645	a_695_459##5	a_27_74##7	7.44667e-19
C646	a_695_459##3	VNB	2.52592e-17
C647	D	D#4	1.66348e-17
C648	a_206_368#	VNB	1.2676e-16
C649	a_695_459##5	a_1019_424##4	2.39006e-17
C650	VGND	a_206_368##3	3.88055e-19
C651	a_27_74##6	VNB	3.33364e-17
C652	D#3	VNB	3.13515e-17
C653	D	D#2	5.43806e-19
C654	a_27_74#	VNB	3.19053e-17
C655	VPWR	a_1019_424##2	9.88028e-19
C656	VPWR#1	a_1217_314##8	2.93557e-17
C657	CLK#3	VNB	3.27989e-17
C658	D	a_206_368##2	1.57721e-17
C659	VPWR	a_1217_314##2	5.76244e-18
C660	a_1217_314##8	VNB	3.97258e-17
C661	D	a_27_74##2	4.41777e-19
C662	a_1217_314##7	VNB	3.70709e-17
C663	a_1019_424#	VNB	3.96904e-17
C664	VPWR	a_206_368##7	1.84807e-17
C665	a_1217_314#	VNB	3.88862e-17
C666	VPWR	a_206_368##4	3.59005e-18
C667	a_206_368##6	VNB	1.85447e-17
C668	a_27_74##7	VNB	6.54818e-17
C669	VGND	VGND#6	5.64301e-17
C670	VPWR	a_538_429##2	7.46525e-18
C671	a_538_429##3	VNB	3.70618e-17
C672	a_695_459#	VNB	5.66956e-17
C673	VPWR	a_695_459##4	2.67369e-19
C674	a_27_74##4	VNB	3.11383e-17
C675	VGND	a_1019_424##2	1.71019e-18
C676	VPWR	a_27_74##5	6.49113e-18
C677	a_206_368##3	VNB	5.37858e-17
C678	VGND	a_1217_314##2	3.92684e-18
C679	D#1	VNB	3.2973e-17
C680	VPWR	D#4	5.24993e-19
C681	VGND	a_27_74##9	4.00661e-17
C682	a_27_74##3	VNB	4.3533e-17
C683	CLK#1	VNB	4.51437e-17
C684	VPWR	D#2	6.86975e-18
C685	VGND	a_206_368##4	7.38667e-18
C686	VPWR	a_206_368##2	1.49057e-18
C687	VPWR#2	VNB	1.37248e-16
C688	a_1217_314##8	Q#1	2.43796e-17
C689	VGND	a_538_429##2	3.7321e-18
C690	VGND#2	VNB	1.20513e-16
C691	VPWR#6	VNB	3.04324e-17
C692	VGND	a_695_459##4	3.79784e-18
C693	VGND#6	VNB	2.64084e-17
C694	VGND	a_27_74##5	2.59436e-18
C695	a_1217_314##6	VNB	3.23375e-17
C696	VGND	D#4	2.65579e-18
C697	a_1019_424##2	VNB	6.18131e-17
C698	a_1217_314##2	VNB	6.4798e-17
C699	a_27_74##9	VNB	5.25227e-17
C700	VGND	a_206_368##2	3.64715e-18
C701	a_206_368##7	VNB	3.28911e-17
C702	VGND	a_27_74##2	2.43525e-19
C703	a_206_368##4	VNB	3.82694e-17
C704	a_206_368##9	a_1019_424##6	8.0781e-17
C705	a_538_429##2	VNB	5.43693e-17
C706	VGND	CLK#2	3.25479e-18
C707	VPWR#1	a_1217_314##7	1.22489e-18
C708	a_27_74##11	a_538_429##5	7.58242e-19
C709	a_695_459##4	VNB	5.18581e-18
C710	a_27_74##5	VNB	7.2514e-17
C711	a_538_429##5	a_206_368#	1.19235e-18
C712	D#4	VNB	3.03732e-17
C713	D#2	VNB	3.03064e-17
C714	a_206_368##2	VNB	1.41206e-16
C715	a_27_74##2	VNB	3.03554e-17
C716	CLK#2	VNB	6.5905e-17
C717	VPWR#10	a_1217_314##8	6.24441e-19
C718	a_1019_424##3	a_1217_314##9	2.12461e-17
C719	VPWR#3	a_1019_424##2	1.31252e-19
C720	VGND#5	a_27_74##9	3.93787e-17
C721	CLK#6	a_27_74##3	2.83275e-19
C722	VPWR	D	9.64176e-19
C723	a_1217_314##7	Q#1	2.01419e-17
C724	VGND	D	4.95947e-18
C725	VGND#4	a_27_74##9	6.95462e-17
C726	D	VNB	6.00632e-19
C727	a_431_508##2	a_206_368#	1.31301e-19
C728	Q	VNB	7.7748e-18
C729	VPWR	VNB	2.94862e-16
C730	VGND	VNB	3.03881e-16
C731	a_1217_314##10	a_1217_314##8	1.40145e-19
C732	a_27_74##12	VPWR#8	2.24962e-19
C733	VGND#8	a_27_74##12	3.66687e-17
C734	VGND#8	VNB	5.42833e-17
C735	VGND#8	VGND#7	3.05999e-19
C736	VPWR#8	CLK#2	1.54809e-19
C737	VGND#8	a_27_74##2	9.56684e-20
C738	VGND#8	a_27_74##13	1.76844e-17
C739	VGND#8	CLK#3	4.9665e-18
C740	VPWR#8	VPWR#7	7.52649e-19
C741	VPWR#8	D#1	1.80685e-19
C742	a_206_368##11	VPWR#8	9.24198e-18
C743	VPWR#8	CLK#1	5.58143e-18
C744	VGND#8	VGND#13	4.80602e-20
C745	a_27_74##16	VPWR#8	2.11169e-17
C746	VPWR	VPWR#8	8.83952e-17
C747	VPWR#8	VNB	4.59895e-17
C748	VGND#8	CLK#2	1.55626e-19
C749	VPWR#8	a_27_74##2	1.04761e-19
C750	VGND	VGND#8	1.02683e-16
C751	VPWR#8	a_27_74##3	6.63405e-18
C752	VGND#8	a_206_368##2	8.96849e-19
C753	VGND#8	a_27_74#	6.40412e-18
*
*
.ENDS sky130_fd_sc_hs__dfxtp_2
*
