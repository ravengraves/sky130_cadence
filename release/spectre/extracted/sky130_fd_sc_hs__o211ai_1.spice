* Extracted by Quantus, converted by sky130cad/quantus.py
*
*
*
*                       LINUX           Wed Nov 18 08:54:18 2026
*
*
*
*  PROGRAM  advgen
*
*  Name           : advgen - Quantus - (64-bit)
*  Version        : 25.1.0-p047
*  Build Date     : Thu Dec 11 23:20:30 PST 2025
*
*  HSPICE LIBRARY
*
*  OPERATING_TEMPERATURE 150
*  QRC_TECH_DIR <path>/tech
*
*
*

*
.SUBCKT sky130_fd_sc_hs__o211ai_1 VNB VPB VGND VPWR Y B1 C1 A1 A2
*
*
*  caps2d version: 10
*
*
*       TRANSISTOR CARDS
*
*
XM4 a_31_74##2 A1#1 VGND#4 VNB sky130_fd_pr__nfet_01v8_lvt l=0.15 w=0.74 ad=0.2109 as=0.259 pd=2.05 ps=2.18
XM2 VGND#4 A2#1 a_31_74# VNB sky130_fd_pr__nfet_01v8_lvt l=0.15 w=0.74 ad=0.259 as=0.2331 pd=2.18 ps=2.11
XM7 a_31_74# B1#3 a_311_74# VNB sky130_fd_pr__nfet_01v8_lvt l=0.15 w=0.74 ad=0.2331 as=0.3108 pd=2.11 ps=2.32
XM1 a_311_74# C1#3 Y#1 VNB sky130_fd_pr__nfet_01v8_lvt l=0.15 w=0.74 ad=0.3108 as=0.4588 pd=2.32 ps=2.72
XM0 VPWR#4 A1#4 a_116_368# VPB sky130_fd_pr__pfet_01v8 l=0.15 w=1.12 ad=0.3304 as=0.3024 pd=2.83 ps=2.78
XM6 a_116_368# A2#3 Y#4 VPB sky130_fd_pr__pfet_01v8 l=0.15 w=1.12 ad=0.3024 as=0.6384 pd=2.78 ps=3.38
XM3 Y#4 B1#1 VPWR#5 VPB sky130_fd_pr__pfet_01v8 l=0.15 w=1.12 ad=0.6384 as=0.392 pd=3.38 ps=2.94
XM5 VPWR#5 C1#1 Y#5 VPB sky130_fd_pr__pfet_01v8 l=0.15 w=1.12 ad=0.392 as=0.3304 pd=2.94 ps=2.83
*
*
*       RESISTOR AND CAP/DIODE CARDS
*
Rg1	A1#1	A1#2	368.862610
Rg2	A1#2	A1#3	28.628225
Rg3	A1#2	A1#4	471.862823
Rg4	A2#1	A2#2	353.846649
Rg5	A2#2	A2#3	456.846832
Rg6	B1#1	B1#2	456.846832
Rg7	B1#2	B1#3	353.846649
Rg8	C1#1	C1#2	495.178009
Rg9	C1#2	C1#3	404.323944
Rf1	A1	A1#3	168.106262
Rf2	A2	A2#2	177.550385
Rf3	a_31_74#	a_31_74##2	101.289673
Rf4	B1	B1#2	166.047348
Rf5	C1	C1#2	163.775864
Rf6	Y	Y#2	3.925415
Rf7	Y#2	Y#3	72.232285
Rf8	Y#3	Y#4	90.874123
Rf9	Y#2	Y	6.589870
Rf10	Y#3	Y#5	17.643423
Rf11	Y#1	Y#2	3.750000
Rf13	VPWR#2	VPWR#3	31.387180
Rf14	VPWR#3	VPWR#4	132.633575
Rf15	VPWR#2	VPWR#5	34.487274
Rf16	VGND#1	VGND#2	46.727783
Rf18	VGND#2	VGND#4	35.885353
Re1	VPWR#3	VPWR	1.637070
Re2	VGND	VGND#1	1.637131
*
*       CAPACITOR CARDS
*
*
C1	VGND	VNB	6.12575e-17
C2	VPWR	VNB	6.05727e-17
C3	Y	VNB	4.52214e-17
C4	B1	VNB	4.00028e-18
C5	C1	VNB	6.93141e-18
C6	A1	VNB	1.17305e-17
C7	A2	VNB	4.16226e-18
C8	A1#3	VNB	7.0572e-17
C9	A2#2	VNB	3.75861e-17
C10	VGND	Y	2.7911e-17
C11	B1#2	VNB	3.28515e-17
C12	C1#2	VNB	4.02619e-17
C13	VGND#1	VNB	2.03173e-16
C14	VGND	B1	1.43204e-17
C15	VPWR#3	VNB	1.65695e-16
C16	A1#4	VNB	4.20212e-17
C17	VGND	C1	3.97737e-18
C18	A2#3	VNB	3.13366e-17
C19	B1#1	VNB	3.59457e-17
C20	C1#1	VNB	3.68886e-17
C21	VPWR	B1	3.00647e-18
C22	A1#1	VNB	3.43523e-17
C23	A2#1	VNB	2.54882e-17
C24	B1#3	VNB	2.76687e-17
C25	VPWR	C1	2.5936e-18
C26	C1#3	VNB	3.46958e-17
C27	VPWR#4	VNB	7.89668e-17
C28	B1	Y	3.93464e-17
C29	Y#4	VNB	9.20907e-18
C30	VPWR	A1	2.51901e-18
C31	VPWR#5	VNB	1.76005e-18
C32	a_31_74##2	VNB	4.06605e-17
C33	Y	C1	3.9761e-17
C34	VGND#4	VNB	1.32095e-18
C35	VPWR	A2	1.23098e-17
C36	a_31_74#	VNB	9.52836e-18
C37	B1	C1	3.8149e-17
C38	VGND	A1#3	5.25134e-18
C39	Y#3	VNB	9.31774e-17
C40	VGND	A2#2	4.86022e-18
C41	VGND	B1#2	5.52287e-20
C42	VGND	C1#2	3.32079e-19
C43	VGND	VGND#1	4.76983e-17
C44	VPWR	A2#2	3.75538e-18
C45	B1	a_311_74#	2.45091e-17
C46	A1	A2	1.79807e-17
C47	VPWR	VPWR#3	2.06336e-17
C48	VGND	A1#1	8.12707e-19
C49	VGND	A2#1	8.57273e-19
C50	VPWR	A1#4	5.63501e-18
C51	VGND	B1#3	9.82678e-19
C52	B1	A1#3	1.49172e-19
C53	Y	C1#2	7.69952e-18
C54	VGND	C1#3	2.01134e-18
C55	VPWR	A2#3	3.8357e-18
C56	A2#2	B1	2.50401e-17
C57	VGND#1	Y	3.08151e-17
C58	VPWR	B1#1	2.06109e-18
C59	B1	B1#2	2.11407e-17
C60	VPWR	C1#1	7.50348e-19
C61	VGND	Y#4	3.86842e-18
C62	B1	C1#2	6.62371e-18
C63	VGND	a_31_74##2	1.74382e-17
C64	A2	a_116_368#	3.70807e-17
C65	VGND#1	B1	1.3152e-17
C66	VGND	a_31_74#	1.4776e-17
C67	A1	A1#3	1.07225e-17
C68	C1	B1#2	2.86634e-18
C69	C1	C1#2	1.9891e-17
C70	VPWR	VPWR#4	3.91212e-17
C71	A1	A2#2	8.8105e-18
C72	VGND#1	C1	7.99467e-19
C73	A2	A1#3	1.53561e-18
C74	VPWR	Y#4	1.87998e-17
C75	VPWR	VPWR#5	2.19206e-17
C76	VGND	Y#3	6.84367e-18
C77	A2	A2#2	1.81244e-18
C78	Y	B1#3	4.90839e-18
C79	A2	B1#2	3.41169e-19
C80	Y	C1#3	3.03039e-17
C81	A2	C1#2	1.75568e-19
C82	B1	A1#1	4.08841e-19
C83	B1	A2#1	1.49595e-18
C84	A1	A1#4	6.13654e-18
C85	B1	B1#3	1.42778e-17
C86	A2	VPWR#3	6.18666e-18
C87	B1	C1#3	1.05281e-17
C88	B1#2	a_311_74#	3.94024e-19
C89	A1	A2#3	2.65941e-19
C90	VPWR	Y#3	2.87477e-17
C91	A2	A1#4	2.22203e-17
C92	B1	Y#4	3.38109e-17
C93	Y	Y#1	1.34279e-17
C94	C1	B1#3	1.92283e-19
C95	A2	A2#3	1.97209e-17
C96	A2	B1#1	1.3072e-18
C97	A1#3	A2#2	4.96565e-17
C98	A2	C1#1	1.34478e-19
C99	a_31_74#	B1	6.14226e-17
C100	Y	Y#3	7.56444e-18
C101	A2#2	B1#2	2.92418e-17
C102	A1	VPWR#4	2.59989e-17
C103	A1#4	a_116_368#	1.24929e-17
C104	A2#3	a_116_368#	7.06404e-18
C105	VPWR#4	A2	6.31554e-17
C106	B1	Y#3	1.17845e-17
C107	VGND#1	A2#2	4.657e-20
C108	B1#2	C1#2	2.69887e-17
C109	A2#2	VPWR#3	9.28573e-19
C110	A2	Y#4	6.08023e-17
C111	VGND#1	B1#2	1.16625e-19
C112	VPWR#3	B1#2	1.08291e-19
C113	VGND#1	C1#2	1.64305e-19
C114	B1#3	a_311_74#	1.07667e-17
C115	C1	Y#3	3.14442e-17
C116	C1#3	a_311_74#	6.81137e-18
C117	B1#2	C1#1	1.86557e-18
C118	VPWR#3	A2#3	5.11399e-18
C119	A1#3	VPWR#4	5.77195e-18
C120	a_31_74##2	a_116_368#	1.81681e-19
C121	VPWR#3	B1#1	3.48685e-18
C122	A1#4	A2#3	5.70847e-17
C123	B1#3	C1#2	9.97517e-19
C124	A2#2	Y#4	1.87581e-17
C125	A1#3	a_31_74##2	3.83832e-17
C126	VGND#1	B1#3	4.83839e-18
C127	A2#3	B1#1	1.76943e-17
C128	Y#4	B1#2	3.62499e-18
C129	VGND#1	C1#3	7.28243e-18
C130	a_31_74##2	A2#2	2.45138e-17
C131	A2#2	VGND#4	1.36668e-18
C132	B1#1	C1#1	3.82025e-17
C133	A2#2	a_31_74#	3.64249e-17
C134	VPWR#5	C1#2	4.18198e-19
C135	VPWR#3	VPWR#4	3.12433e-17
C136	Y#4	VPWR#3	2.17709e-17
C137	A1#4	VPWR#4	3.91186e-17
C138	Y#3	A1#3	2.02668e-19
C139	VPWR#4	A2#3	4.05118e-18
C140	C1#2	Y#1	9.77477e-19
C141	VGND#1	a_31_74#	1.57541e-17
C142	Y#4	A1#4	4.70761e-18
C143	Y#3	A2#2	1.35199e-19
C144	VPWR#4	B1#1	4.00079e-19
C145	VPWR#5	A1#4	5.77008e-19
C146	A1#1	A2#1	2.36875e-17
C147	Y#4	A2#3	2.16937e-17
C148	Y#3	B1#2	5.97364e-19
C149	VPWR#5	A2#3	2.58995e-18
C150	Y#4	B1#1	8.00677e-17
C151	A2#1	B1#3	3.4964e-17
C152	VPWR#5	B1#1	5.42167e-17
C153	Y#3	C1#2	8.35561e-18
C154	Y#4	C1#1	7.40929e-19
C155	C1#1	VPWR#5	2.88761e-17
C156	B1#3	C1#3	2.28169e-17
C157	C1#1	Y#5	1.16542e-17
C158	a_31_74##2	A1#1	5.25884e-17
C159	A1#1	VGND#4	1.93247e-17
C160	a_31_74##2	A2#1	1.71796e-18
C161	VPWR#4	Y#4	3.75234e-18
C162	a_31_74#	A1#1	8.07544e-19
C163	VGND#4	A2#1	3.60439e-17
C164	a_31_74##2	B1#3	2.2152e-19
C165	VPWR#4	VPWR#5	4.43507e-19
C166	Y#3	A2#3	2.14594e-19
C167	a_31_74#	A2#1	3.44064e-17
C168	VGND#4	B1#3	1.49558e-18
C169	Y#3	B1#1	6.96281e-18
C170	B1#3	a_31_74#	1.87126e-17
C171	VGND#4	C1#3	5.77412e-19
C172	Y#4	VPWR#5	5.37504e-17
C173	a_31_74#	C1#3	2.18929e-18
C174	Y#3	C1#1	4.8871e-17
C175	C1#3	Y#1	1.22462e-17
C176	a_31_74#	Y#4	1.01997e-17
C177	a_31_74##2	VGND#4	6.07538e-17
C178	a_31_74##2	a_31_74#	2.73774e-18
C179	a_31_74#	VGND#4	4.76763e-17
C180	Y#4	Y#3	2.47096e-18
C181	Y#3	VPWR#5	1.07601e-16
C182	Y#3	Y#5	4.53204e-18
C183	VGND#2	B1#3	7.09586e-19
C184	VGND#2	a_31_74##2	2.10217e-17
C185	VPWR#3	VPWR#2	5.43346e-17
C186	Y#3	VPWR#2	3.25859e-17
C187	VGND#2	A2#1	4.42063e-18
C188	VPWR	VPWR#2	3.6809e-17
C189	VPWR#4	VPWR#2	3.08729e-19
C190	VPWR#2	VNB	4.89554e-17
C191	VPWR#2	C1#1	2.60157e-18
C192	VGND#2	VNB	4.58601e-17
C193	VGND#2	a_31_74#	2.1064e-18
C194	VGND#2	A1#1	5.34434e-18
C195	VGND#2	A2#2	5.89493e-21
C196	Y#4	VPWR#2	3.22396e-19
C197	VGND#2	C1#3	3.79909e-19
C198	VPWR#2	B1#1	2.36815e-18
C199	VGND#1	VGND#2	5.04715e-17
C200	VPWR#2	C1#2	4.87781e-20
C201	VGND#2	A1#3	9.73954e-19
C202	VGND	VGND#2	5.10098e-17
*
*
.ENDS sky130_fd_sc_hs__o211ai_1
*
