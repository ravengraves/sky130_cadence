* Extracted by Quantus, converted by sky130cad/quantus.py
*
*
*
*                       LINUX           Wed Nov 18 08:59:53 2026
*
*
*
*  PROGRAM  advgen
*
*  Name           : advgen - Quantus - (64-bit)
*  Version        : 25.1.0-p047
*  Build Date     : Thu Dec 11 23:20:30 PST 2025
*
*  HSPICE LIBRARY
*
*  OPERATING_TEMPERATURE 150
*  QRC_TECH_DIR <path>/tech
*
*
*

*
.SUBCKT sky130_fd_sc_hs__o2bb2ai_1 VNB VPB VGND VPWR Y A2_N A1_N B2 B1
*
*
*  caps2d version: 10
*
*
*       TRANSISTOR CARDS
*
*
XM8 VGND#4 A1_N#4 a_114_74# VNB sky130_fd_pr__nfet_01v8_lvt l=0.15 w=0.64 ad=0.1824 as=0.1536 pd=1.85 ps=1.76
XM9 a_114_74# A2_N#3 a_131_383##5 VNB sky130_fd_pr__nfet_01v8_lvt l=0.15 w=0.64 ad=0.1536 as=0.1824 pd=1.76 ps=1.85
XM5 Y#3 a_131_383##4 a_397_74##2 VNB sky130_fd_pr__nfet_01v8_lvt l=0.15 w=0.74 ad=0.2109 as=0.259 pd=2.05 ps=2.18
XM3 a_397_74##2 B2#1 VGND#5 VNB sky130_fd_pr__nfet_01v8_lvt l=0.15 w=0.74 ad=0.259 as=0.2072 pd=2.18 ps=2.04
XM6 VGND#5 B1#3 a_397_74# VNB sky130_fd_pr__nfet_01v8_lvt l=0.15 w=0.74 ad=0.2072 as=0.2109 pd=2.04 ps=2.05
XM7 VPWR#4 A1_N#1 a_131_383##7 VPB sky130_fd_pr__pfet_01v8 l=0.15 w=0.84 ad=0.2898 as=0.252 pd=2.37 ps=2.28
XM0 a_131_383##7 A2_N#1 VPWR#3 VPB sky130_fd_pr__pfet_01v8 l=0.15 w=0.84 ad=0.252 as=0.742025 pd=2.28 ps=3.73
XM2 VPWR#3 a_131_383# Y#1 VPB sky130_fd_pr__pfet_01v8 l=0.15 w=1.12 ad=0.742025 as=0.336 pd=3.73 ps=2.84
XM4 Y#1 B2#3 a_490_368# VPB sky130_fd_pr__pfet_01v8 l=0.15 w=1.12 ad=0.336 as=0.3696 pd=2.84 ps=2.9
XM1 a_490_368# B1#4 VPWR#1 VPB sky130_fd_pr__pfet_01v8 l=0.15 w=1.12 ad=0.3696 as=0.3304 pd=2.9 ps=2.83
*
*
*       RESISTOR AND CAP/DIODE CARDS
*
Rg1	A1_N#1	A1_N#2	533.838745
Rg2	A1_N#2	A1_N#3	29.612585
Rg3	A1_N#2	A1_N#4	334.951599
Rg4	A2_N#1	A2_N#2	494.537140
Rg5	A2_N#2	A2_N#3	286.018372
Rg6	a_131_383#	a_131_383##2	449.655212
Rg7	a_131_383##2	a_131_383##3	61.112164
Rg8	a_131_383##2	a_131_383##4	397.555725
Rg9	B2#1	B2#2	366.265259
Rg10	B2#2	B2#3	465.025360
Rg11	B1#1	B1#2	28.644930
Rg12	B1#2	B1#3	368.862610
Rg13	B1#2	B1#4	471.862823
Rf1	A1_N	A1_N#3	162.201172
Rf2	A2_N#2	A2_N	169.090439
Rf3	a_131_383##5	a_131_383##6	55.575886
Rf4	a_131_383##6	a_131_383##7	67.780479
Rf5	a_131_383##6	a_131_383##3	165.920166
Rf6	Y	Y#2	0.130472
Rf7	Y#2	Y#3	108.778999
Rf8	Y#1	Y#2	5.000000
Rf9	B2#2	B2#5	162.730148
Rf10	B2#6	B2	2.497339
Rf11	B2#5	B2#6	6.871449
Rf12	a_397_74#	a_397_74##2	105.869698
Rf13	B1	B1#1	168.106262
Rf14	VPWR#1	VPWR#2	148.808945
Rf15	VPWR#2	VPWR#3	25.496538
Rf16	VPWR#2	VPWR#4	145.872864
Rf18	VGND#2	VGND#3	69.130760
Rf19	VGND#3	VGND#4	131.311981
Rf20	VGND#2	VGND#5	51.511902
Re1	VPWR#2	VPWR	1.403190
Re2	VGND	VGND#3	1.403242
*
*       CAPACITOR CARDS
*
*
C1	a_131_383##2	B2#3	1.17196e-18
C2	B2#5	a_131_383##2	4.15037e-18
C3	A2_N#1	a_131_383##2	1.84606e-19
C4	VPWR#2	a_131_383##2	3.08965e-20
C5	VGND#3	a_131_383##2	5.21403e-21
C6	B1#1	B1#2	1.26883e-17
C7	a_397_74#	B1#2	6.77874e-18
C8	B2#2	B1#2	3.47648e-17
C9	a_131_383##2	B2#2	3.09703e-17
C10	a_131_383##3	a_131_383##2	3.09647e-19
C11	A2_N#2	a_131_383##2	9.23923e-20
C12	Y#3	B1#2	2.13129e-19
C13	Y#3	a_131_383##2	5.11799e-18
C14	B2#5	a_397_74##2	2.5696e-17
C15	Y#3	B2#5	1.46204e-17
C16	a_397_74#	VGND#5	5.41219e-17
C17	a_397_74##2	a_397_74#	3.20688e-18
C18	a_397_74##2	VGND#5	3.43985e-17
C19	Y#3	VGND#5	2.67498e-18
C20	Y#3	a_397_74##2	6.90942e-17
C21	B1#2	VPWR#1	5.77195e-18
C22	a_131_383##5	Y#3	7.0336e-17
C23	VGND#4	a_131_383##5	2.1808e-17
C24	Y#3	VPWR#3	4.83364e-19
C25	a_397_74#	B1#3	5.08126e-17
C26	B1#3	VGND#5	1.81039e-17
C27	a_397_74#	B2#1	1.7299e-18
C28	a_397_74##2	B1#3	1.59458e-18
C29	B2#1	VGND#5	1.91599e-17
C30	B1	B1#2	1.0857e-17
C31	Y#3	B1#3	8.70205e-19
C32	a_397_74##2	B2#1	5.31688e-17
C33	VGND#5	a_131_383##4	8.77781e-19
C34	Y#3	B2#1	3.57823e-18
C35	a_131_383##4	a_397_74##2	1.52137e-17
C36	VGND#4	VPWR#4	2.32181e-19
C37	B2#5	B2#3	5.56136e-18
C38	VGND#5	A2_N#3	1.98217e-19
C39	Y#3	a_131_383##4	5.84402e-17
C40	VGND#5	A1_N#4	1.46207e-19
C41	B2#5	a_131_383#	6.19144e-19
C42	a_131_383##5	a_131_383##4	1.67999e-18
C43	Y#3	A2_N#3	1.04124e-18
C44	VGND#4	B2#1	2.01134e-19
C45	B2	B1#2	9.28544e-18
C46	a_131_383##5	A2_N#3	5.32594e-17
C47	a_131_383##7	VPWR#3	7.33732e-17
C48	VGND#4	a_131_383##4	5.0006e-19
C49	VPWR#4	VPWR#3	1.70209e-18
C50	a_131_383##5	A1_N#4	7.79485e-18
C51	VGND#4	A2_N#3	1.21831e-17
C52	VPWR#4	a_131_383##7	8.38057e-17
C53	VGND#4	A1_N#4	4.17455e-17
C54	B2#5	VPWR#2	4.66196e-19
C55	B2#1	B1#3	3.96386e-17
C56	B1#4	VPWR#1	4.62898e-17
C57	VPWR#1	B2#3	9.18853e-18
C58	a_131_383##4	B2#1	2.97547e-17
C59	VPWR#1	a_131_383#	5.02565e-19
C60	B2#3	Y#1	2.14004e-17
C61	B2#5	B2#2	1.31466e-17
C62	A2_N#3	a_131_383##4	4.52562e-18
C63	a_131_383#	Y#1	2.37616e-17
C64	VGND#4	A1_N#1	2.53183e-19
C65	a_131_383#	VPWR#3	2.44835e-17
C66	VGND#3	a_397_74##2	5.01847e-18
C67	B1#1	a_397_74#	3.09746e-17
C68	a_131_383##7	a_131_383#	3.80046e-19
C69	A1_N#4	A2_N#3	4.9638e-17
C70	A2_N#1	VPWR#3	3.43226e-17
C71	VGND#3	Y#3	1.78397e-17
C72	VPWR#4	a_131_383#	5.01585e-19
C73	VGND#3	a_131_383##5	2.92631e-17
C74	a_131_383##7	A2_N#1	5.72882e-17
C75	Y	a_131_383##2	6.22021e-18
C76	a_397_74#	B2#2	1.12651e-18
C77	VPWR#3	A1_N#1	5.7476e-19
C78	VPWR#2	VPWR#1	3.573e-17
C79	VPWR#4	A2_N#1	1.53081e-18
C80	VGND#5	B2#2	4.00908e-19
C81	a_131_383##7	A1_N#1	4.99013e-17
C82	VGND#3	VGND#4	3.95143e-17
C83	a_397_74##2	B2#2	2.47138e-18
C84	VPWR#4	A1_N#1	2.82452e-17
C85	Y#3	B2#2	1.37204e-18
C86	VPWR#2	VPWR#3	1.76691e-18
C87	a_131_383##3	Y#3	3.18831e-17
C88	a_131_383##7	VPWR#2	8.11294e-18
C89	a_131_383##5	a_131_383##3	2.50133e-18
C90	VPWR#2	VPWR#4	3.36549e-17
C91	B2#3	B1#4	4.88363e-17
C92	Y#3	A2_N#2	2.30783e-19
C93	VPWR	a_131_383##2	5.60081e-20
C94	a_131_383##5	A2_N#2	1.46048e-20
C95	a_131_383#	B2#3	4.58585e-17
C96	VGND#3	a_131_383##4	5.48401e-18
C97	a_131_383##3	VPWR#3	6.37647e-17
C98	a_397_74#	a_490_368#	2.01885e-19
C99	VGND#4	A1_N#3	7.98486e-18
C100	VGND#3	A2_N#3	3.24378e-18
C101	A2_N#1	a_131_383#	9.87492e-18
C102	VPWR#2	B1#4	5.14762e-19
C103	a_131_383##7	A2_N#2	3.18545e-18
C104	a_131_383##4	B2#2	8.36592e-19
C105	VGND	B1#2	1.0726e-18
C106	A1_N#1	A2_N#1	4.54895e-17
C107	VPWR#2	B2#3	8.35528e-18
C108	a_131_383##7	A1_N#3	2.92436e-18
C109	a_131_383##3	a_131_383##4	4.99063e-20
C110	VPWR#2	a_131_383#	1.09408e-17
C111	VPWR#4	A1_N#3	6.78143e-18
C112	VPWR#2	A2_N#1	5.36758e-18
C113	A2_N#2	a_131_383##4	8.01145e-19
C114	VPWR#2	A1_N#1	3.92646e-18
C115	A1_N#3	A2_N#3	6.52027e-18
C116	a_131_383##3	a_131_383#	1.22311e-18
C117	a_131_383##3	A2_N#1	1.70311e-17
C118	a_397_74#	B2	2.45707e-17
C119	VPWR#2	B2#2	2.54553e-19
C120	B2	VGND#5	1.58075e-19
C121	a_397_74##2	B2	2.91038e-18
C122	B1	VPWR#1	3.27364e-17
C123	A1_N#3	A2_N#1	7.98887e-19
C124	a_131_383##3	VPWR#2	2.33171e-20
C125	B1#4	a_490_368#	3.25071e-17
C126	B1#1	B2#2	4.76057e-19
C127	B2#3	a_490_368#	3.18077e-17
C128	VGND#3	a_131_383##3	8.55587e-19
C129	VPWR#2	A2_N#2	9.65921e-20
C130	B2	VPWR#1	1.25358e-18
C131	A2_N#3	a_114_74#	1.48128e-17
C132	A1_N#4	a_114_74#	1.54437e-17
C133	A1_N	VGND#4	2.79664e-17
C134	Y	B2#5	4.24828e-17
C135	A2_N#2	a_131_383##3	2.23426e-17
C136	A2_N	a_131_383##5	2.93515e-17
C137	B1#2	VNB	5.8788e-17
C138	a_131_383##2	VNB	1.80588e-17
C139	a_131_383##3	A1_N#3	3.47309e-19
C140	VGND#4	A2_N	2.55601e-18
C141	A1_N	VPWR#4	1.74288e-17
C142	B1	B1#4	5.18735e-18
C143	A1_N#3	A2_N#2	2.8185e-17
C144	a_397_74##2	Y	2.13836e-18
C145	B1	B2#3	1.56961e-19
C146	B2#2	a_490_368#	1.40468e-19
C147	VPWR	B2#5	3.75215e-18
C148	A2_N	a_131_383##7	3.73919e-17
C149	B2	B1#4	2.07446e-18
C150	Y	VPWR#1	2.65367e-17
C151	Y	Y#1	3.18211e-18
C152	VPWR#3	Y	8.49151e-17
C153	A2_N	A2_N#3	5.09007e-18
C154	a_131_383##7	Y	2.21423e-18
C155	VGND	B2#5	2.25426e-18
C156	VPWR	VPWR#1	3.9962e-17
C157	B2	VPWR#2	2.97786e-19
C158	B1	B2#2	4.5217e-19
C159	VGND	a_397_74#	1.7503e-17
C160	VGND	a_397_74##2	1.41728e-17
C161	VPWR	a_131_383##7	1.37557e-17
C162	B2	B1#1	1.93798e-17
C163	VGND	Y#3	1.71296e-17
C164	VPWR	VPWR#4	4.02632e-17
C165	VGND	a_131_383##5	2.2045e-17
C166	B2	B2#2	6.36496e-18
C167	Y	B1#4	1.23917e-17
C168	A2_N	A1_N#1	1.7788e-18
C169	VGND	VGND#4	4.8514e-17
C170	Y	B2#3	4.24918e-17
C171	Y	a_131_383#	3.51981e-17
C172	Y	A2_N#1	7.44844e-19
C173	VGND#3	A2_N	2.62029e-19
C174	VGND	a_131_383##7	2.86263e-18
C175	A1_N	a_131_383##3	3.5051e-18
C176	VGND	VPWR#4	2.90925e-18
C177	VPWR	B1#4	5.58794e-18
C178	VGND	B1#3	1.26524e-18
C179	A1_N	A2_N#2	1.07827e-18
C180	VPWR	B2#3	2.15287e-18
C181	VGND	B2#1	6.65688e-19
C182	VPWR#2	Y	3.65213e-17
C183	VPWR	a_131_383#	5.39384e-19
C184	VGND	a_131_383##4	1.03376e-19
C185	A1_N	A1_N#3	2.32541e-17
C186	A2_N	a_131_383##3	3.39196e-17
C187	VPWR	A2_N#1	7.08797e-18
C188	VGND	A2_N#3	1.71834e-18
C189	VGND	A1_N#4	4.20879e-18
C190	VPWR	A1_N#1	7.41289e-18
C191	A2_N	A2_N#2	1.36588e-17
C192	Y	B2#2	2.11041e-18
C193	A2_N	A1_N#3	1.00487e-17
C194	VPWR	VPWR#2	8.34599e-17
C195	a_131_383##3	Y	3.43331e-17
C196	B2#5	VNB	9.96505e-19
C197	a_397_74#	VNB	3.98813e-17
C198	VGND#5	VNB	2.59439e-18
C199	a_397_74##2	VNB	9.40982e-19
C200	VPWR	a_131_383##3	3.8907e-18
C201	B2	B1	2.21611e-17
C202	Y#3	VNB	6.41413e-18
C203	a_131_383##5	VNB	1.83731e-17
C204	VGND	VGND#3	2.86841e-17
C205	VGND#4	VNB	6.82335e-17
C206	VPWR#1	VNB	8.01922e-17
C207	VGND	B1#1	4.36762e-18
C208	VPWR	A1_N#3	7.73472e-19
C209	VGND	B2#2	1.26413e-20
C210	VPWR#3	VNB	8.12248e-19
C211	a_131_383##7	VNB	1.11597e-17
C212	VGND	a_131_383##3	4.91197e-18
C213	VPWR#4	VNB	8.42771e-17
C214	B1#3	VNB	3.22841e-17
C215	B2#1	VNB	2.76289e-17
C216	a_131_383##4	VNB	3.10706e-17
C217	VGND	A1_N#3	6.32102e-19
C218	A2_N#3	VNB	2.8635e-17
C219	A1_N#4	VNB	2.63354e-17
C220	B1#4	VNB	3.42109e-17
C221	A1_N	A2_N	3.25726e-17
C222	B2#3	VNB	3.04946e-17
C223	a_131_383#	VNB	3.71227e-17
C224	A2_N#1	VNB	4.43225e-17
C225	VPWR	B1	2.51901e-18
C226	A1_N#1	VNB	5.92634e-17
C227	VPWR	B2	5.30756e-18
C228	VPWR#2	VNB	2.20371e-16
C229	VGND#3	VNB	1.94269e-16
C230	B1#1	VNB	9.3392e-18
C231	VPWR	A1_N	2.25116e-18
C232	B2#2	VNB	2.96462e-17
C233	a_131_383##3	VNB	4.26531e-17
C234	VGND	B2	2.41992e-18
C235	VPWR	A2_N	1.34472e-18
C236	A2_N#2	VNB	2.96278e-17
C237	A1_N#3	VNB	5.88854e-17
C238	VGND	A1_N	2.55124e-18
C239	VPWR	Y	2.07281e-17
C240	VGND	A2_N	7.91901e-18
C241	B1	VNB	1.16306e-17
C242	A1_N	VNB	1.69416e-17
C243	A2_N	VNB	5.09037e-18
C244	Y	VNB	3.79153e-18
C245	VPWR	VNB	6.18581e-17
C246	VGND	VNB	6.54135e-17
C247	VGND#2	B1#2	3.74163e-19
C248	VGND#2	B1#1	6.32879e-19
C249	VGND#2	B2#1	5.35342e-18
C250	VGND#2	A2_N#3	1.90727e-19
C251	VGND#3	VGND#2	5.23481e-17
C252	VGND#2	B1#3	5.97019e-18
C253	VGND#2	a_397_74#	2.10936e-17
C254	VGND#2	B2#2	7.66781e-20
C255	VGND#2	a_131_383##4	7.08731e-19
C256	VGND#2	a_397_74##2	7.79758e-18
C257	VGND	VGND#2	4.39892e-17
C258	VGND#2	A1_N#4	1.03291e-19
C259	VGND#2	VNB	4.93331e-17
*
*
.ENDS sky130_fd_sc_hs__o2bb2ai_1
*
