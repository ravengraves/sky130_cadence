* Extracted by Quantus, converted by sky130cad/quantus.py
*
*
*
*                       LINUX           Wed Nov 18 09:07:37 2026
*
*
*
*  PROGRAM  advgen
*
*  Name           : advgen - Quantus - (64-bit)
*  Version        : 25.1.0-p047
*  Build Date     : Thu Dec 11 23:20:30 PST 2025
*
*  HSPICE LIBRARY
*
*  OPERATING_TEMPERATURE 150
*  QRC_TECH_DIR <path>/tech
*
*
*

*
.SUBCKT sky130_fd_sc_hs__or4b_1 VNB VPB VGND VPWR X C B A D_N
*
*
*  caps2d version: 10
*
*
*       TRANSISTOR CARDS
*
*
XM11 a_27_74##6 D_N#3 VGND#9 VNB sky130_fd_pr__nfet_01v8_lvt l=0.15 w=0.55 ad=0.15675 as=0.231 pd=1.67 ps=1.94
XM3 VGND#9 a_27_74##3 a_228_74##7 VNB sky130_fd_pr__nfet_01v8_lvt l=0.15 w=0.55 ad=0.231 as=0.50875 pd=1.94 ps=2.95
XM10 a_228_74##7 C#1 VGND#8 VNB sky130_fd_pr__nfet_01v8_lvt l=0.15 w=0.55 ad=0.50875 as=0.231 pd=2.95 ps=1.94
XM2 VGND#8 B#1 a_228_74##4 VNB sky130_fd_pr__nfet_01v8_lvt l=0.15 w=0.55 ad=0.231 as=0.154 pd=1.94 ps=1.66
XM5 a_228_74##4 A#1 VGND#7 VNB sky130_fd_pr__nfet_01v8_lvt l=0.15 w=0.55 ad=0.154 as=0.31975 pd=1.66 ps=2.47
XM6 VGND#7 a_228_74# X#3 VNB sky130_fd_pr__nfet_01v8_lvt l=0.15 w=0.74 ad=0.31975 as=0.2109 pd=2.47 ps=2.05
XM7 a_27_74##4 D_N#1 VPWR#7 VPB sky130_fd_pr__pfet_01v8 l=0.15 w=0.84 ad=0.2478 as=0.2898 pd=2.27 ps=2.37
XM8 a_228_74##9 a_27_74# a_356_368# VPB sky130_fd_pr__pfet_01v8 l=0.15 w=1 ad=0.295 as=0.27 pd=2.59 ps=2.54
XM4 a_356_368# C#3 a_440_368# VPB sky130_fd_pr__pfet_01v8 l=0.15 w=1 ad=0.27 as=0.27 pd=2.54 ps=2.54
XM0 a_440_368# B#3 a_524_368# VPB sky130_fd_pr__pfet_01v8 l=0.15 w=1 ad=0.27 as=0.39 pd=2.54 ps=2.78
XM9 a_524_368# A#3 VPWR#6 VPB sky130_fd_pr__pfet_01v8 l=0.15 w=1 ad=0.39 as=0.5814 pd=2.78 ps=3.32
XM1 VPWR#6 a_228_74##3 X#1 VPB sky130_fd_pr__pfet_01v8 l=0.15 w=1.12 ad=0.5814 as=0.3304 pd=3.32 ps=2.83
*
*
*       RESISTOR AND CAP/DIODE CARDS
*
Rg1	D_N#1	D_N#2	450.433960
Rg2	D_N#2	D_N#3	514.692688
Rg3	a_27_74#	a_27_74##2	670.386108
Rg4	a_27_74##2	a_27_74##3	563.532471
Rg5	C#1	C#2	262.028717
Rg6	C#2	C#3	533.757141
Rg7	B#1	B#2	339.500092
Rg8	B#2	B#3	475.028809
Rg9	A#1	A#2	437.056641
Rg10	A#2	A#3	400.207520
Rg11	a_228_74#	a_228_74##2	366.265259
Rg12	a_228_74##2	a_228_74##3	465.025360
Rf1	D_N#4	D_N	0.739201
Rf2	D_N#2	D_N#6	160.972000
Rf3	D_N#4	D_N#6	6.495599
Rf4	a_27_74##4	a_27_74##5	75.822662
Rf5	a_27_74##5	a_27_74##6	104.893082
Rf6	C#2	C#5	161.231903
Rf7	C#6	C	0.999102
Rf8	C#5	C#6	2.852918
Rf9	C#7	C	0.999102
Rf10	C#6	C#7	12.418585
Rf11	B	B#4	12.597526
Rf12	B#4	B	1.968364
Rf13	A#4	A#2	160.844009
Rf14	A	A#6	0.611206
Rf15	A#4	A#6	5.905091
Rf16	a_228_74##4	a_228_74##5	90.738014
Rf17	a_228_74##5	a_228_74##6	175.651886
Rf18	a_228_74##6	a_228_74##8	49.902843
Rf19	a_228_74##6	a_228_74##9	16.991049
Rf20	a_228_74##8	a_228_74##7	41.132111
Rf21	a_228_74##7	a_228_74##8	15.000000
Rf22	X	X#2	0.163794
Rf23	X#2	X	11.956983
Rf24	X	X#3	86.144768
Rf25	X#1	X#2	5.000000
Rf27	VPWR#2	VPWR#3	97.863129
Rf28	VPWR#3	VPWR#4	100.419899
Rf30	VPWR#2	VPWR#6	31.534731
Rf31	VPWR#4	VPWR#7	31.534731
Rf33	VGND#2	VGND#3	75.558197
Rf34	VGND#3	VGND#4	19.333849
Rf35	VGND#4	VGND#5	100.785156
Rf37	VGND#2	VGND#7	35.098007
Rf38	VGND#3	VGND#8	35.688515
Rf39	VGND#5	VGND#9	37.066368
Rf41	a_27_74##2	a_27_74##5	160.232803
Rf43	B#2	B#4	160.232803
Rf45	a_228_74##2	a_228_74##5	160.232803
Re1	VPWR#3	VPWR	1.091357
Re2	VGND	VGND#4	1.091398
*
*       CAPACITOR CARDS
*
*
C1	a_228_74##6	C#7	6.07631e-17
C2	VGND#3	VGND#7	1.54933e-19
C3	VGND#3	a_228_74##4	9.27958e-18
C4	VGND#8	a_228_74##6	3.71822e-18
C5	a_228_74##7	a_228_74##6	3.09546e-18
C6	a_228_74##4	A#4	2.12145e-17
C7	a_228_74##6	VPWR#6	6.63556e-18
C8	C#5	a_228_74##4	7.01396e-18
C9	VGND#3	a_228_74#	2.07692e-19
C10	VGND#8	C#5	1.24298e-17
C11	VGND#3	A#1	6.78128e-19
C12	C#5	a_228_74##7	4.41576e-17
C13	VGND#3	B#1	6.9953e-18
C14	VGND#7	X#3	3.79867e-17
C15	a_228_74##6	a_228_74##9	6.34524e-18
C16	a_228_74##4	X#3	2.53651e-18
C17	VGND#3	C#1	2.57244e-18
C18	VPWR#7	a_228_74##6	3.14033e-17
C19	a_228_74##4	VGND#7	4.54472e-17
C20	VGND#3	a_27_74##3	1.89948e-19
C21	a_27_74##4	a_228_74##6	2.16952e-18
C22	VGND#8	VGND#7	2.02605e-18
C23	VGND#8	a_228_74##4	4.84643e-17
C24	VGND#3	D_N#3	8.29721e-20
C25	a_228_74##7	a_228_74##4	4.92439e-19
C26	a_228_74##7	VGND#8	3.15143e-17
C27	VGND#9	VGND#8	3.07189e-18
C28	VGND#9	a_228_74##7	3.34453e-17
C29	a_27_74##6	a_228_74##7	2.00984e-18
C30	a_27_74##6	VGND#9	5.69226e-17
C31	C#5	A#1	4.3774e-19
C32	C#5	B#1	1.11627e-18
C33	a_228_74##6	a_228_74##3	1.20773e-18
C34	VPWR#6	X#1	3.84843e-17
C35	X#3	a_228_74#	3.55528e-17
C36	a_228_74##6	A#3	1.61294e-18
C37	a_228_74#	VGND#7	2.20767e-17
C38	C#5	a_27_74##3	3.45056e-19
C39	X#3	A#1	2.13266e-18
C40	a_228_74##6	B#3	2.58673e-17
C41	a_228_74##4	a_228_74#	9.89737e-19
C42	A#1	VGND#7	2.07448e-17
C43	VGND#8	a_228_74#	3.2398e-19
C44	a_228_74##4	A#1	4.67891e-17
C45	a_228_74##6	C#3	2.75907e-17
C46	VGND#7	B#1	6.78336e-19
C47	VGND#8	A#1	7.03615e-19
C48	a_228_74##4	B#1	3.30679e-17
C49	a_27_74##6	a_27_74##4	1.72193e-18
C50	VGND#7	C#1	2.7933e-19
C51	a_228_74##7	A#1	4.53632e-20
C52	a_228_74##6	a_27_74#	6.66638e-17
C53	B#1	VGND#8	1.66109e-17
C54	a_228_74##4	C#1	7.49703e-19
C55	VGND#4	VGND#3	2.78065e-17
C56	C#7	B#3	1.45879e-18
C57	a_228_74##7	B#1	1.44922e-19
C58	C#1	VGND#8	2.26827e-17
C59	a_228_74##6	D_N#1	4.56797e-18
C60	VGND#9	B#1	2.83713e-19
C61	a_228_74##7	C#1	4.28352e-17
C62	C#7	C#3	6.31104e-18
C63	VGND#8	a_27_74##3	9.40239e-19
C64	VGND#9	C#1	8.84633e-19
C65	a_228_74##7	a_27_74##3	4.45541e-17
C66	VGND#8	D_N#3	5.23849e-19
C67	C#7	a_27_74#	5.62835e-18
C68	a_27_74##6	C#1	1.09623e-19
C69	a_27_74##3	VGND#9	1.588e-17
C70	a_228_74##7	D_N#3	8.98205e-19
C71	a_228_74##6	VPWR#3	1.06749e-17
C72	a_27_74##6	a_27_74##3	2.33267e-18
C73	D_N#3	VGND#9	2.19676e-17
C74	a_27_74##4	VPWR#7	6.70505e-17
C75	a_27_74##6	D_N#3	4.53567e-17
C76	X#1	a_228_74##3	2.54793e-17
C77	A#1	a_228_74#	1.61838e-17
C78	a_228_74##3	VPWR#6	3.4645e-17
C79	a_228_74##2	A#4	3.31204e-17
C80	X#1	A#3	2.19605e-18
C81	A#3	VPWR#6	3.9025e-17
C82	a_228_74##6	B#2	3.27513e-19
C83	VGND#4	C#5	7.95986e-19
C84	X#1	B#3	4.78087e-19
C85	B#1	A#1	3.24613e-17
C86	A#4	A#2	9.49165e-18
C87	a_228_74##7	a_27_74#	2.60525e-18
C88	VPWR#6	B#3	3.6618e-18
C89	X#1	C#3	3.0439e-19
C90	a_228_74##6	C#2	1.47945e-18
C91	A#4	B#2	2.83554e-18
C92	VPWR#6	C#3	1.69986e-18
C93	C#1	B#1	1.78775e-17
C94	X#1	a_27_74#	3.60234e-19
C95	C#7	B#2	1.73508e-18
C96	C#5	A#2	1.13863e-19
C97	VPWR#6	a_27_74#	1.28354e-18
C98	a_228_74##6	a_27_74##2	7.46564e-17
C99	VPWR#7	A#3	4.74212e-19
C100	a_27_74##3	C#1	4.13827e-18
C101	a_228_74##2	X#3	5.03579e-17
C102	C#5	B#2	2.3732e-18
C103	VPWR#7	B#3	4.57488e-19
C104	C#7	C#2	2.90865e-18
C105	a_228_74##2	VGND#7	3.11379e-17
C106	a_228_74##6	D_N#2	1.77552e-19
C107	VGND#4	a_228_74##7	1.46279e-17
C108	a_228_74##4	a_228_74##2	5.51835e-18
C109	D_N#3	a_27_74##3	2.28407e-17
C110	VPWR#7	C#3	7.29404e-19
C111	X#3	A#2	7.48865e-20
C112	a_27_74#	a_228_74##9	3.14809e-17
C113	C#5	C#2	1.03819e-17
C114	C#7	a_27_74##2	1.6035e-19
C115	VGND#7	A#2	9.83986e-19
C116	VPWR#7	a_27_74#	4.97095e-18
C117	a_228_74##4	A#2	5.80924e-18
C118	a_27_74##4	a_27_74#	1.13941e-18
C119	C#5	a_27_74##2	1.78477e-21
C120	VPWR#7	D_N#1	2.37341e-17
C121	a_228_74##4	B#2	4.00311e-18
C122	a_27_74##4	D_N#1	5.37139e-17
C123	a_228_74##6	a_524_368#	1.1586e-18
C124	VGND#8	B#2	3.45235e-18
C125	a_228_74##2	VPWR#6	4.76064e-17
C126	a_228_74##4	C#2	6.186e-19
C127	A#2	VPWR#6	5.29945e-19
C128	a_228_74##6	a_440_368#	7.03846e-18
C129	a_228_74##7	C#2	1.03656e-17
C130	A#3	a_228_74##3	1.89196e-17
C131	a_27_74##6	C#2	6.60379e-21
C132	a_228_74##7	a_27_74##2	2.39456e-17
C133	a_228_74##6	a_356_368#	5.8758e-18
C134	B#3	A#3	3.41296e-17
C135	VGND#9	a_27_74##2	2.97741e-17
C136	a_228_74##2	a_228_74#	5.08005e-18
C137	a_228_74##7	D_N#2	4.76687e-19
C138	C#3	B#3	5.89869e-17
C139	VGND#4	C#1	8.01144e-18
C140	a_27_74##6	D_N#2	3.5683e-17
C141	A#2	a_228_74#	1.34802e-18
C142	a_27_74#	C#3	6.62887e-17
C143	B#2	A#1	3.73296e-18
C144	a_27_74##2	a_228_74##9	5.23695e-19
C145	a_27_74##2	VPWR#7	3.00113e-17
C146	a_27_74##2	a_27_74##4	5.0452e-19
C147	D_N#1	a_27_74#	4.28215e-18
C148	VPWR#3	B#3	6.85687e-18
C149	C#2	B#1	2.3787e-18
C150	a_228_74##2	a_228_74##3	7.18565e-18
C151	VPWR#3	C#3	6.86195e-18
C152	D_N#2	a_27_74##4	3.01983e-17
C153	a_228_74##2	A#3	3.14762e-17
C154	A#2	a_228_74##3	4.62379e-19
C155	VPWR#3	a_27_74#	4.6863e-18
C156	a_27_74##3	C#2	2.72339e-18
C157	a_228_74##2	B#3	2.96367e-19
C158	VGND#4	a_27_74#	2.03026e-19
C159	VGND#3	B	5.28035e-19
C160	a_228_74##2	C#3	1.34217e-19
C161	a_27_74##2	a_27_74##3	5.46184e-18
C162	B#3	A#2	2.7013e-18
C163	a_228_74##2	a_27_74#	1.1795e-19
C164	D_N#2	a_27_74##3	1.60615e-18
C165	C#3	B#2	3.60421e-18
C166	B	a_228_74##6	2.82733e-17
C167	a_228_74##2	VPWR#3	4.5394e-19
C168	B	A#4	1.86875e-17
C169	C#7	B	2.40754e-17
C170	a_27_74##2	a_27_74#	4.8338e-18
C171	VPWR#3	B#2	3.12262e-19
C172	a_27_74##6	D_N	1.76446e-17
C173	a_228_74##6	C	4.78589e-18
C174	C#5	B	7.70887e-18
C175	A#2	a_228_74##2	3.2208e-17
C176	D_N#2	a_27_74#	1.90733e-19
C177	VPWR#3	C#2	2.75719e-19
C178	A#3	a_524_368#	2.85037e-17
C179	a_228_74##2	B#2	1.32902e-18
C180	VGND#4	C#2	3.42397e-19
C181	B#3	a_524_368#	2.85037e-17
C182	B#2	A#2	3.07255e-17
C183	VGND#4	a_27_74##2	5.10264e-20
C184	a_228_74##4	B	8.84454e-18
C185	B#3	a_440_368#	2.38236e-17
C186	VGND#8	B	1.05e-17
C187	C#3	a_440_368#	2.38236e-17
C188	D_N	a_27_74##4	1.78065e-17
C189	C#2	B#2	2.94629e-17
C190	C#3	a_356_368#	2.38236e-17
C191	a_27_74#	a_356_368#	2.38236e-17
C192	a_228_74##7	C	1.0006e-17
C193	a_27_74##2	C#2	3.86228e-18
C194	VPWR	a_228_74##6	2.97518e-17
C195	a_228_74##2	a_524_368#	6.93593e-18
C196	X#3	X	4.03994e-18
C197	VGND	VGND#3	3.88158e-17
C198	D_N#2	a_27_74##2	7.83238e-17
C199	VPWR	C#7	3.25817e-18
C200	a_228_74##2	a_356_368#	1.68257e-20
C201	A	a_228_74##3	2.41498e-19
C202	X	X#1	3.03383e-18
C203	VPWR#6	X	2.96775e-17
C204	A	A#3	2.06671e-18
C205	A	B#3	7.96233e-19
C206	VGND	A#4	2.19928e-18
C207	B	A#3	8.02098e-19
C208	VGND	C#5	5.60787e-18
C209	B	B#3	4.36953e-18
C210	VPWR	VPWR#6	2.24862e-17
C211	B	C#3	1.40036e-18
C212	VGND	X#3	2.06619e-17
C213	VGND	a_228_74##4	1.73934e-17
C214	VPWR	VPWR#7	2.24728e-17
C215	A	a_228_74##2	5.50874e-17
C216	VGND	a_228_74##7	2.98594e-17
C217	VPWR	a_27_74##4	1.65863e-17
C218	A	A#2	6.49477e-18
C219	VGND	a_27_74##6	1.65636e-17
C220	X	a_228_74##3	2.16451e-17
C221	X	A#3	1.19597e-18
C222	A	B#2	4.02971e-19
C223	B	a_228_74##2	1.51616e-17
C224	D_N	D_N#2	9.83362e-18
C225	B	A#2	5.63996e-18
C226	B	B#2	2.0595e-17
C227	VPWR	a_228_74##3	3.68939e-18
C228	VGND#3	VNB	2.33051e-17
C229	VGND	a_228_74#	2.19669e-18
C230	B	C#2	3.75446e-18
C231	VPWR	A#3	9.00216e-18
C232	VPWR	B#3	9.20238e-18
C233	VGND	B#1	1.07051e-18
C234	VGND	C#1	1.02877e-18
C235	VPWR	C#3	9.3593e-18
C236	C	B#2	2.29607e-18
C237	VGND	a_27_74##3	8.53422e-19
C238	VPWR	a_27_74#	9.83177e-18
C239	a_228_74##6	VNB	1.01807e-17
C240	C	C#2	1.03587e-17
C241	VGND	D_N#3	1.17004e-18
C242	a_228_74##2	X	6.04848e-17
C243	VPWR	D_N#1	7.89921e-19
C244	A#4	VNB	9.77003e-19
C245	X	A#2	2.44446e-20
C246	C	a_27_74##2	1.99018e-19
C247	C#7	VNB	2.8748e-18
C248	VPWR	VPWR#3	3.35945e-17
C249	C#5	VNB	8.18159e-19
C250	VPWR	a_228_74##2	1.23048e-17
C251	VGND	a_27_74#	4.96467e-21
C252	X#3	VNB	5.4365e-17
C253	VGND#7	VNB	3.21316e-18
C254	a_228_74##4	VNB	6.07909e-18
C255	VGND#8	VNB	2.9468e-18
C256	a_228_74##7	VNB	8.71636e-18
C257	VGND#9	VNB	6.58046e-18
C258	a_27_74##6	VNB	4.89975e-17
C259	X#1	VNB	2.08513e-17
C260	VGND	VGND#4	2.11488e-17
C261	VPWR#6	VNB	7.89548e-18
C262	VPWR	a_27_74##2	8.23048e-18
C263	VGND	a_228_74##2	4.91315e-18
C264	VPWR	D_N#2	1.067e-18
C265	VPWR#7	VNB	1.35843e-17
C266	a_27_74##4	VNB	5.01993e-17
C267	a_228_74#	VNB	3.18675e-17
C268	A#1	VNB	3.38594e-17
C269	B#1	VNB	2.8318e-17
C270	VGND	a_27_74##2	3.81465e-18
C271	B	A	1.30199e-17
C272	C#1	VNB	2.99328e-17
C273	a_27_74##3	VNB	3.78357e-17
C274	VGND	D_N#2	1.13614e-18
C275	D_N#3	VNB	4.32943e-17
C276	a_228_74##3	VNB	3.91706e-17
C277	A#3	VNB	3.49786e-17
C278	B#3	VNB	3.21966e-17
C279	C#3	VNB	3.49426e-17
C280	C	B	1.86246e-17
C281	a_27_74#	VNB	5.05226e-17
C282	D_N#1	VNB	4.8218e-17
C283	VPWR	D_N	1.11268e-18
C284	VPWR#3	VNB	2.29184e-16
C285	VGND#4	VNB	2.1014e-16
C286	VPWR	A	2.51368e-18
C287	a_228_74##2	VNB	4.96594e-17
C288	A#2	VNB	2.93127e-17
C289	B#2	VNB	2.78405e-17
C290	VGND	D_N	1.18058e-18
C291	VPWR	B	2.73652e-18
C292	C#2	VNB	3.7446e-17
C293	a_27_74##2	VNB	6.74281e-17
C294	D_N#2	VNB	7.3371e-17
C295	VGND	B	3.88175e-18
C296	VPWR	X	2.15631e-17
C297	VGND	X	1.70226e-18
C298	D_N	VNB	1.89879e-17
C299	A	VNB	1.87981e-18
C300	B	VNB	4.12043e-18
C301	C	VNB	7.72589e-19
C302	X	VNB	5.08039e-17
C303	VPWR	VNB	6.69124e-17
C304	VGND	VNB	6.20707e-17
C305	VGND#2	X#3	2.43073e-17
C306	VGND#5	D_N#2	6.28006e-20
C307	VGND#5	a_27_74##3	7.29991e-18
C308	VPWR#3	VPWR#4	6.43054e-17
C309	VGND#2	A#1	7.2775e-18
C310	VGND#2	A#2	3.69778e-20
C311	VPWR#2	a_228_74##3	4.63558e-18
C312	VGND#5	a_228_74##7	1.02738e-17
C313	VGND#2	a_228_74##4	9.18194e-18
C314	X	VPWR#2	2.43413e-17
C315	VGND#5	a_27_74##6	2.09873e-17
C316	VPWR#4	a_27_74#	3.11266e-20
C317	VGND#2	C#1	1.24849e-19
C318	a_228_74##6	VPWR#4	7.35005e-18
C319	VGND#5	VGND#3	4.61948e-19
C320	VPWR#4	D_N#2	5.78763e-20
C321	VGND#3	VGND#2	1.26019e-18
C322	VGND#5	a_27_74##2	2.56747e-19
C323	VGND#2	a_228_74#	7.23135e-18
C324	VGND#5	C#1	4.4513e-19
C325	VPWR#2	A#2	3.15403e-20
C326	VGND#2	a_228_74##2	4.41816e-19
C327	VGND#5	D_N#3	6.22412e-18
C328	VGND#5	VGND#8	1.9309e-19
C329	VPWR#3	VPWR#2	6.49674e-17
C330	VGND#2	B#1	5.43871e-19
C331	VPWR#2	VNB	5.8924e-17
C332	a_27_74##4	VPWR#4	2.09699e-17
C333	VGND	VGND#2	6.01662e-17
C334	VGND#5	a_27_74#	2.36518e-20
C335	VPWR#4	VNB	5.75054e-17
C336	VPWR#2	A#3	6.84131e-18
C337	VPWR	VPWR#2	4.49706e-17
C338	a_27_74##2	VPWR#4	1.26906e-18
C339	VPWR#4	D_N#1	2.57139e-18
C340	VGND#4	VGND#5	6.45967e-17
C341	VGND#2	VNB	5.35553e-17
C342	VGND	VGND#5	6.42696e-17
C343	VPWR	VPWR#4	4.00816e-17
C344	a_228_74##2	VPWR#2	2.77089e-18
C345	VGND#5	VNB	5.95385e-17
C346	VGND#4	VGND#2	5.92089e-17
C347	VGND#5	B#1	1.15802e-19
*
*
.ENDS sky130_fd_sc_hs__or4b_1
*
