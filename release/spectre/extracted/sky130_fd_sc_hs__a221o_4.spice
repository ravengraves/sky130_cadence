* Extracted by Quantus, converted by sky130cad/quantus.py
*
*
*
*                       LINUX           Wed Nov 18 08:06:52 2026
*
*
*
*  PROGRAM  advgen
*
*  Name           : advgen - Quantus - (64-bit)
*  Version        : 25.1.0-p047
*  Build Date     : Thu Dec 11 23:20:30 PST 2025
*
*  HSPICE LIBRARY
*
*  OPERATING_TEMPERATURE 150
*  QRC_TECH_DIR <path>/tech
*
*
*

*
.SUBCKT sky130_fd_sc_hs__a221o_4 VPB VNB VGND X VPWR A1 A2 B2 B1 C1
*
*
*  caps2d version: 10
*
*
*       TRANSISTOR CARDS
*
*
XM3 a_154_135##19 A1#3 a_71_135##4 VNB sky130_fd_pr__nfet_01v8_lvt l=0.15 w=0.64 ad=0.1792 as=0.1696 pd=1.84 ps=1.81
XM26 a_71_135##2 A1#4 a_154_135##19 VNB sky130_fd_pr__nfet_01v8_lvt l=0.15 w=0.64 ad=0.1696 as=0.1792 pd=1.81 ps=1.84
XM6 VGND#15 A2#6 a_71_135# VNB sky130_fd_pr__nfet_01v8_lvt l=0.15 w=0.64 ad=0.1696 as=0.1792 pd=1.81 ps=1.84
XM14 a_71_135# A2#1 VGND#14 VNB sky130_fd_pr__nfet_01v8_lvt l=0.15 w=0.64 ad=0.1792 as=0.246725 pd=1.84 ps=2.19
XM24 X#8 a_154_135##12 VGND#14 VNB sky130_fd_pr__nfet_01v8_lvt l=0.15 w=0.74 ad=0.2072 as=0.246725 pd=2.04 ps=2.19
XM0 X#8 a_154_135##8 VGND#13 VNB sky130_fd_pr__nfet_01v8_lvt l=0.15 w=0.74 ad=0.2072 as=0.2072 pd=2.04 ps=2.04
XM1 VGND#13 a_154_135##6 X#5 VNB sky130_fd_pr__nfet_01v8_lvt l=0.15 w=0.74 ad=0.2072 as=0.2072 pd=2.04 ps=2.04
XM27 VGND#12 a_154_135# X#5 VNB sky130_fd_pr__nfet_01v8_lvt l=0.15 w=0.74 ad=0.5001 as=0.2072 pd=2.96 ps=2.04
XM13 VGND#12 C1#7 a_154_135##21 VNB sky130_fd_pr__nfet_01v8_lvt l=0.15 w=0.64 ad=0.5001 as=0.1792 pd=2.96 ps=1.84
XM19 a_154_135##21 C1#5 VGND#11 VNB sky130_fd_pr__nfet_01v8_lvt l=0.15 w=0.64 ad=0.1792 as=0.3296 pd=1.84 ps=2.34
XM16 a_1346_123##4 B2#6 VGND#11 VNB sky130_fd_pr__nfet_01v8_lvt l=0.15 w=0.64 ad=0.1792 as=0.3296 pd=1.84 ps=2.34
XM9 VGND#10 B2#5 a_1346_123##4 VNB sky130_fd_pr__nfet_01v8_lvt l=0.15 w=0.64 ad=0.1696 as=0.1792 pd=1.81 ps=1.84
XM4 a_1346_123##2 B1#7 a_154_135##15 VNB sky130_fd_pr__nfet_01v8_lvt l=0.15 w=0.64 ad=0.1696 as=0.1792 pd=1.81 ps=1.84
XM12 a_154_135##15 B1#1 a_1346_123# VNB sky130_fd_pr__nfet_01v8_lvt l=0.15 w=0.64 ad=0.1792 as=0.2144 pd=1.84 ps=1.95
XM15 a_157_376##6 A1#6 VPWR#13 VPB sky130_fd_pr__pfet_01v8 l=0.15 w=1 ad=0.42 as=0.275 pd=2.84 ps=2.55
XM25 VPWR#12 A1#5 a_157_376##6 VPB sky130_fd_pr__pfet_01v8 l=0.15 w=1 ad=0.745 as=0.42 pd=3.49 ps=2.84
XM10 a_157_376##4 A2#4 VPWR#12 VPB sky130_fd_pr__pfet_01v8 l=0.15 w=1 ad=0.3 as=0.745 pd=2.6 ps=3.49
XM22 VPWR#11 A2#5 a_157_376##4 VPB sky130_fd_pr__pfet_01v8 l=0.15 w=1 ad=0.493 as=0.3 pd=3.16 ps=2.6
XM21 VPWR#11 a_154_135##14 X#2 VPB sky130_fd_pr__pfet_01v8 l=0.15 w=1.12 ad=0.493 as=0.336 pd=3.16 ps=2.84
XM23 VPWR#10 a_154_135##13 X#2 VPB sky130_fd_pr__pfet_01v8 l=0.15 w=1.12 ad=0.336 as=0.336 pd=2.84 ps=2.84
XM11 X#1 a_154_135##9 VPWR#10 VPB sky130_fd_pr__pfet_01v8 l=0.15 w=1.12 ad=0.336 as=0.336 pd=2.84 ps=2.84
XM8 X#1 a_154_135##5 VPWR#9 VPB sky130_fd_pr__pfet_01v8 l=0.15 w=1.12 ad=0.336 as=0.308 pd=2.84 ps=2.79
XM2 a_1102_392##5 C1#6 a_154_135##20 VPB sky130_fd_pr__pfet_01v8 l=0.15 w=1 ad=0.275 as=0.3 pd=2.55 ps=2.6
XM17 a_154_135##20 C1#1 a_1102_392##3 VPB sky130_fd_pr__pfet_01v8 l=0.15 w=1 ad=0.3 as=0.3 pd=2.6 ps=2.6
XM5 a_1102_392##3 B2#7 a_157_376##2 VPB sky130_fd_pr__pfet_01v8 l=0.15 w=1 ad=0.3 as=0.3 pd=2.6 ps=2.6
XM20 a_157_376##2 B2#1 a_1102_392##6 VPB sky130_fd_pr__pfet_01v8 l=0.15 w=1 ad=0.3 as=0.59 pd=2.6 ps=3.18
XM18 a_1102_392##6 B1#4 a_157_376# VPB sky130_fd_pr__pfet_01v8 l=0.15 w=1 ad=0.59 as=0.34 pd=3.18 ps=2.68
XM7 a_157_376# B1#5 a_1102_392# VPB sky130_fd_pr__pfet_01v8 l=0.15 w=1 ad=0.34 as=0.275 pd=2.68 ps=2.55
*
*
*       RESISTOR AND CAP/DIODE CARDS
*
Rg1	A1#1	A1#2	196.384094
Rg2	A1#2	A1#3	462.997528
Rg3	A1#2	A1#4	255.630157
Rg4	A1#4	A1#5	737.050720
Rg5	A1#3	A1#6	742.110352
Rg6	A2#1	A2#2	346.017487
Rg7	A2#2	A2#3	54.610939
Rg8	A2#3	A2#4	597.260620
Rg9	A2#2	A2#5	476.440948
Rg10	A2#3	A2#6	234.008942
Rg11	A2#6	A2#7	279.244598
Rg12	a_154_135#	a_154_135##2	402.535675
Rg13	a_154_135##2	a_154_135##3	57.566727
Rg14	a_154_135##3	a_154_135##4	26.734375
Rg15	a_154_135##2	a_154_135##5	412.166595
Rg16	a_154_135##3	a_154_135##6	322.018829
Rg17	a_154_135##4	a_154_135##7	49.225208
Rg18	a_154_135##7	a_154_135##8	307.787018
Rg19	a_154_135##4	a_154_135##9	425.478546
Rg20	a_154_135##7	a_154_135##10	24.730078
Rg21	a_154_135##10	a_154_135##11	46.623253
Rg22	a_154_135##11	a_154_135##12	299.955994
Rg23	a_154_135##10	a_154_135##13	393.474976
Rg24	a_154_135##11	a_154_135##14	458.013000
Rg25	C1#1	C1#2	608.574463
Rg26	C1#2	C1#3	63.166168
Rg27	C1#3	C1#4	51.225143
Rg28	C1#2	C1#5	315.993835
Rg29	C1#3	C1#6	382.975983
Rg30	C1#4	C1#7	355.470276
Rg31	B2#1	B2#2	382.271759
Rg32	B2#2	B2#3	1400.736206
Rg33	B2#2	B2#4	48.179859
Rg34	B2#4	B2#5	416.199707
Rg35	B2#3	B2#6	273.732178
Rg36	B2#4	B2#7	519.614807
Rg37	B1#1	B1#2	498.943756
Rg38	B1#2	B1#3	67.539665
Rg39	B1#3	B1#4	450.445862
Rg40	B1#2	B1#5	548.196411
Rg41	B1#2	B1#6	158.871552
Rg42	B1#3	B1#7	428.613678
Rf1	A1	A1#1	166.334732
Rf2	A2	A2#7	175.034546
Rf3	a_71_135#	a_71_135##3	134.195892
Rf4	a_71_135##3	a_71_135##4	86.865944
Rf5	a_71_135##2	a_71_135##3	15.000000
Rf6	X#1	X#3	57.837627
Rf7	X#3	X#4	255.493820
Rf8	X#2	X#3	15.000000
Rf9	X#5	X#6	75.295479
Rf10	X#6	X	50.387463
Rf11	X#6	X#8	14.606806
Rf12	C1	C1#4	161.413818
Rf13	B2	B2#3	181.963150
Rf14	a_157_376#	a_157_376##3	105.718460
Rf15	a_157_376##3	a_157_376##5	330.087067
Rf16	a_157_376##5	a_157_376##6	108.613464
Rf17	a_157_376##2	a_157_376##3	7.500000
Rf18	a_157_376##4	a_157_376##5	7.500000
Rf19	a_154_135##15	a_154_135##16	196.007645
Rf20	a_154_135##16	a_154_135##17	34.786316
Rf21	a_154_135##17	a_154_135##18	98.180603
Rf22	a_154_135##18	a_154_135##19	245.036407
Rf23	a_154_135##16	a_154_135##20	32.136841
Rf24	a_154_135##17	a_154_135##21	19.131779
Rf25	a_1102_392#	a_1102_392##2	107.903496
Rf26	a_1102_392##2	a_1102_392##4	74.493446
Rf27	a_1102_392##4	a_1102_392##5	46.363258
Rf28	a_1102_392##2	a_1102_392##6	19.626133
Rf29	a_1102_392##3	a_1102_392##4	15.000000
Rf30	a_1346_123#	a_1346_123##3	100.352066
Rf31	a_1346_123##3	a_1346_123##4	115.902962
Rf32	a_1346_123##2	a_1346_123##3	7.500000
Rf33	B1	B1#6	1.901346
Rf34	B1#6	B1	11.180702
Rf35	VGND#1	VGND#2	59.934223
Rf36	VGND#2	VGND#3	82.312668
Rf37	VGND#3	VGND#4	83.080086
Rf38	VGND#4	VGND#5	77.236038
Rf39	VGND#5	VGND#6	48.676620
Rf40	VGND#6	VGND#7	17.199682
Rf41	VGND#7	VGND#8	80.851654
Rf43	VGND#2	VGND#10	58.003994
Rf44	VGND#3	VGND#11	57.473431
Rf45	VGND#4	VGND#12	20.669479
Rf46	VGND#5	VGND#13	58.086449
Rf47	VGND#7	VGND#14	44.445877
Rf48	VGND#8	VGND#15	73.314125
Rf49	VPWR#1	VPWR#2	244.694626
Rf50	VPWR#2	VPWR#3	65.696381
Rf51	VPWR#3	VPWR#4	40.153240
Rf52	VPWR#4	VPWR#5	25.543140
Rf53	VPWR#5	VPWR#6	93.503586
Rf54	VPWR#6	VPWR#7	90.946815
Rf56	VPWR#2	VPWR#9	32.539131
Rf57	VPWR#3	VPWR#10	32.539131
Rf58	VPWR#5	VPWR#11	32.539131
Rf59	VPWR#6	VPWR#12	18.148239
Rf60	VPWR#7	VPWR#13	36.258804
Rf65	a_154_135##4	a_154_135##18	53.410934
Re2	X	X#4	14.521620
Re3	VPWR#1	VPWR	2.920302
Re4	VPWR	VPWR#4	1.251558
Re5	VGND#1	VGND	2.920302
Re6	VGND	VGND#6	1.251558
*
*       CAPACITOR CARDS
*
*
C1	X#2	a_157_376##4	1.81297e-16
C2	a_1346_123##2	a_154_135##15	1.21956e-16
C3	a_157_376##4	A2#3	7.01429e-19
C4	VPWR#6	A2#5	1.57503e-18
C5	a_154_135##16	C1#1	8.579e-18
C6	C1#1	B2#4	4.01765e-18
C7	a_154_135##12	VGND#14	2.18203e-17
C8	X#6	X#5	3.1466e-18
C9	VPWR#5	A2#5	4.88179e-18
C10	a_154_135##4	C1#3	5.31488e-20
C11	a_157_376##2	B2#6	2.39753e-18
C12	a_157_376##4	VPWR#11	5.30304e-17
C13	X#2	VPWR#12	7.55999e-18
C14	VGND#3	VGND#2	5.03108e-19
C15	a_154_135##16	a_154_135##11	1.68873e-19
C16	a_154_135##4	a_154_135##11	7.95813e-17
C17	a_71_135#	a_154_135##12	1.03777e-18
C18	C1#3	C1#1	8.39167e-18
C19	a_1102_392##3	B2#6	3.30737e-19
C20	a_1102_392##5	VPWR#2	3.4477e-17
C21	A2#1	VGND#14	1.68864e-17
C22	X#2	a_157_376##6	1.1854e-17
C23	VPWR#6	A2#4	1.54769e-17
C24	X#6	VGND#13	4.8087e-17
C25	VGND#15	a_154_135##12	5.13893e-19
C26	A2#1	a_71_135#	1.2102e-17
C27	VGND#10	a_1346_123##2	4.24467e-17
C28	a_157_376##4	VPWR#12	1.51161e-18
C29	VGND#14	a_154_135##11	9.31924e-19
C30	a_154_135##4	A2#3	1.28598e-17
C31	VGND#14	A2#6	2.33084e-18
C32	VGND#15	A2#1	1.13005e-18
C33	X#6	X#8	4.80644e-19
C34	a_157_376##6	a_157_376##4	1.93595e-18
C35	VPWR#6	A1#5	1.55343e-17
C36	a_71_135#	A2#6	3.09355e-17
C37	a_1346_123##4	a_1346_123##2	2.59247e-18
C38	VGND#14	A1#4	1.37959e-19
C39	A2#6	VGND#15	1.7148e-17
C40	a_157_376##6	VPWR#12	2.00218e-18
C41	a_71_135#	A1#4	2.47564e-19
C42	VGND#14	X#6	3.5172e-17
C43	a_71_135##2	A2#6	9.33562e-19
C44	a_1346_123##4	VGND#10	4.93334e-17
C45	VPWR#6	A1#6	1.67737e-18
C46	VGND#15	A1#4	9.91771e-19
C47	A2#7	A2#3	1.22995e-18
C48	a_71_135#	a_154_135##11	2.11615e-19
C49	a_154_135##19	A2#6	1.98789e-19
C50	B1#7	B1#2	1.75941e-18
C51	a_1102_392##2	a_157_376#	1.85927e-17
C52	a_71_135##2	A1#4	4.52549e-17
C53	a_71_135#	X#6	4.63296e-18
C54	VPWR#13	a_157_376##6	4.31061e-17
C55	a_71_135##4	A2#6	3.42415e-19
C56	VGND#11	VGND#10	4.487e-18
C57	B2#4	B1#7	2.22122e-17
C58	a_154_135##19	A1#4	3.33141e-17
C59	a_71_135##2	A1#3	8.89542e-19
C60	VPWR#6	VPWR#11	3.12723e-18
C61	a_154_135##5	C1#3	8.48888e-20
C62	a_157_376##6	A1#2	2.02585e-19
C63	a_71_135##4	A1#4	1.96076e-18
C64	a_1102_392##2	a_1102_392##6	4.33732e-18
C65	VGND#11	a_1346_123##4	3.88771e-17
C66	a_154_135##19	A1#3	2.88796e-17
C67	a_71_135##4	A1#3	3.09075e-17
C68	a_157_376##4	VPWR#6	7.21196e-17
C69	a_1102_392##2	a_157_376##2	1.50524e-17
C70	B2#5	B2#4	3.33226e-17
C71	B1#7	B1#1	3.67315e-17
C72	a_157_376##4	VPWR#5	5.61623e-18
C73	VPWR#6	VPWR#12	1.18445e-17
C74	VGND#4	a_154_135##17	4.28706e-18
C75	a_157_376##4	VPWR#3	2.97886e-18
C76	a_154_135##17	a_157_376##2	9.16731e-18
C77	a_71_135#	A2#3	2.06839e-17
C78	a_1102_392#	B1#5	4.19511e-17
C79	VGND#12	VGND#11	4.28376e-18
C80	a_157_376##4	VPWR#2	2.32997e-18
C81	a_157_376#	B1#5	4.62484e-17
C82	a_154_135##16	a_157_376##2	6.99423e-17
C83	VGND#3	a_154_135##17	4.52618e-18
C84	B2#6	B2#4	8.51996e-18
C85	a_1102_392#	B1#4	1.30824e-18
C86	a_157_376##6	VPWR#6	7.01334e-17
C87	a_1102_392##6	B1#5	1.28928e-18
C88	B2#6	B2#5	3.44477e-17
C89	X#2	A2#1	9.58923e-19
C90	a_157_376#	B1#4	5.74911e-17
C91	a_1102_392#	B1#3	1.10438e-19
C92	a_1102_392#	B2#1	2.2995e-19
C93	B1#4	a_1102_392##6	2.92432e-17
C94	VPWR#11	A2#1	4.07415e-19
C95	C1#3	B2#6	2.26097e-18
C96	VGND#1	VGND#3	5.50072e-18
C97	a_157_376#	B2#1	1.22204e-18
C98	A2#3	VGND#15	5.01745e-18
C99	VPWR#3	a_154_135##11	6.10725e-20
C100	VPWR#13	VPWR#6	3.36171e-18
C101	a_157_376##2	B1#4	1.32835e-18
C102	a_157_376##4	A2#1	3.65213e-19
C103	VGND#1	VGND#2	8.02142e-17
C104	C1#5	B2#6	1.27478e-17
C105	a_1102_392#	B1#2	7.09224e-20
C106	B2#1	a_1102_392##6	3.41292e-17
C107	a_1102_392##3	B1#4	3.35991e-19
C108	a_1102_392##2	VPWR#1	1.11348e-16
C109	X#5	VGND#12	4.33596e-17
C110	a_157_376##2	B2#1	5.73166e-17
C111	a_154_135##20	B1#4	2.97158e-19
C112	X#6	a_154_135##11	4.44004e-18
C113	X#4	VPWR#6	2.84271e-18
C114	a_1102_392##6	B2#7	1.00148e-18
C115	a_1102_392##3	B2#1	1.3819e-18
C116	C1#7	C1#5	3.31792e-17
C117	VPWR#1	a_154_135##16	2.53256e-18
C118	VGND#13	VGND#12	2.50117e-18
C119	a_157_376##2	B2#7	4.8698e-17
C120	a_157_376#	B1#3	2.4555e-18
C121	a_154_135##20	B2#1	4.34576e-19
C122	a_1102_392##3	B2#7	4.39183e-17
C123	VPWR#2	a_154_135##11	6.15299e-20
C124	VPWR#6	A2#3	9.8214e-20
C125	a_157_376##2	C1#1	1.9619e-17
C126	a_157_376#	B1#2	7.74421e-19
C127	X#5	VGND#13	3.58587e-17
C128	a_154_135##20	B2#7	2.65348e-18
C129	a_157_376##6	A1#4	6.65065e-19
C130	a_154_135#	C1#7	5.99622e-18
C131	VGND#1	a_154_135##16	2.67337e-18
C132	a_1102_392##3	C1#1	4.42543e-17
C133	a_157_376##2	C1#6	2.03744e-17
C134	a_1346_123#	a_1102_392#	1.58234e-18
C135	a_154_135##20	C1#1	3.11712e-17
C136	a_157_376#	B2#4	1.13438e-18
C137	VPWR#9	B2#7	4.52444e-20
C138	VGND#5	X#6	2.81269e-18
C139	a_71_135##2	A1#2	2.80472e-18
C140	a_154_135##6	a_154_135#	3.81383e-17
C141	a_154_135##20	C1#6	2.86501e-17
C142	a_154_135##15	a_1102_392#	1.82401e-18
C143	VPWR#9	C1#1	8.2176e-20
C144	a_154_135##19	A2#3	1.00561e-17
C145	VPWR#5	A2#3	1.56086e-20
C146	A2#5	a_154_135##11	4.13778e-18
C147	a_1102_392##5	C1#6	5.59304e-17
C148	a_154_135##20	a_154_135##5	5.99848e-19
C149	VPWR#9	C1#6	2.46257e-18
C150	a_154_135##8	a_154_135##6	3.80682e-17
C151	VPWR#1	a_154_135##15	5.94479e-18
C152	a_154_135##15	a_157_376#	7.57691e-17
C153	VGND#14	VGND#13	2.58718e-18
C154	a_1102_392##5	a_154_135##5	1.96054e-18
C155	X#1	C1#6	1.33812e-18
C156	a_154_135##11	C1#7	4.14984e-19
C157	a_1102_392##6	B2#4	1.78233e-18
C158	VPWR#9	a_154_135##5	4.98638e-17
C159	VGND#1	a_1346_123#	7.80731e-17
C160	a_154_135##19	A1#2	5.19338e-19
C161	a_154_135##12	a_154_135##8	3.606e-17
C162	VGND#1	a_154_135##15	1.07936e-17
C163	X#1	a_154_135##5	3.65502e-17
C164	a_154_135##19	A2#4	1.33714e-17
C165	VGND#1	a_1346_123##2	6.00038e-17
C166	VPWR#9	a_154_135##9	2.74703e-18
C167	VPWR#10	a_154_135##5	4.36232e-18
C168	X#1	a_154_135##9	4.47648e-17
C169	a_1346_123#	B1#2	1.72511e-19
C170	VGND#4	B2#3	1.77801e-18
C171	VGND#1	a_1346_123##4	7.90211e-18
C172	a_154_135##19	A1#5	1.14121e-17
C173	VPWR#2	C1#4	1.12402e-19
C174	a_154_135##15	a_157_376##2	3.94018e-18
C175	A2#1	a_154_135##12	2.76705e-17
C176	VGND#3	B2#3	5.09742e-17
C177	VPWR#10	a_154_135##9	3.79519e-17
C178	VGND#2	B2#3	3.61936e-17
C179	a_157_376##4	a_154_135##5	2.71947e-17
C180	a_157_376##2	B2#4	6.17382e-18
C181	VGND#2	B1#1	4.46208e-19
C182	a_154_135##19	A1#6	7.70063e-18
C183	VPWR#10	a_154_135##13	3.66907e-17
C184	a_1346_123#	B2#4	8.63875e-20
C185	a_71_135##4	A1#2	1.96857e-18
C186	VGND#4	C1#4	2.10886e-20
C187	A2#6	A2#1	3.00164e-17
C188	a_154_135##15	B1#3	2.8043e-17
C189	X#2	a_154_135##13	4.47277e-17
C190	A2#4	A2#3	2.73691e-18
C191	a_157_376##4	a_154_135##9	1.65334e-17
C192	VGND#6	X#6	9.86281e-18
C193	VPWR#10	a_154_135##14	2.74703e-18
C194	VPWR#11	a_154_135##13	2.74703e-18
C195	VGND#15	VGND#14	6.71758e-18
C196	VGND#2	B1#7	8.95581e-19
C197	VGND#7	a_154_135##4	5.39441e-19
C198	X#2	a_154_135##14	4.56888e-17
C199	a_157_376##4	a_154_135##13	1.69625e-17
C200	a_154_135##15	B1#2	2.74928e-17
C201	A1#4	A2#6	1.74355e-18
C202	a_157_376##2	C1#3	5.72465e-19
C203	B2#3	a_154_135##16	3.31646e-18
C204	VGND#4	a_154_135##4	4.66889e-19
C205	VPWR#11	a_154_135##14	4.46241e-17
C206	C1	C1#3	4.00764e-19
C207	a_71_135#	VGND#15	5.20309e-17
C208	X#2	A2#5	2.0457e-17
C209	a_157_376##4	a_154_135##14	1.98831e-17
C210	C1	a_154_135##11	4.81398e-18
C211	a_1102_392##3	B2#4	1.5389e-19
C212	A2#5	VPWR#11	2.73645e-17
C213	a_1102_392#	VPWR#1	7.88587e-17
C214	VGND#2	B2#5	1.9585e-18
C215	a_154_135##15	B2#4	1.37897e-17
C216	VGND#7	A2#7	2.86123e-17
C217	a_154_135##17	C1#4	3.1089e-18
C218	A1#3	A1#4	4.39127e-17
C219	VPWR#6	A1#1	8.2412e-19
C220	VGND#5	A2#7	4.62299e-19
C221	VPWR#1	a_157_376#	1.18825e-17
C222	X#2	A2#4	1.83595e-17
C223	a_1346_123##2	B1#3	9.0012e-18
C224	a_157_376##4	A2#5	5.57798e-17
C225	a_71_135##2	a_71_135#	1.54687e-18
C226	VGND#4	C1#3	2.22354e-20
C227	a_1346_123#	B1#6	8.31481e-18
C228	VPWR#11	A2#4	1.12145e-18
C229	A2#3	a_154_135##11	5.94724e-18
C230	VGND#5	a_154_135##11	1.86973e-20
C231	a_157_376##2	a_154_135##11	1.20534e-18
C232	VGND#1	a_1102_392#	1.08825e-18
C233	VPWR#1	a_157_376##2	1.15734e-17
C234	X#2	A1#5	3.82738e-19
C235	a_157_376##4	A2#4	5.42501e-17
C236	a_71_135##2	VGND#15	5.15798e-18
C237	a_71_135#	a_154_135##19	3.41614e-17
C238	a_154_135##4	a_154_135##17	1.98854e-18
C239	a_1102_392##3	VPWR#1	7.54026e-17
C240	a_1346_123##2	B1#2	5.28503e-20
C241	VGND#7	A1#1	1.06259e-19
C242	B1	B1#2	1.47086e-18
C243	VPWR#11	A1#5	2.77909e-19
C244	A2#4	VPWR#12	2.51737e-17
C245	a_1102_392##3	C1#3	1.29052e-19
C246	a_154_135##4	a_154_135##16	3.44435e-19
C247	a_1346_123#	B2#3	1.6234e-19
C248	a_157_376##4	A1#5	7.16639e-19
C249	X#2	A1#6	3.49087e-19
C250	a_157_376##6	A2#4	4.73236e-19
C251	VGND#3	C1#5	3.66733e-18
C252	a_1102_392##5	VPWR#1	1.15693e-17
C253	a_154_135##15	C1#3	8.46644e-19
C254	A1#5	VPWR#12	2.75338e-17
C255	a_154_135##20	B2#4	6.36523e-20
C256	VPWR#6	VPWR#5	8.96601e-19
C257	a_1346_123##2	B2#3	7.41206e-18
C258	VPWR#13	A2#4	4.56902e-19
C259	a_1346_123##2	B2#4	2.87586e-17
C260	VGND#10	B2#3	1.49355e-18
C261	a_157_376##6	A1#5	6.54452e-17
C262	X#4	a_71_135##2	3.08518e-17
C263	VGND#4	C1#7	1.93982e-18
C264	X#6	a_154_135##4	4.99091e-17
C265	B2#3	a_1346_123##4	7.41652e-18
C266	VGND#3	C1#3	6.93529e-20
C267	X#4	a_154_135##19	1.4234e-16
C268	VPWR#13	A1#5	3.08856e-18
C269	VGND#11	B2#3	2.20492e-17
C270	a_71_135##2	a_154_135##19	9.67976e-17
C271	VGND#4	a_154_135##11	5.91032e-20
C272	X#4	a_71_135##4	2.97164e-17
C273	B1#4	B1#5	3.61829e-17
C274	A1#6	a_157_376##6	2.38988e-17
C275	VPWR#1	B1#3	2.21835e-20
C276	VGND#12	B2#3	7.89903e-19
C277	VPWR#13	A1#6	3.85043e-17
C278	VPWR#1	B1#2	6.923e-21
C279	X#6	A2#7	1.56037e-19
C280	a_154_135##20	C1#3	5.88317e-19
C281	VGND#4	a_154_135#	8.5059e-18
C282	B2	B2#4	3.43128e-19
C283	a_71_135##4	a_71_135##2	2.71796e-18
C284	VPWR#1	B2#4	1.48119e-19
C285	B2#1	B1#4	1.42625e-17
C286	VGND#12	C1#4	5.54889e-19
C287	VGND#3	a_154_135#	9.27151e-20
C288	VGND#5	a_154_135##6	2.5008e-18
C289	VGND#10	B2#4	1.22273e-17
C290	VPWR#1	C1#3	7.67228e-20
C291	a_71_135##4	a_154_135##19	2.02925e-17
C292	VPWR#5	VPWR#3	1.36595e-18
C293	VGND#7	A2#3	1.60795e-19
C294	VGND#4	a_154_135##6	6.23002e-19
C295	a_1102_392#	B1#6	7.14373e-18
C296	B2#7	B2#1	4.12133e-17
C297	VGND#2	a_1346_123##2	2.49053e-17
C298	a_154_135##4	VGND#12	2.27458e-17
C299	a_154_135##4	X#5	6.01548e-17
C300	VGND#1	B1#3	3.07505e-20
C301	a_154_135##17	B2#6	2.60723e-18
C302	VGND#5	a_154_135##8	2.386e-18
C303	a_154_135##4	VGND#13	2.63704e-18
C304	VGND#1	B1#1	9.23501e-18
C305	VGND#1	B1#2	2.09579e-20
C306	a_1102_392##5	C1#3	1.87553e-19
C307	a_154_135##4	X#8	1.40627e-18
C308	C1#1	B2#7	4.75319e-17
C309	a_157_376##4	VPWR#4	4.27504e-18
C310	X#4	X#2	7.6738e-19
C311	VGND#1	B1#7	9.23501e-18
C312	VPWR#1	B2#6	1.23537e-19
C313	VGND#14	a_154_135##4	1.33017e-18
C314	VGND#4	a_154_135##8	2.83116e-19
C315	a_154_135##16	B2#6	8.9067e-18
C316	A2#1	a_154_135##11	9.8707e-18
C317	a_71_135#	a_154_135##4	3.67534e-17
C318	VGND#1	B2#5	2.17309e-18
C319	a_157_376##2	B2#3	1.56783e-19
C320	VGND#13	A2#7	2.5464e-19
C321	a_154_135##17	C1#5	3.20081e-17
C322	A2	A2#3	7.60434e-19
C323	C1#6	C1#1	4.16559e-17
C324	a_1346_123##4	B2#4	1.12996e-17
C325	A1#4	A2#4	4.75361e-19
C326	X#4	VPWR#12	1.62615e-18
C327	VPWR#6	A1#4	1.22404e-19
C328	A2#7	VGND#14	1.50561e-17
C329	X#4	a_157_376##6	7.24556e-17
C330	A2#7	a_71_135#	2.313e-18
C331	a_157_376##2	C1#4	1.4522e-18
C332	VPWR#3	VPWR#2	1.36819e-18
C333	VGND#15	A2#7	2.28003e-17
C334	X#4	VPWR#13	5.4103e-17
C335	VGND#7	A2#1	3.50828e-18
C336	a_154_135##5	C1#6	3.06252e-18
C337	VGND#2	a_1346_123##4	4.84612e-19
C338	a_154_135##17	C1#7	3.74057e-17
C339	VGND#3	VGND#11	1.93914e-18
C340	A1#6	A1#4	2.0841e-18
C341	a_1102_392#	a_157_376#	7.95717e-17
C342	C1#4	a_1102_392##5	1.65385e-18
C343	a_154_135##4	a_157_376##2	8.56543e-18
C344	A1#1	VGND#15	3.06479e-17
C345	a_154_135##9	a_154_135##5	5.15139e-17
C346	A1#1	a_71_135##2	1.20366e-17
C347	a_154_135##19	A1#1	9.59472e-19
C348	a_1346_123##4	C1#3	2.36404e-19
C349	a_1102_392##6	a_1102_392#	3.3339e-18
C350	a_71_135##4	A1#1	1.43839e-18
C351	a_154_135##17	a_154_135#	4.90072e-19
C352	VGND#11	B2#4	5.16109e-19
C353	a_154_135##4	X#1	6.03487e-17
C354	a_154_135##13	a_154_135##9	4.73315e-17
C355	a_1346_123#	B1#1	3.21337e-17
C356	a_157_376#	a_1102_392##6	4.92145e-17
C357	VPWR#9	a_154_135##11	5.04747e-19
C358	a_154_135##4	X#2	1.2623e-16
C359	VGND#5	X#5	4.30775e-18
C360	B2#3	B1#7	1.36968e-17
C361	VPWR#1	B1#5	6.90192e-18
C362	a_154_135##15	B1#1	2.83643e-17
C363	a_154_135##4	a_157_376##4	3.73568e-18
C364	a_154_135##14	a_154_135##13	4.92134e-17
C365	a_154_135##17	a_154_135##6	1.30183e-19
C366	B2#3	B2#5	2.37379e-17
C367	VPWR#1	B1#4	6.10418e-18
C368	B1#3	B1#2	8.15994e-18
C369	a_1346_123#	B1#7	8.81739e-19
C370	VGND#12	VGND#3	8.22673e-19
C371	a_157_376##2	a_157_376#	2.07208e-18
C372	VPWR#1	B2#1	6.09433e-18
C373	a_1346_123##2	B1#1	8.62722e-19
C374	C1#5	B2#3	5.53603e-18
C375	VGND#4	X#5	4.65735e-18
C376	VGND#6	a_154_135##12	4.31484e-18
C377	A2#5	a_154_135##14	2.74079e-17
C378	VPWR#1	B2#7	6.05653e-18
C379	a_154_135##15	B1#7	2.72143e-17
C380	VGND#11	C1#3	9.16657e-18
C381	X#4	A1#4	2.30579e-18
C382	X#2	A1#1	2.89399e-19
C383	a_154_135#	B2#3	3.64968e-19
C384	VPWR#1	C1#1	4.45525e-18
C385	a_157_376##2	a_1102_392##6	4.28375e-17
C386	X#4	A1#3	9.45021e-18
C387	a_1102_392##2	B1#3	1.04468e-19
C388	a_157_376##4	A1#1	1.08638e-19
C389	a_154_135##17	C1	3.23036e-17
C390	VPWR#1	C1#6	1.24126e-18
C391	C1	a_154_135##16	3.14717e-17
C392	A2#4	A2#5	4.59772e-17
C393	a_1346_123##2	B1#7	3.01189e-17
C394	a_154_135##11	X#1	8.30743e-18
C395	VPWR#4	a_154_135##11	8.19763e-20
C396	a_157_376##6	A1#1	3.23176e-19
C397	VGND#13	VGND#4	1.38955e-18
C398	a_154_135##15	B2#5	4.38461e-20
C399	a_1102_392##3	a_1102_392##6	4.69322e-18
C400	VGND#10	B1#7	9.04798e-19
C401	a_154_135##4	a_154_135#	5.60388e-18
C402	A1#5	A2#4	8.14981e-18
C403	a_154_135##4	a_154_135##6	4.43845e-19
C404	B2#4	B1#3	2.92459e-17
C405	a_1346_123##2	B2#5	1.2662e-18
C406	a_154_135##4	a_154_135##8	1.00453e-19
C407	a_157_376##2	a_1102_392##3	7.98867e-17
C408	a_1346_123##4	B1#7	2.08912e-19
C409	a_154_135##4	a_154_135##12	7.19504e-20
C410	A1#6	A1#5	2.74358e-17
C411	VGND#2	B2	3.6925e-17
C412	a_1346_123##2	a_154_135##16	2.30579e-18
C413	a_154_135##4	A2#1	6.15816e-18
C414	B2#5	VGND#10	1.76183e-17
C415	A1#4	A2#3	3.15298e-18
C416	A2#7	a_154_135##12	2.50183e-18
C417	X#6	a_154_135##6	1.33807e-18
C418	a_157_376##2	a_154_135##20	4.54719e-17
C419	A2#7	A2#1	1.22358e-17
C420	a_1102_392##2	B2#4	7.66677e-19
C421	VGND#7	a_71_135#	1.23878e-18
C422	a_1346_123#	B1	2.48127e-17
C423	a_1346_123##4	B2#5	4.232e-17
C424	a_154_135##15	B1	5.20879e-17
C425	VPWR#4	a_154_135##14	4.40701e-18
C426	a_154_135##19	X#2	6.53451e-17
C427	a_154_135##11	VPWR#10	1.29768e-18
C428	VGND#10	B2#6	7.01302e-19
C429	A1#2	A1#4	2.2784e-19
C430	a_1102_392##3	a_154_135##20	6.41826e-19
C431	a_157_376##2	a_1102_392##5	5.75611e-17
C432	a_154_135##17	a_1346_123##4	4.05976e-18
C433	A1#1	A2#6	1.20702e-18
C434	VGND#11	B2#5	1.34655e-18
C435	X#6	a_154_135##8	3.90612e-17
C436	A1#1	A1#4	1.1287e-18
C437	a_1346_123##4	B2#6	3.08036e-17
C438	A1#1	A1#3	1.86858e-19
C439	X#4	A2#4	3.34157e-19
C440	VGND	C1#3	3.12137e-20
C441	B2	VGND#10	1.83728e-17
C442	X#4	A1#5	1.9137e-17
C443	a_154_135##5	C1#4	1.32103e-18
C444	a_157_376##2	VPWR#9	3.77797e-17
C445	VGND#10	C1#5	2.87003e-19
C446	B2	a_1346_123##4	1.95381e-17
C447	C1	a_157_376##2	3.44648e-17
C448	VGND#11	B2	3.45324e-18
C449	VGND	A2#3	1.50042e-19
C450	a_1346_123##4	a_154_135##16	6.55808e-17
C451	X#4	A1#6	3.21618e-17
C452	B2#6	VGND#11	1.98243e-17
C453	VGND	A1#2	9.00153e-18
C454	C1	a_154_135##20	2.31809e-17
C455	a_154_135##17	VGND#11	5.82863e-17
C456	C1	a_1102_392##5	3.28775e-18
C457	X#6	a_154_135##12	2.63152e-17
C458	B1	a_1102_392#	2.31847e-17
C459	a_1346_123##4	C1#5	3.22369e-19
C460	X#1	C1	8.91578e-18
C461	a_1102_392##5	a_154_135##20	6.56511e-19
C462	X#4	A1#2	1.34468e-19
C463	a_154_135##17	B1#3	1.28831e-19
C464	VPWR	VPWR#6	1.25385e-16
C465	VPWR	VPWR#5	4.80223e-17
C466	VPWR	VPWR#3	4.92945e-17
C467	a_154_135##11	X#2	4.69352e-18
C468	VPWR	VPWR#2	9.53201e-17
C469	VGND#6	a_154_135##11	8.73387e-20
C470	C1#5	VGND#11	2.34843e-17
C471	a_154_135##4	A2#5	9.42198e-18
C472	VGND#11	a_154_135##16	1.77845e-17
C473	VPWR#1	B1#6	9.02809e-19
C474	VGND#12	B2#6	5.23323e-20
C475	a_154_135##17	a_154_135##21	4.05145e-19
C476	X#6	A2#1	1.13829e-18
C477	A2	VGND#14	9.54547e-18
C478	VGND#1	B1#6	2.00274e-18
C479	A2	a_71_135#	1.86889e-17
C480	VGND#15	A2	5.86237e-18
C481	C1#5	a_154_135##21	1.2912e-17
C482	B1#3	VNB	3.39831e-17
C483	VGND#1	B2#3	1.52863e-17
C484	B1#2	VNB	2.89551e-17
C485	B2#4	VNB	1.19353e-16
C486	VPWR	a_154_135##16	2.58129e-18
C487	C1#3	VNB	4.45894e-17
C488	a_154_135##11	VNB	9.6386e-17
C489	VGND#11	C1#7	7.04179e-19
C490	VPWR#9	a_1102_392##5	1.77231e-17
C491	X#1	a_154_135##20	6.04365e-19
C492	A2#3	VNB	3.93396e-17
C493	VGND#7	VGND#5	2.15149e-18
C494	A1#2	VNB	2.44416e-17
C495	VGND#12	C1#5	1.00277e-18
C496	B2#4	B1#4	7.5914e-19
C497	a_154_135##17	VGND#12	8.21867e-17
C498	X#6	A2#6	2.04453e-19
C499	A1	VGND#15	2.59744e-17
C500	a_71_135##2	A1	4.29132e-17
C501	C1#7	a_154_135##21	1.2912e-17
C502	a_154_135##16	B1#3	1.86955e-19
C503	a_154_135##17	B2#4	1.21824e-19
C504	B2	B2#5	5.66208e-18
C505	VGND#11	a_154_135#	1.03024e-19
C506	B2	B2#6	2.82963e-18
C507	B2	C1#5	6.42741e-19
C508	C1#7	VGND#12	2.36606e-17
C509	VPWR	a_71_135#	3.16056e-18
C510	VPWR	a_71_135##2	3.04628e-18
C511	VPWR#2	C1#6	3.17702e-18
C512	VPWR	a_154_135##19	6.66589e-18
C513	VGND	VGND#7	5.65176e-17
C514	X#5	a_154_135##17	1.73951e-18
C515	VGND	VGND#5	5.41491e-17
C516	X#4	A1#1	3.08034e-18
C517	VGND	VGND#4	1.31317e-16
C518	VGND	VGND#3	6.62979e-17
C519	X#5	C1#7	4.02306e-19
C520	VPWR	a_157_376##2	2.36318e-17
C521	C1	C1#6	7.07553e-18
C522	VPWR	a_1102_392##3	1.77418e-17
C523	VPWR	a_154_135##20	4.14279e-18
C524	a_154_135##4	C1#4	6.74075e-18
C525	C1	a_154_135##5	2.75154e-18
C526	a_1102_392##2	B1#4	1.8707e-17
C527	VPWR	a_1102_392##5	2.14436e-17
C528	VGND	a_154_135##17	2.16435e-17
C529	VGND	a_154_135##16	3.75671e-18
C530	VPWR	VPWR#9	1.61309e-17
C531	C1	a_154_135##9	4.85685e-19
C532	VGND#12	a_154_135#	4.17893e-17
C533	X#5	a_154_135##11	4.00571e-18
C534	VPWR	X#1	3.5853e-18
C535	A2	a_154_135##12	2.73433e-19
C536	VPWR	VPWR#10	1.58731e-17
C537	C1	a_154_135##13	2.39689e-19
C538	A2	A2#1	2.72372e-18
C539	VPWR	X#2	1.06966e-17
C540	B2#3	B2#4	1.69283e-18
C541	VPWR#10	VPWR#9	9.2618e-18
C542	VGND	X#6	1.71112e-17
C543	VPWR	VPWR#11	1.36022e-17
C544	A2	A2#6	2.72838e-18
C545	VPWR	a_157_376##4	4.04579e-17
C546	X#2	A2#3	1.61286e-18
C547	A2	A1#4	9.12331e-20
C548	VPWR	a_157_376##6	1.85584e-17
C549	VPWR#6	VNB	5.33994e-17
C550	VGND#5	VGND#4	2.98814e-18
C551	VPWR#5	VNB	2.47476e-17
C552	VPWR#3	VNB	2.48736e-17
C553	a_154_135#	X#5	1.34374e-17
C554	VPWR#2	VNB	5.20322e-17
C555	VGND	VGND#11	4.95717e-18
C556	VPWR#2	a_154_135##5	3.93582e-18
C557	VGND#7	VNB	2.47013e-17
C558	A1#1	A2#7	1.06627e-17
C559	VGND#5	VNB	2.4628e-17
C560	VGND#4	VNB	5.02911e-17
C561	VGND	X#5	1.34287e-17
C562	A1	A2#6	3.97954e-19
C563	VGND#3	VNB	3.31328e-17
C564	VGND#2	VNB	2.60664e-17
C565	A1	A1#4	6.37736e-19
C566	X#1	VPWR#10	1.00957e-18
C567	VGND#12	a_154_135##6	1.74704e-18
C568	VGND	a_71_135#	4.21327e-18
C569	VGND	VGND#15	2.76857e-18
C570	a_1102_392##2	VNB	6.02911e-18
C571	a_154_135##16	B2#4	2.91742e-17
C572	VGND	a_71_135##2	1.1722e-17
C573	a_154_135##17	C1#3	1.22509e-17
C574	a_1102_392##2	B2#1	1.84492e-17
C575	a_154_135##17	VNB	1.32969e-17
C576	VGND	a_154_135##19	3.07023e-18
C577	a_154_135##16	VNB	4.01443e-18
C578	VGND	a_71_135##4	1.33381e-17
C579	a_157_376##4	a_154_135##11	3.7581e-18
C580	VGND#13	a_154_135#	1.1595e-18
C581	X#6	VNB	2.28292e-18
C582	B1	VPWR#1	2.06309e-17
C583	a_154_135##16	B1#4	4.0002e-20
C584	VGND#1	B1	2.51117e-17
C585	a_1346_123#	VNB	4.20788e-17
C586	a_154_135##15	VNB	9.70111e-18
C587	a_1346_123##2	VNB	1.51641e-17
C588	X#5	a_154_135##6	4.5574e-17
C589	VGND#10	VNB	9.50373e-18
C590	VPWR#3	a_154_135##9	3.93582e-18
C591	a_1346_123##4	VNB	3.03531e-18
C592	VGND#11	VNB	6.21285e-18
C593	VGND#12	VNB	4.57381e-18
C594	X#5	VNB	2.60419e-18
C595	VGND#1	B2	9.60304e-18
C596	VGND#13	VNB	4.51417e-18
C597	VGND#14	VNB	4.5012e-18
C598	a_71_135#	VNB	2.89424e-18
C599	VPWR	C1#1	1.33611e-18
C600	VGND#15	VNB	1.09916e-17
C601	VGND#12	a_154_135##8	2.56711e-19
C602	a_71_135##2	VNB	9.64422e-18
C603	VPWR	C1#6	2.0226e-18
C604	a_154_135##19	VNB	1.59568e-17
C605	C1	C1#4	2.4127e-17
C606	B1	B1#6	4.4969e-17
C607	a_71_135##4	VNB	2.45117e-17
C608	VPWR	a_154_135##5	4.58629e-19
C609	a_157_376##2	VPWR#2	5.95267e-18
C610	a_1102_392#	VNB	5.63238e-17
C611	a_157_376#	VNB	2.63536e-18
C612	VPWR	a_154_135##9	5.18211e-19
C613	VGND	C1#5	7.86586e-18
C614	a_154_135##4	C1	1.72355e-17
C615	C1#3	B2#4	8.23709e-18
C616	a_154_135##6	VGND#13	1.86322e-17
C617	a_157_376##2	VNB	2.01787e-17
C618	VGND	C1#7	8.22317e-18
C619	VPWR	a_154_135##13	5.18211e-19
C620	a_1102_392##3	VNB	4.90804e-18
C621	VGND	a_154_135#	4.43423e-18
C622	a_154_135##20	VNB	6.95595e-19
C623	VPWR	a_154_135##14	7.98319e-19
C624	VGND	a_154_135##6	8.98766e-18
C625	a_1102_392##5	VNB	9.31047e-18
C626	VPWR#9	VNB	4.10389e-18
C627	VGND	a_154_135##8	6.14326e-18
C628	VPWR	A2#5	1.11015e-17
C629	VGND#13	a_154_135##11	9.48746e-19
C630	VGND	a_154_135##12	6.59171e-18
C631	VPWR#10	VNB	5.22667e-20
C632	VPWR	A2#4	9.06176e-18
C633	B2	B2#3	7.23392e-18
C634	VGND	A2#1	3.02562e-18
C635	X#2	VNB	7.53554e-20
C636	VPWR#11	VNB	2.2955e-18
C637	VPWR	A1#5	8.95535e-18
C638	X#2	VPWR#10	1.01262e-18
C639	a_157_376##4	VNB	2.37921e-18
C640	VPWR	A1#6	4.84858e-18
C641	X#5	a_154_135##8	1.22097e-18
C642	a_157_376##4	VPWR#9	8.98522e-18
C643	VGND	A1#3	5.64967e-18
C644	a_157_376##6	VNB	3.13372e-18
C645	VPWR#13	VNB	3.38948e-17
C646	B1#1	VNB	3.14018e-17
C647	X#4	A1	3.42347e-18
C648	B1#7	VNB	2.72466e-17
C649	VPWR	VPWR#1	3.85377e-17
C650	a_1346_123#	a_154_135##15	5.48883e-17
C651	B2#5	VNB	2.32007e-17
C652	B2#6	VNB	2.69161e-17
C653	B2#7	B2#4	4.57266e-18
C654	C1#5	VNB	3.0228e-17
C655	C1#7	VNB	2.96618e-17
C656	a_154_135#	VNB	2.97416e-17
C657	a_154_135##6	VNB	2.98384e-17
C658	VPWR	VPWR#4	2.31735e-17
C659	a_154_135##8	VNB	2.79905e-17
C660	A2	A2#7	3.74208e-19
C661	a_154_135##12	VNB	2.79061e-17
C662	VPWR	X#4	1.30237e-17
C663	VPWR#3	a_154_135##13	3.93582e-18
C664	A2#1	VNB	3.50132e-17
C665	A2#6	VNB	1.17924e-17
C666	A2	A1#1	5.3563e-19
C667	C1#4	C1#3	2.03898e-18
C668	A1#4	VNB	3.46035e-17
C669	A1#3	VNB	6.89877e-17
C670	VGND#4	VGND#3	3.42796e-18
C671	a_154_135##8	VGND#13	2.03175e-17
C672	B1#5	VNB	3.83315e-17
C673	B1#4	VNB	3.3512e-17
C674	B2#1	VNB	3.14851e-17
C675	VPWR#11	VPWR#10	9.2618e-18
C676	B2#7	VNB	3.41487e-17
C677	a_157_376##4	X#1	6.03895e-17
C678	C1#1	VNB	3.8172e-17
C679	VPWR	a_154_135##4	1.44861e-17
C680	C1#6	VNB	3.55704e-17
C681	a_154_135##5	VNB	3.69341e-17
C682	VGND#14	a_154_135##6	2.79319e-19
C683	a_154_135##9	VNB	2.98419e-17
C684	a_154_135##16	C1#3	2.34359e-17
C685	a_154_135##13	VNB	2.87459e-17
C686	a_154_135##14	VNB	3.35144e-17
C687	a_154_135##17	a_154_135##11	2.64941e-19
C688	A2#5	VNB	4.28247e-17
C689	a_154_135##11	C1#4	6.42312e-18
C690	VPWR#6	a_154_135##14	1.08203e-18
C691	VGND	X#4	4.93725e-17
C692	A2#4	VNB	4.39395e-17
C693	A1#5	VNB	4.22141e-17
C694	VGND	VGND#6	2.43011e-17
C695	A1#6	VNB	5.52911e-17
C696	VGND	B2#3	9.74314e-18
C697	VPWR#1	VNB	3.0458e-16
C698	VGND#1	VNB	2.30593e-16
C699	a_154_135##16	B2#7	1.472e-19
C700	a_154_135##8	X#8	1.49424e-17
C701	a_1346_123##2	a_1346_123#	2.38922e-18
C702	VGND	a_154_135##4	1.08347e-17
C703	VPWR#4	VNB	1.26455e-17
C704	VGND	A2#7	2.02422e-17
C705	X#4	VNB	7.60328e-17
C706	VGND#6	VNB	1.3704e-17
C707	VGND	A1#1	1.90535e-17
C708	B1#6	VNB	9.15807e-17
C709	B2#3	VNB	1.04628e-16
C710	VPWR	C1	4.78275e-18
C711	C1#4	VNB	3.13847e-17
C712	X#2	VPWR#11	5.23892e-18
C713	a_154_135##4	VNB	1.47943e-17
C714	a_157_376##4	VPWR#10	4.36756e-17
C715	A2#7	VNB	5.59915e-17
C716	A1#1	VNB	6.01468e-17
C717	VGND#13	a_154_135##12	5.70692e-19
C718	VGND	C1	3.3432e-18
C719	C1	VNB	6.1645e-18
C720	VGND#14	a_154_135##8	6.16296e-19
C721	B1	VNB	6.08816e-17
C722	B2	VNB	2.75532e-18
C723	A2	VNB	4.48564e-19
C724	A1	VNB	6.89446e-18
C725	VPWR	VNB	2.96985e-16
C726	VGND	VNB	2.92108e-16
C727	a_154_135##12	X#8	1.49424e-17
C728	X	a_154_135##11	9.09435e-18
C729	X	a_154_135##6	3.97693e-19
C730	VGND#8	A2#7	4.76016e-17
C731	X	A2	1.19921e-18
C732	VGND#8	A1#4	1.77717e-19
C733	VGND#8	A2#3	6.98106e-20
C734	X	a_154_135#	3.96406e-19
C735	VGND#8	a_71_135##4	1.17059e-17
C736	X	VPWR#6	3.59565e-18
C737	X	a_157_376##6	2.31267e-19
C738	VGND#6	X	8.3249e-19
C739	VGND#8	VNB	9.20131e-17
C740	VGND#8	VGND#7	6.40224e-19
C741	X	A2#3	4.9522e-19
C742	VPWR#7	A1#6	3.53769e-18
C743	X	VNB	2.73473e-18
C744	X	a_154_135##19	1.02454e-17
C745	X	VGND#7	1.45649e-18
C746	VGND	VGND#8	1.66757e-16
C747	VGND#8	a_71_135##2	6.90407e-18
C748	VPWR#7	VPWR#6	1.2403e-18
C749	X	A2#6	1.7908e-18
C750	a_157_376##6	VPWR#7	5.81738e-18
C751	X	a_157_376##4	8.29501e-18
C752	VGND	X	3.99e-17
C753	X	a_71_135##2	8.75597e-18
C754	X	VGND#8	2.64035e-18
C755	VGND#8	VGND#15	1.90393e-18
C756	X	A2#7	1.05801e-18
C757	VPWR	VPWR#7	9.02713e-17
C758	X	A2#1	1.22936e-17
C759	X	VPWR#11	2.99992e-18
C760	X	VGND#15	1.66663e-17
C761	X	a_154_135##4	4.86768e-17
C762	X#4	VGND#8	1.19355e-17
C763	X	a_154_135##12	1.37348e-17
C764	X#4	VPWR#7	2.37604e-18
C765	X	X#2	1.36695e-17
C766	VPWR	X	1.79756e-18
C767	VPWR#7	VNB	4.69885e-17
C768	a_71_135#	X	6.14603e-17
C769	VGND#8	A1#2	8.32819e-18
C770	X	a_154_135##8	6.59373e-19
C771	X	A1	3.40333e-18
C772	VGND#8	A1#1	5.68276e-17
C773	X	VGND#14	3.62972e-17
C774	VGND#8	A1#3	3.95018e-18
*
*
.ENDS sky130_fd_sc_hs__a221o_4
*
