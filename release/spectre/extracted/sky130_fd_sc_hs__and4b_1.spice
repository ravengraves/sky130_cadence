* Extracted by Quantus, converted by sky130cad/quantus.py
*
*
*
*                       LINUX           Wed Nov 18 08:18:41 2026
*
*
*
*  PROGRAM  advgen
*
*  Name           : advgen - Quantus - (64-bit)
*  Version        : 25.1.0-p047
*  Build Date     : Thu Dec 11 23:20:30 PST 2025
*
*  HSPICE LIBRARY
*
*  OPERATING_TEMPERATURE 150
*  QRC_TECH_DIR <path>/tech
*
*
*

*
.SUBCKT sky130_fd_sc_hs__and4b_1 VPB VNB VGND VPWR X C A_N B D
*
*
*  caps2d version: 10
*
*
*       TRANSISTOR CARDS
*
*
XM11 a_27_74##6 A_N#3 VGND#7 VNB sky130_fd_pr__nfet_01v8_lvt l=0.15 w=0.55 ad=0.15675 as=0.14575 pd=1.67 ps=1.63
XM7 a_226_424##8 a_27_74# a_353_124# VNB sky130_fd_pr__nfet_01v8_lvt l=0.15 w=0.64 ad=0.1824 as=0.221125 pd=1.85 ps=2.08
XM1 a_353_124# B#1 a_448_139# VNB sky130_fd_pr__nfet_01v8_lvt l=0.15 w=0.64 ad=0.221125 as=0.1536 pd=2.08 ps=1.76
XM4 a_448_139# C#2 a_526_139# VNB sky130_fd_pr__nfet_01v8_lvt l=0.15 w=0.64 ad=0.1536 as=0.3418 pd=1.76 ps=2.55
XM0 a_526_139# D#1 VGND#6 VNB sky130_fd_pr__nfet_01v8_lvt l=0.15 w=0.64 ad=0.3418 as=0.3107 pd=2.55 ps=2.34
XM3 VGND#6 a_226_424# X#3 VNB sky130_fd_pr__nfet_01v8_lvt l=0.15 w=0.74 ad=0.3107 as=0.2109 pd=2.34 ps=2.05
XM9 a_27_74##7 A_N#1 VPWR#9 VPB sky130_fd_pr__pfet_01v8 l=0.15 w=0.84 ad=0.2478 as=0.336 pd=2.27 ps=2.48
XM8 VPWR#9 a_27_74##3 a_226_424##6 VPB sky130_fd_pr__pfet_01v8 l=0.15 w=0.84 ad=0.336 as=0.3192 pd=2.48 ps=2.44
XM10 a_226_424##6 B#3 VPWR#7 VPB sky130_fd_pr__pfet_01v8 l=0.15 w=0.84 ad=0.3192 as=0.7728 pd=2.44 ps=3.52
XM2 VPWR#7 C#1 a_226_424##4 VPB sky130_fd_pr__pfet_01v8 l=0.15 w=0.84 ad=0.7728 as=0.294 pd=3.52 ps=2.38
XM5 a_226_424##4 D#3 VPWR#6 VPB sky130_fd_pr__pfet_01v8 l=0.15 w=0.84 ad=0.294 as=0.5026 pd=2.38 ps=3.26
XM6 VPWR#6 a_226_424##3 X#1 VPB sky130_fd_pr__pfet_01v8 l=0.15 w=1.12 ad=0.5026 as=0.3304 pd=3.26 ps=2.83
*
*
*       RESISTOR AND CAP/DIODE CARDS
*
Rg1	A_N#1	A_N#2	448.493469
Rg2	A_N#2	A_N#3	391.125610
Rg3	a_27_74#	a_27_74##2	1106.984131
Rg4	a_27_74##2	a_27_74##3	389.830780
Rg5	B#1	B#2	423.458374
Rg6	B#2	B#3	405.626038
Rg7	C#1	C#2	837.009338
Rg8	C#2	C#3	279.244598
Rg9	D#1	D#2	452.792206
Rg10	D#2	D#3	391.579895
Rg11	a_226_424#	a_226_424##2	306.251678
Rg12	a_226_424##2	a_226_424##3	432.953217
Rf1	A_N#4	A_N	1.963513
Rf2	A_N#2	A_N#6	82.079918
Rf3	A_N#4	A_N#6	3.777997
Rf4	a_27_74##2	a_27_74##5	165.960739
Rf5	a_27_74##5	a_27_74##6	118.032372
Rf6	a_27_74##5	a_27_74##7	84.491028
Rf7	B	B#4	1.221360
Rf8	B#5	B#2	81.337761
Rf9	B#4	B#5	7.118146
Rf10	B	B#7	1.221360
Rf11	B#5	B#7	8.237855
Rf12	C#4	C	1.179130
Rf13	C#3	C#6	161.411926
Rf14	C#6	C	1.179130
Rf15	C#4	C#6	15.178270
Rf16	D	D#2	162.201172
Rf17	a_226_424##4	a_226_424##5	19.676609
Rf18	a_226_424##5	a_226_424##6	91.183853
Rf19	a_226_424##5	a_226_424##7	58.038216
Rf20	a_226_424##7	a_226_424##8	103.057823
Rf21	a_226_424##7	a_226_424##2	236.846466
Rf22	X#2	X	0.367216
Rf23	X	X#3	82.838799
Rf24	X#2	X	13.219784
Rf25	X#1	X#2	5.000000
Rf27	VGND#2	VGND#3	100.785156
Rf28	VGND#3	VGND#4	104.822197
Rf30	VGND#2	VGND#6	46.120842
Rf31	VGND#4	VGND#7	33.552704
Rf33	VPWR#2	VPWR#3	101.040833
Rf34	VPWR#3	VPWR#4	104.547249
Rf36	VPWR#2	VPWR#6	35.274624
Rf37	VPWR#3	VPWR#8	9.133158
Rf38	VPWR#8	VPWR#7	15.000000
Rf39	VPWR#4	VPWR#9	31.141060
Rf40	VPWR#7	VPWR#8	15.000000
Re1	VPWR#3	VPWR	1.091357
Re2	VGND	VGND#3	1.091398
*
*       CAPACITOR CARDS
*
*
C1	a_27_74##5	a_226_424##7	2.6757e-19
C2	a_27_74##5	a_226_424##5	1.22903e-18
C3	a_226_424##5	X#1	2.17944e-18
C4	a_226_424##5	VPWR#6	5.8463e-17
C5	a_226_424##5	a_226_424##4	4.95053e-18
C6	a_226_424##5	VPWR#7	1.07376e-16
C7	a_27_74##5	a_226_424##8	1.97358e-17
C8	VGND#6	X#3	5.68339e-17
C9	a_226_424##6	a_226_424##5	1.50739e-18
C10	a_27_74##6	a_27_74##5	1.75105e-18
C11	a_226_424##7	C#2	2.80994e-17
C12	a_226_424##5	C#2	2.47558e-18
C13	X#3	X#1	3.78573e-18
C14	a_226_424##7	B#1	9.73865e-18
C15	a_27_74##5	a_226_424##6	2.8512e-17
C16	a_27_74##5	VPWR#9	3.34822e-17
C17	VGND#7	a_226_424##8	4.66924e-18
C18	a_27_74##6	a_226_424##8	1.5728e-17
C19	a_27_74##6	VGND#7	6.49581e-17
C20	a_27_74##5	C#2	3.54438e-20
C21	a_226_424##5	a_226_424##3	2.40284e-18
C22	a_27_74##5	B#1	9.16239e-20
C23	X#3	a_226_424#	3.48383e-17
C24	a_226_424##5	D#3	3.48963e-17
C25	VPWR#6	X#1	4.13128e-17
C26	a_226_424#	VGND#6	2.4142e-17
C27	a_27_74##5	a_27_74#	9.82074e-19
C28	a_226_424##8	a_226_424##6	9.96155e-18
C29	X#3	D#1	3.56393e-18
C30	a_226_424##5	C#1	3.61233e-17
C31	D#1	VGND#6	2.76758e-17
C32	a_27_74##5	A_N#3	1.75957e-18
C33	X#3	C#2	8.18959e-19
C34	a_226_424##5	B#3	1.33221e-18
C35	VGND#6	C#2	3.97911e-18
C36	X#3	B#1	4.66335e-19
C37	VPWR#7	VPWR#6	1.5672e-18
C38	VGND#6	B#1	1.54269e-18
C39	a_226_424##5	a_27_74##3	3.57431e-19
C40	a_27_74##6	a_27_74##7	2.61307e-19
C41	a_226_424##8	D#1	1.5629e-18
C42	VGND#6	a_27_74#	9.47762e-19
C43	a_226_424##5	A_N#1	3.22877e-19
C44	a_226_424##8	C#2	2.49864e-18
C45	a_226_424##6	VPWR#7	3.58891e-17
C46	a_27_74##5	C#1	4.79235e-19
C47	a_226_424##8	B#1	1.13814e-17
C48	VPWR#9	VPWR#7	1.28002e-17
C49	VGND#7	B#1	1.76322e-19
C50	VPWR#9	a_226_424##6	1.67183e-17
C51	a_226_424##8	a_27_74#	5.17232e-17
C52	a_27_74##5	B#3	1.14397e-18
C53	a_27_74##7	a_226_424##6	3.16551e-18
C54	VGND#7	a_27_74#	9.23495e-18
C55	a_226_424##8	A_N#3	2.63055e-18
C56	a_27_74##5	a_27_74##3	6.13901e-18
C57	a_27_74##6	a_27_74#	3.37891e-18
C58	a_27_74##7	VPWR#9	5.55121e-17
C59	A_N#3	VGND#7	2.54764e-17
C60	a_27_74##6	A_N#3	3.18843e-17
C61	VPWR#7	C#2	3.86543e-19
C62	a_27_74##5	A_N#1	1.30449e-18
C63	a_226_424##7	a_226_424##2	2.83433e-18
C64	a_226_424##7	D#2	5.81328e-18
C65	a_226_424##5	D#2	4.0577e-18
C66	D#1	a_226_424#	2.07845e-17
C67	X#1	a_226_424##3	3.65983e-17
C68	a_226_424##6	a_27_74#	4.54349e-19
C69	a_226_424##3	VPWR#6	3.19171e-17
C70	a_226_424##7	C#3	2.17717e-18
C71	X#1	D#3	3.05121e-19
C72	C#2	D#1	1.27015e-17
C73	D#3	VPWR#6	3.0886e-17
C74	X#1	C#1	2.14016e-19
C75	VPWR#7	a_226_424##3	3.61793e-19
C76	a_226_424##7	B#2	9.954e-19
C77	D#3	a_226_424##4	1.95174e-17
C78	VPWR#6	C#1	1.18219e-18
C79	B#2	a_226_424##5	9.52914e-18
C80	VPWR#7	D#3	1.39763e-18
C81	B#1	C#2	4.11096e-17
C82	C#1	a_226_424##4	5.33957e-18
C83	a_226_424##6	D#3	1.3946e-19
C84	a_226_424##7	a_27_74##2	1.15977e-19
C85	VPWR#7	C#1	5.54224e-17
C86	a_226_424##5	a_27_74##2	4.28078e-20
C87	a_27_74#	B#1	3.17019e-17
C88	a_226_424##6	C#1	4.29624e-19
C89	VPWR#7	B#3	5.35438e-17
C90	X#3	a_226_424##2	3.71887e-17
C91	VPWR#9	C#1	2.44578e-19
C92	a_226_424##7	A_N#2	8.70969e-20
C93	a_226_424##6	B#3	4.26747e-17
C94	a_226_424##2	VGND#6	4.1244e-17
C95	VPWR#7	a_27_74##3	3.14769e-18
C96	A_N#3	a_27_74#	1.01679e-17
C97	VPWR#9	B#3	5.1597e-18
C98	a_226_424##6	a_27_74##3	4.20216e-17
C99	VGND#3	a_226_424##8	5.29074e-18
C100	a_27_74##5	B#2	5.30774e-18
C101	VPWR#7	A_N#1	1.28888e-18
C102	a_27_74##3	VPWR#9	2.81084e-17
C103	a_226_424##6	A_N#1	1.14186e-18
C104	a_27_74##7	a_27_74##3	2.12408e-18
C105	a_27_74##5	a_27_74##2	2.98823e-17
C106	VGND#6	C#3	2.07227e-18
C107	A_N#1	VPWR#9	3.241e-17
C108	a_226_424##7	a_526_139#	5.67706e-18
C109	a_27_74##7	A_N#1	5.53222e-17
C110	VPWR#3	VPWR#7	6.84106e-17
C111	a_226_424##2	X#1	2.67123e-17
C112	A_N#2	a_27_74##5	6.66582e-17
C113	a_226_424##2	VPWR#6	1.96519e-17
C114	a_226_424##7	a_448_139#	1.50478e-18
C115	X#1	D#2	2.22207e-18
C116	VGND#7	C#3	1.39715e-18
C117	D#3	a_226_424##3	1.94012e-17
C118	a_27_74##6	C#3	1.41857e-19
C119	a_226_424##8	B#2	2.95766e-17
C120	C#1	D#3	3.02415e-17
C121	a_226_424##8	a_27_74##2	1.13931e-17
C122	a_226_424##2	a_226_424#	3.62502e-18
C123	a_27_74##6	a_27_74##2	5.35233e-18
C124	a_226_424##8	A_N#2	2.30859e-18
C125	a_226_424##2	D#1	3.60556e-17
C126	B#3	C#1	3.20361e-18
C127	VGND#3	B#1	9.18129e-19
C128	B#2	VPWR#7	6.83456e-18
C129	a_226_424##2	C#2	1.61095e-19
C130	a_27_74##6	A_N#2	2.73247e-17
C131	VGND#3	a_27_74#	5.728e-18
C132	B#2	a_226_424##6	2.42321e-17
C133	C#3	a_226_424#	1.11665e-18
C134	C#2	D#2	2.20317e-17
C135	a_27_74##3	B#3	2.91095e-17
C136	C#3	D#1	9.0478e-18
C137	a_226_424##6	a_27_74##2	2.40187e-18
C138	C#3	C#2	7.0858e-19
C139	A_N#1	a_27_74##3	2.54449e-17
C140	B#1	C#3	8.09833e-18
C141	B#2	C#2	1.47015e-17
C142	a_226_424##7	D	3.02836e-17
C143	a_27_74#	C#3	2.31649e-18
C144	a_226_424##5	D	2.49071e-17
C145	A_N#2	a_27_74##7	2.58877e-17
C146	A_N#3	C#3	2.48563e-19
C147	D#2	a_226_424##3	8.19994e-18
C148	a_27_74#	B#2	1.09775e-17
C149	a_27_74##2	B#1	1.56586e-18
C150	a_226_424##8	a_353_124#	3.61298e-18
C151	a_226_424##7	B	2.51322e-17
C152	a_27_74##2	a_27_74#	1.75886e-17
C153	C#1	D#2	1.05662e-17
C154	B	a_226_424##5	3.36661e-17
C155	A_N#3	a_27_74##2	5.0317e-18
C156	D#1	a_526_139#	1.95344e-17
C157	B#2	C#1	8.71837e-18
C158	C#2	a_526_139#	1.76808e-17
C159	a_27_74##5	B	2.0551e-17
C160	a_27_74##3	B#2	3.309e-19
C161	C#2	a_448_139#	1.24886e-17
C162	B#1	a_448_139#	1.24886e-17
C163	C	a_226_424##7	2.18875e-17
C164	A_N#1	a_27_74##2	2.87427e-18
C165	D#2	a_226_424##2	2.41112e-17
C166	VGND#3	C#3	6.58339e-18
C167	a_226_424##7	a_226_424##5	1.05813e-17
C168	B#1	a_353_124#	1.40677e-17
C169	D	X#1	6.51797e-18
C170	a_27_74#	a_353_124#	1.57045e-17
C171	VGND#3	B#2	5.0892e-19
C172	a_226_424##8	B	3.31839e-17
C173	VGND#3	a_27_74##2	2.336e-20
C174	B	VPWR#7	4.37842e-18
C175	B	a_226_424##6	2.07672e-17
C176	a_27_74##6	A_N	2.00483e-17
C177	C	VGND#6	1.1946e-17
C178	D	C#2	2.43017e-18
C179	a_27_74##2	B#2	2.56655e-17
C180	a_226_424##8	C	6.52016e-18
C181	VPWR	a_226_424##5	2.07153e-17
C182	VGND#7	C	5.60785e-18
C183	B	C#2	3.66736e-18
C184	A_N	a_27_74##7	2.03168e-17
C185	D	a_226_424##3	2.15262e-18
C186	B	a_27_74#	4.08646e-18
C187	A_N#2	a_27_74##2	2.98687e-17
C188	VPWR	a_27_74##5	6.18297e-18
C189	D	C#1	1.14231e-18
C190	VGND	a_226_424##7	1.08045e-17
C191	X	X#1	1.53952e-18
C192	C	a_226_424#	2.69121e-18
C193	VPWR#6	X	2.4015e-17
C194	B	C#1	2.21616e-18
C195	C	D#1	3.58932e-18
C196	C	C#2	5.54847e-18
C197	C	B#1	1.43307e-17
C198	C	a_27_74#	8.23926e-18
C199	B	A_N#1	2.80065e-19
C200	VGND	a_27_74##5	4.12964e-18
C201	C	A_N#3	1.68193e-18
C202	VPWR	VPWR#6	1.93972e-17
C203	a_226_424##2	D	3.02058e-17
C204	VGND	X#3	1.69699e-17
C205	VPWR	VPWR#7	9.69517e-17
C206	D	D#2	1.85824e-17
C207	VPWR	a_226_424##6	1.16878e-17
C208	a_226_424##7	VNB	5.46453e-18
C209	a_226_424##5	VNB	5.35934e-18
C210	VPWR	VPWR#9	2.23738e-17
C211	VPWR	a_27_74##7	1.71929e-17
C212	VGND	a_226_424##8	1.73212e-17
C213	VGND	VGND#7	1.53414e-17
C214	X	a_226_424##3	1.27598e-17
C215	VGND	a_27_74##6	1.98932e-17
C216	VGND	X#1	8.47654e-19
C217	a_27_74##5	VNB	1.69841e-17
C218	B	B#2	2.20187e-17
C219	B	a_27_74##2	4.89264e-18
C220	VGND#3	C	6.29756e-17
C221	X#3	VNB	4.79025e-17
C222	VGND#6	VNB	3.46331e-18
C223	VPWR	a_226_424##3	2.8573e-18
C224	VGND	a_226_424#	7.56852e-18
C225	VPWR	D#3	2.22802e-18
C226	VGND	D#1	7.20388e-18
C227	VPWR	C#1	4.21119e-19
C228	a_226_424##8	VNB	4.67065e-18
C229	VGND	C#2	5.28417e-19
C230	VGND#7	VNB	8.25783e-18
C231	VPWR	B#3	5.95127e-19
C232	C	C#3	2.14427e-17
C233	a_27_74##6	VNB	4.08617e-17
C234	VGND	a_27_74#	2.161e-17
C235	A_N	A_N#2	1.85056e-17
C236	X#1	VNB	4.7711e-17
C237	VPWR	a_27_74##3	1.63259e-18
C238	VPWR#6	VNB	8.63767e-18
C239	VGND	A_N#3	7.55025e-19
C240	VPWR	A_N#1	1.10673e-18
C241	VPWR#7	VNB	5.53471e-17
C242	VPWR#9	VNB	4.06274e-18
C243	a_27_74##7	VNB	4.72095e-17
C244	a_226_424#	VNB	3.68006e-17
C245	D#1	VNB	3.45782e-17
C246	VPWR	a_226_424##2	3.8783e-18
C247	C#2	VNB	3.2776e-17
C248	B#1	VNB	3.24477e-17
C249	VPWR	D#2	6.79551e-19
C250	a_27_74#	VNB	9.58561e-17
C251	A_N#3	VNB	3.90431e-17
C252	VPWR	B#2	1.2838e-18
C253	a_226_424##3	VNB	4.208e-17
C254	VGND	VGND#3	2.90036e-17
C255	D#3	VNB	3.79046e-17
C256	VGND	a_226_424##2	6.37027e-18
C257	C#1	VNB	3.47202e-17
C258	VPWR	A_N#2	1.72854e-18
C259	B#3	VNB	2.37946e-17
C260	a_27_74##3	VNB	3.19466e-17
C261	VGND	C#3	5.94768e-18
C262	A_N#1	VNB	4.78938e-17
C263	VGND	B#2	1.30274e-18
C264	VPWR#3	VNB	1.84638e-16
C265	VGND	a_27_74##2	8.20088e-19
C266	VGND#3	VNB	2.28474e-16
C267	VGND	A_N#2	2.15443e-18
C268	a_226_424##2	VNB	3.83332e-17
C269	D#2	VNB	3.69073e-17
C270	C#3	VNB	4.10598e-17
C271	B#2	VNB	5.52767e-17
C272	a_27_74##2	VNB	6.94924e-17
C273	A_N#2	VNB	6.57679e-17
C274	VPWR	D	4.87595e-18
C275	VPWR	B	3.25602e-18
C276	VGND	D	1.99061e-18
C277	VPWR	A_N	1.86741e-18
C278	VGND	B	3.20278e-18
C279	VGND	A_N	2.08723e-18
C280	D	VNB	2.55605e-18
C281	VPWR	X	2.01318e-17
C282	VGND	C	2.92944e-17
C283	A_N	VNB	3.02566e-17
C284	C	VNB	1.87885e-17
C285	X	VNB	1.84129e-17
C286	VPWR	VNB	6.0228e-17
C287	VGND	VNB	6.54359e-17
C288	VGND#2	X#3	1.41902e-17
C289	VPWR#4	A_N#2	5.27017e-20
C290	VPWR#7	VPWR#2	8.77975e-19
C291	VGND#4	a_226_424##8	3.28725e-18
C292	VPWR#2	a_226_424##3	7.81869e-18
C293	VGND#4	A_N#3	9.45734e-19
C294	VGND#3	VGND#4	6.31842e-17
C295	VGND#2	VNB	6.77117e-17
C296	VGND#4	a_27_74##2	4.36665e-20
C297	VGND#4	VNB	5.55228e-17
C298	VGND#4	a_27_74##6	1.9788e-17
C299	VPWR	VPWR#2	3.99145e-17
C300	VPWR#4	A_N#1	5.64947e-18
C301	VGND#2	a_226_424##2	1.12575e-18
C302	VPWR#3	VPWR#4	5.55784e-17
C303	a_226_424##5	VPWR#2	6.7035e-18
C304	VGND#2	a_226_424#	7.53699e-18
C305	a_226_424##6	VPWR#4	2.03316e-18
C306	VPWR#2	VNB	5.04853e-17
C307	VPWR	VPWR#4	3.79302e-17
C308	a_27_74##5	VPWR#4	3.5763e-19
C309	a_27_74##7	VPWR#4	2.11637e-17
C310	VPWR#4	VNB	5.02566e-17
C311	VGND#4	a_27_74#	9.2299e-18
C312	VPWR#4	a_27_74##2	1.14548e-19
C313	VGND	VGND#2	6.72369e-17
C314	VPWR#2	D#2	4.85871e-20
C315	D	VPWR#2	1.21391e-18
C316	VGND#2	C#3	3.49828e-18
C317	VGND	VGND#4	3.99384e-17
C318	VPWR#2	D#3	7.67227e-18
C319	C	VGND#2	5.85593e-18
C320	VGND#2	a_226_424##7	2.60054e-18
C321	VGND#3	VGND#2	6.45564e-17
C322	X	VPWR#2	2.21118e-17
C323	VGND#4	A_N#2	1.77625e-19
C324	VPWR#4	a_27_74##3	5.46459e-18
C325	VPWR#4	VPWR#7	7.98463e-19
C326	VPWR#3	VPWR#2	5.79458e-17
C327	VGND#2	D#2	2.16897e-19
C328	a_226_424##2	VPWR#2	4.77269e-19
C329	VGND#2	D#1	3.8203e-18
C330	VGND#4	a_27_74##5	1.09529e-18
*
*
.ENDS sky130_fd_sc_hs__and4b_1
*
