* Extracted by Quantus, converted by sky130cad/quantus.py
*
*
*
*                       LINUX           Wed Nov 18 09:03:58 2026
*
*
*
*  PROGRAM  advgen
*
*  Name           : advgen - Quantus - (64-bit)
*  Version        : 25.1.0-p047
*  Build Date     : Thu Dec 11 23:20:30 PST 2025
*
*  HSPICE LIBRARY
*
*  OPERATING_TEMPERATURE 150
*  QRC_TECH_DIR <path>/tech
*
*
*

*
.SUBCKT sky130_fd_sc_hs__o41a_2 VNB VPB VGND VPWR X A1 A2 A3 A4 B1
*
*
*  caps2d version: 10
*
*
*       TRANSISTOR CARDS
*
*
XM12 a_27_74##3 A1#3 VGND#9 VNB sky130_fd_pr__nfet_01v8_lvt l=0.15 w=0.74 ad=0.2109 as=0.3108 pd=2.05 ps=2.32
XM6 VGND#9 A2#1 a_27_74##4 VNB sky130_fd_pr__nfet_01v8_lvt l=0.15 w=0.74 ad=0.3108 as=0.2072 pd=2.32 ps=2.04
XM8 a_27_74##4 A3#3 VGND#8 VNB sky130_fd_pr__nfet_01v8_lvt l=0.15 w=0.74 ad=0.2072 as=0.4329 pd=2.04 ps=2.65
XM5 VGND#8 A4#1 a_27_74# VNB sky130_fd_pr__nfet_01v8_lvt l=0.15 w=0.74 ad=0.4329 as=0.2183 pd=2.65 ps=2.07
XM2 a_27_74# B1#1 a_428_368##8 VNB sky130_fd_pr__nfet_01v8_lvt l=0.15 w=0.74 ad=0.2183 as=0.2627 pd=2.07 ps=2.19
XM4 X#2 a_428_368##6 VGND#7 VNB sky130_fd_pr__nfet_01v8_lvt l=0.15 w=0.74 ad=0.2072 as=0.2627 pd=2.04 ps=2.19
XM13 VGND#1 a_428_368##5 X#2 VNB sky130_fd_pr__nfet_01v8_lvt l=0.15 w=0.74 ad=0.2627 as=0.2072 pd=2.19 ps=2.04
XM0 VPWR#4 A1#1 a_116_368# VPB sky130_fd_pr__pfet_01v8 l=0.15 w=1.12 ad=0.3304 as=0.3024 pd=2.83 ps=2.78
XM9 a_116_368# A2#3 a_200_368# VPB sky130_fd_pr__pfet_01v8 l=0.15 w=1.12 ad=0.3024 as=0.4704 pd=2.78 ps=3.08
XM10 a_200_368# A3#1 a_314_368# VPB sky130_fd_pr__pfet_01v8 l=0.15 w=1.12 ad=0.4704 as=0.4704 pd=3.08 ps=3.08
XM1 a_314_368# A4#3 a_428_368##10 VPB sky130_fd_pr__pfet_01v8 l=0.15 w=1.12 ad=0.4704 as=0.4554 pd=3.08 ps=3.08
XM3 a_428_368##10 B1#3 VPWR#5 VPB sky130_fd_pr__pfet_01v8 l=0.15 w=1 ad=0.4554 as=1.0918 pd=3.08 ps=4.36
XM11 VPWR#5 a_428_368##7 X#1 VPB sky130_fd_pr__pfet_01v8 l=0.15 w=1.12 ad=1.0918 as=0.336 pd=4.36 ps=2.84
XM7 X#1 a_428_368# VPWR#1 VPB sky130_fd_pr__pfet_01v8 l=0.15 w=1.12 ad=0.336 as=0.3304 pd=2.84 ps=2.83
*
*
*       RESISTOR AND CAP/DIODE CARDS
*
Rg1	A1#1	A1#2	434.639221
Rg2	A1#2	A1#3	382.539734
Rg3	A2#1	A2#2	382.539734
Rg4	A2#2	A2#3	434.639221
Rg5	A3#1	A3#2	434.639221
Rg6	A3#2	A3#3	382.539734
Rg7	A4#1	A4#2	382.539734
Rg8	A4#2	A4#3	434.639221
Rg9	B1#1	B1#2	382.539734
Rg10	B1#2	B1#3	400.207520
Rg11	a_428_368#	a_428_368##2	537.780457
Rg12	a_428_368##2	a_428_368##3	66.369736
Rg13	a_428_368##3	a_428_368##4	209.786652
Rg14	a_428_368##2	a_428_368##5	447.089325
Rg15	a_428_368##3	a_428_368##6	367.764618
Rg16	a_428_368##3	a_428_368##7	471.250305
Rf1	A1#4	A1	2.103764
Rf2	A1#2	A1#6	162.336563
Rf3	A1#4	A1#6	5.806452
Rf4	A2	A2#2	186.761703
Rf5	A3	A3#2	165.267365
Rf6	A4	A4#2	166.137894
Rf7	a_27_74#	a_27_74##2	100.668480
Rf8	a_27_74##2	a_27_74##3	87.959900
Rf9	a_27_74##2	a_27_74##4	18.149860
Rf10	B1#4	B1	1.409262
Rf11	B1#2	B1#6	161.642059
Rf12	B1#4	B1#6	2.139219
Rf13	B1#7	B1	1.409262
Rf14	B1#6	B1#7	12.529713
Rf15	a_428_368##8	a_428_368##4	69.917572
Rf16	a_428_368##4	a_428_368##10	124.348511
Rf17	X#1	X	72.250107
Rf18	X	X#2	32.635002
Rf19	VPWR#1	VPWR#2	128.938553
Rf20	VPWR#2	VPWR#3	61.801472
Rf21	VPWR#3	VPWR#4	188.494446
Rf22	VPWR#2	VPWR#5	11.183528
Rf23	VGND#1	VGND#2	105.222557
Rf24	VGND#2	VGND#3	81.792023
Rf25	VGND#3	VGND#4	38.655746
Rf26	VGND#4	VGND#5	79.539490
Rf28	VGND#2	VGND#7	37.460041
Rf29	VGND#4	VGND#8	28.751598
Rf30	VGND#5	VGND#9	35.098007
Re1	VPWR#3	VPWR	0.982218
Re2	VGND	VGND#3	0.982254
*
*       CAPACITOR CARDS
*
*
C1	VGND#2	a_428_368##8	1.15671e-17
C2	VGND#4	a_27_74#	1.79032e-19
C3	VGND#8	VGND#2	3.40998e-19
C4	VGND#4	a_27_74##4	8.44746e-18
C5	VGND#3	a_428_368##2	1.37731e-21
C6	a_428_368##8	B1#6	1.8316e-17
C7	a_428_368##4	a_428_368##2	3.77387e-18
C8	a_428_368##2	X#1	1.16554e-18
C9	VPWR#2	VPWR#1	2.43207e-18
C10	a_27_74##2	VGND#8	2.70742e-17
C11	VGND#2	a_428_368##2	1.70953e-20
C12	VPWR#2	X#1	8.24615e-17
C13	a_27_74##2	a_27_74##4	9.59055e-20
C14	VPWR#2	VPWR#5	1.96728e-17
C15	a_27_74##2	VGND#9	2.05183e-17
C16	VGND#1	X#2	5.82245e-17
C17	a_428_368##10	VPWR#2	7.49077e-17
C18	VGND#7	VGND#1	6.71828e-19
C19	VGND#7	X#2	4.1754e-17
C20	a_428_368##8	X#2	3.04471e-18
C21	VPWR#2	a_428_368##2	4.25241e-20
C22	B1#6	a_428_368##10	1.94759e-17
C23	a_428_368##8	VGND#7	3.51201e-17
C24	a_27_74##3	A1#6	2.91324e-17
C25	VGND#2	a_428_368##5	2.88996e-18
C26	a_27_74#	a_428_368##8	7.29226e-17
C27	VGND#8	VGND#7	3.98483e-19
C28	VGND#2	a_428_368##6	7.64873e-18
C29	a_27_74#	VGND#8	6.14718e-17
C30	VGND#2	B1#1	1.42868e-18
C31	VGND#1	VPWR#1	1.11239e-17
C32	VGND#4	A4#1	7.67666e-19
C33	a_27_74##4	a_27_74#	2.9022e-18
C34	VGND#2	A4#1	3.61609e-19
C35	a_27_74##4	VGND#8	4.40069e-17
C36	VGND#4	A3#3	2.72714e-18
C37	VGND#9	VGND#8	2.42151e-18
C38	VGND#2	A3#3	1.07799e-19
C39	VGND#9	a_27_74##4	4.526e-17
C40	a_27_74##3	a_27_74##4	3.05636e-18
C41	a_27_74##3	VGND#9	5.76818e-17
C42	A1#6	VPWR#4	1.21602e-17
C43	a_27_74#	a_428_368##10	6.74065e-18
C44	a_27_74##2	A3#3	2.3176e-17
C45	a_428_368##5	VGND#1	2.54889e-17
C46	X#1	VPWR#1	9.078e-17
C47	VPWR#2	a_428_368#	2.38168e-18
C48	a_27_74##2	A2#1	2.12127e-17
C49	X#2	a_428_368##5	3.6206e-17
C50	VGND#1	a_428_368##6	1.44921e-18
C51	VGND#7	a_428_368##5	2.51208e-19
C52	X#2	a_428_368##6	3.35706e-17
C53	VPWR#2	a_428_368##7	4.91109e-17
C54	VGND#1	B1#1	1.54529e-19
C55	a_428_368##6	VGND#7	1.74061e-17
C56	X#2	B1#1	3.58427e-19
C57	a_428_368##10	X#1	9.69554e-19
C58	VPWR#2	B1#3	2.99242e-17
C59	a_428_368##8	a_428_368##6	1.88472e-18
C60	VGND#7	B1#1	1.06114e-18
C61	a_428_368##10	VPWR#5	2.16329e-18
C62	B1#1	a_428_368##8	3.08142e-17
C63	VPWR#2	A4#3	3.90536e-18
C64	VGND#7	A4#1	9.25834e-20
C65	VGND#8	a_428_368##6	2.70265e-19
C66	a_27_74#	B1#1	4.91566e-17
C67	a_27_74##3	VPWR#4	3.27106e-19
C68	B1#6	B1#3	5.38937e-19
C69	VGND#7	A3#3	3.38044e-20
C70	VGND#8	B1#1	1.5238e-18
C71	VPWR#2	A3#1	6.03332e-19
C72	a_27_74#	A4#1	5.7106e-17
C73	A4#1	VGND#8	2.73127e-17
C74	a_27_74#	A3#3	7.63125e-19
C75	VPWR#2	A2#3	2.93089e-19
C76	a_27_74##4	A4#1	7.89741e-19
C77	A3#3	VGND#8	3.04145e-17
C78	VGND#9	A4#1	1.61149e-19
C79	VPWR#4	a_428_368##10	1.59329e-18
C80	a_27_74##4	A3#3	3.85195e-17
C81	VGND#8	A2#1	1.41771e-18
C82	VGND#9	A3#3	7.82642e-19
C83	a_27_74##4	A2#1	3.32919e-17
C84	VGND#8	A1#3	6.69321e-19
C85	A2#1	VGND#9	2.14359e-17
C86	a_27_74##4	A1#3	1.06133e-18
C87	a_27_74##3	A2#1	9.74128e-19
C88	A1#3	VGND#9	2.65165e-17
C89	VGND#3	VGND#4	3.86831e-17
C90	VPWR#3	VPWR#2	6.60214e-17
C91	VGND#3	VGND#2	5.07096e-17
C92	a_27_74##3	A1#3	5.00574e-17
C93	A1#6	A2#3	7.79764e-19
C94	VGND#2	a_428_368##4	5.75788e-19
C95	a_428_368##6	a_428_368##5	3.84298e-17
C96	a_428_368##4	VPWR#2	7.06902e-17
C97	A1#6	A1#1	3.79209e-18
C98	VPWR#1	a_428_368#	5.36265e-17
C99	VGND#3	B1#6	5.21685e-19
C100	a_428_368#	X#1	2.7003e-17
C101	VPWR#1	a_428_368##7	4.01918e-18
C102	VPWR#2	B1#2	8.21685e-19
C103	B1#1	a_428_368##6	3.78477e-18
C104	a_428_368##7	X#1	3.28341e-17
C105	a_428_368##10	a_428_368#	2.49906e-19
C106	a_428_368##7	VPWR#5	2.81434e-17
C107	X#1	B1#3	5.37751e-19
C108	A4#1	B1#1	3.55284e-17
C109	B1#6	B1#2	1.47061e-17
C110	a_428_368##10	a_428_368##7	3.59056e-19
C111	B1#3	VPWR#5	3.22206e-17
C112	X#1	A4#3	8.76179e-20
C113	a_428_368##10	B1#3	4.2915e-17
C114	A3#3	A4#1	1.18648e-17
C115	VGND#3	VGND#1	2.87791e-17
C116	a_428_368##10	A4#3	6.12444e-17
C117	a_428_368##10	A3#1	4.36943e-18
C118	A2#1	A3#3	3.90924e-17
C119	VGND#3	a_428_368##8	1.03739e-17
C120	a_428_368##4	X#2	3.43702e-18
C121	VGND#4	VGND#2	4.08189e-19
C122	a_27_74##2	A3#2	5.10486e-17
C123	VGND#3	a_27_74#	1.9572e-17
C124	a_428_368##4	VGND#7	2.81215e-17
C125	a_428_368##10	A2#3	3.55699e-19
C126	a_428_368##8	a_428_368##4	3.56974e-20
C127	VPWR#4	A4#3	4.15443e-19
C128	A1#3	A2#1	2.15941e-17
C129	a_428_368##10	A1#1	1.97264e-19
C130	a_27_74##2	A2#2	4.75247e-17
C131	VPWR#3	VPWR#1	2.76924e-17
C132	VPWR#4	A3#1	9.91551e-19
C133	a_428_368##8	B1#2	2.64873e-18
C134	VPWR#4	A2#3	1.51739e-17
C135	a_428_368##10	VPWR#3	2.03608e-17
C136	A1#6	A2#2	3.16229e-17
C137	a_27_74#	A4#2	4.47926e-17
C138	VPWR#4	A1#1	5.24701e-17
C139	VGND#8	A4#2	9.25167e-19
C140	a_428_368##4	X#1	3.49496e-17
C141	a_428_368##4	VPWR#5	9.39081e-18
C142	A1#6	A1#2	1.20725e-17
C143	VGND#8	A3#2	1.0011e-18
C144	X#1	B1#2	3.0963e-20
C145	a_428_368##7	a_428_368#	4.86012e-17
C146	VPWR#3	VPWR#4	5.37127e-17
C147	B1#2	VPWR#5	5.29945e-19
C148	VGND#1	a_428_368##2	1.72601e-18
C149	a_428_368##10	B1#2	1.90709e-18
C150	B1#3	a_428_368##7	3.2421e-18
C151	VGND#9	A2#2	7.47625e-19
C152	A4#2	a_428_368##10	3.78182e-18
C153	A4#3	a_428_368##7	1.51948e-19
C154	X	a_428_368##2	1.33839e-17
C155	a_428_368##4	a_428_368##5	1.05011e-19
C156	VGND#3	B1#1	7.58074e-18
C157	A4#3	B1#3	2.7354e-17
C158	a_428_368##4	a_428_368##6	3.8463e-18
C159	VGND#3	A4#1	1.68833e-18
C160	a_27_74##3	A1#2	3.334e-18
C161	B1#1	a_428_368##4	1.31416e-19
C162	A3#1	A4#3	2.9202e-17
C163	a_428_368##2	X#2	6.62058e-20
C164	A2#3	A3#1	2.93352e-17
C165	VPWR#4	A2#2	5.22791e-20
C166	VPWR#3	B1#3	2.39446e-18
C167	a_428_368##4	a_428_368#	9.48278e-19
C168	A1#2	VPWR#4	3.46568e-18
C169	A1#1	A2#3	5.59225e-17
C170	VPWR#3	A4#3	7.77731e-18
C171	a_428_368##4	a_428_368##7	8.79501e-18
C172	VPWR#3	A3#1	6.1373e-18
C173	a_428_368##4	B1#3	5.91844e-19
C174	VGND#4	a_27_74##2	2.25448e-19
C175	B1#2	a_428_368##7	1.15014e-19
C176	a_428_368##4	A4#3	9.32223e-20
C177	a_428_368##4	A3#1	5.60129e-20
C178	A3#2	a_428_368##7	3.50643e-20
C179	VGND	a_428_368##2	5.96061e-19
C180	A3#2	B1#3	1.47924e-19
C181	a_428_368##8	B1	3.0165e-17
C182	A3#2	A4#3	1.30237e-18
C183	a_27_74#	B1	2.4547e-17
C184	A3#2	A3#1	1.3485e-18
C185	A3#2	A2#3	4.51391e-19
C186	VGND#3	a_428_368##4	5.69921e-21
C187	A2#2	A3#1	9.76132e-19
C188	A2#2	A2#3	8.74509e-19
C189	VGND#3	B1#2	6.34752e-20
C190	VPWR#3	A4#2	6.67361e-20
C191	a_27_74##2	A2	3.72327e-18
C192	A2#2	A1#1	7.42969e-19
C193	B1	a_428_368##10	2.58897e-17
C194	B1#2	a_428_368##4	8.41573e-18
C195	A3#2	VPWR#3	5.97473e-19
C196	a_428_368##4	A4#2	1.40197e-19
C197	A4#3	a_314_368#	2.18215e-18
C198	A3#1	a_314_368#	2.82367e-17
C199	A4#2	B1#2	3.19212e-17
C200	A4	a_428_368##10	2.60082e-17
C201	A3#2	a_428_368##4	7.20115e-19
C202	A3#1	a_200_368#	2.09248e-18
C203	A2#3	a_200_368#	2.82494e-17
C204	A3#2	A4#2	4.57327e-17
C205	A3	a_428_368##10	4.77382e-17
C206	A2#3	a_116_368#	2.24035e-17
C207	A2#2	A3#2	6.16553e-17
C208	A1#1	a_116_368#	1.82871e-18
C209	VPWR	VPWR#2	1.05858e-16
C210	B1	a_428_368##7	2.04404e-19
C211	a_27_74##3	A1	1.95246e-17
C212	A1#2	A2#2	2.89244e-17
C213	B1	B1#3	1.54858e-18
C214	VPWR#4	A2	5.66437e-17
C215	VPWR	B1#6	1.25933e-18
C216	B1	A4#3	4.58639e-19
C217	A3#2	a_314_368#	5.2267e-19
C218	a_428_368##2	VNB	3.99034e-17
C219	A4	B1#3	7.90055e-19
C220	VPWR	A1#6	3.03469e-18
C221	A4	A4#3	4.6757e-18
C222	VGND	VGND#4	2.33218e-17
C223	A1	VPWR#4	2.13841e-17
C224	VGND	VGND#2	5.06003e-17
C225	A4	A3#1	1.58775e-19
C226	A3	a_428_368##7	4.07165e-20
C227	A2#2	a_200_368#	4.65238e-19
C228	A3	B1#3	1.83426e-19
C229	A3	A4#3	1.31631e-17
C230	VGND	B1#6	2.32269e-18
C231	VGND#3	B1	2.02055e-19
C232	A3	A3#1	2.76679e-17
C233	VGND	a_27_74##2	4.19817e-18
C234	B1	a_428_368##4	7.28732e-17
C235	A3	A2#3	1.34133e-18
C236	A4	VPWR#3	6.3307e-19
C237	X	a_428_368##5	5.27057e-18
C238	VPWR	VPWR#1	3.90002e-17
C239	B1	B1#2	7.14962e-18
C240	VGND	A1#6	1.97751e-18
C241	VPWR	X#1	1.56803e-17
C242	X	a_428_368##6	6.95918e-18
C243	X	B1#1	2.18772e-19
C244	VGND	VGND#1	3.20854e-17
C245	A2	A3#1	1.85697e-17
C246	A4#2	B1	1.91955e-17
C247	VPWR	a_428_368##10	1.90335e-17
C248	VGND	X#2	1.58524e-17
C249	A3	VPWR#3	1.12489e-17
C250	A2	A2#3	3.73152e-17
C251	VGND	a_428_368##8	1.65938e-17
C252	A4	B1#2	1.22544e-18
C253	VGND	a_27_74#	1.76496e-17
C254	A2	A1#1	1.38947e-17
C255	VGND	VGND#8	3.19934e-17
C256	VPWR	VPWR#4	5.92863e-17
C257	A4	A4#2	7.51426e-18
C258	VGND	a_27_74##4	1.61923e-17
C259	A3	a_428_368##4	3.06115e-19
C260	VGND	a_27_74##3	1.70791e-17
C261	A2	VPWR#3	5.57001e-18
C262	A3#2	A4	2.70268e-17
C263	VGND	VPWR#1	5.05403e-18
C264	VPWR	a_428_368#	4.25033e-18
C265	VGND	a_428_368##5	4.49327e-18
C266	VGND	a_428_368##6	4.86538e-18
C267	VPWR	a_428_368##7	5.16508e-18
C268	A2	A3#2	1.28397e-18
C269	VGND	B1#1	1.52275e-18
C270	VPWR	B1#3	3.87163e-18
C271	VGND	A4#1	1.45915e-19
C272	VPWR	A4#3	2.87386e-18
C273	VGND#4	VNB	2.98172e-17
C274	VGND	A3#3	7.70158e-20
C275	VGND#2	VNB	4.33346e-17
C276	VPWR	A3#1	4.0983e-18
C277	VGND	A2#1	1.5907e-19
C278	A3	a_314_368#	7.73196e-18
C279	VPWR#2	VNB	5.99193e-17
C280	VGND	A1#3	1.14572e-18
C281	VPWR	A2#3	2.86406e-19
C282	X	a_428_368##4	5.51865e-17
C283	VPWR	A1#1	1.02433e-18
C284	VGND#2	VGND#1	2.0314e-18
C285	B1#6	VNB	2.6543e-18
C286	X	B1#2	3.35544e-21
C287	a_27_74##2	VNB	1.45441e-17
C288	A1	A1#2	1.09633e-17
C289	VPWR	VPWR#3	3.38631e-17
C290	A1#6	VNB	7.70864e-19
C291	A2	a_200_368#	8.74278e-18
C292	VGND#1	VNB	5.68771e-17
C293	VPWR	a_428_368##4	5.5862e-18
C294	X#2	VNB	2.82627e-18
C295	VGND#7	VNB	6.32887e-18
C296	A2	a_116_368#	3.3089e-18
C297	a_428_368##8	VNB	1.40253e-17
C298	A4	B1	1.69062e-17
C299	a_27_74#	VNB	8.11448e-18
C300	VGND#8	VNB	4.80315e-18
C301	a_27_74##4	VNB	1.96561e-18
C302	VGND#9	VNB	3.15884e-18
C303	a_27_74##3	VNB	4.7835e-17
C304	VPWR	A3#2	2.32657e-18
C305	VPWR#1	VNB	8.41452e-17
C306	X#1	VNB	9.75296e-18
C307	VGND	VGND#3	1.57401e-17
C308	a_428_368##10	VNB	3.00183e-18
C309	VGND	a_428_368##4	3.19099e-18
C310	VPWR#4	VNB	9.37864e-17
C311	VGND	A4#2	2.80172e-18
C312	a_428_368##5	VNB	3.56496e-17
C313	a_428_368##6	VNB	3.14973e-17
C314	VGND	A3#2	4.21857e-18
C315	B1#1	VNB	3.66783e-17
C316	A4#1	VNB	2.93956e-17
C317	VGND	A2#2	4.20614e-18
C318	A3#3	VNB	2.96101e-17
C319	A2#1	VNB	2.84991e-17
C320	A2	A3	6.01718e-17
C321	A1#3	VNB	3.67417e-17
C322	a_428_368#	VNB	3.89766e-17
C323	a_428_368##7	VNB	3.44857e-17
C324	B1#3	VNB	3.33436e-17
C325	VGND#2	X#2	1.55903e-17
C326	A4#3	VNB	3.76843e-17
C327	A3#1	VNB	3.22172e-17
C328	A2#3	VNB	3.21989e-17
C329	VPWR	B1	3.32457e-18
C330	A1#1	VNB	4.05872e-17
C331	VPWR#3	VNB	2.41179e-16
C332	VPWR	A4	4.74347e-18
C333	VGND#3	VNB	2.22453e-16
C334	a_428_368##4	VNB	3.75593e-17
C335	VPWR	A3	1.28693e-17
C336	B1#2	VNB	3.4651e-17
C337	VGND	B1	3.98919e-18
C338	A4#2	VNB	2.58428e-17
C339	A3#2	VNB	3.6403e-17
C340	VPWR	A2	2.04014e-17
C341	A2#2	VNB	3.6104e-17
C342	A1#2	VNB	4.63651e-17
C343	VPWR	A1	1.62104e-18
C344	VGND	A2	1.435e-18
C345	VGND	A1	1.6868e-18
C346	B1	VNB	6.19001e-18
C347	A4	VNB	1.5243e-18
C348	A2	VNB	1.20734e-19
C349	A1	VNB	2.30296e-17
C350	X	VNB	1.52643e-17
C351	VPWR	VNB	7.0997e-17
C352	VGND	VNB	7.27639e-17
C353	VGND#5	a_27_74##2	2.25448e-19
C354	VGND#5	a_27_74##4	8.48245e-18
C355	VGND	VGND#5	5.37024e-17
C356	VGND#5	A4#1	6.42636e-20
C357	VGND#3	VGND#5	5.53144e-17
C358	VGND#5	A3#3	6.28248e-19
C359	VGND#5	a_27_74##3	2.10084e-17
C360	VGND#5	VNB	4.91809e-17
C361	VGND#5	A2#1	4.87993e-18
C362	VGND#5	VGND#8	3.14289e-19
C363	VGND#5	A1#2	7.669e-20
C364	VGND#5	VGND#4	1.05354e-18
C365	VGND#5	A1#3	5.26185e-18
*
*
.ENDS sky130_fd_sc_hs__o41a_2
*
