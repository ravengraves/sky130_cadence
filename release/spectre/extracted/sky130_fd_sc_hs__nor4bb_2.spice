* Extracted by Quantus, converted by sky130cad/quantus.py
*
*
*
*                       LINUX           Wed Nov 18 08:52:17 2026
*
*
*
*  PROGRAM  advgen
*
*  Name           : advgen - Quantus - (64-bit)
*  Version        : 25.1.0-p047
*  Build Date     : Thu Dec 11 23:20:30 PST 2025
*
*  HSPICE LIBRARY
*
*  OPERATING_TEMPERATURE 150
*  QRC_TECH_DIR <path>/tech
*
*
*

*
.SUBCKT sky130_fd_sc_hs__nor4bb_2 VNB VPB VGND VPWR Y B A C_N D_N
*
*
*  caps2d version: 10
*
*
*       TRANSISTOR CARDS
*
*
XM3 a_27_392##9 C_N#1 VGND#13 VNB sky130_fd_pr__nfet_01v8_lvt l=0.15 w=0.64 ad=0.1824 as=0.36145 pd=1.85 ps=2.84
XM0 VGND#13 D_N#3 a_311_124##10 VNB sky130_fd_pr__nfet_01v8_lvt l=0.15 w=0.64 ad=0.36145 as=0.2496 pd=2.84 ps=2.06
XM13 Y#6 a_311_124##6 VGND#12 VNB sky130_fd_pr__nfet_01v8_lvt l=0.15 w=0.74 ad=0.2072 as=0.4735 pd=2.04 ps=2.86
XM16 VGND#11 a_311_124##5 Y#6 VNB sky130_fd_pr__nfet_01v8_lvt l=0.15 w=0.74 ad=0.4192 as=0.2072 pd=2.81 ps=2.04
XM1 VGND#11 a_27_392##6 Y#4 VNB sky130_fd_pr__nfet_01v8_lvt l=0.15 w=0.74 ad=0.4192 as=0.2072 pd=2.81 ps=2.04
XM6 Y#4 a_27_392# VGND#7 VNB sky130_fd_pr__nfet_01v8_lvt l=0.15 w=0.74 ad=0.2072 as=0.259 pd=2.04 ps=2.18
XM2 VGND#7 B#6 Y#7 VNB sky130_fd_pr__nfet_01v8_lvt l=0.15 w=0.74 ad=0.259 as=0.2072 pd=2.18 ps=2.04
XM8 Y#7 B#4 VGND#6 VNB sky130_fd_pr__nfet_01v8_lvt l=0.15 w=0.74 ad=0.2072 as=0.6031 pd=2.04 ps=3.11
XM18 Y#1 A#4 VGND#6 VNB sky130_fd_pr__nfet_01v8_lvt l=0.15 w=0.74 ad=0.2405 as=0.6031 pd=2.13 ps=3.11
XM14 VGND#1 A#1 Y#1 VNB sky130_fd_pr__nfet_01v8_lvt l=0.15 w=0.74 ad=0.2109 as=0.2405 pd=2.05 ps=2.13
XM7 a_27_392##11 C_N#3 VPWR#7 VPB sky130_fd_pr__pfet_01v8 l=0.15 w=1 ad=0.295 as=1.17 pd=2.59 ps=4.34
XM4 VPWR#7 D_N#1 a_311_124##11 VPB sky130_fd_pr__pfet_01v8 l=0.15 w=1 ad=1.17 as=0.295 pd=4.34 ps=2.59
XM9 Y#9 a_311_124##7 a_493_368##4 VPB sky130_fd_pr__pfet_01v8 l=0.15 w=1.12 ad=0.336 as=0.3304 pd=2.84 ps=2.83
XM17 a_493_368##2 a_311_124# Y#9 VPB sky130_fd_pr__pfet_01v8 l=0.15 w=1.12 ad=0.392 as=0.336 pd=2.94 ps=2.84
XM15 a_772_368##2 a_27_392##7 a_493_368##2 VPB sky130_fd_pr__pfet_01v8 l=0.15 w=1.12 ad=0.392 as=0.392 pd=2.94 ps=2.94
XM11 a_493_368# a_27_392##5 a_772_368##2 VPB sky130_fd_pr__pfet_01v8 l=0.15 w=1.12 ad=0.3304 as=0.392 pd=2.83 ps=2.94
XM10 a_985_368##3 B#7 a_772_368# VPB sky130_fd_pr__pfet_01v8 l=0.15 w=1.12 ad=0.3304 as=0.336 pd=2.83 ps=2.84
XM19 a_772_368# B#1 a_985_368##4 VPB sky130_fd_pr__pfet_01v8 l=0.15 w=1.12 ad=0.336 as=0.392 pd=2.84 ps=2.94
XM12 VPWR#6 A#6 a_985_368##4 VPB sky130_fd_pr__pfet_01v8 l=0.15 w=1.12 ad=0.336 as=0.392 pd=2.84 ps=2.94
XM5 a_985_368# A#5 VPWR#6 VPB sky130_fd_pr__pfet_01v8 l=0.15 w=1.12 ad=0.3304 as=0.336 pd=2.83 ps=2.84
*
*
*       RESISTOR AND CAP/DIODE CARDS
*
Rg1	C_N#1	C_N#2	502.207916
Rg2	C_N#2	C_N#3	458.917694
Rg3	D_N#1	D_N#2	417.171356
Rg4	D_N#2	D_N#3	369.122406
Rg5	a_311_124#	a_311_124##2	503.938385
Rg6	a_311_124##2	a_311_124##3	64.267426
Rg7	a_311_124##3	a_311_124##4	28.553638
Rg8	a_311_124##2	a_311_124##5	451.838898
Rg9	a_311_124##3	a_311_124##6	415.274414
Rg10	a_311_124##3	a_311_124##7	429.620972
Rg11	a_27_392#	a_27_392##2	399.152252
Rg12	a_27_392##2	a_27_392##3	66.417778
Rg13	a_27_392##3	a_27_392##4	23.782587
Rg14	a_27_392##2	a_27_392##5	450.102234
Rg15	a_27_392##3	a_27_392##6	384.761932
Rg16	a_27_392##4	a_27_392##7	436.388367
Rg17	B#1	B#2	467.578552
Rg18	B#2	B#3	63.334919
Rg19	B#3	B#4	394.805237
Rg20	B#3	B#5	48.569492
Rg21	B#5	B#6	417.000061
Rg22	B#3	B#7	448.030548
Rg23	A#1	A#2	388.639923
Rg24	A#2	A#3	61.128864
Rg25	A#3	A#4	397.555725
Rg26	A#2	A#5	446.830719
Rg27	A#3	A#6	449.655212
Rf1	C_N	C_N#4	13.384872
Rf2	C_N#4	C_N	5.511418
Rf3	D_N#2	D_N	161.413818
Rf4	a_311_124##4	a_311_124##9	66.618652
Rf5	a_311_124##9	a_311_124##10	57.487732
Rf6	a_311_124##9	a_311_124##11	58.696819
Rf7	a_27_392##4	a_27_392##10	408.065979
Rf8	a_27_392##10	a_27_392##11	124.892509
Rf9	a_27_392##9	a_27_392##10	7.500000
Rf10	a_493_368#	a_493_368##3	82.270859
Rf11	a_493_368##3	a_493_368##4	102.234436
Rf12	a_493_368##2	a_493_368##3	7.500000
Rf13	a_772_368#	a_772_368##2	145.795807
Rf14	B	B#8	3.667233
Rf15	B#8	B	11.001698
Rf16	B#8	B#5	188.685318
Rf17	Y#1	Y#2	119.404739
Rf18	Y#2	Y#3	62.120838
Rf19	Y#3	Y#5	14.780771
Rf20	Y#5	Y#6	77.737762
Rf21	Y#2	Y#7	21.341251
Rf22	Y#3	Y#8	42.313217
Rf23	Y#8	Y#9	115.807526
Rf24	Y#8	Y	15.238690
Rf25	Y#4	Y#5	7.500000
Rf26	A#7	A	1.310145
Rf27	A#2	A#9	81.426544
Rf28	A#7	A#9	5.042445
Rf29	A#10	A	1.310145
Rf30	A#9	A#10	9.626486
Rf31	a_985_368#	a_985_368##2	79.092201
Rf32	a_985_368##2	a_985_368##3	86.854294
Rf33	a_985_368##2	a_985_368##4	17.027714
Rf34	VGND#1	VGND#2	36.772179
Rf35	VGND#2	VGND#3	88.551895
Rf36	VGND#3	VGND#4	84.107811
Rf37	VGND#4	VGND#5	95.050690
Rf38	VGND#3	VGND#6	17.749863
Rf39	VGND#4	VGND#7	38.247387
Rf40	VGND#5	VGND#8	66.233353
Rf41	VGND#8	VGND#9	87.543053
Rf43	VGND#5	VGND#11	26.808384
Rf44	VGND#8	VGND#12	22.459743
Rf45	VGND#9	VGND#13	24.212385
Rf46	VPWR#1	VPWR#2	35.892784
Rf47	VPWR#2	VPWR#3	227.285080
Rf48	VPWR#3	VPWR#4	160.996597
Rf50	VPWR#2	VPWR#6	53.143215
Rf51	VPWR#4	VPWR#7	11.089654
Rf52	C_N#2	C_N#4	80.116402
Rf56	B#2	B#8	160.232803
Re1	VPWR#1	VPWR	11.068454
Re2	VPWR	VPWR#3	0.790604
Re3	VGND#2	VGND	11.068454
Re4	VGND	VGND#5	0.790604
*
*       CAPACITOR CARDS
*
*
C1	a_27_392##9	a_311_124##10	5.11557e-17
C2	VGND#4	a_311_124##5	1.68762e-19
C3	a_311_124##9	a_311_124##11	2.56595e-18
C4	VGND#8	a_311_124##6	1.53392e-17
C5	Y#2	A#4	9.84602e-20
C6	a_27_392##9	VGND#13	3.59236e-18
C7	Y#3	B#4	4.90476e-20
C8	VGND#4	Y#3	2.25448e-19
C9	B#2	A#3	1.70524e-17
C10	Y#2	B#4	2.57487e-17
C11	VGND#8	D_N#3	4.15104e-18
C12	Y#3	B#6	1.47452e-19
C13	VGND#4	Y#2	2.91756e-19
C14	Y#2	B#6	2.06338e-17
C15	Y#3	a_27_392#	1.94953e-17
C16	VGND#3	Y#2	4.09782e-17
C17	a_985_368#	VPWR#6	5.52027e-17
C18	B#5	A#3	9.45174e-19
C19	Y#2	a_27_392#	1.46695e-19
C20	VPWR#2	A#5	4.88949e-18
C21	Y#3	a_27_392##6	7.22518e-18
C22	a_985_368##4	a_985_368#	2.96061e-18
C23	a_27_392##2	B#5	2.35911e-17
C24	VPWR#2	A#6	5.07406e-18
C25	a_985_368##4	VPWR#6	5.20507e-17
C26	Y#3	a_311_124##5	4.24989e-19
C27	VGND#1	A#1	3.76963e-17
C28	a_772_368#	VPWR#6	2.66821e-18
C29	a_985_368##3	a_985_368#	1.87679e-21
C30	A#1	Y#1	2.23798e-17
C31	Y#3	a_311_124##6	2.91248e-20
C32	VPWR#2	B#1	4.69591e-18
C33	VGND#1	A#4	3.22759e-18
C34	a_27_392##4	a_27_392##2	3.48441e-18
C35	a_772_368#	a_985_368##4	6.30352e-17
C36	Y#6	a_311_124##2	3.40022e-19
C37	Y#1	A#4	4.1546e-17
C38	a_311_124##2	a_27_392##4	3.66261e-17
C39	a_985_368##2	A#5	9.23947e-21
C40	a_985_368##3	a_985_368##4	2.32892e-18
C41	Y#7	A#1	1.80605e-19
C42	VGND#1	B#4	1.23538e-19
C43	VPWR#2	B#7	4.65442e-18
C44	A#4	VGND#6	1.3145e-17
C45	Y#1	B#4	3.84069e-19
C46	a_772_368#	a_985_368##3	7.84931e-17
C47	Y#7	A#4	3.24709e-19
C48	a_985_368##2	A#6	2.28414e-17
C49	B#4	VGND#6	1.72511e-17
C50	VPWR#2	a_27_392##5	8.21431e-20
C51	VGND#7	A#4	3.78389e-20
C52	Y#7	B#4	3.63966e-17
C53	a_311_124##4	a_311_124##2	1.49459e-17
C54	a_985_368##2	B#1	1.39846e-17
C55	a_493_368#	a_985_368##3	4.45881e-17
C56	a_772_368##2	a_772_368#	1.36006e-18
C57	Y#3	Y#8	4.90882e-18
C58	VGND#7	B#4	1.38388e-18
C59	a_311_124##9	a_311_124##6	4.70882e-19
C60	B#6	Y#7	1.13452e-17
C61	Y#4	B#4	2.575e-19
C62	a_985_368##2	B#7	7.65638e-21
C63	VGND#7	B#6	3.71216e-17
C64	a_311_124##9	D_N#3	1.7913e-19
C65	Y#7	a_27_392#	5.05284e-19
C66	a_493_368#	a_772_368##2	7.65442e-17
C67	Y#4	B#6	1.53687e-18
C68	a_27_392#	VGND#7	1.61771e-17
C69	a_27_392##9	a_27_392##11	2.76934e-18
C70	a_493_368##2	a_493_368#	2.81393e-18
C71	Y#9	a_985_368##3	1.05294e-18
C72	a_985_368##2	a_27_392##5	6.75209e-22
C73	Y#4	a_27_392#	3.74549e-17
C74	Y#8	a_27_392##2	1.8177e-17
C75	VGND#7	a_27_392##6	2.38274e-19
C76	a_493_368##2	a_772_368##2	6.24809e-17
C77	Y#8	B#7	1.05392e-18
C78	Y#3	Y#2	3.91105e-19
C79	Y#4	a_27_392##6	4.93188e-17
C80	VGND#7	a_311_124##5	1.05468e-19
C81	Y#3	A#3	9.19982e-20
C82	a_27_392##6	VGND#11	1.49316e-17
C83	a_493_368##2	Y#9	7.98115e-17
C84	Y#4	a_311_124##5	8.31673e-19
C85	Y#8	a_27_392##5	1.16073e-17
C86	Y#6	a_27_392##6	7.48325e-19
C87	Y#8	a_311_124##2	7.52745e-20
C88	a_311_124##5	VGND#11	1.79278e-17
C89	a_493_368##4	a_493_368##2	2.73314e-18
C90	Y#4	a_311_124##6	8.19134e-20
C91	Y#6	a_311_124##5	4.41439e-17
C92	Y#8	a_27_392##7	1.54625e-17
C93	a_493_368##4	Y#9	8.51305e-17
C94	VGND#3	VGND#1	2.1426e-18
C95	Y#6	a_311_124##6	3.13478e-17
C96	Y#8	a_311_124#	5.40608e-19
C97	A#3	VPWR#6	2.33137e-19
C98	a_311_124##6	VGND#12	1.1716e-17
C99	VGND#3	Y#1	8.33719e-17
C100	a_311_124##11	a_493_368##4	7.05857e-17
C101	Y#3	a_27_392##2	5.52662e-18
C102	Y#6	D_N#3	9.26969e-19
C103	Y#6	C_N#1	3.28048e-19
C104	VPWR#1	VPWR#2	3.39083e-18
C105	VGND#3	VGND#6	1.89822e-17
C106	D_N#3	a_311_124##10	2.26583e-17
C107	a_311_124##9	a_27_392##5	1.3932e-19
C108	a_27_392##9	a_311_124##6	1.12906e-18
C109	VGND#4	Y#7	6.9777e-18
C110	D_N#3	VGND#13	1.6875e-17
C111	Y#1	a_985_368##2	3.49766e-18
C112	a_311_124##10	C_N#1	2.31199e-18
C113	a_27_392##9	D_N#3	4.03624e-17
C114	Y#3	a_311_124##2	6.52105e-20
C115	VGND#3	Y#7	5.3237e-17
C116	a_311_124##9	a_27_392##7	1.83837e-19
C117	C_N#1	VGND#13	1.28996e-17
C118	a_27_392##9	C_N#1	5.48957e-17
C119	a_311_124##9	a_311_124#	3.18865e-19
C120	VGND#7	VGND#3	1.61048e-18
C121	VGND#4	Y#4	8.7085e-18
C122	VGND#3	VGND#2	1.20191e-18
C123	a_311_124##9	a_311_124##7	1.29408e-19
C124	a_985_368#	A#5	5.66019e-17
C125	A#4	A#1	3.32536e-17
C126	a_311_124##9	D_N#1	5.58211e-18
C127	VGND#8	Y#6	2.45284e-17
C128	A#5	VPWR#6	2.70995e-17
C129	VGND#8	VGND#5	3.03256e-18
C130	a_985_368#	A#6	2.12167e-18
C131	VGND#5	VGND#4	1.43657e-18
C132	a_985_368##4	A#5	2.17823e-18
C133	a_311_124##9	C_N#3	6.51762e-19
C134	A#6	VPWR#6	2.8986e-17
C135	B#4	A#4	4.69489e-18
C136	a_772_368#	A#5	3.55352e-19
C137	VGND#8	VGND#12	1.14856e-17
C138	a_985_368##4	A#6	5.61094e-17
C139	a_985_368##3	A#5	1.99198e-19
C140	VPWR#6	B#1	6.06286e-19
C141	a_772_368#	A#6	1.78939e-18
C142	VPWR#2	B#2	2.26359e-20
C143	VGND#3	A#2	1.45086e-20
C144	B#6	B#4	4.00854e-17
C145	B#1	a_985_368##4	2.08503e-17
C146	a_985_368##3	A#6	4.57853e-19
C147	a_772_368#	B#1	5.36445e-17
C148	a_985_368##2	A#2	1.41329e-18
C149	a_985_368##4	B#7	7.65638e-19
C150	a_985_368##3	B#1	8.47748e-19
C151	VPWR#2	B#5	4.14866e-20
C152	a_27_392#	B#6	2.48734e-17
C153	VGND#3	B#2	2.15426e-18
C154	a_772_368#	B#7	6.08935e-17
C155	a_985_368##4	a_27_392##5	6.75209e-20
C156	a_985_368#	VPWR#2	4.45926e-19
C157	Y#2	Y#1	3.21371e-19
C158	a_985_368##3	B#7	3.75277e-17
C159	B#2	a_985_368##2	2.64986e-17
C160	a_772_368#	a_27_392##5	4.10362e-19
C161	VGND#4	B#5	5.21403e-20
C162	a_493_368#	B#7	1.04981e-18
C163	a_27_392##6	a_27_392#	3.9519e-17
C164	VGND#3	B#5	2.40898e-19
C165	a_985_368##3	a_27_392##5	4.12156e-18
C166	a_772_368##2	B#7	3.67576e-19
C167	VGND#8	a_27_392##9	2.015e-17
C168	Y#2	VGND#6	1.53052e-18
C169	a_772_368#	a_27_392##7	1.19064e-19
C170	a_493_368#	a_27_392##5	5.99419e-17
C171	VGND#2	VGND#1	2.15695e-17
C172	VGND#8	a_27_392##4	3.87414e-17
C173	a_985_368##3	a_27_392##7	1.9761e-19
C174	a_772_368##2	a_27_392##5	4.02821e-17
C175	VGND#2	Y#1	6.9283e-18
C176	a_311_124##5	a_27_392##6	1.77825e-17
C177	a_493_368#	a_27_392##2	1.60174e-19
C178	Y#9	B#7	1.32705e-19
C179	a_493_368#	a_27_392##7	8.77595e-19
C180	a_493_368##2	a_27_392##5	1.31837e-18
C181	Y#2	Y#7	5.35177e-19
C182	a_985_368##3	a_311_124#	1.2106e-19
C183	Y#3	VGND#7	1.81964e-17
C184	Y#2	B#2	3.25496e-17
C185	a_27_392##7	a_772_368##2	3.18586e-17
C186	a_985_368##4	VPWR#2	1.75281e-17
C187	Y#9	a_27_392##5	2.1236e-19
C188	Y#8	B#5	4.77527e-18
C189	VGND#8	a_311_124##4	2.23749e-18
C190	a_493_368##2	a_27_392##7	6.7552e-17
C191	a_311_124##6	a_311_124##5	3.90669e-17
C192	Y#3	B#5	2.21695e-18
C193	Y#9	a_27_392##7	1.26244e-18
C194	Y#2	VGND#7	1.49979e-17
C195	Y#3	Y#4	1.16479e-19
C196	Y#2	B#5	4.11257e-17
C197	a_493_368##2	a_311_124#	3.55329e-17
C198	a_493_368##4	a_27_392##7	2.06919e-19
C199	a_772_368#	VPWR#2	5.65914e-17
C200	a_27_392##4	Y#8	6.14771e-17
C201	VGND#8	D_N#2	6.36764e-20
C202	Y#9	a_311_124#	6.10518e-17
C203	D_N#3	a_311_124##6	3.48114e-18
C204	a_27_392##2	a_772_368##2	2.21726e-19
C205	a_493_368##2	a_311_124##7	4.50208e-19
C206	VGND#1	A#2	1.20993e-17
C207	a_27_392##4	Y#3	2.73813e-17
C208	Y#4	Y#2	1.58886e-19
C209	a_493_368##4	a_311_124#	2.08121e-18
C210	VGND#5	VGND#7	1.31407e-18
C211	Y#1	A#2	1.32495e-17
C212	a_985_368#	VPWR#1	3.88661e-17
C213	a_311_124##7	Y#9	2.02381e-17
C214	VGND#5	Y#4	4.33566e-17
C215	Y#8	a_311_124##4	3.714e-19
C216	a_493_368##4	a_311_124##7	8.66838e-17
C217	C_N#1	D_N#3	2.23721e-17
C218	VGND#5	VGND#11	1.29678e-17
C219	a_311_124##11	a_311_124##7	3.2359e-18
C220	VGND#5	Y#6	4.65489e-17
C221	a_985_368##2	a_985_368#	2.96061e-20
C222	a_493_368##4	D_N#1	3.4315e-18
C223	a_27_392##4	a_311_124##9	2.48901e-17
C224	a_311_124##11	D_N#1	6.20872e-17
C225	a_493_368##4	C_N#3	2.46705e-19
C226	D_N#1	VPWR#7	9.76295e-18
C227	a_985_368##2	VPWR#6	1.59634e-17
C228	a_311_124##9	a_27_392##2	1.91564e-20
C229	a_27_392##11	D_N#1	4.32774e-19
C230	a_311_124##9	a_311_124##4	1.82955e-17
C231	C_N#3	VPWR#7	1.90622e-17
C232	a_772_368#	VPWR#3	1.44389e-17
C233	a_27_392##11	C_N#3	4.36871e-17
C234	A	A#3	7.63729e-18
C235	A#2	a_985_368#	2.20279e-17
C236	a_985_368##2	a_985_368##4	3.23722e-18
C237	A#6	A#5	4.73903e-17
C238	a_311_124##9	D_N#2	6.44775e-18
C239	A#2	VPWR#6	1.04702e-18
C240	a_772_368##2	VPWR#3	6.54546e-17
C241	Y#4	a_27_392##4	2.24646e-17
C242	a_493_368##2	VPWR#3	4.60393e-17
C243	a_27_392##4	VGND#11	4.08515e-19
C244	a_311_124##9	a_311_124##2	2.59107e-19
C245	a_27_392##4	Y#6	7.07247e-17
C246	B#1	A#6	3.9594e-17
C247	a_985_368##2	a_772_368#	1.88957e-17
C248	a_311_124##9	C_N#2	3.11737e-19
C249	a_493_368##4	VPWR#3	4.77191e-17
C250	a_27_392##4	VGND#12	4.79691e-18
C251	Y#1	VGND#1	6.73327e-17
C252	B#2	a_772_368#	1.17123e-18
C253	a_985_368##3	B#2	2.71616e-19
C254	VGND#2	A#1	4.28156e-18
C255	Y#6	a_311_124##4	3.23334e-19
C256	B	A#3	1.06818e-17
C257	a_27_392##9	a_27_392##4	1.11346e-18
C258	B#7	B#1	4.61707e-17
C259	Y#9	a_311_124##2	1.54557e-18
C260	B	a_27_392##2	7.56594e-20
C261	B#5	a_772_368#	6.20727e-18
C262	a_985_368##3	a_985_368##2	2.32892e-20
C263	B#5	a_985_368##3	4.21026e-17
C264	a_27_392##9	a_311_124##4	1.85322e-18
C265	a_27_392##5	B#7	5.57896e-18
C266	a_311_124##10	D_N#2	9.37531e-18
C267	Y#1	VGND#6	3.89385e-19
C268	a_493_368#	a_27_392##4	2.59846e-19
C269	a_27_392##9	D_N#2	1.3686e-18
C270	a_27_392##7	a_27_392##5	3.69176e-17
C271	a_27_392##4	a_772_368##2	6.30483e-19
C272	a_311_124##10	C_N#2	1.2235e-18
C273	VGND#5	B#6	2.8947e-19
C274	a_27_392##4	a_493_368##2	1.00433e-18
C275	Y#7	Y#1	1.05984e-18
C276	a_27_392##4	Y#9	1.04077e-17
C277	VGND#5	a_27_392#	7.47344e-19
C278	a_493_368##4	a_311_124##2	9.32843e-20
C279	a_27_392##9	C_N#2	2.36164e-17
C280	VGND#5	a_27_392##6	1.1188e-17
C281	a_311_124#	a_27_392##7	3.30284e-17
C282	a_311_124##9	VGND#12	6.52359e-19
C283	VGND#5	a_311_124##5	1.11874e-17
C284	a_311_124##4	Y#9	3.60151e-17
C285	VPWR#1	A#5	2.99916e-18
C286	VGND#5	a_311_124##6	1.32881e-18
C287	a_311_124##4	a_493_368##4	4.56925e-17
C288	a_311_124##7	a_311_124#	4.70364e-17
C289	VGND#5	D_N#3	7.53544e-20
C290	a_311_124##10	a_311_124##9	7.31511e-18
C291	a_493_368##4	D_N#2	3.10362e-19
C292	Y#8	a_985_368##3	8.3419e-18
C293	D_N#1	a_311_124##7	5.63979e-18
C294	a_985_368##2	VPWR#2	8.13447e-19
C295	a_27_392##11	D_N#2	3.53341e-19
C296	a_27_392##4	a_27_392##6	3.5411e-18
C297	A#2	A#5	3.33216e-18
C298	VGND#7	Y#7	4.2284e-17
C299	C_N#3	D_N#1	2.87625e-18
C300	Y#8	a_493_368#	2.64386e-17
C301	a_27_392##4	a_311_124##5	2.15532e-17
C302	a_27_392##11	C_N#2	5.22832e-18
C303	VPWR#3	a_27_392##5	4.4526e-18
C304	Y#1	A#3	1.07841e-18
C305	a_27_392##4	a_311_124##6	2.26245e-17
C306	VPWR#3	a_27_392##7	5.3494e-18
C307	a_27_392##4	D_N#3	9.78097e-19
C308	a_27_392##9	a_311_124##9	2.09177e-17
C309	Y#4	Y#7	1.89442e-18
C310	a_27_392##4	C_N#1	3.51816e-19
C311	VPWR#3	a_311_124#	4.464e-18
C312	B#2	B#1	2.0582e-18
C313	D_N	a_311_124##9	2.18729e-17
C314	D_N#3	a_311_124##4	1.78734e-18
C315	VPWR#3	a_311_124##7	4.43427e-18
C316	Y#8	a_772_368##2	9.48589e-19
C317	A	a_985_368##2	2.55715e-17
C318	VGND#4	VGND#3	1.74001e-18
C319	Y#4	VGND#7	4.6528e-17
C320	VGND	a_27_392##2	1.6811e-20
C321	C_N#2	D_N#3	3.55472e-18
C322	Y#8	a_493_368##2	2.90908e-17
C323	D_N	a_311_124##10	2.95817e-17
C324	B	a_985_368##2	3.84128e-17
C325	a_27_392##9	D_N	5.31631e-18
C326	VPWR#1	A#2	7.59795e-19
C327	a_311_124##4	a_311_124#	2.28633e-19
C328	VGND#2	A#2	1.11623e-18
C329	Y#4	VGND#11	1.00393e-18
C330	VGND#1	A	2.14714e-17
C331	Y#2	B	2.1308e-17
C332	Y#1	A	2.99088e-17
C333	C_N	VGND#13	1.09072e-18
C334	a_27_392##9	C_N	5.57895e-17
C335	D_N#2	a_311_124##7	5.55666e-19
C336	VPWR#3	B#5	9.27699e-20
C337	Y#6	Y#4	2.41935e-18
C338	VGND#3	A#3	2.58435e-20
C339	C_N#3	D_N#2	7.50842e-19
C340	Y#1	B	2.92594e-17
C341	Y#3	Y	9.79032e-18
C342	D_N	VPWR#7	2.93908e-18
C343	VGND#3	A#1	2.27114e-18
C344	Y#2	Y	3.38803e-18
C345	VPWR#3	a_27_392##4	3.70244e-20
C346	A	a_985_368#	2.80878e-17
C347	VPWR	VPWR#2	1.11466e-16
C348	VGND#1	a_985_368#	3.47626e-19
C349	VGND#5	a_27_392##4	8.57849e-19
C350	VPWR#3	a_311_124##4	3.88369e-20
C351	B#5	B#2	8.80108e-19
C352	VGND#4	A#4	4.81179e-20
C353	VPWR	a_985_368##2	3.86091e-18
C354	C_N	VPWR#7	8.75456e-18
C355	Y#6	VGND#11	1.35612e-18
C356	VGND#5	a_311_124##4	2.67502e-20
C357	a_27_392##11	C_N	1.96129e-17
C358	VPWR	Y#8	4.53739e-18
C359	VGND#4	a_27_392##2	3.7593e-20
C360	VGND#3	A#4	2.19545e-17
C361	B	a_985_368##3	1.58286e-17
C362	VPWR	a_311_124##9	3.07351e-19
C363	VGND	VGND#8	9.43038e-17
C364	VGND	VGND#4	7.90626e-17
C365	a_27_392##4	a_311_124##4	8.39138e-17
C366	VGND	VGND#3	1.33686e-16
C367	VGND#4	B#4	1.00597e-18
C368	A#3	VNB	2.22259e-17
C369	a_27_392##2	VNB	2.376e-17
C370	a_311_124##2	VNB	2.59494e-17
C371	VGND	Y#8	8.15285e-19
C372	Y	a_493_368#	1.16678e-17
C373	D_N#2	a_311_124##4	2.19328e-17
C374	VGND	Y#3	1.42132e-18
C375	VGND	Y#2	5.1866e-18
C376	VPWR#3	a_27_392##2	7.0406e-21
C377	VGND#3	B#4	1.76772e-17
C378	VGND	a_311_124##9	4.05964e-18
C379	VPWR	a_985_368#	5.87128e-19
C380	C_N#2	D_N#2	2.78405e-17
C381	VPWR	a_985_368##4	1.75892e-17
C382	A	A#6	1.3518e-18
C383	VPWR	a_772_368#	3.46407e-17
C384	VGND	Y#1	1.6867e-17
C385	VPWR	a_985_368##3	8.9474e-18
C386	A	B#1	7.69012e-21
C387	VPWR	a_493_368#	9.64745e-18
C388	VGND	Y#7	1.43086e-17
C389	VPWR	a_772_368##2	2.6858e-17
C390	VGND	Y#4	2.03235e-17
C391	VPWR#3	a_311_124##2	1.234e-20
C392	VPWR	a_493_368##2	2.40992e-17
C393	VGND#4	B#6	5.55808e-18
C394	VPWR	Y#9	9.19161e-18
C395	VGND	Y#6	1.86094e-17
C396	VPWR	a_493_368##4	2.22836e-17
C397	VGND	a_311_124##10	4.46115e-18
C398	VPWR	a_311_124##11	1.94167e-17
C399	B	A#6	1.44588e-18
C400	VGND	a_27_392##9	4.53193e-17
C401	VPWR	a_27_392##11	1.76066e-17
C402	B	B#7	2.09784e-18
C403	B	a_27_392##5	3.18566e-19
C404	VGND	a_985_368##3	2.69097e-18
C405	VGND#3	B#6	7.08957e-19
C406	VGND	Y#9	3.33639e-18
C407	Y	B#1	1.85468e-19
C408	VPWR#1	A	2.38093e-18
C409	Y	B#7	9.72869e-19
C410	VGND#2	A	2.0101e-18
C411	VPWR#2	VNB	5.5274e-17
C412	VGND#8	VNB	4.13381e-17
C413	VGND#4	VNB	3.04919e-17
C414	VPWR	A#5	6.85762e-19
C415	D_N	a_311_124##4	3.21453e-18
C416	VGND#3	VNB	4.74094e-17
C417	VPWR	A#6	9.33818e-19
C418	VGND	B#6	7.67589e-19
C419	A	A#2	1.95366e-17
C420	VGND	a_27_392#	1.11675e-19
C421	VPWR	B#1	1.99393e-18
C422	D_N	D_N#2	2.00683e-17
C423	VGND	a_27_392##6	1.31477e-19
C424	A	B#2	1.193e-18
C425	VGND#4	a_27_392#	5.62944e-18
C426	VPWR	B#7	1.53632e-18
C427	Y#8	VNB	1.01275e-18
C428	VGND	a_311_124##5	2.69469e-19
C429	Y#3	VNB	2.1279e-18
C430	VPWR	a_27_392##5	1.65326e-18
C431	D_N	C_N#2	2.65002e-18
C432	Y#2	VNB	5.56431e-18
C433	VGND	a_311_124##6	1.41345e-18
C434	VPWR	a_27_392##7	7.0343e-19
C435	VGND	D_N#3	3.21309e-19
C436	a_985_368##2	A#3	3.26144e-19
C437	C_N	D_N#2	6.83093e-18
C438	VGND	C_N#1	7.68132e-19
C439	VPWR	a_311_124#	1.64537e-18
C440	a_311_124##9	VNB	1.16273e-17
C441	VPWR	a_311_124##7	1.43837e-18
C442	B	B#2	3.55294e-18
C443	C_N	C_N#2	3.05325e-17
C444	VPWR	D_N#1	2.91816e-18
C445	VGND#5	a_27_392##2	1.18597e-20
C446	VGND#1	VNB	3.87272e-17
C447	B	B#5	6.82582e-18
C448	Y#1	VNB	6.93737e-18
C449	VPWR	C_N#3	4.07232e-18
C450	Y#7	VNB	2.12109e-18
C451	VGND#7	VNB	3.39417e-19
C452	Y#4	VNB	2.02263e-18
C453	Y#6	VNB	1.93806e-18
C454	Y	B#2	4.46063e-20
C455	a_311_124##10	VNB	3.97699e-18
C456	a_27_392##9	VNB	7.0214e-17
C457	Y	B#5	1.85565e-17
C458	VPWR	VPWR#3	1.26731e-16
C459	VGND#8	a_27_392##6	3.04515e-19
C460	a_985_368#	VNB	4.99592e-17
C461	VPWR#6	VNB	2.82484e-18
C462	a_985_368##4	VNB	2.77726e-18
C463	a_772_368#	VNB	1.07352e-17
C464	a_985_368##3	VNB	6.42668e-18
C465	VPWR	A#2	5.90383e-19
C466	a_493_368#	VNB	6.2528e-18
C467	a_772_368##2	VNB	7.41782e-18
C468	a_493_368##2	VNB	2.48707e-18
C469	VPWR	B#2	1.86118e-18
C470	a_493_368##4	VNB	4.55186e-18
C471	VPWR	B#5	3.51995e-18
C472	a_311_124##11	VNB	1.54088e-17
C473	VGND	VGND#2	1.21726e-17
C474	VGND#5	a_311_124##2	3.69516e-20
C475	a_27_392##11	VNB	6.16186e-17
C476	VPWR	a_27_392##4	2.69211e-18
C477	A#1	VNB	3.19841e-17
C478	A#4	VNB	2.78475e-17
C479	VGND	VGND#5	8.09391e-17
C480	VPWR	a_311_124##4	7.68674e-18
C481	B#4	VNB	3.00921e-17
C482	B#6	VNB	2.56767e-17
C483	VGND	A#2	1.80797e-18
C484	a_27_392#	VNB	2.73048e-17
C485	VPWR	D_N#2	4.50827e-19
C486	C_N	D_N	2.79774e-17
C487	a_27_392##6	VNB	2.81172e-17
C488	VGND	B#2	1.80314e-18
C489	a_311_124##5	VNB	2.91691e-17
C490	VPWR	C_N#2	5.00919e-21
C491	a_311_124##6	VNB	3.16108e-17
C492	VGND	B#5	2.51311e-18
C493	D_N#3	VNB	4.72179e-17
C494	VGND#4	a_27_392##6	5.2376e-19
C495	C_N#1	VNB	4.10152e-17
C496	VGND	a_27_392##4	1.53389e-17
C497	A#5	VNB	4.00492e-17
C498	VGND	a_311_124##4	4.81123e-18
C499	A#6	VNB	3.36183e-17
C500	B#1	VNB	3.00155e-17
C501	B#7	VNB	3.67514e-17
C502	a_27_392##5	VNB	3.98343e-17
C503	a_27_392##7	VNB	3.30649e-17
C504	a_311_124#	VNB	3.26297e-17
C505	a_311_124##7	VNB	3.38643e-17
C506	D_N#1	VNB	3.48767e-17
C507	a_27_392##9	VGND#12	5.82157e-19
C508	C_N#3	VNB	4.53382e-17
C509	B	A	3.5995e-17
C510	VPWR#1	VNB	8.95403e-17
C511	VGND#2	VNB	9.31326e-17
C512	VPWR#3	VNB	7.31748e-17
C513	VPWR	D_N	3.1027e-18
C514	VGND#5	VNB	3.74565e-17
C515	A#2	VNB	5.97605e-17
C516	VPWR	C_N	5.4919e-18
C517	B#2	VNB	4.07283e-17
C518	B#5	VNB	6.55394e-17
C519	Y	B	2.17936e-18
C520	A#3	A#2	3.60937e-18
C521	a_27_392##4	VNB	3.69355e-17
C522	VGND	D_N	3.10979e-18
C523	VPWR	A	2.05665e-18
C524	a_311_124##4	VNB	7.97273e-17
C525	D_N#2	VNB	4.73785e-17
C526	VGND	C_N	5.89629e-18
C527	VPWR	B	4.0143e-18
C528	a_311_124##9	a_493_368##4	1.46039e-17
C529	C_N#2	VNB	6.77947e-17
C530	VGND	A	1.5229e-18
C531	VPWR	Y	1.75692e-18
C532	VGND#8	a_311_124##5	7.9214e-19
C533	VGND	B	2.92335e-18
C534	VGND	Y	1.76072e-18
C535	D_N	VNB	6.08717e-19
C536	C_N	VNB	6.14492e-18
C537	Y#2	A#1	5.4764e-20
C538	A	VNB	3.10632e-17
C539	B	VNB	6.91595e-18
C540	Y	VNB	4.41637e-18
C541	VPWR	VNB	3.0763e-16
C542	VGND	VNB	2.88607e-16
C543	VPWR#4	C_N#3	3.26803e-17
C544	C_N	VPWR#4	8.54737e-17
C545	VPWR#4	D_N#2	1.34922e-17
C546	VGND#9	VGND#13	5.25219e-18
C547	VGND#9	VGND#8	8.23216e-18
C548	VGND#9	D_N#3	1.81365e-17
C549	VGND#9	D_N#2	1.16054e-19
C550	VPWR	VPWR#4	2.29901e-16
C551	a_27_392##9	VPWR#4	2.57472e-18
C552	VPWR#4	a_311_124##11	1.09607e-16
C553	VPWR#4	a_311_124#	7.117e-20
C554	VGND	VGND#9	1.409e-16
C555	a_27_392##11	VPWR#4	1.13939e-16
C556	VPWR#4	D_N#1	2.79404e-17
C557	D_N	VPWR#4	3.89439e-17
C558	VGND#9	a_311_124##6	1.47856e-18
C559	a_311_124##4	VPWR#4	5.09778e-19
C560	VPWR#4	C_N#2	1.85512e-17
C561	VGND#9	VNB	7.28196e-17
C562	VGND#9	a_27_392##9	1.02579e-16
C563	VPWR#4	a_493_368##4	5.55217e-18
C564	VPWR#4	a_27_392##7	5.70496e-20
C565	VGND#9	C_N#1	1.39473e-17
C566	VPWR#4	VPWR#7	4.79278e-17
C567	VGND#9	C_N#2	1.05474e-18
C568	VPWR#4	VNB	9.64835e-17
C569	VPWR#4	a_311_124##7	8.81779e-19
C570	VPWR#4	a_311_124##9	2.25376e-18
*
*
.ENDS sky130_fd_sc_hs__nor4bb_2
*
