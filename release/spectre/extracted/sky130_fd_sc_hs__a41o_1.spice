* Extracted by Quantus, converted by sky130cad/quantus.py
*
*
*
*                       LINUX           Wed Nov 18 08:15:01 2026
*
*
*
*  PROGRAM  advgen
*
*  Name           : advgen - Quantus - (64-bit)
*  Version        : 25.1.0-p047
*  Build Date     : Thu Dec 11 23:20:30 PST 2025
*
*  HSPICE LIBRARY
*
*  OPERATING_TEMPERATURE 150
*  QRC_TECH_DIR <path>/tech
*
*
*

*
.SUBCKT sky130_fd_sc_hs__a41o_1 VPB VNB VGND VPWR X A2 A3 A4 B1 A1
*
*
*  caps2d version: 10
*
*
*       TRANSISTOR CARDS
*
*
XM5 X#1 a_83_244# VGND#5 VNB sky130_fd_pr__nfet_01v8_lvt l=0.15 w=0.74 ad=0.7104 as=0.3108 pd=3.4 ps=2.32
XM2 VGND#5 B1#1 a_83_244##4 VNB sky130_fd_pr__nfet_01v8_lvt l=0.15 w=0.74 ad=0.3108 as=0.2072 pd=2.32 ps=2.04
XM1 a_83_244##4 A1#3 a_449_74# VNB sky130_fd_pr__nfet_01v8_lvt l=0.15 w=0.74 ad=0.2072 as=0.2368 pd=2.04 ps=2.12
XM9 a_449_74# A2#3 a_543_74# VNB sky130_fd_pr__nfet_01v8_lvt l=0.15 w=0.74 ad=0.2368 as=0.3108 pd=2.12 ps=2.32
XM11 a_543_74# A3#3 a_657_74# VNB sky130_fd_pr__nfet_01v8_lvt l=0.15 w=0.74 ad=0.3108 as=0.3108 pd=2.32 ps=2.32
XM8 a_657_74# A4#3 VGND#1 VNB sky130_fd_pr__nfet_01v8_lvt l=0.15 w=0.74 ad=0.3108 as=0.2109 pd=2.32 ps=2.05
XM0 X#3 a_83_244##3 VPWR#9 VPB sky130_fd_pr__pfet_01v8 l=0.15 w=1.12 ad=0.3304 as=0.3304 pd=2.83 ps=2.83
XM3 a_83_244##7 B1#3 a_354_392##3 VPB sky130_fd_pr__pfet_01v8 l=0.15 w=1 ad=0.295 as=0.35 pd=2.59 ps=2.7
XM6 a_354_392##3 A1#1 VPWR#8 VPB sky130_fd_pr__pfet_01v8 l=0.15 w=1 ad=0.35 as=0.43 pd=2.7 ps=2.86
XM10 VPWR#8 A2#1 a_354_392##4 VPB sky130_fd_pr__pfet_01v8 l=0.15 w=1 ad=0.43 as=0.3 pd=2.86 ps=2.6
XM4 a_354_392##4 A3#1 VPWR#7 VPB sky130_fd_pr__pfet_01v8 l=0.15 w=1 ad=0.3 as=0.42 pd=2.6 ps=2.84
XM7 VPWR#7 A4#4 a_354_392# VPB sky130_fd_pr__pfet_01v8 l=0.15 w=1 ad=0.42 as=0.295 pd=2.84 ps=2.59
*
*
*       RESISTOR AND CAP/DIODE CARDS
*
Rg1	a_83_244#	a_83_244##2	345.494812
Rg2	a_83_244##2	a_83_244##3	560.613342
Rg3	B1#1	B1#2	439.925934
Rg4	B1#2	B1#3	409.090576
Rg5	A1#1	A1#2	417.269073
Rg6	A1#2	A1#3	452.344543
Rg7	A2#1	A2#2	509.830780
Rg8	A2#2	A2#3	307.937683
Rg9	A3#1	A3#2	509.830780
Rg10	A3#2	A3#3	307.937683
Rg11	A4#1	A4#2	32.582375
Rg12	A4#2	A4#3	322.953644
Rg13	A4#2	A4#4	524.846741
Rf1	X#1	X#2	21.397133
Rf2	X#2	X	0.840643
Rf3	X#2	X#3	87.670609
Rf4	X#1	X#2	7.500000
Rf5	B1#2	B1	162.201172
Rf6	a_83_244##4	a_83_244##5	73.234535
Rf7	a_83_244##5	a_83_244##2	90.287498
Rf8	a_83_244##5	a_83_244##7	55.168293
Rf9	A1#2	A1	162.201172
Rf10	A2#2	A2	163.409653
Rf11	A3#4	A3#2	161.262482
Rf12	A3	A3#6	1.029682
Rf13	A3#4	A3#6	10.589491
Rf14	a_354_392#	a_354_392##2	100.812180
Rf15	a_354_392##2	a_354_392##3	82.647232
Rf16	a_354_392##2	a_354_392##4	21.715120
Rf17	A4	A4#1	163.775864
Rf18	VGND#1	VGND#2	162.319641
Rf19	VGND#2	VGND#3	51.476067
Rf21	VGND#3	VGND#5	31.141060
Rf23	VPWR#2	VPWR#3	75.192947
Rf24	VPWR#3	VPWR#4	22.621120
Rf25	VPWR#4	VPWR#5	101.573006
Rf27	VPWR#2	VPWR#7	34.939823
Rf28	VPWR#3	VPWR#8	31.534731
Rf29	VPWR#5	VPWR#9	48.259808
Re1	VPWR#4	VPWR	1.091357
Re2	VGND	VGND#2	1.091398
*
*       CAPACITOR CARDS
*
*
C1	a_83_244##4	a_354_392##3	8.57082e-18
C2	VGND	VNB	6.87454e-17
C3	VPWR	VNB	6.738e-17
C4	A2	VNB	2.18872e-18
C5	A4	VNB	2.13747e-17
C6	a_354_392#	VPWR#7	9.16525e-17
C7	B1	VNB	2.39389e-18
C8	VGND	A2	1.65064e-17
C9	A1	VNB	1.90522e-18
C10	VGND	A4	2.09996e-18
C11	VGND	B1	2.01736e-18
C12	VGND	A1	4.9529e-18
C13	VPWR	A4	3.21679e-18
C14	a_83_244##2	VNB	8.76258e-17
C15	B1#2	VNB	3.66473e-17
C16	VPWR	B1	3.16345e-18
C17	A1#2	VNB	4.00208e-17
C18	A2#2	VNB	3.75016e-17
C19	VPWR	A1	2.03664e-18
C20	A3#2	VNB	3.75187e-17
C21	VGND#2	VNB	2.29168e-16
C22	VPWR#4	VNB	2.08649e-16
C23	VGND	a_83_244##2	8.93921e-18
C24	a_83_244##3	VNB	5.059e-17
C25	B1#3	VNB	3.87691e-17
C26	A1#1	VNB	3.40634e-17
C27	VGND	A1#2	1.0603e-18
C28	A2#1	VNB	3.56109e-17
C29	A3#1	VNB	3.58699e-17
C30	VGND	A2#2	3.32079e-19
C31	A4#4	VNB	4.35745e-17
C32	VGND	A3#2	6.13671e-18
C33	a_83_244#	VNB	3.3297e-17
C34	B1#1	VNB	3.04064e-17
C35	VPWR	a_83_244##2	6.32228e-18
C36	VGND	VGND#2	3.46821e-17
C37	A1#3	VNB	3.20854e-17
C38	A2	a_449_74#	1.22223e-20
C39	A2#3	VNB	2.6534e-17
C40	A3#3	VNB	2.47775e-17
C41	A4#3	VNB	2.52936e-17
C42	X#3	VNB	6.15053e-17
C43	A2	a_543_74#	5.19417e-18
C44	VPWR#9	VNB	1.4507e-17
C45	VPWR	A2#2	3.05762e-18
C46	a_83_244##7	VNB	2.54616e-17
C47	a_354_392##3	VNB	7.03397e-18
C48	VPWR	A3#2	1.51428e-18
C49	VPWR#8	VNB	3.79192e-18
C50	a_354_392##4	VNB	2.18579e-18
C51	VPWR#7	VNB	3.96252e-18
C52	B1	A1	2.36052e-17
C53	a_354_392#	VNB	5.96544e-17
C54	X#1	VNB	6.8408e-17
C55	VGND#5	VNB	4.3257e-18
C56	VPWR	VPWR#4	1.89391e-17
C57	a_83_244##4	VNB	4.78884e-18
C58	VGND	a_83_244#	2.49533e-18
C59	VGND	B1#1	3.71136e-19
C60	a_83_244##2	A2	6.50398e-19
C61	VPWR	a_83_244##3	6.11679e-18
C62	VGND	A1#3	1.35281e-18
C63	VGND#1	VNB	8.15525e-17
C64	VPWR	B1#3	2.76457e-18
C65	VGND	A2#3	9.5317e-19
C66	A2	B1#2	9.45644e-20
C67	VGND	A3#3	1.31078e-18
C68	VPWR	A1#1	3.77016e-19
C69	VGND	A4#3	2.18908e-18
C70	A2	A1#2	5.26619e-19
C71	VPWR	A2#1	6.96373e-19
C72	VGND	X#3	7.84057e-19
C73	A2	A2#2	1.03802e-17
C74	VPWR	A3#1	2.21941e-19
C75	VGND	VPWR#9	2.89261e-18
C76	A3#6	VNB	9.54901e-19
C77	VPWR	A4#4	1.47419e-18
C78	a_354_392##2	VNB	1.14443e-17
C79	A2	A3#2	2.06466e-17
C80	VGND#2	A2	1.56796e-17
C81	VGND	a_354_392#	3.79994e-18
C82	VPWR#3	VNB	2.21754e-17
C83	VGND	X#1	4.25845e-17
C84	VGND	VGND#5	2.23554e-17
C85	VGND	a_83_244##4	1.68547e-17
C86	a_83_244##2	B1	3.72904e-17
C87	VPWR	X#3	1.92539e-17
C88	VGND	VGND#1	5.82107e-17
C89	B1	B1#2	1.54524e-17
C90	VPWR	a_83_244##7	2.22154e-17
C91	VPWR	a_354_392##3	1.76112e-17
C92	B1	A1#2	2.82401e-18
C93	VPWR	VPWR#8	2.0903e-17
C94	VPWR	a_354_392##4	1.65542e-17
C95	VPWR	VPWR#7	2.21099e-17
C96	A1	B1#2	4.25542e-18
C97	VPWR	a_354_392#	1.76877e-17
C98	VGND	A3#6	5.39819e-18
C99	VGND	a_354_392##2	5.93704e-18
C100	A1	A1#2	1.58208e-17
C101	A1	A2#2	2.12738e-17
C102	X#1	VGND#5	6.03207e-17
C103	A2	A1#3	9.01906e-18
C104	A1	A3#2	6.40719e-19
C105	A2	A2#3	2.73247e-17
C106	B1	VPWR#4	5.4607e-19
C107	A2	A3#3	1.29708e-17
C108	A2	A4#3	5.76731e-18
C109	VGND#2	A1	1.28978e-18
C110	B1	a_83_244##3	5.13967e-19
C111	VPWR	A3#6	1.37799e-18
C112	X#1	a_83_244##4	3.95836e-19
C113	VPWR	a_354_392##2	3.02084e-18
C114	A2#2	a_543_74#	8.66223e-19
C115	VPWR	VPWR#3	1.84046e-17
C116	A1	A2#1	1.072e-18
C117	A3#2	a_657_74#	9.24912e-19
C118	a_83_244##4	A2	3.76784e-17
C119	VGND#5	a_83_244##4	6.22529e-17
C120	a_354_392##2	VPWR#3	3.13618e-19
C121	a_83_244##2	B1#2	2.36104e-17
C122	A4#2	VNB	6.61508e-17
C123	A2	VGND#1	1.3738e-17
C124	a_83_244##2	A1#2	1.32247e-19
C125	a_83_244##2	A2#2	1.18048e-18
C126	B1#2	A1#2	3.37479e-17
C127	A2#2	B1#2	1.78165e-20
C128	A4	a_354_392#	2.77697e-17
C129	B1	a_83_244##7	2.79755e-17
C130	B1	a_354_392##3	1.63688e-17
C131	A1#2	A2#2	2.86026e-17
C132	VGND#1	a_354_392#	3.74862e-18
C133	A1	a_354_392##3	3.6008e-17
C134	A1#3	a_449_74#	1.85513e-18
C135	A2#2	A3#2	5.08509e-17
C136	VGND#1	A4	4.27864e-17
C137	A1	VPWR#8	1.58075e-19
C138	A2#3	a_449_74#	1.6507e-17
C139	VPWR#4	B1#2	1.76016e-20
C140	VGND#2	A1#2	1.86224e-19
C141	a_83_244##4	B1	2.88731e-17
C142	a_83_244##2	a_83_244##3	4.28101e-18
C143	VPWR#4	A1#2	2.83415e-20
C144	VGND#2	A2#2	1.64305e-19
C145	VGND	A4#2	4.8709e-19
C146	a_83_244##3	B1#2	1.453e-18
C147	A2#3	a_543_74#	1.86562e-17
C148	A3#3	a_543_74#	2.09248e-18
C149	VGND#2	A3#2	6.18942e-19
C150	a_83_244##4	A1	1.79866e-17
C151	A3#6	A4	3.21124e-17
C152	A3#3	a_657_74#	2.32378e-17
C153	a_83_244##7	a_354_392##2	1.22724e-18
C154	A4#3	a_657_74#	2.35472e-17
C155	A1#2	A2#1	4.924e-18
C156	a_83_244##2	a_83_244#	5.48e-18
C157	a_83_244##2	B1#1	2.63386e-18
C158	a_354_392##3	a_354_392##2	4.59926e-19
C159	VPWR	A4#2	7.60278e-19
C160	A1	a_354_392##2	4.13384e-18
C161	VPWR#4	B1#3	7.74694e-18
C162	a_354_392##2	VPWR#8	2.58443e-17
C163	X#3	a_83_244##2	4.41531e-18
C164	VPWR#4	A1#1	5.67627e-18
C165	a_83_244##2	VPWR#9	2.89714e-17
C166	a_83_244##2	a_83_244##7	3.28794e-18
C167	A1#3	A2#2	4.32671e-18
C168	a_83_244##3	B1#3	4.227e-18
C169	X#3	B1#2	7.30081e-19
C170	a_354_392##2	a_354_392##4	1.96856e-19
C171	VPWR#9	B1#2	3.54964e-20
C172	a_83_244##7	B1#2	3.38237e-18
C173	B1#3	A1#1	3.41452e-17
C174	a_83_244##7	A1#2	6.76481e-20
C175	a_354_392##2	VPWR#7	3.32225e-17
C176	a_354_392##3	A1#2	3.12233e-18
C177	a_83_244##2	X#1	1.14705e-16
C178	A3#6	a_354_392#	2.38114e-17
C179	VGND#2	A1#3	7.57054e-18
C180	A1#1	A2#1	2.48406e-17
C181	VGND#5	a_83_244##2	3.50644e-17
C182	VPWR#8	A1#2	4.59898e-19
C183	VGND#2	A2#3	6.10598e-18
C184	a_354_392##2	a_354_392#	3.27651e-18
C185	VGND#2	A3#3	3.13134e-18
C186	VPWR#8	A2#2	5.14028e-19
C187	VGND#5	B1#2	1.0197e-18
C188	A2#1	A3#1	4.68985e-17
C189	a_83_244##4	B1#2	5.46516e-18
C190	a_354_392#	A4#2	1.12653e-17
C191	A3#1	A4#4	2.92975e-17
C192	a_83_244##4	A1#2	1.62159e-18
C193	VPWR#7	A3#2	9.36707e-19
C194	a_83_244##4	A2#2	1.42086e-18
C195	a_83_244##7	VPWR#4	1.03798e-17
C196	a_354_392##3	VPWR#4	2.10092e-17
C197	X#3	a_83_244##3	5.31387e-17
C198	a_354_392##4	VPWR#3	7.77184e-18
C199	a_83_244##3	VPWR#9	4.34937e-17
C200	a_83_244##7	a_83_244##3	2.13862e-18
C201	VPWR#9	B1#3	2.36451e-18
C202	VPWR#3	VPWR#7	5.6599e-20
C203	a_83_244##7	B1#3	3.67423e-17
C204	VGND#1	A3#2	2.24877e-18
C205	VPWR#8	a_83_244##3	4.15383e-19
C206	VPWR#9	A1#1	3.13978e-19
C207	a_83_244#	B1#1	2.15074e-17
C208	VGND#2	a_83_244##4	1.6394e-17
C209	a_354_392##3	B1#3	2.00851e-17
C210	a_354_392##2	B1#2	5.9507e-20
C211	a_83_244##7	A1#1	1.99255e-18
C212	VPWR#9	A2#1	9.13659e-20
C213	VPWR#8	B1#3	1.37126e-18
C214	a_354_392##3	A1#1	7.28981e-17
C215	A3#2	A4#2	3.07755e-17
C216	a_83_244##7	A2#1	1.54126e-19
C217	B1#1	A1#3	4.19519e-17
C218	a_354_392##2	A1#2	1.7431e-18
C219	A1#1	VPWR#8	3.43615e-17
C220	a_354_392##3	A2#1	5.35774e-19
C221	VGND#2	VGND#1	5.00679e-17
C222	A4	A4#2	2.1048e-17
C223	a_354_392##4	A1#1	1.40035e-18
C224	VGND#1	A3#6	2.15895e-18
C225	A2#1	VPWR#8	2.95071e-17
C226	a_354_392##2	A2#2	3.33734e-17
C227	A1#3	A2#3	3.33341e-17
C228	VPWR#7	A1#1	2.84221e-19
C229	a_354_392##4	A2#1	4.35506e-17
C230	VPWR#8	A3#1	1.2302e-18
C231	A3#6	A3#2	6.2931e-18
C232	VPWR#7	A2#1	1.37316e-18
C233	a_354_392##4	A3#1	5.0689e-17
C234	a_354_392##2	A3#2	4.21074e-17
C235	A2#3	A3#3	2.21706e-17
C236	VPWR#8	A4#4	5.83743e-19
C237	A3#6	A4#2	1.95466e-17
C238	A3#1	VPWR#7	3.55928e-17
C239	a_354_392#	A3#1	2.14024e-18
C240	A4#4	VPWR#7	3.27865e-17
C241	A3#3	A4#3	2.85763e-17
C242	a_354_392#	A4#4	5.81299e-17
C243	VGND#2	a_354_392##2	1.0357e-18
C244	A1	A4#2	4.04451e-19
C245	X#1	a_83_244#	4.62063e-17
C246	X#3	VPWR#9	8.54107e-17
C247	a_83_244#	VGND#5	2.91898e-17
C248	X#1	B1#1	1.07441e-19
C249	a_83_244##4	a_83_244#	3.38672e-19
C250	B1#1	VGND#5	2.34758e-17
C251	VPWR#9	a_83_244##7	8.00647e-17
C252	a_83_244##4	B1#1	4.86535e-17
C253	VPWR#4	VPWR#3	2.84478e-17
C254	VGND#5	A1#3	1.34048e-18
C255	a_354_392##2	B1#3	1.82625e-19
C256	a_83_244##4	A1#3	5.12345e-17
C257	VPWR#9	VPWR#8	1.06326e-18
C258	a_83_244##7	a_354_392##3	9.02446e-17
C259	VGND#5	A2#3	7.58212e-19
C260	a_83_244##4	A2#3	4.9228e-18
C261	a_354_392##2	A1#1	5.25738e-19
C262	VGND#5	A3#3	3.4368e-19
C263	VGND#1	B1#1	2.68152e-19
C264	a_354_392##3	VPWR#8	7.12248e-17
C265	a_83_244##4	A3#3	8.75161e-19
C266	VGND#5	A4#3	3.1517e-19
C267	a_354_392##2	A2#1	2.45069e-17
C268	X#1	X#3	2.58605e-18
C269	a_354_392##3	a_354_392##4	2.05102e-18
C270	A3#6	a_354_392##2	4.09728e-18
C271	VGND#1	A1#3	4.99601e-19
C272	a_83_244##4	A4#3	5.81081e-19
C273	a_354_392##2	A3#1	2.14195e-17
C274	VPWR#8	a_354_392##4	5.39534e-17
C275	VGND#1	A2#3	2.20905e-18
C276	VPWR#8	VPWR#7	1.55267e-18
C277	a_354_392##2	A4#4	8.53523e-19
C278	VGND#1	A3#3	1.34579e-17
C279	a_354_392##4	VPWR#7	6.74223e-17
C280	A4#2	VGND#1	8.3001e-18
C281	VGND#1	A4#3	4.739e-17
C282	VPWR#3	A2#1	3.4413e-18
C283	a_83_244##2	VPWR#5	1.0062e-18
C284	A4	VPWR#2	3.38564e-19
C285	a_354_392##2	VPWR#2	1.20253e-19
C286	a_354_392##4	VPWR#2	9.19246e-18
C287	VPWR#5	VPWR#3	2.77912e-19
C288	VPWR#2	A4#2	6.24902e-19
C289	VGND	VGND#3	4.6292e-17
C290	VPWR#4	VPWR#2	5.71433e-17
C291	VPWR#3	VPWR#2	8.2776e-19
C292	VGND#3	B1#1	2.76426e-18
C293	VPWR#5	A2#1	1.94692e-20
C294	VPWR#5	A1#1	1.18563e-19
C295	VGND#3	VNB	6.78727e-17
C296	VGND#2	VGND#3	7.82175e-17
C297	VPWR	VPWR#2	3.54393e-17
C298	VPWR#5	B1#3	7.69945e-19
C299	VPWR#5	a_83_244##3	8.8306e-18
C300	VGND#3	a_83_244##4	3.36643e-18
C301	VPWR#2	A4#4	3.18442e-18
C302	VGND#3	a_83_244#	4.50137e-18
C303	VGND#3	a_83_244##2	1.03252e-18
C304	VPWR#5	VPWR#8	7.49527e-20
C305	VPWR#4	VPWR#5	6.3202e-17
C306	VPWR#2	A3#1	2.59951e-18
C307	VPWR#2	VNB	5.04777e-17
C308	a_83_244##7	VPWR#5	1.79023e-17
C309	VPWR	VPWR#5	5.61264e-17
C310	X#3	VPWR#5	2.08765e-17
C311	VPWR#5	VNB	5.75727e-17
C312	a_354_392#	VPWR#2	2.0566e-17
C313	VGND#3	X#1	6.95641e-17
*
*
.ENDS sky130_fd_sc_hs__a41o_1
*
