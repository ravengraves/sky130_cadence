* Extracted by Quantus, converted by sky130cad/quantus.py
*
*
*
*                       LINUX           Wed Nov 18 09:14:08 2026
*
*
*
*  PROGRAM  advgen
*
*  Name           : advgen - Quantus - (64-bit)
*  Version        : 25.1.0-p047
*  Build Date     : Thu Dec 11 23:20:30 PST 2025
*
*  HSPICE LIBRARY
*
*  OPERATING_TEMPERATURE 150
*  QRC_TECH_DIR <path>/tech
*
*
*

*
.SUBCKT sky130_fd_sc_hs__xnor2_2 VNB VPB VGND A VPWR Y B
*
*
*  caps2d version: 10
*
*
*       TRANSISTOR CARDS
*
*
XM14 VGND#5 A#1 a_151_74# VNB sky130_fd_pr__nfet_01v8_lvt l=0.15 w=0.74 ad=0.25 as=0.1776 pd=2.44 ps=1.96
XM2 a_151_74# B#3 a_133_368##11 VNB sky130_fd_pr__nfet_01v8_lvt l=0.15 w=0.74 ad=0.1776 as=0.206875 pd=1.96 ps=2.05
XM6 Y#4 a_133_368##7 a_340_107##6 VNB sky130_fd_pr__nfet_01v8_lvt l=0.15 w=0.74 ad=0.4008 as=0.197775 pd=2.67 ps=2.05
XM15 a_340_107##4 a_133_368# Y#4 VNB sky130_fd_pr__nfet_01v8_lvt l=0.15 w=0.74 ad=0.2072 as=0.4008 pd=2.04 ps=2.67
XM0 VGND#7 A#4 a_340_107##4 VNB sky130_fd_pr__nfet_01v8_lvt l=0.15 w=0.74 ad=0.3824 as=0.2072 pd=2.73 ps=2.04
XM3 a_340_107##2 B#9 VGND#7 VNB sky130_fd_pr__nfet_01v8_lvt l=0.15 w=0.74 ad=0.222 as=0.3824 pd=2.08 ps=2.73
XM9 VGND#6 B#7 a_340_107##2 VNB sky130_fd_pr__nfet_01v8_lvt l=0.15 w=0.74 ad=0.3916 as=0.222 pd=2.75 ps=2.08
XM8 a_340_107# A#7 VGND#6 VNB sky130_fd_pr__nfet_01v8_lvt l=0.15 w=0.74 ad=0.20355 as=0.3916 pd=2.05 ps=2.75
XM7 VPWR#6 A#3 a_133_368##10 VPB sky130_fd_pr__pfet_01v8 l=0.15 w=1 ad=0.4177 as=0.345 pd=3.02 ps=2.69
XM13 a_133_368##10 B#4 VPWR#5 VPB sky130_fd_pr__pfet_01v8 l=0.15 w=1 ad=0.345 as=0.90245 pd=2.69 ps=3.88
XM4 Y#2 a_133_368##5 VPWR#5 VPB sky130_fd_pr__pfet_01v8 l=0.15 w=1.12 ad=0.336 as=0.90245 pd=2.84 ps=3.88
XM12 VPWR#3 a_133_368##6 Y#2 VPB sky130_fd_pr__pfet_01v8 l=0.15 w=1.12 ad=0.5525 as=0.336 pd=3.36 ps=2.84
XM10 VPWR#3 A#6 a_638_368##2 VPB sky130_fd_pr__pfet_01v8 l=0.15 w=1.12 ad=0.5525 as=0.5646 pd=3.36 ps=3.38
XM1 Y#1 B#10 a_638_368##2 VPB sky130_fd_pr__pfet_01v8 l=0.15 w=1.12 ad=0.336 as=0.5646 pd=2.84 ps=3.38
XM11 a_638_368# B#5 Y#1 VPB sky130_fd_pr__pfet_01v8 l=0.15 w=1.12 ad=0.392 as=0.336 pd=2.94 ps=2.84
XM5 a_638_368# A#9 VPWR#1 VPB sky130_fd_pr__pfet_01v8 l=0.15 w=1.12 ad=0.392 as=0.3864 pd=2.94 ps=2.93
*
*
*       RESISTOR AND CAP/DIODE CARDS
*
Rg1	A#1	A#2	365.895599
Rg2	A#2	A#3	460.048218
Rg3	B#1	B#2	66.050674
Rg4	B#2	B#3	397.555725
Rg5	B#2	B#4	415.223511
Rg6	a_133_368#	a_133_368##2	375.222931
Rg7	a_133_368##2	a_133_368##3	47.371826
Rg8	a_133_368##3	a_133_368##4	22.738758
Rg9	a_133_368##4	a_133_368##5	507.088562
Rg10	a_133_368##2	a_133_368##6	473.627625
Rg11	a_133_368##4	a_133_368##7	319.630890
Rg12	A#4	A#5	307.937683
Rg13	A#5	A#6	492.059540
Rg14	B#5	B#6	522.198975
Rg15	B#6	B#7	334.791077
Rg16	B#6	B#8	50.300888
Rg17	B#8	B#9	322.953644
Rg18	B#8	B#10	507.075531
Rg19	A#7	A#8	441.314972
Rg20	A#8	A#9	436.388367
Rf1	A#10	A#2	161.672424
Rf2	A#12	A#13	1.439625
Rf3	A#10	A#13	4.588779
Rf4	a_133_368##3	a_133_368##9	133.860657
Rf5	a_133_368##9	a_133_368##10	85.412933
Rf6	a_133_368##9	a_133_368##11	24.330074
Rf7	Y#1	Y#3	131.922791
Rf8	Y#3	Y	2.946370
Rf9	Y	Y#4	448.463257
Rf10	Y#3	Y	9.157308
Rf11	Y#2	Y#3	5.000000
Rf12	a_638_368#	a_638_368##2	101.842056
Rf13	A#8	A	165.031555
Rf14	A	A#15	113.740868
Rf15	A#15	A#16	3.349972
Rf16	a_340_107#	a_340_107##3	80.244843
Rf17	a_340_107##3	a_340_107##5	60.241066
Rf18	a_340_107##5	a_340_107##6	82.494400
Rf19	a_340_107##2	a_340_107##3	15.000000
Rf20	a_340_107##4	a_340_107##5	7.500000
Rf21	B	B#1	585.978577
Rf22	B	B#6	163.775864
Rf23	VPWR#1	VPWR#2	199.709274
Rf24	VPWR#2	VPWR#3	31.903471
Rf25	VPWR#2	VPWR#4	79.446091
Rf26	VPWR#4	VPWR#5	16.177336
Rf27	VPWR#4	VPWR#6	122.415611
Rf29	VGND#2	VGND#3	76.642677
Rf30	VGND#3	VGND#4	57.865093
Rf31	VGND#4	VGND#5	196.593414
Rf32	VGND#2	VGND#6	24.453804
Rf33	VGND#3	VGND#7	24.722408
Rf37	A#5	A#15	160.232803
Re1	A#16	A#12	23.476074
Re2	VPWR#2	VPWR	0.892922
Re3	VGND	VGND#4	0.892955
*
*       CAPACITOR CARDS
*
*
C1	A#13	a_133_368##9	2.88793e-17
C2	A#3	B#2	2.86677e-18
C3	A#16	B#8	5.77011e-18
C4	A#16	a_133_368##4	6.21165e-18
C5	VPWR#4	a_133_368##4	1.14772e-20
C6	a_133_368##9	a_340_107##4	1.61495e-18
C7	A#12	a_133_368##4	4.73311e-21
C8	Y#4	a_133_368##9	8.06537e-17
C9	VPWR#4	B#2	7.86243e-20
C10	A#12	B#2	2.26269e-20
C11	a_340_107#	VGND#6	1.05465e-18
C12	a_133_368##9	a_340_107##6	2.31368e-17
C13	a_340_107##2	a_340_107#	2.44666e-18
C14	Y#4	A#13	1.24408e-17
C15	a_133_368##9	a_133_368##11	2.23324e-18
C16	VPWR#2	a_133_368##4	7.40279e-20
C17	a_340_107##2	VGND#6	1.80292e-18
C18	VPWR#3	a_133_368##4	5.0887e-19
C19	VPWR#4	VPWR#3	1.80891e-18
C20	Y#4	A#10	3.98327e-17
C21	a_340_107##2	VGND#7	2.46514e-18
C22	VGND#4	a_133_368##4	3.08421e-19
C23	a_340_107##4	a_340_107##2	2.56098e-18
C24	VPWR#4	VPWR#5	1.36597e-17
C25	a_340_107##4	VGND#7	1.38552e-18
C26	VGND#3	A#7	1.05664e-18
C27	a_340_107##4	Y#4	3.88522e-17
C28	VPWR#6	VPWR#4	1.00709e-17
C29	VGND#3	B#7	2.21413e-18
C30	a_340_107##6	a_340_107##4	6.60897e-19
C31	Y#4	a_340_107##6	5.75142e-17
C32	VGND#3	B#9	1.24978e-17
C33	B#8	B#6	4.77634e-18
C34	Y#4	a_133_368##11	6.49375e-19
C35	VGND#3	A#4	1.10494e-17
C36	a_133_368##10	B#2	7.7359e-18
C37	VGND#3	a_133_368#	9.21331e-19
C38	Y#4	VGND#5	1.3268e-16
C39	A#5	B#8	2.23784e-17
C40	a_133_368##4	A#5	2.32487e-17
C41	VGND#3	a_133_368##7	3.98869e-19
C42	A#13	a_133_368##10	1.75765e-17
C43	A#10	a_133_368##10	1.49951e-18
C44	a_133_368##3	a_133_368##4	3.67623e-17
C45	a_133_368##3	B#2	1.87503e-19
C46	a_340_107#	A#7	3.6157e-17
C47	a_638_368#	VPWR#1	1.05876e-16
C48	B#1	a_133_368##4	3.63521e-17
C49	A#7	VGND#6	1.69107e-17
C50	B#1	B#2	8.37275e-19
C51	a_133_368##9	a_133_368#	7.58199e-20
C52	a_340_107#	B#7	8.77605e-19
C53	a_133_368##9	a_133_368##4	2.07856e-19
C54	a_340_107##2	A#7	9.93824e-19
C55	Y#4	a_133_368##10	2.013e-19
C56	B#7	VGND#6	1.7644e-17
C57	a_638_368#	Y#1	4.69543e-17
C58	a_133_368##9	a_133_368##7	9.0547e-19
C59	a_340_107##2	B#7	4.10604e-17
C60	a_638_368##2	a_638_368#	2.82362e-18
C61	a_340_107##4	A#7	7.58977e-19
C62	a_133_368##9	B#3	2.2154e-17
C63	a_133_368##9	B#2	8.4346e-18
C64	a_340_107##2	B#9	4.95081e-17
C65	Y#1	a_638_368##2	6.7919e-17
C66	a_638_368#	VPWR#3	6.39528e-21
C67	A#2	B#2	2.57912e-17
C68	a_340_107##4	B#7	7.59782e-19
C69	B#9	VGND#7	1.67622e-17
C70	a_133_368##9	A#1	5.09779e-18
C71	A#13	B#3	1.21904e-18
C72	a_340_107##2	A#4	5.58719e-19
C73	a_340_107##4	B#9	2.78191e-18
C74	A#4	VGND#7	1.76418e-17
C75	VPWR#3	a_638_368##2	2.03303e-17
C76	Y#4	B#9	3.81866e-19
C77	a_340_107##4	A#4	5.08116e-17
C78	VPWR#4	A#6	2.97257e-19
C79	Y#4	A#4	6.56678e-19
C80	a_340_107##4	a_133_368#	5.89146e-17
C81	VPWR#4	a_133_368##6	1.18433e-18
C82	a_133_368#	Y#4	2.24539e-17
C83	a_340_107##4	a_133_368##7	2.32155e-18
C84	a_340_107##6	a_133_368#	5.14107e-19
C85	Y#4	a_133_368##7	4.01715e-17
C86	VPWR#4	a_133_368##5	1.77341e-17
C87	a_340_107##4	B#3	6.8374e-19
C88	A#13	B#2	4.49102e-18
C89	a_340_107##6	a_133_368##7	3.89163e-17
C90	a_133_368##4	a_133_368#	3.9436e-19
C91	Y#4	B#3	2.72388e-17
C92	a_340_107##4	A#1	2.09135e-19
C93	VPWR#4	B#4	1.99213e-17
C94	a_133_368##10	VPWR#5	8.09941e-19
C95	a_340_107##6	B#3	1.84051e-18
C96	Y#4	A#1	3.74628e-17
C97	B#3	a_133_368##11	2.44608e-17
C98	a_340_107##6	A#1	5.44559e-19
C99	VGND#5	a_133_368##7	1.17668e-19
C100	VPWR#4	A#3	3.97354e-18
C101	VGND#5	B#3	4.92349e-18
C102	A#16	VGND#3	5.73771e-19
C103	A#1	VGND#5	1.58419e-17
C104	B#2	a_133_368##4	5.49084e-19
C105	B#7	A#7	1.79502e-17
C106	B#3	a_133_368##4	7.91054e-19
C107	A#12	VPWR#4	5.87541e-18
C108	A#9	VPWR#1	2.69999e-17
C109	a_638_368#	A#9	4.91778e-17
C110	B#9	B#7	3.55627e-17
C111	VPWR#1	B#5	4.93383e-18
C112	Y#1	A#9	1.19707e-18
C113	VPWR#2	VPWR#4	6.14725e-17
C114	VGND#4	VGND#3	3.87032e-17
C115	a_638_368#	B#5	3.92618e-17
C116	a_638_368##2	A#9	3.44451e-19
C117	VPWR#1	B#10	1.86789e-19
C118	Y#1	B#5	3.51529e-17
C119	A#4	B#9	2.12636e-17
C120	VPWR#3	A#9	7.43181e-20
C121	a_638_368#	B#10	4.84831e-19
C122	a_638_368##2	B#5	7.46554e-19
C123	VPWR#1	A#6	6.12452e-20
C124	Y#1	B#10	4.3427e-17
C125	A#12	a_133_368##9	3.47668e-17
C126	VPWR#3	B#5	1.29526e-19
C127	a_638_368#	A#6	2.08488e-19
C128	a_638_368##2	B#10	4.27351e-17
C129	a_133_368#	A#4	3.72108e-17
C130	Y#1	A#6	1.35033e-17
C131	A#12	A#13	1.25445e-17
C132	VPWR#3	B#10	1.03525e-18
C133	a_638_368#	a_133_368##6	1.15908e-20
C134	VGND#3	B#6	5.58791e-20
C135	A#6	a_638_368##2	3.49731e-17
C136	Y#1	a_133_368##6	3.34531e-19
C137	A#12	A#10	1.93992e-17
C138	a_340_107##2	A#16	5.57276e-18
C139	A#6	VPWR#3	2.82737e-17
C140	a_133_368##7	a_133_368#	1.61392e-17
C141	a_638_368##2	a_133_368##6	6.3344e-19
C142	a_340_107##2	B#8	6.7667e-19
C143	B	a_133_368##4	2.53075e-20
C144	VGND#3	A#5	6.65291e-19
C145	a_340_107##4	A#16	4.03955e-17
C146	a_133_368##6	VPWR#3	3.23936e-17
C147	A#16	Y#4	1.14513e-18
C148	a_133_368##6	Y#2	2.32319e-17
C149	B#3	a_133_368##7	4.20906e-18
C150	a_133_368##10	A#6	1.30403e-19
C151	A#16	a_340_107##6	1.61804e-18
C152	VPWR#3	a_133_368##5	1.1935e-18
C153	a_133_368##5	Y#2	2.32319e-17
C154	A#12	Y#4	1.7573e-17
C155	a_133_368##10	a_133_368##6	1.81512e-19
C156	A#1	B#3	4.67605e-17
C157	A#12	a_340_107##6	2.9448e-18
C158	a_133_368##5	VPWR#5	2.10025e-17
C159	a_133_368##10	a_133_368##5	1.95099e-18
C160	B#4	VPWR#5	3.00721e-17
C161	Y	a_133_368##4	1.97268e-18
C162	a_340_107#	A#8	6.06799e-19
C163	VPWR#6	a_133_368##5	1.45097e-18
C164	Y	B#2	1.06788e-18
C165	A#12	VGND#5	2.62749e-18
C166	VGND#4	a_340_107##4	1.35328e-17
C167	a_133_368##10	B#4	4.05039e-17
C168	A#16	Y#1	6.87739e-19
C169	VGND#4	Y#4	8.67638e-17
C170	VPWR#4	B#1	1.53789e-18
C171	VPWR#6	B#4	3.53678e-18
C172	A#16	a_638_368##2	1.32272e-18
C173	a_133_368##10	A#3	3.46792e-17
C174	A#16	VPWR#3	2.05492e-18
C175	VPWR#2	VPWR#1	5.43747e-17
C176	A#3	VPWR#6	2.45164e-17
C177	B#6	a_340_107##2	1.9771e-18
C178	a_133_368##9	a_133_368##3	9.21491e-19
C179	a_638_368#	VPWR#2	2.62392e-18
C180	VPWR#4	A#2	6.79531e-20
C181	VGND#4	VGND#5	6.00339e-17
C182	Y#1	VPWR#2	1.36783e-18
C183	B#5	A#9	3.42779e-17
C184	a_638_368##2	VPWR#2	5.31426e-17
C185	a_133_368##9	B#1	4.65346e-17
C186	A#5	VGND#7	7.72915e-19
C187	A#12	VPWR#5	1.21676e-19
C188	a_340_107##4	A#5	1.93075e-18
C189	VPWR#1	A#8	5.87941e-19
C190	A#12	a_133_368##10	4.42384e-18
C191	A#8	a_638_368#	6.28792e-19
C192	a_340_107##4	a_133_368##4	9.72926e-19
C193	B#10	B#5	4.78169e-17
C194	a_133_368##9	A#2	2.46703e-18
C195	VPWR#1	B#6	1.01954e-20
C196	a_340_107##4	a_133_368##3	2.63648e-17
C197	A#13	A#2	6.8683e-18
C198	a_638_368#	B#6	6.94195e-20
C199	VPWR#2	VPWR#6	3.21461e-17
C200	a_133_368##3	Y#4	2.53696e-18
C201	A#6	B#10	2.40017e-17
C202	a_133_368##3	a_340_107##6	5.3649e-17
C203	Y#1	B#6	4.31113e-19
C204	A#10	A#2	1.35078e-17
C205	A#16	a_133_368#	9.39375e-19
C206	a_638_368##2	B#6	8.67743e-20
C207	a_340_107##4	B#1	3.51427e-18
C208	Y#4	B#1	2.32621e-18
C209	A	B#8	2.31661e-19
C210	Y#1	A#5	4.16747e-19
C211	a_133_368##6	A#6	2.60576e-17
C212	a_638_368##2	A#5	3.03266e-19
C213	Y#4	A#2	8.36332e-18
C214	A#12	B#3	3.53656e-22
C215	a_133_368##4	Y#4	3.66161e-18
C216	VGND#5	B#1	2.49112e-20
C217	a_133_368##5	a_133_368##6	4.78457e-17
C218	VGND#4	a_133_368#	5.14439e-18
C219	B#6	A#7	1.57721e-18
C220	B#1	a_638_368#	1.42416e-18
C221	B#1	Y#1	8.96295e-17
C222	VGND#4	a_133_368##7	4.48038e-18
C223	A#2	VGND#5	1.82573e-18
C224	B#1	a_638_368##2	2.69993e-18
C225	B#4	a_133_368##5	6.33021e-18
C226	B#1	VPWR#3	7.42236e-18
C227	A#16	B#10	2.21853e-17
C228	A#16	A#6	7.75845e-18
C229	B#1	VPWR#5	5.40999e-18
C230	Y#4	B#2	1.33193e-19
C231	VGND	B#8	1.1162e-18
C232	A#3	B#4	3.66449e-17
C233	a_133_368##10	B#1	3.62281e-17
C234	A#16	a_133_368##6	1.72991e-18
C235	a_133_368##3	B#7	3.0367e-19
C236	VPWR#2	B#10	4.47264e-18
C237	a_133_368#	A#5	6.35205e-19
C238	a_133_368##3	B#9	5.15105e-19
C239	VPWR#2	A#6	8.30952e-18
C240	a_133_368##3	A#4	1.53061e-18
C241	a_133_368##4	a_340_107##6	1.54276e-18
C242	a_133_368##10	A#2	3.54961e-18
C243	a_133_368##3	a_133_368#	5.63167e-18
C244	B#5	A#8	2.34895e-18
C245	VPWR#6	A#2	2.54152e-19
C246	VPWR#2	a_133_368##6	5.55115e-18
C247	a_133_368##3	a_133_368##7	9.26661e-18
C248	Y	VPWR#4	1.14711e-16
C249	Y#4	a_151_74#	1.25386e-18
C250	A#2	B#3	3.16917e-18
C251	B	a_340_107#	5.77849e-17
C252	B#1	A#9	3.02803e-19
C253	B	VGND#6	1.19353e-18
C254	B#1	B#5	7.08953e-18
C255	B	a_340_107##2	5.37693e-17
C256	A#16	VGND#4	1.79657e-18
C257	a_133_368##9	Y	5.65197e-19
C258	B#1	B#10	1.11632e-17
C259	VPWR	VPWR#4	6.92909e-17
C260	A#16	A#8	8.18065e-19
C261	B#1	A#6	1.94988e-17
C262	Y	A#10	1.70507e-17
C263	B#1	a_133_368##6	2.15011e-17
C264	A#16	B#6	1.8429e-19
C265	B#1	a_133_368##5	1.81683e-17
C266	B	VPWR#1	5.52499e-17
C267	B	a_638_368#	4.28461e-17
C268	A#16	A#5	2.39388e-17
C269	B#1	B#4	2.22603e-18
C270	Y#4	Y	1.1979e-18
C271	VPWR	A#13	1.65004e-18
C272	VPWR#2	B#6	4.16606e-20
C273	B	a_638_368##2	7.61067e-20
C274	A#16	a_133_368##3	6.41417e-17
C275	VPWR	A#10	2.73175e-18
C276	VPWR#2	A#5	5.80084e-20
C277	A#12	a_133_368##3	1.15592e-17
C278	B#1	A#16	1.00313e-16
C279	B#6	A#8	2.72889e-17
C280	Y	Y#1	1.73671e-18
C281	A#12	B#1	3.00965e-17
C282	B#8	VNB	2.10301e-17
C283	B	A#7	1.68885e-17
C284	a_133_368##4	VNB	5.09564e-17
C285	B#2	VNB	2.03882e-17
C286	Y	VPWR#3	6.24036e-17
C287	B	B#7	7.43455e-18
C288	B#3	a_151_74#	3.2852e-18
C289	B	B#9	3.93783e-18
C290	VGND#3	a_340_107##2	2.67312e-17
C291	Y	VPWR#5	4.36868e-18
C292	A#12	A#2	4.94829e-20
C293	A#1	a_151_74#	1.36735e-17
C294	VGND	VGND#3	3.52785e-17
C295	B	A#4	1.54019e-18
C296	Y	a_133_368##10	8.15231e-17
C297	VPWR	VPWR#1	5.60061e-17
C298	VGND#4	B#1	7.47337e-20
C299	B	a_133_368#	4.15309e-19
C300	VPWR	a_638_368#	2.22757e-17
C301	Y	VPWR#6	5.05172e-17
C302	a_340_107##2	A	1.67674e-18
C303	VPWR	Y#1	1.25154e-17
C304	B	a_133_368##7	4.07257e-19
C305	VPWR	a_638_368##2	2.20334e-17
C306	VPWR	VPWR#3	1.65868e-17
C307	a_133_368##3	A#5	2.6935e-18
C308	B#1	B#6	5.03278e-19
C309	VPWR	VPWR#5	2.56256e-19
C310	VGND	a_133_368##9	1.12822e-17
C311	VPWR	a_133_368##10	5.19845e-18
C312	B	A#9	2.71434e-17
C313	B#1	A#5	6.11339e-19
C314	VGND	A#13	6.59836e-19
C315	VPWR	VPWR#6	4.0928e-17
C316	A	VPWR#1	1.7229e-19
C317	B	B#5	5.10288e-18
C318	B#2	a_133_368##5	5.39544e-19
C319	A	a_638_368#	5.17146e-19
C320	VGND	A#10	2.27493e-18
C321	VGND	a_340_107#	1.50037e-17
C322	A	Y#1	8.78262e-19
C323	B	B#10	2.79659e-19
C324	a_133_368##3	B#1	7.83425e-17
C325	VGND#3	VGND#7	1.2109e-17
C326	VGND	a_340_107##2	1.83093e-17
C327	B	A#6	1.9087e-19
C328	VGND	a_340_107##4	2.18456e-17
C329	VGND	Y#4	7.23187e-17
C330	Y	B#5	2.34638e-19
C331	VGND	a_340_107##6	4.11067e-18
C332	Y	B#10	5.98616e-19
C333	VGND	VGND#5	5.4634e-17
C334	Y	A#6	1.54719e-17
C335	Y	a_133_368##6	4.18838e-17
C336	VPWR	A#9	1.37267e-18
C337	Y	a_133_368##5	4.7295e-17
C338	VPWR	B#5	1.47266e-18
C339	A#16	B	1.76098e-17
C340	Y	B#4	2.82589e-17
C341	VPWR	B#10	1.40868e-18
C342	Y	A#3	3.83544e-17
C343	VPWR	A#6	8.76921e-19
C344	VGND	a_133_368##10	1.30124e-19
C345	VGND#3	B#8	2.73553e-20
C346	VGND	A#7	1.03342e-18
C347	A#16	Y	8.84177e-18
C348	VGND	B#7	4.45391e-19
C349	A	A#9	3.39778e-18
C350	VGND#3	a_340_107##4	3.80196e-17
C351	VGND	B#9	3.89532e-19
C352	VPWR	B#4	8.71338e-18
C353	A	B#5	1.52273e-17
C354	A#12	Y	9.6753e-18
C355	VGND#3	VNB	3.19773e-17
C356	B	A#8	1.78254e-17
C357	VPWR	A#3	8.85927e-18
C358	Y	VPWR#2	1.26627e-17
C359	VPWR#4	VNB	5.35909e-17
C360	B	B#6	1.98574e-17
C361	VPWR	A#16	4.57194e-18
C362	B	A#5	1.64261e-18
C363	a_133_368##9	VNB	6.99696e-18
C364	a_133_368##3	B	3.00186e-18
C365	VPWR	VPWR#2	3.6146e-17
C366	A#10	VNB	6.91218e-18
C367	a_340_107#	VNB	2.1897e-17
C368	A#16	A	3.29132e-18
C369	a_340_107##4	VNB	1.64761e-18
C370	Y#4	VNB	4.65154e-17
C371	a_340_107##6	VNB	1.97098e-18
C372	B#1	Y	1.35286e-16
C373	VGND#5	VNB	7.78008e-17
C374	VPWR#1	VNB	8.05393e-17
C375	a_638_368#	VNB	3.75377e-18
C376	Y	A#2	7.82202e-18
C377	VPWR	a_133_368##3	2.93889e-18
C378	A	A#8	1.68569e-17
C379	a_638_368##2	VNB	4.02794e-18
C380	VPWR#3	VNB	4.32132e-18
C381	VGND	A#16	3.85533e-17
C382	A	B#6	9.09071e-18
C383	VPWR	B#1	1.75288e-17
C384	VGND	A#12	3.5749e-17
C385	a_133_368##10	VNB	9.37663e-19
C386	A	A#5	1.34942e-19
C387	VPWR#6	VNB	5.52612e-17
C388	A#7	VNB	3.8944e-17
C389	Y#4	VGND#3	3.55702e-18
C390	B#7	VNB	2.55721e-17
C391	VGND	VGND#4	2.98384e-17
C392	B#9	VNB	2.48846e-17
C393	A#4	VNB	2.57291e-17
C394	A	B#1	3.01667e-17
C395	a_133_368#	VNB	2.7545e-17
C396	a_133_368##7	VNB	2.86151e-17
C397	VGND	B#6	9.51903e-19
C398	B#3	VNB	3.00889e-17
C399	A#1	VNB	3.32909e-17
C400	A#9	VNB	4.24033e-17
C401	VGND	a_133_368##3	1.40681e-18
C402	B#5	VNB	3.46027e-17
C403	B#10	VNB	3.37876e-17
C404	VGND	B#1	2.51544e-18
C405	A#6	VNB	3.96048e-17
C406	a_133_368##6	VNB	3.81116e-17
C407	VGND	A#2	1.10693e-20
C408	a_133_368##5	VNB	3.72531e-17
C409	B#4	VNB	3.35817e-17
C410	A#3	VNB	4.2282e-17
C411	VPWR	B	7.4894e-18
C412	A#16	VNB	5.5867e-18
C413	A#12	VNB	4.53204e-18
C414	VPWR#2	VNB	2.71638e-16
C415	VPWR	Y	4.54144e-17
C416	VGND#4	VNB	2.69711e-16
C417	B	A	1.74053e-16
C418	A#8	VNB	4.45781e-17
C419	B#6	VNB	2.88413e-17
C420	A#5	VNB	3.35103e-17
C421	a_133_368##3	VNB	6.21815e-18
C422	VGND	B	1.09209e-17
C423	B#1	VNB	4.78019e-17
C424	VPWR	A	4.87073e-18
C425	A#2	VNB	4.13817e-17
C426	VGND	A	2.56114e-18
C427	B	VNB	6.81407e-17
C428	Y	VNB	5.10553e-17
C429	VGND#5	B#2	1.12305e-20
C430	VPWR	VNB	5.96132e-17
C431	A	VNB	4.54059e-18
C432	VGND	VNB	4.40842e-17
C433	VGND#2	B#9	2.4068e-18
C434	VGND	VGND#2	5.06763e-17
C435	VGND#2	a_340_107#	3.56578e-17
C436	VGND#2	B	1.24103e-18
C437	VGND#2	A#4	5.42108e-19
C438	VGND#2	VGND#6	1.45967e-17
C439	VGND#4	VGND#2	5.70902e-17
C440	VGND#3	VGND#2	5.88136e-18
C441	VGND#2	VNB	5.42917e-17
C442	VGND#2	A#7	1.46184e-17
C443	VGND#2	a_340_107##2	2.61406e-17
C444	VGND#2	A#8	7.27229e-19
C445	VGND#2	B#7	1.28389e-17
C446	VGND#2	B#6	8.35839e-20
*
*
.ENDS sky130_fd_sc_hs__xnor2_2
*
