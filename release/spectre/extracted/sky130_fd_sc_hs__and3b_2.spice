* Extracted by Quantus, converted by sky130cad/quantus.py
*
*
*
*                       LINUX           Wed Nov 18 08:17:56 2026
*
*
*
*  PROGRAM  advgen
*
*  Name           : advgen - Quantus - (64-bit)
*  Version        : 25.1.0-p047
*  Build Date     : Thu Dec 11 23:20:30 PST 2025
*
*  HSPICE LIBRARY
*
*  OPERATING_TEMPERATURE 150
*  QRC_TECH_DIR <path>/tech
*
*
*

*
.SUBCKT sky130_fd_sc_hs__and3b_2 VPB VNB VGND VPWR X B A_N C
*
*
*  caps2d version: 10
*
*
*       TRANSISTOR CARDS
*
*
XM10 a_27_88##7 A_N#3 VGND#7 VNB sky130_fd_pr__nfet_01v8_lvt l=0.15 w=0.55 ad=0.15675 as=0.16225 pd=1.67 ps=1.69
XM11 a_284_368##13 a_27_88# a_376_74# VNB sky130_fd_pr__nfet_01v8_lvt l=0.15 w=0.74 ad=0.2109 as=0.1776 pd=2.05 ps=1.96
XM8 a_376_74# B#3 a_454_74# VNB sky130_fd_pr__nfet_01v8_lvt l=0.15 w=0.74 ad=0.1776 as=0.3108 pd=1.96 ps=2.32
XM0 a_454_74# C#3 VGND#6 VNB sky130_fd_pr__nfet_01v8_lvt l=0.15 w=0.74 ad=0.3108 as=0.3108 pd=2.32 ps=2.32
XM5 X#1 a_284_368##4 VGND#6 VNB sky130_fd_pr__nfet_01v8_lvt l=0.15 w=0.74 ad=0.2072 as=0.3108 pd=2.04 ps=2.32
XM7 VGND#1 a_284_368##5 X#1 VNB sky130_fd_pr__nfet_01v8_lvt l=0.15 w=0.74 ad=0.2109 as=0.2072 pd=2.05 ps=2.04
XM9 a_27_88##5 A_N#1 VPWR#7 VPB sky130_fd_pr__pfet_01v8 l=0.15 w=0.84 ad=0.2478 as=0.2562 pd=2.27 ps=2.29
XM4 a_284_368##12 a_27_88##4 VPWR#5 VPB sky130_fd_pr__pfet_01v8 l=0.15 w=1 ad=0.295 as=0.42 pd=2.59 ps=2.84
XM6 VPWR#5 B#1 a_284_368##9 VPB sky130_fd_pr__pfet_01v8 l=0.15 w=1 ad=0.42 as=0.3 pd=2.84 ps=2.6
XM1 a_284_368##9 C#1 VPWR#4 VPB sky130_fd_pr__pfet_01v8 l=0.15 w=1 ad=0.3 as=0.4254 pd=2.6 ps=3.02
XM3 VPWR#4 a_284_368##7 X#3 VPB sky130_fd_pr__pfet_01v8 l=0.15 w=1.12 ad=0.4254 as=0.3528 pd=3.02 ps=2.87
XM2 X#3 a_284_368##6 VPWR#1 VPB sky130_fd_pr__pfet_01v8 l=0.15 w=1.12 ad=0.3528 as=0.3304 pd=2.87 ps=2.83
*
*
*       RESISTOR AND CAP/DIODE CARDS
*
Rg1	A_N#1	A_N#2	403.817810
Rg2	A_N#2	A_N#3	374.220459
Rg3	a_27_88#	a_27_88##2	316.423859
Rg4	a_27_88##2	a_27_88##3	163.383881
Rg5	a_27_88##2	a_27_88##4	459.869537
Rg6	B#1	B#2	457.627838
Rg7	B#2	B#3	307.937683
Rg8	C#1	C#2	400.207520
Rg9	C#2	C#3	382.539734
Rg10	a_284_368#	a_284_368##2	41.678959
Rg11	a_284_368##2	a_284_368##3	69.339531
Rg12	a_284_368##3	a_284_368##4	368.862610
Rg13	a_284_368##2	a_284_368##5	370.459167
Rg14	a_284_368##2	a_284_368##6	472.309845
Rg15	a_284_368##3	a_284_368##7	471.862823
Rf1	A_N#4	A_N	1.081709
Rf2	A_N#2	A_N#6	81.198112
Rf3	A_N#4	A_N#6	2.883209
Rf4	a_27_88##5	a_27_88##3	105.932587
Rf5	a_27_88##3	a_27_88##7	97.022240
Rf6	B	B#4	9.063801
Rf7	B#4	B	2.913365
Rf8	C#2	C#5	162.055817
Rf9	C#6	C	1.823013
Rf10	C#5	C#6	8.098473
Rf11	X	X#2	7.282945
Rf12	X#2	X	7.282945
Rf13	X	X#3	27.946503
Rf14	X#1	X#2	7.500000
Rf15	a_284_368#	a_284_368##10	317.180054
Rf16	a_284_368##10	a_284_368##11	71.598000
Rf17	a_284_368##11	a_284_368##12	16.919262
Rf18	a_284_368##11	a_284_368##13	55.110386
Rf19	a_284_368##9	a_284_368##10	5.000000
Rf20	VPWR#1	VPWR#2	99.045586
Rf21	VPWR#2	VPWR#3	70.469200
Rf22	VPWR#2	VPWR#4	35.885353
Rf23	VPWR#3	VPWR#5	38.575687
Rf24	VPWR#3	VPWR#6	105.971741
Rf25	VPWR#6	VPWR#7	40.215752
Rf27	VGND#1	VGND#2	115.668877
Rf28	VGND#2	VGND#3	59.876873
Rf29	VGND#3	VGND#4	105.898689
Rf31	VGND#2	VGND#6	33.306259
Rf32	VGND#4	VGND#7	36.082184
Rf35	B#2	B#4	160.232803
Re1	VPWR#3	VPWR	1.091357
Re2	VGND	VGND#3	1.091398
*
*       CAPACITOR CARDS
*
*
C1	VGND#2	C#5	5.73835e-19
C2	a_27_88##2	B#1	7.88448e-19
C3	VGND#1	a_284_368##2	9.37888e-18
C4	a_284_368##3	X#1	2.56833e-19
C5	a_284_368##2	X#1	1.06158e-19
C6	VGND#2	VGND#1	8.0087e-19
C7	VPWR#3	a_27_88##2	1.25939e-19
C8	VGND#3	a_284_368##3	5.34301e-21
C9	a_284_368##3	a_284_368##2	3.35563e-18
C10	VGND#3	a_284_368##2	2.20845e-21
C11	VGND#3	a_27_88##2	2.02591e-19
C12	a_284_368#	a_284_368##3	1.24058e-19
C13	a_284_368#	a_284_368##2	2.75513e-17
C14	a_284_368##13	a_27_88##2	2.05836e-17
C15	VPWR#2	VPWR#1	8.90425e-19
C16	VGND#6	C#5	1.52949e-17
C17	C#2	a_284_368##3	2.87851e-17
C18	a_284_368##11	X#3	9.58843e-19
C19	a_284_368##9	VPWR#2	7.7449e-18
C20	a_27_88##2	B#2	2.92379e-17
C21	a_284_368##11	a_284_368##9	2.86765e-18
C22	VGND#6	VGND#1	1.38514e-18
C23	a_284_368##2	VPWR#1	1.32087e-18
C24	a_284_368##11	VPWR#5	8.46034e-17
C25	a_27_88##3	a_27_88##2	1.26655e-18
C26	a_284_368##11	a_284_368##12	6.36999e-18
C27	VGND#2	a_284_368##5	1.37227e-18
C28	a_284_368##3	X#3	1.35495e-19
C29	VPWR#7	a_284_368##11	1.77276e-17
C30	a_284_368##2	X#3	1.33853e-19
C31	VGND#2	a_284_368##4	8.25239e-18
C32	C#5	a_284_368##9	1.97376e-17
C33	VGND#2	a_284_368##3	6.63179e-20
C34	a_27_88##5	a_284_368##11	1.87913e-18
C35	a_284_368##13	VGND#6	2.80184e-18
C36	VGND#2	C#3	3.80187e-18
C37	VGND#2	a_284_368##2	2.74114e-20
C38	VGND#7	a_284_368##13	1.60784e-17
C39	a_284_368##9	a_284_368##3	2.79391e-19
C40	a_27_88##7	a_284_368##13	1.8293e-18
C41	a_284_368##9	a_284_368##2	2.62161e-19
C42	a_27_88##7	VGND#7	4.66734e-17
C43	VPWR#2	a_284_368##6	3.56631e-18
C44	VPWR#2	a_284_368##3	1.39238e-19
C45	VGND#1	a_284_368##5	2.91593e-17
C46	VPWR#4	VPWR#1	1.39744e-17
C47	VPWR#2	a_284_368##7	7.61582e-18
C48	a_284_368##5	X#1	1.5442e-17
C49	VPWR#2	a_284_368##2	1.3039e-19
C50	VGND#1	a_284_368##4	1.36741e-18
C51	VGND#6	a_284_368##5	1.23531e-18
C52	a_284_368##11	a_284_368##7	7.97067e-20
C53	a_284_368##4	X#1	1.4935e-17
C54	VPWR#2	C#1	4.55175e-18
C55	VGND#1	C#3	2.76593e-19
C56	a_284_368##9	X#3	3.52502e-17
C57	VGND#6	a_284_368##4	1.67902e-17
C58	a_284_368##9	VPWR#4	6.51731e-17
C59	a_284_368##11	C#1	1.20603e-19
C60	VGND#6	C#3	5.06826e-17
C61	VPWR#5	VPWR#4	5.23325e-18
C62	a_27_88##7	a_27_88##5	5.87612e-19
C63	a_284_368##11	B#1	1.38432e-18
C64	VGND#6	B#3	4.87552e-18
C65	a_284_368##9	VPWR#5	5.79408e-17
C66	VGND#6	a_27_88#	8.97297e-19
C67	a_284_368##13	C#3	4.75196e-19
C68	a_284_368##11	a_27_88##4	5.39669e-17
C69	VGND#7	C#3	1.67307e-19
C70	C#5	C#1	2.02608e-18
C71	a_284_368##13	B#3	4.45775e-18
C72	a_284_368##11	A_N#1	5.43553e-18
C73	VPWR#7	VPWR#5	2.82203e-18
C74	VGND#7	B#3	1.93342e-19
C75	a_284_368##13	a_27_88#	5.64667e-17
C76	C#5	B#1	1.2071e-18
C77	VGND#7	a_27_88#	2.882e-18
C78	C	a_284_368##3	8.55436e-18
C79	a_284_368##13	A_N#3	5.31952e-18
C80	a_284_368##11	a_27_88##2	1.04592e-17
C81	VPWR#3	VPWR#2	4.67633e-17
C82	a_27_88##7	a_27_88#	3.84002e-19
C83	VGND#3	VGND#2	4.68756e-17
C84	VGND#7	A_N#3	3.33342e-17
C85	a_27_88##5	VPWR#7	6.72559e-17
C86	a_284_368##11	VPWR#3	1.11961e-17
C87	a_27_88##7	A_N#3	3.28479e-17
C88	a_284_368#	VPWR#2	2.20327e-19
C89	VPWR#1	a_284_368##6	3.09978e-17
C90	a_284_368##4	a_284_368##5	3.84396e-17
C91	X#3	a_284_368##6	3.62849e-17
C92	VPWR#1	a_284_368##7	5.48303e-18
C93	VPWR#4	a_284_368##6	5.13814e-18
C94	X#3	a_284_368##7	3.64307e-17
C95	C#3	a_284_368##4	2.12366e-17
C96	a_284_368##9	a_284_368##6	8.53011e-19
C97	VPWR#4	a_284_368##7	4.41468e-17
C98	X#3	C#1	1.45335e-18
C99	a_284_368##9	a_284_368##7	1.54847e-17
C100	B	a_284_368##3	3.12595e-19
C101	B	a_284_368##2	5.00858e-20
C102	a_284_368##11	B#2	1.89084e-18
C103	C#1	VPWR#4	2.81699e-17
C104	B	a_27_88##2	6.10671e-18
C105	B#3	C#3	2.19427e-17
C106	VPWR#5	a_284_368##7	8.3188e-19
C107	X#3	B#1	1.20091e-19
C108	a_284_368##9	C#1	6.42956e-17
C109	C#5	C#2	1.49717e-17
C110	VPWR#4	B#1	7.4488e-19
C111	VGND#3	VGND#1	2.89809e-17
C112	VPWR#5	C#1	1.33475e-18
C113	a_284_368##11	a_27_88##3	7.03982e-17
C114	X#3	a_27_88##4	7.80873e-20
C115	a_284_368##9	B#1	5.86865e-17
C116	a_27_88#	B#3	4.6953e-17
C117	VPWR#4	a_27_88##4	3.58719e-19
C118	C#3	a_284_368##3	8.28109e-19
C119	B#1	VPWR#5	2.97016e-17
C120	B#2	C#5	1.02946e-17
C121	a_284_368#	VGND#1	3.62757e-17
C122	a_284_368##9	a_27_88##4	1.60682e-18
C123	a_284_368##11	A_N#2	5.55802e-19
C124	a_27_88##4	VPWR#5	3.51407e-17
C125	A_N#3	a_27_88#	2.6543e-18
C126	VPWR#7	B#1	2.66023e-19
C127	X	a_284_368##3	1.40095e-17
C128	VGND#3	a_284_368##13	1.68264e-17
C129	X	a_284_368##2	1.31371e-17
C130	a_27_88##4	a_284_368##12	3.19584e-17
C131	VPWR#3	VPWR#1	2.58868e-17
C132	VPWR#5	A_N#1	9.01751e-19
C133	VPWR#7	a_27_88##4	3.19921e-18
C134	VGND#6	C#2	4.20666e-18
C135	a_27_88##5	a_27_88##4	3.90288e-19
C136	VPWR#7	A_N#1	3.88505e-17
C137	a_284_368##9	VPWR#3	7.18667e-18
C138	a_27_88##5	A_N#1	3.74669e-17
C139	a_284_368#	VPWR#1	4.5402e-17
C140	a_284_368#	X#3	2.37529e-17
C141	a_284_368##13	B#2	7.48724e-18
C142	a_27_88##2	B#3	9.42119e-19
C143	a_284_368##9	a_284_368#	1.32994e-18
C144	X#3	C#2	2.27895e-20
C145	a_284_368##7	a_284_368##6	4.67523e-17
C146	C#2	VPWR#4	1.09199e-18
C147	a_284_368##13	a_27_88##3	6.46361e-17
C148	a_27_88##3	VGND#7	1.52416e-17
C149	a_284_368##9	C#2	1.29857e-18
C150	C#1	a_284_368##7	3.14024e-17
C151	a_284_368##13	A_N#2	4.39222e-20
C152	a_284_368##9	B#2	6.12186e-19
C153	VPWR#5	B#2	9.39525e-19
C154	a_27_88##7	A_N#2	2.71203e-17
C155	B#1	C#1	4.13982e-17
C156	VGND#3	B#3	6.13758e-18
C157	VGND#3	a_27_88#	6.12016e-18
C158	VGND	a_284_368##2	9.64013e-19
C159	VGND#2	C	7.10227e-19
C160	VGND#3	A_N#3	3.55614e-20
C161	a_27_88##4	B#1	2.69038e-17
C162	a_27_88##3	VPWR#7	1.16829e-17
C163	a_27_88##3	a_27_88##5	1.05709e-18
C164	VPWR#3	a_284_368##7	4.45323e-19
C165	B#2	C#3	4.73087e-18
C166	A_N#1	a_27_88##4	3.09953e-18
C167	A_N#2	a_27_88##5	2.72579e-17
C168	a_284_368#	a_284_368##6	2.06449e-17
C169	VPWR#3	B#1	2.62752e-18
C170	a_284_368#	a_284_368##7	7.81968e-19
C171	VPWR#3	a_27_88##4	3.15058e-18
C172	a_27_88##3	a_27_88#	4.05606e-19
C173	a_284_368#	C#1	1.53379e-19
C174	C#2	a_284_368##7	7.91084e-19
C175	VPWR#3	A_N#1	2.22442e-19
C176	A_N#2	a_27_88#	7.65668e-20
C177	a_284_368##3	VNB	2.16895e-17
C178	a_284_368##2	VNB	5.8313e-17
C179	a_27_88##2	VNB	3.05434e-17
C180	B#1	C#2	3.00747e-18
C181	a_284_368##11	B	2.59413e-17
C182	VGND#6	C	1.93007e-17
C183	C#3	a_454_74#	2.09248e-18
C184	B#3	a_454_74#	1.86562e-17
C185	VGND#2	X	1.54804e-17
C186	B	C#5	2.70765e-17
C187	B#3	a_376_74#	1.23956e-17
C188	a_27_88##3	a_27_88##4	7.53545e-18
C189	C	X#3	4.9212e-18
C190	a_27_88#	a_376_74#	1.52285e-18
C191	a_27_88##3	A_N#1	1.32496e-19
C192	C	a_284_368##9	1.03566e-17
C193	A_N#2	a_27_88##4	7.37886e-19
C194	a_27_88##7	A_N	1.75749e-17
C195	B	VGND#6	3.32423e-17
C196	VGND#3	B#2	1.66993e-19
C197	VPWR#3	a_27_88##3	4.63223e-20
C198	VPWR	VPWR#2	4.9308e-17
C199	a_284_368##13	B	5.51096e-17
C200	VPWR	a_284_368##11	1.47718e-17
C201	VGND#1	X	6.71126e-17
C202	B#2	C#2	2.99113e-17
C203	VGND#6	X	5.05357e-17
C204	A_N	a_27_88##5	1.92707e-17
C205	VPWR	C#5	2.04609e-18
C206	B	a_284_368##9	3.11308e-17
C207	VGND	VGND#2	3.01154e-17
C208	B	a_284_368##5	1.06243e-20
C209	C	a_284_368##7	1.86607e-18
C210	A_N#2	a_27_88##3	8.43668e-17
C211	B	a_284_368##4	2.37844e-20
C212	B	C#3	9.04716e-18
C213	VGND	C#5	2.7966e-18
C214	B	B#3	2.69042e-17
C215	B#2	a_454_74#	8.66223e-19
C216	B	a_27_88#	9.77385e-18
C217	VPWR	VPWR#1	3.91539e-17
C218	VPWR	X#3	4.11441e-18
C219	X	a_284_368##5	2.49928e-17
C220	VGND#2	VNB	3.76821e-17
C221	VGND	VGND#1	3.69357e-17
C222	X	a_284_368##4	2.26113e-17
C223	VPWR	a_284_368##9	2.37336e-17
C224	X	C#3	1.56466e-18
C225	VGND	VGND#6	2.19756e-17
C226	VPWR#2	VNB	3.76272e-17
C227	a_284_368##11	VNB	1.30728e-17
C228	VGND	a_284_368##13	1.94716e-17
C229	B	C#1	5.47149e-19
C230	VPWR	a_27_88##5	1.65858e-17
C231	VGND	a_27_88##7	1.43244e-17
C232	B	B#1	4.38533e-18
C233	C#5	VNB	2.92866e-18
C234	X	a_284_368##6	1.53751e-19
C235	B	a_27_88##4	1.64576e-18
C236	X	a_284_368##7	1.72126e-19
C237	C	C#2	6.57657e-18
C238	VGND#1	VNB	6.92548e-17
C239	VGND#6	VNB	3.24285e-18
C240	VGND	a_284_368##5	4.64128e-18
C241	VPWR	a_284_368##6	3.62787e-19
C242	VGND#3	B	1.46277e-17
C243	a_284_368##13	VNB	1.0388e-17
C244	VGND	a_284_368##4	4.46365e-18
C245	VGND#7	VNB	9.56886e-18
C246	VPWR	a_284_368##7	3.73191e-19
C247	a_27_88##7	VNB	3.91967e-17
C248	VGND	C#3	4.2606e-19
C249	VPWR	C#1	7.43629e-18
C250	VPWR#1	VNB	5.02144e-17
C251	VGND	B#3	3.07978e-19
C252	X#3	VNB	7.84263e-19
C253	B	C#2	4.62761e-18
C254	VPWR	B#1	7.37318e-18
C255	VGND	a_27_88#	5.77609e-18
C256	VPWR#4	VNB	2.48867e-18
C257	a_284_368##9	VNB	2.56874e-18
C258	VGND	A_N#3	4.17162e-18
C259	VPWR	a_27_88##4	7.31815e-18
C260	A_N	A_N#2	1.86946e-17
C261	B	B#2	1.97374e-17
C262	VPWR#5	VNB	7.74233e-18
C263	VPWR	A_N#1	1.47142e-18
C264	X	a_284_368#	3.85499e-17
C265	VPWR#7	VNB	7.48343e-18
C266	a_27_88##5	VNB	4.7652e-17
C267	X	C#2	1.5291e-18
C268	a_284_368##5	VNB	3.52004e-17
C269	VPWR	VPWR#3	5.3001e-17
C270	a_284_368##4	VNB	3.20864e-17
C271	X	B#2	4.64369e-19
C272	C#3	VNB	2.78219e-17
C273	B#3	VNB	2.61837e-17
C274	VPWR	a_284_368#	5.58616e-18
C275	a_27_88#	VNB	2.94321e-17
C276	B	a_454_74#	3.38292e-18
C277	A_N#3	VNB	4.3745e-17
C278	a_284_368##6	VNB	3.32277e-17
C279	a_284_368##7	VNB	3.30725e-17
C280	VGND	VGND#3	2.6155e-17
C281	VPWR	a_27_88##3	1.08038e-17
C282	C#1	VNB	3.17236e-17
C283	VGND	a_284_368#	2.77417e-18
C284	B#1	VNB	3.63926e-17
C285	VPWR	A_N#2	1.99442e-18
C286	a_27_88##4	VNB	4.30271e-17
C287	VGND	C#2	9.57113e-21
C288	A_N#1	VNB	4.24518e-17
C289	VGND	a_27_88##3	1.11021e-17
C290	VPWR#3	VNB	2.25059e-16
C291	VGND#3	VNB	2.19254e-16
C292	VGND	A_N#2	1.84091e-18
C293	a_284_368#	VNB	4.73579e-17
C294	C#2	VNB	3.70362e-17
C295	C	X	4.01182e-17
C296	B#2	VNB	3.00986e-17
C297	a_27_88##3	VNB	1.08163e-16
C298	A_N#2	VNB	9.5193e-17
C299	VPWR	C	2.72933e-18
C300	B	X	2.67105e-18
C301	VPWR	A_N	2.06052e-18
C302	VGND	C	2.78449e-18
C303	VPWR	B	3.73799e-18
C304	VGND	A_N	1.85272e-18
C305	VGND	B	1.74059e-17
C306	C	VNB	5.09345e-18
C307	A_N	VNB	2.87107e-17
C308	VGND	X	1.70763e-17
C309	B	VNB	2.80386e-18
C310	X	VNB	8.63351e-18
C311	VPWR	VNB	6.79755e-17
C312	VGND	VNB	7.5914e-17
C313	VGND#4	a_27_88##3	6.91677e-18
C314	VGND#4	VNB	6.13035e-17
C315	VPWR#6	A_N#2	8.70058e-20
C316	VGND#4	B#3	1.01227e-19
C317	VPWR#6	A_N#1	5.58603e-18
C318	VPWR	VPWR#6	5.99363e-17
C319	VGND#4	A_N#3	8.33854e-19
C320	a_27_88##3	VPWR#6	3.93602e-18
C321	VGND#4	a_284_368##13	4.79588e-18
C322	VGND	VGND#4	6.37624e-17
C323	VGND#4	C#3	7.93119e-20
C324	VGND#3	VGND#4	6.31842e-17
C325	VGND#4	a_27_88##2	8.13415e-21
C326	VGND#4	A_N#2	1.67506e-19
C327	VGND#4	a_27_88##7	1.45892e-17
C328	VGND#4	a_27_88#	1.10158e-18
C329	VPWR#6	VPWR#5	1.1875e-18
C330	VPWR#3	VPWR#6	6.05617e-17
C331	VPWR#6	VNB	5.92714e-17
C332	a_27_88##5	VPWR#6	1.94921e-17
*
*
.ENDS sky130_fd_sc_hs__and3b_2
*
