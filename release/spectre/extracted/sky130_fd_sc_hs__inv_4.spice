* Extracted by Quantus, converted by sky130cad/quantus.py
*
*
*
*                       LINUX           Wed Nov 18 08:41:59 2026
*
*
*
*  PROGRAM  advgen
*
*  Name           : advgen - Quantus - (64-bit)
*  Version        : 25.1.0-p047
*  Build Date     : Thu Dec 11 23:20:30 PST 2025
*
*  HSPICE LIBRARY
*
*  OPERATING_TEMPERATURE 150
*  QRC_TECH_DIR <path>/tech
*
*
*

*
.SUBCKT sky130_fd_sc_hs__inv_4 VPB VNB VGND VPWR Y A
*
*
*  caps2d version: 10
*
*
*       TRANSISTOR CARDS
*
*
XM3 VGND#3 A#10 Y#5 VNB sky130_fd_pr__nfet_01v8_lvt l=0.15 w=0.74 ad=0.2331 as=0.2368 pd=2.11 ps=2.12
XM4 Y#5 A#8 VGND#4 VNB sky130_fd_pr__nfet_01v8_lvt l=0.15 w=0.74 ad=0.2368 as=0.2442 pd=2.12 ps=2.14
XM7 Y#1 A#6 VGND#4 VNB sky130_fd_pr__nfet_01v8_lvt l=0.15 w=0.74 ad=0.2072 as=0.2442 pd=2.04 ps=2.14
XM0 VGND#1 A#1 Y#1 VNB sky130_fd_pr__nfet_01v8_lvt l=0.15 w=0.74 ad=0.2109 as=0.2072 pd=2.05 ps=2.04
XM1 VPWR#4 A#12 Y#4 VPB sky130_fd_pr__pfet_01v8 l=0.15 w=1.12 ad=0.3304 as=0.336 pd=2.83 ps=2.84
XM5 Y#4 A#11 VPWR#3 VPB sky130_fd_pr__pfet_01v8 l=0.15 w=1.12 ad=0.336 as=0.336 pd=2.84 ps=2.84
XM6 Y#6 A#7 VPWR#3 VPB sky130_fd_pr__pfet_01v8 l=0.15 w=1.12 ad=0.336 as=0.336 pd=2.84 ps=2.84
XM2 VPWR#1 A#5 Y#6 VPB sky130_fd_pr__pfet_01v8 l=0.15 w=1.12 ad=0.3304 as=0.336 pd=2.83 ps=2.84
*
*
*       RESISTOR AND CAP/DIODE CARDS
*
Rg1	A#1	A#2	397.555725
Rg2	A#2	A#3	66.369736
Rg3	A#3	A#4	57.428749
Rg4	A#2	A#5	449.655212
Rg5	A#3	A#6	395.494293
Rg6	A#3	A#7	448.603302
Rg7	A#4	A#8	378.670319
Rg8	A#4	A#9	90.033310
Rg9	A#9	A#10	397.555725
Rg10	A#4	A#11	429.126801
Rg11	A#9	A#12	449.655212
Rf1	A	A#13	2.292021
Rf2	A#13	A	12.376911
Rf3	Y#1	Y#2	28.306047
Rf4	Y#2	Y	40.367004
Rf5	Y	Y#3	71.698235
Rf6	Y#3	Y#4	81.107391
Rf7	Y#2	Y#5	89.810654
Rf8	Y#3	Y#6	18.602406
Rf9	VGND#1	VGND#2	99.926414
Rf10	VGND#2	VGND#3	99.545227
Rf11	VGND#2	VGND#4	38.595905
Rf12	VPWR#1	VPWR#2	107.912292
Rf13	VPWR#2	VPWR#3	58.891026
Rf14	VPWR#2	VPWR#4	112.886047
Rf15	A#4	A#13	40.058201
Re1	VPWR#2	VPWR	1.964508
Re2	VGND	VGND#2	1.964582
*
*       CAPACITOR CARDS
*
*
C1	VGND	VNB	4.88082e-17
C2	VPWR	VNB	5.40079e-17
C3	Y	VNB	3.86602e-17
C4	A	VNB	4.26885e-17
C5	VGND	Y	3.94768e-18
C6	A#4	VNB	5.78833e-17
C7	VGND#2	VNB	1.59168e-16
C8	VGND	A	1.06617e-17
C9	VPWR#2	VNB	1.5931e-16
C10	A#12	VNB	4.03614e-17
C11	VPWR	A	9.57787e-18
C12	A#11	VNB	3.45838e-17
C13	VGND	VGND#2	4.89123e-17
C14	A#7	VNB	3.20736e-17
C15	A#5	VNB	4.45233e-17
C16	A	Y	2.71379e-17
C17	A#10	VNB	3.62823e-17
C18	A#8	VNB	2.53633e-17
C19	A#6	VNB	2.64922e-17
C20	VPWR	VPWR#2	3.84052e-17
C21	A#1	VNB	3.02842e-17
C22	Y	A#4	4.81567e-19
C23	VPWR#4	VNB	7.35298e-17
C24	Y#4	VNB	2.19739e-18
C25	VPWR#3	VNB	2.92383e-18
C26	VPWR	A#12	2.54915e-18
C27	A	A#4	3.65021e-17
C28	Y#6	VNB	4.04095e-18
C29	VPWR#1	VNB	6.01691e-17
C30	VGND	A#10	4.23691e-19
C31	VGND#3	VNB	7.39935e-17
C32	VPWR	A#11	2.43008e-19
C33	Y#5	VNB	5.49754e-18
C34	VGND	A#8	6.67323e-19
C35	VGND#2	A	7.42146e-21
C36	VGND#4	VNB	5.50335e-19
C37	VPWR	A#7	8.16063e-19
C38	VGND	A#6	1.26882e-18
C39	Y#1	VNB	4.75786e-18
C40	VGND	A#1	7.69741e-19
C41	VPWR	A#5	1.9099e-18
C42	VGND#1	VNB	5.26179e-17
C43	A	VPWR#2	4.27409e-20
C44	Y#2	VNB	1.32722e-18
C45	Y#3	VNB	2.06201e-17
C46	A	A#12	5.94907e-18
C47	VGND#2	A#4	6.75926e-20
C48	VGND	VGND#3	4.15716e-17
C49	A	A#11	2.04678e-18
C50	VPWR#2	A#4	4.06694e-20
C51	VGND	Y#5	1.45225e-17
C52	VPWR	VPWR#4	3.46164e-17
C53	A	A#7	2.04678e-18
C54	VGND	Y#1	1.09498e-17
C55	VPWR	Y#4	1.74485e-17
C56	VGND	VGND#1	3.95003e-17
C57	A	A#5	1.74732e-18
C58	VGND	Y#2	2.92938e-18
C59	VPWR	Y#6	1.58676e-17
C60	Y	A#1	6.52017e-18
C61	VPWR	VPWR#1	3.40989e-17
C62	VPWR#2	A#12	2.55989e-18
C63	A	VPWR#4	3.44699e-17
C64	VPWR#2	A#11	7.3428e-18
C65	A	Y#4	5.24979e-17
C66	VPWR	Y#3	5.89208e-18
C67	VPWR#2	A#7	5.10124e-18
C68	Y	VGND#1	3.07584e-17
C69	VPWR#2	A#5	2.14403e-18
C70	VGND#2	A#10	6.86709e-19
C71	A#12	A#11	4.57353e-17
C72	VGND#3	A	2.87137e-17
C73	VGND#2	A#8	4.35849e-18
C74	Y#5	A	5.31274e-17
C75	Y	Y#3	1.85889e-19
C76	VGND#2	A#6	4.60875e-18
C77	A#4	Y#4	1.44966e-18
C78	VGND#2	A#1	6.14854e-19
C79	A#11	A#7	4.75287e-17
C80	A#4	VPWR#3	1.24432e-18
C81	A#4	Y#6	2.74109e-19
C82	Y#2	A	5.74019e-17
C83	A	Y#3	6.26217e-17
C84	VPWR#2	VPWR#4	2.78308e-17
C85	A#7	A#5	4.56992e-17
C86	Y#5	A#4	2.75132e-18
C87	Y#4	VPWR#2	1.71122e-17
C88	VGND#4	A#4	1.31713e-18
C89	VGND#2	VGND#3	2.96388e-17
C90	Y#6	VPWR#2	1.66935e-17
C91	VGND#2	Y#5	1.47411e-17
C92	VPWR#2	VPWR#1	2.68879e-17
C93	A#12	VPWR#4	3.34451e-17
C94	Y#2	A#4	4.1919e-18
C95	VGND#2	Y#1	1.04974e-17
C96	A#2	VNB	3.5695e-17
C97	Y#4	A#12	5.42965e-17
C98	Y#3	A#4	3.08473e-18
C99	A#9	VNB	3.90616e-17
C100	VGND#2	VGND#1	2.76646e-17
C101	VPWR#4	A#11	1.23306e-18
C102	VPWR#3	A#12	6.79311e-19
C103	Y#4	A#11	7.01254e-17
C104	VGND#2	Y#2	6.23298e-19
C105	VPWR#4	A#7	2.59902e-19
C106	A#11	VPWR#3	2.84583e-17
C107	A#10	A#8	3.41e-17
C108	Y#4	A#7	1.77076e-18
C109	Y#6	A#11	1.94132e-18
C110	A#7	VPWR#3	2.47104e-17
C111	VPWR#1	A#11	2.59902e-19
C112	Y#3	VPWR#2	3.13618e-19
C113	Y#6	A#7	4.60882e-17
C114	A#8	A#6	2.76917e-17
C115	VPWR#3	A#5	6.79311e-19
C116	VPWR#1	A#7	1.23306e-18
C117	Y#6	A#5	4.7814e-17
C118	A#5	VPWR#1	2.86965e-17
C119	A#6	A#1	4.09717e-17
C120	Y#3	A#12	2.30059e-19
C121	Y#3	A#11	4.04872e-19
C122	VGND#3	A#10	2.95975e-17
C123	A#10	Y#5	2.7973e-17
C124	Y#3	A#7	1.80473e-17
C125	VPWR#4	Y#4	7.74409e-17
C126	VGND#3	A#8	2.41832e-18
C127	Y#2	A#2	2.01717e-18
C128	VGND#4	A#10	1.68177e-18
C129	VPWR#4	VPWR#3	1.94092e-18
C130	Y#5	A#8	2.64519e-17
C131	Y#1	A#10	2.90403e-19
C132	Y#3	A#5	3.02419e-17
C133	VGND#4	A#8	3.29067e-17
C134	Y#4	VPWR#3	5.2514e-17
C135	Y#5	A#6	3.98946e-19
C136	Y#1	A#8	1.17376e-18
C137	Y#4	Y#6	2.36849e-18
C138	A#6	VGND#4	1.77536e-17
C139	VGND#1	A#8	3.10457e-19
C140	Y#5	A#1	1.77288e-19
C141	Y#2	A#10	9.30048e-20
C142	A#6	Y#1	1.78495e-17
C143	VPWR#3	Y#6	5.21059e-17
C144	VGND#4	A#1	3.39141e-18
C145	VGND#1	A#6	2.4417e-18
C146	VPWR#3	VPWR#1	1.94092e-18
C147	Y#2	A#8	1.72606e-19
C148	A#1	Y#1	1.52965e-17
C149	VGND#1	A#1	3.11275e-17
C150	Y#6	VPWR#1	5.29637e-17
C151	Y#3	A#2	1.88108e-18
C152	Y#2	A#6	2.28531e-17
C153	Y#2	A#1	1.43449e-17
C154	Y	A#2	1.78532e-17
C155	Y	A#9	1.63379e-19
C156	Y#3	VPWR#4	3.73288e-21
C157	VGND#3	Y#5	7.00829e-17
C158	Y#4	Y#3	6.21728e-19
C159	VGND#3	VGND#4	2.5909e-18
C160	VGND#1	VPWR#1	9.19337e-20
C161	Y#5	VGND#4	4.94873e-17
C162	Y#3	VPWR#3	1.74399e-17
C163	Y#5	Y#1	1.57858e-18
C164	A	A#2	9.72496e-18
C165	Y#3	Y#6	1.19687e-18
C166	A	A#9	2.28498e-17
C167	VGND#4	Y#1	3.34994e-17
C168	Y#3	VPWR#1	3.12606e-17
C169	VGND#4	VGND#1	2.67683e-18
C170	Y#5	Y#2	5.05559e-19
C171	Y#1	VGND#1	4.16102e-17
C172	Y#2	VGND#4	2.15763e-17
C173	Y#2	Y#1	1.76953e-18
C174	VGND#1	Y#2	3.09676e-18
C175	A#4	A#2	4.03955e-18
C176	Y#2	Y#3	3.25095e-18
C177	A#9	A#4	3.65119e-18
C178	A#9	Y#4	1.46925e-18
C179	VGND#2	A#2	4.65437e-20
C180	VGND#2	A#9	4.76064e-20
C181	A#2	Y#6	2.70455e-19
C182	VPWR#2	A#2	2.01982e-20
C183	VPWR#2	A#9	2.04712e-20
C184	Y#5	A#9	1.98655e-18
*
*
.ENDS sky130_fd_sc_hs__inv_4
*
