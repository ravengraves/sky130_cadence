* Extracted by Quantus, converted by sky130cad/quantus.py
*
*
*
*                       LINUX           Wed Nov 18 09:07:18 2026
*
*
*
*  PROGRAM  advgen
*
*  Name           : advgen - Quantus - (64-bit)
*  Version        : 25.1.0-p047
*  Build Date     : Thu Dec 11 23:20:30 PST 2025
*
*  HSPICE LIBRARY
*
*  OPERATING_TEMPERATURE 150
*  QRC_TECH_DIR <path>/tech
*
*
*

*
.SUBCKT sky130_fd_sc_hs__or4_2 VNB VPB VGND VPWR X C D B A
*
*
*  caps2d version: 10
*
*
*       TRANSISTOR CARDS
*
*
XM7 VGND#5 D#3 a_85_392##12 VNB sky130_fd_pr__nfet_01v8_lvt l=0.15 w=0.64 ad=0.284075 as=0.1792 pd=2.19 ps=1.84
XM2 a_85_392##12 C#3 VGND#7 VNB sky130_fd_pr__nfet_01v8_lvt l=0.15 w=0.64 ad=0.1792 as=0.3886 pd=1.84 ps=2.51
XM9 VGND#7 B#1 a_85_392##11 VNB sky130_fd_pr__nfet_01v8_lvt l=0.15 w=0.64 ad=0.3886 as=0.1792 pd=2.51 ps=1.84
XM11 a_85_392##11 A#1 VGND#6 VNB sky130_fd_pr__nfet_01v8_lvt l=0.15 w=0.64 ad=0.1792 as=0.361 pd=1.84 ps=2.53
XM3 VGND#6 a_85_392##6 X#1 VNB sky130_fd_pr__nfet_01v8_lvt l=0.15 w=0.74 ad=0.361 as=0.2072 pd=2.53 ps=2.04
XM6 X#1 a_85_392# VGND#1 VNB sky130_fd_pr__nfet_01v8_lvt l=0.15 w=0.74 ad=0.2072 as=0.2109 pd=2.04 ps=2.05
XM4 a_85_392##10 D#1 a_174_392# VPB sky130_fd_pr__pfet_01v8 l=0.15 w=1 ad=0.295 as=0.27 pd=2.59 ps=2.54
XM5 a_174_392# C#1 a_258_392# VPB sky130_fd_pr__pfet_01v8 l=0.15 w=1 ad=0.27 as=0.27 pd=2.54 ps=2.54
XM0 a_258_392# B#3 a_342_392# VPB sky130_fd_pr__pfet_01v8 l=0.15 w=1 ad=0.27 as=0.43 pd=2.54 ps=2.86
XM10 a_342_392# A#3 VPWR#4 VPB sky130_fd_pr__pfet_01v8 l=0.15 w=1 ad=0.43 as=0.4764 pd=2.86 ps=3.11
XM1 X#2 a_85_392##4 VPWR#4 VPB sky130_fd_pr__pfet_01v8 l=0.15 w=1.12 ad=0.336 as=0.4764 pd=2.84 ps=3.11
XM8 VPWR#1 a_85_392##5 X#2 VPB sky130_fd_pr__pfet_01v8 l=0.15 w=1.12 ad=0.3864 as=0.336 pd=2.93 ps=2.84
*
*
*       RESISTOR AND CAP/DIODE CARDS
*
Rg1	D#1	D#2	428.875610
Rg2	D#2	D#3	473.981903
Rg3	C#1	C#2	532.613342
Rg4	C#2	C#3	303.924591
Rg5	B#1	B#2	438.086243
Rg6	B#2	B#3	470.241455
Rg7	A#1	A#2	411.232849
Rg8	A#2	A#3	453.277618
Rg9	a_85_392#	a_85_392##2	444.832245
Rg10	a_85_392##2	a_85_392##3	50.809727
Rg11	a_85_392##3	a_85_392##4	456.150757
Rg12	a_85_392##2	a_85_392##5	449.292908
Rg13	a_85_392##3	a_85_392##6	353.150574
Rf1	D#4	D	1.462815
Rf2	D#2	D#6	161.695618
Rf3	D#4	D#6	9.917418
Rf4	C	C#2	173.420837
Rf5	B	B#2	166.137894
Rf6	A#4	A#2	162.219223
Rf7	A	A#6	1.986418
Rf8	A#4	A#6	4.798750
Rf9	a_85_392##3	a_85_392##8	226.427246
Rf10	a_85_392##8	a_85_392##9	77.463295
Rf11	a_85_392##9	a_85_392##10	166.742737
Rf12	a_85_392##8	a_85_392##11	16.144831
Rf13	a_85_392##9	a_85_392##12	13.032116
Rf14	X#1	X	63.421364
Rf15	X	X#2	67.540680
Rf16	VGND#1	VGND#2	103.740898
Rf17	VGND#2	VGND#3	47.967400
Rf18	VGND#3	VGND#4	34.999290
Rf19	VGND#4	VGND#5	106.888191
Rf20	VGND#2	VGND#6	31.940144
Rf21	VGND#4	VGND#7	26.145979
Rf22	VPWR#1	VPWR#2	105.431503
Rf23	VPWR#2	VPWR#3	44.171017
Rf24	VPWR#2	VPWR#4	35.727165
Re1	VPWR#3	VPWR	1.227783
Re2	VGND	VGND#3	1.227829
*
*       CAPACITOR CARDS
*
*
C1	VGND#4	VGND#2	2.04223e-19
C2	VGND#4	a_85_392##9	1.53639e-17
C3	VGND#4	a_85_392##8	8.60081e-20
C4	VGND#2	a_85_392##8	1.39251e-18
C5	a_85_392##9	a_85_392##8	3.78938e-18
C6	a_85_392##8	A#4	4.28485e-17
C7	VGND#2	VGND#1	1.58142e-18
C8	VGND#2	X#1	1.36893e-17
C9	a_85_392##8	X#1	4.86002e-18
C10	a_85_392##8	VGND#6	5.54949e-17
C11	VGND#7	VGND#2	1.48232e-18
C12	a_85_392##8	a_85_392##11	4.05145e-19
C13	a_85_392##9	VGND#7	5.52379e-17
C14	VGND#5	VGND#4	1.99772e-19
C15	a_85_392##8	VGND#7	5.73093e-17
C16	VPWR#2	VPWR#1	9.53351e-19
C17	a_85_392##9	a_85_392##12	4.609e-18
C18	X#2	VPWR#2	1.4945e-17
C19	a_85_392##9	VGND#5	7.42832e-17
C20	a_85_392##8	VPWR#4	1.44324e-19
C21	VGND#1	X#1	3.77878e-17
C22	VGND#6	VGND#1	1.52734e-18
C23	VGND#6	X#1	4.92371e-17
C24	a_85_392##9	a_85_392##10	1.99186e-18
C25	VGND#2	a_85_392#	9.20492e-19
C26	VGND#7	VGND#6	1.39628e-18
C27	VGND#2	a_85_392##6	7.85166e-18
C28	VGND#2	A#1	4.30915e-18
C29	a_85_392##8	a_85_392##6	1.35545e-18
C30	VGND#4	B#1	2.66541e-19
C31	X#1	X#2	6.70825e-18
C32	VGND#2	B#1	9.07312e-19
C33	a_85_392##8	A#1	3.97489e-17
C34	VGND#5	VGND#7	2.80909e-18
C35	VGND#4	C#3	2.99239e-18
C36	a_85_392##9	B#1	9.89435e-19
C37	VGND#2	C#3	1.40083e-19
C38	a_85_392##8	B#1	4.02926e-17
C39	a_85_392##9	C#3	4.10186e-17
C40	a_85_392##8	C#3	9.81031e-19
C41	a_85_392##9	D#3	4.0778e-17
C42	a_85_392##8	D#3	5.21198e-19
C43	X#2	VPWR#1	7.69042e-17
C44	VGND#1	a_85_392#	3.03565e-17
C45	VPWR#2	a_85_392##4	4.63558e-18
C46	X#1	a_85_392#	2.61894e-17
C47	VPWR#4	VPWR#1	1.69573e-18
C48	VGND#1	a_85_392##6	2.37575e-18
C49	VPWR#2	A#3	5.32574e-18
C50	VGND#6	a_85_392#	4.37361e-19
C51	VPWR#4	X#2	9.13085e-17
C52	X#1	a_85_392##6	4.03041e-17
C53	VGND#1	A#1	3.09764e-19
C54	a_85_392##6	VGND#6	2.03332e-17
C55	X#1	A#1	1.6992e-18
C56	A#1	VGND#6	2.26778e-17
C57	VGND#7	a_85_392##6	2.78241e-19
C58	A#1	a_85_392##11	1.2912e-17
C59	VGND#6	B#1	4.22116e-19
C60	VGND#7	A#1	7.76718e-19
C61	B#1	a_85_392##11	1.2912e-17
C62	VGND#6	C#3	1.01114e-19
C63	B#1	VGND#7	2.44237e-17
C64	a_85_392##10	VPWR#4	1.62316e-18
C65	VGND#4	D#1	7.99194e-20
C66	C#3	VGND#7	2.6675e-17
C67	a_85_392##9	D#1	2.69291e-18
C68	VGND#5	B#1	2.28452e-19
C69	C#3	a_85_392##12	1.29377e-17
C70	VGND#7	D#3	1.48374e-18
C71	VPWR#3	VPWR#2	3.90806e-17
C72	VGND#5	C#3	1.4125e-18
C73	D#3	a_85_392##12	1.33759e-17
C74	D#3	VGND#5	2.13725e-17
C75	VGND#3	VGND#4	4.24621e-17
C76	VGND#3	VGND#2	4.47269e-17
C77	a_85_392##3	VPWR#2	3.53783e-19
C78	VGND#3	a_85_392##8	1.59037e-17
C79	a_85_392##6	a_85_392#	3.8127e-17
C80	a_85_392##5	VPWR#1	3.12703e-17
C81	VGND#2	a_85_392##3	5.35216e-19
C82	X#2	a_85_392##5	5.91866e-17
C83	VPWR#1	a_85_392##4	1.34947e-18
C84	A#1	a_85_392##6	1.47843e-17
C85	VPWR#4	a_85_392##5	1.48454e-18
C86	X#2	a_85_392##4	5.83702e-17
C87	VPWR#1	A#3	2.81611e-19
C88	a_85_392##4	VPWR#4	3.05913e-17
C89	a_85_392##8	A#2	7.23997e-18
C90	X#2	A#3	2.22296e-18
C91	B#1	A#1	3.77772e-17
C92	A#4	a_85_392##3	2.62035e-17
C93	A#3	VPWR#4	4.0241e-17
C94	X#2	B#3	4.12715e-19
C95	a_85_392##8	B#2	7.5836e-18
C96	VPWR#4	B#3	5.67322e-18
C97	A#4	A#2	1.13091e-17
C98	C#3	B#1	1.10262e-17
C99	VGND#3	VGND#1	2.64586e-17
C100	a_85_392##9	C#2	3.71473e-17
C101	a_85_392##10	a_85_392##4	1.66355e-19
C102	VPWR#4	C#1	6.80796e-19
C103	C#2	a_85_392##8	2.82099e-18
C104	A#4	B#2	3.60628e-18
C105	a_85_392##10	A#3	2.60501e-19
C106	D#3	C#3	3.38213e-17
C107	VPWR#4	D#1	4.69931e-19
C108	a_85_392##3	X#1	3.72032e-17
C109	a_85_392##9	D#2	1.36567e-18
C110	a_85_392##10	B#3	4.11779e-19
C111	a_85_392##3	VGND#6	2.90949e-17
C112	VPWR#3	VPWR#1	3.10026e-17
C113	a_85_392##10	C#1	7.53406e-18
C114	VGND#3	VGND#5	3.33106e-17
C115	VGND#6	A#2	8.74134e-19
C116	a_85_392##10	D#1	5.74156e-17
C117	VPWR#1	a_85_392##3	5.81567e-19
C118	a_85_392##8	a_342_392#	1.93271e-19
C119	a_85_392##3	X#2	3.13463e-17
C120	VGND#7	B#2	1.15537e-18
C121	a_85_392##3	VPWR#4	1.0066e-17
C122	a_85_392##10	VPWR#3	2.59235e-17
C123	a_85_392##4	a_85_392##5	4.68257e-17
C124	C#2	VGND#7	3.17078e-18
C125	A#2	VPWR#4	3.44578e-18
C126	X#2	B#2	2.99061e-19
C127	A#3	a_85_392##4	2.86627e-17
C128	a_85_392##9	a_174_392#	2.84165e-19
C129	a_85_392##3	a_85_392#	2.09037e-19
C130	VGND#3	A#1	1.65165e-18
C131	VGND#5	D#2	6.09267e-19
C132	B#3	A#3	2.74726e-17
C133	a_85_392##3	a_85_392##6	3.50762e-18
C134	VGND#3	B#1	2.72548e-18
C135	A#2	a_85_392##6	4.57136e-19
C136	C#1	B#3	5.35864e-17
C137	A	VPWR#2	3.32747e-19
C138	D#1	C#1	6.24603e-17
C139	VPWR#3	A#3	3.44779e-18
C140	a_85_392##10	D#2	6.44779e-17
C141	VPWR#3	B#3	6.13103e-18
C142	C#2	B#1	4.1171e-18
C143	VPWR#3	C#1	6.13773e-18
C144	a_85_392##8	B	2.48579e-17
C145	A#2	a_85_392##4	2.80763e-18
C146	VPWR#3	D#1	8.24723e-18
C147	D#3	C#2	1.24991e-17
C148	B	A#4	2.07623e-17
C149	VGND#3	D#1	1.47274e-20
C150	a_85_392##9	D	5.86998e-17
C151	C#1	B#2	4.91108e-18
C152	A	VPWR#4	2.02404e-17
C153	D#1	C#2	5.77013e-19
C154	D#2	C#1	5.86213e-19
C155	VPWR#3	B#2	2.66541e-19
C156	D#2	D#1	1.14783e-17
C157	A#2	a_85_392##3	3.02339e-17
C158	B	X#2	4.5588e-18
C159	A#3	a_342_392#	2.19109e-18
C160	VPWR#3	C#2	6.96958e-19
C161	B	VPWR#4	3.43235e-17
C162	B#3	a_342_392#	2.56095e-17
C163	a_85_392##3	B#2	9.26358e-20
C164	D#2	VPWR#3	5.57831e-19
C165	B#2	A#2	3.47088e-17
C166	C#2	a_85_392##3	1.37304e-18
C167	B#3	a_258_392#	1.99226e-17
C168	C#1	a_258_392#	1.98877e-17
C169	C#2	A#2	9.60279e-20
C170	VPWR	VPWR#2	2.67533e-17
C171	C#2	B#2	3.47374e-17
C172	X	VGND#1	2.99601e-17
C173	C#1	a_174_392#	1.86988e-17
C174	a_85_392##10	D	2.26468e-18
C175	X#1	X	1.9961e-18
C176	A	a_85_392##5	3.00598e-19
C177	D#1	a_174_392#	1.88096e-18
C178	A	a_85_392##4	1.71744e-18
C179	D#2	C#2	3.47843e-17
C180	a_85_392##10	C	5.92799e-17
C181	X	VPWR#1	3.68226e-17
C182	VGND	VGND#4	1.87912e-17
C183	B	a_85_392##4	3.00206e-18
C184	VGND	VGND#2	5.4134e-17
C185	D	D#3	4.90477e-18
C186	VGND	a_85_392##9	2.29722e-17
C187	B	A#3	1.47745e-17
C188	VGND	a_85_392##8	1.96825e-17
C189	B	B#3	3.58644e-17
C190	B	C#1	7.83236e-18
C191	VGND	A#4	3.64207e-18
C192	A	VPWR#3	7.58749e-19
C193	X	a_85_392#	8.50661e-18
C194	VPWR	VPWR#1	4.14488e-17
C195	VPWR	X#2	1.64866e-17
C196	X	a_85_392##6	1.83743e-19
C197	VPWR	VPWR#4	2.04505e-17
C198	VGND	VGND#1	3.91215e-17
C199	A	a_85_392##3	6.45578e-18
C200	B	VPWR#3	1.40763e-17
C201	VGND	X#1	1.43916e-17
C202	A	A#2	1.06745e-17
C203	VPWR	a_85_392##10	2.15281e-17
C204	VGND	VGND#7	3.02188e-17
C205	C	B#3	8.21307e-18
C206	A	B#2	2.90978e-18
C207	VGND	VGND#5	4.24533e-17
C208	C	C#1	3.18206e-17
C209	X	a_85_392##5	1.56235e-17
C210	B	A#2	2.63668e-18
C211	VGND	X#2	2.70895e-18
C212	X	a_85_392##4	7.02934e-19
C213	C	D#1	1.86189e-17
C214	B	B#2	1.8906e-17
C215	C	VPWR#3	1.40935e-17
C216	C#2	B	2.17267e-17
C217	VGND	a_85_392##10	7.57994e-19
C218	VPWR	a_85_392##5	1.88552e-19
C219	VGND	a_85_392#	2.03529e-18
C220	VGND	a_85_392##6	1.30359e-18
C221	VPWR	a_85_392##4	3.19578e-18
C222	VGND	A#1	2.09829e-19
C223	D	C#2	2.68581e-17
C224	VPWR	A#3	2.78477e-18
C225	VGND	B#1	1.6257e-19
C226	VPWR	B#3	2.73717e-19
C227	VPWR#2	VNB	2.9949e-17
C228	VGND	C#3	3.77669e-19
C229	D	D#2	5.05204e-18
C230	VGND#4	VNB	3.07946e-17
C231	C	B#2	2.02692e-18
C232	B	a_342_392#	1.30482e-18
C233	VPWR	C#1	6.42993e-19
C234	VGND#2	VNB	3.61532e-17
C235	VGND	D#3	1.97829e-19
C236	a_85_392##9	VNB	3.67254e-17
C237	a_85_392##8	VNB	8.57894e-18
C238	VPWR	D#1	4.2131e-18
C239	a_85_392##3	X	3.13295e-17
C240	C	C#2	4.12317e-18
C241	B	a_258_392#	5.60327e-18
C242	X	A#2	3.71399e-19
C243	A#4	VNB	6.99758e-19
C244	D#2	C	2.56646e-17
C245	VPWR	VPWR#3	6.21097e-17
C246	VGND#1	VNB	5.3391e-17
C247	VPWR	a_85_392##3	3.46334e-18
C248	X#1	VNB	2.43639e-18
C249	VGND#6	VNB	2.26504e-18
C250	VGND#7	VNB	6.31945e-18
C251	C	a_258_392#	6.70769e-18
C252	VPWR	B#2	8.38142e-19
C253	B	A	2.45362e-17
C254	VGND#5	VNB	5.35268e-17
C255	VPWR#1	VNB	7.08927e-17
C256	VPWR	C#2	5.15354e-19
C257	X#2	VNB	4.97288e-18
C258	VGND	VGND#3	8.87434e-18
C259	VPWR#4	VNB	5.22808e-18
C260	VGND	a_85_392##3	6.80947e-18
C261	VPWR	D#2	4.57818e-18
C262	a_85_392##10	VNB	7.87729e-17
C263	a_85_392#	VNB	3.14336e-17
C264	a_85_392##6	VNB	2.91802e-17
C265	A#1	VNB	2.97981e-17
C266	VGND	C#2	4.47548e-18
C267	B#1	VNB	2.81314e-17
C268	C#3	VNB	2.53076e-17
C269	C	B	9.87017e-17
C270	D#3	VNB	4.66306e-17
C271	A	X	3.77242e-18
C272	a_85_392##5	VNB	4.17964e-17
C273	a_85_392##4	VNB	3.64342e-17
C274	A#3	VNB	4.24186e-17
C275	B#3	VNB	3.29443e-17
C276	C#1	VNB	3.66155e-17
C277	VPWR	A	5.79897e-18
C278	D#1	VNB	6.14457e-17
C279	VPWR	B	1.59877e-17
C280	VPWR#3	VNB	2.48251e-16
C281	VGND#3	VNB	1.81406e-16
C282	a_85_392##3	VNB	6.74057e-17
C283	A#2	VNB	3.32929e-17
C284	B#2	VNB	3.12091e-17
C285	VGND	B	3.97634e-18
C286	VPWR	C	1.59821e-17
C287	C#2	VNB	3.75953e-17
C288	D#2	VNB	3.78036e-17
C289	VGND	D	3.92204e-18
C290	VPWR	X	2.40568e-18
C291	VGND	X	4.72723e-18
C292	A	VNB	1.88532e-18
C293	B	VNB	3.52322e-18
C294	D	VNB	3.95876e-18
C295	C	VNB	1.18567e-18
C296	X	VNB	5.30063e-17
C297	VPWR	VNB	7.53934e-17
C298	VGND	VNB	5.47593e-17
*
*
.ENDS sky130_fd_sc_hs__or4_2
*
