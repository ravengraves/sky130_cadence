* Extracted by Quantus, converted by sky130cad/quantus.py
*
*
*
*                       LINUX           Wed Nov 18 08:02:02 2026
*
*
*
*  PROGRAM  advgen
*
*  Name           : advgen - Quantus - (64-bit)
*  Version        : 25.1.0-p047
*  Build Date     : Thu Dec 11 23:20:30 PST 2025
*
*  HSPICE LIBRARY
*
*  OPERATING_TEMPERATURE 150
*  QRC_TECH_DIR <path>/tech
*
*
*

*
.SUBCKT sky130_fd_sc_hs__a2111o_1 VPB VNB VGND VPWR X A1 B1 C1 A2 D1
*
*
*  caps2d version: 10
*
*
*       TRANSISTOR CARDS
*
*
XM6 a_85_136##9 A1#2 a_168_136# VNB sky130_fd_pr__nfet_01v8_lvt l=0.15 w=0.64 ad=0.1696 as=0.1344 pd=1.81 ps=1.7
XM10 a_168_136# A2#3 VGND#9 VNB sky130_fd_pr__nfet_01v8_lvt l=0.15 w=0.64 ad=0.1344 as=0.2496 pd=1.7 ps=2.06
XM4 VGND#9 B1#2 a_85_136##7 VNB sky130_fd_pr__nfet_01v8_lvt l=0.15 w=0.64 ad=0.2496 as=0.1792 pd=2.06 ps=1.84
XM8 a_85_136##7 C1#2 VGND#8 VNB sky130_fd_pr__nfet_01v8_lvt l=0.15 w=0.64 ad=0.1792 as=0.3008 pd=1.84 ps=2.22
XM7 VGND#8 D1#1 a_85_136##10 VNB sky130_fd_pr__nfet_01v8_lvt l=0.15 w=0.64 ad=0.3008 as=0.1696 pd=2.22 ps=1.81
XM11 VGND#7 a_85_136# X#3 VNB sky130_fd_pr__nfet_01v8_lvt l=0.15 w=0.74 ad=0.1961 as=0.1961 pd=2.01 ps=2.01
XM3 a_80_392##2 A1#1 VPWR#7 VPB sky130_fd_pr__pfet_01v8 l=0.15 w=1 ad=0.275 as=0.34 pd=2.55 ps=2.68
XM0 VPWR#7 A2#1 a_80_392# VPB sky130_fd_pr__pfet_01v8 l=0.15 w=1 ad=0.34 as=0.3 pd=2.68 ps=2.6
XM5 a_80_392# B1#1 a_353_392# VPB sky130_fd_pr__pfet_01v8 l=0.15 w=1 ad=0.3 as=0.24 pd=2.6 ps=2.48
XM9 a_353_392# C1#1 a_431_392# VPB sky130_fd_pr__pfet_01v8 l=0.15 w=1 ad=0.24 as=0.24 pd=2.48 ps=2.48
XM1 a_431_392# D1#3 a_85_136##5 VPB sky130_fd_pr__pfet_01v8 l=0.15 w=1 ad=0.24 as=0.275 pd=2.48 ps=2.55
XM2 VPWR#6 a_85_136##4 X#1 VPB sky130_fd_pr__pfet_01v8 l=0.15 w=1.12 ad=0.308 as=0.308 pd=2.79 ps=2.79
*
*
*       RESISTOR AND CAP/DIODE CARDS
*
Rg1	A1#1	A1#2	774.737183
Rg2	A1#2	A1#3	439.477417
Rg3	A2#1	A2#2	400.207520
Rg4	A2#2	A2#3	302.199066
Rg5	B1#1	B1#2	770.731873
Rg6	B1#2	B1#3	299.329773
Rg7	C1#1	C1#2	774.737183
Rg8	C1#2	C1#3	299.329773
Rg9	D1#1	D1#2	329.052460
Rg10	D1#2	D1#3	417.171356
Rg11	a_85_136#	a_85_136##2	368.862610
Rg12	a_85_136##2	a_85_136##3	36.503117
Rg13	a_85_136##2	a_85_136##4	462.979767
Rf1	A1	A1#3	1.422963
Rf2	A1#3	A1	22.125437
Rf3	a_80_392#	a_80_392##2	97.622070
Rf4	B1	B1#3	170.265472
Rf5	A2	A2#4	20.038189
Rf6	A2#4	A2	0.646393
Rf7	C1	C1#3	168.411850
Rf8	D1#2	D1	161.413818
Rf9	a_85_136##5	a_85_136##6	92.539314
Rf10	a_85_136##6	a_85_136##8	77.410408
Rf11	a_85_136##8	a_85_136##9	96.855919
Rf12	a_85_136##6	a_85_136##10	42.390129
Rf13	a_85_136##6	a_85_136##3	186.553650
Rf14	a_85_136##7	a_85_136##8	15.000000
Rf15	X	X#2	0.194040
Rf16	X#2	X	14.164948
Rf17	X	X#4	6.403333
Rf18	X#4	X	7.955656
Rf19	X#1	X#2	5.000000
Rf20	X#3	X#4	7.500000
Rf22	VGND#2	VGND#3	70.989845
Rf23	VGND#3	VGND#4	31.509756
Rf24	VGND#4	VGND#5	71.687523
Rf26	VGND#2	VGND#7	42.062149
Rf27	VGND#3	VGND#8	67.672203
Rf28	VGND#5	VGND#9	67.467606
Rf30	VPWR#2	VPWR#3	100.477249
Rf31	VPWR#3	VPWR#4	85.169937
Rf33	VPWR#2	VPWR#6	48.259808
Rf34	VPWR#4	VPWR#7	43.729290
Rf37	A2#2	A2#4	160.232803
Re1	VPWR#3	VPWR	1.091357
Re2	VGND	VGND#4	1.091398
*
*       CAPACITOR CARDS
*
*
C1	VGND	VNB	6.67797e-17
C2	VPWR	VNB	8.13453e-17
C3	X	VNB	1.12835e-16
C4	A1	VNB	3.87244e-17
C5	VGND	X	2.0164e-17
C6	C1	VNB	3.73712e-18
C7	A2	VNB	1.28916e-18
C8	VGND	A1	2.56898e-17
C9	VPWR	X	2.06892e-17
C10	D1	VNB	3.97893e-19
C11	VGND	C1	1.46311e-17
C12	VGND	A2	5.76317e-18
C13	VGND	D1	1.52702e-18
C14	A1#3	VNB	5.38095e-17
C15	A2#2	VNB	3.10863e-17
C16	VPWR	A2	1.15123e-17
C17	B1#3	VNB	4.71791e-17
C18	C1#3	VNB	3.47166e-17
C19	VPWR	D1	3.05059e-18
C20	D1#2	VNB	3.81184e-17
C21	a_85_136##3	VNB	7.83528e-17
C22	VGND#4	VNB	2.08148e-16
C23	a_85_136##6	B1#2	6.67162e-19
C24	VPWR#3	VNB	2.25278e-16
C25	VGND	A1#3	3.66601e-18
C26	A1#1	VNB	5.90305e-17
C27	A2#1	VNB	2.98084e-17
C28	B1#1	VNB	3.88772e-17
C29	VGND	B1#3	1.81319e-17
C30	C1#1	VNB	3.34503e-17
C31	VGND	C1#3	2.70606e-18
C32	D1#3	VNB	3.61385e-17
C33	a_85_136##4	VNB	4.56607e-17
C34	A1#2	VNB	4.0559e-17
C35	VGND	a_85_136##3	4.80787e-18
C36	A2#3	VNB	2.6145e-17
C37	VGND	VGND#4	1.81301e-17
C38	B1#2	VNB	2.69527e-17
C39	C1#2	VNB	2.79205e-17
C40	D1#1	VNB	3.33379e-17
C41	a_85_136#	VNB	3.83821e-17
C42	a_80_392##2	VNB	5.41199e-17
C43	VPWR#7	VNB	4.12663e-18
C44	a_80_392#	VNB	2.1393e-18
C45	a_85_136##5	VNB	2.05457e-17
C46	VPWR	a_85_136##3	3.454e-18
C47	VPWR#6	VNB	1.69504e-17
C48	A2	D1	2.7391e-17
C49	a_85_136##9	VNB	3.10534e-17
C50	VPWR	VPWR#3	3.48014e-17
C51	VGND#9	VNB	2.76433e-18
C52	a_85_136##7	VNB	7.36971e-18
C53	X	C1#3	2.77178e-19
C54	A1	A1#3	2.56082e-17
C55	VGND#8	VNB	3.06405e-18
C56	VGND	A2#3	1.51336e-18
C57	VPWR	A1#1	1.9157e-18
C58	a_85_136##10	VNB	9.72132e-18
C59	X	D1#2	3.10852e-19
C60	VGND#7	VNB	1.43291e-17
C61	a_85_136##6	C1#2	7.54916e-19
C62	VPWR	A2#1	9.89289e-19
C63	X	a_85_136##3	6.12967e-17
C64	VGND	D1#1	2.17797e-18
C65	VPWR	B1#1	2.33194e-18
C66	VGND	a_85_136#	8.23871e-18
C67	A1	B1#3	8.85152e-19
C68	VPWR	C1#1	2.32532e-18
C69	VGND	a_80_392##2	3.83227e-18
C70	VPWR	D1#3	4.27517e-18
C71	a_85_136##6	VNB	1.25518e-17
C72	VPWR	a_85_136##4	5.60116e-18
C73	VGND#3	VNB	2.68333e-17
C74	VGND	a_85_136##9	8.72644e-18
C75	VGND	VGND#9	4.07502e-18
C76	VGND	a_85_136##7	1.1253e-17
C77	X	D1#3	1.03573e-18
C78	B1#3	C1	3.2832e-17
C79	VGND	VGND#8	2.46343e-18
C80	X	a_85_136##4	3.61464e-17
C81	VPWR	a_80_392##2	1.77547e-17
C82	VGND	a_85_136##10	1.17939e-17
C83	C1	C1#3	1.74307e-17
C84	A2	A2#2	1.70614e-17
C85	VPWR	a_80_392#	1.70284e-17
C86	a_85_136##6	D1#1	1.87643e-17
C87	A2	B1#3	4.13916e-19
C88	VPWR	a_85_136##5	2.05765e-17
C89	VGND	a_85_136##6	2.41756e-18
C90	A2	C1#3	3.77991e-19
C91	VGND#4	C1	2.98281e-17
C92	X	D1#1	1.18157e-18
C93	A2	D1#2	8.02342e-18
C94	X	a_85_136#	2.59397e-17
C95	A1	A1#2	3.92019e-18
C96	VGND	VGND#3	2.98022e-17
C97	A1	A2#3	2.95521e-18
C98	D1	D1#2	1.5169e-17
C99	A2	VPWR#3	2.30558e-18
C100	D1	a_85_136##3	7.61792e-20
C101	VPWR#6	X	8.71621e-17
C102	a_85_136##6	a_85_136#	1.13405e-18
C103	X	X#1	5.57274e-18
C104	A1	a_80_392##2	1.72466e-18
C105	A2	A1#1	6.39604e-18
C106	D1	VPWR#3	5.32575e-19
C107	VPWR	a_85_136##6	8.11716e-19
C108	a_85_136##9	VGND#9	1.83186e-17
C109	A2	B1#1	1.47629e-17
C110	A2	C1#1	1.38839e-17
C111	VGND#7	X	6.71118e-17
C112	X	X#3	3.62139e-18
C113	C1	B1#2	8.37298e-19
C114	A1	a_85_136##9	3.35944e-17
C115	C1	C1#2	3.25683e-18
C116	D1	C1#1	1.21393e-18
C117	A1	VGND#9	1.66421e-17
C118	C1	D1#1	4.03942e-19
C119	A2	A1#2	5.89799e-18
C120	a_85_136##9	a_85_136##7	1.73239e-18
C121	a_85_136##6	X	5.52632e-18
C122	C1	a_85_136#	3.45807e-19
C123	D1	a_85_136##4	2.12854e-19
C124	A2	B1#2	9.503e-18
C125	A1#3	B1#3	7.54787e-18
C126	A2	C1#2	9.90133e-18
C127	A2	VPWR#7	6.36987e-19
C128	D1	C1#2	1.11941e-18
C129	A2	a_80_392#	6.37291e-17
C130	B1#3	C1#3	2.33296e-17
C131	B1#1	a_353_392#	2.35127e-17
C132	A1#2	a_168_136#	1.06828e-17
C133	a_85_136##7	VGND#9	3.19785e-17
C134	C1	a_85_136##7	1.70741e-17
C135	C1#1	a_353_392#	2.35127e-17
C136	A2#3	a_168_136#	1.13402e-17
C137	C1	VGND#8	1.4992e-17
C138	a_85_136##9	A2	2.03318e-17
C139	C1#1	a_431_392#	2.35127e-17
C140	VGND#4	B1#3	1.76043e-17
C141	D1	a_85_136##5	3.38624e-17
C142	VGND#9	VGND#8	2.8153e-18
C143	D1#3	a_431_392#	2.35127e-17
C144	a_85_136##7	A2	9.52725e-17
C145	VGND#4	C1#3	8.12362e-18
C146	D1#2	a_85_136##3	5.28729e-18
C147	VGND#3	D1#1	5.0123e-19
C148	A1#1	A2#2	1.62417e-17
C149	a_85_136##7	VGND#8	1.44025e-17
C150	A2#2	B1#1	1.53187e-17
C151	VPWR#3	D1#2	1.10254e-19
C152	VGND#3	a_85_136#	1.37279e-18
C153	C1	VGND#3	1.46963e-17
C154	a_85_136##7	a_85_136##10	2.69772e-18
C155	a_85_136##9	a_168_136#	1.88787e-18
C156	A1#3	A2#3	9.69359e-18
C157	a_85_136##6	a_85_136##5	2.73907e-18
C158	A1#2	A2#2	1.62295e-17
C159	VGND#8	a_85_136##10	3.08188e-17
C160	a_85_136##6	D1	5.80787e-17
C161	C1#1	D1#2	1.59865e-17
C162	A2#2	B1#2	1.73798e-17
C163	A2#3	B1#3	4.11203e-18
C164	a_85_136##6	VPWR#6	7.86427e-18
C165	VGND#8	VGND#7	4.93548e-18
C166	D1#2	a_85_136##4	6.76505e-19
C167	a_80_392##2	A1#3	6.90987e-19
C168	B1#3	B1#2	3.42741e-18
C169	VPWR#3	B1#1	7.81561e-18
C170	B1#3	C1#2	9.44003e-19
C171	VPWR#3	C1#1	8.84882e-18
C172	A1#1	A2#1	3.52643e-17
C173	a_85_136##10	VGND#7	2.61053e-17
C174	VPWR#7	A2#2	5.28258e-19
C175	VPWR#3	D1#3	8.11631e-18
C176	a_80_392#	A2#2	1.67215e-18
C177	C1#3	D1#1	2.86941e-18
C178	A2#1	B1#1	4.13086e-17
C179	C1#2	D1#2	1.67791e-17
C180	C1#3	a_85_136#	1.19458e-18
C181	a_80_392#	B1#3	3.24632e-19
C182	VGND#4	A2#3	1.28334e-19
C183	a_85_136##9	A1#3	3.26725e-18
C184	VGND#4	B1#2	1.5513e-20
C185	B1#1	C1#1	8.07298e-17
C186	D1#1	a_85_136##3	2.43974e-18
C187	VGND#4	C1#2	8.33726e-20
C188	VGND#9	A1#3	2.36939e-18
C189	VGND#4	D1#1	4.2778e-20
C190	C1#1	D1#3	6.57227e-17
C191	VGND#9	A2#2	8.42584e-19
C192	a_85_136##7	A2#2	3.02722e-18
C193	a_85_136##5	D1#2	7.29796e-18
C194	D1#3	a_85_136##4	3.63335e-18
C195	VGND#9	B1#3	1.54247e-17
C196	VPWR#6	D1#2	2.10284e-20
C197	B1#3	a_85_136##7	2.30263e-17
C198	a_80_392#	VPWR#3	5.06308e-18
C199	a_85_136##3	VPWR#6	3.49472e-17
C200	a_85_136##7	C1#3	1.39117e-18
C201	a_85_136##6	VGND#8	1.82165e-17
C202	a_80_392##2	A1#1	5.51692e-17
C203	VGND#8	C1#3	1.56712e-18
C204	A1#1	VPWR#7	3.081e-17
C205	a_85_136##7	D1#2	4.69661e-18
C206	a_80_392##2	A2#1	1.94074e-18
C207	a_85_136##5	VPWR#3	1.76132e-17
C208	VGND#7	C1#3	1.44633e-18
C209	a_80_392#	A1#1	2.59323e-18
C210	a_85_136##6	a_85_136##10	1.37854e-18
C211	VGND#8	D1#2	1.22403e-18
C212	A2#1	VPWR#7	2.45781e-17
C213	a_85_136##6	A2#2	3.79872e-19
C214	a_80_392#	A2#1	6.30596e-17
C215	VPWR#7	B1#1	6.83285e-19
C216	A1#2	A2#3	4.51938e-17
C217	a_85_136##6	VGND#7	2.8101e-18
C218	a_80_392#	B1#1	6.09586e-17
C219	VGND#4	a_85_136##7	3.20193e-18
C220	VGND#3	A1#3	6.45755e-20
C221	VPWR#7	C1#1	3.89986e-19
C222	a_85_136##3	VGND#7	3.65134e-17
C223	a_80_392#	C1#1	6.97532e-18
C224	A2#3	B1#2	1.948e-17
C225	VPWR#7	D1#3	3.36226e-19
C226	VPWR#6	A2#1	2.3146e-19
C227	a_80_392#	D1#3	3.16484e-18
C228	a_85_136##5	B1#1	2.77345e-18
C229	B1#2	C1#2	4.40404e-17
C230	VPWR#6	B1#1	1.67518e-19
C231	a_85_136##6	D1#2	9.01438e-18
C232	a_85_136##5	C1#1	6.41051e-18
C233	VGND#3	B1#3	4.10348e-19
C234	VPWR#6	C1#1	2.08633e-19
C235	a_85_136##5	D1#3	7.39665e-17
C236	a_85_136##6	a_85_136##3	6.0491e-19
C237	C1#2	D1#1	1.14773e-17
C238	VGND#3	a_85_136##7	3.20938e-19
C239	VPWR#6	D1#3	4.17839e-18
C240	VGND#3	C1#3	5.82749e-18
C241	a_85_136##5	a_85_136##4	8.48629e-18
C242	a_85_136##4	VPWR#6	2.50616e-17
C243	D1#1	a_85_136#	3.16881e-18
C244	VGND#3	VGND#8	8.29394e-19
C245	a_85_136##4	X#1	1.12913e-17
C246	VGND#3	D1#2	1.31595e-19
C247	VGND#3	a_85_136##10	4.60266e-18
C248	a_85_136##9	A1#2	3.47165e-17
C249	VGND#3	VGND#7	3.4748e-18
C250	a_80_392##2	VPWR#7	6.62427e-17
C251	VGND#4	VGND#3	2.7403e-17
C252	a_85_136##9	A2#3	1.81124e-17
C253	a_80_392##2	a_80_392#	2.85228e-18
C254	VGND#9	A1#2	5.44949e-18
C255	a_85_136##6	A2#1	1.37639e-19
C256	a_80_392#	VPWR#7	6.15298e-17
C257	a_85_136##9	B1#2	2.79505e-19
C258	a_85_136##7	A1#2	5.05247e-19
C259	VGND#9	A2#3	3.63507e-17
C260	a_85_136##6	B1#1	3.76755e-19
C261	a_85_136##7	A2#3	1.6501e-18
C262	B1#2	VGND#9	1.57206e-17
C263	VGND#8	A2#3	2.59978e-19
C264	a_85_136##6	C1#1	6.64804e-19
C265	a_85_136##7	B1#2	4.12044e-17
C266	VGND#9	C1#2	5.29392e-19
C267	VGND#8	B1#2	4.48996e-19
C268	a_85_136##7	C1#2	4.06314e-17
C269	a_85_136##6	D1#3	1.41612e-18
C270	a_80_392#	a_85_136##5	2.01148e-17
C271	VGND#9	D1#1	4.13191e-19
C272	a_85_136##9	a_80_392##2	1.63414e-17
C273	C1#2	VGND#8	1.49032e-17
C274	a_85_136##7	D1#1	1.9173e-18
C275	a_85_136##6	a_85_136##4	1.08705e-18
C276	a_85_136##10	C1#2	6.00055e-19
C277	VGND#8	D1#1	3.82102e-17
C278	a_85_136##7	a_85_136#	1.57517e-19
C279	D1#1	a_85_136##10	2.13294e-17
C280	a_85_136##9	a_80_392#	1.31299e-18
C281	VGND#8	a_85_136#	1.2265e-18
C282	VGND#7	D1#1	2.41998e-18
C283	a_85_136##10	a_85_136#	3.78648e-18
C284	a_85_136##5	VPWR#6	4.40366e-17
C285	a_85_136#	VGND#7	2.57909e-17
C286	VGND#3	a_85_136##6	1.9094e-19
C287	a_85_136##6	A2#3	1.59233e-19
C288	a_85_136#	X#3	7.22397e-18
C289	VGND#2	a_85_136##10	1.59725e-18
C290	a_85_136##6	VPWR#2	2.3677e-19
C291	VGND#5	VGND#9	2.17176e-18
C292	VGND#2	a_85_136#	1.09233e-17
C293	VPWR#2	a_85_136##4	1.13541e-17
C294	VPWR#4	A2#1	5.00513e-18
C295	VGND#5	A2#2	5.83506e-20
C296	VGND#5	VGND#3	4.10038e-19
C297	VGND	VGND#2	5.50576e-17
C298	VPWR#2	VNB	6.04539e-17
C299	VPWR#4	VNB	6.28346e-17
C300	VGND#5	A1	5.40135e-17
C301	VGND#2	a_85_136##6	3.66353e-19
C302	X	VPWR#2	2.11441e-17
C303	VGND	VGND#5	5.95321e-17
C304	VPWR#4	D1#3	4.41533e-20
C305	VPWR#2	C1#1	6.36489e-20
C306	VGND#5	a_85_136##7	8.21698e-20
C307	VGND#5	a_85_136##9	1.53658e-18
C308	VGND#5	B1#3	4.28781e-17
C309	VPWR#3	VPWR#2	6.34628e-17
C310	VPWR#4	B1#1	3.74428e-19
C311	VGND#2	a_85_136##3	7.52332e-19
C312	VGND#3	VGND#2	1.10144e-18
C313	VPWR#2	A2#1	4.28232e-20
C314	a_80_392#	VPWR#4	1.47597e-17
C315	a_85_136##3	VPWR#2	4.62476e-19
C316	VPWR#4	A1#1	5.52227e-18
C317	VGND#4	VGND#5	7.1054e-17
C318	VGND#2	X	1.96159e-17
C319	VPWR#2	D1#3	6.85737e-19
C320	VGND#5	C1#3	5.42422e-19
C321	VGND#5	A1#3	1.167e-17
C322	VGND#4	VGND#2	5.46687e-17
C323	a_80_392##2	VPWR#4	2.10814e-17
C324	VGND#2	VNB	5.34103e-17
C325	VPWR	VPWR#2	5.77745e-17
C326	VPWR#4	C1#1	1.55802e-19
C327	VPWR#3	VPWR#4	6.73147e-17
C328	VPWR#2	B1#1	4.45127e-20
C329	VGND#2	C1#3	5.52108e-19
C330	VGND#5	VNB	6.70808e-17
C331	a_85_136##5	VPWR#2	4.75662e-18
C332	VPWR	VPWR#4	6.07935e-17
*
*
.ENDS sky130_fd_sc_hs__a2111o_1
*
