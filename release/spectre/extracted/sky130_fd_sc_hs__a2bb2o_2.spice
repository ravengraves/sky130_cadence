* Extracted by Quantus, converted by sky130cad/quantus.py
*
*
*
*                       LINUX           Wed Nov 18 08:10:05 2026
*
*
*
*  PROGRAM  advgen
*
*  Name           : advgen - Quantus - (64-bit)
*  Version        : 25.1.0-p047
*  Build Date     : Thu Dec 11 23:20:30 PST 2025
*
*  HSPICE LIBRARY
*
*  OPERATING_TEMPERATURE 150
*  QRC_TECH_DIR <path>/tech
*
*
*

*
.SUBCKT sky130_fd_sc_hs__a2bb2o_2 VPB VNB VGND VPWR X B1 B2 A2_N A1_N
*
*
*  caps2d version: 10
*
*
*       TRANSISTOR CARDS
*
*
XM9 VGND#10 B1#1 a_149_74# VNB sky130_fd_pr__nfet_01v8_lvt l=0.15 w=0.74 ad=0.2109 as=0.1554 pd=2.05 ps=1.9
XM2 a_149_74# B2#3 a_221_74##11 VNB sky130_fd_pr__nfet_01v8_lvt l=0.15 w=0.74 ad=0.1554 as=0.2886 pd=1.9 ps=2.26
XM13 a_221_74##11 a_293_333##4 VGND#9 VNB sky130_fd_pr__nfet_01v8_lvt l=0.15 w=0.74 ad=0.2886 as=0.515 pd=2.26 ps=3.18
XM4 VGND#9 A2_N#3 a_293_333##5 VNB sky130_fd_pr__nfet_01v8_lvt l=0.15 w=0.55 ad=0.515 as=0.154 pd=3.18 ps=1.66
XM7 a_293_333##5 A1_N#3 VGND#8 VNB sky130_fd_pr__nfet_01v8_lvt l=0.15 w=0.55 ad=0.154 as=0.262 pd=1.66 ps=2.26
XM10 VGND#8 a_221_74##4 X#3 VNB sky130_fd_pr__nfet_01v8_lvt l=0.15 w=0.74 ad=0.262 as=0.2072 pd=2.26 ps=2.04
XM8 X#3 a_221_74##5 VGND#7 VNB sky130_fd_pr__nfet_01v8_lvt l=0.15 w=0.74 ad=0.2072 as=0.1961 pd=2.04 ps=2.01
XM11 a_61_392##2 B1#4 VPWR#9 VPB sky130_fd_pr__pfet_01v8 l=0.15 w=1 ad=0.275 as=0.3 pd=2.55 ps=2.6
XM3 VPWR#9 B2#1 a_61_392# VPB sky130_fd_pr__pfet_01v8 l=0.15 w=1 ad=0.3 as=0.3 pd=2.6 ps=2.6
XM5 a_61_392# a_293_333##3 a_221_74##9 VPB sky130_fd_pr__pfet_01v8 l=0.15 w=1 ad=0.3 as=0.275 pd=2.6 ps=2.55
XM1 a_293_333##7 A2_N#1 a_546_378# VPB sky130_fd_pr__pfet_01v8 l=0.15 w=1 ad=0.275 as=0.24 pd=2.55 ps=2.48
XM12 a_546_378# A1_N#1 VPWR#8 VPB sky130_fd_pr__pfet_01v8 l=0.15 w=1 ad=0.24 as=0.3918 pd=2.48 ps=2.96
XM6 X#1 a_221_74##7 VPWR#8 VPB sky130_fd_pr__pfet_01v8 l=0.15 w=1.12 ad=0.336 as=0.3918 pd=2.84 ps=2.96
XM0 VPWR#7 a_221_74# X#1 VPB sky130_fd_pr__pfet_01v8 l=0.15 w=1.12 ad=0.308 as=0.336 pd=2.79 ps=2.84
*
*
*       RESISTOR AND CAP/DIODE CARDS
*
Rg1	B1#1	B1#2	322.953644
Rg2	B1#2	B1#3	58.159077
Rg3	B1#2	B1#4	524.846741
Rg4	B2#1	B2#2	509.830780
Rg5	B2#2	B2#3	307.937683
Rg6	a_293_333#	a_293_333##2	232.189651
Rg7	a_293_333##2	a_293_333##3	550.358398
Rg8	a_293_333##2	a_293_333##4	329.212952
Rg9	A2_N#1	A2_N#2	520.207153
Rg10	A2_N#2	A2_N#3	339.500092
Rg11	A1_N#1	A1_N#2	479.379059
Rg12	A1_N#2	A1_N#3	362.454590
Rg13	a_221_74#	a_221_74##2	448.603302
Rg14	a_221_74##2	a_221_74##3	171.636658
Rg15	a_221_74##3	a_221_74##4	475.427429
Rg16	a_221_74##2	a_221_74##5	395.494293
Rg17	a_221_74##2	a_221_74##6	44.632042
Rg18	a_221_74##3	a_221_74##7	424.231750
Rf1	B1	B1#3	163.775864
Rf2	B2	B2#4	2.823864
Rf3	B2#4	B2	14.119321
Rf4	a_61_392#	a_61_392##2	149.915421
Rf5	A2_N#4	A2_N#2	161.115265
Rf6	A2_N	A2_N#6	0.882458
Rf7	A2_N#4	A2_N#6	3.543054
Rf8	a_293_333##5	a_293_333#	101.096901
Rf9	a_293_333#	a_293_333##7	62.695671
Rf10	A1_N	A1_N#4	11.022836
Rf11	A1_N#4	A1_N	3.543054
Rf12	X	X#2	1.511111
Rf13	X#2	X	9.671110
Rf14	X	X#4	5.591110
Rf15	X#4	X	5.591110
Rf16	X#1	X#2	15.000000
Rf17	X#3	X#4	7.500000
Rf18	a_221_74##6	a_221_74##10	401.567139
Rf19	a_221_74##10	a_221_74##11	120.516861
Rf20	a_221_74##9	a_221_74##10	5.000000
Rf22	VPWR#2	VPWR#3	67.859894
Rf23	VPWR#3	VPWR#4	65.692909
Rf24	VPWR#4	VPWR#5	111.012222
Rf26	VPWR#2	VPWR#7	33.326477
Rf27	VPWR#3	VPWR#8	31.799385
Rf28	VPWR#5	VPWR#9	36.061966
Rf30	VGND#2	VGND#3	76.208740
Rf31	VGND#3	VGND#4	58.059399
Rf32	VGND#4	VGND#5	147.537460
Rf34	VGND#2	VGND#7	41.038895
Rf35	VGND#3	VGND#8	42.152893
Rf36	VGND#4	VGND#9	15.995978
Rf37	VGND#5	VGND#10	31.928404
Rf39	B2#2	B2#4	160.232803
Rf42	A1_N#2	A1_N#4	160.232803
Re1	VPWR#4	VPWR	0.982218
Re2	VGND	VGND#4	0.982254
*
*       CAPACITOR CARDS
*
*
C1	VGND#9	VGND#3	2.40304e-18
C2	VPWR#4	a_293_333##2	2.29544e-20
C3	VGND#10	B1#2	1.28053e-18
C4	a_221_74##2	VPWR#7	1.60506e-18
C5	VGND#4	a_221_74##3	2.90131e-20
C6	VGND#4	a_221_74##2	1.4921e-20
C7	a_221_74##3	X#1	2.55721e-19
C8	a_221_74##2	X#1	2.52311e-19
C9	a_221_74##6	a_221_74##3	2.14833e-19
C10	a_221_74##6	a_221_74##2	2.97195e-17
C11	VPWR#3	a_221_74##3	2.63655e-20
C12	A1_N#2	a_221_74##3	2.38796e-17
C13	a_293_333##5	A2_N#6	2.14406e-17
C14	a_293_333##5	A2_N#4	1.7263e-17
C15	X#3	VGND#7	4.29799e-17
C16	a_293_333##2	A2_N#2	5.16782e-19
C17	a_221_74##9	VPWR#3	7.59736e-18
C18	VGND#8	VGND#7	6.59586e-19
C19	VGND#3	a_221_74##5	7.976e-19
C20	VGND#8	X#3	4.3923e-17
C21	a_293_333##7	a_293_333##2	7.72817e-19
C22	a_293_333#	a_293_333##2	4.4441e-19
C23	VGND#3	a_221_74##4	9.59211e-18
C24	a_293_333##5	VGND#8	4.80709e-17
C25	VGND#3	A1_N#3	8.54866e-18
C26	VGND#9	VGND#8	1.10658e-18
C27	a_221_74##9	a_293_333##2	2.26819e-18
C28	B2#2	a_293_333##2	3.99281e-17
C29	a_293_333##5	VGND#9	5.28445e-17
C30	a_221_74##9	B1#2	2.861e-19
C31	VGND#3	A2_N#3	1.07788e-18
C32	B1#2	B2#2	3.57897e-17
C33	a_221_74##11	a_293_333##5	1.26184e-18
C34	a_221_74##11	VGND#9	6.39882e-17
C35	a_61_392#	a_293_333##2	1.82249e-18
C36	A2_N#6	a_221_74##9	1.87602e-18
C37	A2_N#4	a_293_333##7	1.95172e-17
C38	VGND#10	VGND#9	9.29886e-19
C39	A2_N#4	a_221_74##9	1.25556e-19
C40	VGND#10	a_221_74##11	2.49564e-17
C41	a_293_333##5	a_293_333##7	1.32825e-18
C42	a_61_392##2	B1#2	4.39127e-18
C43	a_293_333##5	a_221_74##9	3.23872e-18
C44	a_221_74##11	a_293_333##7	1.04327e-18
C45	VGND#9	a_221_74##9	1.72176e-18
C46	VPWR#8	VPWR#7	1.05088e-17
C47	VGND#7	a_221_74##5	2.09681e-17
C48	X#3	a_221_74##5	3.18717e-17
C49	a_221_74##11	a_61_392#	4.32355e-18
C50	VPWR#3	a_221_74##7	3.97828e-18
C51	VGND#7	a_221_74##4	7.50877e-19
C52	VGND#8	a_221_74##5	1.98906e-19
C53	X#3	a_221_74##4	3.27654e-17
C54	VGND#7	A1_N#3	1.82298e-19
C55	VPWR#3	A1_N#1	1.20279e-18
C56	a_221_74##4	VGND#8	1.18568e-17
C57	a_221_74##4	a_221_74##2	3.91469e-18
C58	X#3	A1_N#3	1.0731e-18
C59	a_293_333##5	a_221_74##4	6.07831e-19
C60	VGND#8	A1_N#3	3.2467e-17
C61	a_221_74##9	VPWR#8	3.54909e-17
C62	A1_N#3	a_293_333##5	1.36902e-17
C63	VGND#10	a_61_392##2	4.89978e-18
C64	VGND#8	A2_N#3	1.32829e-18
C65	VGND#9	A1_N#3	2.08393e-18
C66	a_293_333##5	A2_N#3	2.76801e-17
C67	a_221_74##9	a_293_333##7	1.29404e-16
C68	a_221_74##11	A1_N#3	1.27538e-19
C69	VGND#9	A2_N#3	4.20508e-17
C70	a_293_333##5	a_293_333##4	3.31662e-19
C71	a_221_74##11	A2_N#3	7.62691e-19
C72	a_293_333##4	VGND#9	3.78554e-17
C73	a_61_392#	a_221_74##9	1.07454e-16
C74	a_293_333##5	B2#3	9.38878e-20
C75	a_221_74##11	a_293_333##4	2.97757e-17
C76	VGND#9	B2#3	1.49407e-18
C77	VGND#10	A2_N#3	1.63407e-19
C78	a_221_74##11	B2#3	4.51771e-17
C79	a_61_392#	VPWR#9	8.5014e-17
C80	VGND#9	B1#1	5.40851e-19
C81	VGND#10	a_293_333##4	6.46839e-19
C82	VGND#4	VGND#3	3.71897e-17
C83	a_221_74##11	B1#1	8.28896e-18
C84	a_61_392##2	a_61_392#	2.14025e-18
C85	VGND#10	B2#3	8.36328e-18
C86	VPWR#4	VPWR#3	4.00179e-17
C87	a_61_392##2	VPWR#9	8.51906e-17
C88	VGND#10	B1#1	4.23007e-17
C89	A1_N	a_221_74##3	3.43129e-18
C90	A1_N	a_293_333##2	7.36107e-20
C91	a_221_74##6	VPWR#3	2.16429e-18
C92	VPWR#7	a_221_74#	2.51635e-17
C93	a_221_74##4	a_221_74##5	3.94629e-17
C94	a_221_74#	X#1	2.06882e-17
C95	VPWR#7	a_221_74##7	4.8653e-18
C96	VPWR#8	a_221_74#	5.30609e-18
C97	a_221_74##7	X#1	2.61428e-17
C98	A1_N#3	a_221_74##4	2.11806e-17
C99	VPWR#8	a_221_74##7	3.51067e-17
C100	a_293_333##7	a_221_74#	1.32597e-19
C101	VPWR#8	A1_N#1	3.73388e-17
C102	a_221_74##9	a_221_74#	4.67959e-19
C103	A2_N#3	A1_N#3	3.41991e-17
C104	a_293_333##7	a_221_74##7	2.4578e-19
C105	a_221_74##9	a_221_74##7	6.89766e-19
C106	VPWR#8	A2_N#1	2.14179e-18
C107	a_293_333##7	A1_N#1	3.25352e-18
C108	a_293_333##4	A2_N#3	3.61772e-18
C109	a_221_74##9	A1_N#1	2.33248e-17
C110	VPWR#8	a_293_333##3	7.26961e-19
C111	a_293_333##7	A2_N#1	2.63916e-17
C112	A2_N#6	A1_N#2	4.70202e-18
C113	a_221_74##9	A2_N#1	3.06502e-17
C114	B2	a_293_333##2	4.61982e-18
C115	VPWR#8	B2#1	2.22212e-19
C116	B2	B1#2	2.21993e-17
C117	a_293_333##7	a_293_333##3	2.81007e-18
C118	VPWR#9	A1_N#1	1.60525e-19
C119	B2#3	a_293_333##4	2.31882e-17
C120	VGND#7	a_221_74##6	2.67103e-17
C121	A2_N#6	A2_N#2	8.28076e-18
C122	a_221_74##9	a_293_333##3	6.88482e-17
C123	VGND#4	VGND#9	6.77459e-17
C124	VPWR#9	A2_N#1	4.43333e-19
C125	VGND#8	a_221_74##6	1.94727e-18
C126	a_293_333##3	a_61_392#	2.33705e-17
C127	A2_N#4	A2_N#2	8.18806e-18
C128	B1#1	B2#3	5.95966e-17
C129	a_221_74##9	B2#1	2.08025e-18
C130	VPWR#9	a_293_333##3	3.35435e-18
C131	a_221_74##3	a_221_74##2	7.52345e-18
C132	a_61_392#	B2#1	3.46501e-17
C133	A1_N#2	VGND#8	3.97233e-18
C134	a_61_392##2	a_293_333##3	3.19387e-19
C135	a_293_333#	A2_N#4	3.08025e-17
C136	VPWR#9	B2#1	5.70638e-17
C137	a_61_392#	B1#4	7.57621e-19
C138	a_61_392##2	B2#1	7.95126e-19
C139	VPWR#9	B1#4	5.01085e-17
C140	a_293_333##5	A2_N#2	3.35706e-18
C141	a_221_74##6	VPWR#7	5.51559e-17
C142	a_61_392##2	B1#4	3.62827e-17
C143	VGND#9	A2_N#2	6.99066e-19
C144	a_221_74##6	X#1	3.54072e-18
C145	a_221_74##9	VPWR#4	5.06749e-17
C146	a_221_74##11	A2_N#2	2.28174e-19
C147	a_221_74##6	VPWR#8	4.10758e-17
C148	a_293_333#	VGND#9	5.27668e-17
C149	a_221_74##7	a_221_74#	4.83768e-17
C150	a_293_333##7	a_221_74##6	1.01015e-18
C151	a_221_74##11	a_293_333#	5.98569e-17
C152	VPWR#8	A1_N#2	3.41164e-19
C153	X	a_221_74##3	1.44457e-17
C154	X	a_221_74##2	1.5304e-17
C155	VGND#9	B2#2	1.54797e-19
C156	a_293_333##7	A1_N#2	6.48191e-19
C157	B2#2	a_221_74##11	7.0062e-18
C158	A1_N#1	a_221_74##7	3.76994e-17
C159	VGND#7	a_221_74##2	7.40477e-18
C160	a_293_333##7	A2_N#2	6.7634e-18
C161	a_221_74##9	A2_N#2	2.4402e-19
C162	A2_N#1	A1_N#1	6.37291e-17
C163	a_293_333##3	a_221_74##7	7.86156e-20
C164	a_293_333#	a_293_333##7	3.08206e-18
C165	B1#3	VGND#10	7.3891e-18
C166	a_221_74##9	a_293_333#	4.35732e-18
C167	A1_N#2	a_221_74##4	1.43776e-17
C168	a_293_333##3	A2_N#1	5.85282e-18
C169	a_221_74##9	B2#2	5.16489e-19
C170	a_61_392#	B2#2	8.07337e-18
C171	VGND#3	A1_N	7.38385e-19
C172	A2_N#2	A1_N#3	1.02687e-18
C173	B2#1	a_293_333##3	4.94901e-17
C174	a_293_333#	a_221_74##4	1.59412e-19
C175	A1_N#1	a_221_74##3	1.37474e-18
C176	a_293_333#	A1_N#3	4.83023e-20
C177	a_293_333##4	A2_N#2	7.7104e-19
C178	a_221_74##6	a_221_74#	2.42777e-17
C179	a_293_333#	A2_N#3	1.79952e-20
C180	B1#4	B2#1	4.79236e-17
C181	a_61_392##2	B1#3	7.44528e-18
C182	VPWR#4	A2_N#1	4.46371e-18
C183	a_293_333#	a_293_333##4	2.90103e-18
C184	a_221_74##6	a_221_74##7	1.08407e-17
C185	a_221_74##9	a_546_378#	1.28231e-17
C186	a_221_74##6	A1_N#1	2.37754e-19
C187	VGND	a_221_74##2	9.70512e-19
C188	a_221_74##6	A2_N#1	3.1697e-19
C189	VGND	B1#2	1.31239e-18
C190	A2_N#6	A1_N	3.02627e-17
C191	A2_N#1	A1_N#2	1.20887e-18
C192	VGND#8	A1_N	1.78927e-17
C193	a_293_333##2	A2_N#1	2.81644e-19
C194	a_221_74##3	VNB	1.80042e-17
C195	a_221_74##2	VNB	6.14748e-17
C196	VPWR#4	A2_N#2	1.00716e-19
C197	a_293_333##2	VNB	2.36085e-17
C198	B1#2	VNB	2.52553e-17
C199	a_221_74##6	A1_N#2	3.64322e-19
C200	VPWR#4	a_293_333#	2.89225e-19
C201	a_293_333##7	A1_N	2.43134e-17
C202	A1_N#1	a_546_378#	1.51392e-17
C203	A1_N	a_221_74##9	1.94023e-17
C204	A2_N#1	a_546_378#	5.11592e-18
C205	A2_N#2	A1_N#2	4.37362e-17
C206	a_221_74##11	B2	6.58514e-17
C207	VGND#10	B2	1.67877e-17
C208	a_293_333#	A1_N#2	4.06948e-19
C209	VGND#4	B1#3	1.71863e-21
C210	A1_N	a_221_74##4	7.52243e-19
C211	B2#3	a_149_74#	1.50905e-17
C212	a_293_333#	A2_N#2	3.44204e-17
C213	B1#1	a_149_74#	1.596e-17
C214	VPWR	VPWR#3	2.71211e-17
C215	VGND#10	B1	2.98845e-17
C216	B2	a_61_392#	4.16911e-17
C217	X	VGND#7	2.30286e-17
C218	VGND#8	X	1.37848e-17
C219	B2	a_61_392##2	2.8674e-17
C220	a_293_333##5	X	2.2206e-18
C221	VPWR	A2_N#6	1.30965e-18
C222	A1_N	a_221_74##7	4.11135e-18
C223	VGND	VGND#3	4.06075e-17
C224	VPWR	A2_N#4	1.08017e-19
C225	A1_N	A1_N#1	1.21355e-17
C226	VGND#3	VGND#7	1.1974e-18
C227	A1_N	A2_N#1	6.29862e-18
C228	B1	a_61_392##2	3.14723e-17
C229	A1_N	a_293_333##3	2.77513e-19
C230	VPWR	a_221_74##11	1.30856e-18
C231	VGND	A2_N#6	1.68884e-18
C232	VPWR	VPWR#7	1.62542e-17
C233	VGND	A2_N#4	1.55494e-18
C234	X	a_221_74##5	9.19404e-18
C235	VPWR	VPWR#8	1.88939e-17
C236	X	a_221_74##4	1.33763e-17
C237	VGND#3	VNB	2.94306e-17
C238	VGND#9	a_293_333##2	3.69841e-19
C239	X	A1_N#3	8.25064e-19
C240	VPWR	a_293_333##7	1.05134e-17
C241	VGND	X#3	2.08106e-17
C242	X	A2_N#3	1.69909e-19
C243	VPWR	a_221_74##9	4.67166e-17
C244	A1_N	a_221_74##6	1.59064e-17
C245	VPWR#3	VNB	3.23939e-17
C246	VGND	a_293_333##5	1.32178e-17
C247	X	a_293_333##4	1.84491e-19
C248	VPWR	a_61_392#	1.27692e-17
C249	VGND#3	X#3	1.05855e-17
C250	VGND	VGND#9	7.88507e-17
C251	VPWR	VPWR#9	2.23011e-17
C252	A1_N	A1_N#2	2.17392e-17
C253	VGND	a_221_74##11	2.05084e-17
C254	VPWR	a_61_392##2	1.5423e-17
C255	VGND	VGND#10	1.90611e-17
C256	A1_N	A2_N#2	3.18058e-18
C257	X	a_221_74#	7.68845e-18
C258	a_293_333#	A1_N	3.32714e-18
C259	A2_N#6	VNB	2.3049e-19
C260	X	a_221_74##7	1.47606e-17
C261	A2_N#4	VNB	2.76468e-18
C262	VGND	a_293_333##7	2.89707e-18
C263	X	A1_N#1	2.03434e-18
C264	VGND	a_61_392#	3.33154e-18
C265	VGND#7	VNB	3.86334e-17
C266	X#3	VNB	2.18219e-18
C267	VGND#8	VNB	6.25383e-19
C268	VGND	a_61_392##2	3.40749e-18
C269	a_293_333##5	VNB	1.03452e-17
C270	VGND	a_221_74##5	4.92904e-18
C271	VPWR	a_221_74#	3.08657e-19
C272	VGND#9	VNB	5.63114e-17
C273	a_221_74##11	VNB	7.66007e-18
C274	VGND	a_221_74##4	5.55218e-19
C275	VPWR	a_221_74##7	3.1843e-19
C276	VGND	A1_N#3	1.26559e-19
C277	VGND#10	VNB	3.2225e-17
C278	VPWR	A1_N#1	2.83004e-18
C279	VGND	A2_N#3	4.39801e-19
C280	VPWR#7	VNB	1.97658e-17
C281	VPWR	A2_N#1	6.02031e-18
C282	B2	B2#2	2.08609e-17
C283	VPWR#8	VNB	1.75055e-18
C284	VGND	B2#3	1.36013e-18
C285	VPWR	a_293_333##3	5.06255e-18
C286	VGND	B1#1	6.3616e-19
C287	a_293_333##7	VNB	1.5544e-17
C288	VPWR	B2#1	1.45743e-18
C289	a_221_74##9	VNB	2.33307e-17
C290	X	a_221_74##6	1.22529e-16
C291	VPWR	B1#4	2.34354e-18
C292	a_61_392#	VNB	8.29163e-18
C293	VPWR#9	VNB	2.6186e-18
C294	X	A1_N#2	5.24921e-18
C295	a_61_392##2	VNB	5.95702e-17
C296	a_221_74##5	VNB	3.54961e-17
C297	VPWR	VPWR#4	2.47256e-17
C298	X	A2_N#2	1.68478e-19
C299	B1	B1#3	1.99668e-17
C300	a_221_74##4	VNB	3.45853e-17
C301	A1_N#3	VNB	2.78508e-17
C302	a_293_333#	X	1.67688e-18
C303	A2_N#3	VNB	2.39209e-17
C304	VPWR	a_221_74##6	1.57544e-17
C305	a_293_333##4	VNB	2.64115e-17
C306	B2#3	VNB	2.4041e-17
C307	B1#1	VNB	2.69858e-17
C308	VGND#3	a_221_74##3	9.38336e-21
C309	a_221_74#	VNB	3.45874e-17
C310	a_221_74##7	VNB	2.99184e-17
C311	A1_N#1	VNB	3.21533e-17
C312	VGND	a_221_74##6	4.7501e-18
C313	A2_N#1	VNB	4.30238e-17
C314	VPWR	B1#3	2.24298e-18
C315	a_293_333##3	VNB	4.07858e-17
C316	B2#1	VNB	3.29125e-17
C317	VGND	A2_N#2	1.37797e-19
C318	B1#4	VNB	4.26706e-17
C319	VGND	a_293_333#	9.32141e-18
C320	VPWR#4	VNB	2.37894e-16
C321	VGND	B2#2	3.29866e-19
C322	a_221_74##11	a_293_333##2	1.70122e-17
C323	VGND#4	VNB	2.00954e-16
C324	VGND	B1#3	1.37143e-18
C325	a_221_74##6	VNB	6.14461e-17
C326	A1_N#2	VNB	2.99565e-17
C327	A2_N#2	VNB	4.4101e-17
C328	A1_N	X	6.63865e-17
C329	VGND#3	a_293_333##5	5.18684e-18
C330	a_293_333#	VNB	4.05521e-17
C331	B1	B2	3.25384e-17
C332	B2#2	VNB	3.29472e-17
C333	B1#3	VNB	5.41233e-17
C334	VPWR	A1_N	3.77693e-18
C335	VGND	A1_N	5.32251e-18
C336	VPWR	B2	3.40279e-18
C337	VPWR	B1	4.54611e-18
C338	VGND	B2	8.1245e-18
C339	A1_N	VNB	1.2498e-18
C340	VPWR	X	5.46375e-18
C341	VGND	B1	5.14387e-18
C342	B2	VNB	3.16235e-18
C343	B1	VNB	2.72257e-17
C344	X	VNB	5.63444e-18
C345	a_221_74##11	B1#2	3.13041e-19
C346	VPWR	VNB	7.13593e-17
C347	VGND	VNB	7.398e-17
C348	VGND#5	VGND#9	5.32076e-19
C349	VPWR#2	VNB	4.66935e-17
C350	VGND#5	B1#3	6.70528e-19
C351	VGND#5	B1#1	3.80801e-18
C352	VPWR#4	VPWR#5	7.10261e-17
C353	VPWR#5	VNB	6.11978e-17
C354	VPWR#4	VPWR#2	4.45043e-17
C355	VPWR#5	B2#1	1.87389e-18
C356	a_61_392#	VPWR#5	1.39059e-17
C357	VGND#2	X#3	1.08285e-17
C358	VGND#2	VNB	4.94538e-17
C359	VGND#5	B1	1.65497e-18
C360	VPWR#2	a_221_74##2	2.6014e-20
C361	VGND#2	a_221_74##5	7.60438e-18
C362	VGND#5	VNB	4.71703e-17
C363	VPWR#5	B1#3	1.22591e-18
C364	VGND#3	VGND#2	1.05191e-18
C365	VGND#2	a_221_74##2	1.198e-19
C366	VPWR#3	VPWR#2	1.5702e-18
C367	a_221_74##6	VPWR#2	3.44796e-18
C368	a_61_392##2	VPWR#5	1.78179e-17
C369	VGND#2	A1_N#3	9.39451e-20
C370	VGND#5	B2#3	7.43555e-18
C371	VGND#5	a_221_74##11	1.9433e-18
C372	VGND#2	a_221_74##6	5.90093e-19
C373	VPWR#5	a_293_333##3	3.09161e-18
C374	a_221_74##9	VPWR#5	7.50122e-18
C375	VPWR#5	B1#2	2.29544e-21
C376	a_221_74##11	VPWR#5	3.35934e-19
C377	B1	VPWR#5	7.21288e-19
C378	VPWR	VPWR#2	3.56909e-17
C379	VGND	VGND#2	5.14047e-17
C380	VGND#5	B2	1.90495e-18
C381	VPWR#5	B2#2	6.02553e-20
C382	VPWR#5	B1#4	1.86856e-18
C383	VGND#4	VGND#5	4.94625e-17
C384	VPWR#2	a_221_74#	3.98337e-18
C385	VGND#2	a_221_74##3	2.06434e-20
C386	VGND	VGND#5	3.61761e-17
C387	VPWR	VPWR#5	4.51932e-17
C388	VGND#2	a_221_74##4	6.11254e-19
C389	VGND#4	VGND#2	4.7707e-17
*
*
.ENDS sky130_fd_sc_hs__a2bb2o_2
*
