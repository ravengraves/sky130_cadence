* Extracted by Quantus, converted by sky130cad/quantus.py
*
*
*
*                       LINUX           Wed Nov 18 08:49:09 2026
*
*
*
*  PROGRAM  advgen
*
*  Name           : advgen - Quantus - (64-bit)
*  Version        : 25.1.0-p047
*  Build Date     : Thu Dec 11 23:20:30 PST 2025
*
*  HSPICE LIBRARY
*
*  OPERATING_TEMPERATURE 150
*  QRC_TECH_DIR <path>/tech
*
*
*

*
.SUBCKT sky130_fd_sc_hs__nor2_4 VPB VNB VGND VPWR Y A B
*
*
*  caps2d version: 10
*
*
*       TRANSISTOR CARDS
*
*
XM6 VGND#3 A#8 Y#4 VNB sky130_fd_pr__nfet_01v8_lvt l=0.15 w=0.74 ad=0.2294 as=0.8436 pd=2.1 ps=3.76
XM9 Y#4 A#5 VGND#4 VNB sky130_fd_pr__nfet_01v8_lvt l=0.15 w=0.74 ad=0.8436 as=0.2442 pd=3.76 ps=2.14
XM2 VGND#4 B#8 Y#6 VNB sky130_fd_pr__nfet_01v8_lvt l=0.15 w=0.74 ad=0.2442 as=0.222 pd=2.14 ps=2.08
XM10 Y#6 B#5 VGND#1 VNB sky130_fd_pr__nfet_01v8_lvt l=0.15 w=0.74 ad=0.222 as=1.0138 pd=2.08 ps=4.22
XM0 a_27_368##6 A#10 VPWR#6 VPB sky130_fd_pr__pfet_01v8 l=0.15 w=1.12 ad=0.3304 as=0.336 pd=2.83 ps=2.84
XM3 a_27_368##8 A#9 VPWR#6 VPB sky130_fd_pr__pfet_01v8 l=0.15 w=1.12 ad=0.336 as=0.336 pd=2.84 ps=2.84
XM7 VPWR#5 A#6 a_27_368##8 VPB sky130_fd_pr__pfet_01v8 l=0.15 w=1.12 ad=0.336 as=0.336 pd=2.84 ps=2.84
XM8 VPWR#5 A#1 a_27_368##3 VPB sky130_fd_pr__pfet_01v8 l=0.15 w=1.12 ad=0.336 as=0.336 pd=2.84 ps=2.84
XM1 a_27_368##3 B#10 Y#5 VPB sky130_fd_pr__pfet_01v8 l=0.15 w=1.12 ad=0.336 as=0.336 pd=2.84 ps=2.84
XM4 Y#5 B#9 a_27_368##7 VPB sky130_fd_pr__pfet_01v8 l=0.15 w=1.12 ad=0.336 as=0.392 pd=2.84 ps=2.94
XM5 a_27_368##7 B#6 Y#1 VPB sky130_fd_pr__pfet_01v8 l=0.15 w=1.12 ad=0.392 as=0.392 pd=2.94 ps=2.94
XM11 Y#1 B#1 a_27_368# VPB sky130_fd_pr__pfet_01v8 l=0.15 w=1.12 ad=0.392 as=0.3976 pd=2.94 ps=2.95
*
*
*       RESISTOR AND CAP/DIODE CARDS
*
Rg1	A#1	A#2	568.858643
Rg2	A#2	A#3	67.132561
Rg3	A#3	A#4	52.285404
Rg4	A#2	A#5	390.265381
Rg5	A#3	A#6	476.975128
Rg6	A#4	A#7	94.937218
Rg7	A#7	A#8	322.953644
Rg8	A#4	A#9	486.547119
Rg9	A#7	A#10	507.075531
Rg10	B#1	B#2	509.190948
Rg11	B#2	B#3	77.878807
Rg12	B#3	B#4	90.026909
Rg13	B#4	B#5	319.959229
Rg14	B#3	B#6	476.975128
Rg15	B#4	B#7	66.386436
Rg16	B#7	B#8	322.953644
Rg17	B#4	B#9	504.081116
Rg18	B#7	B#10	507.075531
Rf1	A	A#11	14.119321
Rf2	A#11	A	2.823864
Rf3	Y#1	Y#2	82.967758
Rf4	Y#2	Y	19.591959
Rf5	Y	Y#3	14.142132
Rf6	Y#3	Y#4	74.128220
Rf7	Y#2	Y#5	24.864502
Rf8	Y#3	Y#6	14.766976
Rf9	a_27_368#	a_27_368##2	97.232872
Rf10	a_27_368##2	a_27_368##4	92.590553
Rf11	a_27_368##4	a_27_368##5	85.157799
Rf12	a_27_368##5	a_27_368##6	87.602989
Rf13	a_27_368##2	a_27_368##7	21.554951
Rf14	a_27_368##5	a_27_368##8	25.098005
Rf15	a_27_368##3	a_27_368##4	5.000000
Rf16	B	B#11	2.470881
Rf17	B#11	B	14.472304
Rf18	VGND#1	VGND#2	75.195351
Rf19	VGND#2	VGND#3	165.392654
Rf20	VGND#2	VGND#4	36.824379
Rf21	VPWR#1	VPWR#2	38.814804
Rf22	VPWR#2	VPWR#3	65.941528
Rf24	VPWR#2	VPWR#5	61.544025
Rf25	VPWR#3	VPWR#6	61.544025
Rf26	A#4	A#11	40.058201
Rf27	B#2	B#11	53.410934
Re1	VPWR#1	VPWR	1.091357
Re2	VGND	VGND#2	1.091398
*
*       CAPACITOR CARDS
*
*
C1	a_27_368##5	A#2	2.31052e-20
C2	a_27_368##2	B#4	7.78339e-20
C3	a_27_368##2	B#3	3.62874e-20
C4	a_27_368##5	VPWR#2	7.675e-19
C5	Y#2	B#7	3.33417e-18
C6	Y#2	B#4	6.3245e-18
C7	Y#2	B#3	1.69824e-18
C8	Y#2	A#7	2.81305e-19
C9	Y#2	A#2	1.1776e-18
C10	VGND#1	B#4	8.03363e-18
C11	VPWR#1	B#7	2.63675e-20
C12	VPWR#1	B#4	6.11725e-20
C13	VPWR#1	B#3	4.69341e-20
C14	B#3	VGND#1	1.02539e-17
C15	Y#2	a_27_368##2	4.05689e-19
C16	B#7	Y#6	5.28174e-19
C17	B#4	Y#6	3.72237e-19
C18	VGND#2	B#7	9.64294e-20
C19	VGND#2	B#4	4.6164e-20
C20	VGND#1	Y#3	7.18631e-17
C21	VGND#2	A#2	3.52683e-20
C22	VGND#1	Y#2	4.48269e-18
C23	Y#3	Y#6	5.78988e-19
C24	Y#3	VGND#4	6.00859e-17
C25	Y#4	Y#3	2.94759e-18
C26	B#3	B#2	4.01816e-18
C27	a_27_368##2	a_27_368#	1.46101e-18
C28	a_27_368##3	VPWR#2	2.22559e-18
C29	VGND#4	VGND#1	2.06089e-18
C30	a_27_368##2	Y#1	1.72002e-17
C31	a_27_368##2	a_27_368##7	9.89517e-19
C32	A#7	A#4	4.74226e-18
C33	Y#2	Y#1	7.94253e-19
C34	a_27_368##8	VPWR#2	8.44968e-18
C35	A#4	A#2	4.80129e-18
C36	a_27_368##2	Y#5	1.59922e-17
C37	Y#4	VGND#4	3.8419e-17
C38	A#7	Y#4	1.67322e-18
C39	Y#2	a_27_368##7	2.53524e-17
C40	a_27_368##5	VPWR#5	9.29392e-18
C41	VGND#3	VGND#4	3.08193e-19
C42	a_27_368##3	a_27_368##2	1.43757e-18
C43	Y#2	Y#5	1.40954e-19
C44	a_27_368##5	a_27_368##8	3.95309e-20
C45	Y#3	a_27_368##3	9.25709e-18
C46	VGND#3	Y#4	8.36142e-17
C47	A#2	Y#4	9.81623e-19
C48	a_27_368##3	Y#2	2.93602e-17
C49	a_27_368##5	VPWR#6	8.96986e-18
C50	VGND#3	A#7	6.01164e-20
C51	a_27_368#	Y#1	9.60434e-17
C52	a_27_368##7	a_27_368#	1.06142e-18
C53	Y#4	a_27_368##3	2.89479e-18
C54	B#7	B#4	3.89662e-18
C55	Y#3	B#5	2.07422e-17
C56	Y#1	a_27_368##7	6.44572e-17
C57	Y#5	Y#1	1.07978e-18
C58	Y#3	B#8	3.46189e-17
C59	Y#5	a_27_368##7	6.09455e-17
C60	B#5	VGND#1	2.81364e-17
C61	VPWR#2	B#1	4.24522e-20
C62	Y#3	A#5	1.536e-18
C63	B	B#3	1.80697e-17
C64	Y#1	B#3	6.62171e-19
C65	a_27_368##3	a_27_368##7	1.04439e-18
C66	B#5	Y#6	1.6128e-17
C67	VGND#1	B#8	9.76024e-19
C68	Y#3	A#8	1.43499e-19
C69	VPWR#2	B#6	6.23621e-20
C70	a_27_368##3	Y#5	7.72969e-17
C71	VGND#4	B#5	1.53598e-18
C72	B#8	Y#6	1.56829e-17
C73	VGND#3	a_27_368##6	3.95059e-19
C74	VGND#1	A#5	4.34349e-19
C75	B#8	VGND#4	2.05411e-17
C76	VPWR#2	B#9	1.86473e-19
C77	a_27_368##2	B#1	5.48547e-19
C78	a_27_368##3	VPWR#5	8.31869e-17
C79	Y#4	B#8	3.61382e-19
C80	a_27_368##7	B#4	5.04339e-19
C81	VGND#4	A#5	3.19598e-17
C82	A	B#7	7.30189e-18
C83	a_27_368##8	a_27_368##3	4.93988e-18
C84	VPWR#2	B#10	4.35193e-19
C85	A	A#7	2.22786e-17
C86	Y#4	A#5	3.61518e-17
C87	a_27_368##2	B#6	1.98245e-17
C88	Y#2	B#1	1.14106e-19
C89	a_27_368##7	B#3	4.99296e-19
C90	A	A#2	1.31835e-17
C91	VGND#4	A#8	5.59089e-19
C92	a_27_368##8	VPWR#5	6.83943e-17
C93	VGND#3	A#5	5.77028e-19
C94	A#8	Y#4	3.21264e-17
C95	VPWR#2	A#1	4.97762e-18
C96	Y#2	B#6	2.96271e-19
C97	B#4	B#3	4.07881e-18
C98	a_27_368##2	B#9	1.6075e-17
C99	VPWR#6	VPWR#5	1.87864e-18
C100	VGND#3	A#8	3.91186e-17
C101	VPWR#6	a_27_368##8	6.84668e-17
C102	Y#2	B#9	1.6231e-17
C103	a_27_368##2	B#10	2.65489e-19
C104	VPWR#2	A#6	7.28165e-18
C105	a_27_368##6	a_27_368##8	5.01824e-18
C106	Y	B#7	1.08989e-17
C107	Y	B#4	1.26188e-17
C108	Y#2	B#10	6.29599e-18
C109	a_27_368##2	A#1	1.14054e-19
C110	a_27_368##6	VPWR#6	7.74651e-17
C111	VPWR#2	A#9	5.30308e-19
C112	a_27_368##5	A#6	2.44523e-17
C113	Y	A#2	4.28563e-18
C114	a_27_368#	B#1	4.21851e-17
C115	Y#2	A#1	9.2765e-19
C116	Y#1	B#1	6.01579e-17
C117	VPWR#2	A#10	2.31528e-19
C118	a_27_368##5	A#9	2.45405e-17
C119	a_27_368#	B#6	7.57059e-19
C120	a_27_368##7	B#1	1.37791e-18
C121	Y#2	A#6	1.13987e-19
C122	Y#1	B#6	3.68728e-17
C123	a_27_368##3	B#7	7.88858e-20
C124	Y#5	B#1	8.28978e-20
C125	a_27_368##7	B#6	5.22615e-17
C126	Y#1	B#9	4.31172e-19
C127	B#8	B#5	3.30348e-17
C128	Y#2	A#9	7.07384e-20
C129	Y#5	B#6	1.19463e-18
C130	B#9	a_27_368##7	1.91791e-17
C131	a_27_368##3	B#6	1.93917e-19
C132	VPWR#1	VPWR#2	2.86484e-17
C133	Y#5	B#9	4.81288e-17
C134	Y#2	A#10	8.37218e-20
C135	A#5	B#8	3.04713e-17
C136	a_27_368##7	B#10	1.92877e-19
C137	a_27_368##3	B#9	4.55367e-19
C138	Y#5	B#10	4.07561e-17
C139	A#2	B#7	3.06514e-17
C140	a_27_368##7	A#1	8.28599e-20
C141	a_27_368##3	B#10	3.47187e-17
C142	A#8	A#5	3.30372e-18
C143	Y#5	A#1	1.15908e-18
C144	a_27_368##2	VPWR#1	7.04616e-17
C145	a_27_368##3	A#1	7.84685e-17
C146	a_27_368##3	A#2	1.05204e-18
C147	A#1	VPWR#5	2.34766e-17
C148	a_27_368##3	A#6	2.62812e-18
C149	a_27_368##8	A#1	2.49225e-18
C150	VGND	B#4	2.2407e-18
C151	VGND#2	Y#3	1.16068e-17
C152	VGND	B#3	1.21776e-20
C153	VGND	A#7	2.98872e-19
C154	A#6	VPWR#5	2.89199e-17
C155	VGND	A#2	3.17314e-19
C156	VPWR#6	A#1	1.53981e-19
C157	VPWR#2	A#4	4.24656e-20
C158	a_27_368##8	A#6	6.24562e-17
C159	a_27_368##2	B#2	9.4137e-20
C160	VGND#2	VGND#1	7.76189e-17
C161	VPWR#5	A#9	3.44144e-19
C162	VPWR#6	A#6	6.54315e-19
C163	a_27_368##5	A#4	6.47472e-18
C164	Y#2	B#2	2.68144e-19
C165	a_27_368##8	A#9	5.37203e-17
C166	a_27_368#	VPWR#1	5.06655e-17
C167	VPWR#5	A#10	1.53981e-19
C168	A#9	VPWR#6	2.43726e-17
C169	VGND#2	Y#4	3.57537e-17
C170	B#6	B#1	3.40171e-17
C171	B#2	VGND#1	1.93492e-17
C172	a_27_368##8	A#10	3.19159e-18
C173	VGND#2	VGND#3	4.51543e-17
C174	a_27_368##6	A#9	3.08115e-18
C175	Y#2	A#4	6.36636e-19
C176	A#10	VPWR#6	3.15179e-17
C177	VPWR#5	A#2	3.7537e-19
C178	a_27_368##6	A#10	6.86909e-17
C179	a_27_368##3	VPWR#1	4.51237e-17
C180	B#9	B#6	3.41577e-17
C181	B#7	VNB	2.17121e-17
C182	a_27_368#	B#2	5.45801e-18
C183	B#4	VNB	2.68922e-17
C184	B#3	VNB	2.564e-17
C185	A#7	VNB	3.89127e-17
C186	Y#1	B#2	3.15731e-18
C187	A#2	VNB	2.38285e-17
C188	A#4	Y#4	1.94776e-17
C189	B#10	B#9	4.87851e-17
C190	VGND#3	A#4	2.27661e-19
C191	A#1	B#10	4.90948e-17
C192	B	Y#2	1.39863e-17
C193	VPWR#5	A#4	4.25776e-19
C194	VGND#2	B#8	2.3616e-18
C195	A#6	A#1	4.92037e-17
C196	VGND#2	A#5	9.45063e-19
C197	A	a_27_368##5	7.81483e-17
C198	VGND#1	B	1.26439e-16
C199	VPWR#6	A#4	3.95829e-19
C200	VPWR#1	B#1	4.46303e-18
C201	VPWR#1	B#6	4.46319e-18
C202	A#9	A#6	4.78617e-17
C203	B	a_27_368#	2.55443e-17
C204	VPWR#1	B#9	4.47264e-18
C205	B	Y#1	5.38261e-17
C206	VPWR#1	B#10	4.47264e-18
C207	Y#4	A	1.16157e-16
C208	A#10	A#9	4.92814e-17
C209	VGND#3	A	4.05669e-17
C210	VPWR#1	A#1	1.34175e-18
C211	VPWR	VPWR#2	3.15141e-17
C212	VPWR#6	A#7	4.25776e-19
C213	VPWR	a_27_368##5	4.94734e-18
C214	A	a_27_368##3	1.50386e-17
C215	VPWR	a_27_368##2	2.90679e-17
C216	VPWR	Y#2	1.37579e-18
C217	A	a_27_368##6	5.22815e-17
C218	VGND	a_27_368##5	3.63958e-18
C219	VPWR	a_27_368#	2.19712e-17
C220	VGND	Y#3	1.9875e-17
C221	VPWR	Y#1	8.47646e-18
C222	VGND	Y#2	1.42102e-18
C223	VPWR	Y#5	8.72865e-18
C224	VGND	VGND#1	1.2702e-16
C225	Y	B#5	1.57845e-18
C226	VPWR#1	B#2	6.29607e-19
C227	VPWR	a_27_368##3	2.41231e-17
C228	Y	B#8	2.00864e-18
C229	VGND	VGND#4	1.62401e-17
C230	VGND	Y#4	3.96484e-17
C231	Y	A#5	1.2491e-18
C232	VPWR	a_27_368##8	1.62885e-17
C233	VPWR#2	VNB	2.14945e-17
C234	VGND	VGND#3	5.27507e-17
C235	Y	A#8	6.60774e-19
C236	VGND	a_27_368#	2.84287e-18
C237	VPWR	a_27_368##6	1.74508e-17
C238	a_27_368##5	VNB	2.39102e-18
C239	VGND	Y#1	2.71674e-18
C240	VGND#2	A#4	4.86538e-19
C241	a_27_368##2	VNB	5.23611e-18
C242	Y#3	VNB	4.35163e-18
C243	Y#2	VNB	2.71106e-18
C244	VGND	a_27_368##3	4.76256e-18
C245	VGND#1	VNB	1.13223e-16
C246	VGND#4	VNB	5.75344e-19
C247	Y#4	VNB	9.27165e-18
C248	VGND	a_27_368##6	3.75991e-18
C249	VPWR	B#1	2.32728e-18
C250	VGND#3	VNB	7.48348e-17
C251	VGND	B#5	4.6024e-19
C252	B	VPWR#1	4.62677e-19
C253	a_27_368#	VNB	5.2258e-17
C254	VPWR	B#6	1.60516e-18
C255	Y#1	VNB	5.76013e-18
C256	VGND	B#8	3.40863e-20
C257	a_27_368##6	A#7	1.14455e-18
C258	VPWR	B#9	1.60408e-18
C259	VGND	A#5	6.0855e-19
C260	VGND	A#8	5.10393e-19
C261	VPWR	B#10	1.52716e-18
C262	a_27_368##3	VNB	6.81176e-18
C263	VPWR#5	VNB	2.92383e-18
C264	B	B#2	3.84544e-17
C265	VPWR	A#1	2.46597e-18
C266	a_27_368##8	VNB	2.18579e-18
C267	VPWR#6	VNB	2.82484e-18
C268	VPWR	A#6	2.51606e-18
C269	a_27_368##6	VNB	6.01055e-17
C270	VPWR	A#9	2.51606e-18
C271	B#5	VNB	2.83347e-17
C272	B#8	VNB	2.43751e-17
C273	VPWR	A#10	1.98638e-18
C274	A#5	VNB	2.48815e-17
C275	A	A#4	3.71439e-17
C276	A#8	VNB	3.70521e-17
C277	VPWR	VPWR#1	4.81156e-17
C278	B#1	VNB	4.2811e-17
C279	B#6	VNB	3.58752e-17
C280	B#9	VNB	3.56739e-17
C281	B#10	VNB	3.66744e-17
C282	VPWR	B#2	6.81908e-19
C283	A#1	VNB	3.56738e-17
C284	A#6	VNB	3.71981e-17
C285	VGND	VGND#2	3.66669e-17
C286	A#9	VNB	3.67615e-17
C287	A#10	VNB	4.30327e-17
C288	Y	B	2.07345e-17
C289	VGND	A#4	1.19327e-18
C290	VPWR#1	VNB	2.67845e-16
C291	A	Y	1.3944e-17
C292	VPWR	B	7.28316e-18
C293	VGND#2	VNB	2.35546e-16
C294	B#2	VNB	6.41037e-17
C295	VPWR	A	7.22014e-18
C296	A#4	VNB	5.27398e-17
C297	VGND	B	8.44655e-18
C298	VGND	A	1.10278e-17
C299	B	VNB	3.67582e-17
C300	A	VNB	4.07106e-17
C301	Y	VNB	1.89418e-18
C302	VPWR	VNB	7.34863e-17
C303	VGND	VNB	5.84554e-17
C304	VPWR#3	VNB	4.40073e-17
C305	VPWR	VPWR#3	4.28527e-17
C306	VPWR#3	A#4	4.30395e-20
C307	VPWR#1	VPWR#3	5.09642e-17
C308	VPWR#3	A#10	5.49364e-18
C309	VPWR#3	A#9	7.28165e-18
C310	VPWR#3	A#6	5.30308e-19
C311	VPWR#3	A#1	8.1728e-20
C312	a_27_368##6	VPWR#3	2.10557e-17
C313	a_27_368##8	VPWR#3	8.4992e-18
C314	a_27_368##5	VPWR#3	7.675e-19
C315	VPWR#3	VPWR#2	6.93111e-19
*
*
.ENDS sky130_fd_sc_hs__nor2_4
*
