* Extracted by Quantus, converted by sky130cad/quantus.py
*
*
*
*                       LINUX           Wed Nov 18 08:35:46 2026
*
*
*
*  PROGRAM  advgen
*
*  Name           : advgen - Quantus - (64-bit)
*  Version        : 25.1.0-p047
*  Build Date     : Thu Dec 11 23:20:30 PST 2025
*
*  HSPICE LIBRARY
*
*  OPERATING_TEMPERATURE 150
*  QRC_TECH_DIR <path>/tech
*
*
*

*
.SUBCKT sky130_fd_sc_hs__ebufn_2 VPB VNB VGND VPWR Z TE_B A
*
*
*  caps2d version: 10
*
*
*       TRANSISTOR CARDS
*
*
XM1 Z#2 a_84_48##5 a_27_74##4 VNB sky130_fd_pr__nfet_01v8_lvt l=0.15 w=0.74 ad=0.2072 as=0.2109 pd=2.04 ps=2.05
XM11 a_27_74##2 a_84_48##6 Z#2 VNB sky130_fd_pr__nfet_01v8_lvt l=0.15 w=0.74 ad=0.3071 as=0.2072 pd=2.31 ps=2.04
XM9 VGND#7 a_283_48##3 a_27_74##2 VNB sky130_fd_pr__nfet_01v8_lvt l=0.15 w=0.74 ad=0.2109 as=0.3071 pd=2.05 ps=2.31
XM6 a_27_74# a_283_48##4 VGND#7 VNB sky130_fd_pr__nfet_01v8_lvt l=0.15 w=0.74 ad=0.2109 as=0.2109 pd=2.05 ps=2.05
XM7 a_283_48##5 TE_B#1 VGND#6 VNB sky130_fd_pr__nfet_01v8_lvt l=0.15 w=0.64 ad=0.1824 as=0.2688 pd=1.85 ps=2.12
XM3 VGND#6 A#3 a_84_48##8 VNB sky130_fd_pr__nfet_01v8_lvt l=0.15 w=0.64 ad=0.2688 as=0.1824 pd=2.12 ps=1.85
XM4 a_33_368##4 a_84_48##7 Z#3 VPB sky130_fd_pr__pfet_01v8 l=0.15 w=1.12 ad=0.3304 as=0.392 pd=2.83 ps=2.94
XM8 Z#3 a_84_48# a_33_368##2 VPB sky130_fd_pr__pfet_01v8 l=0.15 w=1.12 ad=0.392 as=0.392 pd=2.94 ps=2.94
XM0 VPWR#7 TE_B#5 a_33_368##2 VPB sky130_fd_pr__pfet_01v8 l=0.15 w=1.12 ad=0.5815 as=0.392 pd=3.56 ps=2.94
XM10 a_33_368# TE_B#7 VPWR#7 VPB sky130_fd_pr__pfet_01v8 l=0.15 w=1.12 ad=0.3304 as=0.5815 pd=2.83 ps=3.56
XM2 a_283_48##7 TE_B#6 VPWR#6 VPB sky130_fd_pr__pfet_01v8 l=0.15 w=1 ad=0.295 as=0.5 pd=2.59 ps=3
XM5 VPWR#6 A#1 a_84_48##9 VPB sky130_fd_pr__pfet_01v8 l=0.15 w=1 ad=0.5 as=0.295 pd=3 ps=2.59
*
*
*       RESISTOR AND CAP/DIODE CARDS
*
Rg1	a_84_48#	a_84_48##2	458.595978
Rg2	a_84_48##2	a_84_48##3	23.018295
Rg3	a_84_48##3	a_84_48##4	67.622208
Rg4	a_84_48##4	a_84_48##5	367.764618
Rg5	a_84_48##3	a_84_48##6	363.093384
Rg6	a_84_48##4	a_84_48##7	471.250305
Rg7	a_283_48#	a_283_48##2	419.186768
Rg8	a_283_48##2	a_283_48##3	476.077545
Rg9	a_283_48##2	a_283_48##4	262.702026
Rg10	TE_B#1	TE_B#2	394.016998
Rg11	TE_B#2	TE_B#3	31.374666
Rg12	TE_B#3	TE_B#4	460.909943
Rg13	TE_B#4	TE_B#5	694.865845
Rg14	TE_B#3	TE_B#6	369.571381
Rg15	TE_B#4	TE_B#7	385.612793
Rg16	A#1	A#2	396.069458
Rg17	A#2	A#3	407.094757
Rf1	Z	Z#1	8.393542
Rf2	Z#1	Z#2	93.779106
Rf3	Z#1	Z#3	25.482611
Rf4	a_27_74#	a_27_74##3	87.945633
Rf5	a_27_74##3	a_27_74##4	102.240906
Rf6	a_27_74##2	a_27_74##3	7.500000
Rf7	a_33_368#	a_33_368##3	79.704376
Rf8	a_33_368##3	a_33_368##4	99.044327
Rf9	a_33_368##2	a_33_368##3	7.500000
Rf10	a_283_48##5	a_283_48#	16.239082
Rf11	a_283_48#	a_283_48##7	73.082176
Rf12	TE_B	TE_B#2	167.712585
Rf13	A#4	A#2	161.760818
Rf14	A	A#6	1.528014
Rf15	A#4	A#6	5.161376
Rf16	a_84_48##8	a_84_48##10	109.970825
Rf17	a_84_48##10	a_84_48##2	388.464752
Rf18	a_84_48##9	a_84_48##10	5.000000
Rf20	VPWR#2	VPWR#3	95.265945
Rf21	VPWR#3	VPWR#4	22.986374
Rf23	VPWR#2	VPWR#6	30.131420
Rf24	VPWR#4	VPWR#7	24.468842
Rf26	VGND#2	VGND#3	98.228386
Rf27	VGND#3	VGND#4	35.827560
Rf29	VGND#2	VGND#6	31.337896
Rf30	VGND#4	VGND#7	42.655182
Re1	VPWR#3	VPWR	1.091357
Re2	VGND	VGND#3	1.091398
*
*       CAPACITOR CARDS
*
*
C1	TE_B#3	A#1	8.44277e-20
C2	a_283_48##2	TE_B#5	6.22962e-18
C3	Z#1	a_84_48##4	1.60519e-17
C4	a_84_48##3	TE_B#5	1.06711e-17
C5	Z#1	a_84_48##3	4.48644e-18
C6	a_84_48##8	TE_B#3	9.32651e-19
C7	a_27_74#	TE_B#4	1.18733e-18
C8	VPWR#3	TE_B#4	1.13854e-19
C9	a_283_48##2	TE_B#4	2.77615e-17
C10	VPWR#3	TE_B#3	1.24927e-19
C11	a_27_74#	a_283_48##2	6.10501e-18
C12	VGND#3	TE_B#4	5.30431e-19
C13	VGND#3	TE_B#3	1.87714e-20
C14	VGND#7	a_283_48##2	5.69137e-19
C15	VGND#3	a_283_48##2	4.94532e-19
C16	a_84_48##8	A#4	2.37834e-17
C17	VGND#6	A#4	1.21837e-17
C18	TE_B#3	A#2	3.06701e-17
C19	a_27_74##2	a_283_48##2	7.69689e-19
C20	a_27_74##2	a_84_48##3	3.97441e-18
C21	a_84_48##3	TE_B#3	2.23578e-19
C22	Z#2	a_84_48##4	6.88986e-18
C23	VGND#6	a_84_48##8	5.81785e-17
C24	Z#2	a_84_48##3	1.29667e-18
C25	A#6	a_84_48##9	3.3132e-17
C26	a_283_48#	TE_B#4	1.78064e-17
C27	a_283_48#	TE_B#3	2.51121e-17
C28	a_283_48#	a_84_48##4	4.94584e-20
C29	A#4	a_84_48##9	4.73359e-18
C30	a_283_48#	a_84_48##3	2.66301e-19
C31	a_27_74##4	a_84_48##4	2.53053e-19
C32	a_283_48##7	A#6	5.02508e-18
C33	a_84_48##9	TE_B#4	1.69092e-18
C34	a_27_74##4	a_84_48##3	9.76305e-20
C35	a_84_48##9	TE_B#3	1.29576e-18
C36	VGND#7	VGND#6	1.15943e-19
C37	a_84_48##2	TE_B#4	1.90705e-17
C38	a_84_48##4	a_84_48##3	3.17024e-18
C39	Z#2	Z#1	5.47496e-18
C40	a_84_48##2	TE_B#3	4.21946e-19
C41	a_84_48##2	a_283_48##2	1.26606e-17
C42	a_84_48##2	a_84_48##4	3.89852e-20
C43	a_84_48##2	a_84_48##3	2.94219e-17
C44	a_27_74#	VGND#7	4.43803e-17
C45	a_27_74##2	a_27_74#	2.7908e-18
C46	a_84_48##8	a_84_48##9	2.31423e-18
C47	a_27_74##2	VGND#7	5.74914e-17
C48	VGND#6	a_84_48##9	3.78707e-18
C49	a_283_48##7	TE_B#4	1.03457e-17
C50	a_27_74##2	Z#2	5.46725e-17
C51	a_283_48##7	TE_B#3	1.78753e-17
C52	a_27_74##4	a_27_74##2	2.9318e-18
C53	a_27_74##4	Z#2	7.22758e-17
C54	Z#1	a_33_368##2	3.24149e-18
C55	TE_B#4	a_33_368#	1.70133e-18
C56	a_283_48##7	a_84_48##3	5.17063e-20
C57	Z#1	Z#3	4.62368e-18
C58	Z#1	a_33_368##4	1.03099e-17
C59	a_84_48##9	VPWR#6	7.03813e-17
C60	a_84_48##8	A#3	3.56437e-17
C61	TE_B#4	VPWR#7	1.93347e-19
C62	a_84_48##9	a_283_48##7	7.93862e-17
C63	A#3	VGND#6	2.3411e-17
C64	a_84_48##8	TE_B#1	4.4909e-19
C65	a_84_48##9	a_33_368#	3.14839e-17
C66	TE_B#1	VGND#6	2.4578e-17
C67	a_33_368#	VPWR#6	1.10282e-17
C68	TE_B#1	a_283_48##5	7.98637e-18
C69	VGND#6	a_283_48##4	4.84075e-19
C70	VGND#7	A#3	1.16189e-20
C71	A#6	A#1	3.28378e-18
C72	a_283_48##7	a_33_368#	2.39629e-19
C73	a_33_368##2	TE_B#4	4.28097e-19
C74	VGND#6	a_283_48##3	8.23026e-20
C75	VGND#7	TE_B#1	3.57112e-20
C76	a_27_74##4	a_33_368##4	6.89436e-18
C77	a_27_74#	a_283_48##4	4.25952e-17
C78	a_33_368#	VPWR#7	1.05359e-18
C79	a_283_48##4	VGND#7	1.43616e-17
C80	a_27_74#	a_283_48##3	1.35131e-18
C81	a_33_368##2	a_33_368#	2.46004e-18
C82	a_27_74##2	a_283_48##4	4.46888e-19
C83	VGND#7	a_283_48##3	2.70078e-17
C84	a_27_74#	a_84_48##6	2.13261e-19
C85	a_33_368##2	VPWR#7	1.52626e-18
C86	a_27_74##2	a_283_48##3	2.86606e-17
C87	VGND#7	a_84_48##6	6.25174e-19
C88	a_33_368##2	a_84_48##3	3.7761e-19
C89	Z#2	a_283_48##3	1.00588e-18
C90	a_27_74##2	a_84_48##6	3.91999e-17
C91	a_27_74##4	a_283_48##3	2.28706e-19
C92	a_33_368##2	Z#3	4.86401e-17
C93	Z#2	a_84_48##6	3.36563e-17
C94	a_27_74##2	a_84_48##5	1.10712e-18
C95	a_33_368##4	a_33_368##2	2.66286e-18
C96	a_27_74##4	a_84_48##6	1.02151e-18
C97	Z#2	a_84_48##5	3.02152e-17
C98	a_33_368##4	Z#3	7.7255e-17
C99	a_84_48##4	Z#3	3.09154e-20
C100	a_27_74##4	a_84_48##5	3.42043e-17
C101	Z#1	TE_B#5	2.5911e-19
C102	Z#1	a_84_48#	1.60919e-17
C103	a_33_368##2	a_283_48##3	4.02347e-19
C104	TE_B	TE_B#3	3.01556e-17
C105	a_84_48##9	A#1	5.68513e-17
C106	TE_B#1	A#3	2.25255e-17
C107	TE_B	a_84_48##3	2.37525e-19
C108	Z#1	a_84_48##7	1.71405e-17
C109	A#1	VPWR#6	3.55705e-17
C110	a_33_368##4	a_84_48##4	5.71283e-20
C111	a_84_48##9	TE_B#6	3.35052e-17
C112	a_283_48##7	A#1	3.65577e-18
C113	a_33_368##4	a_84_48##3	1.4466e-19
C114	VPWR#6	TE_B#6	4.31695e-17
C115	a_283_48##4	TE_B#1	6.65015e-19
C116	a_33_368#	A#1	3.75254e-19
C117	a_84_48##9	TE_B#7	5.67423e-19
C118	a_283_48##7	TE_B#6	2.94534e-17
C119	A#6	A#2	7.46273e-18
C120	VPWR#6	TE_B#7	3.3241e-18
C121	TE_B#3	A#3	5.30373e-19
C122	a_33_368#	TE_B#6	5.7244e-18
C123	a_283_48##7	TE_B#7	6.5367e-18
C124	A#4	A#2	1.2211e-17
C125	a_283_48##3	a_283_48##4	3.34004e-17
C126	Z	TE_B#4	1.70956e-18
C127	VPWR#6	TE_B#5	3.3242e-19
C128	a_33_368#	TE_B#7	6.13995e-17
C129	Z	a_84_48##3	1.58652e-18
C130	a_33_368##2	TE_B#6	1.08126e-19
C131	TE_B#7	VPWR#7	2.88803e-17
C132	a_33_368#	TE_B#5	7.33287e-19
C133	a_84_48##6	a_283_48##3	2.22516e-17
C134	a_33_368##2	TE_B#7	2.62977e-18
C135	TE_B#5	VPWR#7	2.2748e-17
C136	Z#3	TE_B#7	3.43499e-19
C137	a_84_48##8	A#2	7.46602e-18
C138	VGND#3	a_27_74#	1.36893e-17
C139	a_33_368##2	TE_B#5	6.22123e-17
C140	VGND#6	A#2	3.00542e-18
C141	a_84_48##5	a_84_48##6	3.86917e-17
C142	Z#3	TE_B#5	1.53215e-18
C143	a_33_368##2	a_84_48#	3.93252e-17
C144	a_33_368##4	TE_B#5	1.98955e-19
C145	a_84_48##9	VPWR#3	2.19567e-18
C146	VPWR	TE_B#4	2.86391e-20
C147	Z#3	a_84_48#	4.34285e-17
C148	a_33_368##2	a_84_48##7	8.06933e-19
C149	a_33_368##4	a_84_48#	2.07304e-18
C150	a_283_48#	a_84_48##8	1.09005e-18
C151	a_84_48##7	Z#3	2.0799e-17
C152	a_33_368#	VPWR#3	1.88402e-17
C153	a_283_48#	VGND#6	6.2692e-17
C154	a_33_368##4	a_84_48##7	5.96929e-17
C155	a_283_48#	a_283_48##5	3.86059e-18
C156	Z#1	a_84_48##2	4.58916e-17
C157	a_84_48##9	A#2	6.39657e-18
C158	a_27_74#	a_283_48#	9.00268e-17
C159	a_283_48##3	TE_B#5	1.30766e-17
C160	A#2	VPWR#6	1.96543e-18
C161	VGND#7	a_283_48#	1.22894e-18
C162	a_283_48##7	A#2	2.89118e-19
C163	TE_B#6	A#1	2.13207e-17
C164	Z#2	a_283_48#	7.32653e-19
C165	a_27_74#	a_84_48##2	4.00085e-17
C166	VGND	TE_B#4	7.34845e-19
C167	a_84_48##2	a_27_74##2	6.92979e-17
C168	a_84_48##9	a_283_48#	3.45799e-19
C169	VGND	a_283_48##2	4.45949e-19
C170	VGND	a_84_48##4	4.10841e-19
C171	Z#2	a_84_48##2	1.25325e-17
C172	VGND	a_84_48##3	1.46473e-18
C173	TE_B#7	TE_B#6	6.22762e-18
C174	a_283_48#	a_283_48##7	4.15011e-18
C175	VGND#3	a_283_48##4	1.7669e-18
C176	TE_B#5	TE_B#7	2.33405e-17
C177	a_84_48##2	a_283_48##7	3.54378e-17
C178	a_84_48##2	a_33_368#	2.96609e-17
C179	A#6	TE_B#3	2.88296e-18
C180	a_84_48#	TE_B#5	3.52089e-17
C181	a_84_48##2	a_33_368##2	6.83393e-18
C182	a_283_48#	A#3	3.3431e-19
C183	a_84_48##2	Z#3	3.47511e-18
C184	a_283_48#	TE_B#1	5.42582e-17
C185	a_283_48##4	a_283_48#	2.84804e-17
C186	TE_B#4	VNB	2.62592e-17
C187	a_84_48##7	a_84_48#	3.32866e-17
C188	TE_B#3	VNB	4.77431e-17
C189	a_283_48##2	VNB	2.41774e-17
C190	VPWR#3	TE_B#7	4.98336e-18
C191	a_84_48##4	VNB	3.85909e-17
C192	a_84_48##3	VNB	4.42838e-17
C193	a_283_48#	a_283_48##3	3.07201e-19
C194	a_283_48#	a_84_48##6	1.05521e-20
C195	a_84_48##2	a_283_48##3	9.88147e-18
C196	a_283_48#	a_84_48##5	1.01826e-20
C197	a_84_48##3	a_283_48##3	1.34939e-17
C198	TE_B	A#6	6.29206e-18
C199	TE_B	A#4	2.04835e-17
C200	a_84_48##2	A#1	3.21827e-19
C201	a_84_48##2	TE_B#6	1.01469e-18
C202	TE_B	a_84_48##8	6.06899e-18
C203	a_84_48##2	TE_B#7	3.13816e-17
C204	a_84_48##2	TE_B#5	1.80099e-17
C205	a_84_48##2	a_84_48#	3.8611e-19
C206	TE_B	a_84_48##9	5.66751e-18
C207	VPWR	A#6	4.14557e-18
C208	a_283_48##7	TE_B	3.30327e-17
C209	VGND#3	a_283_48#	2.69755e-17
C210	VPWR	Z#1	2.96878e-18
C211	Z	VPWR#7	2.94821e-18
C212	VGND	A#4	3.89839e-18
C213	A#4	TE_B#3	3.64091e-18
C214	Z	a_33_368##2	4.41288e-17
C215	a_84_48##2	a_283_48#	1.20715e-17
C216	VPWR	a_84_48##9	3.062e-17
C217	VGND	Z#1	1.45304e-18
C218	VPWR	VPWR#6	2.48529e-17
C219	VGND	a_84_48##8	1.95581e-17
C220	VPWR	a_283_48##7	6.4328e-18
C221	VGND	VGND#6	2.03607e-17
C222	VPWR	a_33_368#	1.86112e-17
C223	VGND	a_27_74#	1.46829e-17
C224	VPWR	a_33_368##2	2.415e-17
C225	Z	a_283_48##3	6.24472e-19
C226	VGND	a_27_74##2	2.28466e-17
C227	VPWR	Z#3	8.71159e-18
C228	VGND	Z#2	7.5162e-18
C229	A#6	VNB	3.62685e-18
C230	VPWR	a_33_368##4	2.61895e-17
C231	VGND	a_27_74##4	2.30447e-17
C232	A#4	VNB	2.44721e-18
C233	VGND	a_283_48##7	1.25929e-18
C234	Z#1	VNB	1.80484e-17
C235	a_84_48##8	VNB	5.73202e-17
C236	VGND#6	VNB	4.36509e-18
C237	Z	TE_B#7	3.62865e-18
C238	a_27_74#	VNB	1.66097e-18
C239	Z	TE_B#5	2.27803e-17
C240	VGND#7	VNB	2.05446e-19
C241	a_27_74##2	VNB	5.15102e-18
C242	VGND	A#3	2.01842e-18
C243	Z	a_84_48#	9.09233e-18
C244	VPWR	A#1	7.43629e-18
C245	Z#2	VNB	5.49889e-18
C246	VGND	TE_B#1	1.51252e-18
C247	a_27_74##4	VNB	5.53152e-17
C248	VPWR	TE_B#6	4.30425e-18
C249	VGND	a_283_48##4	1.06359e-18
C250	a_84_48##9	VNB	6.64119e-17
C251	VPWR#6	VNB	9.85572e-18
C252	VGND	a_283_48##3	6.69907e-19
C253	VPWR	TE_B#7	4.54296e-19
C254	TE_B	A#2	6.11641e-18
C255	a_283_48##7	VNB	5.48174e-18
C256	VGND	a_84_48##6	1.81523e-18
C257	VPWR	TE_B#5	4.1488e-19
C258	a_33_368#	VNB	4.65454e-18
C259	VGND	a_84_48##5	3.04926e-18
C260	VPWR	a_84_48#	1.52443e-18
C261	a_33_368##2	VNB	2.62649e-18
C262	VPWR	a_84_48##7	2.34384e-18
C263	a_283_48#	TE_B	5.18947e-17
C264	a_33_368##4	VNB	4.77961e-17
C265	A#3	VNB	3.55008e-17
C266	TE_B#1	VNB	3.59872e-17
C267	VPWR	VPWR#3	1.63335e-17
C268	a_283_48##4	VNB	2.70878e-17
C269	a_283_48##3	VNB	3.46087e-17
C270	a_84_48##6	VNB	2.82672e-17
C271	a_84_48##5	VNB	3.57018e-17
C272	a_84_48##2	Z	9.76438e-17
C273	A#1	VNB	4.18346e-17
C274	TE_B#6	VNB	3.73085e-17
C275	TE_B#7	VNB	4.11426e-17
C276	VGND	VGND#3	1.74541e-17
C277	VPWR	a_84_48##2	8.95626e-18
C278	TE_B#5	VNB	5.01411e-17
C279	a_84_48#	VNB	3.35638e-17
C280	a_84_48##7	VNB	5.29571e-17
C281	VGND	a_283_48#	3.83529e-17
C282	VPWR#3	VNB	2.08651e-16
C283	VGND	a_84_48##2	7.63551e-18
C284	VGND#3	VNB	2.12368e-16
C285	A#2	VNB	4.40073e-17
C286	a_283_48#	VNB	7.7249e-17
C287	a_84_48##2	VNB	5.2695e-18
C288	VPWR	TE_B	3.05964e-18
C289	VPWR	Z	4.55623e-18
C290	VGND	TE_B	4.86135e-18
C291	VGND	Z	2.92358e-18
C292	TE_B	VNB	1.81265e-18
C293	Z	VNB	1.73842e-18
C294	VPWR	VNB	7.2109e-17
C295	VGND	VNB	7.24605e-17
C296	VGND#2	a_84_48##8	2.25734e-17
C297	VGND	VGND#4	6.08028e-17
C298	VPWR#4	TE_B#4	2.622e-19
C299	VGND#2	A#3	4.70848e-18
C300	VGND#4	a_27_74##4	5.39749e-17
C301	VPWR#4	a_84_48#	4.91538e-18
C302	VGND#4	a_27_74#	5.17368e-19
C303	a_33_368#	VPWR#4	2.40399e-17
C304	VGND#4	a_283_48##4	5.18946e-18
C305	VPWR#3	VPWR#2	6.78619e-17
C306	VPWR#2	TE_B#6	3.13904e-18
C307	VPWR#4	a_84_48##3	8.65325e-20
C308	VPWR#4	TE_B#5	1.10082e-17
C309	VGND#4	a_84_48##5	4.66027e-18
C310	VGND#3	VGND#2	6.52626e-17
C311	VPWR#2	A#1	2.15118e-18
C312	a_33_368##4	VPWR#4	5.97807e-17
C313	VGND#4	VGND#2	2.2572e-19
C314	VGND#4	TE_B#1	2.61335e-19
C315	VPWR#4	a_84_48##4	1.9605e-20
C316	VGND#2	A#4	4.12191e-19
C317	VPWR#2	VNB	6.32558e-17
C318	VPWR#4	TE_B#7	7.2613e-18
C319	VGND#2	TE_B#3	1.55687e-19
C320	VPWR#4	VPWR#6	8.29068e-19
C321	VPWR#4	VNB	7.53338e-17
C322	VPWR#3	VPWR#4	8.5571e-17
C323	VGND#4	a_84_48##3	6.81934e-20
C324	VGND#4	a_27_74##2	5.18734e-17
C325	VPWR#4	a_283_48##3	7.23778e-20
C326	VGND#4	a_84_48##6	5.09773e-18
C327	VGND#2	a_283_48#	2.07209e-17
C328	VGND#4	VGND#6	8.99216e-20
C329	VPWR#4	VPWR#2	5.22469e-19
C330	VGND#2	TE_B	1.08488e-18
C331	VGND#4	A#3	1.2759e-19
C332	VGND#2	VNB	5.83895e-17
C333	VGND#3	VGND#4	8.17488e-17
C334	VGND#4	VNB	7.04614e-17
C335	a_33_368##2	VPWR#4	7.63535e-17
C336	VPWR	VPWR#2	4.79501e-17
C337	VGND#2	TE_B#1	7.47364e-18
C338	VGND#4	a_84_48##4	2.75876e-20
C339	VGND#4	a_283_48##3	4.69308e-18
C340	VPWR	VPWR#4	5.81379e-17
C341	VPWR#4	a_84_48##7	4.66932e-18
C342	a_84_48##9	VPWR#2	1.81995e-17
C343	VGND	VGND#2	4.39816e-17
C344	VPWR#2	TE_B#3	2.2938e-19
C345	VPWR#4	VPWR#7	9.37741e-18
*
*
.ENDS sky130_fd_sc_hs__ebufn_2
*
