* Extracted by Quantus, converted by sky130cad/quantus.py
*
*
*
*                       LINUX           Wed Nov 18 08:49:12 2026
*
*
*
*  PROGRAM  advgen
*
*  Name           : advgen - Quantus - (64-bit)
*  Version        : 25.1.0-p047
*  Build Date     : Thu Dec 11 23:20:30 PST 2025
*
*  HSPICE LIBRARY
*
*  OPERATING_TEMPERATURE 150
*  QRC_TECH_DIR <path>/tech
*
*
*

*
.SUBCKT sky130_fd_sc_hs__nor2_8 VPB VNB VGND VPWR Y B A
*
*
*  caps2d version: 10
*
*
*       TRANSISTOR CARDS
*
*
XM17 VGND#13 A#19 Y#12 VNB sky130_fd_pr__nfet_01v8_lvt l=0.15 w=0.74 ad=0.7881 as=0.259 pd=3.61 ps=2.18
XM18 Y#12 A#16 VGND#12 VNB sky130_fd_pr__nfet_01v8_lvt l=0.15 w=0.74 ad=0.259 as=0.555 pd=2.18 ps=2.98
XM23 VGND#12 A#14 Y#10 VNB sky130_fd_pr__nfet_01v8_lvt l=0.15 w=0.74 ad=0.555 as=0.259 pd=2.98 ps=2.18
XM11 Y#10 A#12 VGND#11 VNB sky130_fd_pr__nfet_01v8_lvt l=0.15 w=0.74 ad=0.259 as=0.259 pd=2.18 ps=2.18
XM1 Y#4 B#12 VGND#11 VNB sky130_fd_pr__nfet_01v8_lvt l=0.15 w=0.74 ad=0.7141 as=0.259 pd=3.41 ps=2.18
XM19 VGND#10 B#19 Y#4 VNB sky130_fd_pr__nfet_01v8_lvt l=0.15 w=0.74 ad=0.3108 as=0.7141 pd=2.32 ps=3.41
XM10 Y#6 B#17 VGND#10 VNB sky130_fd_pr__nfet_01v8_lvt l=0.15 w=0.74 ad=0.2072 as=0.3108 pd=2.04 ps=2.32
XM12 VGND#9 B#15 Y#6 VNB sky130_fd_pr__nfet_01v8_lvt l=0.15 w=0.74 ad=0.2627 as=0.2072 pd=2.19 ps=2.04
XM22 a_27_368##10 A#11 VPWR#9 VPB sky130_fd_pr__pfet_01v8 l=0.15 w=1.12 ad=0.3304 as=0.392 pd=2.83 ps=2.94
XM20 a_27_368##16 A#21 VPWR#9 VPB sky130_fd_pr__pfet_01v8 l=0.15 w=1.12 ad=0.336 as=0.392 pd=2.84 ps=2.94
XM8 VPWR#7 A#20 a_27_368##16 VPB sky130_fd_pr__pfet_01v8 l=0.15 w=1.12 ad=0.336 as=0.336 pd=2.84 ps=2.84
XM13 VPWR#7 A#18 a_27_368##15 VPB sky130_fd_pr__pfet_01v8 l=0.15 w=1.12 ad=0.336 as=0.336 pd=2.84 ps=2.84
XM6 VPWR#5 A#17 a_27_368##15 VPB sky130_fd_pr__pfet_01v8 l=0.15 w=1.12 ad=0.392 as=0.336 pd=2.94 ps=2.84
XM15 a_27_368##14 A#15 VPWR#5 VPB sky130_fd_pr__pfet_01v8 l=0.15 w=1.12 ad=0.336 as=0.392 pd=2.84 ps=2.94
XM0 a_27_368##14 A#13 VPWR#3 VPB sky130_fd_pr__pfet_01v8 l=0.15 w=1.12 ad=0.336 as=0.448 pd=2.84 ps=3.04
XM4 VPWR#3 A#1 a_27_368##5 VPB sky130_fd_pr__pfet_01v8 l=0.15 w=1.12 ad=0.448 as=0.336 pd=3.04 ps=2.84
XM5 a_27_368##5 B#22 Y#11 VPB sky130_fd_pr__pfet_01v8 l=0.15 w=1.12 ad=0.336 as=0.392 pd=2.84 ps=2.94
XM21 a_27_368##13 B#21 Y#11 VPB sky130_fd_pr__pfet_01v8 l=0.15 w=1.12 ad=0.392 as=0.392 pd=2.94 ps=2.94
XM7 Y#8 B#20 a_27_368##13 VPB sky130_fd_pr__pfet_01v8 l=0.15 w=1.12 ad=0.336 as=0.392 pd=2.84 ps=2.94
XM3 a_27_368##12 B#18 Y#8 VPB sky130_fd_pr__pfet_01v8 l=0.15 w=1.12 ad=0.336 as=0.336 pd=2.84 ps=2.84
XM2 a_27_368##12 B#16 Y#7 VPB sky130_fd_pr__pfet_01v8 l=0.15 w=1.12 ad=0.336 as=0.336 pd=2.84 ps=2.84
XM16 Y#7 B#14 a_27_368##11 VPB sky130_fd_pr__pfet_01v8 l=0.15 w=1.12 ad=0.336 as=0.392 pd=2.84 ps=2.94
XM9 Y#1 B#13 a_27_368##11 VPB sky130_fd_pr__pfet_01v8 l=0.15 w=1.12 ad=0.336 as=0.392 pd=2.84 ps=2.94
XM14 Y#1 B#1 a_27_368# VPB sky130_fd_pr__pfet_01v8 l=0.15 w=1.12 ad=0.336 as=0.3864 pd=2.84 ps=2.93
*
*
*       RESISTOR AND CAP/DIODE CARDS
*
Rg1	A#1	A#2	426.670685
Rg2	A#2	A#3	57.827347
Rg3	A#3	A#4	22.901611
Rg4	A#4	A#5	67.211143
Rg5	A#5	A#6	61.971390
Rg6	A#6	A#7	62.604244
Rg7	A#7	A#8	24.260521
Rg8	A#8	A#9	175.388519
Rg9	A#9	A#10	214.351181
Rg10	A#10	A#11	626.002380
Rg11	A#2	A#12	376.075470
Rg12	A#3	A#13	409.423920
Rg13	A#4	A#14	409.541138
Rg14	A#5	A#15	429.900116
Rg15	A#6	A#16	433.945770
Rg16	A#6	A#17	448.292297
Rg17	A#7	A#18	409.423920
Rg18	A#8	A#19	406.487701
Rg19	A#9	A#20	385.612793
Rg20	A#10	A#21	385.612793
Rg21	B#1	B#2	619.145020
Rg22	B#2	B#3	14.346365
Rg23	B#3	B#4	287.006287
Rg24	B#4	B#5	142.058319
Rg25	B#5	B#6	73.836411
Rg26	B#6	B#7	112.269272
Rg27	B#7	B#8	75.886009
Rg28	B#8	B#9	172.421280
Rg29	B#9	B#10	225.421448
Rg30	B#10	B#11	220.395599
Rg31	B#11	B#12	445.694244
Rg32	B#3	B#13	583.699280
Rg33	B#4	B#14	556.550232
Rg34	B#5	B#15	278.631012
Rg35	B#6	B#16	400.390808
Rg36	B#7	B#17	268.627838
Rg37	B#8	B#18	395.156311
Rg38	B#9	B#19	353.903290
Rg39	B#9	B#20	462.937073
Rg40	B#10	B#21	556.550232
Rg41	B#11	B#22	414.368347
Rf1	A	A#22	3.056027
Rf2	A#22	A	11.612904
Rf3	Y#1	Y#2	111.146217
Rf4	Y#2	Y#3	31.055914
Rf5	Y#3	Y	17.848484
Rf6	Y	Y#5	11.162811
Rf7	Y#2	Y#6	36.823551
Rf8	Y#2	Y#7	47.690155
Rf9	Y#3	Y#8	29.691940
Rf10	Y	Y#9	71.994041
Rf11	Y#9	Y#10	18.149860
Rf12	Y	Y#11	29.704142
Rf13	Y#9	Y#12	117.180099
Rf14	Y#4	Y#5	2.500000
Rf15	B	B#23	4.724072
Rf16	B#23	B	9.841817
Rf17	a_27_368#	a_27_368##2	92.493721
Rf18	a_27_368##2	a_27_368##3	67.849350
Rf19	a_27_368##3	a_27_368##4	67.484093
Rf20	a_27_368##4	a_27_368##6	86.950043
Rf21	a_27_368##6	a_27_368##7	78.532578
Rf22	a_27_368##7	a_27_368##8	69.463600
Rf23	a_27_368##8	a_27_368##9	63.573402
Rf24	a_27_368##9	a_27_368##10	96.671074
Rf25	a_27_368##2	a_27_368##11	29.930687
Rf26	a_27_368##3	a_27_368##12	36.308861
Rf27	a_27_368##4	a_27_368##13	26.725168
Rf28	a_27_368##7	a_27_368##14	20.631947
Rf29	a_27_368##8	a_27_368##15	20.631947
Rf30	a_27_368##9	a_27_368##16	33.587738
Rf31	a_27_368##5	a_27_368##6	5.000000
Rf32	VGND#1	VGND#2	60.607380
Rf33	VGND#2	VGND#3	73.001427
Rf34	VGND#3	VGND#4	123.041023
Rf35	VGND#4	VGND#5	41.248997
Rf36	VGND#5	VGND#6	46.467060
Rf37	VGND#6	VGND#7	114.210495
Rf39	VGND#2	VGND#9	33.306259
Rf40	VGND#3	VGND#10	31.534731
Rf41	VGND#4	VGND#11	38.247387
Rf42	VGND#6	VGND#12	18.298729
Rf43	VGND#7	VGND#13	10.971647
Rf44	VPWR#1	VPWR#2	300.858459
Rf45	VPWR#2	VPWR#3	35.032631
Rf46	VPWR#2	VPWR#4	53.302330
Rf47	VPWR#4	VPWR#5	31.534731
Rf48	VPWR#4	VPWR#6	69.348907
Rf49	VPWR#6	VPWR#7	31.534731
Rf50	VPWR#6	VPWR#8	65.696381
Rf51	VPWR#8	VPWR#9	34.880951
Rf54	B#2	B#23	53.410934
Rf53	A#5	A#22	32.046562
Re1	VPWR#1	VPWR	4.549932
Re2	VPWR	VPWR#2	0.974985
Re3	VGND#1	VGND	4.549932
Re4	VGND	VGND#5	0.974985
*
*       CAPACITOR CARDS
*
*
C1	Y#10	Y#4	3.3865e-18
C2	Y#9	A#4	6.57169e-18
C3	VGND#2	Y#6	8.47532e-18
C4	a_27_368##9	a_27_368##16	3.31225e-18
C5	Y#10	VGND#11	4.526e-17
C6	VGND#4	VGND#10	1.22171e-19
C7	VPWR#6	A#18	1.82512e-18
C8	a_27_368##9	A#17	4.1194e-19
C9	a_27_368##8	A#17	1.79456e-17
C10	a_27_368##7	A#17	1.59587e-19
C11	a_27_368##9	a_27_368##8	8.60298e-19
C12	a_27_368##9	VPWR#9	3.42149e-17
C13	Y#12	Y#10	1.79592e-18
C14	VGND#4	Y#4	2.45881e-17
C15	a_27_368##9	A#18	7.48675e-19
C16	VPWR#6	A#20	1.84912e-18
C17	a_27_368##8	A#18	1.39432e-17
C18	VGND#3	Y#4	2.53036e-17
C19	Y#11	A#6	2.24621e-20
C20	VGND#6	VGND#11	1.45893e-18
C21	Y#11	A#4	4.4413e-20
C22	a_27_368##10	a_27_368##9	3.4272e-18
C23	Y#4	Y#7	2.12835e-18
C24	a_27_368##5	A#4	6.36909e-19
C25	a_27_368##9	A#20	1.98103e-17
C26	a_27_368##8	A#20	1.6466e-19
C27	VGND#2	B#15	2.75371e-18
C28	A#4	VPWR#3	2.49216e-18
C29	a_27_368##8	a_27_368##7	9.43977e-19
C30	VGND#6	Y#10	4.7186e-17
C31	VGND#4	B#17	6.55993e-20
C32	VGND#6	Y#9	3.61813e-17
C33	A#4	a_27_368##14	6.13443e-19
C34	A#8	a_27_368##15	4.03581e-19
C35	A#9	VPWR#7	3.65092e-19
C36	VGND#3	B#17	3.35704e-18
C37	Y#4	a_27_368##13	3.22715e-17
C38	a_27_368##9	A#21	1.33159e-17
C39	VGND#4	B#11	1.76238e-19
C40	a_27_368#	Y#1	1.02194e-16
C41	a_27_368##8	A#21	7.36537e-20
C42	A#8	VPWR#7	1.13154e-18
C43	A#6	a_27_368##15	3.982e-19
C44	a_27_368##11	a_27_368#	4.08233e-18
C45	VGND#9	Y#2	1.94875e-17
C46	VPWR#9	A#10	9.48087e-19
C47	VGND#6	VGND#12	1.37283e-17
C48	Y#4	a_27_368##5	9.36779e-18
C49	VGND#4	Y#9	3.77957e-19
C50	Y#4	a_27_368##4	3.77148e-18
C51	Y#1	a_27_368##11	8.28705e-17
C52	VGND#4	B#19	2.78714e-19
C53	VGND#3	B#19	2.73234e-18
C54	a_27_368##9	A#11	2.00179e-18
C55	Y#7	Y#1	2.54838e-18
C56	VGND#4	B#10	1.89414e-19
C57	Y#4	a_27_368##3	5.89957e-19
C58	B#12	B#9	1.56117e-19
C59	B#15	B#3	1.10468e-17
C60	A#12	B#11	2.5407e-18
C61	Y#7	a_27_368##11	7.61893e-17
C62	VGND#3	B#10	2.64699e-19
C63	VGND#6	Y#12	8.31695e-17
C64	a_27_368##12	a_27_368##11	3.80868e-18
C65	VPWR#6	VPWR#4	1.07669e-18
C66	VGND#4	B#12	6.12656e-18
C67	a_27_368##12	Y#7	7.35454e-17
C68	Y#2	B#15	3.83301e-19
C69	B#11	B#10	7.12083e-18
C70	Y#8	Y#7	7.84562e-19
C71	VGND#3	B#9	1.24093e-19
C72	Y#8	a_27_368##12	7.3651e-17
C73	VGND#6	A#12	7.8853e-19
C74	VGND#4	A#12	7.89083e-18
C75	a_27_368##13	a_27_368##12	3.83733e-18
C76	Y#9	VGND#11	1.42163e-17
C77	B#10	B#9	7.11062e-18
C78	Y#2	B#17	1.82368e-18
C79	a_27_368##13	Y#8	6.58902e-17
C80	B#15	VGND#9	2.72142e-17
C81	a_27_368##4	VPWR#1	1.51804e-17
C82	a_27_368##3	VPWR#1	6.20741e-17
C83	Y#6	B#15	4.397e-17
C84	Y#11	Y#8	4.34605e-18
C85	a_27_368##2	VPWR#1	8.53668e-17
C86	VGND#3	B#8	1.71399e-20
C87	VGND#9	B#17	1.26752e-18
C88	VGND#6	A#14	1.71317e-17
C89	VGND#10	B#15	1.41935e-18
C90	Y#11	a_27_368##13	6.58451e-17
C91	a_27_368##4	B#11	6.79746e-20
C92	Y#6	B#17	3.74853e-17
C93	VGND#4	A#14	1.04283e-18
C94	VGND#1	VGND#2	1.11932e-17
C95	VPWR#1	Y#2	2.24856e-18
C96	VGND#9	B#19	3.96119e-19
C97	B#9	B#8	1.71637e-17
C98	B#17	VGND#10	2.3709e-17
C99	a_27_368##5	a_27_368##13	4.15025e-18
C100	Y#9	Y#10	9.49193e-19
C101	Y#6	B#19	1.24498e-18
C102	Y#4	B#17	7.03456e-18
C103	a_27_368##5	Y#11	7.58259e-17
C104	VPWR#4	VPWR#2	1.07949e-18
C105	B#19	VGND#10	2.93007e-17
C106	VGND#11	B#17	5.75543e-20
C107	Y#4	B#19	7.02818e-17
C108	VGND#6	A#16	2.51731e-17
C109	VGND#3	Y#2	3.07226e-19
C110	VGND#10	B#12	4.49719e-19
C111	a_27_368##4	B#10	7.82626e-20
C112	VGND#4	A#16	6.47164e-20
C113	VGND#11	B#19	1.71004e-19
C114	VGND#1	Y#2	2.90171e-18
C115	a_27_368##5	VPWR#3	8.07487e-17
C116	Y#4	B#12	6.96624e-17
C117	Y#9	VGND#12	1.26837e-18
C118	VGND#10	A#12	1.24185e-19
C119	a_27_368##7	VPWR#2	1.6661e-19
C120	a_27_368##14	a_27_368##5	1.5103e-18
C121	B#12	VGND#11	1.72876e-17
C122	Y#11	VPWR#5	1.12801e-21
C123	B#6	B#14	8.18755e-18
C124	a_27_368##4	VPWR#2	6.16219e-17
C125	Y#9	A#12	2.12396e-17
C126	Y#4	A#12	1.28112e-18
C127	B#8	B#6	1.71287e-17
C128	Y#10	B#12	8.91178e-19
C129	a_27_368##14	VPWR#3	6.1225e-17
C130	VGND#11	A#12	3.22813e-17
C131	VGND#3	B#6	6.28454e-20
C132	VGND#2	Y#2	1.18676e-19
C133	VGND#6	A#19	2.69811e-18
C134	Y#4	A#14	2.31183e-19
C135	VPWR#5	VPWR#3	1.77565e-18
C136	A#12	Y#10	1.37611e-17
C137	a_27_368##4	B#9	5.51145e-20
C138	VGND#11	A#14	1.23566e-18
C139	VPWR#5	a_27_368##14	5.29637e-17
C140	VGND#2	B#6	8.41489e-20
C141	Y#10	A#14	3.68052e-17
C142	VGND#11	A#16	5.11928e-20
C143	a_27_368##15	a_27_368##14	1.38143e-18
C144	Y#9	A#14	2.52935e-17
C145	B#11	B#21	6.60025e-18
C146	A#14	VGND#12	8.90985e-18
C147	Y#10	A#16	5.55977e-19
C148	Y#12	A#14	4.76354e-19
C149	a_27_368##15	VPWR#5	6.1225e-17
C150	VGND#5	Y#9	5.6362e-20
C151	B#21	B#9	6.59079e-18
C152	A#16	VGND#12	2.32774e-17
C153	VPWR#7	VPWR#5	1.77565e-18
C154	Y#10	A#19	3.10258e-19
C155	Y#12	A#16	3.30468e-17
C156	VPWR#7	a_27_368##15	5.29637e-17
C157	B#6	B#4	8.8762e-18
C158	a_27_368##3	B#8	5.43797e-20
C159	Y#12	A#19	4.50034e-17
C160	A#1	B#11	9.13331e-19
C161	a_27_368##16	a_27_368##15	1.25897e-18
C162	VPWR#4	A#5	8.50767e-21
C163	a_27_368##16	VPWR#7	5.21059e-17
C164	VGND#6	A#5	2.87638e-18
C165	VPWR#9	VPWR#7	2.06271e-18
C166	a_27_368##8	A#5	1.93533e-18
C167	VPWR#9	a_27_368##16	5.48043e-17
C168	a_27_368##7	A#5	1.4012e-18
C169	VPWR#6	A#9	2.00458e-20
C170	a_27_368##2	Y#1	1.51825e-17
C171	a_27_368#	B#1	4.40548e-17
C172	A#4	B#11	3.11882e-17
C173	Y#1	B#1	5.41158e-17
C174	B#4	B#3	7.12834e-18
C175	Y#9	A#5	5.2616e-18
C176	a_27_368##10	VPWR#9	8.18206e-17
C177	a_27_368#	B#13	1.43982e-18
C178	a_27_368##11	B#1	1.45611e-18
C179	Y#1	B#13	5.65636e-17
C180	a_27_368#	B#14	3.3145e-19
C181	B#13	a_27_368##11	2.51199e-17
C182	Y#1	B#14	2.35017e-18
C183	Y#7	B#13	1.8971e-18
C184	a_27_368##3	B#6	4.1682e-20
C185	a_27_368##2	a_27_368##11	5.42136e-18
C186	A#4	A#1	6.92585e-19
C187	B#14	a_27_368##11	3.15166e-17
C188	VPWR#6	A#8	2.12692e-20
C189	a_27_368##12	B#13	2.9103e-19
C190	Y#4	B#21	1.39113e-17
C191	Y#7	B#14	5.65763e-17
C192	B#17	B#15	3.59238e-17
C193	a_27_368##11	B#16	7.31275e-19
C194	a_27_368##12	B#14	6.837e-19
C195	a_27_368##2	B#6	3.10459e-20
C196	Y#7	B#16	4.58874e-17
C197	a_27_368##3	Y#7	1.48548e-17
C198	A#6	A#15	8.30923e-19
C199	a_27_368##11	B#18	3.14693e-19
C200	B#16	a_27_368##12	2.36511e-17
C201	Y#2	B#8	1.28504e-17
C202	B#19	B#17	2.0521e-17
C203	A#15	A#4	9.64071e-19
C204	Y#4	A#1	6.53392e-20
C205	Y#7	B#18	1.61928e-18
C206	Y#8	B#16	1.59101e-18
C207	VGND#6	VGND#4	1.20239e-18
C208	a_27_368##2	Y#7	1.67199e-17
C209	a_27_368##9	VPWR#6	3.13618e-19
C210	B#18	a_27_368##12	2.9611e-17
C211	a_27_368##13	B#16	3.1439e-19
C212	Y#8	B#18	5.46339e-17
C213	B#12	B#19	2.40424e-18
C214	a_27_368##12	B#20	6.95049e-19
C215	a_27_368##13	B#18	7.3088e-19
C216	Y#8	B#20	4.64488e-17
C217	a_27_368##2	B#13	1.61488e-17
C218	Y#4	A#15	2.39183e-20
C219	Y#2	a_27_368##11	1.71183e-17
C220	a_27_368##12	B#21	2.92858e-19
C221	B#20	a_27_368##13	2.69063e-17
C222	a_27_368##3	a_27_368##12	5.15619e-18
C223	A#12	B#12	2.48296e-17
C224	A#20	A#8	9.64071e-19
C225	VGND#6	A#8	4.69825e-20
C226	a_27_368##9	A#10	8.59134e-18
C227	Y#8	B#21	1.88639e-18
C228	Y#11	B#20	2.36812e-18
C229	VPWR#3	B#18	3.83651e-20
C230	A	a_27_368##9	1.73904e-17
C231	A	a_27_368##8	8.05118e-17
C232	A	a_27_368##7	8.28819e-17
C233	B#21	a_27_368##13	3.26391e-17
C234	a_27_368##5	B#20	3.3145e-19
C235	Y#4	B#11	2.58737e-17
C236	a_27_368##8	VPWR#6	3.13618e-19
C237	A#14	A#12	2.84173e-17
C238	Y#11	B#21	5.90368e-17
C239	VPWR#3	B#20	6.66502e-20
C240	B#8	Y#6	1.24217e-19
C241	Y#9	A	9.05342e-17
C242	VPWR#6	A#6	6.71264e-21
C243	B#9	VGND#10	1.64393e-18
C244	a_27_368##13	B#22	6.9265e-19
C245	a_27_368##5	B#21	2.04504e-18
C246	Y#4	B#10	3.357e-17
C247	a_27_368##4	Y#8	1.51106e-17
C248	a_27_368##2	B#4	1.57995e-20
C249	B#22	Y#11	2.05217e-17
C250	VPWR#3	B#21	2.34758e-19
C251	Y#2	B#13	4.32574e-20
C252	VGND#9	B#6	6.80863e-19
C253	A#16	A#14	5.80875e-18
C254	VPWR#1	B#9	2.00291e-20
C255	a_27_368##2	B#14	1.60882e-17
C256	a_27_368##5	B#22	8.04794e-17
C257	B#8	VGND#10	6.68952e-18
C258	VPWR#1	B#8	5.18465e-20
C259	VPWR#4	A#6	1.3705e-20
C260	a_27_368##3	Y#8	1.67471e-17
C261	Y#2	B#6	3.40447e-17
C262	Y#11	A#1	7.39966e-19
C263	VPWR#3	B#22	5.18866e-19
C264	Y#4	B#9	3.67324e-17
C265	VPWR#1	B#6	2.90592e-20
C266	a_27_368##9	A#9	2.9774e-18
C267	a_27_368##5	A#1	7.19115e-17
C268	B#6	Y#6	8.63309e-19
C269	A#19	A#16	2.74053e-17
C270	A#1	VPWR#3	3.14099e-17
C271	VGND#4	VGND#3	3.06191e-19
C272	VPWR#1	B#4	3.24471e-20
C273	Y#11	A#13	4.02678e-19
C274	VPWR#1	B#3	1.28929e-19
C275	Y#4	B#8	2.01251e-17
C276	A#8	A#6	2.53731e-18
C277	a_27_368##8	VPWR#4	1.6661e-19
C278	Y#2	a_27_368##3	3.35183e-18
C279	a_27_368##14	A#1	3.00092e-19
C280	a_27_368##5	A#13	8.81592e-19
C281	VGND#9	B#4	1.27817e-17
C282	A#13	VPWR#3	3.61347e-17
C283	VPWR#5	A#1	3.12383e-19
C284	Y#11	A#15	2.40777e-19
C285	Y#2	B	5.35452e-18
C286	VPWR#2	B#11	4.4456e-20
C287	a_27_368##4	a_27_368##13	2.8683e-18
C288	a_27_368##3	B#16	1.57897e-17
C289	a_27_368##2	B#3	2.72536e-19
C290	VPWR#2	B#10	5.98201e-20
C291	a_27_368##14	A#13	5.1046e-17
C292	Y#2	B#14	9.1977e-18
C293	VGND#1	B#4	1.75178e-18
C294	VPWR#2	B#9	2.17649e-20
C295	VGND#1	B#3	3.8929e-17
C296	Y#2	a_27_368##12	2.32455e-17
C297	VPWR#5	A#13	2.15582e-18
C298	VPWR#3	A#15	7.45976e-19
C299	Y#11	A#17	2.03656e-19
C300	VGND#9	B#3	1.94819e-17
C301	a_27_368##15	A#13	1.11554e-19
C302	A#15	a_27_368##14	1.78231e-17
C303	VPWR#5	A#15	5.62217e-17
C304	Y#4	B#6	5.73578e-19
C305	a_27_368##9	A#8	5.41774e-19
C306	VGND#6	A#6	2.81847e-19
C307	a_27_368##15	A#15	1.24422e-18
C308	a_27_368##14	A#17	2.33542e-19
C309	a_27_368##14	VPWR#4	3.02912e-18
C310	Y#6	B#3	5.13405e-20
C311	VPWR#7	A#15	3.03503e-19
C312	Y#2	a_27_368##2	1.75994e-18
C313	A#17	VPWR#5	2.65305e-17
C314	B#13	B#1	5.3493e-17
C315	a_27_368##7	VPWR#4	3.13618e-19
C316	a_27_368##15	A#17	5.10562e-17
C317	a_27_368##8	A#8	2.16524e-18
C318	VGND#1	VGND#9	7.75954e-18
C319	A#6	A#4	1.15309e-18
C320	VPWR#7	A#17	2.15582e-18
C321	VPWR#5	A#18	7.45976e-19
C322	a_27_368##4	Y#11	3.23488e-17
C323	a_27_368##3	B#18	1.56155e-17
C324	VPWR#2	A#4	3.1885e-20
C325	B#14	B#13	4.31041e-17
C326	a_27_368##16	A#17	9.62907e-20
C327	A#18	a_27_368##15	1.78245e-17
C328	VGND#10	B#3	5.09353e-19
C329	VPWR#7	A#18	5.19794e-17
C330	Y#2	B#4	1.45914e-17
C331	VPWR	VPWR#6	5.54011e-17
C332	VPWR	VPWR#4	5.25251e-17
C333	a_27_368##16	A#18	2.23229e-19
C334	a_27_368#	VPWR#1	8.2509e-17
C335	a_27_368##15	A#20	2.40966e-19
C336	a_27_368##7	a_27_368##5	1.03204e-18
C337	B#16	B#14	4.63053e-17
C338	VPWR#1	Y#1	1.07705e-17
C339	VGND#5	A#4	1.04005e-19
C340	VPWR#7	A#20	4.57251e-17
C341	VGND#6	A#4	1.79939e-19
C342	VPWR	a_27_368##9	4.44569e-18
C343	VPWR	a_27_368##8	2.78351e-18
C344	A#20	a_27_368##16	2.07556e-17
C345	VPWR	a_27_368##7	2.96882e-18
C346	a_27_368##15	A#21	1.07786e-19
C347	VPWR	a_27_368##4	3.0998e-17
C348	VGND#1	a_27_368#	1.12613e-17
C349	VGND#3	VGND#2	9.5684e-19
C350	VPWR	a_27_368##3	2.61377e-17
C351	VPWR#9	A#20	2.91959e-18
C352	VPWR	a_27_368##2	7.64437e-18
C353	VPWR#7	A#21	2.13205e-18
C354	VGND#1	Y#1	7.06896e-18
C355	B#18	B#16	4.72347e-17
C356	a_27_368##10	A#20	2.00227e-19
C357	a_27_368##4	B#20	1.56951e-17
C358	A#21	a_27_368##16	2.09314e-17
C359	VPWR	Y#2	3.69615e-18
C360	VPWR#9	A#21	6.18252e-17
C361	VGND#5	Y#10	1.70181e-17
C362	a_27_368##10	A#21	2.13628e-18
C363	B#20	B#18	4.62952e-17
C364	Y#2	B#3	2.43723e-18
C365	A#11	VPWR#9	2.87917e-17
C366	a_27_368##10	A#11	6.16475e-17
C367	B#21	B#20	3.79667e-17
C368	a_27_368##7	VPWR#3	2.31081e-17
C369	VGND	VGND#6	1.19332e-16
C370	VGND	VGND#4	9.18343e-17
C371	VGND	VGND#3	7.95066e-17
C372	VGND	VGND#2	3.30773e-17
C373	a_27_368##15	VPWR#6	6.49096e-18
C374	VGND	a_27_368##9	6.31394e-18
C375	a_27_368##5	VPWR#2	3.75867e-17
C376	B#22	B#21	3.67938e-17
C377	VGND	Y#9	5.35555e-18
C378	a_27_368##14	VPWR#2	1.0665e-17
C379	a_27_368##15	VPWR#4	7.20319e-18
C380	a_27_368##4	B#21	1.58967e-17
C381	VGND	Y#2	3.05937e-18
C382	A	B#11	3.72387e-18
C383	A	B#10	4.11539e-19
C384	Y#12	A#5	2.54107e-18
C385	a_27_368##9	a_27_368##14	2.23336e-20
C386	a_27_368##8	A#6	1.32724e-18
C387	A#1	B#22	4.74997e-17
C388	Y#9	a_27_368##5	4.08706e-18
C389	A	A#9	9.63451e-18
C390	A#13	A#1	3.14965e-17
C391	A	A#8	2.43209e-17
C392	Y#4	A#6	1.2923e-19
C393	A	A#6	1.71944e-17
C394	a_27_368##7	a_27_368##14	1.67034e-18
C395	VPWR#6	VNB	2.78482e-17
C396	A	A#4	3.79696e-17
C397	VPWR#4	VNB	2.66338e-17
C398	VGND#6	VNB	3.97729e-17
C399	VGND#4	VNB	3.80496e-17
C400	a_27_368##9	A#4	3.25843e-20
C401	VGND#3	VNB	4.2373e-17
C402	A#15	A#13	4.76814e-17
C403	VGND#2	VNB	2.29344e-17
C404	a_27_368##9	VNB	1.51453e-18
C405	B	B#3	7.06108e-17
C406	A#5	a_27_368##14	1.88338e-19
C407	a_27_368##4	VNB	6.20411e-18
C408	a_27_368##3	VNB	4.42695e-18
C409	A#5	VPWR#5	2.19688e-18
C410	VPWR#1	B#1	6.76802e-18
C411	a_27_368##2	VNB	4.74685e-18
C412	A	Y#4	1.69755e-17
C413	Y#9	VNB	1.86268e-18
C414	Y#4	A#4	1.08644e-17
C415	VPWR#1	B#13	6.12578e-18
C416	Y#2	VNB	4.24108e-18
C417	A#17	A#15	3.81822e-17
C418	VPWR#1	B#14	5.19064e-18
C419	Y#7	B#8	5.97409e-19
C420	Y#12	A	6.97272e-17
C421	VGND#5	A#14	2.00979e-18
C422	VPWR#1	B#16	4.43427e-18
C423	VGND#9	B	3.24507e-17
C424	Y#6	B	8.95463e-20
C425	VPWR#1	B#18	4.43427e-18
C426	A#18	A#17	4.76814e-17
C427	Y#6	VGND#9	6.80594e-17
C428	VPWR#1	B#20	2.12845e-18
C429	VGND#11	A#4	6.6225e-19
C430	a_27_368#	B#3	3.07577e-19
C431	a_27_368##8	VPWR#5	1.80796e-17
C432	A#20	A#18	4.75011e-17
C433	Y#12	A#8	3.5819e-18
C434	B	a_27_368#	7.36216e-19
C435	a_27_368##7	A#4	4.53005e-18
C436	a_27_368##12	B#8	7.17171e-19
C437	A	a_27_368##5	7.41267e-18
C438	B	Y#1	3.09476e-17
C439	a_27_368##7	VPWR#5	1.41034e-17
C440	VPWR#2	B#20	2.29104e-18
C441	VGND#10	VGND#9	1.84033e-18
C442	Y#8	B#9	1.36614e-19
C443	Y#7	B#6	1.57499e-18
C444	A#21	A#20	4.8915e-17
C445	VPWR#2	B#21	4.4729e-18
C446	a_27_368##7	A#1	2.05063e-19
C447	Y#1	B#3	2.78458e-17
C448	VPWR#2	B#22	4.43283e-18
C449	a_27_368##13	B#10	5.0864e-19
C450	a_27_368##16	VPWR#6	5.19698e-18
C451	VPWR#2	A#1	2.32645e-18
C452	a_27_368##11	B#4	5.69014e-19
C453	A#11	A#21	3.80761e-17
C454	VGND	B#11	1.2502e-19
C455	VPWR#2	A#13	2.58772e-18
C456	Y#8	B#8	1.68636e-19
C457	VPWR	Y#4	6.06488e-18
C458	VGND#10	Y#6	5.63094e-17
C459	VGND	A#10	5.08706e-18
C460	a_27_368##12	B#6	2.18398e-20
C461	VGND	A#9	3.19676e-18
C462	a_27_368##13	B#9	3.52801e-19
C463	B	B#15	5.25702e-18
C464	Y#12	A#6	1.56255e-18
C465	a_27_368##11	B#3	5.52685e-19
C466	VGND	A#4	1.61907e-20
C467	VPWR	Y#7	9.53773e-18
C468	VGND	VGND#9	1.45374e-17
C469	VPWR	Y#8	1.02126e-17
C470	VGND	Y#6	1.84339e-17
C471	VGND	VGND#10	2.22475e-17
C472	a_27_368##8	a_27_368##15	1.67034e-18
C473	VGND	Y#4	5.04988e-17
C474	VPWR	Y#11	1.05655e-17
C475	Y#4	Y#6	5.35944e-18
C476	B#11	VNB	3.01207e-17
C477	VPWR	a_27_368##5	2.3187e-17
C478	B#10	VNB	2.18712e-17
C479	VGND	Y#10	1.71403e-17
C480	VPWR	VPWR#3	2.22813e-17
C481	B#9	VNB	3.01638e-17
C482	VPWR#4	A#15	1.82358e-18
C483	B#8	VNB	3.0303e-17
C484	VPWR	a_27_368##14	1.46854e-17
C485	a_27_368##9	A#13	1.47716e-19
C486	VGND	Y#12	1.93654e-17
C487	B#6	VNB	2.84814e-17
C488	VPWR	VPWR#5	2.18706e-17
C489	a_27_368##5	B#11	1.23193e-18
C490	VPWR	a_27_368##15	1.46854e-17
C491	B#4	VNB	3.2278e-17
C492	B#3	VNB	2.01664e-16
C493	VPWR	VPWR#7	2.17598e-17
C494	A#10	VNB	3.44926e-17
C495	A#9	VNB	1.96685e-17
C496	VPWR	a_27_368##16	1.22103e-17
C497	A#8	VNB	4.02014e-17
C498	a_27_368##8	A#13	7.62285e-20
C499	VPWR	VPWR#9	2.20612e-17
C500	A#6	VNB	2.42815e-17
C501	A	B#21	5.4263e-19
C502	VPWR	a_27_368##10	1.92862e-17
C503	A#4	VNB	6.29312e-17
C504	VGND#9	VNB	6.14081e-18
C505	Y#6	VNB	2.11139e-18
C506	VGND#10	VNB	4.24167e-18
C507	a_27_368##7	A#13	1.87611e-17
C508	Y#4	VNB	2.09638e-17
C509	VGND#11	VNB	3.39417e-19
C510	Y#4	VGND#10	9.89485e-17
C511	Y#10	VNB	2.64167e-18
C512	Y#12	VNB	7.41102e-18
C513	a_27_368#	VNB	7.18128e-17
C514	Y#1	VNB	1.23429e-17
C515	VGND	a_27_368##10	9.62176e-18
C516	a_27_368##11	VNB	1.96174e-18
C517	Y#7	VNB	4.53143e-19
C518	a_27_368##12	VNB	3.3712e-18
C519	VGND	B#17	5.3236e-19
C520	Y#8	VNB	1.3706e-19
C521	VGND	B#19	2.5251e-19
C522	Y#11	VNB	7.41333e-19
C523	VGND	B#12	1.04197e-18
C524	VPWR	B#14	9.40464e-19
C525	VPWR#2	A#5	1.13436e-21
C526	a_27_368##5	VNB	2.1231e-18
C527	VGND	A#12	3.13503e-19
C528	VPWR#3	VNB	4.25138e-18
C529	VPWR	B#16	1.65796e-18
C530	a_27_368##14	VNB	2.24265e-18
C531	VPWR	B#18	1.65796e-18
C532	VPWR#5	VNB	1.07948e-18
C533	VGND	A#16	5.24944e-19
C534	a_27_368##15	VNB	2.24265e-18
C535	VGND	A#19	8.42691e-19
C536	VPWR	B#20	1.66524e-18
C537	VPWR#7	VNB	2.3154e-19
C538	a_27_368##16	VNB	4.60451e-18
C539	VPWR	B#21	1.56401e-18
C540	VPWR#9	VNB	1.90225e-18
C541	VPWR	B#22	1.40547e-18
C542	a_27_368##10	VNB	6.32225e-17
C543	a_27_368##9	VPWR#7	1.56067e-17
C544	B#15	VNB	2.67891e-17
C545	VPWR	A#1	5.09689e-19
C546	VGND#11	VGND#10	5.92559e-19
C547	B#17	VNB	2.5627e-17
C548	B#19	VNB	2.78112e-17
C549	VPWR	A#13	1.16166e-19
C550	B#12	VNB	2.79703e-17
C551	VPWR	A#15	1.18488e-18
C552	A#12	VNB	2.83722e-17
C553	A#14	VNB	2.90578e-17
C554	VPWR	A#17	1.42422e-19
C555	A#16	VNB	2.73905e-17
C556	A#19	VNB	3.53153e-17
C557	VPWR	A#18	1.18488e-18
C558	VGND#1	B	4.05129e-17
C559	VPWR	A#20	1.09596e-18
C560	B#1	VNB	5.07871e-17
C561	B#13	VNB	4.05587e-17
C562	VPWR	A#21	1.28106e-18
C563	B#14	VNB	4.0996e-17
C564	B#16	VNB	3.24841e-17
C565	VPWR	A#11	7.689e-19
C566	A	A#5	2.28776e-17
C567	B#18	VNB	3.25142e-17
C568	B#20	VNB	3.18356e-17
C569	a_27_368##8	VPWR#7	1.57853e-17
C570	B#21	VNB	4.15096e-17
C571	VPWR	VPWR#1	7.15638e-17
C572	B#22	VNB	3.28198e-17
C573	A#1	VNB	3.12529e-17
C574	A#13	VNB	3.14528e-17
C575	VGND	A#11	3.90972e-18
C576	VPWR	VPWR#2	1.26073e-16
C577	A#15	VNB	2.94247e-17
C578	A#17	VNB	2.95194e-17
C579	a_27_368##9	A#15	2.63665e-19
C580	A#18	VNB	2.82729e-17
C581	Y#4	VGND#11	6.53593e-17
C582	A#20	VNB	2.95348e-17
C583	VPWR#4	A#17	2.56173e-18
C584	A#21	VNB	2.91158e-17
C585	A#11	VNB	7.47675e-17
C586	VGND	VGND#5	2.26682e-17
C587	VPWR#1	VNB	2.04107e-16
C588	VGND#1	VNB	1.56878e-16
C589	VPWR#2	VNB	7.00966e-17
C590	a_27_368##8	A#15	2.02978e-19
C591	VPWR	A	1.42616e-17
C592	VGND#5	VNB	1.33061e-17
C593	A#5	VNB	4.10807e-17
C594	VGND	A	1.3214e-17
C595	VGND#3	Y#6	8.51842e-18
C596	A	VNB	4.19825e-17
C597	B	VNB	3.16006e-17
C598	a_27_368##7	A#15	1.43801e-17
C599	VPWR	VNB	2.90565e-16
C600	VGND	VNB	2.93172e-16
C601	VGND#7	A#10	1.06622e-17
C602	VGND#7	A#11	3.16427e-18
C603	a_27_368##9	VPWR#8	2.46159e-19
C604	VGND#7	a_27_368##9	2.72169e-17
C605	VGND#7	A#16	9.43931e-19
C606	VPWR#8	A#21	1.87151e-18
C607	VGND#7	A#8	2.59732e-19
C608	a_27_368##10	VPWR#8	2.09533e-17
C609	VGND#7	a_27_368##10	4.64033e-18
C610	VGND#7	VNB	1.3536e-16
C611	VGND#7	Y#12	8.43826e-17
C612	a_27_368##16	VPWR#8	5.25959e-18
C613	VGND#7	VGND#6	3.30977e-18
C614	VPWR#8	VPWR#6	1.22366e-18
C615	VPWR#8	A#10	2.03167e-20
C616	VPWR#8	A#11	2.61038e-18
C617	VGND#7	A	1.87449e-17
C618	VGND#7	A#9	6.06762e-18
C619	VGND#7	A#19	2.79023e-17
C620	VPWR#8	VNB	4.74199e-17
C621	VGND	VGND#7	1.92578e-16
C622	VGND#7	VGND#13	3.37258e-17
C623	VPWR	VPWR#8	7.99149e-17
*
*
.ENDS sky130_fd_sc_hs__nor2_8
*
