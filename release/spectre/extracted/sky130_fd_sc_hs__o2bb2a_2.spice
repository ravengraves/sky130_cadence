* Extracted by Quantus, converted by sky130cad/quantus.py
*
*
*
*                       LINUX           Wed Nov 18 08:59:43 2026
*
*
*
*  PROGRAM  advgen
*
*  Name           : advgen - Quantus - (64-bit)
*  Version        : 25.1.0-p047
*  Build Date     : Thu Dec 11 23:20:30 PST 2025
*
*  HSPICE LIBRARY
*
*  OPERATING_TEMPERATURE 150
*  QRC_TECH_DIR <path>/tech
*
*
*

*
.SUBCKT sky130_fd_sc_hs__o2bb2a_2 VNB VPB VGND VPWR X B1 B2 A2_N A1_N
*
*
*  caps2d version: 10
*
*
*       TRANSISTOR CARDS
*
*
XM11 a_27_74##2 B1#3 VGND#7 VNB sky130_fd_pr__nfet_01v8_lvt l=0.15 w=0.74 ad=0.2109 as=0.2072 pd=2.05 ps=2.04
XM4 VGND#7 B2#3 a_27_74# VNB sky130_fd_pr__nfet_01v8_lvt l=0.15 w=0.74 ad=0.2072 as=0.259 pd=2.04 ps=2.18
XM0 a_27_74# a_270_48##3 a_201_392##7 VNB sky130_fd_pr__nfet_01v8_lvt l=0.15 w=0.74 ad=0.259 as=0.2109 pd=2.18 ps=2.05
XM7 a_270_48##7 A2_N#1 a_500_74# VNB sky130_fd_pr__nfet_01v8_lvt l=0.15 w=0.64 ad=0.1824 as=0.1536 pd=1.85 ps=1.76
XM3 a_500_74# A1_N#1 VGND#6 VNB sky130_fd_pr__nfet_01v8_lvt l=0.15 w=0.64 ad=0.1536 as=0.2906 pd=1.76 ps=2.31
XM9 X#3 a_201_392##5 VGND#6 VNB sky130_fd_pr__nfet_01v8_lvt l=0.15 w=0.74 ad=0.2072 as=0.2906 pd=2.04 ps=2.31
XM12 VGND#1 a_201_392##4 X#3 VNB sky130_fd_pr__nfet_01v8_lvt l=0.15 w=0.74 ad=0.2109 as=0.2072 pd=2.05 ps=2.04
XM2 VPWR#5 B1#1 a_117_392# VPB sky130_fd_pr__pfet_01v8 l=0.15 w=1 ad=0.295 as=0.27 pd=2.59 ps=2.54
XM10 a_117_392# B2#1 a_201_392##9 VPB sky130_fd_pr__pfet_01v8 l=0.15 w=1 ad=0.27 as=0.36 pd=2.54 ps=2.72
XM8 a_201_392##9 a_270_48##4 VPWR#7 VPB sky130_fd_pr__pfet_01v8 l=0.15 w=1 ad=0.36 as=0.506675 pd=2.72 ps=3.16
XM1 VPWR#7 A2_N#3 a_270_48##5 VPB sky130_fd_pr__pfet_01v8 l=0.15 w=0.84 ad=0.506675 as=0.3276 pd=3.16 ps=2.46
XM5 a_270_48##5 A1_N#3 VPWR#6 VPB sky130_fd_pr__pfet_01v8 l=0.15 w=0.84 ad=0.3276 as=0.641075 pd=2.46 ps=3.59
XM13 VPWR#6 a_201_392##6 X#1 VPB sky130_fd_pr__pfet_01v8 l=0.15 w=1.12 ad=0.641075 as=0.336 pd=3.59 ps=2.84
XM6 X#1 a_201_392# VPWR#1 VPB sky130_fd_pr__pfet_01v8 l=0.15 w=1.12 ad=0.336 as=0.3304 pd=2.84 ps=2.83
*
*
*       RESISTOR AND CAP/DIODE CARDS
*
Rg1	B1#1	B1#2	426.054413
Rg2	B1#2	B1#3	460.175812
Rg3	B2#1	B2#2	409.090576
Rg4	B2#2	B2#3	439.925934
Rg5	a_270_48#	a_270_48##2	178.049744
Rg6	a_270_48##2	a_270_48##3	454.941925
Rg7	a_270_48##2	a_270_48##4	424.106537
Rg8	A2_N#1	A2_N#2	475.735992
Rg9	A2_N#2	A2_N#3	354.298584
Rg10	A1_N#1	A1_N#2	509.818970
Rg11	A1_N#2	A1_N#3	371.262421
Rg12	a_201_392#	a_201_392##2	469.642059
Rg13	a_201_392##2	a_201_392##3	84.295372
Rg14	a_201_392##2	a_201_392##4	371.731934
Rg15	a_201_392##3	a_201_392##5	349.304138
Rg16	a_201_392##3	a_201_392##6	447.214264
Rf1	B1#4	B1	0.739201
Rf2	B1#2	B1#6	160.972000
Rf3	B1#4	B1#6	6.495599
Rf4	B2#2	B2#5	160.926926
Rf5	B2#6	B2	0.694128
Rf6	B2#5	B2#6	8.857635
Rf7	a_27_74#	a_27_74##2	119.237885
Rf8	A2_N	A2_N#2	161.216980
Rf9	a_270_48##5	a_270_48#	72.743820
Rf10	a_270_48#	a_270_48##7	80.388535
Rf11	A1_N	A1_N#2	162.594833
Rf12	a_201_392##7	a_201_392##8	188.394897
Rf13	a_201_392##8	a_201_392##9	201.103729
Rf14	X	X#2	0.188680
Rf15	X#2	X	13.773650
Rf16	X	X#3	87.205292
Rf17	X#1	X#2	5.000000
Rf18	VPWR#1	VPWR#2	126.136734
Rf19	VPWR#2	VPWR#3	60.932301
Rf20	VPWR#3	VPWR#4	28.999557
Rf21	VPWR#4	VPWR#5	141.569427
Rf22	VPWR#2	VPWR#6	25.106941
Rf23	VPWR#4	VPWR#7	27.688198
Rf24	VGND#1	VGND#2	113.842613
Rf25	VGND#2	VGND#3	64.990410
Rf26	VGND#3	VGND#4	105.898689
Rf28	VGND#2	VGND#6	31.239477
Rf29	VGND#4	VGND#7	30.747387
Rf35	a_201_392##3	a_201_392##8	160.232803
Re1	VPWR#3	VPWR	1.091357
Re2	VGND	VGND#3	1.091398
*
*       CAPACITOR CARDS
*
*
C1	VGND#2	X#3	1.55536e-17
C2	VGND#2	a_201_392##7	1.30278e-17
C3	VGND#3	a_270_48##2	5.93322e-20
C4	B1#6	B2#5	2.18983e-17
C5	a_201_392##3	a_201_392##2	3.88183e-18
C6	a_201_392##3	a_270_48##2	1.00944e-19
C7	a_201_392##2	X#1	1.10368e-19
C8	VPWR#2	VPWR#1	1.90549e-18
C9	VGND#2	a_201_392##2	4.86452e-20
C10	VGND#1	X#3	7.59266e-17
C11	VPWR#2	VPWR#6	1.48757e-17
C12	a_270_48##2	A2_N#2	3.21626e-17
C13	VGND#6	VGND#1	1.62784e-18
C14	a_27_74#	B2#5	3.00735e-17
C15	VGND#6	X#3	4.56172e-17
C16	VPWR#7	VPWR#2	7.627e-18
C17	a_201_392##9	VPWR#4	1.82061e-17
C18	a_270_48#	a_270_48##2	2.8678e-17
C19	a_201_392##9	VPWR#2	8.8255e-19
C20	a_27_74##2	B1#6	2.74954e-17
C21	VGND#2	a_201_392##4	1.59361e-18
C22	VPWR#5	VPWR#4	2.41223e-19
C23	a_201_392##7	VGND#6	2.7273e-17
C24	a_270_48##2	VPWR#7	1.36099e-18
C25	B2#2	a_270_48##2	3.73554e-17
C26	VGND#2	a_201_392##5	4.90131e-18
C27	VPWR#2	a_201_392##2	4.52658e-20
C28	a_201_392##7	a_270_48##7	6.17781e-17
C29	VGND#2	A1_N#1	9.77153e-19
C30	VGND#1	VPWR#1	9.71428e-18
C31	a_27_74#	a_270_48##7	3.46614e-18
C32	a_201_392##9	a_270_48##2	7.43269e-19
C33	a_27_74#	a_201_392##7	5.55742e-17
C34	B2#5	a_201_392##9	1.12585e-17
C35	VGND#7	a_201_392##7	5.90166e-18
C36	VGND#7	a_27_74#	6.64558e-17
C37	B2#5	VPWR#5	5.93433e-19
C38	a_27_74##2	a_27_74#	2.34428e-18
C39	a_27_74##2	VGND#7	6.66122e-17
C40	B1#6	VPWR#5	2.10698e-17
C41	a_270_48##7	a_270_48##5	5.68465e-18
C42	a_201_392##7	a_270_48##5	9.74087e-19
C43	VGND#1	a_201_392##4	2.7044e-17
C44	X#3	a_201_392##4	4.04207e-17
C45	VGND#1	a_201_392##5	1.35946e-18
C46	VPWR#2	a_201_392#	3.04549e-18
C47	VGND#6	a_201_392##4	1.27751e-18
C48	a_27_74#	a_201_392##9	1.68355e-18
C49	X#3	a_201_392##5	4.22146e-17
C50	VGND#1	A1_N#1	2.75722e-19
C51	a_201_392##5	VGND#6	1.73571e-17
C52	VPWR#2	a_201_392##6	1.60594e-17
C53	X#3	A1_N#1	2.40022e-18
C54	VGND#6	A1_N#1	3.90519e-17
C55	X#3	A2_N#1	5.48609e-19
C56	VPWR#2	A1_N#3	1.52216e-17
C57	VGND#6	A2_N#1	1.94169e-18
C58	a_270_48##7	A1_N#1	1.30688e-18
C59	a_27_74##2	VPWR#5	2.08498e-19
C60	VPWR#2	A2_N#3	1.64019e-18
C61	VGND#6	a_270_48##3	1.11524e-19
C62	a_270_48##5	VPWR#7	1.82808e-18
C63	a_201_392##7	A1_N#1	5.01361e-18
C64	a_270_48##7	A2_N#1	5.26414e-17
C65	VPWR#4	a_270_48##4	5.55462e-18
C66	a_201_392##9	a_270_48##5	5.70922e-17
C67	VPWR#2	a_270_48##4	9.68299e-19
C68	VGND#6	B2#3	3.89904e-20
C69	a_201_392##7	A2_N#1	2.44991e-17
C70	a_270_48##7	a_270_48##3	1.57506e-18
C71	VGND#7	A1_N#1	2.86698e-20
C72	a_201_392##9	VPWR#7	6.61153e-17
C73	VPWR#4	B2#1	5.69506e-18
C74	a_27_74#	A2_N#1	1.01459e-18
C75	a_201_392##7	a_270_48##3	4.94853e-17
C76	a_270_48##7	B2#3	2.64872e-19
C77	VGND#7	A2_N#1	1.19274e-19
C78	a_270_48##3	a_27_74#	2.26772e-17
C79	a_201_392##7	B2#3	1.74887e-18
C80	VPWR#5	VPWR#7	6.00163e-19
C81	VGND#7	a_270_48##3	2.35254e-18
C82	a_27_74#	B2#3	3.42844e-17
C83	a_27_74##2	a_270_48##3	2.74923e-19
C84	VPWR#5	a_201_392##9	3.07349e-17
C85	VGND#7	B2#3	4.01069e-17
C86	a_270_48##2	A2_N#1	2.41976e-19
C87	a_27_74#	B1#3	8.90407e-19
C88	a_27_74##2	B2#3	8.56418e-19
C89	VGND#7	B1#3	3.53179e-17
C90	VPWR#3	VPWR#4	4.49989e-17
C91	a_27_74##2	B1#3	3.21586e-17
C92	a_270_48##5	A2_N#1	2.92812e-18
C93	VGND#3	VGND#2	4.77837e-17
C94	VPWR#3	VPWR#2	5.07942e-17
C95	a_201_392##9	A2_N#1	2.76327e-19
C96	VGND#2	a_201_392##3	1.05501e-18
C97	a_201_392##5	a_201_392##4	3.85675e-17
C98	VPWR#1	a_201_392#	3.27586e-17
C99	a_201_392##3	VPWR#2	5.24456e-17
C100	VGND#2	A1_N#2	2.43425e-20
C101	a_201_392#	X#1	2.44089e-17
C102	VPWR#1	a_201_392##6	1.27785e-18
C103	A1_N#1	a_201_392##5	2.20902e-17
C104	a_201_392##6	X#1	2.37354e-17
C105	VPWR#2	A1_N#2	8.8644e-19
C106	a_201_392##6	VPWR#6	1.13402e-17
C107	A2_N	a_270_48##2	4.15756e-18
C108	A2_N#1	A1_N#1	5.45193e-17
C109	a_270_48##5	a_201_392##6	1.82796e-18
C110	A1_N#3	VPWR#6	1.87761e-17
C111	VPWR#7	a_201_392##6	8.07215e-19
C112	a_270_48##5	A1_N#3	2.94554e-17
C113	a_201_392##9	a_201_392##6	4.89814e-19
C114	a_270_48##3	A2_N#1	6.49369e-18
C115	VPWR#7	A1_N#3	2.37302e-18
C116	VGND#3	VGND#1	2.66603e-17
C117	a_270_48##5	A2_N#3	3.60931e-17
C118	a_201_392##9	A1_N#3	1.20257e-17
C119	A2_N#3	VPWR#7	2.45031e-17
C120	B2	a_270_48##2	7.94798e-18
C121	VPWR#4	B2#2	4.02748e-20
C122	B2#3	a_270_48##3	3.1294e-17
C123	a_201_392##9	A2_N#3	2.55699e-17
C124	a_201_392##3	X#3	3.47721e-17
C125	a_270_48##4	VPWR#7	3.17728e-17
C126	a_201_392##3	VGND#6	7.23049e-17
C127	a_201_392##9	a_270_48##4	7.37247e-17
C128	VGND#3	a_201_392##7	7.78751e-17
C129	B1#3	B2#3	4.22955e-17
C130	VPWR#7	B2#1	1.14111e-18
C131	a_270_48##7	a_201_392##3	6.18598e-17
C132	a_201_392##9	B2#1	2.53669e-17
C133	VPWR#3	VPWR#1	2.60874e-17
C134	VPWR#5	a_270_48##4	3.90457e-18
C135	a_201_392##7	a_201_392##3	1.13463e-18
C136	VPWR#7	B1#1	6.75594e-19
C137	a_201_392##9	B1#1	1.00402e-17
C138	a_270_48##7	A1_N#2	1.35942e-19
C139	VPWR#5	B2#1	1.52373e-17
C140	B2#5	B2#2	1.39163e-17
C141	VPWR#5	B1#1	5.90288e-17
C142	B1#6	B2#2	2.89521e-18
C143	a_270_48##7	A2_N#2	8.93198e-18
C144	a_201_392##7	A2_N#2	1.07812e-19
C145	B2#5	B1#2	5.73343e-18
C146	a_201_392##9	VPWR#3	6.1034e-18
C147	a_201_392##3	VPWR#6	2.0028e-17
C148	a_270_48##7	a_270_48#	2.10954e-19
C149	B1#6	B1#2	1.33286e-17
C150	a_201_392##6	a_201_392#	4.73694e-17
C151	a_270_48##5	a_201_392##3	1.01692e-17
C152	a_201_392##7	a_270_48#	2.43415e-17
C153	VPWR#3	VPWR#5	3.91678e-17
C154	a_27_74#	a_270_48#	1.11014e-17
C155	X	a_201_392##2	1.29857e-17
C156	A1_N#3	a_201_392##6	1.55375e-17
C157	a_27_74#	B2#2	2.93794e-18
C158	a_270_48##5	A2_N#2	2.58616e-18
C159	VPWR#3	A2_N#1	9.08811e-20
C160	a_201_392##3	a_201_392##4	9.21299e-19
C161	A2_N#3	A1_N#3	2.65643e-17
C162	a_270_48##4	a_201_392##6	2.07757e-19
C163	a_201_392##9	A2_N#2	5.08538e-19
C164	a_201_392##3	a_201_392##5	4.04755e-18
C165	VGND#3	A2_N#1	4.61106e-18
C166	a_270_48#	VPWR#7	4.50109e-18
C167	a_201_392##3	A1_N#1	1.58433e-17
C168	a_27_74##2	B1#2	3.70104e-18
C169	VGND#3	a_270_48##3	1.46331e-18
C170	a_270_48#	a_201_392##9	5.87955e-17
C171	a_201_392##3	A2_N#1	1.12104e-17
C172	a_270_48##4	A2_N#3	1.92698e-17
C173	a_201_392##3	a_270_48##3	1.35879e-19
C174	A2_N#1	A1_N#2	1.59729e-18
C175	a_201_392##9	B2#2	2.57445e-18
C176	B2#1	a_270_48##4	3.27182e-17
C177	VPWR#4	VPWR#2	4.01127e-19
C178	a_201_392##7	a_500_74#	3.30773e-18
C179	X#3	a_201_392##2	1.15886e-17
C180	a_201_392##3	a_201_392#	6.28804e-20
C181	B1#1	B2#1	5.82171e-17
C182	VPWR#5	B1#2	5.44893e-18
C183	VPWR#3	A2_N#3	6.02084e-18
C184	a_270_48#	a_270_48##3	4.32549e-18
C185	a_201_392##3	a_201_392##6	1.13509e-17
C186	a_270_48#	B2#3	8.27286e-19
C187	a_201_392##3	A1_N#3	2.23813e-17
C188	A1_N#2	a_201_392##6	3.3345e-18
C189	a_201_392##3	A2_N#3	6.7441e-19
C190	VGND	a_201_392##2	1.14131e-19
C191	a_201_392##3	a_270_48##4	4.09365e-19
C192	a_270_48#	a_201_392##6	3.18058e-20
C193	a_270_48#	A1_N#3	4.03384e-19
C194	a_270_48##4	A2_N#2	3.11421e-19
C195	A1_N#1	a_500_74#	2.70915e-18
C196	a_270_48#	a_270_48##4	7.42242e-18
C197	A2_N#1	a_500_74#	6.45992e-18
C198	a_270_48#	B2#1	6.56209e-19
C199	a_270_48#	B1#1	4.65803e-19
C200	VGND#3	A1_N#2	1.71541e-20
C201	VPWR#3	A2_N#2	6.34132e-20
C202	a_270_48##7	A2_N	3.7626e-17
C203	a_201_392##3	A1_N#2	5.23769e-17
C204	A1_N	VPWR#6	1.56379e-18
C205	VGND#3	A2_N#2	3.18577e-20
C206	A1_N	a_270_48##5	1.23792e-17
C207	a_201_392##3	A2_N#2	1.84786e-19
C208	A1_N	a_201_392##9	1.12316e-18
C209	A2_N#2	A1_N#2	3.62105e-17
C210	a_270_48#	a_201_392##3	2.36264e-18
C211	VPWR#2	X	3.71959e-17
C212	a_27_74#	B2	1.7667e-17
C213	A2_N	a_270_48##5	3.80833e-17
C214	B2#1	a_117_392#	2.52858e-17
C215	a_270_48#	A1_N#2	2.54331e-19
C216	B1#1	a_117_392#	2.61244e-17
C217	a_270_48#	A2_N#2	5.12398e-18
C218	VPWR	VPWR#4	2.51618e-17
C219	VPWR	VPWR#2	5.0412e-17
C220	B2	a_201_392##9	2.66447e-17
C221	a_27_74##2	B1	1.76446e-17
C222	a_270_48#	B2#2	2.46105e-18
C223	X#3	X	3.16013e-18
C224	a_270_48#	B1#2	6.42411e-19
C225	a_201_392##2	VNB	3.92692e-17
C226	a_270_48##2	VNB	3.55434e-17
C227	A1_N	a_201_392##6	4.43378e-19
C228	a_201_392##3	a_500_74#	1.34406e-17
C229	B1#2	B2#2	3.8405e-17
C230	VPWR	B2#5	4.13787e-18
C231	VPWR	B1#6	1.93575e-18
C232	VGND	VGND#2	2.70817e-17
C233	X	VPWR#1	9.45509e-17
C234	B1	VPWR#5	2.04979e-17
C235	X	X#1	8.9284e-19
C236	VGND	B2#5	1.65863e-18
C237	VPWR	VPWR#1	3.16037e-17
C238	VGND	B1#6	1.29669e-18
C239	VGND	VGND#1	3.1989e-17
C240	VPWR	a_270_48##5	4.00801e-18
C241	VGND	X#3	2.04016e-17
C242	VGND	VGND#6	2.28192e-17
C243	VPWR	VPWR#7	1.99469e-17
C244	a_201_392##3	A1_N	6.53114e-17
C245	VPWR	a_201_392##9	3.04532e-17
C246	VGND	a_270_48##7	8.30642e-18
C247	A1_N	A1_N#2	1.8479e-17
C248	VGND	a_201_392##7	3.99981e-17
C249	VPWR	VPWR#5	5.06726e-17
C250	VGND	a_27_74#	1.52163e-17
C251	VGND	VGND#7	2.28449e-17
C252	A1_N	A2_N#2	3.66057e-18
C253	VGND	a_27_74##2	1.5278e-17
C254	VGND	VPWR#1	3.12218e-18
C255	X	a_201_392#	3.43052e-17
C256	A2_N	A1_N#2	3.46387e-18
C257	X	a_201_392##6	3.1733e-17
C258	X	A1_N#3	1.91682e-18
C259	A2_N	A2_N#2	1.45048e-17
C260	X	A2_N#3	3.02556e-19
C261	B2#5	VPWR#4	5.3597e-19
C262	a_270_48#	A2_N	2.6418e-17
C263	X	a_270_48##4	3.01232e-19
C264	VGND	a_201_392##4	4.47888e-18
C265	VPWR	a_201_392#	4.66507e-18
C266	VGND	a_201_392##5	1.37822e-18
C267	VPWR	a_201_392##6	3.15169e-18
C268	VGND	A1_N#1	6.90549e-19
C269	B2	a_270_48#	2.85523e-17
C270	VPWR	A1_N#3	6.84769e-18
C271	VGND	A2_N#1	4.27655e-18
C272	VPWR	A2_N#3	6.84769e-18
C273	VGND#2	VNB	3.66428e-17
C274	VGND	a_270_48##3	4.7089e-18
C275	B2	B2#2	4.52803e-18
C276	VPWR#4	VNB	3.32976e-17
C277	VGND	B2#3	8.86273e-19
C278	VPWR	a_270_48##4	4.74313e-20
C279	VPWR#2	VNB	4.34025e-17
C280	VGND	B1#3	1.66768e-18
C281	VPWR	B2#1	2.50405e-18
C282	a_201_392##3	X	9.05846e-17
C283	VPWR	B1#1	1.482e-18
C284	X	A1_N#2	8.57935e-20
C285	B2#5	VNB	4.69498e-19
C286	VPWR	VPWR#3	1.35525e-17
C287	B1	B1#2	9.83362e-18
C288	B1#6	VNB	7.01975e-19
C289	VGND#1	VNB	6.9214e-17
C290	X#3	VNB	9.62846e-18
C291	VGND#6	VNB	1.79581e-18
C292	VPWR	a_201_392##3	8.03707e-18
C293	a_270_48##7	VNB	7.85696e-18
C294	a_201_392##7	VNB	1.43431e-17
C295	a_27_74#	VNB	1.0627e-17
C296	VGND#7	VNB	2.58926e-18
C297	a_27_74##2	VNB	5.01686e-17
C298	VPWR#1	VNB	8.06912e-17
C299	VPWR	a_270_48#	3.50446e-18
C300	VGND	VGND#3	1.89708e-17
C301	A2_N	A1_N	2.46338e-17
C302	VPWR#7	VNB	6.26327e-18
C303	VGND	a_201_392##3	7.36883e-18
C304	a_201_392##9	VNB	5.91053e-18
C305	VPWR	B1#2	4.63624e-21
C306	VPWR#5	VNB	8.55174e-17
C307	a_201_392##4	VNB	3.40821e-17
C308	a_201_392##5	VNB	2.88438e-17
C309	A1_N#1	VNB	2.85646e-17
C310	VGND	a_270_48#	3.56859e-18
C311	A2_N#1	VNB	4.84503e-17
C312	a_270_48##3	VNB	3.45412e-17
C313	B2#3	VNB	2.68818e-17
C314	B1#3	VNB	3.62707e-17
C315	a_201_392#	VNB	4.11258e-17
C316	a_201_392##6	VNB	3.49058e-17
C317	A1_N#3	VNB	3.24747e-17
C318	A2_N#3	VNB	3.05389e-17
C319	a_270_48##4	VNB	3.67768e-17
C320	B2#1	VNB	2.54234e-17
C321	B1#1	VNB	2.99175e-17
C322	VPWR	A1_N	3.23646e-18
C323	VPWR#3	VNB	2.01998e-16
C324	VGND#3	VNB	2.20563e-16
C325	VPWR	A2_N	1.71008e-18
C326	a_201_392##3	VNB	3.89609e-17
C327	A1_N#2	VNB	3.70541e-17
C328	A2_N#2	VNB	3.20714e-17
C329	VGND	A1_N	1.56032e-18
C330	VPWR	B2	1.11458e-18
C331	a_270_48#	VNB	9.52685e-18
C332	B2#2	VNB	4.06055e-17
C333	VGND	A2_N	1.78942e-18
C334	VPWR	B1	1.11268e-18
C335	B1#2	VNB	5.87555e-17
C336	VGND	B2	1.18251e-18
C337	VPWR	X	2.06684e-17
C338	VGND	B1	1.18058e-18
C339	VGND	X	1.17891e-18
C340	A1_N	VNB	3.24471e-18
C341	A2_N	VNB	1.96633e-18
C342	a_201_392##7	a_270_48##2	1.50482e-18
C343	B1	VNB	1.78821e-17
C344	X	VNB	1.09169e-17
C345	VPWR	VNB	6.32622e-17
C346	VGND	VNB	6.89699e-17
C347	VGND#2	VGND#1	7.07222e-19
C348	VGND#4	B2#2	5.01757e-20
C349	VGND#3	VGND#4	6.31842e-17
C350	VGND#4	a_270_48##3	4.20975e-18
C351	VGND#4	a_27_74##2	1.78091e-17
C352	VGND#4	VNB	5.60078e-17
C353	VGND#4	a_27_74#	1.47075e-17
C354	VGND	VGND#4	3.73071e-17
C355	VGND#4	B1#2	6.28006e-20
C356	VGND#4	B2#3	1.24646e-18
C357	VGND#4	a_270_48#	3.68149e-19
C358	VGND#4	B1#3	1.24646e-18
*
*
.ENDS sky130_fd_sc_hs__o2bb2a_2
*
