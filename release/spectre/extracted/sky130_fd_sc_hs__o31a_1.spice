* Extracted by Quantus, converted by sky130cad/quantus.py
*
*
*
*                       LINUX           Wed Nov 18 09:01:47 2026
*
*
*
*  PROGRAM  advgen
*
*  Name           : advgen - Quantus - (64-bit)
*  Version        : 25.1.0-p047
*  Build Date     : Thu Dec 11 23:20:30 PST 2025
*
*  HSPICE LIBRARY
*
*  OPERATING_TEMPERATURE 150
*  QRC_TECH_DIR <path>/tech
*
*
*

*
.SUBCKT sky130_fd_sc_hs__o31a_1 VNB VPB VGND VPWR X A2 A1 A3 B1
*
*
*  caps2d version: 10
*
*
*       TRANSISTOR CARDS
*
*
XM8 X#3 a_84_48##3 VGND#7 VNB sky130_fd_pr__nfet_01v8_lvt l=0.15 w=0.74 ad=0.2109 as=0.3107 pd=2.05 ps=2.34
XM1 VGND#7 A1#3 a_230_94##2 VNB sky130_fd_pr__nfet_01v8_lvt l=0.15 w=0.64 ad=0.3107 as=0.2272 pd=2.34 ps=1.99
XM7 a_230_94##2 A2#3 VGND#6 VNB sky130_fd_pr__nfet_01v8_lvt l=0.15 w=0.64 ad=0.2272 as=0.3648 pd=1.99 ps=2.42
XM2 VGND#6 A3#1 a_230_94# VNB sky130_fd_pr__nfet_01v8_lvt l=0.15 w=0.64 ad=0.3648 as=0.2208 pd=2.42 ps=1.97
XM0 a_230_94# B1#1 a_84_48##4 VNB sky130_fd_pr__nfet_01v8_lvt l=0.15 w=0.64 ad=0.2208 as=0.2272 pd=1.97 ps=1.99
XM6 X#1 a_84_48# VPWR#7 VPB sky130_fd_pr__pfet_01v8 l=0.15 w=1.12 ad=0.3304 as=0.5814 pd=2.83 ps=3.32
XM5 VPWR#7 A1#1 a_256_368# VPB sky130_fd_pr__pfet_01v8 l=0.15 w=1 ad=0.5814 as=0.27 pd=3.32 ps=2.54
XM3 a_256_368# A2#1 a_340_368# VPB sky130_fd_pr__pfet_01v8 l=0.15 w=1 ad=0.27 as=0.36 pd=2.54 ps=2.72
XM9 a_340_368# A3#3 a_84_48##7 VPB sky130_fd_pr__pfet_01v8 l=0.15 w=1 ad=0.36 as=0.3748 pd=2.72 ps=2.78
XM4 a_84_48##7 B1#3 VPWR#6 VPB sky130_fd_pr__pfet_01v8 l=0.15 w=0.84 ad=0.3748 as=0.399 pd=2.78 ps=2.63
*
*
*       RESISTOR AND CAP/DIODE CARDS
*
Rg1	a_84_48#	a_84_48##2	447.381653
Rg2	a_84_48##2	a_84_48##3	364.741730
Rg3	A1#1	A1#2	400.207520
Rg4	A1#2	A1#3	353.846649
Rg5	A2#1	A2#2	422.415131
Rg6	A2#2	A2#3	325.153564
Rg7	A3#1	A3#2	353.846649
Rg8	A3#2	A3#3	400.207520
Rg9	B1#1	B1#2	353.846649
Rg10	B1#2	B1#3	354.298584
Rf1	X	X#2	0.176491
Rf2	X#2	X	12.883880
Rf3	X	X#3	86.755157
Rf4	X#1	X#2	5.000000
Rf5	A1#2	A1#5	161.302414
Rf6	A1#6	A1	1.069610
Rf7	A1#5	A1#6	5.583287
Rf8	A2	A2#2	168.106262
Rf9	A3#4	A3#2	160.996811
Rf10	A3	A3#6	0.764007
Rf11	A3#4	A3#6	5.905091
Rf12	a_230_94#	a_230_94##2	115.376869
Rf13	B1#4	B1#2	161.913620
Rf14	B1	B1#6	1.680815
Rf15	B1#4	B1#6	5.294745
Rf16	a_84_48##4	a_84_48##5	144.086578
Rf17	a_84_48##5	a_84_48##2	309.926697
Rf18	a_84_48##5	a_84_48##7	15.059351
Rf20	VPWR#2	VPWR#3	88.558434
Rf21	VPWR#3	VPWR#4	60.018620
Rf23	VPWR#2	VPWR#6	47.526955
Rf24	VPWR#4	VPWR#7	31.179564
Rf26	VGND#2	VGND#3	19.498312
Rf27	VGND#3	VGND#4	65.720917
Rf29	VGND#2	VGND#6	33.971684
Rf30	VGND#4	VGND#7	33.306259
Re1	VPWR#3	VPWR	1.403190
Re2	VGND	VGND#3	1.403242
*
*       CAPACITOR CARDS
*
*
C1	a_230_94#	a_84_48##4	5.92105e-17
C2	VGND	VNB	7.02735e-17
C3	VPWR	VNB	5.88772e-17
C4	X	VNB	4.93602e-17
C5	A2	VNB	2.47527e-18
C6	A3	VNB	1.60656e-18
C7	B1	VNB	4.30324e-18
C8	a_84_48##2	VNB	4.65773e-17
C9	VGND	X	9.0513e-19
C10	A1#2	VNB	2.71005e-17
C11	A2#2	VNB	2.91916e-17
C12	A3#2	VNB	2.64109e-17
C13	VGND	A2	2.6541e-18
C14	B1#2	VNB	4.24864e-17
C15	VGND#3	VNB	2.03516e-16
C16	VPWR	X	1.80303e-17
C17	VPWR#3	VNB	1.84876e-16
C18	a_84_48#	VNB	4.09163e-17
C19	A1#1	VNB	3.37116e-17
C20	VPWR	A2	2.58567e-18
C21	A2#1	VNB	2.88226e-17
C22	A3#3	VNB	3.36206e-17
C23	B1#3	VNB	3.43476e-17
C24	a_84_48##3	VNB	3.78884e-17
C25	A1#3	VNB	3.40699e-17
C26	A2#3	VNB	3.49041e-17
C27	A3#1	VNB	3.43321e-17
C28	VPWR	A3	2.51368e-18
C29	B1#1	VNB	3.89366e-17
C30	X#1	VNB	2.01242e-17
C31	VPWR	B1	2.73316e-18
C32	a_84_48##7	VNB	4.72471e-18
C33	VPWR#6	VNB	2.43654e-17
C34	X#3	VNB	5.30605e-17
C35	VGND#7	VNB	1.16059e-17
C36	a_230_94##2	VNB	8.77157e-18
C37	VGND#6	VNB	9.17148e-18
C38	a_230_94#	VNB	9.0732e-18
C39	a_84_48##4	VNB	6.49749e-17
C40	VGND	a_84_48##2	3.97706e-18
C41	A1#5	VNB	1.28818e-18
C42	A2	A3	1.30199e-17
C43	A1#6	VNB	2.48525e-18
C44	A3#4	VNB	2.1016e-18
C45	B1#4	VNB	5.21658e-18
C46	a_84_48##5	VNB	2.29754e-17
C47	VGND	VGND#3	5.86907e-17
C48	VPWR	a_84_48##2	7.4514e-18
C49	A3	B1	1.64842e-17
C50	X	a_84_48##2	5.97998e-17
C51	X	A1#2	1.59706e-20
C52	VPWR	VPWR#3	2.36436e-17
C53	VGND	a_84_48##3	1.97793e-18
C54	a_84_48##2	A2	7.54836e-19
C55	VGND	A1#3	8.13922e-18
C56	VPWR	a_84_48#	3.8172e-18
C57	VGND	A2#3	1.01039e-17
C58	VPWR	A1#1	7.24984e-18
C59	VGND	A3#1	9.39056e-18
C60	A2	A1#2	3.38264e-18
C61	VGND	B1#1	9.39056e-18
C62	VPWR	A2#1	9.28394e-18
C63	A2	A2#2	1.79319e-17
C64	VPWR	A3#3	7.25174e-18
C65	VPWR	B1#3	2.34868e-18
C66	A2	A3#2	3.77627e-18
C67	X	a_84_48#	2.24003e-17
C68	VGND	X#3	1.93554e-17
C69	X	A1#1	1.16212e-18
C70	VGND	VGND#7	2.04957e-17
C71	VGND	a_230_94##2	1.72996e-17
C72	VGND	a_230_94#	1.74155e-17
C73	VGND	a_84_48##4	1.68119e-17
C74	A3	A2#2	1.26569e-18
C75	VGND	A1#5	4.99236e-18
C76	A3	A3#2	5.92379e-18
C77	A2	A1#1	5.67158e-19
C78	A2	A2#1	2.69765e-18
C79	VPWR	a_84_48##7	1.46871e-17
C80	A3	B1#2	1.03905e-18
C81	VGND	A3#4	2.66662e-18
C82	A2	A3#3	7.6603e-19
C83	VGND	B1#4	5.19724e-18
C84	B1	A3#2	1.69474e-18
C85	X	X#1	3.12787e-18
C86	B1	B1#2	5.59957e-18
C87	X	VPWR#7	1.50496e-17
C88	a_84_48##2	a_256_368#	8.89678e-19
C89	a_84_48##5	a_84_48##7	4.56815e-18
C90	VPWR	A1#6	2.62342e-18
C91	X#3	X	3.32175e-18
C92	A3	A2#1	5.43312e-19
C93	A3	A3#3	2.00604e-18
C94	A3	B1#3	8.69321e-19
C95	A2#2	a_340_368#	1.99343e-19
C96	VPWR	a_84_48##5	1.89797e-17
C97	B1	A3#3	3.74198e-19
C98	a_84_48##2	A1#2	3.61348e-17
C99	X#3	A2	1.29459e-18
C100	B1	B1#3	2.22458e-18
C101	a_84_48##5	VPWR#6	3.34101e-17
C102	a_230_94##2	A2	4.12375e-17
C103	A2	VGND#6	1.8969e-18
C104	a_230_94#	A3#4	2.3053e-17
C105	A2	a_84_48##4	1.67792e-18
C106	A1#2	A2#2	3.40202e-17
C107	A1#5	A2	2.04001e-17
C108	A1#1	a_256_368#	2.38236e-17
C109	A1#6	A2	1.53353e-17
C110	A2#1	a_256_368#	2.38236e-17
C111	A2#2	A3#2	3.0334e-17
C112	A2	A3#4	1.86875e-17
C113	a_84_48##2	VPWR#3	1.15409e-20
C114	VGND#3	A1#2	4.40591e-20
C115	A2#1	a_340_368#	2.76262e-17
C116	A3#3	a_340_368#	2.76262e-17
C117	A3#2	B1#2	3.44611e-17
C118	A2	a_84_48##5	4.03704e-17
C119	a_84_48##2	a_84_48#	6.90819e-18
C120	VPWR#3	A2#2	2.81703e-19
C121	a_84_48##2	A1#1	2.65418e-17
C122	a_84_48#	A1#2	2.69721e-19
C123	a_84_48##2	A2#1	2.91714e-19
C124	VGND#3	B1#2	6.67562e-20
C125	a_84_48##2	A3#3	1.42475e-19
C126	a_230_94#	B1#4	2.71043e-17
C127	A1#2	A2#1	1.30131e-18
C128	B1	a_84_48##4	9.74056e-18
C129	a_84_48##2	B1#3	1.44775e-19
C130	a_230_94##2	a_84_48##5	5.98138e-18
C131	a_84_48##2	A1#3	4.91139e-19
C132	A2#1	A3#2	8.32078e-19
C133	B1#4	a_84_48##4	2.54709e-17
C134	A3	a_84_48##5	4.35769e-17
C135	A1#3	A2#2	1.03537e-18
C136	B1	a_84_48##5	3.96731e-17
C137	a_84_48##2	VPWR#7	5.65512e-17
C138	VPWR#3	A2#1	6.8598e-18
C139	a_230_94#	a_84_48##5	7.81232e-18
C140	A2#2	A3#1	6.08332e-19
C141	VPWR#3	A3#3	4.59111e-18
C142	a_84_48#	A1#1	1.88962e-17
C143	A1#2	VPWR#7	1.2284e-18
C144	a_84_48##2	a_84_48##7	4.8034e-20
C145	VGND#3	a_84_48##3	4.18241e-19
C146	a_84_48##4	a_84_48##5	4.76516e-18
C147	A1#1	A2#1	5.40482e-17
C148	X#3	a_84_48##2	2.79373e-17
C149	a_84_48##2	VGND#7	3.71529e-17
C150	VGND#3	A2#3	4.67827e-18
C151	a_230_94##2	a_84_48##2	7.64463e-19
C152	X#3	A1#2	1.79468e-19
C153	VGND#3	A3#1	4.59258e-18
C154	A2#1	A3#3	3.69756e-17
C155	VGND#3	B1#1	1.59934e-18
C156	a_230_94##2	A1#2	2.80528e-18
C157	X#3	A2#2	3.34503e-19
C158	a_84_48##5	a_256_368#	5.74691e-18
C159	A3#2	a_84_48##7	5.29945e-19
C160	A3#3	B1#3	2.68646e-17
C161	a_84_48##2	A1#5	2.38023e-17
C162	a_230_94##2	A2#2	2.86921e-18
C163	a_84_48##4	A1#2	9.87284e-20
C164	X#3	A3#2	2.9213e-20
C165	VGND#6	A2#2	1.23933e-18
C166	a_84_48##2	A1#6	4.92647e-17
C167	a_84_48##5	a_340_368#	8.91437e-18
C168	B1#2	VPWR#6	1.2284e-18
C169	A1#5	A1#2	1.03861e-17
C170	a_84_48##4	A2#2	8.3256e-20
C171	VGND#6	A3#2	9.94945e-19
C172	A3#4	B1#4	2.06777e-17
C173	X#1	a_84_48#	2.60856e-17
C174	A1#6	A1#2	5.75254e-18
C175	a_230_94#	A3#2	2.85406e-18
C176	a_84_48##7	VPWR#3	3.82842e-18
C177	A1#5	A2#2	2.96104e-18
C178	a_84_48#	VPWR#7	3.24917e-17
C179	a_84_48##4	A3#2	3.29044e-19
C180	X#1	A1#1	2.16049e-18
C181	VGND#7	VGND#3	3.04394e-19
C182	A1#6	A2#2	1.41997e-18
C183	a_230_94#	B1#2	2.62995e-18
C184	A1#1	VPWR#7	2.76149e-17
C185	VGND#3	a_230_94##2	8.38052e-18
C186	X#1	A2#1	5.17302e-19
C187	a_84_48##4	B1#2	1.18121e-17
C188	A3#4	A2#2	2.78122e-18
C189	a_84_48##3	A1#3	2.17186e-17
C190	a_84_48##7	a_84_48#	1.40675e-18
C191	VPWR#7	A2#1	2.93408e-18
C192	VGND#3	a_230_94#	1.50804e-17
C193	X#1	A3#3	3.50012e-19
C194	VPWR#7	A3#3	1.49313e-18
C195	a_84_48##7	A1#1	1.90638e-18
C196	A3#4	A3#2	9.72352e-18
C197	A1#3	A2#3	2.38093e-17
C198	VPWR#6	A1#1	4.46757e-20
C199	a_84_48##7	A2#1	4.39686e-18
C200	a_84_48##5	A2#2	1.52081e-18
C201	A3#4	B1#2	2.24518e-18
C202	B1#4	A3#2	3.18236e-18
C203	VPWR#6	A2#1	7.87561e-20
C204	a_84_48##7	A3#3	5.09037e-17
C205	A2#3	A3#1	1.17562e-17
C206	VPWR#6	A3#3	2.20359e-18
C207	B1#4	B1#2	1.039e-17
C208	B1#3	a_84_48##7	2.16352e-17
C209	a_84_48##5	A3#2	3.30395e-18
C210	VPWR#6	B1#3	3.25515e-17
C211	A3#1	B1#1	2.6364e-17
C212	a_84_48##5	B1#2	2.02743e-18
C213	A1#6	a_84_48#	2.18987e-19
C214	X#3	a_84_48##3	4.00134e-17
C215	A1#6	A1#1	2.02255e-18
C216	a_84_48##3	VGND#7	3.18884e-17
C217	X#1	VPWR#7	3.90336e-17
C218	a_84_48##5	VPWR#3	3.87488e-18
C219	X#3	A1#3	1.91845e-19
C220	A1#6	A2#1	7.14124e-19
C221	A1#3	VGND#7	2.06798e-17
C222	X#3	A2#3	2.51776e-20
C223	VGND#6	a_84_48##3	7.60073e-19
C224	a_230_94##2	A1#3	4.03702e-17
C225	VGND#7	A2#3	1.27896e-18
C226	X#3	A3#1	8.7639e-20
C227	VGND#6	A1#3	1.8607e-18
C228	a_230_94##2	A2#3	3.57633e-17
C229	a_84_48##5	a_84_48#	5.85446e-20
C230	VGND#7	A3#1	2.8137e-19
C231	a_230_94#	A1#3	1.64786e-19
C232	VPWR#7	a_84_48##7	9.55188e-18
C233	A2#3	VGND#6	2.67671e-17
C234	a_230_94##2	A3#1	1.04145e-18
C235	a_84_48##4	A1#3	4.43562e-20
C236	a_230_94#	A2#3	1.03349e-18
C237	a_84_48##5	A1#1	1.46058e-19
C238	A3#1	VGND#6	2.47291e-17
C239	a_230_94##2	B1#1	2.5083e-19
C240	a_84_48##4	A2#3	1.76604e-20
C241	a_230_94#	A3#1	3.98364e-17
C242	VGND#6	B1#1	2.2614e-18
C243	a_84_48##5	A2#1	2.31615e-17
C244	a_84_48##4	A3#1	2.19567e-19
C245	a_230_94#	B1#1	4.10722e-17
C246	a_84_48##5	A3#3	1.85769e-17
C247	a_84_48##7	VPWR#6	4.24706e-17
C248	a_84_48##4	B1#1	1.88745e-17
C249	a_84_48##5	B1#3	2.03713e-17
C250	X#3	VGND#7	6.83464e-17
C251	VGND#7	a_230_94##2	5.80208e-17
C252	VGND#7	VGND#6	3.66997e-18
C253	a_230_94##2	VGND#6	3.40452e-17
C254	a_230_94##2	a_230_94#	1.90762e-18
C255	a_230_94#	VGND#6	3.93671e-17
C256	a_230_94##2	A1#5	2.10845e-17
C257	a_84_48##2	VPWR#4	9.81435e-19
C258	VGND	VGND#4	3.66842e-17
C259	VPWR#4	A3#3	5.33222e-19
C260	X	VPWR#4	3.76438e-17
C261	VGND#3	VGND#2	2.84764e-17
C262	VPWR#3	VPWR#4	5.74843e-17
C263	VGND#4	A1#3	6.39206e-18
C264	VPWR#2	A3#2	6.66304e-20
C265	VGND#4	a_84_48##2	4.29419e-19
C266	VPWR#2	A1#1	1.48135e-19
C267	VGND#2	a_84_48##4	1.82365e-17
C268	VGND#2	B1#1	4.807e-18
C269	VPWR#2	VNB	5.83528e-17
C270	VGND#4	a_230_94##2	4.00495e-18
C271	VPWR#4	a_84_48##7	2.05721e-18
C272	VPWR#4	VNB	5.92703e-17
C273	VPWR#2	A2#1	2.61139e-19
C274	VGND#2	B1#4	1.15442e-18
C275	VGND#4	A1#2	2.67025e-20
C276	VGND#2	VNB	2.83967e-17
C277	VPWR#4	a_84_48#	1.52968e-17
C278	VGND#4	VNB	4.97214e-17
C279	VGND#3	VGND#4	5.56311e-17
C280	VPWR#4	VPWR#6	3.77475e-19
C281	VPWR#2	A3#3	2.32667e-18
C282	a_84_48##7	VPWR#2	1.04831e-17
C283	VGND#4	A1#5	1.10906e-18
C284	VPWR#4	VPWR#2	1.23511e-18
C285	VPWR#4	A1#1	1.04087e-17
C286	VPWR#3	VPWR#2	4.81154e-17
C287	VPWR#2	B1#3	2.26514e-18
C288	VPWR#4	VPWR#7	2.91013e-18
C289	VGND#4	X#3	2.23318e-17
C290	a_84_48##5	VPWR#2	2.43691e-18
C291	VPWR	VPWR#2	5.53547e-17
C292	VPWR#4	A2#1	1.63031e-18
C293	VGND#4	a_84_48##3	4.70245e-18
C294	VPWR	VPWR#4	7.0144e-17
C295	VGND	VGND#2	1.89434e-17
*
*
.ENDS sky130_fd_sc_hs__o31a_1
*
