* Extracted by Quantus, converted by sky130cad/quantus.py
*
*
*
*                       LINUX           Wed Nov 18 08:42:31 2026
*
*
*
*  PROGRAM  advgen
*
*  Name           : advgen - Quantus - (64-bit)
*  Version        : 25.1.0-p047
*  Build Date     : Thu Dec 11 23:20:30 PST 2025
*
*  HSPICE LIBRARY
*
*  OPERATING_TEMPERATURE 150
*  QRC_TECH_DIR <path>/tech
*
*
*

*
.SUBCKT sky130_fd_sc_hs__maj3_1 VPB VNB VGND VPWR X A B C
*
*
*  caps2d version: 10
*
*
*       TRANSISTOR CARDS
*
*
XM3 X#3 a_84_74##3 VGND#7 VNB sky130_fd_pr__nfet_01v8_lvt l=0.15 w=0.74 ad=0.2081 as=0.2778 pd=2.05 ps=2.27
XM4 VGND#7 A#4 a_223_120# VNB sky130_fd_pr__nfet_01v8_lvt l=0.15 w=0.64 ad=0.2778 as=0.1536 pd=2.27 ps=1.76
XM0 a_223_120# B#5 a_84_74##11 VNB sky130_fd_pr__nfet_01v8_lvt l=0.15 w=0.64 ad=0.1536 as=0.2444 pd=1.76 ps=2.16
XM12 a_84_74##11 B#4 a_403_136# VNB sky130_fd_pr__nfet_01v8_lvt l=0.15 w=0.64 ad=0.2444 as=0.1536 pd=2.16 ps=1.76
XM5 a_403_136# C#3 VGND#6 VNB sky130_fd_pr__nfet_01v8_lvt l=0.15 w=0.64 ad=0.1536 as=0.2688 pd=1.76 ps=2.12
XM10 VGND#6 A#2 a_595_136# VNB sky130_fd_pr__nfet_01v8_lvt l=0.15 w=0.64 ad=0.2688 as=0.1728 pd=2.12 ps=1.82
XM7 a_595_136# C#6 a_84_74##10 VNB sky130_fd_pr__nfet_01v8_lvt l=0.15 w=0.64 ad=0.1728 as=0.1733 pd=1.82 ps=1.85
XM11 X#1 a_84_74# VPWR#7 VPB sky130_fd_pr__pfet_01v8 l=0.15 w=1.12 ad=0.3304 as=0.3868 pd=2.83 ps=2.95
XM6 VPWR#7 A#5 a_226_384# VPB sky130_fd_pr__pfet_01v8 l=0.15 w=1 ad=0.3868 as=0.27 pd=2.95 ps=2.54
XM1 a_226_384# B#6 a_84_74##9 VPB sky130_fd_pr__pfet_01v8 l=0.15 w=1 ad=0.27 as=0.33 pd=2.54 ps=2.66
XM8 a_84_74##9 B#1 a_406_384# VPB sky130_fd_pr__pfet_01v8 l=0.15 w=1 ad=0.33 as=0.27 pd=2.66 ps=2.54
XM2 a_406_384# C#1 VPWR#6 VPB sky130_fd_pr__pfet_01v8 l=0.15 w=1 ad=0.27 as=0.39 pd=2.54 ps=2.78
XM13 VPWR#6 A#1 a_598_384# VPB sky130_fd_pr__pfet_01v8 l=0.15 w=1 ad=0.39 as=0.27 pd=2.78 ps=2.54
XM9 a_598_384# C#4 a_84_74##4 VPB sky130_fd_pr__pfet_01v8 l=0.15 w=1 ad=0.27 as=0.295 pd=2.54 ps=2.59
*
*
*       RESISTOR AND CAP/DIODE CARDS
*
Rg1	a_84_74#	a_84_74##2	434.057068
Rg2	a_84_74##2	a_84_74##3	307.355530
Rg3	B#1	B#2	415.223511
Rg4	B#2	B#3	68.002701
Rg5	B#2	B#4	294.260559
Rg6	B#3	B#5	343.184387
Rg7	B#3	B#6	412.311401
Rg8	C#1	C#2	397.001862
Rg9	C#2	C#3	264.146423
Rg10	A#1	A#2	757.336182
Rg11	A#2	A#3	279.244598
Rg12	A#3	A#4	1361.859741
Rg13	A#4	A#5	792.138123
Rg14	C#4	C#5	400.207520
Rg15	C#5	C#6	279.244598
Rf1	X#2	X	0.323707
Rf2	X	X#3	82.884430
Rf3	X#2	X	11.653459
Rf4	X#1	X#2	5.000000
Rf5	B#7	B	0.774904
Rf6	B#3	B#9	161.007706
Rf7	B#7	B#9	11.911013
Rf8	C#5	C	190.354538
Rf9	C	C#2	167.304962
Rf10	A#3	A	192.067703
Rf11	a_84_74##4	a_84_74##5	129.030334
Rf12	a_84_74##5	a_84_74##6	52.569668
Rf13	a_84_74##6	a_84_74##7	24.545425
Rf14	a_84_74##7	a_84_74##2	243.239960
Rf15	a_84_74##5	a_84_74##9	32.566124
Rf16	a_84_74##6	a_84_74##10	121.796066
Rf17	a_84_74##7	a_84_74##11	14.213133
Rf19	VPWR#2	VPWR#3	52.356598
Rf20	VPWR#3	VPWR#4	79.965767
Rf22	VPWR#2	VPWR#6	29.205244
Rf23	VPWR#4	VPWR#7	36.908188
Rf25	VGND#2	VGND#3	34.431774
Rf26	VGND#3	VGND#4	81.586975
Rf28	VGND#2	VGND#6	81.812569
Rf29	VGND#4	VGND#7	38.889141
Re1	VPWR#3	VPWR	1.227783
Re2	VGND	VGND#3	1.227829
*
*       CAPACITOR CARDS
*
*
C1	VPWR#3	B#2	1.53709e-20
C2	a_84_74##7	a_84_74##10	1.09238e-18
C3	VGND#3	B#2	8.65135e-20
C4	a_84_74##7	VGND#6	1.25806e-17
C5	a_84_74##6	VGND#6	3.71564e-17
C6	a_84_74##7	a_84_74##11	4.50678e-18
C7	VGND#7	a_84_74##7	1.27401e-17
C8	A#3	B#2	1.61662e-19
C9	X#3	a_84_74##7	1.84565e-18
C10	B#2	C#2	3.75615e-17
C11	a_84_74##5	a_84_74##4	6.29058e-20
C12	a_84_74##10	VGND#6	1.48406e-17
C13	B#3	B#2	9.81419e-19
C14	a_84_74##5	VPWR#6	3.54506e-17
C15	a_84_74##5	a_84_74##9	2.25105e-18
C16	VGND#7	VGND#6	1.80475e-18
C17	VPWR#7	a_84_74##5	8.30259e-18
C18	a_84_74##10	a_84_74##4	4.20137e-18
C19	a_84_74##7	C#6	3.56293e-19
C20	a_84_74##6	C#6	1.93125e-19
C21	a_84_74##7	A#2	2.63029e-19
C22	a_84_74##6	A#2	5.9648e-19
C23	a_84_74##7	C#3	2.7142e-18
C24	a_84_74##6	C#3	2.05786e-17
C25	X#3	VGND#7	4.60098e-17
C26	a_84_74##7	B#4	1.11128e-17
C27	a_84_74##6	B#4	2.00787e-17
C28	a_84_74##7	B#5	3.41181e-17
C29	a_84_74##6	B#5	7.80277e-20
C30	a_84_74##7	A#4	1.89837e-17
C31	a_84_74##6	A#4	1.97276e-19
C32	a_84_74##7	a_84_74##3	6.96877e-19
C33	a_84_74##5	A#4	3.42677e-20
C34	a_84_74##10	C#6	2.89434e-17
C35	a_84_74##4	VPWR#6	2.55009e-17
C36	a_84_74##10	A#2	2.01266e-17
C37	a_84_74##7	B#2	1.36673e-18
C38	VGND#6	C#6	4.05858e-18
C39	a_84_74##10	C#3	2.83442e-19
C40	a_84_74##9	a_84_74##4	9.96008e-19
C41	VGND#6	A#2	2.60239e-17
C42	a_84_74##10	B#4	1.40378e-19
C43	VGND#6	C#3	3.20388e-17
C44	a_84_74##5	C#4	4.78755e-19
C45	a_84_74##9	VPWR#6	2.18362e-17
C46	a_84_74##10	B#5	1.05125e-19
C47	a_84_74##6	B#2	4.96616e-18
C48	VGND#6	B#4	4.92673e-18
C49	a_84_74##5	A#1	8.23422e-19
C50	VGND#6	B#5	2.17294e-18
C51	VPWR#7	VPWR#6	1.23757e-18
C52	B#4	a_84_74##11	4.45549e-18
C53	a_84_74##5	C#1	1.99396e-17
C54	VGND#7	C#3	1.48175e-19
C55	VGND#6	A#4	2.61988e-19
C56	B#5	a_84_74##11	1.4087e-17
C57	a_84_74##5	B#1	1.59341e-17
C58	a_84_74##5	B#2	6.40346e-18
C59	VGND#7	B#4	2.68816e-19
C60	VPWR#7	a_84_74##9	2.22981e-17
C61	VGND#7	B#5	3.33764e-18
C62	a_84_74##5	B#6	6.39583e-18
C63	X#3	B#5	2.21096e-19
C64	VGND#7	A#4	3.74935e-17
C65	a_84_74##5	A#5	1.68737e-18
C66	X#3	A#4	2.19772e-18
C67	a_84_74##3	VGND#7	2.06879e-17
C68	X#3	a_84_74##3	3.52768e-17
C69	A#2	C#6	3.39968e-17
C70	a_84_74##5	VPWR#3	1.52881e-18
C71	a_84_74##4	C#4	5.58699e-17
C72	VGND#3	a_84_74##7	6.97866e-18
C73	VGND#3	a_84_74##6	2.05476e-18
C74	a_84_74##4	A#1	2.65452e-17
C75	C#3	A#2	1.60454e-17
C76	VPWR#6	C#4	9.08697e-18
C77	a_84_74##4	C#1	1.84929e-18
C78	a_84_74##6	C#5	1.42079e-19
C79	A#1	VPWR#6	3.43138e-17
C80	a_84_74##5	C#5	2.67679e-19
C81	a_84_74##9	C#4	2.54522e-19
C82	B#4	C#3	4.08004e-17
C83	a_84_74##4	B#1	1.2879e-19
C84	a_84_74##7	A#3	1.80622e-18
C85	VPWR#6	C#1	5.00869e-17
C86	a_84_74##6	A#3	3.82218e-18
C87	a_84_74##9	A#1	2.32562e-19
C88	a_84_74##5	A#3	5.55226e-19
C89	VPWR#6	B#1	5.99667e-18
C90	B#5	B#4	2.29404e-17
C91	a_84_74##9	C#1	4.34154e-18
C92	a_84_74##6	C#2	3.91161e-17
C93	VPWR#6	B#6	4.56943e-19
C94	a_84_74##5	C#2	3.70478e-17
C95	a_84_74##9	B#1	5.07556e-17
C96	VPWR#7	C#1	2.45667e-19
C97	A#4	B#5	6.87549e-17
C98	a_84_74##7	B#3	3.45282e-17
C99	VPWR#6	A#5	2.70817e-19
C100	B#3	a_84_74##6	1.35026e-17
C101	C#5	a_84_74##10	6.12368e-17
C102	B#6	a_84_74##9	4.11205e-17
C103	VPWR#7	B#1	2.66289e-18
C104	B#3	a_84_74##5	3.83403e-17
C105	VPWR#6	a_84_74#	1.40161e-20
C106	a_84_74##3	A#4	2.5654e-17
C107	a_84_74##9	A#5	3.97216e-18
C108	A#3	a_84_74##10	9.33335e-18
C109	VPWR#7	B#6	7.429e-18
C110	a_84_74##2	a_84_74##6	1.43592e-18
C111	VGND#6	A#3	4.53558e-17
C112	VPWR#7	A#5	6.52559e-17
C113	a_84_74#	VPWR#7	2.795e-17
C114	VGND#6	C#2	3.77973e-19
C115	a_84_74#	X#1	1.1818e-17
C116	C#5	a_84_74##4	6.05577e-17
C117	a_84_74##9	VPWR#3	1.51668e-17
C118	VGND#7	A#3	9.45962e-19
C119	A#1	C#4	5.32214e-17
C120	VPWR#6	A#3	4.06277e-19
C121	a_84_74##5	a_406_384#	5.96875e-18
C122	C#1	A#1	2.82577e-17
C123	C#2	VPWR#6	1.3853e-18
C124	a_84_74##2	VGND#7	3.62364e-17
C125	X#3	a_84_74##2	4.2822e-17
C126	B#1	C#1	5.2093e-17
C127	C#5	A#2	1.65566e-17
C128	VGND#3	B#4	5.36105e-18
C129	A#3	C#6	7.49673e-18
C130	B#3	a_84_74##9	2.23313e-19
C131	VGND#3	B#5	1.70239e-18
C132	B#6	B#1	3.69609e-17
C133	VGND#3	A#4	6.78295e-18
C134	A#3	C#3	1.85799e-17
C135	a_84_74##6	a_403_136#	1.96165e-18
C136	C#2	A#2	2.04323e-17
C137	A#3	B#4	1.27556e-17
C138	a_84_74##4	a_598_384#	5.31481e-18
C139	a_84_74##2	VPWR#7	2.03059e-17
C140	B#5	A#3	7.7499e-19
C141	A#5	B#6	5.5634e-17
C142	B#4	C#2	7.54463e-19
C143	A#4	A#3	4.96982e-19
C144	a_84_74##10	a_595_136#	2.43692e-18
C145	a_84_74##7	a_223_120#	7.38259e-19
C146	B#3	B#4	1.38518e-18
C147	a_84_74#	A#5	4.305e-17
C148	VPWR#3	B#1	9.2516e-18
C149	C#5	A#1	1.63393e-17
C150	VPWR#3	B#6	1.20135e-17
C151	a_84_74##2	B#4	8.11739e-20
C152	A#4	B#3	1.71648e-17
C153	a_84_74##2	B#5	1.72466e-20
C154	a_84_74##2	A#4	3.66803e-17
C155	C#2	A#1	1.45846e-17
C156	a_84_74##2	a_84_74##3	3.27021e-18
C157	a_84_74##6	C	1.69162e-17
C158	C	a_84_74##5	2.91535e-17
C159	a_84_74##7	B	2.24117e-17
C160	C#6	a_595_136#	1.36917e-17
C161	A#5	B#3	1.75834e-17
C162	C#4	a_598_384#	2.50123e-17
C163	A#2	a_595_136#	1.32389e-17
C164	a_84_74##10	C	2.27091e-17
C165	A#1	a_598_384#	2.41961e-17
C166	a_84_74##2	A#5	1.41302e-17
C167	VGND#3	A#3	1.14297e-17
C168	B#2	VNB	1.7869e-17
C169	C#3	a_403_136#	1.11526e-17
C170	B#3	VPWR#3	5.25116e-19
C171	C#1	a_406_384#	2.36696e-17
C172	B#4	a_403_136#	1.2229e-17
C173	VGND#3	B#3	3.86825e-19
C174	B#1	a_406_384#	2.42668e-17
C175	C	a_84_74##4	1.39513e-17
C176	A#3	C#2	9.49921e-19
C177	A#3	B#3	1.8396e-19
C178	B#5	a_223_120#	1.41674e-17
C179	A	a_84_74##10	3.26087e-17
C180	B#6	a_226_384#	2.54194e-17
C181	A#4	a_223_120#	1.41674e-17
C182	X	a_84_74##5	1.29389e-18
C183	VGND#6	A	1.75692e-18
C184	A#5	a_226_384#	2.54194e-17
C185	C	A#2	6.94769e-18
C186	a_84_74##2	B#3	2.70893e-19
C187	A	a_84_74##4	2.50861e-19
C188	VPWR	a_84_74##5	7.63733e-18
C189	X#3	X	3.38884e-18
C190	A	C#6	1.28799e-17
C191	B	A#4	6.77206e-18
C192	C	A#1	6.23005e-18
C193	A	A#2	8.76478e-19
C194	A	C#3	2.27591e-19
C195	VGND	a_84_74##7	1.66932e-17
C196	VGND	a_84_74##6	7.61357e-18
C197	X	VPWR#7	9.18529e-17
C198	X	X#1	7.06019e-18
C199	VPWR	a_84_74##4	2.12603e-17
C200	VGND	a_84_74##10	8.39929e-18
C201	VPWR	a_84_74##9	1.52957e-17
C202	VGND	VGND#6	4.5431e-18
C203	B	A#5	1.24754e-17
C204	VPWR	VPWR#7	1.85189e-17
C205	B	a_84_74#	8.74303e-19
C206	a_84_74##7	VNB	9.43172e-19
C207	VGND	X#3	1.71135e-17
C208	a_84_74##6	VNB	1.18067e-18
C209	a_84_74##5	VNB	1.0347e-18
C210	VGND	a_84_74##4	2.78751e-18
C211	C	A#3	5.72886e-19
C212	C	C#2	7.89355e-18
C213	a_84_74##10	VNB	2.39745e-17
C214	VGND#6	VNB	1.36806e-18
C215	X	A#5	2.26034e-18
C216	VPWR	C#4	9.34242e-18
C217	X	a_84_74#	4.19263e-17
C218	VPWR	A#1	6.21978e-18
C219	A	C#5	8.14187e-19
C220	VGND	C#3	2.10403e-18
C221	B	B#3	3.80146e-18
C222	VGND#7	VNB	2.85849e-18
C223	VPWR	C#1	4.10669e-18
C224	VGND	B#4	5.04966e-18
C225	X#3	VNB	4.81127e-17
C226	VPWR	B#1	9.34242e-18
C227	a_84_74##4	VNB	5.06575e-17
C228	VGND	B#5	4.909e-18
C229	a_84_74##2	B	2.16239e-17
C230	VGND	A#4	1.03676e-17
C231	VPWR	B#6	9.55159e-18
C232	VPWR#6	VNB	3.67264e-18
C233	VGND	a_84_74##3	8.03001e-18
C234	VPWR	A#5	4.45409e-18
C235	a_84_74##9	VNB	2.97089e-18
C236	VPWR	a_84_74#	3.29165e-18
C237	VPWR#7	VNB	2.24147e-18
C238	a_84_74##7	a_84_74##5	4.9321e-18
C239	C#6	VNB	3.15454e-17
C240	VPWR	VPWR#3	2.01589e-17
C241	A#2	VNB	2.28617e-17
C242	C#3	VNB	1.77592e-17
C243	B#4	VNB	1.59072e-17
C244	VPWR	C#5	2.41135e-18
C245	B#5	VNB	1.99005e-17
C246	X	a_84_74##2	3.64101e-17
C247	A#4	VNB	8.2989e-17
C248	a_84_74##3	VNB	3.73085e-17
C249	VPWR	C#2	9.56207e-19
C250	C#4	VNB	3.64537e-17
C251	VPWR	B#3	3.19577e-18
C252	A#1	VNB	3.65028e-17
C253	VGND	VGND#3	2.07482e-17
C254	C#1	VNB	2.83965e-17
C255	VPWR	a_84_74##2	3.4583e-18
C256	VGND	C#5	3.13906e-18
C257	B#1	VNB	2.96538e-17
C258	B#6	VNB	2.97853e-17
C259	VGND	A#3	3.55283e-17
C260	A#5	VNB	3.86295e-17
C261	VGND	C#2	1.29422e-18
C262	a_84_74#	VNB	4.31973e-17
C263	VGND	B#3	2.10783e-18
C264	VPWR#3	VNB	1.95099e-16
C265	VGND	a_84_74##2	5.58841e-18
C266	VGND#3	VNB	1.89341e-16
C267	C#5	VNB	5.42662e-17
C268	A#3	VNB	9.79387e-17
C269	a_84_74##6	a_84_74##5	3.36428e-18
C270	C#2	VNB	3.00214e-17
C271	B#3	VNB	2.73122e-17
C272	a_84_74##2	VNB	3.48788e-17
C273	X	B	3.9144e-18
C274	VPWR	C	2.09244e-18
C275	VPWR	B	4.58917e-18
C276	VGND	C	2.33984e-18
C277	VGND	B	2.13568e-18
C278	VPWR	X	1.92115e-17
C279	VGND	A	1.77835e-17
C280	C	VNB	3.31465e-18
C281	B	VNB	5.53306e-20
C282	VGND	X	8.69038e-19
C283	A	VNB	3.62291e-17
C284	X	VNB	6.86968e-17
C285	VPWR	VNB	6.39284e-17
C286	VGND	VNB	5.86403e-17
C287	VPWR#4	VNB	5.60698e-17
C288	X	VPWR#4	2.45258e-17
C289	VPWR#2	C#5	5.92635e-20
C290	a_84_74##2	VPWR#4	3.31295e-19
C291	VGND#3	VGND#2	7.1619e-17
C292	VGND#4	a_84_74##3	3.8228e-18
C293	VPWR#3	VPWR#4	6.0293e-17
C294	VPWR#4	A#5	7.65532e-18
C295	VGND#2	VNB	6.02665e-17
C296	VGND#4	VNB	5.49769e-17
C297	VPWR#2	C#4	9.95758e-18
C298	VGND#2	A#3	9.52315e-17
C299	VPWR#2	a_84_74#	2.76857e-19
C300	VGND#4	X#3	1.43505e-17
C301	VGND#4	a_84_74##7	2.15444e-18
C302	a_84_74##4	VPWR#2	1.98758e-17
C303	VGND#2	VGND#6	1.20793e-18
C304	B#3	VPWR#4	9.58791e-20
C305	VGND#4	a_84_74##2	5.90409e-19
C306	VPWR#7	VPWR#2	3.18382e-20
C307	VPWR#4	B#6	4.97011e-18
C308	a_84_74##5	VPWR#2	5.67596e-19
C309	VGND#4	A#4	2.3052e-17
C310	VGND#3	VGND#4	6.1282e-17
C311	VGND	VGND#2	5.39673e-17
C312	VPWR	VPWR#2	7.45589e-17
C313	VPWR#2	C#1	7.71153e-18
C314	VGND	VGND#4	6.84512e-17
C315	VPWR	VPWR#4	4.43325e-17
C316	VPWR#3	VPWR#2	6.92826e-17
C317	B	VPWR#4	1.28464e-18
C318	VGND#4	VGND#2	1.53135e-18
C319	VGND#4	A#3	2.24296e-19
C320	VGND#2	C#5	3.56135e-20
C321	VGND#2	a_84_74##6	5.45507e-19
C322	VGND#2	A	4.40596e-17
C323	VPWR#4	VPWR#2	3.54466e-19
C324	VGND#7	VGND#2	1.026e-18
C325	VPWR#4	a_84_74#	5.31158e-18
C326	VGND#2	C#6	9.5555e-19
C327	VGND#2	A#4	6.11464e-19
C328	VGND#2	C#2	2.09721e-19
C329	VPWR#2	A#1	4.22025e-18
C330	VGND#4	B#5	2.53675e-18
C331	VPWR#2	VNB	6.49836e-17
*
*
.ENDS sky130_fd_sc_hs__maj3_1
*
