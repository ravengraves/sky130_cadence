* Extracted by Quantus, converted by sky130cad/quantus.py
*
*
*
*                       LINUX           Wed Nov 18 08:37:21 2026
*
*
*
*  PROGRAM  advgen
*
*  Name           : advgen - Quantus - (64-bit)
*  Version        : 25.1.0-p047
*  Build Date     : Thu Dec 11 23:20:30 PST 2025
*
*  HSPICE LIBRARY
*
*  OPERATING_TEMPERATURE 150
*  QRC_TECH_DIR <path>/tech
*
*
*

*
.SUBCKT sky130_fd_sc_hs__einvn_8 VPB VNB VGND VPWR Z TE_B A
*
*
*  caps2d version: 10
*
*
*       TRANSISTOR CARDS
*
*
XM23 VGND#7 TE_B#18 a_126_74##18 VNB sky130_fd_pr__nfet_01v8_lvt l=0.15 w=0.74 ad=0.2109 as=0.2109 pd=2.05 ps=2.05
XM21 a_293_74##12 a_126_74##16 VGND#11 VNB sky130_fd_pr__nfet_01v8_lvt l=0.15 w=0.74 ad=0.2109 as=0.2072 pd=2.05 ps=2.04
XM18 VGND#11 a_126_74##15 a_293_74##16 VNB sky130_fd_pr__nfet_01v8_lvt l=0.15 w=0.74 ad=0.2072 as=0.2072 pd=2.04 ps=2.04
XM7 a_293_74##16 a_126_74##14 VGND#10 VNB sky130_fd_pr__nfet_01v8_lvt l=0.15 w=0.74 ad=0.2072 as=0.259 pd=2.04 ps=2.18
XM8 VGND#10 a_126_74##13 a_293_74##15 VNB sky130_fd_pr__nfet_01v8_lvt l=0.15 w=0.74 ad=0.259 as=0.2072 pd=2.18 ps=2.04
XM28 a_293_74##15 a_126_74##12 VGND#9 VNB sky130_fd_pr__nfet_01v8_lvt l=0.15 w=0.74 ad=0.2072 as=0.259 pd=2.04 ps=2.18
XM19 VGND#9 a_126_74##11 a_293_74##14 VNB sky130_fd_pr__nfet_01v8_lvt l=0.15 w=0.74 ad=0.259 as=0.2072 pd=2.18 ps=2.04
XM14 a_293_74##14 a_126_74##10 VGND#8 VNB sky130_fd_pr__nfet_01v8_lvt l=0.15 w=0.74 ad=0.2072 as=0.2072 pd=2.04 ps=2.04
XM13 VGND#8 a_126_74# a_293_74##7 VNB sky130_fd_pr__nfet_01v8_lvt l=0.15 w=0.74 ad=0.2072 as=0.2072 pd=2.04 ps=2.04
XM30 a_293_74##7 A#25 Z#9 VNB sky130_fd_pr__nfet_01v8_lvt l=0.15 w=0.74 ad=0.2072 as=0.2072 pd=2.04 ps=2.04
XM0 Z#9 A#22 a_293_74##5 VNB sky130_fd_pr__nfet_01v8_lvt l=0.15 w=0.74 ad=0.2072 as=0.2072 pd=2.04 ps=2.04
XM25 a_293_74##5 A#20 Z#11 VNB sky130_fd_pr__nfet_01v8_lvt l=0.15 w=0.74 ad=0.2072 as=0.2072 pd=2.04 ps=2.04
XM6 Z#11 A#16 a_293_74##3 VNB sky130_fd_pr__nfet_01v8_lvt l=0.15 w=0.74 ad=0.2072 as=0.259 pd=2.04 ps=2.18
XM31 a_293_74##3 A#13 Z#14 VNB sky130_fd_pr__nfet_01v8_lvt l=0.15 w=0.74 ad=0.259 as=0.2072 pd=2.18 ps=2.04
XM24 a_293_74##13 A#12 Z#14 VNB sky130_fd_pr__nfet_01v8_lvt l=0.15 w=0.74 ad=0.2072 as=0.2072 pd=2.04 ps=2.04
XM5 Z#15 A#10 a_293_74##13 VNB sky130_fd_pr__nfet_01v8_lvt l=0.15 w=0.74 ad=0.3108 as=0.2072 pd=2.32 ps=2.04
XM22 Z#15 A#1 a_293_74# VNB sky130_fd_pr__nfet_01v8_lvt l=0.15 w=0.74 ad=0.3108 as=0.2109 pd=2.32 ps=2.05
XM20 VPWR#7 TE_B#19 a_126_74##20 VPB sky130_fd_pr__pfet_01v8 l=0.15 w=1.12 ad=0.3864 as=0.3304 pd=2.93 ps=2.83
XM9 a_239_368##10 TE_B#17 VPWR#11 VPB sky130_fd_pr__pfet_01v8 l=0.15 w=1.12 ad=0.3304 as=0.392 pd=2.83 ps=2.94
XM27 a_239_368##16 TE_B#16 VPWR#11 VPB sky130_fd_pr__pfet_01v8 l=0.15 w=1.12 ad=0.336 as=0.392 pd=2.84 ps=2.94
XM15 VPWR#10 TE_B#15 a_239_368##16 VPB sky130_fd_pr__pfet_01v8 l=0.15 w=1.12 ad=0.392 as=0.336 pd=2.94 ps=2.84
XM26 VPWR#10 TE_B#14 a_239_368##15 VPB sky130_fd_pr__pfet_01v8 l=0.15 w=1.12 ad=0.392 as=0.336 pd=2.94 ps=2.84
XM16 a_239_368##15 TE_B#13 VPWR#9 VPB sky130_fd_pr__pfet_01v8 l=0.15 w=1.12 ad=0.336 as=0.392 pd=2.84 ps=2.94
XM32 VPWR#9 TE_B#12 a_239_368##14 VPB sky130_fd_pr__pfet_01v8 l=0.15 w=1.12 ad=0.392 as=0.336 pd=2.94 ps=2.84
XM1 VPWR#8 TE_B#11 a_239_368##14 VPB sky130_fd_pr__pfet_01v8 l=0.15 w=1.12 ad=0.448 as=0.336 pd=3.04 ps=2.84
XM3 a_239_368##5 TE_B#1 VPWR#8 VPB sky130_fd_pr__pfet_01v8 l=0.15 w=1.12 ad=0.336 as=0.448 pd=2.84 ps=3.04
XM2 a_239_368##5 A#27 Z#8 VPB sky130_fd_pr__pfet_01v8 l=0.15 w=1.12 ad=0.336 as=0.336 pd=2.84 ps=2.84
XM33 a_239_368##13 A#26 Z#8 VPB sky130_fd_pr__pfet_01v8 l=0.15 w=1.12 ad=0.336 as=0.336 pd=2.84 ps=2.84
XM4 a_239_368##13 A#23 Z#7 VPB sky130_fd_pr__pfet_01v8 l=0.15 w=1.12 ad=0.336 as=0.392 pd=2.84 ps=2.94
XM17 Z#7 A#18 a_239_368##12 VPB sky130_fd_pr__pfet_01v8 l=0.15 w=1.12 ad=0.392 as=0.336 pd=2.94 ps=2.84
XM12 Z#6 A#17 a_239_368##12 VPB sky130_fd_pr__pfet_01v8 l=0.15 w=1.12 ad=0.336 as=0.336 pd=2.84 ps=2.84
XM29 a_239_368##11 A#11 Z#6 VPB sky130_fd_pr__pfet_01v8 l=0.15 w=1.12 ad=0.336 as=0.336 pd=2.84 ps=2.84
XM11 Z#1 A#9 a_239_368##11 VPB sky130_fd_pr__pfet_01v8 l=0.15 w=1.12 ad=0.336 as=0.336 pd=2.84 ps=2.84
XM10 Z#1 A#8 a_239_368# VPB sky130_fd_pr__pfet_01v8 l=0.15 w=1.12 ad=0.336 as=0.3304 pd=2.84 ps=2.83
*
*
*       RESISTOR AND CAP/DIODE CARDS
*
Rg1	a_126_74#	a_126_74##2	473.208221
Rg2	a_126_74##2	a_126_74##3	210.494781
Rg3	a_126_74##3	a_126_74##4	250.665115
Rg4	a_126_74##4	a_126_74##5	210.494781
Rg5	a_126_74##5	a_126_74##6	250.665115
Rg6	a_126_74##6	a_126_74##7	210.494781
Rg7	a_126_74##7	a_126_74##8	210.494781
Rg8	a_126_74##8	a_126_74##9	355.091553
Rg9	a_126_74##2	a_126_74##10	262.702026
Rg10	a_126_74##3	a_126_74##11	262.702026
Rg11	a_126_74##4	a_126_74##12	262.702026
Rg12	a_126_74##5	a_126_74##13	262.702026
Rg13	a_126_74##6	a_126_74##14	262.702026
Rg14	a_126_74##7	a_126_74##15	262.702026
Rg15	a_126_74##8	a_126_74##16	262.702026
Rg16	TE_B#1	TE_B#2	656.453186
Rg17	TE_B#2	TE_B#3	214.351181
Rg18	TE_B#3	TE_B#4	243.044296
Rg19	TE_B#4	TE_B#5	214.351181
Rg20	TE_B#5	TE_B#6	243.044296
Rg21	TE_B#6	TE_B#7	214.351181
Rg22	TE_B#7	TE_B#8	243.044296
Rg23	TE_B#8	TE_B#9	553.475403
Rg24	TE_B#9	TE_B#10	41.528614
Rg25	TE_B#2	TE_B#11	385.612793
Rg26	TE_B#3	TE_B#12	385.612793
Rg27	TE_B#4	TE_B#13	385.612793
Rg28	TE_B#5	TE_B#14	385.612793
Rg29	TE_B#6	TE_B#15	385.612793
Rg30	TE_B#7	TE_B#16	385.612793
Rg31	TE_B#8	TE_B#17	385.612793
Rg32	TE_B#9	TE_B#18	379.052216
Rg33	TE_B#9	TE_B#19	439.857941
Rg34	A#1	A#2	397.555725
Rg35	A#2	A#3	67.132561
Rg36	A#3	A#4	21.384537
Rg37	A#4	A#5	49.993565
Rg38	A#5	A#6	26.059803
Rg39	A#6	A#7	45.324081
Rg40	A#2	A#8	449.655212
Rg41	A#3	A#9	419.554810
Rg42	A#4	A#10	391.786469
Rg43	A#5	A#11	413.801331
Rg44	A#6	A#12	415.715271
Rg45	A#7	A#13	423.579987
Rg46	A#7	A#14	91.651230
Rg47	A#14	A#15	25.693840
Rg48	A#15	A#16	384.761932
Rg49	A#7	A#17	429.126801
Rg50	A#14	A#18	395.236115
Rg51	A#15	A#19	66.943687
Rg52	A#19	A#20	438.137817
Rg53	A#19	A#21	75.978477
Rg54	A#21	A#22	424.485199
Rg55	A#19	A#23	452.484344
Rg56	A#21	A#24	62.871655
Rg57	A#24	A#25	397.555725
Rg58	A#21	A#26	438.831757
Rg59	A#24	A#27	449.655212
Rf1	TE_B#10	TE_B	166.925232
Rf2	a_126_74##9	a_126_74##19	59.036663
Rf3	a_126_74##19	a_126_74##20	71.556335
Rf4	a_126_74##18	a_126_74##19	7.500000
Rf5	Z#1	Z#2	77.655472
Rf6	Z#2	Z#3	65.696381
Rf7	Z#3	Z#4	64.246559
Rf8	Z#4	Z#5	26.522648
Rf9	Z#5	Z	24.203583
Rf10	Z#2	Z#6	15.590988
Rf11	Z#3	Z#7	15.590988
Rf12	Z#4	Z#8	25.312788
Rf13	Z#5	Z#10	35.237938
Rf14	Z#10	Z#12	30.641333
Rf15	Z#12	Z#13	61.260300
Rf16	Z#13	Z#14	32.884026
Rf17	Z#13	Z#15	88.894249
Rf18	Z#9	Z#10	15.000000
Rf19	Z#11	Z#12	15.000000
Rf20	A	A#7	20.708275
Rf21	a_239_368#	a_239_368##2	94.986412
Rf22	a_239_368##2	a_239_368##3	65.941528
Rf23	a_239_368##3	a_239_368##4	69.471481
Rf24	a_239_368##4	a_239_368##6	79.847282
Rf25	a_239_368##6	a_239_368##7	65.892159
Rf26	a_239_368##7	a_239_368##8	75.784508
Rf27	a_239_368##8	a_239_368##9	69.463600
Rf28	a_239_368##9	a_239_368##10	105.664001
Rf29	a_239_368##2	a_239_368##11	28.306047
Rf30	a_239_368##3	a_239_368##12	28.306047
Rf31	a_239_368##4	a_239_368##13	18.149860
Rf32	a_239_368##7	a_239_368##14	22.350895
Rf33	a_239_368##8	a_239_368##15	37.259827
Rf34	a_239_368##9	a_239_368##16	37.259827
Rf35	a_239_368##5	a_239_368##6	5.000000
Rf36	a_293_74#	a_293_74##2	89.290916
Rf37	a_293_74##2	a_293_74##4	54.585381
Rf38	a_293_74##4	a_293_74##6	32.707878
Rf39	a_293_74##6	a_293_74##8	48.014969
Rf40	a_293_74##8	a_293_74##9	101.667900
Rf41	a_293_74##9	a_293_74##10	68.112778
Rf42	a_293_74##10	a_293_74##11	68.002594
Rf43	a_293_74##11	a_293_74##12	109.788223
Rf44	a_293_74##2	a_293_74##13	24.272007
Rf45	a_293_74##9	a_293_74##14	31.628586
Rf46	a_293_74##10	a_293_74##15	36.178436
Rf47	a_293_74##11	a_293_74##16	36.178436
Rf48	a_293_74##3	a_293_74##4	15.000000
Rf49	a_293_74##5	a_293_74##6	15.000000
Rf50	a_293_74##7	a_293_74##8	7.500000
Rf51	VGND#1	VGND#2	230.815033
Rf52	VGND#2	VGND#3	67.887894
Rf53	VGND#3	VGND#4	34.309200
Rf54	VGND#4	VGND#5	33.578697
Rf55	VGND#5	VGND#6	65.753731
Rf56	VGND#6	VGND#7	151.692474
Rf57	VGND#2	VGND#8	31.534731
Rf58	VGND#3	VGND#9	33.306259
Rf59	VGND#5	VGND#10	33.306259
Rf60	VGND#6	VGND#11	41.038895
Rf61	VPWR#1	VPWR#2	235.928574
Rf62	VPWR#2	VPWR#3	73.001427
Rf63	VPWR#3	VPWR#4	24.082130
Rf64	VPWR#4	VPWR#5	45.266777
Rf65	VPWR#5	VPWR#6	69.348907
Rf66	VPWR#6	VPWR#7	146.467987
Rf67	VPWR#2	VPWR#8	31.534731
Rf68	VPWR#3	VPWR#9	36.219261
Rf69	VPWR#5	VPWR#10	36.219261
Rf70	VPWR#6	VPWR#11	36.219261
Re1	VPWR#1	VPWR	3.246228
Re2	VPWR	VPWR#4	1.159367
Re3	VGND#1	VGND	3.246228
Re4	VGND	VGND#4	1.159367
*
*       CAPACITOR CARDS
*
*
C1	Z#3	a_239_368##4	2.02304e-17
C2	VPWR#9	VPWR#8	1.69573e-18
C3	a_293_74##7	A#25	4.9381e-17
C4	A#6	A#9	2.31942e-19
C5	a_293_74##12	TE_B#7	7.97636e-19
C6	Z#9	a_126_74#	2.30174e-18
C7	a_239_368##10	a_239_368##9	6.56179e-19
C8	A#6	a_239_368##11	1.57752e-19
C9	a_126_74##18	TE_B#8	5.82137e-18
C10	VGND#8	A#25	2.06297e-18
C11	VPWR#9	a_239_368##14	6.72357e-17
C12	A#4	Z#1	2.01805e-18
C13	a_293_74##7	a_126_74#	1.97118e-17
C14	a_293_74##14	A#25	1.68548e-19
C15	a_239_368##8	a_126_74##5	3.7631e-18
C16	VGND#6	VGND#5	1.08661e-18
C17	a_239_368#	A#2	8.18384e-20
C18	A#15	a_239_368##12	5.32412e-19
C19	a_293_74##12	a_239_368##9	1.38683e-17
C20	VGND#8	a_126_74#	4.34916e-17
C21	a_239_368##4	VPWR#1	5.11744e-17
C22	a_239_368##4	A#24	9.44289e-20
C23	A#6	Z#6	1.6812e-19
C24	a_239_368##3	VPWR#1	8.67927e-17
C25	a_293_74##3	Z#14	2.85466e-17
C26	A#15	A#17	2.31942e-19
C27	a_293_74##7	a_126_74##10	3.97516e-19
C28	a_293_74##9	a_126_74##2	9.92745e-18
C29	a_239_368##15	VPWR#9	7.36761e-17
C30	A#19	Z#7	5.48219e-20
C31	A#4	A#2	3.00393e-18
C32	a_293_74##14	a_126_74#	3.82529e-19
C33	Z#3	a_239_368##3	1.43054e-17
C34	a_239_368##2	VPWR#1	9.04496e-17
C35	A#4	a_239_368##11	9.61013e-19
C36	VGND#8	a_126_74##10	3.88289e-17
C37	A#2	Z#1	1.39623e-18
C38	A#21	a_239_368##13	4.73255e-19
C39	VPWR#10	VPWR#9	2.03612e-18
C40	A#17	A#6	2.31942e-19
C41	A#15	Z#7	6.72482e-19
C42	a_293_74##7	a_126_74##11	1.6961e-19
C43	Z#11	Z#14	3.11588e-18
C44	a_293_74##14	a_126_74##10	1.20941e-17
C45	VGND#1	a_293_74##2	9.30676e-17
C46	A#24	Z#8	2.6664e-19
C47	VGND#8	a_126_74##2	1.8771e-18
C48	A#19	a_239_368##13	6.70106e-19
C49	a_126_74##3	a_293_74##14	4.96868e-19
C50	VPWR#10	a_239_368##15	8.50789e-17
C51	VGND#8	a_126_74##11	2.22015e-18
C52	VGND#9	a_126_74##4	2.34713e-18
C53	VGND#9	a_126_74##10	7.30871e-19
C54	a_239_368##8	a_126_74##4	3.12229e-18
C55	VPWR#1	Z#3	3.82834e-18
C56	a_293_74##15	a_126_74##5	9.22256e-19
C57	VPWR#1	Z#2	1.05002e-17
C58	VGND#10	a_126_74##6	2.34713e-18
C59	A#21	Z#8	2.14928e-19
C60	a_293_74##14	a_126_74##11	3.5365e-17
C61	a_293_74##3	Z#11	4.18414e-17
C62	a_239_368##4	A#21	7.61154e-20
C63	a_293_74##16	a_126_74##7	9.10769e-19
C64	a_239_368##16	a_239_368##15	1.66923e-18
C65	a_126_74##2	a_293_74##14	4.90657e-19
C66	VGND#11	a_126_74##8	1.59647e-18
C67	VGND#8	a_126_74##12	3.18276e-19
C68	VGND#9	a_126_74##3	2.27496e-18
C69	Z#2	a_239_368##3	1.5695e-17
C70	VGND#9	a_126_74##11	1.71068e-17
C71	VPWR#6	TE_B#8	3.34812e-19
C72	a_126_74##4	a_293_74##15	4.90657e-19
C73	a_239_368##7	a_126_74##4	6.97708e-19
C74	VGND#10	a_126_74##5	2.27496e-18
C75	a_239_368##16	VPWR#10	7.36761e-17
C76	VGND#1	Z#13	2.72991e-18
C77	a_293_74##14	a_126_74##12	1.08835e-18
C78	a_293_74##15	a_126_74##11	6.54348e-20
C79	a_126_74##6	a_293_74##16	4.90657e-19
C80	VGND#11	a_126_74##7	1.57651e-18
C81	VGND#9	a_126_74##12	4.12401e-17
C82	a_293_74##12	a_126_74##8	1.79174e-17
C83	VPWR#11	VPWR#10	2.03612e-18
C84	a_239_368##8	VPWR#4	3.01413e-19
C85	a_293_74##15	a_126_74##12	1.18687e-17
C86	Z#11	a_293_74##5	3.97505e-17
C87	VPWR#11	a_239_368##16	8.50789e-17
C88	VGND#5	VGND#3	1.13178e-18
C89	VGND#9	a_126_74##13	2.37027e-18
C90	VGND#10	a_126_74##12	7.30871e-19
C91	a_239_368##4	A#19	1.71689e-20
C92	A#27	A#21	2.3257e-19
C93	Z#2	a_239_368##2	1.56081e-17
C94	a_293_74##15	a_126_74##13	3.57912e-17
C95	a_239_368##10	a_239_368##16	1.66923e-18
C96	a_293_74##7	a_293_74##3	9.13773e-19
C97	a_293_74##2	A#1	1.03708e-18
C98	VPWR#6	TE_B#7	1.22089e-20
C99	a_293_74##2	A#6	5.95311e-19
C100	a_239_368##7	a_126_74##3	3.67149e-18
C101	VGND#9	a_126_74##14	3.18276e-19
C102	VGND#10	a_126_74##13	1.71068e-17
C103	TE_B#1	A#24	1.21898e-17
C104	a_239_368##10	VPWR#11	7.94262e-17
C105	a_293_74##15	a_126_74##14	1.17793e-18
C106	a_293_74##16	a_126_74##13	6.94006e-20
C107	a_293_74##5	Z#9	3.66671e-17
C108	VGND#10	a_126_74##14	4.14421e-17
C109	VPWR#5	TE_B#7	5.86029e-21
C110	a_293_74##15	a_126_74##15	3.40958e-20
C111	a_293_74##2	a_293_74#	9.61411e-19
C112	a_239_368##9	a_239_368##8	6.56179e-19
C113	a_293_74##16	a_126_74##14	1.18892e-17
C114	a_239_368##4	A#15	1.29157e-19
C115	VGND#6	a_293_74##11	1.89457e-19
C116	a_126_74##20	a_239_368##10	9.40026e-17
C117	VPWR#7	VPWR#11	6.28087e-19
C118	a_239_368##2	A#9	1.58468e-17
C119	VGND#10	a_126_74##15	2.36973e-18
C120	VGND#11	a_126_74##14	6.16164e-19
C121	VGND#6	TE_B#8	3.9897e-19
C122	a_239_368##7	a_126_74##2	3.12664e-18
C123	a_293_74##2	A#10	2.94456e-17
C124	a_293_74##16	a_126_74##15	3.59786e-17
C125	a_293_74##7	Z#9	6.22417e-17
C126	VGND#10	a_126_74##16	3.18252e-19
C127	VGND#11	a_126_74##15	1.34453e-17
C128	a_239_368##3	A#15	6.14537e-20
C129	VPWR#7	a_126_74##20	1.14995e-16
C130	a_293_74##2	A#7	2.00983e-19
C131	VPWR#6	a_126_74##9	1.16413e-18
C132	a_293_74##16	a_126_74##16	1.44224e-18
C133	a_293_74##12	a_126_74##15	6.5891e-20
C134	VPWR#5	TE_B#6	1.95187e-20
C135	VGND#11	a_126_74##16	3.42118e-17
C136	a_293_74##2	Z#15	4.88914e-17
C137	VGND#6	a_126_74##9	5.19673e-18
C138	Z#5	A#24	2.14729e-17
C139	a_239_368##5	a_126_74#	3.9436e-19
C140	VGND#3	VGND#2	1.13428e-18
C141	a_239_368##3	A#7	8.58444e-20
C142	VGND#5	a_293_74##11	1.89457e-19
C143	a_293_74##12	a_126_74##16	1.20474e-17
C144	a_239_368##2	A#11	1.57323e-17
C145	a_239_368##2	A#7	3.0904e-20
C146	Z#13	A#7	7.72722e-17
C147	VGND#11	TE_B#18	3.18908e-19
C148	VGND#8	a_293_74##7	6.75887e-17
C149	a_126_74##18	a_126_74##16	2.77495e-18
C150	a_293_74##2	A#12	2.52667e-17
C151	a_293_74##2	A#4	5.00268e-19
C152	Z#5	A#7	3.0667e-17
C153	VGND#7	a_126_74##16	5.26212e-19
C154	Z#2	A#9	1.37698e-18
C155	A#7	Z#4	8.8039e-18
C156	A#7	Z#3	8.07746e-17
C157	A#10	A#1	2.19169e-17
C158	Z#13	A#1	8.03297e-21
C159	a_126_74##18	TE_B#18	2.3926e-17
C160	a_293_74##14	a_293_74##7	2.00505e-18
C161	A#7	Z#2	8.03289e-17
C162	VPWR#6	TE_B#10	1.36808e-19
C163	VGND#7	TE_B#18	3.79292e-17
C164	Z#5	A#21	9.71384e-18
C165	a_239_368##3	A#17	1.58461e-17
C166	Z#5	A#11	1.15673e-19
C167	a_239_368##8	a_239_368##7	7.00646e-19
C168	a_293_74##2	a_293_74##13	1.07613e-18
C169	a_293_74##14	VGND#8	5.82226e-17
C170	VGND#5	a_293_74##10	1.59316e-19
C171	Z#4	A#11	2.87367e-20
C172	A#12	A#10	3.94004e-17
C173	Z#13	A#15	6.81647e-19
C174	a_293_74##2	A#13	1.1301e-18
C175	VPWR#2	A#26	2.21465e-18
C176	Z#2	A#11	3.35394e-17
C177	VGND#9	VGND#8	1.89091e-18
C178	Z#4	A#21	6.93488e-19
C179	a_293_74#	a_239_368#	3.05711e-19
C180	Z#13	A#10	1.37612e-20
C181	A#13	A#12	4.02677e-17
C182	a_239_368#	A#8	4.4208e-17
C183	a_126_74##2	TE_B#1	2.64116e-18
C184	VGND#9	a_293_74##14	6.70137e-17
C185	Z#5	A#19	4.81767e-19
C186	Z#1	A#8	4.63511e-17
C187	Z#5	A#17	1.67097e-19
C188	a_239_368##3	A#18	1.61437e-17
C189	a_293_74##2	Z#14	2.84733e-17
C190	a_239_368##2	A#6	4.31748e-20
C191	a_239_368##2	Z#1	1.6243e-17
C192	Z#4	A#17	4.40349e-20
C193	a_239_368#	A#9	1.30694e-18
C194	a_239_368##11	A#8	1.29161e-18
C195	VGND#2	a_293_74##5	2.17853e-17
C196	A#16	A#13	2.59428e-17
C197	VGND#3	a_293_74##10	1.76539e-19
C198	Z#3	A#17	1.37698e-18
C199	Z#1	A#9	5.2791e-17
C200	a_293_74##11	TE_B#7	6.10914e-18
C201	Z#2	A#17	2.92306e-17
C202	a_239_368##9	VPWR#6	1.11392e-19
C203	A#9	a_239_368##11	2.39036e-17
C204	VPWR#2	A#27	4.46413e-18
C205	a_239_368#	A#11	3.00902e-19
C206	Z#13	A#12	1.66707e-17
C207	Z#1	A#11	1.37698e-18
C208	A#20	A#16	3.95557e-17
C209	a_293_74##15	VGND#9	6.53762e-17
C210	VGND#2	A#22	3.17789e-18
C211	a_239_368##4	A#23	2.08876e-17
C212	A#11	a_239_368##11	2.73382e-17
C213	a_239_368##12	A#9	2.68812e-19
C214	a_126_74##8	TE_B#8	1.94188e-17
C215	Z#5	A#18	2.97995e-19
C216	A#11	Z#6	2.32435e-17
C217	Z#3	A#19	1.26261e-18
C218	a_293_74##3	a_293_74##2	4.60085e-18
C219	Z#4	A#18	7.85304e-20
C220	VPWR#8	TE_B#2	7.95465e-19
C221	a_293_74##7	TE_B#1	1.84882e-18
C222	a_239_368##2	a_239_368##11	5.47123e-20
C223	VGND#10	VGND#9	1.89091e-18
C224	a_239_368##12	A#11	6.2318e-19
C225	A#22	A#20	4.00788e-17
C226	a_239_368##11	A#17	6.2318e-19
C227	Z#13	A#6	1.43139e-18
C228	Z#3	A#18	3.58635e-17
C229	VGND#3	a_293_74##9	1.46399e-19
C230	TE_B#3	a_239_368##14	3.50072e-19
C231	a_239_368##5	VPWR#2	3.50357e-17
C232	A#17	Z#6	2.32435e-17
C233	a_126_74##8	TE_B#7	1.20238e-17
C234	Z#2	A#18	1.37698e-18
C235	a_293_74##11	TE_B#6	7.86311e-18
C236	TE_B#4	VPWR#9	1.91448e-18
C237	a_239_368##9	VPWR#5	2.09678e-19
C238	VGND#10	a_293_74##15	6.8791e-17
C239	a_239_368##7	A#26	7.10307e-20
C240	A#17	a_239_368##12	2.39036e-17
C241	a_239_368##11	A#18	2.68812e-19
C242	VPWR#2	TE_B#1	2.32645e-18
C243	TE_B#2	a_239_368##14	3.45404e-19
C244	Z#13	A#13	1.72456e-17
C245	VPWR#3	TE_B#3	1.83134e-20
C246	A#25	A#22	3.998e-17
C247	TE_B#5	a_239_368##15	3.50072e-19
C248	a_239_368##3	Z#6	3.20146e-19
C249	TE_B#3	VPWR#9	1.81779e-18
C250	a_239_368##4	A#26	2.10188e-17
C251	VGND#2	A#25	4.43427e-18
C252	a_239_368##13	A#17	3.28804e-19
C253	A#18	a_239_368##12	2.73349e-17
C254	TE_B#6	VPWR#10	1.86739e-18
C255	Z#5	A#23	4.69079e-19
C256	a_293_74##16	a_293_74##15	1.04461e-18
C257	a_126_74##7	TE_B#7	1.35883e-17
C258	TE_B#4	a_239_368##15	3.45404e-19
C259	Z#13	Z#15	8.16134e-20
C260	A#18	Z#7	2.54251e-17
C261	Z#3	A#15	3.51373e-18
C262	Z#4	A#23	1.23616e-19
C263	TE_B#7	a_239_368##16	3.50121e-19
C264	a_239_368##2	A#4	8.58444e-20
C265	a_239_368##2	Z#6	3.15831e-19
C266	a_126_74#	A#25	4.02926e-17
C267	TE_B#5	VPWR#10	1.8244e-18
C268	a_239_368##13	A#18	1.53707e-18
C269	a_239_368##12	A#23	6.06271e-19
C270	Z#3	A#23	2.53876e-17
C271	VPWR#1	A#21	9.08465e-21
C272	a_293_74##16	VGND#10	6.53762e-17
C273	VGND#2	a_293_74##7	3.72166e-17
C274	a_293_74##11	a_293_74##10	1.29003e-18
C275	VGND#2	a_293_74##9	2.15613e-19
C276	TE_B#8	VPWR#11	1.84283e-18
C277	Z#8	A#18	2.14592e-19
C278	a_293_74##9	Z#5	2.61645e-18
C279	A#23	Z#7	1.16921e-17
C280	VPWR#1	A#19	1.54842e-20
C281	TE_B#6	a_239_368##16	3.45404e-19
C282	Z#15	A#6	2.51133e-19
C283	a_126_74##7	TE_B#6	9.75527e-18
C284	VPWR#1	A#15	3.73886e-20
C285	a_293_74##11	TE_B#5	1.50185e-18
C286	a_239_368##13	A#23	4.45474e-17
C287	a_239_368##7	A#27	1.16215e-19
C288	a_293_74##9	A#25	2.11897e-20
C289	a_293_74##9	TE_B#1	2.7918e-18
C290	a_126_74##10	a_126_74#	3.68725e-17
C291	a_239_368##8	VPWR#5	1.11392e-19
C292	Z#13	A#16	1.29179e-20
C293	TE_B#7	VPWR#11	1.89873e-18
C294	VPWR#1	A#6	9.72175e-21
C295	VPWR#2	TE_B#11	5.71269e-18
C296	VPWR#8	A#18	3.89904e-20
C297	Z#8	A#23	4.96861e-19
C298	VGND#11	VGND#10	2.49656e-18
C299	a_293_74##3	A#19	1.25814e-20
C300	a_293_74#	A#4	1.10099e-19
C301	a_239_368##3	a_239_368##12	5.47123e-20
C302	Z#3	Z#2	3.01982e-18
C303	VPWR#1	A#4	3.01268e-20
C304	a_239_368##13	A#26	3.948e-17
C305	a_239_368##10	TE_B#8	2.04303e-17
C306	VGND#1	A#21	2.144e-20
C307	Z#5	A#26	1.31481e-18
C308	Z#11	A#21	8.35253e-19
C309	VGND#2	a_126_74#	2.38182e-18
C310	a_126_74##6	TE_B#6	1.59213e-17
C311	VGND#1	A#19	2.71573e-20
C312	Z#2	Z#1	3.01982e-18
C313	a_239_368##9	TE_B#8	2.5136e-18
C314	VPWR#8	A#23	7.09397e-20
C315	Z#13	a_293_74##13	6.87995e-20
C316	A#26	Z#8	1.87995e-17
C317	a_293_74##10	TE_B#5	4.56085e-18
C318	VPWR#1	A#2	1.1053e-20
C319	Z#4	A#26	1.8629e-17
C320	VGND#1	A#15	5.74796e-20
C321	a_126_74##11	a_126_74##10	3.68345e-17
C322	a_293_74##5	A#24	1.69848e-19
C323	VGND#11	a_293_74##16	6.42923e-17
C324	a_239_368##5	A#26	2.27167e-18
C325	a_293_74##2	Z#13	1.60622e-17
C326	a_239_368##13	A#27	1.72215e-18
C327	Z#3	A#26	6.12748e-19
C328	a_239_368##14	VPWR#3	8.51897e-18
C329	a_293_74##3	A#15	1.21586e-18
C330	VGND#1	A#6	2.55238e-20
C331	VPWR#2	TE_B#2	1.80692e-20
C332	VPWR#8	A#26	2.11221e-19
C333	Z#15	A#4	4.01915e-18
C334	Z#11	A#19	2.19775e-18
C335	A#27	Z#8	2.30919e-17
C336	VGND#1	A#4	4.6674e-20
C337	a_126_74##6	TE_B#5	9.02439e-18
C338	a_239_368##4	Z#7	7.97341e-19
C339	a_293_74##12	a_293_74##16	1.1214e-18
C340	a_293_74##5	A#21	4.891e-19
C341	a_239_368##5	A#27	7.07991e-17
C342	a_126_74##12	a_126_74##11	2.6166e-17
C343	a_239_368##14	VPWR#2	8.4521e-18
C344	a_293_74##9	a_293_74##7	2.45062e-19
C345	a_239_368##7	TE_B#1	1.89945e-18
C346	VGND#1	A#2	2.01472e-20
C347	a_293_74##9	a_239_368##5	1.97e-18
C348	a_293_74##9	a_126_74#	2.58406e-18
C349	Z#9	A#24	1.40907e-18
C350	VPWR#8	A#27	5.18866e-19
C351	VPWR#3	TE_B#12	2.61225e-18
C352	a_293_74#	A#2	2.33206e-19
C353	Z#11	A#15	3.43027e-18
C354	a_239_368##3	Z#7	2.04313e-19
C355	a_239_368##5	TE_B#1	6.69191e-17
C356	a_293_74##12	VGND#11	6.80848e-17
C357	Z#5	Z#6	1.08484e-21
C358	Z#5	A#27	5.6362e-18
C359	a_293_74##5	A#19	4.05749e-19
C360	a_126_74##13	a_126_74##12	3.68786e-17
C361	a_126_74##5	TE_B#5	1.64387e-17
C362	Z#2	a_239_368##11	4.53296e-17
C363	TE_B#1	VPWR#8	2.90093e-17
C364	VGND#2	a_126_74##10	1.25816e-18
C365	Z#13	Z#14	6.55534e-19
C366	a_239_368##9	TE_B#7	8.89261e-18
C367	Z#4	A#27	3.50173e-18
C368	Z#9	A#21	2.32477e-18
C369	VGND#3	a_293_74##14	6.76291e-18
C370	a_293_74##10	TE_B#4	7.68075e-18
C371	a_239_368##14	TE_B#1	4.11471e-19
C372	a_239_368##2	A#2	1.71689e-21
C373	a_239_368##5	TE_B#11	8.81592e-19
C374	Z#3	A#27	2.63043e-19
C375	a_293_74##7	A#24	1.04478e-17
C376	Z#4	Z#6	6.94296e-22
C377	Z#15	A#2	1.86536e-18
C378	a_126_74##18	VGND#11	1.60219e-18
C379	VPWR#9	TE_B#1	2.8528e-19
C380	TE_B#11	VPWR#8	3.62796e-17
C381	a_126_74##14	a_126_74##13	2.61599e-17
C382	a_126_74##5	TE_B#4	8.6653e-18
C383	a_239_368##14	TE_B#11	5.30747e-17
C384	a_293_74##10	a_293_74##9	1.38661e-18
C385	VGND#2	a_293_74##14	6.93955e-18
C386	a_239_368##4	a_239_368##13	4.35239e-20
C387	Z#9	A#19	4.6531e-19
C388	A#7	A#24	7.6648e-20
C389	VPWR#4	TE_B#5	1.83134e-20
C390	Z#2	A#6	8.90966e-19
C391	VPWR#9	TE_B#11	7.67963e-19
C392	A#7	A#21	1.08106e-17
C393	VPWR#8	TE_B#12	7.67963e-19
C394	a_239_368##7	TE_B#11	2.15202e-17
C395	a_126_74##18	a_293_74##12	9.02559e-17
C396	VGND#7	VGND#11	7.65877e-19
C397	VPWR#4	TE_B#4	1.80692e-20
C398	VGND#8	a_293_74##9	3.08609e-17
C399	A#7	A#19	1.82795e-17
C400	a_293_74##9	a_126_74##10	2.26304e-19
C401	a_239_368##14	TE_B#12	4.51969e-17
C402	a_239_368##7	VPWR#3	1.11392e-19
C403	A#7	A#15	2.7778e-17
C404	a_126_74##15	a_126_74##14	3.68823e-17
C405	VPWR#2	A#24	1.24914e-20
C406	VGND#6	a_126_74##8	4.36757e-19
C407	VGND#3	a_126_74##11	2.7424e-18
C408	Z#5	TE_B#1	2.28911e-19
C409	a_239_368##10	a_126_74##8	1.78358e-18
C410	TE_B#12	VPWR#9	2.44408e-17
C411	A#7	A#6	2.12007e-17
C412	Z#9	A#15	2.52849e-19
C413	a_126_74##4	TE_B#4	1.71119e-17
C414	VPWR#8	TE_B#13	2.81672e-19
C415	Z#2	Z#6	6.16604e-19
C416	VGND#1	a_293_74#	7.97326e-17
C417	a_239_368##15	TE_B#12	2.82196e-19
C418	Z#4	TE_B#1	1.23063e-19
C419	Z#13	a_293_74##3	1.35681e-17
C420	A#7	A#4	2.03508e-17
C421	a_239_368##14	TE_B#13	1.10522e-18
C422	VPWR#6	VPWR#5	1.07669e-18
C423	a_239_368##9	TE_B#6	7.44102e-18
C424	VGND#1	Z#15	9.66137e-18
C425	a_239_368##15	VPWR#5	1.52587e-18
C426	a_126_74##16	a_126_74##15	3.61879e-17
C427	a_293_74##10	TE_B#3	1.28064e-18
C428	VPWR#9	TE_B#13	5.67925e-17
C429	A#7	A#2	2.45569e-17
C430	a_239_368##7	a_126_74#	2.49997e-19
C431	VGND#1	Z#14	5.84456e-18
C432	TE_B#13	a_239_368##15	1.60405e-17
C433	VGND#1	a_293_74##3	9.03034e-17
C434	VGND#7	a_126_74##18	8.57244e-17
C435	a_126_74##4	TE_B#3	7.94814e-18
C436	VPWR#10	TE_B#13	7.45976e-19
C437	VGND#1	Z#11	1.24308e-18
C438	VPWR#9	TE_B#14	2.6158e-18
C439	a_239_368##4	Z#8	1.94732e-17
C440	a_239_368##8	TE_B#12	1.10932e-19
C441	VGND#1	a_293_74##5	4.0799e-17
C442	Z#3	a_239_368##12	4.35963e-17
C443	TE_B#18	a_126_74##16	6.66675e-19
C444	a_239_368##8	TE_B#6	8.12008e-19
C445	VGND#4	a_126_74##5	6.2081e-20
C446	a_239_368##15	TE_B#14	5.00423e-17
C447	a_239_368##7	TE_B#12	1.70124e-17
C448	a_293_74##9	TE_B#3	6.10424e-18
C449	VGND#4	a_126_74##4	6.1305e-20
C450	VPWR#5	TE_B#14	2.61225e-18
C451	TE_B#14	VPWR#10	2.43633e-17
C452	a_293_74##9	a_126_74##11	4.36021e-19
C453	Z#9	A#6	1.00891e-19
C454	a_239_368##7	VPWR#2	3.31134e-19
C455	VPWR#9	TE_B#15	3.03503e-19
C456	A#24	A#21	3.48545e-18
C457	Z#5	TE_B#11	5.22409e-20
C458	a_239_368##16	TE_B#14	2.82196e-19
C459	a_126_74##9	TE_B#8	2.28443e-17
C460	a_239_368##7	a_239_368##5	5.43544e-19
C461	VPWR#2	A#21	1.00688e-20
C462	Z#2	a_239_368##12	4.35352e-17
C463	a_126_74##3	TE_B#3	1.76576e-17
C464	a_239_368##15	TE_B#15	1.65323e-18
C465	VGND#6	a_126_74##7	3.10405e-20
C466	VGND#3	a_126_74##12	1.17634e-18
C467	Z#4	TE_B#11	2.76553e-20
C468	Z#11	Z#13	9.69386e-20
C469	VPWR#10	TE_B#15	5.67925e-17
C470	a_126_74#	A#24	5.48061e-18
C471	TE_B#15	a_239_368##16	1.60405e-17
C472	a_239_368##15	TE_B#16	1.34794e-19
C473	VPWR#11	TE_B#15	1.26222e-18
C474	a_239_368#	VPWR#1	7.39736e-17
C475	VPWR#10	TE_B#16	2.6158e-18
C476	VGND#9	a_293_74##10	1.59535e-17
C477	a_126_74##3	TE_B#2	7.4648e-18
C478	a_293_74#	A#7	2.78243e-17
C479	VPWR#1	Z#1	9.3781e-18
C480	VGND#5	a_126_74##7	3.02645e-20
C481	Z#15	A#7	6.21894e-17
C482	a_239_368##16	TE_B#16	5.00423e-17
C483	Z#2	A#4	8.26274e-19
C484	Z#3	Z#7	4.31568e-18
C485	VGND#6	VGND#10	5.91997e-20
C486	a_126_74#	TE_B#1	1.4559e-17
C487	a_239_368##8	TE_B#13	7.80992e-18
C488	TE_B#16	VPWR#11	2.45239e-17
C489	a_239_368##8	TE_B#5	8.8926e-18
C490	VPWR#10	TE_B#17	3.03503e-19
C491	a_239_368##7	TE_B#13	8.83991e-19
C492	a_293_74##3	A#7	3.09033e-19
C493	a_239_368##10	TE_B#16	3.93128e-19
C494	A#9	A#8	4.58825e-17
C495	a_293_74##9	TE_B#2	7.0878e-18
C496	Z#11	A#7	7.43889e-17
C497	a_239_368##16	TE_B#17	1.86043e-18
C498	VGND#9	a_293_74##9	1.66961e-17
C499	a_293_74##9	a_126_74##12	8.44557e-20
C500	a_293_74##11	a_126_74##8	2.198e-18
C501	VGND#5	a_126_74##13	1.06951e-18
C502	a_239_368#	Z#1	7.51503e-17
C503	VPWR#5	TE_B#15	1.88666e-18
C504	VPWR#11	TE_B#17	5.70033e-17
C505	a_293_74##9	Z	9.7936e-18
C506	VGND#4	a_293_74##15	1.37137e-17
C507	a_126_74##2	TE_B#2	2.26926e-17
C508	Z#9	A#7	3.32114e-18
C509	a_239_368##7	VPWR#8	2.86587e-17
C510	a_239_368##10	TE_B#17	7.74499e-17
C511	A#21	A#19	4.36265e-18
C512	a_239_368##16	VPWR#6	7.26329e-18
C513	a_239_368##16	TE_B#19	6.11109e-20
C514	A#11	A#9	4.79994e-17
C515	a_239_368##7	Z	8.18995e-18
C516	a_126_74##20	TE_B#17	1.96246e-18
C517	VGND#2	A#24	2.17463e-20
C518	VPWR#11	TE_B#19	1.10181e-18
C519	Z#4	a_239_368##13	1.31557e-17
C520	VPWR#7	TE_B#17	9.59305e-19
C521	a_239_368##11	a_239_368#	3.51463e-18
C522	a_239_368##10	TE_B#19	1.95561e-18
C523	VPWR#5	VPWR#3	1.07669e-18
C524	a_239_368##16	VPWR#5	6.45178e-18
C525	a_126_74##20	TE_B#19	7.17585e-17
C526	A#17	A#11	4.69513e-17
C527	a_239_368##9	TE_B#14	1.10932e-19
C528	VPWR#7	TE_B#19	3.73522e-17
C529	Z#3	a_239_368##13	5.82642e-17
C530	VGND#5	a_126_74##6	6.1305e-20
C531	Z#1	a_239_368##11	4.18019e-17
C532	a_239_368##8	TE_B#14	1.02632e-17
C533	VGND#6	a_293_74##16	6.52656e-18
C534	a_239_368##8	TE_B#4	8.34359e-18
C535	VPWR	VPWR#6	8.06485e-17
C536	a_239_368##7	TE_B#14	2.07916e-19
C537	VGND#6	a_126_74##14	5.41692e-19
C538	VPWR	VPWR#5	4.95631e-17
C539	A#18	A#17	4.79994e-17
C540	VPWR	VPWR#3	4.33322e-17
C541	VPWR	VPWR#2	9.54968e-17
C542	A#7	a_239_368#	3.29479e-17
C543	a_293_74##16	a_126_74##9	4.61207e-20
C544	Z#5	Z#8	6.88e-19
C545	a_293_74##15	a_293_74##9	1.02087e-18
C546	VPWR#6	TE_B#16	2.61225e-18
C547	A#7	Z#1	5.92116e-17
C548	VGND#11	a_126_74##9	1.8325e-18
C549	a_293_74##9	a_126_74##13	3.21474e-20
C550	a_293_74##11	a_126_74##7	9.91742e-18
C551	VGND#5	a_126_74##14	1.26241e-18
C552	a_239_368##7	a_239_368##14	2.94685e-19
C553	a_293_74##12	a_126_74##9	1.06148e-17
C554	a_239_368##4	VPWR#2	2.54391e-17
C555	A#7	Z#6	3.76443e-19
C556	a_126_74##18	a_126_74##9	5.62584e-17
C557	VGND#5	a_293_74##16	7.18695e-18
C558	A#23	A#18	3.4523e-17
C559	VPWR	a_239_368##9	2.48861e-18
C560	a_239_368##15	VPWR#4	1.26435e-17
C561	VPWR	a_239_368##8	2.69919e-18
C562	VGND#7	a_126_74##9	2.78023e-18
C563	A#7	a_239_368##12	6.22123e-19
C564	VPWR	a_239_368##7	3.85775e-18
C565	VGND#10	a_293_74##11	1.59535e-17
C566	A#19	A#15	4.12871e-18
C567	Z#4	Z#8	2.75587e-18
C568	VPWR	a_239_368##4	3.0588e-17
C569	VPWR	a_239_368##3	1.76095e-18
C570	VGND#2	A#21	1.05158e-20
C571	a_293_74#	A#1	5.14606e-17
C572	a_293_74##12	TE_B#10	2.59288e-18
C573	VPWR	Z#5	1.50473e-18
C574	VPWR	Z#4	2.28882e-18
C575	A#26	A#23	4.69693e-17
C576	VPWR	Z#3	7.5628e-18
C577	VGND#1	A#1	6.64135e-18
C578	a_126_74##18	TE_B#10	3.34228e-17
C579	TE_B#10	VGND#7	6.98542e-18
C580	VGND#1	A#10	6.00866e-18
C581	Z#8	Z#3	3.02758e-18
C582	a_239_368##9	TE_B#15	6.95736e-18
C583	VGND#10	a_293_74##10	1.66961e-17
C584	A#1	Z#15	2.46049e-17
C585	VGND#1	A#12	5.99919e-18
C586	a_239_368##8	TE_B#15	1.41095e-19
C587	a_239_368##12	a_239_368##11	3.40187e-18
C588	VGND#1	A#13	6.00484e-18
C589	a_239_368##8	VPWR#9	2.0735e-17
C590	A#27	A#26	4.71806e-17
C591	a_239_368##8	TE_B#3	3.43542e-19
C592	a_293_74#	A#10	2.20749e-18
C593	VGND#1	A#16	5.41456e-18
C594	a_293_74##11	a_239_368##9	6.37646e-17
C595	VGND#6	a_126_74##15	4.90333e-18
C596	Z#5	a_239_368##5	1.09637e-17
C597	VGND#1	A#20	4.43427e-18
C598	a_293_74##9	A#24	2.37152e-18
C599	VGND	VGND#6	9.57955e-17
C600	VGND	VGND#5	4.53166e-17
C601	VGND#1	A#22	1.2416e-18
C602	VGND	VGND#3	4.53175e-17
C603	VGND	VGND#2	9.21878e-17
C604	VPWR#6	TE_B#17	1.88666e-18
C605	VGND	a_293_74##11	2.54591e-18
C606	TE_B#1	A#27	4.65507e-17
C607	a_239_368##7	VPWR#9	3.39348e-17
C608	Z#15	A#10	3.48814e-17
C609	a_293_74##11	a_126_74##6	9.23034e-18
C610	VGND	a_293_74##10	2.08618e-18
C611	VGND	a_293_74##9	3.58666e-18
C612	Z#14	A#1	2.58203e-19
C613	VGND	a_239_368##9	4.87625e-18
C614	VGND	a_239_368##8	4.67983e-18
C615	a_239_368##5	Z#4	1.80746e-17
C616	VGND	a_239_368##7	4.68075e-18
C617	a_239_368##7	TE_B#3	8.52824e-18
C618	A#10	a_293_74##13	1.44303e-17
C619	a_239_368##10	a_126_74##9	4.67241e-18
C620	TE_B#11	TE_B#1	3.1496e-17
C621	a_239_368##10	VPWR#6	1.78561e-17
C622	a_239_368##7	Z#5	4.70126e-19
C623	VGND	Z#5	4.81752e-19
C624	Z#15	A#12	5.26473e-19
C625	a_293_74##10	a_126_74##6	5.14737e-19
C626	VPWR#3	VPWR#2	9.5684e-19
C627	Z#14	A#10	4.42325e-19
C628	TE_B#12	TE_B#11	4.69255e-17
C629	a_239_368##9	TE_B#16	1.02632e-17
C630	a_126_74##20	TE_B#10	2.8861e-17
C631	a_239_368##8	TE_B#16	5.29881e-20
C632	TE_B#10	VPWR#7	3.86106e-17
C633	A#12	a_293_74##13	1.44303e-17
C634	a_239_368##8	a_239_368##15	4.74772e-19
C635	Z#9	Z#4	3.62905e-18
C636	VGND#4	a_126_74##12	5.73824e-20
C637	VPWR#1	A#8	6.72258e-18
C638	TE_B#13	TE_B#12	3.80046e-17
C639	VGND#6	a_293_74##12	1.07039e-17
C640	a_293_74##11	a_239_368##8	1.18054e-17
C641	VGND#4	a_126_74##13	1.78258e-18
C642	Z#15	A#13	2.3024e-19
C643	VPWR#1	A#9	6.11548e-18
C644	VGND#6	a_126_74##16	4.35503e-18
C645	VPWR#6	VNB	4.26171e-17
C646	VPWR#5	VNB	2.49005e-17
C647	VPWR#3	VNB	2.20655e-17
C648	A#12	Z#14	1.476e-17
C649	VPWR#2	VNB	5.11259e-17
C650	VGND#6	VNB	4.1399e-17
C651	VPWR#1	A#11	6.08257e-18
C652	VGND#5	VNB	2.29576e-17
C653	a_239_368##15	a_239_368##7	1.97648e-18
C654	a_239_368##13	a_239_368##12	3.85197e-18
C655	VGND#3	VNB	2.2853e-17
C656	VGND#2	VNB	4.95498e-17
C657	TE_B#14	TE_B#13	4.79394e-17
C658	a_293_74##9	VNB	1.79975e-19
C659	VPWR#1	A#17	6.11536e-18
C660	a_293_74##2	VNB	4.63071e-18
C661	a_239_368##9	VNB	2.6278e-18
C662	a_239_368##8	VNB	2.33022e-18
C663	a_239_368##7	VNB	1.10336e-18
C664	VPWR#1	A#18	6.0778e-18
C665	a_239_368##4	VNB	6.3842e-18
C666	a_239_368##3	VNB	4.22328e-18
C667	a_293_74##3	A#12	1.12253e-18
C668	a_239_368##2	VNB	4.48627e-18
C669	a_239_368##7	TE_B#2	1.12535e-17
C670	Z#13	VNB	7.03917e-19
C671	VGND#11	a_293_74##11	2.37521e-17
C672	VPWR#1	A#23	4.42929e-18
C673	a_239_368##9	a_126_74##8	2.19151e-18
C674	a_293_74##7	Z#5	1.03063e-17
C675	a_239_368##7	Z#4	2.48114e-19
C676	Z#5	VNB	1.09891e-18
C677	TE_B#15	TE_B#14	3.79987e-17
C678	Z#4	VNB	1.30382e-20
C679	VPWR#1	A#26	2.19988e-18
C680	a_126_74##20	VPWR#6	6.28344e-18
C681	A#13	Z#14	1.68562e-17
C682	VGND#6	a_239_368##10	4.63643e-19
C683	a_239_368##9	VPWR#10	1.51761e-17
C684	Z#11	A#12	2.21448e-19
C685	a_126_74##9	a_126_74##16	2.85103e-17
C686	A#7	A#8	6.70321e-18
C687	a_293_74##10	a_126_74##5	1.03735e-17
C688	TE_B#16	TE_B#15	4.7938e-17
C689	TE_B#18	a_126_74##9	2.66339e-17
C690	a_239_368##9	TE_B#17	2.22545e-19
C691	A#7	A#9	2.06457e-18
C692	VPWR	TE_B#8	9.91094e-19
C693	TE_B	a_126_74##18	2.17681e-17
C694	VPWR	TE_B#7	7.38002e-23
C695	a_293_74##3	A#13	4.70737e-17
C696	VPWR	TE_B#6	5.67042e-21
C697	VGND#7	TE_B	3.27149e-17
C698	a_239_368##8	VPWR#10	1.95146e-17
C699	VPWR	TE_B#3	5.67042e-21
C700	a_293_74##7	Z	2.55597e-17
C701	A#7	A#17	2.06454e-18
C702	TE_B#17	TE_B#16	3.80287e-17
C703	Z#14	A#16	4.15218e-19
C704	a_293_74##10	a_239_368##8	6.2808e-17
C705	Z#11	A#13	7.11758e-19
C706	VGND#6	a_126_74##18	1.50183e-17
C707	VGND	A#24	2.93788e-20
C708	VGND	A#21	1.40745e-20
C709	TE_B#19	TE_B#17	6.56551e-18
C710	VGND#6	TE_B#18	1.73686e-19
C711	Z#9	A#12	8.55012e-20
C712	Z#8	a_239_368##13	3.4678e-17
C713	A#7	A#27	3.22728e-19
C714	VPWR#4	TE_B#13	2.71207e-18
C715	a_293_74##3	A#16	3.79734e-17
C716	VGND	TE_B#8	4.8245e-19
C717	VGND	TE_B#7	4.75887e-21
C718	VGND	TE_B#5	4.75887e-21
C719	VGND	TE_B#3	4.75887e-21
C720	VGND#3	a_126_74##3	3.49206e-20
C721	VGND	a_126_74##8	5.07282e-19
C722	VGND	a_126_74##7	1.12519e-20
C723	Z	a_239_368##5	2.76287e-17
C724	a_239_368##9	a_126_74##7	4.12864e-18
C725	VGND	a_126_74##6	2.06824e-20
C726	a_293_74##12	a_293_74##11	1.27459e-18
C727	Z#11	A#16	3.90442e-17
C728	a_239_368##5	a_239_368##13	5.01824e-18
C729	VGND	a_126_74##5	1.12519e-20
C730	VGND	a_126_74##4	2.06824e-20
C731	VGND	a_126_74##3	1.12519e-20
C732	VGND	a_126_74##2	1.11113e-20
C733	Z#9	A#13	1.26736e-19
C734	a_293_74##12	a_239_368##10	1.35835e-17
C735	a_239_368##9	a_239_368##16	4.70002e-19
C736	VPWR#7	VPWR#6	4.01093e-19
C737	a_293_74#	Z#15	6.36881e-17
C738	VGND	a_293_74##3	5.72764e-18
C739	A#24	VNB	2.79554e-17
C740	VGND	Z#11	6.86404e-18
C741	A#21	VNB	2.76305e-17
C742	a_293_74##3	A#20	4.46099e-19
C743	A#19	VNB	2.53754e-17
C744	VGND	a_293_74##5	2.64989e-17
C745	A#15	VNB	3.5734e-17
C746	VGND	Z#9	9.14518e-18
C747	VGND	a_293_74##7	2.1719e-17
C748	A#6	VNB	2.38086e-17
C749	a_293_74##10	a_126_74##4	8.99735e-18
C750	VGND	VGND#8	2.17698e-17
C751	VPWR	Z#8	5.87655e-18
C752	A#4	VNB	3.15192e-17
C753	VGND	a_293_74##14	1.50855e-17
C754	a_239_368##9	TE_B#19	2.40229e-20
C755	VPWR	a_239_368##5	2.07523e-17
C756	VGND	VGND#9	2.18421e-17
C757	A#2	VNB	3.8249e-17
C758	VPWR	VPWR#8	2.16929e-17
C759	VGND	a_293_74##15	1.50237e-17
C760	a_239_368##5	Z#8	4.25041e-17
C761	TE_B#8	VNB	2.56953e-17
C762	a_293_74##7	A#13	7.7333e-20
C763	VGND	VGND#10	2.18458e-17
C764	VPWR	a_239_368##14	1.80542e-17
C765	TE_B#7	VNB	1.32969e-17
C766	VGND	a_293_74##16	1.50686e-17
C767	TE_B#6	VNB	1.33294e-17
C768	VPWR	VPWR#9	2.1098e-17
C769	TE_B#5	VNB	1.32902e-17
C770	VPWR	a_239_368##15	1.51981e-17
C771	VGND#2	a_126_74##3	2.63844e-20
C772	TE_B#4	VNB	1.33362e-17
C773	a_126_74##18	a_239_368##10	1.30338e-17
C774	VGND	a_293_74##12	1.28368e-17
C775	TE_B#3	VNB	1.32996e-17
C776	VPWR	VPWR#10	2.10952e-17
C777	VGND	a_126_74##18	3.54674e-17
C778	TE_B#2	VNB	1.54259e-17
C779	Z#11	A#20	3.93679e-17
C780	a_126_74##8	VNB	1.86384e-17
C781	VGND	VGND#7	9.01489e-17
C782	VPWR	a_239_368##16	1.52518e-17
C783	a_126_74##7	VNB	1.45781e-17
C784	VPWR	VPWR#11	2.11686e-17
C785	a_126_74##6	VNB	1.64031e-17
C786	a_126_74##5	VNB	1.63988e-17
C787	VPWR	a_239_368##10	1.66776e-17
C788	a_126_74##4	VNB	1.64255e-17
C789	Z#9	A#16	2.14278e-19
C790	a_126_74##3	VNB	1.65131e-17
C791	VPWR	a_126_74##20	2.09531e-17
C792	VPWR#1	A#7	1.50771e-17
C793	a_126_74##2	VNB	1.37618e-17
C794	Z	a_126_74#	2.2851e-18
C795	VPWR	VPWR#7	8.2015e-17
C796	a_293_74#	VNB	4.70971e-17
C797	Z#15	VNB	9.2631e-19
C798	TE_B	TE_B#18	2.40465e-18
C799	VGND#1	A#7	1.39307e-17
C800	a_293_74##3	VNB	4.68513e-18
C801	Z#11	VNB	9.77478e-19
C802	a_293_74##10	a_239_368##7	6.4297e-18
C803	a_293_74##3	A#22	2.19979e-19
C804	a_293_74##5	VNB	4.43553e-18
C805	Z#9	VNB	2.61873e-18
C806	a_293_74##7	VNB	6.89983e-18
C807	VGND#7	VGND#6	1.53119e-20
C808	VGND#8	VNB	1.31987e-20
C809	a_293_74##5	A#20	3.58007e-17
C810	a_293_74##14	VNB	2.24178e-18
C811	VGND#9	VNB	1.06304e-18
C812	A#6	A#4	4.0818e-18
C813	a_293_74##15	VNB	2.5601e-18
C814	a_293_74##9	a_126_74##4	5.14737e-19
C815	VGND#10	VNB	1.06392e-18
C816	a_293_74##16	VNB	2.55128e-18
C817	a_293_74##7	A#16	1.06896e-19
C818	VGND#11	VNB	4.45064e-19
C819	VGND	a_239_368##10	5.37334e-18
C820	a_293_74##12	VNB	4.09928e-18
C821	a_126_74##18	VNB	1.94798e-17
C822	VGND#7	VNB	7.41944e-17
C823	VGND	VPWR#7	3.83144e-18
C824	a_239_368#	VNB	5.38758e-17
C825	VGND	A#16	4.16594e-19
C826	Z#4	a_239_368##4	3.54799e-18
C827	Z#9	A#20	3.94331e-19
C828	VGND	A#20	1.37789e-18
C829	a_239_368##5	VNB	1.8631e-18
C830	VGND	A#22	1.27048e-18
C831	VPWR#8	VNB	4.04362e-18
C832	a_239_368##14	VNB	2.19633e-18
C833	VGND	A#25	1.18938e-18
C834	a_239_368##5	VPWR#8	7.20009e-17
C835	VPWR#9	VNB	7.64071e-19
C836	VGND	a_126_74#	1.74816e-18
C837	a_239_368##15	VNB	2.29965e-18
C838	VGND#8	A#16	4.57029e-20
C839	VGND	a_126_74##10	7.67436e-19
C840	VPWR#10	VNB	7.64071e-19
C841	a_239_368##9	a_126_74##6	1.84563e-18
C842	TE_B#10	a_126_74##9	7.79296e-18
C843	a_239_368##16	VNB	2.29965e-18
C844	VGND	a_126_74##11	7.5408e-20
C845	VPWR#11	VNB	8.53234e-19
C846	VGND	a_126_74##12	7.09258e-19
C847	a_239_368##10	VNB	1.61616e-17
C848	Z	TE_B#1	1.8848e-17
C849	a_293_74##3	A#25	1.34517e-19
C850	VGND	a_126_74##13	1.40208e-19
C851	a_126_74##20	VNB	1.97643e-17
C852	VPWR#7	VNB	9.28392e-17
C853	VGND	a_126_74##14	6.39982e-19
C854	A#1	VNB	3.31473e-17
C855	VGND	a_126_74##15	2.94227e-19
C856	a_293_74##5	A#22	3.58006e-17
C857	A#10	VNB	2.9741e-17
C858	VGND	a_126_74##16	8.07566e-19
C859	VPWR	A#23	1.65326e-18
C860	A#12	VNB	2.91007e-17
C861	A#13	VNB	2.94949e-17
C862	VGND	TE_B#18	4.01737e-18
C863	VPWR	A#26	1.57004e-18
C864	A#16	VNB	2.97529e-17
C865	a_239_368##9	VPWR#11	2.9016e-17
C866	a_293_74##7	A#20	1.83787e-19
C867	A#20	VNB	2.94597e-17
C868	VPWR	A#27	1.39065e-18
C869	A#22	VNB	2.93208e-17
C870	VPWR	TE_B#1	5.21199e-19
C871	A#25	VNB	3.09087e-17
C872	a_126_74#	VNB	3.33333e-17
C873	VPWR	TE_B#11	1.31893e-19
C874	a_126_74##10	VNB	2.21362e-17
C875	a_126_74##11	VNB	2.41076e-17
C876	VPWR	TE_B#12	2.45932e-19
C877	a_126_74##12	VNB	2.24968e-17
C878	VPWR	TE_B#13	1.92148e-18
C879	a_126_74##13	VNB	2.44314e-17
C880	a_126_74##14	VNB	2.22907e-17
C881	VPWR	TE_B#14	2.21663e-19
C882	a_239_368##14	a_239_368##5	2.07064e-18
C883	a_126_74##15	VNB	2.41765e-17
C884	a_126_74##16	VNB	2.45111e-17
C885	VPWR	TE_B#15	1.20926e-18
C886	TE_B#18	VNB	3.66591e-17
C887	VPWR	TE_B#16	2.21663e-19
C888	Z#9	A#22	3.93305e-17
C889	A#8	VNB	3.7146e-17
C890	VPWR	TE_B#17	1.32741e-18
C891	A#9	VNB	3.26956e-17
C892	A#11	VNB	3.24023e-17
C893	VPWR	TE_B#19	5.51736e-18
C894	A#17	VNB	3.31879e-17
C895	VGND#8	A#20	7.99039e-20
C896	VGND#7	VPWR#7	8.96587e-19
C897	A#18	VNB	3.20111e-17
C898	A#23	VNB	3.20233e-17
C899	VPWR	VPWR#1	4.1981e-17
C900	A#26	VNB	3.20482e-17
C901	TE_B	TE_B#10	1.08089e-17
C902	VGND#2	a_126_74##2	6.1305e-20
C903	A#27	VNB	3.23776e-17
C904	TE_B#1	VNB	4.48193e-17
C905	VPWR	VPWR#4	2.25761e-17
C906	a_239_368##8	a_126_74##6	1.2318e-18
C907	TE_B#11	VNB	3.54133e-17
C908	a_293_74##3	a_126_74#	9.25897e-20
C909	Z#14	Z#15	2.62329e-18
C910	TE_B#12	VNB	3.07665e-17
C911	TE_B#13	VNB	3.04108e-17
C912	TE_B#14	VNB	3.08488e-17
C913	VPWR	A#7	4.73603e-18
C914	TE_B#15	VNB	2.93731e-17
C915	VGND	VGND#1	4.0062e-17
C916	TE_B#16	VNB	3.08488e-17
C917	TE_B#17	VNB	3.17574e-17
C918	a_293_74##7	A#22	3.83051e-19
C919	VPWR	TE_B#10	4.93846e-18
C920	VGND	VGND#4	1.9886e-17
C921	TE_B#19	VNB	3.673e-17
C922	a_239_368##14	VPWR#8	6.22197e-17
C923	VGND	A#7	3.64544e-18
C924	VPWR#1	VNB	2.5363e-16
C925	VGND	a_126_74##9	7.10719e-18
C926	a_293_74##9	a_239_368##7	6.30201e-17
C927	VGND#1	VNB	2.54276e-16
C928	VGND	TE_B#10	5.68312e-19
C929	VPWR#4	VNB	1.14064e-17
C930	VGND#4	VNB	1.18307e-17
C931	A#7	VNB	8.65588e-17
C932	a_126_74##9	VNB	8.30969e-17
C933	a_293_74##12	TE_B#8	5.47823e-18
C934	TE_B#10	VNB	9.84029e-17
C935	VPWR	Z	1.24317e-18
C936	Z#9	A#25	2.59581e-17
C937	VGND	TE_B	4.38521e-18
C938	a_293_74##9	a_126_74##3	1.07464e-17
C939	VGND	Z	1.42262e-18
C940	TE_B	VNB	1.40238e-17
C941	Z	VNB	5.03688e-18
C942	VGND#8	A#22	2.80855e-19
C943	VPWR	VNB	2.96036e-16
C944	VGND	VNB	2.87485e-16
*
*
.ENDS sky130_fd_sc_hs__einvn_8
*
