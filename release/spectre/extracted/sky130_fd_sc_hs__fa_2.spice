* Extracted by Quantus, converted by sky130cad/quantus.py
*
*
*
*                       LINUX           Wed Nov 18 08:38:14 2026
*
*
*
*  PROGRAM  advgen
*
*  Name           : advgen - Quantus - (64-bit)
*  Version        : 25.1.0-p047
*  Build Date     : Thu Dec 11 23:20:30 PST 2025
*
*  HSPICE LIBRARY
*
*  OPERATING_TEMPERATURE 150
*  QRC_TECH_DIR <path>/tech
*
*
*

*
.SUBCKT sky130_fd_sc_hs__fa_2 VPB VNB VGND A VPWR COUT SUM B CIN
*
*
*  caps2d version: 10
*
*
*       TRANSISTOR CARDS
*
*
XM0 a_27_79##2 A#4 VGND#12 VNB sky130_fd_pr__nfet_01v8_lvt l=0.15 w=0.74 ad=0.2109 as=0.3663 pd=2.05 ps=2.47
XM11 VGND#12 B#11 a_27_79# VNB sky130_fd_pr__nfet_01v8_lvt l=0.15 w=0.74 ad=0.3663 as=0.4218 pd=2.47 ps=2.62
XM28 a_27_79# CIN#1 a_336_347##15 VNB sky130_fd_pr__nfet_01v8_lvt l=0.15 w=0.74 ad=0.4218 as=0.259 pd=2.62 ps=2.18
XM18 a_336_347##15 B#10 a_487_79# VNB sky130_fd_pr__nfet_01v8_lvt l=0.15 w=0.74 ad=0.259 as=0.1776 pd=2.18 ps=1.96
XM17 a_487_79# A#7 VGND#11 VNB sky130_fd_pr__nfet_01v8_lvt l=0.15 w=0.74 ad=0.1776 as=0.3922 pd=1.96 ps=2.54
XM2 VGND#11 CIN#4 a_701_79##2 VNB sky130_fd_pr__nfet_01v8_lvt l=0.15 w=0.74 ad=0.3922 as=0.2072 pd=2.54 ps=2.04
XM31 a_701_79##2 B#8 VGND#8 VNB sky130_fd_pr__nfet_01v8_lvt l=0.15 w=0.74 ad=0.2072 as=0.38795 pd=2.04 ps=2.79
XM3 VGND#8 A#8 a_701_79# VNB sky130_fd_pr__nfet_01v8_lvt l=0.15 w=0.74 ad=0.38795 as=0.3108 pd=2.79 ps=2.32
XM8 a_701_79# a_336_347# a_992_347##9 VNB sky130_fd_pr__nfet_01v8_lvt l=0.15 w=0.74 ad=0.3108 as=0.259 pd=2.32 ps=2.18
XM16 a_992_347##9 CIN#7 a_1119_79# VNB sky130_fd_pr__nfet_01v8_lvt l=0.15 w=0.74 ad=0.259 as=0.2072 pd=2.18 ps=2.04
XM23 a_1119_79# B#1 a_1205_79# VNB sky130_fd_pr__nfet_01v8_lvt l=0.15 w=0.74 ad=0.2072 as=0.1776 pd=2.04 ps=1.96
XM21 a_1205_79# A#13 VGND#7 VNB sky130_fd_pr__nfet_01v8_lvt l=0.15 w=0.74 ad=0.1776 as=0.507325 pd=1.96 ps=3.04
XM14 COUT#1 a_336_347##9 VGND#7 VNB sky130_fd_pr__nfet_01v8_lvt l=0.15 w=0.74 ad=0.2072 as=0.507325 pd=2.04 ps=3.04
XM6 VGND#6 a_336_347##4 COUT#1 VNB sky130_fd_pr__nfet_01v8_lvt l=0.15 w=0.74 ad=0.50255 as=0.2072 pd=3.03 ps=2.04
XM15 VGND#6 a_992_347##5 SUM#3 VNB sky130_fd_pr__nfet_01v8_lvt l=0.15 w=0.74 ad=0.50255 as=0.2072 pd=3.03 ps=2.04
XM24 SUM#3 a_992_347# VGND#1 VNB sky130_fd_pr__nfet_01v8_lvt l=0.15 w=0.74 ad=0.2072 as=0.2109 pd=2.04 ps=2.05
XM22 a_27_378##2 A#1 VPWR#13 VPB sky130_fd_pr__pfet_01v8 l=0.15 w=1 ad=0.295 as=0.527125 pd=2.59 ps=3.31
XM26 VPWR#13 B#5 a_27_378# VPB sky130_fd_pr__pfet_01v8 l=0.15 w=1 ad=0.527125 as=0.3 pd=3.31 ps=2.6
XM9 a_27_378# CIN#3 a_336_347##13 VPB sky130_fd_pr__pfet_01v8 l=0.15 w=1 ad=0.3 as=0.59 pd=2.6 ps=3.18
XM7 a_336_347##13 B#9 a_484_347# VPB sky130_fd_pr__pfet_01v8 l=0.15 w=1 ad=0.59 as=0.27 pd=3.18 ps=2.54
XM12 a_484_347# A#5 VPWR#12 VPB sky130_fd_pr__pfet_01v8 l=0.15 w=1 ad=0.27 as=0.425 pd=2.54 ps=2.85
XM30 VPWR#12 CIN#6 a_683_347# VPB sky130_fd_pr__pfet_01v8 l=0.15 w=1 ad=0.425 as=0.382125 pd=2.85 ps=3.02
XM19 a_683_347# B#7 VPWR#11 VPB sky130_fd_pr__pfet_01v8 l=0.15 w=1 ad=0.382125 as=0.467125 pd=3.02 ps=3.19
XM29 VPWR#11 A#10 a_683_347##2 VPB sky130_fd_pr__pfet_01v8 l=0.15 w=1 ad=0.467125 as=0.3 pd=3.19 ps=2.6
XM13 a_683_347##2 a_336_347##3 a_992_347##8 VPB sky130_fd_pr__pfet_01v8 l=0.15 w=1 ad=0.3 as=0.36 pd=2.6 ps=2.72
XM25 a_992_347##8 CIN#9 a_1094_347# VPB sky130_fd_pr__pfet_01v8 l=0.15 w=1 ad=0.36 as=0.4047 pd=2.72 ps=2.99
XM1 a_1094_347# B#2 a_1202_368# VPB sky130_fd_pr__pfet_01v8 l=0.15 w=1 ad=0.4047 as=0.27 pd=2.99 ps=2.54
XM5 a_1202_368# A#11 VPWR#10 VPB sky130_fd_pr__pfet_01v8 l=0.15 w=1 ad=0.27 as=0.4554 pd=2.54 ps=3.08
XM10 COUT#2 a_336_347##7 VPWR#10 VPB sky130_fd_pr__pfet_01v8 l=0.15 w=1.12 ad=0.4424 as=0.4554 pd=3.03 ps=3.08
XM27 VPWR#9 a_336_347##8 COUT#2 VPB sky130_fd_pr__pfet_01v8 l=0.15 w=1.12 ad=0.6048 as=0.4424 pd=3.32 ps=3.03
XM4 VPWR#9 a_992_347##6 SUM#1 VPB sky130_fd_pr__pfet_01v8 l=0.15 w=1.12 ad=0.6048 as=0.336 pd=3.32 ps=2.84
XM20 SUM#1 a_992_347##4 VPWR#1 VPB sky130_fd_pr__pfet_01v8 l=0.15 w=1.12 ad=0.336 as=0.3304 pd=2.84 ps=2.83
*
*
*       RESISTOR AND CAP/DIODE CARDS
*
Rg1	A#1	A#2	513.876282
Rg2	A#2	A#3	28.628225
Rg3	A#2	A#4	408.799255
Rg4	CIN#1	CIN#2	309.686829
Rg5	CIN#2	CIN#3	439.994080
Rg6	A#5	A#6	400.207520
Rg7	A#6	A#7	307.937683
Rg8	CIN#4	CIN#5	359.357056
Rg9	CIN#5	CIN#6	411.880859
Rg10	A#8	A#9	307.937683
Rg11	A#9	A#10	400.207520
Rg12	a_336_347#	a_336_347##2	307.937683
Rg13	a_336_347##2	a_336_347##3	400.207520
Rg14	CIN#7	CIN#8	307.937683
Rg15	CIN#8	CIN#9	400.207520
Rg16	B#1	B#2	831.706848
Rg17	B#2	B#3	1559.067261
Rg18	B#3	B#4	816.906250
Rg19	B#4	B#5	1086.693726
Rg20	B#5	B#6	401.126526
Rg21	B#3	B#7	382.271759
Rg22	B#7	B#8	853.458069
Rg23	B#4	B#9	450.339508
Rg24	B#9	B#10	786.029297
Rg25	B#6	B#11	302.924744
Rg26	A#11	A#12	400.207520
Rg27	A#12	A#13	368.193207
Rg28	a_336_347##4	a_336_347##5	303.268829
Rg29	a_336_347##5	a_336_347##6	159.947800
Rg30	a_336_347##6	a_336_347##7	471.321259
Rg31	a_336_347##5	a_336_347##8	544.730652
Rg32	a_336_347##6	a_336_347##9	308.163879
Rg33	a_992_347#	a_992_347##2	340.569855
Rg34	a_992_347##2	a_992_347##3	185.754196
Rg35	a_992_347##2	a_992_347##4	516.454041
Rg36	a_992_347##3	a_992_347##5	342.878601
Rg37	a_992_347##3	a_992_347##6	439.865051
Rf1	A	A#3	177.884048
Rf2	B#6	B	207.546967
Rf3	a_27_378#	a_27_378##2	75.419403
Rf4	a_27_79#	a_27_79##2	119.470192
Rf5	A#6	A#17	186.264206
Rf6	A#9	A#19	189.555878
Rf7	a_683_347#	a_683_347##2	95.040199
Rf8	a_701_79#	a_701_79##2	98.291634
Rf9	CIN#8	CIN	274.602020
Rf10	CIN	CIN#11	8.631551
Rf11	CIN#11	CIN#2	300.875122
Rf12	CIN#11	CIN#5	194.850891
Rf13	A#12	A#21	160.996811
Rf14	A#22	A#23	0.764007
Rf15	A#21	A#22	5.905091
Rf16	a_336_347##6	a_336_347##11	319.369507
Rf17	a_336_347##11	a_336_347##12	203.396576
Rf18	a_336_347##12	a_336_347##13	182.816742
Rf19	a_336_347##11	a_336_347##2	172.851028
Rf20	a_336_347##12	a_336_347##15	14.902061
Rf21	COUT#1	COUT	102.024384
Rf22	COUT	COUT#2	24.756521
Rf23	a_992_347##7	a_992_347##8	259.352295
Rf24	a_992_347##7	a_992_347##9	252.519745
Rf25	SUM	SUM#2	0.183608
Rf26	SUM#2	SUM	13.403392
Rf27	SUM	SUM#3	85.853798
Rf28	SUM#1	SUM#2	5.000000
Rf29	VGND#1	VGND#2	112.187668
Rf30	VGND#2	VGND#3	91.467110
Rf31	VGND#3	VGND#4	185.641190
Rf32	VGND#4	VGND#5	58.050613
Rf33	VGND#2	VGND#6	24.454403
Rf34	VGND#3	VGND#7	21.816292
Rf35	VGND#4	VGND#8	24.468842
Rf36	VGND#5	VGND#9	195.515945
Rf38	VGND#5	VGND#11	29.070862
Rf39	VGND#9	VGND#12	39.073792
Rf40	VPWR#1	VPWR#2	117.654686
Rf41	VPWR#2	VPWR#3	91.946045
Rf42	VPWR#3	VPWR#4	190.038589
Rf43	VPWR#4	VPWR#5	53.823952
Rf44	VPWR#5	VPWR#6	27.004150
Rf45	VPWR#6	VPWR#7	158.988739
Rf47	VPWR#2	VPWR#9	28.171486
Rf48	VPWR#3	VPWR#10	33.326477
Rf49	VPWR#4	VPWR#11	32.008339
Rf50	VPWR#6	VPWR#12	46.120842
Rf51	VPWR#7	VPWR#13	31.595499
Rf62	a_992_347##3	a_992_347##7	160.232803
Re1	A#23	A#19	13.698293
Re2	A#19	A#17	2.273854
Re3	A#17	A	3.920510
Re5	VPWR#2	VPWR	3.246228
Re6	VPWR	VPWR#5	1.159367
Re7	VGND#2	VGND	3.246228
Re8	VGND	VGND#5	1.159367
*
*       CAPACITOR CARDS
*
*
C1	CIN#11	B#3	1.06306e-18
C2	COUT#2	VPWR#9	2.92215e-18
C3	a_336_347##12	CIN#4	2.42191e-17
C4	a_336_347##12	VGND#11	5.52239e-17
C5	SUM#3	a_992_347##5	3.87564e-17
C6	a_683_347#	CIN#6	3.60627e-17
C7	VGND#5	CIN#11	1.34928e-18
C8	a_336_347##11	a_336_347##6	7.5266e-20
C9	VGND#1	a_336_347##4	3.12342e-19
C10	VPWR#11	A#5	3.99028e-19
C11	CIN#1	B#10	2.77156e-17
C12	VGND#4	CIN#8	1.15104e-19
C13	VPWR#6	B#3	1.34712e-17
C14	VPWR#4	a_336_347##2	3.4729e-19
C15	a_336_347##11	CIN#4	2.34348e-20
C16	CIN#6	VPWR#12	2.50672e-17
C17	A#19	a_992_347##9	1.20173e-18
C18	a_992_347##5	VGND#6	2.07604e-17
C19	VPWR#10	VPWR#9	8.06589e-18
C20	a_336_347##13	B#7	1.94005e-19
C21	A#17	B#4	4.33752e-19
C22	A#22	a_336_347##6	1.04355e-18
C23	a_683_347#	A#5	8.28412e-19
C24	A#19	a_701_79#	3.44543e-18
C25	SUM#3	a_336_347##4	1.61785e-18
C26	a_336_347##12	A#7	2.20563e-17
C27	A#17	B#3	1.28438e-19
C28	VPWR#11	B#9	1.67104e-19
C29	VPWR#12	A#5	4.86063e-17
C30	a_336_347##6	A#21	4.56263e-17
C31	COUT#1	a_992_347##5	1.37613e-18
C32	a_336_347##13	CIN#6	2.96949e-19
C33	VPWR#2	VPWR#1	5.4039e-17
C34	B#11	CIN#1	1.24856e-17
C35	VPWR#3	VPWR#9	1.26202e-18
C36	VGND#4	a_336_347##2	1.48648e-19
C37	A#19	a_701_79##2	3.81038e-18
C38	a_336_347##11	A#7	1.67983e-20
C39	a_336_347##4	VGND#6	2.90885e-17
C40	A#22	A#12	7.44052e-18
C41	SUM#3	a_336_347##9	3.64018e-19
C42	VPWR#12	B#9	5.38051e-18
C43	a_336_347##13	A#5	2.75585e-18
C44	a_336_347##12	B#10	4.33075e-17
C45	a_336_347##12	a_336_347##15	4.49996e-18
C46	VPWR#2	VPWR#9	1.08721e-16
C47	COUT#1	a_336_347##4	2.46176e-17
C48	VPWR#4	B#3	4.9029e-17
C49	a_336_347##11	CIN#8	4.00024e-17
C50	VGND#2	VPWR#1	3.81725e-18
C51	A#21	A#12	1.26137e-17
C52	a_27_378#	A#5	1.93856e-19
C53	SUM#3	VGND#1	6.52427e-17
C54	VGND#6	a_336_347##9	1.40348e-18
C55	VPWR#5	B#4	6.43635e-18
C56	A#4	B#11	1.58433e-17
C57	VPWR#2	COUT#2	5.79118e-18
C58	VPWR#12	CIN#3	1.75362e-18
C59	VGND#4	A#9	7.15206e-19
C60	A#17	VGND#11	3.47862e-18
C61	B#9	a_336_347##13	2.51084e-17
C62	a_336_347##5	a_992_347##5	5.34085e-19
C63	CIN#8	A#22	5.48008e-18
C64	SUM#3	A#13	2.27399e-19
C65	VPWR#5	B#3	1.63022e-17
C66	VPWR#13	A#5	2.6157e-19
C67	VPWR#2	VPWR#10	9.69624e-18
C68	a_336_347##12	CIN#1	3.24699e-17
C69	a_27_378#	B#9	1.38592e-18
C70	COUT#1	a_336_347##9	2.33112e-17
C71	a_992_347##3	SUM#3	6.99018e-17
C72	a_336_347##12	a_27_79#	1.0427e-16
C73	VGND#4	a_336_347##11	1.49937e-18
C74	VGND#2	COUT#2	2.59996e-18
C75	VPWR#12	B#5	6.65671e-19
C76	CIN#8	A#21	8.73063e-18
C77	VGND#6	VGND#1	4.01007e-18
C78	a_336_347##13	CIN#3	5.03711e-17
C79	VGND#6	A#13	5.86648e-19
C80	a_992_347##3	VGND#6	7.33107e-17
C81	VPWR#13	B#9	7.03995e-19
C82	A#17	a_27_79#	2.24121e-18
C83	a_992_347##8	COUT#2	2.38138e-18
C84	a_336_347##9	VGND#7	1.57159e-17
C85	a_992_347##3	COUT#1	7.37964e-17
C86	a_27_378#	CIN#3	4.57723e-17
C87	VPWR#2	a_992_347##8	2.17834e-18
C88	VGND#5	a_992_347##9	3.67411e-17
C89	COUT#1	A#13	9.76959e-19
C90	A#23	COUT#2	3.08659e-18
C91	a_336_347##13	B#5	6.17253e-18
C92	a_336_347##12	B#11	5.80318e-18
C93	VPWR#13	CIN#3	1.02159e-18
C94	VGND#12	a_336_347##12	1.85838e-18
C95	VGND#6	SUM#3	2.64981e-17
C96	VGND#5	a_701_79#	2.17014e-17
C97	a_336_347##11	A#9	3.02359e-17
C98	VGND#6	a_336_347##6	1.27711e-21
C99	A#23	VPWR#10	1.84483e-18
C100	a_27_378#	B#5	7.21655e-17
C101	a_992_347##8	VPWR#10	5.2419e-17
C102	A#13	VGND#7	2.045e-17
C103	a_336_347##6	COUT#1	4.51208e-17
C104	a_992_347##9	a_336_347##4	1.75409e-19
C105	a_336_347##13	A#1	1.7644e-18
C106	CIN#2	VPWR#6	2.4962e-18
C107	B#5	VPWR#13	2.95821e-17
C108	VGND#5	a_701_79##2	3.10898e-17
C109	a_336_347##6	VGND#7	5.60349e-18
C110	COUT#1	B#1	3.57459e-19
C111	a_27_79#	a_27_378#	1.51409e-18
C112	a_27_378#	A#1	2.58109e-18
C113	a_336_347##12	CIN#5	3.71091e-17
C114	VGND#5	VGND#11	2.46582e-17
C115	a_27_378##2	B#5	3.15474e-18
C116	a_336_347##12	A#4	1.41279e-18
C117	a_27_79##2	a_336_347##12	2.13929e-18
C118	a_336_347##11	CIN#5	7.96522e-18
C119	A#23	a_992_347##8	2.33414e-17
C120	A#1	VPWR#13	3.25106e-17
C121	a_992_347##6	a_992_347##4	4.70039e-17
C122	a_992_347##9	a_336_347##9	4.56897e-19
C123	a_992_347##9	a_336_347##6	7.42984e-17
C124	COUT#1	CIN#7	2.20561e-19
C125	a_27_378##2	A#1	5.48178e-17
C126	CIN#11	VPWR#6	8.92688e-19
C127	VGND#5	a_27_79#	3.18254e-17
C128	A#19	a_992_347##8	4.64395e-18
C129	VPWR#3	a_336_347##7	3.95033e-18
C130	a_336_347##12	A#6	3.17363e-18
C131	a_992_347##8	VPWR#4	9.5816e-18
C132	a_992_347##9	A#13	2.04521e-17
C133	A#19	a_683_347##2	6.05195e-18
C134	a_336_347##8	a_992_347##6	1.99086e-17
C135	a_992_347##9	A#12	5.98027e-19
C136	VPWR#5	VPWR#10	3.18177e-18
C137	VGND#5	a_27_79##2	1.88289e-17
C138	COUT#1	a_336_347#	2.2284e-19
C139	A#19	VPWR#11	2.81197e-18
C140	B#3	B#2	3.13675e-20
C141	CIN#5	CIN#11	4.84807e-18
C142	a_992_347##8	VPWR#3	1.0077e-17
C143	A#19	a_683_347#	6.67352e-18
C144	a_336_347##12	CIN#2	8.87654e-17
C145	VPWR#3	A#11	6.61643e-18
C146	a_992_347##9	B#1	2.01925e-17
C147	a_992_347##3	a_992_347##2	1.31139e-17
C148	a_683_347##2	a_992_347##8	4.37605e-17
C149	a_992_347##9	CIN#8	7.00768e-19
C150	a_336_347##7	a_336_347##8	3.37198e-17
C151	a_683_347##2	VPWR#4	8.8712e-18
C152	VPWR#5	a_992_347##8	3.25779e-17
C153	a_336_347##5	a_992_347##3	1.72806e-17
C154	VPWR#9	a_992_347##2	3.19461e-20
C155	VPWR#5	a_683_347##2	1.39261e-17
C156	VPWR#6	VPWR#11	2.5351e-18
C157	a_27_79##2	a_27_378##2	8.24257e-19
C158	VPWR#4	B#2	9.96657e-18
C159	CIN#11	A#6	1.76802e-18
C160	a_992_347##3	SUM#1	3.89455e-17
C161	A#17	VPWR#12	4.31656e-18
C162	VGND#2	a_992_347#	9.54691e-18
C163	a_992_347##9	CIN#7	4.24951e-17
C164	B#6	a_336_347##12	1.99436e-17
C165	a_992_347##3	VPWR#9	6.13286e-17
C166	VPWR#3	B#2	2.29995e-17
C167	A#11	a_336_347##7	2.96821e-17
C168	VPWR#9	a_336_347##5	2.82479e-20
C169	VGND#2	a_992_347##5	9.31675e-18
C170	a_683_347#	VPWR#5	2.02436e-17
C171	a_336_347##2	a_701_79#	1.49003e-18
C172	a_992_347##3	COUT#2	9.37979e-17
C173	a_701_79#	CIN#7	7.41596e-19
C174	a_683_347##2	VPWR#11	2.92958e-17
C175	A#17	a_336_347##13	4.01187e-17
C176	VGND#2	a_336_347##4	9.54691e-18
C177	B#2	a_336_347##7	1.25618e-18
C178	CIN#2	CIN#11	1.8987e-18
C179	a_336_347#	a_992_347##9	1.85837e-17
C180	VPWR#9	a_336_347##6	2.88553e-20
C181	VPWR#4	CIN#9	1.12179e-18
C182	A#17	a_27_378#	2.12108e-18
C183	VGND#2	a_336_347##9	9.18036e-18
C184	a_336_347##6	COUT#2	3.53131e-17
C185	B#2	A#11	5.92907e-17
C186	a_336_347##6	a_336_347##5	1.39552e-17
C187	VPWR#5	a_336_347##13	1.69438e-17
C188	a_701_79#	A#9	7.19073e-19
C189	a_683_347#	a_683_347##2	2.27492e-18
C190	VPWR#3	CIN#9	1.67144e-18
C191	SUM#3	a_992_347##2	1.46929e-17
C192	a_701_79#	a_336_347#	3.34348e-17
C193	a_683_347#	VPWR#4	1.80026e-18
C194	VPWR#5	a_27_378#	1.69059e-17
C195	a_992_347##9	A#8	9.09076e-19
C196	a_701_79##2	CIN#7	1.06762e-20
C197	COUT#2	A#12	3.73493e-19
C198	a_683_347#	VPWR#11	3.07664e-17
C199	VPWR#4	a_336_347##3	3.91627e-18
C200	COUT#2	a_336_347##5	5.42243e-18
C201	CIN#9	B#2	5.33937e-17
C202	VPWR#5	a_27_378##2	1.90387e-17
C203	A#12	VPWR#10	1.14156e-18
C204	a_336_347##6	a_992_347##8	6.69172e-18
C205	a_701_79#	A#8	4.34797e-17
C206	SUM#3	a_336_347##5	3.42186e-20
C207	a_336_347##3	B#3	2.21017e-17
C208	a_992_347##9	B#8	2.18272e-19
C209	a_701_79##2	a_336_347#	1.92293e-20
C210	VGND#5	a_336_347##13	4.57512e-19
C211	A#22	a_336_347##8	6.63774e-19
C212	CIN#8	COUT#2	4.14231e-18
C213	VPWR#12	VPWR#11	4.21176e-18
C214	VGND#11	CIN#5	7.94126e-19
C215	A#8	VGND#8	1.82334e-17
C216	a_336_347##3	CIN#9	3.29901e-17
C217	a_992_347##8	A#12	1.41592e-18
C218	VPWR#4	A#10	2.80594e-18
C219	a_701_79#	B#8	1.01944e-18
C220	VGND#6	a_992_347##2	5.02223e-20
C221	a_992_347##9	VGND#7	3.78393e-18
C222	VPWR#12	a_683_347#	2.88479e-17
C223	a_701_79##2	A#8	7.03445e-19
C224	B#7	B#2	9.2111e-20
C225	A#22	COUT#2	2.6323e-18
C226	A#22	a_336_347##7	1.90398e-18
C227	VGND#11	A#6	9.4089e-19
C228	B#8	VGND#8	1.83341e-17
C229	CIN#8	a_992_347##8	5.31473e-17
C230	A#10	a_336_347##3	3.85398e-17
C231	VPWR#6	B#7	1.34342e-18
C232	VGND#11	A#8	4.42533e-19
C233	VGND#6	a_336_347##5	6.84499e-20
C234	A#10	B#3	1.75034e-17
C235	A#19	B#8	6.94824e-18
C236	a_336_347##13	VPWR#6	4.53537e-18
C237	a_701_79##2	B#8	3.86973e-17
C238	a_992_347##3	a_992_347#	3.53316e-20
C239	a_992_347##8	a_336_347##2	5.3349e-19
C240	A#22	A#11	3.29304e-18
C241	a_992_347##3	a_992_347##5	9.82231e-18
C242	B#7	A#10	2.68042e-17
C243	a_336_347##11	B#2	9.92461e-20
C244	a_336_347##13	a_683_347#	1.11155e-19
C245	VGND#11	B#8	1.60439e-18
C246	VGND#5	A#13	7.27853e-18
C247	a_992_347##3	a_336_347##4	2.99279e-17
C248	A#21	COUT#2	4.96825e-20
C249	a_701_79##2	CIN#4	3.05774e-17
C250	CIN#2	a_27_79#	1.60859e-18
C251	VGND#5	B#1	1.14238e-17
C252	a_992_347##3	a_336_347##9	2.88357e-17
C253	VPWR#2	a_992_347##4	4.103e-18
C254	CIN#8	B#3	2.65771e-19
C255	a_683_347##2	A#9	5.74103e-20
C256	a_336_347##13	VPWR#12	1.14194e-17
C257	B#4	B#7	2.99829e-19
C258	VGND#5	CIN#7	1.10287e-17
C259	CIN#6	B#7	3.80362e-17
C260	a_992_347##3	A#13	4.29377e-19
C261	a_336_347##6	a_336_347##4	5.29393e-19
C262	VPWR#11	A#9	2.06322e-19
C263	VPWR#2	a_992_347##6	3.02689e-18
C264	A#22	B#2	3.27138e-18
C265	CIN#4	VGND#11	2.46087e-17
C266	A#17	B#10	3.97596e-18
C267	VGND#5	a_336_347#	1.10287e-17
C268	a_992_347##3	B#1	1.97515e-19
C269	a_336_347##6	a_336_347##9	5.47785e-18
C270	COUT#1	a_336_347##5	1.06708e-17
C271	a_701_79##2	A#7	1.12387e-18
C272	a_27_79#	B#6	2.47343e-17
C273	VPWR#2	a_336_347##8	3.3596e-19
C274	VPWR#6	A#5	1.9309e-18
C275	a_336_347##11	a_992_347##8	2.09969e-18
C276	VGND#5	A#8	9.00594e-18
C277	a_27_378#	VPWR#12	2.79378e-18
C278	a_336_347##6	A#13	1.84111e-17
C279	B#6	VGND#12	3.57638e-18
C280	VPWR#2	a_336_347##7	4.57305e-19
C281	A#5	CIN#6	2.51116e-17
C282	a_27_79##2	B#6	2.9532e-17
C283	B#9	B#7	1.26484e-19
C284	VGND#5	B#8	6.44999e-18
C285	a_336_347##6	B#1	7.29912e-18
C286	VGND#11	A#7	4.12014e-17
C287	A#21	B#2	1.37815e-18
C288	CIN#5	a_683_347#	1.49941e-19
C289	A#22	CIN#9	2.4616e-19
C290	a_336_347##6	CIN#7	3.65548e-20
C291	VGND#5	CIN#4	1.20805e-17
C292	a_701_79#	a_992_347##9	3.3488e-17
C293	a_701_79##2	B#10	2.19695e-19
C294	A#23	a_336_347##8	4.65302e-19
C295	a_336_347##6	a_336_347#	2.68467e-20
C296	VGND#5	A#7	8.037e-18
C297	B#1	A#12	1.43496e-17
C298	A#3	a_27_79##2	4.03947e-17
C299	B#9	A#5	5.60429e-17
C300	VGND#5	B#10	1.64745e-17
C301	A#23	a_336_347##7	7.16143e-19
C302	VGND#11	B#10	4.32732e-18
C303	a_336_347##13	a_27_378#	6.78479e-17
C304	VPWR#12	A#6	5.44101e-19
C305	A#22	a_992_347##8	1.06869e-17
C306	VGND#5	CIN#1	1.331e-17
C307	CIN#11	a_484_347#	7.93699e-19
C308	CIN#8	B#1	1.98172e-17
C309	A#23	A#11	4.67327e-19
C310	a_336_347##2	a_336_347##9	3.36844e-20
C311	CIN#6	B#3	1.76528e-17
C312	VGND#5	B#11	1.1894e-17
C313	CIN#3	B#9	1.79322e-17
C314	a_336_347##2	A#13	1.07926e-19
C315	A#23	B#2	3.47598e-18
C316	VGND#11	CIN#1	1.223e-18
C317	VGND#5	A#4	6.51527e-18
C318	a_336_347##2	B#1	9.29513e-20
C319	CIN	B#3	1.04765e-18
C320	A#23	CIN#9	2.40607e-20
C321	B#5	B#9	5.64965e-19
C322	B#10	a_336_347##15	1.71925e-17
C323	a_701_79#	VGND#8	5.17395e-19
C324	a_701_79##2	a_992_347##9	1.18335e-19
C325	a_336_347##2	CIN#7	2.87809e-19
C326	a_336_347##12	CIN#11	2.33915e-18
C327	a_336_347##13	CIN#2	9.12907e-17
C328	VGND#12	A#7	1.37064e-19
C329	a_336_347##2	a_336_347#	9.00799e-19
C330	B#5	CIN#3	5.23402e-17
C331	A#19	CIN#9	4.05144e-20
C332	a_27_378#	VPWR#13	3.07717e-17
C333	A#9	B#3	3.28598e-19
C334	a_27_79#	B#10	9.92263e-19
C335	a_336_347##2	A#8	3.71237e-19
C336	VGND#11	B#11	6.05186e-19
C337	VPWR#5	A#11	5.37905e-18
C338	VGND#1	VPWR#1	1.01023e-17
C339	A#19	a_336_347##3	1.66597e-18
C340	A#5	B#4	1.63022e-17
C341	CIN#1	a_336_347##15	4.98623e-18
C342	a_336_347##2	B#8	3.37577e-19
C343	a_992_347##3	a_992_347##4	4.31928e-18
C344	a_701_79##2	a_701_79#	4.63497e-18
C345	B#6	a_336_347##13	1.06825e-17
C346	VPWR#5	B#2	4.35907e-18
C347	A#19	A#10	3.68624e-18
C348	a_27_378##2	a_27_378#	4.48983e-18
C349	VGND#12	B#10	2.90776e-19
C350	a_336_347##2	CIN#4	5.92763e-20
C351	A#1	B#5	2.4543e-17
C352	VPWR#6	B#5	4.04535e-19
C353	B#6	a_27_378#	3.51392e-18
C354	a_992_347##3	a_992_347##6	1.09746e-17
C355	a_336_347##11	CIN#11	2.26441e-18
C356	a_336_347##11	a_1119_79#	3.08194e-18
C357	VPWR#5	CIN#9	4.94023e-18
C358	B#6	VPWR#13	3.4684e-18
C359	a_336_347##2	A#7	4.24898e-20
C360	A#19	B#7	6.39049e-18
C361	a_27_79#	CIN#1	4.19027e-17
C362	B#8	A#9	1.81944e-17
C363	a_992_347##3	a_336_347##8	3.19821e-17
C364	VPWR#5	a_336_347##3	4.94023e-18
C365	a_336_347##13	A#3	2.43802e-19
C366	A#19	CIN#6	4.45057e-19
C367	a_27_378##2	VPWR#13	4.63576e-17
C368	a_992_347##3	a_336_347##7	1.24778e-17
C369	a_701_79##2	VGND#8	7.18509e-19
C370	a_992_347##8	a_1202_368#	5.73283e-18
C371	VPWR#5	A#10	3.97963e-18
C372	VGND#12	CIN#1	7.81453e-19
C373	a_336_347##6	a_336_347##8	3.14649e-18
C374	CIN#5	B#8	2.08823e-17
C375	a_992_347##3	A#11	2.3394e-19
C376	A#17	CIN#6	1.77885e-18
C377	a_27_79#	B#11	5.94099e-17
C378	a_27_378##2	A#3	3.7427e-18
C379	CIN#5	B#3	1.93883e-19
C380	a_992_347##3	B#2	1.5301e-19
C381	A#17	A#5	3.36874e-18
C382	a_27_79##2	CIN#1	1.78813e-19
C383	a_336_347##12	B#4	3.08619e-19
C384	CIN#11	A#10	3.68304e-19
C385	VPWR#5	CIN#6	7.8528e-18
C386	a_992_347##8	a_1094_347#	4.37546e-18
C387	A#12	a_336_347##7	1.34046e-18
C388	B#11	VGND#12	1.9865e-17
C389	A#17	B#9	7.72408e-18
C390	VPWR#5	A#5	1.69996e-18
C391	a_27_79#	A#4	1.75272e-18
C392	a_992_347##9	a_1205_79#	1.64038e-18
C393	A#17	CIN#3	1.29853e-18
C394	CIN#8	a_336_347##7	3.00457e-19
C395	a_27_79##2	B#11	1.93185e-18
C396	B#10	A#6	1.35192e-17
C397	B#2	A#12	1.51015e-17
C398	a_336_347##12	a_336_347##13	1.1423e-18
C399	SUM	a_992_347##2	4.51247e-18
C400	A#17	B#5	6.92074e-20
C401	CIN#8	A#11	6.65893e-19
C402	VPWR#5	CIN#3	5.15311e-18
C403	VGND#11	a_701_79##2	3.33884e-17
C404	CIN#11	B#7	1.23468e-17
C405	A#4	VGND#12	2.27222e-17
C406	VPWR#6	VPWR#4	1.57007e-18
C407	a_336_347##12	B#3	2.56576e-20
C408	CIN#8	B#2	1.81907e-17
C409	VPWR#5	B#5	8.10373e-19
C410	CIN#2	B#10	1.64175e-17
C411	A#6	B#4	4.26659e-19
C412	a_992_347##9	a_1119_79#	1.77549e-18
C413	CIN#8	CIN#9	1.02791e-17
C414	a_27_79##2	A#4	5.37952e-17
C415	VGND#3	VGND#6	4.99168e-18
C416	VPWR#5	A#1	6.04086e-18
C417	a_683_347##2	B#3	6.95975e-18
C418	a_336_347##2	B#2	4.04735e-19
C419	a_336_347##12	a_487_79#	2.99053e-18
C420	CIN#8	a_336_347##3	1.60994e-17
C421	a_992_347##5	a_992_347#	3.81972e-17
C422	CIN#3	B#4	8.61431e-18
C423	CIN#11	CIN#6	1.67599e-17
C424	CIN#8	A#10	1.03353e-19
C425	CIN#8	B#7	4.19356e-21
C426	A#4	B#6	7.97732e-19
C427	VPWR#11	B#4	2.0357e-19
C428	VPWR#2	VPWR#3	3.47597e-17
C429	a_336_347##11	B#3	1.83134e-19
C430	A#23	VPWR#5	2.52934e-17
C431	VGND#3	a_992_347##5	5.93985e-19
C432	CIN#11	A#5	2.08841e-17
C433	a_336_347##4	a_992_347##5	1.39331e-17
C434	B#7	A#9	7.24016e-18
C435	A#19	VPWR#5	3.35296e-17
C436	CIN#2	B#4	2.72695e-18
C437	COUT#1	COUT#2	3.54087e-18
C438	CIN#11	a_683_347#	3.92436e-17
C439	CIN#5	A#10	1.90916e-19
C440	VPWR#2	a_992_347##3	1.90848e-17
C441	VPWR#11	B#3	1.12729e-18
C442	A#17	VPWR#5	3.68538e-17
C443	CIN#5	B#7	1.09554e-17
C444	VGND#5	A#23	2.32652e-17
C445	VGND#2	a_992_347##3	2.71298e-17
C446	VPWR#1	a_992_347##4	3.25163e-17
C447	B#5	B#4	1.53953e-18
C448	VPWR#2	a_336_347##6	4.57203e-18
C449	VGND#3	VGND#7	1.03227e-17
C450	CIN#5	CIN#6	1.99448e-18
C451	VGND#5	A#19	3.40702e-17
C452	A#23	a_992_347##3	1.94203e-18
C453	CIN#11	B#9	2.49786e-19
C454	VGND#2	a_336_347##6	7.01633e-18
C455	VGND#3	a_336_347##4	2.53189e-18
C456	CIN#5	A#5	4.83311e-19
C457	CIN	VPWR#4	1.06837e-19
C458	VGND#5	A#17	3.89372e-17
C459	SUM#1	a_992_347##4	3.67592e-17
C460	A#23	a_336_347##6	1.59843e-17
C461	CIN#11	VPWR#12	5.01209e-17
C462	a_336_347##9	a_336_347##4	3.9419e-17
C463	VPWR#1	a_992_347##6	1.23062e-18
C464	A#23	A#12	4.3378e-19
C465	CIN#2	CIN#6	3.08255e-19
C466	VPWR#9	a_992_347##4	3.53056e-18
C467	B#9	A#6	1.19176e-17
C468	A#23	VPWR#4	2.83716e-19
C469	CIN#2	A#5	9.54668e-19
C470	A#23	CIN#8	4.74337e-17
C471	CIN#11	CIN#3	1.54172e-19
C472	SUM#1	a_992_347##6	3.51293e-17
C473	a_336_347##11	CIN	3.42289e-18
C474	A#13	a_1205_79#	1.27965e-17
C475	CIN#2	B#9	5.03373e-17
C476	A#23	VPWR#3	6.20422e-18
C477	VGND#3	a_336_347##9	1.47024e-17
C478	A#11	a_1202_368#	2.30401e-17
C479	A#19	CIN#8	9.56136e-18
C480	B#1	a_1205_79#	1.27965e-17
C481	VPWR#1	a_336_347##8	2.1339e-19
C482	a_683_347#	B#3	4.84874e-18
C483	CIN#2	CIN#3	1.97894e-18
C484	VGND#2	VGND#3	4.66306e-17
C485	B#2	a_1202_368#	2.30401e-17
C486	a_992_347##6	VPWR#9	2.51342e-17
C487	A#19	a_336_347##2	1.76726e-17
C488	VGND#4	A#13	2.83766e-19
C489	CIN#11	CIN	3.38534e-18
C490	A#13	a_336_347##9	1.20709e-17
C491	VGND#5	a_336_347##6	4.32286e-18
C492	B#6	CIN#3	2.15139e-18
C493	VPWR#5	CIN#8	5.15827e-18
C494	SUM#1	a_336_347##8	1.06666e-18
C495	B#1	a_1119_79#	1.45056e-17
C496	B#2	a_1094_347#	2.18312e-17
C497	A#19	A#9	1.48233e-17
C498	A#19	VPWR#4	4.63488e-18
C499	B#6	B#5	1.33156e-18
C500	a_336_347##6	a_992_347##3	5.95186e-18
C501	COUT#2	a_992_347##6	3.12079e-18
C502	CIN#7	a_1119_79#	1.45056e-17
C503	CIN#9	a_1094_347#	2.13534e-17
C504	VPWR#5	a_336_347##2	2.3915e-18
C505	A#23	VGND#4	4.43065e-19
C506	VGND#4	a_992_347##9	1.7806e-17
C507	A#19	CIN#5	4.51121e-17
C508	VGND#3	A#13	1.27782e-17
C509	VPWR#9	a_336_347##8	5.06612e-17
C510	VGND#5	CIN#8	1.46846e-18
C511	A#3	B#5	2.5687e-18
C512	VPWR#5	A#9	6.19466e-20
C513	A#17	CIN#5	3.50972e-17
C514	VPWR#10	a_992_347##6	2.99843e-19
C515	A#23	VGND#3	5.0915e-18
C516	A#12	a_336_347##6	3.62301e-17
C517	SUM#1	a_336_347##7	3.20545e-19
C518	VGND#5	a_336_347##2	1.92436e-20
C519	VPWR#5	CIN#5	1.10004e-18
C520	VGND#4	B#1	4.15393e-19
C521	A#17	VPWR#6	5.62512e-18
C522	COUT#2	a_336_347##8	5.37104e-17
C523	A#17	A#6	1.86823e-17
C524	CIN#8	a_336_347##6	3.41661e-18
C525	VGND#5	A#9	6.45704e-19
C526	B#1	A#13	5.15056e-17
C527	VPWR#9	a_336_347##7	2.77473e-18
C528	CIN#8	A#12	1.68607e-18
C529	VGND#3	a_992_347##9	7.39756e-17
C530	a_336_347##2	a_336_347##6	1.05767e-18
C531	A#17	CIN#2	7.16676e-17
C532	VGND#5	CIN#5	3.45785e-18
C533	VPWR#10	a_336_347##8	4.82481e-18
C534	A#19	VGND#4	5.66091e-18
C535	VGND#4	a_701_79#	3.37117e-17
C536	VPWR#5	CIN#2	7.52881e-18
C537	VGND#3	B#1	8.85744e-18
C538	SUM#1	A#11	2.20834e-19
C539	a_336_347##2	A#12	2.37437e-20
C540	COUT#2	a_336_347##7	4.68086e-17
C541	a_336_347##2	CIN#8	8.78279e-17
C542	VPWR#5	B#6	1.80346e-18
C543	a_27_79#	VGND#12	3.56954e-17
C544	B#3	VGND#8	5.19325e-19
C545	A#5	a_484_347#	2.27533e-17
C546	VGND#5	CIN#2	4.12451e-18
C547	VGND#4	CIN#7	8.9583e-19
C548	CIN#8	A#9	1.42111e-20
C549	VPWR#5	VPWR#6	1.09485e-16
C550	B#9	a_484_347#	2.23478e-17
C551	VPWR#10	a_336_347##7	5.03302e-17
C552	VGND#5	B#6	4.67019e-18
C553	SUM#3	SUM	2.99476e-18
C554	CIN#7	B#1	3.97161e-17
C555	A#9	a_336_347##2	5.74107e-17
C556	CIN	a_992_347##8	3.97659e-18
C557	VPWR#5	VPWR#4	1.26791e-16
C558	COUT#2	A#11	2.90085e-18
C559	CIN	a_683_347##2	4.33436e-17
C560	A#7	a_487_79#	1.6159e-17
C561	CIN	VPWR#11	3.20579e-18
C562	VGND#5	A#3	3.34442e-18
C563	a_336_347##2	CIN#5	3.55345e-19
C564	VGND#4	VGND#8	6.71785e-18
C565	B#10	a_487_79#	1.6159e-17
C566	VGND#3	CIN#7	5.89888e-18
C567	CIN	a_683_347#	2.19161e-17
C568	a_27_79##2	a_27_79#	2.94634e-18
C569	VPWR#5	VPWR#3	8.18879e-17
C570	A#23	a_336_347##11	7.87934e-18
C571	VPWR#9	B#2	4.07545e-20
C572	CIN#5	A#9	1.3711e-18
C573	a_336_347##2	A#6	2.344e-19
C574	a_992_347##8	a_336_347##8	5.13136e-19
C575	A#11	VPWR#10	3.35677e-17
C576	a_336_347##11	a_336_347##9	1.04115e-20
C577	VGND#4	a_336_347#	9.27936e-18
C578	COUT#2	B#2	1.32255e-18
C579	A#6	CIN#5	2.48344e-17
C580	a_992_347##3	a_1202_368#	6.13297e-21
C581	SUM	VPWR#1	6.31056e-17
C582	A#23	A#22	1.51227e-17
C583	A#19	a_336_347##12	1.27669e-18
C584	SUM	SUM#1	4.90344e-19
C585	a_27_79##2	VGND#12	5.78386e-17
C586	a_336_347#	CIN#7	2.85949e-17
C587	VPWR#9	SUM	4.78744e-17
C588	A#17	a_484_347#	7.44765e-19
C589	B	a_336_347##13	8.79143e-18
C590	a_992_347##8	a_336_347##7	1.41796e-17
C591	VPWR#10	SUM	8.37696e-19
C592	B	a_27_378#	1.04941e-17
C593	VPWR#10	B#2	5.4203e-18
C594	VGND#4	a_701_79##2	2.99623e-17
C595	VGND#3	a_336_347#	5.7657e-19
C596	B	VPWR#13	1.50534e-17
C597	CIN#2	A#6	2.11213e-18
C598	a_336_347##11	A#19	4.0899e-17
C599	a_27_378##2	B	3.79778e-17
C600	COUT#2	CIN#9	8.69277e-19
C601	A#23	A#21	1.09173e-17
C602	a_336_347##11	A#13	1.22316e-20
C603	CIN#8	a_1094_347#	1.16268e-18
C604	B#6	CIN#2	2.0985e-17
C605	a_992_347##2	VNB	3.15531e-17
C606	a_336_347##13	B#4	8.03741e-18
C607	a_336_347##5	VNB	1.96941e-17
C608	VGND#4	A#8	1.013e-17
C609	B#4	VNB	7.90062e-17
C610	B#3	VNB	9.09365e-17
C611	a_992_347##8	A#11	2.65093e-17
C612	VPWR#10	CIN#9	1.23019e-18
C613	VGND#2	a_992_347##2	9.8284e-20
C614	a_336_347##12	A#17	7.1724e-17
C615	A#3	B#6	5.6759e-17
C616	A#8	a_336_347#	2.08412e-17
C617	COUT#2	a_336_347##3	4.17041e-19
C618	a_992_347##3	a_1205_79#	7.15992e-21
C619	VGND#2	a_336_347##5	1.25555e-18
C620	VGND#3	A#8	4.28918e-19
C621	VGND#11	VGND#4	3.74376e-18
C622	a_336_347##6	a_1205_79#	2.94486e-18
C623	CIN	A#11	3.65188e-19
C624	a_992_347##8	B#2	5.01569e-17
C625	CIN	B#2	5.09917e-19
C626	a_336_347##11	B#1	1.42667e-17
C627	CIN	CIN#9	1.61099e-18
C628	VPWR#10	a_336_347##3	4.77164e-19
C629	VPWR#11	A#11	5.55831e-19
C630	CIN	a_336_347##3	1.41438e-17
C631	VGND#4	B#8	9.30995e-18
C632	CIN	A#10	3.07867e-17
C633	CIN	B#7	1.44319e-17
C634	CIN#2	a_484_347#	2.59314e-18
C635	CIN	CIN#6	1.82523e-19
C636	SUM	a_992_347##4	2.47307e-17
C637	SUM	a_992_347##6	2.04531e-17
C638	a_992_347##8	CIN#9	6.25807e-17
C639	B#8	A#8	1.90238e-17
C640	SUM	a_336_347##8	8.19682e-19
C641	VGND#5	VGND#4	1.08844e-16
C642	SUM	a_336_347##7	1.34613e-19
C643	SUM	A#11	9.10655e-21
C644	VPWR#10	A#10	4.41956e-19
C645	VPWR#11	B#2	7.07406e-19
C646	CIN#11	A#19	7.29642e-18
C647	B	B#9	2.0069e-19
C648	a_992_347##3	VPWR#3	2.69469e-18
C649	VGND#5	VGND#3	8.41558e-17
C650	B	CIN#3	8.36307e-19
C651	a_336_347##11	CIN#7	1.29382e-17
C652	VGND#2	VGND#1	5.41256e-17
C653	a_683_347##2	CIN#9	9.54099e-19
C654	VPWR#6	VNB	3.27326e-17
C655	B	B#5	5.96719e-18
C656	VPWR#4	VNB	4.3489e-17
C657	VPWR#3	VNB	5.50406e-17
C658	B	A#1	1.24314e-17
C659	VGND#4	VNB	5.51223e-17
C660	A#19	CIN	5.33009e-17
C661	VGND#3	VNB	6.2584e-17
C662	VGND#4	CIN#4	1.47571e-18
C663	VPWR#5	A#22	2.55901e-18
C664	a_336_347##3	a_992_347##8	2.28003e-17
C665	a_336_347##12	VNB	4.86401e-18
C666	a_336_347##11	a_992_347##9	7.86355e-17
C667	VPWR#5	CIN	3.90353e-18
C668	VGND#2	SUM#3	1.99441e-17
C669	a_336_347##11	VNB	1.50209e-19
C670	A#22	VNB	2.2373e-18
C671	SUM#1	VPWR#1	4.11982e-17
C672	A#21	VNB	1.63257e-18
C673	VPWR#11	CIN#9	9.59803e-19
C674	VGND#5	CIN	8.44731e-19
C675	VPWR#2	SUM	2.15108e-17
C676	VPWR#5	B	2.81414e-18
C677	VGND#1	VNB	6.94775e-17
C678	VGND#2	VGND#6	9.62616e-17
C679	VGND#2	SUM	8.88323e-19
C680	SUM#3	VNB	1.00561e-17
C681	VGND#6	VNB	4.45833e-17
C682	CIN#4	B#8	3.74144e-17
C683	COUT#1	VNB	4.29962e-20
C684	a_683_347##2	a_336_347##3	3.38561e-17
C685	a_992_347##9	VNB	2.94491e-18
C686	A#17	CIN#11	3.65621e-17
C687	a_701_79##2	VNB	2.16977e-18
C688	a_336_347##2	CIN	1.19053e-17
C689	VGND#11	VNB	3.09225e-18
C690	A#9	CIN	2.19472e-17
C691	VPWR#3	a_336_347##6	1.15716e-19
C692	a_336_347##11	a_336_347#	1.2911e-17
C693	VGND#2	COUT#1	5.87215e-18
C694	VGND#3	a_992_347##3	5.518e-18
C695	a_992_347##8	A#10	1.84348e-18
C696	VGND#12	VNB	3.96028e-18
C697	a_27_79##2	VNB	3.79507e-17
C698	VPWR#1	VNB	8.00529e-17
C699	VPWR#9	VNB	4.51802e-17
C700	a_992_347##3	SUM	5.41734e-17
C701	COUT#2	VNB	1.06373e-18
C702	VPWR#11	a_336_347##3	1.48773e-18
C703	VPWR#10	VNB	4.82431e-18
C704	VPWR#9	VPWR#1	2.14093e-18
C705	a_992_347##8	VNB	6.99936e-19
C706	a_683_347##2	VNB	4.80612e-19
C707	VPWR#11	VNB	2.00741e-18
C708	VGND#4	A#7	3.45785e-19
C709	A#21	B#1	2.97815e-18
C710	a_683_347#	VNB	3.57291e-20
C711	a_336_347##11	a_701_79#	7.35019e-17
C712	VPWR#12	VNB	2.35547e-18
C713	VGND#5	a_336_347##12	5.60736e-17
C714	a_336_347##13	VNB	7.02365e-19
C715	a_27_378#	VNB	1.17165e-18
C716	a_683_347##2	A#10	4.81339e-17
C717	VPWR#13	VNB	7.0882e-18
C718	a_336_347##12	A#8	2.8747e-19
C719	a_27_378##2	VNB	4.69141e-17
C720	a_992_347#	VNB	3.54514e-17
C721	a_992_347##5	VNB	3.09156e-17
C722	a_336_347##4	VNB	3.07555e-17
C723	CIN	a_1202_368#	1.99643e-19
C724	a_336_347##9	VNB	3.04817e-17
C725	VPWR#13	B#4	7.26612e-19
C726	A#13	VNB	3.09568e-17
C727	B	A#3	2.28963e-19
C728	B#1	VNB	4.13851e-17
C729	CIN#7	VNB	2.95064e-17
C730	a_336_347#	VNB	3.03455e-17
C731	VGND#5	a_336_347##11	1.77668e-17
C732	A#8	VNB	2.93463e-17
C733	B#8	VNB	4.26287e-17
C734	a_992_347##8	B#7	6.49308e-19
C735	CIN#4	VNB	2.85754e-17
C736	A#7	VNB	2.37522e-17
C737	CIN#11	VPWR#5	9.88298e-18
C738	B#10	VNB	3.76145e-17
C739	A#7	CIN#4	1.43622e-17
C740	CIN#1	VNB	3.14051e-17
C741	B#11	VNB	3.17598e-17
C742	A#10	VPWR#11	2.6879e-17
C743	A#4	VNB	3.76889e-17
C744	a_992_347##4	VNB	4.82123e-17
C745	a_992_347##6	VNB	3.31092e-17
C746	a_336_347##8	VNB	3.7237e-17
C747	a_336_347##7	VNB	3.60434e-17
C748	a_336_347##11	A#8	1.862e-17
C749	A#11	VNB	2.93592e-17
C750	B#2	VNB	9.6968e-17
C751	VGND#1	a_992_347#	2.65418e-17
C752	CIN#9	VNB	2.40048e-17
C753	VGND#3	a_336_347##6	6.26695e-19
C754	a_336_347##3	VNB	2.47558e-17
C755	A#10	VNB	2.74353e-17
C756	a_683_347##2	B#7	7.74809e-19
C757	B#7	VNB	3.46248e-17
C758	CIN#6	VNB	2.58262e-17
C759	A#5	VNB	2.09785e-17
C760	B#9	VNB	3.76524e-17
C761	CIN#3	VNB	2.69013e-17
C762	B#5	VNB	7.11478e-17
C763	a_683_347#	A#10	4.89692e-19
C764	A#1	VNB	4.96485e-17
C765	VPWR#2	VNB	1.289e-16
C766	a_336_347##11	VGND#8	2.33511e-18
C767	VGND#2	a_992_347##9	3.05716e-18
C768	VGND#2	VNB	1.3475e-16
C769	A#23	VNB	3.01016e-18
C770	A#19	VNB	6.13123e-18
C771	a_992_347##8	CIN#6	3.08939e-19
C772	A#17	VNB	2.91032e-18
C773	CIN#11	B#4	1.32745e-18
C774	VPWR#5	VNB	2.77633e-16
C775	a_336_347##12	B#8	2.7181e-19
C776	VGND#5	VNB	3.25593e-16
C777	a_336_347##12	a_701_79##2	1.12268e-17
C778	a_992_347##3	VNB	3.68046e-17
C779	VPWR#11	B#7	3.4753e-17
C780	a_336_347##6	VNB	3.76661e-17
C781	A#12	VNB	2.50337e-17
C782	CIN#8	VNB	2.93225e-17
C783	a_336_347##2	VNB	2.60107e-17
C784	A#9	VNB	2.57871e-17
C785	SUM#3	a_992_347#	3.97716e-17
C786	CIN#5	VNB	2.29529e-17
C787	A#6	VNB	2.34516e-17
C788	CIN#2	VNB	3.30337e-17
C789	B#6	VNB	3.36333e-17
C790	A#3	VNB	6.13535e-17
C791	A#19	B#3	5.0991e-19
C792	B#4	B#3	1.02104e-19
C793	VGND#5	A#21	1.80239e-18
C794	a_683_347##2	CIN#6	1.80086e-19
C795	VPWR#6	B#4	4.41303e-17
C796	B#10	A#7	4.85675e-17
C797	CIN#8	VPWR#4	6.03732e-19
C798	VGND#1	a_992_347##5	1.47934e-18
C799	a_683_347#	B#7	3.28028e-17
C800	a_336_347##11	B#8	2.30349e-17
C801	CIN	VNB	3.02025e-19
C802	VGND#3	A#12	5.83885e-19
C803	B	VNB	2.36673e-18
C804	SUM	VNB	1.00737e-17
C805	VPWR#3	CIN#8	2.68344e-19
C806	A#23	a_992_347##9	7.04898e-18
C807	VPWR#11	CIN#6	1.8587e-18
C808	VGND#6	a_992_347#	4.01858e-18
C809	a_336_347##11	a_701_79##2	5.52308e-17
C810	VPWR#12	B#7	1.3083e-18
C811	VPWR#5	VPWR#7	1.42527e-16
C812	VPWR#5	A	2.45506e-17
C813	VPWR#7	VNB	6.75191e-17
C814	a_27_378##2	VPWR#7	1.77468e-17
C815	VGND#9	a_336_347##12	1.73731e-19
C816	VGND#9	CIN#1	3.04317e-18
C817	a_336_347##13	VPWR#7	3.3089e-18
C818	VGND#9	CIN#2	2.13385e-19
C819	A	B#5	1.54999e-18
C820	VPWR#7	CIN#3	2.85737e-18
C821	VGND#9	A#7	1.216e-19
C822	A	B	3.31298e-18
C823	VPWR#7	A#3	2.35901e-19
C824	A	A#3	1.90543e-17
C825	A	VPWR#7	3.46335e-18
C826	A	B#6	4.55323e-17
C827	a_27_378#	VPWR#7	8.8226e-18
C828	A	VNB	2.73909e-17
C829	VPWR#7	B#5	1.99943e-17
C830	A	a_27_378##2	4.23992e-17
C831	VGND#9	B#6	2.0499e-19
C832	VGND#9	B#11	7.69868e-18
C833	A	VPWR#13	4.07047e-18
C834	A#17	VGND#9	1.66197e-18
C835	VPWR#7	CIN#2	2.17281e-19
C836	VGND#9	B#10	2.11298e-19
C837	VGND#9	VNB	7.06841e-17
C838	A	a_27_378#	1.22311e-17
C839	A#17	VPWR#7	2.12767e-18
C840	A	a_27_79##2	1.26752e-17
C841	A	VGND#9	4.77845e-18
C842	VGND#5	A	2.32675e-17
C843	VPWR#7	A#1	2.33525e-18
C844	A	a_336_347##13	1.06917e-17
C845	VGND#9	a_27_79##2	1.92328e-17
C846	A	VGND#12	3.10687e-18
C847	VGND#9	a_27_79#	2.88614e-17
C848	VPWR#7	B#4	8.17629e-18
C849	VGND#5	VGND#9	1.28355e-16
C850	A	A#1	8.78737e-19
C851	A	a_27_79#	7.35674e-18
C852	VGND#9	A#3	8.43229e-19
C853	VGND#9	A#4	5.47779e-18
*
*
.ENDS sky130_fd_sc_hs__fa_2
*
