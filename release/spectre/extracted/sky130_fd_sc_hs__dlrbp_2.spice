* Extracted by Quantus, converted by sky130cad/quantus.py
*
*
*
*                       LINUX           Wed Nov 18 08:31:26 2026
*
*
*
*  PROGRAM  advgen
*
*  Name           : advgen - Quantus - (64-bit)
*  Version        : 25.1.0-p047
*  Build Date     : Thu Dec 11 23:20:30 PST 2025
*
*  HSPICE LIBRARY
*
*  OPERATING_TEMPERATURE 150
*  QRC_TECH_DIR <path>/tech
*
*
*

*
.SUBCKT sky130_fd_sc_hs__dlrbp_2 VPB VNB VGND VPWR Q Q_N GATE RESET_B D
*
*
*  caps2d version: 10
*
*
*       TRANSISTOR CARDS
*
*
XM20 a_27_112##7 D#3 VGND#15 VNB sky130_fd_pr__nfet_01v8_lvt l=0.15 w=0.55 ad=0.15675 as=0.30395 pd=1.67 ps=2.34
XM21 VGND#15 GATE#3 a_230_74##10 VNB sky130_fd_pr__nfet_01v8_lvt l=0.15 w=0.74 ad=0.30395 as=0.2109 pd=2.34 ps=2.05
XM13 a_363_82##8 a_230_74##4 VGND#14 VNB sky130_fd_pr__nfet_01v8_lvt l=0.15 w=0.74 ad=0.2109 as=0.37645 pd=2.05 ps=2.83
XM15 VGND#14 a_27_112# a_569_80# VNB sky130_fd_pr__nfet_01v8_lvt l=0.15 w=0.64 ad=0.37645 as=0.1344 pd=2.83 ps=1.7
XM2 a_569_80# a_363_82##2 a_641_80##8 VNB sky130_fd_pr__nfet_01v8_lvt l=0.15 w=0.64 ad=0.1344 as=0.2692 pd=1.7 ps=2.3
XM8 a_641_80##8 a_230_74##6 a_773_124# VNB sky130_fd_pr__nfet_01v8_lvt l=0.15 w=0.42 ad=0.2692 as=0.1008 pd=2.3 ps=1.32
XM25 a_773_124# a_821_98##2 VGND#13 VNB sky130_fd_pr__nfet_01v8_lvt l=0.15 w=0.42 ad=0.1008 as=0.1197 pd=1.32 ps=1.41
XM5 a_821_98##19 a_641_80# a_1049_74# VNB sky130_fd_pr__nfet_01v8_lvt l=0.15 w=0.74 ad=0.2109 as=0.1776 pd=2.05 ps=1.96
XM23 a_1049_74# RESET_B#3 VGND#12 VNB sky130_fd_pr__nfet_01v8_lvt l=0.15 w=0.74 ad=0.1776 as=0.2886 pd=1.96 ps=2.26
XM3 Q#2 a_821_98##9 VGND#12 VNB sky130_fd_pr__nfet_01v8_lvt l=0.15 w=0.74 ad=0.2072 as=0.2886 pd=2.04 ps=2.26
XM6 VGND#11 a_821_98##11 Q#2 VNB sky130_fd_pr__nfet_01v8_lvt l=0.15 w=0.74 ad=0.2627 as=0.2072 pd=2.19 ps=2.04
XM19 a_1449_368##10 a_821_98##4 VGND#10 VNB sky130_fd_pr__nfet_01v8_lvt l=0.15 w=0.64 ad=0.1824 as=0.2938 pd=1.85 ps=2.32
XM16 VGND#10 a_1449_368##5 Q_N#2 VNB sky130_fd_pr__nfet_01v8_lvt l=0.15 w=0.74 ad=0.2938 as=0.2072 pd=2.32 ps=2.04
XM22 Q_N#2 a_1449_368# VGND#1 VNB sky130_fd_pr__nfet_01v8_lvt l=0.15 w=0.74 ad=0.2072 as=0.2109 pd=2.04 ps=2.05
XM11 a_27_112##5 D#1 VPWR#15 VPB sky130_fd_pr__pfet_01v8 l=0.15 w=0.84 ad=0.2478 as=0.4557 pd=2.27 ps=3.04
XM9 VPWR#15 GATE#1 a_230_74##12 VPB sky130_fd_pr__pfet_01v8 l=0.15 w=0.84 ad=0.4557 as=0.2898 pd=3.04 ps=2.37
XM27 a_363_82##9 a_230_74# VPWR#14 VPB sky130_fd_pr__pfet_01v8 l=0.15 w=0.84 ad=0.2478 as=0.4056 pd=2.27 ps=2.84
XM4 VPWR#14 a_27_112##3 a_566_392# VPB sky130_fd_pr__pfet_01v8 l=0.15 w=1 ad=0.4056 as=0.27 pd=2.84 ps=2.54
XM24 a_566_392# a_230_74##5 a_641_80##7 VPB sky130_fd_pr__pfet_01v8 l=0.15 w=1 ad=0.27 as=0.3328 pd=2.54 ps=2.77
XM10 a_641_80##7 a_363_82##3 a_757_508# VPB sky130_fd_pr__pfet_01v8 l=0.15 w=0.42 ad=0.3328 as=0.2121 pd=2.77 ps=1.85
XM12 a_757_508# a_821_98##3 VPWR#13 VPB sky130_fd_pr__pfet_01v8 l=0.15 w=0.42 ad=0.2121 as=0.4417 pd=1.85 ps=3.46
XM7 VPWR#13 a_641_80##4 a_821_98##16 VPB sky130_fd_pr__pfet_01v8 l=0.15 w=1.12 ad=0.4417 as=0.392 pd=3.46 ps=2.94
XM14 a_821_98##16 RESET_B#1 VPWR#12 VPB sky130_fd_pr__pfet_01v8 l=0.15 w=1.12 ad=0.392 as=0.4256 pd=2.94 ps=3
XM17 VPWR#12 a_821_98##13 Q#1 VPB sky130_fd_pr__pfet_01v8 l=0.15 w=1.12 ad=0.4256 as=0.336 pd=3 ps=2.84
XM0 Q#1 a_821_98##12 VPWR#11 VPB sky130_fd_pr__pfet_01v8 l=0.15 w=1.12 ad=0.336 as=0.3304 pd=2.84 ps=2.83
XM1 a_1449_368##9 a_821_98##10 VPWR#10 VPB sky130_fd_pr__pfet_01v8 l=0.15 w=1 ad=0.295 as=0.4318 pd=2.59 ps=3.04
XM26 VPWR#10 a_1449_368##6 Q_N#1 VPB sky130_fd_pr__pfet_01v8 l=0.15 w=1.12 ad=0.4318 as=0.336 pd=3.04 ps=2.84
XM18 Q_N#1 a_1449_368##4 VPWR#1 VPB sky130_fd_pr__pfet_01v8 l=0.15 w=1.12 ad=0.336 as=0.3304 pd=2.84 ps=2.83
*
*
*       RESISTOR AND CAP/DIODE CARDS
*
Rg1	D#1	D#2	362.037811
Rg2	D#2	D#3	384.265259
Rg3	GATE#1	GATE#2	472.100342
Rg4	GATE#2	GATE#3	320.356293
Rg5	a_230_74#	a_230_74##2	478.659607
Rg6	a_230_74##2	a_230_74##3	335.111847
Rg7	a_230_74##2	a_230_74##4	330.282410
Rg8	a_27_112#	a_27_112##2	459.674774
Rg9	a_27_112##2	a_27_112##3	397.001862
Rg10	a_363_82#	a_363_82##2	439.477417
Rg11	a_230_74##5	a_230_74##6	1166.219849
Rg12	a_230_74##6	a_230_74##7	216.119781
Rg13	a_363_82##3	a_363_82##4	226.096359
Rg14	a_821_98#	a_821_98##2	667.283508
Rg15	a_821_98#	a_821_98##3	260.436676
Rg16	a_641_80#	a_641_80##2	397.590515
Rg17	a_641_80##2	a_641_80##3	68.007858
Rg18	a_641_80##2	a_641_80##4	449.490784
Rg19	RESET_B#1	RESET_B#2	500.238068
Rg20	RESET_B#2	RESET_B#3	320.356293
Rg21	a_821_98##4	a_821_98##5	340.169525
Rg22	a_821_98##5	a_821_98##6	176.618256
Rg23	a_821_98##6	a_821_98##7	43.647682
Rg24	a_821_98##7	a_821_98##8	22.738758
Rg25	a_821_98##8	a_821_98##9	365.539856
Rg26	a_821_98##5	a_821_98##10	437.431122
Rg27	a_821_98##6	a_821_98##11	384.320526
Rg28	a_821_98##6	a_821_98##12	474.928162
Rg29	a_821_98##8	a_821_98##13	471.875854
Rg30	a_1449_368#	a_1449_368##2	368.862610
Rg31	a_1449_368##2	a_1449_368##3	81.843414
Rg32	a_1449_368##2	a_1449_368##4	471.862823
Rg33	a_1449_368##3	a_1449_368##5	347.966095
Rg34	a_1449_368##3	a_1449_368##6	450.541138
Rf1	D#2	D#5	161.093033
Rf2	D#6	D	0.860229
Rf3	D#5	D#6	5.117745
Rf4	GATE#4	GATE	1.235440
Rf5	GATE#2	GATE#6	161.468246
Rf6	GATE#4	GATE#6	3.759755
Rf7	a_27_112##2	a_27_112##6	349.571045
Rf8	a_27_112##6	a_27_112##7	105.567162
Rf9	a_27_112##5	a_27_112##6	7.500000
Rf10	a_230_74##7	a_230_74##9	311.372864
Rf11	a_230_74##9	a_230_74##10	13.073523
Rf12	a_230_74##9	a_230_74##3	35.271755
Rf13	a_230_74##3	a_230_74##12	47.721573
Rf14	a_363_82##4	a_363_82#	358.359924
Rf15	a_363_82#	a_363_82##7	72.221634
Rf16	a_363_82##7	a_363_82##8	24.208523
Rf17	a_363_82##7	a_363_82##9	79.304680
Rf18	a_641_80##3	a_641_80##6	243.537354
Rf19	a_641_80##6	a_641_80##7	65.657898
Rf20	a_641_80##6	a_641_80##8	82.177826
Rf21	RESET_B	RESET_B#4	1.674986
Rf22	RESET_B#5	RESET_B#2	161.907791
Rf23	RESET_B#4	RESET_B#5	3.529830
Rf24	a_821_98##7	a_821_98##15	145.085922
Rf25	a_821_98##15	a_821_98##17	17.805361
Rf26	a_821_98##17	a_821_98#	194.530289
Rf27	a_821_98##15	a_821_98##19	68.841354
Rf28	a_821_98##16	a_821_98##17	5.000000
Rf29	Q#1	Q	107.731071
Rf30	Q	Q#2	68.546249
Rf31	a_1449_368##3	a_1449_368##8	181.768127
Rf32	a_1449_368##8	a_1449_368##9	41.359882
Rf33	a_1449_368##8	a_1449_368##10	34.686226
Rf34	Q_N	Q_N#1	18.225628
Rf35	Q_N	Q_N#2	87.171745
Rf36	VPWR#1	VPWR#2	118.056465
Rf37	VPWR#2	VPWR#3	81.024994
Rf38	VPWR#3	VPWR#4	67.887894
Rf39	VPWR#4	VPWR#5	84.348778
Rf40	VPWR#5	VPWR#6	101.174927
Rf41	VPWR#6	VPWR#7	61.867599
Rf42	VPWR#7	VPWR#8	123.935982
Rf44	VPWR#2	VPWR#10	44.145977
Rf45	VPWR#3	VPWR#11	34.487274
Rf46	VPWR#4	VPWR#12	34.939823
Rf47	VPWR#5	VPWR#13	23.951298
Rf48	VPWR#7	VPWR#14	31.468460
Rf49	VPWR#8	VPWR#15	29.980259
Rf50	VGND#1	VGND#2	110.981651
Rf51	VGND#2	VGND#3	81.974648
Rf52	VGND#3	VGND#4	75.923454
Rf53	VGND#4	VGND#5	100.760612
Rf54	VGND#5	VGND#6	75.582733
Rf55	VGND#6	VGND#7	64.804886
Rf56	VGND#7	VGND#8	122.855499
Rf58	VGND#2	VGND#10	38.772522
Rf59	VGND#3	VGND#11	35.688515
Rf60	VGND#4	VGND#12	32.026825
Rf61	VGND#5	VGND#13	44.349312
Rf62	VGND#7	VGND#14	24.334328
Rf63	VGND#8	VGND#15	32.322075
Re1	VPWR#2	VPWR	3.246228
Re2	VPWR	VPWR#6	1.159367
Re3	VGND#2	VGND	3.246228
Re4	VGND	VGND#6	1.159367
*
*       CAPACITOR CARDS
*
*
C1	a_641_80##3	VPWR#5	2.2224e-18
C2	a_821_98##15	a_821_98##7	2.62858e-18
C3	Q#1	a_821_98##10	2.59295e-19
C4	a_821_98##15	VPWR#5	5.38576e-17
C5	VPWR#11	a_821_98##12	6.03332e-17
C6	a_641_80##8	a_230_74##5	1.11417e-18
C7	VGND#7	a_230_74##10	4.22061e-17
C8	RESET_B#3	a_821_98##9	2.38388e-17
C9	a_1449_368##9	a_821_98##13	1.80142e-19
C10	VGND#5	a_363_82##4	5.01727e-19
C11	Q#1	a_821_98##12	6.25445e-17
C12	a_230_74##10	a_641_80##8	2.56658e-18
C13	Q#2	a_821_98##8	4.48776e-18
C14	VPWR#11	a_821_98##13	2.38841e-18
C15	RESET_B#2	a_821_98##15	2.32999e-17
C16	VGND#7	a_27_112#	7.48306e-18
C17	a_821_98#	VPWR#5	2.86179e-17
C18	VPWR#5	a_821_98##2	3.29438e-19
C19	VPWR#12	a_821_98##12	2.84498e-18
C20	a_821_98##15	VPWR#4	8.56994e-18
C21	Q#1	a_821_98##13	1.59514e-17
C22	a_641_80#	RESET_B#3	4.68222e-17
C23	VGND#4	a_821_98##8	3.51858e-20
C24	VGND#15	VGND#7	7.71831e-19
C25	VGND#7	a_230_74##7	3.92508e-17
C26	VPWR#11	RESET_B#1	3.08249e-19
C27	a_821_98##13	VPWR#12	3.28412e-17
C28	VGND#5	a_230_74##7	2.03352e-17
C29	VPWR#7	a_363_82##4	4.6857e-18
C30	a_641_80##3	a_821_98##15	4.91925e-17
C31	VPWR#2	a_1449_368##2	4.5102e-20
C32	Q#1	RESET_B#1	1.63801e-18
C33	VGND#4	a_230_74##7	1.16691e-19
C34	VGND#12	a_821_98##15	1.65484e-18
C35	a_363_82##4	VPWR#5	3.10461e-17
C36	VGND#7	a_230_74##4	1.23401e-17
C37	a_230_74##10	VGND#14	4.6824e-18
C38	VGND#2	VGND#1	5.47604e-17
C39	VPWR#2	a_821_98##8	3.08458e-19
C40	RESET_B#1	VPWR#12	3.6591e-17
C41	a_821_98##2	a_641_80#	5.22785e-18
C42	VGND#2	Q_N#2	3.81825e-17
C43	VGND#7	a_230_74##2	3.03452e-20
C44	RESET_B#1	a_821_98##16	2.60186e-17
C45	Q#2	Q#1	1.52316e-18
C46	a_230_74##10	a_363_82##8	3.13537e-18
C47	VPWR#2	a_821_98##5	1.25711e-18
C48	a_821_98##15	a_821_98#	5.70493e-19
C49	VPWR#12	a_641_80##4	1.15081e-18
C50	VGND#2	a_1449_368##10	2.48767e-17
C51	VGND#5	a_641_80##2	2.16229e-20
C52	VGND#3	a_821_98##8	2.70112e-19
C53	a_641_80##6	a_641_80##3	6.73384e-18
C54	VGND#7	GATE#3	1.19417e-18
C55	a_641_80##4	a_821_98##16	1.11434e-17
C56	a_230_74##6	a_821_98##2	5.26181e-17
C57	VGND#2	a_1449_368##2	3.62108e-19
C58	a_230_74##2	a_27_112#	2.01116e-19
C59	VGND#2	Q#2	4.14676e-19
C60	a_641_80##4	VPWR#13	2.374e-17
C61	VGND#7	a_27_112##2	8.57308e-19
C62	VGND#2	a_821_98##8	4.11473e-19
C63	a_363_82##4	a_821_98##15	3.5567e-18
C64	a_821_98##19	a_821_98##15	2.29937e-18
C65	a_641_80##6	a_821_98#	3.23755e-19
C66	VGND#15	a_230_74##10	6.02388e-17
C67	a_821_98##3	VPWR#13	1.27753e-17
C68	a_363_82##2	a_230_74##6	9.69739e-18
C69	a_641_80##7	a_641_80##4	5.32391e-20
C70	VGND#2	a_821_98##5	1.63014e-18
C71	VGND#7	a_230_74##3	1.95797e-19
C72	a_27_112##7	a_230_74##10	2.20128e-18
C73	a_1449_368##3	Q_N#2	2.18437e-17
C74	a_27_112##2	VPWR#7	6.47553e-18
C75	a_641_80##6	a_363_82##4	3.53532e-17
C76	a_1449_368##3	VGND#10	4.76087e-17
C77	VGND#3	a_821_98##5	6.63918e-19
C78	a_27_112#	a_363_82##2	5.16179e-17
C79	a_641_80##6	VPWR#5	7.29257e-19
C80	a_1449_368##10	a_1449_368##3	4.66229e-20
C81	a_27_112##7	VGND#15	4.15497e-17
C82	a_363_82##3	a_641_80##7	1.10296e-17
C83	a_363_82##7	a_230_74##2	1.96767e-17
C84	a_230_74##7	a_641_80##6	3.07836e-18
C85	VPWR#7	a_230_74##3	1.49443e-19
C86	a_230_74##4	a_27_112#	2.24998e-17
C87	a_230_74##5	a_641_80##7	2.33939e-17
C88	a_230_74##7	a_363_82##7	3.02278e-19
C89	GATE#3	a_27_112#	1.91462e-19
C90	a_821_98##7	Q#2	4.76083e-17
C91	VPWR#2	VPWR#1	5.45908e-17
C92	a_363_82#	a_641_80##6	5.52294e-17
C93	VPWR#14	a_230_74##5	2.4329e-18
C94	VGND#12	a_821_98##7	3.04885e-18
C95	Q_N#1	VPWR#2	3.85277e-17
C96	GATE#3	a_230_74##4	4.25913e-18
C97	a_641_80##6	a_821_98##2	4.41463e-18
C98	a_363_82##7	a_363_82#	2.20504e-18
C99	VGND#2	VPWR#1	4.93889e-18
C100	VPWR#14	a_27_112##3	3.78079e-17
C101	a_1449_368##9	VPWR#2	2.25422e-17
C102	a_641_80##6	a_821_98##19	5.91293e-19
C103	RESET_B#2	VGND#12	2.8104e-17
C104	a_363_82##9	a_27_112##3	1.60985e-18
C105	a_641_80##6	a_27_112##2	2.06328e-19
C106	D#3	GATE#3	1.91531e-17
C107	a_821_98##19	a_641_80##2	5.72106e-18
C108	VPWR#2	VPWR#11	2.16954e-17
C109	a_27_112##5	D#5	3.76863e-17
C110	VGND#2	VPWR#10	3.84299e-18
C111	a_230_74#	VPWR#14	1.82815e-17
C112	a_363_82##7	a_27_112##2	2.59264e-17
C113	a_641_80##6	a_230_74##6	1.31559e-17
C114	Q_N#1	VPWR#1	7.26276e-17
C115	a_821_98##19	RESET_B#2	2.35052e-18
C116	VPWR#2	Q#1	3.67868e-19
C117	a_363_82##9	a_230_74#	4.5279e-17
C118	VPWR#15	a_27_112##3	1.08222e-18
C119	a_1449_368##3	a_1449_368##2	2.84962e-18
C120	VPWR#14	GATE#1	1.30597e-18
C121	a_230_74##12	a_230_74#	1.23072e-18
C122	VGND#2	Q#1	4.00483e-19
C123	VPWR#10	VPWR#1	1.68847e-18
C124	a_363_82##9	GATE#1	6.04943e-19
C125	a_821_98##19	a_641_80##3	3.14568e-17
C126	VPWR#15	a_230_74#	1.80381e-18
C127	a_363_82##7	a_230_74##3	4.63764e-17
C128	a_363_82##7	a_230_74##6	5.25157e-20
C129	VPWR#14	D#1	7.77625e-19
C130	VGND#13	a_641_80##3	1.27583e-17
C131	a_230_74##12	GATE#1	4.28115e-17
C132	a_821_98##5	a_1449_368##3	2.918e-17
C133	VGND#1	a_1449_368#	2.65895e-17
C134	a_27_112##5	a_230_74#	8.69262e-19
C135	VPWR#10	Q_N#1	7.26383e-17
C136	GATE#1	VPWR#15	3.1473e-17
C137	a_230_74##12	D#1	2.87693e-18
C138	Q_N#2	a_1449_368#	4.03411e-17
C139	a_27_112##5	GATE#1	3.9117e-17
C140	a_1449_368##3	VPWR#10	4.03643e-17
C141	VGND#13	a_821_98#	2.01335e-18
C142	a_363_82##7	GATE#2	8.11349e-19
C143	a_363_82##7	a_363_82##2	3.03202e-19
C144	VGND#1	a_1449_368##5	1.33717e-18
C145	D#1	VPWR#15	3.23843e-17
C146	VGND#7	VGND#5	2.32518e-19
C147	VGND#10	a_1449_368#	7.45888e-19
C148	a_821_98##7	a_821_98##8	3.3963e-17
C149	a_27_112##5	D#1	5.51206e-17
C150	a_1449_368##6	a_1449_368##4	4.65711e-17
C151	a_641_80##8	a_641_80##6	3.46587e-18
C152	Q_N#2	a_1449_368##5	3.85991e-17
C153	VGND#12	a_230_74##7	2.7096e-19
C154	a_1449_368##9	VPWR#10	9.15817e-17
C155	a_1449_368##10	a_1449_368#	1.05754e-20
C156	a_821_98##7	a_821_98##5	6.13067e-20
C157	VGND#1	a_821_98##4	2.52841e-19
C158	a_363_82##7	a_27_112#	1.12332e-18
C159	a_1449_368##8	a_1449_368##4	6.79523e-21
C160	a_1449_368##5	VGND#10	2.04884e-17
C161	a_821_98##7	a_641_80##2	1.69408e-19
C162	a_821_98##19	a_230_74##7	3.24074e-19
C163	VPWR#4	a_821_98##8	3.65691e-20
C164	a_821_98##10	a_1449_368##6	3.05101e-17
C165	a_821_98##7	Q#1	5.52298e-17
C166	Q_N#2	a_821_98##4	4.16088e-20
C167	a_230_74##7	VGND#13	1.82479e-17
C168	VPWR#11	VPWR#10	5.30906e-18
C169	a_821_98##7	VPWR#12	2.36307e-17
C170	a_1449_368##10	a_1449_368##5	3.1082e-20
C171	a_821_98##12	a_1449_368##6	3.35593e-19
C172	a_230_74##7	a_641_80##8	4.16648e-17
C173	a_363_82##7	a_230_74##4	1.81388e-17
C174	a_821_98##4	VGND#10	2.66262e-17
C175	a_363_82##7	a_641_80##8	4.44592e-18
C176	RESET_B#2	a_821_98##8	3.4772e-17
C177	a_1449_368##8	a_1449_368##6	1.80504e-20
C178	a_821_98##12	a_821_98##10	5.74158e-18
C179	VPWR#11	a_1449_368##9	5.10252e-17
C180	VPWR#7	a_230_74##2	3.41559e-20
C181	VGND#11	a_1449_368##5	4.0529e-19
C182	VPWR#12	RESET_B#2	4.82546e-19
C183	a_230_74##7	VGND#14	1.55882e-19
C184	VGND#2	a_1449_368#	7.14572e-18
C185	VGND#5	VGND#4	4.88987e-19
C186	a_1449_368##10	a_821_98##4	3.85779e-17
C187	RESET_B#2	a_821_98##5	5.61573e-20
C188	a_363_82#	a_641_80##8	3.89641e-17
C189	VGND#2	a_1449_368##5	8.8103e-18
C190	VGND#10	a_821_98##11	4.91382e-19
C191	a_641_80##8	a_641_80##2	8.64641e-20
C192	a_230_74##10	a_230_74##7	1.78865e-18
C193	a_1449_368##9	VPWR#3	4.56955e-18
C194	a_641_80##2	RESET_B#2	2.56712e-17
C195	Q#1	a_1449_368##9	2.24363e-18
C196	a_363_82##7	GATE#3	9.1346e-19
C197	a_821_98##13	a_821_98##12	4.89186e-17
C198	VPWR#3	a_821_98##8	3.90506e-19
C199	VGND#2	a_821_98##4	1.54309e-17
C200	VGND#11	a_821_98##4	2.5442e-18
C201	a_1449_368##8	a_821_98##10	5.09355e-19
C202	a_1449_368##8	VPWR#10	2.90742e-18
C203	VGND#2	a_821_98##11	1.56401e-19
C204	VPWR#3	a_821_98##12	1.86464e-18
C205	a_1449_368##10	a_821_98##11	1.8473e-18
C206	D#5	D#2	1.21373e-17
C207	a_363_82##9	a_230_74##2	2.64306e-18
C208	a_641_80##3	VPWR#13	5.07116e-19
C209	Q#1	VPWR#11	6.89193e-17
C210	VPWR#5	a_821_98##13	3.45284e-19
C211	Q#2	a_821_98##4	3.12086e-19
C212	RESET_B#1	a_821_98##13	3.39417e-17
C213	a_821_98##11	VGND#11	2.33225e-17
C214	a_363_82##7	VGND#14	1.6128e-18
C215	VPWR#4	a_821_98##13	3.33486e-18
C216	a_821_98#	VPWR#13	1.21457e-18
C217	Q_N#2	VGND#1	7.42264e-17
C218	VGND#12	a_821_98##4	8.77454e-20
C219	a_1449_368##8	a_821_98##12	4.94215e-21
C220	VPWR#12	VPWR#11	2.15119e-18
C221	a_230_74##10	a_27_112##2	1.27605e-18
C222	Q#1	VPWR#4	4.51655e-18
C223	Q#2	a_821_98##11	5.70299e-17
C224	a_641_80##3	a_641_80##2	2.51466e-19
C225	a_641_80##4	RESET_B#1	3.65453e-17
C226	a_641_80##7	a_821_98#	2.73776e-18
C227	VPWR#5	RESET_B#1	1.63772e-18
C228	VGND#11	a_821_98##9	6.49864e-19
C229	VGND#4	VGND#3	8.77876e-19
C230	VPWR#5	VPWR#12	1.78326e-18
C231	a_230_74##3	a_363_82##8	7.90375e-19
C232	VPWR#12	Q#1	6.04688e-17
C233	a_363_82##7	a_363_82##8	1.45173e-18
C234	VGND#12	a_821_98##11	1.2318e-18
C235	VGND#10	VGND#1	1.98257e-18
C236	Q#1	VPWR#3	6.20512e-18
C237	a_230_74##10	a_230_74##3	4.47515e-18
C238	VPWR#4	RESET_B#1	2.60702e-18
C239	VPWR#3	a_821_98##5	1.2459e-18
C240	a_363_82##4	a_641_80##7	7.51902e-17
C241	Q#2	a_821_98##9	4.24237e-17
C242	a_821_98##3	a_641_80##4	9.10247e-18
C243	a_1449_368##8	a_1449_368##2	9.80947e-20
C244	a_27_112##7	a_230_74##3	5.96496e-20
C245	a_230_74##10	a_230_74##12	2.1003e-18
C246	VGND#11	RESET_B#3	1.78306e-19
C247	VPWR#14	a_363_82##4	1.82665e-17
C248	GATE#2	a_230_74##10	4.47396e-18
C249	RESET_B#2	a_821_98##4	1.80034e-19
C250	a_821_98##9	VGND#12	1.80529e-17
C251	VPWR#5	a_641_80##4	2.40273e-17
C252	VGND#10	Q_N#2	6.82353e-17
C253	a_821_98##15	a_821_98##12	2.31468e-19
C254	a_230_74##10	a_363_82##7	8.29373e-17
C255	RESET_B#2	a_821_98##11	3.10086e-19
C256	Q#2	RESET_B#3	1.99129e-18
C257	VPWR#12	VPWR#3	7.1293e-20
C258	a_363_82##3	a_821_98##3	9.11118e-18
C259	VGND#6	a_363_82##2	4.07902e-18
C260	a_27_112##7	GATE#2	4.1305e-18
C261	a_821_98#	a_641_80##2	2.25427e-19
C262	RESET_B#2	a_821_98##9	2.50847e-18
C263	D	a_230_74##2	9.45639e-20
C264	a_1449_368##8	a_821_98##8	1.26672e-19
C265	a_363_82#	a_641_80##7	6.7981e-17
C266	VPWR#7	a_821_98##3	7.53405e-20
C267	VPWR#2	a_1449_368##4	6.73797e-18
C268	VGND#12	RESET_B#3	4.4353e-17
C269	a_1449_368##10	Q_N#2	3.1738e-19
C270	VGND#15	D#2	5.54022e-18
C271	a_641_80#	RESET_B#2	5.39404e-18
C272	a_821_98##19	a_821_98##9	4.26113e-19
C273	a_230_74##5	a_363_82##3	1.66193e-17
C274	a_27_112##7	D#2	4.23866e-18
C275	a_821_98##15	a_821_98##13	6.08226e-19
C276	Q#2	a_641_80#	3.684e-19
C277	VPWR#2	a_1449_368##6	1.06298e-17
C278	VPWR#5	a_821_98##3	2.42235e-17
C279	VPWR#14	a_363_82#	3.01588e-18
C280	VPWR#5	VPWR#13	6.74175e-18
C281	a_363_82#	a_363_82##9	2.57515e-19
C282	VPWR#2	a_821_98##10	1.07791e-17
C283	VGND#12	a_641_80#	6.36699e-18
C284	VGND#15	a_27_112##5	3.26135e-18
C285	a_1449_368##10	VGND#10	5.95652e-17
C286	VPWR#2	a_821_98##12	2.7179e-19
C287	a_27_112##2	VPWR#14	5.10664e-17
C288	a_27_112##3	a_230_74##5	4.89627e-17
C289	a_821_98##2	a_641_80##3	1.88724e-17
C290	VPWR#7	a_363_82##3	2.75072e-19
C291	a_821_98##19	RESET_B#3	9.16849e-18
C292	a_27_112##2	a_363_82##9	7.46655e-17
C293	a_641_80##3	a_230_74##6	1.02863e-18
C294	a_821_98##8	a_821_98##5	4.89077e-19
C295	a_821_98##15	RESET_B#1	5.72259e-17
C296	RESET_B	a_641_80##2	2.89813e-18
C297	VPWR#5	a_363_82##3	2.75376e-18
C298	a_27_112##7	a_27_112##5	3.16227e-18
C299	a_27_112##2	VPWR#15	4.65519e-20
C300	a_230_74#	a_27_112##3	2.39237e-17
C301	VGND#11	VGND#10	4.786e-18
C302	a_230_74##3	a_363_82##9	2.0161e-17
C303	a_230_74##6	a_821_98#	5.22617e-18
C304	a_821_98##19	a_641_80#	4.78931e-17
C305	RESET_B#1	a_821_98##8	1.26353e-18
C306	a_1449_368##8	a_821_98##5	4.3763e-17
C307	a_230_74##2	a_363_82##8	1.18423e-20
C308	VPWR#7	a_230_74##5	7.15276e-19
C309	a_230_74##7	a_641_80#	1.65878e-18
C310	a_821_98##15	a_641_80##4	4.39187e-17
C311	VGND#13	a_641_80#	1.06678e-18
C312	a_363_82##9	GATE#2	2.39612e-20
C313	a_27_112##5	a_230_74##3	3.19393e-18
C314	GATE#1	a_230_74#	6.33748e-18
C315	a_821_98##15	Q#1	2.61298e-18
C316	VPWR#5	a_230_74##5	1.39891e-19
C317	a_230_74##7	a_821_98##2	1.3488e-17
C318	GATE#2	a_230_74##12	1.032e-17
C319	VGND#11	a_1449_368##10	2.54152e-17
C320	a_821_98##19	a_821_98##2	5.03348e-18
C321	VPWR#15	GATE#2	1.91304e-19
C322	a_230_74##7	a_230_74##6	1.12573e-18
C323	GATE#2	a_27_112##5	5.05834e-18
C324	a_230_74##7	a_363_82##2	3.21722e-17
C325	a_821_98##7	a_821_98##12	2.30989e-19
C326	a_641_80##2	RESET_B#1	2.35654e-18
C327	D#1	GATE#1	1.99281e-17
C328	VGND#13	a_821_98##2	4.46434e-17
C329	a_230_74##12	D#2	1.85934e-19
C330	a_230_74##7	a_27_112#	2.70224e-17
C331	VPWR#7	a_27_112##3	7.93934e-18
C332	a_363_82#	a_230_74##6	1.82294e-17
C333	VPWR#6	a_363_82##3	4.61111e-18
C334	a_821_98##7	a_821_98##13	3.27554e-18
C335	VPWR#15	D#2	5.1347e-19
C336	a_821_98##15	a_821_98##3	1.18887e-18
C337	a_641_80##8	a_641_80#	8.07893e-20
C338	Q#2	a_1449_368##10	2.4397e-18
C339	a_821_98##19	a_230_74##6	4.44107e-19
C340	a_821_98##15	VPWR#12	9.4247e-17
C341	a_230_74##7	a_230_74##4	1.18945e-18
C342	a_27_112##5	D#2	9.20899e-18
C343	VPWR#6	a_230_74##5	4.50979e-18
C344	VPWR#5	a_27_112##3	5.61043e-20
C345	a_230_74##7	GATE#3	4.36108e-19
C346	a_363_82#	a_27_112#	1.96372e-17
C347	a_27_112##2	a_230_74##6	1.14428e-18
C348	a_230_74##10	a_230_74##2	1.98434e-19
C349	VGND#13	a_230_74##6	2.86988e-18
C350	VGND#6	a_230_74##5	6.1934e-20
C351	a_641_80##8	a_821_98##2	4.85627e-18
C352	Q#2	VGND#11	4.76263e-17
C353	VPWR#7	a_230_74#	5.98808e-18
C354	a_821_98##15	a_363_82##3	3.00595e-19
C355	a_821_98##15	a_821_98##16	4.5716e-18
C356	Q_N	a_1449_368##2	1.17587e-17
C357	a_641_80##3	a_641_80##4	1.05881e-18
C358	VGND#13	a_363_82##2	4.6218e-19
C359	Q_N	a_821_98##5	2.31236e-19
C360	a_230_74##3	a_230_74##4	1.50607e-19
C361	a_641_80##8	a_230_74##6	3.18246e-17
C362	a_821_98#	a_641_80##4	1.43201e-17
C363	a_363_82#	a_230_74##2	2.42558e-19
C364	VGND#12	VGND#11	2.0116e-18
C365	a_363_82##4	RESET_B#1	3.01813e-19
C366	GATE#2	a_230_74##4	7.99906e-19
C367	a_363_82##4	a_641_80##4	6.11499e-19
C368	a_821_98##15	VPWR#13	9.93658e-19
C369	a_363_82##4	a_821_98##3	1.11822e-17
C370	a_641_80##8	a_363_82##2	2.82753e-17
C371	D#3	GATE#2	4.97211e-18
C372	a_230_74##5	a_821_98#	6.91782e-18
C373	VGND#12	Q#2	4.99367e-17
C374	a_363_82##4	a_363_82##3	2.18519e-17
C375	VGND#3	a_1449_368##10	4.96664e-18
C376	a_1449_368##3	VPWR#2	3.88605e-18
C377	a_363_82##4	a_230_74##5	6.15928e-17
C378	VGND#2	a_1449_368##3	7.2128e-18
C379	Q	a_821_98##8	2.97438e-17
C380	a_363_82##4	a_27_112##3	4.89018e-18
C381	a_641_80##8	a_27_112#	2.17498e-18
C382	Q	a_821_98##5	1.91702e-19
C383	VGND#4	RESET_B	1.17112e-18
C384	a_230_74##7	a_230_74##5	1.09364e-18
C385	a_363_82#	a_363_82##3	3.25473e-19
C386	a_230_74##2	a_27_112##2	2.88077e-17
C387	a_821_98##15	a_821_98##8	7.79135e-19
C388	a_363_82#	a_230_74##5	5.3011e-17
C389	a_363_82#	a_27_112##3	7.85762e-18
C390	a_1449_368##2	Q_N#1	7.64865e-20
C391	a_641_80##8	a_230_74##4	1.14284e-18
C392	a_27_112##2	a_230_74##5	1.71264e-17
C393	a_641_80##6	a_230_74##5	3.05709e-17
C394	a_363_82#	a_230_74#	7.15807e-19
C395	VGND#4	Q#2	7.49262e-18
C396	a_27_112#	VGND#14	1.64349e-17
C397	a_27_112##2	a_27_112##3	2.09262e-17
C398	a_821_98##15	RESET_B	2.68191e-17
C399	a_641_80#	a_1049_74#	1.33097e-17
C400	VPWR#15	VPWR#7	2.56304e-19
C401	a_821_98##19	Q#2	4.6748e-18
C402	a_363_82#	GATE#1	2.64218e-19
C403	a_641_80##7	a_821_98##15	4.54334e-19
C404	a_230_74##10	a_363_82##2	1.79213e-19
C405	a_27_112##2	a_230_74#	4.3619e-17
C406	VGND#5	VGND#12	8.20848e-19
C407	a_27_112##2	GATE#1	3.95958e-19
C408	RESET_B#2	a_821_98##7	3.6825e-17
C409	a_641_80##8	GATE#3	3.65191e-19
C410	a_230_74##3	a_230_74#	4.02904e-19
C411	a_363_82##4	VPWR#6	6.65565e-17
C412	a_27_112##2	D#1	2.94118e-19
C413	a_230_74##4	VGND#14	1.83993e-17
C414	VGND#3	Q#2	9.66298e-18
C415	a_230_74##3	GATE#1	8.79955e-19
C416	a_821_98##19	VGND#12	3.38445e-17
C417	a_230_74##12	a_363_82##9	2.88223e-17
C418	VPWR#15	VPWR#14	4.52155e-18
C419	GATE#2	a_230_74#	1.89124e-19
C420	a_230_74##10	a_27_112#	9.4018e-19
C421	a_230_74##3	a_230_74##2	1.27093e-17
C422	VGND#6	a_230_74##7	6.89239e-17
C423	a_27_112##5	VPWR#7	1.44963e-18
C424	a_821_98##2	a_773_124#	9.87534e-18
C425	a_230_74##4	a_363_82##8	1.30958e-17
C426	VPWR#6	a_363_82#	8.2719e-20
C427	a_230_74##6	a_773_124#	9.87534e-18
C428	VGND#15	a_27_112#	4.92444e-19
C429	a_363_82##3	a_757_508#	1.17351e-17
C430	VGND#6	a_363_82#	1.3842e-19
C431	D#2	GATE#1	5.52381e-18
C432	VGND#2	VGND#3	6.46164e-17
C433	a_641_80##3	a_821_98#	9.32754e-17
C434	a_230_74##10	a_230_74##4	1.74069e-17
C435	VGND#3	a_1449_368##5	1.56401e-19
C436	a_1449_368##8	Q_N	7.31178e-19
C437	VPWR#5	VPWR#4	9.12227e-19
C438	VGND#12	VGND#3	3.51704e-19
C439	a_230_74##5	a_566_392#	1.97909e-17
C440	VGND#15	D	7.97717e-18
C441	a_363_82##4	a_821_98#	6.52758e-17
C442	a_27_112##3	a_566_392#	2.38647e-20
C443	VGND#15	a_230_74##4	8.29856e-19
C444	a_821_98##19	RESET_B	2.96604e-17
C445	VGND#15	D#5	2.65078e-18
C446	VPWR#2	VPWR#3	4.50138e-17
C447	VGND	a_821_98##8	9.94117e-20
C448	a_230_74##10	GATE#3	5.12713e-17
C449	a_821_98##15	a_641_80##2	7.61913e-18
C450	a_363_82##2	a_569_80#	7.18415e-18
C451	Q_N#2	a_1449_368##2	1.08952e-17
C452	VGND	a_230_74##2	5.73844e-19
C453	VGND#3	Q	1.29612e-18
C454	VGND#5	a_821_98##19	1.90107e-17
C455	a_27_112#	a_569_80#	9.92599e-18
C456	a_27_112##7	a_230_74##4	3.92038e-19
C457	a_27_112##5	a_230_74##12	5.86893e-17
C458	GATE#2	a_230_74##2	6.31103e-19
C459	a_363_82#	a_363_82##4	2.01005e-18
C460	Q	VPWR#3	6.48407e-19
C461	GATE#3	VGND#15	2.69529e-17
C462	Q	a_1449_368##8	4.64263e-17
C463	a_1449_368##8	VPWR#2	5.66288e-19
C464	a_1449_368##8	Q_N#2	2.95741e-19
C465	a_230_74##7	a_363_82#	2.39684e-17
C466	a_27_112##7	D#5	9.08374e-18
C467	a_230_74##10	D#3	8.93112e-19
C468	VGND#13	a_821_98##19	5.13595e-17
C469	a_27_112##5	VPWR#15	5.65252e-17
C470	a_230_74##7	a_27_112##2	6.20752e-19
C471	VGND#4	a_821_98##19	8.43517e-18
C472	a_27_112##7	GATE#3	1.32935e-18
C473	Q_N#2	Q_N	3.16284e-18
C474	a_230_74##10	GATE	2.36429e-17
C475	a_363_82#	a_27_112##2	1.50501e-16
C476	D	VPWR#15	1.56494e-18
C477	D	a_27_112##5	6.67584e-18
C478	a_27_112##7	GATE	5.73055e-18
C479	D#3	VGND#15	2.48828e-17
C480	VPWR	VPWR#7	1.0011e-16
C481	VPWR	VPWR#5	1.23932e-16
C482	VPWR	VPWR#4	5.57961e-17
C483	VPWR	VPWR#3	1.73858e-17
C484	a_230_74##3	a_27_112##2	1.79113e-18
C485	VGND#3	a_821_98##11	5.30412e-18
C486	VGND#2	a_1449_368##8	3.38507e-18
C487	VPWR#4	VPWR#3	1.04266e-18
C488	a_27_112##7	D#3	3.50501e-17
C489	a_1449_368##2	VNB	3.88129e-17
C490	a_821_98##8	VNB	7.90343e-17
C491	VPWR	a_821_98##15	2.34396e-17
C492	a_821_98##5	VNB	3.79235e-17
C493	a_641_80##2	VNB	2.09915e-17
C494	a_230_74##2	VNB	2.09795e-17
C495	a_363_82##4	a_757_508#	3.18985e-18
C496	Q	a_1449_368##10	3.16724e-17
C497	GATE#2	a_230_74##3	5.45152e-17
C498	VPWR	a_641_80##6	5.97083e-18
C499	Q_N	VPWR#1	3.47519e-17
C500	Q	VGND#11	2.53132e-17
C501	VGND#4	a_821_98##15	4.40175e-19
C502	Q_N	Q_N#1	2.46769e-19
C503	VPWR#10	Q_N	2.8074e-17
C504	a_230_74##3	D#2	1.19588e-18
C505	a_1449_368##9	Q_N	2.31385e-19
C506	VGND#4	a_821_98##9	7.51136e-18
C507	RESET_B	a_641_80#	6.12636e-20
C508	VGND#1	VPWR#1	1.03343e-17
C509	VGND	VGND#7	9.19963e-17
C510	VGND	VGND#5	9.60748e-17
C511	D#2	GATE#2	2.9606e-17
C512	VGND	VGND#4	7.69872e-17
C513	VGND	VGND#3	2.27974e-17
C514	a_641_80##8	a_821_98##19	3.55323e-18
C515	VPWR	D#5	1.45192e-18
C516	Q_N#2	a_821_98##5	1.7337e-19
C517	VGND#3	a_821_98##9	6.36169e-19
C518	VGND	a_821_98##15	4.03213e-18
C519	VGND#5	RESET_B#3	2.59295e-19
C520	a_821_98##5	a_1449_368##9	3.38162e-19
C521	Q	a_1449_368##9	2.92238e-17
C522	Q	VPWR#11	2.49735e-17
C523	Q	Q#1	3.52122e-19
C524	VGND	a_641_80##6	6.70596e-18
C525	VGND	a_363_82##7	8.62018e-18
C526	a_1449_368##5	a_1449_368#	3.8388e-17
C527	a_821_98##8	VPWR#11	1.98816e-18
C528	a_641_80##8	VGND#13	1.27424e-17
C529	GATE	D#3	7.14579e-19
C530	VGND#4	RESET_B#3	4.55467e-18
C531	VGND#4	a_821_98##7	1.30061e-18
C532	D	a_230_74#	2.37269e-19
C533	VGND#7	VNB	4.60713e-17
C534	VGND	D#5	2.31867e-18
C535	VGND#5	VNB	4.55269e-17
C536	VGND#4	VNB	3.90711e-17
C537	D	GATE#1	1.62677e-18
C538	VGND#3	VNB	3.65232e-17
C539	VPWR#1	a_1449_368##4	3.22955e-17
C540	VPWR	VPWR#11	3.56752e-19
C541	a_1449_368##10	a_1449_368##2	1.5863e-20
C542	VPWR	Q#1	1.30999e-17
C543	VPWR#7	VNB	4.47954e-17
C544	VPWR#5	VNB	4.8025e-17
C545	Q	a_821_98##4	6.23952e-19
C546	VPWR	VPWR#12	2.19124e-17
C547	VPWR#4	VNB	2.91273e-17
C548	VGND	Q#2	1.71626e-17
C549	a_230_74##7	a_569_80#	1.20888e-18
C550	VPWR#3	VNB	3.2307e-17
C551	Q	a_821_98##11	4.62372e-19
C552	VGND	VGND#12	1.98339e-17
C553	a_1449_368##8	VNB	1.98963e-18
C554	Q	a_821_98##9	6.46887e-20
C555	VGND	a_821_98##19	2.3217e-17
C556	VPWR	a_641_80##7	6.53211e-18
C557	a_821_98##15	VNB	7.35233e-18
C558	Q_N	a_1449_368##4	9.96497e-18
C559	VGND#3	RESET_B#3	1.13554e-19
C560	VGND	a_641_80##8	9.88743e-18
C561	Q_N	a_1449_368##6	9.36232e-18
C562	VPWR	a_363_82##9	4.14774e-18
C563	VGND#5	a_641_80#	2.10216e-18
C564	a_641_80##6	VNB	1.13588e-17
C565	Q_N	a_821_98##10	1.02772e-19
C566	VPWR	a_230_74##12	4.13771e-18
C567	Q_N#1	a_1449_368##4	4.94466e-17
C568	VGND	a_230_74##10	3.90578e-17
C569	a_363_82##7	VNB	7.78468e-18
C570	VPWR	VPWR#15	1.98598e-17
C571	VGND	VGND#15	2.03809e-17
C572	VPWR	a_27_112##5	3.41217e-17
C573	VGND	a_27_112##7	1.63707e-17
C574	a_821_98##4	a_1449_368##5	2.21534e-17
C575	VPWR#1	a_1449_368##6	1.22325e-18
C576	VGND	Q#1	2.3088e-18
C577	D#5	VNB	1.77453e-18
C578	VGND#1	VNB	6.84293e-17
C579	Q_N#2	VNB	9.87449e-18
C580	Q	a_821_98##10	5.73974e-19
C581	a_1449_368##10	a_821_98##8	2.42031e-20
C582	VGND#10	VNB	7.8031e-18
C583	a_1449_368##10	VNB	8.58263e-18
C584	VPWR#10	a_1449_368##4	6.33477e-19
C585	VGND#11	VNB	6.44124e-18
C586	VGND#4	a_641_80#	5.32748e-18
C587	Q#2	VNB	2.19624e-18
C588	VGND#12	VNB	1.2508e-18
C589	VGND	a_363_82##9	6.02916e-19
C590	RESET_B	RESET_B#2	5.92182e-18
C591	a_821_98##19	VNB	1.25265e-17
C592	VGND	a_230_74##12	1.85117e-18
C593	VGND#13	VNB	9.87379e-18
C594	a_641_80##8	VNB	4.58944e-19
C595	Q_N#1	a_1449_368##6	4.65893e-17
C596	a_230_74##10	VNB	1.41727e-17
C597	VGND#15	VNB	1.03583e-17
C598	VGND	a_821_98##11	1.15615e-19
C599	VGND#2	Q_N	1.51368e-18
C600	a_27_112##7	VNB	4.69365e-17
C601	VGND	a_821_98##9	1.0235e-18
C602	a_821_98##11	a_1449_368##5	1.68747e-19
C603	VPWR#1	VNB	7.95364e-17
C604	a_1449_368##8	a_1449_368##3	2.68547e-19
C605	Q_N#1	VNB	2.37174e-18
C606	VGND	RESET_B#3	9.83459e-19
C607	VPWR	a_821_98##12	1.08355e-18
C608	D	a_230_74##3	6.69736e-18
C609	VPWR#10	VNB	5.1965e-18
C610	a_1449_368##9	a_1449_368##4	2.42687e-20
C611	a_1449_368##9	VNB	5.20352e-18
C612	VPWR	a_821_98##13	3.26023e-18
C613	VGND	a_821_98##2	5.86065e-18
C614	Q#1	a_821_98##8	2.90715e-18
C615	VPWR#11	VNB	1.11523e-17
C616	Q#1	VNB	4.95285e-18
C617	VPWR	RESET_B#1	2.21689e-19
C618	D	GATE#2	1.70903e-17
C619	a_1449_368##3	Q_N	2.87391e-17
C620	VPWR#12	VNB	4.05632e-18
C621	VPWR	a_641_80##4	1.05429e-18
C622	VGND	a_27_112#	3.17676e-18
C623	VPWR	a_821_98##3	9.62285e-19
C624	D	D#2	5.55457e-18
C625	VGND	a_230_74##4	8.41982e-18
C626	VPWR#2	Q	4.30943e-18
C627	a_363_82##7	a_363_82##9	2.28947e-18
C628	a_641_80##7	VNB	5.46882e-19
C629	VPWR	a_363_82##3	8.94669e-19
C630	VGND	GATE#3	1.69273e-18
C631	a_821_98##7	VPWR#4	3.00645e-19
C632	VGND#2	Q	5.51781e-18
C633	VGND	D#3	9.10762e-18
C634	VPWR	a_230_74##5	6.37048e-18
C635	VGND#5	a_821_98##2	2.69317e-18
C636	VPWR#14	VNB	4.37044e-18
C637	a_1449_368##6	VPWR#10	2.72129e-17
C638	a_363_82##9	VNB	3.74188e-18
C639	VPWR	a_27_112##3	1.29386e-18
C640	a_230_74##12	VNB	6.0427e-18
C641	VGND#7	VGND#14	7.91008e-18
C642	VPWR#15	VNB	1.48523e-17
C643	VPWR	a_230_74#	8.33499e-18
C644	a_821_98##2	a_641_80##2	8.00062e-19
C645	a_27_112##5	VNB	7.13843e-17
C646	VPWR	GATE#1	8.46748e-18
C647	a_1449_368#	VNB	3.37046e-17
C648	a_1449_368##5	VNB	3.0493e-17
C649	VPWR	D#1	8.28002e-18
C650	GATE	a_230_74##3	1.28869e-17
C651	a_821_98##4	VNB	3.86509e-17
C652	a_821_98##7	Q	2.79963e-17
C653	a_821_98##11	VNB	3.17857e-17
C654	a_821_98##9	VNB	3.1701e-17
C655	RESET_B#2	Q	3.49757e-18
C656	GATE	GATE#2	7.44884e-18
C657	a_821_98##11	a_821_98##4	4.15511e-18
C658	RESET_B#3	VNB	2.59614e-17
C659	a_641_80#	VNB	3.37709e-17
C660	GATE	D#2	7.02669e-19
C661	a_821_98##2	VNB	5.33837e-17
C662	a_230_74##6	VNB	3.6129e-17
C663	VPWR	VPWR#6	5.08627e-17
C664	VGND#5	a_641_80##3	1.77666e-18
C665	a_363_82##2	VNB	2.31257e-17
C666	a_27_112#	VNB	2.82526e-17
C667	a_230_74##4	VNB	4.4436e-17
C668	GATE#3	VNB	3.67025e-17
C669	D#3	VNB	4.05399e-17
C670	VPWR	a_821_98##7	5.25244e-18
C671	a_1449_368##9	a_1449_368##6	6.44659e-20
C672	VPWR	RESET_B#2	1.45914e-18
C673	a_1449_368##4	VNB	4.17358e-17
C674	a_1449_368##6	VNB	3.47724e-17
C675	VPWR	a_641_80##3	5.76894e-18
C676	a_821_98##10	VNB	4.09443e-17
C677	VPWR#1	a_821_98##12	1.23371e-19
C678	a_821_98##12	VNB	3.25118e-17
C679	VPWR	a_821_98#	6.26236e-18
C680	a_821_98##13	VNB	3.27924e-17
C681	VPWR	a_363_82##4	4.3799e-17
C682	RESET_B#1	VNB	3.45449e-17
C683	a_641_80##4	VNB	3.10581e-17
C684	VGND	VGND#6	4.73917e-17
C685	a_821_98##3	VNB	2.71318e-17
C686	a_363_82##3	VNB	2.21032e-17
C687	VPWR	a_363_82#	1.50362e-18
C688	a_821_98##10	VPWR#10	3.47792e-17
C689	a_230_74##5	VNB	6.35517e-17
C690	VGND	a_821_98##7	9.60122e-18
C691	VPWR	a_27_112##2	1.69281e-17
C692	a_27_112##3	VNB	3.39633e-17
C693	VGND	RESET_B#2	1.66076e-18
C694	a_230_74#	VNB	4.05894e-17
C695	VPWR	a_230_74##3	2.14705e-18
C696	VGND	a_641_80##3	1.02146e-17
C697	GATE#1	VNB	3.69422e-17
C698	D#1	VNB	3.70393e-17
C699	VGND	a_821_98#	4.15277e-19
C700	VPWR	GATE#2	3.95435e-18
C701	VGND	a_363_82##4	9.913e-19
C702	VPWR#2	VNB	1.75004e-16
C703	VPWR#11	a_1449_368##6	6.67004e-19
C704	VGND	a_230_74##7	4.26528e-17
C705	VGND#2	VNB	1.76656e-16
C706	VPWR#6	VNB	2.86201e-17
C707	VGND	a_363_82#	8.03895e-18
C708	VGND#6	VNB	2.63324e-17
C709	a_1449_368##10	a_821_98##5	1.28115e-18
C710	VGND	a_27_112##2	3.46792e-18
C711	a_1449_368##3	VNB	4.34369e-17
C712	VGND	a_230_74##3	3.14726e-18
C713	a_821_98##7	VNB	4.72197e-18
C714	a_821_98##8	VGND#11	2.27004e-18
C715	RESET_B#2	VNB	2.95301e-17
C716	VGND	GATE#2	4.35781e-19
C717	a_641_80##3	VNB	4.67666e-17
C718	VPWR#4	RESET_B#2	4.93888e-20
C719	VGND	D#2	2.22407e-19
C720	a_821_98#	VNB	5.92628e-17
C721	a_363_82##4	VNB	4.58638e-17
C722	a_230_74##7	VNB	5.0897e-17
C723	a_1449_368##9	a_821_98##10	7.45057e-17
C724	a_363_82#	VNB	2.58161e-17
C725	a_27_112##2	VNB	4.66368e-17
C726	a_230_74##3	VNB	5.48642e-17
C727	GATE#2	VNB	3.72592e-17
C728	D#2	VNB	4.22159e-17
C729	a_821_98##9	a_821_98##11	3.74316e-17
C730	VPWR#10	a_821_98##12	6.14373e-19
C731	VPWR	D	1.65864e-18
C732	VPWR	RESET_B	1.11266e-18
C733	VGND	D	2.10054e-18
C734	VGND	RESET_B	3.60776e-18
C735	VGND	GATE	6.39812e-18
C736	VPWR#11	a_821_98##10	3.15045e-18
C737	D	VNB	2.22093e-18
C738	RESET_B	VNB	2.52491e-18
C739	VGND#5	a_641_80##6	1.14573e-18
C740	GATE	VNB	8.19336e-19
C741	Q_N	VNB	8.50466e-18
C742	Q	VNB	1.34768e-17
C743	VPWR	VNB	3.02532e-16
C744	VGND	VNB	3.11948e-16
C745	a_1449_368##9	a_821_98##12	2.5098e-18
C746	VGND#8	VGND#7	3.10079e-19
C747	VGND#8	D#5	4.07825e-19
C748	VPWR	VPWR#8	1.06054e-16
C749	VGND#8	a_27_112##7	1.19155e-17
C750	VGND	VGND#8	1.07583e-16
C751	VGND#8	GATE#3	7.46402e-18
C752	VPWR#8	GATE#1	5.99795e-18
C753	VGND#8	VNB	6.26394e-17
C754	VPWR#8	a_230_74##3	7.91033e-20
C755	VGND#8	D#3	3.61817e-18
C756	VPWR#8	VPWR#7	1.87957e-19
C757	VGND#8	GATE	1.17159e-18
C758	VGND#8	a_230_74##3	7.93013e-20
C759	VGND#8	a_230_74##10	2.58996e-17
C760	a_27_112##5	VPWR#8	2.09191e-17
C761	VPWR#8	D#1	4.1371e-18
C762	VPWR#8	VNB	6.26988e-17
C763	VGND#8	GATE#2	1.27013e-19
C764	VPWR#8	GATE#2	6.79801e-20
*
*
.ENDS sky130_fd_sc_hs__dlrbp_2
*
