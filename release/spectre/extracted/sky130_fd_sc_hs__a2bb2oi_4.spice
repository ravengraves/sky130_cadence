* Extracted by Quantus, converted by sky130cad/quantus.py
*
*
*
*                       LINUX           Wed Nov 18 08:10:52 2026
*
*
*
*  PROGRAM  advgen
*
*  Name           : advgen - Quantus - (64-bit)
*  Version        : 25.1.0-p047
*  Build Date     : Thu Dec 11 23:20:30 PST 2025
*
*  HSPICE LIBRARY
*
*  OPERATING_TEMPERATURE 150
*  QRC_TECH_DIR <path>/tech
*
*
*

*
.SUBCKT sky130_fd_sc_hs__a2bb2oi_4 VPB VNB VGND VPWR Y A2_N B2 B1 A1_N
*
*
*  caps2d version: 10
*
*
*       TRANSISTOR CARDS
*
*
XM23 VGND#15 A2_N#1 a_114_392##16 VNB sky130_fd_pr__nfet_01v8_lvt l=0.15 w=0.74 ad=0.1961 as=0.2072 pd=2.01 ps=2.04
XM28 a_114_392##16 A1_N#4 VGND#14 VNB sky130_fd_pr__nfet_01v8_lvt l=0.15 w=0.74 ad=0.2072 as=0.2368 pd=2.04 ps=2.12
XM15 Y#4 a_114_392##6 VGND#14 VNB sky130_fd_pr__nfet_01v8_lvt l=0.15 w=0.74 ad=0.2072 as=0.2368 pd=2.04 ps=2.12
XM4 VGND#13 a_114_392##12 Y#4 VNB sky130_fd_pr__nfet_01v8_lvt l=0.15 w=0.74 ad=0.2072 as=0.2072 pd=2.04 ps=2.04
XM9 Y#9 a_114_392##10 VGND#13 VNB sky130_fd_pr__nfet_01v8_lvt l=0.15 w=0.74 ad=0.2072 as=0.2072 pd=2.04 ps=2.04
XM21 VGND#12 a_114_392##8 Y#9 VNB sky130_fd_pr__nfet_01v8_lvt l=0.15 w=0.74 ad=0.2109 as=0.2072 pd=2.05 ps=2.04
XM0 a_914_74##7 B2#10 Y#6 VNB sky130_fd_pr__nfet_01v8_lvt l=0.15 w=0.74 ad=0.1961 as=0.2072 pd=2.01 ps=2.04
XM2 Y#6 B2#8 a_914_74##5 VNB sky130_fd_pr__nfet_01v8_lvt l=0.15 w=0.74 ad=0.2072 as=0.2072 pd=2.04 ps=2.04
XM7 Y#8 B2#6 a_914_74##5 VNB sky130_fd_pr__nfet_01v8_lvt l=0.15 w=0.74 ad=0.2072 as=0.2072 pd=2.04 ps=2.04
XM17 a_914_74##3 B2#1 Y#8 VNB sky130_fd_pr__nfet_01v8_lvt l=0.15 w=0.74 ad=0.2072 as=0.2072 pd=2.04 ps=2.04
XM8 VGND#11 B1#10 a_914_74##3 VNB sky130_fd_pr__nfet_01v8_lvt l=0.15 w=0.74 ad=0.2072 as=0.2072 pd=2.04 ps=2.04
XM11 a_914_74##8 B1#7 VGND#11 VNB sky130_fd_pr__nfet_01v8_lvt l=0.15 w=0.74 ad=0.2072 as=0.2072 pd=2.04 ps=2.04
XM18 a_914_74##8 B1#5 VGND#10 VNB sky130_fd_pr__nfet_01v8_lvt l=0.15 w=0.74 ad=0.2072 as=0.2072 pd=2.04 ps=2.04
XM3 VGND#10 B1#4 a_914_74# VNB sky130_fd_pr__nfet_01v8_lvt l=0.15 w=0.74 ad=0.2072 as=0.1961 pd=2.04 ps=2.01
XM24 a_29_392##4 A2_N#6 a_114_392##15 VPB sky130_fd_pr__pfet_01v8 l=0.15 w=1 ad=0.275 as=0.3 pd=2.55 ps=2.6
XM12 a_114_392##15 A2_N#5 a_29_392##2 VPB sky130_fd_pr__pfet_01v8 l=0.15 w=1 ad=0.3 as=0.3 pd=2.6 ps=2.6
XM14 VPWR#12 A1_N#3 a_29_392##2 VPB sky130_fd_pr__pfet_01v8 l=0.15 w=1 ad=0.3 as=0.3 pd=2.6 ps=2.6
XM27 a_29_392# A1_N#1 VPWR#12 VPB sky130_fd_pr__pfet_01v8 l=0.15 w=1 ad=0.275 as=0.3 pd=2.55 ps=2.6
XM26 Y#5 a_114_392##11 a_539_368##8 VPB sky130_fd_pr__pfet_01v8 l=0.15 w=1.12 ad=0.336 as=0.308 pd=2.84 ps=2.79
XM25 Y#5 a_114_392##9 a_539_368##12 VPB sky130_fd_pr__pfet_01v8 l=0.15 w=1.12 ad=0.336 as=0.336 pd=2.84 ps=2.84
XM10 a_539_368##12 a_114_392##7 Y#1 VPB sky130_fd_pr__pfet_01v8 l=0.15 w=1.12 ad=0.336 as=0.336 pd=2.84 ps=2.84
XM5 a_539_368##5 a_114_392# Y#1 VPB sky130_fd_pr__pfet_01v8 l=0.15 w=1.12 ad=0.336 as=0.336 pd=2.84 ps=2.84
XM19 VPWR#9 B2#12 a_539_368##5 VPB sky130_fd_pr__pfet_01v8 l=0.15 w=1.12 ad=0.336 as=0.336 pd=2.84 ps=2.84
XM16 VPWR#9 B2#11 a_539_368##11 VPB sky130_fd_pr__pfet_01v8 l=0.15 w=1.12 ad=0.336 as=0.336 pd=2.84 ps=2.84
XM29 a_539_368##11 B2#7 VPWR#7 VPB sky130_fd_pr__pfet_01v8 l=0.15 w=1.12 ad=0.336 as=0.336 pd=2.84 ps=2.84
XM13 a_539_368##10 B2#5 VPWR#7 VPB sky130_fd_pr__pfet_01v8 l=0.15 w=1.12 ad=0.336 as=0.336 pd=2.84 ps=2.84
XM6 VPWR#5 B1#12 a_539_368##10 VPB sky130_fd_pr__pfet_01v8 l=0.15 w=1.12 ad=0.336 as=0.336 pd=2.84 ps=2.84
XM20 VPWR#5 B1#11 a_539_368##9 VPB sky130_fd_pr__pfet_01v8 l=0.15 w=1.12 ad=0.336 as=0.336 pd=2.84 ps=2.84
XM22 a_539_368##9 B1#8 VPWR#3 VPB sky130_fd_pr__pfet_01v8 l=0.15 w=1.12 ad=0.336 as=0.336 pd=2.84 ps=2.84
XM1 a_539_368# B1#1 VPWR#3 VPB sky130_fd_pr__pfet_01v8 l=0.15 w=1.12 ad=0.308 as=0.336 pd=2.79 ps=2.84
*
*
*       RESISTOR AND CAP/DIODE CARDS
*
Rg1	A2_N#1	A2_N#2	471.758209
Rg2	A2_N#2	A2_N#3	53.894333
Rg3	A2_N#3	A2_N#4	101.395874
Rg4	A2_N#2	A2_N#5	398.913605
Rg5	A2_N#3	A2_N#6	442.645020
Rg6	A1_N#1	A1_N#2	394.695099
Rg7	A1_N#2	A1_N#3	494.052399
Rg8	A1_N#2	A1_N#4	445.890747
Rg9	a_114_392#	a_114_392##2	676.474121
Rg10	a_114_392##2	a_114_392##3	193.167313
Rg11	a_114_392##3	a_114_392##4	68.612923
Rg12	a_114_392##4	a_114_392##5	79.856697
Rg13	a_114_392##5	a_114_392##6	507.366974
Rg14	a_114_392##2	a_114_392##7	463.019989
Rg15	a_114_392##3	a_114_392##8	365.484741
Rg16	a_114_392##3	a_114_392##9	454.433350
Rg17	a_114_392##4	a_114_392##10	306.145477
Rg18	a_114_392##4	a_114_392##11	490.267334
Rg19	a_114_392##5	a_114_392##12	292.883667
Rg20	B2#1	B2#2	397.555725
Rg21	B2#2	B2#3	66.369736
Rg22	B2#3	B2#4	57.428749
Rg23	B2#2	B2#5	449.655212
Rg24	B2#3	B2#6	394.514160
Rg25	B2#3	B2#7	447.610504
Rg26	B2#4	B2#8	385.158295
Rg27	B2#4	B2#9	90.033310
Rg28	B2#9	B2#10	418.139221
Rg29	B2#4	B2#11	431.330811
Rg30	B2#9	B2#12	454.869080
Rg31	B1#1	B1#2	455.914490
Rg32	B1#2	B1#3	90.016602
Rg33	B1#2	B1#4	426.989899
Rg34	B1#3	B1#5	404.209686
Rg35	B1#3	B1#6	57.428749
Rg36	B1#6	B1#7	395.494293
Rg37	B1#3	B1#8	429.126801
Rg38	B1#6	B1#9	66.386436
Rg39	B1#9	B1#10	397.555725
Rg40	B1#6	B1#11	448.603302
Rg41	B1#9	B1#12	449.655212
Rf1	A2_N	A2_N#4	7.873454
Rf2	A2_N#4	A2_N	6.692436
Rf3	a_29_392#	a_29_392##3	105.119629
Rf4	a_29_392##3	a_29_392##4	119.021851
Rf5	a_29_392##2	a_29_392##3	5.000000
Rf6	A1_N	A1_N#5	15.353235
Rf7	A1_N#5	A1_N	3.543054
Rf8	a_114_392##4	a_114_392##14	144.350372
Rf9	a_114_392##14	a_114_392##15	116.294197
Rf10	a_114_392##14	a_114_392##16	37.072105
Rf11	B2	B2#13	2.750425
Rf12	B2#13	B2	11.918507
Rf13	Y#1	Y#2	42.230213
Rf14	Y#2	Y	23.261898
Rf15	Y	Y#3	56.745438
Rf16	Y#3	Y#4	77.204659
Rf17	Y#2	Y#5	90.853760
Rf18	Y	Y#7	40.039341
Rf19	Y#7	Y#8	46.161751
Rf20	Y#3	Y#9	15.522211
Rf21	Y#6	Y#7	15.000000
Rf22	a_914_74#	a_914_74##2	80.271690
Rf23	a_914_74##2	a_914_74##4	81.103577
Rf24	a_914_74##4	a_914_74##6	58.010189
Rf25	a_914_74##6	a_914_74##7	58.999928
Rf26	a_914_74##2	a_914_74##8	21.341251
Rf27	a_914_74##3	a_914_74##4	7.500000
Rf28	a_914_74##5	a_914_74##6	15.000000
Rf29	a_539_368#	a_539_368##2	80.666893
Rf30	a_539_368##2	a_539_368##3	66.866013
Rf31	a_539_368##3	a_539_368##4	66.866013
Rf32	a_539_368##4	a_539_368##6	76.107391
Rf33	a_539_368##6	a_539_368##7	79.406776
Rf34	a_539_368##7	a_539_368##8	87.406158
Rf35	a_539_368##2	a_539_368##9	18.602406
Rf36	a_539_368##3	a_539_368##10	27.563665
Rf37	a_539_368##4	a_539_368##11	18.602406
Rf38	a_539_368##7	a_539_368##12	22.677097
Rf39	a_539_368##5	a_539_368##6	5.000000
Rf40	B1	B1#13	0.916808
Rf41	B1#13	B1	13.752123
Rf43	VPWR#2	VPWR#3	58.891026
Rf44	VPWR#2	VPWR#4	62.125736
Rf45	VPWR#4	VPWR#5	38.736572
Rf46	VPWR#4	VPWR#6	59.967037
Rf47	VPWR#6	VPWR#7	38.736572
Rf48	VPWR#6	VPWR#8	68.798325
Rf49	VPWR#8	VPWR#9	53.143215
Rf50	VPWR#8	VPWR#10	125.014397
Rf51	VPWR#10	VPWR#11	130.062698
Rf52	VPWR#11	VPWR#12	38.224945
Rf55	VGND#2	VGND#3	64.974709
Rf56	VGND#3	VGND#4	225.003815
Rf57	VGND#4	VGND#5	26.638899
Rf58	VGND#5	VGND#6	36.135464
Rf59	VGND#6	VGND#7	67.183754
Rf60	VGND#7	VGND#8	61.339714
Rf62	VGND#2	VGND#10	49.830547
Rf63	VGND#3	VGND#11	45.213318
Rf64	VGND#4	VGND#12	32.342297
Rf65	VGND#6	VGND#13	32.342297
Rf66	VGND#7	VGND#14	43.278866
Rf67	VGND#8	VGND#15	31.534733
Rf71	B2#4	B2#13	40.058201
Rf72	B1#3	B1#13	40.058201
Rf69	A1_N#2	A1_N#5	160.232803
Re1	VPWR#2	VPWR	3.735117
Re2	VPWR	VPWR#10	1.067176
Re3	VGND#2	VGND	3.735117
Re4	VGND	VGND#5	1.067176
*
*       CAPACITOR CARDS
*
*
C1	Y#5	Y#1	3.33078e-18
C2	a_114_392##14	A2_N#1	1.39874e-17
C3	VGND#5	a_114_392##3	3.24519e-20
C4	VPWR#8	B2#7	5.30308e-19
C5	Y#6	B2#10	4.3825e-17
C6	a_539_368##3	B1#11	4.81711e-19
C7	VGND#12	B2#8	3.33137e-19
C8	VPWR#6	B2#7	5.25111e-18
C9	Y#5	a_539_368##12	6.00465e-17
C10	Y#5	a_114_392##3	4.71375e-18
C11	a_914_74##7	B2#10	4.80128e-17
C12	a_539_368##2	B1#11	1.75131e-17
C13	Y#9	B2#8	2.55383e-19
C14	a_539_368##4	B1#12	4.34608e-20
C15	a_539_368##3	B2#2	3.92977e-19
C16	Y#6	a_114_392##8	3.16469e-19
C17	VGND#12	B2#10	2.35851e-18
C18	a_539_368##8	a_539_368##12	5.01824e-18
C19	VPWR#8	B2#11	5.25568e-18
C20	a_539_368##3	B1#12	2.028e-17
C21	a_914_74##7	B2#9	3.26426e-19
C22	a_914_74##7	a_114_392##8	1.50237e-18
C23	VPWR#6	B2#11	3.00302e-19
C24	Y#9	B2#10	6.67291e-19
C25	a_539_368##2	B1#12	1.11924e-19
C26	a_914_74#	VGND#10	4.84961e-17
C27	a_539_368##8	Y#5	7.84584e-17
C28	Y#6	a_114_392##10	1.02082e-19
C29	a_539_368##7	VPWR#8	6.72345e-18
C30	a_539_368##9	VPWR#4	6.26355e-18
C31	a_539_368##8	a_114_392##5	4.94387e-18
C32	VGND#12	a_114_392##8	3.64273e-17
C33	a_539_368##4	B2#5	1.11924e-19
C34	A2_N#3	A2_N#2	1.58074e-18
C35	a_539_368##3	B2#5	2.09737e-17
C36	VPWR#8	B2#12	7.11348e-18
C37	a_114_392##8	Y#9	1.70171e-17
C38	Y#3	VGND#12	9.32525e-18
C39	a_914_74##8	a_914_74#	2.09171e-18
C40	a_539_368##2	B2#5	4.34608e-20
C41	VPWR#6	B2#12	8.74044e-20
C42	VGND#12	a_114_392##10	1.99142e-18
C43	VGND#13	a_114_392##8	1.94862e-18
C44	a_29_392#	a_539_368##8	4.97398e-17
C45	a_539_368##4	B2#7	1.75361e-17
C46	B2#9	B2#4	4.0818e-18
C47	a_114_392##10	Y#9	1.86436e-17
C48	a_539_368##3	B2#7	5.69908e-19
C49	Y#4	a_114_392##8	3.06478e-19
C50	a_539_368##10	VPWR#6	5.25841e-18
C51	Y#3	Y#9	1.53635e-18
C52	a_914_74##8	VGND#10	3.99628e-17
C53	VPWR#8	a_114_392#	4.91559e-18
C54	B2#4	B2#2	4.0818e-18
C55	VPWR#12	a_539_368##8	2.29092e-18
C56	VGND#13	a_114_392##10	2.98978e-17
C57	a_914_74##2	B1#9	1.60237e-18
C58	Y#9	a_114_392##12	1.31985e-18
C59	a_539_368##4	B2#11	1.75418e-17
C60	a_539_368##10	VPWR#4	5.19734e-18
C61	a_539_368##4	VPWR#8	3.13618e-19
C62	Y#4	a_114_392##10	7.01302e-19
C63	a_29_392#	VPWR#12	6.69868e-17
C64	a_114_392##16	a_114_392##8	1.49989e-19
C65	VGND#11	VGND#10	3.28162e-19
C66	a_539_368##8	A2_N#2	2.75788e-19
C67	Y#3	VGND#13	1.55551e-17
C68	a_539_368##3	B2#11	2.62378e-19
C69	VGND#13	a_114_392##12	2.72058e-17
C70	VPWR#8	a_114_392##7	1.86473e-19
C71	a_914_74##2	B1#6	5.33764e-18
C72	Y#9	a_114_392##6	2.73945e-19
C73	a_29_392##2	a_29_392#	2.52173e-18
C74	a_539_368##3	a_539_368#	4.6216e-21
C75	Y#2	B2#5	1.34057e-19
C76	Y#4	a_114_392##12	2.63816e-17
C77	a_539_368##11	VPWR#8	8.48902e-18
C78	a_114_392##16	a_114_392##10	1.76124e-19
C79	a_539_368##4	B2#12	1.07385e-19
C80	a_114_392##4	B2#9	3.38031e-19
C81	a_539_368##4	VPWR#6	3.13618e-19
C82	VGND#11	a_914_74##8	3.99628e-17
C83	VGND#13	a_114_392##6	1.53508e-18
C84	a_29_392##2	VPWR#12	6.50088e-17
C85	a_539_368##3	B2#12	1.5759e-19
C86	a_539_368##2	a_539_368#	6.21728e-19
C87	a_539_368##11	VPWR#6	8.43957e-18
C88	a_114_392##4	a_114_392##5	1.61021e-17
C89	Y#4	a_114_392##6	3.45979e-17
C90	VPWR#8	a_114_392##9	6.40414e-20
C91	VGND#3	a_914_74##2	2.91756e-19
C92	a_114_392##16	a_114_392##12	2.76307e-19
C93	a_114_392##4	a_114_392##3	1.99465e-17
C94	Y#2	B2#7	1.92672e-19
C95	VGND#13	A1_N#4	3.15555e-19
C96	a_914_74##3	a_914_74##8	1.97519e-18
C97	a_114_392##6	VGND#14	1.40974e-17
C98	VGND#6	Y#3	5.26088e-19
C99	a_539_368##3	VPWR#6	3.13618e-19
C100	a_114_392##4	A2_N#2	8.90798e-20
C101	a_539_368##3	a_114_392#	1.06086e-19
C102	Y#4	A1_N#4	1.72217e-18
C103	a_539_368##7	a_114_392##7	2.19907e-17
C104	a_114_392##15	a_29_392##2	5.98028e-17
C105	a_539_368##2	VPWR#3	1.74636e-17
C106	a_114_392##16	a_114_392##6	7.47423e-19
C107	VGND#12	a_114_392##3	2.2046e-19
C108	Y#2	B2#11	3.06544e-19
C109	VPWR#8	a_114_392##11	4.1373e-20
C110	a_539_368##3	a_539_368##9	1.60699e-19
C111	VGND#14	A1_N#4	3.09184e-17
C112	a_914_74##3	VGND#11	4.55814e-17
C113	a_29_392##4	a_29_392##2	2.52173e-18
C114	a_539_368##5	VPWR#8	3.7044e-17
C115	Y#4	A2_N#1	3.82517e-19
C116	a_539_368##3	VPWR#4	3.13618e-19
C117	A1_N#4	a_114_392##16	1.40188e-17
C118	VGND#12	a_114_392##2	8.65916e-19
C119	a_539_368##2	a_539_368##9	9.88441e-19
C120	a_539_368##7	a_114_392##9	2.21087e-17
C121	A1_N#2	a_114_392##5	3.07767e-18
C122	VGND#14	A2_N#1	1.01238e-18
C123	B1#9	B1#6	4.0818e-18
C124	a_29_392##4	a_114_392##15	8.77644e-17
C125	VGND#15	A1_N#4	2.53732e-18
C126	Y#2	B2#12	5.29442e-19
C127	a_539_368##3	VPWR#5	1.22125e-17
C128	A2_N#1	a_114_392##16	1.96488e-17
C129	A2_N#2	A1_N#2	1.51704e-17
C130	a_539_368##2	VPWR#4	3.13618e-19
C131	VGND#15	A2_N#1	5.01544e-17
C132	a_114_392##3	Y#9	1.8777e-19
C133	VGND#14	a_114_392##14	2.05473e-17
C134	a_539_368##2	VPWR#5	1.30848e-17
C135	a_914_74##3	Y#8	4.91559e-17
C136	VGND#7	a_114_392##14	2.42607e-19
C137	Y#2	a_114_392#	6.06738e-18
C138	a_539_368##3	a_539_368##10	3.11986e-18
C139	a_539_368##4	VPWR#7	1.32159e-17
C140	a_114_392##14	a_114_392##16	1.36661e-19
C141	a_114_392##15	a_114_392##5	6.06224e-20
C142	a_114_392##5	VGND#13	5.53524e-19
C143	Y#2	a_114_392##7	1.60465e-17
C144	B1#5	B1#4	3.69144e-17
C145	a_539_368##3	VPWR#7	1.22181e-17
C146	a_29_392##2	A2_N#2	1.20237e-18
C147	A2_N#4	A2_N#2	5.53407e-18
C148	a_539_368##4	a_539_368##11	1.36226e-18
C149	Y#8	a_914_74##5	3.91118e-17
C150	a_539_368#	B1#1	5.51682e-17
C151	VGND#15	a_114_392##14	3.15456e-17
C152	B1#1	VPWR#3	2.70995e-17
C153	a_539_368##11	a_539_368##3	1.60699e-19
C154	B1#7	B1#5	4.00235e-17
C155	a_539_368#	B1#8	2.12167e-18
C156	a_914_74##3	a_914_74##7	3.8488e-20
C157	a_539_368##9	B1#1	1.99344e-18
C158	a_114_392##15	A2_N#3	1.02562e-17
C159	a_539_368##4	VPWR#9	1.74539e-17
C160	B1#8	VPWR#3	2.89893e-17
C161	a_114_392##5	Y#4	3.18695e-18
C162	VPWR#5	B1#1	2.70458e-19
C163	B1#6	B1#2	4.03955e-18
C164	VGND#3	B1#6	2.26697e-20
C165	VGND#7	a_114_392##5	1.0733e-20
C166	a_539_368##9	B1#8	5.23881e-17
C167	a_114_392##15	A2_N#2	1.41708e-17
C168	a_914_74##5	Y#6	3.62682e-17
C169	VGND#4	B2#9	5.2663e-20
C170	B1#10	B1#7	3.69993e-17
C171	a_539_368##7	Y#1	1.93591e-17
C172	VPWR#3	B1#11	6.54315e-19
C173	VPWR#5	B1#8	3.71489e-19
C174	a_539_368##5	a_539_368##4	6.21728e-19
C175	a_539_368##9	B1#11	4.59753e-17
C176	VPWR#3	B1#12	1.53981e-19
C177	B1#11	VPWR#5	2.21054e-17
C178	a_539_368##3	a_539_368##5	6.05209e-21
C179	B2#1	B1#10	4.09007e-17
C180	a_539_368##7	a_539_368##12	4.35239e-20
C181	a_29_392##4	A2_N#3	5.92318e-18
C182	a_29_392#	a_114_392##6	1.19463e-18
C183	a_539_368##9	B1#12	1.67533e-18
C184	a_539_368##10	B1#11	2.63233e-19
C185	a_539_368##4	a_539_368##3	5.1918e-19
C186	VGND#6	a_114_392##5	9.12304e-20
C187	Y#6	a_914_74##7	4.1813e-17
C188	VPWR#5	B1#12	4.28625e-17
C189	a_29_392##4	A2_N#2	1.28759e-19
C190	a_539_368##9	B2#5	1.63495e-19
C191	B1#12	a_539_368##10	1.98967e-17
C192	B2#6	B2#1	4.06232e-17
C193	a_539_368##7	Y#5	1.17824e-17
C194	VPWR#5	B2#5	1.65292e-18
C195	VPWR#7	B1#12	1.65292e-18
C196	Y#3	a_114_392##3	1.13168e-18
C197	Y#2	VPWR#7	2.34248e-20
C198	B2#5	a_539_368##10	2.52109e-17
C199	a_539_368##11	B1#12	1.63495e-19
C200	VPWR#7	B2#5	4.91311e-17
C201	B2#8	B2#6	4.06774e-17
C202	VGND#12	a_914_74##7	1.01949e-17
C203	Y#9	Y#6	1.18763e-18
C204	a_29_392##2	A2_N#1	3.26861e-18
C205	a_539_368##10	B2#7	2.63233e-19
C206	a_539_368##11	B2#5	1.67533e-18
C207	a_539_368##3	a_539_368##2	5.1918e-19
C208	B2#2	B1#9	3.48767e-17
C209	B2#7	VPWR#7	2.21054e-17
C210	VPWR#9	B2#5	1.53981e-19
C211	B2#10	B2#8	4.06774e-17
C212	a_539_368##11	B2#7	5.23858e-17
C213	VGND#3	B2#2	4.22022e-20
C214	a_114_392#	B2#9	9.24399e-18
C215	Y#2	a_114_392##3	1.76042e-18
C216	VPWR#7	B2#11	3.71489e-19
C217	VPWR#9	B2#7	3.44144e-19
C218	Y#9	VGND#12	2.44191e-17
C219	a_539_368##11	B2#11	4.59447e-17
C220	a_539_368##7	VPWR#10	6.41578e-17
C221	a_114_392##8	B2#10	1.7691e-18
C222	VPWR#7	B2#12	1.72497e-19
C223	B2#11	VPWR#9	2.46209e-17
C224	VGND#3	B1#5	1.12432e-18
C225	Y#2	a_114_392##2	1.13395e-17
C226	a_539_368##11	B2#12	1.66337e-18
C227	a_539_368##5	B2#11	1.92555e-18
C228	B1#6	VPWR#3	6.2216e-19
C229	VGND#13	VGND#12	2.30966e-18
C230	VGND#4	a_114_392##2	6.2996e-19
C231	B2#12	VPWR#9	2.79535e-17
C232	a_114_392##2	a_114_392#	6.18637e-18
C233	a_114_392##10	a_114_392##8	3.84112e-17
C234	a_539_368##5	B2#12	7.20605e-17
C235	VGND#4	B2#4	5.95222e-20
C236	B1#2	VPWR#3	5.98782e-19
C237	VGND#3	B2#4	1.11082e-19
C238	VGND#13	Y#9	2.44031e-17
C239	VGND#3	B1#7	6.5792e-18
C240	Y#2	Y#1	7.25355e-19
C241	a_914_74##2	a_539_368##3	4.32206e-19
C242	Y#2	a_539_368##7	2.57705e-18
C243	a_539_368##5	a_114_392#	7.09936e-17
C244	a_114_392##12	a_114_392##10	3.70554e-17
C245	VGND#7	a_114_392##4	6.95505e-19
C246	VPWR#8	B2#4	2.86596e-20
C247	a_114_392#	Y#1	2.04524e-17
C248	Y#4	Y#9	3.67592e-18
C249	VPWR#6	B2#4	2.01982e-20
C250	a_539_368##5	a_114_392##7	2.2722e-18
C251	a_539_368##12	a_114_392#	2.09336e-18
C252	a_114_392##3	a_114_392##7	2.59382e-18
C253	Y#2	a_539_368##12	2.02488e-17
C254	B1#6	a_539_368##9	6.21314e-19
C255	VGND#3	B1#10	6.18116e-18
C256	VGND#3	a_914_74##8	5.3707e-18
C257	a_114_392##7	Y#1	2.78275e-17
C258	Y#5	a_114_392#	2.63195e-19
C259	Y#3	Y#5	1.48548e-18
C260	a_114_392##6	a_114_392##12	3.74675e-17
C261	Y#4	VGND#13	3.9476e-17
C262	VGND#5	Y#3	5.26088e-19
C263	a_539_368##12	a_114_392##7	5.13331e-17
C264	VGND#7	A1_N#2	2.94259e-20
C265	A2_N#2	VGND#15	6.19847e-18
C266	Y#5	a_114_392##7	6.10158e-19
C267	Y#1	a_114_392##9	6.10158e-19
C268	a_539_368##4	B2#4	4.85422e-18
C269	VGND#3	B2#1	6.7546e-18
C270	a_539_368##12	a_114_392##9	4.47908e-17
C271	VGND#7	VGND#6	1.18143e-18
C272	a_114_392##16	Y#9	3.62345e-20
C273	A1_N#4	a_114_392##6	3.29211e-17
C274	B1#9	VPWR#5	6.29318e-19
C275	Y#5	a_114_392##9	5.43146e-17
C276	A1_N	a_114_392##5	4.69854e-18
C277	Y#1	a_114_392##11	2.63195e-19
C278	A1_N	a_114_392##3	3.64808e-19
C279	A1_N	a_114_392##2	7.17594e-20
C280	a_539_368##7	a_114_392##4	7.25749e-20
C281	a_539_368##8	a_114_392##9	2.48418e-18
C282	a_539_368##12	a_114_392##11	2.6342e-18
C283	A1_N	A2_N#2	4.54644e-18
C284	VGND#14	Y#4	4.54642e-17
C285	B1#6	VPWR#5	6.13865e-19
C286	A2_N#1	A1_N#4	4.41758e-17
C287	a_114_392##11	Y#5	2.37824e-17
C288	VGND#3	B2#6	6.07509e-18
C289	VGND#3	a_914_74##3	2.30246e-17
C290	a_539_368##8	a_114_392##11	9.32662e-17
C291	a_114_392##14	A2_N#3	2.04727e-18
C292	a_29_392#	a_114_392##11	4.35149e-18
C293	a_114_392##16	Y#4	3.28877e-18
C294	B1	B1#9	5.05017e-18
C295	VGND#4	B2#8	1.69629e-18
C296	B1	B1#6	3.65753e-17
C297	VPWR#12	a_114_392##11	2.20563e-19
C298	a_539_368##8	A1_N#1	5.9924e-18
C299	B1	B1#2	2.47027e-17
C300	a_29_392#	A1_N#1	7.66344e-17
C301	B1	B2#2	4.43371e-18
C302	Y#3	a_114_392##4	6.41265e-17
C303	a_114_392##16	VGND#14	4.31067e-17
C304	VGND#3	B2#8	3.95625e-18
C305	a_114_392##14	A2_N#2	1.23465e-17
C306	a_114_392##4	Y#2	2.72725e-18
C307	VGND#6	VGND#4	1.46556e-18
C308	A1_N#1	VPWR#12	2.0798e-17
C309	a_114_392##15	a_114_392##11	3.28167e-19
C310	a_539_368##8	A1_N#3	1.04728e-18
C311	a_114_392##11	a_114_392##3	3.06078e-18
C312	VGND#4	a_914_74##5	7.00668e-18
C313	a_29_392##2	A1_N#1	6.38194e-19
C314	a_114_392##14	a_114_392##4	9.1452e-20
C315	a_29_392#	A1_N#3	1.76564e-18
C316	VPWR#4	B1#6	8.18847e-21
C317	a_114_392##14	a_29_392#	4.6799e-19
C318	VGND#4	B2#10	5.35671e-18
C319	a_114_392##15	A1_N#1	4.84113e-19
C320	VGND#5	Y#9	1.04313e-17
C321	VPWR#12	A1_N#3	3.87979e-17
C322	a_539_368##8	A2_N#5	2.031e-19
C323	a_29_392##2	A1_N#3	3.0374e-17
C324	Y#2	A1_N#2	7.57616e-20
C325	a_29_392#	A2_N#5	2.11095e-19
C326	B1#8	B1#1	4.73439e-17
C327	VGND#3	B2#10	2.50714e-19
C328	VGND#3	a_914_74##5	3.12111e-17
C329	a_114_392##15	A1_N#3	2.54896e-18
C330	VPWR#12	A2_N#5	1.309e-18
C331	a_114_392##14	A1_N#2	1.55903e-17
C332	Y#8	B2#4	2.49057e-18
C333	B2	B1#9	5.48768e-18
C334	a_914_74#	B1#6	7.93277e-19
C335	VGND#15	a_114_392##16	5.09537e-17
C336	B2	B1#6	4.21604e-20
C337	a_914_74##5	B2#4	9.48554e-19
C338	a_29_392##4	A1_N#3	2.11095e-19
C339	a_29_392##2	A2_N#5	3.30568e-17
C340	B2	B2#9	1.98059e-17
C341	Y#6	B2#4	3.43896e-18
C342	B2	B2#2	9.05691e-18
C343	a_114_392##15	A2_N#5	4.65422e-17
C344	B1#11	B1#8	4.58636e-17
C345	a_914_74##7	B2#4	1.58669e-19
C346	B2	a_114_392##3	4.21096e-19
C347	B2	a_114_392##2	7.45466e-18
C348	a_29_392##4	A2_N#5	8.86137e-18
C349	a_29_392##2	A2_N#6	7.17196e-19
C350	a_114_392##3	B2#9	5.84877e-19
C351	a_114_392##14	A2_N#4	1.63195e-18
C352	a_914_74#	B1#2	2.13521e-18
C353	A2_N#6	a_114_392##15	2.10596e-17
C354	a_114_392##14	a_29_392##2	1.45599e-17
C355	a_914_74##2	B1#4	1.8692e-19
C356	VGND#6	a_114_392##10	1.52035e-18
C357	a_29_392##4	A2_N#6	6.13773e-17
C358	B1#12	B1#11	4.70164e-17
C359	VGND#4	a_914_74##7	2.72901e-17
C360	a_114_392##4	Y#9	6.90331e-19
C361	a_114_392##4	VGND#13	1.04431e-18
C362	VGND#7	a_114_392##12	7.06937e-19
C363	B2#5	B1#12	4.61993e-17
C364	VGND#10	B1#6	6.96029e-19
C365	Y#4	a_114_392##4	5.10568e-17
C366	a_914_74##2	B1#5	1.70515e-17
C367	VGND#6	a_114_392##12	1.22744e-18
C368	a_539_368##8	VPWR#10	5.06418e-17
C369	A2_N	A2_N#3	3.19162e-17
C370	A2_N	A2_N#2	3.40036e-19
C371	B2#7	B2#5	4.70164e-17
C372	a_114_392##2	B2#9	1.11223e-17
C373	VGND#10	B1#2	6.73524e-20
C374	VPWR#8	a_114_392##2	9.32765e-21
C375	B2#4	VPWR#7	6.47602e-19
C376	VGND#14	A1_N#2	5.95037e-19
C377	a_114_392##3	B2#10	2.14891e-19
C378	Y#3	Y#2	3.50149e-19
C379	a_539_368#	VPWR#3	5.25446e-17
C380	VGND#7	a_114_392##6	1.13928e-17
C381	a_914_74##2	B1#7	2.06026e-17
C382	B2#4	a_539_368##11	6.57862e-19
C383	VGND#7	VGND#13	1.76957e-18
C384	B2#4	VPWR#9	6.13865e-19
C385	B2#11	B2#7	4.58638e-17
C386	A2_N#2	A1_N#3	2.51496e-18
C387	a_539_368##9	a_539_368#	2.36849e-18
C388	B2#2	VPWR#7	6.22379e-19
C389	a_114_392##16	A2_N#4	1.08939e-18
C390	a_914_74##2	B1#10	1.26526e-19
C391	VGND#15	A2_N#4	1.0961e-17
C392	B2#12	B2#11	4.75303e-17
C393	Y	B2#9	1.2726e-18
C394	VGND#7	A1_N#4	6.60622e-18
C395	Y	B2#2	1.00776e-19
C396	Y	a_114_392##3	2.87729e-18
C397	VGND#7	Y#4	6.47039e-18
C398	Y	a_114_392##2	2.43507e-17
C399	a_539_368##9	VPWR#3	5.20507e-17
C400	a_114_392##4	Y#5	4.82732e-17
C401	a_114_392#	B2#12	4.65899e-17
C402	a_114_392##4	a_539_368##8	3.06829e-17
C403	a_914_74##2	B2#1	4.7366e-20
C404	VGND#11	B1#9	5.05143e-19
C405	VPWR#5	VPWR#3	1.94092e-18
C406	VGND#6	Y#4	7.55485e-18
C407	Y#5	A1_N#2	8.23644e-19
C408	VGND#7	A2_N#1	1.32128e-18
C409	a_114_392##7	a_114_392#	4.95037e-17
C410	a_539_368##8	A1_N#2	1.71336e-18
C411	a_114_392##15	a_114_392##4	9.95213e-19
C412	a_29_392#	A1_N#2	2.06803e-18
C413	VPWR#12	A1_N#2	7.03308e-19
C414	VPWR#5	a_539_368##9	5.30395e-17
C415	VGND#5	a_114_392##8	1.52755e-18
C416	VGND#11	B1#6	2.59788e-19
C417	a_29_392##2	A1_N#2	6.12261e-20
C418	a_114_392##9	a_114_392##7	4.63333e-17
C419	a_114_392##15	A1_N#2	4.02265e-18
C420	VPWR	a_114_392##5	2.5851e-18
C421	A1_N	Y#2	1.11138e-18
C422	B2#9	VPWR#9	6.06874e-19
C423	a_114_392##14	A1_N	4.6455e-17
C424	a_914_74#	B1#4	4.51848e-17
C425	a_539_368##10	a_539_368##9	1.79241e-18
C426	B1	a_539_368##3	1.56514e-17
C427	a_114_392##11	a_114_392##9	4.66721e-17
C428	B1	a_539_368##2	8.66938e-17
C429	VGND#7	a_114_392##16	5.20281e-18
C430	a_914_74##2	B1	8.29743e-17
C431	B1#4	VGND#10	1.47861e-17
C432	a_114_392##4	B2#10	1.44341e-19
C433	a_539_368##10	VPWR#5	5.11921e-17
C434	A1_N#1	a_114_392##11	4.12248e-18
C435	a_114_392##4	a_114_392##8	3.19067e-18
C436	a_914_74#	B1#5	1.91181e-18
C437	a_114_392##4	a_114_392##10	2.98578e-18
C438	B2	a_539_368##4	8.77678e-17
C439	B2	a_539_368##3	1.6434e-17
C440	a_914_74##8	B1#4	6.16437e-19
C441	a_114_392##4	a_114_392##12	2.98578e-18
C442	A1_N#3	A1_N#1	4.217e-17
C443	a_914_74#	B1	5.99004e-17
C444	a_114_392##4	a_114_392##6	1.23428e-17
C445	VGND#15	VGND#7	2.23873e-18
C446	a_914_74##2	a_914_74#	6.3426e-19
C447	VPWR#7	VPWR#5	2.59774e-18
C448	VGND#10	B1#5	2.79774e-17
C449	VGND	a_114_392##5	1.64937e-18
C450	VGND	a_114_392##3	1.65574e-19
C451	Y#2	B2	3.04536e-17
C452	VGND	a_114_392##2	9.60568e-19
C453	VGND	A2_N#3	2.36573e-19
C454	A1_N#2	a_114_392##6	7.51932e-18
C455	a_914_74#	B1#7	2.14555e-19
C456	A2_N#5	A1_N#3	4.31672e-17
C457	a_914_74##3	a_539_368##3	1.31054e-17
C458	B1#5	a_914_74##8	1.12206e-17
C459	A2_N#1	A1_N#2	8.64297e-18
C460	VPWR#7	a_539_368##10	5.11378e-17
C461	VGND#4	Y	8.40312e-18
C462	VGND#10	B1#7	1.00858e-18
C463	VPWR#10	a_114_392##7	4.46319e-18
C464	A2_N#6	A2_N#5	4.25944e-17
C465	a_914_74##2	VGND#10	1.58036e-17
C466	A2_N#4	A2_N#1	8.14108e-18
C467	VGND#11	B1#5	9.10358e-20
C468	VPWR#10	a_114_392##9	4.43427e-18
C469	Y#8	B2	3.89192e-17
C470	B1	a_539_368#	5.33729e-17
C471	A2_N	a_114_392##14	2.9702e-17
C472	Y#6	B2	6.63927e-17
C473	a_539_368##11	a_539_368##10	1.79241e-18
C474	VPWR#10	a_114_392##11	4.46319e-18
C475	a_914_74##8	B1#7	3.13941e-17
C476	Y#8	a_539_368##3	9.72575e-19
C477	A1_N	Y#5	6.34008e-18
C478	VGND#10	B1#10	2.60713e-20
C479	A1_N	a_29_392#	5.64493e-17
C480	Y#3	a_114_392##8	1.73503e-17
C481	B1#9	VNB	2.51829e-17
C482	a_914_74##2	a_914_74##8	5.26243e-19
C483	B1#6	VNB	5.56961e-17
C484	A1_N	VPWR#12	2.06895e-18
C485	B1#7	VGND#11	1.34115e-17
C486	B1#2	VNB	3.79953e-17
C487	B2#9	VNB	2.79526e-17
C488	a_539_368##11	VPWR#7	5.29637e-17
C489	B2#2	VNB	2.63162e-17
C490	a_114_392##5	VNB	2.84976e-17
C491	a_114_392##3	VNB	2.31657e-17
C492	Y	Y#2	4.70133e-18
C493	a_114_392##15	A1_N	1.01472e-17
C494	a_114_392##2	VNB	4.2779e-17
C495	A2_N#3	VNB	6.82605e-17
C496	A2_N#2	VNB	4.14524e-17
C497	VPWR	VPWR#8	8.56942e-17
C498	a_914_74##8	B1#10	1.31403e-18
C499	VPWR	VPWR#6	6.79329e-17
C500	VPWR	VPWR#4	1.32647e-17
C501	a_114_392##3	a_114_392##2	4.78914e-18
C502	a_914_74##3	B1#7	3.80285e-19
C503	VPWR	a_539_368##7	2.94054e-17
C504	A2_N	a_114_392##16	2.03462e-18
C505	B2	a_539_368##5	4.50684e-17
C506	VPWR	a_539_368##4	2.93961e-18
C507	A2_N	VGND#15	2.06477e-17
C508	VPWR#9	VPWR#7	1.94092e-18
C509	VPWR	a_539_368##3	2.53142e-18
C510	VGND#11	B1#10	2.78015e-17
C511	A1_N#2	a_114_392##11	9.37809e-19
C512	Y#3	a_114_392##10	1.20716e-17
C513	a_914_74##2	VGND#11	2.0926e-17
C514	Y	a_914_74##7	8.70705e-18
C515	Y	VGND#12	2.97662e-17
C516	VPWR	Y#2	2.47793e-18
C517	VGND	VGND#7	7.34544e-17
C518	a_914_74##8	B2#1	1.56207e-19
C519	VGND	VGND#6	4.68107e-17
C520	A1_N#3	A1_N#2	3.42949e-18
C521	VGND	VGND#4	1.09176e-16
C522	VGND	VGND#3	7.81057e-17
C523	a_914_74##3	B2#2	1.59417e-19
C524	a_914_74##3	B1#10	3.16508e-17
C525	VPWR#9	a_539_368##11	5.21059e-17
C526	VPWR#4	B1#1	1.47917e-19
C527	A1_N	a_114_392##6	5.54305e-18
C528	VGND#11	B2#1	1.00981e-18
C529	VGND	a_539_368##3	3.48438e-18
C530	a_539_368##3	B1#9	4.04535e-19
C531	A2_N	a_114_392##15	3.76064e-17
C532	Y#8	B1#10	9.36519e-19
C533	a_914_74##3	a_914_74##2	5.98929e-19
C534	A2_N	a_29_392##4	3.36635e-17
C535	a_114_392##4	VPWR#10	5.69436e-19
C536	VGND	Y#3	4.14888e-18
C537	Y	Y#1	1.05771e-19
C538	a_539_368##5	a_539_368##11	2.36849e-18
C539	VGND	Y#2	1.50129e-18
C540	VGND	a_114_392##14	1.41602e-17
C541	VGND#5	a_114_392##4	1.00906e-19
C542	a_914_74##3	B2#1	3.97217e-17
C543	B1	B1#1	3.40835e-18
C544	VGND#7	VNB	2.74251e-17
C545	B1	B1#8	2.02189e-18
C546	VPWR#8	VPWR#6	7.0017e-19
C547	VGND#6	VNB	2.3745e-17
C548	VGND#4	VNB	5.9691e-17
C549	VGND#3	VNB	6.11666e-17
C550	B1	B1#11	2.04676e-18
C551	VPWR	a_539_368##10	1.21964e-17
C552	VGND	a_914_74##3	1.93282e-17
C553	B1	B1#12	1.55431e-18
C554	VPWR#4	B1#8	3.00302e-19
C555	VGND	Y#8	6.44284e-18
C556	VPWR	a_539_368##11	1.72175e-17
C557	VPWR#8	VNB	3.95415e-17
C558	VGND#11	B2#6	6.76285e-20
C559	VPWR#6	VNB	2.63212e-17
C560	VGND	a_914_74##5	2.34626e-17
C561	VPWR#4	VNB	2.49249e-17
C562	B1	B2#5	3.4526e-19
C563	VGND	Y#6	9.5463e-18
C564	VPWR	a_539_368##5	2.22196e-17
C565	VGND	a_914_74##7	1.81264e-17
C566	VPWR	Y#1	7.46629e-18
C567	VGND	VGND#12	1.60604e-17
C568	a_539_368##5	VPWR#9	5.90477e-17
C569	a_539_368##7	VNB	5.82133e-18
C570	Y#8	B2#1	2.98328e-17
C571	VGND	Y#9	1.14898e-17
C572	VGND	VGND#13	1.57328e-17
C573	VPWR	Y#5	7.98694e-18
C574	a_539_368##3	VNB	3.06963e-18
C575	VGND	Y#4	1.58021e-17
C576	Y	B2#1	8.19876e-20
C577	B2	B1#11	1.77518e-19
C578	VPWR	a_539_368##8	2.52416e-17
C579	A2_N	A1_N#4	2.7371e-19
C580	Y	B2#6	1.06248e-19
C581	A1_N#2	a_114_392##4	1.09278e-18
C582	VPWR	a_29_392#	1.90745e-17
C583	VGND	a_114_392##16	1.24041e-17
C584	B2	B1#12	3.56616e-19
C585	A2_N	A2_N#1	5.00001e-18
C586	a_914_74##2	VNB	1.43615e-18
C587	VGND	VGND#15	2.17165e-17
C588	Y	B2#8	1.89381e-19
C589	A1_N	a_114_392##11	1.12976e-18
C590	B2	B2#5	1.62788e-19
C591	VPWR	a_29_392##2	1.36856e-17
C592	a_539_368##4	B2#9	8.71697e-19
C593	Y	B2#10	7.14049e-19
C594	Y#2	VNB	2.36623e-18
C595	VPWR	a_114_392##15	8.81671e-18
C596	Y	a_114_392##8	1.96366e-18
C597	B2	B2#7	2.0582e-18
C598	a_914_74##3	B2#6	1.07386e-18
C599	a_114_392##14	VNB	1.19522e-17
C600	VPWR	a_29_392##4	3.20818e-17
C601	Y	a_114_392##10	3.51303e-19
C602	B2	B2#11	2.0582e-18
C603	Y	a_114_392##12	1.93714e-19
C604	B2	B2#12	2.0411e-18
C605	a_914_74#	VNB	4.49905e-17
C606	Y	a_114_392##6	1.34609e-19
C607	VGND#10	VNB	2.37287e-19
C608	a_914_74##8	VNB	2.12109e-18
C609	B2	a_114_392#	6.76904e-18
C610	Y#8	B2#2	1.45411e-18
C611	a_539_368##7	a_114_392##3	4.20724e-21
C612	VGND#11	VNB	1.20161e-19
C613	a_914_74##3	VNB	5.77969e-18
C614	B2	a_114_392##7	2.7226e-19
C615	Y#8	VNB	5.01523e-19
C616	a_914_74##5	VNB	4.182e-18
C617	VGND	Y#5	2.89333e-18
C618	VGND#11	B2#8	3.60448e-20
C619	Y#6	VNB	1.56291e-18
C620	VGND	a_539_368##8	3.58719e-18
C621	a_914_74##7	VNB	7.78725e-18
C622	VGND#12	VNB	5.47427e-18
C623	Y#9	VNB	4.59962e-18
C624	VGND	a_29_392##2	3.0887e-18
C625	Y#8	B2#6	3.97987e-17
C626	Y#4	VNB	2.08738e-18
C627	VGND#14	VNB	7.86262e-20
C628	VPWR#4	B1#11	5.25752e-18
C629	a_114_392##16	VNB	4.64315e-18
C630	VGND	a_29_392##4	2.11301e-18
C631	VGND#15	VNB	3.87786e-18
C632	VPWR	a_114_392##6	8.9363e-19
C633	a_539_368#	VNB	5.11832e-17
C634	VPWR#3	VNB	2.82484e-18
C635	a_539_368##9	VNB	2.1429e-18
C636	VPWR#5	VNB	4.09278e-19
C637	VGND	B1#10	8.05866e-19
C638	a_539_368##10	VNB	4.60133e-18
C639	VGND	B2#1	6.10517e-19
C640	a_539_368##2	B1#9	4.91425e-19
C641	VPWR#7	VNB	4.09278e-19
C642	a_539_368##11	VNB	2.1429e-18
C643	VGND	B2#6	6.75927e-19
C644	VPWR#9	VNB	2.92383e-18
C645	a_914_74##3	B2#8	5.90724e-19
C646	VGND	B2#8	7.93456e-19
C647	a_539_368##5	VNB	2.11035e-18
C648	VGND	B2#10	1.60871e-18
C649	VGND	a_114_392##8	6.88738e-19
C650	VPWR#10	a_114_392##5	8.10687e-19
C651	a_539_368##5	Y#1	6.02474e-17
C652	VPWR	B1#12	1.11033e-18
C653	Y#5	VNB	7.46013e-19
C654	VGND	a_114_392##10	6.86454e-19
C655	a_539_368##8	VNB	1.99567e-17
C656	VPWR	B2#5	1.11926e-18
C657	a_914_74##5	B2#6	3.37376e-17
C658	VGND	a_114_392##12	6.0708e-19
C659	a_29_392#	VNB	1.49569e-17
C660	VPWR#12	VNB	4.09278e-19
C661	VGND	a_114_392##6	2.07799e-18
C662	VPWR	B2#7	7.02477e-19
C663	a_114_392##4	A1_N	2.78158e-17
C664	a_29_392##2	VNB	3.33672e-18
C665	VGND	A1_N#4	6.85912e-19
C666	a_114_392##14	a_114_392##6	4.35471e-19
C667	VPWR	B2#11	8.27752e-19
C668	a_114_392##15	VNB	4.19123e-18
C669	VGND	A2_N#1	1.59948e-18
C670	a_29_392##4	VNB	5.87304e-17
C671	VPWR	B2#12	6.17352e-19
C672	A1_N	A1_N#2	2.47145e-17
C673	VPWR#10	a_114_392##3	2.31172e-20
C674	B1#4	VNB	3.14678e-17
C675	B1#5	VNB	2.52122e-17
C676	VPWR	a_114_392#	1.41546e-18
C677	a_539_368##3	B1#1	2.19936e-19
C678	VGND#11	B2#10	3.06144e-20
C679	B1#7	VNB	2.68377e-17
C680	VPWR	a_114_392##7	1.56884e-18
C681	B1#10	VNB	2.55158e-17
C682	VPWR#6	B1#12	3.95328e-19
C683	B2#1	VNB	3.03233e-17
C684	a_539_368##7	a_114_392##2	1.21781e-19
C685	VPWR	a_114_392##9	1.65805e-18
C686	B2#6	VNB	3.02533e-17
C687	B2	B2#4	3.87139e-17
C688	B2#8	VNB	3.05128e-17
C689	VPWR	a_114_392##11	1.52541e-18
C690	B2#10	VNB	3.42762e-17
C691	VPWR#10	a_114_392##2	6.48111e-20
C692	VPWR	A1_N#1	6.23083e-19
C693	a_114_392##8	VNB	2.66899e-17
C694	a_114_392##10	VNB	2.25363e-17
C695	VPWR	A1_N#3	1.29029e-18
C696	a_114_392##12	VNB	2.20259e-17
C697	a_114_392##6	VNB	4.8927e-17
C698	VPWR	A2_N#5	1.49429e-18
C699	VPWR#6	VPWR#4	1.14549e-19
C700	A1_N#4	VNB	2.8638e-17
C701	VPWR	A2_N#6	2.22248e-18
C702	A2_N#1	VNB	3.73347e-17
C703	a_539_368##12	a_539_368##5	5.01824e-18
C704	a_539_368##2	B1#1	1.94029e-19
C705	B1#1	VNB	4.15307e-17
C706	B1#8	VNB	3.24964e-17
C707	a_539_368##12	a_114_392##3	3.09141e-19
C708	VPWR#4	B1#12	4.71655e-18
C709	B1#11	VNB	3.05734e-17
C710	a_914_74##3	B2#10	4.337e-19
C711	B1#12	VNB	2.83131e-17
C712	Y	B2#4	3.55962e-19
C713	A2_N	A2_N#4	4.40173e-17
C714	B2#5	VNB	2.73882e-17
C715	VPWR	VPWR#10	9.0881e-17
C716	B2#7	VNB	3.0588e-17
C717	a_114_392##4	Y	1.82608e-17
C718	B2#11	VNB	3.2131e-17
C719	a_539_368##2	B1#6	4.68619e-18
C720	B2#12	VNB	3.38817e-17
C721	a_914_74##5	B2#8	3.37224e-17
C722	a_114_392#	VNB	4.18678e-17
C723	a_114_392##7	VNB	3.53241e-17
C724	a_114_392##9	VNB	3.17405e-17
C725	a_114_392##11	VNB	4.18262e-17
C726	VPWR	a_114_392##4	8.77365e-18
C727	A1_N#1	VNB	3.26752e-17
C728	VPWR	A1_N#2	1.19537e-20
C729	a_539_368##4	B2#2	4.91425e-19
C730	A1_N#3	VNB	2.88055e-17
C731	VGND	VGND#5	1.84464e-17
C732	VPWR#8	B2#5	8.1728e-20
C733	A2_N#5	VNB	3.10861e-17
C734	a_114_392##14	A1_N#4	9.98173e-18
C735	A2_N#6	VNB	4.2456e-17
C736	VGND	a_114_392##4	1.22373e-17
C737	B2	B1	1.71118e-17
C738	VGND	A1_N#2	5.62535e-19
C739	a_914_74##5	B2#2	1.28462e-19
C740	VPWR#10	VNB	5.3164e-17
C741	VGND	A2_N#4	1.34345e-17
C742	VGND#5	VNB	1.05013e-17
C743	a_539_368##3	B1#8	2.13148e-19
C744	a_539_368##12	Y#1	5.09848e-17
C745	B2#4	VNB	5.59243e-17
C746	a_539_368##12	a_114_392##2	3.76151e-19
C747	a_114_392##4	VNB	5.24724e-17
C748	A1_N#2	VNB	5.27375e-17
C749	Y#6	B2#8	3.97987e-17
C750	VPWR	A1_N	4.71107e-18
C751	A2_N#4	VNB	1.02424e-16
C752	Y	B2	2.75074e-17
C753	VPWR#6	B2#5	4.9096e-18
C754	VGND	A1_N	3.8292e-18
C755	VPWR	B2	1.07066e-17
C756	Y#6	B2#9	1.84435e-18
C757	VPWR	A2_N	3.0865e-18
C758	VGND	B2	1.08906e-17
C759	VGND#12	B2#6	2.25627e-19
C760	A1_N	VNB	6.41024e-18
C761	VGND	A2_N	1.7327e-17
C762	B1	VNB	5.20636e-17
C763	B2	VNB	1.75854e-17
C764	VGND	Y	1.8344e-17
C765	A2_N	VNB	4.57492e-17
C766	a_539_368##2	B1#8	1.74841e-17
C767	Y	VNB	1.83934e-17
C768	VPWR	VNB	3.07484e-16
C769	VGND	VNB	3.05551e-16
C770	VPWR#4	B2#5	3.95329e-19
C771	a_539_368##2	B1#2	8.60074e-19
C772	VGND#2	B1#10	3.12597e-19
C773	VGND#2	a_914_74#	3.78255e-17
C774	VGND#8	A2_N#2	2.57145e-19
C775	B1	VPWR#2	1.60432e-17
C776	VPWR#11	A2_N#5	5.01164e-18
C777	VPWR#2	a_539_368##3	5.64655e-19
C778	VPWR#2	B1#8	6.08984e-18
C779	VGND	VGND#8	9.8557e-17
C780	VGND#8	A2_N#1	1.25158e-18
C781	VGND#2	a_914_74##8	2.14839e-17
C782	VPWR#2	B1#12	9.04276e-20
C783	a_29_392#	VPWR#11	1.78491e-17
C784	VGND#2	B1#9	1.61907e-20
C785	VPWR#11	A1_N#3	4.63276e-18
C786	VPWR#2	VPWR#4	5.27837e-17
C787	VGND#2	VNB	1.75098e-16
C788	VGND#2	B1#4	7.65803e-18
C789	VGND#2	a_914_74##3	2.28772e-19
C790	VGND#8	A2_N#3	3.03e-19
C791	VPWR#2	VNB	1.72901e-16
C792	VGND#2	B1#2	4.56785e-20
C793	VPWR#11	a_539_368##8	2.14232e-18
C794	VPWR#11	A1_N#1	5.42181e-18
C795	VGND#2	a_914_74##2	3.66037e-18
C796	VGND#2	B1#7	1.74257e-18
C797	VPWR#11	a_114_392##5	7.34082e-19
C798	VPWR#11	VNB	8.73857e-17
C799	VPWR#11	A2_N#1	2.04296e-20
C800	VGND#8	a_114_392##16	5.25224e-18
C801	A1_N	VPWR#11	6.61479e-19
C802	a_539_368#	VPWR#2	4.04749e-17
C803	VGND#8	A2_N#4	8.88936e-18
C804	VPWR#11	a_114_392##11	1.7761e-19
C805	VPWR#2	B1#6	3.79399e-20
C806	VPWR#2	B1#1	8.75114e-18
C807	a_539_368##9	VPWR#2	2.78825e-17
C808	a_29_392##4	VPWR#11	6.4759e-17
C809	a_539_368##2	VPWR#2	3.24859e-18
C810	VPWR#2	B1#11	1.23279e-18
C811	VPWR#11	a_114_392##9	4.14473e-20
C812	VPWR	VPWR#11	1.64427e-16
C813	VGND#2	VGND#3	5.54541e-17
C814	VGND#2	B1#6	5.39539e-20
C815	VPWR#11	a_114_392##6	8.43738e-19
C816	VGND#8	A1_N#2	2.16931e-20
C817	VPWR#11	A2_N#2	3.40874e-20
C818	VGND#8	VNB	5.84936e-17
C819	VGND#2	B1#5	6.85313e-18
C820	VGND#8	a_114_392##14	3.31293e-18
C821	VGND#2	B1	1.75378e-17
C822	a_29_392##2	VPWR#11	2.56485e-17
C823	VPWR#11	A2_N#6	4.76224e-18
C824	VGND#8	VGND#7	1.45378e-18
C825	VPWR#11	A2_N#3	5.69087e-20
C826	VGND#8	A2_N	1.41484e-17
*
*
.ENDS sky130_fd_sc_hs__a2bb2oi_4
*
