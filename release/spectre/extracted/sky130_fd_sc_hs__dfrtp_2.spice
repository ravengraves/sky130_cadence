* Extracted by Quantus, converted by sky130cad/quantus.py
*
*
*
*                       LINUX           Wed Nov 18 08:27:33 2026
*
*
*
*  PROGRAM  advgen
*
*  Name           : advgen - Quantus - (64-bit)
*  Version        : 25.1.0-p047
*  Build Date     : Thu Dec 11 23:20:30 PST 2025
*
*  HSPICE LIBRARY
*
*  OPERATING_TEMPERATURE 150
*  QRC_TECH_DIR <path>/tech
*
*
*

*
.SUBCKT sky130_fd_sc_hs__dfrtp_2 VPB VNB VGND RESET_B VPWR Q D CLK
*
*
*  caps2d version: 10
*
*
*       TRANSISTOR CARDS
*
*
XM28 a_30_78##5 D#1 a_117_78# VNB sky130_fd_pr__nfet_01v8_lvt l=0.15 w=0.42 ad=0.1197 as=0.1008 pd=1.41 ps=1.32
XM24 a_117_78# RESET_B#3 VGND#16 VNB sky130_fd_pr__nfet_01v8_lvt l=0.15 w=0.42 ad=0.1008 as=0.1197 pd=1.32 ps=1.41
XM8 a_306_74##12 CLK#3 VGND#15 VNB sky130_fd_pr__nfet_01v8_lvt l=0.15 w=0.74 ad=0.2109 as=0.3108 pd=2.05 ps=2.32
XM19 VGND#15 a_306_74##8 a_490_362##13 VNB sky130_fd_pr__nfet_01v8_lvt l=0.15 w=0.74 ad=0.3108 as=0.2109 pd=2.32 ps=2.05
XM3 a_30_78# a_306_74##9 a_696_457##10 VNB sky130_fd_pr__nfet_01v8_lvt l=0.15 w=0.42 ad=0.1197 as=0.147 pd=1.41 ps=1.54
XM9 a_696_457##10 a_490_362# a_817_138# VNB sky130_fd_pr__nfet_01v8_lvt l=0.15 w=0.42 ad=0.147 as=0.1008 pd=1.54 ps=1.32
XM0 a_817_138# a_837_359# a_895_138# VNB sky130_fd_pr__nfet_01v8_lvt l=0.15 w=0.42 ad=0.1008 as=0.1008 pd=1.32 ps=1.32
XM16 a_895_138# RESET_B#7 VGND#14 VNB sky130_fd_pr__nfet_01v8_lvt l=0.15 w=0.42 ad=0.1008 as=0.706575 pd=1.32 ps=3.68
XM11 VGND#14 a_696_457##4 a_837_359##7 VNB sky130_fd_pr__nfet_01v8_lvt l=0.15 w=0.74 ad=0.706575 as=0.2405 pd=3.68 ps=2.13
XM29 a_837_359##7 a_490_362##5 a_1271_74##10 VNB sky130_fd_pr__nfet_01v8_lvt l=0.15 w=0.74 ad=0.2405 as=0.458 pd=2.13 ps=3.28
XM20 a_1271_74##10 a_306_74# a_1481_81# VNB sky130_fd_pr__nfet_01v8_lvt l=0.15 w=0.42 ad=0.458 as=0.1008 pd=3.28 ps=1.32
XM4 a_1481_81# a_1525_212# VGND#13 VNB sky130_fd_pr__nfet_01v8_lvt l=0.15 w=0.42 ad=0.1008 as=0.1554 pd=1.32 ps=1.58
XM30 VGND#13 RESET_B#9 a_1663_81# VNB sky130_fd_pr__nfet_01v8_lvt l=0.15 w=0.42 ad=0.1554 as=0.1008 pd=1.58 ps=1.32
XM26 a_1663_81# a_1271_74##4 a_1525_212##4 VNB sky130_fd_pr__nfet_01v8_lvt l=0.15 w=0.42 ad=0.1008 as=0.1176 pd=1.32 ps=1.4
XM6 VGND#12 a_1271_74# a_1921_409##11 VNB sky130_fd_pr__nfet_01v8_lvt l=0.15 w=0.74 ad=0.2072 as=0.2109 pd=2.04 ps=2.05
XM17 VGND#11 a_1921_409##6 Q#3 VNB sky130_fd_pr__nfet_01v8_lvt l=0.15 w=0.74 ad=0.2109 as=0.2072 pd=2.05 ps=2.04
XM15 Q#3 a_1921_409# VGND#1 VNB sky130_fd_pr__nfet_01v8_lvt l=0.15 w=0.74 ad=0.2072 as=0.2072 pd=2.04 ps=2.04
XM7 VPWR#17 D#3 a_30_78##6 VPB sky130_fd_pr__pfet_01v8 l=0.15 w=0.42 ad=0.1197 as=0.126 pd=1.41 ps=1.44
XM33 a_30_78##6 RESET_B#4 VPWR#16 VPB sky130_fd_pr__pfet_01v8 l=0.15 w=0.42 ad=0.126 as=0.1176 pd=1.44 ps=1.4
XM5 a_306_74##13 CLK#1 VPWR#14 VPB sky130_fd_pr__pfet_01v8 l=0.15 w=1.12 ad=0.3136 as=0.336 pd=2.8 ps=2.84
XM27 VPWR#14 a_306_74##7 a_490_362##12 VPB sky130_fd_pr__pfet_01v8 l=0.15 w=1.12 ad=0.336 as=0.3136 pd=2.84 ps=2.8
XM13 a_30_78##2 a_490_362##3 a_696_457##8 VPB sky130_fd_pr__pfet_01v8 l=0.15 w=0.42 ad=0.1218 as=0.126 pd=1.42 ps=1.44
XM1 a_696_457##8 a_306_74##6 a_786_457# VPB sky130_fd_pr__pfet_01v8 l=0.15 w=0.42 ad=0.126 as=0.1134 pd=1.44 ps=1.38
XM21 a_786_457# a_837_359##3 VPWR#11 VPB sky130_fd_pr__pfet_01v8 l=0.15 w=0.42 ad=0.1134 as=0.2786 pd=1.38 ps=2.34
XM14 VPWR#11 RESET_B#8 a_696_457##9 VPB sky130_fd_pr__pfet_01v8 l=0.15 w=0.42 ad=0.2786 as=0.1239 pd=2.34 ps=1.43
XM18 VPWR#9 a_696_457# a_837_359##4 VPB sky130_fd_pr__pfet_01v8 l=0.15 w=1 ad=0.295 as=0.368125 pd=2.59 ps=2.86
XM23 a_837_359##4 a_306_74##2 a_1271_74##8 VPB sky130_fd_pr__pfet_01v8 l=0.15 w=1 ad=0.368125 as=0.453925 pd=2.86 ps=3.66
XM2 a_1271_74##8 a_490_362##6 a_1478_493# VPB sky130_fd_pr__pfet_01v8 l=0.15 w=0.42 ad=0.453925 as=0.1134 pd=3.66 ps=1.38
XM22 a_1478_493# a_1525_212##3 VPWR#7 VPB sky130_fd_pr__pfet_01v8 l=0.15 w=0.42 ad=0.1134 as=0.147 pd=1.38 ps=1.54
XM31 VPWR#7 RESET_B#11 a_1525_212##7 VPB sky130_fd_pr__pfet_01v8 l=0.15 w=0.42 ad=0.147 as=0.2352 pd=1.54 ps=1.96
XM10 a_1525_212##7 a_1271_74##6 VPWR#5 VPB sky130_fd_pr__pfet_01v8 l=0.15 w=0.42 ad=0.2352 as=0.3276 pd=1.96 ps=2.55
XM25 VPWR#5 a_1271_74##5 a_1921_409##10 VPB sky130_fd_pr__pfet_01v8 l=0.15 w=0.84 ad=0.3276 as=0.2478 pd=2.55 ps=2.27
XM32 VPWR#4 a_1921_409##7 Q#1 VPB sky130_fd_pr__pfet_01v8 l=0.15 w=1.12 ad=0.3584 as=0.336 pd=2.88 ps=2.84
XM12 Q#1 a_1921_409##5 VPWR#1 VPB sky130_fd_pr__pfet_01v8 l=0.15 w=1.12 ad=0.336 as=0.3304 pd=2.84 ps=2.83
*
*
*       RESISTOR AND CAP/DIODE CARDS
*
Rg1	D#1	D#2	317.704102
Rg2	D#2	D#3	451.289124
Rg3	RESET_B#1	RESET_B#2	4.834517
Rg4	RESET_B#2	RESET_B#3	448.992950
Rg5	RESET_B#2	RESET_B#4	443.537872
Rg6	CLK#1	CLK#2	442.817719
Rg7	CLK#2	CLK#3	377.742493
Rg8	a_490_362#	a_490_362##2	624.064209
Rg9	a_490_362##2	a_490_362##3	324.847656
Rg10	a_837_359#	a_837_359##2	557.729431
Rg11	a_837_359##2	a_837_359##3	250.751389
Rg12	RESET_B#5	RESET_B#6	26.676205
Rg13	RESET_B#6	RESET_B#7	535.091370
Rg14	RESET_B#6	RESET_B#8	248.803528
Rg15	a_696_457#	a_696_457##2	408.064636
Rg16	a_696_457##2	a_696_457##3	48.064560
Rg17	a_696_457##2	a_696_457##4	341.183014
Rg18	a_490_362##4	a_490_362##5	692.665833
Rg19	a_490_362##6	a_490_362##7	255.594910
Rg20	a_306_74#	a_306_74##2	1391.874512
Rg21	a_306_74##2	a_306_74##3	1839.146240
Rg22	a_306_74##3	a_306_74##4	1396.022583
Rg23	a_306_74##4	a_306_74##5	36.728947
Rg24	a_306_74##3	a_306_74##6	296.970245
Rg25	a_306_74##4	a_306_74##7	407.140045
Rg26	a_306_74##5	a_306_74##8	297.644440
Rg27	a_306_74##5	a_306_74##9	617.284729
Rg28	a_1525_212#	a_1525_212##2	287.852539
Rg29	a_1525_212##2	a_1525_212##3	717.208069
Rg30	RESET_B#9	RESET_B#10	808.138977
Rg31	RESET_B#10	RESET_B#11	255.290619
Rg32	a_1271_74#	a_1271_74##2	487.382751
Rg33	a_1271_74##2	a_1271_74##3	270.660217
Rg34	a_1271_74##3	a_1271_74##4	598.250793
Rg35	a_1271_74##2	a_1271_74##5	427.050812
Rg36	a_1271_74##3	a_1271_74##6	409.677429
Rg37	a_1921_409#	a_1921_409##2	343.439178
Rg38	a_1921_409##2	a_1921_409##3	192.180481
Rg39	a_1921_409##3	a_1921_409##4	186.375366
Rg40	a_1921_409##2	a_1921_409##5	525.154541
Rg41	a_1921_409##3	a_1921_409##6	343.842529
Rg42	a_1921_409##3	a_1921_409##7	524.520081
Rf1	D	D#4	5.647728
Rf2	D#4	D	7.412643
Rf3	RESET_B#1	RESET_B#13	53.942986
Rf4	RESET_B#14	RESET_B	10.309834
Rf5	RESET_B#13	RESET_B#14	17.937956
Rf6	CLK	CLK#2	174.424850
Rf7	a_306_74##5	a_306_74##11	227.936676
Rf8	a_306_74##11	a_306_74##12	19.159866
Rf9	a_306_74##11	a_306_74##13	76.665009
Rf10	a_30_78#	a_30_78##3	165.690704
Rf11	a_30_78##3	a_30_78##4	165.862854
Rf12	a_30_78##4	a_30_78##5	157.508240
Rf13	a_30_78##4	a_30_78##6	38.276512
Rf14	a_30_78##2	a_30_78##3	15.000000
Rf15	RESET_B#16	RESET_B#17	11.254055
Rf16	RESET_B#5	RESET_B#19	161.709076
Rf17	RESET_B#16	RESET_B#19	2.937730
Rf18	a_696_457##3	a_696_457##6	259.008789
Rf19	a_696_457##6	a_696_457##7	50.136822
Rf20	a_696_457##7	a_696_457##8	40.545063
Rf21	a_696_457##6	a_696_457##9	35.883732
Rf22	a_696_457##7	a_696_457##10	128.666718
Rf23	a_837_359##4	a_837_359##5	84.633240
Rf24	a_837_359##5	a_837_359##2	334.383972
Rf25	a_837_359##5	a_837_359##7	22.070141
Rf26	a_490_362##7	a_490_362##4	195.554733
Rf27	a_490_362##4	a_490_362##10	422.590485
Rf28	a_490_362##10	a_490_362##11	63.824791
Rf29	a_490_362##11	a_490_362##12	32.061905
Rf30	a_490_362##10	a_490_362##13	23.292347
Rf31	a_490_362##11	a_490_362##2	175.598114
Rf32	RESET_B#20	RESET_B#21	0.843932
Rf33	RESET_B#22	RESET_B#10	161.076736
Rf34	RESET_B#21	RESET_B#22	11.383702
Rf35	a_1271_74##3	a_1271_74##9	338.998016
Rf36	a_1271_74##9	a_1271_74##10	158.986389
Rf37	a_1271_74##8	a_1271_74##9	7.500000
Rf38	a_1525_212##4	a_1525_212##5	38.836884
Rf39	a_1525_212##5	a_1525_212##2	231.718811
Rf40	a_1525_212##5	a_1525_212##7	166.043564
Rf41	a_1921_409##4	a_1921_409##9	164.983810
Rf42	a_1921_409##9	a_1921_409##10	51.817974
Rf43	a_1921_409##9	a_1921_409##11	36.417549
Rf44	Q	Q#2	0.196836
Rf45	Q#2	Q	14.369054
Rf46	Q	Q#4	7.282945
Rf47	Q#4	Q	7.282945
Rf48	Q#1	Q#2	5.000000
Rf49	Q#3	Q#4	7.500000
Rf50	VGND#1	VGND#2	108.421173
Rf51	VGND#2	VGND#3	72.385628
Rf52	VGND#3	VGND#4	17.199682
Rf53	VGND#4	VGND#5	83.216850
Rf54	VGND#5	VGND#6	207.888870
Rf55	VGND#6	VGND#7	129.420319
Rf56	VGND#7	VGND#8	86.540306
Rf57	VGND#8	VGND#9	74.519791
Rf59	VGND#2	VGND#11	41.038895
Rf60	VGND#3	VGND#12	38.992386
Rf61	VGND#5	VGND#13	29.551975
Rf62	VGND#6	VGND#14	21.042736
Rf63	VGND#8	VGND#15	36.082184
Rf64	VGND#9	VGND#16	41.120300
Rf65	VPWR#1	VPWR#2	117.411003
Rf66	VPWR#2	VPWR#3	89.462326
Rf67	VPWR#2	VPWR#4	38.286041
Rf68	VPWR#3	VPWR#5	40.957939
Rf69	VPWR#3	VPWR#6	84.714043
Rf70	VPWR#6	VPWR#7	37.460041
Rf71	VPWR#6	VPWR#8	166.506073
Rf72	VPWR#8	VPWR#9	44.191132
Rf73	VPWR#8	VPWR#10	79.941223
Rf74	VPWR#10	VPWR#11	30.964441
Rf75	VPWR#10	VPWR#12	89.462326
Rf76	VPWR#12	VPWR#13	88.366570
Rf77	VPWR#13	VPWR#14	33.916985
Rf78	VPWR#13	VPWR#15	71.540421
Rf79	VPWR#15	VPWR#16	33.326477
Rf80	VPWR#15	VPWR#17	98.032440
Rf81	D#2	D#4	53.410934
Re1	RESET_B#20	RESET_B#17	14.521620
Re2	RESET_B#17	RESET_B	6.390494
Re4	VPWR#3	VPWR	2.268450
Re5	VPWR	VPWR#12	1.620321
Re6	VGND#4	VGND	2.268450
Re7	VGND	VGND#7	1.620321
*
*       CAPACITOR CARDS
*
*
C1	RESET_B#17	a_837_359##4	4.04806e-17
C2	VPWR#16	D#3	2.29408e-18
C3	a_696_457##10	RESET_B#7	7.69271e-19
C4	a_30_78##2	a_306_74##3	6.28944e-18
C5	VPWR#17	RESET_B#4	2.43029e-18
C6	a_490_362##4	VGND#13	2.60766e-17
C7	RESET_B#17	VPWR#9	4.04111e-17
C8	a_490_362##13	a_696_457##4	1.15146e-18
C9	a_490_362#	a_306_74##3	1.96508e-19
C10	a_837_359##5	VGND#14	7.13373e-18
C11	D#3	a_30_78##6	1.21064e-17
C12	a_1921_409##7	a_1921_409##5	5.17214e-17
C13	a_490_362##13	a_30_78#	7.7782e-17
C14	VGND#12	VPWR#5	2.40289e-18
C15	RESET_B#17	a_696_457##9	9.63604e-18
C16	VPWR#11	a_490_362##12	1.39136e-20
C17	a_837_359##5	a_306_74##2	2.44636e-18
C18	a_306_74##3	a_306_74##6	9.97265e-19
C19	VPWR#17	D#3	2.84566e-17
C20	a_1271_74##10	a_490_362##4	2.0771e-16
C21	VPWR#4	a_1921_409##4	8.88429e-18
C22	a_1525_212##5	a_1271_74##4	4.76561e-18
C23	a_696_457##10	a_837_359#	5.32188e-18
C24	RESET_B#17	VPWR#11	3.66231e-18
C25	a_1921_409##9	a_1921_409##3	1.64418e-18
C26	a_306_74##4	a_306_74##3	1.34634e-19
C27	VGND#6	a_696_457##4	7.34616e-18
C28	VPWR#12	a_1271_74##8	7.16245e-18
C29	a_490_362##12	a_306_74##4	4.8864e-17
C30	a_490_362##13	RESET_B#7	1.8403e-17
C31	a_1271_74##8	VPWR#8	1.12514e-17
C32	a_30_78##2	a_696_457##8	5.46833e-17
C33	a_306_74##3	a_895_138#	1.13404e-18
C34	a_490_362##4	VGND#14	3.99507e-18
C35	a_1271_74##5	a_1921_409##7	6.19465e-18
C36	VPWR#12	a_837_359##4	1.25003e-17
C37	VGND#2	VGND#1	1.25309e-18
C38	a_696_457##6	a_306_74##2	4.22248e-19
C39	a_696_457##7	a_306_74##4	1.01455e-19
C40	VPWR#10	a_490_362#	3.33462e-19
C41	RESET_B#17	a_696_457##8	6.9702e-18
C42	a_1271_74##10	a_696_457##3	9.33018e-19
C43	a_306_74##11	a_306_74##5	1.95143e-18
C44	a_696_457##10	a_490_362#	4.95582e-17
C45	a_490_362##12	a_306_74##3	1.44778e-20
C46	a_1921_409##10	a_1271_74##3	5.14238e-19
C47	a_1271_74##8	VPWR#6	2.08239e-17
C48	RESET_B#17	a_30_78##2	4.07919e-17
C49	a_490_362##13	a_837_359#	1.41203e-17
C50	a_306_74##4	a_490_362##3	2.14697e-17
C51	a_1525_212##5	RESET_B#9	8.34056e-19
C52	VPWR#12	a_696_457##9	7.09579e-18
C53	a_30_78##2	RESET_B#2	1.27951e-19
C54	a_306_74##9	a_306_74##3	5.25156e-20
C55	VPWR#5	a_1271_74##3	6.22502e-19
C56	VGND#7	a_837_359##4	1.76013e-18
C57	VGND#16	RESET_B#2	6.2025e-18
C58	VGND#15	a_490_362##13	4.49099e-17
C59	a_1271_74##6	a_1271_74##5	2.00629e-17
C60	a_30_78#	a_490_362#	6.17045e-18
C61	CLK#2	a_30_78##4	1.33931e-18
C62	VGND#6	RESET_B#7	2.97422e-18
C63	VPWR#12	VPWR#11	1.36283e-17
C64	a_490_362#	a_306_74##6	4.0951e-18
C65	a_1525_212##7	a_1271_74##3	4.80871e-17
C66	a_306_74##3	a_490_362##3	1.46134e-17
C67	VGND#7	VPWR#9	4.3479e-18
C68	a_837_359##4	VPWR#8	7.04738e-18
C69	a_696_457##6	a_696_457#	3.88931e-19
C70	a_696_457##10	a_306_74##9	1.06796e-17
C71	a_490_362##13	a_490_362##4	2.24424e-18
C72	a_696_457##7	a_306_74##3	3.42007e-18
C73	a_30_78##2	a_490_362##12	3.95462e-17
C74	a_306_74##11	CLK#2	5.99716e-17
C75	a_1271_74##3	VPWR#7	3.04713e-19
C76	a_1921_409##9	VPWR#4	1.01355e-17
C77	a_490_362##13	a_490_362#	1.33594e-17
C78	VGND#12	a_1271_74##2	1.6621e-18
C79	VPWR#14	a_306_74##4	1.11368e-18
C80	a_696_457##8	VPWR#12	1.9343e-17
C81	a_837_359##5	RESET_B#6	1.11224e-18
C82	a_1525_212##5	a_1921_409##9	3.37883e-17
C83	a_30_78##4	a_490_362##12	3.6014e-20
C84	RESET_B#20	VPWR#8	1.58519e-18
C85	a_30_78#	a_306_74##9	5.53191e-17
C86	RESET_B#10	a_1525_212##7	3.85455e-17
C87	RESET_B#11	a_1271_74##6	8.671e-18
C88	a_696_457##7	RESET_B#8	5.64178e-19
C89	a_30_78##2	VPWR#12	3.22798e-17
C90	a_1271_74##8	a_1271_74##3	3.4537e-18
C91	a_30_78##4	RESET_B#1	2.96878e-17
C92	a_30_78##2	VPWR#14	3.73131e-17
C93	a_1921_409##9	a_1271_74##2	1.31626e-17
C94	a_490_362##13	a_696_457##3	8.87632e-19
C95	RESET_B#20	VPWR#6	4.37122e-18
C96	RESET_B#10	VPWR#7	1.48634e-17
C97	VPWR#14	a_306_74##3	3.81262e-18
C98	VGND#6	a_837_359#	1.32863e-18
C99	VPWR#12	a_490_362##12	3.20424e-18
C100	VGND#4	a_1921_409#	4.76587e-18
C101	a_696_457##6	RESET_B#8	1.2602e-17
C102	a_490_362##13	a_306_74##9	1.03989e-17
C103	RESET_B#1	a_306_74##11	3.60369e-17
C104	a_306_74##7	a_306_74##4	3.27078e-17
C105	VPWR#12	VPWR#14	2.35784e-19
C106	a_1525_212##7	a_1525_212##2	2.9804e-20
C107	VGND#4	a_1921_409##6	4.76587e-18
C108	a_30_78#	a_306_74##8	5.70936e-19
C109	a_306_74##13	a_30_78##2	1.70473e-18
C110	a_1271_74##8	RESET_B#10	7.8655e-19
C111	a_1525_212##3	RESET_B#11	1.78176e-17
C112	a_306_74##7	a_306_74##3	1.57032e-17
C113	VGND#3	a_1921_409##11	9.77075e-18
C114	VPWR#7	a_1525_212##2	7.02327e-19
C115	VPWR#12	a_306_74##13	4.36852e-18
C116	VGND#7	a_490_362##12	1.98325e-18
C117	VGND#4	a_1271_74#	5.18579e-18
C118	a_696_457##7	a_837_359##3	2.17509e-17
C119	a_696_457##9	VPWR#10	2.65148e-18
C120	a_30_78##4	D#2	1.04973e-17
C121	a_696_457##6	a_306_74##3	2.02251e-18
C122	a_1525_212##5	a_306_74#	1.65091e-19
C123	VPWR#3	VPWR#8	9.43605e-18
C124	RESET_B#20	a_306_74#	1.54934e-18
C125	a_696_457##10	a_696_457##7	9.47915e-20
C126	a_490_362##13	a_306_74##8	3.93838e-17
C127	VPWR#12	VPWR#16	9.92007e-18
C128	VGND#4	a_1271_74##4	1.33072e-17
C129	a_696_457##7	VPWR#10	4.97607e-18
C130	a_696_457##10	a_837_359##2	7.87742e-17
C131	a_306_74##13	a_306_74##4	1.18118e-18
C132	a_306_74##13	a_490_362##12	5.25843e-18
C133	a_1525_212##7	a_490_362##7	1.23267e-19
C134	VGND#16	VGND#15	1.26968e-18
C135	VPWR#3	VPWR#6	1.20614e-16
C136	a_696_457##6	a_837_359##3	2.04075e-18
C137	a_1271_74##8	a_1525_212##2	3.01502e-18
C138	a_696_457##7	RESET_B#6	6.67245e-20
C139	VPWR#12	a_30_78##6	1.24322e-17
C140	VGND#7	a_306_74##13	1.35622e-18
C141	VGND#4	RESET_B#9	5.08253e-18
C142	a_696_457##3	RESET_B#6	2.44738e-17
C143	a_490_362##6	a_1525_212##3	2.62148e-17
C144	a_306_74##8	VGND#15	2.19922e-17
C145	a_696_457##9	VPWR#8	2.03335e-18
C146	VPWR#3	VPWR#2	7.24676e-17
C147	a_30_78##4	a_306_74##13	5.23245e-17
C148	CLK#3	a_306_74##4	5.83795e-18
C149	a_490_362##13	a_837_359##2	4.20951e-17
C150	VGND#2	a_1921_409##11	7.93625e-18
C151	VPWR#12	VPWR#17	6.19213e-17
C152	VGND#4	a_1525_212#	3.77193e-18
C153	a_490_362##13	CLK#3	8.31551e-20
C154	a_696_457##7	a_306_74##6	1.46282e-17
C155	VPWR#4	a_1921_409##3	1.19911e-18
C156	a_306_74##2	a_1525_212##3	1.55409e-19
C157	a_696_457##10	a_490_362##2	1.83166e-18
C158	a_490_362##7	a_1271_74##8	1.29379e-16
C159	CLK#1	a_306_74##4	1.85956e-19
C160	a_696_457##7	a_696_457##6	6.64658e-18
C161	a_30_78##5	RESET_B#2	8.1313e-18
C162	a_30_78#	a_490_362##2	5.70385e-17
C163	VGND#11	VGND#1	2.12594e-18
C164	a_490_362##13	a_837_359##5	5.68333e-17
C165	a_696_457##6	a_306_74##6	4.68782e-19
C166	CLK#3	VGND#15	2.43838e-17
C167	a_306_74##2	a_490_362##6	8.48251e-18
C168	a_696_457##6	VPWR#10	9.83126e-19
C169	a_490_362##13	a_490_362##2	2.65997e-18
C170	VPWR#16	VPWR#14	8.67867e-18
C171	a_30_78##6	a_490_362##12	1.86078e-20
C172	VGND#16	a_306_74##8	1.60147e-19
C173	a_30_78##4	VPWR#16	3.88763e-17
C174	a_490_362##4	a_1271_74##8	5.09195e-18
C175	RESET_B#5	a_306_74##3	2.0147e-19
C176	a_1525_212##5	a_1921_409##10	3.29834e-18
C177	RESET_B#6	a_306_74##3	1.20974e-18
C178	VPWR#11	VPWR#8	1.23435e-18
C179	CLK#3	a_306_74##12	1.0629e-17
C180	a_696_457##7	a_786_457#	2.58097e-18
C181	a_306_74##11	a_306_74##13	3.12852e-18
C182	a_696_457##7	a_490_362##3	5.18953e-19
C183	a_490_362##4	a_837_359##4	1.71248e-18
C184	a_696_457##6	RESET_B#6	7.70923e-18
C185	RESET_B#17	a_490_362##5	3.43815e-18
C186	RESET_B#17	VPWR#10	4.61831e-18
C187	VGND#15	RESET_B#3	3.51053e-19
C188	RESET_B#5	RESET_B#6	1.34401e-17
C189	a_1271_74##8	a_306_74#	4.30637e-20
C190	a_696_457#	a_306_74##2	5.46627e-17
C191	a_306_74##5	a_490_362##13	4.59651e-17
C192	VGND#8	a_306_74##8	7.37113e-18
C193	a_696_457##6	a_490_362##3	2.71704e-20
C194	VGND#16	CLK#3	1.34248e-18
C195	VPWR#4	a_1271_74##2	8.1674e-20
C196	a_1271_74##8	a_696_457##3	7.70458e-20
C197	RESET_B#17	VPWR#8	6.1909e-18
C198	a_306_74##5	VGND#15	1.99523e-17
C199	VPWR#16	a_306_74##3	5.19527e-20
C200	RESET_B#2	CLK#1	9.06632e-18
C201	a_30_78##4	a_30_78##6	1.03313e-18
C202	RESET_B#2	CLK#3	3.35013e-18
C203	a_696_457##3	a_837_359##4	4.69035e-19
C204	a_306_74##13	RESET_B#2	7.70294e-18
C205	a_1271_74#	a_1921_409##4	5.77992e-18
C206	a_696_457##3	VPWR#9	2.84461e-17
C207	RESET_B#8	a_696_457#	3.54442e-18
C208	VGND#4	VGND#5	1.14214e-16
C209	RESET_B#4	a_306_74##3	1.29471e-19
C210	RESET_B#3	VGND#16	1.87169e-17
C211	a_696_457##3	a_696_457##9	4.27102e-19
C212	RESET_B#17	a_490_362#	9.27979e-19
C213	CLK#2	VGND#15	1.40667e-18
C214	a_30_78##5	CLK#3	1.31081e-18
C215	a_30_78##6	VPWR#16	3.00001e-17
C216	a_1271_74##3	a_1271_74#	8.58135e-19
C217	a_30_78##5	VGND#16	2.34095e-17
C218	a_837_359##2	a_306_74##3	1.2698e-18
C219	VGND#4	VGND#3	5.48079e-17
C220	a_837_359##4	a_490_362##5	1.00836e-18
C221	VGND#8	CLK#3	5.30374e-18
C222	RESET_B#17	a_306_74##9	3.81391e-19
C223	RESET_B#5	VPWR#9	2.6599e-17
C224	a_30_78##6	a_306_74##4	1.49084e-19
C225	VPWR#17	a_30_78##4	4.04124e-18
C226	VGND#7	a_490_362##5	5.50696e-18
C227	VGND#4	VGND#2	8.09583e-17
C228	RESET_B#5	a_696_457##9	1.57708e-17
C229	a_837_359##3	RESET_B#8	1.16063e-17
C230	a_837_359##2	RESET_B#6	3.37382e-17
C231	a_306_74##6	a_696_457#	1.1025e-19
C232	VPWR#3	a_1921_409##9	2.37996e-18
C233	RESET_B#9	a_1271_74##3	9.69264e-18
C234	VGND#16	D#1	2.45047e-18
C235	VGND#7	a_696_457##4	2.83372e-18
C236	VPWR#17	VPWR#16	2.06271e-18
C237	a_1921_409##11	VGND#11	5.73587e-17
C238	VPWR#12	VPWR#15	6.85413e-17
C239	RESET_B#17	VGND#6	2.83702e-18
C240	a_1525_212##5	a_1525_212##7	2.28484e-18
C241	a_837_359##4	a_837_359##2	9.49817e-20
C242	a_1921_409##10	a_1271_74##2	9.04263e-19
C243	a_1525_212##5	a_1271_74##2	1.27128e-17
C244	a_30_78##5	RESET_B#3	1.46891e-17
C245	a_30_78##2	VPWR#13	4.59966e-18
C246	VGND#7	RESET_B#7	3.70545e-18
C247	VPWR#9	a_837_359##2	3.72675e-20
C248	VPWR#12	VPWR#13	7.54865e-17
C249	VPWR#12	a_490_362#	1.02131e-19
C250	VPWR#16	RESET_B#2	1.54269e-18
C251	VGND#16	RESET_B#1	1.50226e-17
C252	a_1271_74##3	a_306_74#	6.68581e-18
C253	VGND#13	VGND#3	2.53624e-19
C254	VGND#7	a_837_359#	1.5761e-18
C255	VPWR#3	a_1921_409##5	4.10076e-18
C256	VPWR#17	a_30_78##6	3.03093e-17
C257	VPWR#12	VPWR#10	7.76466e-17
C258	VPWR#12	a_306_74##9	5.10523e-20
C259	a_306_74##6	a_837_359##3	3.23637e-17
C260	VGND#8	RESET_B#3	4.59371e-19
C261	VPWR#11	a_837_359##2	7.28605e-19
C262	a_1525_212##2	a_1271_74##4	4.95367e-19
C263	VGND#7	a_490_362#	2.12488e-18
C264	a_30_78##5	RESET_B#1	3.3819e-17
C265	VPWR#3	a_1921_409##7	6.33525e-18
C266	a_306_74##4	a_490_362##2	3.09017e-17
C267	VPWR#3	a_1525_212##5	7.60174e-19
C268	a_30_78##5	D#1	3.54137e-17
C269	VGND#12	VGND#11	2.14818e-18
C270	VPWR#12	VPWR#8	1.13206e-16
C271	VGND#4	a_1921_409##9	4.37692e-18
C272	a_1525_212##2	RESET_B#9	4.1862e-17
C273	a_490_362##2	a_306_74##3	1.20907e-18
C274	VGND#7	a_306_74##9	2.20357e-18
C275	VPWR#3	a_1271_74##5	1.12736e-17
C276	a_30_78##4	a_306_74##7	3.9197e-19
C277	VGND#7	a_306_74##8	2.41597e-18
C278	a_30_78##2	a_837_359##2	8.74553e-19
C279	a_490_362##3	a_306_74##6	3.11944e-17
C280	RESET_B#20	RESET_B#21	3.59879e-17
C281	VPWR#3	a_1271_74##6	1.35389e-17
C282	a_306_74#	a_1525_212##2	5.49822e-17
C283	a_30_78##5	D#2	1.30555e-17
C284	a_490_362##12	a_837_359##2	1.22521e-20
C285	a_30_78##4	VPWR#15	3.67007e-18
C286	a_490_362##4	a_1271_74#	2.53728e-19
C287	VGND#7	CLK#3	2.33464e-19
C288	RESET_B#20	a_1525_212##3	3.83955e-18
C289	VGND#12	a_1921_409##11	6.40846e-17
C290	VPWR#5	a_1271_74##2	6.65875e-19
C291	a_696_457##8	a_490_362##2	4.19478e-19
C292	VPWR#3	RESET_B#11	7.48392e-18
C293	D#3	RESET_B#2	3.21698e-18
C294	a_490_362##4	a_1271_74##4	4.58222e-19
C295	VGND#7	RESET_B#3	9.99256e-18
C296	VGND#4	a_1525_212##5	1.04571e-17
C297	a_30_78##2	a_490_362##2	4.94867e-17
C298	VPWR#15	a_306_74##3	3.89167e-20
C299	a_490_362##7	a_306_74#	1.53406e-17
C300	VPWR#3	a_1525_212##3	3.61354e-18
C301	a_490_362##4	RESET_B#9	8.08352e-19
C302	a_30_78##4	CLK#1	2.06609e-17
C303	a_696_457##6	RESET_B#16	2.8869e-17
C304	a_490_362##12	a_490_362##2	3.3447e-19
C305	VGND#7	D#1	1.243e-17
C306	RESET_B#20	a_306_74##2	2.06576e-18
C307	a_490_362##4	a_1525_212#	8.63177e-18
C308	VPWR#11	RESET_B#7	1.82722e-19
C309	VPWR#13	a_306_74##4	8.62369e-20
C310	VPWR#3	a_490_362##6	7.99172e-18
C311	VPWR#3	RESET_B#21	2.09912e-18
C312	a_306_74##5	a_306_74##4	3.20011e-17
C313	a_837_359##5	a_306_74#	2.66263e-19
C314	a_30_78##4	VPWR#13	3.10626e-18
C315	RESET_B#16	a_306_74##3	2.49464e-20
C316	a_490_362##4	a_306_74#	7.59374e-17
C317	a_306_74##5	a_30_78##2	1.34819e-18
C318	a_1271_74##10	a_306_74##2	8.78695e-18
C319	VPWR#1	a_1921_409##5	3.21927e-17
C320	a_306_74##5	a_490_362##12	4.92584e-17
C321	a_490_362##4	a_490_362##5	2.10482e-17
C322	CLK#1	a_306_74##7	4.91924e-17
C323	a_1525_212##5	a_1921_409##11	4.48786e-18
C324	a_1921_409##6	a_1921_409#	3.83509e-17
C325	a_30_78##4	RESET_B#4	1.16857e-17
C326	a_490_362##4	a_696_457##4	2.20199e-17
C327	a_696_457##3	a_306_74#	1.02375e-18
C328	VGND#4	a_306_74##2	1.85558e-19
C329	VGND#7	VGND#8	9.21026e-17
C330	a_1921_409##5	Q#1	2.44017e-17
C331	a_30_78##4	a_306_74##4	2.99433e-19
C332	CLK#2	a_30_78##2	1.11737e-19
C333	VPWR#2	a_1921_409##5	2.34761e-18
C334	a_1271_74##8	a_1525_212##5	3.23202e-20
C335	a_306_74##5	RESET_B#2	1.08023e-19
C336	a_696_457##3	a_490_362##5	1.06293e-17
C337	a_1525_212##4	VGND#12	4.58138e-17
C338	CLK#2	a_490_362##12	3.18369e-18
C339	VGND#6	VGND#14	8.79562e-18
C340	VGND#7	VGND#6	1.49533e-16
C341	VGND#4	RESET_B#21	1.79878e-18
C342	VPWR#1	a_1921_409##7	1.28429e-18
C343	a_837_359##5	a_490_362##5	1.55869e-17
C344	RESET_B#17	a_306_74##2	4.72448e-18
C345	RESET_B#4	CLK#1	4.87144e-18
C346	VPWR#13	a_306_74##3	1.60309e-18
C347	VPWR#4	a_1921_409##5	3.12873e-18
C348	VGND#7	VGND#5	5.43047e-18
C349	VPWR#2	a_1921_409##4	4.40249e-19
C350	VPWR#4	VPWR#1	1.59645e-18
C351	a_696_457##3	RESET_B#7	2.39128e-17
C352	a_306_74##13	CLK#2	3.23996e-17
C353	RESET_B#17	a_696_457#	3.99972e-18
C354	a_1525_212##5	VGND#12	2.12052e-17
C355	a_1921_409##7	Q#1	2.40761e-17
C356	a_30_78##4	D#3	8.29231e-18
C357	a_1271_74#	a_1921_409##6	5.11512e-18
C358	a_696_457##3	a_837_359#	1.66016e-18
C359	CLK#2	a_306_74##4	4.36346e-17
C360	a_1271_74##3	a_1271_74##5	8.57318e-18
C361	D#3	RESET_B#4	2.7349e-17
C362	VPWR#1	a_1271_74##5	1.08046e-19
C363	VPWR#12	a_306_74##2	1.09233e-17
C364	a_306_74##11	a_490_362##13	5.40705e-19
C365	a_1921_409##7	VPWR#4	2.70062e-17
C366	a_837_359##2	a_490_362##5	1.40111e-19
C367	a_1271_74#	a_1921_409##3	2.02999e-19
C368	VPWR#2	a_1921_409##7	5.45342e-18
C369	RESET_B#1	a_306_74##13	2.91633e-17
C370	a_1271_74##2	a_1921_409##7	1.311e-18
C371	RESET_B#16	RESET_B#6	7.51307e-18
C372	a_837_359##5	a_696_457##4	3.15969e-17
C373	RESET_B#21	VPWR#7	2.46327e-17
C374	a_1271_74##8	a_1478_493#	2.7589e-18
C375	VPWR#12	a_696_457#	2.02068e-18
C376	RESET_B#10	a_1271_74##5	5.75773e-19
C377	a_696_457##8	a_490_362#	1.01929e-19
C378	a_1271_74##3	VPWR#6	1.34673e-19
C379	VGND#7	a_306_74##2	5.20375e-19
C380	RESET_B#17	a_306_74##6	2.49895e-18
C381	a_1921_409##10	a_1921_409##7	1.60506e-18
C382	a_837_359##2	RESET_B#7	6.10972e-18
C383	RESET_B#2	CLK#2	1.3406e-17
C384	RESET_B#10	a_1271_74##6	5.53127e-18
C385	VPWR#9	a_1478_493#	6.97567e-21
C386	VPWR#12	RESET_B#8	2.55482e-18
C387	VPWR#3	a_1271_74##2	7.11778e-19
C388	VPWR#16	VPWR#13	1.02734e-19
C389	a_837_359##2	a_837_359#	1.30195e-17
C390	VPWR#4	a_1271_74##5	3.58572e-18
C391	a_1271_74##4	a_1271_74#	6.17712e-18
C392	VGND#13	VGND#12	1.86884e-18
C393	VPWR#12	a_837_359##3	3.16574e-18
C394	VPWR#10	a_306_74##3	3.17098e-17
C395	VPWR#5	a_1921_409##7	5.90632e-19
C396	a_490_362#	a_837_359##2	2.39167e-17
C397	a_306_74##11	VGND#15	6.13321e-17
C398	VPWR#2	a_1921_409##3	3.68078e-20
C399	a_1525_212##3	RESET_B#10	2.3045e-17
C400	VGND#2	a_1921_409##4	3.37699e-19
C401	a_837_359##5	RESET_B#7	1.41058e-17
C402	a_1921_409##10	a_1271_74##5	5.67198e-17
C403	VPWR#17	D#2	3.2287e-18
C404	a_30_78##6	VPWR#15	1.17103e-17
C405	a_490_362##12	a_490_362#	1.52278e-19
C406	a_30_78##4	VGND#16	1.722e-19
C407	a_1525_212##7	a_1921_409##7	4.41671e-20
C408	VGND#1	a_1921_409#	2.67457e-17
C409	VPWR#12	a_490_362##3	6.30978e-18
C410	a_30_78##2	a_306_74##9	5.47927e-19
C411	VPWR#4	a_1271_74##6	3.44176e-19
C412	VGND#7	a_306_74##6	6.37703e-19
C413	RESET_B#10	VPWR#6	7.93676e-19
C414	a_1921_409##10	VPWR#4	7.8498e-17
C415	VGND#13	a_1525_212##4	1.28564e-17
C416	a_1271_74##5	VPWR#5	1.83873e-17
C417	a_306_74##9	a_490_362##2	3.2454e-17
C418	VGND#4	a_1921_409##3	1.16759e-18
C419	VGND#5	a_1271_74##3	1.33554e-18
C420	VPWR#12	a_306_74##7	5.03497e-18
C421	CLK	a_306_74##4	1.26675e-19
C422	RESET_B#20	VPWR#3	3.48357e-17
C423	a_306_74##11	a_306_74##12	7.02751e-18
C424	a_490_362##7	a_1525_212##3	2.72962e-17
C425	RESET_B#9	a_1271_74##4	5.30503e-17
C426	a_1921_409##10	a_1271_74##6	1.41016e-18
C427	VGND#4	a_1921_409##2	4.93932e-21
C428	a_306_74##2	a_1525_212##2	4.30237e-19
C429	a_1921_409#	Q#3	1.5442e-17
C430	VPWR#12	CLK#1	4.5886e-18
C431	CLK	RESET_B#2	9.45771e-20
C432	a_1525_212##7	a_1271_74##5	7.87965e-18
C433	RESET_B#1	RESET_B#2	2.9488e-17
C434	a_306_74##11	a_306_74##4	3.03582e-19
C435	a_306_74##5	a_306_74##9	2.3217e-19
C436	a_837_359##5	a_837_359#	3.1596e-19
C437	a_1921_409##9	a_1921_409##4	2.35411e-17
C438	VPWR#2	a_1921_409##2	3.6317e-20
C439	VGND#4	a_1271_74##2	1.18541e-18
C440	VPWR#12	RESET_B#4	4.04849e-19
C441	VGND#1	a_1921_409##6	1.37822e-18
C442	RESET_B#17	a_837_359##5	1.02771e-17
C443	a_1271_74##8	RESET_B#21	2.76217e-17
C444	VPWR#5	VPWR#4	3.53616e-18
C445	a_1271_74##6	VPWR#5	1.80052e-17
C446	a_306_74##5	a_306_74##8	9.73492e-18
C447	a_490_362##7	a_306_74##2	3.26017e-17
C448	CLK#2	a_490_362#	4.83882e-21
C449	VPWR#17	VPWR#15	1.56089e-18
C450	VPWR#8	a_306_74##3	3.80878e-18
C451	VPWR#7	a_1271_74##5	6.849e-19
C452	VGND#11	a_1921_409#	7.92936e-19
C453	VPWR#12	D#3	2.66325e-18
C454	RESET_B#17	a_696_457##7	3.30062e-17
C455	a_30_78##4	RESET_B#2	2.70352e-17
C456	a_1525_212##7	a_1271_74##6	4.26022e-17
C457	a_490_362##4	a_306_74##2	4.52739e-17
C458	VGND#16	a_306_74##11	4.53418e-17
C459	VGND#5	RESET_B#10	1.9285e-19
C460	a_1921_409##6	Q#3	1.4935e-17
C461	RESET_B#17	a_696_457##6	3.32307e-17
C462	a_1525_212#	RESET_B#9	1.98465e-17
C463	VPWR#5	a_1921_409##10	4.81166e-17
C464	VPWR#5	RESET_B#11	1.44222e-18
C465	RESET_B#20	VPWR#12	3.81049e-18
C466	a_837_359##5	a_490_362#	1.64073e-19
C467	VPWR#6	RESET_B#11	4.59983e-18
C468	VGND#1	a_1271_74#	1.57068e-19
C469	a_696_457##10	a_696_457##8	3.21247e-19
C470	a_696_457##3	a_306_74##2	5.17849e-18
C471	VPWR#7	a_1271_74##6	2.49982e-18
C472	a_490_362##13	a_895_138#	1.30964e-19
C473	VPWR#10	RESET_B#6	4.63216e-19
C474	a_1921_409##9	a_1271_74##3	4.11601e-19
C475	a_1271_74##8	a_1271_74##5	2.58864e-20
C476	VGND#11	a_1921_409##6	1.67785e-17
C477	a_1525_212##7	RESET_B#11	2.90569e-17
C478	a_696_457##10	a_306_74##6	3.13358e-19
C479	RESET_B#1	CLK#3	1.9832e-19
C480	RESET_B#5	a_306_74##2	1.77712e-19
C481	D	RESET_B#2	9.01206e-18
C482	a_696_457##7	a_490_362#	1.2607e-19
C483	VGND#5	VGND#3	4.56524e-19
C484	D#2	RESET_B#2	7.17589e-17
C485	VPWR#5	a_1525_212##3	4.72166e-19
C486	a_1525_212##7	a_1921_409##10	3.02969e-17
C487	RESET_B#5	a_696_457#	5.66983e-19
C488	VPWR#6	a_490_362##7	5.35757e-19
C489	VPWR#7	RESET_B#11	1.26777e-17
C490	VPWR#8	a_1525_212##3	1.88084e-19
C491	a_30_78##2	a_696_457##10	4.2994e-19
C492	VGND#5	a_1525_212##2	1.39466e-18
C493	a_1921_409##11	a_1921_409##6	2.11952e-18
C494	RESET_B#17	VPWR#12	8.10007e-17
C495	a_1271_74##8	a_1271_74##6	6.40989e-20
C496	VPWR#3	a_1921_409##4	2.64392e-18
C497	VGND#8	a_490_362##13	1.59684e-17
C498	a_1525_212##5	a_1271_74##3	1.25835e-16
C499	a_306_74#	a_1525_212#	3.41345e-17
C500	RESET_B#17	RESET_B#16	9.09419e-18
C501	RESET_B#20	a_1271_74##3	6.70321e-18
C502	a_1525_212##7	a_1525_212##3	7.37197e-19
C503	D#2	RESET_B#3	3.7534e-18
C504	RESET_B#17	a_306_74##4	6.93438e-21
C505	VGND#11	a_1271_74#	2.29901e-18
C506	VGND#4	a_1921_409##4	3.4001e-18
C507	VPWR#6	a_1525_212##3	8.7611e-19
C508	VPWR#3	a_1271_74##3	4.98452e-18
C509	a_1525_212##7	VPWR#5	6.19277e-17
C510	a_1921_409##9	a_1921_409##7	7.51694e-20
C511	RESET_B#17	a_306_74##3	8.61163e-19
C512	VGND#12	a_1921_409##6	3.51251e-19
C513	VPWR#7	a_1525_212##3	2.97604e-17
C514	a_696_457##7	VPWR#12	1.1503e-17
C515	a_30_78#	a_30_78##2	1.11629e-18
C516	a_696_457##10	a_817_138#	1.67463e-18
C517	VGND#4	a_1271_74##3	1.11918e-17
C518	a_30_78##5	a_306_74##11	9.08469e-18
C519	VPWR#3	RESET_B#10	2.96304e-18
C520	a_1271_74##8	RESET_B#11	2.55026e-20
C521	a_1271_74##4	a_1663_81#	9.87534e-18
C522	RESET_B#20	a_1525_212##2	5.87516e-18
C523	a_490_362##13	a_817_138#	7.52371e-19
C524	VGND#6	a_490_362##13	7.06002e-17
C525	a_306_74##6	a_837_359##2	3.38265e-18
C526	a_1921_409##11	a_1271_74#	5.23158e-17
C527	VPWR#12	a_696_457##6	4.23098e-18
C528	VPWR#8	RESET_B#6	1.2376e-18
C529	Q	a_1921_409##3	1.30936e-17
C530	RESET_B#9	a_1663_81#	9.87534e-18
C531	Q	a_1921_409##2	1.71928e-17
C532	a_1921_409##9	VPWR#2	2.97717e-19
C533	Q	a_1271_74##2	7.09493e-19
C534	a_490_362##3	a_837_359##2	6.5477e-19
C535	RESET_B#20	a_490_362##7	4.71414e-17
C536	RESET_B#17	RESET_B#6	1.3679e-18
C537	VPWR#8	a_490_362##6	3.35428e-19
C538	VPWR#7	VPWR#5	4.66135e-18
C539	a_490_362##5	a_306_74#	3.44872e-18
C540	a_1525_212##5	RESET_B#10	7.43049e-19
C541	VGND#11	a_1271_74##4	1.04735e-19
C542	a_490_362##2	a_306_74##6	1.76782e-18
C543	VPWR#7	a_490_362##6	3.51776e-18
C544	VGND#4	a_1525_212##2	6.43205e-18
C545	VGND#7	a_837_359##5	1.59335e-17
C546	VPWR#3	a_490_362##7	2.0069e-18
C547	a_490_362##12	a_30_78#	1.94262e-17
C548	a_1271_74##8	a_1525_212##3	1.25893e-17
C549	RESET_B#20	a_490_362##4	1.18831e-17
C550	a_1271_74##3	RESET_B#21	1.90906e-17
C551	a_1271_74#	VGND#12	1.63468e-17
C552	VPWR#6	a_490_362##6	6.59398e-18
C553	VGND#4	a_490_362##7	4.79095e-19
C554	a_1921_409##11	a_1271_74##4	4.90879e-19
C555	a_1525_212##5	a_1921_409##7	4.41671e-20
C556	VPWR#7	a_1525_212##7	3.07399e-17
C557	a_306_74##11	RESET_B#2	6.33478e-18
C558	VGND#4	a_490_362##4	3.27616e-17
C559	VGND#3	VGND#2	1.14216e-18
C560	VPWR#7	a_306_74##2	1.45444e-18
C561	a_1525_212##4	a_1271_74#	1.09638e-18
C562	a_490_362##13	a_490_362##12	1.97719e-18
C563	VGND#6	a_490_362##4	9.43731e-17
C564	VPWR#12	RESET_B#16	8.73944e-19
C565	a_1271_74##8	a_490_362##6	2.71257e-17
C566	RESET_B#17	a_490_362##4	3.52477e-18
C567	a_696_457##4	a_490_362##5	2.85705e-17
C568	VGND#8	a_306_74##11	1.015e-17
C569	VPWR#9	a_1525_212##3	4.20548e-19
C570	a_1525_212##2	a_1525_212##5	5.06113e-18
C571	VGND#4	VGND#1	5.33414e-17
C572	a_306_74#	a_1481_81#	7.53443e-18
C573	VGND#5	a_490_362##4	6.8029e-17
C574	VGND#12	a_1271_74##4	3.24433e-18
C575	VPWR#12	a_30_78##4	1.12395e-17
C576	VPWR#8	a_306_74##2	5.14185e-17
C577	RESET_B#17	a_696_457##3	1.89805e-17
C578	a_1525_212##3	a_1478_493#	1.96032e-18
C579	RESET_B#21	RESET_B#10	4.74389e-18
C580	a_1271_74##3	RESET_B#10	8.1663e-17
C581	a_490_362##6	a_1478_493#	8.18186e-18
C582	VPWR#7	a_696_457#	3.43902e-19
C583	VPWR#6	a_306_74##2	9.42212e-19
C584	RESET_B#17	RESET_B#5	1.47794e-17
C585	RESET_B#20	VGND#13	2.8472e-18
C586	a_1271_74##8	a_306_74##2	4.26413e-17
C587	a_1271_74##3	a_1525_212##2	7.52198e-17
C588	a_1525_212##4	a_1271_74##4	3.69731e-17
C589	VGND#7	a_490_362##4	3.70292e-17
C590	VPWR#12	a_696_457##3	2.68388e-18
C591	VPWR#9	a_490_362##6	5.45248e-19
C592	RESET_B#1	CLK#1	1.52579e-19
C593	a_1525_212##5	a_1271_74##5	3.1368e-19
C594	VGND#7	RESET_B#16	1.11539e-18
C595	a_837_359##5	a_1271_74##8	1.36145e-18
C596	RESET_B#17	a_837_359##2	3.05968e-17
C597	a_1525_212##2	RESET_B#10	2.49956e-17
C598	a_490_362##7	a_1271_74##3	8.83782e-18
C599	VGND#13	a_1271_74#	4.82226e-19
C600	VGND#7	a_696_457##3	9.51857e-18
C601	VGND#12	RESET_B#9	3.32004e-19
C602	a_837_359##4	a_306_74##2	3.60606e-17
C603	VGND#6	a_696_457##3	1.90789e-19
C604	VGND#4	a_1921_409##11	1.95882e-17
C605	VPWR#12	RESET_B#5	1.13934e-18
C606	a_1271_74##8	a_1525_212##7	1.55695e-18
C607	RESET_B#7	a_696_457##4	2.34261e-18
C608	a_490_362##4	a_1271_74##3	1.74112e-17
C609	RESET_B#17	a_490_362##2	1.52964e-17
C610	RESET_B#20	a_1271_74##10	3.80457e-18
C611	VGND#7	RESET_B#5	1.23755e-18
C612	a_1271_74##8	a_696_457#	6.70539e-19
C613	VPWR#12	a_306_74##4	1.27931e-19
C614	VPWR#12	a_837_359##2	2.02898e-18
C615	VPWR#8	a_696_457#	1.66245e-18
C616	RESET_B#21	a_1525_212##2	2.42672e-18
C617	a_490_362##7	a_1525_212##2	4.19301e-19
C618	VPWR#9	a_306_74##2	6.79444e-18
C619	a_490_362##4	RESET_B#10	5.54545e-19
C620	a_837_359##3	a_786_457#	6.41601e-18
C621	RESET_B#7	a_895_138#	7.05199e-18
C622	VGND#7	a_837_359##2	5.04997e-18
C623	a_1525_212##4	RESET_B#9	3.81441e-18
C624	a_1921_409##3	a_1921_409##2	7.57297e-18
C625	VPWR#12	a_306_74##3	3.79403e-17
C626	VPWR#12	a_490_362##2	3.90537e-19
C627	VGND#4	a_1525_212##4	3.20181e-17
C628	VGND#8	a_306_74##4	1.82511e-19
C629	a_837_359#	a_895_138#	6.9985e-18
C630	a_490_362##4	a_1525_212##2	4.9356e-17
C631	VGND#7	a_306_74##11	2.18155e-17
C632	a_696_457#	a_837_359##4	3.02185e-17
C633	a_306_74##6	a_786_457#	7.01774e-18
C634	a_1271_74##8	VPWR#7	3.59699e-17
C635	VGND#13	a_1271_74##4	3.39465e-18
C636	a_696_457##9	a_306_74##2	1.35095e-18
C637	VGND#7	a_490_362##2	2.71459e-18
C638	a_490_362##4	a_490_362##7	2.45135e-19
C639	VPWR#12	a_306_74##5	9.84826e-19
C640	Q	VPWR#2	1.74842e-17
C641	a_837_359##4	RESET_B#6	1.20317e-19
C642	VPWR#9	a_696_457#	6.21419e-17
C643	VGND#7	a_306_74##5	5.44368e-18
C644	a_837_359#	RESET_B#7	4.53108e-17
C645	a_30_78##5	a_117_78#	1.96089e-18
C646	VPWR#10	RESET_B#8	3.20821e-18
C647	VPWR#12	CLK#2	5.5175e-19
C648	VPWR#11	a_306_74##2	4.43019e-19
C649	a_490_362##4	a_1525_212##5	8.55407e-19
C650	VGND#4	VGND#13	2.40655e-17
C651	VGND#2	Q	1.68735e-17
C652	VPWR#9	a_306_74##3	2.29023e-19
C653	a_490_362##4	a_696_457##3	1.18969e-18
C654	VGND#7	CLK#2	4.3261e-18
C655	a_1525_212##4	a_1525_212#	5.61176e-19
C656	RESET_B#21	a_490_362##7	9.97549e-19
C657	a_306_74##11	a_306_74##9	5.79093e-20
C658	a_696_457##9	a_696_457#	6.92777e-19
C659	a_1921_409##9	Q	1.93186e-17
C660	VGND#5	a_306_74##2	2.24216e-20
C661	VGND#13	RESET_B#9	3.15526e-17
C662	D	a_30_78##4	6.45303e-17
C663	a_837_359#	a_817_138#	4.48282e-18
C664	VGND#7	RESET_B#1	3.19819e-18
C665	VPWR#9	RESET_B#8	4.38725e-18
C666	a_490_362#	a_817_138#	7.55747e-18
C667	a_696_457##3	RESET_B#5	1.54031e-17
C668	VPWR#11	a_696_457#	1.57059e-18
C669	a_837_359##5	VPWR#9	4.97278e-18
C670	VGND#4	a_1271_74##10	9.14967e-18
C671	a_30_78#	a_306_74##4	1.43031e-19
C672	VGND#7	a_306_74##4	7.44229e-19
C673	a_837_359##2	a_696_457##3	4.94363e-17
C674	a_696_457##9	RESET_B#8	2.08724e-17
C675	a_490_362#	a_837_359#	4.61447e-17
C676	a_696_457##6	a_837_359##4	1.17461e-18
C677	a_1271_74##2	a_1921_409##3	1.07415e-19
C678	a_1525_212##4	a_306_74#	3.6614e-19
C679	VGND#6	a_837_359##2	8.45565e-20
C680	VPWR#10	a_837_359##3	3.15911e-18
C681	a_306_74##11	a_306_74##8	3.15378e-19
C682	VPWR#9	a_837_359##3	9.46679e-19
C683	VPWR#2	VPWR#1	9.29204e-19
C684	VGND#13	a_1525_212#	3.01414e-17
C685	RESET_B#8	VPWR#11	1.49794e-17
C686	a_696_457##8	a_696_457#	4.87568e-19
C687	VPWR#9	RESET_B#6	6.80838e-18
C688	a_490_362##2	a_837_359##2	3.99315e-18
C689	a_1921_409##4	a_1921_409##3	7.68092e-18
C690	a_837_359##4	a_1271_74##8	9.36487e-17
C691	VGND#2	a_1921_409#	2.66322e-18
C692	a_696_457##9	a_306_74##3	3.19069e-18
C693	RESET_B#17	a_837_359##7	6.62011e-20
C694	VPWR#9	a_306_74##6	2.15215e-19
C695	Q	VGND#1	6.53119e-17
C696	VGND#7	RESET_B#2	7.62825e-19
C697	RESET_B#20	a_1481_81#	2.82986e-18
C698	a_306_74##9	a_490_362#	2.47743e-17
C699	a_837_359##3	VPWR#11	1.59708e-17
C700	VGND#11	Q	6.53762e-17
C701	a_696_457##6	VPWR#9	4.04859e-18
C702	a_1921_409##11	Q	2.19622e-18
C703	a_696_457##8	RESET_B#8	9.04901e-19
C704	a_1271_74##2	a_1921_409##4	2.03415e-17
C705	a_306_74##11	CLK#3	3.87484e-17
C706	VGND#13	a_306_74#	3.64266e-18
C707	RESET_B#17	VGND#14	1.59021e-20
C708	D	a_30_78##5	7.79337e-17
C709	VPWR#9	a_1271_74##8	3.92888e-18
C710	VGND#3	a_1921_409##6	1.96198e-19
C711	a_490_362##13	a_306_74##4	1.45114e-17
C712	a_306_74##5	CLK#2	3.26895e-17
C713	VGND#1	VPWR#1	1.01277e-17
C714	CLK	a_30_78##2	6.00611e-18
C715	CLK	a_490_362##12	5.99728e-18
C716	VGND#2	a_1921_409##3	3.08065e-20
C717	VPWR#11	a_306_74##6	1.954e-18
C718	a_306_74##13	CLK	5.23383e-18
C719	a_696_457##8	a_837_359##3	6.22347e-19
C720	VPWR#11	a_306_74##4	2.94398e-19
C721	RESET_B#1	CLK#2	9.75879e-19
C722	VGND#2	a_1921_409##6	7.35012e-18
C723	RESET_B#3	a_117_78#	7.85499e-18
C724	VGND#11	a_1921_409##4	8.07976e-18
C725	VPWR#9	a_837_359##4	8.45557e-17
C726	a_306_74##8	a_306_74##9	3.01557e-18
C727	a_490_362##4	a_837_359##5	7.55026e-17
C728	Q	VPWR#1	1.03118e-16
C729	VGND#13	a_490_362##5	3.32118e-19
C730	D#1	a_117_78#	8.21089e-18
C731	Q	Q#1	5.74289e-18
C732	VPWR#15	VPWR#13	1.28023e-18
C733	RESET_B#17	a_696_457##10	2.8418e-18
C734	VPWR#4	Q	1.07571e-16
C735	a_306_74##11	RESET_B#3	2.66643e-18
C736	a_696_457##9	RESET_B#6	3.72024e-18
C737	a_30_78##2	a_837_359##3	2.70899e-19
C738	a_1921_409##3	VNB	2.11611e-17
C739	a_1921_409##2	VNB	3.31742e-17
C740	RESET_B#6	a_306_74##2	5.1671e-19
C741	a_1921_409##4	a_1921_409##11	2.28296e-19
C742	a_1271_74##2	VNB	3.25487e-17
C743	a_306_74#	a_1271_74##10	1.51001e-17
C744	a_306_74##4	VNB	1.21879e-16
C745	a_306_74##3	VNB	1.53008e-16
C746	VPWR#13	CLK#2	3.75424e-20
C747	VGND#8	a_306_74##5	7.15154e-19
C748	VPWR#11	a_490_362##3	6.13934e-19
C749	RESET_B#6	VNB	6.02375e-17
C750	VGND#2	a_1921_409##9	1.14243e-18
C751	RESET_B#2	VNB	9.57229e-17
C752	RESET_B#17	a_30_78#	5.19903e-18
C753	a_696_457##8	a_306_74##6	2.28454e-17
C754	VPWR#11	a_306_74##3	2.25067e-17
C755	D	VPWR#17	2.14539e-17
C756	VGND#3	a_1271_74#	5.78364e-18
C757	RESET_B#17	a_490_362##13	9.5924e-18
C758	VGND#2	a_1921_409##2	6.09207e-20
C759	a_1271_74##3	a_1271_74##2	4.36691e-18
C760	a_30_78##2	a_306_74##6	2.63827e-18
C761	VGND#13	a_696_457##4	4.89743e-20
C762	VPWR#14	a_837_359##3	2.08642e-19
C763	RESET_B#21	a_1525_212##3	9.27919e-18
C764	VPWR#11	a_306_74##7	1.19255e-18
C765	CLK#3	a_306_74##8	2.09552e-17
C766	a_837_359##5	a_696_457##3	1.07647e-16
C767	VGND#15	a_306_74##4	9.94296e-19
C768	VGND#2	a_1271_74#	8.41738e-19
C769	a_696_457##6	VPWR#11	4.09883e-17
C770	VGND#7	a_1271_74##10	7.58919e-18
C771	VPWR#3	VPWR#1	5.46912e-17
C772	a_696_457##8	a_490_362##3	2.07792e-17
C773	VGND#5	a_1271_74##4	3.59019e-18
C774	a_1271_74##10	a_490_362##5	3.57423e-17
C775	a_1921_409##11	a_1271_74##3	7.53851e-20
C776	Q	a_1921_409#	2.47871e-17
C777	Q	a_1921_409##6	2.31012e-17
C778	Q	a_1271_74#	6.36044e-19
C779	a_1921_409##3	Q#3	1.25563e-19
C780	RESET_B#20	a_1921_409##10	1.89097e-18
C781	a_696_457##9	VPWR#9	2.78305e-17
C782	VGND#7	a_837_359##7	4.13279e-19
C783	VGND#12	a_1271_74##3	5.36017e-19
C784	a_30_78##2	a_490_362##3	2.12602e-17
C785	VPWR#13	a_306_74##7	3.73439e-18
C786	VGND#8	CLK#2	4.54796e-20
C787	a_696_457##3	a_696_457##6	5.05863e-19
C788	VPWR#15	VNB	3.65577e-17
C789	VPWR#13	VNB	3.82522e-17
C790	VPWR#14	a_306_74##6	5.89099e-19
C791	VPWR#10	VNB	2.90271e-17
C792	VGND#5	a_1525_212##5	1.66472e-18
C793	VPWR#8	VNB	4.682e-17
C794	VPWR#6	VNB	5.9769e-17
C795	a_490_362##5	a_837_359##7	5.01087e-18
C796	VPWR#2	VNB	3.80177e-17
C797	VGND#6	RESET_B#6	6.29478e-19
C798	VGND#8	VNB	3.86657e-17
C799	VGND#6	VNB	7.95306e-17
C800	VPWR#3	VPWR#4	2.09577e-17
C801	VGND#5	VNB	6.83094e-17
C802	VGND#3	VNB	2.17351e-17
C803	a_490_362##13	RESET_B#6	6.69328e-19
C804	VGND#2	VNB	3.78286e-17
C805	VGND#4	VPWR#1	3.88056e-18
C806	a_490_362##12	a_490_362##3	4.17786e-19
C807	a_1921_409##9	VNB	9.33732e-18
C808	a_1921_409##10	VPWR#2	6.05427e-18
C809	RESET_B#6	a_696_457#	9.72092e-18
C810	a_837_359##2	a_817_138#	6.21151e-19
C811	a_1525_212##5	VNB	1.75364e-17
C812	a_1271_74##10	a_696_457##4	1.02572e-18
C813	CLK	a_306_74##7	1.51766e-18
C814	RESET_B#3	CLK#3	4.58018e-18
C815	RESET_B#20	a_1525_212##7	3.80966e-18
C816	CLK	CLK#1	3.3269e-18
C817	VPWR#11	VPWR#9	6.80414e-18
C818	Q	a_1921_409##5	3.82161e-17
C819	a_1921_409##10	VPWR#3	2.69123e-17
C820	Q	a_1921_409##7	2.3409e-17
C821	a_30_78##2	a_306_74##7	2.99393e-17
C822	a_1921_409##2	Q#3	2.37428e-19
C823	a_837_359##5	VNB	8.47264e-18
C824	VPWR#14	a_490_362##3	1.21428e-18
C825	a_696_457##7	VNB	5.45086e-18
C826	a_696_457##6	VNB	5.19133e-18
C827	VGND#5	RESET_B#9	3.54151e-18
C828	RESET_B#20	VPWR#7	8.07275e-18
C829	RESET_B#16	VNB	1.90767e-18
C830	a_30_78##4	VNB	1.12156e-17
C831	a_306_74##11	VNB	1.57423e-17
C832	RESET_B#7	a_306_74##3	1.03968e-19
C833	a_696_457##3	RESET_B#16	1.00009e-17
C834	VGND#4	VPWR#4	3.10205e-18
C835	a_306_74##7	a_490_362##12	2.12859e-17
C836	a_696_457##4	a_837_359##7	1.59534e-17
C837	VGND#7	a_696_457##10	1.1314e-17
C838	VGND#1	VNB	6.84052e-17
C839	VPWR#8	a_490_362##5	3.85987e-19
C840	a_306_74##13	a_490_362##3	1.68557e-19
C841	VGND#11	VNB	9.90255e-18
C842	a_1921_409##11	VNB	1.16283e-17
C843	VPWR#12	CLK	1.24797e-18
C844	VGND#12	VNB	8.69715e-18
C845	a_1525_212##4	VNB	9.99431e-18
C846	VGND#13	VNB	1.6568e-18
C847	a_1525_212##7	VPWR#3	3.33119e-17
C848	RESET_B#8	a_306_74##3	1.9214e-17
C849	a_490_362##13	VGND#14	8.9161e-18
C850	VPWR#13	CLK#1	5.04031e-18
C851	a_1271_74##10	VNB	2.78033e-18
C852	a_30_78##2	CLK#1	9.93553e-18
C853	RESET_B#16	a_696_457##9	1.06544e-17
C854	VGND#11	VPWR#4	9.56833e-18
C855	VGND#7	a_30_78#	1.05674e-17
C856	VPWR#14	a_306_74##7	4.00261e-17
C857	a_696_457##10	VNB	5.04353e-18
C858	a_30_78#	VNB	3.35859e-18
C859	a_490_362##13	VNB	3.98169e-17
C860	VPWR#12	D	5.31873e-18
C861	VGND#15	VNB	4.10204e-18
C862	D#1	RESET_B#3	3.49432e-17
C863	VGND#11	a_1921_409##3	3.81426e-18
C864	VGND#16	VNB	8.0312e-18
C865	VGND#7	D	7.3863e-18
C866	RESET_B#20	a_1271_74##8	6.44626e-17
C867	a_30_78##5	VNB	2.85719e-17
C868	VPWR#3	Q	2.08925e-17
C869	VPWR#1	VNB	8.01444e-17
C870	a_696_457##4	VGND#14	1.28874e-17
C871	VGND#4	Q	2.04997e-17
C872	VPWR#4	VNB	1.59725e-17
C873	VGND#13	RESET_B#10	3.73377e-19
C874	a_1921_409##10	VNB	1.64195e-17
C875	a_837_359##2	a_837_359##5	8.25142e-19
C876	VGND#7	a_490_362##13	1.47248e-16
C877	a_490_362##12	CLK#1	2.14226e-18
C878	VPWR#5	VNB	5.52259e-18
C879	a_1525_212##7	VNB	6.1497e-18
C880	a_696_457##8	a_306_74##4	8.11467e-19
C881	VPWR#7	VNB	3.06429e-18
C882	a_1271_74##8	VNB	8.4524e-18
C883	a_306_74##13	a_306_74##7	2.62783e-18
C884	a_837_359##4	VNB	1.19837e-18
C885	VPWR#9	VNB	7.36443e-18
C886	a_696_457##9	VNB	3.04793e-18
C887	VPWR#11	VNB	9.8912e-18
C888	Q	a_1921_409##4	1.62217e-18
C889	a_696_457##7	a_837_359##2	4.07211e-17
C890	a_696_457##8	VNB	6.92316e-19
C891	a_30_78##2	VNB	1.58667e-17
C892	a_490_362##12	VNB	2.20095e-18
C893	a_1921_409##9	a_1271_74#	2.19552e-18
C894	a_30_78##2	RESET_B#4	4.09443e-19
C895	VPWR#14	VNB	4.24962e-19
C896	a_306_74##13	VNB	2.91372e-18
C897	a_1525_212##4	a_1525_212##2	1.39984e-19
C898	VPWR#16	VNB	1.94315e-18
C899	VGND#5	a_1525_212#	3.49844e-18
C900	a_30_78##6	VNB	4.73677e-18
C901	CLK	CLK#2	3.74587e-19
C902	a_30_78##2	a_696_457##7	4.33145e-17
C903	VPWR#14	CLK#1	3.58837e-17
C904	VPWR#17	VNB	5.68378e-17
C905	a_1921_409#	VNB	3.32541e-17
C906	a_1921_409##6	VNB	3.06908e-17
C907	a_837_359##2	a_696_457##6	5.16497e-17
C908	a_1271_74#	VNB	4.3315e-17
C909	a_1271_74##4	VNB	4.36123e-17
C910	a_1525_212##7	VPWR#6	6.92384e-18
C911	RESET_B#9	VNB	3.72265e-17
C912	a_1525_212#	VNB	2.36605e-17
C913	VPWR#15	RESET_B#4	9.67464e-19
C914	a_306_74#	VNB	5.825e-17
C915	a_490_362##5	VNB	4.4654e-17
C916	a_696_457##4	VNB	3.10562e-17
C917	VPWR#3	a_1271_74##8	2.74164e-17
C918	RESET_B#7	VNB	3.94316e-17
C919	a_837_359##5	a_1271_74##10	8.6439e-17
C920	a_837_359#	VNB	3.06745e-17
C921	a_490_362#	VNB	5.72696e-17
C922	a_306_74##9	VNB	4.32835e-17
C923	D	D#2	6.165e-17
C924	a_306_74##8	VNB	2.96033e-17
C925	a_696_457##8	a_306_74##3	3.60534e-18
C926	CLK#3	VNB	3.28157e-17
C927	RESET_B#3	VNB	3.07509e-17
C928	a_306_74##13	CLK#1	3.57629e-17
C929	D#1	VNB	3.23939e-17
C930	RESET_B#7	VGND#14	1.34323e-17
C931	a_1921_409##5	VNB	4.90477e-17
C932	a_1921_409##7	VNB	3.81484e-17
C933	a_1271_74##5	VNB	4.62986e-17
C934	VGND#13	a_1525_212##2	2.55559e-17
C935	a_30_78##6	a_306_74##7	1.90572e-19
C936	a_1271_74##6	VNB	3.78434e-17
C937	VPWR#13	RESET_B#4	3.67723e-19
C938	RESET_B#11	VNB	2.46311e-17
C939	a_1525_212##3	VNB	4.25271e-17
C940	a_490_362##5	a_306_74##2	1.00137e-17
C941	a_490_362##6	VNB	2.95066e-17
C942	a_306_74##2	VNB	1.43427e-16
C943	a_696_457#	VNB	3.39226e-17
C944	RESET_B#8	VNB	2.79837e-17
C945	VPWR#14	RESET_B#4	3.12623e-18
C946	a_837_359##3	VNB	2.01233e-17
C947	a_306_74##6	VNB	2.62138e-17
C948	a_490_362##3	VNB	2.28662e-17
C949	a_306_74##7	VNB	3.04774e-17
C950	VPWR#16	CLK#1	5.90081e-18
C951	CLK#1	VNB	4.27466e-17
C952	RESET_B#4	VNB	2.92303e-17
C953	D#3	VNB	4.70692e-17
C954	RESET_B#20	VNB	4.511e-18
C955	VPWR#3	VNB	2.58145e-16
C956	a_30_78#	a_696_457##10	9.517e-17
C957	VGND#4	VNB	2.60423e-16
C958	a_696_457##7	a_490_362##2	4.41808e-19
C959	RESET_B#17	VNB	9.49748e-18
C960	VPWR#12	VNB	2.97663e-16
C961	a_837_359##3	a_306_74##3	1.49312e-17
C962	VGND#7	VNB	3.63086e-16
C963	a_1921_409##4	VNB	4.45141e-17
C964	RESET_B#16	a_837_359##2	6.7064e-19
C965	a_1271_74##3	VNB	8.74954e-17
C966	RESET_B#10	VNB	5.81406e-17
C967	a_1525_212##2	VNB	5.58643e-17
C968	a_490_362##7	VNB	3.92112e-17
C969	a_490_362##4	VNB	5.89696e-17
C970	VGND#7	a_30_78##5	2.746e-17
C971	a_30_78##6	CLK#1	5.4022e-19
C972	a_696_457##3	VNB	6.98854e-17
C973	RESET_B#5	VNB	4.79611e-18
C974	a_837_359##2	VNB	5.8003e-17
C975	VGND#5	a_306_74#	4.05432e-18
C976	a_490_362##2	VNB	4.47822e-17
C977	a_696_457##10	a_696_457##4	3.55371e-19
C978	a_1921_409##11	a_1921_409##3	6.76462e-20
C979	a_306_74##5	VNB	1.58408e-18
C980	CLK#2	VNB	3.61496e-17
C981	RESET_B#1	VNB	4.92924e-18
C982	D#2	VNB	1.21604e-16
C983	a_837_359##5	a_837_359##7	1.03225e-18
C984	VPWR#16	RESET_B#4	3.22984e-17
C985	a_30_78##2	a_306_74##4	2.95443e-17
C986	VPWR#15	D#3	2.74035e-18
C987	VPWR#10	VPWR#8	3.60484e-19
C988	RESET_B#17	a_1271_74##8	3.67349e-18
C989	CLK	VNB	4.36089e-18
C990	D	VNB	4.5461e-17
C991	a_1525_212##5	a_1271_74#	4.99707e-18
C992	a_490_362##13	a_696_457##10	7.22791e-17
C993	Q	VNB	2.32733e-17
C994	RESET_B#4	a_30_78##6	9.71666e-18
C995	a_490_362##4	a_1525_212##4	3.53402e-18
C996	a_306_74##4	a_490_362#	8.91222e-19
C997	VGND#6	a_490_362##5	4.806e-18
C998	RESET_B	a_306_74##5	9.05614e-18
C999	RESET_B	VPWR#14	8.92823e-18
C1000	VGND#9	a_30_78##5	2.42051e-17
C1001	VPWR#12	RESET_B	5.59347e-17
C1002	RESET_B	RESET_B#2	1.33767e-17
C1003	RESET_B	a_490_362##2	4.82422e-19
C1004	RESET_B	a_490_362##12	3.48309e-17
C1005	VGND#9	VNB	6.68262e-17
C1006	VGND#9	CLK#3	1.44399e-18
C1007	a_30_78##4	RESET_B	8.22768e-17
C1008	VGND#9	a_306_74##11	1.04822e-17
C1009	RESET_B	a_30_78##2	2.65401e-17
C1010	RESET_B	D	4.11387e-18
C1011	RESET_B	VGND#16	3.10822e-18
C1012	RESET_B	VPWR#13	5.042e-18
C1013	VGND#9	VGND#8	1.18259e-18
C1014	RESET_B	VNB	1.33011e-17
C1015	VGND#9	RESET_B#3	9.69467e-18
C1016	RESET_B	CLK	1.40238e-17
C1017	RESET_B	CLK#1	2.22342e-18
C1018	RESET_B	VPWR#16	3.7973e-18
C1019	RESET_B	VPWR#15	1.96063e-18
C1020	RESET_B	a_306_74##7	2.29591e-18
C1021	RESET_B	VGND#15	4.87012e-18
C1022	VGND#9	D	9.84563e-19
C1023	VGND#9	D#1	6.28822e-18
C1024	VGND#9	D#2	4.37366e-19
C1025	RESET_B	CLK#2	4.96441e-18
C1026	RESET_B	a_306_74##4	3.00888e-18
C1027	RESET_B	a_306_74##13	6.01797e-17
C1028	RESET_B	a_306_74##11	4.01671e-18
C1029	VGND#9	VGND#15	6.40886e-19
C1030	RESET_B	a_490_362##13	2.38284e-18
C1031	VGND#7	VGND#9	1.22801e-16
C1032	VGND#9	a_306_74##8	2.35003e-19
*
*
.ENDS sky130_fd_sc_hs__dfrtp_2
*
