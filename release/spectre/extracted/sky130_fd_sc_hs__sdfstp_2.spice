* Extracted by Quantus, converted by sky130cad/quantus.py
*
*
*
*                       LINUX           Wed Nov 18 09:10:40 2026
*
*
*
*  PROGRAM  advgen
*
*  Name           : advgen - Quantus - (64-bit)
*  Version        : 25.1.0-p047
*  Build Date     : Thu Dec 11 23:20:30 PST 2025
*
*  HSPICE LIBRARY
*
*  OPERATING_TEMPERATURE 150
*  QRC_TECH_DIR <path>/tech
*
*
*

*
.SUBCKT sky130_fd_sc_hs__sdfstp_2 VNB VPB VGND SET_B VPWR Q SCD CLK SCE D
*
*
*  caps2d version: 10
*
*
*       TRANSISTOR CARDS
*
*
XM40 a_27_74##8 SCE#4 VGND#21 VNB sky130_fd_pr__nfet_01v8_lvt l=0.15 w=0.42 ad=0.1197 as=0.1995 pd=1.41 ps=1.79
XM24 VGND#21 a_27_74# a_239_74# VNB sky130_fd_pr__nfet_01v8_lvt l=0.15 w=0.42 ad=0.1995 as=0.1008 pd=1.79 ps=1.32
XM6 a_239_74# D#1 a_290_464##6 VNB sky130_fd_pr__nfet_01v8_lvt l=0.15 w=0.42 ad=0.1008 as=0.1176 pd=1.32 ps=1.4
XM17 a_290_464##6 SCE#6 a_403_74# VNB sky130_fd_pr__nfet_01v8_lvt l=0.15 w=0.42 ad=0.1176 as=0.1344 pd=1.4 ps=1.48
XM26 a_403_74# SCD#3 VGND#20 VNB sky130_fd_pr__nfet_01v8_lvt l=0.15 w=0.42 ad=0.1344 as=0.1197 pd=1.48 ps=1.41
XM18 a_608_74##15 CLK#3 VGND#19 VNB sky130_fd_pr__nfet_01v8_lvt l=0.15 w=0.74 ad=0.2109 as=0.259 pd=2.05 ps=2.18
XM8 VGND#19 a_608_74##10 a_795_74##13 VNB sky130_fd_pr__nfet_01v8_lvt l=0.15 w=0.74 ad=0.259 as=0.2072 pd=2.18 ps=2.04
XM20 a_290_464# a_608_74##9 a_991_81##15 VNB sky130_fd_pr__nfet_01v8_lvt l=0.15 w=0.42 ad=0.1176 as=0.2562 pd=1.4 ps=2.06
XM39 a_991_81##15 a_795_74# a_1143_81# VNB sky130_fd_pr__nfet_01v8_lvt l=0.15 w=0.42 ad=0.2562 as=0.0882 pd=2.06 ps=1.26
XM44 a_1143_81# a_1185_55##2 VGND#18 VNB sky130_fd_pr__nfet_01v8_lvt l=0.15 w=0.42 ad=0.0882 as=0.2316 pd=1.26 ps=2.11
XM36 a_1185_55##5 a_991_81# a_1429_74# VNB sky130_fd_pr__nfet_01v8_lvt l=0.15 w=0.42 ad=0.1197 as=0.1008 pd=1.41 ps=1.32
XM32 a_1429_74# SET_B#1 VGND#17 VNB sky130_fd_pr__nfet_01v8_lvt l=0.15 w=0.42 ad=0.1008 as=0.2734 pd=1.32 ps=2.32
XM19 a_1641_74##2 a_991_81##10 VGND#17 VNB sky130_fd_pr__nfet_01v8_lvt l=0.15 w=0.64 ad=0.1792 as=0.2734 pd=1.84 ps=2.32
XM35 VGND#16 a_991_81##4 a_1641_74##2 VNB sky130_fd_pr__nfet_01v8_lvt l=0.15 w=0.64 ad=0.2336 as=0.1792 pd=2.01 ps=1.84
XM14 a_1641_74# a_795_74##9 a_1804_424##17 VNB sky130_fd_pr__nfet_01v8_lvt l=0.15 w=0.64 ad=0.1792 as=0.2272 pd=1.84 ps=1.99
XM27 a_1804_424##15 a_795_74##6 a_1641_74# VNB sky130_fd_pr__nfet_01v8_lvt l=0.15 w=0.64 ad=0.202 as=0.1792 pd=1.98 ps=1.84
XM7 a_1804_424##15 a_608_74# a_2141_74# VNB sky130_fd_pr__nfet_01v8_lvt l=0.15 w=0.42 ad=0.202 as=0.1008 pd=1.98 ps=1.32
XM22 a_2141_74# a_2186_367##2 a_2219_74# VNB sky130_fd_pr__nfet_01v8_lvt l=0.15 w=0.42 ad=0.1008 as=0.1764 pd=1.32 ps=1.68
XM15 a_2219_74# SET_B#4 VGND#15 VNB sky130_fd_pr__nfet_01v8_lvt l=0.15 w=0.42 ad=0.1764 as=0.2877 pd=1.68 ps=2.21
XM38 VGND#15 a_1804_424##6 a_2186_367##7 VNB sky130_fd_pr__nfet_01v8_lvt l=0.15 w=0.42 ad=0.2877 as=0.1197 pd=2.21 ps=1.41
XM43 a_2611_98##9 a_1804_424##5 VGND#14 VNB sky130_fd_pr__nfet_01v8_lvt l=0.15 w=0.64 ad=0.1824 as=0.269 pd=1.85 ps=2.23
XM45 Q#2 a_2611_98##6 VGND#14 VNB sky130_fd_pr__nfet_01v8_lvt l=0.15 w=0.74 ad=0.2072 as=0.269 pd=2.04 ps=2.23
XM2 VGND#1 a_2611_98##5 Q#2 VNB sky130_fd_pr__nfet_01v8_lvt l=0.15 w=0.74 ad=0.222 as=0.2072 pd=2.08 ps=2.04
XM33 a_27_74##9 SCE#5 VPWR#23 VPB sky130_fd_pr__pfet_01v8 l=0.15 w=0.64 ad=0.1888 as=0.192 pd=1.87 ps=1.88
XM16 VPWR#23 SCE#1 a_206_464# VPB sky130_fd_pr__pfet_01v8 l=0.15 w=0.64 ad=0.192 as=0.1728 pd=1.88 ps=1.82
XM1 a_206_464# D#3 a_290_464##4 VPB sky130_fd_pr__pfet_01v8 l=0.15 w=0.64 ad=0.1728 as=0.3072 pd=1.82 ps=2.24
XM23 a_290_464##4 a_27_74##3 a_416_464# VPB sky130_fd_pr__pfet_01v8 l=0.15 w=0.64 ad=0.3072 as=0.1728 pd=2.24 ps=1.82
XM5 a_416_464# SCD#4 VPWR#22 VPB sky130_fd_pr__pfet_01v8 l=0.15 w=0.64 ad=0.1728 as=0.2749 pd=1.82 ps=2.35
XM3 a_608_74##13 CLK#1 VPWR#21 VPB sky130_fd_pr__pfet_01v8 l=0.15 w=1.12 ad=0.3192 as=0.336 pd=2.81 ps=2.84
XM28 VPWR#21 a_608_74##11 a_795_74##17 VPB sky130_fd_pr__pfet_01v8 l=0.15 w=1.12 ad=0.336 as=0.3076 pd=2.84 ps=2.83
XM25 a_290_464##5 a_795_74##5 a_991_81##14 VPB sky130_fd_pr__pfet_01v8 l=0.15 w=0.42 ad=0.1239 as=0.18445 pd=1.43 ps=1.87
XM12 a_991_81##14 a_608_74##8 a_1117_483# VPB sky130_fd_pr__pfet_01v8 l=0.15 w=0.42 ad=0.18445 as=0.1714 pd=1.87 ps=1.78
XM37 a_1117_483# a_1185_55##4 VPWR#20 VPB sky130_fd_pr__pfet_01v8 l=0.15 w=0.42 ad=0.1714 as=0.2247 pd=1.78 ps=1.91
XM11 VPWR#20 a_991_81##3 a_1185_55##7 VPB sky130_fd_pr__pfet_01v8 l=0.15 w=0.42 ad=0.2247 as=0.1449 pd=1.91 ps=1.53
XM29 a_1185_55##7 SET_B#3 VPWR#19 VPB sky130_fd_pr__pfet_01v8 l=0.15 w=0.42 ad=0.1449 as=0.3276 pd=1.53 ps=2.65
XM41 a_1584_379##2 a_991_81##8 VPWR#19 VPB sky130_fd_pr__pfet_01v8 l=0.15 w=0.84 ad=0.252 as=0.3276 pd=2.28 ps=2.65
XM13 VPWR#18 a_991_81##9 a_1584_379##2 VPB sky130_fd_pr__pfet_01v8 l=0.15 w=0.84 ad=0.2352 as=0.252 pd=2.24 ps=2.28
XM4 a_1804_424##13 a_608_74##2 a_1584_379# VPB sky130_fd_pr__pfet_01v8 l=0.15 w=0.84 ad=0.2898 as=0.252 pd=2.37 ps=2.28
XM30 a_1584_379# a_608_74##7 a_1804_424##11 VPB sky130_fd_pr__pfet_01v8 l=0.15 w=0.84 ad=0.252 as=0.3591 pd=2.28 ps=2.86
XM0 a_1804_424##11 a_795_74##10 a_2141_508# VPB sky130_fd_pr__pfet_01v8 l=0.15 w=0.42 ad=0.3591 as=0.1008 pd=2.86 ps=1.32
XM10 a_2141_508# a_2186_367##3 VPWR#17 VPB sky130_fd_pr__pfet_01v8 l=0.15 w=0.42 ad=0.1008 as=0.126 pd=1.32 ps=1.44
XM34 VPWR#17 SET_B#6 a_1804_424##14 VPB sky130_fd_pr__pfet_01v8 l=0.15 w=0.42 ad=0.126 as=0.1176 pd=1.44 ps=1.4
XM42 a_2186_367##4 a_1804_424##7 VPWR#16 VPB sky130_fd_pr__pfet_01v8 l=0.15 w=0.42 ad=0.1176 as=0.1176 pd=1.4 ps=1.4
XM21 a_2611_98##10 a_1804_424# VPWR#15 VPB sky130_fd_pr__pfet_01v8 l=0.15 w=1 ad=0.28 as=0.3868 pd=2.56 ps=2.95
XM31 Q#1 a_2611_98##4 VPWR#15 VPB sky130_fd_pr__pfet_01v8 l=0.15 w=1.12 ad=0.336 as=0.3868 pd=2.84 ps=2.95
XM9 VPWR#1 a_2611_98# Q#1 VPB sky130_fd_pr__pfet_01v8 l=0.15 w=1.12 ad=0.3192 as=0.336 pd=2.81 ps=2.84
*
*
*       RESISTOR AND CAP/DIODE CARDS
*
Rg1	SCE#1	SCE#2	360.192505
Rg2	SCE#2	SCE#3	41.885086
Rg3	SCE#3	SCE#4	580.435486
Rg4	SCE#2	SCE#5	307.679871
Rg5	a_27_74#	a_27_74##2	216.119781
Rg6	D#1	D#2	744.072815
Rg7	D#2	D#3	301.353882
Rg8	a_27_74##3	a_27_74##4	296.912354
Rg9	SCE#6	SCE#7	416.971466
Rg10	SCD#1	SCD#2	61.920815
Rg11	SCD#2	SCD#3	468.943939
Rg12	SCD#2	SCD#4	416.451172
Rg13	CLK#1	CLK#2	506.808380
Rg14	CLK#2	CLK#3	378.639191
Rg15	a_795_74#	a_795_74##2	526.291016
Rg16	a_795_74##2	a_795_74##3	241.326981
Rg17	a_795_74##2	a_795_74##4	43.187008
Rg18	a_795_74##3	a_795_74##5	399.077515
Rg19	a_1185_55#	a_1185_55##2	222.649536
Rg20	a_1185_55#	a_1185_55##3	299.452332
Rg21	a_1185_55##3	a_1185_55##4	310.783966
Rg22	a_991_81#	a_991_81##2	338.727966
Rg23	a_991_81##2	a_991_81##3	530.790833
Rg24	SET_B#1	SET_B#2	429.478333
Rg25	SET_B#2	SET_B#3	512.633179
Rg26	a_991_81##4	a_991_81##5	367.229675
Rg27	a_991_81##5	a_991_81##6	21.843695
Rg28	a_991_81##6	a_991_81##7	37.411411
Rg29	a_991_81##7	a_991_81##8	430.654846
Rg30	a_991_81##5	a_991_81##9	419.955353
Rg31	a_991_81##6	a_991_81##10	251.379669
Rg32	a_795_74##6	a_795_74##7	444.515137
Rg33	a_795_74##7	a_795_74##8	505.692139
Rg34	a_795_74##7	a_795_74##9	234.008942
Rg35	a_608_74#	a_608_74##2	1628.810303
Rg36	a_608_74##2	a_608_74##3	305.272156
Rg37	a_608_74##3	a_608_74##4	2211.390869
Rg38	a_608_74##4	a_608_74##5	1439.085938
Rg39	a_608_74##5	a_608_74##6	59.143440
Rg40	a_608_74##3	a_608_74##7	516.968567
Rg41	a_608_74##4	a_608_74##8	240.280167
Rg42	a_608_74##5	a_608_74##9	628.999512
Rg43	a_608_74##6	a_608_74##10	401.056915
Rg44	a_608_74##6	a_608_74##11	447.848328
Rg45	a_795_74##10	a_795_74##11	341.235687
Rg46	a_2186_367#	a_2186_367##2	216.119781
Rg47	a_2186_367#	a_2186_367##3	822.215515
Rg48	SET_B#4	SET_B#5	536.992615
Rg49	SET_B#5	SET_B#6	480.740387
Rg50	a_1804_424#	a_1804_424##2	534.304016
Rg51	a_1804_424##2	a_1804_424##3	178.605804
Rg52	a_1804_424##3	a_1804_424##4	39.977921
Rg53	a_1804_424##2	a_1804_424##5	272.757050
Rg54	a_1804_424##3	a_1804_424##6	352.653320
Rg55	a_1804_424##4	a_1804_424##7	398.767578
Rg56	a_2611_98#	a_2611_98##2	460.380524
Rg57	a_2611_98##2	a_2611_98##3	74.487549
Rg58	a_2611_98##3	a_2611_98##4	458.091156
Rg59	a_2611_98##2	a_2611_98##5	352.396484
Rg60	a_2611_98##3	a_2611_98##6	361.824097
Rf1	D#4	D	0.660563
Rf2	D#2	D#6	160.893372
Rf3	D#4	D#6	8.660800
Rf4	a_27_74##4	a_27_74##6	291.994385
Rf5	a_27_74##6	a_27_74##7	94.174995
Rf6	a_27_74##7	a_27_74##8	35.080269
Rf7	a_27_74##6	a_27_74##9	19.781082
Rf8	a_27_74##7	a_27_74##2	184.769806
Rf9	SCE#7	SCE	251.252716
Rf10	SCE	SCE#3	85.627823
Rf11	SCD	SCD#1	1.128962
Rf12	SCD#1	SCD	19.756838
Rf13	CLK#4	CLK#2	161.655762
Rf14	CLK	CLK#6	1.422963
Rf15	CLK#4	CLK#6	6.353694
Rf16	a_608_74##6	a_608_74##14	211.960068
Rf17	a_608_74##14	a_608_74##15	94.925797
Rf18	a_608_74##13	a_608_74##14	15.000000
Rf19	a_290_464#	a_290_464##2	117.060059
Rf20	a_290_464##2	a_290_464##3	174.601059
Rf21	a_290_464##3	a_290_464##4	56.299774
Rf22	a_290_464##2	a_290_464##5	21.676468
Rf23	a_290_464##3	a_290_464##6	177.554245
Rf24	a_795_74##3	a_795_74##13	348.841888
Rf25	a_1185_55##5	a_1185_55#	233.738617
Rf26	a_1185_55##7	a_1185_55##3	280.138489
Rf27	SET_B#7	SET_B#8	1.320761
Rf28	SET_B#2	SET_B#10	161.553558
Rf29	SET_B#7	SET_B#10	3.536082
Rf30	a_991_81##7	a_991_81##12	268.351685
Rf31	a_991_81##12	a_991_81##13	92.916672
Rf32	a_991_81##13	a_991_81##14	98.739693
Rf33	a_991_81##13	a_991_81##15	53.910976
Rf34	a_1584_379#	a_1584_379##2	141.735626
Rf35	a_1641_74#	a_1641_74##2	134.342651
Rf36	a_795_74##11	a_795_74##15	201.792847
Rf37	a_795_74##15	a_795_74##16	322.744873
Rf38	a_795_74##16	a_795_74##17	179.947769
Rf39	a_795_74##15	a_795_74##8	161.843979
Rf40	a_795_74##16	a_795_74##4	179.093903
Rf41	SET_B#11	SET_B	11.386155
Rf42	SET_B#5	SET_B#14	161.841171
Rf43	SET_B#11	SET_B#14	10.390493
Rf44	a_1804_424##4	a_1804_424##9	106.380615
Rf45	a_1804_424##9	a_1804_424##10	20.443399
Rf46	a_1804_424##10	a_1804_424##12	61.483932
Rf47	a_1804_424##12	a_1804_424##13	99.400368
Rf48	a_1804_424##9	a_1804_424##14	27.785934
Rf49	a_1804_424##10	a_1804_424##16	127.065117
Rf50	a_1804_424##16	a_1804_424##17	91.455025
Rf51	a_1804_424##11	a_1804_424##12	15.000000
Rf52	a_1804_424##15	a_1804_424##16	15.000000
Rf53	a_2186_367##4	a_2186_367##5	173.239883
Rf54	a_2186_367##5	a_2186_367#	265.718140
Rf55	a_2186_367##5	a_2186_367##7	28.098698
Rf56	a_2611_98##3	a_2611_98##8	182.101395
Rf57	a_2611_98##8	a_2611_98##9	33.829830
Rf58	a_2611_98##8	a_2611_98##10	42.687065
Rf59	Q#1	Q	39.252953
Rf60	Q	Q#2	52.531548
Rf61	VPWR#1	VPWR#2	61.735207
Rf62	VPWR#2	VPWR#3	34.887100
Rf63	VPWR#3	VPWR#4	73.579330
Rf64	VPWR#4	VPWR#5	107.392517
Rf65	VPWR#5	VPWR#6	82.214622
Rf66	VPWR#6	VPWR#7	111.069572
Rf67	VPWR#7	VPWR#8	68.798325
Rf68	VPWR#8	VPWR#9	102.401550
Rf69	VPWR#9	VPWR#10	183.365021
Rf70	VPWR#10	VPWR#11	25.543140
Rf71	VPWR#11	VPWR#12	46.362534
Rf72	VPWR#12	VPWR#13	145.686676
Rf74	VPWR#3	VPWR#15	40.984402
Rf75	VPWR#4	VPWR#16	31.948624
Rf76	VPWR#5	VPWR#17	37.283096
Rf77	VPWR#7	VPWR#18	49.050522
Rf78	VPWR#8	VPWR#19	70.310089
Rf79	VPWR#9	VPWR#20	48.538895
Rf80	VPWR#10	VPWR#21	33.326477
Rf81	VPWR#12	VPWR#22	24.862514
Rf82	VPWR#13	VPWR#23	33.326477
Rf83	VGND#1	VGND#2	75.552567
Rf84	VGND#2	VGND#3	35.097054
Rf85	VGND#3	VGND#4	123.894348
Rf86	VGND#4	VGND#5	139.202133
Rf87	VGND#5	VGND#6	89.462326
Rf88	VGND#6	VGND#7	79.902992
Rf89	VGND#7	VGND#8	106.931671
Rf90	VGND#8	VGND#9	190.612732
Rf91	VGND#9	VGND#10	23.716879
Rf92	VGND#10	VGND#11	53.667580
Rf93	VGND#11	VGND#12	130.122818
Rf95	VGND#3	VGND#14	42.062149
Rf96	VGND#4	VGND#15	15.818231
Rf97	VGND#6	VGND#16	32.539131
Rf98	VGND#7	VGND#17	26.375343
Rf99	VGND#8	VGND#18	22.500479
Rf100	VGND#9	VGND#19	32.518913
Rf101	VGND#11	VGND#20	33.129639
Rf102	VGND#12	VGND#21	27.459908
Rf116	a_991_81##2	a_991_81##12	80.116402
Re2	SET_B	SET_B#8	16.991604
Re3	VPWR#2	VPWR#25	4.826505
Re4	VPWR#25	VPWR	1.014099
Re5	VPWR	VPWR#11	2.265657
Re6	VGND#2	VGND#23	4.826505
Re7	VGND#23	VGND	1.014099
Re8	VGND	VGND#10	2.265657
Re12	VPWR#6	VPWR#25	0.698413
Re15	VGND#5	VGND#23	0.698413
*
*       CAPACITOR CARDS
*
*
C1	a_991_81##14	a_795_74##2	3.2166e-18
C2	VGND#10	a_290_464#	1.07079e-17
C3	D#1	SCE#6	3.17997e-17
C4	VPWR#11	a_1185_55##4	2.61518e-18
C5	a_2186_367##4	VPWR#4	1.81243e-17
C6	a_1641_74#	a_795_74##6	2.9289e-17
C7	SCE#6	SCD#2	1.95612e-18
C8	VPWR#11	VPWR#10	9.22688e-17
C9	a_1804_424##15	a_2186_367#	2.70872e-17
C10	VGND#11	a_290_464##6	1.10772e-17
C11	a_795_74##11	a_2186_367##3	3.16162e-17
C12	a_991_81##13	a_795_74##3	7.71155e-17
C13	VGND#21	VGND#20	4.64817e-19
C14	VPWR#21	CLK#1	3.6861e-17
C15	VGND#10	a_795_74##13	4.39143e-17
C16	VGND#21	a_27_74##7	5.99213e-18
C17	VGND#3	a_2611_98##5	7.13412e-19
C18	a_795_74##3	a_795_74#	1.34121e-18
C19	VGND#16	a_608_74#	6.42362e-20
C20	a_991_81##3	a_608_74##4	1.91834e-17
C21	a_1804_424##15	a_795_74##9	8.71295e-19
C22	a_290_464##3	D#3	2.66818e-19
C23	VPWR#11	VPWR#9	1.2498e-16
C24	a_795_74##15	VPWR#19	1.0754e-16
C25	VGND#3	a_2611_98##9	1.1655e-17
C26	a_1804_424##14	VPWR#5	2.00524e-17
C27	a_1641_74##2	VGND#16	7.15457e-17
C28	a_795_74##2	a_1185_55#	1.24931e-17
C29	VPWR#21	a_608_74##5	4.63857e-19
C30	a_795_74##3	a_608_74##9	4.0517e-17
C31	a_795_74##15	a_608_74#	1.25493e-17
C32	VGND#10	VGND#19	2.00058e-17
C33	a_608_74##2	a_2186_367#	3.67917e-19
C34	VPWR#8	SET_B#3	1.08088e-18
C35	a_1804_424##17	a_795_74##6	4.60354e-19
C36	a_608_74##13	CLK#1	4.05295e-17
C37	VPWR#18	a_1804_424##13	3.21267e-17
C38	a_1584_379##2	a_1584_379#	3.09062e-18
C39	a_1185_55##7	a_991_81#	1.75929e-18
C40	a_2611_98##8	VPWR#3	8.63734e-20
C41	a_608_74##7	a_795_74##11	8.45478e-18
C42	a_795_74##3	a_608_74##10	3.63796e-19
C43	a_1185_55##3	a_608_74##4	1.23406e-18
C44	a_795_74##6	a_608_74##2	1.03073e-17
C45	a_795_74##16	a_1185_55##7	7.55184e-17
C46	VGND#10	a_608_74##15	3.62119e-17
C47	SET_B#8	a_608_74##3	7.1417e-19
C48	VPWR#21	SCD#4	1.4233e-18
C49	VGND#4	a_2611_98##6	7.18982e-19
C50	a_1641_74#	a_795_74##9	3.2853e-17
C51	VGND#9	CLK#4	2.18192e-19
C52	VPWR#11	a_608_74##11	1.17436e-18
C53	a_27_74#	D#1	3.41494e-17
C54	a_1804_424##10	a_1804_424##3	1.13028e-19
C55	VPWR#22	CLK#1	4.64958e-18
C56	a_1804_424##15	a_795_74##11	1.64458e-17
C57	a_608_74##2	a_795_74##11	1.49131e-18
C58	a_1804_424##10	a_608_74##7	1.40883e-19
C59	VGND#10	VGND#20	1.66089e-17
C60	VPWR#21	a_608_74##4	7.70754e-19
C61	VGND#16	a_795_74##6	1.67521e-19
C62	SET_B#8	a_795_74##7	5.37171e-18
C63	VPWR#11	CLK#1	5.96658e-18
C64	a_1804_424##15	a_991_81##4	2.97613e-19
C65	VGND#3	a_2611_98##3	2.83214e-19
C66	VGND#17	VGND#16	1.79823e-18
C67	VPWR#9	a_991_81##3	1.12138e-18
C68	a_1584_379##2	a_1804_424##13	2.65609e-18
C69	a_290_464##3	SCE#1	1.19677e-19
C70	a_795_74##8	a_608_74##2	3.00018e-17
C71	a_1804_424##17	a_795_74##9	3.30142e-17
C72	VGND#3	a_2611_98##6	4.19463e-18
C73	a_290_464##3	VPWR#12	1.69731e-17
C74	a_1185_55##7	a_795_74##15	8.34875e-17
C75	VPWR#11	SCD#4	2.78791e-19
C76	a_795_74##15	a_795_74##6	3.69839e-18
C77	a_2611_98##6	a_2611_98##5	3.83443e-17
C78	SCD#4	VPWR#22	2.35969e-17
C79	a_1804_424##3	a_1804_424##2	1.10181e-18
C80	a_991_81##9	a_795_74##8	3.88749e-18
C81	VGND#21	a_290_464##6	1.29468e-17
C82	VGND#10	a_290_464##6	2.70291e-17
C83	a_1641_74#	a_991_81##4	3.64406e-19
C84	CLK#2	a_608_74##10	4.63636e-18
C85	VPWR#1	a_2611_98#	3.72387e-17
C86	VPWR#11	a_27_74##3	1.60825e-18
C87	a_1185_55##4	a_608_74##4	1.67095e-17
C88	a_991_81##7	a_608_74##2	5.28031e-19
C89	a_1804_424##15	a_795_74##8	3.88047e-19
C90	a_795_74##16	VPWR#20	1.00027e-16
C91	SCE#4	a_27_74#	1.20276e-17
C92	a_795_74##2	a_1185_55##3	4.49149e-17
C93	VGND#4	VGND#15	1.01072e-17
C94	VGND#16	a_795_74##9	1.71721e-18
C95	SCE#2	D#1	9.71501e-19
C96	a_1584_379##2	VPWR#18	5.79396e-17
C97	VGND#4	a_1804_424##5	4.27664e-19
C98	VPWR#11	D#3	1.69615e-18
C99	a_2186_367##5	a_2611_98##10	5.64793e-18
C100	a_1804_424##10	a_608_74##2	1.29401e-19
C101	SET_B#8	a_795_74##2	2.47735e-19
C102	a_1641_74#	a_795_74##8	3.57156e-18
C103	a_1804_424##10	VPWR#6	9.86986e-20
C104	VGND#17	a_1641_74##2	3.22914e-17
C105	VPWR#22	a_27_74##3	1.0014e-18
C106	a_2611_98#	Q#1	2.21166e-17
C107	a_1804_424##17	a_991_81##4	8.30265e-19
C108	VGND#10	VGND#21	2.28529e-17
C109	VPWR#6	a_608_74##3	8.15385e-18
C110	a_1804_424##17	a_795_74##8	5.15808e-19
C111	a_290_464##3	SCE#5	1.20169e-19
C112	VPWR#11	SCE#1	7.33271e-19
C113	a_290_464##2	a_795_74##3	5.07539e-17
C114	a_290_464##3	VPWR#10	2.61012e-19
C115	a_27_74##8	a_290_464##6	2.13484e-18
C116	VPWR#9	a_1185_55##4	1.68251e-18
C117	VPWR#1	a_2611_98##4	2.56758e-18
C118	a_1641_74##2	a_795_74##9	6.45488e-19
C119	VGND#10	a_27_74##8	1.76e-17
C120	VGND#16	a_795_74##8	1.80098e-18
C121	VGND#3	a_1804_424##5	6.04812e-18
C122	VPWR#11	SCE#5	1.85427e-18
C123	VPWR#15	a_2611_98#	1.3342e-18
C124	a_1804_424##15	a_991_81##7	2.01945e-19
C125	VPWR#19	VPWR#18	4.44806e-18
C126	a_1804_424##5	a_2611_98##6	2.41338e-17
C127	SET_B#2	a_991_81##8	4.94585e-18
C128	a_27_74##6	SCD#4	8.43468e-20
C129	a_991_81##4	VGND#16	2.91966e-17
C130	VPWR#22	D#3	4.5619e-19
C131	a_795_74##17	a_795_74##2	1.41311e-20
C132	a_608_74##15	a_608_74##5	2.06582e-19
C133	a_608_74##5	a_608_74##8	3.92613e-20
C134	a_1641_74##2	a_795_74##8	7.10082e-18
C135	a_290_464##4	a_27_74##3	2.86484e-17
C136	Q#1	a_2611_98##4	4.49997e-17
C137	VPWR#23	SCD#4	2.22483e-19
C138	VGND#17	a_795_74##9	9.16277e-20
C139	SET_B#8	a_1584_379#	6.13176e-18
C140	a_290_464#	a_795_74##2	1.54438e-19
C141	VGND#5	a_1804_424##10	1.28629e-18
C142	a_991_81##3	SET_B#2	2.9231e-18
C143	VPWR#1	a_1804_424#	4.36897e-19
C144	a_608_74##4	a_608_74##8	8.05736e-19
C145	VGND#4	a_1804_424##6	1.48597e-17
C146	a_1804_424##6	a_2611_98##6	5.35428e-19
C147	Q#2	VGND#1	6.36971e-17
C148	a_1641_74##2	a_991_81##4	5.98196e-17
C149	a_795_74##4	a_795_74##2	1.25399e-17
C150	VPWR#19	a_1584_379##2	5.1635e-17
C151	SET_B#8	a_1804_424##13	5.58211e-18
C152	VGND#4	SET_B#5	6.27191e-19
C153	a_2611_98##4	VPWR#15	2.75289e-17
C154	a_608_74##6	a_290_464##2	9.05756e-17
C155	a_1804_424##11	VPWR#6	5.38761e-17
C156	VPWR#22	SCE#1	2.10346e-19
C157	a_608_74##5	a_795_74##3	3.7648e-17
C158	a_290_464##4	D#3	3.20573e-17
C159	a_290_464##2	VPWR#10	5.14348e-19
C160	VPWR#23	a_27_74##3	5.33082e-19
C161	VGND#16	a_991_81##10	7.39149e-19
C162	a_795_74##15	a_991_81##4	4.07489e-18
C163	SET_B#8	VPWR#18	4.48088e-18
C164	a_795_74##3	a_608_74##4	1.42926e-18
C165	Q#1	a_1804_424#	1.09973e-18
C166	a_27_74##6	a_27_74##3	8.33371e-20
C167	a_1641_74##2	a_991_81##7	2.70796e-17
C168	a_991_81##13	a_795_74##2	3.53461e-17
C169	a_1185_55##5	a_1641_74##2	1.75772e-18
C170	SET_B#8	a_795_74##15	6.45452e-17
C171	VGND#3	a_1804_424##6	5.14022e-19
C172	a_27_74##7	D#1	3.01753e-19
C173	a_2611_98##10	a_2611_98##4	1.51863e-18
C174	VGND#17	a_991_81##4	1.42369e-18
C175	a_1804_424##6	a_1804_424##5	4.22933e-18
C176	a_1804_424##11	VPWR#5	7.75987e-19
C177	a_2611_98##3	VPWR#2	3.55992e-18
C178	a_27_74##8	VGND#21	3.21076e-17
C179	a_991_81##14	a_795_74##16	6.6281e-17
C180	a_991_81##7	VGND#17	3.93935e-17
C181	a_290_464#	SCD#2	1.6434e-19
C182	SET_B#8	a_1584_379##2	8.07658e-18
C183	D#1	SCE#7	1.79541e-17
C184	VPWR#8	a_608_74##8	3.15657e-21
C185	a_1804_424##13	VPWR#6	2.52648e-17
C186	VPWR#22	a_608_74##4	5.43078e-20
C187	VGND#5	a_795_74##7	1.29918e-19
C188	a_290_464##4	SCE#1	1.93835e-18
C189	a_1804_424#	VPWR#15	3.57821e-17
C190	a_1804_424##15	SET_B#11	6.54429e-19
C191	VGND#7	a_795_74##15	2.1628e-19
C192	a_2611_98##3	VPWR#3	1.44802e-19
C193	a_1641_74##2	a_991_81##10	3.28418e-17
C194	a_290_464##3	CLK#2	4.70574e-19
C195	a_2611_98##3	VPWR#15	3.79883e-17
C196	VGND#2	a_2611_98##3	4.0145e-18
C197	VGND#14	VGND#1	2.28769e-18
C198	VPWR#23	D#3	4.20045e-18
C199	a_795_74##15	a_1804_424##10	3.45992e-18
C200	a_2186_367##5	a_2186_367##4	1.05155e-18
C201	VPWR#10	a_608_74##5	6.50638e-20
C202	VPWR#16	a_2611_98##4	3.84886e-19
C203	SET_B#8	VPWR#19	5.63278e-18
C204	a_608_74##5	a_795_74##5	2.61471e-17
C205	a_1584_379#	VPWR#7	8.08721e-19
C206	a_1185_55##3	a_991_81##3	1.2728e-17
C207	VPWR#10	a_795_74##5	3.94813e-19
C208	VGND#4	SET_B#4	2.49827e-17
C209	VGND#16	SET_B#1	2.54964e-19
C210	CLK#4	SCD#2	9.30466e-19
C211	a_1641_74##2	SET_B#2	1.64561e-19
C212	VGND#4	a_2186_367#	3.54385e-17
C213	a_2611_98##10	a_1804_424#	6.92649e-17
C214	a_795_74##4	SET_B#3	5.63387e-20
C215	a_27_74##6	D#3	1.52327e-19
C216	a_1185_55##5	VGND#17	1.28859e-17
C217	a_2611_98##4	a_2611_98#	4.67163e-17
C218	a_991_81##10	VGND#17	1.78007e-17
C219	a_795_74##5	a_608_74##4	1.02202e-17
C220	a_2611_98##8	a_2611_98##3	2.08173e-19
C221	a_27_74##7	a_27_74#	7.7303e-20
C222	a_795_74##15	a_608_74##7	9.56205e-18
C223	a_795_74##3	a_795_74##2	1.24824e-17
C224	VPWR#9	a_795_74##5	3.42994e-19
C225	a_991_81##4	a_608_74##3	1.66157e-19
C226	VPWR#23	SCE#1	3.06481e-17
C227	VPWR#15	a_1804_424##7	5.612e-19
C228	VPWR#11	a_608_74##4	2.05217e-17
C229	a_608_74##6	a_608_74##5	6.68131e-18
C230	a_27_74##2	D#1	3.68076e-17
C231	a_1641_74##2	SET_B#1	1.75411e-18
C232	SET_B#4	a_1804_424##6	6.82815e-18
C233	VGND#3	SET_B#4	3.72034e-20
C234	VPWR#16	a_1804_424#	2.68218e-18
C235	VGND#14	Q#2	5.91272e-17
C236	a_795_74##5	a_1185_55##3	6.0942e-19
C237	a_795_74##2	a_608_74##8	9.79744e-18
C238	a_795_74##17	a_608_74##9	1.454e-20
C239	a_2611_98##10	a_1804_424##7	2.55547e-18
C240	a_1804_424##10	VPWR#5	4.04372e-18
C241	SCE#4	a_27_74##2	1.48381e-17
C242	a_795_74##13	SCD#2	2.62556e-21
C243	VPWR#23	SCE#5	2.78057e-17
C244	CLK#4	CLK#2	1.21081e-17
C245	a_2186_367##4	a_1804_424#	1.02125e-18
C246	VPWR#10	a_608_74##4	1.62397e-17
C247	VPWR#7	a_1804_424##13	3.37645e-17
C248	a_795_74##4	a_795_74##5	3.22211e-20
C249	VGND#17	SET_B#1	3.16002e-17
C250	VGND#8	a_991_81##13	2.06871e-18
C251	a_1804_424##15	VGND#4	9.86961e-18
C252	a_27_74##6	SCE#1	1.60349e-17
C253	a_1804_424#	a_2611_98##4	4.19949e-17
C254	VPWR#10	a_608_74##11	4.0059e-18
C255	VGND#4	a_2186_367##2	1.16527e-17
C256	VGND#11	VGND#9	8.48256e-19
C257	a_27_74##7	SCE#4	2.90877e-17
C258	VPWR#16	a_1804_424##7	2.85345e-17
C259	SCE#5	a_27_74##9	1.83054e-18
C260	a_1185_55##5	a_991_81##10	2.61966e-19
C261	a_1804_424##4	a_2186_367##4	5.93614e-17
C262	a_608_74##11	a_608_74##5	3.6532e-17
C263	a_795_74##15	a_608_74##2	4.78529e-17
C264	a_1641_74##2	a_991_81#	5.44378e-19
C265	VGND#6	a_1641_74#	1.63503e-18
C266	VPWR#5	SET_B#5	6.86142e-20
C267	a_27_74##6	VPWR#23	6.27544e-17
C268	a_991_81##13	a_991_81##14	1.37666e-18
C269	VPWR#8	VPWR#18	9.75285e-20
C270	VPWR#9	a_608_74##11	6.44526e-20
C271	a_1804_424##11	a_608_74##3	6.49494e-20
C272	a_2611_98##10	SET_B#6	7.14023e-20
C273	SET_B#8	SET_B#7	8.51973e-18
C274	a_795_74##17	a_795_74##16	1.18908e-18
C275	a_1804_424##3	a_1804_424#	3.16905e-18
C276	a_1185_55##5	a_991_81##2	6.0544e-17
C277	VGND#10	a_608_74##5	1.26119e-18
C278	a_2186_367##2	SET_B#4	1.63991e-17
C279	a_27_74##4	a_290_464##3	7.58332e-17
C280	a_608_74##11	a_608_74##4	1.04392e-17
C281	a_2186_367##4	a_1804_424##7	3.15232e-17
C282	a_795_74##16	a_991_81#	6.53856e-19
C283	a_290_464##2	a_991_81##13	4.40598e-18
C284	VPWR#6	a_795_74##11	7.54077e-20
C285	a_2186_367##5	a_2611_98##8	3.85201e-17
C286	a_608_74##13	SCD#2	1.21934e-17
C287	VGND#17	a_991_81#	5.42709e-18
C288	SET_B#8	a_795_74##8	1.0481e-17
C289	VPWR#11	a_795_74##2	7.58152e-19
C290	a_1185_55#	VGND#17	1.93366e-19
C291	a_27_74##6	SCE#5	2.43144e-17
C292	a_1804_424##7	a_1804_424#	5.61985e-18
C293	a_608_74##6	SCD#2	4.81291e-19
C294	VPWR#16	SET_B#6	6.38851e-19
C295	a_1804_424##9	VPWR#5	5.55972e-19
C296	a_608_74##6	a_608_74##11	1.19054e-17
C297	VGND#1	VPWR#1	2.2055e-19
C298	a_1804_424##15	a_795_74##7	7.26179e-20
C299	VGND#5	a_795_74##11	1.09867e-19
C300	a_1185_55##5	SET_B#1	3.28059e-18
C301	a_795_74##5	a_795_74##2	4.02326e-18
C302	a_1804_424##14	a_1804_424##7	8.23103e-19
C303	VPWR#11	a_795_74##16	3.47479e-17
C304	SET_B#8	a_991_81##7	4.94849e-17
C305	CLK#1	a_608_74##6	3.86035e-18
C306	VGND#6	a_795_74##8	7.64086e-19
C307	a_2186_367##5	a_1804_424##4	9.98397e-17
C308	a_2611_98##3	a_2611_98##2	3.3145e-18
C309	a_290_464#	a_290_464##2	1.9722e-18
C310	VPWR#10	CLK#1	9.61501e-19
C311	a_27_74##6	a_27_74##9	7.16773e-18
C312	VGND#4	a_608_74#	1.3065e-18
C313	a_2611_98##9	VGND#14	5.46709e-17
C314	a_795_74##15	a_991_81##9	1.35355e-17
C315	a_2186_367##4	SET_B#6	1.73107e-18
C316	Q#1	VPWR#1	5.9101e-17
C317	VPWR#9	a_608_74##4	5.56e-17
C318	SET_B#8	SET_B#2	1.38619e-17
C319	VPWR#11	SCE#2	1.71816e-18
C320	a_1185_55##5	VGND#18	1.30916e-18
C321	VPWR#17	a_1804_424##7	3.90121e-19
C322	VGND#6	a_1804_424##17	2.11232e-17
C323	SET_B#4	a_2219_74#	1.08718e-17
C324	SET_B#5	a_1804_424##4	2.74059e-17
C325	a_1584_379##2	VPWR#8	3.53588e-18
C326	SCE#7	a_290_464##3	1.30963e-17
C327	a_1804_424##9	a_2186_367##4	2.7602e-17
C328	a_1185_55#	VGND#18	3.08225e-18
C329	VGND#17	a_1185_55##2	3.5328e-19
C330	VPWR#16	a_2186_367##3	1.42075e-19
C331	a_1641_74#	a_608_74##3	3.78048e-21
C332	a_2186_367##2	a_2219_74#	1.08718e-17
C333	a_608_74#	a_2186_367##2	3.40356e-17
C334	a_1804_424##2	a_2611_98##3	3.39477e-17
C335	SET_B#8	a_991_81##2	1.3749e-17
C336	a_1804_424##14	SET_B#6	3.0518e-17
C337	SET_B#6	a_1804_424##7	5.25004e-18
C338	a_2186_367#	a_1804_424##4	3.34212e-18
C339	SCE	SCD#2	4.17829e-19
C340	a_1185_55##5	a_991_81#	3.39875e-17
C341	SCE	SCE#2	4.25136e-17
C342	a_1584_379#	a_608_74##3	1.86316e-18
C343	VPWR#11	a_991_81##14	8.07397e-18
C344	a_608_74##5	a_608_74##4	7.99096e-20
C345	a_1804_424##15	a_795_74##15	1.66165e-17
C346	a_1804_424##10	a_1804_424##4	1.54214e-18
C347	a_1804_424##9	VPWR#4	1.09778e-18
C348	VPWR#11	a_991_81##13	4.36064e-18
C349	VPWR#12	SCD#4	3.18364e-18
C350	SET_B#8	a_1185_55#	1.57548e-18
C351	a_2186_367#	SET_B#5	4.51058e-17
C352	a_991_81##15	a_1185_55#	2.32515e-17
C353	VGND#7	a_991_81##7	9.2714e-19
C354	VPWR#15	VPWR#1	1.7335e-18
C355	a_290_464##2	a_795_74##13	1.95095e-19
C356	VPWR#17	a_2186_367#	3.64734e-19
C357	VPWR#22	SCD#2	1.6105e-18
C358	SET_B#6	VPWR#17	1.09539e-17
C359	a_1584_379##2	VPWR#7	4.73093e-18
C360	VGND#2	a_2611_98##5	1.36088e-17
C361	SCD#2	CLK#2	1.39248e-17
C362	VGND#6	a_991_81##7	1.37041e-19
C363	a_795_74##15	a_991_81##8	2.37043e-17
C364	a_2186_367##3	a_2141_508#	9.87534e-18
C365	a_27_74##4	SCD#4	2.28572e-18
C366	VGND#4	a_795_74##6	7.56122e-20
C367	a_1641_74#	a_795_74##7	1.51612e-17
C368	VPWR#11	a_991_81##2	3.48461e-18
C369	a_1804_424##14	a_2186_367##3	1.26766e-18
C370	VPWR#11	a_795_74##17	3.60884e-17
C371	D#2	a_290_464##3	2.54097e-18
C372	a_795_74##10	a_2141_508#	9.87534e-18
C373	a_1584_379#	a_795_74##7	5.64769e-20
C374	VGND#10	SCD#2	2.59707e-18
C375	VGND#2	a_2611_98##6	1.27006e-17
C376	a_795_74##11	a_2186_367#	9.14781e-18
C377	a_27_74##4	a_27_74##3	8.08506e-18
C378	a_1185_55##5	a_1185_55##2	1.14839e-18
C379	a_2186_367##3	SET_B#6	3.54079e-17
C380	VGND#10	a_991_81##2	5.53999e-18
C381	a_608_74##15	SCD#2	4.78162e-18
C382	a_2186_367##2	a_2141_74#	8.35249e-18
C383	a_795_74##6	a_608_74#	3.93922e-17
C384	SET_B#11	a_1804_424##3	3.51361e-18
C385	VPWR#15	Q#1	6.73427e-17
C386	VPWR#11	VPWR#21	1.83386e-17
C387	a_27_74##4	D#3	1.935e-17
C388	VPWR#8	a_608_74##4	1.02107e-17
C389	a_608_74#	a_2141_74#	9.87534e-18
C390	VPWR#17	a_2186_367##3	2.23197e-17
C391	CLK	a_608_74##5	1.12008e-18
C392	a_1804_424##4	a_1804_424##3	5.3253e-17
C393	VGND#2	a_1804_424##5	5.63637e-18
C394	a_795_74##16	SET_B#3	4.66087e-18
C395	a_27_74##6	a_27_74##4	8.80703e-19
C396	VGND#10	a_1185_55#	8.82162e-18
C397	VGND#10	a_991_81##13	7.71416e-18
C398	a_1641_74#	a_795_74##15	2.32547e-17
C399	a_27_74##4	SCE#1	9.61368e-20
C400	a_1804_424##10	VPWR#17	2.00009e-17
C401	VGND#7	a_1641_74##2	8.724e-18
C402	VPWR#11	a_1185_55##3	3.37198e-18
C403	a_1804_424##10	SET_B#5	1.9786e-17
C404	a_1804_424##11	SET_B#6	2.27016e-19
C405	a_991_81##15	a_1185_55##5	1.21256e-18
C406	a_991_81#	a_608_74##4	1.6257e-19
C407	VPWR#11	a_608_74##13	6.21391e-18
C408	a_1185_55##2	VGND#18	9.19015e-18
C409	VPWR#12	a_27_74##3	6.19516e-18
C410	a_1804_424##14	a_795_74##10	2.44188e-19
C411	a_27_74##4	SCE#5	1.69468e-20
C412	VGND#7	SET_B#2	5.49165e-19
C413	VGND#10	a_1185_55##3	2.51136e-18
C414	a_2186_367#	a_2186_367##5	1.26606e-18
C415	a_1804_424##9	SET_B#5	6.79531e-17
C416	a_1804_424##13	a_608_74##3	1.73662e-17
C417	a_795_74##15	SET_B#3	2.25725e-17
C418	a_991_81##15	a_991_81#	3.26411e-19
C419	SET_B#11	a_1804_424##4	1.38721e-17
C420	a_1804_424##11	a_795_74##11	3.22731e-17
C421	VPWR#11	VPWR#22	2.20496e-17
C422	VGND#8	VGND#17	1.03048e-18
C423	a_1185_55##5	a_795_74#	1.60325e-19
C424	VPWR#7	a_795_74##8	8.41145e-19
C425	a_795_74##10	a_2186_367##3	4.03786e-17
C426	VGND#10	a_795_74##4	2.05672e-18
C427	VPWR#17	a_795_74##10	3.42628e-18
C428	VGND#4	a_795_74##9	5.67954e-20
C429	VPWR#11	a_795_74##3	3.19829e-18
C430	a_991_81##7	a_795_74##8	1.33486e-17
C431	a_1584_379#	a_795_74##11	6.13799e-19
C432	SCE#1	D#2	2.11177e-18
C433	a_27_74##7	SCE#7	1.94323e-18
C434	VGND#10	a_608_74##13	2.8189e-18
C435	a_1804_424##9	VPWR#17	5.51743e-18
C436	a_1804_424##11	a_2186_367##3	2.1354e-18
C437	D#4	a_27_74##4	8.78846e-18
C438	VPWR#4	a_1804_424##3	4.0092e-19
C439	VGND#10	a_795_74##3	3.83995e-18
C440	a_1804_424##14	a_608_74##7	1.48472e-19
C441	a_795_74##9	a_795_74##6	3.2207e-17
C442	VGND#6	a_1641_74##2	8.86887e-18
C443	a_1804_424##17	a_795_74##7	1.49275e-18
C444	VPWR#11	a_608_74##6	5.08476e-18
C445	VPWR#8	a_608_74##3	3.2347e-17
C446	VPWR#11	a_290_464##4	1.63199e-17
C447	a_795_74##16	a_991_81##3	2.78829e-17
C448	a_1804_424##13	a_795_74##7	2.67169e-20
C449	VGND#20	SCD#2	1.05136e-17
C450	a_1804_424##10	a_2186_367#	3.45959e-17
C451	a_991_81##7	SET_B#2	6.24099e-17
C452	VGND#10	a_608_74##6	7.27592e-18
C453	a_991_81##15	a_1185_55##2	2.6532e-18
C454	a_1584_379#	a_2186_367##3	1.62591e-19
C455	VGND#8	a_991_81##2	1.31025e-18
C456	VPWR#11	CLK#2	1.15311e-19
C457	a_1185_55##5	a_608_74##9	3.32412e-20
C458	a_2611_98##10	VPWR#15	9.95352e-17
C459	SCD#2	CLK#1	9.36521e-18
C460	a_290_464##3	VGND#20	4.68312e-20
C461	VPWR#17	a_608_74##7	1.07783e-18
C462	VGND#6	a_991_81##4	3.01497e-18
C463	a_991_81##13	a_795_74#	4.80904e-18
C464	a_1584_379#	a_795_74##8	6.22382e-18
C465	a_608_74##7	a_795_74##10	1.1974e-17
C466	VPWR#8	a_991_81##7	2.18208e-19
C467	VPWR#9	VPWR#8	3.09436e-19
C468	SET_B#5	a_1804_424##3	3.43409e-17
C469	a_991_81##2	a_991_81##7	2.1267e-18
C470	a_795_74##15	a_991_81##3	1.88706e-18
C471	a_795_74##13	a_991_81#	6.17978e-19
C472	a_2186_367#	a_1804_424##9	9.51387e-19
C473	SET_B#11	SET_B#5	9.85204e-18
C474	a_1804_424##11	a_795_74##10	2.3717e-17
C475	a_795_74##3	a_991_81##15	5.66586e-17
C476	VGND#10	CLK#2	9.4484e-19
C477	VGND#7	a_991_81##2	3.22803e-18
C478	a_2186_367##5	a_2611_98##6	5.12613e-19
C479	a_1804_424##13	a_795_74##8	9.93036e-19
C480	VPWR#11	VPWR#23	1.62176e-17
C481	VPWR#7	a_991_81##7	2.15298e-19
C482	a_27_74##7	D#2	1.97334e-19
C483	a_290_464##3	VPWR#11	3.50518e-17
C484	a_991_81##2	SET_B#2	6.3707e-17
C485	SCD	SCD#2	4.0001e-17
C486	a_608_74##8	a_1117_483#	8.7572e-18
C487	a_290_464#	a_795_74##3	8.12519e-17
C488	SCE#7	D#4	3.13503e-18
C489	a_795_74##13	a_1185_55##5	3.44304e-19
C490	a_27_74##6	D#2	4.62594e-20
C491	VPWR#11	a_27_74##4	1.24453e-17
C492	a_1584_379#	a_795_74##10	6.29793e-19
C493	a_795_74##13	a_795_74##3	5.60062e-18
C494	VGND#8	VGND#7	1.65525e-19
C495	VPWR#11	a_290_464##2	1.79769e-17
C496	VPWR#4	a_1804_424##2	9.62655e-19
C497	VGND#7	a_991_81##10	4.828e-18
C498	a_991_81##4	a_795_74##9	2.75464e-18
C499	a_991_81##15	a_795_74#	3.5184e-17
C500	a_991_81##14	a_795_74##17	2.09612e-17
C501	VPWR#16	VPWR#15	1.52381e-18
C502	VGND#10	a_27_74##4	3.09581e-18
C503	VGND#1	a_2611_98##5	2.12478e-17
C504	a_795_74##16	a_1185_55##4	2.2144e-17
C505	VGND#17	VGND#6	7.35222e-19
C506	SET_B#1	a_1429_74#	9.87534e-18
C507	a_1584_379##2	a_795_74##8	2.31233e-18
C508	a_1804_424##11	a_608_74##7	3.9915e-17
C509	VPWR#11	SCE#7	5.02012e-18
C510	a_991_81##2	a_1185_55#	9.50653e-17
C511	a_608_74##2	a_608_74##7	4.47245e-17
C512	a_27_74##4	SCD#2	3.47212e-17
C513	a_795_74##13	a_1185_55##2	3.71602e-19
C514	a_991_81#	a_1429_74#	9.87534e-18
C515	a_290_464##3	a_608_74##5	1.57037e-19
C516	a_1804_424##10	a_795_74##11	6.52776e-17
C517	VGND#2	VGND#1	2.37596e-17
C518	a_1804_424##13	a_795_74##10	1.68122e-19
C519	VGND#10	SCE#7	8.56923e-18
C520	a_991_81##13	a_608_74##9	3.69402e-19
C521	a_27_74##4	SCE#2	3.95426e-20
C522	a_991_81##2	a_1185_55##3	8.91111e-17
C523	VGND#8	a_1185_55#	3.43331e-17
C524	VPWR#11	D#2	1.96175e-18
C525	VPWR#7	a_608_74##3	4.74854e-17
C526	a_608_74##6	a_290_464#	1.94284e-17
C527	a_290_464#	a_795_74#	3.31631e-20
C528	a_2186_367#	SET_B#11	3.75735e-17
C529	VPWR#8	SET_B#2	2.96145e-19
C530	VPWR#18	a_991_81##7	5.20318e-20
C531	a_1584_379#	a_608_74##7	3.87875e-17
C532	VGND#2	Q#2	3.4878e-17
C533	D#4	D#2	5.65822e-18
C534	VGND#10	D#2	2.17631e-18
C535	a_1185_55#	a_1185_55##3	3.59307e-18
C536	VGND#8	SET_B#1	6.81814e-19
C537	Q#2	a_2611_98##5	3.7637e-17
C538	SCD#4	a_416_464#	1.26229e-17
C539	a_2186_367##5	a_1804_424##5	2.86433e-18
C540	a_795_74##13	a_608_74##6	2.60257e-17
C541	VPWR#16	a_2611_98##10	3.6491e-17
C542	VGND#3	a_2611_98##8	7.71936e-19
C543	Q	a_2611_98##2	3.41158e-17
C544	VPWR#11	a_27_74##2	9.75815e-19
C545	a_795_74##16	VPWR#9	8.32504e-17
C546	a_27_74##6	a_27_74##2	1.56592e-18
C547	a_608_74##9	a_991_81##15	2.0555e-18
C548	a_1584_379##2	a_991_81##7	5.00397e-19
C549	Q	a_1804_424##2	4.42261e-19
C550	a_27_74##3	a_416_464#	5.89735e-18
C551	a_1804_424##11	a_608_74##2	1.20065e-18
C552	VGND#8	a_1185_55##5	3.02187e-17
C553	VPWR#6	a_608_74#	8.56782e-20
C554	a_2186_367#	a_1804_424##3	7.95027e-19
C555	VGND#19	a_608_74##6	2.937e-18
C556	VGND#10	a_27_74##2	6.59733e-18
C557	VGND#10	a_290_464##2	8.57374e-19
C558	VGND#1	a_2611_98##6	1.41114e-18
C559	a_1804_424##13	a_608_74##7	4.70084e-19
C560	a_795_74##13	a_795_74#	2.78123e-18
C561	a_1641_74##2	a_608_74##3	5.00851e-20
C562	a_991_81##9	a_608_74##2	4.19899e-18
C563	a_991_81##10	a_991_81##4	3.20078e-17
C564	a_795_74##4	a_1185_55##3	1.9461e-17
C565	a_795_74##16	a_608_74##8	3.17172e-17
C566	a_1641_74##2	a_795_74##15	2.12631e-17
C567	VGND#7	SET_B#1	3.6905e-18
C568	a_1584_379#	a_608_74##2	5.47696e-17
C569	VGND#14	a_2611_98##5	8.70544e-19
C570	a_290_464##6	a_290_464##3	8.63715e-19
C571	a_290_464#	CLK#2	4.6975e-19
C572	SET_B#8	a_991_81##4	2.06534e-18
C573	a_1584_379##2	a_608_74##3	6.81035e-18
C574	a_290_464#	a_608_74##9	2.81232e-17
C575	a_1584_379#	a_1804_424##10	1.89972e-18
C576	SCE	a_290_464##3	1.98441e-18
C577	D#3	a_206_464#	1.52812e-17
C578	a_1185_55##2	a_1143_81#	8.8457e-18
C579	VPWR#9	a_991_81##2	1.05534e-19
C580	VGND#5	a_608_74#	6.52923e-18
C581	VPWR#3	a_1804_424##2	4.99596e-20
C582	a_2186_367##4	a_2611_98##10	4.5282e-17
C583	VPWR#11	CLK#4	1.84711e-18
C584	a_795_74#	a_1143_81#	8.8457e-18
C585	SCE#1	a_206_464#	1.52812e-17
C586	D#4	a_27_74##2	1.13468e-18
C587	a_1804_424##11	a_991_81##9	6.64259e-20
C588	Q#2	a_2611_98##6	3.56583e-17
C589	a_795_74##4	a_795_74##3	3.47183e-19
C590	a_795_74##15	a_2186_367#	6.58811e-19
C591	SCE#7	SCD#2	4.1678e-17
C592	a_1804_424##13	a_608_74##2	2.76503e-17
C593	VGND#7	a_1185_55##5	1.97778e-18
C594	VPWR#8	VPWR#7	2.8627e-18
C595	CLK#2	VGND#19	2.79701e-18
C596	a_290_464##2	a_608_74##5	4.1788e-17
C597	VGND#5	a_795_74##6	4.42881e-18
C598	a_290_464##2	a_991_81##14	6.37729e-17
C599	a_795_74##13	a_608_74##9	2.90126e-17
C600	a_2186_367##5	a_1804_424##6	3.44461e-17
C601	a_795_74##16	VPWR#8	1.55423e-17
C602	SCE#7	SCE#2	7.75929e-19
C603	a_2611_98##9	a_2611_98##5	1.5511e-20
C604	a_991_81##8	a_991_81##9	3.93998e-17
C605	VGND#8	a_991_81#	2.55535e-18
C606	a_2611_98##8	a_2611_98#	1.99468e-19
C607	VGND#1	a_1804_424##5	2.33612e-19
C608	VPWR#21	a_795_74##17	3.65863e-17
C609	a_608_74##15	CLK#2	5.80574e-18
C610	a_27_74##7	SCE	4.56493e-17
C611	a_2186_367##5	VGND#14	3.32201e-18
C612	a_1584_379#	a_991_81##9	1.3768e-19
C613	a_27_74##6	SCE	6.33017e-17
C614	a_1185_55##7	SET_B#2	3.2466e-18
C615	a_795_74##16	a_795_74##15	3.05837e-18
C616	a_290_464##6	SCD#2	1.28261e-17
C617	a_27_74##7	SCE#2	1.35964e-17
C618	VGND#5	a_795_74##9	4.39804e-18
C619	VGND#8	VGND#18	5.27696e-18
C620	a_290_464#	a_608_74##10	1.61398e-18
C621	VPWR#3	a_2611_98##4	1.69183e-18
C622	VPWR#18	a_608_74##2	8.91532e-19
C623	a_795_74##13	a_991_81##15	1.1233e-17
C624	SET_B#1	a_991_81##10	1.32879e-17
C625	a_2611_98##6	VGND#14	1.97398e-17
C626	a_2611_98##8	a_2611_98##2	9.06255e-20
C627	a_2186_367##4	VPWR#16	5.75453e-17
C628	VPWR#9	a_795_74##2	9.52298e-20
C629	SCE	D#4	3.22036e-17
C630	a_795_74##16	a_795_74##5	1.85535e-18
C631	VPWR	a_1804_424##3	4.73344e-19
C632	a_2611_98##2	Q#2	1.36978e-19
C633	a_991_81##13	a_608_74##8	1.07244e-18
C634	VGND#9	a_608_74##5	4.80053e-19
C635	VPWR	a_1804_424##2	8.90457e-19
C636	VGND#19	a_608_74##9	3.29128e-19
C637	VGND#7	VGND#6	3.15095e-19
C638	a_1804_424##13	a_991_81##9	2.34967e-18
C639	VPWR	a_608_74##4	9.39805e-18
C640	VGND#7	a_991_81#	7.54803e-18
C641	VPWR	a_608_74##3	1.96723e-17
C642	VGND#10	CLK#4	3.80391e-18
C643	VPWR	a_795_74##7	1.26625e-18
C644	CLK#2	a_608_74##6	2.85153e-17
C645	Q#2	a_1804_424##5	1.11699e-18
C646	a_1584_379##2	a_608_74##2	1.3669e-18
C647	a_608_74##9	a_608_74##4	2.69358e-20
C648	a_608_74##10	a_795_74##13	1.56323e-17
C649	a_1804_424##2	a_2611_98##6	4.33332e-18
C650	a_1185_55##7	a_991_81##2	2.31542e-17
C651	a_795_74##15	a_795_74##11	3.04238e-19
C652	SET_B#3	a_991_81##8	1.8606e-17
C653	a_290_464##2	a_608_74##4	1.46045e-18
C654	a_2611_98##9	a_2611_98##6	1.06468e-18
C655	a_290_464##2	a_290_464##5	3.77027e-18
C656	a_991_81##9	VPWR#18	2.92116e-17
C657	VGND#1	a_1804_424##6	1.93353e-19
C658	a_795_74##7	a_608_74##3	2.13844e-20
C659	a_290_464#	CLK#3	6.57855e-20
C660	a_795_74##13	a_290_464#	7.80105e-17
C661	a_2186_367##5	SET_B#4	1.69859e-18
C662	VPWR#19	a_608_74##2	1.10609e-19
C663	a_795_74##15	VPWR#8	2.76526e-17
C664	a_608_74##15	CLK#4	2.97091e-17
C665	a_2611_98##8	a_2611_98##4	5.09097e-19
C666	a_1804_424##5	VGND#14	2.37709e-17
C667	a_2186_367##5	a_2611_98##9	5.54022e-17
C668	VGND#8	a_1185_55##2	1.19111e-17
C669	D#2	SCD#2	2.98234e-18
C670	VGND#19	a_608_74##10	5.09699e-17
C671	a_1584_379##2	a_991_81##9	5.69711e-17
C672	a_991_81#	SET_B#1	4.3314e-17
C673	VGND#4	a_2186_367##5	8.21842e-17
C674	VPWR#3	a_1804_424#	2.6133e-18
C675	a_795_74##16	a_608_74##11	9.80088e-20
C676	VPWR#11	a_27_74##6	2.46236e-17
C677	SCE#2	D#2	3.1191e-17
C678	a_2611_98##8	a_1804_424##3	5.02739e-19
C679	a_290_464##3	SCD	6.72888e-17
C680	a_2611_98##8	Q	2.00701e-18
C681	a_795_74##13	CLK#3	5.18494e-19
C682	a_795_74##17	VPWR#10	6.05864e-17
C683	VPWR#18	a_991_81##8	7.42979e-19
C684	a_991_81##3	SET_B#3	2.91952e-17
C685	VPWR#5	a_1804_424##7	3.83106e-19
C686	a_27_74##6	SCE#2	1.15972e-17
C687	a_608_74##10	a_608_74##5	8.44772e-18
C688	a_2186_367##5	a_1804_424##9	3.33647e-18
C689	a_1804_424##3	a_1804_424##5	1.26034e-18
C690	VPWR#20	a_1185_55#	1.60646e-19
C691	VPWR#23	SCE#2	7.87874e-19
C692	a_1185_55##7	a_608_74##4	9.65795e-19
C693	VPWR#19	a_991_81##9	1.22572e-18
C694	a_608_74##15	a_608_74##10	1.5148e-18
C695	a_1804_424##14	a_2186_367##4	3.49193e-17
C696	a_2611_98##9	a_1804_424##5	3.22699e-17
C697	VPWR#17	VPWR#16	1.18959e-18
C698	a_2186_367#	a_1804_424##5	5.2939e-20
C699	a_27_74##7	a_27_74##6	2.71588e-18
C700	a_795_74##15	a_795_74##8	3.03835e-17
C701	SCE#7	a_27_74##4	4.49344e-17
C702	a_290_464##2	a_795_74##17	8.49225e-17
C703	SET_B	a_1804_424##3	2.78891e-18
C704	VPWR#22	VPWR#21	6.15361e-18
C705	SCD#3	a_403_74#	1.16772e-17
C706	VGND#9	a_795_74##3	5.96907e-21
C707	a_1584_379##2	a_991_81##8	3.90692e-17
C708	CLK#3	VGND#19	1.89921e-17
C709	VGND#10	a_27_74##7	1.01619e-18
C710	SET_B	a_795_74##7	4.10401e-18
C711	D#2	a_27_74##4	9.27737e-17
C712	VPWR#4	a_1804_424##7	1.78567e-18
C713	VGND#14	a_1804_424##6	8.04555e-19
C714	SCE#6	a_403_74#	1.16772e-17
C715	a_1185_55##7	a_1185_55##3	2.14494e-20
C716	a_795_74##17	VPWR#9	1.64749e-17
C717	a_2186_367##5	a_2186_367##2	3.26724e-19
C718	CLK	a_290_464#	4.52555e-18
C719	VGND#8	a_795_74##3	1.18852e-19
C720	a_290_464##3	VPWR#21	6.92265e-18
C721	a_290_464##6	a_27_74##4	9.59283e-19
C722	VGND#20	a_608_74##10	4.24228e-19
C723	SCE#7	D#2	7.38148e-17
C724	a_27_74##4	a_27_74##2	1.76749e-19
C725	a_2611_98##8	a_1804_424#	4.64322e-18
C726	VPWR#18	SET_B#3	3.2903e-19
C727	a_991_81##13	a_795_74##16	6.68245e-18
C728	a_2186_367#	a_2219_74#	1.17374e-18
C729	VGND#19	CLK	2.14619e-17
C730	a_2186_367##5	a_2186_367##7	6.43251e-18
C731	VPWR#20	a_1185_55##3	4.70879e-19
C732	a_1185_55##2	a_991_81#	2.70375e-18
C733	VPWR	VPWR#9	1.0048e-17
C734	a_2186_367#	SET_B#4	3.53455e-17
C735	VGND#2	VGND#3	5.37684e-17
C736	a_1185_55##4	a_991_81##3	1.02196e-17
C737	VPWR#19	a_991_81##8	1.39126e-17
C738	VPWR	VPWR#8	7.83414e-17
C739	VGND#8	a_795_74#	7.4585e-18
C740	VPWR	VPWR#7	9.48506e-17
C741	a_27_74##2	SCE#7	1.10285e-19
C742	VPWR	VPWR#5	9.43503e-17
C743	a_608_74##5	a_795_74##2	1.09587e-18
C744	VPWR	VPWR#4	7.66405e-17
C745	a_795_74##16	a_608_74##5	1.77357e-19
C746	a_608_74##15	CLK#3	5.70621e-17
C747	VPWR	VPWR#3	1.08166e-17
C748	a_2611_98##8	a_1804_424##2	4.29827e-17
C749	VPWR#11	D#4	1.78241e-18
C750	a_290_464##3	a_416_464#	2.56332e-18
C751	VGND#19	a_795_74##13	6.19951e-17
C752	a_608_74##15	a_290_464#	5.47807e-19
C753	a_2611_98##9	a_1804_424##6	1.01683e-18
C754	VGND#8	a_991_81##15	1.44191e-17
C755	a_2186_367#	a_2186_367##2	6.66226e-18
C756	a_27_74##2	SCD#2	1.67396e-19
C757	a_1584_379##2	SET_B#3	1.90306e-19
C758	a_290_464##3	a_290_464##2	1.23328e-18
C759	VGND#10	a_1185_55##2	9.92217e-18
C760	VPWR#5	SET_B#6	5.54482e-18
C761	a_795_74##4	a_1185_55##7	5.92083e-19
C762	VPWR#2	a_2611_98#	2.35645e-18
C763	VPWR	a_1804_424##10	1.28998e-17
C764	VGND#19	SCD#3	4.76576e-19
C765	a_991_81##14	a_1185_55##3	7.60398e-20
C766	VPWR	a_1804_424##9	4.55897e-18
C767	a_1804_424##11	a_608_74#	1.05865e-18
C768	a_27_74##2	SCE#2	6.33892e-18
C769	a_290_464##2	VPWR#21	3.72113e-17
C770	a_795_74##13	a_795_74##17	8.79688e-20
C771	a_795_74##15	a_991_81##7	7.53072e-17
C772	a_608_74#	a_2186_367#	4.46408e-17
C773	VGND#14	SET_B#4	9.41587e-20
C774	a_290_464##6	SCE#7	8.36142e-17
C775	VGND#20	CLK#3	2.59164e-18
C776	SET_B#8	a_1641_74#	1.12732e-17
C777	VPWR	a_795_74##16	1.12829e-17
C778	VGND#10	a_795_74#	1.23345e-17
C779	a_795_74##8	a_608_74##3	1.46563e-18
C780	SET_B#3	VPWR#19	1.69556e-17
C781	VPWR	a_795_74##15	2.09655e-17
C782	Q	VGND#1	3.24933e-17
C783	VPWR#2	a_2611_98##4	6.07862e-18
C784	D#1	a_239_74#	9.87534e-18
C785	SCD	a_608_74##15	1.85168e-17
C786	VGND#9	a_608_74##9	4.03096e-18
C787	VGND#14	Q	3.19291e-18
C788	VGND#20	SCD	1.29381e-17
C789	VPWR#17	a_1804_424##14	2.73344e-17
C790	a_27_74#	a_239_74#	9.87534e-18
C791	a_608_74##8	a_1185_55##4	1.74273e-17
C792	VPWR#20	a_608_74##4	3.49795e-20
C793	a_2611_98##9	Q	3.39437e-19
C794	a_1804_424##6	a_2186_367##7	6.2173e-18
C795	VGND#9	a_608_74##6	1.03804e-18
C796	a_290_464##3	a_608_74##13	5.41403e-17
C797	a_290_464##6	SCD	3.38082e-17
C798	a_2186_367##5	a_608_74#	1.88199e-19
C799	a_608_74##15	SCD#3	2.69566e-18
C800	VGND#10	a_608_74##9	4.25122e-19
C801	SET_B#8	a_1804_424##17	1.71185e-18
C802	SET_B	VGND#4	8.65998e-18
C803	SCE	VPWR#23	2.44767e-18
C804	VGND	a_1804_424##3	3.80825e-18
C805	a_795_74#	a_1185_55##2	3.98147e-17
C806	a_608_74##15	a_795_74##13	2.24131e-18
C807	a_2186_367##5	VGND#15	2.33258e-18
C808	VGND	a_1804_424##2	1.67687e-18
C809	a_2611_98##9	a_2611_98##2	1.99427e-20
C810	VPWR#2	a_1804_424#	4.4584e-18
C811	a_991_81##14	a_795_74##4	1.13534e-17
C812	SET_B#3	a_1185_55##7	1.33762e-17
C813	a_608_74#	a_795_74##11	3.26045e-17
C814	VGND#10	D#4	2.02515e-18
C815	SCE#2	SCE#1	1.57587e-18
C816	a_795_74##16	a_608_74##4	2.84864e-17
C817	a_795_74##5	a_1185_55##4	8.64234e-19
C818	a_290_464##2	a_608_74##9	7.09457e-19
C819	a_2186_367##5	a_1804_424#	3.01773e-19
C820	VGND#10	a_608_74##10	2.51297e-18
C821	VGND#8	a_608_74##9	7.42242e-19
C822	SET_B#8	VGND#16	2.74133e-18
C823	a_27_74##4	a_206_464#	1.1593e-18
C824	SET_B	a_2611_98##8	1.6019e-18
C825	CLK	a_608_74##13	1.00388e-17
C826	a_2611_98##10	a_1804_424##3	6.62586e-19
C827	a_1804_424##6	VGND#15	6.15344e-18
C828	VGND#20	SCD#3	4.13597e-17
C829	SET_B	a_2186_367##5	4.19405e-18
C830	VGND#21	SCE#2	1.66394e-18
C831	SET_B#8	VGND#7	3.27353e-18
C832	a_608_74##13	a_290_464##2	1.21633e-17
C833	SET_B	a_1804_424##10	2.62534e-17
C834	SET_B	a_1804_424##9	1.04698e-17
C835	VPWR#5	a_2186_367##3	8.20695e-18
C836	VGND#10	CLK#3	8.71753e-18
C837	a_795_74##2	a_608_74##4	8.71463e-19
C838	a_795_74##15	SET_B#2	5.51037e-17
C839	a_795_74##5	a_608_74##8	1.71107e-17
C840	VGND#4	a_1804_424##3	2.04626e-18
C841	SET_B#8	a_1641_74##2	2.55178e-17
C842	a_290_464##6	CLK#3	1.29168e-18
C843	SET_B	SET_B#11	3.70058e-17
C844	VPWR#10	a_795_74##3	1.3694e-19
C845	a_795_74##8	a_608_74#	2.49307e-19
C846	a_608_74##15	SCE#6	2.20795e-19
C847	a_991_81##14	a_795_74##3	1.47073e-18
C848	SET_B	a_795_74##15	2.36086e-17
C849	SET_B#8	VGND#6	2.18661e-18
C850	a_1185_55##7	a_991_81##3	1.75747e-17
C851	Q	VPWR#1	3.34567e-17
C852	a_608_74##15	VGND#19	5.8303e-17
C853	Q	Q#1	3.75423e-19
C854	a_290_464##3	VPWR#22	4.68454e-17
C855	VPWR#2	a_2611_98##2	2.02358e-20
C856	VGND#10	SCD#3	2.84194e-18
C857	VPWR	a_1804_424##15	9.18475e-19
C858	VPWR#15	Q	3.25305e-17
C859	VPWR#9	a_795_74##3	9.70351e-20
C860	a_608_74##2	a_608_74##3	3.4058e-19
C861	VGND#9	a_795_74##13	7.22043e-17
C862	a_2611_98##10	Q	1.86971e-19
C863	a_290_464##2	a_608_74##8	7.87982e-19
C864	SET_B#8	VGND#17	7.19269e-18
C865	a_2611_98##9	a_1804_424##3	4.58445e-19
C866	VGND#9	a_608_74##10	4.75234e-18
C867	SCD	a_608_74##13	5.83166e-17
C868	SCD	VPWR#22	3.42763e-18
C869	VGND#5	a_1804_424##15	5.29303e-17
C870	a_608_74##9	a_795_74#	1.17617e-17
C871	VPWR#5	VPWR#4	3.94175e-19
C872	a_991_81##13	SET_B#2	1.34976e-19
C873	VPWR#3	VPWR#1	2.02912e-18
C874	VPWR#2	VPWR#3	3.83959e-17
C875	VGND	VGND#8	1.21208e-17
C876	a_27_74##2	a_290_464##6	2.16692e-17
C877	VGND#10	SCE#6	1.11213e-19
C878	VGND	VGND#7	8.33489e-17
C879	a_991_81##3	VPWR#20	1.50047e-17
C880	a_991_81##7	a_608_74##3	5.22991e-19
C881	VGND	VGND#6	6.93648e-17
C882	a_795_74##3	a_795_74##17	2.04845e-18
C883	VGND#20	SCE#6	3.34203e-18
C884	VGND	VGND#4	1.52822e-16
C885	a_1804_424##11	a_1804_424##14	1.72692e-18
C886	a_2186_367##5	a_2141_74#	1.61858e-20
C887	VGND	VGND#3	2.68857e-17
C888	a_795_74##15	a_1804_424##11	2.08556e-17
C889	VPWR#7	a_795_74##10	5.18637e-20
C890	SET_B#4	VGND#15	1.25065e-17
C891	SET_B#4	a_1804_424##3	2.36824e-18
C892	a_795_74##7	a_608_74##2	4.25849e-17
C893	a_991_81##7	SET_B#7	2.28353e-17
C894	VGND#11	VGND#19	1.87017e-19
C895	a_795_74##16	a_991_81##2	3.61708e-19
C896	a_290_464##6	SCD#3	1.44496e-17
C897	VGND#10	D#1	1.35488e-18
C898	a_991_81##4	a_795_74##8	1.52378e-17
C899	CLK	a_608_74##10	1.87473e-19
C900	a_1804_424##15	a_1641_74#	5.23713e-17
C901	VGND	a_2611_98##8	2.51075e-19
C902	a_290_464##3	a_795_74##5	1.11659e-19
C903	a_27_74##2	VGND#21	3.57169e-17
C904	VGND	a_2186_367##5	2.44451e-17
C905	VGND#4	a_1804_424##10	2.73347e-19
C906	a_1804_424##10	a_608_74#	1.06876e-17
C907	SET_B	a_2611_98##9	8.61791e-19
C908	VGND#20	VGND#19	1.54614e-18
C909	VGND	a_1804_424##10	3.36504e-18
C910	a_991_81##2	a_795_74##15	5.03743e-18
C911	VPWR	a_2611_98##10	2.02186e-17
C912	a_1185_55##7	a_795_74##2	2.07832e-19
C913	VPWR	VPWR#16	1.73844e-17
C914	VPWR#22	VPWR#10	1.66319e-18
C915	a_795_74##15	a_608_74##4	7.88568e-18
C916	VGND#5	a_1804_424##17	2.82016e-17
C917	VGND#8	a_795_74##13	2.61127e-17
C918	VPWR	a_2186_367##4	2.07237e-17
C919	VPWR#5	a_795_74##10	5.18092e-18
C920	VPWR#19	a_608_74##8	9.07514e-20
C921	VGND	SET_B#11	3.93818e-18
C922	SET_B	a_1804_424##15	3.72386e-17
C923	VPWR	a_1804_424##14	1.55455e-17
C924	VGND#10	a_27_74#	2.85563e-19
C925	SET_B	a_1641_74#	1.44054e-17
C926	SET_B	a_1804_424##17	3.77052e-19
C927	VGND#4	a_1804_424##2	9.89092e-20
C928	VPWR#2	a_2611_98##8	4.88718e-19
C929	VGND	a_795_74##15	9.88571e-18
C930	a_2611_98##9	a_1804_424##2	1.07735e-17
C931	VPWR#10	a_608_74##6	2.76236e-20
C932	VPWR#20	a_1185_55##4	2.49776e-17
C933	VPWR	a_1804_424##11	2.81596e-17
C934	a_608_74##6	a_795_74##17	1.22754e-18
C935	VPWR	a_1584_379#	1.23706e-17
C936	VPWR#16	a_1804_424##3	2.73098e-18
C937	Q	a_2611_98##5	3.03839e-18
C938	VPWR	a_1804_424##13	2.4979e-17
C939	a_290_464##2	a_795_74##5	2.60968e-17
C940	a_2611_98##3	VGND#14	3.76712e-17
C941	VGND#4	VGND#3	5.44512e-19
C942	a_1804_424##11	VPWR#17	1.23268e-17
C943	Q	a_2611_98##6	3.48739e-18
C944	a_290_464##3	SCD#2	1.77206e-17
C945	VGND	SET_B#7	3.22596e-18
C946	VPWR	a_1584_379##2	1.75871e-17
C947	Q	a_1804_424##5	1.74113e-19
C948	VGND#20	D#1	3.11357e-19
C949	a_27_74##6	a_206_464#	3.42024e-18
C950	VPWR	a_1185_55##7	6.76177e-18
C951	VGND#10	SCE#4	6.8657e-19
C952	a_1804_424##9	a_1804_424#	1.88906e-19
C953	a_608_74##6	VPWR#21	2.90995e-19
C954	a_608_74##10	a_608_74##9	3.92933e-18
C955	CLK#1	a_608_74##11	4.64043e-17
C956	a_991_81##13	a_991_81##2	2.08166e-18
C957	a_1804_424##15	a_1804_424##6	3.92281e-19
C958	a_290_464##6	SCE#6	3.89144e-17
C959	a_2611_98##9	a_2611_98##3	4.32448e-20
C960	a_991_81##7	a_991_81##10	3.46803e-18
C961	a_608_74##13	a_608_74##6	4.84064e-18
C962	VPWR#23	VPWR#22	9.02048e-19
C963	a_795_74##15	a_1584_379#	1.03375e-16
C964	a_1804_424##17	a_1804_424##15	2.55444e-18
C965	a_608_74##15	a_608_74##13	2.37492e-18
C966	SET_B#7	SET_B#2	6.82427e-18
C967	VGND#2	a_2611_98##2	4.26354e-20
C968	a_991_81##9	a_608_74##3	2.33778e-17
C969	a_290_464##2	a_795_74##2	8.93556e-19
C970	SET_B#2	a_608_74##4	5.55628e-19
C971	VGND#21	SCD#3	3.86076e-19
C972	VGND#20	a_608_74##15	4.51218e-17
C973	a_795_74##16	a_1185_55#	1.0738e-18
C974	VGND	a_2611_98##9	1.94689e-17
C975	SET_B	VPWR#17	3.10777e-18
C976	VPWR#20	a_608_74##8	3.13384e-18
C977	a_290_464##3	a_608_74##11	4.52477e-19
C978	a_991_81##7	SET_B#1	7.97924e-18
C979	SET_B	a_1804_424##11	7.32342e-18
C980	a_2186_367##5	a_1804_424##3	3.84716e-17
C981	SET_B	a_1584_379#	3.693e-18
C982	VGND#11	a_608_74##15	4.65386e-18
C983	VGND	a_1804_424##15	2.7465e-17
C984	SET_B	a_1804_424##13	3.58773e-19
C985	VGND	a_1641_74#	6.13648e-18
C986	a_991_81##14	a_1185_55##4	7.72762e-20
C987	VGND	a_1804_424##17	2.62618e-17
C988	VGND	VGND#16	1.49092e-17
C989	SET_B#2	a_608_74##3	3.96645e-19
C990	VGND	a_1641_74##2	1.92439e-17
C991	VGND	VGND#17	2.37705e-17
C992	VPWR	a_795_74##6	6.04185e-19
C993	a_795_74##15	a_608_74##3	1.2928e-18
C994	VGND	a_1185_55##5	9.32517e-18
C995	VGND#20	a_27_74#	1.56679e-19
C996	a_991_81##14	a_608_74##4	1.04192e-18
C997	Q	a_2611_98#	2.19208e-17
C998	SET_B#2	a_991_81##10	7.13398e-19
C999	Q	a_2611_98##4	1.18238e-17
C1000	SCD#4	CLK#1	3.8332e-18
C1001	VPWR#5	a_608_74##7	7.6969e-19
C1002	Q	a_1804_424#	9.26474e-19
C1003	a_290_464##2	a_608_74##11	1.87363e-17
C1004	a_608_74##13	CLK#2	8.76658e-18
C1005	a_290_464##3	SCE#2	3.15925e-19
C1006	VGND#2	a_2611_98##8	2.81311e-18
C1007	a_290_464##6	D#1	3.27882e-17
C1008	VGND#3	VGND#1	1.70172e-18
C1009	VGND#11	SCD#3	3.49176e-18
C1010	a_1804_424##15	SET_B#4	1.85913e-18
C1011	a_2611_98##2	VNB	3.6962e-17
C1012	SCD	a_608_74##11	3.40568e-19
C1013	VPWR#11	SCE	5.76621e-18
C1014	a_1804_424##3	VNB	1.15766e-16
C1015	a_1804_424##2	VNB	4.50796e-17
C1016	a_608_74##5	VNB	8.92516e-17
C1017	a_608_74##4	VNB	1.93312e-16
C1018	SCD	CLK#1	1.05066e-18
C1019	a_608_74##3	VNB	1.20438e-16
C1020	VGND#10	SCE	6.17654e-18
C1021	a_795_74##7	VNB	2.87472e-17
C1022	a_27_74##6	D#4	1.27476e-17
C1023	CLK#3	a_608_74##10	2.83548e-17
C1024	a_795_74##2	VNB	6.45162e-17
C1025	VPWR#6	a_795_74##10	4.02422e-18
C1026	SCD#2	VNB	1.03733e-16
C1027	SCE#2	VNB	9.33572e-17
C1028	a_1804_424##9	a_1804_424##7	1.72462e-18
C1029	VGND#21	SCE#6	3.83417e-19
C1030	a_991_81##13	a_1185_55#	2.24287e-17
C1031	VPWR#18	a_991_81##4	3.07531e-19
C1032	VPWR#8	a_608_74##2	9.13988e-20
C1033	a_1641_74#	a_1804_424##17	6.36851e-17
C1034	SET_B	a_608_74#	6.26884e-18
C1035	SCD#2	CLK#3	2.71248e-18
C1036	SET_B	a_795_74##6	1.78478e-18
C1037	a_608_74##8	a_991_81##14	1.30796e-17
C1038	VGND#3	a_1804_424##2	8.17436e-19
C1039	a_991_81#	SET_B#2	5.44923e-18
C1040	VPWR	a_1804_424#	4.25561e-19
C1041	VPWR#11	CLK	1.82703e-18
C1042	SET_B#8	a_608_74##2	2.8015e-18
C1043	VPWR	a_1804_424##7	8.87104e-19
C1044	VGND	a_1185_55##7	1.421e-18
C1045	a_991_81##2	SET_B#7	2.46102e-17
C1046	VGND#10	CLK	1.62938e-18
C1047	a_2186_367##4	a_1804_424##3	1.01804e-17
C1048	VPWR#4	VPWR#3	8.86976e-19
C1049	VPWR	SET_B#6	5.32108e-19
C1050	a_290_464##2	SCD#2	3.36905e-19
C1051	VPWR	a_2186_367##3	1.08037e-18
C1052	a_290_464##4	VPWR#12	9.13888e-18
C1053	VPWR#6	a_608_74##7	6.78737e-18
C1054	VPWR	a_795_74##10	2.59604e-18
C1055	VPWR	a_608_74##7	4.38363e-18
C1056	VPWR#23	a_290_464##4	9.31372e-18
C1057	a_795_74##16	a_1185_55##3	7.45512e-17
C1058	a_290_464##3	CLK#1	2.24961e-17
C1059	VPWR	a_991_81##9	4.04223e-18
C1060	VGND#11	VNB	4.23137e-17
C1061	a_27_74##3	SCD#4	3.473e-17
C1062	VGND#9	VNB	4.8641e-17
C1063	VPWR	a_991_81##8	4.04223e-18
C1064	a_991_81##2	SET_B#1	5.48119e-18
C1065	VGND#8	VNB	6.6917e-17
C1066	VGND#7	VNB	4.13136e-17
C1067	VPWR#7	a_608_74##2	1.91787e-19
C1068	a_991_81##13	a_608_74##5	7.71142e-19
C1069	VGND#6	VNB	3.75767e-17
C1070	VPWR	SET_B#3	1.60558e-20
C1071	VGND#4	VNB	6.91928e-17
C1072	VPWR#11	SCD	4.99442e-18
C1073	a_608_74##13	CLK#4	3.05899e-17
C1074	VGND#3	VNB	3.37233e-17
C1075	VPWR#12	VNB	4.03166e-17
C1076	VGND#10	SCD	5.15648e-18
C1077	VPWR#10	VNB	4.40761e-17
C1078	a_2186_367##5	a_1804_424##2	2.20553e-19
C1079	VPWR#9	VNB	4.95155e-17
C1080	VPWR#8	VNB	2.8965e-17
C1081	Q	VPWR#2	7.19656e-18
C1082	VPWR#7	VNB	3.26591e-17
C1083	VGND	a_1804_424##5	4.72338e-18
C1084	VPWR#5	VNB	4.06038e-17
C1085	a_290_464##6	a_27_74#	3.77272e-18
C1086	a_1584_379##2	a_991_81##4	5.1786e-19
C1087	VPWR#4	VNB	4.173e-17
C1088	VGND	a_1804_424##6	4.82315e-19
C1089	VGND#2	Q	6.05045e-18
C1090	VPWR#3	VNB	2.43022e-17
C1091	a_795_74##15	a_1185_55##3	7.14936e-19
C1092	VPWR#6	a_608_74##2	1.08998e-19
C1093	VGND#20	VPWR#22	9.36308e-20
C1094	a_2611_98##8	VNB	2.04531e-18
C1095	VPWR#2	VPWR#1	3.00088e-17
C1096	a_795_74##15	a_795_74##7	6.29005e-18
C1097	a_2186_367##5	VNB	2.34164e-17
C1098	VGND	a_608_74#	1.17468e-18
C1099	a_2611_98##10	VPWR#4	8.75434e-18
C1100	a_1804_424##10	VNB	1.08794e-17
C1101	a_991_81##2	a_991_81#	9.96739e-18
C1102	a_1804_424##9	VNB	1.18488e-17
C1103	a_991_81##8	a_608_74##3	2.33576e-17
C1104	a_1804_424##15	a_2186_367##2	3.62617e-18
C1105	a_1185_55#	a_991_81##10	2.2804e-19
C1106	SET_B#11	VNB	4.66718e-19
C1107	VGND	a_991_81##10	7.41894e-19
C1108	a_991_81##2	a_608_74##4	1.69654e-18
C1109	a_290_464##2	CLK#1	4.73083e-18
C1110	a_795_74##16	VNB	2.43208e-17
C1111	VGND#21	D#1	4.30765e-18
C1112	a_795_74##5	a_991_81##14	1.70451e-17
C1113	a_795_74##15	VNB	2.41276e-17
C1114	VGND	a_991_81#	8.49362e-20
C1115	SET_B	a_608_74##2	3.59474e-18
C1116	a_991_81##13	VNB	9.98895e-18
C1117	a_290_464##6	a_608_74##15	1.18304e-17
C1118	SET_B#7	VNB	6.68481e-19
C1119	a_2611_98##3	Q	4.85518e-17
C1120	a_1804_424##11	a_1584_379#	3.80717e-17
C1121	D#4	SCE#2	9.85e-18
C1122	a_290_464##3	VNB	9.63125e-18
C1123	a_795_74##17	a_608_74##8	1.82494e-19
C1124	CLK	a_608_74##6	3.61378e-17
C1125	a_290_464##2	VNB	2.2527e-18
C1126	a_1185_55##2	a_991_81##2	2.80571e-18
C1127	CLK	CLK#2	7.30779e-18
C1128	SCE	D#2	4.0352e-18
C1129	CLK#4	VNB	4.89412e-19
C1130	Q#1	VPWR#2	3.06009e-17
C1131	SCD#3	CLK#3	3.62042e-18
C1132	a_1185_55#	SET_B#1	3.59691e-19
C1133	a_27_74##2	SCE	5.15433e-17
C1134	a_27_74##7	VNB	4.18794e-17
C1135	VPWR	VPWR#6	7.1639e-17
C1136	a_27_74##6	VNB	5.94603e-17
C1137	VGND#11	SCE#6	5.51221e-18
C1138	D#4	VNB	7.15367e-19
C1139	a_991_81##13	a_1185_55##3	2.26426e-17
C1140	VGND#1	VNB	4.55388e-17
C1141	Q#2	VNB	2.20983e-18
C1142	VGND#14	VNB	7.26737e-18
C1143	a_1804_424##9	SET_B#6	1.95625e-17
C1144	VPWR#5	VPWR#16	1.13024e-19
C1145	a_2611_98##9	VNB	8.76048e-18
C1146	D#3	a_27_74##3	1.47829e-17
C1147	a_795_74##5	a_290_464##5	4.68003e-18
C1148	a_1804_424##15	VNB	7.44241e-18
C1149	SCD	CLK#2	9.06469e-19
C1150	a_1641_74#	VNB	4.13759e-18
C1151	VPWR	a_1804_424##4	4.11073e-18
C1152	a_1804_424##17	VNB	9.67359e-18
C1153	VGND#16	VNB	5.736e-18
C1154	a_1641_74##2	VNB	6.42066e-18
C1155	VPWR	SET_B#5	3.48874e-18
C1156	a_1185_55#	a_991_81#	3.93915e-19
C1157	VGND#17	VNB	3.46668e-18
C1158	VPWR#10	a_608_74##9	2.08631e-20
C1159	a_1185_55##5	VNB	6.79379e-18
C1160	SET_B#11	a_608_74#	5.51707e-20
C1161	a_27_74##8	D#1	2.30562e-19
C1162	a_991_81##15	VNB	4.1011e-18
C1163	VPWR	a_795_74##11	3.44609e-18
C1164	a_290_464#	VNB	6.11496e-18
C1165	VGND#10	VGND#11	7.84989e-17
C1166	a_795_74##15	VPWR#18	5.21342e-19
C1167	a_795_74##13	VNB	1.68376e-17
C1168	VPWR#2	VPWR#15	1.65717e-17
C1169	VGND#19	VNB	8.4347e-19
C1170	VPWR	a_795_74##8	1.28971e-20
C1171	VGND#4	VGND#14	1.36012e-18
C1172	a_608_74##15	VNB	1.1814e-17
C1173	VGND#20	VNB	5.98574e-18
C1174	VPWR	a_991_81##7	1.94337e-18
C1175	a_27_74##7	a_290_464##6	1.27342e-19
C1176	a_290_464##6	SCE#4	8.75882e-19
C1177	a_290_464##6	VNB	7.70247e-18
C1178	SET_B	VGND#5	4.98037e-18
C1179	a_290_464##3	SCD#4	3.57228e-17
C1180	a_290_464#	a_608_74##5	2.54028e-17
C1181	VGND#21	VNB	2.00193e-18
C1182	VPWR	SET_B#2	2.3909e-18
C1183	a_27_74##8	VNB	2.3294e-17
C1184	VPWR#1	VNB	3.72787e-17
C1185	Q#1	VNB	2.79216e-18
C1186	VPWR	a_991_81##2	1.30879e-18
C1187	a_2611_98##10	VPWR#3	9.21172e-18
C1188	VGND#11	SCE#7	3.89363e-19
C1189	VPWR#15	VNB	6.006e-18
C1190	a_2611_98##10	VNB	1.40951e-17
C1191	VPWR#16	VNB	6.87627e-18
C1192	a_2186_367##4	VNB	2.13845e-17
C1193	a_1804_424##14	VNB	7.17775e-18
C1194	a_1185_55#	a_1185_55##2	1.47905e-17
C1195	SET_B	a_1804_424##4	7.99696e-18
C1196	VPWR#17	VNB	4.00183e-19
C1197	VPWR	a_1185_55##3	1.42914e-19
C1198	a_1804_424##11	VNB	7.52981e-18
C1199	SET_B	SET_B#5	1.98265e-18
C1200	a_1584_379#	VNB	2.47143e-18
C1201	a_991_81##13	a_608_74##4	2.83774e-19
C1202	a_1804_424##13	VNB	1.14375e-17
C1203	SET_B	a_2186_367#	3.33744e-17
C1204	VPWR#18	VNB	9.15222e-18
C1205	a_1584_379##2	VNB	3.24571e-18
C1206	VGND#21	a_27_74#	3.39931e-17
C1207	a_795_74##17	a_795_74##5	5.14248e-18
C1208	VPWR#19	VNB	4.88904e-18
C1209	SET_B	a_795_74##11	8.07474e-18
C1210	a_1185_55##7	VNB	8.25376e-18
C1211	VPWR#20	VNB	2.14909e-18
C1212	a_1804_424##15	a_608_74#	5.9186e-17
C1213	a_1804_424##13	a_1804_424##11	2.20733e-18
C1214	VGND#10	VGND#9	8.57628e-17
C1215	a_991_81##14	VNB	8.01257e-18
C1216	a_290_464##6	VGND#20	1.47562e-17
C1217	a_795_74##17	VNB	1.57292e-17
C1218	VGND	SET_B#8	5.52364e-17
C1219	VPWR#7	a_991_81##9	1.79369e-18
C1220	a_608_74##13	VNB	4.62083e-18
C1221	a_27_74##4	a_290_464##4	5.55768e-17
C1222	VPWR#22	VNB	5.78516e-18
C1223	VGND	VGND#5	7.63008e-17
C1224	VPWR#23	VNB	2.02131e-18
C1225	a_795_74#	a_1185_55#	2.58119e-17
C1226	a_2611_98##5	VNB	3.72289e-17
C1227	a_2611_98##6	VNB	3.20417e-17
C1228	SET_B#5	a_1804_424##7	1.88122e-19
C1229	VGND#10	a_1185_55##5	8.17256e-18
C1230	a_1804_424##5	VNB	3.57562e-17
C1231	a_290_464##2	SCD#4	1.21799e-19
C1232	a_1804_424##6	VNB	3.17622e-17
C1233	a_2611_98##8	VPWR#15	3.1624e-18
C1234	SET_B#4	VNB	3.37411e-17
C1235	VGND	a_1804_424##4	4.69491e-18
C1236	VGND#16	a_1804_424##17	3.50582e-17
C1237	a_2186_367##2	VNB	1.93142e-17
C1238	a_1641_74##2	a_1641_74#	1.34915e-18
C1239	a_1804_424##10	a_2186_367##3	3.06602e-17
C1240	a_608_74#	VNB	7.24876e-17
C1241	VGND	SET_B#5	4.91765e-20
C1242	a_795_74##6	VNB	3.55897e-17
C1243	SET_B#3	a_608_74##4	1.91983e-17
C1244	a_795_74##9	VNB	2.59449e-17
C1245	VGND	a_2186_367#	1.21367e-17
C1246	a_991_81##4	VNB	3.71757e-17
C1247	a_991_81##10	VNB	2.54006e-17
C1248	VGND	a_795_74##11	1.03249e-19
C1249	SET_B#1	VNB	2.5539e-17
C1250	a_991_81#	VNB	3.9114e-17
C1251	a_1185_55##2	VNB	2.74017e-17
C1252	a_1804_424##4	a_2186_367##3	3.29314e-20
C1253	a_795_74#	VNB	3.76326e-17
C1254	VGND	a_991_81##7	5.51329e-18
C1255	SCE#1	D#3	3.55704e-17
C1256	a_608_74##9	VNB	4.56512e-17
C1257	a_608_74##10	VNB	3.21775e-17
C1258	VGND#10	VGND#8	1.13801e-16
C1259	CLK#3	VNB	3.31438e-17
C1260	SCD#3	VNB	2.60095e-17
C1261	VGND	a_991_81##2	8.05037e-18
C1262	a_1804_424##15	a_608_74##2	4.74353e-20
C1263	SCE#6	VNB	2.56741e-17
C1264	D#1	VNB	3.80131e-17
C1265	a_27_74#	VNB	1.7921e-17
C1266	SCE#4	VNB	5.1593e-17
C1267	VGND	a_1185_55##3	4.90546e-20
C1268	SCE#6	SCD#3	2.71345e-17
C1269	a_2611_98#	VNB	3.66624e-17
C1270	a_795_74##17	a_608_74##5	6.13008e-18
C1271	a_2611_98##4	VNB	3.4986e-17
C1272	a_991_81##2	a_795_74##2	2.26877e-19
C1273	a_1804_424#	VNB	4.53425e-17
C1274	a_1804_424##7	VNB	4.39766e-17
C1275	VGND#6	a_795_74##7	1.88005e-19
C1276	SET_B#6	VNB	3.84731e-17
C1277	a_27_74##8	a_27_74#	2.15745e-18
C1278	a_2186_367##3	VNB	4.45464e-17
C1279	VPWR#12	a_27_74##4	1.28377e-19
C1280	a_795_74##10	VNB	2.9378e-17
C1281	SET_B	a_2141_508#	3.33485e-19
C1282	a_608_74##7	VNB	4.417e-17
C1283	a_608_74##2	VNB	7.35319e-17
C1284	a_991_81##9	VNB	3.63871e-17
C1285	a_991_81##8	VNB	3.21094e-17
C1286	SET_B#3	VNB	3.93556e-17
C1287	a_991_81##3	VNB	3.9052e-17
C1288	a_1185_55##4	VNB	1.96529e-17
C1289	a_608_74##8	VNB	2.47204e-17
C1290	a_991_81##13	a_795_74##4	4.63984e-17
C1291	a_795_74##5	VNB	3.45819e-17
C1292	a_608_74##11	VNB	3.35397e-17
C1293	a_1641_74#	a_608_74#	1.5125e-18
C1294	CLK#1	VNB	4.33345e-17
C1295	SCD#4	VNB	2.83081e-17
C1296	a_27_74##3	VNB	2.61994e-17
C1297	D#3	VNB	2.38408e-17
C1298	a_608_74##11	a_795_74##17	2.3051e-17
C1299	SCE#1	VNB	2.37939e-17
C1300	SCE#5	VNB	2.7814e-17
C1301	VPWR#2	VNB	1.28615e-16
C1302	a_1185_55#	a_608_74##4	2.29722e-19
C1303	VGND#2	VNB	1.33457e-16
C1304	a_1804_424##15	SET_B#5	5.19247e-20
C1305	SET_B#8	VNB	1.68598e-17
C1306	VPWR#6	VNB	3.58127e-17
C1307	a_1584_379#	a_1804_424##13	9.22477e-17
C1308	a_2186_367#	VGND#15	6.26952e-19
C1309	VGND#5	VNB	4.41755e-17
C1310	a_2186_367##3	SET_B#5	1.31249e-17
C1311	VPWR#11	VNB	3.01113e-16
C1312	SCE#4	VGND#21	1.78025e-17
C1313	VGND#10	VNB	3.35027e-16
C1314	a_2611_98##3	VNB	3.6937e-17
C1315	a_1804_424##4	VNB	5.35803e-18
C1316	a_1641_74#	a_608_74##2	4.47624e-18
C1317	SET_B#5	VNB	7.27486e-17
C1318	a_2186_367#	VNB	6.06696e-17
C1319	a_795_74##15	a_1584_379##2	9.06769e-17
C1320	a_795_74##11	VNB	4.18234e-17
C1321	a_795_74##16	a_795_74##2	8.26753e-18
C1322	a_795_74##8	VNB	5.99888e-17
C1323	a_290_464##3	a_27_74##3	1.69812e-17
C1324	a_991_81##7	VNB	7.04866e-17
C1325	VPWR#8	a_991_81##8	2.76401e-18
C1326	SET_B#2	VNB	5.77931e-17
C1327	a_991_81##2	VNB	7.74694e-17
C1328	a_1185_55#	VNB	4.00253e-17
C1329	VGND#16	a_2186_367##2	2.873e-20
C1330	a_1185_55##3	VNB	4.11141e-17
C1331	a_795_74##4	VNB	1.81891e-20
C1332	a_795_74##3	VNB	5.74877e-17
C1333	a_1804_424##15	a_795_74##6	3.15448e-17
C1334	a_608_74##6	VNB	3.85495e-17
C1335	CLK#2	VNB	3.89338e-17
C1336	a_27_74##4	VNB	2.67766e-17
C1337	SCE#7	VNB	4.52261e-17
C1338	D#2	VNB	5.46485e-17
C1339	a_27_74##2	VNB	3.60895e-17
C1340	VPWR#16	VPWR#3	3.00315e-19
C1341	VPWR#21	a_608_74##11	4.03337e-17
C1342	SCE#5	SCE#1	2.89604e-17
C1343	VGND#10	a_991_81##15	1.46929e-17
C1344	a_795_74##17	a_608_74##4	2.82737e-17
C1345	a_1804_424##17	a_608_74#	2.01668e-19
C1346	VGND#8	a_795_74##2	9.92648e-20
C1347	VPWR#11	VPWR#12	7.65062e-17
C1348	a_27_74##8	SCE#4	2.34061e-17
C1349	SCE	VNB	7.99174e-18
C1350	VGND	SET_B	5.40314e-17
C1351	CLK	VNB	2.94338e-19
C1352	SCD	VNB	3.24343e-18
C1353	Q	VNB	4.08176e-17
C1354	VPWR	VNB	2.48992e-16
C1355	SET_B	VNB	1.51811e-17
C1356	a_1804_424##10	SET_B#11	4.0352e-18
C1357	VGND	VNB	2.36952e-16
C1358	a_795_74##13	a_608_74##5	9.20137e-18
C1359	D#2	a_290_464##4	2.53211e-18
C1360	a_1804_424##10	a_795_74##10	8.37424e-18
C1361	VPWR#13	VPWR#22	3.18311e-19
C1362	VGND#12	a_27_74##7	2.72067e-19
C1363	VGND#12	a_290_464##6	1.04531e-17
C1364	VGND#12	VGND#11	3.63312e-19
C1365	VGND#10	VGND#12	1.17239e-16
C1366	VPWR#13	VNB	6.53106e-17
C1367	VGND#12	SCE	1.97469e-19
C1368	VPWR#13	SCE#1	3.93245e-18
C1369	VGND#12	a_27_74##8	2.07885e-17
C1370	VPWR#13	D#2	1.51734e-19
C1371	a_27_74##6	VPWR#13	2.06004e-17
C1372	VGND#12	SCE#7	1.19344e-18
C1373	VGND#12	D#2	4.74562e-19
C1374	a_27_74##4	VPWR#13	2.09475e-18
C1375	VGND#12	a_27_74##2	1.51809e-18
C1376	VPWR#13	SCE#5	1.7835e-18
C1377	VPWR#13	a_27_74##2	1.25878e-19
C1378	a_290_464##4	VPWR#13	1.09775e-17
C1379	VPWR#11	VPWR#13	1.1631e-16
C1380	VGND#12	D#1	7.54625e-18
C1381	VGND#12	VNB	6.72373e-17
C1382	VGND#12	a_27_74#	3.67927e-18
C1383	VGND#12	SCE#4	2.71976e-18
C1384	VPWR#13	D#3	7.58497e-18
*
*
.ENDS sky130_fd_sc_hs__sdfstp_2
*
