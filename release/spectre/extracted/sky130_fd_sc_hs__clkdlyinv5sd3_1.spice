* Extracted by Quantus, converted by sky130cad/quantus.py
*
*
*
*                       LINUX           Wed Nov 18 08:23:59 2026
*
*
*
*  PROGRAM  advgen
*
*  Name           : advgen - Quantus - (64-bit)
*  Version        : 25.1.0-p047
*  Build Date     : Thu Dec 11 23:20:30 PST 2025
*
*  HSPICE LIBRARY
*
*  OPERATING_TEMPERATURE 150
*  QRC_TECH_DIR <path>/tech
*
*
*

*
.SUBCKT sky130_fd_sc_hs__clkdlyinv5sd3_1 VPB VNB VGND VPWR Y A
*
*
*  caps2d version: 10
*
*
*       TRANSISTOR CARDS
*
*
XM3 a_28_74##6 A#3 VGND#9 VNB sky130_fd_pr__nfet_01v8_lvt l=0.15 w=0.42 ad=0.1113 as=0.2961 pd=1.37 ps=2.25
XM6 VGND#9 a_28_74# a_288_74##6 VNB sky130_fd_pr__nfet_01v8_lvt l=0.18 w=0.42 ad=0.2961 as=0.1113 pd=2.25 ps=1.37
XM7 VGND#8 a_288_74# a_549_74##6 VNB sky130_fd_pr__nfet_01v8_lvt l=0.18 w=0.42 ad=0.2478 as=0.1113 pd=2.02 ps=1.37
XM8 a_682_74##6 a_549_74# VGND#7 VNB sky130_fd_pr__nfet_01v8_lvt l=0.18 w=0.42 ad=0.2457 as=0.1932 pd=2.01 ps=1.76
XM2 VGND#7 a_682_74##3 Y#3 VNB sky130_fd_pr__nfet_01v8_lvt l=0.15 w=0.42 ad=0.1932 as=0.1113 pd=1.76 ps=1.37
XM4 a_28_74##4 A#1 VPWR#9 VPB sky130_fd_pr__pfet_01v8 l=0.15 w=1.12 ad=0.3136 as=0.4068 pd=2.8 ps=2.99
XM1 VPWR#9 a_28_74##3 a_288_74##7 VPB sky130_fd_pr__pfet_01v8 l=0.5 w=1 ad=0.4068 as=0.26 pd=2.99 ps=2.52
XM0 VPWR#8 a_288_74##3 a_549_74##7 VPB sky130_fd_pr__pfet_01v8 l=0.5 w=1 ad=0.27 as=0.265 pd=2.54 ps=2.53
XM9 a_682_74##4 a_549_74##3 VPWR#7 VPB sky130_fd_pr__pfet_01v8 l=0.5 w=1 ad=0.26 as=0.508 pd=2.52 ps=3.19
XM5 VPWR#7 a_682_74# Y#1 VPB sky130_fd_pr__pfet_01v8 l=0.15 w=1.12 ad=0.508 as=0.3136 pd=3.19 ps=2.8
*
*
*       RESISTOR AND CAP/DIODE CARDS
*
Rg1	A#1	A#2	505.110291
Rg2	A#2	A#3	382.539764
Rg3	a_28_74#	a_28_74##2	275.028717
Rg4	a_28_74##2	a_28_74##3	141.539703
Rg5	a_288_74#	a_288_74##2	295.097870
Rg6	a_288_74##2	a_288_74##3	140.324768
Rg7	a_549_74#	a_549_74##2	273.197937
Rg8	a_549_74##2	a_549_74##3	140.324768
Rg9	a_682_74#	a_682_74##2	467.246124
Rg10	a_682_74##2	a_682_74##3	455.213867
Rf1	A	A#4	3.280892
Rf2	A#5	A#2	163.513702
Rf3	A#4	A#5	1.266811
Rf4	A	A#7	3.280892
Rf5	A#5	A#7	6.545189
Rf6	a_28_74##4	a_28_74##5	99.886612
Rf7	a_28_74##5	a_28_74##6	87.592514
Rf8	a_288_74##2	a_288_74##5	194.951324
Rf9	a_288_74##5	a_288_74##6	52.096035
Rf10	a_288_74##5	a_288_74##7	17.895864
Rf11	a_549_74##2	a_549_74##5	224.869141
Rf12	a_549_74##5	a_549_74##6	68.059647
Rf13	a_549_74##5	a_549_74##7	89.471367
Rf14	a_682_74##4	a_682_74##5	129.092072
Rf15	a_682_74##5	a_682_74##6	127.751671
Rf16	Y#2	Y	1.177624
Rf17	Y	Y#4	15.111293
Rf18	Y#4	Y	1.268211
Rf19	Y#2	Y	12.229176
Rf20	Y#1	Y#2	5.000000
Rf21	Y#3	Y#4	15.000000
Rf23	VPWR#2	VPWR#3	135.484131
Rf24	VPWR#3	VPWR#4	40.142254
Rf25	VPWR#4	VPWR#5	98.558121
Rf27	VPWR#2	VPWR#7	38.384460
Rf28	VPWR#4	VPWR#8	34.238716
Rf29	VPWR#5	VPWR#9	30.944223
Rf31	VGND#2	VGND#3	135.484131
Rf32	VGND#3	VGND#4	40.142254
Rf33	VGND#4	VGND#5	97.827614
Rf35	VGND#2	VGND#7	34.704330
Rf36	VGND#4	VGND#8	33.444363
Rf37	VGND#5	VGND#9	33.916985
Rf39	a_28_74##2	a_28_74##5	160.232803
Rf42	a_682_74##2	a_682_74##5	160.232803
Re1	VPWR#3	VPWR	1.165462
Re2	VGND#3	VGND	1.165462
*
*       CAPACITOR CARDS
*
*
C1	VGND#4	a_288_74##5	8.83117e-19
C2	a_288_74##5	a_549_74##5	4.4515e-18
C3	VGND#4	a_288_74##6	1.71263e-17
C4	VGND#9	VGND#4	1.37413e-20
C5	a_549_74##5	a_682_74##6	6.75623e-18
C6	a_288_74##5	a_549_74##6	4.49436e-19
C7	VGND#8	a_288_74##5	5.71588e-18
C8	VGND#7	Y#3	3.04946e-17
C9	a_288_74##7	VPWR#4	1.3381e-17
C10	a_682_74##6	Y#3	2.48329e-18
C11	VPWR#9	VPWR#4	1.93468e-19
C12	a_549_74##5	a_682_74##4	8.05504e-18
C13	a_682_74##6	VGND#7	8.70671e-18
C14	VGND#4	a_549_74#	1.80924e-19
C15	a_549_74##6	a_682_74##6	2.39756e-17
C16	VGND#4	a_288_74#	2.19741e-18
C17	a_288_74##5	a_549_74##7	3.4759e-18
C18	VGND#8	a_682_74##6	1.69003e-18
C19	VGND#4	a_28_74#	1.30894e-18
C20	VGND#8	a_549_74##6	1.15146e-17
C21	a_288_74##5	VPWR#8	4.40832e-17
C22	a_288_74##6	a_549_74##6	2.65192e-18
C23	VGND#4	A#3	1.05961e-19
C24	a_288_74##5	a_288_74##7	3.90253e-18
C25	Y#3	Y#1	5.25545e-19
C26	a_288_74##6	VGND#8	3.65628e-17
C27	VGND#9	VGND#8	7.53127e-19
C28	a_682_74##6	Y#1	8.44886e-20
C29	a_28_74##4	a_288_74##5	1.16498e-18
C30	VGND#9	a_288_74##6	1.17317e-17
C31	a_549_74##5	a_549_74#	1.98166e-20
C32	a_28_74##6	a_288_74##6	1.50063e-18
C33	a_28_74##6	VGND#9	4.43527e-17
C34	A#7	a_28_74##4	5.8611e-17
C35	a_549_74##5	a_288_74#	9.44811e-19
C36	a_549_74##5	a_28_74#	8.67077e-20
C37	a_288_74##5	a_288_74#	4.29418e-19
C38	a_288_74##5	a_28_74#	1.22924e-18
C39	VPWR#7	Y#1	6.52116e-17
C40	Y#3	a_682_74##3	1.38239e-17
C41	VPWR#4	a_288_74##3	2.49546e-18
C42	a_682_74##4	Y#1	3.90887e-19
C43	VGND#7	a_682_74##3	2.65212e-17
C44	Y#3	a_549_74#	1.72202e-18
C45	a_682_74##4	VPWR#7	2.69362e-17
C46	a_682_74##6	a_682_74##3	2.21714e-18
C47	VPWR#4	a_28_74##3	2.24403e-18
C48	a_549_74#	VGND#7	1.54077e-17
C49	Y#3	a_288_74#	4.85257e-19
C50	a_682_74##6	a_549_74#	3.16815e-17
C51	a_549_74##5	a_549_74##3	2.4661e-20
C52	VGND#7	a_288_74#	1.16458e-18
C53	a_549_74##7	a_682_74##4	5.11807e-17
C54	a_549_74##6	a_549_74#	5.73468e-19
C55	a_682_74##6	a_288_74#	5.73751e-18
C56	a_288_74##5	a_549_74##3	4.72625e-19
C57	VGND#8	a_549_74#	8.58356e-19
C58	a_549_74##5	a_288_74##3	1.08515e-19
C59	a_28_74##6	a_28_74##4	1.1762e-19
C60	a_288_74#	a_549_74##6	2.38582e-17
C61	a_682_74##6	a_28_74#	2.14718e-19
C62	VPWR#8	a_549_74##7	3.14505e-17
C63	a_288_74#	VGND#8	1.52558e-17
C64	a_288_74##5	a_288_74##3	5.04075e-18
C65	a_549_74##5	a_28_74##3	1.68131e-20
C66	a_549_74##6	a_28_74#	7.28973e-19
C67	a_288_74##6	a_288_74#	2.23516e-18
C68	Y#1	a_682_74##3	2.05888e-18
C69	VGND#8	a_28_74#	1.66201e-18
C70	a_288_74##7	VPWR#8	5.2351e-17
C71	VGND#9	a_288_74#	5.15727e-19
C72	a_288_74##5	a_28_74##3	1.49153e-17
C73	a_28_74#	a_288_74##6	2.36776e-17
C74	Y#1	a_549_74#	5.45338e-20
C75	VGND#8	A#3	1.36423e-19
C76	VPWR#9	VPWR#8	2.21136e-18
C77	a_28_74#	VGND#9	1.63252e-17
C78	a_288_74##5	A#1	3.34387e-19
C79	a_288_74##6	A#3	3.0678e-18
C80	A#7	a_28_74##3	2.95271e-18
C81	VPWR#9	a_288_74##7	1.70926e-17
C82	a_28_74##6	a_28_74#	1.80157e-18
C83	A#3	VGND#9	2.1631e-17
C84	a_28_74##4	a_288_74##7	3.50209e-19
C85	a_28_74##6	A#3	3.94294e-17
C86	A#7	A#1	9.07067e-18
C87	a_28_74##4	VPWR#9	7.004e-17
C88	VGND#4	a_288_74##2	8.56453e-19
C89	VGND#3	a_549_74##5	2.4683e-18
C90	a_682_74#	Y#1	1.84824e-17
C91	a_549_74##5	a_682_74##2	8.80455e-19
C92	VPWR#7	a_682_74#	6.38082e-17
C93	Y#1	a_549_74##3	6.86606e-20
C94	a_549_74#	a_682_74##3	1.33761e-17
C95	a_682_74##4	a_682_74#	4.90357e-18
C96	VPWR#7	a_549_74##3	3.44874e-17
C97	a_549_74##5	a_549_74##2	2.27888e-18
C98	a_682_74##4	a_549_74##3	1.07748e-16
C99	VPWR#7	a_288_74##3	1.73638e-18
C100	a_288_74#	a_549_74#	2.82482e-18
C101	a_288_74##5	a_549_74##2	3.20038e-19
C102	a_549_74##7	a_549_74##3	6.226e-18
C103	a_682_74##4	a_288_74##3	9.47042e-18
C104	a_288_74##2	a_549_74##5	4.61661e-17
C105	VPWR#8	a_549_74##3	1.96871e-18
C106	a_549_74##7	a_288_74##3	3.66595e-17
C107	a_28_74#	a_288_74#	2.51391e-18
C108	a_288_74##5	a_288_74##2	2.91906e-18
C109	VGND#3	a_682_74##6	1.00789e-17
C110	VPWR#8	a_288_74##3	8.86888e-17
C111	VGND#3	a_549_74##6	8.52972e-18
C112	a_549_74##7	a_28_74##3	5.26812e-19
C113	a_549_74##5	a_28_74##2	6.23963e-19
C114	VGND#7	a_682_74##2	2.81763e-17
C115	a_288_74##7	a_288_74##3	2.50059e-18
C116	VPWR#8	a_28_74##3	6.35968e-18
C117	a_682_74##6	a_682_74##2	5.33879e-18
C118	VPWR#9	a_288_74##3	1.21867e-18
C119	a_28_74##2	a_288_74##5	1.36002e-16
C120	A#3	a_28_74#	7.09416e-18
C121	a_288_74##7	a_28_74##3	4.11866e-17
C122	a_28_74##4	a_288_74##3	3.01049e-19
C123	VPWR#8	A#1	5.88642e-19
C124	a_28_74##3	VPWR#9	3.78506e-17
C125	a_682_74##6	a_549_74##2	7.88678e-17
C126	A#7	a_28_74##2	2.6001e-17
C127	a_288_74##7	A#1	2.0161e-18
C128	a_28_74##4	a_28_74##3	6.05146e-18
C129	a_682_74##4	VPWR#3	9.78867e-18
C130	A#1	VPWR#9	3.99557e-17
C131	a_549_74##7	VPWR#3	1.36807e-17
C132	a_682_74##6	a_288_74##2	1.0558e-18
C133	a_28_74##4	A#1	3.74329e-17
C134	A#7	A#2	7.92757e-18
C135	a_682_74##2	Y#1	9.21702e-17
C136	a_682_74##2	VPWR#7	3.69003e-17
C137	VGND#8	a_288_74##2	1.76607e-17
C138	a_549_74##3	a_682_74#	2.7457e-17
C139	a_682_74##4	a_549_74##2	5.67829e-17
C140	a_28_74##2	a_288_74##6	1.01689e-17
C141	VGND#9	a_28_74##2	2.26944e-17
C142	a_682_74##4	a_288_74##2	1.72569e-18
C143	a_288_74##3	a_549_74##3	7.00559e-18
C144	VGND#9	A#2	8.77831e-19
C145	a_682_74##2	a_682_74##3	4.93178e-18
C146	a_288_74##2	VPWR#8	1.23512e-17
C147	VGND#3	a_288_74#	1.06948e-17
C148	a_28_74##6	A#2	6.21166e-17
C149	a_28_74##3	a_288_74##3	8.77362e-18
C150	a_549_74##2	a_682_74##3	1.68944e-18
C151	a_288_74#	a_549_74##2	4.41991e-20
C152	A#1	a_28_74##3	4.08977e-17
C153	a_28_74##2	a_28_74##4	3.93163e-18
C154	VPWR#3	a_288_74##3	1.32551e-17
C155	VPWR#9	A#2	6.29041e-19
C156	a_28_74##4	A#2	1.74609e-18
C157	a_682_74##2	a_549_74##3	1.45647e-17
C158	a_28_74##2	a_288_74#	4.5595e-19
C159	a_28_74##2	a_28_74#	8.34817e-18
C160	A#3	a_28_74##2	1.4739e-19
C161	a_28_74##3	a_288_74##2	3.25496e-20
C162	a_28_74##2	a_288_74##3	7.28456e-19
C163	VPWR	VPWR#4	6.25675e-17
C164	a_28_74##2	a_28_74##3	3.80407e-17
C165	A#1	a_28_74##2	3.04423e-18
C166	VGND#3	a_549_74##2	4.9442e-20
C167	VPWR	a_549_74##5	5.28233e-18
C168	VGND	VGND#4	8.13191e-17
C169	a_682_74##2	a_549_74##2	5.21557e-17
C170	VPWR	a_288_74##5	1.27095e-18
C171	VGND#3	a_288_74##2	1.6304e-18
C172	VPWR	A#7	5.56552e-18
C173	a_682_74##2	a_288_74##2	9.60988e-20
C174	a_288_74##2	a_549_74##2	4.90719e-18
C175	Y	Y#1	4.16662e-18
C176	VPWR#7	Y	3.54634e-17
C177	VGND	a_549_74##5	6.83093e-18
C178	VGND	a_288_74##5	3.28876e-18
C179	a_28_74##2	a_288_74##2	5.81258e-18
C180	VGND#4	VNB	3.432e-17
C181	VPWR	VPWR#7	2.20654e-17
C182	VPWR#4	VNB	3.28606e-17
C183	VGND	Y#3	2.08377e-17
C184	VPWR	a_682_74##4	1.77136e-17
C185	A#2	a_28_74##2	7.89503e-17
C186	VGND	a_682_74##6	2.25654e-17
C187	VPWR	a_549_74##7	1.28416e-17
C188	VGND	a_549_74##6	1.37836e-17
C189	VPWR	VPWR#8	1.99553e-17
C190	VPWR	a_288_74##7	1.70906e-17
C191	a_549_74##5	VNB	2.01463e-17
C192	VGND	a_288_74##6	1.8798e-17
C193	VPWR	VPWR#9	2.30982e-17
C194	VGND	VGND#9	1.50108e-17
C195	a_288_74##5	VNB	1.86192e-17
C196	VGND	a_28_74##6	1.87578e-17
C197	VPWR	a_28_74##4	1.62672e-17
C198	VGND	Y#1	1.06696e-18
C199	A#7	VNB	1.74516e-17
C200	Y	a_682_74#	1.04357e-17
C201	VGND	a_682_74##4	3.98304e-18
C202	Y#3	VNB	2.64043e-17
C203	VGND	VPWR#8	4.37013e-18
C204	VGND#7	VNB	3.26504e-18
C205	a_682_74##6	VNB	1.76411e-17
C206	a_549_74##6	VNB	2.59809e-18
C207	VGND#8	VNB	1.0573e-17
C208	a_288_74##6	VNB	1.05249e-17
C209	VPWR	a_682_74#	2.72975e-18
C210	VGND	a_682_74##3	1.6316e-18
C211	VGND#9	VNB	2.39501e-18
C212	a_28_74##6	VNB	3.80407e-17
C213	VGND	a_549_74#	1.42974e-18
C214	VPWR	a_549_74##3	9.16527e-18
C215	Y#1	VNB	8.55623e-17
C216	VGND	a_288_74#	6.84148e-18
C217	VPWR	a_288_74##3	1.48877e-17
C218	VPWR#7	VNB	2.33119e-18
C219	VGND	a_28_74#	5.82703e-18
C220	a_682_74##4	VNB	9.4198e-18
C221	VPWR	a_28_74##3	1.00663e-17
C222	a_549_74##7	VNB	6.80728e-18
C223	VGND	A#3	1.08819e-18
C224	VPWR#8	VNB	1.00995e-17
C225	VPWR	A#1	8.25302e-19
C226	a_288_74##7	VNB	4.34334e-18
C227	VPWR#9	VNB	3.85576e-18
C228	a_28_74##4	VNB	3.55693e-17
C229	VPWR	VPWR#3	6.50837e-17
C230	a_682_74##3	VNB	3.35949e-17
C231	a_549_74#	VNB	3.41555e-17
C232	a_288_74#	VNB	4.5503e-17
C233	VPWR	a_682_74##2	7.12336e-18
C234	a_28_74#	VNB	3.95967e-17
C235	A#3	VNB	3.67631e-17
C236	VPWR	a_549_74##2	8.38336e-19
C237	a_682_74#	VNB	3.69237e-17
C238	VPWR	a_288_74##2	5.1718e-18
C239	a_549_74##3	VNB	1.08951e-16
C240	VGND	VGND#3	6.45375e-17
C241	VPWR	a_28_74##2	8.56405e-18
C242	a_288_74##3	VNB	1.09038e-16
C243	VGND	a_682_74##2	8.01548e-18
C244	a_28_74##3	VNB	1.1011e-16
C245	VGND	a_549_74##2	3.39214e-18
C246	A#1	VNB	5.62308e-17
C247	VGND	a_288_74##2	1.22449e-17
C248	VPWR#3	VNB	3.99482e-17
C249	VGND	a_28_74##2	1.31275e-17
C250	VGND#3	VNB	3.77706e-17
C251	VGND	A#2	6.43288e-18
C252	a_682_74##2	VNB	6.58854e-17
C253	a_549_74##2	VNB	7.1603e-17
C254	a_288_74##2	VNB	7.77195e-17
C255	a_28_74##2	VNB	6.9836e-17
C256	A#2	VNB	7.33117e-17
C257	VPWR	Y	2.46636e-17
C258	Y	VNB	2.4356e-17
C259	VPWR	VNB	2.87179e-16
C260	VGND	VNB	2.95479e-16
C261	Y	VPWR#2	3.28847e-17
C262	VPWR	VPWR#5	9.48033e-17
C263	VGND	VGND#2	1.29019e-16
C264	VPWR#2	a_549_74##3	1.52628e-17
C265	VGND#5	a_28_74##6	2.46863e-17
C266	VPWR#5	VPWR#4	4.40448e-19
C267	VGND#5	A#3	4.84508e-18
C268	VGND#2	a_682_74##3	6.1519e-18
C269	VGND	VGND#5	9.39338e-17
C270	VGND#5	a_28_74##2	5.2428e-18
C271	VGND#2	a_549_74##2	8.34358e-19
C272	VPWR#2	a_682_74#	4.54745e-18
C273	a_682_74##4	VPWR#2	8.02637e-18
C274	VPWR#5	A#1	1.11819e-18
C275	VGND#2	Y#3	2.25397e-17
C276	VGND#5	a_28_74#	8.17652e-18
C277	VGND#2	a_682_74##2	7.1945e-19
C278	VPWR#2	VNB	6.13928e-17
C279	VGND#5	VGND#4	7.36092e-19
C280	VPWR#5	a_28_74##3	1.28336e-17
C281	VPWR#5	VNB	5.26519e-17
C282	a_28_74##4	VPWR#5	9.48505e-18
C283	VGND#2	a_288_74#	1.60027e-19
C284	VGND#5	a_288_74#	5.89398e-20
C285	VGND#2	VNB	6.49939e-17
C286	VPWR	VPWR#2	1.14236e-16
C287	a_682_74##2	VPWR#2	1.04459e-18
C288	VGND#2	a_682_74##6	1.18335e-17
C289	VGND#5	VNB	5.56836e-17
C290	a_28_74##2	VPWR#5	2.36869e-18
C291	VGND#2	a_549_74#	1.11497e-17
*
*
.ENDS sky130_fd_sc_hs__clkdlyinv5sd3_1
*
