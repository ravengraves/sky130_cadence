* Extracted by Quantus, converted by sky130cad/quantus.py
*
*
*
*                       LINUX           Wed Nov 18 09:15:58 2026
*
*
*
*  PROGRAM  advgen
*
*  Name           : advgen - Quantus - (64-bit)
*  Version        : 25.1.0-p047
*  Build Date     : Thu Dec 11 23:20:30 PST 2025
*
*  HSPICE LIBRARY
*
*  OPERATING_TEMPERATURE 150
*  QRC_TECH_DIR <path>/tech
*
*
*

*
.SUBCKT sky130_fd_sc_hs__xor3_4 VNB VPB VGND VPWR X A B C
*
*
*  caps2d version: 10
*
*
*       TRANSISTOR CARDS
*
*
XM16 a_27_118##3 a_74_294##3 VGND#11 VNB sky130_fd_pr__nfet_01v8_lvt l=0.15 w=0.64 ad=0.1824 as=0.4845 pd=1.85 ps=3.14
XM19 VGND#11 A#1 a_74_294##11 VNB sky130_fd_pr__nfet_01v8_lvt l=0.15 w=0.64 ad=0.4845 as=0.4416 pd=3.14 ps=2.66
XM4 a_74_294##11 B#9 a_416_118##3 VNB sky130_fd_pr__nfet_01v8_lvt l=0.15 w=0.64 ad=0.4416 as=0.2075 pd=2.66 ps=1.98
XM25 a_416_118##3 a_397_320##7 a_27_118# VNB sky130_fd_pr__nfet_01v8_lvt l=0.15 w=0.42 ad=0.2075 as=0.244 pd=1.98 ps=2.18
XM22 a_27_118# B#11 a_323_392##4 VNB sky130_fd_pr__nfet_01v8_lvt l=0.15 w=0.64 ad=0.244 as=0.29175 pd=2.18 ps=2.23
XM18 a_323_392##4 a_397_320# a_74_294##4 VNB sky130_fd_pr__nfet_01v8_lvt l=0.15 w=0.64 ad=0.29175 as=0.2848 pd=2.23 ps=2.17
XM5 a_397_320##9 B#1 VGND#10 VNB sky130_fd_pr__nfet_01v8_lvt l=0.15 w=0.74 ad=0.2072 as=0.42 pd=2.04 ps=2.67
XM6 a_323_392##2 a_1155_284# a_1218_388##16 VNB sky130_fd_pr__nfet_01v8_lvt l=0.15 w=0.64 ad=0.176 as=0.3392 pd=1.83 ps=2.34
XM1 a_1218_388##16 C#7 a_416_118##5 VNB sky130_fd_pr__nfet_01v8_lvt l=0.15 w=0.64 ad=0.3392 as=0.1824 pd=2.34 ps=1.85
XM11 a_1155_284##4 C#1 VGND#9 VNB sky130_fd_pr__nfet_01v8_lvt l=0.15 w=0.42 ad=0.2121 as=0.2942 pd=1.85 ps=2.34
XM26 VGND#9 a_1218_388##14 X#7 VNB sky130_fd_pr__nfet_01v8_lvt l=0.15 w=0.74 ad=0.2942 as=0.2072 pd=2.34 ps=2.04
XM15 X#7 a_1218_388##12 VGND#4 VNB sky130_fd_pr__nfet_01v8_lvt l=0.15 w=0.74 ad=0.2072 as=0.2072 pd=2.04 ps=2.04
XM20 X#1 a_1218_388##10 VGND#4 VNB sky130_fd_pr__nfet_01v8_lvt l=0.15 w=0.74 ad=0.2072 as=0.2072 pd=2.04 ps=2.04
XM24 VGND#1 a_1218_388# X#1 VNB sky130_fd_pr__nfet_01v8_lvt l=0.15 w=0.74 ad=0.2072 as=0.2072 pd=2.04 ps=2.04
XM12 a_27_118##6 a_74_294# VPWR#13 VPB sky130_fd_pr__pfet_01v8 l=0.15 w=1 ad=0.295 as=0.35 pd=2.59 ps=2.7
XM21 VPWR#13 A#3 a_74_294##7 VPB sky130_fd_pr__pfet_01v8 l=0.15 w=1 ad=0.35 as=0.3706 pd=2.7 ps=2.77
XM3 a_74_294##7 B#5 a_323_392##6 VPB sky130_fd_pr__pfet_01v8 l=0.15 w=0.84 ad=0.3706 as=0.3054 pd=2.77 ps=2.45
XM0 a_323_392##6 a_397_320##5 a_27_118##5 VPB sky130_fd_pr__pfet_01v8 l=0.15 w=0.64 ad=0.3054 as=0.29975 pd=2.45 ps=2.43
XM27 a_27_118##5 B#10 a_416_118# VPB sky130_fd_pr__pfet_01v8 l=0.15 w=0.64 ad=0.29975 as=0.30525 pd=2.43 ps=2.45
XM17 a_416_118# a_397_320##6 a_74_294##5 VPB sky130_fd_pr__pfet_01v8 l=0.15 w=0.84 ad=0.30525 as=0.546 pd=2.45 ps=2.98
XM13 a_397_320##8 B#6 VPWR#10 VPB sky130_fd_pr__pfet_01v8 l=0.15 w=1.12 ad=0.3304 as=0.3304 pd=2.83 ps=2.83
XM2 a_416_118##7 a_1155_284##3 a_1218_388##18 VPB sky130_fd_pr__pfet_01v8 l=0.15 w=0.84 ad=0.3822 as=0.4452 pd=2.59 ps=2.74
XM8 a_1218_388##18 C#5 a_323_392# VPB sky130_fd_pr__pfet_01v8 l=0.15 w=0.84 ad=0.4452 as=0.2478 pd=2.74 ps=2.27
XM14 a_1155_284##5 C#6 VPWR#5 VPB sky130_fd_pr__pfet_01v8 l=0.15 w=0.64 ad=0.1888 as=0.8024 pd=1.87 ps=3.75
XM9 VPWR#5 a_1218_388##15 X#4 VPB sky130_fd_pr__pfet_01v8 l=0.15 w=1.12 ad=0.8024 as=0.336 pd=3.75 ps=2.84
XM10 X#4 a_1218_388##13 VPWR#8 VPB sky130_fd_pr__pfet_01v8 l=0.15 w=1.12 ad=0.336 as=0.4256 pd=2.84 ps=3
XM23 VPWR#8 a_1218_388##11 X#5 VPB sky130_fd_pr__pfet_01v8 l=0.15 w=1.12 ad=0.4256 as=0.336 pd=3 ps=2.84
XM7 X#5 a_1218_388##9 VPWR#1 VPB sky130_fd_pr__pfet_01v8 l=0.15 w=1.12 ad=0.336 as=0.3304 pd=2.84 ps=2.83
*
*
*       RESISTOR AND CAP/DIODE CARDS
*
Rg1	a_74_294#	a_74_294##2	400.207520
Rg2	a_74_294##2	a_74_294##3	353.846649
Rg3	A#1	A#2	279.244598
Rg4	A#2	A#3	457.627838
Rg5	a_397_320#	a_397_320##2	317.032928
Rg6	a_397_320##2	a_397_320##3	274.008820
Rg7	a_397_320##3	a_397_320##4	361.627106
Rg8	a_397_320##4	a_397_320##5	494.110046
Rg9	a_397_320##3	a_397_320##6	318.596710
Rg10	a_397_320##4	a_397_320##7	340.173401
Rg11	B#1	B#2	319.912079
Rg12	B#2	B#3	249.959061
Rg13	B#3	B#4	1852.070557
Rg14	B#4	B#5	978.076599
Rg15	B#2	B#6	505.030823
Rg16	B#2	B#7	43.398811
Rg17	B#3	B#8	1388.183594
Rg18	B#8	B#9	978.206787
Rg19	B#4	B#10	349.219452
Rg20	B#8	B#11	383.213074
Rg21	a_1155_284#	a_1155_284##2	304.971558
Rg22	a_1155_284##2	a_1155_284##3	361.787689
Rg23	C#1	C#2	973.316711
Rg24	C#2	C#3	52.252907
Rg25	C#3	C#4	30.613651
Rg26	C#4	C#5	375.573853
Rg27	C#2	C#6	536.062439
Rg28	C#4	C#7	372.473053
Rg29	a_1218_388#	a_1218_388##2	343.038818
Rg30	a_1218_388##2	a_1218_388##3	66.369736
Rg31	a_1218_388##3	a_1218_388##4	67.806938
Rg32	a_1218_388##4	a_1218_388##5	23.289124
Rg33	a_1218_388##5	a_1218_388##6	50.392693
Rg34	a_1218_388##6	a_1218_388##7	24.799288
Rg35	a_1218_388##7	a_1218_388##8	49.332317
Rg36	a_1218_388##2	a_1218_388##9	491.849670
Rg37	a_1218_388##3	a_1218_388##10	340.977417
Rg38	a_1218_388##3	a_1218_388##11	490.797760
Rg39	a_1218_388##4	a_1218_388##12	322.894470
Rg40	a_1218_388##5	a_1218_388##13	461.749268
Rg41	a_1218_388##6	a_1218_388##14	317.345428
Rg42	a_1218_388##7	a_1218_388##15	461.749268
Rf1	A#4	A	1.683980
Rf2	A#2	A#6	161.916779
Rf3	A#4	A#6	7.318094
Rf4	a_27_118#	a_27_118##2	64.888428
Rf5	a_27_118##2	a_27_118##4	199.400970
Rf6	a_27_118##2	a_27_118##5	46.748199
Rf7	a_27_118##4	a_27_118##6	111.489586
Rf8	a_27_118##3	a_27_118##4	7.500000
Rf9	a_416_118##2	a_416_118##3	190.404922
Rf10	a_416_118##2	a_416_118##4	8.762174
Rf11	a_416_118#	a_416_118##2	15.000000
Rf12	a_74_294##4	a_74_294##6	91.075768
Rf13	a_74_294##6	a_74_294##8	244.234360
Rf14	a_74_294##8	a_74_294##9	17.734955
Rf15	a_74_294##9	a_74_294##2	216.861328
Rf16	a_74_294##9	a_74_294##11	94.219971
Rf17	a_74_294##5	a_74_294##6	7.500000
Rf18	a_74_294##7	a_74_294##8	5.000000
Rf19	a_397_320##8	a_397_320##10	114.767540
Rf20	a_397_320##10	a_397_320##2	287.511200
Rf21	a_397_320##9	a_397_320##10	15.000000
Rf22	B	B#12	0.617720
Rf23	B#13	B#7	160.850525
Rf24	B#12	B#13	3.543054
Rf25	a_1218_388##16	a_1218_388##17	78.999084
Rf26	a_1218_388##17	a_1218_388##18	18.851362
Rf27	a_416_118##5	a_416_118##6	201.170486
Rf28	a_416_118##6	a_416_118##7	18.408216
Rf29	C#3	C	162.698593
Rf30	a_323_392#	a_323_392##3	284.046967
Rf31	a_323_392##3	a_323_392##5	248.983276
Rf32	a_323_392##5	a_323_392##6	249.040222
Rf33	a_323_392##2	a_323_392##3	15.000000
Rf34	a_323_392##4	a_323_392##5	7.500000
Rf35	a_1155_284##4	a_1155_284##6	157.922058
Rf36	a_1155_284##6	a_1155_284##2	390.721130
Rf37	a_1155_284##5	a_1155_284##6	15.000000
Rf38	a_1218_388##19	a_1218_388##8	80.853905
Rf39	X#1	X#2	40.242439
Rf40	X#2	X#3	41.670425
Rf41	X#3	X#4	53.127357
Rf42	X#2	X	12.744197
Rf43	X	X#6	14.369054
Rf44	X#6	X	0.196836
Rf45	X#3	X#7	42.545338
Rf46	X#5	X#6	5.000000
Rf47	VGND#1	VGND#2	92.571297
Rf48	VGND#2	VGND#3	57.442680
Rf49	VGND#2	VGND#4	56.430489
Rf50	VGND#3	VGND#5	240.807251
Rf51	VGND#5	VGND#6	147.229568
Rf52	VGND#6	VGND#7	184.759323
Rf54	VGND#3	VGND#9	27.946524
Rf55	VGND#5	VGND#10	33.445892
Rf56	VGND#7	VGND#11	22.694660
Rf57	VPWR#1	VPWR#2	115.707314
Rf58	VPWR#2	VPWR#3	54.155411
Rf59	VPWR#3	VPWR#4	30.450809
Rf60	VPWR#4	VPWR#6	13.863805
Rf61	VPWR#6	VPWR#7	6.328702
Rf62	VPWR#2	VPWR#8	67.810089
Rf63	VPWR#4	VPWR#9	230.219376
Rf64	VPWR#9	VPWR#10	38.286041
Rf65	VPWR#9	VPWR#11	124.891815
Rf66	VPWR#11	VPWR#12	192.098267
Rf67	VPWR#12	VPWR#13	33.699932
Rf69	VPWR#5	VPWR#6	7.500000
Rf70	VPWR#5	VPWR#7	5.000000
Re1	a_416_118##6	a_416_118##4	24.299402
Re2	a_1218_388##19	a_1218_388##17	22.652748
Re3	VPWR#3	VPWR	2.512894
Re4	VPWR	VPWR#11	1.435940
Re5	VGND#3	VGND	2.512894
Re6	VGND	VGND#6	1.435940
*
*       CAPACITOR CARDS
*
*
C1	VPWR#8	a_1218_388##5	4.67169e-18
C2	B#8	a_397_320##2	2.60332e-18
C3	a_74_294##11	a_74_294##3	2.15858e-18
C4	a_74_294##9	B#10	4.98294e-19
C5	a_397_320##2	B#4	3.03822e-17
C6	a_27_118##3	A#1	3.178e-17
C7	a_27_118##6	VPWR#13	5.98584e-17
C8	X#4	a_1218_388##7	4.49488e-18
C9	B#4	B#6	4.74938e-17
C10	a_74_294##3	VGND#11	1.74463e-17
C11	a_27_118##2	a_397_320##4	3.67615e-17
C12	a_27_118##3	A#6	1.76262e-18
C13	a_397_320##4	a_397_320##2	6.1812e-19
C14	VPWR#3	VPWR#4	1.10551e-16
C15	a_397_320##9	a_416_118##5	1.00592e-18
C16	a_27_118##2	a_397_320##6	2.21845e-19
C17	a_27_118##3	a_74_294##3	5.00144e-17
C18	VPWR#3	VPWR#2	6.61003e-17
C19	a_74_294##9	a_397_320##5	9.32747e-18
C20	VGND#2	VGND#1	1.1306e-18
C21	VPWR#8	a_1218_388##3	1.34555e-18
C22	B#4	B#2	1.02873e-17
C23	a_323_392##2	VGND#10	1.0027e-16
C24	B#8	a_397_320##4	4.96777e-19
C25	a_27_118##2	a_397_320##3	5.79279e-19
C26	C#2	a_1218_388##14	3.51625e-19
C27	a_27_118##2	B#10	2.48423e-18
C28	X#4	a_1218_388##5	1.85108e-18
C29	a_74_294##9	B#5	5.65849e-17
C30	VGND#2	X#1	1.37683e-17
C31	a_323_392##2	a_397_320##9	5.77009e-17
C32	a_397_320##6	B#4	2.18268e-17
C33	A#2	a_397_320##4	4.6953e-19
C34	a_1218_388##10	a_1218_388#	3.83222e-17
C35	a_1218_388##3	X#1	2.11018e-19
C36	a_27_118##2	a_397_320##5	6.72007e-18
C37	VGND#4	a_1218_388##5	1.39552e-18
C38	VPWR#1	a_1218_388##9	3.14716e-17
C39	VPWR#3	X#3	1.81278e-18
C40	VGND#3	VGND#5	1.26119e-17
C41	a_74_294##9	A#3	4.52997e-17
C42	VGND#1	VPWR#1	1.12128e-17
C43	a_1218_388##17	VPWR#4	3.34114e-18
C44	VGND#3	VGND#2	6.6084e-17
C45	VPWR#3	X#2	1.06631e-18
C46	X#4	a_1218_388##3	4.21042e-19
C47	a_1218_388##9	X#5	2.44129e-17
C48	a_397_320##4	B#4	1.03375e-18
C49	B#8	a_397_320##3	1.22396e-18
C50	A#6	a_397_320##5	1.01526e-18
C51	a_416_118##6	VPWR#9	7.44996e-18
C52	a_1218_388##2	X#1	3.99016e-19
C53	VPWR#1	a_1218_388##11	1.23306e-18
C54	a_27_118##2	B#5	1.99934e-18
C55	VPWR#8	a_1218_388##9	7.03669e-19
C56	a_1218_388##12	a_1218_388##10	3.90059e-17
C57	a_323_392##4	a_323_392##2	9.70735e-19
C58	a_74_294##9	a_74_294#	2.34846e-18
C59	a_1218_388##11	X#5	2.37392e-17
C60	VGND#3	X#3	9.49622e-19
C61	B#10	B#4	9.71467e-20
C62	A#6	a_397_320##4	8.35184e-20
C63	a_1155_284##5	a_1218_388##7	2.40825e-19
C64	VGND#3	X#2	1.88868e-18
C65	VPWR#1	a_1218_388##13	2.58333e-19
C66	VGND#2	a_1218_388#	5.38002e-19
C67	a_1218_388##11	VPWR#8	2.45582e-17
C68	VGND#2	X#7	5.32799e-18
C69	VGND#4	a_1218_388##3	2.6118e-18
C70	a_27_118##2	A#3	1.82619e-20
C71	a_397_320##9	a_74_294##4	6.74364e-17
C72	a_1218_388##5	X#7	4.60403e-19
C73	X#4	a_1218_388##11	3.05158e-18
C74	a_1218_388##14	a_1218_388##12	3.74583e-17
C75	X#3	X#1	1.30223e-18
C76	VGND#9	a_1218_388##7	2.23725e-18
C77	a_1218_388##7	a_1218_388##5	3.63396e-18
C78	a_1218_388##13	VPWR#8	2.85728e-17
C79	a_397_320##3	B#4	1.32059e-18
C80	a_397_320##4	B#10	1.20412e-17
C81	a_323_392##6	B#11	9.25574e-19
C82	VPWR#5	a_1218_388##11	3.26328e-19
C83	X#4	C#2	8.98428e-20
C84	C#7	C#2	1.76419e-17
C85	a_74_294##4	B#6	2.25447e-20
C86	a_323_392##4	a_397_320##9	5.75646e-17
C87	VGND#2	a_1218_388##10	5.89395e-18
C88	X#4	a_1218_388##13	6.22702e-17
C89	VGND#9	VGND#2	3.6171e-19
C90	VPWR#11	VPWR#9	1.3513e-16
C91	VPWR#8	a_1218_388##15	5.42745e-19
C92	C#1	a_1218_388##14	1.78998e-17
C93	VPWR#5	a_1218_388##13	1.05716e-18
C94	X#3	VGND#4	1.26782e-17
C95	a_397_320##5	B#4	6.51833e-18
C96	a_323_392#	a_1218_388##7	4.11152e-20
C97	X#4	a_1218_388##15	5.60769e-17
C98	a_323_392##6	B#9	3.51841e-19
C99	VPWR#11	VPWR#4	3.78103e-18
C100	a_323_392##4	a_397_320##6	1.08568e-17
C101	a_1218_388##15	VPWR#5	2.90206e-17
C102	VGND#2	a_1218_388##12	4.70302e-18
C103	X#2	a_1218_388#	1.58251e-19
C104	VGND#4	X#2	1.04246e-17
C105	a_1155_284##4	a_1218_388##7	5.93826e-20
C106	X#4	C#6	4.07809e-19
C107	C#7	C#1	9.8238e-19
C108	a_1155_284##5	a_1218_388##15	1.64205e-18
C109	X#3	a_1218_388##10	4.62533e-19
C110	a_323_392##4	B#10	4.10207e-19
C111	C#6	VPWR#5	2.86765e-17
C112	a_397_320##5	a_397_320##3	4.85698e-19
C113	a_323_392#	a_1218_388##15	6.87113e-20
C114	a_1155_284##5	C#6	6.31889e-17
C115	X#2	a_1218_388##10	1.7958e-19
C116	VGND#2	a_1218_388##14	3.05617e-19
C117	X#7	X#4	4.02812e-18
C118	B#5	B#4	5.21613e-19
C119	VPWR#5	C#5	2.32394e-19
C120	a_1155_284#	C#7	1.20376e-17
C121	a_323_392##4	a_397_320##5	1.62507e-19
C122	a_323_392#	C#6	2.08796e-18
C123	X#3	a_1218_388##12	2.34701e-18
C124	a_1155_284##5	C#4	4.63287e-19
C125	a_1155_284##5	C#5	1.75019e-17
C126	a_1155_284##4	a_1218_388##5	1.15062e-20
C127	VGND#6	VGND#5	1.25601e-16
C128	a_416_118##3	a_323_392##4	4.20204e-17
C129	B#12	a_416_118##6	1.41667e-17
C130	a_416_118##3	a_397_320##5	1.22849e-19
C131	C#5	a_323_392#	1.61012e-17
C132	X#2	a_1218_388##12	6.17873e-20
C133	VPWR#4	a_1218_388##8	3.41727e-19
C134	a_323_392##4	B#5	8.58566e-20
C135	VGND#2	C#1	1.13572e-19
C136	B#1	a_1155_284#	2.52486e-18
C137	X#7	C#2	4.64567e-20
C138	C#2	a_1155_284##5	9.19279e-18
C139	a_1155_284##5	a_1155_284##3	1.49294e-19
C140	a_74_294##9	a_27_118##5	8.73954e-18
C141	a_1218_388##18	C#5	5.19155e-17
C142	B#2	a_1155_284#	1.59855e-18
C143	a_1155_284##4	X#3	2.25951e-18
C144	VGND#5	a_323_392##2	1.289e-16
C145	a_416_118##3	a_27_118#	8.21511e-17
C146	X#3	a_1218_388##14	1.78166e-18
C147	VGND#5	C#7	1.12326e-18
C148	B#8	B#1	4.23639e-18
C149	a_1218_388##19	VGND#9	5.30569e-18
C150	a_1155_284##3	a_1218_388##18	3.41324e-17
C151	a_1218_388##19	a_1155_284##4	3.20339e-18
C152	B#4	B#1	2.79418e-17
C153	a_74_294##9	a_323_392##6	1.32427e-16
C154	a_416_118##7	a_1155_284##3	1.00636e-17
C155	a_323_392#	C#4	7.63482e-18
C156	VGND#3	VGND#1	6.13224e-17
C157	a_27_118##3	B#5	8.84745e-19
C158	VPWR#10	a_1155_284##3	2.19479e-18
C159	VGND#3	X#1	1.75291e-17
C160	a_1155_284##2	VPWR#9	2.30107e-17
C161	a_1218_388##8	X#3	3.76636e-17
C162	VGND#5	a_1155_284#	1.12221e-18
C163	a_416_118##4	a_74_294##9	5.22282e-18
C164	a_416_118##7	B#6	1.12155e-18
C165	VGND#9	C#2	3.11494e-19
C166	a_323_392#	C#2	4.10955e-17
C167	B#11	a_397_320#	1.83802e-17
C168	a_74_294##9	a_74_294##7	9.13929e-18
C169	VGND#3	X#7	2.94211e-17
C170	VPWR#10	B#6	6.97032e-17
C171	VGND#3	VGND#9	2.19991e-17
C172	B#8	a_397_320#	1.02063e-17
C173	a_416_118##5	a_1155_284##5	1.28781e-18
C174	B#6	a_397_320##8	2.60601e-17
C175	VGND#3	a_1155_284##4	4.70824e-17
C176	a_323_392#	a_1155_284##4	7.38324e-17
C177	a_74_294##9	VPWR#11	8.44803e-17
C178	VGND#5	B#1	4.44935e-18
C179	VGND#6	B#12	3.6452e-18
C180	a_397_320#	B#4	1.5892e-17
C181	VGND#3	a_416_118##5	8.04982e-18
C182	a_74_294##5	B#6	3.60751e-18
C183	a_397_320##7	B#11	1.5e-17
C184	a_27_118##2	a_416_118##4	5.16221e-17
C185	VGND#5	a_1155_284##2	4.57428e-20
C186	a_74_294##9	VPWR#13	8.75085e-17
C187	a_1218_388##18	C#4	8.07592e-18
C188	a_397_320##8	a_397_320##6	1.76932e-19
C189	a_74_294##9	a_27_118##2	1.28622e-17
C190	a_416_118##5	a_323_392#	6.27555e-17
C191	VGND#2	X#3	1.8956e-19
C192	B#9	B#11	9.51e-19
C193	VGND#3	a_323_392##2	7.06166e-17
C194	a_397_320##6	a_74_294##5	1.34892e-17
C195	a_1218_388##5	a_1218_388##3	2.79188e-18
C196	VGND#6	a_74_294##9	2.12208e-18
C197	a_1155_284##4	C#2	2.07641e-18
C198	a_1218_388##18	C#2	3.18581e-19
C199	a_1218_388##17	a_416_118##5	8.63048e-18
C200	a_397_320##8	B#10	3.63593e-20
C201	VPWR#11	a_27_118##2	3.5304e-18
C202	a_397_320##6	a_416_118#	1.76147e-17
C203	B#9	a_397_320##7	2.24372e-17
C204	a_27_118##6	a_74_294##9	6.79557e-19
C205	a_1218_388##16	a_323_392#	4.43868e-18
C206	a_27_118##2	a_323_392##6	9.2341e-18
C207	a_27_118##3	a_74_294##11	2.17156e-17
C208	a_74_294##5	B#10	7.05259e-19
C209	a_416_118##5	a_1218_388##18	6.88019e-19
C210	a_27_118##5	a_397_320##6	1.66318e-20
C211	a_1218_388##17	a_323_392##2	3.3847e-18
C212	VPWR#11	A#6	3.18707e-18
C213	B#10	a_416_118#	1.4941e-17
C214	VGND#2	X#2	3.74812e-19
C215	a_323_392##6	a_397_320##6	1.96111e-17
C216	B#11	B#4	2.55442e-19
C217	a_323_392##2	a_323_392#	1.40344e-18
C218	a_416_118##5	C#4	4.85762e-18
C219	VGND#5	a_323_392##4	1.57834e-17
C220	A#1	B#9	8.11109e-18
C221	VGND#6	a_27_118##2	1.81851e-17
C222	a_416_118##6	a_1218_388##16	1.87591e-18
C223	B#10	a_27_118##5	1.90048e-17
C224	a_27_118##3	VGND#11	4.4508e-18
C225	a_416_118##6	a_323_392##2	5.95383e-17
C226	a_323_392##6	B#10	1.54637e-17
C227	A#6	a_74_294##9	5.02961e-17
C228	a_1218_388##19	VPWR#8	2.02221e-18
C229	C#1	C#6	2.23629e-18
C230	a_416_118##6	VGND#10	2.3181e-18
C231	a_74_294##5	B#5	6.82262e-20
C232	VPWR#3	VPWR#1	5.35972e-17
C233	a_27_118##5	a_397_320##5	2.93939e-17
C234	VPWR#3	a_1218_388##7	7.77708e-20
C235	C#2	a_1218_388##7	3.16213e-19
C236	a_416_118##5	C#2	7.68452e-18
C237	a_397_320##9	a_416_118##6	6.42978e-18
C238	a_1218_388##19	X#4	3.98959e-17
C239	a_1218_388##19	C#2	1.58615e-18
C240	a_74_294##3	A#1	1.36166e-17
C241	B#12	a_1155_284##2	2.51809e-21
C242	a_323_392##6	a_397_320##5	2.4929e-17
C243	a_416_118##6	a_74_294##4	7.36174e-20
C244	a_1218_388##19	VPWR#5	8.86219e-17
C245	a_27_118##5	B#5	1.3019e-18
C246	VPWR#3	a_1218_388##5	4.87757e-19
C247	B#8	a_397_320##7	4.81344e-18
C248	a_416_118##6	a_323_392##4	1.44986e-18
C249	VGND#3	VPWR#1	4.93889e-18
C250	a_1218_388##19	a_1155_284##5	3.54329e-17
C251	X#4	VPWR#3	3.85876e-17
C252	a_416_118##4	a_397_320##9	1.43492e-18
C253	a_323_392##6	B#5	3.93523e-17
C254	VPWR#3	VPWR#5	2.05595e-17
C255	a_1218_388##16	C#4	6.80572e-18
C256	B#11	a_397_320##3	1.05029e-17
C257	a_416_118##4	a_74_294##4	2.08583e-18
C258	a_27_118##5	A#3	1.8347e-19
C259	VGND#3	VPWR#8	3.01395e-18
C260	B#5	a_74_294##7	1.21606e-18
C261	VPWR#3	a_1155_284##5	4.17555e-17
C262	a_416_118##4	a_323_392##4	1.53712e-16
C263	VGND#3	X#4	2.53698e-18
C264	a_323_392##6	A#3	9.60406e-19
C265	VPWR#13	B#5	6.2216e-19
C266	VGND#6	a_416_118##5	9.96446e-18
C267	a_416_118##4	a_27_118#	3.7162e-17
C268	VPWR#3	a_323_392#	5.53922e-18
C269	VPWR#2	a_1218_388##5	1.5153e-20
C270	a_416_118##5	B#4	8.50934e-20
C271	VGND#3	VPWR#5	2.58388e-18
C272	VGND#6	a_1218_388##16	3.44636e-18
C273	A#3	a_74_294##7	2.17998e-17
C274	a_416_118##3	a_416_118##4	3.0479e-18
C275	VGND#3	a_1218_388##7	9.71762e-19
C276	a_1218_388##16	C#2	6.68625e-19
C277	a_1218_388##8	VGND#9	5.29959e-17
C278	VGND#6	a_323_392##2	5.31041e-17
C279	A#3	VPWR#13	2.25332e-17
C280	VPWR#11	a_323_392##4	1.41274e-18
C281	a_1155_284##4	a_1218_388##8	4.22315e-17
C282	VGND#6	VGND#10	1.02666e-17
C283	X#3	X#2	1.65739e-18
C284	B#9	B#8	1.51638e-18
C285	a_27_118##6	A#3	2.1591e-19
C286	VPWR#9	B#4	1.16717e-17
C287	VGND#3	a_1218_388##5	1.29072e-18
C288	VGND#6	a_397_320##9	1.34227e-17
C289	VPWR#13	a_74_294#	5.12626e-17
C290	VGND#6	a_74_294##4	6.88972e-18
C291	a_1218_388##17	a_1155_284##5	9.58832e-18
C292	a_1218_388##11	a_1218_388##9	4.76658e-17
C293	B#9	B#4	1.64508e-20
C294	VGND#6	a_323_392##4	1.15518e-16
C295	a_1218_388##17	a_323_392#	5.20704e-17
C296	a_323_392##2	C#4	1.51788e-18
C297	a_74_294#	a_27_118##6	2.44149e-17
C298	VGND#3	a_1218_388##3	3.76913e-20
C299	VPWR#8	VPWR#1	1.94092e-18
C300	VGND#6	a_27_118#	4.20655e-18
C301	B#12	a_1155_284#	1.17343e-19
C302	a_1218_388##17	a_1218_388##18	4.88072e-17
C303	VPWR#10	B#4	3.03842e-18
C304	VGND#3	a_1218_388##2	8.59141e-21
C305	VGND#6	a_416_118##3	6.13401e-17
C306	VGND#3	C#4	4.29709e-20
C307	VGND#6	a_74_294##11	4.53195e-18
C308	a_1218_388##13	a_1218_388##11	3.40167e-17
C309	a_1218_388##3	a_1218_388##2	3.59053e-18
C310	VGND#3	C#2	3.92609e-18
C311	a_416_118##6	a_1218_388##18	8.61467e-19
C312	VPWR#2	VPWR#1	7.0017e-19
C313	a_27_118##2	a_397_320##2	2.91629e-19
C314	B#12	B#4	1.81251e-19
C315	a_74_294##9	A#2	5.53315e-18
C316	VPWR#2	a_1218_388##3	4.42118e-20
C317	VGND#6	a_27_118##3	3.36428e-17
C318	a_416_118##5	a_1155_284##2	1.05035e-17
C319	a_416_118##6	a_416_118##7	3.99332e-18
C320	B#9	a_397_320##4	5.90853e-19
C321	a_1155_284##2	a_1218_388##16	7.45608e-18
C322	a_74_294##4	a_397_320##8	1.87664e-17
C323	a_416_118##6	VPWR#10	6.92225e-17
C324	VPWR#4	C#4	5.13369e-20
C325	a_323_392##2	a_1155_284##2	1.40159e-18
C326	a_1218_388##15	a_1218_388##13	4.79129e-17
C327	VGND#1	a_1218_388#	4.90723e-17
C328	VPWR#10	B#2	6.28318e-18
C329	a_397_320##9	a_74_294##5	1.87014e-19
C330	a_416_118##6	a_397_320##8	4.28641e-17
C331	VPWR#11	a_1155_284##5	1.1081e-17
C332	VPWR#9	B#2	6.20397e-20
C333	a_27_118##2	A#2	8.90135e-19
C334	a_416_118##6	a_74_294##5	2.73142e-17
C335	a_74_294##2	a_74_294##9	2.4856e-18
C336	VPWR#2	a_1218_388##9	2.39799e-18
C337	X#1	a_1218_388#	1.40132e-17
C338	a_397_320##8	B#4	2.1229e-17
C339	X#4	VPWR#8	1.00715e-16
C340	a_74_294##4	a_74_294##5	3.87458e-18
C341	VPWR#2	a_1218_388##2	4.36223e-20
C342	A#6	A#2	1.18945e-17
C343	VPWR#11	a_1218_388##18	7.19043e-18
C344	a_1218_388##16	B#2	2.73438e-19
C345	C#6	a_1218_388##15	8.55048e-18
C346	B#9	a_397_320##5	1.05733e-17
C347	VGND#1	a_1218_388##10	2.97776e-18
C348	a_1218_388##17	C#4	3.4695e-19
C349	a_323_392##2	B#4	1.02063e-18
C350	VPWR#11	a_416_118##7	1.55195e-17
C351	a_416_118##4	a_74_294##5	3.60109e-17
C352	VGND#3	a_1218_388#	4.01049e-18
C353	a_1218_388##19	C#1	1.0766e-18
C354	C	C#4	1.87241e-17
C355	VGND#4	a_1218_388#	6.64895e-19
C356	VPWR#4	C#2	1.44404e-19
C357	a_397_320##9	B#7	5.65708e-18
C358	a_1218_388##8	X#4	1.35708e-17
C359	C#5	a_1218_388##15	2.00961e-19
C360	a_1218_388##17	C#2	1.65991e-18
C361	VPWR#11	VPWR#10	1.66692e-17
C362	a_416_118##4	a_416_118#	2.192e-18
C363	B#9	B#5	1.92938e-19
C364	a_323_392##4	a_74_294##5	1.10396e-16
C365	VGND#3	a_1218_388##10	9.4557e-19
C366	VPWR#5	VPWR#8	1.95356e-18
C367	VGND#6	a_1218_388##18	2.06437e-18
C368	a_1218_388##8	VPWR#5	2.13082e-17
C369	VPWR#11	a_397_320##8	1.33662e-17
C370	X#1	a_1218_388##10	3.66215e-17
C371	B#12	B#2	9.01125e-18
C372	a_416_118##4	a_27_118##5	5.56518e-17
C373	C#5	C#6	4.68596e-18
C374	a_74_294##2	A#6	2.11078e-17
C375	a_1155_284##5	a_1218_388##8	2.43587e-17
C376	VGND#3	a_1218_388##12	2.90946e-19
C377	VPWR#3	C#1	4.60894e-20
C378	a_74_294##5	VPWR#11	1.46396e-16
C379	a_323_392##2	B#12	2.31381e-17
C380	VPWR#2	a_1218_388##11	5.52447e-18
C381	a_416_118##4	a_323_392##6	6.82081e-17
C382	VGND#1	a_1218_388##12	3.18252e-19
C383	a_74_294##5	B#8	2.67046e-19
C384	a_323_392#	a_1218_388##8	2.97702e-18
C385	VGND#6	VPWR#10	3.2783e-18
C386	a_397_320##8	B#2	7.35313e-18
C387	VGND#3	a_1218_388##14	8.45778e-18
C388	VGND#10	B#8	4.07579e-19
C389	a_397_320##9	a_397_320##2	8.11525e-18
C390	a_1218_388##10	VGND#4	1.60596e-17
C391	VPWR#5	X#4	6.0182e-17
C392	VPWR#11	a_27_118##5	4.74355e-18
C393	a_397_320##2	a_74_294##4	6.36784e-17
C394	VGND#3	C#1	1.16603e-17
C395	VGND#6	a_74_294##5	3.2534e-18
C396	a_1155_284##3	C#5	1.48944e-17
C397	X#1	a_1218_388##12	1.71051e-18
C398	a_323_392##4	a_397_320##2	1.35359e-16
C399	VPWR#11	a_323_392##6	2.41086e-17
C400	a_74_294##5	B#4	7.70915e-17
C401	a_1155_284##5	VPWR#9	2.45263e-17
C402	X#7	a_1218_388##10	1.34943e-18
C403	a_323_392##2	B#2	4.54939e-18
C404	a_416_118##6	C#4	3.66827e-19
C405	VPWR#11	VPWR#13	2.22346e-17
C406	VPWR#2	a_1218_388##13	3.60858e-18
C407	a_1218_388##12	VGND#4	2.0046e-17
C408	X#4	VPWR#2	5.71281e-18
C409	a_1155_284##2	a_1155_284##5	1.39545e-18
C410	B#6	a_1155_284##3	4.49551e-18
C411	VPWR#11	a_27_118##6	1.58626e-17
C412	VGND#9	a_1218_388##10	2.90636e-19
C413	a_323_392#	a_1155_284##2	1.57687e-19
C414	a_1155_284##2	a_1218_388##18	9.91238e-17
C415	X#7	a_1218_388##12	4.23931e-17
C416	a_1155_284##5	VPWR#5	7.77281e-17
C417	a_416_118##6	B#4	3.81238e-18
C418	a_1155_284##2	a_416_118##7	5.32474e-17
C419	a_323_392##6	a_323_392##4	1.04523e-18
C420	a_74_294##11	A#2	1.72626e-18
C421	a_397_320##9	B#12	1.70547e-17
C422	a_416_118##6	a_1155_284#	1.21468e-17
C423	VGND#4	a_1218_388##14	3.6369e-19
C424	VPWR#10	a_1155_284##2	6.59485e-18
C425	A#2	VGND#11	9.37638e-19
C426	a_397_320##9	B#8	1.77356e-18
C427	VGND#9	a_1218_388##12	1.3231e-18
C428	a_397_320##8	a_1155_284##2	6.60556e-19
C429	a_416_118##6	B#1	1.22235e-18
C430	a_27_118##3	A#2	2.60533e-18
C431	VPWR#2	a_1218_388##15	4.13407e-19
C432	VPWR#5	VPWR#2	3.51957e-20
C433	a_416_118##6	B#2	9.08784e-18
C434	X#7	a_1218_388##14	3.78272e-17
C435	a_74_294##5	a_397_320##4	1.36729e-20
C436	B#2	VGND#10	1.61296e-18
C437	B#7	VPWR#10	2.37177e-17
C438	B#10	a_397_320##6	2.64439e-17
C439	a_1155_284##4	a_1218_388##12	8.9204e-20
C440	a_1155_284##5	VPWR#4	7.18436e-17
C441	a_397_320##8	B#7	1.01982e-17
C442	VGND#4	C#1	2.21949e-19
C443	a_397_320##9	B#4	3.11841e-17
C444	a_27_118##3	a_74_294##2	4.64066e-17
C445	a_416_118##4	a_397_320#	4.83298e-19
C446	VPWR#3	a_1218_388##9	5.43773e-18
C447	a_323_392#	a_1155_284##5	1.26572e-16
C448	VPWR#4	C#6	2.29513e-18
C449	a_1218_388##14	VGND#9	2.07759e-17
C450	VGND#2	a_1218_388##5	1.12617e-20
C451	a_397_320##5	a_397_320##6	8.32858e-19
C452	a_74_294##5	a_397_320##3	5.76756e-19
C453	a_416_118##4	B#11	1.40713e-17
C454	VPWR#3	a_1218_388##11	4.11419e-18
C455	X#7	C#1	1.64542e-18
C456	a_416_118##4	B#8	7.39635e-19
C457	a_1218_388##19	a_1218_388##15	7.0512e-18
C458	a_397_320##5	B#10	1.67136e-17
C459	a_416_118##4	a_397_320##7	7.6011e-19
C460	VPWR#3	a_1218_388##13	2.53093e-18
C461	C#1	a_1218_388##8	3.47145e-17
C462	a_1155_284##4	a_1218_388##14	9.17473e-19
C463	a_416_118##4	B#4	6.0632e-19
C464	a_397_320##2	a_74_294##5	5.12201e-17
C465	a_1218_388##18	a_1155_284##5	3.61102e-17
C466	a_1218_388##19	C#6	1.98529e-18
C467	VGND#6	B#1	2.04268e-18
C468	B#5	B#10	2.83273e-18
C469	VPWR#3	a_1218_388##15	9.77891e-18
C470	a_74_294##9	B#9	4.23582e-19
C471	C#1	VGND#9	2.65488e-17
C472	a_74_294##4	B#8	1.58118e-18
C473	VGND#6	a_397_320#	1.62632e-18
C474	VPWR#3	C#6	7.82587e-18
C475	B#5	a_397_320##5	2.72529e-17
C476	VPWR#4	C#5	2.59912e-18
C477	VPWR#9	a_1155_284##3	1.72565e-18
C478	X#1	VGND#1	7.04433e-17
C479	a_27_118##2	B#11	6.36108e-19
C480	a_416_118##7	VPWR#9	1.19708e-17
C481	a_27_118##5	B#4	2.62935e-19
C482	a_1218_388##18	a_323_392#	5.974e-17
C483	a_416_118##4	a_397_320##4	4.4069e-18
C484	VGND#6	a_397_320##7	2.81129e-18
C485	a_1155_284##4	C#1	6.65652e-17
C486	A#3	a_397_320##5	9.98644e-20
C487	a_397_320##9	B#2	6.57733e-18
C488	VGND#3	C#6	9.58513e-19
C489	VGND#6	B#9	1.21755e-17
C490	a_416_118##4	a_397_320##3	2.17945e-17
C491	a_74_294##4	B#4	2.57703e-17
C492	X	a_1218_388##5	4.77024e-19
C493	A#3	B#5	3.97127e-17
C494	a_1155_284##2	C#7	2.70086e-19
C495	VGND#6	A#1	8.0657e-18
C496	X	a_1218_388##3	7.68884e-18
C497	X	a_1218_388##2	1.05595e-17
C498	C#4	C#2	2.25964e-18
C499	X#3	VPWR#8	7.02136e-18
C500	a_416_118##5	C#1	2.09078e-19
C501	a_74_294##9	B#4	1.65865e-17
C502	VGND#6	a_74_294##3	8.95072e-18
C503	a_1218_388##17	C#5	3.65281e-18
C504	a_323_392##2	a_1218_388##14	3.87026e-19
C505	VGND#4	VGND#1	2.42564e-18
C506	a_27_118##2	a_397_320##7	2.3801e-18
C507	a_1155_284##4	C#7	5.02627e-19
C508	VGND#2	a_1218_388##3	3.9159e-20
C509	a_74_294#	A#3	3.37769e-17
C510	VPWR#9	B#6	4.62573e-18
C511	VPWR#11	B#4	5.47601e-17
C512	X#2	VPWR#8	3.70819e-18
C513	VGND#5	C#4	1.92875e-20
C514	a_74_294##2	VPWR#13	3.13527e-17
C515	a_323_392##4	B#8	3.11192e-17
C516	a_416_118##6	a_1155_284##3	4.07778e-18
C517	a_416_118##5	C#7	4.75991e-17
C518	a_74_294##2	a_27_118##6	3.37777e-17
C519	VPWR#11	B#2	2.50825e-19
C520	a_323_392##2	C#1	3.75738e-18
C521	a_416_118##6	B#6	5.77756e-18
C522	VGND#4	X#1	6.31873e-17
C523	a_27_118##2	B#9	3.99245e-17
C524	A#6	a_397_320##7	9.50616e-21
C525	a_323_392##6	B#4	4.0346e-18
C526	a_397_320##2	B#1	1.76973e-19
C527	a_74_294##4	B#2	5.69835e-19
C528	C#7	a_1218_388##16	1.26112e-17
C529	a_397_320##2	a_397_320#	1.67216e-17
C530	a_1218_388##8	a_1218_388##13	1.52038e-19
C531	VGND#2	a_1218_388##2	7.40251e-20
C532	VPWR#11	a_1155_284##3	1.3782e-18
C533	a_323_392##4	B#4	1.88054e-17
C534	B#11	a_397_320##2	2.20118e-18
C535	X#3	a_1218_388##7	2.536e-19
C536	a_1218_388##8	a_1218_388##15	9.82473e-19
C537	a_416_118##5	a_1155_284#	2.6865e-17
C538	a_416_118##4	a_397_320##6	2.19167e-17
C539	a_397_320##8	VPWR#9	1.05539e-17
C540	a_397_320##7	a_397_320##2	2.71754e-19
C541	VPWR#11	B#6	2.26247e-18
C542	a_323_392##2	C#7	1.17606e-17
C543	a_416_118##4	B#10	2.0183e-17
C544	VPWR#11	a_397_320##6	1.30053e-18
C545	VPWR#10	a_416_118##7	5.66239e-17
C546	a_27_118##3	a_27_118##6	3.96725e-18
C547	a_27_118##2	A#1	1.36998e-18
C548	VGND#6	B#8	7.17699e-17
C549	a_416_118##4	a_397_320##5	1.57213e-18
C550	a_1155_284#	a_1218_388##16	2.16877e-17
C551	a_1218_388##19	VPWR#3	2.85951e-17
C552	a_1218_388##8	a_1218_388##7	2.01602e-17
C553	A#2	a_397_320##7	2.08259e-19
C554	VGND#6	B#4	3.3115e-18
C555	a_416_118##4	B#5	7.15205e-19
C556	A#2	B#9	1.69297e-18
C557	a_416_118##5	B#1	4.88691e-19
C558	a_1155_284##2	C#6	3.58562e-19
C559	a_27_118#	B#8	8.36831e-19
C560	a_1155_284#	a_323_392##2	2.31736e-17
C561	a_1218_388##8	a_1218_388##5	2.52764e-19
C562	VPWR#11	B#5	6.84944e-18
C563	a_74_294##3	A#2	3.11397e-18
C564	VGND#6	B#2	1.52174e-18
C565	VGND#6	a_397_320##5	3.62195e-20
C566	a_1155_284##2	C#5	1.99754e-18
C567	X#7	VGND#4	5.95497e-17
C568	VPWR#11	A#3	7.96798e-19
C569	a_74_294##5	VPWR#9	3.17437e-18
C570	VGND#5	B#8	4.40786e-18
C571	a_74_294##9	a_397_320##4	3.99379e-19
C572	a_323_392##6	a_397_320##4	7.30883e-19
C573	a_1155_284##2	a_1155_284##3	2.31576e-17
C574	VGND#6	a_397_320##4	4.67841e-19
C575	VGND#6	B#5	7.29404e-20
C576	a_1218_388##17	VPWR#3	1.75815e-17
C577	a_27_118##2	a_74_294##3	2.88565e-19
C578	VGND#10	a_1155_284#	4.3748e-19
C579	VPWR#11	a_74_294#	1.64937e-18
C580	B#6	a_1155_284##2	3.89394e-18
C581	VGND#6	a_397_320##3	1.46519e-18
C582	a_397_320##8	VPWR#10	8.39338e-17
C583	a_323_392##2	B#1	3.88091e-17
C584	a_323_392##6	a_397_320##3	2.96739e-19
C585	a_397_320##9	a_1155_284#	4.14245e-19
C586	C	a_416_118##5	2.42628e-17
C587	VGND#9	VGND#4	2.15693e-18
C588	C#2	a_1218_388##15	5.5039e-19
C589	C#2	a_1218_388##8	9.10806e-18
C590	a_1218_388##16	C	1.01117e-17
C591	X#3	a_1218_388##5	2.42781e-17
C592	a_416_118##6	a_1218_388##17	9.70435e-18
C593	a_323_392##4	a_397_320##4	1.07299e-19
C594	a_74_294##5	VPWR#10	2.20432e-18
C595	B#1	VGND#10	2.88775e-17
C596	VGND#5	B#4	1.33055e-20
C597	X	VPWR#2	1.67289e-17
C598	a_1218_388##19	a_1218_388##8	9.1086e-18
C599	a_323_392##2	a_397_320#	3.39414e-19
C600	a_1218_388##17	VPWR#11	1.01054e-17
C601	a_1218_388##8	VPWR#3	3.99989e-18
C602	B#1	a_397_320##9	1.54906e-17
C603	a_416_118##3	B#8	8.3016e-18
C604	VGND#9	X#7	6.42777e-17
C605	a_74_294##5	a_397_320##8	7.48294e-17
C606	a_416_118##6	VPWR#11	3.19793e-17
C607	X#3	X	3.72999e-18
C608	VGND#3	a_1218_388##8	1.37571e-17
C609	a_323_392##4	a_397_320##3	1.0959e-17
C610	A#2	a_397_320##5	2.58739e-18
C611	a_416_118##4	VPWR#11	4.34504e-17
C612	VGND#6	a_416_118##6	5.6938e-18
C613	a_74_294##4	B#1	6.32624e-19
C614	C	a_1155_284##5	6.53823e-19
C615	VGND#6	a_416_118##4	2.1785e-18
C616	a_323_392##2	B#11	1.00237e-19
C617	C	a_323_392#	5.75595e-17
C618	a_74_294##2	a_397_320##5	2.06727e-19
C619	a_1218_388##18	C	2.5027e-17
C620	a_416_118##3	B#4	1.6369e-19
C621	a_397_320##9	a_397_320#	3.91157e-19
C622	a_1218_388##17	a_1155_284##2	5.53735e-18
C623	a_323_392##4	B#1	1.22088e-19
C624	a_74_294##2	A#3	2.42733e-18
C625	C#2	C#6	7.27667e-19
C626	a_416_118##6	a_1155_284##2	1.00597e-16
C627	a_74_294##2	a_74_294#	5.08626e-18
C628	X#2	a_1218_388##5	9.47404e-20
C629	a_397_320#	a_74_294##4	1.32097e-17
C630	VGND#1	X	4.88073e-19
C631	B#7	a_416_118##6	2.75515e-17
C632	A	a_74_294##11	2.10917e-17
C633	X#3	a_1218_388##3	3.15706e-19
C634	VPWR#11	a_1155_284##2	1.34914e-17
C635	a_27_118##3	A	2.05529e-17
C636	VGND#6	a_1155_284##2	3.54431e-18
C637	a_397_320#	a_323_392##4	2.02673e-17
C638	a_1155_284##4	VGND#9	3.79168e-17
C639	a_416_118##4	a_397_320##2	1.27632e-17
C640	VGND#5	B#2	1.56115e-19
C641	VPWR#11	a_397_320##2	2.70096e-19
C642	VGND#6	a_397_320##2	5.25958e-18
C643	X	VPWR#1	8.54107e-17
C644	X	X#5	1.0392e-20
C645	a_27_118##2	a_27_118#	2.57195e-18
C646	a_27_118##3	a_74_294##9	3.36022e-18
C647	VPWR#8	X	8.40274e-17
C648	VPWR#11	a_74_294##2	4.84542e-18
C649	X#4	X	5.22567e-18
C650	B#7	a_1155_284##2	6.11888e-19
C651	B#11	a_323_392##4	2.12029e-17
C652	a_323_392##6	a_74_294##5	5.51219e-17
C653	VGND#6	a_74_294##2	4.62924e-18
C654	a_416_118##3	a_397_320#	7.81784e-19
C655	a_1155_284##2	C#4	1.60764e-17
C656	a_1218_388##7	VNB	2.36923e-17
C657	B#8	B#4	9.78473e-19
C658	a_1218_388##5	VNB	2.78658e-17
C659	a_1218_388##3	VNB	2.65525e-17
C660	a_1218_388##2	VNB	4.07374e-17
C661	C#4	VNB	4.58266e-17
C662	C#5	C#2	5.87647e-18
C663	C#2	VNB	6.67296e-17
C664	B#8	VNB	1.5621e-16
C665	B#4	VNB	3.11609e-16
C666	B#11	a_27_118#	2.06392e-17
C667	a_416_118##3	a_397_320##4	9.68093e-19
C668	B#2	VNB	4.45042e-17
C669	a_397_320##4	VNB	3.90817e-17
C670	a_397_320##3	VNB	3.24252e-17
C671	a_323_392##6	a_416_118#	7.96543e-19
C672	a_323_392##4	a_397_320##7	4.75922e-20
C673	a_27_118##2	a_416_118##3	8.66398e-17
C674	X#2	a_1218_388##3	1.28975e-17
C675	A	a_397_320##7	2.71604e-20
C676	A	B#9	3.94082e-19
C677	a_416_118##3	B#11	2.03117e-17
C678	A	A#1	6.65577e-18
C679	A	a_74_294##3	2.0987e-18
C680	a_74_294##2	A#2	3.79339e-17
C681	B#2	a_1155_284##2	6.87741e-18
C682	a_323_392##6	a_27_118##5	5.02414e-17
C683	a_27_118#	a_397_320##7	2.63303e-17
C684	a_416_118##3	a_397_320##3	3.03189e-19
C685	a_27_118##2	B#8	1.10782e-19
C686	a_323_392##4	B#9	8.21328e-19
C687	X	a_1218_388##9	3.46666e-17
C688	VPWR#3	C	9.91146e-19
C689	X	a_1218_388##11	3.30656e-17
C690	X	a_1218_388##13	2.56299e-18
C691	VGND#3	C	1.60323e-18
C692	a_397_320##7	a_416_118##3	1.72063e-17
C693	a_27_118##2	a_74_294##11	7.1826e-17
C694	a_323_392#	a_1218_388##14	4.93335e-20
C695	VPWR#9	VNB	7.77231e-17
C696	a_323_392##2	VGND#9	4.20095e-18
C697	a_1218_388##17	C	1.02747e-17
C698	VPWR#4	VNB	6.28947e-17
C699	VPWR#2	VNB	3.00788e-17
C700	VGND#5	VNB	8.17711e-17
C701	VGND#2	VNB	2.80877e-17
C702	a_1155_284##3	C#4	2.78518e-19
C703	X#2	a_1218_388##2	9.74504e-18
C704	X#3	VNB	5.38299e-19
C705	X#2	VNB	7.50636e-18
C706	a_27_118#	B#9	1.15935e-18
C707	B#12	VNB	2.67264e-18
C708	a_74_294##11	a_397_320##7	4.45516e-20
C709	a_74_294##9	VNB	2.19448e-17
C710	X#3	C#2	2.19842e-19
C711	a_27_118##2	B#4	1.65248e-19
C712	a_27_118##2	VNB	1.5277e-17
C713	a_74_294##11	a_397_320##4	9.63936e-20
C714	A#6	VNB	2.56575e-18
C715	VGND#1	VNB	6.89991e-17
C716	X#1	VNB	2.99649e-18
C717	a_323_392#	C#1	2.19862e-19
C718	VGND#4	VNB	5.396e-18
C719	a_1218_388##19	X	1.59283e-18
C720	X#7	VNB	2.04129e-18
C721	VGND#9	VNB	5.51159e-18
C722	a_1155_284##4	VNB	1.16209e-17
C723	VPWR#3	X	1.80165e-17
C724	B#9	a_416_118##3	2.97093e-17
C725	a_416_118##5	VNB	5.96699e-18
C726	a_1218_388##16	VNB	3.23414e-18
C727	a_323_392##2	VNB	4.17036e-17
C728	VGND#3	X	2.1856e-18
C729	VGND#10	VNB	3.32019e-18
C730	a_397_320##9	VNB	3.78531e-18
C731	VGND#6	A	5.54432e-18
C732	a_416_118##5	a_1218_388##16	9.12394e-17
C733	a_323_392##4	VNB	2.09716e-17
C734	a_323_392##2	a_1155_284##4	1.52621e-17
C735	a_27_118#	VNB	2.62818e-20
C736	a_416_118##3	VNB	1.61711e-17
C737	a_74_294##11	VNB	4.27934e-18
C738	a_27_118##3	VNB	6.2557e-17
C739	VPWR#1	VNB	8.00645e-17
C740	VPWR#8	VNB	4.015e-18
C741	X#4	VNB	2.77237e-18
C742	VPWR#5	VNB	4.71253e-18
C743	a_1155_284##5	VNB	3.13469e-17
C744	a_323_392#	VNB	1.38323e-17
C745	a_1218_388##18	VNB	2.71112e-18
C746	a_416_118##7	VNB	1.27256e-17
C747	VPWR#10	VNB	1.17104e-17
C748	a_397_320##8	VNB	9.97551e-18
C749	a_74_294##5	VNB	2.66132e-17
C750	a_27_118##5	VNB	1.12075e-18
C751	B#9	a_74_294##11	2.30882e-17
C752	A	A#2	6.2401e-18
C753	a_323_392##6	VNB	1.89864e-18
C754	VPWR#13	VNB	3.28412e-18
C755	a_27_118##6	VNB	5.37577e-17
C756	A	a_74_294##2	6.47814e-19
C757	a_1218_388#	VNB	2.73817e-17
C758	a_1218_388##10	VNB	2.81562e-17
C759	B#7	B#2	1.11967e-17
C760	a_1218_388##12	VNB	2.74262e-17
C761	a_323_392#	C#7	1.89723e-18
C762	a_1218_388##14	VNB	3.10956e-17
C763	C#1	VNB	6.88294e-17
C764	VPWR#4	VPWR#2	1.00971e-18
C765	C#7	VNB	3.23399e-17
C766	a_1155_284#	VNB	2.56857e-17
C767	B#1	VNB	3.00208e-17
C768	a_397_320#	VNB	2.61545e-17
C769	B#11	VNB	2.92339e-17
C770	a_397_320##7	VNB	2.40454e-17
C771	B#9	VNB	8.14165e-17
C772	A#6	a_74_294##11	1.16345e-17
C773	a_416_118##3	A#1	1.44006e-18
C774	A#1	VNB	2.81608e-17
C775	a_74_294##3	VNB	3.46127e-17
C776	a_1218_388##9	VNB	4.18106e-17
C777	a_1218_388##11	VNB	3.47038e-17
C778	a_1218_388##13	VNB	3.67798e-17
C779	a_1218_388##15	VNB	4.0113e-17
C780	C#6	VNB	5.06894e-17
C781	C#5	VNB	3.53701e-17
C782	a_1155_284##3	VNB	3.23324e-17
C783	a_323_392##2	a_416_118##5	1.16636e-16
C784	B#6	VNB	3.97508e-17
C785	a_397_320##6	VNB	2.65087e-17
C786	B#10	VNB	2.78743e-17
C787	a_397_320##5	VNB	3.92192e-17
C788	a_74_294##9	a_397_320##6	1.1445e-19
C789	B#5	VNB	7.47177e-17
C790	A#3	VNB	3.27269e-17
C791	a_74_294#	VNB	3.77021e-17
C792	a_1218_388##19	VNB	2.64998e-18
C793	a_27_118##3	a_27_118##2	1.21039e-18
C794	VPWR#3	VNB	2.03574e-16
C795	VGND#3	VNB	2.61574e-16
C796	a_1218_388##17	VNB	2.81491e-18
C797	a_416_118##6	VNB	1.6384e-17
C798	a_416_118##4	VNB	9.17553e-18
C799	VPWR#11	VNB	3.45095e-16
C800	A#1	a_74_294##11	1.35265e-17
C801	VGND#6	VNB	3.63561e-16
C802	a_1218_388##8	VNB	5.43155e-17
C803	a_323_392#	a_1155_284#	1.84536e-19
C804	a_1155_284##2	VNB	5.40753e-17
C805	B#7	VNB	5.45035e-18
C806	a_397_320##2	VNB	3.8951e-17
C807	A#2	VNB	3.96208e-17
C808	a_74_294##2	VNB	4.29156e-17
C809	a_27_118##3	B#9	5.23027e-19
C810	a_1218_388##19	VPWR#4	2.30011e-18
C811	C	VNB	5.9464e-19
C812	a_416_118##3	a_74_294##3	7.41097e-19
C813	A	VNB	1.50562e-18
C814	X	VNB	1.13992e-17
C815	A#1	VGND#11	1.68424e-17
C816	VPWR#12	B#4	2.51042e-18
C817	VPWR#12	B#5	1.50559e-17
C818	VPWR#12	A#2	6.47864e-20
C819	VPWR#12	VNB	6.97345e-17
C820	VGND#7	a_27_118##2	1.02887e-17
C821	VGND#7	a_74_294##2	3.99867e-19
C822	VGND#7	A#1	2.89232e-18
C823	VPWR#11	VPWR#12	1.28309e-16
C824	VGND#7	VGND#11	7.67459e-18
C825	VGND#7	B#8	7.8585e-19
C826	VGND#7	B#5	2.43782e-19
C827	VPWR#12	A#3	2.31575e-18
C828	VGND#7	A#2	5.89194e-19
C829	a_74_294##2	VPWR#12	5.63741e-19
C830	VGND#7	B#9	1.27917e-17
C831	VGND#6	VGND#7	1.51824e-16
C832	VGND#7	VNB	9.64169e-17
C833	a_74_294##9	VPWR#12	7.1995e-17
C834	VGND#7	a_397_320##5	1.10807e-19
C835	VGND#7	a_74_294##3	1.94303e-18
C836	VPWR#12	a_74_294#	4.10449e-18
C837	VGND#7	a_27_118##3	7.38816e-17
C838	a_27_118##6	VPWR#12	1.9028e-17
C839	VGND#7	a_416_118##3	3.00502e-18
*
*
.ENDS sky130_fd_sc_hs__xor3_4
*
