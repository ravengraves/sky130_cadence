* Extracted by Quantus, converted by sky130cad/quantus.py
*
*
*
*                       LINUX           Wed Nov 18 08:43:18 2026
*
*
*
*  PROGRAM  advgen
*
*  Name           : advgen - Quantus - (64-bit)
*  Version        : 25.1.0-p047
*  Build Date     : Thu Dec 11 23:20:30 PST 2025
*
*  HSPICE LIBRARY
*
*  OPERATING_TEMPERATURE 150
*  QRC_TECH_DIR <path>/tech
*
*
*

*
.SUBCKT sky130_fd_sc_hs__mux2_2 VPB VNB VGND VPWR X S A0 A1
*
*
*  caps2d version: 10
*
*
*       TRANSISTOR CARDS
*
*
XM12 a_38_74##2 A0#1 a_116_368##11 VNB sky130_fd_pr__nfet_01v8_lvt l=0.15 w=0.74 ad=0.2109 as=0.4255 pd=2.05 ps=2.63
XM13 a_116_368##11 A1#1 a_270_74# VNB sky130_fd_pr__nfet_01v8_lvt l=0.15 w=0.74 ad=0.4255 as=0.1776 pd=2.63 ps=1.96
XM7 a_270_74# S#3 VGND#4 VNB sky130_fd_pr__nfet_01v8_lvt l=0.15 w=0.74 ad=0.1776 as=0.4107 pd=1.96 ps=2.59
XM4 VGND#4 a_459_48##3 a_38_74# VNB sky130_fd_pr__nfet_01v8_lvt l=0.15 w=0.74 ad=0.4107 as=0.2183 pd=2.59 ps=2.07
XM8 a_459_48##8 S#7 VGND#5 VNB sky130_fd_pr__nfet_01v8_lvt l=0.15 w=0.55 ad=0.15675 as=0.27575 pd=1.67 ps=2.31
XM2 X#2 a_116_368##7 VGND#5 VNB sky130_fd_pr__nfet_01v8_lvt l=0.15 w=0.74 ad=0.2072 as=0.27575 pd=2.04 ps=2.31
XM3 VGND#1 a_116_368##5 X#2 VNB sky130_fd_pr__nfet_01v8_lvt l=0.15 w=0.74 ad=0.2627 as=0.2072 pd=2.19 ps=2.04
XM0 a_27_368##2 A0#4 a_116_368##10 VPB sky130_fd_pr__pfet_01v8 l=0.15 w=1 ad=0.295 as=0.3 pd=2.59 ps=2.6
XM9 a_116_368##10 A1#3 a_206_368##2 VPB sky130_fd_pr__pfet_01v8 l=0.15 w=1 ad=0.3 as=0.295 pd=2.6 ps=2.59
XM1 a_27_368# S#1 VPWR#7 VPB sky130_fd_pr__pfet_01v8 l=0.15 w=1 ad=0.295 as=0.4 pd=2.59 ps=2.8
XM11 VPWR#7 a_459_48# a_206_368# VPB sky130_fd_pr__pfet_01v8 l=0.15 w=1 ad=0.4 as=0.295 pd=2.8 ps=2.59
XM5 a_459_48##7 S#4 VPWR#6 VPB sky130_fd_pr__pfet_01v8 l=0.15 w=0.84 ad=0.2478 as=0.4172 pd=2.27 ps=3.03
XM6 X#7 a_116_368##4 VPWR#6 VPB sky130_fd_pr__pfet_01v8 l=0.15 w=1.12 ad=0.336 as=0.4172 pd=2.84 ps=3.03
XM10 VPWR#1 a_116_368# X#7 VPB sky130_fd_pr__pfet_01v8 l=0.15 w=1.12 ad=0.392 as=0.336 pd=2.94 ps=2.84
*
*
*       RESISTOR AND CAP/DIODE CARDS
*
Rg1	A0#1	A0#2	320.354431
Rg2	A0#2	A0#3	28.628225
Rg3	A0#2	A0#4	472.248596
Rg4	A1#1	A1#2	342.541748
Rg5	A1#2	A1#3	474.591675
Rg6	S#1	S#2	426.054413
Rg7	S#2	S#3	479.308075
Rg8	a_459_48#	a_459_48##2	381.775604
Rg9	a_459_48##2	a_459_48##3	498.092743
Rg10	a_459_48##2	a_459_48##4	39.496929
Rg11	S#4	S#5	465.887054
Rg12	S#5	S#6	68.002693
Rg13	S#5	S#7	325.822968
Rg14	a_116_368#	a_116_368##2	437.854187
Rg15	a_116_368##2	a_116_368##3	72.435509
Rg16	a_116_368##3	a_116_368##4	529.530212
Rg17	a_116_368##2	a_116_368##5	394.814545
Rg18	a_116_368##2	a_116_368##6	48.081161
Rg19	a_116_368##3	a_116_368##7	408.763916
Rf1	A0	A0#3	163.775864
Rf2	A1	A1#4	1.012718
Rf3	A1#5	A1#2	161.245514
Rf4	A1#4	A1#5	10.942473
Rf5	a_27_368#	a_27_368##2	145.509918
Rf6	a_38_74#	a_38_74##2	187.755630
Rf7	a_206_368#	a_206_368##2	133.734070
Rf8	S#6	S	250.421661
Rf9	S	S#2	171.255646
Rf10	a_459_48##4	a_459_48##6	204.097534
Rf11	a_459_48##6	a_459_48##7	24.338219
Rf12	a_459_48##6	a_459_48##8	82.452316
Rf13	X	X#1	2.068272
Rf14	X#1	X#3	2.068272
Rf15	X	X#4	2.068272
Rf16	X#1	X#4	7.049322
Rf17	X	X#5	2.068272
Rf18	X#4	X#5	7.049322
Rf19	X#6	X#8	2.019027
Rf20	X#5	X#6	6.763539
Rf21	X#2	X#3	15.000000
Rf22	X#7	X#8	15.000000
Rf23	a_116_368##6	a_116_368##9	465.018127
Rf24	a_116_368##9	a_116_368##10	49.322220
Rf25	a_116_368##9	a_116_368##11	103.723328
Rf26	VPWR#1	VPWR#2	92.526024
Rf27	VPWR#2	VPWR#3	102.240471
Rf28	VPWR#3	VPWR#4	29.195665
Rf30	VPWR#2	VPWR#6	31.473843
Rf31	VPWR#4	VPWR#7	31.948624
Rf32	VGND#1	VGND#2	100.091019
Rf33	VGND#2	VGND#3	69.443474
Rf34	VGND#3	VGND#4	151.314896
Rf35	VGND#2	VGND#5	29.449923
Rf36	VGND#3	VGND#6	32.605515
Re1	VPWR#3	VPWR	0.892922
Re2	VGND	VGND#6	0.892955
*
*       CAPACITOR CARDS
*
*
C1	a_116_368##2	VPWR#1	1.33786e-18
C2	a_116_368##11	a_116_368##9	2.02512e-18
C3	a_116_368##9	a_459_48##2	6.22151e-18
C4	VPWR#3	a_459_48##2	1.96533e-19
C5	VPWR#2	VPWR#1	1.18611e-18
C6	VGND#6	a_116_368##3	5.34921e-21
C7	a_459_48##8	a_459_48##6	2.83251e-18
C8	VGND#6	a_116_368##2	4.96017e-21
C9	VGND#6	a_459_48##2	1.93737e-19
C10	a_116_368##6	a_116_368##3	2.38114e-19
C11	a_116_368##6	a_116_368##2	2.95769e-17
C12	a_116_368##6	S#5	8.19618e-20
C13	a_116_368##9	a_459_48##7	3.45038e-18
C14	X#6	VPWR#6	5.64055e-19
C15	a_116_368##9	a_206_368#	9.02326e-17
C16	a_459_48##2	S#6	8.81388e-18
C17	a_116_368##9	VPWR#7	3.14148e-18
C18	VGND#5	VGND#1	9.84888e-18
C19	a_206_368#	a_459_48##2	1.4691e-18
C20	a_459_48##8	VGND#1	1.41218e-18
C21	a_116_368##9	a_27_368#	9.98172e-19
C22	a_459_48##4	S#5	1.12183e-18
C23	a_116_368##9	a_206_368##2	8.41132e-17
C24	a_459_48##4	a_459_48##2	2.16528e-17
C25	a_459_48##8	VGND#5	3.05181e-17
C26	a_116_368##11	A1#4	2.71301e-17
C27	VGND#2	a_116_368##5	2.76579e-18
C28	a_459_48##6	a_459_48##7	3.20486e-18
C29	VPWR#7	a_459_48##2	3.27297e-19
C30	VGND#3	a_116_368##7	3.52278e-19
C31	a_38_74##2	A1#4	2.04997e-18
C32	VGND#2	a_116_368##7	3.83426e-18
C33	S#2	a_459_48##2	4.64908e-17
C34	VGND#3	S#7	2.99987e-18
C35	VGND#4	a_459_48##8	2.09996e-18
C36	VGND#2	S#7	5.42151e-18
C37	a_38_74#	VGND#4	7.14443e-17
C38	VGND#3	a_459_48##3	3.21663e-18
C39	VGND#3	S#3	4.56321e-19
C40	a_38_74#	a_116_368##11	1.41786e-17
C41	a_116_368##11	VGND#4	3.78581e-17
C42	VGND#3	A1#1	2.62918e-19
C43	a_459_48##6	a_116_368##3	1.29543e-18
C44	a_116_368##9	a_459_48##3	5.98021e-20
C45	a_116_368##9	S#3	1.02656e-19
C46	a_459_48##6	S#5	1.28392e-17
C47	a_38_74##2	a_116_368##11	8.50797e-17
C48	a_459_48##6	a_459_48##2	1.36329e-18
C49	A1#4	a_116_368##10	1.58666e-17
C50	A1#4	a_27_368##2	2.03654e-18
C51	a_116_368##9	a_116_368#	3.31358e-19
C52	VPWR#6	VPWR#1	1.11806e-17
C53	VPWR#2	a_116_368##4	3.98464e-18
C54	VGND#1	a_116_368##5	2.81363e-17
C55	a_116_368##9	a_116_368##4	5.39645e-19
C56	a_116_368##5	X#2	1.5993e-17
C57	VPWR#2	S#4	4.54995e-18
C58	X#6	a_116_368#	8.61283e-18
C59	VGND#1	a_116_368##7	4.14656e-18
C60	VGND#5	a_116_368##5	5.0181e-18
C61	a_116_368##7	X#2	1.54945e-17
C62	a_206_368#	X#7	3.44838e-20
C63	a_116_368##9	S#4	1.90885e-18
C64	VGND#1	S#7	4.23675e-19
C65	a_459_48##8	a_116_368##5	1.96145e-19
C66	X#6	a_116_368##4	1.68418e-17
C67	VGND#5	a_116_368##7	3.32714e-17
C68	VGND#3	VGND#2	7.1114e-19
C69	S#5	a_116_368##7	5.33538e-18
C70	a_206_368#	VPWR#6	9.25343e-18
C71	a_459_48##8	a_116_368##7	1.72907e-18
C72	a_116_368##9	a_459_48#	2.03344e-17
C73	S#7	VGND#5	1.50542e-17
C74	X#6	S#4	5.13522e-18
C75	VPWR#7	VPWR#6	6.68458e-19
C76	a_38_74##2	a_116_368##10	1.32372e-19
C77	a_116_368##3	a_116_368##2	5.38987e-18
C78	a_459_48##8	S#7	3.72699e-17
C79	VGND#5	a_459_48##3	1.00991e-19
C80	a_116_368##9	S#1	1.90549e-17
C81	a_38_74##2	a_27_368##2	8.01667e-19
C82	a_38_74#	S#7	4.82862e-19
C83	a_459_48##6	a_116_368##4	9.79045e-19
C84	a_459_48##8	a_459_48##3	8.8037e-19
C85	a_206_368#	VPWR#7	7.41797e-17
C86	a_38_74#	a_459_48##3	4.11396e-17
C87	a_116_368##9	A1#3	1.35077e-18
C88	a_459_48##8	S#3	9.63642e-20
C89	a_459_48##6	S#4	1.87182e-17
C90	VGND#4	a_459_48##3	4.19444e-17
C91	a_38_74#	S#3	2.59829e-17
C92	a_27_368#	VPWR#7	3.75406e-17
C93	a_206_368##2	a_206_368#	1.38594e-18
C94	S#5	a_116_368##3	1.37934e-17
C95	a_116_368##9	A0#4	3.54286e-19
C96	VGND#4	S#3	3.84042e-17
C97	a_459_48##6	a_459_48#	1.25132e-18
C98	a_38_74#	A1#1	7.20673e-19
C99	a_116_368##11	a_459_48##3	1.69606e-18
C100	a_459_48##3	S#5	1.80893e-19
C101	a_206_368##2	a_27_368#	7.90507e-17
C102	VGND#4	A1#1	1.09736e-18
C103	a_38_74##2	a_459_48##3	5.20393e-19
C104	a_459_48##6	S#1	3.07175e-19
C105	a_116_368##11	S#3	9.824e-18
C106	a_38_74#	A0#1	5.53054e-19
C107	VPWR#3	VPWR#2	5.39064e-17
C108	a_116_368##10	a_27_368#	4.27063e-19
C109	VGND#6	VGND#3	2.58895e-17
C110	a_38_74##2	S#3	5.46782e-19
C111	a_116_368##11	A1#1	5.05894e-17
C112	VGND#6	VGND#2	4.7279e-17
C113	a_116_368##10	a_206_368##2	4.2434e-17
C114	a_27_368##2	a_27_368#	1.58266e-18
C115	a_116_368##9	VPWR#3	5.09264e-18
C116	a_38_74##2	A1#1	1.97134e-17
C117	A0#1	a_116_368##11	2.3812e-17
C118	a_27_368##2	a_206_368##2	9.25191e-19
C119	a_38_74##2	A0#1	4.65713e-17
C120	a_27_368##2	a_116_368##10	1.00838e-16
C121	a_116_368##6	VPWR#2	6.48552e-18
C122	VGND#3	S#6	3.23454e-17
C123	a_116_368##9	VPWR#2	2.92252e-18
C124	VGND#2	S#6	4.10369e-20
C125	a_116_368##9	a_116_368##6	8.75889e-19
C126	VPWR#2	S#6	1.7744e-19
C127	VPWR#1	a_116_368#	3.11811e-17
C128	X#6	a_116_368##6	9.45698e-17
C129	a_116_368##9	S#6	1.82864e-18
C130	a_116_368#	X#7	2.69139e-17
C131	a_116_368##7	a_116_368##5	4.16894e-17
C132	VPWR#1	a_116_368##4	5.22489e-18
C133	VPWR#6	a_116_368#	5.44122e-18
C134	a_116_368##4	X#7	2.61978e-17
C135	a_116_368##9	a_459_48##4	5.55814e-17
C136	a_459_48##2	S#5	2.50154e-18
C137	VPWR#6	a_116_368##4	4.71998e-17
C138	S#7	a_116_368##7	1.8362e-17
C139	a_459_48##6	a_116_368##6	3.01926e-17
C140	a_206_368#	a_116_368#	5.08153e-19
C141	S#4	VPWR#6	2.05852e-17
C142	a_206_368#	a_116_368##4	1.28249e-18
C143	a_116_368##9	S#2	1.05852e-16
C144	VGND#1	a_116_368##2	1.16138e-17
C145	S#4	a_459_48##7	2.26145e-17
C146	S#6	a_459_48##6	5.51454e-17
C147	a_459_48##3	S#7	2.13968e-18
C148	VPWR#7	a_116_368##4	3.00913e-19
C149	VPWR#6	a_459_48#	1.67947e-18
C150	a_206_368#	S#4	3.4003e-18
C151	VGND#6	VGND#1	2.84764e-17
C152	A1#2	a_116_368##9	4.42006e-17
C153	VPWR#6	S#1	2.42699e-19
C154	a_459_48##4	a_459_48##6	2.77758e-18
C155	a_206_368#	a_459_48#	6.58187e-17
C156	S#3	a_459_48##3	1.50678e-17
C157	a_116_368##3	X#2	1.96491e-19
C158	a_459_48#	VPWR#7	3.07416e-17
C159	a_116_368##6	VGND#1	3.67024e-17
C160	a_206_368#	S#1	1.07011e-17
C161	a_27_368#	a_459_48#	5.28591e-19
C162	a_116_368##9	A0#3	5.22105e-19
C163	S#2	a_459_48##6	3.2644e-19
C164	VGND#6	a_38_74#	7.79335e-17
C165	S#1	VPWR#7	3.20265e-17
C166	A1#1	S#3	4.61258e-17
C167	a_116_368##2	X#2	1.82201e-19
C168	a_206_368##2	a_459_48#	3.5004e-19
C169	VGND#6	VGND#4	1.54438e-18
C170	a_206_368#	A1#3	3.1652e-19
C171	a_27_368#	S#1	4.86103e-17
C172	a_116_368##10	a_459_48#	2.82547e-19
C173	a_206_368##2	S#1	1.536e-17
C174	VPWR#3	VPWR#1	2.97507e-17
C175	A0#1	A1#1	1.27658e-17
C176	a_27_368#	A1#3	9.20416e-18
C177	S#6	a_459_48##8	3.51571e-17
C178	a_116_368##10	S#1	6.43734e-19
C179	VGND#6	a_38_74##2	7.72204e-17
C180	a_206_368##2	A1#3	4.37031e-17
C181	a_27_368##2	S#1	3.22977e-19
C182	a_27_368#	A0#4	3.61196e-19
C183	VGND#4	S#6	1.90005e-17
C184	a_116_368##10	A1#3	5.92462e-17
C185	a_206_368##2	A0#4	1.80791e-18
C186	a_27_368##2	A1#3	9.98498e-18
C187	a_206_368#	VPWR#3	1.71141e-17
C188	a_116_368##6	VPWR#1	5.49101e-17
C189	A1#4	A1#2	5.27254e-18
C190	A0#4	a_116_368##10	1.93275e-17
C191	a_116_368##6	X#7	3.77993e-18
C192	a_27_368##2	A0#4	5.15942e-17
C193	a_116_368##6	VPWR#6	4.98874e-17
C194	a_38_74#	S#2	7.14051e-19
C195	A1#4	A0#3	5.13195e-17
C196	a_116_368##6	a_459_48##7	1.45152e-18
C197	VGND#4	S#2	6.26063e-17
C198	a_116_368##4	a_116_368#	4.99447e-17
C199	a_116_368##11	S#2	4.83784e-18
C200	a_459_48##8	a_116_368##3	1.1366e-19
C201	X	a_116_368##3	2.34444e-17
C202	X	a_116_368##2	1.73527e-17
C203	X	S#5	9.512e-18
C204	a_116_368##4	a_116_368##2	2.31808e-18
C205	A1#2	a_116_368##11	4.96885e-17
C206	S#4	a_116_368##4	2.81658e-17
C207	a_459_48##6	a_116_368##9	4.54416e-17
C208	a_459_48##4	a_206_368#	3.47765e-18
C209	a_38_74##2	A1#2	9.14681e-19
C210	a_459_48#	a_116_368##4	4.42394e-19
C211	a_116_368##11	A0#3	1.3462e-19
C212	a_459_48##8	S#5	8.75276e-18
C213	a_459_48#	S#4	3.78473e-18
C214	A0#3	a_38_74##2	4.7884e-17
C215	VGND#6	a_459_48##3	4.75765e-18
C216	S#2	a_27_368#	2.3028e-18
C217	VGND#6	S#3	4.80694e-18
C218	S#4	a_116_368##3	1.951e-18
C219	a_206_368##2	S#2	8.84293e-19
C220	S#1	a_459_48#	2.79908e-17
C221	VGND#6	A1#1	4.77586e-18
C222	a_27_368#	A1#2	8.83217e-19
C223	VGND#6	A0#1	4.77586e-18
C224	a_459_48##3	S#6	2.47049e-18
C225	a_206_368##2	A1#2	1.51747e-18
C226	A1#2	a_116_368##10	1.18191e-17
C227	A1#3	S#1	4.79879e-18
C228	a_459_48##2	S#4	1.65245e-18
C229	a_459_48##6	X#6	2.68757e-17
C230	a_116_368##6	a_116_368#	2.26198e-17
C231	S#2	a_459_48##3	1.3207e-17
C232	A0#4	A1#3	4.65948e-17
C233	A0#3	a_27_368##2	2.54966e-17
C234	VPWR#3	a_459_48#	2.32223e-18
C235	S#2	S#3	2.23225e-18
C236	a_116_368##6	a_116_368##4	1.04209e-17
C237	S#2	A1#1	2.61569e-19
C238	a_38_74#	a_270_74#	5.64211e-19
C239	a_116_368##6	S#4	3.37447e-17
C240	VGND#2	a_116_368##3	1.3393e-19
C241	a_38_74#	a_459_48##2	9.42098e-19
C242	VGND	a_116_368##2	1.66209e-19
C243	A1#2	S#3	5.78567e-18
C244	VGND	a_459_48##2	3.36594e-19
C245	A1#2	A1#1	1.75355e-18
C246	a_116_368##11	a_270_74#	3.07141e-18
C247	a_38_74##2	a_270_74#	5.50797e-20
C248	A0#3	A1#1	1.46833e-20
C249	VGND#3	a_459_48##2	4.38902e-19
C250	VGND#2	a_116_368##2	1.2419e-19
C251	VGND#2	VGND#1	8.62086e-19
C252	VGND#4	S#5	1.02271e-19
C253	A1#3	S#2	2.92471e-18
C254	VPWR#3	S#6	2.03443e-19
C255	VGND#2	S#5	4.13399e-20
C256	VGND#4	a_459_48##2	1.27376e-18
C257	a_116_368##3	VNB	2.42735e-17
C258	a_116_368##2	VNB	6.54476e-17
C259	S#5	VNB	2.84149e-17
C260	a_459_48##2	VNB	5.33015e-17
C261	VGND#2	X	4.57432e-18
C262	a_116_368##6	S#6	5.36991e-20
C263	VGND#3	VGND#5	2.11857e-18
C264	VGND#6	S#2	1.03607e-19
C265	S#3	a_270_74#	6.04798e-18
C266	A1#1	a_270_74#	1.1769e-17
C267	S#6	a_459_48##4	2.896e-17
C268	VGND#6	A1#2	2.20379e-19
C269	S#1	a_459_48##2	3.80529e-19
C270	a_459_48##6	X	4.94978e-17
C271	S#2	S#6	3.94619e-18
C272	VGND#6	A0#3	1.88375e-18
C273	VPWR	VPWR#2	3.68651e-17
C274	VGND#3	a_459_48##8	6.35184e-17
C275	S#2	a_459_48##4	4.03543e-17
C276	VPWR	a_116_368##9	2.10312e-17
C277	VPWR	X#6	7.5016e-18
C278	X	VGND#1	4.11328e-17
C279	X	X#2	2.52333e-18
C280	X	VGND#5	3.86057e-17
C281	A1#2	S#2	2.26439e-17
C282	a_459_48##8	X	4.50622e-17
C283	VPWR	a_459_48##6	4.76413e-18
C284	VPWR#2	a_116_368##3	6.30447e-20
C285	VGND#2	a_459_48##8	9.8556e-18
C286	VGND	VGND#3	2.90234e-17
C287	VGND	VGND#2	2.80724e-17
C288	A0#3	A1#2	3.12462e-17
C289	VPWR	A1#4	2.40075e-18
C290	a_38_74#	VGND#3	2.64383e-17
C291	VGND	a_116_368##9	1.1291e-18
C292	X	X#7	1.99651e-21
C293	X	VPWR#6	9.0953e-21
C294	VGND	a_459_48##6	2.04665e-18
C295	VPWR#2	a_116_368##2	5.08179e-20
C296	VPWR	VPWR#1	4.08363e-17
C297	VGND	A1#4	2.58142e-18
C298	VGND#3	VNB	3.89651e-17
C299	VPWR	VPWR#6	1.80454e-17
C300	X	a_116_368##5	1.77319e-17
C301	VGND#2	VNB	3.72201e-17
C302	VGND	VGND#1	4.07624e-17
C303	X	a_116_368##7	2.34908e-17
C304	VPWR#2	VNB	4.56313e-17
C305	VPWR	a_206_368#	1.59574e-17
C306	VGND	VGND#5	1.88077e-17
C307	X	S#7	4.62808e-18
C308	a_116_368##9	VNB	3.14987e-17
C309	VPWR	VPWR#7	1.77241e-17
C310	VGND	a_459_48##8	1.85819e-17
C311	VGND#3	VGND#4	1.5787e-19
C312	VGND	a_38_74#	3.81637e-17
C313	VPWR	a_27_368#	2.7485e-17
C314	VGND	VGND#4	1.31925e-17
C315	VPWR	a_206_368##2	1.1933e-17
C316	VPWR	a_116_368##10	7.76261e-18
C317	VGND	a_116_368##11	1.4697e-17
C318	VPWR	a_27_368##2	2.9573e-17
C319	VGND	a_38_74##2	3.65124e-17
C320	a_459_48##6	VNB	5.32866e-18
C321	X	a_116_368#	8.63423e-19
C322	X	a_116_368##4	3.84164e-18
C323	A1#4	VNB	2.32793e-18
C324	X	S#4	2.81579e-18
C325	VGND#1	VNB	6.89203e-17
C326	VPWR#2	S#5	2.01001e-20
C327	VGND#5	VNB	1.94278e-18
C328	a_459_48##8	VNB	8.92724e-18
C329	VGND	a_116_368##10	2.90053e-18
C330	a_38_74#	VNB	1.29539e-17
C331	VGND	a_27_368##2	3.20928e-18
C332	VGND#4	VNB	3.76027e-18
C333	VGND	a_116_368##5	4.79294e-18
C334	VPWR	a_116_368#	2.91571e-19
C335	a_116_368##11	VNB	4.45784e-18
C336	VGND	a_116_368##7	3.70486e-20
C337	VPWR	a_116_368##4	3.67191e-19
C338	a_38_74##2	VNB	4.24755e-17
C339	VGND	S#7	1.44466e-20
C340	VPWR#1	VNB	4.9933e-17
C341	VPWR	S#4	6.78566e-18
C342	VGND	a_459_48##3	1.83927e-18
C343	VPWR	a_459_48#	6.7599e-19
C344	VPWR#6	VNB	5.35532e-18
C345	VGND	S#3	1.45091e-18
C346	VGND	A1#1	3.69911e-18
C347	VPWR	S#1	2.3956e-18
C348	a_206_368#	VNB	4.66429e-18
C349	VGND	A0#1	2.48805e-18
C350	VPWR#7	VNB	3.90207e-18
C351	VPWR	A1#3	1.27156e-20
C352	a_27_368#	VNB	1.01279e-17
C353	X	a_116_368##6	5.50237e-17
C354	a_206_368##2	VNB	4.01198e-18
C355	a_116_368##10	VNB	3.47231e-18
C356	a_27_368##2	VNB	6.50436e-17
C357	a_116_368##5	VNB	3.07465e-17
C358	VPWR	VPWR#3	1.90764e-17
C359	a_116_368##7	VNB	2.5197e-17
C360	S#7	VNB	3.16215e-17
C361	a_459_48##3	VNB	4.17425e-17
C362	VPWR	a_116_368##6	1.89693e-17
C363	S#3	VNB	3.56282e-17
C364	A1#1	VNB	2.88393e-17
C365	A0#1	VNB	3.67079e-17
C366	VPWR	a_459_48##4	2.22237e-18
C367	a_116_368#	VNB	3.26097e-17
C368	VPWR	S#2	4.32149e-18
C369	a_116_368##4	VNB	3.22142e-17
C370	VGND	VGND#6	6.43462e-17
C371	S#4	VNB	4.45634e-17
C372	VPWR	A1#2	2.08569e-18
C373	VGND	a_116_368##6	4.15655e-18
C374	a_459_48#	VNB	3.75636e-17
C375	VPWR	A0#3	4.101e-18
C376	S#1	VNB	3.87763e-17
C377	VGND	S#6	7.42917e-18
C378	A1#3	VNB	4.04103e-17
C379	VGND	a_459_48##4	2.69928e-18
C380	A0#4	VNB	4.63344e-17
C381	VGND	S#2	5.55919e-18
C382	VPWR#3	VNB	2.45047e-16
C383	VGND	A1#2	2.75703e-18
C384	VGND#6	VNB	3.19643e-16
C385	VGND	A0#3	5.28632e-18
C386	a_116_368##6	VNB	4.9915e-17
C387	S#6	VNB	7.30364e-17
C388	a_116_368##11	VGND#3	1.52343e-18
C389	a_459_48##4	VNB	7.54354e-18
C390	S#2	VNB	5.31728e-17
C391	A1#2	VNB	4.76685e-17
C392	A0#3	VNB	8.71887e-17
C393	a_38_74#	a_116_368##9	8.6972e-19
C394	VGND	X	1.55047e-17
C395	X	VNB	8.17204e-18
C396	VPWR	VNB	7.58486e-17
C397	VGND	VNB	8.09336e-17
C398	VPWR#4	VNB	8.6242e-17
C399	VPWR	VPWR#4	5.35694e-17
C400	A0#3	VPWR#4	7.58904e-19
C401	VPWR#4	A1#2	2.14464e-19
C402	VPWR#4	S#2	4.76304e-20
C403	VPWR#3	VPWR#4	1.03125e-16
C404	VPWR#4	VPWR#2	2.50274e-19
C405	VPWR#4	A0#4	3.19421e-18
C406	VPWR#4	A1#3	3.18356e-18
C407	VPWR#4	S#1	4.15315e-18
C408	VPWR#4	a_459_48#	1.95589e-19
C409	a_27_368##2	VPWR#4	7.13247e-17
C410	a_206_368##2	VPWR#4	8.22553e-19
C411	a_27_368#	VPWR#4	6.84761e-17
C412	a_206_368#	VPWR#4	1.1256e-19
*
*
.ENDS sky130_fd_sc_hs__mux2_2
*
