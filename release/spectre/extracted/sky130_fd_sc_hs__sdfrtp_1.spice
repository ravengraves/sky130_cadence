* Extracted by Quantus, converted by sky130cad/quantus.py
*
*
*
*                       LINUX           Wed Nov 18 09:09:38 2026
*
*
*
*  PROGRAM  advgen
*
*  Name           : advgen - Quantus - (64-bit)
*  Version        : 25.1.0-p047
*  Build Date     : Thu Dec 11 23:20:30 PST 2025
*
*  HSPICE LIBRARY
*
*  OPERATING_TEMPERATURE 150
*  QRC_TECH_DIR <path>/tech
*
*
*

*
.SUBCKT sky130_fd_sc_hs__sdfrtp_1 VNB VPB VGND RESET_B VPWR Q D CLK SCE SCD
*
*
*  caps2d version: 10
*
*
*       TRANSISTOR CARDS
*
*
XM36 a_27_88##8 SCE#4 VGND#18 VNB sky130_fd_pr__nfet_01v8_lvt l=0.15 w=0.42 ad=0.1197 as=0.1197 pd=1.41 ps=1.41
XM2 a_225_81##2 a_27_88# a_312_81# VNB sky130_fd_pr__nfet_01v8_lvt l=0.15 w=0.42 ad=0.1197 as=0.1008 pd=1.41 ps=1.32
XM39 a_312_81# D#3 a_300_464##8 VNB sky130_fd_pr__nfet_01v8_lvt l=0.15 w=0.42 ad=0.1008 as=0.2625 pd=1.32 ps=2.09
XM24 a_300_464##8 SCE#6 a_545_81# VNB sky130_fd_pr__nfet_01v8_lvt l=0.15 w=0.42 ad=0.2625 as=0.1008 pd=2.09 ps=1.32
XM15 a_545_81# SCD#1 a_225_81# VNB sky130_fd_pr__nfet_01v8_lvt l=0.15 w=0.42 ad=0.1008 as=0.1953 pd=1.32 ps=1.77
XM3 a_225_81# RESET_B#1 VGND#17 VNB sky130_fd_pr__nfet_01v8_lvt l=0.15 w=0.42 ad=0.1953 as=0.1197 pd=1.77 ps=1.41
XM6 a_855_368##14 CLK#1 VGND#16 VNB sky130_fd_pr__nfet_01v8_lvt l=0.15 w=0.74 ad=0.2109 as=0.2109 pd=2.05 ps=2.05
XM20 VGND#16 a_855_368##10 a_1034_368##11 VNB sky130_fd_pr__nfet_01v8_lvt l=0.15 w=0.74 ad=0.2109 as=0.2109 pd=2.05 ps=2.05
XM18 a_300_464# a_855_368##9 a_1233_118##7 VNB sky130_fd_pr__nfet_01v8_lvt l=0.15 w=0.42 ad=0.1197 as=0.1176 pd=1.41 ps=1.4
XM0 a_1233_118##7 a_1034_368# a_1319_118# VNB sky130_fd_pr__nfet_01v8_lvt l=0.15 w=0.42 ad=0.1176 as=0.1008 pd=1.4 ps=1.32
XM22 a_1319_118# a_1367_92##3 a_1397_118# VNB sky130_fd_pr__nfet_01v8_lvt l=0.15 w=0.42 ad=0.1008 as=0.1008 pd=1.32 ps=1.32
XM14 a_1397_118# RESET_B#7 VGND#15 VNB sky130_fd_pr__nfet_01v8_lvt l=0.15 w=0.42 ad=0.1008 as=0.5314 pd=1.32 ps=3.2
XM34 VGND#15 a_1233_118##3 a_1367_92##7 VNB sky130_fd_pr__nfet_01v8_lvt l=0.15 w=0.64 ad=0.5314 as=0.1792 pd=3.2 ps=1.84
XM4 a_1367_92##7 a_1034_368##4 a_1745_74##10 VNB sky130_fd_pr__nfet_01v8_lvt l=0.15 w=0.64 ad=0.1792 as=0.4687 pd=1.84 ps=3.25
XM8 a_1745_74##10 a_855_368##8 a_1972_74# VNB sky130_fd_pr__nfet_01v8_lvt l=0.15 w=0.42 ad=0.4687 as=0.0882 pd=3.25 ps=1.26
XM1 a_1972_74# a_1997_272# VGND#14 VNB sky130_fd_pr__nfet_01v8_lvt l=0.15 w=0.42 ad=0.0882 as=0.1281 pd=1.26 ps=1.45
XM23 VGND#14 RESET_B#11 a_2135_74# VNB sky130_fd_pr__nfet_01v8_lvt l=0.15 w=0.42 ad=0.1281 as=0.0882 pd=1.45 ps=1.26
XM26 a_2135_74# a_1745_74##3 a_1997_272##4 VNB sky130_fd_pr__nfet_01v8_lvt l=0.15 w=0.42 ad=0.0882 as=0.1197 pd=1.26 ps=1.41
XM17 VGND#13 a_1745_74# a_2399_424##8 VNB sky130_fd_pr__nfet_01v8_lvt l=0.15 w=0.55 ad=0.1595 as=0.15675 pd=1.68 ps=1.67
XM11 VGND#12 a_2399_424# Q#3 VNB sky130_fd_pr__nfet_01v8_lvt l=0.15 w=0.74 ad=0.2109 as=0.2109 pd=2.05 ps=2.05
XM32 a_27_88##9 SCE#5 VPWR#18 VPB sky130_fd_pr__pfet_01v8 l=0.15 w=0.64 ad=0.1888 as=0.224 pd=1.87 ps=1.98
XM5 VPWR#18 SCE#1 a_216_464# VPB sky130_fd_pr__pfet_01v8 l=0.15 w=0.64 ad=0.224 as=0.1728 pd=1.98 ps=1.82
XM29 a_216_464# D#1 a_300_464##6 VPB sky130_fd_pr__pfet_01v8 l=0.15 w=0.64 ad=0.1728 as=0.6656 pd=1.82 ps=3.36
XM9 a_300_464##6 a_27_88##3 a_538_464# VPB sky130_fd_pr__pfet_01v8 l=0.15 w=0.64 ad=0.6656 as=0.1728 pd=3.36 ps=1.82
XM16 a_538_464# SCD#3 VPWR#16 VPB sky130_fd_pr__pfet_01v8 l=0.15 w=0.64 ad=0.1728 as=0.2688 pd=1.82 ps=2.12
XM38 VPWR#16 RESET_B#3 a_300_464##7 VPB sky130_fd_pr__pfet_01v8 l=0.15 w=0.64 ad=0.2688 as=0.1888 pd=2.12 ps=1.87
XM25 a_855_368##13 CLK#4 VPWR#15 VPB sky130_fd_pr__pfet_01v8 l=0.15 w=1.12 ad=0.3304 as=0.336 pd=2.83 ps=2.84
XM30 VPWR#15 a_855_368##6 a_1034_368##13 VPB sky130_fd_pr__pfet_01v8 l=0.15 w=1.12 ad=0.336 as=0.3304 pd=2.84 ps=2.83
XM27 a_300_464##2 a_1034_368##3 a_1233_118##9 VPB sky130_fd_pr__pfet_01v8 l=0.15 w=0.42 ad=0.1239 as=0.1526 pd=1.43 ps=1.59
XM19 a_1233_118##9 a_855_368# a_1343_461# VPB sky130_fd_pr__pfet_01v8 l=0.15 w=0.42 ad=0.1526 as=0.1134 pd=1.59 ps=1.38
XM12 a_1343_461# a_1367_92# VPWR#14 VPB sky130_fd_pr__pfet_01v8 l=0.15 w=0.42 ad=0.1134 as=0.271775 pd=1.38 ps=2.28
XM35 VPWR#14 RESET_B#8 a_1233_118##8 VPB sky130_fd_pr__pfet_01v8 l=0.15 w=0.42 ad=0.271775 as=0.1239 pd=2.28 ps=1.43
XM21 VPWR#13 a_1233_118# a_1367_92##4 VPB sky130_fd_pr__pfet_01v8 l=0.15 w=1 ad=0.295 as=0.3 pd=2.59 ps=2.6
XM7 a_1367_92##4 a_855_368##7 a_1745_74##9 VPB sky130_fd_pr__pfet_01v8 l=0.15 w=1 ad=0.3 as=0.442975 pd=2.6 ps=3.64
XM33 a_1745_74##9 a_1034_368##6 a_1993_508# VPB sky130_fd_pr__pfet_01v8 l=0.15 w=0.42 ad=0.442975 as=0.1134 pd=3.64 ps=1.38
XM28 a_1993_508# a_1997_272##3 VPWR#12 VPB sky130_fd_pr__pfet_01v8 l=0.15 w=0.42 ad=0.1134 as=0.1785 pd=1.38 ps=1.69
XM13 VPWR#12 RESET_B#9 a_1997_272##7 VPB sky130_fd_pr__pfet_01v8 l=0.15 w=0.42 ad=0.1785 as=0.126 pd=1.69 ps=1.44
XM31 a_1997_272##7 a_1745_74##5 VPWR#11 VPB sky130_fd_pr__pfet_01v8 l=0.15 w=0.42 ad=0.126 as=0.3276 pd=1.44 ps=2.55
XM10 VPWR#11 a_1745_74##6 a_2399_424##7 VPB sky130_fd_pr__pfet_01v8 l=0.15 w=0.84 ad=0.3276 as=0.2478 pd=2.55 ps=2.27
XM37 VPWR#10 a_2399_424##4 Q#1 VPB sky130_fd_pr__pfet_01v8 l=0.15 w=1.12 ad=0.3304 as=0.3304 pd=2.83 ps=2.83
*
*
*       RESISTOR AND CAP/DIODE CARDS
*
Rg1	SCE#1	SCE#2	464.907227
Rg2	SCE#2	SCE#3	38.488544
Rg3	SCE#3	SCE#4	592.435059
Rg4	SCE#3	SCE#5	508.461609
Rg5	a_27_88#	a_27_88##2	268.456512
Rg6	D#1	D#2	836.053162
Rg7	D#2	D#3	216.119781
Rg8	a_27_88##3	a_27_88##4	328.563354
Rg9	SCE#6	SCE#7	402.624939
Rg10	SCD#1	SCD#2	551.807007
Rg11	SCD#2	SCD#3	368.945282
Rg12	RESET_B#1	RESET_B#2	815.586304
Rg13	RESET_B#2	RESET_B#3	375.332092
Rg14	RESET_B#2	RESET_B#4	50.284184
Rg15	CLK#1	CLK#2	345.498596
Rg16	CLK#2	CLK#3	49.299824
Rg17	CLK#2	CLK#4	489.338104
Rg18	a_1034_368#	a_1034_368##2	653.108765
Rg19	a_1034_368##2	a_1034_368##3	346.627197
Rg20	a_1367_92#	a_1367_92##2	373.501709
Rg21	a_1367_92##2	a_1367_92##3	472.124023
Rg22	RESET_B#5	RESET_B#6	44.394718
Rg23	RESET_B#6	RESET_B#7	734.643311
Rg24	RESET_B#6	RESET_B#8	248.803528
Rg25	a_1233_118#	a_1233_118##2	598.022339
Rg26	a_1233_118##2	a_1233_118##3	358.503784
Rg27	a_1034_368##4	a_1034_368##5	658.234131
Rg28	a_855_368#	a_855_368##2	288.269775
Rg29	a_855_368##2	a_855_368##3	1561.330444
Rg30	a_855_368##3	a_855_368##4	191.540756
Rg31	a_855_368##4	a_855_368##5	39.736492
Rg32	a_855_368##5	a_855_368##6	456.846832
Rg33	a_855_368##2	a_855_368##7	1841.322388
Rg34	a_855_368##7	a_855_368##8	1135.156616
Rg35	a_855_368##3	a_855_368##9	464.600281
Rg36	a_855_368##4	a_855_368##10	269.511658
Rg37	a_1034_368##6	a_1034_368##7	233.205399
Rg38	a_1997_272#	a_1997_272##2	516.543396
Rg39	a_1997_272##2	a_1997_272##3	544.431396
Rg40	RESET_B#9	RESET_B#10	351.674164
Rg41	RESET_B#10	RESET_B#11	762.789551
Rg42	a_1745_74#	a_1745_74##2	656.039490
Rg43	a_1745_74##2	a_1745_74##3	319.064575
Rg44	a_1745_74##2	a_1745_74##4	355.077576
Rg45	a_1745_74##4	a_1745_74##5	393.906769
Rg46	a_1745_74##4	a_1745_74##6	580.994019
Rg47	a_2399_424#	a_2399_424##2	368.862610
Rg48	a_2399_424##2	a_2399_424##3	52.252907
Rg49	a_2399_424##2	a_2399_424##4	471.862823
Rf1	D	D#4	2.165378
Rf2	D#5	D#2	162.398178
Rf3	D#4	D#5	7.380112
Rf4	a_27_88##4	a_27_88##6	215.371552
Rf5	a_27_88##6	a_27_88##7	65.337128
Rf6	a_27_88##7	a_27_88##8	41.554085
Rf7	a_27_88##6	a_27_88##9	29.754587
Rf8	a_27_88##7	a_27_88##2	208.051071
Rf9	SCE#7	SCE	216.988861
Rf10	SCE	SCE#9	15.471772
Rf11	SCE#9	SCE	2.641522
Rf12	SCD	SCD#4	10.235490
Rf13	SCD#4	SCD	4.330400
Rf14	a_225_81#	a_225_81##2	177.920792
Rf15	RESET_B#4	RESET_B#13	160.920990
Rf16	RESET_B#14	RESET_B#15	0.688184
Rf17	RESET_B#13	RESET_B#14	5.117745
Rf18	CLK#3	CLK	88.417366
Rf19	a_855_368##5	a_855_368##12	165.567062
Rf20	a_855_368##12	a_855_368##13	70.404984
Rf21	a_855_368##12	a_855_368##14	84.878418
Rf22	a_300_464#	a_300_464##3	190.087311
Rf23	a_300_464##3	a_300_464##4	152.307022
Rf24	a_300_464##4	a_300_464##5	19.861990
Rf25	a_300_464##5	a_300_464##6	92.532890
Rf26	a_300_464##4	a_300_464##7	12.441607
Rf27	a_300_464##5	a_300_464##8	194.615997
Rf28	a_300_464##2	a_300_464##3	15.000000
Rf29	RESET_B#16	RESET_B#17	10.860382
Rf30	RESET_B#5	RESET_B#19	161.315399
Rf31	RESET_B#16	RESET_B#19	3.104646
Rf32	a_1233_118##2	a_1233_118##5	243.989868
Rf33	a_1233_118##5	a_1233_118##6	59.125999
Rf34	a_1233_118##6	a_1233_118##7	143.129684
Rf35	a_1233_118##5	a_1233_118##8	32.250862
Rf36	a_1233_118##6	a_1233_118##9	30.244545
Rf37	a_1367_92##4	a_1367_92##5	103.218613
Rf38	a_1367_92##5	a_1367_92##2	277.353149
Rf39	a_1367_92##5	a_1367_92##7	18.755672
Rf40	a_1034_368##7	a_1034_368##5	263.657227
Rf41	a_1034_368##5	a_1034_368##10	350.731659
Rf42	a_1034_368##10	a_1034_368##11	11.321297
Rf43	a_1034_368##10	a_1034_368##12	42.950062
Rf44	a_1034_368##12	a_1034_368##13	23.776016
Rf45	a_1034_368##12	a_1034_368##2	183.519806
Rf46	RESET_B	RESET_B#10	171.978958
Rf47	a_1745_74##2	a_1745_74##8	268.501831
Rf48	a_1745_74##8	a_1745_74##9	178.446320
Rf49	a_1745_74##8	a_1745_74##10	56.143372
Rf50	a_1997_272##4	a_1997_272##5	124.974739
Rf51	a_1997_272##5	a_1997_272##2	238.297241
Rf52	a_1997_272##5	a_1997_272##7	93.983185
Rf53	a_2399_424##3	a_2399_424##6	89.584229
Rf54	a_2399_424##6	a_2399_424##7	61.297485
Rf55	a_2399_424##6	a_2399_424##8	57.043766
Rf56	Q	Q#2	0.251111
Rf57	Q#2	Q	18.331110
Rf58	Q	Q#4	7.282945
Rf59	Q#4	Q	7.282945
Rf60	Q#1	Q#2	5.000000
Rf61	Q#3	Q#4	7.500000
Rf63	VPWR#2	VPWR#3	77.384460
Rf64	VPWR#3	VPWR#4	75.615547
Rf65	VPWR#4	VPWR#5	38.749577
Rf66	VPWR#5	VPWR#6	117.709343
Rf67	VPWR#6	VPWR#7	80.243538
Rf68	VPWR#7	VPWR#8	182.756897
Rf69	VPWR#8	VPWR#9	110.281715
Rf70	VPWR#2	VPWR#10	38.286041
Rf71	VPWR#3	VPWR#11	35.274624
Rf72	VPWR#4	VPWR#12	40.352859
Rf73	VPWR#6	VPWR#13	78.767654
Rf74	VPWR#7	VPWR#14	31.319780
Rf75	VPWR#8	VPWR#15	31.948624
Rf76	VPWR#9	VPWR#16	36.430706
Rf77	VPWR#9	VPWR#17	190.381577
Rf78	VPWR#17	VPWR#18	31.337896
Rf81	VGND#2	VGND#3	69.585991
Rf82	VGND#3	VGND#4	100.575104
Rf83	VGND#4	VGND#5	20.429605
Rf84	VGND#5	VGND#6	181.505951
Rf85	VGND#6	VGND#7	201.262390
Rf86	VGND#7	VGND#8	70.989845
Rf87	VGND#8	VGND#9	37.353798
Rf88	VGND#9	VGND#10	193.559280
Rf90	VGND#2	VGND#12	41.038895
Rf91	VGND#3	VGND#13	31.125740
Rf92	VGND#4	VGND#14	34.507496
Rf93	VGND#6	VGND#15	24.468842
Rf94	VGND#7	VGND#16	38.817978
Rf95	VGND#8	VGND#17	51.146652
Rf96	VGND#10	VGND#18	37.263206
Rf101	SCE#2	SCE#9	80.116402
Rf102	SCD#2	SCD#4	80.116402
Re2	RESET_B	RESET_B#17	4.743838
Re3	RESET_B#17	RESET_B#15	16.168276
Re4	VPWR#5	VPWR	1.989084
Re5	VPWR	VPWR#9	1.989084
Re6	VGND#5	VGND	1.989084
Re7	VGND	VGND#9	1.989084
*
*       CAPACITOR CARDS
*
*
C1	VGND#5	a_2399_424##8	1.68539e-17
C2	a_1034_368#	a_1367_92##3	4.24591e-17
C3	VPWR#5	a_855_368##7	1.18162e-17
C4	a_1233_118##7	a_855_368##9	2.3018e-17
C5	a_1233_118##9	a_855_368##2	3.56397e-18
C6	a_1233_118##6	a_855_368##2	3.88312e-18
C7	a_1233_118##8	RESET_B#8	2.82766e-17
C8	a_1745_74##4	a_2399_424##4	2.86761e-19
C9	VGND#9	a_27_88##7	1.58859e-18
C10	a_1233_118##5	a_1367_92#	2.96957e-18
C11	VGND#8	RESET_B#4	1.09653e-20
C12	RESET_B#17	a_1745_74##10	1.74222e-18
C13	CLK#2	a_855_368##4	3.7092e-17
C14	a_300_464##2	a_855_368##4	4.34414e-19
C15	a_1367_92##5	a_1034_368##5	1.74918e-16
C16	a_1034_368##11	a_1034_368#	1.11402e-17
C17	a_1367_92##2	a_1034_368##4	3.91053e-19
C18	VPWR#5	a_1233_118#	3.81587e-18
C19	a_27_88##3	SCD#3	3.54622e-17
C20	SCD#2	VPWR#16	1.00284e-18
C21	VPWR#13	a_1367_92#	2.41735e-19
C22	VGND#5	a_855_368##7	4.4021e-20
C23	a_300_464##2	a_1034_368##13	6.54925e-17
C24	a_1367_92##2	a_1233_118##3	1.51774e-19
C25	VGND#4	a_1745_74#	7.60611e-20
C26	a_27_88##7	a_27_88##6	2.15541e-18
C27	a_300_464#	a_855_368##9	1.81386e-17
C28	RESET_B#17	a_1367_92##7	9.31467e-22
C29	RESET_B#8	VPWR#14	1.7927e-17
C30	RESET_B#17	a_1367_92#	2.04767e-18
C31	a_1367_92##5	RESET_B#7	6.26587e-18
C32	VGND#5	a_1997_272##4	2.35821e-17
C33	a_2399_424##7	a_1745_74#	1.35715e-18
C34	VPWR#5	RESET_B#8	2.05365e-18
C35	VGND#5	a_1233_118#	1.32965e-18
C36	VGND#18	a_225_81##2	2.91055e-17
C37	a_1367_92##2	RESET_B#7	3.50208e-17
C38	a_1233_118##8	a_1367_92#	7.69636e-19
C39	a_1233_118##6	a_855_368#	1.50799e-17
C40	a_1233_118##7	a_855_368##10	2.11148e-20
C41	RESET_B#17	VGND#15	1.03638e-20
C42	RESET_B#17	a_855_368#	2.16586e-18
C43	a_300_464##2	a_855_368##3	2.41128e-17
C44	VPWR#5	a_1367_92#	3.36437e-18
C45	a_1367_92##2	a_1367_92##3	3.94837e-18
C46	a_855_368##9	a_1034_368#	3.87953e-17
C47	a_1034_368##11	a_855_368##9	1.10005e-17
C48	D#1	a_27_88##3	2.00003e-18
C49	a_2399_424##6	VGND#12	9.56057e-18
C50	VPWR#13	a_855_368#	1.47181e-19
C51	a_1233_118##5	VPWR#13	3.21149e-18
C52	a_300_464##2	VPWR#15	1.75912e-17
C53	a_1745_74##2	a_1745_74##6	1.57069e-18
C54	VGND#3	a_1745_74#	4.38814e-18
C55	SCD#3	RESET_B#2	3.13318e-18
C56	a_1233_118##6	RESET_B#6	1.50815e-18
C57	a_1367_92#	VPWR#14	1.82285e-17
C58	VPWR#11	a_1745_74#	9.38728e-19
C59	a_1233_118##5	a_855_368#	2.54366e-19
C60	RESET_B#17	a_1034_368##3	5.00031e-19
C61	a_1034_368#	a_1367_92##2	8.35433e-18
C62	a_1367_92##5	a_1233_118##2	8.40018e-17
C63	a_1997_272##5	VPWR#3	1.00929e-19
C64	a_300_464#	a_855_368##10	6.2056e-19
C65	VGND#9	D#5	4.98739e-18
C66	SCE#7	a_300_464##6	2.95259e-18
C67	a_1233_118##6	a_1233_118##8	2.16047e-18
C68	a_225_81##2	D#1	2.96431e-19
C69	a_1233_118##8	a_855_368#	1.68165e-19
C70	a_300_464##2	a_855_368##2	9.61608e-18
C71	a_1233_118##5	a_855_368##2	1.625e-18
C72	a_1367_92##5	a_1367_92##3	1.06588e-19
C73	a_1745_74##4	a_1745_74##6	4.03604e-18
C74	a_1233_118##5	RESET_B#7	1.29264e-19
C75	a_300_464##5	a_855_368##12	1.96096e-18
C76	RESET_B#6	a_855_368##2	1.35598e-18
C77	VGND#4	a_1745_74##3	8.25102e-18
C78	a_1034_368##13	a_855_368##4	6.37475e-18
C79	SCE#1	D#1	4.7343e-17
C80	RESET_B#10	a_1745_74##5	3.74425e-18
C81	a_1233_118##6	a_1034_368##3	4.75323e-19
C82	a_1034_368##11	a_855_368##10	5.23998e-17
C83	RESET_B#17	a_1233_118##7	4.20094e-18
C84	VPWR#14	a_855_368#	2.82764e-18
C85	VGND#5	a_1745_74##10	3.70088e-17
C86	a_27_88##4	a_300_464##6	1.25258e-16
C87	a_855_368##9	a_1034_368##2	1.81859e-17
C88	a_855_368##10	a_855_368##9	3.66859e-18
C89	RESET_B#17	a_300_464#	3.00999e-18
C90	a_27_88##8	VGND#18	3.8252e-17
C91	a_1233_118##5	a_1034_368##3	6.19946e-20
C92	VPWR#8	RESET_B#4	3.15821e-19
C93	VGND#7	a_1034_368##11	8.2357e-17
C94	VGND#3	a_1745_74##3	7.86763e-19
C95	VGND#3	a_1745_74##6	3.71751e-19
C96	a_855_368##10	VGND#16	1.24828e-17
C97	a_855_368##13	a_1034_368##13	2.93905e-18
C98	a_1034_368##13	a_855_368##3	3.15004e-17
C99	a_1997_272##3	RESET_B#10	1.09956e-17
C100	a_300_464##2	a_1367_92#	2.27464e-19
C101	a_1233_118##6	VPWR#14	4.74955e-18
C102	SCE#5	SCE#1	2.90656e-17
C103	a_1745_74##9	a_1993_508#	2.5002e-18
C104	RESET_B#17	a_1034_368##11	6.31456e-18
C105	VPWR#14	a_1034_368##3	6.42077e-19
C106	VGND#7	CLK#2	1.15121e-20
C107	a_300_464##6	D#2	6.44497e-19
C108	a_1233_118##5	RESET_B#6	1.06927e-17
C109	a_1034_368##11	CLK#1	2.11889e-18
C110	a_1367_92##5	a_1034_368#	8.75666e-20
C111	a_1233_118##9	a_855_368#	2.37506e-17
C112	a_855_368##12	a_300_464##4	3.37754e-18
C113	a_1745_74#	a_1745_74##6	6.79408e-18
C114	VGND#8	VGND#16	1.42867e-19
C115	RESET_B#15	a_855_368##6	3.58648e-18
C116	a_300_464#	a_1233_118##6	2.22807e-18
C117	a_27_88##6	VPWR#18	4.00732e-17
C118	a_2399_424##7	VPWR#3	9.99744e-18
C119	VPWR#9	a_1034_368##3	4.1355e-18
C120	RESET_B#17	VGND#6	1.36296e-18
C121	VGND#6	RESET_B#6	3.57488e-20
C122	a_1233_118##2	RESET_B#16	9.34571e-18
C123	a_855_368##14	a_855_368##10	7.93333e-19
C124	VGND#9	a_855_368#	2.34127e-19
C125	VGND#4	RESET_B#11	8.32067e-18
C126	a_1034_368##11	a_1367_92##5	7.54434e-19
C127	a_855_368##13	VPWR#15	1.83718e-19
C128	a_1034_368##13	a_855_368##2	7.52089e-21
C129	RESET_B#15	CLK#4	1.49315e-18
C130	a_300_464##2	a_855_368#	2.83005e-18
C131	VGND#6	a_1034_368##11	1.09721e-16
C132	CLK#1	a_855_368##10	3.51734e-17
C133	a_1233_118##5	VPWR#14	3.43433e-17
C134	a_2399_424##3	VGND#12	4.49123e-17
C135	VGND#16	CLK#1	2.68428e-17
C136	VGND#18	a_27_88##7	1.29852e-17
C137	VPWR#4	VPWR#11	2.07843e-19
C138	VPWR#14	a_855_368##6	8.96591e-19
C139	a_1034_368##5	RESET_B#6	3.83061e-19
C140	VPWR#15	a_1367_92#	5.26325e-19
C141	a_1997_272##5	a_2399_424##2	6.1781e-19
C142	a_1034_368##7	a_1997_272##3	2.16593e-17
C143	a_1034_368##3	a_1233_118##9	1.10537e-17
C144	a_1367_92##2	a_1367_92##5	1.05077e-18
C145	a_855_368##7	a_1997_272##2	2.34727e-17
C146	a_1034_368##11	RESET_B#1	7.9919e-20
C147	D#5	a_300_464##8	3.08875e-17
C148	VGND#5	a_1233_118##7	3.30752e-18
C149	VGND#3	RESET_B#11	5.58773e-20
C150	a_1233_118##6	a_1367_92##2	3.68968e-17
C151	a_855_368##14	CLK#1	2.31986e-17
C152	a_27_88##6	a_27_88##9	2.12367e-20
C153	a_300_464##2	a_1034_368##3	3.95455e-17
C154	VPWR#9	RESET_B#3	7.53393e-18
C155	RESET_B#1	CLK#3	7.77736e-18
C156	a_855_368##7	a_1034_368##7	2.7726e-17
C157	a_1367_92##2	a_1233_118##5	1.2405e-17
C158	VPWR#15	a_855_368#	9.35085e-19
C159	VGND#16	RESET_B#1	5.26199e-19
C160	VPWR#9	SCD#3	4.42754e-18
C161	a_1034_368##7	a_1233_118#	2.20526e-18
C162	RESET_B#1	CLK#1	6.38998e-18
C163	VGND#5	a_1034_368##11	2.07513e-17
C164	a_1034_368##13	a_1034_368##3	4.49177e-19
C165	VGND#4	a_1997_272#	2.66759e-18
C166	VGND#17	CLK#1	2.36424e-18
C167	a_1034_368##5	a_855_368##7	4.6467e-17
C168	VPWR#16	VPWR#15	4.97042e-19
C169	a_2399_424##8	a_1745_74##2	5.40127e-19
C170	a_1034_368##13	CLK#2	5.30942e-20
C171	VGND#13	a_1745_74##6	9.40404e-19
C172	a_1997_272##5	a_1745_74##4	2.59757e-17
C173	a_1997_272##7	VPWR#4	8.28995e-18
C174	VPWR#9	a_27_88##3	6.34279e-18
C175	a_300_464##2	a_855_368##6	2.57017e-17
C176	a_1997_272##4	a_2399_424##6	7.70225e-18
C177	SCE#3	D#1	8.20441e-18
C178	a_855_368##14	RESET_B#1	5.37973e-18
C179	VPWR#15	a_1034_368##3	1.35665e-18
C180	a_1034_368##5	a_1233_118#	1.5111e-18
C181	VGND#18	SCE#3	1.76197e-18
C182	VPWR#15	a_855_368##2	5.22074e-18
C183	VGND#13	a_1745_74##2	1.57032e-18
C184	RESET_B#15	a_300_464#	3.383e-18
C185	a_300_464##4	a_1034_368##3	5.61619e-19
C186	a_1233_118##6	a_1034_368##2	3.27327e-18
C187	VPWR#9	D#1	1.76355e-18
C188	a_225_81#	CLK#1	4.06132e-19
C189	a_1233_118##2	a_855_368##7	1.61186e-18
C190	VGND#3	a_1997_272#	1.86847e-20
C191	VGND#7	a_855_368##14	1.08299e-17
C192	a_1233_118##2	RESET_B#6	4.25739e-17
C193	a_1034_368##13	a_855_368##6	2.7104e-17
C194	VGND#6	a_855_368##8	1.04848e-19
C195	RESET_B#16	a_1233_118##8	1.14678e-17
C196	SCD#2	RESET_B#1	2.34167e-18
C197	a_1233_118##5	a_1034_368##2	9.70409e-20
C198	a_1997_272##4	a_1745_74##2	7.135e-17
C199	RESET_B#15	a_1034_368##11	4.82062e-18
C200	a_1233_118##2	a_1233_118#	4.60675e-19
C201	RESET_B#1	VGND#17	1.67242e-17
C202	VPWR#9	SCE#1	8.44354e-19
C203	a_300_464##2	CLK#4	9.29621e-19
C204	VGND#9	D#1	5.35617e-21
C205	a_1997_272##7	VPWR#3	1.00255e-17
C206	RESET_B#5	a_855_368##7	1.41536e-18
C207	SCD#1	RESET_B#1	1.89039e-17
C208	VPWR#15	a_855_368##6	3.52974e-17
C209	RESET_B#17	VPWR#8	3.4593e-19
C210	RESET_B#17	VPWR#5	5.9331e-17
C211	a_300_464##5	a_855_368##6	1.13799e-19
C212	a_855_368##14	SCD#1	3.35399e-19
C213	RESET_B#15	VGND#16	3.42117e-18
C214	a_225_81##2	D#5	1.19833e-17
C215	VGND#5	VGND#6	1.25708e-16
C216	SCE#7	RESET_B#1	8.92547e-19
C217	VPWR#9	SCE#5	7.49673e-19
C218	VGND#4	a_855_368##8	6.83439e-19
C219	RESET_B#5	a_1233_118#	6.81111e-19
C220	a_1034_368##13	CLK#4	1.65886e-18
C221	a_1233_118##7	a_1233_118##9	4.37277e-19
C222	a_225_81#	RESET_B#1	2.97553e-17
C223	VGND#14	a_1745_74##2	6.33523e-18
C224	SCE#7	SCD#1	9.60169e-18
C225	RESET_B#17	VPWR#7	7.5231e-18
C226	a_300_464##2	a_1233_118##6	5.12563e-17
C227	RESET_B#15	a_855_368##14	3.45366e-18
C228	a_855_368##13	a_855_368##6	1.19017e-18
C229	VGND#5	VGND#4	7.88521e-17
C230	a_300_464##4	a_855_368##6	9.3005e-19
C231	a_300_464##8	CLK#1	1.46275e-18
C232	VGND#17	SCD#1	5.29037e-19
C233	VPWR#15	CLK#4	3.50201e-17
C234	RESET_B#17	VPWR#6	5.79249e-18
C235	a_1745_74##8	a_1745_74##4	3.81353e-20
C236	RESET_B#15	VGND#17	2.72033e-18
C237	VGND#9	a_1233_118##7	9.26393e-18
C238	VGND#5	VGND#3	8.4142e-17
C239	VPWR#4	a_1745_74##6	1.87151e-19
C240	RESET_B#5	a_855_368##2	1.3504e-19
C241	a_2399_424##6	VPWR#10	1.44619e-17
C242	VGND#6	a_1034_368##4	4.77313e-18
C243	a_855_368##14	SCE#6	2.16925e-19
C244	RESET_B#7	a_855_368##2	1.74575e-19
C245	a_1745_74##10	a_1745_74##2	1.62854e-20
C246	SCE#6	SCD#1	3.90043e-17
C247	a_855_368##13	CLK#4	3.33557e-17
C248	VGND#9	a_300_464#	1.09149e-17
C249	RESET_B#5	RESET_B#6	1.04668e-17
C250	a_300_464##5	CLK#4	3.26679e-19
C251	a_225_81#	SCD#1	3.03076e-17
C252	RESET_B#17	VPWR#9	1.67505e-17
C253	a_300_464##6	a_538_464#	8.35035e-18
C254	VPWR#3	a_1745_74#	1.31874e-19
C255	a_225_81#	VGND#8	3.43459e-18
C256	a_1034_368##11	a_1397_118#	9.27148e-19
C257	VPWR#3	a_1745_74##6	2.69748e-18
C258	a_855_368##12	a_855_368##6	4.27696e-18
C259	VPWR#15	RESET_B#3	2.95186e-18
C260	a_300_464##8	RESET_B#1	1.38681e-17
C261	VGND#17	SCE#6	1.48996e-19
C262	VGND#9	a_1034_368##11	5.44356e-17
C263	VGND#4	a_1034_368##4	1.19016e-19
C264	a_300_464##4	CLK#4	2.96258e-17
C265	a_2399_424##7	VPWR#10	7.13861e-17
C266	a_300_464##5	RESET_B#13	3.61095e-17
C267	VPWR#5	VPWR#7	7.69911e-17
C268	D#2	SCE#6	3.87908e-18
C269	a_1034_368##3	a_1367_92##2	4.4449e-19
C270	a_300_464#	a_300_464##2	1.1499e-18
C271	VPWR#11	a_1745_74##4	8.23413e-18
C272	a_1034_368##2	a_855_368#	2.07889e-18
C273	VPWR#16	CLK#4	7.737e-19
C274	a_1997_272##4	a_1997_272##5	3.01748e-18
C275	VPWR#5	VPWR#6	8.87997e-17
C276	a_225_81#	SCE#6	1.19242e-17
C277	VPWR#15	SCD#3	2.40619e-19
C278	D#3	SCE#6	5.30803e-18
C279	VPWR#4	a_1745_74##5	7.57996e-19
C280	a_300_464##5	a_855_368##4	4.49797e-20
C281	a_27_88#	D#2	8.29004e-19
C282	VGND#9	a_855_368##14	1.23833e-17
C283	RESET_B#15	VPWR#9	5.37788e-17
C284	VGND#14	a_1997_272##2	1.91465e-18
C285	RESET_B#3	a_300_464##7	2.15916e-17
C286	VPWR#5	a_2399_424##3	5.35466e-18
C287	VGND#6	a_1233_118##3	7.07561e-18
C288	a_300_464##5	RESET_B#3	1.40733e-17
C289	a_300_464##8	SCD#1	2.40825e-17
C290	VPWR#5	VPWR#10	2.06784e-17
C291	VPWR#5	VPWR#4	5.64252e-17
C292	VPWR#11	VPWR#10	1.64291e-18
C293	a_300_464##6	VPWR#16	1.17424e-17
C294	a_855_368##12	CLK#4	7.69407e-19
C295	a_1367_92##2	a_855_368##2	1.17954e-18
C296	VGND#9	RESET_B#15	1.37492e-18
C297	VGND#5	a_2399_424##3	5.85771e-18
C298	a_2399_424#	Q#3	7.72968e-18
C299	VPWR#5	a_1745_74##2	9.36275e-19
C300	VPWR#3	a_1745_74##5	5.37245e-18
C301	RESET_B#3	VPWR#16	1.98241e-17
C302	VPWR#5	a_2399_424##7	1.99221e-17
C303	a_300_464##4	RESET_B#3	2.3431e-17
C304	RESET_B#16	a_855_368##2	2.82173e-19
C305	RESET_B#13	a_300_464##4	1.67968e-17
C306	SCD	RESET_B#2	5.77705e-18
C307	a_1034_368##11	VGND#15	1.15782e-18
C308	VPWR#5	VPWR#3	6.29177e-17
C309	RESET_B#2	CLK#2	6.8227e-19
C310	a_1034_368##13	a_300_464#	5.47618e-18
C311	a_1367_92##2	RESET_B#6	3.09693e-17
C312	VGND#9	a_225_81#	1.41106e-16
C313	a_1034_368##4	a_855_368##7	5.72591e-20
C314	VGND#4	a_1233_118##3	3.14949e-20
C315	a_1233_118##7	a_1319_118#	1.66194e-18
C316	a_225_81#	D#3	2.94438e-19
C317	SCE#4	a_27_88##2	9.00934e-18
C318	VGND#5	a_1745_74##2	8.00926e-18
C319	a_1745_74##8	a_1997_272##4	1.556e-18
C320	a_1997_272##5	a_2399_424##6	3.17358e-17
C321	VPWR#5	VPWR#11	1.6628e-17
C322	a_300_464##8	SCE#6	3.23428e-17
C323	VGND#5	VPWR#10	3.64299e-18
C324	a_2399_424##6	a_2399_424##4	2.10258e-18
C325	VPWR#11	a_2399_424##7	7.65829e-17
C326	a_27_88#	D#3	3.08344e-17
C327	a_2399_424#	VGND#12	2.53657e-17
C328	a_300_464##5	CLK#3	2.78031e-18
C329	a_300_464##5	a_855_368##3	5.48001e-20
C330	a_1997_272##2	VPWR#5	1.41219e-18
C331	VPWR#16	SCD#3	3.20147e-17
C332	a_300_464##5	SCD#3	1.09046e-17
C333	a_225_81##2	SCD#1	1.08488e-19
C334	RESET_B#17	a_1034_368##7	1.95352e-17
C335	VPWR#5	a_1997_272##7	1.83706e-17
C336	VPWR#4	RESET_B#9	1.04986e-17
C337	a_27_88##7	SCE#3	1.83884e-17
C338	a_1367_92##4	VPWR#6	6.14926e-18
C339	VGND#9	VGND#8	5.63448e-17
C340	a_1034_368##4	a_1233_118#	1.9599e-17
C341	a_1034_368##11	a_1034_368##13	4.10839e-18
C342	a_300_464##4	CLK#3	1.8569e-18
C343	VGND#9	a_300_464##8	1.99783e-17
C344	a_300_464##6	RESET_B#3	2.92678e-19
C345	VGND#6	RESET_B#7	2.88256e-18
C346	a_1997_272##7	a_1745_74##4	4.13763e-18
C347	VGND#5	a_1997_272##2	3.12062e-18
C348	a_855_368##3	a_1034_368#	3.67204e-20
C349	a_1034_368##7	VPWR#5	7.22373e-18
C350	RESET_B#17	a_1745_74##9	7.72628e-19
C351	a_225_81#	a_27_88#	1.36766e-19
C352	a_1745_74##10	a_1034_368##7	1.47703e-19
C353	RESET_B#17	a_1034_368##5	1.2937e-17
C354	VGND#9	VGND#7	1.19246e-16
C355	a_300_464##4	SCD#3	1.68644e-18
C356	RESET_B#16	RESET_B#6	8.05576e-18
C357	VGND#6	a_1233_118#	1.01288e-20
C358	a_2399_424##6	a_2399_424#	2.37614e-19
C359	a_2399_424##8	a_2399_424#	1.11688e-18
C360	RESET_B#15	VPWR#8	8.84239e-18
C361	a_855_368##3	a_1034_368##2	3.73131e-17
C362	D#3	a_300_464##8	1.21973e-17
C363	VGND#5	a_1034_368##7	2.99574e-19
C364	VPWR#16	a_27_88##3	4.77135e-18
C365	RESET_B#4	CLK#4	9.71931e-18
C366	a_1034_368##5	VGND#14	2.10616e-18
C367	RESET_B#17	a_1367_92##4	3.79182e-17
C368	VGND#9	VGND#6	2.63149e-17
C369	RESET_B#17	a_1233_118##2	1.85186e-17
C370	VGND#9	a_225_81##2	5.13197e-17
C371	a_300_464##6	SCD#3	1.08702e-17
C372	a_1034_368##2	a_855_368##2	1.23791e-18
C373	a_225_81##2	SCE#6	5.31876e-19
C374	VPWR#6	a_1997_272##3	2.75561e-19
C375	VGND#12	a_1745_74#	2.35101e-18
C376	a_1745_74##2	a_2399_424##3	1.2194e-18
C377	a_1745_74##3	a_2135_74#	8.8457e-18
C378	SCE#4	a_27_88#	3.24573e-18
C379	VGND#5	a_1034_368##5	8.93054e-17
C380	a_2399_424##6	a_1745_74##6	7.54026e-18
C381	RESET_B#11	a_2135_74#	8.8457e-18
C382	SCE	SCE#3	3.60194e-17
C383	VPWR#5	a_1233_118##2	3.55527e-18
C384	RESET_B#17	VPWR#13	2.98562e-17
C385	a_300_464##5	a_27_88##3	6.526e-19
C386	VPWR#7	VPWR#6	4.38157e-19
C387	a_300_464#	a_1233_118##7	1.02513e-16
C388	a_1745_74##9	VPWR#5	6.78668e-17
C389	RESET_B#17	RESET_B#5	1.31235e-17
C390	a_1997_272##5	a_2399_424##7	5.86369e-19
C391	VGND#13	a_2399_424#	6.85651e-19
C392	a_300_464##4	RESET_B#4	7.88909e-18
C393	VGND#8	VGND#7	6.89674e-19
C394	a_1034_368##5	a_1745_74##10	6.07714e-17
C395	VPWR#4	a_1997_272##3	6.73885e-18
C396	a_1997_272##5	a_2399_424##4	7.66591e-19
C397	VGND#5	a_1233_118##2	9.39263e-18
C398	VPWR#16	D#1	5.08803e-19
C399	VGND#18	SCE#6	2.13225e-19
C400	a_1997_272##7	VPWR#11	7.43335e-17
C401	VPWR#5	RESET_B#5	1.96173e-18
C402	a_300_464##8	a_27_88#	1.25372e-18
C403	RESET_B#17	a_1233_118##8	1.12438e-17
C404	a_1745_74#	a_2399_424##8	2.34972e-17
C405	VGND#9	a_27_88##8	1.61135e-17
C406	VPWR#5	a_1367_92##4	1.1244e-17
C407	a_300_464##6	a_27_88##3	6.4391e-17
C408	RESET_B#17	a_1367_92##2	2.4528e-17
C409	a_1745_74##2	RESET_B#10	2.71648e-17
C410	a_300_464##4	a_27_88##3	4.92733e-19
C411	a_300_464##4	a_855_368##3	2.78727e-19
C412	VGND#6	a_1367_92##3	1.19586e-18
C413	a_1034_368##5	a_1367_92##7	1.27218e-19
C414	VPWR#18	SCD#3	2.66946e-19
C415	a_225_81##2	D#3	1.35701e-17
C416	a_27_88##6	SCE#3	3.32263e-17
C417	VGND#5	RESET_B#5	1.38535e-18
C418	a_300_464#	a_855_368##3	1.10863e-17
C419	a_2399_424##6	a_1745_74#	8.43446e-18
C420	VPWR#8	a_855_368##4	1.19195e-19
C421	VPWR#18	a_300_464##6	2.37906e-17
C422	VPWR#5	a_1367_92##2	2.32091e-18
C423	a_1997_272##4	a_2399_424#	1.04923e-18
C424	VPWR#9	VPWR#8	1.27359e-16
C425	a_1745_74##2	a_1997_272##2	1.76522e-17
C426	a_855_368##12	a_855_368##10	5.05557e-18
C427	RESET_B#17	VPWR#14	5.11203e-18
C428	a_1233_118##7	RESET_B#6	2.99769e-20
C429	RESET_B#17	a_1034_368##2	1.16855e-17
C430	a_1233_118##8	VPWR#7	4.36392e-18
C431	a_1034_368##5	VGND#15	4.838e-18
C432	RESET_B#13	CLK#3	1.23086e-18
C433	VGND#14	a_1745_74##8	1.50404e-17
C434	a_1034_368##11	a_1233_118##7	6.1147e-17
C435	VPWR#16	SCE#1	2.66946e-19
C436	VGND#5	a_1367_92##2	6.9286e-18
C437	a_300_464##5	SCD#2	1.1977e-17
C438	VPWR#6	a_1034_368##6	4.98286e-19
C439	VGND#13	a_1745_74#	3.08716e-17
C440	a_1997_272##2	RESET_B#10	5.93769e-17
C441	a_300_464##6	D#1	5.93475e-17
C442	VPWR#9	VPWR#7	3.91189e-17
C443	VPWR#12	VPWR#11	1.31159e-18
C444	VGND#18	D#3	6.30499e-19
C445	a_300_464##5	D#1	3.91176e-19
C446	VPWR#5	a_1233_118##8	6.68884e-18
C447	VGND#5	a_1367_92##4	1.42502e-18
C448	a_300_464##8	SCE#4	5.12056e-19
C449	VPWR#18	a_27_88##3	5.08803e-19
C450	a_1997_272##3	a_1993_508#	8.2613e-18
C451	a_300_464##5	RESET_B#1	2.35018e-18
C452	CLK	a_855_368##4	4.10277e-18
C453	a_1997_272##5	VPWR#11	1.51283e-17
C454	a_2399_424##8	a_1745_74##3	4.13785e-19
C455	a_1997_272##5	a_2399_424#	1.50028e-20
C456	a_300_464##5	a_1034_368##13	4.38967e-22
C457	a_1997_272#	a_1972_74#	8.8457e-18
C458	a_27_88##4	SCD#3	8.30892e-18
C459	a_225_81##2	a_27_88#	3.16161e-17
C460	a_1034_368##11	a_855_368##4	4.71147e-18
C461	RESET_B#17	a_855_368##2	6.77989e-19
C462	a_1034_368##6	a_1993_508#	8.06292e-18
C463	VPWR#14	RESET_B#7	3.50958e-19
C464	a_1997_272##5	a_1745_74##6	2.45471e-18
C465	CLK	CLK#2	1.14989e-17
C466	VPWR#5	VPWR#14	3.55057e-18
C467	RESET_B#17	a_1233_118##9	8.33613e-18
C468	VPWR#4	a_1034_368##6	7.33317e-19
C469	VGND#5	VPWR#13	3.11152e-18
C470	a_300_464#	a_855_368##2	1.46136e-19
C471	a_855_368##8	a_1972_74#	8.8457e-18
C472	CLK	RESET_B#2	3.41501e-18
C473	a_1233_118##8	VPWR#6	2.43016e-18
C474	VPWR#5	a_1997_272##5	3.27314e-18
C475	a_300_464##4	a_855_368##2	2.60427e-19
C476	RESET_B#15	a_1034_368##2	5.40726e-18
C477	a_27_88##9	a_27_88##3	2.12145e-20
C478	a_1997_272##4	a_1745_74#	9.62089e-18
C479	a_1034_368##7	a_1997_272##2	7.826e-18
C480	a_300_464##6	SCE#1	4.1596e-18
C481	a_1745_74##10	a_855_368##7	5.54391e-19
C482	RESET_B#17	RESET_B#6	6.66559e-19
C483	a_1034_368##11	a_300_464#	8.94346e-17
C484	VGND#6	a_1034_368#	1.199e-18
C485	a_1233_118##6	VPWR#7	6.5663e-18
C486	a_27_88##4	D#1	4.22462e-17
C487	a_855_368##12	CLK#1	6.61206e-18
C488	RESET_B#17	a_300_464##2	3.71957e-17
C489	VPWR#9	a_1034_368##2	1.46983e-19
C490	a_2399_424##3	VPWR#10	3.95364e-17
C491	VPWR#18	D#1	7.44954e-18
C492	VPWR#12	a_1997_272##7	3.35744e-17
C493	RESET_B#13	RESET_B#4	1.29388e-17
C494	RESET_B#6	a_855_368##7	1.06141e-18
C495	VPWR#5	a_1745_74##8	5.97426e-19
C496	a_855_368##12	a_1034_368##11	4.30262e-17
C497	VPWR#6	a_1034_368##4	1.70225e-19
C498	VGND#18	a_27_88#	4.25787e-18
C499	VPWR#8	a_855_368##3	1.38832e-19
C500	a_1034_368##5	a_1997_272##2	1.51988e-19
C501	VPWR#5	a_1745_74##4	1.96365e-18
C502	VGND#13	a_1745_74##3	1.64788e-18
C503	SCE#7	a_300_464##5	4.5914e-18
C504	a_300_464##5	CLK#2	2.60717e-19
C505	VGND#9	a_1034_368##2	2.21612e-18
C506	a_855_368##14	a_855_368##13	1.58392e-18
C507	a_225_81##2	SCE#4	1.64662e-18
C508	a_27_88##9	D#1	3.10677e-20
C509	a_1034_368##11	a_855_368##3	1.48024e-17
C510	RESET_B#15	CLK#3	6.6327e-18
C511	a_1034_368##11	a_1034_368##5	2.8296e-18
C512	VPWR#6	a_855_368##7	5.0809e-17
C513	a_855_368##12	a_300_464##2	3.52842e-18
C514	a_27_88##8	a_27_88#	7.86467e-20
C515	a_1997_272##5	a_1997_272##7	1.88411e-18
C516	VPWR#18	SCE#1	4.12609e-17
C517	VGND#7	a_855_368##9	1.1813e-18
C518	a_225_81#	a_545_81#	1.23301e-18
C519	a_1997_272##4	a_1745_74##3	3.59903e-17
C520	a_27_88##2	D#1	2.82164e-18
C521	a_1233_118##6	a_1233_118##5	7.09324e-18
C522	RESET_B#15	RESET_B#4	6.66838e-18
C523	a_27_88##9	VPWR#18	5.57429e-17
C524	VGND#4	a_1745_74##2	2.68759e-18
C525	a_1367_92#	a_1343_461#	3.33403e-18
C526	a_855_368##12	a_855_368##4	2.40358e-17
C527	VGND#18	SCE#4	3.69406e-17
C528	VGND#5	a_1997_272##5	4.36052e-18
C529	VPWR#4	a_855_368##7	6.32892e-19
C530	VGND#9	CLK#3	1.87819e-18
C531	VPWR#14	VPWR#6	1.73837e-18
C532	a_855_368#	a_1343_461#	8.26991e-18
C533	a_1233_118##2	a_1034_368##5	3.66243e-18
C534	VPWR#9	RESET_B#4	1.51424e-18
C535	a_855_368##12	RESET_B#1	9.03825e-20
C536	a_1745_74##6	a_2399_424##4	6.80138e-18
C537	a_27_88##9	SCE#1	1.34618e-18
C538	VGND#13	RESET_B#11	1.68291e-19
C539	VGND#14	a_1745_74#	3.14501e-19
C540	VGND#3	a_1745_74##2	7.4127e-19
C541	a_855_368##12	VGND#16	1.98599e-17
C542	VPWR#5	a_855_368##2	2.30935e-18
C543	a_855_368##4	VGND#16	1.56802e-18
C544	a_1233_118##5	VPWR#7	8.91769e-19
C545	VGND#5	a_1745_74##8	1.12461e-17
C546	VGND#9	RESET_B#4	4.17208e-19
C547	a_300_464##4	VPWR#15	2.83478e-17
C548	RESET_B#7	a_1397_118#	4.96238e-18
C549	a_27_88##4	a_300_464##5	1.51848e-18
C550	SCE#5	VPWR#18	1.88683e-17
C551	a_300_464##5	RESET_B#2	2.2001e-17
C552	VPWR#8	a_855_368##2	1.84506e-17
C553	a_27_88##8	SCE#4	1.25858e-17
C554	a_1367_92##3	a_1397_118#	4.91586e-18
C555	VPWR#11	a_1745_74##2	2.47364e-18
C556	a_1745_74##8	a_1997_272##5	1.61414e-18
C557	VGND#6	a_855_368#	4.30057e-20
C558	a_1745_74##9	a_1997_272##7	5.57853e-18
C559	a_1233_118##2	RESET_B#5	1.68749e-17
C560	a_1367_92##2	a_1034_368##5	2.6161e-20
C561	VGND#9	SCD#2	3.17003e-20
C562	a_855_368##12	a_1034_368##13	5.98686e-17
C563	RESET_B#6	a_1233_118#	1.11227e-17
C564	a_300_464##5	a_855_368##13	2.6989e-18
C565	VGND#16	a_1034_368##11	4.0327e-17
C566	a_1997_272##4	RESET_B#11	4.42004e-18
C567	a_27_88##9	SCE#5	2.97184e-17
C568	VPWR#9	SCE#7	4.48046e-18
C569	VPWR#6	a_1233_118#	2.08221e-18
C570	a_1997_272##7	a_1745_74##2	7.74418e-19
C571	CLK#1	a_855_368##4	1.53738e-18
C572	VGND#7	a_855_368##12	4.41816e-19
C573	RESET_B#15	a_27_88##4	4.21963e-18
C574	a_1367_92##2	a_1233_118##2	6.19346e-17
C575	a_855_368##12	a_855_368##3	2.23736e-18
C576	VGND#9	SCE#7	4.92926e-18
C577	RESET_B#2	CLK#3	1.54585e-17
C578	VGND#14	a_1745_74##3	3.73658e-18
C579	VGND#13	a_1997_272#	1.31532e-19
C580	VGND#7	a_855_368##10	6.63455e-18
C581	VPWR#9	a_27_88##4	1.07372e-17
C582	a_1745_74##5	a_1745_74##6	1.90052e-17
C583	VGND#4	RESET_B#10	1.05424e-18
C584	RESET_B#15	a_300_464##2	2.29519e-17
C585	RESET_B#17	a_1367_92##5	6.1621e-18
C586	VGND#8	CLK	3.70074e-18
C587	VGND#7	CLK	1.60723e-19
C588	VGND#9	a_27_88##4	9.93089e-20
C589	SCD	a_300_464##5	8.41819e-17
C590	a_1745_74##9	a_1745_74##4	1.89775e-19
C591	a_1745_74##9	VPWR#12	4.05525e-17
C592	a_300_464##4	a_855_368##13	3.42026e-17
C593	SCD#3	a_538_464#	1.51429e-17
C594	VPWR#9	D#2	3.54046e-21
C595	a_2399_424##8	VGND#12	4.70544e-17
C596	VGND#3	a_2399_424##8	8.50624e-18
C597	RESET_B#15	a_1034_368##13	4.66697e-17
C598	VPWR#9	a_1233_118##9	1.07649e-17
C599	a_1233_118##7	a_1367_92##2	6.93635e-17
C600	RESET_B#17	a_1233_118##6	4.16128e-17
C601	VPWR#7	RESET_B#8	2.65271e-18
C602	a_1997_272##7	RESET_B#10	3.6403e-18
C603	a_855_368##14	a_1034_368##11	2.74847e-18
C604	a_27_88##3	a_538_464#	1.51429e-17
C605	Q	a_2399_424##2	1.24868e-17
C606	a_1367_92##3	a_1319_118#	7.54106e-18
C607	VGND#9	D#2	1.43977e-19
C608	a_1997_272##4	a_1997_272#	1.98335e-18
C609	Q	a_1745_74##4	1.01168e-19
C610	a_855_368##12	VPWR#15	1.26778e-18
C611	a_1034_368##2	a_1367_92##2	2.15824e-17
C612	a_1034_368#	a_1319_118#	7.54106e-18
C613	a_1233_118##9	VPWR#7	8.1995e-18
C614	a_225_81##2	a_312_81#	1.04027e-18
C615	a_300_464#	a_1367_92##2	1.74387e-18
C616	RESET_B#15	VPWR#15	1.97046e-18
C617	VGND#8	CLK#1	1.11141e-18
C618	VPWR#9	a_300_464##2	2.46896e-17
C619	VPWR#12	RESET_B#10	4.5428e-18
C620	RESET_B#8	a_855_368##2	2.12051e-17
C621	RESET_B#17	a_1233_118##5	3.4859e-17
C622	VGND#9	a_27_88##2	8.38883e-18
C623	VGND#14	RESET_B#11	1.51074e-17
C624	a_1745_74##4	a_2399_424##2	4.88859e-19
C625	VPWR#7	a_855_368##2	5.23996e-17
C626	RESET_B#9	a_1745_74##5	2.55756e-17
C627	a_1034_368##11	a_1367_92##2	4.65787e-17
C628	D#1	a_216_464#	1.62684e-17
C629	RESET_B#15	a_855_368##13	5.78481e-17
C630	VPWR#9	a_1034_368##13	4.39822e-18
C631	VPWR#4	VPWR#3	8.1034e-19
C632	a_1745_74##10	a_1745_74##3	7.86193e-20
C633	D#5	SCD#2	1.04171e-19
C634	SCE#1	a_216_464#	1.62684e-17
C635	a_300_464##2	VPWR#8	1.36118e-17
C636	VGND#13	VGND#12	2.45988e-18
C637	a_1745_74#	a_2399_424#	4.98535e-18
C638	VGND#7	CLK#1	4.57481e-18
C639	a_1233_118##7	a_1034_368##2	2.44583e-18
C640	a_855_368##14	VGND#16	3.6242e-17
C641	a_300_464##4	a_300_464##7	2.41654e-18
C642	a_1745_74##9	RESET_B#10	1.97714e-18
C643	VPWR#9	VPWR#15	8.92699e-18
C644	a_1997_272##4	a_855_368##8	4.65351e-19
C645	a_1997_272##2	VPWR#12	2.76938e-18
C646	VGND#13	VPWR#11	2.37402e-18
C647	VPWR#5	a_1233_118##6	8.811e-18
C648	a_300_464#	a_1034_368##2	5.44355e-17
C649	VPWR#4	a_1745_74##2	3.53836e-20
C650	a_1745_74##8	RESET_B#11	2.32636e-19
C651	a_855_368##12	a_855_368##13	1.13732e-18
C652	RESET_B#15	a_855_368##4	2.49438e-19
C653	VPWR#7	a_1367_92#	3.24422e-18
C654	a_27_88##6	a_27_88##3	3.98529e-19
C655	VPWR#9	a_855_368##13	2.67471e-18
C656	a_300_464##5	VPWR#16	3.29968e-17
C657	VGND#14	a_1997_272#	2.50571e-17
C658	VGND#9	a_1034_368##13	2.38948e-18
C659	a_1034_368##11	a_1034_368##2	8.4089e-19
C660	a_300_464##8	a_300_464##5	1.30886e-18
C661	VPWR#3	a_1745_74##2	2.3037e-20
C662	VPWR#5	a_1233_118##5	4.25772e-18
C663	a_1997_272##3	RESET_B#9	1.69156e-17
C664	VPWR#10	a_2399_424##4	6.96434e-17
C665	a_300_464##2	VPWR#7	7.87251e-19
C666	VGND#4	a_1997_272##4	1.93789e-18
C667	RESET_B#15	a_855_368##3	2.43018e-18
C668	VGND#8	RESET_B#1	4.4304e-18
C669	a_1745_74##10	RESET_B#11	1.87696e-19
C670	a_27_88##7	SCE	3.29959e-17
C671	a_1745_74##9	a_1997_272##2	2.8964e-18
C672	D#5	SCE#7	1.01735e-17
C673	a_27_88##6	SCE	9.23687e-17
C674	CLK#3	RESET_B#4	1.01662e-17
C675	VGND#17	VGND#16	1.48362e-18
C676	VPWR#7	RESET_B#6	2.63653e-19
C677	VGND#13	a_2399_424##8	2.71256e-17
C678	RESET_B#17	RESET_B#16	8.06288e-18
C679	VGND#5	a_1367_92##5	1.68635e-17
C680	a_300_464##5	CLK	1.68851e-17
C681	D#5	SCE	1.47595e-17
C682	a_1367_92#	a_855_368##2	1.66874e-17
C683	CLK	a_300_464##4	1.60359e-18
C684	a_2399_424##7	a_2399_424##4	1.60329e-18
C685	VPWR#9	VPWR#16	1.57191e-17
C686	VPWR#16	a_300_464##4	2.1271e-17
C687	a_27_88##6	a_27_88##4	3.6007e-19
C688	a_1367_92##4	a_1997_272##2	1.87574e-19
C689	VGND#9	a_855_368##13	3.29279e-18
C690	a_1367_92##4	a_1745_74##9	1.57541e-17
C691	a_1745_74##3	a_1745_74#	3.09957e-18
C692	CLK	a_855_368##12	3.56905e-17
C693	VPWR#6	a_855_368##2	3.10932e-18
C694	a_2399_424##6	a_2399_424##3	1.4608e-17
C695	VGND#14	a_855_368##8	5.717e-18
C696	a_27_88##6	D#1	5.64896e-18
C697	VPWR#10	a_1745_74##6	4.02869e-18
C698	a_1745_74##8	a_1997_272#	4.39475e-19
C699	CLK	RESET_B#13	4.61489e-18
C700	a_1367_92#	RESET_B#6	3.97924e-18
C701	a_1745_74##8	a_1745_74##9	1.94269e-18
C702	a_1034_368##6	a_1997_272##3	2.5715e-17
C703	a_1034_368##7	a_1745_74##9	1.04332e-16
C704	VPWR#5	a_1745_74#	8.02208e-19
C705	VGND#3	a_1997_272##4	1.76951e-17
C706	VPWR#11	a_2399_424##4	9.27637e-19
C707	a_1745_74##10	a_1997_272#	3.46787e-18
C708	a_300_464##8	SCD	1.71059e-17
C709	a_855_368##12	CLK#2	7.38085e-18
C710	VGND#17	a_855_368##14	2.17218e-17
C711	SCD#2	RESET_B#2	3.87741e-17
C712	D#5	a_300_464##5	1.11799e-19
C713	a_300_464##6	VPWR#9	7.79388e-17
C714	D#5	a_27_88##4	4.52117e-19
C715	a_1997_272##4	a_2399_424##8	1.56423e-17
C716	SCE#7	SCD#2	3.5041e-17
C717	VGND#5	a_2399_424#	5.87549e-18
C718	a_1367_92##4	a_1034_368##7	3.54581e-17
C719	a_2399_424##7	a_1745_74##6	5.73664e-17
C720	a_27_88##7	D#2	1.98289e-19
C721	VPWR#13	a_1745_74##9	5.34718e-18
C722	VPWR#5	RESET_B#16	9.76126e-19
C723	a_1997_272##5	a_855_368##8	9.11708e-20
C724	a_27_88##4	SCD#2	2.25547e-17
C725	SCD#1	a_545_81#	8.30758e-18
C726	a_1997_272##5	a_855_368##7	7.0269e-20
C727	VPWR#10	a_1745_74##5	3.24507e-19
C728	RESET_B#1	CLK#2	1.02765e-19
C729	VGND#5	a_1745_74#	6.47014e-18
C730	SCE#6	a_545_81#	8.30758e-18
C731	a_1997_272##5	a_2399_424##3	3.2995e-18
C732	VGND#14	a_1034_368##4	2.81372e-19
C733	SCE#7	a_27_88##4	9.28604e-17
C734	a_2399_424##6	Q	3.49052e-18
C735	D#2	SCD#2	7.76242e-19
C736	a_1034_368##5	a_1745_74##9	1.62646e-18
C737	VGND#6	a_1034_368##5	1.00516e-16
C738	a_1233_118##7	a_855_368#	2.68944e-19
C739	a_27_88##6	SCE#1	1.14271e-17
C740	a_1745_74##6	VPWR#11	2.52241e-17
C741	RESET_B#11	a_1745_74##3	4.16093e-17
C742	VPWR#9	VPWR#18	2.22581e-17
C743	VPWR#8	a_1034_368##3	8.07034e-19
C744	a_855_368##7	a_1034_368##6	1.31022e-17
C745	a_2399_424##6	a_1745_74##2	1.08889e-18
C746	VPWR#6	RESET_B#6	1.21583e-18
C747	D#2	SCE#7	1.88469e-17
C748	VGND#5	a_1745_74##3	1.26619e-18
C749	a_1745_74##10	a_855_368##8	4.08101e-17
C750	a_300_464##5	a_300_464##6	3.94128e-20
C751	a_1034_368##5	a_1367_92##4	1.84065e-17
C752	a_1745_74##8	a_855_368##7	1.6208e-17
C753	a_225_81##2	SCE	2.86028e-18
C754	VPWR#13	a_1367_92##4	8.14556e-17
C755	a_1745_74##8	a_855_368##8	2.34491e-17
C756	VPWR#9	a_855_368##2	2.59673e-18
C757	a_855_368##2	a_855_368#	1.04676e-18
C758	a_1997_272##4	VGND#13	3.66677e-17
C759	a_855_368##12	RESET_B#2	2.93253e-19
C760	CLK#3	a_855_368##14	4.08952e-18
C761	D#2	a_27_88##4	5.5883e-18
C762	RESET_B#17	a_1034_368##4	1.06665e-18
C763	a_1997_272##2	VPWR#4	2.74094e-19
C764	a_27_88##7	D	5.56757e-19
C765	D#5	D#2	1.67122e-17
C766	VPWR#9	a_27_88##9	1.7688e-17
C767	a_855_368##14	CLK#2	3.13234e-19
C768	VGND#4	VGND#3	7.02797e-19
C769	a_27_88##7	a_27_88##2	2.2011e-18
C770	VPWR#7	a_1034_368##3	1.8432e-18
C771	a_1233_118##5	RESET_B#16	2.54782e-17
C772	a_27_88##4	a_27_88##2	5.3767e-19
C773	a_300_464##8	a_300_464##6	3.48522e-18
C774	a_300_464##8	a_855_368##12	2.57879e-19
C775	VGND#5	RESET_B#16	1.2486e-18
C776	CLK	a_855_368##14	3.09148e-17
C777	a_27_88##6	a_27_88##2	7.21451e-19
C778	a_1745_74##5	VPWR#11	2.12669e-17
C779	VPWR	VPWR#7	3.88134e-18
C780	a_27_88##2	D#2	2.61581e-17
C781	VGND#14	a_1233_118##3	1.24356e-20
C782	a_1034_368##11	a_855_368#	2.70364e-19
C783	a_1997_272##4	a_1745_74##4	3.18038e-19
C784	a_1233_118##6	a_1343_461#	5.51034e-19
C785	VGND#5	a_1997_272#	6.74305e-18
C786	a_300_464##6	a_300_464##4	2.19958e-18
C787	a_300_464##8	CLK	6.69558e-18
C788	a_1233_118##2	a_1367_92##4	2.24813e-18
C789	SCE#7	RESET_B#2	2.94722e-19
C790	a_27_88##6	SCE#5	1.31633e-17
C791	VPWR#12	a_1745_74##6	1.51089e-19
C792	D#3	a_312_81#	6.86229e-18
C793	a_225_81#	VGND#17	3.5748e-17
C794	a_1233_118#	a_855_368##7	7.1729e-17
C795	a_1997_272##5	a_1745_74##2	1.0651e-16
C796	a_27_88#	a_312_81#	8.27954e-18
C797	a_1745_74#	a_2399_424##2	2.48899e-19
C798	a_1034_368##4	a_1745_74##10	4.48929e-18
C799	RESET_B#17	RESET_B#7	1.64424e-18
C800	SCD	a_300_464##6	4.01147e-18
C801	a_1367_92##4	RESET_B#6	1.21288e-19
C802	VPWR#9	a_1233_118##6	1.66581e-18
C803	SCE#7	SCE#3	2.03838e-19
C804	VGND#5	a_855_368##8	5.37467e-18
C805	a_1233_118##2	VPWR#13	8.34348e-18
C806	a_1997_272##7	a_1745_74##5	3.42734e-17
C807	VGND#9	a_855_368##4	1.38085e-18
C808	VGND#6	a_1233_118##2	1.17046e-19
C809	a_1997_272#	RESET_B#11	3.32255e-17
C810	VPWR#9	RESET_B#2	1.30771e-19
C811	VPWR#18	SCE#3	1.06074e-18
C812	a_1034_368##7	VPWR#6	1.36718e-18
C813	VPWR#8	a_855_368##6	3.96006e-18
C814	a_1745_74##8	a_1745_74##2	1.10348e-18
C815	a_1745_74##8	a_1233_118#	9.82353e-20
C816	VGND#17	RESET_B#4	2.71582e-18
C817	a_855_368##3	a_1034_368##3	2.00539e-17
C818	a_1233_118##2	a_1233_118##8	1.20275e-18
C819	VPWR#11	RESET_B#9	6.79043e-19
C820	VGND#5	a_1034_368##4	1.49356e-18
C821	VGND#9	a_855_368##3	4.25356e-19
C822	Q	Q#3	3.85735e-18
C823	VPWR	a_1233_118##6	1.43044e-18
C824	VGND#17	RESET_B#13	6.85588e-18
C825	a_1034_368##4	a_1367_92##7	1.24533e-17
C826	VGND#12	Q	6.36871e-17
C827	a_1233_118##8	VPWR#13	2.63408e-17
C828	VPWR#12	a_1745_74##5	4.32612e-19
C829	a_300_464##8	a_855_368##14	8.42647e-18
C830	a_225_81##2	D	1.36251e-17
C831	VGND#18	D	4.97952e-18
C832	VGND#5	a_1233_118##3	1.76298e-18
C833	RESET_B#8	a_1233_118#	4.06458e-18
C834	a_855_368##2	a_1034_368##3	1.87368e-17
C835	a_27_88##8	D	1.67698e-19
C836	a_300_464##4	VPWR#8	7.00849e-18
C837	RESET_B#5	VPWR#13	2.46979e-17
C838	VPWR#13	a_855_368##2	2.0647e-19
C839	a_1997_272##7	RESET_B#9	2.77473e-17
C840	RESET_B#15	a_300_464##5	3.73743e-18
C841	CLK	a_855_368##13	2.28166e-17
C842	a_1997_272##5	RESET_B#10	2.14606e-17
C843	VGND#14	VGND#13	1.63456e-18
C844	a_2399_424##3	a_2399_424##2	6.72694e-18
C845	RESET_B#5	a_1233_118##8	1.05854e-17
C846	VGND#5	RESET_B#7	4.57917e-18
C847	VPWR#11	a_1997_272##3	2.63756e-19
C848	a_1745_74#	a_2399_424##3	1.30239e-17
C849	RESET_B#13	a_300_464##7	3.00342e-18
C850	RESET_B#15	a_300_464##4	2.9853e-17
C851	VPWR#14	VPWR#13	4.87909e-18
C852	RESET_B#9	VPWR#12	1.13238e-17
C853	a_855_368##8	a_1997_272#	5.5422e-17
C854	a_225_81#	SCD#2	7.17035e-19
C855	a_1745_74##8	RESET_B#10	2.68729e-18
C856	a_1745_74##4	a_2399_424##3	7.43784e-19
C857	VGND#9	CLK#2	5.46088e-20
C858	a_27_88##4	RESET_B#2	4.80291e-19
C859	VPWR#6	a_1034_368##5	6.10853e-19
C860	a_1233_118##3	a_1367_92##7	1.24533e-17
C861	VPWR#8	CLK#4	3.24906e-18
C862	a_300_464##8	VGND#17	1.52353e-18
C863	a_1745_74##9	a_1745_74##5	3.09634e-19
C864	VPWR#13	RESET_B#6	6.20608e-18
C865	a_1997_272##7	a_1997_272##3	1.4639e-18
C866	Q	Q#1	1.56075e-17
C867	a_27_88##4	SCE#3	8.74801e-19
C868	a_1367_92#	RESET_B#8	1.1047e-17
C869	a_855_368#	a_1233_118#	6.83865e-20
C870	VPWR#10	Q	8.55027e-17
C871	D#5	RESET_B#1	1.78681e-19
C872	VGND#9	RESET_B#2	2.38422e-20
C873	a_1745_74##2	a_1745_74#	6.15293e-18
C874	a_300_464##8	SCD#2	2.53834e-18
C875	VGND	VGND#6	3.09949e-18
C876	a_855_368##6	a_855_368##3	2.77084e-17
C877	RESET_B#15	a_855_368##12	2.41467e-17
C878	VGND#14	a_1997_272##4	1.72895e-17
C879	a_1233_118##3	VGND#15	1.0702e-17
C880	VPWR#14	a_1233_118##8	9.20178e-18
C881	a_300_464##5	VPWR#9	9.33147e-18
C882	VPWR#14	a_1367_92##2	8.18754e-19
C883	a_1997_272##3	VPWR#12	1.3921e-17
C884	a_225_81#	SCE#7	5.08599e-19
C885	CLK	CLK#1	1.18446e-18
C886	a_1997_272##5	a_1997_272##2	1.10513e-18
C887	CLK	RESET_B#1	2.21634e-18
C888	a_1745_74##9	RESET_B#9	1.14741e-18
C889	a_225_81#	a_300_464##8	8.46318e-17
C890	a_300_464##4	VPWR#9	4.4981e-17
C891	a_855_368##6	a_855_368##2	2.17293e-17
C892	a_1745_74##2	RESET_B#11	3.40323e-17
C893	a_300_464##8	a_855_368##4	4.8063e-20
C894	a_1233_118##8	a_855_368##2	4.91456e-18
C895	a_1034_368##4	a_855_368##8	2.53678e-18
C896	a_855_368#	a_1367_92#	3.79151e-17
C897	a_1745_74##8	a_1997_272##2	1.24729e-16
C898	a_855_368##4	a_855_368##3	1.68015e-17
C899	a_1367_92##5	a_1745_74##10	9.27174e-20
C900	a_1233_118##2	VPWR#6	9.40474e-19
C901	a_300_464##8	SCE#7	4.33139e-17
C902	D#5	SCD#1	1.46843e-19
C903	SCD	SCD#3	3.16721e-18
C904	VGND#6	a_1367_92##2	3.04812e-20
C905	Q	a_2399_424#	2.96419e-17
C906	Q	a_1745_74#	2.27601e-19
C907	VPWR#12	a_1034_368##6	1.20503e-18
C908	RESET_B#7	VGND#15	1.5476e-17
C909	a_300_464##2	a_1367_92##2	1.39321e-18
C910	D	D#3	8.03783e-19
C911	a_1034_368##3	a_1367_92#	1.08041e-18
C912	D	a_27_88#	4.172e-18
C913	VPWR#9	a_855_368##12	1.51304e-18
C914	a_1745_74##2	a_1745_74##4	5.33245e-18
C915	a_225_81#	a_27_88##4	1.57302e-19
C916	a_1745_74##9	a_1997_272##3	2.60122e-17
C917	D	SCE#4	1.09363e-18
C918	a_225_81##2	SCE#7	2.4804e-18
C919	a_1233_118##8	RESET_B#6	4.97361e-18
C920	CLK#4	a_855_368##4	8.86155e-19
C921	a_1034_368##13	a_1367_92##2	4.72151e-20
C922	a_1367_92##5	a_855_368##7	2.23049e-18
C923	SCE#3	D#2	1.07667e-17
C924	SCE	D#1	3.35327e-18
C925	a_1233_118##9	a_1034_368##2	1.04612e-18
C926	a_225_81#	RESET_B#2	1.17157e-19
C927	RESET_B#15	SCD	2.94195e-18
C928	a_1034_368##3	a_855_368#	2.39307e-17
C929	VPWR#9	SCD	4.30103e-18
C930	a_300_464##8	a_27_88##4	1.36737e-18
C931	a_1367_92##4	a_1997_272##3	2.22368e-19
C932	a_27_88##7	a_27_88#	1.88752e-20
C933	VGND#9	SCD	4.48055e-18
C934	a_300_464##2	a_1034_368##2	7.13263e-17
C935	VPWR#12	a_855_368##7	6.17435e-19
C936	a_1997_272##2	RESET_B#11	5.367e-18
C937	D#5	SCE#6	6.93817e-19
C938	Q	a_2399_424##4	3.18454e-17
C939	VGND	a_1233_118##7	1.05196e-18
C940	RESET_B#15	RESET_B#13	1.86991e-17
C941	VGND	a_1034_368##11	1.61297e-18
C942	a_1034_368##7	a_1745_74##8	5.12589e-17
C943	a_1233_118##3	a_1034_368##4	4.04537e-17
C944	VGND#7	a_1034_368##2	5.41236e-21
C945	a_1233_118##7	a_1233_118##3	1.21951e-19
C946	a_1745_74##9	a_1034_368##6	3.57501e-17
C947	VPWR#9	SCE	6.89632e-18
C948	a_1745_74##10	a_1997_272##4	1.17214e-18
C949	a_1034_368##13	a_1034_368##2	4.05566e-19
C950	a_2399_424##2	VNB	2.5388e-17
C951	VGND#9	SCE	8.29756e-18
C952	a_1745_74##4	VNB	4.70999e-17
C953	a_855_368##4	VNB	3.65058e-17
C954	a_855_368##3	VNB	7.07212e-17
C955	RESET_B#5	VPWR#6	1.0496e-18
C956	a_855_368##2	VNB	1.68687e-16
C957	RESET_B#6	VNB	6.48422e-17
C958	a_225_81##2	a_27_88##4	7.16626e-19
C959	CLK#2	VNB	1.84366e-17
C960	RESET_B#2	VNB	3.81359e-17
C961	SCE#3	VNB	1.03165e-16
C962	VPWR#13	a_1997_272##3	1.71279e-19
C963	a_225_81##2	a_225_81#	1.01397e-18
C964	VGND#6	a_1034_368##2	3.12029e-20
C965	VGND#6	VGND#15	5.14845e-18
C966	VPWR#14	a_855_368##2	2.26998e-17
C967	CLK	RESET_B#15	2.5537e-17
C968	VGND#9	a_855_368##12	4.60245e-18
C969	VPWR#9	CLK	8.35173e-19
C970	VGND#9	a_855_368##10	2.2314e-18
C971	VGND#9	CLK	1.0807e-17
C972	a_855_368##8	a_1997_272##2	1.88848e-17
C973	a_1367_92##4	a_1034_368##6	5.9257e-19
C974	D#2	a_300_464##8	6.60633e-18
C975	a_1367_92##5	a_1233_118#	6.18415e-18
C976	VGND#9	CLK#1	8.36982e-19
C977	a_27_88##7	SCE#4	1.56812e-17
C978	a_1367_92##5	a_855_368##8	5.28323e-19
C979	VGND#8	VNB	2.56442e-17
C980	SCD	SCD#2	3.10527e-17
C981	VGND#7	VNB	5.9384e-17
C982	VGND#9	D	4.5337e-18
C983	a_855_368##7	a_1745_74##9	2.39301e-17
C984	VGND#6	VNB	8.59752e-17
C985	VGND#4	VNB	2.80802e-17
C986	VGND#3	VNB	3.89828e-17
C987	SCE#7	SCD	2.28324e-17
C988	D#5	D#3	4.4331e-18
C989	VPWR#8	VNB	6.38941e-17
C990	a_1233_118##7	RESET_B#7	1.70377e-18
C991	VPWR#7	VNB	4.57213e-17
C992	VPWR#6	VNB	3.49343e-17
C993	a_27_88##4	SCD	2.84784e-17
C994	VPWR#4	VNB	2.59637e-17
C995	RESET_B#10	a_1745_74##4	2.82797e-17
C996	VPWR#3	VNB	3.27598e-17
C997	VPWR#5	Q	1.81552e-17
C998	VPWR#9	RESET_B#13	2.36761e-18
C999	VPWR#13	a_1034_368##6	3.68328e-19
C1000	VGND#5	Q	1.99851e-17
C1001	SCD	D#2	3.77761e-19
C1002	a_225_81##2	D#2	1.88465e-18
C1003	a_2399_424##6	VNB	1.2012e-17
C1004	SCE	SCD#2	6.64298e-19
C1005	VGND#7	a_855_368##4	1.13199e-19
C1006	a_1997_272##5	VNB	3.02264e-18
C1007	VGND#9	RESET_B#1	4.93211e-18
C1008	a_1745_74##8	VNB	1.49607e-17
C1009	SCE#3	a_27_88##2	1.56884e-17
C1010	a_855_368##8	a_1034_368##7	9.24755e-19
C1011	a_1367_92##5	VGND#15	2.60404e-18
C1012	CLK	CLK#3	2.11778e-17
C1013	SCE	a_27_88##4	5.14607e-17
C1014	VPWR#7	a_1367_92##2	1.79231e-19
C1015	a_1034_368##5	a_1745_74##8	8.14811e-17
C1016	RESET_B#7	a_1233_118##3	9.16355e-18
C1017	a_2399_424##3	Q	3.79545e-17
C1018	a_1367_92##5	VNB	4.75389e-18
C1019	a_1233_118##6	VNB	3.56463e-18
C1020	CLK	RESET_B#4	3.9792e-18
C1021	a_1034_368##11	a_1233_118##3	1.71499e-18
C1022	SCE	D#2	3.27936e-17
C1023	a_1367_92##4	a_855_368##7	2.14396e-17
C1024	RESET_B#16	VNB	2.65753e-18
C1025	RESET_B#17	VPWR	1.16819e-18
C1026	a_300_464##5	VNB	1.67225e-18
C1027	a_27_88##2	SCE	6.3121e-17
C1028	a_300_464##4	VNB	7.67777e-18
C1029	a_855_368##12	VNB	3.10557e-18
C1030	VPWR#5	a_2399_424##4	5.42862e-18
C1031	RESET_B#13	VNB	3.0725e-18
C1032	CLK#4	a_855_368##6	4.87684e-17
C1033	VGND#9	SCD#1	4.0223e-18
C1034	a_1034_368##5	a_1997_272#	3.38865e-19
C1035	a_27_88##7	VNB	3.47067e-17
C1036	a_27_88##6	VNB	3.84535e-17
C1037	a_27_88##8	D#2	2.67154e-20
C1038	D#5	VNB	2.12856e-18
C1039	a_1233_118##5	a_1233_118#	7.78337e-20
C1040	RESET_B#2	CLK#4	1.94827e-18
C1041	VGND#12	VNB	1.12191e-17
C1042	a_2399_424##8	VNB	1.16154e-17
C1043	a_1745_74##9	a_1233_118#	1.78588e-18
C1044	VGND#13	VNB	2.57414e-18
C1045	a_1997_272##4	VNB	1.39315e-17
C1046	VGND#14	VNB	8.58735e-19
C1047	a_1745_74##10	VNB	3.60602e-18
C1048	D	D#2	8.19073e-18
C1049	a_300_464#	VNB	1.94549e-18
C1050	a_1034_368##11	VNB	4.16328e-17
C1051	a_27_88##2	D	3.45706e-17
C1052	a_1034_368##5	a_855_368##8	3.18804e-17
C1053	VGND#16	VNB	3.16278e-19
C1054	VPWR#13	a_855_368##7	2.85121e-18
C1055	VGND#9	SCE#6	4.03347e-18
C1056	VPWR#5	a_1745_74##6	6.61077e-18
C1057	a_855_368##14	VNB	3.06085e-18
C1058	VGND#17	VNB	1.98288e-18
C1059	a_225_81#	VNB	1.00032e-17
C1060	a_1233_118##7	a_1367_92##3	1.5007e-17
C1061	a_300_464##8	VNB	1.28802e-17
C1062	a_225_81##2	VNB	1.25852e-17
C1063	VGND#18	VNB	6.68007e-18
C1064	a_27_88##2	a_225_81##2	2.63332e-17
C1065	a_27_88##8	VNB	2.472e-17
C1066	VPWR#10	VNB	1.42242e-17
C1067	a_2399_424##7	VNB	1.40631e-17
C1068	VPWR#11	VNB	7.01843e-18
C1069	a_225_81##2	a_300_464##8	6.84254e-18
C1070	a_1997_272##7	VNB	3.01331e-18
C1071	a_1367_92##5	a_1034_368##4	3.1738e-17
C1072	VPWR#12	VNB	5.74239e-18
C1073	a_1745_74##10	VGND#14	1.87493e-17
C1074	a_1367_92##4	VNB	3.06864e-18
C1075	VPWR#13	VNB	5.32514e-18
C1076	a_1233_118##8	VNB	5.58296e-18
C1077	VPWR#14	VNB	7.34731e-18
C1078	a_300_464##8	CLK#2	2.40551e-20
C1079	VGND#9	RESET_B#13	3.20871e-18
C1080	a_1367_92##4	a_1233_118#	5.00913e-17
C1081	a_1034_368##5	a_1034_368##4	2.13976e-17
C1082	a_300_464##2	VNB	9.34992e-18
C1083	a_855_368##13	CLK#3	4.00659e-18
C1084	VGND#18	a_27_88##2	1.52227e-17
C1085	VPWR#15	VNB	2.16375e-19
C1086	a_855_368##13	VNB	1.31139e-18
C1087	a_1034_368##11	RESET_B#7	2.00801e-17
C1088	VPWR#5	a_1745_74##5	3.51306e-18
C1089	VPWR#16	VNB	1.00138e-18
C1090	a_2399_424##6	a_2399_424##2	8.39904e-19
C1091	a_300_464##6	VNB	7.52285e-18
C1092	a_855_368##3	a_855_368##2	2.20442e-19
C1093	VPWR#18	VNB	1.9908e-18
C1094	a_27_88##9	VNB	3.03174e-17
C1095	VPWR#8	a_1034_368##2	1.33855e-19
C1096	a_2399_424#	VNB	3.12516e-17
C1097	a_1233_118##6	RESET_B#8	1.01293e-18
C1098	a_1745_74#	VNB	5.69971e-17
C1099	a_1233_118##8	a_855_368##7	1.68441e-18
C1100	a_1745_74##3	VNB	2.5007e-17
C1101	RESET_B#11	VNB	3.32088e-17
C1102	a_1997_272#	VNB	2.71304e-17
C1103	VGND#5	a_1745_74##6	1.40891e-18
C1104	RESET_B#3	CLK#4	4.61647e-18
C1105	a_855_368##8	VNB	4.77443e-17
C1106	a_1034_368##4	VNB	4.00248e-17
C1107	a_1233_118##3	VNB	3.32407e-17
C1108	RESET_B#7	VNB	4.47608e-17
C1109	a_1367_92##3	VNB	2.47392e-17
C1110	a_1034_368#	VNB	3.08495e-17
C1111	a_1745_74##9	RESET_B#8	1.36313e-19
C1112	a_1034_368##5	a_1233_118##3	2.09905e-17
C1113	a_855_368##9	VNB	3.34636e-17
C1114	a_855_368##10	VNB	2.43886e-17
C1115	a_1233_118##2	a_855_368##8	5.58942e-19
C1116	CLK#1	VNB	2.86163e-17
C1117	a_1367_92##3	RESET_B#7	4.15982e-17
C1118	RESET_B#1	VNB	4.47227e-17
C1119	a_1745_74##8	a_1233_118##2	7.89929e-20
C1120	SCD#1	VNB	3.2026e-17
C1121	a_300_464#	a_1367_92##3	7.52622e-19
C1122	VGND#7	a_855_368##3	4.34595e-19
C1123	SCE#6	VNB	2.54186e-17
C1124	D#3	VNB	1.9302e-17
C1125	VGND#9	a_27_88#	1.96211e-20
C1126	a_27_88#	VNB	2.96287e-17
C1127	SCE#4	VNB	4.80716e-17
C1128	VGND#8	CLK#3	1.04728e-18
C1129	VPWR#7	a_1034_368##2	4.22294e-19
C1130	a_2399_424##4	VNB	4.27747e-17
C1131	a_1745_74##6	VNB	5.20745e-17
C1132	a_1745_74##5	VNB	3.7968e-17
C1133	a_1233_118#	VPWR#13	1.894e-17
C1134	RESET_B#9	VNB	3.23682e-17
C1135	a_1997_272##3	VNB	4.17383e-17
C1136	a_1034_368##6	VNB	2.68479e-17
C1137	a_855_368##7	VNB	1.3396e-16
C1138	a_1233_118#	VNB	4.24649e-17
C1139	RESET_B#8	VNB	2.74643e-17
C1140	a_1367_92#	VNB	2.86189e-17
C1141	a_855_368#	VNB	2.67966e-17
C1142	a_1034_368##3	VNB	2.73492e-17
C1143	a_300_464##2	a_1233_118##9	6.4316e-17
C1144	a_855_368##6	VNB	3.2145e-17
C1145	a_1034_368##5	RESET_B#7	6.93644e-18
C1146	CLK#4	VNB	4.67668e-17
C1147	a_1233_118##2	a_1034_368##4	2.6019e-18
C1148	RESET_B#3	VNB	3.15228e-17
C1149	SCD#3	VNB	2.803e-17
C1150	a_1233_118##5	RESET_B#8	1.15039e-17
C1151	a_27_88##3	VNB	2.26509e-17
C1152	D#1	VNB	5.19652e-17
C1153	VPWR#14	a_855_368##7	6.69145e-19
C1154	a_1233_118##7	a_1034_368#	3.68467e-17
C1155	SCE#1	VNB	2.8357e-17
C1156	VGND#7	CLK#3	1.70066e-19
C1157	SCE#5	VNB	4.25217e-17
C1158	RESET_B#17	VNB	9.26075e-18
C1159	VGND#18	a_300_464##8	2.08402e-18
C1160	a_855_368##13	RESET_B#4	3.93779e-18
C1161	VGND#9	SCE#4	4.95786e-18
C1162	VPWR#5	VNB	3.1624e-16
C1163	VGND#5	VNB	3.43791e-16
C1164	SCE	SCD	2.78909e-18
C1165	RESET_B#15	VNB	9.62789e-18
C1166	VPWR#9	VNB	3.56977e-16
C1167	VGND#9	VNB	3.76615e-16
C1168	a_2399_424##3	VNB	7.0433e-17
C1169	VPWR#5	a_1997_272##3	3.33732e-18
C1170	a_1745_74##2	VNB	8.5426e-17
C1171	RESET_B#10	VNB	7.37001e-17
C1172	a_1997_272##2	VNB	6.97898e-17
C1173	a_1034_368##7	VNB	3.36448e-17
C1174	a_1034_368##5	VNB	4.40453e-17
C1175	a_1233_118##2	VNB	4.50551e-17
C1176	RESET_B#5	VNB	1.99725e-18
C1177	a_1034_368##5	a_1367_92##3	1.98834e-19
C1178	a_1367_92##2	VNB	6.71127e-17
C1179	a_1034_368##2	VNB	5.51449e-17
C1180	a_1233_118##8	a_1233_118#	2.11667e-18
C1181	CLK#3	VNB	4.46632e-17
C1182	D	SCE	2.27854e-17
C1183	a_1034_368##11	a_1367_92##3	1.32188e-17
C1184	RESET_B#4	VNB	3.11484e-17
C1185	SCD#2	VNB	4.59443e-17
C1186	SCE#7	VNB	5.38797e-17
C1187	a_27_88##4	VNB	5.92561e-17
C1188	D#2	VNB	6.71489e-17
C1189	VPWR#9	a_27_88##6	6.93803e-18
C1190	a_27_88##2	VNB	5.08944e-17
C1191	a_1367_92##5	a_1233_118##3	2.62219e-17
C1192	RESET_B#17	a_855_368##7	4.61234e-18
C1193	SCD#3	RESET_B#3	1.75952e-17
C1194	a_1367_92##5	RESET_B#6	5.97965e-19
C1195	VPWR#5	a_1034_368##6	4.97638e-18
C1196	a_1233_118##2	RESET_B#7	1.98445e-17
C1197	VPWR#13	RESET_B#8	2.92526e-18
C1198	a_1367_92##5	VPWR#13	9.38734e-18
C1199	a_300_464#	a_1034_368#	6.99982e-18
C1200	a_1233_118##6	a_1367_92#	2.97034e-17
C1201	SCD	VNB	3.14086e-18
C1202	a_2399_424##6	a_1745_74##4	1.20342e-18
C1203	SCE	VNB	9.76821e-18
C1204	CLK	VNB	1.63213e-17
C1205	D	VNB	1.84494e-18
C1206	Q	VNB	1.17619e-16
C1207	VPWR	VNB	1.83212e-18
C1208	VPWR#14	a_1233_118#	1.18904e-18
C1209	VGND	VNB	2.48361e-18
C1210	VGND#3	a_2399_424#	3.64738e-19
C1211	RESET_B#17	a_1233_118#	2.71658e-18
C1212	RESET_B	VPWR#11	1.7667e-18
C1213	VPWR#17	SCE#1	4.02211e-18
C1214	VPWR#5	VPWR#2	8.13009e-17
C1215	VGND#9	VGND#10	1.4513e-16
C1216	RESET_B	RESET_B#10	1.77143e-17
C1217	a_2399_424##3	VPWR#2	8.68451e-19
C1218	a_27_88##6	VPWR#17	1.782e-18
C1219	VPWR#17	a_27_88##2	3.61183e-19
C1220	VGND#10	a_27_88##2	2.90355e-18
C1221	RESET_B	a_2399_424##7	1.13617e-18
C1222	VGND#2	a_1745_74#	8.45546e-19
C1223	RESET_B	a_1745_74##2	5.17301e-18
C1224	RESET_B	a_1997_272##3	1.05809e-18
C1225	RESET_B	VPWR#4	2.57345e-18
C1226	RESET_B	VNB	1.30679e-17
C1227	RESET_B	VPWR#10	2.1798e-18
C1228	a_2399_424##7	VPWR#2	7.71149e-18
C1229	RESET_B	a_1745_74##4	3.0899e-18
C1230	a_1745_74##8	RESET_B	4.29866e-17
C1231	VPWR#17	D#1	7.87866e-18
C1232	VGND#10	a_27_88#	4.20816e-18
C1233	VGND#2	a_2399_424##8	5.95528e-18
C1234	a_1997_272##5	RESET_B	5.60172e-17
C1235	VPWR#17	D#2	9.21328e-20
C1236	Q	VPWR#2	1.78941e-17
C1237	VPWR#2	VNB	4.96096e-17
C1238	VGND#2	Q	1.97436e-17
C1239	VGND#2	a_2399_424#	6.35596e-18
C1240	RESET_B	a_2399_424##4	4.3702e-21
C1241	VGND#10	a_27_88##7	2.78745e-19
C1242	VGND#10	D#2	1.18155e-19
C1243	VGND#5	RESET_B	1.93954e-18
C1244	VPWR#2	a_2399_424##4	2.08076e-18
C1245	VGND#10	SCE#3	4.29083e-20
C1246	VPWR#3	VPWR#2	8.48256e-19
C1247	VGND#2	a_2399_424##3	9.89137e-19
C1248	VGND#3	VGND#2	9.78682e-19
C1249	RESET_B	a_2399_424##6	1.28321e-18
C1250	VPWR#17	VNB	7.31784e-17
C1251	VPWR#5	RESET_B	4.68558e-17
C1252	a_27_88##4	VPWR#17	7.76582e-19
C1253	VPWR#9	VPWR#17	1.28896e-16
C1254	VGND#10	a_225_81##2	7.7387e-17
C1255	a_1745_74##9	RESET_B	3.2348e-17
C1256	VGND#2	VNB	4.93294e-17
C1257	a_300_464##6	VPWR#17	2.63722e-17
C1258	VPWR#17	SCE#5	2.56458e-18
C1259	RESET_B	a_1745_74##10	8.91744e-19
C1260	VGND#10	D#3	3.98674e-18
C1261	RESET_B	a_1034_368##5	2.8162e-19
C1262	VGND#10	a_27_88##8	1.40247e-17
C1263	a_27_88##9	VPWR#17	2.07971e-17
C1264	RESET_B	VPWR#12	1.83947e-17
C1265	RESET_B	a_1034_368##7	2.81837e-17
C1266	VGND#10	SCE#4	1.09111e-18
C1267	VGND#10	VNB	7.76499e-17
C1268	RESET_B	VGND#14	4.27149e-18
C1269	RESET_B	a_1997_272##7	1.20276e-17
C1270	a_1997_272##2	RESET_B	2.14683e-17
C1271	VGND#5	VGND#2	9.53347e-17
C1272	VGND#13	VGND#2	1.72857e-19
C1273	RESET_B	a_1972_74#	6.04242e-19
C1274	RESET_B	a_855_368##7	1.28725e-18
*
*
.ENDS sky130_fd_sc_hs__sdfrtp_1
*
