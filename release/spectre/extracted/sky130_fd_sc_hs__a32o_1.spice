* Extracted by Quantus, converted by sky130cad/quantus.py
*
*
*
*                       LINUX           Wed Nov 18 08:13:43 2026
*
*
*
*  PROGRAM  advgen
*
*  Name           : advgen - Quantus - (64-bit)
*  Version        : 25.1.0-p047
*  Build Date     : Thu Dec 11 23:20:30 PST 2025
*
*  HSPICE LIBRARY
*
*  OPERATING_TEMPERATURE 150
*  QRC_TECH_DIR <path>/tech
*
*
*

*
.SUBCKT sky130_fd_sc_hs__a32o_1 VPB VNB VGND VPWR X A3 A2 A1 B1 B2
*
*
*  caps2d version: 10
*
*
*       TRANSISTOR CARDS
*
*
XM9 X#1 a_84_48##3 VGND#5 VNB sky130_fd_pr__nfet_01v8_lvt l=0.15 w=0.74 ad=0.2109 as=0.418 pd=2.05 ps=2.63
XM10 VGND#5 A3#1 a_259_94# VNB sky130_fd_pr__nfet_01v8_lvt l=0.15 w=0.64 ad=0.418 as=0.1536 pd=2.63 ps=1.76
XM8 a_259_94# A2#1 a_337_94# VNB sky130_fd_pr__nfet_01v8_lvt l=0.15 w=0.64 ad=0.1536 as=0.2496 pd=1.76 ps=2.06
XM11 a_337_94# A1#3 a_84_48##6 VNB sky130_fd_pr__nfet_01v8_lvt l=0.15 w=0.64 ad=0.2496 as=0.4032 pd=2.06 ps=2.54
XM4 a_84_48##6 B1#1 a_601_94# VNB sky130_fd_pr__nfet_01v8_lvt l=0.15 w=0.64 ad=0.4032 as=0.1536 pd=2.54 ps=1.76
XM1 a_601_94# B2#3 VGND#1 VNB sky130_fd_pr__nfet_01v8_lvt l=0.15 w=0.64 ad=0.1536 as=0.1824 pd=1.76 ps=1.85
XM5 X#3 a_84_48# VPWR#6 VPB sky130_fd_pr__pfet_01v8 l=0.15 w=1.12 ad=0.3304 as=0.5214 pd=2.83 ps=3.2
XM2 VPWR#6 A3#3 a_244_368##4 VPB sky130_fd_pr__pfet_01v8 l=0.15 w=1 ad=0.5214 as=0.3 pd=3.2 ps=2.6
XM7 a_244_368##4 A2#3 VPWR#5 VPB sky130_fd_pr__pfet_01v8 l=0.15 w=1 ad=0.3 as=0.59 pd=2.6 ps=3.18
XM6 VPWR#5 A1#1 a_244_368##2 VPB sky130_fd_pr__pfet_01v8 l=0.15 w=1 ad=0.59 as=0.3 pd=3.18 ps=2.6
XM3 a_244_368##2 B1#3 a_84_48##4 VPB sky130_fd_pr__pfet_01v8 l=0.15 w=1 ad=0.3 as=0.4 pd=2.6 ps=2.8
XM0 a_84_48##4 B2#1 a_244_368# VPB sky130_fd_pr__pfet_01v8 l=0.15 w=1 ad=0.4 as=0.295 pd=2.8 ps=2.59
*
*
*       RESISTOR AND CAP/DIODE CARDS
*
Rg1	a_84_48#	a_84_48##2	456.264679
Rg2	a_84_48##2	a_84_48##3	353.264496
Rg3	A3#1	A3#2	279.244598
Rg4	A3#2	A3#3	457.627838
Rg5	A2#1	A2#2	279.244598
Rg6	A2#2	A2#3	457.627838
Rg7	A1#1	A1#2	474.591675
Rg8	A1#2	A1#3	299.494476
Rg9	B1#1	B1#2	279.244598
Rg10	B1#2	B1#3	457.627838
Rg11	B2#1	B2#2	453.045471
Rg12	B2#2	B2#3	274.662231
Rf1	X	X#2	6.703401
Rf2	X	X#3	90.435631
Rf3	X#2	X	6.703401
Rf4	X#1	X#2	7.500000
Rf5	A3#4	A3	1.268211
Rf6	A3#2	A3#6	161.501007
Rf7	A3#4	A3#6	3.349972
Rf8	A2#2	A2	163.775864
Rf9	A1	A1#4	0.905865
Rf10	A1#5	A1#2	161.138672
Rf11	A1#4	A1#5	3.543054
Rf12	B1	B1#4	1.288721
Rf13	B1#5	B1#2	161.521530
Rf14	B1#4	B1#5	7.246919
Rf15	a_84_48##4	a_84_48##5	203.411667
Rf16	a_84_48##5	a_84_48##6	155.128815
Rf17	B2#4	B2#2	161.623566
Rf18	B2	B2#6	1.390769
Rf19	B2#4	B2#6	5.548359
Rf20	a_244_368#	a_244_368##3	111.866241
Rf21	a_244_368##3	a_244_368##4	103.936546
Rf22	a_244_368##2	a_244_368##3	7.500000
Rf23	VGND#1	VGND#2	149.397903
Rf24	VGND#2	VGND#3	78.108322
Rf26	VGND#3	VGND#5	30.086149
Rf28	VPWR#2	VPWR#3	81.179619
Rf30	VPWR#2	VPWR#5	45.288342
Rf31	VPWR#3	VPWR#6	41.752529
Rf36	a_84_48##2	a_84_48##5	160.232803
Re1	VPWR#2	VPWR	1.227783
Re2	VGND	VGND#2	1.227829
*
*       CAPACITOR CARDS
*
*
C1	VGND	VNB	7.01469e-17
C2	VPWR	VNB	6.93715e-17
C3	X	VNB	5.79896e-17
C4	A3	VNB	1.61999e-18
C5	A2	VNB	1.64913e-18
C6	VGND	X	1.72539e-17
C7	VGND	A3	2.89892e-18
C8	VGND	A2	2.77942e-18
C9	a_84_48##2	VNB	4.97328e-17
C10	A3#2	VNB	2.64426e-17
C11	A2#2	VNB	2.89407e-17
C12	A1#2	VNB	3.50317e-17
C13	B1#2	VNB	3.4213e-17
C14	A3	A2	1.13972e-17
C15	B2#2	VNB	5.13785e-17
C16	VGND#2	VNB	2.17611e-16
C17	VGND	a_84_48##2	1.37484e-17
C18	a_84_48#	VNB	4.22723e-17
C19	A3#3	VNB	3.73165e-17
C20	VGND	A3#2	1.43901e-19
C21	A2#3	VNB	4.00665e-17
C22	VGND	A2#2	3.32079e-19
C23	A1#1	VNB	3.4843e-17
C24	B1#3	VNB	3.4583e-17
C25	VGND	A1#2	4.42773e-19
C26	B2#1	VNB	4.29607e-17
C27	VGND	B1#2	3.32079e-19
C28	a_84_48##3	VNB	3.60539e-17
C29	VGND	B2#2	1.40988e-20
C30	A3#1	VNB	2.74752e-17
C31	VPWR	a_84_48##2	7.64428e-18
C32	VGND	VGND#2	3.52295e-17
C33	A2#1	VNB	2.39013e-17
C34	A1#3	VNB	2.58614e-17
C35	B1#1	VNB	2.30789e-17
C36	B2#3	VNB	2.11222e-17
C37	VPWR	A2#2	1.91557e-18
C38	X#3	VNB	6.32267e-17
C39	a_244_368##4	VNB	2.55182e-18
C40	VPWR#5	VNB	4.51874e-18
C41	X	a_84_48##2	6.60795e-17
C42	a_244_368##2	VNB	6.65677e-18
C43	a_84_48##4	VNB	1.35318e-17
C44	a_244_368#	VNB	6.83806e-17
C45	X	A3#2	3.84674e-19
C46	VGND#5	VNB	7.34693e-18
C47	VGND	a_84_48##3	2.27657e-18
C48	a_84_48##6	VNB	5.19937e-18
C49	a_84_48##2	A3	5.156e-17
C50	VGND	A3#1	9.07752e-18
C51	VPWR	a_84_48#	3.83261e-18
C52	VGND#1	VNB	7.94846e-17
C53	VGND	A2#1	9.56279e-18
C54	A3	A3#2	7.3122e-18
C55	VPWR	A3#3	7.37508e-18
C56	VGND	A1#3	7.31245e-18
C57	A3#6	VNB	1.30347e-19
C58	VGND	B1#1	7.31245e-18
C59	VPWR	A2#3	9.15527e-18
C60	VGND	B2#3	4.11639e-18
C61	A3	A2#2	1.77663e-18
C62	A1#4	VNB	1.49552e-18
C63	VPWR	A1#1	3.91541e-18
C64	VGND	X#3	1.52804e-18
C65	A1#5	VNB	1.69899e-18
C66	B1#4	VNB	8.01797e-19
C67	B1#5	VNB	3.20151e-18
C68	A2	A3#2	1.28446e-18
C69	B2#4	VNB	8.58483e-19
C70	VGND	a_84_48##4	8.99236e-18
C71	A2	A2#2	8.19773e-18
C72	B2#6	VNB	1.86889e-17
C73	VGND	a_244_368#	4.30567e-18
C74	A2	A1#2	2.06705e-18
C75	VGND	VGND#5	2.21472e-17
C76	VGND	a_84_48##6	3.45126e-17
C77	VGND	VGND#1	5.37073e-17
C78	VPWR	X#3	1.99691e-17
C79	a_84_48##6	a_84_48##4	6.66618e-18
C80	VPWR	a_244_368##4	1.63592e-17
C81	X	a_84_48##3	2.93236e-17
C82	X	A3#1	2.34433e-18
C83	VPWR	a_244_368##2	2.29642e-17
C84	VGND	A1#4	2.77942e-18
C85	X	A2#1	3.75295e-19
C86	VPWR	a_84_48##4	1.15467e-17
C87	VPWR	a_244_368#	2.73152e-17
C88	X	A1#3	3.49212e-19
C89	VGND	B1#4	1.67302e-18
C90	VGND	B1#5	3.56894e-18
C91	X	X#3	3.32175e-18
C92	VGND	B2#4	2.2923e-18
C93	A3	a_84_48##3	1.85377e-19
C94	VGND	B2#6	1.00142e-18
C95	a_84_48##2	a_259_94#	2.08654e-18
C96	VPWR	A3#6	2.03254e-18
C97	X	X#1	3.73302e-18
C98	X	VGND#5	2.71176e-17
C99	VPWR	A1#5	1.93667e-18
C100	VPWR	B1#4	1.11636e-18
C101	A2#2	a_337_94#	8.11786e-19
C102	VPWR	B1#5	1.35858e-18
C103	VGND#1	a_84_48##4	1.31229e-18
C104	VPWR	B2#4	1.62248e-18
C105	VPWR	B2#6	1.44236e-18
C106	a_84_48##2	A3#2	4.21961e-17
C107	VGND#5	a_84_48##6	6.68751e-18
C108	A2#2	a_84_48##2	4.38511e-17
C109	a_84_48##2	A1#2	1.18849e-19
C110	A3#2	A2#2	3.74497e-17
C111	a_84_48##6	A2	4.0239e-17
C112	a_84_48##2	B1#2	6.19808e-20
C113	A2#2	A1#2	2.53355e-17
C114	A3#6	A2	3.2406e-18
C115	A2	A1#4	9.87374e-18
C116	A3#1	a_259_94#	1.21877e-17
C117	A2	A1#5	2.96854e-18
C118	A2#1	a_259_94#	1.21877e-17
C119	A1#2	B1#2	2.61455e-17
C120	VGND#2	A2#2	4.47194e-19
C121	a_84_48##2	a_84_48#	3.85773e-18
C122	A2#1	a_337_94#	1.59406e-17
C123	a_84_48##2	A3#3	2.49671e-17
C124	VGND#2	A1#2	2.16114e-19
C125	B1#2	B2#2	2.9073e-17
C126	A1#3	a_337_94#	1.59406e-17
C127	a_84_48##2	A2#3	1.39604e-17
C128	VGND#2	B1#2	1.66236e-19
C129	B1#1	a_601_94#	1.48128e-17
C130	B2#3	a_601_94#	1.54437e-17
C131	A1#5	a_84_48##4	4.14149e-17
C132	a_84_48##2	a_84_48##3	6.59278e-18
C133	VGND#1	a_84_48##6	2.4051e-17
C134	a_84_48##2	A3#1	2.9966e-17
C135	a_84_48##3	A3#2	6.2832e-19
C136	a_84_48##2	A2#1	5.46289e-19
C137	a_84_48##6	a_259_94#	3.07826e-18
C138	a_84_48##2	A1#3	3.36283e-19
C139	a_84_48##2	B1#1	2.53983e-19
C140	B1#4	a_84_48##4	2.33867e-17
C141	a_84_48##6	a_337_94#	7.3799e-18
C142	X#3	a_84_48##2	3.29078e-17
C143	a_84_48##2	VPWR#6	4.48554e-17
C144	B1#5	a_84_48##4	3.01804e-17
C145	a_84_48##2	a_244_368##4	6.55701e-17
C146	a_84_48#	A3#3	2.3512e-17
C147	a_84_48##2	VPWR#5	6.01544e-19
C148	VPWR#6	A3#2	5.6165e-19
C149	A3#3	A2#3	4.34627e-17
C150	a_244_368##4	A2#2	6.15445e-19
C151	VPWR#5	A2#2	8.0638e-19
C152	a_84_48##2	VGND#5	4.93347e-17
C153	VGND#2	A2#1	6.93531e-18
C154	A2#3	A1#1	1.44675e-17
C155	VGND#2	A1#3	4.58768e-18
C156	VPWR#5	A1#2	8.44863e-19
C157	A3#2	VGND#5	1.83755e-18
C158	a_84_48##6	a_84_48##2	5.28493e-18
C159	VGND#2	B1#1	1.39544e-18
C160	a_244_368##2	A1#2	6.86274e-19
C161	a_84_48##6	A1#4	4.25102e-17
C162	A1#1	B1#3	4.44524e-17
C163	VGND#2	B2#3	3.49357e-20
C164	a_84_48##4	A1#2	2.88986e-18
C165	B2#4	a_244_368#	1.06549e-17
C166	a_84_48##4	B1#2	3.31531e-18
C167	B1#3	B2#1	2.92081e-17
C168	a_84_48##2	A3#6	6.06592e-17
C169	a_244_368#	B1#2	7.3961e-19
C170	a_84_48##6	A2#2	2.38758e-18
C171	B2#6	a_244_368#	1.16139e-17
C172	A3#6	A3#2	8.64357e-18
C173	a_244_368#	B2#2	3.45987e-18
C174	A1#2	a_84_48##6	6.80464e-18
C175	a_84_48##6	B1#4	2.69192e-17
C176	X#3	a_84_48#	4.95524e-17
C177	a_84_48#	VPWR#6	3.28728e-17
C178	A3#6	A2#2	1.56709e-17
C179	B1#2	a_84_48##6	4.06666e-18
C180	X#3	A3#3	1.65392e-18
C181	a_84_48##6	B1#5	1.3816e-17
C182	A3#3	VPWR#6	2.46292e-17
C183	VPWR#5	a_84_48#	2.79679e-19
C184	X#3	A2#3	5.23851e-19
C185	A1#4	A2#2	1.66873e-18
C186	a_244_368##4	A3#3	4.44837e-17
C187	a_244_368##2	a_84_48#	4.48309e-19
C188	A2#2	A1#5	1.36899e-17
C189	a_84_48##3	A3#1	1.28156e-17
C190	X#3	A1#1	2.39368e-19
C191	VPWR#5	A3#3	6.62253e-19
C192	B2#2	VGND#1	6.74896e-18
C193	a_244_368##4	A2#3	6.19273e-17
C194	VGND#2	a_84_48##6	3.21706e-17
C195	A1#4	A1#2	6.98301e-18
C196	A2#3	VPWR#5	3.64977e-17
C197	A1#5	A1#2	9.36022e-18
C198	VGND#1	B1#5	1.0892e-18
C199	a_84_48##4	A3#3	2.07819e-19
C200	a_244_368##4	A1#1	1.21236e-18
C201	A3#1	A2#1	4.41366e-17
C202	VGND#2	VGND#1	4.28035e-17
C203	a_244_368##2	A2#3	1.32465e-18
C204	A1#1	VPWR#5	3.20503e-17
C205	A1#4	B1#2	1.04476e-18
C206	B1#4	A1#2	6.69601e-18
C207	a_84_48##4	A2#3	3.91056e-19
C208	A1#5	B1#2	1.11977e-18
C209	a_244_368##2	A1#1	5.97607e-17
C210	A2#1	A1#3	2.39752e-17
C211	a_84_48##4	A1#1	1.92532e-17
C212	B1#4	B1#2	6.02204e-18
C213	a_244_368##2	B1#3	5.64791e-17
C214	B1#5	B1#2	1.51741e-17
C215	a_84_48##4	B1#3	4.24266e-17
C216	A1#3	B1#1	8.04384e-18
C217	a_244_368##2	B2#1	8.39115e-19
C218	VGND#1	B2#4	2.221e-17
C219	a_244_368#	B1#3	2.39205e-18
C220	B2#1	a_84_48##4	3.4719e-17
C221	B1#5	B2#2	7.18359e-18
C222	B2#4	B1#2	3.1476e-18
C223	a_244_368#	B2#1	5.20217e-17
C224	B1#1	B2#3	4.77297e-17
C225	B2#4	B2#2	1.61912e-17
C226	VGND#1	B2#6	1.69858e-17
C227	B2#6	B2#2	1.09326e-17
C228	A1#4	B1#4	1.27065e-17
C229	a_84_48##3	X#1	7.69451e-18
C230	a_84_48##3	VGND#5	2.6339e-17
C231	X#3	VPWR#6	6.55585e-17
C232	A1#5	B1#4	1.81207e-17
C233	A3#1	VGND#5	2.70352e-17
C234	VPWR#6	a_244_368##4	5.37839e-17
C235	VGND#5	A2#1	2.69414e-18
C236	a_84_48##6	a_84_48##3	1.27585e-18
C237	VGND#5	A1#3	1.7588e-18
C238	a_84_48##6	A3#1	1.5049e-18
C239	a_244_368##4	VPWR#5	4.88365e-17
C240	VGND#5	B1#1	4.84373e-19
C241	a_84_48##6	A2#1	2.38475e-17
C242	a_244_368##4	a_244_368##2	2.04868e-18
C243	VGND#1	A3#1	3.78816e-19
C244	a_84_48##6	A1#3	5.70698e-17
C245	a_84_48##4	a_244_368##4	3.11206e-18
C246	a_244_368##2	VPWR#5	5.50456e-17
C247	VGND#1	A2#1	3.70347e-19
C248	a_84_48##4	VPWR#5	1.01541e-18
C249	a_84_48##6	B1#1	4.79707e-17
C250	VGND#1	A1#3	7.56642e-19
C251	a_84_48##4	a_244_368##2	1.31137e-16
C252	a_84_48##6	B2#3	7.59715e-18
C253	VGND#1	B1#1	1.19792e-17
C254	a_244_368##2	a_244_368#	2.64007e-18
C255	VGND#1	B2#3	3.88541e-17
C256	a_84_48##4	a_244_368#	1.10095e-16
C257	B1#5	B2#4	1.94752e-17
C258	VPWR#3	A3#3	1.07295e-17
C259	VPWR#3	a_84_48#	1.66814e-17
C260	VPWR#2	VPWR#3	6.21521e-17
C261	a_84_48##2	VPWR#3	6.93947e-19
C262	VPWR#3	VPWR#5	2.74637e-18
C263	VPWR#3	a_244_368##4	1.78364e-17
C264	VPWR#3	VPWR#6	6.10547e-18
C265	X#3	VPWR#3	4.54923e-17
C266	VPWR	VPWR#3	6.67195e-17
C267	VPWR#3	VNB	5.9064e-17
C268	VPWR#3	A1#1	3.22608e-19
C269	VPWR#3	A2#3	8.25349e-19
C270	VPWR#2	VNB	2.56795e-16
C271	VGND#2	VGND#3	6.2427e-17
C272	a_244_368#	VPWR#2	6.54216e-17
C273	VGND#3	A3#1	6.90271e-18
C274	VPWR#2	a_84_48#	7.27859e-19
C275	VGND#3	a_84_48##3	4.98546e-18
C276	VPWR#2	A1#1	4.16804e-18
C277	a_244_368##4	VPWR#2	4.74423e-18
C278	VPWR	VPWR#2	7.5735e-17
C279	VGND#3	X	2.22685e-17
C280	VPWR#2	B2#2	7.38289e-20
C281	VGND#3	a_84_48##2	2.7318e-18
C282	VPWR#2	A2#3	4.6039e-18
C283	VPWR#2	B2#1	3.20504e-18
C284	VGND	VGND#3	4.10343e-17
C285	a_244_368##2	VPWR#2	5.03383e-17
C286	VGND#3	VNB	5.54903e-17
C287	VGND#3	a_84_48##6	5.80633e-19
C288	VPWR#2	B1#2	1.15465e-19
C289	VPWR#2	B1#3	3.19421e-18
*
*
.ENDS sky130_fd_sc_hs__a32o_1
*
