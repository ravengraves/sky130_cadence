* Extracted by Quantus, converted by sky130cad/quantus.py
*
*
*
*                       LINUX           Wed Nov 18 08:35:58 2026
*
*
*
*  PROGRAM  advgen
*
*  Name           : advgen - Quantus - (64-bit)
*  Version        : 25.1.0-p047
*  Build Date     : Thu Dec 11 23:20:30 PST 2025
*
*  HSPICE LIBRARY
*
*  OPERATING_TEMPERATURE 150
*  QRC_TECH_DIR <path>/tech
*
*
*

*
.SUBCKT sky130_fd_sc_hs__ebufn_8 VPB VNB VGND VPWR Z TE_B A
*
*
*  caps2d version: 10
*
*
*       TRANSISTOR CARDS
*
*
XM35 a_27_74##10 a_84_48##11 Z#5 VNB sky130_fd_pr__nfet_01v8_lvt l=0.15 w=0.74 ad=0.2109 as=0.2072 pd=2.05 ps=2.04
XM33 a_27_74##16 a_84_48##23 Z#5 VNB sky130_fd_pr__nfet_01v8_lvt l=0.15 w=0.74 ad=0.2257 as=0.2072 pd=2.09 ps=2.04
XM21 a_27_74##16 a_84_48##21 Z#7 VNB sky130_fd_pr__nfet_01v8_lvt l=0.15 w=0.74 ad=0.2257 as=0.2072 pd=2.09 ps=2.04
XM0 a_27_74##15 a_84_48##20 Z#7 VNB sky130_fd_pr__nfet_01v8_lvt l=0.15 w=0.74 ad=0.259 as=0.2072 pd=2.18 ps=2.04
XM31 Z#6 a_84_48##17 a_27_74##15 VNB sky130_fd_pr__nfet_01v8_lvt l=0.15 w=0.74 ad=0.259 as=0.259 pd=2.18 ps=2.18
XM14 Z#6 a_84_48##15 a_27_74##14 VNB sky130_fd_pr__nfet_01v8_lvt l=0.15 w=0.74 ad=0.259 as=0.2701 pd=2.18 ps=2.21
XM28 Z#1 a_84_48##13 a_27_74##14 VNB sky130_fd_pr__nfet_01v8_lvt l=0.15 w=0.74 ad=0.2479 as=0.2701 pd=2.15 ps=2.21
XM12 Z#1 a_84_48# a_27_74##5 VNB sky130_fd_pr__nfet_01v8_lvt l=0.15 w=0.74 ad=0.2479 as=0.2072 pd=2.15 ps=2.04
XM3 a_27_74##5 a_833_48##9 VGND#13 VNB sky130_fd_pr__nfet_01v8_lvt l=0.15 w=0.74 ad=0.2072 as=0.2072 pd=2.04 ps=2.04
XM24 a_27_74##13 a_833_48##16 VGND#13 VNB sky130_fd_pr__nfet_01v8_lvt l=0.15 w=0.74 ad=0.2072 as=0.2072 pd=2.04 ps=2.04
XM22 VGND#12 a_833_48##15 a_27_74##13 VNB sky130_fd_pr__nfet_01v8_lvt l=0.15 w=0.74 ad=0.2072 as=0.2072 pd=2.04 ps=2.04
XM18 a_27_74##12 a_833_48##14 VGND#12 VNB sky130_fd_pr__nfet_01v8_lvt l=0.15 w=0.74 ad=0.2072 as=0.2072 pd=2.04 ps=2.04
XM26 VGND#11 a_833_48##13 a_27_74##12 VNB sky130_fd_pr__nfet_01v8_lvt l=0.15 w=0.74 ad=0.2072 as=0.2072 pd=2.04 ps=2.04
XM23 a_27_74##11 a_833_48##12 VGND#11 VNB sky130_fd_pr__nfet_01v8_lvt l=0.15 w=0.74 ad=0.2072 as=0.2072 pd=2.04 ps=2.04
XM37 VGND#10 a_833_48##11 a_27_74##11 VNB sky130_fd_pr__nfet_01v8_lvt l=0.15 w=0.74 ad=0.2072 as=0.2072 pd=2.04 ps=2.04
XM32 VGND#10 a_833_48##10 a_27_74# VNB sky130_fd_pr__nfet_01v8_lvt l=0.15 w=0.74 ad=0.2072 as=0.2109 pd=2.04 ps=2.05
XM34 a_833_48##19 TE_B#1 VGND#9 VNB sky130_fd_pr__nfet_01v8_lvt l=0.15 w=0.74 ad=0.2109 as=0.2072 pd=2.05 ps=2.04
XM5 VGND#9 A#7 a_84_48##26 VNB sky130_fd_pr__nfet_01v8_lvt l=0.15 w=0.74 ad=0.2072 as=0.2072 pd=2.04 ps=2.04
XM29 a_84_48##26 A#1 VGND#1 VNB sky130_fd_pr__nfet_01v8_lvt l=0.15 w=0.74 ad=0.2072 as=0.2146 pd=2.04 ps=2.06
XM13 Z#9 a_84_48##25 a_28_368##11 VPB sky130_fd_pr__pfet_01v8 l=0.15 w=1.12 ad=0.336 as=0.3304 pd=2.84 ps=2.83
XM30 a_28_368##16 a_84_48##24 Z#9 VPB sky130_fd_pr__pfet_01v8 l=0.15 w=1.12 ad=0.336 as=0.336 pd=2.84 ps=2.84
XM19 a_28_368##16 a_84_48##22 Z#11 VPB sky130_fd_pr__pfet_01v8 l=0.15 w=1.12 ad=0.336 as=0.392 pd=2.84 ps=2.94
XM17 Z#11 a_84_48##19 a_28_368##15 VPB sky130_fd_pr__pfet_01v8 l=0.15 w=1.12 ad=0.392 as=0.336 pd=2.94 ps=2.84
XM10 Z#13 a_84_48##18 a_28_368##15 VPB sky130_fd_pr__pfet_01v8 l=0.15 w=1.12 ad=0.336 as=0.336 pd=2.84 ps=2.84
XM36 a_28_368##14 a_84_48##16 Z#13 VPB sky130_fd_pr__pfet_01v8 l=0.15 w=1.12 ad=0.392 as=0.336 pd=2.94 ps=2.84
XM7 Z#14 a_84_48##14 a_28_368##14 VPB sky130_fd_pr__pfet_01v8 l=0.15 w=1.12 ad=0.3752 as=0.392 pd=2.91 ps=2.94
XM27 a_28_368##6 a_84_48##12 Z#14 VPB sky130_fd_pr__pfet_01v8 l=0.15 w=1.12 ad=0.3528 as=0.3752 pd=2.87 ps=2.91
XM8 a_28_368##6 TE_B#11 VPWR#13 VPB sky130_fd_pr__pfet_01v8 l=0.15 w=1.12 ad=0.3528 as=0.448 pd=2.87 ps=3.04
XM4 VPWR#13 TE_B#19 a_28_368##13 VPB sky130_fd_pr__pfet_01v8 l=0.15 w=1.12 ad=0.448 as=0.336 pd=3.04 ps=2.84
XM6 VPWR#12 TE_B#18 a_28_368##13 VPB sky130_fd_pr__pfet_01v8 l=0.15 w=1.12 ad=0.448 as=0.336 pd=3.04 ps=2.84
XM25 a_28_368##12 TE_B#17 VPWR#12 VPB sky130_fd_pr__pfet_01v8 l=0.15 w=1.12 ad=0.336 as=0.448 pd=2.84 ps=3.04
XM9 a_28_368##12 TE_B#16 VPWR#11 VPB sky130_fd_pr__pfet_01v8 l=0.15 w=1.12 ad=0.336 as=0.448 pd=2.84 ps=3.04
XM16 VPWR#11 TE_B#15 a_28_368##2 VPB sky130_fd_pr__pfet_01v8 l=0.15 w=1.12 ad=0.448 as=0.336 pd=3.04 ps=2.84
XM20 VPWR#10 TE_B#14 a_28_368##2 VPB sky130_fd_pr__pfet_01v8 l=0.15 w=1.12 ad=0.5757 as=0.336 pd=3.52 ps=2.84
XM1 a_28_368# TE_B#13 VPWR#10 VPB sky130_fd_pr__pfet_01v8 l=0.15 w=1.12 ad=0.3304 as=0.5757 pd=2.83 ps=3.52
XM2 a_833_48##17 TE_B#12 VPWR#9 VPB sky130_fd_pr__pfet_01v8 l=0.15 w=1.12 ad=0.5712 as=0.392 pd=3.26 ps=2.94
XM11 VPWR#9 A#5 a_84_48##27 VPB sky130_fd_pr__pfet_01v8 l=0.15 w=1.12 ad=0.392 as=0.336 pd=2.94 ps=2.84
XM15 a_84_48##27 A#6 VPWR#1 VPB sky130_fd_pr__pfet_01v8 l=0.15 w=1.12 ad=0.336 as=0.3304 pd=2.84 ps=2.83
*
*
*       RESISTOR AND CAP/DIODE CARDS
*
Rg1	a_84_48#	a_84_48##2	380.339874
Rg2	a_84_48##2	a_84_48##3	73.260269
Rg3	a_84_48##3	a_84_48##4	89.264084
Rg4	a_84_48##4	a_84_48##5	85.903648
Rg5	a_84_48##5	a_84_48##6	69.919678
Rg6	a_84_48##6	a_84_48##7	26.400723
Rg7	a_84_48##7	a_84_48##8	66.497368
Rg8	a_84_48##8	a_84_48##9	76.174339
Rg9	a_84_48##9	a_84_48##10	62.014694
Rg10	a_84_48##10	a_84_48##11	380.339874
Rg11	a_84_48##2	a_84_48##12	462.979767
Rg12	a_84_48##3	a_84_48##13	377.345459
Rg13	a_84_48##3	a_84_48##14	459.985352
Rg14	a_84_48##4	a_84_48##15	377.345459
Rg15	a_84_48##4	a_84_48##16	459.985352
Rg16	a_84_48##5	a_84_48##17	374.238098
Rg17	a_84_48##5	a_84_48##18	456.877991
Rg18	a_84_48##6	a_84_48##19	406.715515
Rg19	a_84_48##7	a_84_48##20	384.222687
Rg20	a_84_48##8	a_84_48##21	412.509735
Rg21	a_84_48##8	a_84_48##22	444.072144
Rg22	a_84_48##9	a_84_48##23	415.552856
Rg23	a_84_48##9	a_84_48##24	447.115234
Rg24	a_84_48##10	a_84_48##25	462.979767
Rg25	a_833_48#	a_833_48##2	746.977295
Rg26	a_833_48##2	a_833_48##3	210.494781
Rg27	a_833_48##3	a_833_48##4	210.494781
Rg28	a_833_48##4	a_833_48##5	210.494781
Rg29	a_833_48##5	a_833_48##6	210.494781
Rg30	a_833_48##6	a_833_48##7	210.494781
Rg31	a_833_48##7	a_833_48##8	210.494781
Rg32	a_833_48##8	a_833_48##9	473.208221
Rg33	a_833_48##2	a_833_48##10	262.702026
Rg34	a_833_48##3	a_833_48##11	262.702026
Rg35	a_833_48##4	a_833_48##12	262.702026
Rg36	a_833_48##5	a_833_48##13	262.702026
Rg37	a_833_48##6	a_833_48##14	262.702026
Rg38	a_833_48##7	a_833_48##15	262.702026
Rg39	a_833_48##8	a_833_48##16	262.702026
Rg40	TE_B#1	TE_B#2	403.623657
Rg41	TE_B#2	TE_B#3	19.203711
Rg42	TE_B#3	TE_B#4	234.943161
Rg43	TE_B#4	TE_B#5	319.528564
Rg44	TE_B#5	TE_B#6	221.972031
Rg45	TE_B#6	TE_B#7	279.358215
Rg46	TE_B#7	TE_B#8	221.972031
Rg47	TE_B#8	TE_B#9	279.358215
Rg48	TE_B#9	TE_B#10	221.972031
Rg49	TE_B#10	TE_B#11	649.986206
Rg50	TE_B#3	TE_B#12	401.985443
Rg51	TE_B#4	TE_B#13	371.735809
Rg52	TE_B#5	TE_B#14	371.735809
Rg53	TE_B#6	TE_B#15	371.735809
Rg54	TE_B#7	TE_B#16	371.735809
Rg55	TE_B#8	TE_B#17	371.735809
Rg56	TE_B#9	TE_B#18	371.735809
Rg57	TE_B#10	TE_B#19	371.735809
Rg58	A#1	A#2	322.953644
Rg59	A#2	A#3	30.596949
Rg60	A#3	A#4	22.738756
Rg61	A#4	A#5	508.060303
Rg62	A#2	A#6	507.075531
Rg63	A#4	A#7	324.673096
Rf1	Z#1	Z#2	93.051025
Rf2	Z#2	Z#3	73.001427
Rf3	Z#3	Z#4	56.457699
Rf4	Z#4	Z	5.632235
Rf5	Z	Z#5	21.495600
Rf6	Z#2	Z#6	23.681496
Rf7	Z#3	Z#7	23.681496
Rf8	Z#4	Z	10.134114
Rf9	Z	Z#8	10.198291
Rf10	Z#8	Z#9	20.052242
Rf11	Z#8	Z#10	61.432507
Rf12	Z#10	Z#11	17.618225
Rf13	Z#10	Z#12	65.696381
Rf14	Z#12	Z#13	17.618225
Rf15	Z#12	Z#14	83.775734
Rf16	a_27_74#	a_27_74##2	97.716675
Rf17	a_27_74##2	a_27_74##3	62.889057
Rf18	a_27_74##3	a_27_74##4	56.490074
Rf19	a_27_74##4	a_27_74##6	91.008553
Rf20	a_27_74##6	a_27_74##7	92.369057
Rf21	a_27_74##7	a_27_74##8	73.001427
Rf22	a_27_74##8	a_27_74##9	69.836731
Rf23	a_27_74##9	a_27_74##10	88.460457
Rf24	a_27_74##2	a_27_74##11	36.178436
Rf25	a_27_74##3	a_27_74##12	36.178436
Rf26	a_27_74##4	a_27_74##13	29.560823
Rf27	a_27_74##7	a_27_74##14	23.681496
Rf28	a_27_74##8	a_27_74##15	23.681496
Rf29	a_27_74##9	a_27_74##16	31.057766
Rf30	a_27_74##5	a_27_74##6	7.500000
Rf31	a_28_368#	a_28_368##3	79.581802
Rf32	a_28_368##3	a_28_368##4	72.908829
Rf33	a_28_368##4	a_28_368##5	73.001427
Rf34	a_28_368##5	a_28_368##7	73.176956
Rf35	a_28_368##7	a_28_368##8	78.206108
Rf36	a_28_368##8	a_28_368##9	67.321365
Rf37	a_28_368##9	a_28_368##10	67.142647
Rf38	a_28_368##10	a_28_368##11	100.900269
Rf39	a_28_368##4	a_28_368##12	10.866916
Rf40	a_28_368##5	a_28_368##13	10.866916
Rf41	a_28_368##8	a_28_368##14	23.470413
Rf42	a_28_368##9	a_28_368##15	33.054329
Rf43	a_28_368##10	a_28_368##16	23.753605
Rf44	a_28_368##2	a_28_368##3	7.500000
Rf45	a_28_368##6	a_28_368##7	7.500000
Rf46	a_833_48##17	a_833_48#	129.659744
Rf47	a_833_48#	a_833_48##19	22.611988
Rf48	TE_B	TE_B#20	13.060371
Rf49	TE_B#20	TE_B	3.882813
Rf50	A	A#3	163.775864
Rf51	a_84_48##26	a_84_48##28	151.578354
Rf52	a_84_48##28	a_84_48##5	557.162842
Rf53	a_84_48##27	a_84_48##28	5.000000
Rf54	VPWR#1	VPWR#2	100.656830
Rf55	VPWR#2	VPWR#3	50.380310
Rf56	VPWR#3	VPWR#4	78.139503
Rf57	VPWR#4	VPWR#5	75.558197
Rf58	VPWR#5	VPWR#6	73.001427
Rf59	VPWR#6	VPWR#7	73.001427
Rf60	VPWR#7	VPWR#8	85.809799
Rf61	VPWR#2	VPWR#9	35.688515
Rf62	VPWR#4	VPWR#10	25.256187
Rf63	VPWR#5	VPWR#11	31.948624
Rf64	VPWR#6	VPWR#12	31.948624
Rf65	VPWR#7	VPWR#13	31.948624
Rf66	VGND#1	VGND#2	91.014488
Rf67	VGND#2	VGND#3	56.712177
Rf68	VGND#3	VGND#4	120.200882
Rf69	VGND#4	VGND#5	62.889057
Rf70	VGND#5	VGND#6	60.032265
Rf71	VGND#6	VGND#7	62.896935
Rf72	VGND#7	VGND#8	79.965767
Rf73	VGND#2	VGND#9	51.682205
Rf74	VGND#4	VGND#10	41.038895
Rf75	VGND#5	VGND#11	41.038895
Rf76	VGND#6	VGND#12	56.430489
Rf77	VGND#7	VGND#13	30.353714
Rf79	TE_B#2	TE_B#20	53.410934
Re1	VPWR#3	VPWR	2.512894
Re2	VPWR	VPWR#8	1.435940
Re3	VGND#3	VGND	2.512894
Re4	VGND	VGND#8	1.435940
*
*       CAPACITOR CARDS
*
*
C1	a_833_48##10	a_833_48##2	3.22795e-18
C2	Z#9	Z#11	2.13906e-18
C3	a_27_74##5	Z#1	6.36649e-17
C4	a_84_48##17	a_27_74##15	1.66125e-17
C5	VGND#9	a_84_48##27	1.70714e-18
C6	VGND#2	A#1	5.20611e-19
C7	a_28_368##9	Z#13	1.3704e-17
C8	VPWR#12	TE_B#8	3.14265e-19
C9	a_28_368##5	TE_B#17	5.24626e-19
C10	a_27_74##2	TE_B#7	8.20546e-18
C11	Z#9	a_28_368##16	4.81836e-17
C12	a_833_48##5	a_27_74##12	4.90657e-19
C13	VGND#4	a_833_48##2	7.25284e-19
C14	a_28_368##4	TE_B#17	2.95811e-17
C15	a_27_74##3	a_27_74##2	7.26074e-19
C16	VPWR#8	a_84_48##10	1.23631e-20
C17	a_28_368##8	Z#13	1.76821e-17
C18	VPWR#4	TE_B#4	2.57666e-20
C19	VGND#12	a_833_48##7	1.67344e-18
C20	a_84_48##20	a_27_74##15	8.22222e-18
C21	a_27_74##16	a_84_48##17	1.77639e-19
C22	VPWR#8	a_84_48##9	1.88101e-20
C23	a_27_74##9	Z#3	1.35249e-17
C24	a_27_74##9	a_84_48##10	7.22385e-20
C25	VPWR#8	a_84_48##8	1.91894e-20
C26	a_28_368##11	a_28_368##16	3.77115e-18
C27	a_84_48##20	Z#7	1.44708e-17
C28	a_28_368##9	a_28_368##15	5.47123e-20
C29	a_833_48##7	TE_B#10	6.71917e-18
C30	VPWR#8	a_84_48##7	3.11128e-20
C31	VGND#2	A#7	6.82816e-18
C32	a_28_368##5	TE_B#18	3.25644e-17
C33	a_27_74##2	TE_B#6	8.98671e-18
C34	a_27_74##4	a_833_48##8	1.69419e-17
C35	a_27_74#	a_84_48##27	1.26795e-17
C36	VPWR#8	a_84_48##4	2.63949e-20
C37	a_27_74##16	a_84_48##20	3.99077e-19
C38	VGND#12	a_833_48##6	1.57651e-18
C39	a_28_368##11	Z#9	7.14561e-17
C40	a_28_368##10	Z#11	1.82427e-17
C41	VPWR#8	a_84_48##3	2.90495e-20
C42	a_28_368##4	TE_B#18	5.24626e-19
C43	a_833_48##8	a_27_74##13	4.96868e-19
C44	a_27_74##8	Z#3	5.35378e-17
C45	VPWR#4	TE_B#3	9.22174e-21
C46	A#3	A#4	2.12277e-17
C47	VPWR#8	a_84_48##2	1.37284e-20
C48	a_84_48##21	Z#7	1.44708e-17
C49	VGND#4	TE_B#1	1.24659e-19
C50	a_27_74##9	a_84_48##9	9.87967e-20
C51	a_28_368##9	Z#11	1.46956e-17
C52	a_84_48##21	a_27_74##16	1.54968e-17
C53	a_27_74##2	TE_B#5	2.22723e-18
C54	a_27_74##4	a_833_48##7	1.08251e-17
C55	a_28_368##5	TE_B#19	2.95921e-17
C56	VGND#2	TE_B#1	6.7492e-18
C57	VGND#8	a_84_48##10	2.66551e-20
C58	a_833_48##7	a_27_74##13	4.90657e-19
C59	VGND#8	a_84_48##9	3.68152e-20
C60	Z#5	a_84_48##21	9.80748e-19
C61	a_28_368##10	a_28_368##16	1.56622e-18
C62	VGND#8	a_84_48##8	3.71738e-20
C63	a_27_74##8	Z#2	5.27048e-17
C64	VPWR#13	TE_B#10	3.49031e-19
C65	a_27_74##9	a_84_48##8	1.32791e-19
C66	VGND#8	a_84_48##7	5.83305e-20
C67	a_84_48##23	a_27_74##16	1.77846e-17
C68	a_833_48##7	TE_B#9	1.25671e-17
C69	a_27_74##10	a_84_48##21	2.04041e-19
C70	VGND#4	a_833_48##10	7.19395e-18
C71	A#3	TE_B#3	9.84336e-19
C72	VGND#8	a_84_48##4	5.92868e-20
C73	Z#5	a_84_48##23	2.59604e-17
C74	VGND#8	a_84_48##3	6.01235e-20
C75	a_28_368##5	TE_B#11	5.24626e-19
C76	VGND#2	a_833_48##10	1.02648e-19
C77	VGND#8	a_84_48##2	3.59785e-20
C78	a_833_48##8	VGND#13	2.39706e-18
C79	A#7	A#1	3.80034e-17
C80	a_27_74##7	Z#2	5.32074e-17
C81	VPWR#2	TE_B#3	2.08882e-20
C82	a_27_74##16	a_84_48##11	9.12926e-19
C83	VGND#5	a_833_48##11	3.07897e-19
C84	a_27_74##10	a_84_48##23	9.23588e-19
C85	a_28_368##10	Z#9	1.58909e-17
C86	Z#5	a_84_48##11	2.35408e-17
C87	VGND#4	a_833_48##11	4.32614e-18
C88	Z#10	Z#12	2.51652e-19
C89	a_28_368##6	a_833_48##9	2.86856e-19
C90	a_27_74##10	a_84_48##11	3.72239e-17
C91	TE_B#1	A#7	3.94055e-17
C92	a_27_74##8	a_84_48##8	3.50569e-20
C93	a_28_368##5	VPWR#7	8.83356e-18
C94	a_28_368##6	TE_B#10	8.09172e-20
C95	VGND#5	a_833_48##12	4.77919e-18
C96	a_833_48##6	TE_B#9	9.87464e-18
C97	a_28_368##8	a_84_48##14	1.63015e-17
C98	a_27_74##3	a_833_48##6	1.02511e-17
C99	a_27_74##4	TE_B#11	1.14158e-18
C100	VGND#4	a_833_48##12	7.17888e-19
C101	VGND#6	a_833_48##13	2.91837e-19
C102	a_27_74##8	a_84_48##7	8.75902e-19
C103	a_833_48##10	TE_B#1	4.76538e-19
C104	Z#12	Z#14	2.34494e-19
C105	a_833_48#	A#4	4.90328e-19
C106	a_28_368##5	VPWR#6	8.78455e-18
C107	a_28_368##8	a_84_48##16	1.57542e-17
C108	VGND#5	a_833_48##13	4.3261e-18
C109	a_27_74##3	a_833_48##5	8.99487e-18
C110	VPWR#1	A#6	4.52962e-17
C111	VGND#4	a_833_48##13	1.12262e-19
C112	a_84_48##27	A#6	3.7769e-17
C113	a_84_48##10	a_84_48##9	3.47246e-18
C114	Z#12	a_28_368##14	1.94598e-17
C115	a_833_48##11	a_833_48##10	3.61894e-17
C116	a_833_48#	TE_B#4	2.91025e-17
C117	VGND#6	a_833_48##14	4.64271e-18
C118	a_833_48##6	TE_B#8	9.28133e-18
C119	a_28_368##9	a_84_48##18	1.60049e-17
C120	a_833_48#	TE_B#3	2.68398e-17
C121	VPWR#1	A#5	3.52539e-18
C122	VPWR#9	A#6	7.19098e-19
C123	a_28_368##4	VPWR#6	8.83356e-18
C124	VGND#5	a_833_48##14	4.34401e-19
C125	a_84_48##27	A#5	7.53386e-17
C126	Z#12	Z#13	1.80884e-19
C127	A#5	VPWR#9	2.72228e-17
C128	VPWR#1	TE_B#12	4.85312e-19
C129	a_27_74##8	a_84_48##4	1.91219e-20
C130	a_833_48##12	a_833_48##11	3.68697e-17
C131	a_833_48#	a_833_48##2	1.01299e-17
C132	a_28_368##9	a_84_48##19	1.63006e-17
C133	a_84_48##5	TE_B#10	4.42847e-18
C134	VGND#6	a_833_48##15	4.62596e-18
C135	a_28_368##4	VPWR#5	8.78455e-18
C136	Z#12	a_84_48##14	4.19899e-20
C137	a_833_48##17	A#5	2.25257e-18
C138	VGND#7	a_27_74##4	2.39447e-19
C139	a_84_48##27	TE_B#12	3.55283e-17
C140	a_27_74##2	a_833_48##5	5.44404e-19
C141	a_84_48##5	TE_B#9	4.0207e-18
C142	a_84_48##5	TE_B#8	2.71768e-18
C143	VPWR#9	TE_B#12	4.00846e-17
C144	VGND#5	a_833_48##15	1.12262e-19
C145	Z#12	a_28_368##15	8.43467e-18
C146	a_833_48##17	TE_B#12	3.67956e-17
C147	a_833_48##13	a_833_48##12	3.61894e-17
C148	a_84_48##27	TE_B#13	2.33221e-17
C149	VGND#7	a_833_48##16	1.25842e-18
C150	a_28_368##10	a_84_48##22	2.1572e-17
C151	a_833_48##5	TE_B#8	1.30296e-17
C152	a_84_48##5	a_833_48##8	1.92138e-18
C153	Z#12	a_84_48##16	1.68233e-17
C154	VGND#6	a_27_74##4	1.89457e-19
C155	a_27_74##2	a_833_48##4	1.02751e-17
C156	a_28_368#	TE_B#12	4.10485e-18
C157	Z#5	a_27_74##16	2.01082e-17
C158	VPWR#9	TE_B#13	1.6164e-18
C159	a_84_48##5	a_833_48##7	2.3e-18
C160	Z#10	a_28_368##15	8.36591e-18
C161	VGND#6	a_833_48##16	2.91837e-19
C162	a_84_48##5	a_833_48##6	2.53798e-18
C163	a_84_48##5	a_833_48##5	7.8634e-19
C164	VPWR#10	TE_B#12	3.74246e-19
C165	a_833_48##17	TE_B#13	1.3503e-17
C166	a_84_48##27	TE_B#14	2.8323e-17
C167	a_27_74##7	a_84_48##4	1.09609e-18
C168	a_833_48##14	a_833_48##13	3.68557e-17
C169	a_28_368#	TE_B#13	6.85455e-17
C170	a_28_368##2	TE_B#12	4.30912e-19
C171	VPWR#9	TE_B#14	9.55865e-20
C172	a_27_74##10	a_27_74##16	2.45062e-18
C173	a_28_368##10	a_84_48##24	1.5721e-17
C174	Z#12	a_84_48##18	1.60489e-17
C175	a_84_48##5	a_84_48##9	1.01245e-17
C176	VGND#7	a_833_48##9	1.2494e-18
C177	a_27_74##2	a_833_48##3	9.56435e-18
C178	a_84_48##5	a_84_48##8	1.64563e-17
C179	TE_B#13	VPWR#10	3.27498e-17
C180	a_833_48##17	TE_B#14	2.9946e-18
C181	Z#10	Z#11	8.06092e-19
C182	Z#10	a_84_48##18	4.34654e-20
C183	a_84_48##27	TE_B#15	2.26823e-17
C184	a_84_48##5	a_84_48##7	2.27409e-17
C185	VGND#6	a_27_74##3	1.89457e-19
C186	a_84_48##9	a_84_48##8	5.3409e-18
C187	a_28_368##2	TE_B#13	2.25649e-18
C188	a_28_368#	TE_B#14	9.48213e-19
C189	a_84_48##5	a_84_48##4	2.17709e-17
C190	a_27_74##7	a_84_48##3	8.7868e-19
C191	a_27_74##10	Z#5	4.07492e-17
C192	a_84_48##5	a_84_48##3	1.85683e-17
C193	a_833_48##15	a_833_48##14	3.7263e-17
C194	a_84_48##5	a_84_48##2	2.21947e-17
C195	a_833_48##5	TE_B#7	6.12394e-18
C196	VPWR#11	TE_B#13	2.75334e-19
C197	TE_B#14	VPWR#10	3.19238e-17
C198	a_833_48##17	TE_B#15	1.37807e-18
C199	a_84_48##27	TE_B#16	2.20344e-17
C200	Z#12	a_84_48##19	4.34654e-20
C201	a_27_74##2	a_833_48##2	1.16284e-18
C202	a_27_74##5	TE_B#11	4.0254e-18
C203	Z#10	a_28_368##16	1.30473e-17
C204	a_28_368##2	TE_B#14	5.70378e-17
C205	Z#10	a_84_48##19	1.6424e-17
C206	VGND#7	a_84_48#	1.36652e-18
C207	VGND#5	a_27_74##3	1.89457e-19
C208	VPWR#11	TE_B#14	7.74125e-19
C209	VPWR#10	TE_B#15	1.20799e-18
C210	a_833_48##17	TE_B#16	8.85715e-19
C211	A#4	a_84_48##26	1.37804e-17
C212	a_27_74##7	a_84_48##2	1.04108e-19
C213	a_833_48##16	a_833_48##15	3.68246e-17
C214	a_84_48##27	TE_B#17	7.29448e-18
C215	VPWR#3	VPWR#5	2.27136e-17
C216	a_28_368##2	TE_B#15	5.28669e-17
C217	VPWR#3	VPWR#4	5.7805e-17
C218	Z#3	Z#2	2.5966e-18
C219	VPWR#3	VPWR#2	7.74642e-17
C220	VGND#3	VGND#4	8.57545e-17
C221	Z#10	a_84_48##22	1.51811e-17
C222	TE_B#15	VPWR#11	3.23643e-17
C223	VPWR#10	TE_B#16	2.66857e-19
C224	VPWR#7	a_833_48##9	5.5145e-20
C225	VGND#3	VGND#2	6.84327e-17
C226	VGND#5	a_27_74##2	1.89457e-19
C227	a_28_368##2	TE_B#16	4.75808e-19
C228	a_833_48##8	TE_B#11	4.03782e-18
C229	a_833_48##9	a_833_48##16	3.65142e-17
C230	a_833_48##4	TE_B#7	1.61477e-17
C231	VPWR#12	TE_B#15	2.8528e-19
C232	TE_B#16	VPWR#11	3.38007e-17
C233	Z#10	a_84_48##24	3.75173e-20
C234	TE_B#16	a_28_368##12	2.3254e-17
C235	VGND#10	a_27_74##2	2.38387e-17
C236	VPWR#12	TE_B#16	7.67963e-19
C237	VGND#4	a_27_74##2	1.89457e-19
C238	VPWR#11	TE_B#17	7.67963e-19
C239	a_84_48#	a_833_48##9	3.9673e-17
C240	a_84_48##27	VPWR#1	1.16059e-16
C241	a_27_74##5	a_84_48##7	1.09063e-19
C242	TE_B#17	a_28_368##12	2.3254e-17
C243	VGND#7	VGND#6	9.01022e-19
C244	a_84_48##8	a_84_48##7	5.05741e-18
C245	TE_B#17	VPWR#12	3.23426e-17
C246	VPWR#11	TE_B#18	2.8528e-19
C247	VPWR#9	VPWR#1	2.31558e-18
C248	VGND#11	a_27_74##3	1.28657e-17
C249	a_84_48##13	a_84_48#	2.67113e-17
C250	a_27_74##4	a_27_74##12	1.32269e-18
C251	a_833_48##4	TE_B#6	3.06197e-18
C252	VPWR#13	TE_B#17	2.8528e-19
C253	TE_B#18	VPWR#12	3.38007e-17
C254	a_84_48##27	VPWR#9	8.04869e-17
C255	VPWR#2	VPWR#1	1.06542e-18
C256	TE_B#18	a_28_368##13	2.3254e-17
C257	VGND#11	a_27_74##2	1.27261e-17
C258	a_27_74##4	a_84_48##2	5.33766e-18
C259	a_84_48##15	a_84_48##13	2.26269e-17
C260	a_27_74##5	a_84_48##4	1.83807e-19
C261	Z#14	TE_B#17	3.86985e-19
C262	VPWR#13	TE_B#18	7.67963e-19
C263	a_28_368##10	VPWR#8	6.76834e-17
C264	VPWR#12	TE_B#19	7.67963e-19
C265	a_27_74##4	VGND#12	1.36154e-17
C266	a_28_368##9	VPWR#8	6.06817e-17
C267	VPWR#3	a_27_74##2	2.93831e-18
C268	a_84_48##26	VGND#1	5.11287e-17
C269	TE_B#19	a_28_368##13	2.3254e-17
C270	a_84_48##27	a_833_48##17	1.23766e-16
C271	a_28_368##5	TE_B#10	5.59767e-19
C272	a_28_368##8	VPWR#8	7.00911e-17
C273	VGND#2	A#3	6.18942e-19
C274	Z#14	TE_B#18	4.36584e-19
C275	TE_B#19	VPWR#13	3.23426e-17
C276	VPWR#12	TE_B#11	2.8528e-19
C277	a_27_74##5	a_84_48##3	2.89232e-19
C278	a_84_48##17	a_84_48##15	2.46073e-17
C279	a_84_48##27	VPWR#2	1.47811e-17
C280	a_28_368##6	TE_B#19	9.93621e-19
C281	VGND#12	a_27_74##3	9.2854e-18
C282	VGND#6	VGND#5	1.10662e-18
C283	a_84_48##2	TE_B#11	6.52239e-18
C284	a_84_48##27	a_28_368#	6.43012e-17
C285	Z#14	TE_B#19	8.32746e-19
C286	a_84_48##2	a_833_48##9	1.102e-17
C287	VGND#9	VGND#1	2.29828e-18
C288	TE_B#11	VPWR#13	3.34599e-17
C289	VGND#3	a_27_74##2	1.72686e-18
C290	a_833_48##3	TE_B#6	1.90343e-17
C291	VGND#1	A#1	2.72088e-17
C292	a_28_368##5	TE_B#9	5.62813e-19
C293	a_27_74##7	a_27_74##5	2.41511e-18
C294	a_28_368##6	TE_B#11	5.07716e-17
C295	a_27_74##5	a_84_48##2	4.24543e-18
C296	a_84_48##20	a_84_48##17	2.46073e-17
C297	a_28_368#	VPWR#9	1.1069e-17
C298	Z#14	TE_B#11	2.5034e-18
C299	a_84_48##27	VPWR#10	9.75741e-18
C300	VPWR#13	a_84_48##12	5.02661e-19
C301	a_84_48##26	A#1	3.51328e-17
C302	a_28_368##14	TE_B#11	3.03042e-19
C303	VGND#13	a_27_74##4	2.03442e-17
C304	VGND#9	a_84_48##26	5.38233e-17
C305	a_28_368##6	a_84_48##12	5.39525e-17
C306	VGND#8	a_27_74##9	6.06509e-17
C307	VGND#1	A#7	2.03915e-18
C308	VPWR#3	a_27_74#	4.03821e-18
C309	Z#10	a_84_48##8	1.40029e-18
C310	a_84_48##27	A#4	1.06876e-17
C311	VGND#8	a_27_74##8	7.16797e-17
C312	a_84_48##12	Z#14	2.20428e-17
C313	a_84_48##21	a_84_48##20	3.79315e-17
C314	a_833_48##17	a_28_368#	7.03279e-19
C315	a_27_74##7	Z#1	5.17626e-17
C316	VGND#9	A#1	6.7523e-19
C317	VPWR#10	VPWR#9	9.23376e-19
C318	VGND#3	VGND#1	5.78164e-17
C319	VPWR#13	a_84_48##14	2.28369e-19
C320	a_84_48##27	a_28_368##2	7.15818e-17
C321	Z#1	a_84_48##3	2.9794e-18
C322	VGND#8	a_27_74##7	7.09743e-17
C323	VGND#3	a_84_48##26	1.96005e-17
C324	a_28_368##14	a_84_48##12	6.93565e-19
C325	a_28_368##6	a_84_48##14	1.43647e-18
C326	VGND#4	a_833_48#	8.629e-18
C327	a_84_48##26	A#7	3.52093e-17
C328	Z#14	a_84_48##14	5.96652e-17
C329	VGND#3	a_833_48##19	4.18865e-17
C330	VPWR#13	a_84_48##16	6.66502e-20
C331	a_28_368##6	a_84_48##2	7.38637e-20
C332	VGND#3	a_27_74#	1.65338e-17
C333	a_84_48##23	a_84_48##21	3.51272e-17
C334	VGND#1	TE_B#1	4.97055e-19
C335	a_84_48##27	VPWR#11	1.11937e-18
C336	a_84_48##14	a_28_368##14	2.69993e-17
C337	Z#10	a_84_48##7	3.90657e-18
C338	Z#1	a_84_48##2	1.84611e-18
C339	VGND#5	VGND#4	1.1306e-18
C340	A#7	VGND#9	1.67273e-17
C341	a_28_368##6	a_84_48##16	3.3145e-19
C342	Z#12	a_84_48##4	2.8786e-18
C343	a_27_74##4	a_833_48##14	1.97627e-19
C344	a_27_74##7	a_27_74##14	4.61644e-18
C345	Z#13	a_84_48##14	1.30747e-18
C346	a_28_368#	VPWR#4	1.14358e-17
C347	VGND#3	a_27_74##11	4.03601e-18
C348	Z#14	a_84_48##16	1.37722e-18
C349	a_27_74##8	Z#6	8.42632e-19
C350	a_84_48##26	TE_B#1	2.07284e-18
C351	VPWR#13	a_84_48##18	3.83642e-20
C352	a_28_368##15	a_84_48##14	2.6824e-19
C353	a_28_368#	VPWR#10	2.73227e-17
C354	a_84_48##16	a_28_368##14	3.15522e-17
C355	a_833_48##19	VGND#9	5.83772e-17
C356	a_833_48##19	A#7	1.36709e-18
C357	a_84_48##27	a_28_368##12	1.07831e-19
C358	a_84_48##11	a_84_48##23	3.89763e-17
C359	VPWR#5	VPWR#10	1.17255e-18
C360	Z#13	a_84_48##16	4.6345e-17
C361	TE_B#1	VGND#9	2.11564e-17
C362	VGND#2	A#4	1.32256e-19
C363	Z#12	a_84_48##3	1.08346e-18
C364	Z#14	a_84_48##3	2.10599e-18
C365	a_28_368##15	a_84_48##16	6.21076e-19
C366	a_28_368##4	TE_B#8	6.1166e-19
C367	a_27_74##4	a_833_48##15	1.45571e-18
C368	a_28_368##14	a_84_48##18	7.54356e-19
C369	a_27_74##7	Z#6	2.76584e-19
C370	a_28_368##2	a_28_368#	2.39599e-18
C371	Z#13	a_84_48##18	4.03838e-17
C372	a_27_74##8	a_27_74##15	3.48726e-18
C373	a_833_48##19	TE_B#1	4.54665e-17
C374	a_84_48##18	a_28_368##15	2.34795e-17
C375	Z#14	a_84_48##2	1.74357e-18
C376	a_27_74##9	Z#7	2.64881e-19
C377	a_28_368##14	a_84_48##19	3.1955e-19
C378	a_833_48##2	TE_B#5	2.37805e-17
C379	VGND#9	a_833_48##10	3.53336e-19
C380	a_28_368##2	VPWR#5	9.69126e-18
C381	Z#11	a_84_48##18	1.53821e-18
C382	a_28_368##2	VPWR#10	2.71985e-17
C383	a_84_48##27	TE_B#8	1.57362e-18
C384	a_28_368##5	a_28_368##4	2.64007e-18
C385	a_27_74#	TE_B#1	2.47072e-19
C386	Z#13	a_84_48##19	1.53821e-18
C387	VPWR#10	VPWR#2	3.18965e-19
C388	a_84_48##26	A#3	5.53661e-17
C389	a_28_368##16	a_84_48##18	3.17518e-19
C390	a_27_74##4	a_833_48##16	3.33443e-18
C391	VPWR#3	VPWR#1	6.43583e-17
C392	a_28_368##4	TE_B#7	5.87697e-19
C393	a_84_48##19	a_28_368##15	2.76413e-17
C394	a_27_74##7	a_833_48##9	2.02452e-19
C395	a_28_368##14	a_84_48##4	4.79837e-19
C396	a_28_368##9	a_84_48##5	6.66439e-20
C397	a_84_48##27	VPWR#3	5.37408e-17
C398	a_28_368##8	a_84_48##5	1.55502e-20
C399	a_27_74##8	Z#7	4.23989e-19
C400	Z#11	a_84_48##19	5.00059e-17
C401	VGND#10	TE_B#1	3.58367e-19
C402	a_28_368##2	VPWR#4	8.70143e-18
C403	VPWR#11	VPWR#10	1.52922e-18
C404	a_84_48##27	TE_B#7	4.16183e-18
C405	a_84_48##5	a_28_368##5	7.82571e-17
C406	a_28_368##16	a_84_48##19	1.66035e-18
C407	a_27_74##9	a_27_74##16	5.65716e-19
C408	VPWR#3	a_833_48##17	7.67755e-18
C409	a_84_48##5	a_28_368##4	2.73211e-17
C410	a_28_368##15	a_84_48##22	6.06271e-19
C411	a_27_74#	a_833_48##10	3.30918e-17
C412	a_28_368##14	a_84_48##3	4.65439e-19
C413	A#5	A#6	4.87137e-17
C414	VGND#8	a_27_74##5	1.80893e-17
C415	a_28_368#	VPWR#3	2.78059e-17
C416	Z#9	a_84_48##19	1.64167e-19
C417	a_84_48##22	Z#11	2.10005e-17
C418	VGND#3	a_84_48##27	3.21843e-18
C419	VPWR#3	VPWR#10	1.52359e-17
C420	a_27_74##4	a_833_48##9	1.96098e-19
C421	a_27_74##8	a_84_48##5	5.54403e-19
C422	a_27_74##7	a_84_48#	9.06417e-19
C423	a_28_368##2	VPWR#11	4.27699e-17
C424	a_28_368##16	a_84_48##22	4.91283e-17
C425	TE_B	A#4	1.05718e-17
C426	VPWR#3	a_28_368##2	2.0325e-17
C427	a_84_48##27	TE_B#6	4.00398e-18
C428	VGND#10	a_833_48##10	1.33485e-17
C429	a_833_48##9	TE_B#11	1.29593e-17
C430	VGND#3	a_833_48##17	4.59095e-18
C431	a_27_74##16	a_27_74##8	2.47118e-18
C432	VPWR#3	VPWR#11	1.58699e-18
C433	Z#9	a_84_48##22	1.44328e-18
C434	a_27_74##4	a_84_48##5	3.44629e-17
C435	Z#11	a_84_48##24	4.03863e-19
C436	TE_B#12	A#5	3.79867e-17
C437	Z#3	a_84_48##9	2.00907e-19
C438	a_27_74##3	a_84_48##5	1.62832e-17
C439	a_833_48##2	TE_B#4	1.89273e-17
C440	a_28_368##11	a_84_48##22	3.036e-19
C441	a_27_74##9	Z#5	1.53083e-17
C442	a_27_74#	a_833_48##11	1.44224e-18
C443	a_27_74##8	a_84_48##13	2.03183e-19
C444	a_84_48##24	a_28_368##16	2.09342e-17
C445	TE_B	TE_B#3	6.81108e-17
C446	a_833_48#	a_84_48##26	6.24763e-21
C447	a_27_74##11	a_833_48##10	7.12802e-20
C448	a_84_48##5	Z#12	8.72823e-17
C449	a_84_48##7	a_84_48##18	1.14316e-18
C450	a_84_48##5	Z#10	7.96608e-17
C451	Z#9	a_84_48##24	4.58018e-17
C452	a_84_48##27	TE_B#5	4.65205e-18
C453	VGND#2	VGND#1	1.13208e-18
C454	VGND#10	a_27_74#	6.42923e-17
C455	a_833_48##19	a_833_48#	1.4187e-17
C456	VGND#8	a_27_74##10	4.90605e-17
C457	a_28_368##11	a_84_48##24	1.31646e-18
C458	a_27_74##7	a_84_48##13	3.07628e-17
C459	VGND#10	a_833_48##11	3.39669e-17
C460	a_27_74#	a_833_48#	7.86448e-17
C461	TE_B	a_833_48##2	1.26778e-18
C462	TE_B#13	TE_B#12	3.0914e-18
C463	a_28_368##16	a_84_48##25	1.45196e-18
C464	Z#3	a_84_48##5	7.91772e-17
C465	VGND#10	a_833_48#	1.50789e-18
C466	Z#2	a_84_48##5	8.94573e-17
C467	a_27_74##16	a_84_48##9	4.59803e-19
C468	Z#3	a_84_48##8	2.55287e-18
C469	Z#9	a_84_48##25	4.07779e-17
C470	a_27_74#	a_833_48##12	3.64999e-20
C471	a_28_368##15	a_84_48##7	2.39918e-19
C472	a_27_74##11	a_833_48##11	1.1876e-17
C473	a_28_368##11	a_84_48##25	4.4644e-17
C474	a_84_48##27	TE_B#4	4.24546e-18
C475	a_27_74##8	a_84_48##15	9.32355e-19
C476	TE_B#14	TE_B#13	2.62824e-17
C477	TE_B#3	a_833_48##19	9.20113e-18
C478	a_27_74##11	a_27_74#	1.15513e-18
C479	VGND#7	a_833_48##8	6.2081e-20
C480	VGND#10	a_833_48##12	2.19505e-18
C481	a_27_74#	TE_B#5	1.07947e-17
C482	A#3	a_84_48##27	3.55256e-17
C483	VPWR#12	VPWR#11	1.69573e-18
C484	a_27_74##7	a_84_48##15	2.21955e-17
C485	VGND#11	a_833_48##11	3.76767e-19
C486	VGND#2	a_84_48##26	1.42264e-17
C487	a_27_74##16	a_84_48##8	6.10912e-19
C488	VPWR#7	TE_B#10	2.27598e-20
C489	a_84_48##27	a_28_368##4	5.08555e-17
C490	a_28_368##10	a_84_48##10	1.83271e-20
C491	Z#3	a_84_48##7	3.45291e-18
C492	a_84_48##27	TE_B#3	8.80585e-18
C493	a_833_48##2	TE_B#3	6.15714e-18
C494	a_27_74##11	a_833_48##12	3.59786e-17
C495	TE_B#15	TE_B#14	4.7606e-17
C496	a_28_368##6	VPWR#8	2.28565e-17
C497	a_84_48##10	Z#5	1.82511e-19
C498	a_27_74##11	VGND#10	6.42923e-17
C499	a_27_74##8	a_84_48##17	3.03802e-17
C500	VGND#10	a_833_48##13	1.92928e-19
C501	VGND#11	a_833_48##12	1.33618e-17
C502	a_27_74##5	a_84_48##5	3.50851e-17
C503	Z	a_84_48##10	2.03192e-17
C504	Z	a_84_48##9	1.04702e-17
C505	a_84_48##5	Z#1	5.81773e-17
C506	TE_B#16	TE_B#15	3.22785e-17
C507	a_27_74##7	a_84_48##17	4.24687e-19
C508	Z	a_84_48##8	1.18187e-18
C509	VGND#7	a_833_48##7	3.02645e-20
C510	Z	a_84_48##7	3.21753e-19
C511	a_84_48##5	a_27_74##14	5.04259e-18
C512	a_84_48##9	Z#5	7.54379e-20
C513	a_84_48##4	a_84_48##3	3.49916e-18
C514	a_27_74##11	a_833_48##13	1.44224e-18
C515	a_28_368##10	a_84_48##9	7.38637e-20
C516	Z	a_84_48##4	1.16532e-19
C517	a_84_48##5	Z#6	3.61992e-18
C518	a_27_74##12	a_833_48##12	7.12802e-20
C519	VGND#3	A#1	1.97038e-19
C520	a_84_48##5	a_27_74##15	3.61992e-18
C521	a_833_48#	a_84_48##27	2.53013e-18
C522	VGND#11	VGND#10	2.4284e-18
C523	a_84_48##5	Z#7	2.51339e-18
C524	VGND#3	A#7	4.06199e-18
C525	a_27_74##8	a_84_48##20	2.16513e-17
C526	VPWR#2	A#6	6.65424e-19
C527	a_84_48##5	a_27_74##16	2.90858e-18
C528	TE_B#17	TE_B#16	4.7556e-17
C529	a_27_74#	TE_B#3	4.33192e-18
C530	a_833_48#	a_833_48##17	2.71395e-18
C531	VGND#11	a_833_48##13	3.40816e-17
C532	VGND#3	TE_B#1	1.82644e-18
C533	a_28_368##11	VPWR#8	4.98984e-17
C534	Z#2	Z#1	2.59275e-18
C535	VPWR#7	VPWR#6	9.5684e-19
C536	a_28_368##16	a_84_48##9	2.75906e-19
C537	VGND#4	TE_B#5	6.26898e-20
C538	VGND#3	a_833_48##11	7.16178e-19
C539	a_27_74##11	a_833_48##14	3.64999e-20
C540	Z#2	a_84_48##7	1.88164e-19
C541	a_27_74##12	a_833_48##13	1.1876e-17
C542	VPWR#9	TE_B#3	3.95736e-19
C543	TE_B#18	TE_B#17	3.22683e-17
C544	a_27_74##9	a_84_48##21	1.57068e-17
C545	a_27_74##10	a_84_48##10	1.64661e-19
C546	VGND#11	a_27_74##11	6.42923e-17
C547	a_28_368##10	a_84_48##8	3.88756e-20
C548	a_28_368##6	VPWR#7	2.339e-17
C549	VGND#2	a_833_48##19	6.59521e-18
C550	Z#2	a_84_48#	1.96619e-19
C551	VGND#11	a_833_48##14	1.84605e-18
C552	VPWR#13	VPWR#12	1.69573e-18
C553	a_28_368##16	a_84_48##8	4.23583e-19
C554	a_27_74##8	a_84_48##21	5.00542e-19
C555	VGND#12	a_833_48##13	3.48281e-19
C556	VGND#4	a_27_74#	1.42366e-17
C557	VPWR#2	A#5	4.77232e-18
C558	Z#2	a_27_74##14	6.5841e-19
C559	TE_B#19	TE_B#18	4.7556e-17
C560	a_27_74##10	a_28_368##11	9.93747e-18
C561	VGND#6	a_833_48##7	3.02645e-20
C562	a_27_74##12	a_833_48##14	3.59669e-17
C563	a_84_48##5	VPWR#12	1.06505e-18
C564	a_84_48##27	a_833_48##5	1.53198e-18
C565	a_27_74##12	a_27_74##11	1.15513e-18
C566	a_84_48##5	a_28_368##13	1.78419e-20
C567	VPWR#6	TE_B#9	2.26701e-20
C568	VGND#4	TE_B#4	4.67039e-19
C569	a_27_74##9	a_84_48##23	1.48016e-17
C570	Z#12	a_28_368##9	7.8221e-19
C571	Z#2	a_84_48##13	9.2281e-19
C572	a_84_48##10	Z#9	1.83496e-19
C573	a_84_48##5	VPWR#13	1.00325e-18
C574	TE_B#11	TE_B#19	3.22683e-17
C575	a_28_368##10	a_84_48##7	1.04946e-19
C576	VGND#11	a_833_48##15	1.92928e-19
C577	Z#10	a_28_368##10	2.28552e-18
C578	a_833_48##17	TE_B#4	6.43525e-18
C579	a_84_48##5	a_28_368##6	6.35253e-17
C580	a_833_48##14	VGND#12	1.60596e-17
C581	a_84_48##5	Z#14	1.01367e-16
C582	a_27_74##8	a_84_48##23	2.18864e-19
C583	Z#2	Z#6	1.63387e-18
C584	a_84_48##5	a_28_368##14	3.14569e-18
C585	Z#3	a_84_48##15	2.01668e-19
C586	VGND#2	TE_B	5.77679e-19
C587	a_84_48##5	Z#13	2.35532e-18
C588	a_84_48##27	a_833_48##4	1.69137e-18
C589	Z#14	VPWR#12	4.56574e-21
C590	Z#3	a_27_74##15	5.01903e-19
C591	a_27_74##12	a_833_48##15	1.4383e-18
C592	a_84_48##9	Z#9	1.47909e-19
C593	VPWR#2	TE_B#12	8.41158e-18
C594	a_84_48##12	TE_B#11	4.32166e-17
C595	Z#2	a_84_48##4	3.7692e-18
C596	a_84_48##5	a_28_368##15	2.80461e-18
C597	a_27_74##13	a_833_48##14	1.29301e-18
C598	a_27_74##12	VGND#11	6.42923e-17
C599	a_833_48#	A#1	1.75762e-19
C600	a_84_48##5	Z#11	3.14569e-18
C601	a_833_48##17	TE_B#3	2.40748e-17
C602	VGND	TE_B#10	9.62309e-19
C603	VGND	TE_B#9	9.57113e-21
C604	a_833_48#	A#7	1.59385e-19
C605	VGND#8	a_84_48#	3.09893e-18
C606	VGND#6	a_833_48##6	3.10405e-20
C607	a_84_48##5	a_28_368##16	2.35532e-18
C608	VPWR#6	VPWR#5	9.53351e-19
C609	VGND#5	a_27_74##11	6.51551e-18
C610	Z#2	a_84_48##15	3.27394e-17
C611	Z#12	a_28_368##8	1.45149e-18
C612	VGND	TE_B#7	5.23073e-21
C613	a_833_48#	TE_B#1	1.5026e-17
C614	a_833_48##15	VGND#12	1.99846e-17
C615	VGND#8	a_84_48##13	4.48038e-18
C616	Z#10	a_28_368##9	7.8221e-19
C617	VPWR#6	TE_B#8	2.27598e-20
C618	a_28_368##6	VPWR#13	5.12388e-17
C619	a_833_48##10	a_833_48#	2.53237e-17
C620	a_84_48##14	a_84_48##12	3.96336e-17
C621	VGND#13	a_833_48##14	3.18252e-19
C622	VGND#8	a_84_48##15	4.43427e-18
C623	VPWR#3	A#6	2.45581e-19
C624	a_84_48##27	a_833_48##3	1.67619e-18
C625	a_833_48#	a_833_48##11	2.03353e-19
C626	VGND#8	a_84_48##17	4.43427e-18
C627	VGND	a_84_48##10	4.44412e-21
C628	VPWR#4	TE_B#13	5.04467e-18
C629	VGND	a_84_48##9	1.8369e-21
C630	Z#3	a_84_48##17	9.32355e-19
C631	a_84_48##3	a_84_48##2	3.73569e-18
C632	a_27_74##13	a_833_48##15	4.13693e-17
C633	VGND#8	a_84_48##20	4.43427e-18
C634	VGND#12	VGND#11	2.35749e-18
C635	Z#2	a_84_48##3	8.26576e-19
C636	VPWR#3	TE_B#12	3.75488e-19
C637	a_27_74##8	a_27_74##7	2.5966e-18
C638	a_84_48##16	a_84_48##14	3.78015e-17
C639	VGND#8	a_84_48##21	4.43427e-18
C640	VPWR#2	TE_B#13	1.63268e-19
C641	VGND#4	a_27_74##11	7.13747e-18
C642	VPWR#3	TE_B#13	1.53948e-19
C643	a_27_74##3	a_84_48##27	6.8223e-18
C644	VGND#8	a_84_48##23	4.43427e-18
C645	Z#2	a_84_48##17	2.42153e-17
C646	VGND#12	a_833_48##16	3.48281e-19
C647	a_28_368##11	a_84_48##10	7.21976e-20
C648	a_28_368##9	a_84_48##7	5.95369e-20
C649	VPWR#3	TE_B#14	6.00778e-21
C650	VGND#13	a_833_48##15	2.37984e-18
C651	a_84_48##27	a_833_48##2	5.16022e-18
C652	VGND#8	a_84_48##11	4.43427e-18
C653	a_28_368##4	a_28_368##2	3.12568e-18
C654	TE_B#4	a_28_368#	1.0479e-18
C655	a_84_48##18	a_84_48##16	4.65181e-17
C656	TE_B#3	A#4	3.0861e-17
C657	Z	a_28_368##10	2.05419e-18
C658	a_833_48##16	a_27_74##13	1.18651e-17
C659	VGND#12	a_27_74##12	6.31873e-17
C660	a_84_48##25	a_84_48##9	9.2906e-19
C661	Z#3	a_84_48##20	2.99989e-17
C662	a_28_368##6	Z#14	5.43855e-17
C663	Z#3	a_27_74##16	2.51223e-17
C664	a_27_74##5	a_833_48##15	2.07534e-19
C665	VPWR#2	A#4	1.17995e-19
C666	a_27_74##4	TE_B#10	1.04244e-17
C667	VGND#6	a_27_74##12	6.51551e-18
C668	a_84_48##5	a_833_48##9	5.22082e-18
C669	a_27_74##2	a_84_48##27	2.73835e-17
C670	VPWR#4	TE_B#14	5.04467e-18
C671	VGND#9	TE_B	2.28266e-17
C672	a_84_48##19	a_84_48##18	4.67502e-17
C673	a_833_48##19	TE_B	5.77515e-17
C674	a_27_74##9	Z	1.0438e-18
C675	a_28_368#	TE_B#3	7.11119e-19
C676	Z#2	a_84_48##20	4.24687e-19
C677	VGND#13	a_833_48##16	4.15165e-17
C678	A#4	VNB	5.50144e-17
C679	VGND#5	a_833_48##6	3.02645e-20
C680	TE_B#10	VNB	1.55465e-17
C681	TE_B#9	VNB	1.67837e-17
C682	VPWR#2	TE_B#14	3.17602e-20
C683	TE_B#8	VNB	1.65938e-17
C684	TE_B#7	VNB	1.66735e-17
C685	TE_B#6	VNB	1.68299e-17
C686	VPWR	VPWR#7	6.49963e-17
C687	TE_B#5	VNB	1.74074e-17
C688	a_28_368##14	a_28_368##6	4.08752e-18
C689	TE_B#4	VNB	1.69495e-17
C690	VPWR	VPWR#6	5.88858e-17
C691	TE_B#3	VNB	1.16239e-16
C692	VPWR	VPWR#5	3.76892e-17
C693	a_833_48##8	VNB	1.43801e-17
C694	VGND#2	TE_B#3	3.44303e-20
C695	a_28_368##4	VPWR#11	4.28381e-17
C696	a_833_48##7	VNB	1.54137e-17
C697	a_84_48##22	a_84_48##19	3.21876e-17
C698	a_833_48##6	VNB	1.54078e-17
C699	a_833_48##5	VNB	1.54173e-17
C700	a_27_74##13	a_833_48##9	5.3129e-19
C701	a_833_48##4	VNB	1.53924e-17
C702	a_833_48##3	VNB	1.53988e-17
C703	a_833_48##2	VNB	4.00963e-17
C704	a_84_48##10	VNB	3.84907e-17
C705	a_27_74##5	a_833_48##16	4.91976e-19
C706	a_84_48##9	VNB	2.80352e-17
C707	a_84_48##8	VNB	3.22542e-17
C708	Z#3	a_84_48##21	2.75636e-17
C709	a_84_48##7	VNB	4.10628e-17
C710	VGND#5	a_27_74##12	7.18695e-18
C711	Z#5	Z#3	3.04149e-18
C712	VPWR#10	TE_B#5	4.35497e-19
C713	a_84_48##4	VNB	3.72194e-17
C714	VPWR#5	TE_B#15	2.55967e-18
C715	a_84_48##3	VNB	3.84222e-17
C716	VPWR	a_28_368##10	2.70154e-17
C717	a_833_48#	A#6	1.39287e-20
C718	a_84_48##2	VNB	3.66269e-17
C719	VPWR	a_28_368##9	2.71751e-17
C720	a_27_74##4	TE_B#9	7.41672e-18
C721	VPWR	a_28_368##8	2.85343e-17
C722	a_833_48#	A#5	1.52575e-20
C723	a_84_48##24	a_84_48##22	4.23321e-17
C724	VPWR	a_28_368##5	2.00772e-17
C725	VGND#13	a_833_48##9	3.49896e-17
C726	Z#14	a_28_368##14	5.58296e-17
C727	VPWR	a_28_368##4	2.00772e-17
C728	VPWR#8	a_84_48##12	4.45505e-18
C729	TE_B	a_84_48##27	1.36845e-17
C730	TE_B#3	A#5	3.48133e-18
C731	VPWR	a_27_74##4	4.87269e-18
C732	VPWR	a_27_74##3	5.91702e-18
C733	TE_B	a_833_48##17	4.9269e-17
C734	VGND	VGND#7	6.06828e-17
C735	a_84_48##25	a_84_48##24	4.62253e-17
C736	VPWR#8	a_84_48##14	4.45505e-18
C737	a_27_74##13	a_84_48#	2.3218e-19
C738	VPWR	a_27_74##2	3.91281e-18
C739	VGND	VGND#6	5.77488e-17
C740	VGND#5	a_833_48##5	6.1305e-20
C741	VPWR	Z#12	2.78081e-18
C742	VGND	VGND#5	6.73053e-17
C743	a_27_74##13	VGND#12	5.88276e-17
C744	VPWR#10	TE_B#4	3.59292e-19
C745	a_27_74##5	a_833_48##9	2.92255e-17
C746	VGND	VGND#4	5.62248e-18
C747	VPWR	Z#10	2.36705e-18
C748	VGND#7	a_27_74##13	7.23643e-18
C749	a_28_368##4	a_28_368##12	1.03623e-18
C750	VPWR#8	a_84_48##16	4.45505e-18
C751	Z#13	Z#14	2.55185e-18
C752	Z#3	a_84_48##23	1.0296e-18
C753	VPWR#5	TE_B#7	2.25069e-20
C754	VPWR#8	a_84_48##18	4.4661e-18
C755	Z	a_27_74##16	9.05957e-18
C756	VGND#13	a_84_48#	1.94888e-18
C757	VPWR#3	TE_B#3	6.7495e-19
C758	a_27_74##10	Z	2.12425e-17
C759	VPWR#8	a_84_48##19	4.43311e-18
C760	a_27_74#	a_833_48##2	2.33173e-17
C761	Z#1	a_833_48##9	1.24931e-18
C762	a_28_368##5	VPWR#12	4.28522e-17
C763	VPWR#5	TE_B#16	2.55967e-18
C764	a_84_48##5	TE_B#17	1.41978e-17
C765	a_28_368##2	TE_B#6	5.59767e-19
C766	VPWR#8	a_84_48##22	4.4293e-18
C767	VGND	a_27_74##9	2.52231e-17
C768	a_84_48##5	TE_B#18	2.1908e-17
C769	VGND#3	A#4	5.95529e-19
C770	VGND	a_27_74##8	2.90849e-17
C771	Z#13	a_28_368##14	5.18225e-17
C772	VGND	a_27_74##7	2.88583e-17
C773	VPWR#8	a_84_48##24	4.4293e-18
C774	a_27_74##5	a_84_48#	3.45678e-17
C775	VGND#13	VGND#12	2.42564e-18
C776	VGND	a_27_74##4	3.09394e-18
C777	a_84_48##5	TE_B#19	2.18437e-17
C778	VGND#6	a_27_74##13	6.46603e-18
C779	VGND	a_27_74##3	2.13894e-18
C780	VGND	a_27_74##2	1.1591e-18
C781	VPWR#8	a_84_48##25	4.4661e-18
C782	a_84_48##5	TE_B#11	3.2126e-17
C783	VGND	Z#3	1.0249e-17
C784	a_84_48##5	a_84_48##12	8.09723e-18
C785	VGND	Z#2	1.09615e-17
C786	a_28_368##4	VPWR#12	4.27404e-17
C787	VGND#7	VNB	3.27068e-17
C788	VGND#6	VNB	2.45876e-17
C789	VGND#5	a_833_48##4	3.10405e-20
C790	VGND#13	a_84_48##13	2.73435e-19
C791	VGND#5	VNB	2.65379e-17
C792	a_84_48##5	a_84_48##14	7.20857e-19
C793	VGND#4	VNB	3.97749e-17
C794	VPWR	a_84_48##27	4.89255e-18
C795	VGND#2	VNB	2.9205e-17
C796	Z#1	a_84_48#	4.15874e-17
C797	a_28_368##2	TE_B#5	6.59135e-19
C798	VPWR#7	VNB	3.47257e-17
C799	VPWR#6	VNB	3.09261e-17
C800	VPWR#5	VNB	3.17141e-17
C801	a_84_48##5	a_84_48##16	3.31858e-20
C802	VPWR#4	VNB	3.14878e-17
C803	Z	Z#11	2.48456e-19
C804	VPWR#5	TE_B#6	2.27598e-20
C805	VPWR#6	TE_B#17	2.55967e-18
C806	a_28_368##15	a_28_368##14	3.6995e-18
C807	VGND	a_27_74##11	1.10964e-17
C808	VPWR#2	VNB	3.01501e-17
C809	Z	a_28_368##16	1.19798e-17
C810	a_27_74##3	TE_B#9	4.31043e-18
C811	VGND	a_27_74##12	1.51696e-17
C812	VPWR	a_28_368##2	1.08203e-18
C813	VGND#10	a_833_48##3	1.59647e-18
C814	a_84_48##5	a_84_48##18	1.85672e-20
C815	VPWR	VPWR#11	1.31069e-17
C816	VGND	a_27_74##13	1.51696e-17
C817	a_28_368##11	Z	3.14485e-17
C818	a_28_368##5	a_28_368##13	1.03443e-18
C819	a_28_368##10	VNB	5.11197e-18
C820	VGND	VGND#13	2.2533e-17
C821	a_28_368##9	VNB	4.08234e-18
C822	VPWR	VPWR#12	1.47372e-17
C823	VGND	a_27_74##5	2.13411e-17
C824	a_28_368##8	VNB	5.2839e-18
C825	VGND	Z#1	9.37706e-18
C826	a_27_74##5	a_84_48##13	3.69094e-19
C827	VGND#13	a_27_74##13	5.26068e-17
C828	a_28_368##5	VNB	2.07307e-18
C829	VPWR#3	A#3	1.96352e-18
C830	VPWR	VPWR#13	1.55398e-17
C831	a_28_368##4	VNB	2.07307e-18
C832	VPWR	a_28_368##6	2.58596e-17
C833	a_27_74##9	VNB	4.1975e-18
C834	a_27_74##8	VNB	5.37768e-18
C835	VPWR	Z#14	1.03182e-17
C836	a_27_74##7	VNB	5.12379e-18
C837	VGND#3	A#3	4.14384e-18
C838	a_27_74##4	VNB	2.43392e-18
C839	VGND	Z#5	9.15343e-18
C840	VPWR	Z#13	8.79022e-18
C841	a_28_368##8	a_84_48##4	8.21941e-20
C842	VGND	a_27_74##10	2.35189e-17
C843	a_27_74##2	VNB	7.68804e-19
C844	VPWR#11	TE_B#7	3.39433e-19
C845	Z#12	VNB	1.0602e-18
C846	VPWR	Z#11	9.05099e-18
C847	Z#10	VNB	7.92032e-19
C848	a_28_368##15	Z#13	4.39255e-17
C849	VGND#3	TE_B#5	1.12936e-19
C850	VGND#13	a_84_48##15	7.09521e-20
C851	Z#3	VNB	8.29081e-19
C852	VPWR	Z#9	1.01308e-17
C853	Z#2	VNB	1.06142e-18
C854	Z#1	a_84_48##13	3.19888e-17
C855	VPWR	a_28_368##11	2.37927e-17
C856	VGND#1	VNB	4.45244e-17
C857	VGND#13	VGND#6	2.12733e-19
C858	a_84_48##26	VNB	3.17119e-17
C859	VGND#9	VNB	4.69357e-18
C860	VGND#3	TE_B#4	1.40299e-18
C861	a_833_48##19	VNB	5.85939e-18
C862	VGND#3	a_833_48#	9.3857e-17
C863	a_27_74#	VNB	1.25777e-18
C864	VGND#10	VNB	2.9779e-18
C865	a_27_74##11	VNB	2.55367e-18
C866	VGND#11	VNB	4.9118e-19
C867	a_27_74##12	VNB	2.55033e-18
C868	VGND#12	VNB	5.2986e-18
C869	VGND#10	a_833_48##2	1.57651e-18
C870	VGND#3	TE_B#3	4.17627e-19
C871	a_27_74##13	VNB	2.17406e-18
C872	VGND#13	VNB	2.49821e-19
C873	a_27_74##5	VNB	7.78426e-18
C874	Z#1	VNB	4.68909e-19
C875	Z	a_84_48##21	5.22421e-21
C876	a_27_74##3	TE_B#8	8.79459e-18
C877	VPWR#8	a_84_48##5	2.55155e-20
C878	a_27_74##5	a_27_74##13	2.78479e-18
C879	Z	a_84_48##23	1.71694e-17
C880	a_27_74##11	a_833_48##4	9.10769e-19
C881	a_84_48##13	a_27_74##14	1.6949e-17
C882	VGND#7	a_27_74##5	1.96105e-17
C883	Z	a_84_48##11	7.49673e-18
C884	VPWR#5	TE_B#5	4.17263e-21
C885	VPWR#6	TE_B#18	2.55967e-18
C886	Z#11	Z#13	2.73857e-18
C887	VPWR#11	TE_B#6	2.67268e-19
C888	VGND#8	a_84_48##5	4.80373e-20
C889	a_28_368##5	VPWR#13	4.27661e-17
C890	a_27_74##10	VNB	5.08875e-17
C891	VGND	a_28_368##11	3.68384e-18
C892	VGND#1	VPWR#1	2.24763e-18
C893	VPWR#1	VNB	7.07238e-17
C894	a_84_48##27	VNB	3.15621e-17
C895	VPWR#9	VNB	6.19169e-19
C896	a_833_48##17	VNB	4.37197e-18
C897	a_28_368#	VNB	5.45555e-18
C898	VPWR#10	VNB	3.87444e-18
C899	a_28_368##2	VNB	2.07307e-18
C900	VPWR#11	VNB	3.74405e-18
C901	VGND#13	a_84_48##17	3.82212e-20
C902	VGND	a_833_48##12	2.13567e-19
C903	Z#1	a_84_48##15	4.50751e-19
C904	VGND	a_833_48##13	7.21016e-19
C905	VPWR#12	VNB	3.74405e-18
C906	VGND	a_833_48##14	3.45854e-19
C907	VPWR#13	VNB	4.05082e-18
C908	VGND	a_833_48##15	2.63491e-19
C909	a_28_368##8	a_84_48##3	1.02743e-19
C910	a_833_48##2	TE_B#1	4.9829e-19
C911	a_28_368##6	VNB	3.11322e-18
C912	VGND	a_833_48##16	8.1591e-19
C913	Z#14	VNB	5.79574e-19
C914	VGND	a_833_48##9	8.46788e-19
C915	VGND	a_84_48#	1.45999e-18
C916	VGND#4	a_833_48##4	3.02645e-20
C917	VGND	a_84_48##13	1.50692e-18
C918	VGND	a_84_48##15	1.64499e-18
C919	Z#11	a_28_368##15	4.38789e-17
C920	VGND	a_84_48##17	1.57806e-18
C921	a_28_368##11	VNB	6.00147e-17
C922	VGND	a_84_48##20	1.65985e-18
C923	A#1	VNB	3.40559e-17
C924	A#7	VNB	2.75076e-17
C925	VGND	a_84_48##21	1.65651e-18
C926	TE_B#1	VNB	3.15295e-17
C927	VGND	a_84_48##23	1.65666e-18
C928	a_833_48##10	VNB	2.97818e-17
C929	a_27_74##5	VGND#13	7.38264e-17
C930	a_84_48##15	a_27_74##14	8.39049e-18
C931	VGND	a_84_48##11	2.4414e-18
C932	a_833_48##11	VNB	2.23274e-17
C933	a_833_48##12	VNB	2.37547e-17
C934	Z	a_84_48##16	1.22526e-20
C935	a_833_48##3	a_27_74##11	4.9075e-19
C936	a_833_48##13	VNB	2.23497e-17
C937	a_833_48##14	VNB	2.58289e-17
C938	Z	a_84_48##18	1.57225e-20
C939	VGND#3	a_833_48##3	2.602e-21
C940	a_833_48##15	VNB	2.60189e-17
C941	a_27_74##3	TE_B#7	1.72262e-18
C942	VPWR#7	TE_B#19	2.55967e-18
C943	a_833_48##16	VNB	2.1671e-17
C944	Z	a_84_48##19	4.63034e-20
C945	VPWR	TE_B#11	2.79747e-19
C946	a_833_48##9	VNB	3.16879e-17
C947	a_28_368##8	Z#14	2.05327e-17
C948	a_84_48#	VNB	2.87762e-17
C949	VPWR	a_84_48##12	1.47934e-18
C950	Z	a_84_48##22	1.16768e-19
C951	a_28_368##4	TE_B#15	5.24626e-19
C952	a_84_48##13	VNB	2.95667e-17
C953	VPWR#3	TE_B	9.67105e-18
C954	VPWR	a_84_48##14	1.55862e-18
C955	VGND#11	a_833_48##5	1.615e-18
C956	a_84_48##15	VNB	2.97312e-17
C957	Z	a_84_48##24	1.83078e-17
C958	a_84_48##17	VNB	2.96939e-17
C959	VGND#3	a_833_48##2	8.6731e-19
C960	VPWR	a_84_48##16	1.64555e-18
C961	VGND#3	TE_B	9.3616e-18
C962	a_84_48##20	VNB	2.93751e-17
C963	Z	a_84_48##25	7.96981e-18
C964	a_84_48##21	VNB	2.90335e-17
C965	VPWR	a_84_48##18	1.64179e-18
C966	a_27_74##4	a_27_74##3	1.60744e-18
C967	a_84_48##23	VNB	2.78617e-17
C968	a_28_368##6	a_28_368##5	2.64007e-18
C969	VPWR	a_84_48##19	1.65381e-18
C970	a_84_48##11	VNB	3.6649e-17
C971	VPWR	a_84_48##22	1.6539e-18
C972	a_84_48##15	Z#6	1.66125e-17
C973	a_28_368##16	a_28_368##15	3.75941e-18
C974	VGND	TE_B#11	1.28342e-18
C975	A#6	VNB	3.89791e-17
C976	A#5	VNB	3.14958e-17
C977	VPWR	a_84_48##24	1.65017e-18
C978	TE_B	A#3	3.36385e-17
C979	TE_B#12	VNB	4.18329e-17
C980	VPWR	a_84_48##25	2.43704e-18
C981	TE_B#13	VNB	3.60779e-17
C982	TE_B#14	VNB	3.35477e-17
C983	TE_B#15	VNB	2.98424e-17
C984	TE_B#16	VNB	3.10031e-17
C985	a_833_48#	TE_B	7.18228e-17
C986	TE_B#17	VNB	3.09378e-17
C987	TE_B#18	VNB	3.12562e-17
C988	TE_B#19	VNB	3.03488e-17
C989	VPWR	VPWR#8	2.13573e-16
C990	TE_B#11	VNB	4.45152e-17
C991	a_84_48##12	VNB	3.35822e-17
C992	a_28_368##8	a_84_48##2	2.66576e-20
C993	a_84_48##14	VNB	3.32901e-17
C994	a_84_48##16	VNB	3.33379e-17
C995	Z	a_84_48##5	5.84974e-17
C996	a_84_48##18	VNB	3.34105e-17
C997	a_833_48##8	TE_B#10	1.92695e-17
C998	a_84_48##19	VNB	3.25151e-17
C999	a_84_48##22	VNB	3.23417e-17
C1000	a_84_48##24	VNB	3.15858e-17
C1001	VGND	VGND#8	2.11201e-16
C1002	VPWR	a_84_48##5	3.06068e-17
C1003	a_84_48##25	VNB	4.26531e-17
C1004	a_84_48##26	a_84_48##27	2.08937e-18
C1005	VPWR#3	VNB	2.18296e-16
C1006	VGND#4	a_833_48##3	6.24711e-20
C1007	a_28_368##16	Z#11	5.17701e-17
C1008	VGND#3	VNB	2.20025e-16
C1009	VPWR#8	VNB	1.30152e-16
C1010	VGND	a_84_48##5	1.80695e-17
C1011	VGND#8	VNB	1.2887e-16
C1012	A#3	VNB	4.08968e-18
C1013	VGND#11	a_833_48##4	1.57651e-18
C1014	a_833_48#	VNB	1.15709e-16
C1015	a_84_48##5	VNB	4.92541e-17
C1016	VPWR#4	TE_B#5	1.80814e-20
C1017	a_84_48##17	Z#6	8.22222e-18
C1018	a_28_368##4	TE_B#16	3.25644e-17
C1019	VPWR	Z	1.82112e-18
C1020	a_28_368##8	a_28_368##14	2.88553e-18
C1021	VPWR#12	TE_B#9	3.13613e-19
C1022	a_27_74##12	a_833_48##6	8.93027e-19
C1023	VGND	Z	1.96596e-18
C1024	VPWR#7	TE_B#11	2.29382e-18
C1025	TE_B	VNB	8.47169e-18
C1026	Z	VNB	1.90816e-17
C1027	VPWR	VNB	3.11005e-16
C1028	VGND	VNB	3.06753e-16
*
*
.ENDS sky130_fd_sc_hs__ebufn_8
*
