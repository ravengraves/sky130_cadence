* Extracted by Quantus, converted by sky130cad/quantus.py
*
*
*
*                       LINUX           Wed Nov 18 08:24:18 2026
*
*
*
*  PROGRAM  advgen
*
*  Name           : advgen - Quantus - (64-bit)
*  Version        : 25.1.0-p047
*  Build Date     : Thu Dec 11 23:20:30 PST 2025
*
*  HSPICE LIBRARY
*
*  OPERATING_TEMPERATURE 150
*  QRC_TECH_DIR <path>/tech
*
*
*

*
.SUBCKT sky130_fd_sc_hs__clkinv_1 VPB VNB VGND VPWR Y A
*
*
*  caps2d version: 10
*
*
*       TRANSISTOR CARDS
*
*
XM1 VGND#2 A#3 Y#1 VNB sky130_fd_pr__nfet_01v8_lvt l=0.15 w=0.42 ad=0.1491 as=0.22535 pd=1.55 ps=2.17
XM0 VPWR#3 A#4 Y#2 VPB sky130_fd_pr__pfet_01v8 l=0.15 w=0.84 ad=0.2394 as=0.252 pd=2.25 ps=2.28
XM2 Y#2 A#1 VPWR#1 VPB sky130_fd_pr__pfet_01v8 l=0.15 w=0.84 ad=0.252 as=0.2394 pd=2.28 ps=2.25
*
*
*       RESISTOR AND CAP/DIODE CARDS
*
Rg1	A#1	A#2	408.589050
Rg2	A#2	A#3	323.137848
Rg3	A#2	A#4	456.203064
Rf1	A	A#2	60.054501
Rf2	Y#1	Y	16.787693
Rf3	Y	Y#2	40.993176
Rf4	VPWR#1	VPWR#2	62.149097
Rf5	VPWR#2	VPWR#3	79.333160
Rf6	VGND#1	VGND#2	63.368923
Re1	VPWR#2	VPWR	3.274347
Re2	VGND	VGND#1	3.274471
*
*       CAPACITOR CARDS
*
*
C1	VGND	VNB	5.27871e-17
C2	VPWR	VNB	4.38996e-17
C3	A	VNB	4.30568e-17
C4	A#2	VNB	1.59264e-16
C5	VGND#1	VNB	1.49234e-16
C6	VGND	A	8.55512e-18
C7	VPWR#2	VNB	1.45288e-16
C8	A#4	VNB	3.59246e-17
C9	VPWR	A	7.82604e-18
C10	A#1	VNB	3.42011e-17
C11	VGND	VGND#1	3.41943e-17
C12	A#3	VNB	3.37312e-17
C13	VPWR#3	VNB	4.83681e-17
C14	Y#2	VNB	5.14546e-19
C15	VPWR#1	VNB	2.82082e-17
C16	VGND#2	VNB	2.84075e-17
C17	Y#1	VNB	1.13858e-16
C18	VPWR	VPWR#2	3.25202e-17
C19	VGND	A#3	1.53548e-18
C20	VPWR	A#4	2.276e-18
C21	A	A#2	7.55145e-17
C22	VPWR	A#1	8.62723e-19
C23	VGND#1	A	7.99132e-19
C24	VGND	VGND#2	2.76298e-17
C25	A	VPWR#2	8.14368e-19
C26	VGND	Y#1	2.81805e-17
C27	VPWR	VPWR#3	2.20557e-17
C28	VPWR	Y#2	1.54974e-17
C29	VPWR	VPWR#1	2.54178e-17
C30	VGND#1	A#2	7.76826e-19
C31	VPWR	Y#1	5.04668e-18
C32	VPWR#2	A#2	7.72309e-20
C33	A	VPWR#3	2.11067e-17
C34	A	Y#2	3.09294e-17
C35	A#2	A#1	3.55425e-18
C36	A	VGND#2	2.40582e-17
C37	A	Y#1	6.41161e-17
C38	VPWR#2	A#4	5.40869e-18
C39	VPWR#2	A#1	2.48764e-18
C40	VGND#1	A#3	4.676e-18
C41	Y#2	A#2	4.38975e-18
C42	VGND#2	A#2	1.05926e-19
C43	A#4	A#1	3.82466e-17
C44	VPWR#3	VPWR#2	1.93815e-19
C45	Y#1	A#2	4.63412e-17
C46	Y#2	VPWR#2	1.44725e-17
C47	VGND#1	Y#1	3.87302e-17
C48	VPWR#3	A#4	2.39218e-17
C49	Y#2	A#4	4.36304e-17
C50	VPWR#3	A#1	1.47287e-18
C51	VPWR#1	A#4	3.03016e-18
C52	Y#2	A#1	2.81877e-17
C53	VPWR#1	A#1	2.85149e-17
C54	Y#1	A#4	6.94889e-20
C55	Y#1	A#1	1.13384e-17
C56	VPWR#3	Y#2	6.422e-17
C57	A#3	VGND#2	1.89218e-17
C58	VPWR#3	VPWR#1	3.33216e-18
C59	Y#1	A#3	2.7084e-17
C60	VGND#2	VPWR#3	1.99913e-19
C61	Y#2	VPWR#1	3.34415e-17
C62	Y#1	Y#2	2.75029e-18
C63	Y#1	VPWR#1	3.40367e-17
C64	VGND#2	Y#1	3.29724e-17
*
*
.ENDS sky130_fd_sc_hs__clkinv_1
*
