* Extracted by Quantus, converted by sky130cad/quantus.py
*
*
*
*                       LINUX           Wed Nov 18 08:36:21 2026
*
*
*
*  PROGRAM  advgen
*
*  Name           : advgen - Quantus - (64-bit)
*  Version        : 25.1.0-p047
*  Build Date     : Thu Dec 11 23:20:30 PST 2025
*
*  HSPICE LIBRARY
*
*  OPERATING_TEMPERATURE 150
*  QRC_TECH_DIR <path>/tech
*
*
*

*
.SUBCKT sky130_fd_sc_hs__edfxbp_1 VPB VNB VGND VPWR Q Q_N D CLK DE
*
*
*  caps2d version: 10
*
*
*       TRANSISTOR CARDS
*
*
XM10 a_27_74##9 D#1 a_145_74# VNB sky130_fd_pr__nfet_01v8_lvt l=0.15 w=0.42 ad=0.1848 as=0.1008 pd=1.72 ps=1.32
XM31 a_145_74# DE#5 VGND#20 VNB sky130_fd_pr__nfet_01v8_lvt l=0.15 w=0.42 ad=0.1008 as=0.1197 pd=1.32 ps=1.41
XM6 a_161_446##9 DE#7 VGND#19 VNB sky130_fd_pr__nfet_01v8_lvt l=0.15 w=0.42 ad=0.1281 as=0.1512 pd=1.45 ps=1.56
XM26 VGND#19 a_161_446##3 a_527_74# VNB sky130_fd_pr__nfet_01v8_lvt l=0.15 w=0.42 ad=0.1512 as=0.1008 pd=1.56 ps=1.32
XM23 a_527_74# a_575_48##3 a_27_74##7 VNB sky130_fd_pr__nfet_01v8_lvt l=0.15 w=0.42 ad=0.1008 as=0.1197 pd=1.32 ps=1.41
XM29 VGND#18 CLK#3 a_818_74##15 VNB sky130_fd_pr__nfet_01v8_lvt l=0.15 w=0.74 ad=0.2109 as=0.1961 pd=2.05 ps=2.01
XM14 VGND#17 a_818_74##9 a_1008_74##14 VNB sky130_fd_pr__nfet_01v8_lvt l=0.15 w=0.74 ad=0.1961 as=0.1961 pd=2.01 ps=2.01
XM1 a_27_74##6 a_818_74##7 a_1198_97##4 VNB sky130_fd_pr__nfet_01v8_lvt l=0.15 w=0.42 ad=0.1113 as=0.2226 pd=1.37 ps=1.9
XM28 a_1198_97##4 a_1008_74##4 a_1334_97# VNB sky130_fd_pr__nfet_01v8_lvt l=0.15 w=0.42 ad=0.2226 as=0.1785 pd=1.9 ps=1.69
XM0 a_1334_97# a_1419_71# VGND#16 VNB sky130_fd_pr__nfet_01v8_lvt l=0.15 w=0.42 ad=0.1785 as=0.2776 pd=1.69 ps=2.34
XM24 VGND#16 a_1198_97##3 a_1419_71##11 VNB sky130_fd_pr__nfet_01v8_lvt l=0.15 w=0.64 ad=0.2776 as=0.1824 pd=2.34 ps=1.85
XM2 VGND#15 a_1419_71##7 a_1807_74# VNB sky130_fd_pr__nfet_01v8_lvt l=0.15 w=0.74 ad=0.2109 as=0.1554 pd=2.05 ps=1.9
XM17 a_1807_74# a_1008_74##5 a_1879_74##11 VNB sky130_fd_pr__nfet_01v8_lvt l=0.15 w=0.74 ad=0.1554 as=0.7478 pd=1.9 ps=4.66
XM20 a_1879_74##11 a_818_74##10 a_2227_118# VNB sky130_fd_pr__nfet_01v8_lvt l=0.15 w=0.42 ad=0.7478 as=0.1008 pd=4.66 ps=1.32
XM5 a_2227_118# a_575_48##4 VGND#14 VNB sky130_fd_pr__nfet_01v8_lvt l=0.15 w=0.42 ad=0.1008 as=0.2902 pd=1.32 ps=2.29
XM27 VGND#14 a_1879_74##8 a_575_48##17 VNB sky130_fd_pr__nfet_01v8_lvt l=0.15 w=0.64 ad=0.2902 as=0.1824 pd=2.29 ps=1.85
XM30 Q#3 a_1879_74##6 VGND#13 VNB sky130_fd_pr__nfet_01v8_lvt l=0.15 w=0.74 ad=0.2109 as=0.4514 pd=2.05 ps=2.7
XM22 VGND#13 a_575_48##8 Q_N#1 VNB sky130_fd_pr__nfet_01v8_lvt l=0.15 w=0.74 ad=0.4514 as=0.2109 pd=2.7 ps=2.05
XM34 a_27_74##5 D#3 a_116_508# VPB sky130_fd_pr__pfet_01v8 l=0.15 w=0.42 ad=0.1239 as=0.1008 pd=1.43 ps=1.32
XM8 a_116_508# a_161_446##2 VPWR#20 VPB sky130_fd_pr__pfet_01v8 l=0.15 w=0.42 ad=0.1008 as=0.1239 pd=1.32 ps=1.43
XM12 a_161_446##8 DE#6 VPWR#19 VPB sky130_fd_pr__pfet_01v8 l=0.15 w=0.64 ad=0.1888 as=0.2809 pd=1.87 ps=2.34
XM3 VPWR#19 DE#1 a_556_504# VPB sky130_fd_pr__pfet_01v8 l=0.15 w=0.42 ad=0.2809 as=0.1008 pd=2.34 ps=1.32
XM13 a_556_504# a_575_48# a_27_74##8 VPB sky130_fd_pr__pfet_01v8 l=0.15 w=0.42 ad=0.1008 as=0.1239 pd=1.32 ps=1.43
XM15 VPWR#18 CLK#1 a_818_74##13 VPB sky130_fd_pr__pfet_01v8 l=0.15 w=1.12 ad=0.3304 as=0.3304 pd=2.83 ps=2.83
XM4 VPWR#17 a_818_74##8 a_1008_74##15 VPB sky130_fd_pr__pfet_01v8 l=0.15 w=1.12 ad=0.3304 as=0.3304 pd=2.83 ps=2.83
XM18 a_27_74# a_1008_74# a_1198_97##6 VPB sky130_fd_pr__pfet_01v8 l=0.15 w=0.42 ad=0.206 as=0.126 pd=1.92 ps=1.44
XM21 a_1198_97##6 a_818_74# a_1423_508# VPB sky130_fd_pr__pfet_01v8 l=0.15 w=0.42 ad=0.126 as=0.1512 pd=1.44 ps=1.56
XM16 a_1423_508# a_1419_71##3 VPWR#16 VPB sky130_fd_pr__pfet_01v8 l=0.15 w=0.42 ad=0.1512 as=0.37685 pd=1.56 ps=3.09
XM19 VPWR#16 a_1198_97# a_1419_71##8 VPB sky130_fd_pr__pfet_01v8 l=0.15 w=0.84 ad=0.37685 as=0.2478 pd=3.09 ps=2.27
XM32 VPWR#15 a_1419_71##4 a_2008_392# VPB sky130_fd_pr__pfet_01v8 l=0.15 w=1 ad=0.295 as=0.27 pd=2.59 ps=2.54
XM11 a_2008_392# a_818_74##12 a_1879_74##12 VPB sky130_fd_pr__pfet_01v8 l=0.15 w=1 ad=0.27 as=0.3475 pd=2.54 ps=2.84
XM35 a_1879_74##12 a_1008_74##7 a_2206_443# VPB sky130_fd_pr__pfet_01v8 l=0.15 w=0.42 ad=0.3475 as=0.1386 pd=2.84 ps=1.5
XM33 a_2206_443# a_575_48##6 VPWR#14 VPB sky130_fd_pr__pfet_01v8 l=0.15 w=0.42 ad=0.1386 as=0.4918 pd=1.5 ps=3.61
XM7 VPWR#14 a_1879_74##7 a_575_48##21 VPB sky130_fd_pr__pfet_01v8 l=0.15 w=1 ad=0.4918 as=0.295 pd=3.61 ps=2.59
XM25 Q#1 a_1879_74# VPWR#13 VPB sky130_fd_pr__pfet_01v8 l=0.15 w=1.12 ad=0.3304 as=0.336 pd=2.83 ps=2.84
XM9 VPWR#13 a_575_48##10 Q_N#3 VPB sky130_fd_pr__pfet_01v8 l=0.15 w=1.12 ad=0.336 as=0.3304 pd=2.84 ps=2.83
*
*
*       RESISTOR AND CAP/DIODE CARDS
*
Rg1	D#1	D#2	325.464630
Rg2	D#2	D#3	467.750122
Rg3	a_161_446#	a_161_446##2	509.556946
Rg4	a_161_446##3	a_161_446##4	295.497040
Rg5	DE#1	DE#2	623.650208
Rg6	DE#2	DE#3	39.880802
Rg7	DE#3	DE#4	310.753204
Rg8	DE#4	DE#5	484.685486
Rg9	DE#2	DE#6	352.285919
Rg10	DE#4	DE#7	364.174438
Rg11	a_575_48#	a_575_48##2	462.550323
Rg12	a_575_48##2	a_575_48##3	328.965332
Rg13	CLK#1	CLK#2	474.071686
Rg14	CLK#2	CLK#3	289.949829
Rg15	a_1008_74#	a_1008_74##2	495.662048
Rg16	a_1008_74##3	a_1008_74##4	372.673157
Rg17	a_818_74#	a_818_74##2	233.787552
Rg18	a_818_74##2	a_818_74##3	666.609619
Rg19	a_818_74##3	a_818_74##4	204.756165
Rg20	a_818_74##4	a_818_74##5	295.600464
Rg21	a_818_74##5	a_818_74##6	179.896255
Rg22	a_818_74##3	a_818_74##7	529.547852
Rg23	a_818_74##4	a_818_74##8	371.735809
Rg24	a_818_74##5	a_818_74##9	520.453369
Rg25	a_1419_71#	a_1419_71##2	398.572327
Rg26	a_1419_71##2	a_1419_71##3	589.929932
Rg27	a_1198_97#	a_1198_97##2	356.519348
Rg28	a_1198_97##2	a_1198_97##3	550.338074
Rg29	a_1419_71##4	a_1419_71##5	873.813843
Rg30	a_1419_71##5	a_1419_71##6	102.600258
Rg31	a_1419_71##5	a_1419_71##7	533.732727
Rg32	a_1008_74##5	a_1008_74##6	686.927185
Rg33	a_818_74##10	a_818_74##11	596.247009
Rg34	a_818_74##11	a_818_74##12	404.649048
Rg35	a_1008_74##7	a_1008_74##8	345.585938
Rg36	a_575_48##4	a_575_48##5	640.105347
Rg37	a_575_48##5	a_575_48##6	315.502228
Rg38	a_575_48##5	a_575_48##7	39.456203
Rg39	a_1879_74#	a_1879_74##2	539.107727
Rg40	a_1879_74##2	a_1879_74##3	146.845963
Rg41	a_1879_74##3	a_1879_74##4	46.974712
Rg42	a_1879_74##4	a_1879_74##5	33.465229
Rg43	a_1879_74##2	a_1879_74##6	275.051239
Rg44	a_1879_74##3	a_1879_74##7	358.763855
Rg45	a_1879_74##4	a_1879_74##8	304.803375
Rg46	a_575_48##8	a_575_48##9	366.265259
Rg47	a_575_48##9	a_575_48##10	456.142303
Rf1	D#4	D	0.864585
Rf2	D#2	D#6	54.275520
Rf3	D#4	D#6	6.078417
Rf4	D#7	D	0.864585
Rf5	D#6	D#7	5.758500
Rf6	DE#8	DE	0.956614
Rf7	DE#3	DE#10	161.189423
Rf8	DE#8	DE#10	2.362036
Rf9	a_161_446##4	a_161_446##6	152.712280
Rf10	a_161_446##6	a_161_446#	49.420227
Rf11	a_161_446##6	a_161_446##8	44.206856
Rf12	a_161_446#	a_161_446##9	92.668594
Rf13	a_575_48##2	a_575_48##12	53.942986
Rf14	a_575_48##13	a_575_48##14	0.532052
Rf15	a_575_48##12	a_575_48##13	7.086109
Rf16	CLK	CLK#2	81.905983
Rf17	a_818_74##13	a_818_74##6	33.999481
Rf18	a_818_74##6	a_818_74##15	104.953674
Rf19	a_27_74#	a_27_74##2	119.529686
Rf20	a_27_74##2	a_27_74##3	142.450089
Rf21	a_27_74##3	a_27_74##4	286.507660
Rf22	a_27_74##4	a_27_74##5	29.200062
Rf23	a_27_74##2	a_27_74##6	131.817291
Rf24	a_27_74##3	a_27_74##7	142.524567
Rf25	a_27_74##3	a_27_74##8	26.462353
Rf26	a_27_74##4	a_27_74##9	147.134003
Rf27	a_1198_97##4	a_1198_97##5	101.997566
Rf28	a_1198_97##5	a_1198_97##6	80.792694
Rf29	a_1198_97##5	a_1198_97##2	256.599182
Rf30	a_1419_71##8	a_1419_71##6	38.131119
Rf31	a_1419_71##6	a_1419_71##10	78.719910
Rf32	a_1419_71##10	a_1419_71##11	52.242409
Rf33	a_1419_71##10	a_1419_71##2	208.593002
Rf34	a_818_74##11	a_818_74##2	655.860962
Rf35	a_1008_74##8	a_1008_74##6	245.901917
Rf36	a_1008_74##6	a_1008_74##3	292.281342
Rf37	a_1008_74##3	a_1008_74##12	90.779556
Rf38	a_1008_74##12	a_1008_74##2	120.298950
Rf39	a_1008_74##12	a_1008_74##14	82.616409
Rf40	a_1008_74##2	a_1008_74##15	25.761993
Rf41	a_1879_74##5	a_1879_74##10	178.164597
Rf42	a_1879_74##10	a_1879_74##11	80.554214
Rf43	a_1879_74##10	a_1879_74##12	118.993103
Rf44	Q	Q#2	0.158107
Rf45	Q#2	Q	11.541809
Rf46	Q	Q#3	96.541603
Rf47	Q#1	Q#2	5.000000
Rf48	a_575_48##9	a_575_48##16	333.954895
Rf49	a_575_48##16	a_575_48##18	2.556245
Rf50	a_575_48##18	a_575_48##19	0.580678
Rf51	a_575_48##19	a_575_48##7	176.687347
Rf52	a_575_48##16	a_575_48##21	23.779566
Rf53	a_575_48##17	a_575_48##18	7.500000
Rf54	Q_N#2	Q_N	5.978708
Rf55	Q_N	Q_N#3	91.519440
Rf56	Q_N#2	Q_N	7.428092
Rf57	Q_N#1	Q_N#2	7.500000
Rf58	VPWR#1	VPWR#2	18.660692
Rf59	VPWR#2	VPWR#3	130.022232
Rf60	VPWR#3	VPWR#4	132.180923
Rf61	VPWR#4	VPWR#5	24.812635
Rf62	VPWR#5	VPWR#6	137.285858
Rf63	VPWR#6	VPWR#7	189.151718
Rf64	VPWR#7	VPWR#8	101.491127
Rf65	VPWR#8	VPWR#9	37.961727
Rf66	VPWR#9	VPWR#10	61.395233
Rf67	VPWR#10	VPWR#11	105.258347
Rf69	VPWR#2	VPWR#13	48.259808
Rf70	VPWR#3	VPWR#14	20.368595
Rf71	VPWR#5	VPWR#15	35.530331
Rf72	VPWR#6	VPWR#16	22.697315
Rf73	VPWR#7	VPWR#17	33.720150
Rf74	VPWR#8	VPWR#18	31.948624
Rf75	VPWR#10	VPWR#19	38.050537
Rf76	VPWR#11	VPWR#20	37.538910
Rf77	VGND#1	VGND#2	16.899656
Rf78	VGND#2	VGND#3	136.677933
Rf79	VGND#3	VGND#4	127.083328
Rf80	VGND#4	VGND#5	94.633202
Rf81	VGND#5	VGND#6	105.258347
Rf82	VGND#6	VGND#7	189.574326
Rf83	VGND#7	VGND#8	69.471481
Rf84	VGND#8	VGND#9	32.240261
Rf85	VGND#9	VGND#10	74.852226
Rf86	VGND#10	VGND#11	78.845467
Rf88	VGND#2	VGND#13	57.891499
Rf89	VGND#3	VGND#14	31.337896
Rf90	VGND#5	VGND#15	41.120300
Rf91	VGND#6	VGND#16	42.910995
Rf92	VGND#7	VGND#17	33.326477
Rf93	VGND#8	VGND#18	51.682205
Rf94	VGND#10	VGND#19	34.507496
Rf95	VGND#11	VGND#20	34.507496
Re1	a_575_48##19	a_575_48##14	35.002666
Re2	VPWR#1	VPWR#22	6.363944
Re3	VPWR#22	VPWR	1.106290
Re4	VPWR	VPWR#9	2.173466
Re5	VGND#1	VGND#22	6.363944
Re6	VGND#22	VGND	1.106290
Re7	VGND	VGND#9	2.173466
Re11	VPWR#4	VPWR#22	0.698413
Re14	VGND#4	VGND#22	0.698413
*
*       CAPACITOR CARDS
*
*
C1	a_1008_74##8	a_575_48##4	1.44858e-18
C2	a_161_446##4	VGND#19	3.08435e-17
C3	a_818_74##10	a_575_48##4	4.28894e-17
C4	VGND#18	VGND#17	2.36972e-18
C5	a_818_74##11	VPWR#5	9.24234e-18
C6	a_1008_74##5	a_1879_74##11	2.33216e-17
C7	VGND#9	a_818_74##9	2.63586e-18
C8	VPWR#14	a_1008_74##7	3.1593e-18
C9	a_575_48##14	a_27_74##2	5.43509e-17
C10	a_161_446##9	a_161_446##4	2.28423e-17
C11	VGND#7	a_818_74##9	4.84593e-18
C12	VPWR#9	DE#2	1.26664e-18
C13	VPWR#9	a_1198_97##5	2.00849e-18
C14	a_1008_74##8	a_818_74##10	3.14199e-17
C15	a_575_48##19	a_575_48##10	1.76182e-19
C16	a_1879_74##10	a_2227_118#	1.64811e-18
C17	VGND#15	a_818_74##10	9.7826e-19
C18	a_1879_74##12	a_575_48##6	4.13343e-18
C19	CLK#1	a_818_74##8	2.38824e-18
C20	a_27_74##2	VPWR#18	9.60977e-21
C21	VPWR#7	a_1008_74#	3.94522e-19
C22	VGND#10	CLK#3	7.73077e-20
C23	a_575_48##21	a_818_74##12	1.61779e-19
C24	DE#4	a_161_446##4	3.00586e-18
C25	a_818_74##11	a_575_48##4	4.23469e-19
C26	VPWR#9	a_27_74##4	2.75885e-17
C27	a_1879_74##10	a_575_48##7	3.54353e-17
C28	a_575_48##19	a_1879_74#	9.05505e-19
C29	a_575_48##9	a_1879_74##4	2.65659e-19
C30	VPWR#6	VPWR#16	9.00237e-18
C31	a_161_446##4	DE#2	5.38198e-17
C32	VGND#10	a_161_446##9	6.53163e-18
C33	VPWR#6	a_1198_97##3	2.18253e-19
C34	VGND#9	a_575_48##3	4.88845e-18
C35	a_27_74##3	a_27_74##8	1.35731e-18
C36	a_1008_74##2	a_1198_97##6	1.2207e-17
C37	VGND#18	a_818_74##15	5.37665e-17
C38	VPWR#6	a_1008_74#	2.62112e-18
C39	VGND#9	a_818_74##4	1.65889e-19
C40	a_27_74##3	VPWR#9	7.37324e-17
C41	VPWR#14	a_818_74##12	2.15221e-18
C42	a_1879_74##10	a_1419_71##4	1.43611e-18
C43	a_1879_74##11	a_1419_71##7	2.93927e-18
C44	a_575_48##19	a_1879_74##7	2.32577e-17
C45	VGND#8	CLK#3	7.14555e-18
C46	a_161_446##9	DE#3	1.9264e-17
C47	a_1879_74##12	a_1008_74##7	3.08676e-17
C48	a_1008_74##2	a_27_74#	2.10837e-17
C49	VGND#9	a_161_446##3	3.69649e-19
C50	a_1008_74##5	a_818_74##11	3.66838e-18
C51	a_1008_74##6	a_575_48##4	4.22504e-19
C52	a_1008_74##5	a_818_74##10	1.77027e-18
C53	a_575_48##14	a_575_48##13	2.0869e-17
C54	VGND#15	a_1008_74##5	6.09888e-18
C55	a_575_48#	CLK#1	4.57261e-18
C56	VGND#9	a_818_74##3	9.80633e-20
C57	VPWR#9	a_27_74##2	1.5273e-17
C58	a_575_48##9	a_1879_74##2	5.31315e-17
C59	VGND#5	a_1198_97##2	2.81048e-20
C60	a_1879_74##10	a_1879_74##8	1.32313e-18
C61	a_27_74##7	a_27_74##3	5.60679e-19
C62	a_161_446##6	DE#7	1.08558e-18
C63	VGND#9	a_1198_97##5	5.60906e-19
C64	VGND#9	DE#7	4.78228e-18
C65	a_1008_74##6	a_818_74##10	6.99241e-19
C66	a_1879_74##10	VPWR#3	1.83702e-18
C67	VGND#10	DE#4	3.56268e-19
C68	a_1198_97##5	a_1419_71##5	2.45835e-19
C69	VGND#9	DE#4	3.10352e-18
C70	a_1879_74##10	VPWR#14	1.43035e-18
C71	VPWR#7	a_818_74##8	9.38562e-19
C72	a_27_74##7	a_818_74##15	1.65267e-18
C73	a_1008_74##6	a_1008_74##5	2.21744e-17
C74	VGND#9	DE#5	1.18927e-18
C75	VGND#10	a_575_48##3	3.19296e-18
C76	a_1008_74##8	a_1879_74##10	6.69071e-17
C77	a_161_446##9	a_161_446#	1.39845e-18
C78	a_1879_74##12	a_818_74##12	5.81273e-17
C79	a_1879_74##11	a_1198_97##3	5.15763e-19
C80	VGND#9	DE#2	1.80577e-18
C81	a_575_48##14	a_575_48##12	1.57591e-17
C82	VGND#3	a_1879_74##2	1.71576e-20
C83	a_27_74##6	a_818_74##4	6.29508e-18
C84	a_1879_74##11	a_1879_74##10	1.84262e-18
C85	a_1008_74##6	a_1419_71##7	2.43323e-17
C86	VGND#20	a_161_446#	2.72161e-17
C87	DE#1	a_575_48#	4.35118e-17
C88	VGND#9	D#1	1.89174e-18
C89	DE#3	DE#4	3.08124e-19
C90	VPWR#10	CLK#1	2.09951e-19
C91	VGND#15	a_1419_71##7	4.40388e-17
C92	VGND#7	a_818_74##4	6.90567e-20
C93	VPWR#9	a_575_48##13	3.74419e-18
C94	a_818_74##6	VPWR#17	8.93713e-19
C95	a_1008_74##6	a_1198_97##3	5.69811e-18
C96	VGND#8	a_575_48##3	5.04951e-19
C97	DE#3	DE#2	1.67207e-17
C98	a_1419_71##6	a_1008_74##5	2.39797e-18
C99	a_1419_71##7	a_1008_74##5	7.04116e-17
C100	a_1198_97##6	VPWR#7	1.65907e-18
C101	a_1879_74##10	a_575_48##4	2.86929e-17
C102	a_1879_74##10	a_1879_74##4	5.26369e-19
C103	VPWR#4	a_818_74##12	7.74154e-18
C104	VPWR#8	CLK#1	3.3124e-18
C105	a_27_74##7	VGND#18	6.53295e-17
C106	a_1879_74##12	a_1419_71##4	9.65138e-18
C107	a_1419_71##6	a_1419_71##7	5.728e-18
C108	a_161_446##9	D#2	2.03441e-19
C109	a_1419_71##11	a_1419_71##7	4.34533e-19
C110	VPWR#15	a_818_74##12	7.10824e-18
C111	VGND#10	DE#2	4.42319e-19
C112	a_27_74##6	a_818_74##3	7.90433e-18
C113	VGND#5	a_1419_71##5	2.37789e-19
C114	DE#6	DE#1	2.36135e-17
C115	VPWR#4	a_1419_71##4	4.82408e-18
C116	a_1879_74##10	a_818_74##11	3.11381e-19
C117	a_27_74##3	VPWR#19	8.17747e-17
C118	VGND#15	a_1198_97##3	6.64407e-19
C119	VGND#10	a_161_446##3	6.9368e-18
C120	a_575_48##19	VGND#13	3.53874e-17
C121	a_1198_97##6	VPWR#6	2.02722e-17
C122	a_1198_97##2	a_1419_71##7	2.0936e-19
C123	VGND#3	a_575_48##5	1.17379e-20
C124	a_818_74##13	CLK#2	2.68026e-18
C125	a_1008_74##12	a_1198_97##5	2.81202e-19
C126	a_27_74##9	D#2	1.56735e-17
C127	a_575_48##5	a_1879_74##5	2.398e-17
C128	VPWR#10	a_575_48#	8.26711e-19
C129	a_27_74##4	a_161_446##8	5.17114e-17
C130	VGND#7	a_818_74##3	1.3106e-20
C131	VPWR#18	CLK#2	6.14949e-19
C132	a_575_48##19	Q#3	7.35425e-17
C133	VPWR#6	a_1198_97##2	5.72271e-19
C134	a_1198_97##2	a_1198_97##3	9.07102e-19
C135	VPWR#15	a_1419_71##4	5.67492e-17
C136	a_1198_97##3	a_1419_71##7	6.05166e-18
C137	a_575_48##9	a_1879_74#	1.79304e-17
C138	VPWR#9	a_161_446##6	2.26561e-18
C139	a_1419_71##11	a_1198_97##3	1.4369e-17
C140	VGND#2	a_1879_74##2	2.38424e-19
C141	a_1008_74##14	a_818_74##4	1.49487e-18
C142	VGND#6	a_818_74##2	1.40849e-19
C143	VGND#8	a_161_446##3	3.45778e-20
C144	a_1879_74##10	a_818_74##10	4.49392e-18
C145	a_161_446##2	DE#6	6.10786e-18
C146	a_27_74#	VPWR#7	6.40736e-17
C147	DE#4	a_161_446#	4.25191e-18
C148	a_575_48##19	a_575_48##17	2.53183e-18
C149	a_818_74##13	a_575_48##2	1.86458e-18
C150	a_161_446#	DE#2	4.62091e-17
C151	VGND#9	a_575_48##12	7.09977e-18
C152	Q_N#1	a_1879_74##2	4.1584e-19
C153	a_27_74##4	D#7	5.94016e-17
C154	a_27_74##3	a_161_446##8	4.99371e-17
C155	a_1419_71##2	a_1198_97##3	1.3314e-17
C156	VGND#14	a_575_48##19	7.31132e-17
C157	a_1198_97##3	VGND#16	2.02882e-17
C158	VGND#19	VGND#18	1.33155e-18
C159	VPWR#15	a_1198_97#	1.16031e-18
C160	a_27_74#	VPWR#6	2.35412e-18
C161	VGND#10	DE#7	7.429e-18
C162	D#3	a_161_446##2	4.49205e-17
C163	a_27_74##4	VPWR#20	6.74112e-17
C164	a_818_74##2	a_1198_97##3	2.80254e-19
C165	VPWR#10	DE#1	7.35616e-18
C166	a_1419_71#	a_1198_97##3	1.26836e-17
C167	VPWR#6	a_1419_71##2	1.128e-19
C168	a_1419_71##8	a_1198_97#	3.48453e-17
C169	a_1198_97##5	a_818_74##3	1.15022e-17
C170	a_1879_74##10	a_1008_74##5	2.78471e-19
C171	a_575_48##19	a_1879_74##11	1.29447e-17
C172	VGND#6	a_1008_74##3	4.05582e-17
C173	a_575_48##7	a_575_48##5	2.32182e-17
C174	a_1008_74##3	a_1419_71##7	7.16231e-19
C175	VPWR#15	a_1419_71##3	3.63517e-19
C176	VGND#19	a_27_74##7	1.67055e-17
C177	VGND#16	a_1419_71#	2.66709e-17
C178	VGND#6	a_818_74##3	4.85434e-20
C179	a_575_48##14	a_1008_74#	1.54638e-19
C180	a_1198_97#	VPWR#16	1.58832e-17
C181	VGND#5	a_1008_74##3	4.00477e-17
C182	a_1008_74##3	a_1198_97##3	4.38073e-17
C183	VPWR#9	D#7	5.47677e-18
C184	a_1879_74##11	a_1879_74##12	5.94291e-19
C185	D#2	DE#4	1.32452e-18
C186	Q#3	a_1879_74##4	3.64698e-18
C187	a_1419_71##8	a_1419_71##3	2.77078e-18
C188	a_1008_74##3	a_1419_71#	2.93095e-17
C189	D#2	DE#2	1.54184e-18
C190	VPWR#9	a_1008_74#	2.47667e-19
C191	a_575_48##19	VGND#15	1.73629e-18
C192	a_1879_74##2	VGND#13	9.5274e-19
C193	VPWR#7	a_818_74##2	1.25537e-19
C194	a_1008_74##3	a_1008_74##4	1.39696e-17
C195	VGND#10	DE#5	2.72824e-19
C196	a_575_48##14	CLK#1	1.27097e-18
C197	a_1008_74##4	a_1419_71#	1.33e-17
C198	a_1419_71##3	VPWR#16	1.03549e-17
C199	VPWR#10	DE#6	4.87908e-18
C200	a_161_446##9	a_27_74##7	1.21416e-18
C201	VPWR#9	a_818_74##8	3.37832e-18
C202	a_818_74##2	VPWR#6	7.56688e-17
C203	a_1879_74##2	a_575_48##8	4.98712e-18
C204	a_818_74##7	a_1008_74##3	6.09733e-18
C205	VGND#16	a_1008_74##4	1.91709e-18
C206	a_1879_74##10	a_575_48##5	2.06955e-17
C207	a_1198_97##6	a_1198_97#	9.347e-19
C208	a_1879_74##11	a_2227_118#	1.64028e-18
C209	a_27_74##4	D#6	5.13621e-18
C210	VPWR#15	a_1419_71##5	1.36355e-18
C211	a_818_74##2	VPWR#5	1.48187e-17
C212	a_818_74##12	a_1008_74##8	4.59143e-18
C213	a_27_74#	a_1198_97##6	1.56263e-17
C214	a_575_48##12	a_27_74##7	7.83294e-17
C215	a_1879_74##4	a_1879_74##6	7.79122e-19
C216	VPWR#10	VPWR#8	4.66591e-19
C217	D#4	DE#5	5.15404e-18
C218	a_27_74#	a_1198_97#	3.02245e-19
C219	a_1008_74##2	a_818_74##7	2.87195e-18
C220	VPWR#9	a_575_48#	1.52091e-17
C221	a_1008_74##8	a_575_48##5	3.89884e-17
C222	a_27_74##5	a_27_74##4	1.66882e-18
C223	a_818_74##11	a_818_74##12	3.89117e-19
C224	VGND#4	a_1879_74##11	3.06342e-17
C225	a_1008_74##2	a_818_74##9	1.6154e-19
C226	a_1198_97##6	a_1419_71##3	2.91948e-18
C227	VPWR#9	DE#1	5.96223e-18
C228	a_27_74##9	a_27_74##4	8.21077e-19
C229	a_818_74##7	a_1008_74##4	9.32469e-18
C230	a_1419_71##10	a_1008_74##6	3.99094e-17
C231	a_818_74##11	a_1419_71##4	2.42944e-17
C232	a_1879_74##4	a_575_48##17	6.15976e-19
C233	a_1198_97##4	a_1008_74##4	6.11928e-18
C234	VPWR#10	a_161_446##2	1.5676e-19
C235	VGND#9	D#4	9.58243e-18
C236	a_27_74#	a_1419_71##3	4.43917e-19
C237	VGND#7	a_818_74##6	1.89797e-20
C238	a_818_74##11	a_1198_97#	4.67626e-19
C239	Q#3	a_1879_74##2	2.41015e-17
C240	VGND#9	DE#1	1.45341e-18
C241	a_818_74##6	a_818_74##9	4.47359e-19
C242	VPWR#10	VPWR#18	3.06237e-19
C243	D#6	DE#2	6.4683e-20
C244	VGND#1	a_575_48##19	5.45784e-18
C245	a_1008_74##6	a_1419_71##4	2.59619e-17
C246	a_1198_97##6	a_818_74#	2.97266e-17
C247	a_27_74##4	DE#4	3.928e-19
C248	DE#7	DE#2	6.22937e-18
C249	a_161_446##9	VGND#19	3.71709e-17
C250	VPWR#9	a_161_446##2	1.78774e-18
C251	a_27_74#	a_1008_74##15	3.90089e-18
C252	VGND#14	a_1879_74##11	2.4814e-19
C253	a_818_74##15	a_818_74##3	2.625e-20
C254	CLK#2	a_818_74##9	4.20504e-18
C255	VPWR#9	D#3	1.57633e-18
C256	a_1419_71##6	a_1419_71##4	3.32789e-19
C257	a_27_74#	a_818_74#	7.13474e-19
C258	VGND#9	a_161_446##2	7.4041e-19
C259	a_818_74##7	a_1198_97##4	1.51005e-17
C260	a_1198_97##5	a_1198_97#	1.94102e-19
C261	DE#4	DE#2	2.4971e-18
C262	D#4	DE#4	1.50196e-19
C263	a_1419_71##10	a_1419_71##6	1.18601e-18
C264	a_818_74##9	a_818_74##7	6.46383e-18
C265	VPWR#17	a_1419_71##3	8.27735e-20
C266	a_575_48##19	VPWR#4	4.98969e-18
C267	VPWR#7	a_1008_74##2	9.69769e-19
C268	a_1198_97##6	a_1008_74#	3.54342e-17
C269	a_1419_71##6	a_1198_97#	2.6531e-18
C270	a_818_74##11	a_575_48##5	1.28472e-18
C271	VGND#20	VGND#19	5.76659e-18
C272	VGND#8	CLK#2	6.7944e-20
C273	VPWR#17	a_27_74#	2.36946e-17
C274	a_1419_71##6	a_1419_71##3	3.88776e-19
C275	Q_N#1	a_575_48##9	4.6692e-17
C276	a_575_48##19	VGND#4	7.08787e-18
C277	a_818_74##7	a_27_74##6	2.63896e-17
C278	a_818_74##11	a_1419_71##5	3.97724e-17
C279	a_27_74##4	DE#2	7.58218e-19
C280	VGND#7	CLK#2	1.80824e-19
C281	a_1008_74#	a_27_74#	1.25375e-17
C282	a_27_74##2	a_818_74##4	1.15146e-17
C283	a_575_48##2	CLK#3	2.85608e-18
C284	VPWR#18	VPWR#7	1.63608e-19
C285	a_1419_71##6	a_818_74#	1.01257e-19
C286	a_575_48##9	VGND#13	8.89301e-17
C287	VPWR#17	a_818_74#	9.18306e-20
C288	a_1008_74##12	a_1198_97##3	8.56631e-19
C289	a_1198_97##6	a_818_74##8	1.50739e-18
C290	VPWR#8	VPWR#7	4.83214e-19
C291	a_575_48##14	VGND#16	1.83143e-18
C292	D#4	DE#2	1.55678e-19
C293	a_1008_74##14	a_818_74##7	1.98435e-18
C294	a_1419_71##2	a_1198_97#	2.32051e-19
C295	Q#3	a_575_48##9	7.1509e-17
C296	VGND#20	a_161_446##9	2.75411e-17
C297	a_1419_71##10	a_1198_97##2	4.71733e-17
C298	CLK#3	a_818_74##9	5.21315e-18
C299	a_818_74##2	a_1419_71##4	2.28695e-19
C300	a_575_48##9	VPWR#1	7.08609e-18
C301	a_1008_74##12	VGND#16	5.76807e-18
C302	a_27_74#	a_818_74##8	7.12102e-18
C303	a_27_74##6	a_818_74##9	5.15278e-18
C304	VPWR#7	a_818_74##6	1.65469e-18
C305	VPWR#17	a_1008_74#	1.07628e-18
C306	a_818_74##2	a_1198_97#	3.90081e-17
C307	DE#2	DE#1	3.68214e-18
C308	a_1008_74##12	a_818_74##2	6.72162e-20
C309	VGND#1	a_575_48##9	5.41397e-18
C310	VGND#17	a_818_74##7	2.64892e-19
C311	a_27_74##2	a_818_74##3	9.21212e-19
C312	a_1008_74##15	a_818_74##8	3.02811e-17
C313	a_575_48##4	a_1879_74##4	4.39132e-18
C314	a_818_74##2	a_1419_71##3	5.3182e-17
C315	DE#7	a_161_446##4	1.61615e-17
C316	a_1008_74##6	a_575_48##5	4.4035e-19
C317	a_1008_74##14	a_818_74##9	2.0631e-17
C318	a_575_48##19	a_575_48##9	2.24283e-18
C319	a_1198_97##5	a_1198_97##2	7.12936e-19
C320	a_575_48##14	a_27_74##6	1.55473e-17
C321	a_1008_74##12	a_1419_71#	1.83818e-18
C322	VGND#19	a_161_446##6	3.01752e-18
C323	a_818_74##2	a_818_74#	5.65596e-18
C324	Q_N#3	VPWR#1	4.26161e-17
C325	VPWR#17	a_818_74##8	4.84147e-17
C326	a_818_74##15	a_818_74##7	7.03461e-19
C327	a_27_74##3	DE#2	2.62174e-18
C328	a_1419_71##5	a_1008_74##6	7.93193e-18
C329	a_575_48##14	VPWR#9	6.7787e-17
C330	a_27_74##6	CLK#3	5.55766e-20
C331	a_575_48##3	CLK#3	3.02925e-18
C332	a_1419_71##10	a_1419_71##2	6.97198e-19
C333	a_1879_74##5	a_575_48##19	5.57335e-17
C334	a_818_74##2	a_1008_74#	3.12563e-17
C335	a_575_48##14	a_1008_74##14	7.70088e-18
C336	DE#3	DE#7	3.1116e-19
C337	a_1879_74##4	a_1879_74##2	4.48626e-19
C338	VPWR#8	CLK#2	1.52525e-19
C339	VGND#10	VGND#8	1.7251e-19
C340	VGND#17	a_818_74##9	3.89346e-17
C341	VGND#9	a_575_48##14	6.57421e-17
C342	a_818_74##8	a_818_74##2	1.37835e-18
C343	a_575_48##19	a_575_48##7	1.77529e-17
C344	a_1879_74##5	VGND#14	4.10754e-17
C345	a_575_48##14	VGND#17	5.18323e-18
C346	a_1419_71##10	a_1008_74##5	1.69988e-19
C347	a_1008_74##12	a_1008_74##3	5.09312e-18
C348	VGND#10	a_161_446##4	1.42872e-18
C349	a_27_74##9	a_161_446##9	1.78137e-18
C350	a_1008_74##14	CLK#3	6.85434e-19
C351	VPWR#17	CLK#1	3.6146e-18
C352	VPWR#9	a_27_74##6	1.31614e-18
C353	DE	DE#2	7.62967e-18
C354	VGND#1	Q_N#3	1.50351e-18
C355	a_575_48##19	a_1008_74##8	2.6605e-17
C356	a_575_48##14	a_818_74##15	3.40048e-18
C357	VPWR#18	a_818_74##8	1.91217e-18
C358	VGND#14	VGND#2	8.06128e-20
C359	a_818_74##15	a_818_74##9	1.09645e-17
C360	a_161_446##9	a_161_446##6	4.21166e-18
C361	a_1198_97##5	a_1419_71##2	2.51861e-17
C362	DE#5	a_161_446#	1.56894e-17
C363	VGND#1	VGND#2	3.81993e-17
C364	VPWR#18	VPWR#17	5.61521e-18
C365	a_1008_74##12	a_1008_74##4	6.99726e-18
C366	a_1879_74##4	a_1879_74#	1.45925e-18
C367	a_818_74##13	CLK#1	3.28424e-17
C368	a_575_48##19	VGND#6	7.30432e-19
C369	a_161_446##3	a_575_48##3	3.68563e-17
C370	VGND#17	CLK#3	2.71461e-18
C371	a_575_48##14	VGND#18	3.96767e-18
C372	a_575_48##19	a_818_74##11	7.65904e-17
C373	VGND#15	a_1879_74##11	8.39896e-18
C374	VGND#9	a_1198_97##4	2.89497e-18
C375	a_818_74##8	a_1008_74##2	1.09081e-17
C376	VPWR#10	a_575_48##2	2.16992e-19
C377	VGND#14	a_575_48##5	7.40511e-19
C378	a_27_74##9	VGND#20	1.31019e-17
C379	VGND#18	a_818_74##9	5.4559e-19
C380	a_1008_74##12	a_1198_97##4	6.79576e-17
C381	D#2	DE#5	1.45126e-17
C382	a_575_48##19	VGND#5	4.13378e-18
C383	a_818_74##11	VPWR#4	1.78174e-18
C384	a_1008_74##2	CLK#1	2.12082e-20
C385	a_575_48##14	a_27_74##7	4.19712e-18
C386	VPWR#18	CLK#1	3.11882e-17
C387	a_575_48##19	a_1008_74##6	4.30786e-17
C388	VGND#9	a_27_74##6	5.36539e-18
C389	a_1419_71##10	a_1419_71##7	6.61353e-19
C390	a_818_74##6	a_818_74##8	1.54328e-17
C391	a_1008_74##12	a_1008_74##2	6.16927e-19
C392	a_1419_71##6	a_1419_71##5	5.08092e-17
C393	a_818_74##15	CLK#3	5.16648e-17
C394	VGND#4	a_818_74##11	1.33077e-18
C395	VPWR#4	a_1008_74##6	2.74198e-19
C396	VGND#3	a_575_48##19	5.32626e-17
C397	VGND#9	a_1008_74##14	2.55835e-17
C398	a_575_48##5	a_1879_74##4	9.03619e-18
C399	CLK#1	a_818_74##6	1.28016e-17
C400	a_575_48##19	a_1419_71##6	4.65078e-17
C401	a_27_74##7	a_818_74##9	1.37956e-19
C402	a_1198_97##5	a_818_74##2	9.20203e-17
C403	a_27_74##3	a_527_74#	3.26133e-18
C404	VGND#17	a_575_48##3	9.65574e-20
C405	VGND#4	a_1008_74##6	2.60764e-18
C406	a_1008_74##12	a_818_74##7	4.02908e-17
C407	a_1198_97##5	a_818_74##8	1.70362e-19
C408	VPWR#18	a_575_48#	2.72184e-18
C409	VGND#2	a_575_48##19	5.19082e-17
C410	VGND#9	VGND#17	1.26991e-17
C411	DE#7	a_161_446##3	1.84788e-17
C412	CLK#3	VGND#18	1.41794e-17
C413	a_575_48##19	a_1198_97##2	2.91415e-17
C414	a_1008_74##3	a_1419_71##10	1.42739e-17
C415	a_27_74##2	a_1008_74#	1.33951e-18
C416	VGND#3	a_1879_74##11	5.55291e-18
C417	VGND#9	a_818_74##15	2.35447e-17
C418	a_1008_74##12	a_27_74##6	5.25136e-17
C419	a_575_48##19	a_575_48##21	4.41227e-18
C420	a_575_48#	a_27_74##8	1.42338e-17
C421	a_1879_74##5	a_575_48##7	2.30129e-17
C422	a_575_48##19	a_1419_71##2	1.54571e-18
C423	VGND#10	a_575_48##12	6.91405e-19
C424	a_1419_71##10	a_1198_97##3	1.30247e-17
C425	a_575_48##2	CLK#1	4.20377e-18
C426	VPWR#19	CLK#1	2.58666e-19
C427	a_27_74##7	CLK#3	2.65779e-18
C428	VPWR#18	DE#1	3.44636e-19
C429	VGND#8	VGND#7	1.10634e-18
C430	a_1879_74##11	a_1008_74##8	4.84239e-17
C431	a_575_48##19	VPWR#14	4.16258e-17
C432	VPWR#1	VPWR#2	4.33767e-17
C433	a_27_74##3	a_818_74##8	9.91531e-19
C434	a_575_48##19	a_818_74##2	7.5087e-18
C435	a_1198_97##5	a_1008_74##3	3.12384e-17
C436	a_575_48##4	a_2227_118#	7.43713e-18
C437	a_575_48##14	a_1198_97##2	7.94034e-18
C438	VGND#18	a_575_48##3	1.24085e-18
C439	a_161_446##4	CLK#1	3.74589e-19
C440	VGND#9	a_27_74##7	5.25983e-17
C441	DE#1	a_575_48##2	1.05309e-17
C442	a_818_74##10	a_2227_118#	6.36549e-18
C443	DE#5	DE#7	2.6249e-18
C444	a_1008_74##12	a_818_74##9	4.0613e-19
C445	a_1198_97##2	a_1419_71##5	1.83051e-17
C446	a_575_48##19	a_1008_74##3	2.60173e-18
C447	a_1008_74##5	a_1419_71##4	9.73189e-19
C448	a_27_74##2	a_818_74##8	2.79824e-17
C449	a_575_48##14	a_1419_71##2	2.27326e-17
C450	VPWR#19	a_575_48#	2.63898e-18
C451	a_575_48##6	a_2206_443#	1.1841e-17
C452	a_161_446##4	DE#1	6.95951e-18
C453	a_27_74##7	a_575_48##3	3.7165e-17
C454	a_575_48##19	a_1879_74##12	1.70846e-17
C455	a_1008_74##14	a_1008_74##12	2.7361e-18
C456	VPWR#6	VPWR#5	2.27933e-19
C457	a_575_48##14	a_818_74##2	1.08364e-17
C458	a_1008_74##7	a_2206_443#	1.1841e-17
C459	a_1008_74##8	a_818_74##11	7.10579e-17
C460	a_1879_74##11	a_818_74##11	6.40714e-18
C461	a_1879_74##12	a_818_74##10	8.84171e-19
C462	VGND#19	CLK#3	3.2421e-19
C463	VGND#18	a_161_446##3	1.19114e-19
C464	a_1198_97##5	VPWR#7	1.07447e-19
C465	VPWR#9	a_818_74##2	1.03109e-19
C466	a_27_74##3	CLK#1	4.53754e-17
C467	a_27_74##4	a_145_74#	3.26133e-18
C468	VPWR#19	DE#1	2.80183e-17
C469	a_575_48##14	a_1008_74##3	1.73896e-17
C470	a_1008_74##6	a_1008_74##8	3.81393e-18
C471	a_1008_74##2	a_1198_97##5	7.44646e-17
C472	VGND#9	a_161_446##9	1.77337e-17
C473	a_575_48##5	a_1879_74##7	8.6129e-18
C474	a_1008_74##12	a_818_74##4	8.20439e-20
C475	VGND#9	a_818_74##2	1.3388e-20
C476	D#1	DE#5	3.78877e-17
C477	VPWR#3	a_1879_74##4	6.49044e-19
C478	a_575_48##14	VGND#8	1.93775e-18
C479	a_575_48##19	VPWR#6	4.38488e-18
C480	VPWR#19	VPWR#18	1.64268e-18
C481	a_27_74##3	VPWR#10	3.89544e-17
C482	a_575_48##19	VPWR#15	1.01177e-17
C483	a_1008_74##6	a_818_74##11	1.31346e-16
C484	a_1879_74##12	VPWR#4	1.75248e-17
C485	a_818_74##12	a_2008_392#	2.54194e-17
C486	a_161_446##9	CLK#3	8.12474e-20
C487	a_575_48##14	a_1008_74##2	4.13604e-17
C488	a_27_74##2	CLK#1	1.43625e-18
C489	a_27_74##7	a_161_446##3	3.76899e-18
C490	a_1008_74##5	a_1807_74#	1.4722e-17
C491	a_1419_71##10	a_1419_71##8	5.61437e-18
C492	a_1419_71##4	a_2008_392#	2.54194e-17
C493	VGND#9	a_1008_74##3	4.78198e-21
C494	a_161_446#	DE#6	7.78508e-20
C495	VPWR#9	a_1008_74##2	7.75818e-18
C496	a_575_48##14	VGND#7	5.11568e-18
C497	a_1419_71##7	a_1807_74#	1.4722e-17
C498	a_1419_71##6	a_818_74##11	7.30805e-17
C499	a_575_48##19	VPWR#5	2.85059e-18
C500	VGND#19	a_575_48##3	5.38572e-18
C501	a_575_48##19	a_1419_71##8	7.57757e-18
C502	DE#6	VPWR#19	1.79445e-17
C503	a_575_48##14	a_818_74##6	4.60411e-17
C504	a_1008_74##6	a_1879_74##11	1.17842e-16
C505	a_27_74##2	a_1008_74##2	1.77974e-17
C506	a_1008_74##6	a_1419_71##6	5.70838e-17
C507	VPWR#9	a_818_74##6	5.09754e-18
C508	a_575_48##14	VGND#6	3.90923e-18
C509	a_575_48##19	VPWR#3	4.72707e-18
C510	a_575_48##14	CLK#2	6.74379e-18
C511	a_27_74##3	a_575_48#	4.17706e-17
C512	VGND#8	CLK	5.77679e-19
C513	VGND#9	a_27_74##9	2.29482e-17
C514	DE#6	a_161_446##8	6.87798e-18
C515	D#2	a_161_446##2	8.15093e-18
C516	a_1008_74##12	a_1008_74##15	7.26661e-19
C517	a_161_446##9	a_575_48##3	2.83986e-20
C518	VGND#9	a_818_74##6	1.07207e-18
C519	a_27_74##7	DE#7	1.9636e-19
C520	a_1008_74##5	a_1419_71##5	7.50452e-18
C521	a_1008_74##6	VGND#15	5.61911e-17
C522	VGND#2	a_575_48##8	2.62798e-18
C523	VPWR#13	Q_N#3	8.53187e-17
C524	a_1419_71##3	a_1423_508#	6.8562e-18
C525	a_1008_74##12	a_818_74##3	7.81481e-19
C526	a_27_74##3	VPWR#8	3.61982e-18
C527	a_575_48##14	a_575_48##2	2.31795e-20
C528	a_27_74##2	a_575_48#	3.98884e-20
C529	VGND#19	a_161_446##3	2.82716e-17
C530	a_1198_97##2	a_1419_71##6	1.53045e-17
C531	VPWR#20	DE#6	4.8684e-19
C532	a_818_74#	a_1423_508#	9.00082e-18
C533	a_818_74##2	a_818_74##11	3.3192e-18
C534	a_1419_71##11	a_1008_74##6	4.64482e-17
C535	a_27_74##3	a_818_74##6	9.39972e-19
C536	a_575_48##13	CLK#1	3.30877e-19
C537	VGND#19	DE#2	1.89862e-18
C538	a_575_48##14	a_161_446##4	6.18562e-18
C539	a_161_446##8	a_161_446##2	5.43913e-19
C540	a_818_74##3	a_1419_71##2	1.16741e-18
C541	a_1419_71##2	a_1419_71##6	2.21863e-18
C542	a_1008_74##6	a_818_74##2	4.923e-19
C543	VGND#9	a_575_48##2	3.35778e-19
C544	VPWR#6	a_1419_71##5	4.54393e-19
C545	a_27_74##2	a_818_74##6	9.99115e-17
C546	VPWR#9	a_161_446##4	4.45738e-18
C547	a_161_446##9	a_161_446##3	6.0876e-19
C548	a_1198_97##2	a_1419_71##2	8.66062e-17
C549	a_1419_71##6	a_818_74##2	4.06705e-17
C550	a_1008_74##3	a_1008_74##6	5.13555e-18
C551	a_575_48##14	DE#3	1.99166e-18
C552	VPWR#20	a_161_446##2	2.93746e-17
C553	a_27_74##3	DE#1	3.20768e-17
C554	VPWR#5	VPWR#3	2.23476e-19
C555	VGND#9	a_161_446##4	6.80021e-18
C556	a_1008_74##4	a_1334_97#	1.06811e-17
C557	a_575_48##9	Q_N#3	1.64704e-17
C558	a_27_74##5	DE#6	2.98144e-19
C559	VPWR#9	DE#3	8.30957e-19
C560	a_1198_97##2	a_818_74##2	2.3164e-17
C561	VGND#19	DE#7	1.24474e-17
C562	a_27_74#	a_818_74##3	1.48619e-18
C563	VPWR#3	a_575_48##10	4.3355e-19
C564	a_575_48##13	DE#2	2.45777e-18
C565	VGND#9	DE#3	1.66449e-18
C566	a_161_446##9	DE#4	2.77263e-17
C567	a_575_48##9	VPWR#13	4.07144e-17
C568	VGND#1	a_1879_74##2	9.26907e-19
C569	VGND#20	a_161_446##3	4.24797e-19
C570	a_1419_71##2	a_818_74##2	2.44547e-17
C571	a_1008_74##3	a_1198_97##2	5.8629e-19
C572	VGND#2	a_1879_74##6	4.45717e-18
C573	VGND#9	VGND#10	8.69529e-17
C574	a_818_74##2	a_1419_71##5	1.62344e-17
C575	a_575_48#	a_556_504#	9.87534e-18
C576	VPWR#9	a_161_446#	4.85086e-18
C577	a_27_74##2	VPWR#8	2.50317e-18
C578	a_27_74##3	CLK#2	3.50455e-18
C579	VPWR#7	a_818_74##4	1.1228e-20
C580	Q_N#3	a_1879_74##4	3.13947e-19
C581	VPWR#3	a_1879_74##2	1.13625e-18
C582	DE	a_161_446##6	1.10272e-17
C583	VPWR#20	D#3	4.69187e-18
C584	DE#1	a_556_504#	9.87534e-18
C585	Q	a_1879_74##4	1.70673e-18
C586	a_27_74##4	DE#6	2.03757e-18
C587	a_1008_74##3	a_1419_71##2	9.02686e-17
C588	a_161_446##9	DE#7	3.73973e-17
C589	VGND#9	a_161_446#	5.07509e-18
C590	Q	a_1879_74##2	1.43816e-17
C591	a_27_74##5	a_161_446##2	5.17248e-18
C592	VGND#9	VGND#8	5.13507e-17
C593	VPWR#2	a_575_48##10	2.80036e-18
C594	a_27_74##2	CLK#2	2.39874e-19
C595	a_27_74##4	a_27_74##3	3.10847e-18
C596	a_1008_74##3	a_818_74##2	1.86694e-17
C597	a_1008_74##2	a_1419_71##2	1.83002e-19
C598	VGND#19	DE#5	8.91656e-19
C599	a_27_74##3	DE#6	2.51928e-17
C600	VPWR#10	DE#2	8.99897e-20
C601	a_27_74##6	a_1008_74##15	8.67762e-18
C602	VGND#9	VGND#7	1.026e-16
C603	VGND#3	a_1879_74##8	5.32476e-18
C604	a_1879_74#	a_575_48##10	4.75919e-17
C605	CLK	a_27_74##3	4.56246e-18
C606	a_1008_74##15	a_818_74##4	2.07945e-18
C607	a_818_74##2	a_1008_74##2	8.3214e-18
C608	a_161_446##9	DE#2	1.37408e-17
C609	a_575_48##14	VPWR#8	3.3037e-18
C610	VGND#20	DE#7	2.98793e-18
C611	D#4	a_161_446##9	3.07832e-18
C612	a_1008_74##7	a_575_48##5	6.45185e-18
C613	a_575_48##19	a_1879_74##4	6.54662e-17
C614	a_161_446##2	a_116_508#	9.7209e-18
C615	VPWR#5	a_1419_71##5	9.58989e-19
C616	a_27_74##5	D#3	2.4674e-17
C617	VGND#9	VGND#6	3.55772e-17
C618	a_1008_74##2	a_1008_74##3	5.66695e-19
C619	a_161_446##9	DE#5	6.50584e-19
C620	a_575_48##13	CLK#2	3.53792e-20
C621	a_1198_97##5	a_818_74##7	3.84235e-20
C622	VPWR#3	a_1879_74#	1.57e-18
C623	D#3	a_116_508#	1.01349e-17
C624	a_575_48##14	VPWR#7	5.51939e-18
C625	a_27_74##2	VPWR#7	6.24337e-18
C626	a_27_74##3	a_575_48##2	1.26293e-17
C627	VGND#2	a_1879_74##8	2.66046e-19
C628	a_27_74##4	a_161_446##2	2.26878e-17
C629	a_575_48##14	a_1198_97##6	1.03909e-18
C630	VGND#3	a_1879_74##10	4.056e-18
C631	VPWR#7	a_818_74##3	1.29222e-19
C632	a_1008_74##15	a_818_74##3	9.08214e-18
C633	a_27_74##2	a_575_48##2	1.34916e-19
C634	a_575_48##14	VPWR#6	3.96553e-18
C635	VPWR#3	VPWR#13	1.51033e-18
C636	a_1008_74##2	a_818_74##6	9.68291e-20
C637	VGND#6	VGND#5	5.43271e-19
C638	a_575_48##12	CLK#2	1.06066e-18
C639	VGND#20	DE#4	5.26489e-18
C640	VPWR#2	a_1879_74#	7.79495e-18
C641	VGND#20	DE#5	3.49909e-17
C642	a_575_48##19	a_1879_74##2	8.50516e-19
C643	a_575_48##14	a_27_74#	3.52986e-18
C644	a_575_48##19	a_1879_74##10	3.3089e-17
C645	a_1879_74##5	VPWR#14	7.98264e-19
C646	a_1879_74##7	a_1879_74#	5.75253e-18
C647	VPWR#9	VPWR#10	8.25888e-17
C648	a_27_74##3	a_161_446##2	1.00991e-19
C649	VGND#7	a_1008_74##12	3.10065e-17
C650	a_161_446##6	a_575_48#	3.78545e-20
C651	VPWR#2	a_1879_74##2	1.70555e-19
C652	a_161_446##9	D#1	4.42809e-19
C653	VPWR	a_1879_74##4	8.92357e-19
C654	VGND#16	a_1419_71##2	1.53877e-18
C655	VPWR	a_1879_74##2	1.66665e-18
C656	CLK#2	a_818_74##6	1.461e-17
C657	VGND#3	a_575_48##4	3.70095e-18
C658	a_575_48##19	a_575_48##5	2.85613e-18
C659	a_575_48##14	a_1008_74##15	1.53435e-17
C660	VPWR#9	VPWR#8	6.38048e-17
C661	VPWR#9	a_1198_97##6	1.06264e-17
C662	VPWR#3	VPWR#2	3.51215e-19
C663	Q_N#1	a_575_48##8	2.45572e-17
C664	a_575_48##13	a_575_48##2	1.73735e-17
C665	a_161_446##9	DE	1.2968e-17
C666	a_818_74##6	a_575_48##2	8.31321e-20
C667	a_161_446##4	a_27_74##3	3.93566e-17
C668	VPWR#3	a_1879_74##7	4.62459e-18
C669	VGND#15	a_1419_71##5	9.79976e-19
C670	a_575_48##14	VPWR#17	4.0011e-18
C671	a_575_48##19	a_1419_71##5	1.58711e-18
C672	VPWR#9	VPWR#7	1.16196e-16
C673	VPWR#9	a_27_74#	3.61758e-17
C674	a_818_74##4	VPWR#17	1.26027e-18
C675	a_27_74##4	D#3	2.45703e-17
C676	VGND#20	D#1	5.04087e-18
C677	a_575_48##7	VPWR#14	3.449e-17
C678	a_575_48##2	CLK#2	1.03112e-17
C679	a_818_74##3	a_1008_74##3	1.96281e-18
C680	a_575_48##12	a_575_48##2	2.31638e-17
C681	a_27_74##3	a_27_74##2	1.46823e-18
C682	a_27_74##9	DE#5	5.62457e-18
C683	a_575_48##6	a_1879_74##7	5.60767e-18
C684	a_575_48##14	a_818_74##13	1.39628e-17
C685	VPWR#9	VPWR#6	1.08222e-17
C686	a_818_74##15	CLK	4.959e-17
C687	VPWR#9	a_1008_74##15	2.77755e-18
C688	a_575_48##8	VGND#13	2.27376e-17
C689	VGND#18	CLK	2.52856e-17
C690	a_161_446##6	DE#1	6.2438e-19
C691	a_27_74##7	CLK	3.87998e-17
C692	a_575_48##3	a_527_74#	9.87534e-18
C693	a_27_74##9	D#6	1.01472e-17
C694	a_161_446##4	a_575_48##2	6.60204e-17
C695	a_161_446##3	a_527_74#	9.87534e-18
C696	VGND#6	a_1008_74##12	6.55361e-17
C697	VPWR#3	Q	1.52122e-18
C698	Q	VPWR#2	2.16214e-17
C699	a_161_446##6	a_575_48##2	7.2797e-20
C700	a_575_48##14	VPWR#18	3.36371e-18
C701	VPWR#9	VPWR#17	1.30731e-17
C702	DE#3	a_575_48##2	3.24226e-19
C703	a_161_446##4	a_575_48##13	3.28723e-17
C704	VGND#1	a_575_48##8	1.66948e-17
C705	a_1008_74##3	VGND#15	1.21934e-17
C706	VGND#2	a_575_48##9	2.32822e-19
C707	VGND#3	a_818_74##10	4.4079e-18
C708	DE#3	a_161_446##4	1.60116e-17
C709	a_161_446#	a_575_48##2	9.92125e-20
C710	Q#3	a_575_48##8	2.58017e-19
C711	VPWR#9	a_818_74##13	2.95533e-18
C712	VGND#9	a_1008_74##15	1.75613e-18
C713	a_1198_97##5	a_1198_97##6	2.39371e-18
C714	VPWR#14	a_575_48##21	4.9215e-17
C715	a_27_74##9	D#1	2.80362e-17
C716	a_1008_74##3	a_1419_71##11	6.08934e-17
C717	a_161_446#	a_161_446##4	3.90323e-18
C718	VPWR#3	a_575_48##6	2.46441e-18
C719	a_27_74##5	VPWR#20	1.25632e-17
C720	VGND	a_1879_74##4	7.81162e-18
C721	a_161_446##4	a_575_48##12	4.76527e-17
C722	VGND#7	a_1008_74##14	4.27892e-17
C723	a_818_74##2	a_1423_508#	6.37887e-18
C724	a_1008_74##7	a_575_48##6	2.45498e-17
C725	a_818_74##12	a_1879_74##7	3.22309e-19
C726	VGND	a_1879_74##2	3.56051e-18
C727	Q_N	Q_N#1	1.01029e-18
C728	D#4	a_27_74##9	5.27657e-17
C729	VGND	a_575_48##5	3.69853e-21
C730	a_1879_74##6	VGND#13	1.37593e-17
C731	VGND#13	Q_N	1.89354e-17
C732	VPWR#9	VPWR#18	2.72565e-18
C733	a_1008_74##3	VGND#16	9.01558e-17
C734	a_161_446##4	D#2	3.15759e-19
C735	a_1879_74##12	a_1008_74##8	4.10336e-17
C736	a_161_446##6	DE#6	4.17226e-18
C737	a_575_48##19	a_575_48##8	1.78399e-18
C738	a_575_48##21	VPWR#3	8.52999e-18
C739	VGND#5	a_1008_74##5	6.7952e-18
C740	VGND#9	a_818_74##13	1.38191e-18
C741	VGND#8	VGND#17	1.13894e-19
C742	a_1008_74##2	a_818_74##3	4.27663e-17
C743	DE#5	a_145_74#	9.7209e-18
C744	VPWR	VPWR#6	1.32691e-16
C745	VPWR	VPWR#5	7.00329e-17
C746	D#2	a_161_446#	5.28873e-17
C747	CLK	a_818_74##13	1.13914e-17
C748	VPWR	VPWR#3	1.49224e-16
C749	D#1	a_145_74#	1.01349e-17
C750	a_27_74##4	a_161_446#	5.36816e-17
C751	a_575_48##19	a_1879_74##6	1.95384e-17
C752	VPWR	VPWR#2	2.73074e-17
C753	a_1198_97##4	a_1008_74##3	6.03527e-17
C754	Q#3	a_1879_74##6	3.65845e-17
C755	a_1008_74##6	a_1807_74#	2.37707e-18
C756	a_818_74##15	a_818_74##13	1.55226e-18
C757	a_1198_97##5	a_27_74#	8.70946e-19
C758	VPWR	a_1879_74##10	4.32743e-18
C759	a_818_74##11	a_1879_74##12	1.84307e-17
C760	a_818_74##12	a_1008_74##7	1.99416e-17
C761	a_575_48##19	a_1879_74##8	2.68598e-17
C762	a_1419_71##5	a_1419_71##4	5.08877e-18
C763	VGND#6	a_1419_71##7	1.07693e-19
C764	VPWR#3	a_1008_74##7	4.60171e-18
C765	VPWR	a_1419_71##10	1.99349e-18
C766	a_161_446##6	a_161_446##2	9.90152e-19
C767	VPWR	a_1198_97##5	1.86106e-18
C768	a_575_48##19	a_575_48##4	1.22911e-18
C769	a_1879_74##12	a_575_48##21	1.25325e-18
C770	VPWR#9	a_161_446##8	6.24073e-18
C771	DE#3	a_161_446##6	1.86807e-17
C772	a_1008_74##2	a_1198_97##4	1.13074e-17
C773	a_818_74##11	VPWR#15	1.16608e-16
C774	VGND	VGND#6	8.6957e-17
C775	VGND	VGND#5	9.37465e-17
C776	VGND	VGND#3	1.09243e-16
C777	VGND	VGND#2	2.99183e-17
C778	Q#3	a_1879_74##8	9.11316e-19
C779	a_575_48##19	a_1419_71##10	2.63208e-17
C780	VGND#5	a_1419_71##7	7.83683e-18
C781	a_1879_74##4	VNB	6.93261e-17
C782	a_27_74##4	D#2	1.80517e-17
C783	a_575_48##19	a_818_74##10	5.6345e-19
C784	a_1879_74##2	VNB	4.40066e-17
C785	a_575_48##5	VNB	5.33669e-17
C786	a_1419_71##5	VNB	1.26728e-16
C787	VGND#8	a_818_74##15	8.33188e-18
C788	a_27_74##6	a_1008_74##2	3.22388e-17
C789	CLK	a_818_74##9	2.5176e-19
C790	a_818_74##4	VNB	2.16275e-17
C791	a_818_74##3	VNB	5.08145e-17
C792	Q_N#1	Q_N#3	3.15575e-18
C793	DE#4	VNB	3.60703e-17
C794	DE#2	VNB	9.5333e-17
C795	a_1419_71##4	a_818_74##12	5.68289e-17
C796	Q_N#3	a_575_48##10	2.62602e-17
C797	a_27_74##2	a_1198_97##6	1.046e-17
C798	a_1008_74##3	a_1334_97#	2.59146e-18
C799	Q	Q_N#3	1.41901e-18
C800	Q	VPWR#13	8.62402e-17
C801	VGND	a_1879_74##10	8.44927e-18
C802	Q	Q#1	6.61702e-18
C803	a_1879_74##12	VPWR#14	1.89175e-17
C804	a_575_48##21	Q	4.95684e-17
C805	a_818_74##6	a_818_74##3	1.56797e-18
C806	VGND	a_1008_74##12	9.74825e-18
C807	VPWR#14	Q	3.22313e-18
C808	a_575_48##13	a_27_74##3	5.18397e-17
C809	a_161_446##6	D#3	1.63771e-20
C810	a_1879_74##8	a_575_48##17	2.15609e-17
C811	VPWR#4	a_818_74##10	4.77286e-21
C812	VGND	a_1419_71##10	2.62702e-18
C813	Q_N	a_575_48##8	1.04515e-17
C814	VGND#6	a_1198_97##3	7.08095e-18
C815	VPWR#3	a_818_74##12	1.76873e-18
C816	VPWR#13	a_575_48##10	5.25659e-17
C817	VGND	a_1198_97##5	1.47824e-18
C818	VPWR#9	a_27_74##5	1.82087e-17
C819	a_575_48##9	VPWR#2	3.34273e-19
C820	a_1008_74##14	a_27_74##6	7.10897e-17
C821	a_575_48##14	a_1008_74##12	2.80512e-18
C822	VGND#7	a_818_74##15	9.64653e-18
C823	a_818_74##6	a_27_74##6	1.227e-17
C824	Q_N#3	a_1879_74#	2.61767e-19
C825	VPWR#6	a_1419_71##4	5.07222e-19
C826	a_1198_97#	a_1419_71##5	1.55543e-17
C827	VGND#10	VNB	3.47522e-17
C828	VGND#8	VNB	2.23579e-17
C829	a_161_446##6	DE#2	3.01565e-17
C830	a_1198_97#	a_1419_71##4	6.38344e-19
C831	VGND#7	VNB	5.9013e-17
C832	VGND#6	VNB	6.52611e-17
C833	VGND#5	VNB	4.55166e-17
C834	a_1879_74##8	VGND#14	2.32572e-17
C835	VGND#3	VNB	6.05486e-17
C836	a_1008_74##14	a_818_74##6	9.01361e-19
C837	VGND#4	a_818_74##10	5.11594e-19
C838	VPWR	a_575_48##21	1.31998e-17
C839	VGND#2	VNB	3.43494e-17
C840	VPWR#10	VNB	3.7547e-17
C841	VGND#5	a_1198_97##3	9.21573e-19
C842	VGND	Q#3	1.06083e-17
C843	VPWR#8	VNB	3.41738e-17
C844	VPWR	a_1879_74##12	2.41256e-17
C845	VPWR#7	VNB	6.54324e-17
C846	VPWR#6	VNB	7.18366e-17
C847	VGND	VGND#14	1.82413e-17
C848	VPWR#5	VNB	3.7956e-17
C849	VPWR#3	VNB	7.79364e-17
C850	VPWR	VPWR#15	1.69064e-17
C851	VPWR#2	VNB	2.78798e-17
C852	VGND	a_1879_74##11	4.32837e-17
C853	VGND#3	VGND#2	1.97949e-19
C854	VPWR	a_1419_71##8	2.95723e-18
C855	VGND#17	a_818_74##6	2.02218e-18
C856	a_1879_74##6	a_575_48##8	1.02475e-17
C857	VGND	a_1419_71##11	5.59875e-18
C858	VPWR#5	a_1419_71##4	1.02939e-20
C859	VPWR	a_1198_97##6	1.06018e-17
C860	D#7	a_161_446##2	3.99618e-18
C861	VPWR#13	a_1879_74#	1.96301e-17
C862	VGND#3	a_1008_74##8	5.09045e-20
C863	VGND#4	a_1008_74##5	2.82218e-19
C864	a_1879_74##10	VNB	6.17668e-18
C865	a_1008_74##12	VNB	1.57745e-17
C866	a_1879_74##4	VPWR#14	2.25559e-18
C867	VPWR#9	DE	7.81528e-19
C868	a_1419_71##10	VNB	1.28691e-17
C869	a_161_446##6	D#2	1.39206e-19
C870	VGND#9	DE	8.31347e-19
C871	a_1198_97##5	VNB	1.41167e-17
C872	D#7	a_161_446#	4.35683e-17
C873	a_27_74##4	VNB	7.22268e-17
C874	a_27_74##6	CLK#2	2.1822e-18
C875	a_27_74##3	VNB	3.15354e-17
C876	a_27_74##2	VNB	1.1329e-17
C877	a_575_48##13	VNB	1.98947e-18
C878	VPWR#3	a_1419_71##4	3.87722e-19
C879	a_575_48##12	VNB	6.53609e-19
C880	a_27_74##6	a_27_74##2	7.79886e-19
C881	a_1879_74#	Q#1	2.5323e-17
C882	VGND#6	a_1419_71#	2.95897e-18
C883	a_161_446##6	VNB	4.54318e-18
C884	a_575_48##14	CLK	3.11207e-17
C885	a_1419_71##3	a_1198_97#	2.54686e-17
C886	Q	a_575_48##10	2.36056e-18
C887	VPWR#9	CLK	3.29871e-18
C888	D#7	VNB	3.04913e-18
C889	Q	a_1879_74#	4.35789e-17
C890	a_575_48##4	VGND#14	1.86771e-17
C891	VGND#9	CLK	4.1869e-18
C892	D#6	VNB	9.8271e-19
C893	Q	a_1879_74##7	4.36687e-18
C894	a_27_74##7	a_818_74##6	1.59906e-19
C895	D#4	VNB	5.07108e-18
C896	Q_N#1	VNB	4.36818e-17
C897	VGND#13	VNB	4.62084e-18
C898	D#6	a_161_446#	1.79833e-17
C899	Q#3	VNB	7.99054e-18
C900	VGND#14	VNB	1.33598e-17
C901	VPWR#6	a_1198_97#	1.39907e-17
C902	a_575_48##12	CLK#3	2.71382e-19
C903	a_575_48##9	a_575_48##8	8.9913e-19
C904	a_1198_97##2	a_1419_71##8	1.12191e-17
C905	a_1879_74##12	VPWR#3	3.25986e-18
C906	VGND#15	VNB	7.54659e-19
C907	a_1419_71##11	VNB	8.33768e-19
C908	a_27_74##2	a_1008_74##15	5.758e-17
C909	VGND#16	VNB	1.04269e-18
C910	a_1198_97##4	VNB	6.85054e-18
C911	D#4	a_161_446#	3.58094e-17
C912	a_27_74##6	VNB	1.95307e-17
C913	a_1008_74##14	VNB	1.57032e-17
C914	VGND#17	VNB	3.02694e-18
C915	a_575_48##21	a_1879_74#	9.15399e-19
C916	VGND#1	Q_N	4.24096e-17
C917	a_818_74##15	VNB	1.30478e-17
C918	VGND#18	VNB	1.8207e-18
C919	CLK#2	a_818_74##15	9.06644e-18
C920	a_27_74##7	VNB	2.45688e-17
C921	a_1879_74##10	a_575_48##6	7.61291e-18
C922	VGND#17	a_1008_74##14	4.13457e-17
C923	VGND#19	VNB	3.26465e-18
C924	VGND	a_1879_74##6	3.47095e-18
C925	a_818_74##15	a_27_74##6	3.89648e-18
C926	VPWR	a_1879_74#	1.01333e-18
C927	a_1198_97##2	VPWR#16	1.48991e-18
C928	a_161_446##9	VNB	4.29152e-18
C929	VGND	a_1879_74##8	1.59863e-18
C930	VGND#20	VNB	3.68508e-18
C931	VPWR	a_1879_74##7	7.82224e-18
C932	a_575_48##9	a_1879_74##6	8.51063e-18
C933	VGND	a_575_48##4	9.40456e-18
C934	a_575_48##12	a_27_74##3	9.67905e-19
C935	a_27_74##9	VNB	5.26532e-17
C936	VGND	a_818_74##10	7.99249e-18
C937	VPWR	a_575_48##6	3.05724e-18
C938	a_1879_74##8	a_1879_74##6	4.11088e-18
C939	Q_N#3	VNB	6.35513e-17
C940	VPWR	a_1008_74##7	7.35181e-18
C941	VPWR#13	VNB	4.35152e-18
C942	a_575_48##14	a_818_74##4	1.78773e-19
C943	a_575_48##21	VNB	3.09801e-18
C944	CLK#2	VGND#18	3.10634e-18
C945	VPWR#14	VNB	8.82899e-18
C946	VGND	a_1419_71#	2.87181e-18
C947	D#7	D#2	1.82767e-17
C948	a_1879_74##12	VNB	9.98314e-18
C949	VPWR#15	VNB	1.06527e-17
C950	a_1419_71##8	VNB	1.32995e-18
C951	a_575_48##19	Q	4.78548e-17
C952	CLK	a_818_74##6	2.11862e-17
C953	a_818_74#	a_1419_71##3	1.8486e-17
C954	a_1198_97##6	VNB	2.23041e-18
C955	a_27_74#	VNB	8.24543e-18
C956	a_575_48##9	a_1879_74##8	1.05238e-20
C957	a_1008_74##15	VNB	1.02384e-18
C958	CLK	CLK#2	4.08801e-17
C959	VPWR#17	VNB	3.80749e-18
C960	VPWR#14	a_1879_74#	3.69452e-19
C961	a_27_74##7	CLK#2	6.75753e-18
C962	a_161_446#	DE	2.83321e-17
C963	a_818_74##13	VNB	3.57113e-18
C964	VPWR#18	VNB	3.73259e-18
C965	CLK	a_575_48##2	9.17032e-19
C966	a_1008_74##14	a_27_74##2	7.43104e-19
C967	VGND#14	a_818_74##10	1.99513e-18
C968	a_575_48##14	a_818_74##3	3.69817e-18
C969	VPWR#19	VNB	3.42763e-19
C970	a_161_446##8	VNB	2.36058e-19
C971	VPWR#20	VNB	1.14508e-18
C972	Q	a_575_48##9	3.11819e-17
C973	a_27_74##5	VNB	2.31128e-17
C974	a_575_48##8	VNB	3.61099e-17
C975	D#6	D#2	6.45989e-18
C976	a_1879_74##6	VNB	3.22316e-17
C977	VGND#9	a_1008_74##12	4.40663e-17
C978	a_1879_74##8	VNB	3.35935e-17
C979	a_575_48##4	VNB	3.97624e-17
C980	a_818_74##10	VNB	4.10723e-17
C981	a_575_48##19	VPWR	7.96551e-17
C982	a_575_48##21	a_1879_74##7	5.41462e-17
C983	a_1008_74##5	VNB	3.82865e-17
C984	VPWR	VPWR#4	5.29846e-17
C985	a_1419_71##7	VNB	3.99787e-17
C986	VGND#6	a_1008_74##4	3.24011e-18
C987	VPWR#6	VPWR#15	1.30325e-18
C988	a_1198_97##3	VNB	6.50476e-17
C989	a_1419_71#	VNB	2.83683e-17
C990	a_1008_74##4	VNB	2.45767e-17
C991	a_575_48##14	VPWR	1.42138e-17
C992	VPWR#3	a_818_74##10	6.49043e-21
C993	a_818_74##15	a_575_48##2	1.58703e-19
C994	a_818_74##7	VNB	4.95311e-17
C995	D#4	D#2	1.8134e-17
C996	a_818_74##9	VNB	4.56794e-17
C997	CLK#3	VNB	3.57572e-17
C998	VPWR#15	a_1879_74##12	3.21081e-17
C999	a_27_74##2	VPWR#17	6.21071e-17
C1000	a_818_74##15	a_1008_74##14	1.98102e-17
C1001	a_575_48##3	VNB	2.64602e-17
C1002	a_161_446##3	VNB	2.01219e-17
C1003	VPWR	a_575_48##9	1.91416e-18
C1004	DE#7	VNB	3.86016e-17
C1005	VPWR	a_1879_74##5	1.34919e-19
C1006	DE#5	VNB	3.44202e-17
C1007	VPWR#6	a_1419_71##3	1.59329e-17
C1008	D#1	VNB	2.73888e-17
C1009	VPWR	a_575_48##7	3.37686e-18
C1010	a_575_48##10	VNB	3.78046e-17
C1011	VPWR	a_1008_74##8	2.28763e-18
C1012	a_1879_74#	VNB	4.66559e-17
C1013	VPWR	a_818_74##11	1.46468e-17
C1014	a_1879_74##7	VNB	3.6772e-17
C1015	VGND#18	a_575_48##2	3.11138e-19
C1016	a_575_48##6	VNB	2.27372e-17
C1017	VGND	a_575_48##19	1.28119e-16
C1018	a_1008_74##7	VNB	3.41464e-17
C1019	a_818_74##12	VNB	3.37292e-17
C1020	VPWR	a_1419_71##6	2.83821e-18
C1021	VGND	VGND#4	9.02974e-17
C1022	a_1419_71##4	VNB	4.58082e-17
C1023	VPWR	a_1198_97##2	5.50827e-18
C1024	a_1198_97#	VNB	4.03674e-17
C1025	VGND	a_575_48##14	1.5166e-17
C1026	a_1419_71##3	VNB	4.89024e-17
C1027	a_818_74#	VNB	2.11708e-17
C1028	a_1879_74##7	VPWR#14	2.32892e-17
C1029	a_1008_74#	VNB	3.02131e-17
C1030	VPWR	a_818_74##2	5.08259e-17
C1031	a_818_74##8	VNB	3.64624e-17
C1032	a_161_446##6	a_27_74##4	5.02931e-18
C1033	a_818_74##2	a_1419_71##8	3.51861e-17
C1034	a_1008_74#	a_818_74#	2.04264e-17
C1035	CLK#1	VNB	6.24485e-17
C1036	VGND	a_1879_74##5	9.01145e-19
C1037	a_27_74##3	a_818_74##13	3.23743e-17
C1038	VGND#5	a_1008_74##6	3.83611e-18
C1039	a_575_48#	VNB	3.75562e-17
C1040	a_27_74##7	a_575_48##2	1.30373e-17
C1041	VGND	a_575_48##7	2.12976e-18
C1042	DE#1	VNB	4.71991e-17
C1043	DE#6	VNB	3.56498e-17
C1044	VGND	a_1008_74##8	3.59146e-18
C1045	a_575_48##4	a_1879_74##5	1.82967e-17
C1046	a_161_446##2	VNB	5.046e-17
C1047	VGND	a_818_74##11	3.52711e-18
C1048	D#3	VNB	3.6746e-17
C1049	a_575_48##4	a_1879_74##8	1.22881e-17
C1050	VGND	a_1008_74##6	1.46738e-17
C1051	a_575_48##5	VPWR#14	8.11373e-18
C1052	VPWR#1	VNB	1.09378e-16
C1053	VGND	a_1419_71##6	2.88797e-18
C1054	VGND#1	VNB	1.09724e-16
C1055	VGND	a_1198_97##2	1.55352e-18
C1056	a_575_48##19	VNB	3.66631e-17
C1057	VGND	a_1419_71##2	1.65539e-18
C1058	VPWR#4	VNB	2.77481e-17
C1059	VGND#4	VNB	5.16832e-17
C1060	VGND	a_818_74##2	7.10854e-20
C1061	a_575_48##21	a_575_48##6	9.22492e-19
C1062	a_575_48##14	VNB	2.29075e-17
C1063	VGND	a_1008_74##3	4.7357e-17
C1064	a_818_74##2	VPWR#16	4.05618e-18
C1065	VGND#7	a_818_74##7	3.257e-18
C1066	VPWR#9	VNB	3.10005e-16
C1067	VGND#9	VNB	3.06956e-16
C1068	a_575_48##9	VNB	4.64324e-17
C1069	a_1879_74##5	VNB	2.25312e-17
C1070	a_575_48##7	VNB	3.81549e-18
C1071	a_1008_74##8	VNB	3.82878e-17
C1072	a_818_74##11	VNB	7.60435e-17
C1073	DE#2	a_575_48##2	1.0772e-17
C1074	a_1008_74##6	VNB	5.31411e-17
C1075	VPWR#3	a_1008_74##8	1.80157e-19
C1076	a_1419_71##6	VNB	7.05235e-18
C1077	a_1198_97##2	VNB	4.97971e-17
C1078	a_1879_74##11	a_818_74##10	4.60444e-17
C1079	a_1419_71##2	VNB	7.77962e-17
C1080	a_818_74##2	VNB	7.92639e-17
C1081	a_818_74##15	VGND#17	4.98616e-17
C1082	a_575_48##14	a_1198_97##5	4.43139e-17
C1083	a_1008_74##3	VNB	4.52038e-17
C1084	a_1008_74##2	VNB	3.85916e-17
C1085	a_818_74##6	VNB	8.64784e-17
C1086	CLK#2	VNB	5.24372e-17
C1087	a_575_48##2	VNB	8.0308e-17
C1088	VPWR#1	a_575_48##10	8.16349e-18
C1089	a_161_446##4	VNB	5.05445e-17
C1090	VGND#13	Q_N#1	4.38751e-17
C1091	DE#3	VNB	6.12493e-21
C1092	a_161_446#	VNB	5.3407e-17
C1093	D#2	VNB	1.10914e-16
C1094	VGND#3	a_1879_74##4	3.64328e-19
C1095	a_27_74##2	a_818_74##13	1.2284e-17
C1096	a_161_446##9	a_575_48##2	1.60925e-19
C1097	VPWR#14	a_575_48##6	4.36828e-17
C1098	a_1198_97##6	a_818_74##2	5.32678e-17
C1099	a_818_74##8	a_1008_74#	2.82078e-18
C1100	a_27_74##7	a_161_446##4	7.03445e-20
C1101	VPWR#9	a_818_74##3	2.57198e-20
C1102	a_1879_74##12	a_1879_74##7	5.87398e-19
C1103	a_1879_74##10	VGND#14	3.16572e-17
C1104	VPWR#6	a_818_74#	6.89425e-18
C1105	VPWR#1	a_1879_74#	1.81245e-18
C1106	VPWR#15	VPWR#3	6.39575e-19
C1107	a_161_446##6	a_27_74##3	2.02535e-17
C1108	VGND#8	a_818_74##9	3.1986e-19
C1109	a_575_48##21	a_1008_74##7	1.51284e-19
C1110	a_27_74#	a_818_74##2	3.58405e-19
C1111	VPWR	Q	2.14668e-17
C1112	CLK	VNB	8.45743e-18
C1113	a_27_74##3	VPWR#18	7.20951e-17
C1114	VGND	Q	3.53861e-19
C1115	a_1879_74##10	a_818_74##12	5.60143e-19
C1116	Q_N	VNB	1.47816e-17
C1117	Q	VNB	1.91182e-17
C1118	VPWR	VNB	2.37769e-16
C1119	a_575_48##14	a_27_74##3	5.36195e-17
C1120	VGND	VNB	2.233e-16
C1121	a_818_74##9	a_818_74##3	7.68218e-19
C1122	VGND#11	D#4	2.55745e-18
C1123	VPWR#11	D#3	7.41069e-18
C1124	VGND#11	D#1	8.27362e-18
C1125	VPWR#11	a_161_446#	1.08158e-19
C1126	VPWR#11	DE#6	7.36706e-20
C1127	VGND#11	a_161_446##9	6.0871e-18
C1128	VPWR#9	VPWR#11	1.25968e-16
C1129	VPWR#11	VPWR#10	5.52543e-19
C1130	VGND#11	VGND#10	1.16144e-18
C1131	VGND#11	DE#4	1.66951e-18
C1132	VPWR#11	D#2	2.61755e-19
C1133	VPWR#11	a_161_446##2	7.10413e-18
C1134	VGND#11	a_27_74##9	2.32026e-17
C1135	VPWR#11	DE#2	1.79842e-19
C1136	VGND#11	VNB	6.73506e-17
C1137	a_27_74##5	VPWR#11	2.20602e-17
C1138	VGND#11	a_161_446##3	9.4006e-20
C1139	VPWR#11	VNB	6.6405e-17
C1140	VGND#11	a_161_446#	1.10301e-18
C1141	VGND#11	DE#7	7.60825e-19
C1142	VGND#11	D#2	3.19091e-19
C1143	VGND#9	VGND#11	1.37576e-16
C1144	VGND#11	DE#5	6.783e-18
C1145	a_27_74##4	VPWR#11	3.85235e-17
*
*
.ENDS sky130_fd_sc_hs__edfxbp_1
*
