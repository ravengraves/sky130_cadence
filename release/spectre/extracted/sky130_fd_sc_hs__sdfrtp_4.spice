* Extracted by Quantus, converted by sky130cad/quantus.py
*
*
*
*                       LINUX           Wed Nov 18 09:10:00 2026
*
*
*
*  PROGRAM  advgen
*
*  Name           : advgen - Quantus - (64-bit)
*  Version        : 25.1.0-p047
*  Build Date     : Thu Dec 11 23:20:30 PST 2025
*
*  HSPICE LIBRARY
*
*  OPERATING_TEMPERATURE 150
*  QRC_TECH_DIR <path>/tech
*
*
*

*
.SUBCKT sky130_fd_sc_hs__sdfrtp_4 VNB VPB VGND RESET_B VPWR Q D CLK SCE SCD
*
*
*  caps2d version: 10
*
*
*       TRANSISTOR CARDS
*
*
XM43 a_27_74##8 SCE#4 VGND#19 VNB sky130_fd_pr__nfet_01v8_lvt l=0.15 w=0.42 ad=0.1197 as=0.1197 pd=1.41 ps=1.41
XM2 a_225_81##2 a_27_74# a_312_81# VNB sky130_fd_pr__nfet_01v8_lvt l=0.15 w=0.42 ad=0.1197 as=0.1533 pd=1.41 ps=1.57
XM20 a_312_81# D#3 a_415_81##8 VNB sky130_fd_pr__nfet_01v8_lvt l=0.15 w=0.42 ad=0.1533 as=0.2667 pd=1.57 ps=2.11
XM12 a_415_81##8 SCE#6 a_572_81# VNB sky130_fd_pr__nfet_01v8_lvt l=0.15 w=0.42 ad=0.2667 as=0.1008 pd=2.11 ps=1.32
XM8 a_572_81# SCD#1 a_225_81# VNB sky130_fd_pr__nfet_01v8_lvt l=0.15 w=0.42 ad=0.1008 as=0.1176 pd=1.32 ps=1.4
XM1 a_225_81# RESET_B#3 VGND#18 VNB sky130_fd_pr__nfet_01v8_lvt l=0.15 w=0.42 ad=0.1176 as=0.1491 pd=1.4 ps=1.55
XM9 a_855_368##13 CLK#1 VGND#17 VNB sky130_fd_pr__nfet_01v8_lvt l=0.15 w=0.74 ad=0.2109 as=0.2072 pd=2.05 ps=2.04
XM37 VGND#17 a_855_368##6 a_1034_74##11 VNB sky130_fd_pr__nfet_01v8_lvt l=0.15 w=0.74 ad=0.2072 as=0.2109 pd=2.04 ps=2.05
XM41 a_415_81# a_855_368##8 a_1233_138##7 VNB sky130_fd_pr__nfet_01v8_lvt l=0.15 w=0.42 ad=0.1197 as=0.1176 pd=1.41 ps=1.4
XM19 a_1233_138##7 a_1034_74# a_1319_138# VNB sky130_fd_pr__nfet_01v8_lvt l=0.15 w=0.42 ad=0.1176 as=0.1008 pd=1.4 ps=1.32
XM44 a_1319_138# a_1367_112# a_1397_138# VNB sky130_fd_pr__nfet_01v8_lvt l=0.15 w=0.42 ad=0.1008 as=0.1008 pd=1.32 ps=1.32
XM27 a_1397_138# RESET_B#7 VGND#16 VNB sky130_fd_pr__nfet_01v8_lvt l=0.15 w=0.42 ad=0.1008 as=0.5676 pd=1.32 ps=3.31
XM46 VGND#16 a_1233_138##3 a_1367_112##7 VNB sky130_fd_pr__nfet_01v8_lvt l=0.15 w=0.74 ad=0.5676 as=0.233 pd=3.31 ps=2.13
XM3 a_1367_112##7 a_1034_74##5 a_1745_74##12 VNB sky130_fd_pr__nfet_01v8_lvt l=0.15 w=0.64 ad=0.233 as=0.433 pd=2.13 ps=3.08
XM31 a_1745_74##12 a_855_368# a_1955_74# VNB sky130_fd_pr__nfet_01v8_lvt l=0.15 w=0.42 ad=0.433 as=0.1008 pd=3.08 ps=1.32
XM6 a_1955_74# a_2003_48##3 VGND#15 VNB sky130_fd_pr__nfet_01v8_lvt l=0.15 w=0.42 ad=0.1008 as=0.1638 pd=1.32 ps=1.62
XM13 VGND#15 RESET_B#11 a_2141_74# VNB sky130_fd_pr__nfet_01v8_lvt l=0.15 w=0.42 ad=0.1638 as=0.0882 pd=1.62 ps=1.26
XM15 a_2141_74# a_1745_74##6 a_2003_48##4 VNB sky130_fd_pr__nfet_01v8_lvt l=0.15 w=0.42 ad=0.0882 as=0.1512 pd=1.26 ps=1.56
XM21 a_2339_74##16 a_1745_74##8 VGND#8 VNB sky130_fd_pr__nfet_01v8_lvt l=0.15 w=0.74 ad=0.2109 as=0.2072 pd=2.05 ps=2.04
XM30 Q#3 a_2339_74##7 VGND#8 VNB sky130_fd_pr__nfet_01v8_lvt l=0.15 w=0.74 ad=0.2072 as=0.2072 pd=2.04 ps=2.04
XM33 Q#3 a_2339_74##13 VGND#6 VNB sky130_fd_pr__nfet_01v8_lvt l=0.15 w=0.74 ad=0.2072 as=0.6586 pd=2.04 ps=3.26
XM22 VGND#6 a_2339_74##9 Q#1 VNB sky130_fd_pr__nfet_01v8_lvt l=0.15 w=0.74 ad=0.6586 as=0.2072 pd=3.26 ps=2.04
XM35 VGND#1 a_2339_74# Q#1 VNB sky130_fd_pr__nfet_01v8_lvt l=0.15 w=0.74 ad=0.2109 as=0.2072 pd=2.05 ps=2.04
XM39 a_27_74##9 SCE#5 VPWR#21 VPB sky130_fd_pr__pfet_01v8 l=0.15 w=0.64 ad=0.1888 as=0.6208 pd=1.87 ps=3.22
XM42 VPWR#21 SCE#1 a_340_464# VPB sky130_fd_pr__pfet_01v8 l=0.15 w=0.64 ad=0.6208 as=0.1728 pd=3.22 ps=1.82
XM28 a_340_464# D#1 a_415_81##6 VPB sky130_fd_pr__pfet_01v8 l=0.15 w=0.64 ad=0.1728 as=0.192 pd=1.82 ps=1.88
XM7 a_415_81##6 a_27_74##3 a_514_464# VPB sky130_fd_pr__pfet_01v8 l=0.15 w=0.64 ad=0.192 as=0.2496 pd=1.88 ps=2.06
XM16 a_514_464# SCD#3 VPWR#19 VPB sky130_fd_pr__pfet_01v8 l=0.15 w=0.64 ad=0.2496 as=0.2688 pd=2.06 ps=2.12
XM45 VPWR#19 RESET_B#4 a_415_81##7 VPB sky130_fd_pr__pfet_01v8 l=0.15 w=0.64 ad=0.2688 as=0.1888 pd=2.12 ps=1.87
XM32 a_855_368##12 CLK#4 VPWR#18 VPB sky130_fd_pr__pfet_01v8 l=0.15 w=1.12 ad=0.3304 as=0.336 pd=2.83 ps=2.84
XM38 VPWR#18 a_855_368##9 a_1034_74##13 VPB sky130_fd_pr__pfet_01v8 l=0.15 w=1.12 ad=0.336 as=0.3304 pd=2.84 ps=2.83
XM25 a_415_81##2 a_1034_74##3 a_1233_138##9 VPB sky130_fd_pr__pfet_01v8 l=0.15 w=0.42 ad=0.1239 as=0.147 pd=1.43 ps=1.54
XM36 a_1233_138##9 a_855_368##7 a_1342_463# VPB sky130_fd_pr__pfet_01v8 l=0.15 w=0.42 ad=0.147 as=0.1008 pd=1.54 ps=1.32
XM23 a_1342_463# a_1367_112##3 VPWR#17 VPB sky130_fd_pr__pfet_01v8 l=0.15 w=0.42 ad=0.1008 as=0.27865 pd=1.32 ps=2.29
XM0 VPWR#17 RESET_B#8 a_1233_138##8 VPB sky130_fd_pr__pfet_01v8 l=0.15 w=0.42 ad=0.27865 as=0.1239 pd=2.29 ps=1.43
XM17 VPWR#16 a_1233_138# a_1367_112##4 VPB sky130_fd_pr__pfet_01v8 l=0.15 w=1 ad=0.295 as=0.3 pd=2.59 ps=2.6
XM40 a_1367_112##4 a_855_368##2 a_1745_74##13 VPB sky130_fd_pr__pfet_01v8 l=0.15 w=1 ad=0.3 as=0.428275 pd=2.6 ps=3.57
XM18 a_1745_74##13 a_1034_74##6 a_1982_508# VPB sky130_fd_pr__pfet_01v8 l=0.15 w=0.42 ad=0.428275 as=0.1134 pd=3.57 ps=1.38
XM14 a_1982_508# a_2003_48# VPWR#15 VPB sky130_fd_pr__pfet_01v8 l=0.15 w=0.42 ad=0.1134 as=0.2247 pd=1.38 ps=1.91
XM34 VPWR#15 RESET_B#9 a_2003_48##7 VPB sky130_fd_pr__pfet_01v8 l=0.15 w=0.42 ad=0.2247 as=0.1617 pd=1.91 ps=1.61
XM11 a_2003_48##7 a_1745_74##9 VPWR#14 VPB sky130_fd_pr__pfet_01v8 l=0.15 w=0.42 ad=0.1617 as=0.3591 pd=1.61 ps=3.07
XM26 VPWR#14 a_1745_74##7 a_2339_74##17 VPB sky130_fd_pr__pfet_01v8 l=0.15 w=0.84 ad=0.3591 as=0.252 pd=3.07 ps=2.28
XM4 a_2339_74##17 a_1745_74# VPWR#13 VPB sky130_fd_pr__pfet_01v8 l=0.15 w=0.84 ad=0.252 as=0.406 pd=2.28 ps=3.01
XM24 VPWR#13 a_2339_74##12 Q#5 VPB sky130_fd_pr__pfet_01v8 l=0.15 w=1.12 ad=0.406 as=0.336 pd=3.01 ps=2.84
XM29 VPWR#12 a_2339_74##11 Q#5 VPB sky130_fd_pr__pfet_01v8 l=0.15 w=1.12 ad=0.336 as=0.336 pd=2.84 ps=2.84
XM5 Q#6 a_2339_74##10 VPWR#12 VPB sky130_fd_pr__pfet_01v8 l=0.15 w=1.12 ad=0.336 as=0.336 pd=2.84 ps=2.84
XM10 Q#6 a_2339_74##8 VPWR#1 VPB sky130_fd_pr__pfet_01v8 l=0.15 w=1.12 ad=0.336 as=0.3304 pd=2.84 ps=2.83
*
*
*       RESISTOR AND CAP/DIODE CARDS
*
Rg1	a_27_74#	a_27_74##2	403.314087
Rg2	SCE#1	SCE#2	523.968933
Rg3	SCE#2	SCE#3	101.487701
Rg4	SCE#3	SCE#4	578.322266
Rg5	SCE#3	SCE#5	454.178406
Rg6	D#1	D#2	683.446960
Rg7	D#2	D#3	212.440369
Rg8	a_27_74##3	a_27_74##4	296.912354
Rg9	SCE#6	SCE#7	384.968384
Rg10	SCD#1	SCD#2	539.388367
Rg11	SCD#2	SCD#3	352.588287
Rg12	RESET_B#1	RESET_B#2	50.300888
Rg13	RESET_B#2	RESET_B#3	744.742188
Rg14	RESET_B#2	RESET_B#4	311.928345
Rg15	CLK#1	CLK#2	345.498596
Rg16	CLK#2	CLK#3	50.284184
Rg17	CLK#2	CLK#4	489.338104
Rg18	a_1034_74#	a_1034_74##2	575.698853
Rg19	a_1034_74##2	a_1034_74##3	333.548126
Rg20	a_1367_112#	a_1367_112##2	500.983856
Rg21	a_1367_112##2	a_1367_112##3	314.717804
Rg22	RESET_B#5	RESET_B#6	44.394718
Rg23	RESET_B#6	RESET_B#7	680.126465
Rg24	RESET_B#6	RESET_B#8	251.024292
Rg25	a_1233_138#	a_1233_138##2	586.545105
Rg26	a_1233_138##2	a_1233_138##3	329.810669
Rg27	a_1034_74##4	a_1034_74##5	658.234131
Rg28	a_855_368#	a_855_368##2	1170.937622
Rg29	a_855_368##2	a_855_368##3	1834.472046
Rg30	a_855_368##3	a_855_368##4	1552.722534
Rg31	a_855_368##4	a_855_368##5	197.533447
Rg32	a_855_368##5	a_855_368##6	296.251892
Rg33	a_855_368##3	a_855_368##7	283.919525
Rg34	a_855_368##4	a_855_368##8	412.952728
Rg35	a_855_368##5	a_855_368##9	475.671509
Rg36	a_1034_74##6	a_1034_74##7	233.787552
Rg37	a_2003_48#	a_2003_48##2	615.935608
Rg38	a_2003_48##2	a_2003_48##3	429.478333
Rg39	RESET_B#9	RESET_B#10	355.533295
Rg40	RESET_B#10	RESET_B#11	770.926208
Rg41	a_1745_74#	a_1745_74##2	488.374908
Rg42	a_1745_74##2	a_1745_74##3	208.992279
Rg43	a_1745_74##3	a_1745_74##4	288.862946
Rg44	a_1745_74##4	a_1745_74##5	19.876480
Rg45	a_1745_74##5	a_1745_74##6	221.750107
Rg46	a_1745_74##2	a_1745_74##7	309.108917
Rg47	a_1745_74##3	a_1745_74##8	280.275299
Rg48	a_1745_74##4	a_1745_74##9	750.361755
Rg49	a_2339_74#	a_2339_74##2	396.534149
Rg50	a_2339_74##2	a_2339_74##3	53.224644
Rg51	a_2339_74##3	a_2339_74##4	88.491348
Rg52	a_2339_74##4	a_2339_74##5	42.651272
Rg53	a_2339_74##5	a_2339_74##6	25.964319
Rg54	a_2339_74##6	a_2339_74##7	509.169769
Rg55	a_2339_74##2	a_2339_74##8	555.898560
Rg56	a_2339_74##3	a_2339_74##9	374.812225
Rg57	a_2339_74##3	a_2339_74##10	460.891510
Rg58	a_2339_74##4	a_2339_74##11	480.487915
Rg59	a_2339_74##5	a_2339_74##12	403.676117
Rg60	a_2339_74##6	a_2339_74##13	318.705414
Rf1	D	D#4	2.165378
Rf2	D#5	D#2	162.398178
Rf3	D#4	D#5	7.380112
Rf4	a_27_74##4	a_27_74##6	310.729065
Rf5	a_27_74##6	a_27_74##7	68.468300
Rf6	a_27_74##7	a_27_74##8	42.382935
Rf7	a_27_74##6	a_27_74##9	29.754587
Rf8	a_27_74##7	a_27_74##2	184.267532
Rf9	SCE#7	SCE	217.719376
Rf10	SCE	SCE#9	3.396243
Rf11	SCE#9	SCE	14.717052
Rf12	SCD	SCD#4	10.235490
Rf13	SCD#4	SCD	4.330400
Rf14	a_225_81#	a_225_81##2	188.468414
Rf15	RESET_B#1	RESET_B#13	160.920990
Rf16	RESET_B#14	RESET_B#15	0.688184
Rf17	RESET_B#13	RESET_B#14	5.117745
Rf18	CLK#3	CLK	88.220528
Rf19	a_855_368##5	a_855_368##11	165.763901
Rf20	a_855_368##11	a_855_368##12	74.057510
Rf21	a_855_368##11	a_855_368##13	80.495392
Rf22	a_415_81#	a_415_81##3	184.103439
Rf23	a_415_81##3	a_415_81##4	147.750854
Rf24	a_415_81##4	a_415_81##5	18.044025
Rf25	a_415_81##5	a_415_81##6	101.126427
Rf26	a_415_81##4	a_415_81##7	11.819120
Rf27	a_415_81##5	a_415_81##8	187.117142
Rf28	a_415_81##2	a_415_81##3	15.000000
Rf29	RESET_B#16	RESET_B#17	10.822159
Rf30	RESET_B#5	RESET_B#19	161.277176
Rf31	RESET_B#16	RESET_B#19	2.362036
Rf32	a_1233_138##2	a_1233_138##5	243.989868
Rf33	a_1233_138##5	a_1233_138##6	56.140888
Rf34	a_1233_138##6	a_1233_138##7	140.129486
Rf35	a_1233_138##5	a_1233_138##8	30.677031
Rf36	a_1233_138##6	a_1233_138##9	20.367285
Rf37	a_1367_112##4	a_1367_112##5	83.352509
Rf38	a_1367_112##5	a_1367_112##2	274.245789
Rf39	a_1367_112##5	a_1367_112##7	22.242311
Rf40	a_1034_74##7	a_1034_74##4	257.849365
Rf41	a_1034_74##4	a_1034_74##10	329.306976
Rf42	a_1034_74##10	a_1034_74##11	12.031229
Rf43	a_1034_74##10	a_1034_74##12	48.859142
Rf44	a_1034_74##12	a_1034_74##13	22.776604
Rf45	a_1034_74##12	a_1034_74##2	184.036102
Rf46	RESET_B#10	RESET_B#21	161.216980
Rf47	RESET_B#22	RESET_B	10.761964
Rf48	RESET_B#21	RESET_B#22	1.968364
Rf49	a_1745_74##5	a_1745_74##11	252.549393
Rf50	a_1745_74##11	a_1745_74##12	48.209122
Rf51	a_1745_74##11	a_1745_74##13	193.113251
Rf52	a_2003_48##4	a_2003_48##5	99.422348
Rf53	a_2003_48##5	a_2003_48##2	232.571899
Rf54	a_2003_48##5	a_2003_48##7	98.516159
Rf55	a_2339_74##4	a_2339_74##15	95.739319
Rf56	a_2339_74##15	a_2339_74##16	67.830971
Rf57	a_2339_74##15	a_2339_74##17	34.641235
Rf58	Q#1	Q#2	27.686930
Rf59	Q#2	Q#3	114.632416
Rf60	Q#2	Q#4	65.985970
Rf61	Q#4	Q#5	91.477638
Rf62	Q#4	Q#6	77.153900
Rf63	Q#4	Q	11.707743
Rf64	VPWR#1	VPWR#2	68.935806
Rf65	VPWR#2	VPWR#3	30.714024
Rf66	VPWR#3	VPWR#4	71.655113
Rf67	VPWR#4	VPWR#5	72.020370
Rf68	VPWR#5	VPWR#6	83.651100
Rf69	VPWR#6	VPWR#7	40.153240
Rf70	VPWR#7	VPWR#8	119.170349
Rf71	VPWR#8	VPWR#9	80.783325
Rf72	VPWR#9	VPWR#10	180.739929
Rf73	VPWR#10	VPWR#11	110.281715
Rf74	VPWR#3	VPWR#12	43.341217
Rf75	VPWR#4	VPWR#13	48.259808
Rf76	VPWR#5	VPWR#14	57.922588
Rf77	VPWR#6	VPWR#15	34.507496
Rf78	VPWR#8	VPWR#16	78.767654
Rf79	VPWR#9	VPWR#17	30.652718
Rf80	VPWR#10	VPWR#18	31.948624
Rf81	VPWR#11	VPWR#19	36.430706
Rf82	VPWR#11	VPWR#20	168.140366
Rf83	VPWR#20	VPWR#22	8.553795
Rf84	VPWR#22	VPWR#21	7.500000
Rf86	VPWR#21	VPWR#22	7.500000
Rf87	VGND#1	VGND#2	61.792049
Rf88	VGND#2	VGND#3	50.660587
Rf89	VGND#3	VGND#4	90.497849
Rf90	VGND#4	VGND#5	161.101074
Rf91	VGND#3	VGND#7	7.862220
Rf92	VGND#7	VGND#6	15.000000
Rf93	VGND#4	VGND#8	39.088303
Rf94	VGND#5	VGND#9	181.505951
Rf95	VGND#9	VGND#10	201.262390
Rf96	VGND#10	VGND#11	69.406258
Rf97	VGND#11	VGND#12	38.692230
Rf98	VGND#12	VGND#13	193.559280
Rf100	VGND#5	VGND#15	30.492321
Rf101	VGND#9	VGND#16	24.468842
Rf102	VGND#10	VGND#17	38.817978
Rf103	VGND#11	VGND#18	35.491676
Rf104	VGND#13	VGND#19	33.523315
Rf105	VGND#6	VGND#7	15.000000
Rf110	SCE#2	SCE#9	53.410934
Rf111	SCD#2	SCD#4	80.116402
Re2	RESET_B	RESET_B#17	4.743838
Re3	RESET_B#17	RESET_B#15	16.168276
Re4	VPWR#2	VPWR#25	4.826505
Re5	VPWR#25	VPWR	1.014099
Re6	VPWR	VPWR#11	2.265657
Re7	VGND#2	VGND#21	4.826505
Re8	VGND#21	VGND	1.014099
Re9	VGND	VGND#12	2.265657
Re14	VPWR#7	VPWR#25	0.698413
Re17	VGND#5	VGND#21	0.698413
*
*       CAPACITOR CARDS
*
*
C1	SCE#6	SCD#1	3.49134e-17
C2	a_1745_74##13	VPWR#15	4.12981e-17
C3	a_27_74##8	D#3	1.20693e-19
C4	a_2003_48##4	RESET_B#11	3.13969e-18
C5	VGND#2	Q#4	7.32492e-18
C6	a_1233_138##6	a_1367_112##2	4.9694e-17
C7	a_27_74##4	a_415_81##6	6.01702e-17
C8	Q#6	VPWR#2	2.72318e-17
C9	a_415_81##2	CLK#4	7.52532e-19
C10	RESET_B#17	VPWR#9	6.9531e-18
C11	VGND#4	a_2339_74##6	4.2586e-20
C12	a_225_81#	a_415_81##8	9.15912e-17
C13	RESET_B#17	a_855_368##7	2.92607e-18
C14	Q#3	a_2339_74##6	9.9116e-18
C15	VPWR#18	a_855_368##9	3.40088e-17
C16	a_415_81##5	RESET_B#2	2.1475e-17
C17	VGND#19	a_27_74#	3.1965e-18
C18	SCE#1	D#1	4.72343e-17
C19	VGND#15	a_1745_74##6	5.85682e-18
C20	a_1367_112##2	a_1233_138##5	2.49711e-17
C21	VPWR#5	a_2003_48#	1.66603e-19
C22	RESET_B#13	a_415_81##7	3.00342e-18
C23	VGND#2	Q#2	3.74449e-18
C24	VGND#10	a_855_368##13	9.07393e-18
C25	a_1745_74##11	a_855_368#	2.02804e-17
C26	RESET_B#17	VPWR#8	6.69659e-18
C27	a_1034_74##13	CLK#4	2.47739e-18
C28	a_855_368##8	a_1034_74##2	1.93213e-17
C29	VGND#2	a_2339_74##3	7.68925e-19
C30	a_225_81##2	SCE#4	2.02811e-18
C31	a_2339_74##15	a_2339_74##6	4.85703e-19
C32	a_855_368##12	a_855_368##9	5.09691e-18
C33	VPWR#8	a_1034_74##6	5.59412e-19
C34	a_855_368##11	a_855_368##4	1.58431e-18
C35	a_1233_138##6	VPWR#9	1.52772e-17
C36	VGND#5	VGND#4	1.34092e-19
C37	a_1233_138##2	a_855_368##3	3.16412e-21
C38	RESET_B#15	a_415_81#	3.50438e-18
C39	a_415_81##5	SCD#3	2.27337e-17
C40	a_27_74##8	a_27_74#	2.38168e-19
C41	a_2003_48##5	a_1745_74##7	7.07928e-19
C42	VPWR#2	Q#5	5.14551e-18
C43	a_415_81##2	RESET_B#4	6.78313e-19
C44	a_1745_74##13	a_1982_508#	2.56357e-18
C45	VGND#2	a_2339_74##2	9.66519e-20
C46	VPWR#18	CLK#4	3.49745e-17
C47	a_2003_48##4	a_2003_48##3	4.82399e-19
C48	Q#4	a_2339_74##2	2.8819e-17
C49	D#3	SCE#6	5.18688e-18
C50	a_1233_138##2	RESET_B#6	4.19786e-17
C51	SCE#5	SCE#1	3.13845e-18
C52	a_1233_138##7	a_1233_138##6	4.1647e-19
C53	Q#4	VPWR#1	3.50776e-17
C54	VGND#19	SCE#4	3.3786e-17
C55	RESET_B#15	a_1034_74##11	3.87426e-18
C56	VPWR#6	a_1034_74##6	3.61161e-19
C57	a_1233_138##6	a_1034_74##2	4.04799e-18
C58	VGND#15	RESET_B#11	2.91472e-17
C59	RESET_B#10	a_1745_74##9	1.3427e-17
C60	a_855_368##12	CLK#4	3.20489e-17
C61	VPWR#17	RESET_B#7	4.67541e-19
C62	a_2003_48##4	a_1745_74##5	4.41474e-17
C63	Q#2	a_2339_74##3	3.46677e-18
C64	a_1745_74##12	VGND#15	1.44585e-17
C65	a_1233_138##5	a_1034_74##2	2.13754e-20
C66	RESET_B#15	VGND#17	3.38772e-18
C67	a_415_81##2	a_855_368##4	2.80332e-17
C68	a_1745_74##12	a_1745_74##6	1.40632e-19
C69	CLK#1	a_855_368##5	1.35076e-18
C70	a_27_74##8	SCE#4	1.23277e-17
C71	VGND#2	Q#5	1.00448e-18
C72	VPWR#18	RESET_B#4	2.95186e-18
C73	a_1745_74##11	a_1034_74##5	5.46142e-19
C74	VGND#18	VGND#10	3.05392e-19
C75	a_2003_48##5	a_2339_74##16	1.21494e-17
C76	RESET_B#15	a_855_368##13	2.57147e-18
C77	RESET_B#6	a_855_368##2	9.60816e-19
C78	VGND#3	a_2339_74##6	4.218e-18
C79	a_2003_48#	RESET_B#10	1.51406e-17
C80	a_2003_48##4	a_855_368#	2.68597e-19
C81	a_415_81##5	a_27_74##3	8.64029e-19
C82	VPWR#8	a_855_368##2	5.34989e-17
C83	VGND#15	a_1745_74##5	1.99309e-17
C84	a_415_81##8	a_415_81##6	2.15069e-18
C85	a_1233_138##5	VPWR#9	9.82305e-19
C86	VPWR#5	VPWR#4	1.17403e-18
C87	a_2003_48##5	a_1745_74##9	2.14287e-18
C88	a_27_74#	D#3	1.72966e-17
C89	RESET_B#15	VGND#18	3.0962e-18
C90	RESET_B#15	a_855_368##9	2.48233e-18
C91	VPWR#19	CLK#4	7.737e-19
C92	VGND#15	a_2003_48##3	2.74029e-17
C93	a_415_81#	a_1233_138##6	4.21771e-18
C94	VPWR#11	a_1034_74##3	4.15789e-18
C95	RESET_B#22	a_2003_48##5	2.67333e-18
C96	a_415_81##2	a_855_368##3	1.05537e-17
C97	a_225_81#	VGND#11	2.64617e-18
C98	a_1367_112##4	a_1745_74##13	2.04987e-17
C99	VGND#12	a_1233_138##7	9.24701e-18
C100	Q#4	Q#6	6.2171e-18
C101	VGND#12	a_855_368##7	2.41261e-19
C102	a_415_81##5	RESET_B#13	5.29063e-17
C103	VPWR#18	SCD#3	2.40619e-19
C104	RESET_B#5	a_855_368##3	1.32376e-19
C105	RESET_B#3	CLK#3	6.57687e-18
C106	Q#5	VPWR#4	8.49699e-18
C107	VPWR#6	a_855_368##2	4.08457e-19
C108	a_1034_74##11	a_1367_112##5	3.17625e-18
C109	RESET_B#4	a_415_81##7	2.15916e-17
C110	RESET_B#15	CLK#4	1.48825e-18
C111	a_1745_74##12	RESET_B#11	3.05238e-19
C112	VGND#10	a_855_368##11	4.78097e-19
C113	VGND#12	a_415_81#	1.03435e-17
C114	RESET_B#5	RESET_B#6	9.25363e-18
C115	RESET_B#11	a_1745_74##4	2.82997e-17
C116	a_1034_74##7	a_2003_48#	3.54054e-17
C117	RESET_B#4	VPWR#19	1.94539e-17
C118	VPWR#5	VPWR#13	4.08135e-18
C119	a_1745_74##11	a_1233_138##3	5.89156e-20
C120	a_855_368##2	a_2003_48##2	1.97953e-17
C121	VGND#12	a_1034_74##11	5.30931e-17
C122	a_2003_48##4	a_2003_48##5	2.4389e-18
C123	VPWR#16	a_1745_74##13	5.34718e-18
C124	a_415_81##5	D#1	2.98427e-19
C125	a_2339_74##9	a_2339_74#	3.86654e-17
C126	a_2339_74##15	a_2339_74##3	5.64883e-20
C127	VGND#15	a_855_368#	4.96036e-18
C128	SCE#4	a_27_74#	3.99387e-18
C129	a_1034_74##13	a_855_368##4	3.34255e-17
C130	VPWR#11	RESET_B#4	4.87202e-18
C131	Q#5	VPWR#3	8.65209e-18
C132	VPWR#8	a_1233_138#	2.11719e-18
C133	VGND#9	a_855_368##7	4.14659e-20
C134	VGND#4	VGND#3	1.40275e-18
C135	a_855_368##2	a_1034_74##7	2.95768e-17
C136	a_1745_74##12	a_2003_48##3	3.57282e-18
C137	RESET_B#6	a_1233_138#	1.13982e-17
C138	VGND#3	VGND#1	4.29409e-18
C139	RESET_B#22	a_1745_74##9	8.24657e-19
C140	VGND#12	VGND#11	6.56763e-17
C141	VPWR#11	SCD#3	4.449e-18
C142	Q#4	a_1745_74##3	1.1895e-19
C143	SCD#2	RESET_B#3	8.6337e-18
C144	VGND#12	a_855_368##13	1.29255e-17
C145	VPWR#19	SCD#3	3.24696e-17
C146	a_415_81#	a_855_368##4	1.10781e-17
C147	a_855_368##4	a_855_368##3	2.20179e-19
C148	Q#4	VPWR#12	2.52426e-17
C149	VGND#3	a_2339_74#	2.5088e-18
C150	a_225_81##2	a_415_81##8	1.37008e-17
C151	a_415_81##6	RESET_B#4	2.65468e-19
C152	RESET_B#15	VPWR#10	8.68565e-18
C153	a_1233_138##7	RESET_B#6	1.02526e-19
C154	a_1367_112##4	VPWR#16	8.53772e-17
C155	a_1034_74##4	a_855_368##2	4.31329e-17
C156	VGND#12	VGND#10	1.22306e-16
C157	a_2339_74##8	VPWR#1	3.0762e-17
C158	VPWR#11	a_27_74##3	6.30869e-18
C159	a_415_81##5	a_855_368##5	5.90883e-20
C160	VGND#15	a_2003_48##2	1.24352e-18
C161	a_1034_74##13	a_855_368##3	3.09106e-21
C162	a_1745_74##12	a_855_368##2	5.15045e-19
C163	a_1745_74##11	a_2003_48##4	1.10375e-19
C164	a_1367_112##2	a_855_368##3	1.50787e-18
C165	SCE#7	RESET_B#3	6.01247e-19
C166	a_1034_74##4	a_1233_138#	3.06638e-19
C167	VGND#15	a_1034_74##5	6.60099e-19
C168	a_1034_74##5	a_855_368##2	1.12815e-19
C169	VPWR#9	RESET_B#8	2.72596e-18
C170	VGND#12	VGND#9	3.18281e-17
C171	a_415_81##5	SCE#1	2.43895e-19
C172	VPWR#11	D#1	1.54686e-18
C173	a_2339_74##17	VPWR#5	3.42736e-18
C174	VGND#12	a_225_81#	1.29238e-16
C175	a_1367_112##5	VPWR#16	4.65372e-18
C176	VPWR#19	a_27_74##3	3.48631e-18
C177	a_2339_74##17	a_1745_74##4	7.59021e-19
C178	a_1233_138##2	a_855_368##2	1.34986e-18
C179	VGND#4	a_2339_74##9	2.22467e-20
C180	a_1367_112##2	RESET_B#6	3.03013e-17
C181	SCE#7	SCD#1	8.35938e-18
C182	a_2339_74##15	a_2339_74##2	7.93453e-20
C183	a_2339_74##8	Q#6	2.31692e-17
C184	a_415_81##6	SCD#3	2.56371e-18
C185	a_1745_74##12	a_855_368#	3.84187e-17
C186	a_2339_74##13	a_2339_74##9	3.04442e-18
C187	a_415_81##2	RESET_B#2	7.49887e-20
C188	RESET_B#21	a_1745_74##9	2.68106e-19
C189	VGND#19	a_415_81##8	2.63149e-18
C190	VPWR#11	SCE#1	8.41757e-19
C191	a_415_81#	a_855_368##3	1.46064e-19
C192	VGND#3	a_2339_74##3	8.02427e-19
C193	a_1233_138##2	a_1233_138#	4.91523e-19
C194	a_855_368##11	a_855_368##5	2.35472e-17
C195	VPWR#4	VPWR#3	7.06045e-19
C196	VGND#10	a_855_368##4	4.51614e-19
C197	RESET_B#8	a_855_368##3	2.18707e-17
C198	VPWR#1	a_2339_74##10	2.6697e-18
C199	a_2003_48##5	RESET_B#21	2.12418e-17
C200	a_1034_74##5	a_1233_138#	1.79014e-17
C201	RESET_B#5	a_855_368##2	1.53096e-18
C202	VGND#3	Q#1	3.72367e-17
C203	VPWR#11	SCE#5	6.54467e-19
C204	VGND#12	a_415_81##8	2.04997e-17
C205	Q#5	Q#4	2.56448e-18
C206	a_415_81##6	a_514_464#	7.64257e-18
C207	VPWR#12	a_2339_74##8	2.29321e-18
C208	VGND#19	a_27_74##7	4.40484e-18
C209	VGND#3	a_2339_74##9	2.72972e-17
C210	a_415_81##5	CLK#3	4.39901e-18
C211	VPWR#19	D#1	2.79983e-19
C212	a_2339_74##17	VPWR#4	3.29746e-18
C213	VGND#11	a_415_81##8	9.0877e-19
C214	a_1034_74##11	a_1397_138#	3.83083e-19
C215	RESET_B#5	a_1233_138#	8.23581e-19
C216	VPWR#11	VPWR#10	1.2621e-16
C217	VGND#15	a_1233_138##3	5.13565e-20
C218	a_415_81##6	a_27_74##3	5.0538e-17
C219	a_855_368##11	RESET_B#2	3.14217e-19
C220	a_2339_74##10	Q#6	2.58898e-17
C221	Q#2	a_1745_74##3	7.16755e-20
C222	D#2	RESET_B#3	1.57669e-19
C223	a_1034_74##11	a_855_368##4	1.31801e-17
C224	a_1034_74##5	a_1745_74##12	3.14207e-18
C225	a_1233_138##8	VPWR#16	2.68867e-17
C226	a_415_81##2	a_855_368##8	6.67566e-21
C227	VPWR#11	VPWR#9	4.35376e-17
C228	RESET_B#17	VPWR#7	4.89468e-19
C229	Q#5	a_2339_74##8	2.11095e-19
C230	a_1745_74##12	a_1034_74##7	1.53747e-19
C231	a_855_368##4	a_1034_74##2	3.45969e-17
C232	VPWR#9	a_1367_112##3	2.41846e-18
C233	VGND#12	a_225_81##2	6.05348e-17
C234	VPWR#5	VPWR#14	3.42956e-19
C235	VGND#4	a_1745_74##4	1.16929e-18
C236	VPWR#18	a_855_368##3	5.02869e-18
C237	a_2339_74##15	a_1745_74##4	4.44906e-18
C238	VGND#4	a_2339_74##13	5.86775e-19
C239	D#2	SCE#6	2.15207e-18
C240	VPWR#19	SCE#1	3.4042e-19
C241	a_2339_74##7	a_2339_74##13	3.70436e-17
C242	a_1034_74##2	a_855_368##3	1.25966e-18
C243	VPWR#12	a_2339_74##10	5.4431e-17
C244	a_855_368##11	CLK#3	7.61468e-18
C245	RESET_B#17	a_1745_74##13	1.20175e-18
C246	a_415_81##6	D#1	3.78037e-17
C247	a_1233_138##5	VPWR#16	3.4209e-18
C248	VGND#12	VGND#19	1.85223e-17
C249	a_1034_74##4	VGND#15	4.39267e-18
C250	a_1233_138##6	a_1233_138##5	4.23226e-18
C251	D#2	D#3	5.44074e-18
C252	a_2339_74##17	a_1745_74##2	6.96925e-18
C253	a_1745_74##11	RESET_B#21	6.88587e-18
C254	RESET_B#22	a_2003_48#	1.26339e-18
C255	a_1034_74##5	a_1367_112##7	1.3722e-17
C256	VPWR#14	a_1745_74##4	9.42867e-18
C257	a_2003_48##7	VPWR#6	1.00038e-17
C258	RESET_B#17	a_855_368##3	6.73066e-19
C259	RESET_B#17	a_1367_112##4	4.61164e-17
C260	a_27_74#	D#2	1.58349e-17
C261	VPWR#17	VPWR#16	4.65125e-18
C262	a_415_81##5	RESET_B#1	9.56597e-18
C263	VGND#12	a_27_74##8	1.68746e-17
C264	VGND#3	VGND#6	1.42996e-17
C265	a_1233_138##6	a_1233_138##8	2.22366e-18
C266	VGND#19	a_225_81##2	3.03813e-17
C267	VPWR#2	a_2339_74##4	3.01446e-18
C268	Q#5	a_2339_74##10	2.08843e-18
C269	a_27_74##9	a_27_74##3	1.46532e-20
C270	VGND#3	a_2339_74##13	1.67101e-17
C271	a_1367_112##3	a_855_368##3	1.76094e-17
C272	a_2339_74##10	a_2339_74##8	4.80955e-17
C273	RESET_B#17	RESET_B#6	8.25026e-19
C274	a_1034_74##4	a_1745_74##12	7.72976e-17
C275	RESET_B#17	VPWR#16	3.05938e-17
C276	VGND#15	a_1745_74##11	1.5774e-17
C277	RESET_B#17	VPWR#11	1.78029e-17
C278	a_415_81##6	SCE#1	6.71056e-18
C279	a_1745_74##13	VPWR#7	3.53665e-17
C280	VGND#4	Q#3	8.47907e-18
C281	a_1034_74##3	a_1367_112##2	1.42465e-19
C282	VGND#2	a_2339_74##4	3.0449e-18
C283	a_2339_74##11	VPWR#12	2.07478e-17
C284	a_1233_138##7	a_1319_138#	1.86095e-18
C285	a_1034_74##4	a_1367_112##7	7.42028e-19
C286	a_1034_74##2	a_855_368##7	2.23372e-18
C287	VPWR#13	a_2339_74##10	1.72497e-19
C288	a_1367_112##3	RESET_B#6	2.28628e-18
C289	VPWR#14	a_1745_74##3	1.42259e-18
C290	RESET_B#17	a_1233_138##8	1.16152e-17
C291	a_2003_48##7	VPWR#5	9.63726e-18
C292	a_2339_74##3	a_2339_74##8	2.0945e-18
C293	SCE#4	a_27_74##2	1.56158e-17
C294	VPWR#17	a_1233_138##8	9.94608e-18
C295	a_2339_74##15	a_1745_74##3	1.3064e-17
C296	a_1233_138##3	a_1367_112##7	8.25709e-18
C297	RESET_B#6	a_855_368##3	1.42052e-18
C298	VGND#4	a_1745_74##3	1.38405e-19
C299	a_2339_74##6	a_2339_74##3	3.36616e-18
C300	RESET_B#13	CLK#3	1.28215e-18
C301	a_27_74##9	D#1	1.08832e-20
C302	a_1034_74##4	VGND#16	7.96981e-18
C303	SCD	RESET_B#2	5.36895e-18
C304	a_1745_74##8	a_2339_74##7	3.69918e-17
C305	VGND#4	a_2339_74##7	6.64522e-18
C306	a_2003_48##5	a_855_368##2	6.43558e-20
C307	Q#5	a_2339_74##11	7.37655e-17
C308	a_27_74##7	D#3	1.54406e-19
C309	a_855_368##5	a_855_368##4	1.44837e-17
C310	RESET_B#17	VPWR#17	5.30632e-18
C311	VGND#5	a_1745_74##11	2.41368e-18
C312	a_27_74#	SCE#2	6.4881e-18
C313	a_1367_112##5	a_855_368#	4.85789e-19
C314	SCE#1	VPWR#21	2.16837e-17
C315	a_415_81##5	SCD#2	1.06054e-17
C316	a_1233_138##6	VPWR#17	1.12123e-17
C317	a_2339_74##11	a_2339_74##10	4.736e-17
C318	VPWR#12	a_2339_74##12	6.46452e-19
C319	RESET_B#15	VPWR#11	5.35443e-17
C320	a_415_81##5	VPWR#10	7.00849e-18
C321	a_1745_74##11	a_855_368##2	1.60921e-17
C322	a_27_74##6	a_27_74##3	2.57082e-19
C323	a_2339_74##16	a_1745_74##4	6.61536e-18
C324	a_1233_138##3	VGND#16	1.30535e-17
C325	VGND#3	Q#3	8.54759e-17
C326	VPWR#13	a_2339_74##11	3.71489e-19
C327	a_27_74##9	SCE#1	7.02958e-19
C328	a_2003_48##7	a_1745_74##4	9.77968e-19
C329	VGND#3	a_2339_74##7	7.30862e-19
C330	VPWR#10	a_1034_74##3	7.98519e-19
C331	VGND#12	RESET_B#15	1.37492e-18
C332	VGND#8	a_1745_74##2	6.44006e-19
C333	Q#5	a_2339_74##12	5.50336e-17
C334	a_27_74##8	VGND#19	3.46752e-17
C335	SCE#5	VPWR#21	2.31384e-17
C336	a_855_368##3	a_855_368##7	6.58896e-19
C337	VGND#5	a_1745_74##4	4.32011e-19
C338	RESET_B#13	RESET_B#1	1.35901e-17
C339	CLK#3	a_855_368##9	3.03158e-19
C340	VPWR#15	VPWR#5	1.8876e-18
C341	VPWR#9	a_1034_74##3	2.08169e-18
C342	a_1233_138##5	VPWR#17	3.41143e-17
C343	a_27_74##7	a_27_74#	4.1776e-19
C344	VGND#5	a_1745_74##5	3.65959e-18
C345	a_2339_74##15	a_1745_74##2	1.05762e-17
C346	RESET_B#17	a_415_81##2	3.71011e-17
C347	a_2339_74##4	Q#5	4.64757e-17
C348	a_1745_74##6	a_1745_74##8	3.44747e-18
C349	a_27_74##9	SCE#5	2.68231e-17
C350	VGND#4	a_1745_74##8	6.069e-18
C351	SCE#7	a_415_81##5	3.05599e-18
C352	a_1034_74##11	a_1034_74##4	3.80022e-18
C353	a_2339_74##12	VPWR#13	2.86528e-17
C354	a_2339_74##12	a_2339_74##11	4.62539e-17
C355	a_1367_112##5	a_1034_74##5	2.48873e-17
C356	a_1745_74##6	a_2141_74#	8.8457e-18
C357	RESET_B#7	VGND#16	1.28321e-17
C358	VGND#5	RESET_B#10	1.30336e-19
C359	a_2339_74##16	a_1745_74##3	5.99759e-18
C360	Q#4	VPWR#3	1.4033e-19
C361	RESET_B#17	a_1367_112##5	4.67059e-18
C362	a_2003_48##2	VPWR#7	1.7579e-19
C363	a_2339_74##4	VPWR#13	1.85347e-17
C364	a_2339_74##15	VPWR#5	3.18153e-19
C365	a_27_74##6	D#1	4.47457e-19
C366	RESET_B#17	a_1034_74##7	1.99902e-17
C367	RESET_B#11	a_2141_74#	8.8457e-18
C368	Q#5	a_1745_74#	1.47717e-18
C369	RESET_B#1	CLK#4	9.72166e-18
C370	a_1745_74##11	a_1233_138#	9.62848e-20
C371	RESET_B#17	a_1233_138##6	4.61786e-17
C372	a_1034_74##7	VPWR#7	3.02822e-19
C373	VGND#8	VGND#3	2.65901e-18
C374	a_2339_74##17	a_2339_74##12	1.41808e-18
C375	RESET_B#17	a_1034_74##4	1.1659e-17
C376	VPWR#10	a_855_368##9	3.95898e-18
C377	VGND#3	a_1745_74##8	3.48661e-19
C378	VGND#9	RESET_B#6	1.79176e-19
C379	VGND#5	a_1034_74##7	1.41816e-19
C380	a_27_74##7	SCE#4	1.68422e-17
C381	a_2339_74##6	a_2339_74##11	2.57212e-18
C382	a_2003_48##4	a_1745_74##4	1.51618e-17
C383	RESET_B#17	a_1233_138##5	3.32286e-17
C384	a_1745_74#	VPWR#13	2.8848e-17
C385	a_855_368##4	a_1034_74##3	1.66403e-17
C386	VGND#4	a_2339_74##16	1.36788e-17
C387	RESET_B#17	a_1233_138##2	1.87006e-17
C388	a_2339_74##4	VPWR#4	3.12308e-19
C389	a_1233_138##7	a_1233_138##3	2.51302e-19
C390	VPWR#14	a_2339_74##12	5.96102e-19
C391	a_1745_74#	a_2339_74##12	2.80673e-17
C392	VGND#5	a_1034_74##4	1.79649e-17
C393	a_27_74##4	a_415_81##5	1.66678e-18
C394	RESET_B#11	a_1745_74##6	4.11628e-17
C395	a_1367_112##5	a_1233_138##3	2.85117e-17
C396	a_27_74##6	SCE#1	6.67027e-19
C397	RESET_B#17	RESET_B#5	1.236e-17
C398	a_855_368##3	a_1034_74##3	2.1389e-17
C399	a_1233_138##6	a_1233_138##9	2.50006e-18
C400	a_2339_74##17	a_1745_74#	5.23547e-17
C401	VGND#4	a_1745_74##6	1.95071e-19
C402	RESET_B#2	CLK#3	1.32499e-17
C403	a_2339_74##15	VPWR#4	1.74659e-19
C404	VPWR#12	a_1745_74##9	5.1302e-20
C405	Q#1	VGND#1	4.28019e-17
C406	a_2003_48##7	a_2339_74##12	1.46482e-19
C407	a_1233_138##7	a_855_368##7	3.05723e-19
C408	RESET_B#17	a_1367_112##2	2.79884e-17
C409	a_1745_74##5	RESET_B#10	8.66e-19
C410	a_2003_48##3	a_1955_74#	9.87534e-18
C411	RESET_B#16	a_1233_138##8	1.0191e-17
C412	VPWR#13	a_1745_74##7	7.31273e-19
C413	D#1	SCD#2	3.75856e-19
C414	a_855_368#	a_1955_74#	9.87534e-18
C415	VPWR#14	a_1745_74#	7.43414e-19
C416	a_2339_74##11	a_2339_74##3	2.57212e-18
C417	a_2339_74##4	Q#4	5.04324e-17
C418	CLK	RESET_B#2	3.08396e-18
C419	a_1233_138##7	RESET_B#7	1.96173e-18
C420	a_1745_74##5	a_2003_48##2	2.45357e-17
C421	RESET_B#17	a_1034_74##2	1.3086e-17
C422	a_2339_74##15	VPWR#14	1.21859e-17
C423	VPWR#10	CLK#4	3.23649e-18
C424	a_2003_48#	a_1982_508#	8.26174e-18
C425	RESET_B#15	a_415_81##2	2.51443e-17
C426	a_1745_74##7	a_1745_74#	3.59729e-17
C427	a_1745_74##9	a_2339_74##12	5.06749e-19
C428	a_27_74##4	SCD#3	1.08492e-18
C429	a_1367_112##4	VPWR#8	7.21922e-18
C430	a_2339_74##17	RESET_B#10	7.14379e-20
C431	a_2339_74##17	a_1745_74##7	4.26324e-17
C432	Q#2	a_2339_74##4	3.41636e-17
C433	a_1034_74##6	a_1982_508#	8.06292e-18
C434	a_1034_74##11	a_1233_138##3	1.81217e-18
C435	a_2003_48##2	RESET_B#10	7.17104e-17
C436	a_1233_138##7	a_1367_112##2	6.07029e-17
C437	RESET_B#17	RESET_B#16	7.49438e-18
C438	VGND#4	a_2003_48##4	1.14077e-17
C439	a_27_74##6	SCE#5	1.52175e-17
C440	RESET_B#15	a_855_368##4	6.75416e-18
C441	a_2003_48##5	a_1745_74##4	4.50727e-17
C442	VGND#2	a_2339_74#	4.04295e-18
C443	RESET_B#15	a_1034_74##13	3.87722e-17
C444	a_1367_112##5	RESET_B#7	8.77503e-18
C445	VPWR#14	RESET_B#10	1.70914e-18
C446	a_1034_74##11	a_855_368##7	2.71788e-19
C447	VPWR#13	a_1745_74##9	9.71107e-19
C448	a_415_81#	a_1367_112##2	1.37381e-18
C449	a_2003_48##3	RESET_B#11	1.97961e-17
C450	a_415_81##2	a_1233_138##6	1.18034e-16
C451	a_27_74##6	a_27_74##9	2.12367e-20
C452	a_225_81#	a_572_81#	1.23301e-18
C453	a_27_74##4	D#1	5.3145e-17
C454	a_855_368##9	a_855_368##4	2.58894e-17
C455	a_1745_74##7	VPWR#14	2.12922e-17
C456	RESET_B#15	VPWR#18	1.13163e-18
C457	VGND#2	a_2339_74##9	1.53393e-18
C458	a_2003_48##7	RESET_B#10	4.69874e-18
C459	VGND#4	RESET_B#11	1.88548e-20
C460	a_27_74##4	SCE#1	1.26572e-17
C461	RESET_B#15	a_1034_74##2	7.31278e-18
C462	a_1034_74##11	a_1367_112##2	4.00691e-17
C463	VPWR#11	a_415_81##2	2.50663e-17
C464	a_1034_74##7	a_2003_48##2	4.71631e-19
C465	a_1233_138##7	a_1367_112#	1.72907e-17
C466	a_2003_48##5	VPWR#6	2.84912e-19
C467	Q#6	VPWR#1	6.51737e-17
C468	a_855_368##9	a_855_368##3	2.0597e-17
C469	a_2339_74##17	a_1745_74##9	1.16074e-18
C470	VPWR#11	a_1034_74##2	1.52369e-19
C471	VPWR#15	RESET_B#10	5.99009e-18
C472	a_1745_74##9	a_1745_74##7	2.53421e-17
C473	RESET_B#15	a_855_368##12	7.58823e-17
C474	RESET_B#15	a_855_368##5	2.74019e-19
C475	VPWR#11	a_1034_74##13	3.55014e-18
C476	a_1034_74##4	a_2003_48##2	4.24045e-20
C477	a_1034_74##11	RESET_B#7	1.33119e-17
C478	a_2003_48##7	a_1745_74##7	2.30752e-18
C479	a_2003_48##5	a_2339_74##17	2.26685e-18
C480	a_1233_138##7	a_1034_74##2	1.98675e-18
C481	a_855_368##11	a_1034_74##11	4.44939e-17
C482	a_1367_112##5	RESET_B#6	6.51098e-19
C483	VGND#12	a_1034_74##2	2.13377e-18
C484	a_1233_138##5	RESET_B#16	2.67335e-17
C485	a_1367_112##3	a_1342_463#	1.67e-18
C486	RESET_B#15	CLK#3	6.6327e-18
C487	a_415_81#	a_1034_74##2	5.62153e-17
C488	RESET_B#7	a_1397_138#	6.28475e-18
C489	a_415_81#	a_1367_112#	1.13629e-18
C490	VPWR#11	VPWR#18	1.00019e-17
C491	a_1745_74##9	VPWR#14	2.35206e-17
C492	a_1034_74##11	VGND#16	1.22429e-18
C493	a_1367_112#	a_1397_138#	4.1272e-18
C494	a_2003_48##5	a_1745_74##3	1.30132e-19
C495	VGND#12	a_855_368##5	1.69823e-18
C496	a_1367_112##5	a_1367_112#	2.2079e-19
C497	a_855_368##7	a_1342_463#	6.489e-18
C498	a_1233_138##5	RESET_B#7	1.68284e-19
C499	a_1745_74##13	RESET_B#10	2.73071e-18
C500	a_2339_74##3	a_2339_74##2	2.74612e-18
C501	a_1034_74##11	a_1034_74##2	8.27462e-19
C502	a_1745_74##3	a_2339_74##6	3.75285e-19
C503	SCE#2	D#1	1.61542e-17
C504	a_1233_138##6	a_855_368##3	6.545e-18
C505	VGND#1	VPWR#1	3.01911e-19
C506	RESET_B#15	RESET_B#1	6.61596e-18
C507	a_855_368#	a_2003_48##3	4.22291e-17
C508	a_1233_138##7	a_1034_74#	3.53746e-17
C509	VPWR#11	a_855_368##12	3.62573e-18
C510	VPWR#12	VPWR#1	2.47585e-18
C511	a_2003_48##2	VPWR#15	1.63664e-18
C512	VGND#12	a_1034_74##13	2.49549e-18
C513	VGND#18	a_415_81##5	2.06136e-18
C514	VGND#12	CLK#3	1.82213e-18
C515	a_2003_48##7	a_1745_74##9	1.82386e-17
C516	a_1034_74##4	a_1233_138##2	4.07244e-19
C517	Q#2	a_2339_74#	4.93949e-18
C518	VPWR#11	RESET_B#1	1.49878e-18
C519	Q#2	Q#4	4.72458e-18
C520	a_1233_138##8	VPWR#9	4.49611e-18
C521	RESET_B#9	a_1745_74##9	1.82319e-17
C522	a_1745_74##11	a_1745_74##4	7.58319e-19
C523	VGND#9	a_1034_74##4	1.04475e-16
C524	a_1034_74##11	a_1367_112#	1.74786e-17
C525	a_2003_48##5	VPWR#5	8.0822e-19
C526	VGND#9	a_855_368#	8.83149e-20
C527	a_1367_112##5	a_855_368##2	6.83242e-20
C528	a_2003_48##2	VPWR#6	2.55993e-19
C529	VGND#11	CLK	1.86122e-18
C530	SCD	a_415_81##5	8.72917e-17
C531	a_1745_74#	a_2339_74##6	7.16426e-18
C532	a_27_74##6	a_27_74##4	2.44301e-19
C533	VPWR#14	RESET_B#9	1.5903e-18
C534	VPWR#11	a_855_368##3	2.2525e-18
C535	a_855_368##11	VGND#17	2.3066e-17
C536	a_415_81#	a_1034_74#	7.11979e-18
C537	a_2003_48##5	VPWR#14	1.5559e-17
C538	a_1745_74##13	a_2003_48##2	2.74591e-18
C539	VPWR#11	VPWR#19	1.57949e-17
C540	VPWR#15	a_1745_74##9	7.77723e-19
C541	VGND#12	a_855_368##12	2.81524e-18
C542	a_415_81##2	a_1034_74##13	5.36602e-17
C543	a_1233_138##2	RESET_B#5	1.65026e-17
C544	VGND#12	SCD#2	3.0548e-20
C545	Q#3	Q#1	1.4283e-18
C546	a_1034_74##11	a_855_368##5	4.35234e-18
C547	VPWR#12	Q#6	6.16114e-17
C548	VPWR#11	SCE#7	4.801e-18
C549	a_225_81##2	a_312_81#	1.97049e-18
C550	a_1233_138##7	a_855_368##8	2.21462e-17
C551	a_1745_74##5	a_2003_48##5	5.39888e-17
C552	a_1367_112##4	a_2003_48##2	1.50228e-19
C553	SCD#2	RESET_B#2	4.8328e-17
C554	RESET_B#15	a_27_74##4	4.01029e-18
C555	a_2003_48##7	RESET_B#9	3.1208e-17
C556	a_1233_138##8	VPWR#8	2.50373e-18
C557	a_1367_112##5	a_1034_74#	1.81388e-19
C558	a_1367_112#	a_1319_138#	7.52081e-18
C559	a_1367_112##2	a_1233_138##2	5.1684e-17
C560	a_2003_48##5	a_1745_74##2	1.33233e-18
C561	a_855_368##5	VGND#17	8.83886e-19
C562	VGND#12	SCE#7	6.40224e-18
C563	a_1233_138##6	RESET_B#6	8.51955e-19
C564	a_1034_74#	a_1319_138#	6.89678e-18
C565	SCD#3	a_514_464#	1.81643e-17
C566	a_1034_74##11	a_1034_74#	1.02067e-17
C567	VPWR#11	a_27_74##4	1.19838e-17
C568	a_2003_48#	RESET_B#9	1.15489e-17
C569	VGND#15	VGND#4	1.22064e-20
C570	a_1745_74##11	a_1745_74##5	2.45776e-18
C571	a_1034_74##5	a_855_368#	2.82014e-18
C572	a_2339_74##15	RESET_B#10	5.85791e-20
C573	a_415_81##6	VPWR#11	3.52393e-17
C574	a_27_74##7	D#2	4.39239e-19
C575	a_27_74##3	a_514_464#	1.81643e-17
C576	a_2339_74##4	a_2339_74##6	4.38299e-17
C577	VPWR#11	a_1233_138##6	1.51329e-17
C578	VGND#12	a_27_74##4	3.54675e-20
C579	VPWR#4	a_2339_74##7	1.44662e-19
C580	a_1034_74##7	a_1745_74##13	1.04153e-16
C581	RESET_B#7	a_855_368##3	2.33223e-19
C582	RESET_B#9	VPWR#15	1.35541e-17
C583	a_415_81##2	VPWR#18	1.97132e-17
C584	Q#2	a_2339_74##9	1.85494e-17
C585	a_1034_74##7	VPWR#8	1.24898e-18
C586	a_2339_74##15	Q#4	4.16043e-19
C587	a_415_81#	a_855_368##8	1.86711e-17
C588	a_415_81#	a_1233_138##7	1.00211e-16
C589	VPWR#11	RESET_B#2	6.53857e-19
C590	a_1233_138##5	a_855_368##3	1.32835e-18
C591	VGND#9	a_1233_138##2	2.12538e-20
C592	a_1745_74##13	a_1745_74##9	4.91077e-19
C593	a_1745_74##2	a_2339_74##6	1.87183e-18
C594	a_1367_112##4	a_1034_74##7	5.29267e-17
C595	VGND#12	D#2	4.97302e-18
C596	a_2003_48##7	a_2003_48#	1.47074e-18
C597	Q#3	VGND#6	2.13794e-18
C598	a_1034_74##2	a_1367_112##2	2.02089e-17
C599	VGND#9	a_1034_74##5	4.79623e-18
C600	a_1233_138##7	a_855_368##6	5.91321e-21
C601	a_1233_138##3	a_855_368#	3.05633e-19
C602	VPWR#13	a_2339_74##7	4.31999e-20
C603	a_2003_48##5	a_2003_48##7	3.02999e-18
C604	VGND#12	a_855_368##4	4.70314e-19
C605	D#1	a_340_464#	1.62684e-17
C606	a_2339_74##4	a_2339_74##3	1.11115e-17
C607	VGND#12	a_27_74##2	7.83909e-18
C608	SCE#1	a_340_464#	1.62684e-17
C609	a_1034_74##11	a_855_368##8	8.41624e-18
C610	RESET_B#2	CLK#4	1.40027e-18
C611	a_1034_74##6	a_2003_48#	2.57174e-17
C612	a_2003_48##5	RESET_B#10	1.09237e-17
C613	a_855_368##12	a_415_81##2	3.63903e-18
C614	a_1034_74##4	a_1745_74##13	4.67154e-19
C615	a_855_368##13	CLK#3	3.89719e-18
C616	RESET_B#15	a_415_81##5	3.28663e-17
C617	a_2003_48#	VPWR#15	1.58418e-17
C618	VPWR#11	a_27_74##9	1.7688e-17
C619	VPWR#17	VPWR#8	1.86722e-18
C620	a_415_81##8	a_855_368##5	4.80694e-20
C621	VGND#12	SCE#2	6.90476e-21
C622	a_27_74##7	SCE	9.27331e-18
C623	a_415_81#	a_855_368##6	5.49215e-19
C624	a_1745_74##13	RESET_B#9	6.75733e-19
C625	a_1034_74##11	a_1233_138##7	5.98903e-17
C626	a_1233_138##3	a_1034_74##5	3.22661e-17
C627	VGND#18	CLK#3	3.1883e-18
C628	a_1745_74##11	RESET_B#10	2.31297e-18
C629	a_27_74##6	SCE	8.00161e-17
C630	a_1034_74##4	a_1367_112##4	6.00322e-17
C631	Q#5	VPWR#12	6.62551e-17
C632	a_1233_138##5	a_1233_138#	9.7338e-20
C633	SCE#7	RESET_B#2	1.23963e-19
C634	a_27_74##2	a_27_74##6	3.82993e-19
C635	a_415_81##5	CLK	1.54746e-17
C636	a_1233_138##5	RESET_B#6	9.44243e-18
C637	VPWR#8	a_1034_74##4	4.28371e-19
C638	SCE#7	SCE#3	4.11254e-19
C639	VPWR	a_1745_74##4	9.53144e-19
C640	CLK#3	a_855_368##5	3.69837e-17
C641	VPWR	a_1745_74##3	2.13912e-19
C642	VPWR	a_1745_74##2	1.2953e-22
C643	CLK	a_855_368##11	3.72049e-17
C644	a_855_368##12	a_1034_74##13	1.86498e-17
C645	VGND#5	a_1745_74##6	7.46052e-18
C646	VPWR	a_855_368##3	2.18147e-18
C647	a_1034_74##11	a_855_368##6	5.03103e-17
C648	RESET_B#22	VPWR#6	7.07336e-19
C649	VPWR#15	a_1034_74##6	1.4176e-18
C650	RESET_B#22	RESET_B#10	1.05077e-17
C651	a_1233_138##6	a_1342_463#	1.34913e-18
C652	RESET_B#17	a_1034_74##5	1.26005e-18
C653	a_855_368##2	a_1034_74##6	1.43583e-17
C654	VGND#1	a_2339_74#	3.70625e-17
C655	CLK	RESET_B#13	4.61489e-18
C656	VGND#9	a_1233_138##3	7.35132e-18
C657	a_1745_74##13	a_2003_48#	2.6671e-17
C658	a_415_81##8	CLK#3	9.15042e-19
C659	RESET_B#15	a_855_368##11	5.88684e-18
C660	a_1233_138##6	RESET_B#8	1.14036e-18
C661	a_1367_112##4	a_1233_138##2	2.45326e-17
C662	VGND#5	RESET_B#11	3.67768e-18
C663	a_415_81##8	SCD	1.71059e-17
C664	CLK#3	RESET_B#1	1.04447e-17
C665	VPWR#13	VPWR#12	2.00319e-18
C666	a_1034_74##11	a_415_81#	8.24723e-17
C667	VGND#18	RESET_B#1	2.57255e-18
C668	a_415_81##5	VPWR#11	5.71499e-17
C669	a_2003_48##2	a_2003_48##5	3.17138e-18
C670	VGND#2	VGND#1	2.90891e-17
C671	VGND#12	SCE#3	1.80992e-20
C672	a_415_81##8	a_415_81##5	1.37223e-18
C673	VGND#1	Q#4	3.31174e-17
C674	a_1233_138##2	VPWR#16	6.72906e-18
C675	a_855_368##6	VGND#17	1.27698e-17
C676	a_27_74##6	SCE#2	1.11484e-17
C677	VGND#5	a_2003_48##3	3.7074e-18
C678	a_855_368##12	VPWR#18	1.65197e-18
C679	RESET_B#21	RESET_B#10	1.19177e-17
C680	a_1367_112##4	a_2003_48#	1.61223e-19
C681	RESET_B#7	a_1233_138##3	1.05468e-17
C682	a_1233_138##5	RESET_B#8	1.19374e-17
C683	a_1745_74##11	a_2003_48##2	1.18101e-16
C684	VGND#8	Q#3	6.60461e-17
C685	RESET_B#17	RESET_B#7	1.6868e-18
C686	a_415_81#	a_415_81##2	1.15537e-18
C687	a_1233_138##2	a_1233_138##8	1.30289e-18
C688	a_2339_74#	Q#1	1.18098e-17
C689	VGND#2	Q#1	2.51136e-17
C690	VPWR#15	a_855_368##2	9.10932e-19
C691	a_1034_74##11	CLK#1	2.71861e-18
C692	SCD#1	a_572_81#	8.30758e-18
C693	VGND#5	a_855_368#	4.02421e-18
C694	a_1745_74##13	a_1034_74##6	3.52419e-17
C695	VPWR#3	a_2339_74##8	6.85371e-19
C696	a_1233_138#	a_855_368##2	7.1534e-17
C697	SCE#6	a_572_81#	8.30758e-18
C698	a_1233_138##2	VPWR#8	9.20217e-19
C699	VPWR#16	a_2003_48#	1.74554e-19
C700	a_855_368##13	a_855_368##6	7.97889e-19
C701	VPWR#13	Q#5	8.81662e-17
C702	a_1745_74##4	a_1745_74##7	3.79106e-18
C703	VGND#1	a_2339_74##9	3.4501e-18
C704	a_855_368##4	a_1034_74#	4.38673e-19
C705	a_27_74##4	RESET_B#2	4.05606e-19
C706	SCE#7	SCD#2	4.03688e-17
C707	RESET_B#22	a_2003_48##7	7.60516e-18
C708	a_1745_74##5	a_1745_74##4	2.40344e-17
C709	RESET_B#22	a_2003_48##2	2.69289e-19
C710	a_415_81##5	a_1034_74##13	3.99826e-22
C711	RESET_B#5	VPWR#16	2.47964e-17
C712	a_225_81##2	SCE	8.1028e-18
C713	VPWR#11	a_855_368##11	6.12003e-19
C714	VGND#9	a_1367_112##2	5.0553e-20
C715	a_1233_138##6	a_1367_112##3	2.45082e-17
C716	a_27_74##4	SCE#3	1.61252e-19
C717	a_1367_112##4	a_1034_74##6	4.61616e-19
C718	VGND#17	CLK#1	2.63452e-17
C719	a_225_81#	SCD#2	4.77042e-19
C720	a_27_74##7	D	7.65885e-19
C721	a_27_74##4	SCD#2	2.87558e-17
C722	Q#2	VGND#1	2.13912e-17
C723	VGND#2	Q#3	4.54286e-19
C724	VGND#9	RESET_B#7	2.28179e-18
C725	RESET_B#5	a_1233_138##8	9.3682e-18
C726	a_2339_74##15	a_2339_74##7	9.78561e-18
C727	a_1034_74##13	a_415_81#	9.80666e-18
C728	SCE#7	a_27_74##4	7.03997e-17
C729	D#2	SCD#2	1.94487e-18
C730	VPWR#4	a_2339_74##10	8.74044e-20
C731	a_855_368##2	a_1745_74##13	2.57314e-17
C732	VGND#9	VGND#16	6.07391e-18
C733	a_415_81##2	VPWR#10	1.4934e-17
C734	a_1034_74##11	RESET_B#3	7.87948e-20
C735	a_2339_74##9	Q#1	1.80864e-17
C736	CLK	a_855_368##13	2.97232e-17
C737	a_1233_138##5	a_1367_112##3	2.01242e-18
C738	a_1367_112#	RESET_B#7	4.16022e-17
C739	a_2339_74##4	a_2339_74##7	1.56356e-19
C740	a_2003_48##2	RESET_B#21	1.27195e-17
C741	RESET_B#15	RESET_B#13	1.86532e-17
C742	VGND#18	CLK	5.84313e-18
C743	RESET_B#8	a_1233_138#	3.55596e-18
C744	VPWR#16	a_1034_74##6	4.01541e-19
C745	a_415_81##8	SCD#2	4.71486e-18
C746	a_1034_74##7	a_1745_74##11	4.97581e-17
C747	SCE#7	D#2	5.48237e-17
C748	a_2339_74##17	Q#5	2.28484e-18
C749	VPWR	VPWR#9	7.29285e-17
C750	VPWR	VPWR#8	9.19962e-17
C751	Q#4	a_2339_74##8	2.01516e-17
C752	a_855_368##13	CLK#1	2.30748e-17
C753	VPWR	VPWR#6	6.34375e-17
C754	a_415_81##8	CLK	7.12996e-18
C755	VPWR#19	VPWR#18	4.9698e-19
C756	VPWR	VPWR#5	7.7983e-17
C757	VPWR#4	a_2339_74##6	4.45219e-20
C758	VPWR	VPWR#4	7.469e-17
C759	Q#3	a_2339_74#	2.33883e-19
C760	VGND#17	a_1034_74##11	3.88926e-17
C761	VPWR	VPWR#3	7.60023e-18
C762	a_27_74##4	D#2	5.93472e-19
C763	a_1367_112##4	a_855_368##2	6.54331e-17
C764	D#3	a_312_81#	9.03678e-18
C765	VPWR#3	a_2339_74##10	4.14071e-18
C766	VPWR	a_2339_74##15	4.24273e-18
C767	a_27_74#	a_312_81#	1.01564e-17
C768	a_225_81#	SCE#7	7.89364e-19
C769	VGND#17	RESET_B#3	5.83565e-19
C770	SCD#3	RESET_B#2	6.87344e-19
C771	a_855_368##11	a_415_81##2	8.68521e-19
C772	RESET_B#5	VPWR#8	1.07371e-18
C773	VPWR	a_2003_48##5	5.43164e-18
C774	a_415_81##5	VPWR#18	2.42581e-17
C775	a_1034_74##11	a_1034_74##13	4.21434e-18
C776	VGND#12	a_855_368##11	6.08223e-18
C777	VPWR	a_1745_74##11	6.33291e-19
C778	VGND#11	VGND#10	9.74388e-19
C779	VGND#10	a_1034_74##2	9.51112e-21
C780	a_2339_74##9	VGND#6	2.42347e-17
C781	a_415_81##2	VPWR#9	9.07031e-19
C782	RESET_B#22	VPWR#15	1.20902e-17
C783	a_1745_74##13	a_1233_138#	4.24685e-19
C784	VPWR	RESET_B#22	2.91152e-18
C785	a_1233_138##6	a_855_368##7	2.29203e-17
C786	a_27_74##2	D#2	3.41283e-18
C787	VPWR#17	a_1367_112##2	1.03743e-18
C788	a_27_74##4	SCE#2	1.15206e-17
C789	VGND#18	CLK#1	2.82572e-18
C790	VPWR#16	a_855_368##2	2.71716e-18
C791	VGND#9	a_1034_74##2	5.05235e-20
C792	a_2339_74##16	VGND#8	6.10157e-17
C793	a_2339_74##17	VPWR#13	6.97738e-17
C794	a_1367_112##3	RESET_B#8	1.05009e-17
C795	Q#2	Q#1	3.36179e-18
C796	SCE#2	D#2	1.97761e-17
C797	a_415_81##8	SCE#7	4.1128e-17
C798	Q#1	a_2339_74##13	3.49195e-19
C799	VPWR#10	a_855_368##4	2.11803e-19
C800	VPWR	a_1233_138##6	7.80485e-18
C801	VGND#9	a_1367_112#	2.07941e-18
C802	a_855_368##13	RESET_B#3	3.58626e-18
C803	VPWR	a_1233_138##5	4.29829e-18
C804	VPWR#11	RESET_B#13	2.19319e-18
C805	RESET_B#10	a_1745_74##4	1.56088e-17
C806	a_1367_112##4	a_1233_138#	6.00567e-17
C807	a_27_74##2	SCE#2	3.48686e-17
C808	a_225_81##2	D	1.47762e-17
C809	VPWR#4	a_2339_74##11	3.00302e-19
C810	a_1034_74#	a_1367_112#	4.31792e-17
C811	a_855_368##13	a_1034_74##11	2.77222e-18
C812	SCE#3	D#2	9.4897e-19
C813	VGND	a_2339_74##6	1.02943e-19
C814	VPWR	RESET_B#16	7.30931e-19
C815	a_415_81##8	a_855_368##11	2.6086e-19
C816	a_1233_138##8	a_855_368##2	1.56498e-18
C817	a_1367_112##4	RESET_B#6	8.79207e-19
C818	Q#3	a_2339_74##9	4.62977e-19
C819	VGND	a_1745_74##4	1.6132e-18
C820	a_225_81#	CLK#1	3.87899e-19
C821	a_1034_74##4	a_1745_74##11	8.2409e-17
C822	a_225_81#	a_27_74##4	1.08055e-19
C823	a_225_81##2	SCE#7	1.08078e-18
C824	VGND	RESET_B#6	2.9865e-19
C825	Q#4	a_2339_74##10	1.14422e-17
C826	a_1745_74##13	RESET_B#8	1.44102e-19
C827	RESET_B	VPWR#6	2.1427e-18
C828	a_415_81##2	a_1367_112##2	1.41145e-18
C829	a_1745_74##11	a_1745_74##13	1.74447e-18
C830	a_855_368##8	a_855_368##3	8.16894e-21
C831	CLK	a_855_368##12	2.25719e-17
C832	a_415_81##5	a_340_464#	2.79171e-21
C833	a_1233_138#	VPWR#16	1.88815e-17
C834	a_1745_74##5	RESET_B#11	2.24383e-17
C835	VPWR#9	a_1367_112##2	1.14493e-19
C836	a_2339_74##13	VGND#6	1.20406e-17
C837	a_855_368##11	a_1034_74##13	4.71723e-17
C838	a_27_74##4	a_514_464#	4.28519e-19
C839	RESET_B#3	VGND#18	1.87875e-17
C840	VPWR#3	a_2339_74##11	7.55066e-18
C841	a_415_81##5	a_855_368##12	3.92756e-17
C842	VPWR#17	a_855_368##2	6.33715e-19
C843	VPWR#14	VPWR#13	5.60287e-18
C844	a_1745_74##4	a_1745_74##3	1.86833e-18
C845	a_1034_74##13	a_1367_112##2	3.80524e-21
C846	RESET_B	a_2003_48##5	8.28625e-18
C847	a_855_368##7	a_1367_112##3	4.43126e-17
C848	RESET_B	a_1745_74##11	2.13338e-17
C849	a_1233_138##6	a_1034_74##3	7.47409e-18
C850	VPWR#2	a_2339_74##8	2.3375e-18
C851	RESET_B	RESET_B#22	1.08472e-17
C852	VPWR#3	a_2339_74##6	4.39282e-20
C853	VGND#8	a_2339_74##9	9.94858e-20
C854	RESET_B	RESET_B#21	1.11374e-17
C855	a_855_368##13	SCD#1	1.50081e-19
C856	VPWR#5	a_2339_74##12	6.84294e-19
C857	VGND#10	a_855_368##5	1.47075e-19
C858	a_1233_138##8	a_1233_138#	2.15557e-18
C859	VPWR#6	a_1745_74##4	9.02212e-19
C860	a_855_368##13	VGND#17	3.39944e-17
C861	RESET_B#21	a_1745_74##4	7.4515e-19
C862	VPWR#16	a_855_368##3	1.8735e-19
C863	VGND#12	RESET_B#13	3.31795e-18
C864	a_225_81#	RESET_B#3	2.42821e-17
C865	a_1745_74##5	a_855_368#	2.54822e-19
C866	Q#2	VGND#6	1.0057e-18
C867	a_415_81##2	a_1034_74##2	7.85862e-17
C868	VPWR#2	a_2339_74##10	1.93556e-18
C869	a_1034_74##3	a_1367_112##3	5.59685e-19
C870	Q#3	a_2339_74##13	5.95349e-17
C871	VPWR#10	a_855_368##3	1.82633e-17
C872	a_1233_138##5	a_1034_74##3	4.51304e-20
C873	VPWR#16	RESET_B#8	2.95768e-18
C874	VGND#18	RESET_B#13	6.86062e-18
C875	a_855_368##8	a_1034_74#	3.38377e-17
C876	VPWR#9	VPWR#8	3.21624e-19
C877	VGND#9	a_1034_74#	2.09114e-18
C878	a_415_81##8	CLK#1	1.23673e-18
C879	VPWR#4	a_2339_74##12	7.75711e-18
C880	VPWR#8	a_1034_74##5	1.33518e-19
C881	VPWR#17	a_1233_138#	9.79183e-19
C882	a_1034_74##13	a_1034_74##2	3.79443e-19
C883	VPWR#14	a_2339_74##17	6.67972e-17
C884	VGND	VGND#9	1.28085e-16
C885	a_1745_74##11	a_1233_138##2	9.1171e-20
C886	VGND	VGND#4	1.00842e-16
C887	VPWR#2	a_2339_74##11	4.53297e-19
C888	VGND	VGND#3	6.19019e-17
C889	SCE	a_27_74#	4.00328e-18
C890	VPWR#10	a_1034_74##2	1.35954e-19
C891	D#2	a_415_81##8	1.95989e-17
C892	a_1034_74##3	a_855_368##7	2.54656e-17
C893	Q#4	a_2339_74##11	7.37588e-19
C894	a_2003_48##2	a_1745_74##4	9.34136e-19
C895	a_1233_138##8	RESET_B#8	2.80465e-17
C896	a_415_81##5	a_415_81##7	2.49998e-18
C897	a_2003_48##4	a_2339_74##16	6.07268e-17
C898	SCE#3	a_27_74##2	7.33778e-18
C899	a_2003_48##2	RESET_B#11	1.68462e-17
C900	a_855_368##13	SCE#6	8.68467e-20
C901	CLK	CLK#1	1.18623e-18
C902	VPWR#16	RESET_B#6	6.29469e-18
C903	VPWR#9	a_1034_74##2	4.16605e-19
C904	VGND#8	a_2339_74##13	8.23937e-19
C905	CLK	RESET_B#3	2.00876e-18
C906	a_2003_48##5	a_2339_74##15	4.10294e-17
C907	VGND	a_2339_74##15	7.0515e-18
C908	VPWR#3	a_2339_74##12	5.23024e-19
C909	a_415_81##2	a_855_368##5	4.11572e-19
C910	a_2003_48##5	a_1745_74##8	9.54568e-20
C911	VGND#18	VGND#17	1.99169e-18
C912	VGND	a_2003_48##5	3.42394e-18
C913	VPWR#11	a_27_74##6	4.42899e-18
C914	VGND	a_1745_74##11	8.87714e-18
C915	a_225_81#	SCD#1	2.57457e-17
C916	a_1745_74##13	RESET_B#22	5.86e-18
C917	VPWR	Q#5	1.37286e-17
C918	VGND#11	CLK#3	4.66024e-19
C919	VPWR#16	a_1367_112##3	2.34914e-19
C920	a_225_81##2	D#2	1.26572e-17
C921	a_855_368##11	a_855_368##8	6.24527e-20
C922	VGND	RESET_B#21	2.38552e-18
C923	VPWR	a_2339_74##17	1.50145e-17
C924	VGND#12	a_855_368##6	2.11587e-18
C925	RESET_B	VGND#15	4.76766e-18
C926	VGND#10	a_855_368##8	2.05534e-18
C927	RESET_B#8	VPWR#17	1.81183e-17
C928	VPWR	a_2003_48##7	1.8811e-17
C929	a_1034_74##13	a_855_368##5	5.75158e-18
C930	Q#3	a_2339_74##7	3.96437e-17
C931	RESET_B	a_1745_74##12	6.02036e-19
C932	a_415_81##8	RESET_B#3	1.68868e-17
C933	VGND	a_1367_112##5	1.31694e-17
C934	VPWR	a_1745_74##13	3.27598e-17
C935	RESET_B#16	a_855_368##3	2.67426e-19
C936	VGND#10	CLK#3	1.02312e-19
C937	VPWR	a_1367_112##4	1.30471e-17
C938	a_855_368#	a_2003_48##2	2.40561e-17
C939	a_1745_74##4	a_1745_74##2	1.01396e-17
C940	VPWR	a_1233_138##8	8.49288e-18
C941	VGND#8	a_1745_74#	7.45974e-19
C942	VGND	RESET_B#16	1.18275e-18
C943	VPWR	VPWR#17	1.31069e-17
C944	VGND#12	CLK#1	1.48935e-18
C945	a_855_368##6	a_855_368##8	3.12592e-18
C946	a_1233_138##8	a_1367_112##3	5.61342e-19
C947	a_1367_112##5	a_1367_112##7	2.57299e-18
C948	D	a_27_74#	1.01262e-17
C949	SCD	D#1	2.45987e-19
C950	VPWR#5	a_1745_74##4	7.98314e-20
C951	a_415_81##6	VPWR#19	8.8433e-18
C952	D	SCE#4	1.07015e-18
C953	VPWR#4	a_1745_74#	3.59879e-18
C954	VGND#12	a_27_74##7	1.08685e-18
C955	a_1233_138##8	a_855_368##3	5.14527e-18
C956	a_855_368##13	a_855_368##12	1.08895e-18
C957	VGND#12	RESET_B#3	5.54577e-18
C958	VGND#2	VGND#3	6.9511e-17
C959	VGND#15	VGND#8	1.01301e-18
C960	a_855_368##11	a_855_368##12	9.10757e-19
C961	VPWR#16	a_855_368##7	1.38778e-19
C962	a_415_81##5	a_855_368##4	3.4081e-19
C963	VGND#18	a_855_368##13	2.42689e-17
C964	a_2339_74##7	VGND#8	1.38497e-17
C965	a_415_81##5	VPWR#19	5.92734e-17
C966	VPWR#9	a_855_368##3	4.94091e-17
C967	a_225_81#	SCE#6	1.2464e-17
C968	a_27_74##2	a_225_81##2	1.01953e-17
C969	a_1034_74##13	CLK#3	9.00254e-20
C970	RESET_B	a_2339_74##17	1.55978e-18
C971	VPWR#10	a_855_368##5	1.15454e-19
C972	a_1367_112##3	VPWR#17	1.85752e-17
C973	RESET_B	VPWR#14	2.32116e-18
C974	RESET_B	a_2003_48##7	2.45058e-18
C975	VGND	Q#3	1.93111e-17
C976	RESET_B	VPWR#15	1.29665e-17
C977	VGND	a_2339_74##16	1.25062e-17
C978	SCE	D#1	1.81432e-18
C979	VPWR#12	a_2339_74##6	5.26492e-19
C980	RESET_B#17	a_1745_74##12	1.80108e-18
C981	VGND	a_2003_48##4	2.14948e-17
C982	VPWR	a_2339_74##7	2.4309e-19
C983	RESET_B	a_1745_74##13	3.51805e-17
C984	a_2003_48##7	VPWR#14	4.10663e-17
C985	VGND#12	SCD#1	4.01236e-18
C986	VGND	VGND#15	2.62481e-17
C987	a_27_74##2	VGND#19	3.9147e-17
C988	a_415_81##8	SCD#1	2.11965e-17
C989	VGND	a_1745_74##12	2.38499e-17
C990	a_855_368##11	a_855_368##6	5.41005e-18
C991	Q#3	a_1745_74##8	1.43797e-18
C992	a_1233_138##8	a_855_368##7	1.53856e-19
C993	VGND	a_1233_138##7	3.09891e-18
C994	RESET_B#15	SCD	2.94195e-18
C995	a_1034_74##4	a_2003_48##3	3.9651e-19
C996	CLK#4	a_855_368##9	4.96985e-17
C997	VGND	a_1034_74##11	1.87248e-17
C998	a_1034_74##4	a_1367_112##5	1.62831e-16
C999	VPWR#11	SCD	4.30848e-18
C1000	a_415_81##5	a_1034_74##3	5.97331e-19
C1001	a_855_368##12	CLK#3	3.73948e-18
C1002	VGND#12	SCE#6	3.9774e-18
C1003	Q#3	a_2339_74##15	1.61083e-17
C1004	SCE#3	SCE#2	7.47878e-19
C1005	RESET_B#17	a_1367_112##7	2.58927e-20
C1006	RESET_B#16	RESET_B#6	7.20107e-18
C1007	VGND#12	SCD	4.48055e-18
C1008	VPWR#5	a_1745_74##7	3.58009e-18
C1009	a_2339_74##16	a_2339_74##7	8.48837e-19
C1010	a_1233_138##8	RESET_B#6	6.05083e-18
C1011	VGND#10	a_855_368##6	6.83189e-18
C1012	a_2339_74##6	VNB	6.66382e-17
C1013	a_2339_74##3	VNB	2.59804e-17
C1014	a_1745_74##13	RESET_B#21	2.81643e-18
C1015	a_2339_74##2	VNB	3.68994e-17
C1016	a_1745_74##4	VNB	9.94345e-17
C1017	a_1034_74##4	a_855_368#	3.40078e-17
C1018	VGND#5	a_2003_48##4	1.29166e-17
C1019	a_1745_74##3	VNB	1.79163e-17
C1020	a_1745_74##2	VNB	1.86249e-17
C1021	CLK#1	a_855_368##6	3.63682e-17
C1022	a_855_368##4	VNB	6.81449e-17
C1023	a_855_368##3	VNB	1.77111e-16
C1024	RESET_B#6	VNB	5.12663e-17
C1025	VGND	Q#5	2.64913e-18
C1026	VPWR#17	a_855_368##7	2.80419e-18
C1027	RESET_B#2	VNB	3.63005e-17
C1028	SCE#3	VNB	5.2496e-17
C1029	VGND	VPWR#13	2.58116e-18
C1030	a_415_81##5	RESET_B#3	2.16766e-19
C1031	VPWR#11	SCE	7.44045e-18
C1032	a_1367_112##5	VGND#16	5.88461e-18
C1033	VGND#15	a_2339_74##16	1.7716e-18
C1034	VGND	VPWR#14	5.01433e-18
C1035	RESET_B#17	VGND#16	1.03638e-20
C1036	a_225_81##2	SCE#2	3.14647e-18
C1037	VGND#12	SCE	8.65926e-18
C1038	a_225_81#	D#3	4.86629e-19
C1039	a_1745_74##11	a_1745_74##6	1.51216e-20
C1040	a_415_81##5	a_855_368##11	2.57148e-18
C1041	VGND#8	a_1745_74##8	3.58742e-17
C1042	VGND	a_1367_112##4	3.58346e-18
C1043	a_1034_74##4	a_1034_74##5	2.80652e-17
C1044	VGND	VPWR#16	2.28173e-18
C1045	VPWR	a_2339_74##12	2.29397e-18
C1046	a_415_81##5	a_855_368##3	2.64255e-19
C1047	VPWR#5	a_1745_74##3	6.05566e-20
C1048	D#2	a_312_81#	6.38791e-19
C1049	VGND#19	SCE#2	8.84604e-19
C1050	VPWR	a_1745_74#	7.76122e-18
C1051	CLK	RESET_B#15	2.52954e-17
C1052	a_415_81##8	SCE#6	3.01903e-17
C1053	VPWR	a_1745_74##7	8.63692e-18
C1054	VPWR#11	CLK	8.35173e-19
C1055	VPWR	a_1745_74##9	1.62462e-18
C1056	VPWR	RESET_B#9	3.33378e-18
C1057	VGND#12	CLK	7.88113e-18
C1058	a_855_368##12	RESET_B#1	3.98304e-18
C1059	RESET_B#4	CLK#4	4.61647e-18
C1060	a_1034_74##4	a_1233_138##3	2.39881e-17
C1061	Q#4	a_1745_74#	2.12346e-19
C1062	VGND#3	Q#2	3.75672e-17
C1063	VGND#11	VNB	2.68666e-17
C1064	VPWR	a_855_368##2	1.09875e-17
C1065	VPWR#9	RESET_B#6	2.63616e-19
C1066	VGND#10	VNB	5.89133e-17
C1067	VGND#9	VNB	8.83598e-17
C1068	a_1233_138##2	a_855_368#	6.29751e-19
C1069	VPWR	a_1233_138#	3.81587e-18
C1070	a_225_81##2	SCD#1	2.03002e-19
C1071	VGND#4	VNB	4.30687e-17
C1072	a_415_81##2	a_1367_112##3	5.7035e-19
C1073	VGND#3	VNB	4.43854e-17
C1074	Q#4	a_2339_74##6	1.82684e-18
C1075	VPWR	RESET_B#8	2.20878e-18
C1076	VGND#4	a_2339_74##15	9.58555e-19
C1077	a_855_368##11	CLK#1	8.19292e-18
C1078	VPWR#10	VNB	6.34563e-17
C1079	VPWR	a_1367_112##3	3.33649e-18
C1080	VPWR#6	a_1745_74##9	4.85808e-19
C1081	VPWR#9	VNB	4.55288e-17
C1082	VGND#11	CLK#1	1.01744e-18
C1083	VPWR#8	VNB	3.48062e-17
C1084	VPWR#6	VNB	2.873e-17
C1085	VGND#12	SCE#4	1.59941e-18
C1086	VPWR#5	VNB	3.59758e-17
C1087	VGND	a_2339_74##7	1.75828e-18
C1088	VPWR#4	VNB	3.04198e-17
C1089	VPWR#3	VNB	2.20574e-17
C1090	VGND	a_1745_74##8	1.809e-18
C1091	SCD	SCD#2	3.31859e-17
C1092	VPWR#17	a_855_368##3	2.42698e-17
C1093	Q#4	VNB	3.60166e-17
C1094	VGND	a_1745_74##6	9.31805e-19
C1095	VGND#12	D	4.54638e-18
C1096	Q#2	VNB	2.05033e-18
C1097	RESET_B#17	VGND#9	1.36296e-18
C1098	a_2003_48##5	RESET_B#11	1.78058e-19
C1099	a_2339_74##15	VNB	6.56716e-18
C1100	VGND	RESET_B#11	2.09153e-19
C1101	VPWR#17	a_1034_74##3	6.98625e-19
C1102	a_1034_74##4	RESET_B#7	2.16467e-18
C1103	VGND	a_2003_48##3	4.11156e-19
C1104	SCE#7	SCD	2.31263e-17
C1105	a_2003_48##5	VNB	1.77959e-17
C1106	a_1745_74##11	VNB	1.58714e-17
C1107	VGND	a_855_368#	1.41766e-19
C1108	a_1745_74##8	a_2339_74##16	1.31017e-17
C1109	RESET_B#22	VNB	3.97064e-18
C1110	VGND	a_1034_74##5	1.49149e-18
C1111	a_415_81##5	a_855_368##9	1.18027e-18
C1112	a_27_74##7	SCE#3	2.44445e-17
C1113	a_1367_112##5	a_1233_138##2	8.12729e-17
C1114	RESET_B#21	VNB	2.73471e-18
C1115	VGND	a_1233_138##3	1.44124e-18
C1116	a_27_74##4	SCD	2.74847e-17
C1117	RESET_B	a_1745_74##9	7.11991e-21
C1118	VPWR#8	a_855_368##3	3.35775e-18
C1119	a_855_368##7	a_1233_138##9	9.74637e-18
C1120	VGND	RESET_B#7	4.39179e-18
C1121	a_2339_74##7	a_1745_74#	1.11012e-17
C1122	RESET_B	a_2003_48#	6.73187e-19
C1123	SCD	D#2	5.10575e-19
C1124	a_225_81#	VGND#18	4.24272e-17
C1125	a_1367_112##5	VNB	1.1083e-18
C1126	a_1233_138##6	VNB	5.29326e-18
C1127	SCE	SCD#2	4.88797e-19
C1128	a_27_74##7	a_27_74##6	5.06307e-18
C1129	RESET_B	a_855_368##2	1.30135e-18
C1130	a_225_81#	a_27_74#	2.72527e-19
C1131	VPWR#15	a_2003_48##7	3.46966e-17
C1132	VGND#8	a_2339_74##15	3.52983e-17
C1133	RESET_B#16	VNB	2.24861e-18
C1134	CLK	a_855_368##5	4.19069e-18
C1135	VGND#15	a_2003_48##4	1.20669e-17
C1136	VPWR#12	a_2339_74##3	2.78096e-19
C1137	a_415_81##5	VNB	8.38157e-18
C1138	SCD	SCE#2	4.49831e-19
C1139	a_855_368##11	VNB	4.25307e-18
C1140	Q#5	a_2339_74##6	4.29005e-18
C1141	CLK	CLK#3	3.40336e-17
C1142	SCE	a_27_74##4	4.20706e-17
C1143	VGND#10	a_1034_74##11	5.47373e-17
C1144	RESET_B#3	CLK#1	5.59041e-18
C1145	RESET_B#13	VNB	2.98396e-18
C1146	VPWR#5	a_1745_74##9	1.43848e-17
C1147	RESET_B#17	a_1233_138##7	4.20447e-18
C1148	CLK	RESET_B#1	3.44039e-18
C1149	SCE	D#2	3.25045e-17
C1150	VGND#8	a_1745_74##6	3.78557e-19
C1151	a_27_74##7	VNB	3.8338e-17
C1152	RESET_B#17	VPWR	5.73519e-17
C1153	D#3	a_415_81##8	1.46203e-17
C1154	a_27_74##6	VNB	4.08778e-17
C1155	a_27_74##2	SCE	4.949e-17
C1156	VGND#10	CLK#1	5.79322e-18
C1157	VPWR	VPWR#7	6.49573e-17
C1158	VGND#1	VNB	4.20882e-17
C1159	SCE	SCE#2	4.96639e-17
C1160	Q#1	VNB	4.78176e-18
C1161	VGND#5	a_1745_74##12	2.38356e-17
C1162	Q#3	VNB	1.95367e-18
C1163	SCD#3	RESET_B#4	1.75817e-17
C1164	VGND#8	VNB	5.06487e-19
C1165	a_415_81##2	a_855_368##7	3.33316e-18
C1166	a_2339_74##16	VNB	4.37931e-18
C1167	a_2003_48##4	VNB	9.67058e-18
C1168	VGND#15	VNB	1.07701e-18
C1169	a_1233_138##2	RESET_B#7	2.51368e-17
C1170	a_1745_74##11	RESET_B#11	1.53967e-19
C1171	VPWR	a_2339_74##4	4.94504e-18
C1172	VPWR#2	VPWR#3	5.22909e-17
C1173	a_225_81##2	SCE#6	5.29417e-19
C1174	a_1367_112##4	a_1034_74##5	1.22831e-18
C1175	a_2003_48##4	a_1745_74##8	1.44296e-18
C1176	a_415_81#	VNB	2.35552e-18
C1177	VPWR#18	a_1367_112##3	2.21723e-19
C1178	a_415_81##6	a_415_81##5	1.789e-18
C1179	a_1034_74##11	VNB	4.13477e-17
C1180	VGND	a_1233_138#	1.63593e-19
C1181	RESET_B#17	a_415_81#	3.28572e-18
C1182	VGND#17	VNB	2.02941e-18
C1183	VPWR	RESET_B#10	2.841e-19
C1184	a_855_368##13	VNB	3.04723e-18
C1185	VGND#18	VNB	6.59128e-18
C1186	a_2339_74##15	a_1745_74#	7.435e-18
C1187	VPWR#17	a_855_368##9	8.55335e-19
C1188	a_225_81#	VNB	9.40125e-18
C1189	VPWR	a_2003_48##2	3.17258e-19
C1190	a_415_81##8	VNB	8.13468e-18
C1191	VPWR	a_1034_74##7	5.20247e-18
C1192	a_225_81##2	VNB	1.32481e-17
C1193	RESET_B	VPWR#7	4.5116e-18
C1194	D	D#2	5.68155e-18
C1195	VGND#19	VNB	5.46306e-18
C1196	VPWR#5	a_1745_74##2	5.91158e-20
C1197	a_27_74##8	VNB	2.32637e-17
C1198	VPWR#1	VNB	4.53048e-17
C1199	VPWR#4	a_1745_74##9	1.57869e-19
C1200	Q#6	VNB	4.85555e-18
C1201	a_27_74##2	D	1.73828e-17
C1202	a_1034_74##3	a_1233_138##9	3.04948e-18
C1203	SCD#2	VPWR#19	9.23754e-19
C1204	VPWR#12	VNB	4.09278e-19
C1205	VPWR	a_1233_138##2	3.45104e-18
C1206	Q#5	VNB	2.67145e-18
C1207	VPWR#13	VNB	8.66537e-18
C1208	a_2339_74##17	VNB	3.62806e-18
C1209	VPWR	RESET_B#5	1.73606e-18
C1210	D	SCE#2	5.41466e-18
C1211	VPWR#14	VNB	1.01552e-17
C1212	a_2003_48##7	VNB	1.38396e-17
C1213	VPWR#15	VNB	7.20336e-18
C1214	VPWR	a_1367_112##2	2.12567e-18
C1215	a_855_368##11	RESET_B#3	1.00363e-19
C1216	a_1745_74##13	VNB	1.05423e-18
C1217	a_1367_112##4	VNB	4.81874e-18
C1218	VPWR#16	VNB	5.1549e-18
C1219	RESET_B	a_1745_74##5	4.61611e-18
C1220	a_1233_138##8	VNB	5.10189e-18
C1221	VPWR#17	VNB	7.44536e-18
C1222	RESET_B	RESET_B#10	6.60475e-18
C1223	a_1745_74##3	a_2339_74##7	1.15729e-17
C1224	a_2339_74##16	a_1745_74##6	1.32263e-18
C1225	a_415_81##2	VNB	1.05075e-17
C1226	RESET_B	a_2003_48##2	1.32334e-17
C1227	a_1034_74##13	VNB	2.39069e-19
C1228	RESET_B#17	a_1034_74##11	5.49177e-18
C1229	a_415_81##8	a_855_368##13	9.21246e-18
C1230	VPWR#18	VNB	2.12432e-19
C1231	RESET_B	a_1034_74##7	3.75687e-17
C1232	a_855_368##12	VNB	5.8692e-19
C1233	VPWR#19	VNB	1.02607e-18
C1234	a_415_81##6	VNB	2.07875e-18
C1235	VPWR#10	RESET_B#1	3.15821e-19
C1236	a_27_74##9	VNB	3.03174e-17
C1237	VGND	VGND#5	1.46722e-16
C1238	a_2339_74#	VNB	2.6579e-17
C1239	VPWR#6	RESET_B#9	9.70527e-18
C1240	a_2339_74##9	VNB	2.40396e-17
C1241	a_415_81##5	CLK#4	3.03975e-17
C1242	a_2339_74##13	VNB	2.62005e-17
C1243	VGND#19	SCE#6	2.45176e-19
C1244	VPWR#7	a_2003_48#	4.48674e-18
C1245	a_2339_74##7	VNB	3.87502e-17
C1246	VGND#9	a_1034_74##11	7.80025e-17
C1247	a_1745_74##8	VNB	2.56932e-17
C1248	a_1745_74##6	VNB	2.30722e-17
C1249	RESET_B#11	VNB	3.61044e-17
C1250	VGND#11	RESET_B#3	7.60338e-19
C1251	a_2003_48##3	VNB	2.46857e-17
C1252	VGND	a_2339_74##4	4.38141e-18
C1253	a_855_368#	VNB	4.38631e-17
C1254	a_415_81##2	a_1034_74##3	3.75877e-17
C1255	a_1367_112##2	a_1034_74##5	4.12057e-19
C1256	a_1034_74##5	VNB	3.62854e-17
C1257	VGND	a_1745_74##5	9.98274e-18
C1258	a_415_81##8	a_27_74#	1.88397e-18
C1259	a_1233_138##3	VNB	3.51915e-17
C1260	RESET_B#7	VNB	3.91872e-17
C1261	a_1367_112#	VNB	2.68701e-17
C1262	VPWR#3	a_1745_74##9	1.17446e-20
C1263	a_1034_74#	VNB	3.10824e-17
C1264	VGND	a_2003_48##2	4.97349e-18
C1265	a_855_368##11	a_855_368##9	1.45177e-18
C1266	a_27_74##3	SCD#3	2.00125e-17
C1267	a_855_368##8	VNB	3.30359e-17
C1268	a_855_368##6	VNB	2.96647e-17
C1269	VGND#8	RESET_B#11	1.03535e-19
C1270	CLK#1	VNB	2.96371e-17
C1271	RESET_B#3	VNB	4.25338e-17
C1272	VGND	a_1034_74##4	4.91097e-17
C1273	Q#4	VPWR#2	6.27076e-18
C1274	SCD#1	VNB	2.67959e-17
C1275	SCE#6	VNB	2.20719e-17
C1276	VPWR#8	RESET_B#6	1.33194e-18
C1277	VGND	a_1233_138##2	9.27567e-18
C1278	VPWR#18	a_855_368##7	6.21474e-19
C1279	D#3	VNB	1.97635e-17
C1280	a_27_74#	VNB	4.26967e-17
C1281	VGND	RESET_B#5	1.31496e-18
C1282	RESET_B#17	a_855_368##2	4.80501e-18
C1283	a_2339_74##3	Q#1	2.55177e-19
C1284	SCE#4	VNB	4.48686e-17
C1285	SCD#1	RESET_B#3	3.58658e-17
C1286	VGND	a_1367_112##2	5.57503e-18
C1287	a_2339_74##8	VNB	4.14778e-17
C1288	a_2339_74##10	VNB	2.84204e-17
C1289	a_2339_74##11	VNB	3.56372e-17
C1290	a_2339_74##12	VNB	3.50062e-17
C1291	VPWR#2	a_2339_74##3	4.00697e-20
C1292	a_225_81##2	D#3	1.51798e-17
C1293	a_1745_74#	VNB	4.41255e-17
C1294	a_1745_74##7	VNB	3.24938e-17
C1295	Q#2	a_2339_74##6	4.38099e-18
C1296	a_1745_74##9	VNB	6.9855e-17
C1297	a_1367_112##2	a_1233_138##3	2.81946e-19
C1298	VPWR#7	a_1034_74##6	6.4437e-18
C1299	RESET_B#9	VNB	3.49501e-17
C1300	a_2003_48#	VNB	4.36099e-17
C1301	a_1034_74##6	VNB	2.66104e-17
C1302	a_855_368##2	VNB	1.36974e-16
C1303	a_1233_138#	VNB	4.1233e-17
C1304	RESET_B#8	VNB	2.60436e-17
C1305	a_1367_112##3	VNB	2.60506e-17
C1306	a_855_368##7	VNB	2.70512e-17
C1307	a_1034_74##3	VNB	2.23232e-17
C1308	VPWR#5	RESET_B#9	9.90034e-19
C1309	a_2003_48##4	a_1745_74##6	3.582e-17
C1310	a_855_368##9	VNB	3.52405e-17
C1311	CLK#4	VNB	4.8883e-17
C1312	RESET_B#4	VNB	3.01429e-17
C1313	SCD#3	VNB	2.47075e-17
C1314	a_1034_74##13	a_1034_74##3	2.80482e-19
C1315	a_27_74##6	SCE#3	2.57617e-17
C1316	a_27_74##3	VNB	2.20763e-17
C1317	D#1	VNB	4.31381e-17
C1318	a_1233_138##2	RESET_B#16	8.55366e-18
C1319	SCE#1	VNB	2.99344e-17
C1320	SCE#5	VNB	4.79806e-17
C1321	VPWR#2	VNB	1.28725e-16
C1322	RESET_B	a_1955_74#	2.39404e-19
C1323	RESET_B#17	a_1233_138#	3.79553e-18
C1324	VGND#2	VNB	1.2666e-16
C1325	a_1367_112##2	RESET_B#7	3.12675e-17
C1326	RESET_B#17	VNB	9.48656e-18
C1327	a_1745_74##13	a_2003_48##7	5.29045e-18
C1328	VPWR#7	VNB	3.27925e-17
C1329	D	a_312_81#	1.20834e-18
C1330	VGND#5	VNB	7.88592e-17
C1331	SCE	SCD	1.7874e-18
C1332	a_1745_74##11	a_2003_48##3	1.13967e-17
C1333	RESET_B#15	VNB	9.14181e-18
C1334	VPWR#11	VNB	3.43293e-16
C1335	VGND#9	a_1233_138#	1.17892e-20
C1336	VGND#12	VNB	3.78445e-16
C1337	VPWR#2	a_2339_74##2	4.83804e-20
C1338	a_2339_74##4	VNB	3.54555e-18
C1339	VPWR#7	a_855_368##2	1.10633e-19
C1340	a_1745_74##5	VNB	5.54839e-18
C1341	RESET_B#10	VNB	8.5777e-17
C1342	a_2003_48##2	VNB	6.68909e-17
C1343	a_1034_74##7	VNB	2.98939e-17
C1344	a_1034_74##4	VNB	3.72166e-17
C1345	a_1233_138##2	VNB	2.95827e-17
C1346	VGND#15	a_1745_74##8	6.3621e-19
C1347	RESET_B#5	VNB	1.74497e-18
C1348	a_1367_112##2	VNB	5.93202e-17
C1349	a_1034_74##2	VNB	5.49128e-17
C1350	a_2339_74##16	RESET_B#11	1.4298e-19
C1351	VPWR#13	a_2339_74##6	3.11343e-18
C1352	a_855_368##5	VNB	3.13862e-17
C1353	SCE#7	a_415_81##6	4.24084e-18
C1354	VPWR#8	a_2003_48#	2.81267e-19
C1355	a_415_81##2	a_855_368##9	2.63851e-17
C1356	CLK#3	VNB	6.47616e-17
C1357	D	SCE	2.38129e-17
C1358	RESET_B#1	VNB	2.97164e-17
C1359	a_1034_74##4	RESET_B#6	4.14712e-19
C1360	a_1745_74##4	a_1745_74##8	7.80084e-18
C1361	VPWR#3	VPWR#1	1.67288e-18
C1362	SCD#2	VNB	5.45335e-17
C1363	SCE#7	VNB	5.71777e-17
C1364	VGND#19	D#3	4.24612e-19
C1365	a_27_74##4	VNB	3.66802e-17
C1366	a_1367_112##2	a_1367_112#	5.89264e-18
C1367	D#2	VNB	5.91777e-17
C1368	a_27_74##2	VNB	3.30171e-17
C1369	VPWR#6	VPWR#5	5.69747e-19
C1370	SCE#2	VNB	1.0048e-16
C1371	Q#3	a_2339_74##4	6.87907e-17
C1372	VPWR#18	a_1034_74##3	1.16712e-18
C1373	D#1	a_27_74##3	2.79483e-17
C1374	VGND#11	a_855_368##13	2.03671e-18
C1375	a_415_81##8	SCE#4	5.62763e-19
C1376	a_1745_74##12	a_2003_48##4	2.33413e-18
C1377	a_415_81##5	RESET_B#4	3.60511e-17
C1378	RESET_B	VPWR	3.89977e-17
C1379	a_1034_74#	a_1367_112##2	4.9169e-18
C1380	VGND#5	a_855_368##2	5.39196e-20
C1381	VPWR#10	a_855_368##8	6.00983e-21
C1382	a_225_81##2	a_27_74#	3.69365e-17
C1383	SCD	VNB	3.26036e-18
C1384	VPWR#2	VPWR#1	2.7274e-17
C1385	Q#4	a_2339_74##3	1.57194e-17
C1386	SCE	VNB	1.5799e-17
C1387	CLK	VNB	1.30593e-17
C1388	D	VNB	1.86905e-18
C1389	a_1745_74##11	a_2003_48##5	4.34798e-18
C1390	RESET_B#17	VPWR#10	3.40763e-19
C1391	a_1367_112##2	a_1367_112##5	1.29272e-18
C1392	a_1034_74##13	a_855_368##9	3.44755e-17
C1393	VPWR	VNB	2.41096e-16
C1394	a_855_368##11	CLK#4	2.54743e-18
C1395	a_2339_74##2	Q#1	5.17645e-19
C1396	RESET_B	VNB	9.44472e-18
C1397	VGND	VNB	2.52074e-16
C1398	a_2003_48##5	a_855_368#	7.76849e-21
C1399	VPWR#4	a_1745_74##2	1.78422e-20
C1400	VPWR#6	a_2003_48#	4.5058e-18
C1401	VGND#13	SCE#4	1.23127e-18
C1402	VGND#13	a_225_81##2	7.319e-17
C1403	a_27_74##6	VPWR#20	7.76887e-17
C1404	a_27_74##9	VPWR#20	7.95979e-17
C1405	VGND#13	SCE#2	3.93973e-20
C1406	VGND#12	VGND#13	1.25616e-16
C1407	VPWR#20	a_27_74##3	2.8821e-19
C1408	a_27_74##4	VPWR#20	2.3609e-17
C1409	VPWR#20	SCE#1	3.71269e-17
C1410	VGND#13	a_27_74##8	1.76179e-17
C1411	VPWR#20	VPWR#19	5.35012e-19
C1412	VPWR#20	a_415_81##6	3.55289e-17
C1413	VGND#13	VNB	7.63081e-17
C1414	VPWR#11	VPWR#20	2.14071e-16
C1415	VPWR#20	VPWR#21	2.66087e-17
C1416	VGND#13	D#3	4.02115e-18
C1417	VGND#13	a_27_74##7	3.31947e-19
C1418	VGND#13	D#2	2.39643e-19
C1419	VGND#13	a_27_74#	3.88562e-18
C1420	VPWR#20	SCD#3	1.62609e-19
C1421	VPWR#20	D#1	1.23323e-17
C1422	VPWR#20	D#2	3.95581e-19
C1423	VPWR#20	SCE#5	2.30992e-17
C1424	VPWR#20	SCE#2	4.91811e-18
C1425	VPWR#20	VNB	8.84523e-17
C1426	VGND#13	a_27_74##2	2.78787e-18
*
*
.ENDS sky130_fd_sc_hs__sdfrtp_4
*
