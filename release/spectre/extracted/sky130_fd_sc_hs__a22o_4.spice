* Extracted by Quantus, converted by sky130cad/quantus.py
*
*
*
*                       LINUX           Wed Nov 18 08:09:15 2026
*
*
*
*  PROGRAM  advgen
*
*  Name           : advgen - Quantus - (64-bit)
*  Version        : 25.1.0-p047
*  Build Date     : Thu Dec 11 23:20:30 PST 2025
*
*  HSPICE LIBRARY
*
*  OPERATING_TEMPERATURE 150
*  QRC_TECH_DIR <path>/tech
*
*
*

*
.SUBCKT sky130_fd_sc_hs__a22o_4 VPB VNB VGND VPWR X A2 B2 B1 A1
*
*
*  caps2d version: 10
*
*
*       TRANSISTOR CARDS
*
*
XM11 VGND#12 a_95_306##10 X#3 VNB sky130_fd_pr__nfet_01v8_lvt l=0.15 w=0.74 ad=0.1961 as=0.2072 pd=2.01 ps=2.04
XM15 VGND#11 a_95_306##6 X#3 VNB sky130_fd_pr__nfet_01v8_lvt l=0.15 w=0.74 ad=0.2072 as=0.2072 pd=2.04 ps=2.04
XM17 X#1 a_95_306##3 VGND#11 VNB sky130_fd_pr__nfet_01v8_lvt l=0.15 w=0.74 ad=0.2072 as=0.2072 pd=2.04 ps=2.04
XM21 X#1 a_95_306# VGND#10 VNB sky130_fd_pr__nfet_01v8_lvt l=0.15 w=0.74 ad=0.2072 as=0.2537 pd=2.04 ps=2.19
XM13 VGND#10 B2#1 a_645_120##2 VNB sky130_fd_pr__nfet_01v8_lvt l=0.15 w=0.64 ad=0.2537 as=0.1792 pd=2.19 ps=1.84
XM5 a_95_306##20 B1#5 a_645_120##2 VNB sky130_fd_pr__nfet_01v8_lvt l=0.15 w=0.64 ad=0.1792 as=0.1792 pd=1.84 ps=1.84
XM20 a_645_120# B1#4 a_95_306##20 VNB sky130_fd_pr__nfet_01v8_lvt l=0.15 w=0.64 ad=0.210625 as=0.1792 pd=1.96 ps=1.84
XM18 a_645_120# B2#4 VGND#9 VNB sky130_fd_pr__nfet_01v8_lvt l=0.15 w=0.64 ad=0.210625 as=0.3904 pd=1.96 ps=2.5
XM2 a_1064_123##2 A2#4 VGND#9 VNB sky130_fd_pr__nfet_01v8_lvt l=0.15 w=0.64 ad=0.1792 as=0.3904 pd=1.84 ps=2.5
XM7 a_1064_123##2 A1#5 a_95_306##22 VNB sky130_fd_pr__nfet_01v8_lvt l=0.15 w=0.64 ad=0.1792 as=0.1792 pd=1.84 ps=1.84
XM8 a_95_306##22 A1#1 a_1064_123# VNB sky130_fd_pr__nfet_01v8_lvt l=0.15 w=0.64 ad=0.1792 as=0.1792 pd=1.84 ps=1.84
XM1 VGND#1 A2#2 a_1064_123# VNB sky130_fd_pr__nfet_01v8_lvt l=0.15 w=0.64 ad=0.1696 as=0.1792 pd=1.81 ps=1.84
XM0 X#5 a_95_306##13 VPWR#7 VPB sky130_fd_pr__pfet_01v8 l=0.15 w=1.12 ad=0.336 as=0.308 pd=2.84 ps=2.79
XM12 VPWR#11 a_95_306##14 X#5 VPB sky130_fd_pr__pfet_01v8 l=0.15 w=1.12 ad=0.336 as=0.336 pd=2.84 ps=2.84
XM22 X#4 a_95_306##11 VPWR#11 VPB sky130_fd_pr__pfet_01v8 l=0.15 w=1.12 ad=0.336 as=0.336 pd=2.84 ps=2.84
XM6 VPWR#10 a_95_306##7 X#4 VPB sky130_fd_pr__pfet_01v8 l=0.15 w=1.12 ad=0.308 as=0.336 pd=2.79 ps=2.84
XM3 a_555_392##7 B2#3 a_95_306##19 VPB sky130_fd_pr__pfet_01v8 l=0.15 w=1 ad=0.275 as=0.3 pd=2.55 ps=2.6
XM14 a_95_306##19 B1#6 a_555_392##5 VPB sky130_fd_pr__pfet_01v8 l=0.15 w=1 ad=0.3 as=0.3 pd=2.6 ps=2.6
XM19 a_555_392##5 B1#1 a_95_306##17 VPB sky130_fd_pr__pfet_01v8 l=0.15 w=1 ad=0.3 as=0.3 pd=2.6 ps=2.6
XM4 a_95_306##17 B2#6 a_555_392##3 VPB sky130_fd_pr__pfet_01v8 l=0.15 w=1 ad=0.3 as=0.33 pd=2.6 ps=2.66
XM23 VPWR#9 A2#5 a_555_392##3 VPB sky130_fd_pr__pfet_01v8 l=0.15 w=1 ad=0.515 as=0.33 pd=3.03 ps=2.66
XM10 a_555_392##9 A1#6 VPWR#9 VPB sky130_fd_pr__pfet_01v8 l=0.15 w=1 ad=0.3 as=0.515 pd=2.6 ps=3.03
XM9 VPWR#8 A1#4 a_555_392##9 VPB sky130_fd_pr__pfet_01v8 l=0.15 w=1 ad=0.3 as=0.3 pd=2.6 ps=2.6
XM16 a_555_392# A2#1 VPWR#8 VPB sky130_fd_pr__pfet_01v8 l=0.15 w=1 ad=0.275 as=0.3 pd=2.55 ps=2.6
*
*
*       RESISTOR AND CAP/DIODE CARDS
*
Rg1	a_95_306#	a_95_306##2	354.846252
Rg2	a_95_306##2	a_95_306##3	302.425262
Rg3	a_95_306##2	a_95_306##4	72.757149
Rg4	a_95_306##4	a_95_306##5	24.841085
Rg5	a_95_306##5	a_95_306##6	301.922638
Rg6	a_95_306##4	a_95_306##7	419.554810
Rg7	a_95_306##5	a_95_306##8	154.435837
Rg8	a_95_306##8	a_95_306##9	45.748947
Rg9	a_95_306##9	a_95_306##10	409.464813
Rg10	a_95_306##8	a_95_306##11	405.599640
Rg11	a_95_306##9	a_95_306##12	146.174789
Rg12	a_95_306##12	a_95_306##13	617.296082
Rg13	a_95_306##12	a_95_306##14	405.599640
Rg14	B2#1	B2#2	340.441467
Rg15	B2#2	B2#3	423.931366
Rg16	B1#1	B1#2	430.768829
Rg17	B1#2	B1#3	54.221630
Rg18	B1#2	B1#4	343.038849
Rg19	B1#3	B1#5	346.629730
Rg20	B1#3	B1#6	432.716705
Rg21	B2#4	B2#5	334.702850
Rg22	B2#5	B2#6	421.710602
Rg23	A1#1	A1#2	341.315308
Rg24	A1#2	A1#3	56.190357
Rg25	A1#2	A1#4	423.573059
Rg26	A1#3	A1#5	345.741425
Rg27	A1#3	A1#6	420.399719
Rg28	A2#1	A2#2	803.013733
Rg29	A2#2	A2#3	1088.625854
Rg30	A2#3	A2#4	273.732178
Rg31	A2#4	A2#5	868.952209
Rf1	X#1	X#2	68.309280
Rf2	X#2	X	24.467714
Rf3	X#2	X#3	25.490992
Rf4	X#2	X#4	46.284489
Rf5	X	X#5	69.296616
Rf6	B1#7	B1#3	161.413818
Rf7	B1	B1#9	1.181018
Rf8	B1#7	B1#9	2.558873
Rf9	a_645_120#	a_645_120##2	74.216721
Rf10	B2#5	B2	200.352631
Rf11	B2	B2#2	205.913315
Rf12	A2#3	A2	172.227692
Rf13	a_95_306##2	a_95_306##16	88.859650
Rf14	a_95_306##16	a_95_306##18	157.809158
Rf15	a_95_306##18	a_95_306##19	15.000000
Rf16	a_95_306##16	a_95_306##21	93.346375
Rf17	a_95_306##21	a_95_306##22	161.616608
Rf18	a_95_306##17	a_95_306##18	15.000000
Rf19	a_95_306##20	a_95_306##21	15.000000
Rf20	A1	A1#7	12.007017
Rf21	A1#7	A1	6.889272
Rf22	a_1064_123#	a_1064_123##2	93.820694
Rf23	a_555_392#	a_555_392##2	92.659187
Rf24	a_555_392##2	a_555_392##4	94.714684
Rf25	a_555_392##4	a_555_392##6	69.347542
Rf26	a_555_392##6	a_555_392##8	66.810341
Rf27	a_555_392##2	a_555_392##9	22.678455
Rf28	a_555_392##3	a_555_392##4	5.000000
Rf29	a_555_392##5	a_555_392##6	15.000000
Rf30	a_555_392##7	a_555_392##8	7.500000
Rf31	VGND#1	VGND#2	42.850208
Rf32	VGND#2	VGND#3	170.788345
Rf33	VGND#3	VGND#4	94.998459
Rf34	VGND#4	VGND#5	36.500717
Rf35	VGND#5	VGND#6	65.753731
Rf36	VGND#6	VGND#7	62.889057
Rf38	VGND#3	VGND#9	49.562149
Rf39	VGND#5	VGND#10	41.199932
Rf40	VGND#6	VGND#11	44.445877
Rf41	VGND#7	VGND#12	51.864471
Rf42	VPWR#1	VPWR#2	48.554047
Rf43	VPWR#2	VPWR#3	74.604385
Rf44	VPWR#3	VPWR#4	139.643860
Rf45	VPWR#4	VPWR#5	86.232399
Rf46	VPWR#5	VPWR#6	71.655113
Rf47	VPWR#6	VPWR#7	99.609695
Rf48	VPWR#2	VPWR#8	33.109421
Rf49	VPWR#3	VPWR#9	25.561712
Rf50	VPWR#5	VPWR#10	47.492367
Rf51	VPWR#6	VPWR#11	48.259808
Rf57	A1#3	A1#7	160.232803
Re1	VPWR#1	VPWR	11.068454
Re2	VPWR	VPWR#4	0.790604
Re3	VGND#2	VGND	11.068454
Re4	VGND	VGND#4	0.790604
*
*       CAPACITOR CARDS
*
*
C1	a_555_392##9	a_555_392#	8.66244e-19
C2	a_95_306##9	a_95_306##5	4.63456e-18
C3	VGND#4	B1#2	4.20914e-21
C4	VGND#11	a_95_306##5	6.68473e-19
C5	X#2	VPWR#6	1.63006e-19
C6	a_555_392##9	VPWR#8	5.15009e-17
C7	VGND#6	a_95_306##6	9.60119e-19
C8	VGND#1	A2#2	3.9528e-17
C9	VPWR#9	VPWR#8	2.60766e-18
C10	A2#2	a_1064_123#	2.15424e-17
C11	VPWR#9	a_555_392##9	6.05025e-17
C12	VGND#1	A1#1	3.12401e-18
C13	A1#3	A1#2	3.63751e-18
C14	VGND#12	a_95_306##12	1.33322e-18
C15	a_95_306##22	A2#2	8.53298e-19
C16	a_1064_123#	A1#1	3.30492e-17
C17	a_555_392##3	a_555_392##9	7.78296e-19
C18	VGND#1	A1#5	3.6695e-19
C19	VGND#12	a_95_306##9	1.22416e-19
C20	VPWR#2	A2#1	1.84634e-18
C21	a_95_306##22	A1#1	2.46718e-17
C22	a_555_392##3	VPWR#9	7.86483e-17
C23	VGND#9	A2#2	8.82266e-20
C24	a_1064_123#	A1#5	1.27414e-18
C25	VGND#1	A2#4	9.8707e-20
C26	VPWR#3	A1#4	5.69648e-19
C27	a_95_306##22	A1#5	3.30696e-17
C28	A2#3	A1#2	2.53693e-19
C29	VPWR#2	A1#4	1.84028e-18
C30	VGND#9	A1#1	1.27049e-19
C31	a_1064_123#	A2#4	6.80538e-19
C32	a_1064_123##2	A1#5	2.8864e-17
C33	VGND#1	B2#4	3.95701e-20
C34	a_555_392##3	a_95_306##17	7.22541e-19
C35	a_95_306##22	A2#4	3.00769e-17
C36	VGND#6	X#2	3.08803e-19
C37	VPWR#3	A1#6	4.84659e-18
C38	VGND#9	A1#5	2.1824e-19
C39	a_1064_123#	B2#4	3.90972e-19
C40	a_1064_123##2	A2#4	2.09228e-17
C41	a_95_306##20	A1#1	2.31191e-19
C42	a_95_306##19	VPWR#9	3.06683e-19
C43	a_95_306##22	B2#4	4.39627e-19
C44	A2#4	VGND#9	1.35435e-17
C45	a_555_392##5	a_95_306##17	1.69699e-19
C46	a_555_392##3	a_95_306##19	4.18787e-17
C47	VPWR#3	A2#5	3.42296e-18
C48	a_95_306##20	A1#5	2.74759e-19
C49	a_1064_123##2	B2#4	1.42126e-18
C50	B2#5	B1#2	4.70899e-17
C51	a_95_306##22	B1#4	2.03858e-19
C52	a_95_306##19	a_95_306##17	1.34128e-18
C53	VGND#9	B2#4	3.55703e-17
C54	a_555_392##7	a_555_392##3	1.63791e-18
C55	VPWR#5	B2#6	3.72342e-20
C56	a_555_392##2	A2#1	5.10724e-19
C57	a_95_306##20	A2#4	5.08154e-19
C58	VPWR#3	B2#6	5.85217e-18
C59	B2#4	a_645_120#	1.50177e-17
C60	a_555_392##5	a_95_306##19	7.47361e-17
C61	VGND#9	B1#4	2.47413e-18
C62	X#2	a_95_306#	8.20455e-20
C63	a_95_306##20	B2#4	2.37191e-17
C64	a_555_392##2	A1#4	1.64588e-17
C65	VPWR#5	B1#1	4.68658e-20
C66	a_645_120#	B1#4	3.42271e-17
C67	VPWR#3	B1#1	2.22841e-19
C68	VGND#9	B1#5	3.87329e-19
C69	X#2	a_95_306##3	5.02806e-19
C70	a_555_392#	A2#2	5.29559e-20
C71	B1#3	B1#2	3.98914e-18
C72	a_95_306##20	B1#4	3.28716e-17
C73	a_95_306##19	a_555_392##7	6.36617e-17
C74	VGND#10	B2#4	3.63233e-19
C75	a_645_120#	B1#5	4.29435e-19
C76	a_555_392##2	A1#6	2.15794e-17
C77	VPWR#5	B1#6	1.06461e-19
C78	VPWR#8	A2#2	5.03869e-19
C79	VGND#9	B2#1	2.30943e-19
C80	VPWR#10	a_95_306##19	4.50384e-17
C81	X#1	B2#4	1.51616e-19
C82	a_95_306##20	B1#5	3.32685e-17
C83	X#2	a_95_306##6	1.56964e-17
C84	VPWR#3	B1#6	7.73137e-20
C85	VGND#10	B1#4	6.23976e-19
C86	a_645_120#	B2#1	2.04559e-19
C87	VGND#3	a_95_306##22	1.34568e-18
C88	a_645_120##2	B1#5	3.11227e-17
C89	VPWR#6	B2#3	1.6208e-20
C90	a_555_392##2	A2#5	3.26857e-19
C91	VGND#9	a_95_306#	4.21708e-19
C92	X#1	B1#4	1.834e-19
C93	a_95_306##20	B2#1	7.56155e-18
C94	VPWR#5	B2#3	7.96888e-19
C95	X#2	a_95_306##10	2.59789e-17
C96	VGND#10	B1#5	1.26432e-18
C97	a_645_120#	a_95_306#	1.27031e-19
C98	VPWR#3	B2#3	5.02829e-20
C99	B2#2	B1#2	1.0593e-19
C100	a_645_120##2	B2#1	2.36249e-17
C101	X#1	B1#5	3.72343e-19
C102	a_95_306##10	a_95_306##5	3.93904e-18
C103	VGND#3	a_1064_123##2	5.1219e-18
C104	a_95_306##20	a_95_306#	2.55699e-19
C105	a_555_392##2	B2#6	9.37606e-20
C106	VPWR#6	a_95_306##7	5.33331e-19
C107	B2#1	VGND#10	1.8146e-17
C108	X#4	VPWR#10	7.65533e-17
C109	a_95_306##5	B2#2	1.29835e-19
C110	VPWR#5	a_95_306##7	8.56201e-18
C111	a_645_120##2	a_95_306#	5.53367e-19
C112	X#1	B2#1	7.20376e-19
C113	a_95_306##20	a_95_306##3	1.38137e-19
C114	VPWR#11	VPWR#10	2.00319e-18
C115	VGND#10	a_95_306#	3.49225e-17
C116	VPWR#6	a_95_306##11	5.32242e-18
C117	VPWR#9	A2#4	1.66438e-18
C118	VPWR#11	X#4	7.6663e-17
C119	a_95_306#	X#1	1.2848e-17
C120	VPWR#5	a_95_306##11	5.45681e-19
C121	a_95_306##2	B1#2	1.60333e-19
C122	VGND#10	a_95_306##3	2.55873e-18
C123	A1#2	A2#1	1.78666e-17
C124	a_555_392##3	A2#4	1.75942e-18
C125	VGND#11	a_95_306#	7.53534e-19
C126	VGND#3	a_645_120#	7.71832e-18
C127	a_1064_123#	a_555_392##2	8.05704e-18
C128	X#1	a_95_306##3	4.65605e-17
C129	VPWR#6	a_95_306##14	4.93148e-18
C130	a_95_306##2	a_95_306##5	6.17304e-18
C131	VGND#10	a_95_306##6	4.0652e-19
C132	X#5	VPWR#11	8.40389e-17
C133	VPWR#5	a_95_306##14	8.74044e-20
C134	a_95_306##3	VGND#11	1.77128e-17
C135	X#1	a_95_306##6	1.462e-18
C136	a_95_306##22	a_555_392##2	5.00699e-18
C137	X#3	a_95_306##3	5.80425e-19
C138	VGND#3	a_95_306##20	4.41761e-19
C139	VPWR#7	VPWR#11	2.66815e-18
C140	VGND#11	a_95_306##6	3.09788e-17
C141	VPWR#6	a_95_306##13	6.52765e-19
C142	X#1	a_95_306##10	4.4234e-19
C143	VPWR#7	X#5	7.97637e-17
C144	a_95_306##6	X#3	1.32913e-17
C145	VGND#11	a_95_306##10	2.44645e-18
C146	VGND#12	a_95_306##6	5.64422e-19
C147	X#3	a_95_306##10	2.99389e-17
C148	VGND#6	X#1	4.39643e-18
C149	a_555_392##5	B1#2	2.68894e-20
C150	a_95_306##10	VGND#12	1.6827e-17
C151	VGND#10	VGND#3	5.68372e-19
C152	VGND#5	X#1	4.65735e-18
C153	A2#2	A1#1	5.06367e-17
C154	VPWR#1	VPWR#2	5.65073e-20
C155	VGND#11	VGND#5	1.40019e-19
C156	a_95_306##19	B1#2	2.05267e-20
C157	a_555_392#	A2#1	3.54047e-17
C158	VGND#6	X#3	4.72098e-18
C159	VPWR#6	a_95_306##12	4.00695e-20
C160	A1#5	A1#1	3.61044e-17
C161	VPWR#8	A2#1	4.48612e-17
C162	a_555_392#	A1#4	7.88066e-19
C163	a_555_392#	VPWR#2	1.68621e-18
C164	a_555_392##9	A2#1	3.34901e-19
C165	X#2	a_95_306##7	4.93599e-18
C166	VPWR#8	A1#4	4.36266e-17
C167	VPWR#3	VPWR#8	3.22544e-19
C168	A2#4	A1#5	3.25968e-17
C169	VPWR#6	a_95_306##9	4.55335e-21
C170	a_555_392#	A1#6	1.8144e-19
C171	A1#4	a_555_392##9	1.48966e-17
C172	VPWR#6	VPWR#5	7.06672e-19
C173	VPWR#8	A1#6	2.73366e-18
C174	VPWR#9	A1#4	7.26712e-19
C175	X#2	a_95_306##11	3.7491e-18
C176	a_555_392##9	A1#6	4.07414e-17
C177	a_555_392##9	VPWR#3	7.26621e-18
C178	B2#4	A2#4	1.28221e-17
C179	VPWR#8	A2#5	2.90456e-19
C180	A1#6	VPWR#9	2.99289e-17
C181	X#2	a_95_306##14	6.31711e-19
C182	a_555_392##9	A2#5	2.14332e-19
C183	a_555_392##9	VPWR#2	6.44151e-18
C184	a_555_392##3	A1#6	7.34127e-19
C185	A2#5	VPWR#9	3.42054e-17
C186	B1#4	B2#4	2.95598e-17
C187	X#2	a_95_306##12	1.52442e-18
C188	VPWR#6	a_95_306##5	1.37287e-20
C189	a_555_392##9	B2#6	6.14824e-20
C190	a_555_392##3	A2#5	3.70872e-17
C191	X#2	a_95_306##13	3.46355e-19
C192	VPWR#3	A1#3	2.05344e-20
C193	VPWR#9	B2#6	1.24473e-18
C194	VPWR#2	A1#2	3.9602e-21
C195	VPWR#2	A1#3	2.47879e-20
C196	a_95_306##19	A1#6	1.21291e-19
C197	X#2	a_95_306##9	1.70353e-17
C198	a_555_392##3	B2#6	4.81257e-17
C199	B1#5	B1#4	3.53559e-17
C200	a_555_392##3	VPWR#3	1.89493e-17
C201	VPWR#9	B1#1	5.93029e-20
C202	B2#6	a_95_306##17	1.66813e-17
C203	a_95_306##19	A2#5	8.94508e-19
C204	VGND#3	A1#3	7.23695e-20
C205	a_555_392##3	B1#1	1.62014e-18
C206	a_555_392##7	A2#5	1.47667e-19
C207	VPWR#9	B1#6	3.74589e-20
C208	B1#1	a_95_306##17	2.023e-17
C209	B2#1	B1#5	3.56505e-17
C210	a_95_306##19	B2#6	1.58815e-17
C211	VPWR#5	a_95_306##5	1.79809e-20
C212	a_555_392##3	B1#6	4.03994e-19
C213	a_1064_123#	A1#2	8.75762e-20
C214	a_555_392##5	B1#1	3.22765e-17
C215	VGND#5	A2#3	5.64601e-19
C216	a_555_392##7	B2#6	2.07588e-19
C217	X#2	a_95_306##5	1.9999e-17
C218	VGND#3	A2#3	7.03279e-17
C219	VPWR#3	B2#5	3.10583e-20
C220	a_95_306##19	B1#1	2.30958e-17
C221	A1#3	a_555_392##2	1.67499e-17
C222	a_1064_123#	VGND#1	5.61581e-17
C223	VPWR#3	VPWR#2	1.09566e-18
C224	a_95_306#	B2#1	2.8029e-17
C225	a_555_392##3	B2#3	2.40555e-19
C226	a_555_392##5	B1#6	3.25661e-17
C227	VPWR#10	a_95_306##5	1.4707e-19
C228	a_555_392##7	B1#1	3.60494e-19
C229	a_95_306##19	B1#6	4.55849e-17
C230	A1	A1#2	1.8277e-17
C231	VGND#2	a_1064_123#	8.75421e-18
C232	VGND#3	B2#5	4.88523e-20
C233	a_555_392##7	B1#6	7.29992e-19
C234	a_555_392##2	A2#3	1.46212e-19
C235	VPWR#5	a_95_306##19	2.73167e-17
C236	a_555_392##2	a_555_392#	1.32102e-18
C237	a_95_306##9	X#4	5.59411e-20
C238	a_95_306##3	a_95_306#	3.80937e-17
C239	VGND#2	a_1064_123##2	2.85115e-18
C240	a_95_306##19	B2#3	4.50327e-17
C241	a_555_392##7	B2#3	2.99382e-17
C242	a_95_306##22	A1#2	1.13747e-18
C243	a_95_306##19	VPWR#3	1.24639e-17
C244	a_1064_123#	a_95_306##22	3.71908e-17
C245	a_95_306##19	a_95_306##7	1.15184e-18
C246	VPWR#10	B2#3	1.19688e-18
C247	a_555_392##2	VPWR#8	2.85553e-17
C248	a_95_306##6	a_95_306##3	3.77067e-17
C249	a_555_392##7	a_95_306##7	6.65424e-19
C250	a_95_306##5	X#4	4.20387e-19
C251	VPWR#11	a_95_306##12	5.70276e-19
C252	a_95_306##7	VPWR#10	4.09689e-17
C253	VPWR#11	B2#3	5.88155e-20
C254	X#4	a_95_306##7	6.08948e-17
C255	a_95_306##10	a_95_306##6	3.74143e-17
C256	a_555_392##2	a_555_392##9	7.85188e-19
C257	a_95_306##2	VPWR#5	2.67625e-19
C258	VPWR#11	a_95_306##9	2.296e-18
C259	a_555_392#	VPWR#1	2.80683e-17
C260	VPWR#10	a_95_306##11	3.71489e-19
C261	VPWR#11	a_95_306##7	6.70578e-19
C262	a_1064_123#	A1#3	3.50032e-20
C263	VGND#4	a_645_120#	3.80746e-18
C264	a_95_306##22	a_1064_123##2	4.31752e-17
C265	VGND#9	a_1064_123#	9.47078e-19
C266	a_95_306##22	A1#3	1.69459e-17
C267	X#4	a_95_306##11	5.18332e-17
C268	a_1064_123##2	A1#3	3.75333e-19
C269	VGND#6	a_95_306##2	1.8672e-20
C270	VPWR#10	a_95_306##14	1.72497e-19
C271	X#4	VPWR#6	8.52086e-18
C272	VPWR#11	a_95_306##11	1.77385e-17
C273	VGND#4	a_645_120##2	1.17643e-17
C274	A2#3	VGND#1	4.46014e-18
C275	VGND#2	a_555_392#	3.16185e-18
C276	VGND#5	a_95_306##2	8.6959e-19
C277	a_555_392##2	VPWR#9	3.49833e-17
C278	a_1064_123#	A2#3	1.34915e-18
C279	X#4	a_95_306##14	1.81514e-18
C280	a_95_306##22	VGND#9	2.72468e-18
C281	A2#3	a_95_306##22	4.57375e-18
C282	VPWR#11	a_95_306##14	5.11757e-17
C283	X#4	VPWR#5	8.47121e-18
C284	a_95_306##12	X#5	4.92281e-19
C285	A2#3	a_1064_123##2	1.56511e-17
C286	a_95_306##14	X#5	2.1708e-17
C287	B2	A1#2	5.17782e-20
C288	VGND#9	A2#3	1.63976e-17
C289	B2	B1#2	2.02341e-18
C290	VPWR#11	a_95_306##13	2.56667e-18
C291	VPWR#7	a_95_306##14	3.2681e-18
C292	a_555_392##3	a_555_392##2	1.1869e-18
C293	VGND#9	a_1064_123##2	7.84788e-18
C294	VGND#6	a_95_306##9	3.43987e-20
C295	a_95_306##13	X#5	3.06778e-17
C296	B2#5	VGND#9	1.09012e-18
C297	A1#4	A2#1	4.21848e-17
C298	VPWR#7	a_95_306##13	5.42802e-17
C299	VGND#10	A2#3	6.81475e-19
C300	B2#5	a_645_120#	8.05712e-19
C301	a_95_306##20	B2#5	6.22999e-17
C302	X#5	VPWR#6	1.05497e-17
C303	X#2	B2#2	3.34937e-19
C304	a_95_306##19	VPWR#4	8.56683e-17
C305	A1#6	A1#4	4.2505e-17
C306	A1#3	a_555_392##9	8.77316e-19
C307	a_645_120#	B1#3	2.39128e-19
C308	VGND#6	VGND#5	3.08268e-18
C309	a_645_120#	VGND#9	3.04387e-17
C310	B1#3	a_95_306##20	4.74661e-17
C311	a_645_120##2	B1#3	4.4729e-19
C312	X#2	VGND#11	2.21494e-17
C313	X#2	a_95_306##2	5.25017e-17
C314	A2#5	A1#6	1.83265e-17
C315	VPWR#7	VPWR#6	1.41623e-19
C316	VGND#6	a_95_306##5	5.96098e-21
C317	VPWR#9	A2#3	3.70911e-19
C318	A1#2	A2#2	1.6255e-17
C319	a_95_306##20	VGND#9	2.77805e-17
C320	a_95_306##20	B2#2	1.45827e-17
C321	VGND#2	A2#2	2.16626e-17
C322	a_555_392##3	A2#3	2.30659e-19
C323	VGND#2	A1#1	3.08991e-18
C324	X#2	X#3	2.90893e-19
C325	VGND#10	B2#2	7.26822e-19
C326	B2#6	A2#5	3.78058e-17
C327	VGND#2	A1#5	1.65576e-18
C328	B2#5	a_555_392##3	1.79249e-17
C329	a_645_120#	a_95_306##20	5.70806e-17
C330	a_645_120##2	a_95_306##2	2.04712e-18
C331	a_645_120#	B1#2	2.92459e-20
C332	B1#1	B2#6	4.34035e-17
C333	a_95_306##2	VGND#10	3.67214e-17
C334	X#2	VGND#12	8.94469e-18
C335	VGND#5	VGND#3	5.02562e-19
C336	a_95_306##2	X#1	6.28596e-17
C337	X	a_95_306##12	1.46742e-17
C338	X	a_95_306##9	1.33951e-19
C339	a_95_306##2	VGND#11	8.84876e-19
C340	VGND#10	VGND#9	2.15874e-18
C341	a_555_392##5	B1#3	4.41302e-19
C342	B1#6	B1#1	4.31294e-17
C343	a_95_306##19	B1#3	3.39295e-19
C344	A2#3	A2#2	1.95526e-18
C345	a_95_306##20	a_645_120##2	3.98951e-17
C346	VGND#4	B1#4	1.72932e-18
C347	VGND#10	a_645_120#	3.67094e-19
C348	A2#4	A1#3	1.5389e-17
C349	A2#3	A1#1	8.91307e-18
C350	a_555_392##2	VPWR#3	1.6661e-19
C351	B2#3	B1#6	4.24171e-17
C352	VGND#4	B1#5	4.01103e-18
C353	B2#2	a_95_306##19	3.14661e-19
C354	A2#3	A1#5	2.57571e-17
C355	VGND#1	a_555_392#	1.65141e-17
C356	B2#2	a_555_392##7	4.36243e-17
C357	B2#5	A2#2	2.66003e-19
C358	VGND#4	B2#1	2.20109e-18
C359	A2#3	A2#4	1.07819e-18
C360	VPWR#10	B2#2	9.97483e-20
C361	a_95_306##20	B1#2	2.82867e-19
C362	B2#4	A2#3	4.56618e-18
C363	X#1	a_645_120#	7.8753e-21
C364	a_95_306##7	B2#3	3.80574e-18
C365	a_95_306##2	a_95_306##19	2.06822e-18
C366	B1#4	A2#3	7.56317e-19
C367	a_95_306##2	a_555_392##7	6.57095e-17
C368	B2#5	A2#4	2.26074e-17
C369	A1	a_555_392##2	6.11778e-17
C370	a_555_392##2	VPWR#2	3.13618e-19
C371	VPWR	a_95_306##5	4.79373e-23
C372	a_95_306##2	VPWR#10	9.85395e-17
C373	VGND#10	a_645_120##2	2.58699e-17
C374	a_95_306##11	a_95_306##7	4.55697e-17
C375	X#1	a_95_306##20	1.63548e-18
C376	a_95_306##13	a_95_306##12	8.85835e-19
C377	a_95_306##14	a_95_306##11	4.66422e-17
C378	a_1064_123#	A1	3.34616e-18
C379	a_95_306##22	A1	4.80514e-17
C380	VPWR#4	B1#1	5.32898e-18
C381	a_95_306##13	a_95_306##14	4.75026e-17
C382	a_95_306##2	B2#4	1.9356e-19
C383	a_95_306##2	B1#4	2.31192e-19
C384	VPWR#4	B1#6	3.84405e-18
C385	A2#5	A1#3	6.18609e-18
C386	VGND	a_95_306##12	1.30859e-20
C387	X#1	VGND#10	3.87488e-17
C388	a_95_306#	B2#2	1.46682e-19
C389	VGND	a_95_306##9	3.20963e-20
C390	VGND	a_95_306##5	3.71642e-21
C391	a_95_306##2	B1#5	3.8663e-19
C392	VPWR#4	B2#3	4.4286e-18
C393	a_95_306##2	B2#1	1.49881e-17
C394	a_95_306##2	a_95_306#	8.17917e-18
C395	a_95_306##2	a_95_306##3	5.77677e-19
C396	B2#5	A2#5	1.9822e-17
C397	VGND#11	VGND#10	3.63476e-18
C398	a_95_306##2	a_95_306##6	7.79393e-20
C399	A1	a_555_392##9	1.77834e-18
C400	X	VPWR#6	1.62843e-19
C401	VGND#3	A1#5	1.90592e-18
C402	X#1	VGND#11	3.10666e-17
C403	a_95_306##20	B2	7.48893e-18
C404	B2#2	B1#1	1.01577e-20
C405	A1#2	VNB	2.48427e-17
C406	B1#2	VNB	1.83386e-17
C407	a_95_306##12	VNB	2.16262e-17
C408	a_95_306##9	VNB	1.95085e-17
C409	A2	VGND#1	6.43898e-19
C410	B2#2	B1#6	7.44824e-20
C411	a_555_392##2	A2#2	3.81077e-19
C412	a_95_306##5	VNB	1.96003e-17
C413	A2	a_1064_123#	3.05519e-18
C414	a_95_306##22	a_555_392##3	9.90029e-18
C415	A2	a_95_306##22	1.06336e-17
C416	B1	a_555_392##5	1.58075e-18
C417	B2#2	B2#3	7.01621e-18
C418	X#3	X#1	3.74105e-18
C419	A2	VGND#9	1.88358e-17
C420	VPWR	VPWR#6	7.40612e-17
C421	a_95_306##12	a_95_306##9	1.04325e-18
C422	VPWR	VPWR#5	7.65255e-17
C423	A1	A2#2	3.72532e-18
C424	a_95_306##7	B2#2	2.61411e-19
C425	VGND#3	A2#4	2.66136e-19
C426	VPWR	VPWR#3	1.25748e-16
C427	VGND#2	A1#3	1.5492e-19
C428	VPWR	VPWR#2	5.15912e-17
C429	a_95_306##2	B2#3	2.22589e-18
C430	B2	a_555_392##3	1.24571e-17
C431	A1	A2#4	6.59362e-18
C432	a_95_306##2	a_95_306##7	2.00942e-18
C433	A2#3	VGND#2	1.24683e-17
C434	X	X#2	1.32378e-18
C435	B2	a_555_392##5	6.98673e-17
C436	X#3	VGND#11	3.14622e-17
C437	B2	a_555_392##7	1.03243e-18
C438	VPWR	a_555_392##2	5.26427e-18
C439	B1#2	B2#4	3.75737e-19
C440	a_555_392##2	A1#2	2.67163e-19
C441	A2#3	A1#3	7.19886e-19
C442	VPWR#4	B1#3	4.13806e-20
C443	VGND#3	B2#4	2.26467e-18
C444	B2#5	A1#3	1.66921e-18
C445	X	VGND#12	2.23963e-17
C446	VGND#4	B1#3	9.8791e-20
C447	VPWR	X#2	2.0679e-18
C448	VGND	VGND#6	6.86608e-17
C449	VPWR#4	B2#2	1.71648e-20
C450	VGND#12	VGND#11	2.03461e-18
C451	VGND	VGND#5	6.93144e-17
C452	VGND	VGND#3	1.242e-16
C453	A1	A2#1	3.94039e-18
C454	A2	A2#2	2.27867e-19
C455	VGND#4	a_95_306##2	2.98812e-19
C456	A2	A1#1	3.9492e-19
C457	A1	A2#5	2.21337e-18
C458	A2	A1#5	8.54506e-19
C459	B1#3	B2#5	1.45818e-17
C460	VGND#2	A1#2	1.13784e-19
C461	A2	A2#4	6.18298e-18
C462	A2	B2#4	6.57788e-19
C463	VPWR	a_555_392#	4.49307e-18
C464	X#2	VPWR#10	8.54513e-18
C465	X	VPWR#11	8.14844e-18
C466	B2#2	B2#5	4.88336e-19
C467	VGND#12	X#3	3.99628e-17
C468	VPWR	VPWR#8	2.17583e-17
C469	VGND#3	B1#4	2.24812e-18
C470	VGND	X#2	4.44136e-18
C471	VPWR	a_555_392##9	1.49706e-17
C472	X	VPWR#7	1.9893e-17
C473	VPWR#6	VNB	3.04351e-17
C474	VGND	a_1064_123#	1.55209e-17
C475	VPWR#5	VNB	3.46678e-17
C476	B2#2	B1#3	5.25752e-17
C477	VPWR	a_555_392##3	2.03155e-17
C478	VGND	a_95_306##22	9.96714e-18
C479	a_95_306##2	B2#5	8.89981e-20
C480	VPWR#3	VNB	4.95578e-17
C481	VPWR#2	VNB	2.58163e-17
C482	VGND	a_1064_123##2	1.21025e-17
C483	B2	A1#4	1.60691e-19
C484	VPWR	a_555_392##5	6.4924e-18
C485	VGND#6	VNB	3.05468e-17
C486	a_95_306##20	a_555_392##3	4.66639e-18
C487	VGND	a_645_120#	1.51646e-17
C488	VGND#5	VNB	2.86561e-17
C489	VPWR	a_95_306##19	6.38162e-17
C490	VGND#3	VNB	5.78184e-17
C491	VGND	a_95_306##20	1.03794e-17
C492	B2	A1#6	2.70809e-19
C493	a_95_306##2	B1#3	2.64622e-19
C494	VPWR	a_555_392##7	8.32101e-18
C495	VGND	a_645_120##2	1.55038e-17
C496	B2	A2#5	1.54439e-18
C497	VGND	X#1	1.37808e-17
C498	VPWR	X#4	1.88387e-17
C499	a_555_392##2	VNB	5.53675e-18
C500	B2	B2#6	4.51945e-18
C501	a_95_306##2	B2#2	8.90988e-17
C502	a_555_392##2	A2#4	5.74056e-18
C503	VGND	X#3	1.44064e-17
C504	VPWR	X#5	1.33649e-17
C505	B2	B1#1	1.28174e-17
C506	VGND	a_555_392#	8.71074e-19
C507	VPWR	VPWR#7	6.82193e-17
C508	B2	B1#6	1.40047e-17
C509	B2	B2#3	1.69561e-20
C510	X#2	X#4	7.6905e-20
C511	VGND	a_555_392##3	2.84714e-18
C512	X#2	VNB	2.93947e-19
C513	VGND#1	VNB	4.75591e-17
C514	a_1064_123#	VNB	7.02348e-18
C515	a_95_306##22	VNB	2.96727e-18
C516	VGND	a_555_392##7	1.0531e-18
C517	VGND#9	VNB	4.12044e-18
C518	a_645_120#	VNB	4.54609e-18
C519	a_95_306##20	VNB	5.33011e-18
C520	a_645_120##2	VNB	4.10636e-18
C521	VGND#10	VNB	4.74364e-18
C522	A1	A1#3	1.35439e-17
C523	VGND	VPWR#7	4.50771e-18
C524	X#1	VNB	2.69857e-18
C525	VGND#11	VNB	1.42664e-18
C526	VGND	A2#2	8.43148e-18
C527	X#3	VNB	3.17033e-18
C528	VGND	A1#1	5.24759e-18
C529	A1	A2#3	4.76858e-19
C530	VGND#12	VNB	2.65271e-17
C531	VGND	A1#5	5.07596e-18
C532	a_555_392#	VNB	5.33271e-17
C533	VPWR#8	VNB	2.3644e-18
C534	VGND	A2#4	2.32166e-18
C535	VPWR	A2#1	1.99412e-18
C536	B2#5	A1	1.04884e-17
C537	a_555_392##9	VNB	2.24265e-18
C538	VGND	B2#4	2.88275e-18
C539	VPWR#9	VNB	3.07191e-18
C540	VPWR	A1#4	1.02065e-18
C541	VGND	B1#4	1.10463e-17
C542	a_555_392##3	VNB	8.4947e-18
C543	VGND	B1#5	1.03712e-17
C544	VGND	B2#1	8.16362e-18
C545	VPWR	A2#5	3.36461e-19
C546	a_95_306##19	VNB	2.11383e-17
C547	X	a_95_306##11	5.64004e-19
C548	VGND	a_95_306#	4.41929e-18
C549	a_555_392##7	VNB	1.18812e-18
C550	B1	B2#5	9.96108e-18
C551	VPWR	B2#6	1.71715e-18
C552	VGND#5	B2#1	1.00891e-18
C553	VPWR#10	VNB	1.24875e-17
C554	VGND	a_95_306##3	8.6703e-18
C555	X	a_95_306##14	1.7061e-18
C556	B2	A1#3	2.45232e-19
C557	X#2	VPWR#11	2.97922e-17
C558	X#4	VNB	2.30882e-18
C559	VPWR	B1#1	6.11534e-19
C560	VGND	a_95_306##6	4.79891e-18
C561	VPWR#11	VNB	6.8037e-19
C562	X	a_95_306##13	1.69447e-17
C563	B1	B1#3	7.43908e-18
C564	VGND	a_95_306##10	9.42092e-18
C565	VPWR	B1#6	3.86518e-19
C566	X#5	VNB	6.63705e-18
C567	VPWR#7	VNB	7.89525e-17
C568	VPWR	B2#3	2.11145e-18
C569	A2#2	VNB	8.73992e-17
C570	B2#2	B1	1.39488e-17
C571	B2	B2#5	4.77702e-19
C572	A1#1	VNB	1.90141e-17
C573	VPWR	a_95_306##7	5.0412e-18
C574	A1#5	VNB	1.99369e-17
C575	VPWR	a_95_306##11	4.09577e-18
C576	A2#4	VNB	4.8859e-17
C577	B2	B1#3	3.12309e-18
C578	B2#4	VNB	2.47303e-17
C579	VPWR	a_95_306##14	3.2834e-18
C580	B1#4	VNB	3.17401e-17
C581	B2#2	B2	1.88704e-18
C582	B1#5	VNB	2.86364e-17
C583	VPWR	a_95_306##13	3.09693e-18
C584	VPWR#4	B1#2	2.50346e-21
C585	B2#1	VNB	2.93254e-17
C586	a_95_306#	VNB	3.18442e-17
C587	a_95_306##3	VNB	2.76149e-17
C588	a_95_306##6	VNB	2.4945e-17
C589	a_95_306##10	VNB	4.16994e-17
C590	VPWR	VPWR#4	7.85426e-17
C591	A2#1	VNB	5.42381e-17
C592	A1#4	VNB	2.69596e-17
C593	A1#6	VNB	2.98406e-17
C594	A2#5	VNB	3.91697e-17
C595	VPWR	A1#3	5.39003e-19
C596	B2#6	VNB	3.11903e-17
C597	B1#1	VNB	3.19565e-17
C598	B1#6	VNB	2.95693e-17
C599	VGND	VGND#2	6.65465e-17
C600	VPWR	B2#5	2.26242e-18
C601	B2#3	VNB	3.87568e-17
C602	a_95_306##7	VNB	3.76547e-17
C603	VGND	VGND#4	5.05885e-17
C604	X#5	X#2	1.11253e-18
C605	a_95_306##11	VNB	3.09113e-17
C606	VPWR	B2#2	2.11321e-18
C607	a_95_306##14	VNB	3.08642e-17
C608	VGND	A1#3	3.88667e-19
C609	a_95_306##13	VNB	6.9598e-17
C610	VGND	A2#3	3.10818e-17
C611	VPWR	a_95_306##2	4.96033e-18
C612	VGND	B2#5	5.27908e-18
C613	VPWR#1	VNB	9.98133e-17
C614	VGND#2	VNB	1.27237e-16
C615	VGND	B1#3	2.53937e-18
C616	B1	B2	3.08843e-17
C617	VGND#5	a_95_306#	2.76822e-18
C618	VPWR#4	VNB	4.43133e-17
C619	VGND	B2#2	2.16089e-18
C620	VGND#4	VNB	2.72568e-17
C621	VGND	a_95_306##2	9.45293e-18
C622	A1#3	VNB	3.38868e-17
C623	a_555_392#	VPWR#8	5.63135e-17
C624	A2#3	VNB	8.27566e-17
C625	B2#5	VNB	3.90631e-17
C626	B1#3	VNB	3.4583e-17
C627	B2#2	VNB	3.4629e-17
C628	VPWR	A1	2.48713e-18
C629	a_95_306##2	VNB	6.23677e-17
C630	VPWR	B1	2.13748e-18
C631	VGND	A1	3.72026e-18
C632	VPWR	B2	5.47405e-18
C633	VGND	B2	1.94542e-18
C634	A1	VNB	1.08454e-19
C635	VPWR	X	4.49549e-18
C636	VGND#3	a_95_306#	2.96189e-19
C637	B1	VNB	2.93966e-19
C638	B2	VNB	3.29757e-18
C639	VGND	X	2.09601e-17
C640	A2	VNB	1.49587e-18
C641	X	VNB	5.2137e-17
C642	VGND#6	a_95_306##3	4.42194e-18
C643	VPWR	VNB	3.0161e-16
C644	VGND	VNB	3.08307e-16
C645	VGND#7	a_95_306##9	1.35561e-20
C646	VGND#7	X#3	4.06044e-18
C647	VGND#7	a_95_306##6	7.75626e-19
C648	VGND#7	VGND#6	2.92557e-18
C649	VGND	VGND#7	1.187e-16
C650	VGND#7	a_95_306##12	2.48124e-19
C651	VGND#7	a_95_306##13	3.91175e-19
C652	VGND#7	X#2	2.47938e-19
C653	VGND#7	a_95_306##10	5.63975e-18
C654	VGND#7	X	7.50753e-18
C655	VGND#7	VNB	7.28466e-17
C656	VGND#7	VGND#11	1.6049e-18
*
*
.ENDS sky130_fd_sc_hs__a22o_4
*
