* Extracted by Quantus, converted by sky130cad/quantus.py
*
*
*
*                       LINUX           Wed Nov 18 08:45:39 2026
*
*
*
*  PROGRAM  advgen
*
*  Name           : advgen - Quantus - (64-bit)
*  Version        : 25.1.0-p047
*  Build Date     : Thu Dec 11 23:20:30 PST 2025
*
*  HSPICE LIBRARY
*
*  OPERATING_TEMPERATURE 150
*  QRC_TECH_DIR <path>/tech
*
*
*

*
.SUBCKT sky130_fd_sc_hs__nand2b_4 VPB VNB VGND VPWR Y A_N B
*
*
*  caps2d version: 10
*
*
*       TRANSISTOR CARDS
*
*
XM6 a_31_74##12 A_N#4 VGND#9 VNB sky130_fd_pr__nfet_01v8_lvt l=0.15 w=0.74 ad=0.2109 as=0.2109 pd=2.05 ps=2.05
XM3 a_243_74##7 a_31_74##5 Y#3 VNB sky130_fd_pr__nfet_01v8_lvt l=0.15 w=0.74 ad=0.2109 as=0.2072 pd=2.05 ps=2.04
XM0 Y#3 a_31_74##9 a_243_74##8 VNB sky130_fd_pr__nfet_01v8_lvt l=0.15 w=0.74 ad=0.2072 as=0.2072 pd=2.04 ps=2.04
XM7 a_243_74##8 a_31_74##7 Y#5 VNB sky130_fd_pr__nfet_01v8_lvt l=0.15 w=0.74 ad=0.2072 as=0.3071 pd=2.04 ps=2.31
XM10 Y#5 a_31_74# a_243_74##4 VNB sky130_fd_pr__nfet_01v8_lvt l=0.15 w=0.74 ad=0.3071 as=0.2072 pd=2.31 ps=2.04
XM4 VGND#8 B#10 a_243_74##4 VNB sky130_fd_pr__nfet_01v8_lvt l=0.15 w=0.74 ad=0.259 as=0.2072 pd=2.18 ps=2.04
XM8 a_243_74##2 B#9 VGND#8 VNB sky130_fd_pr__nfet_01v8_lvt l=0.15 w=0.74 ad=0.2072 as=0.259 pd=2.04 ps=2.18
XM11 VGND#7 B#6 a_243_74##2 VNB sky130_fd_pr__nfet_01v8_lvt l=0.15 w=0.74 ad=0.5587 as=0.2072 pd=2.99 ps=2.04
XM14 a_243_74# B#1 VGND#7 VNB sky130_fd_pr__nfet_01v8_lvt l=0.15 w=0.74 ad=0.2109 as=0.5587 pd=2.05 ps=2.99
XM2 VPWR#9 A_N#5 a_31_74##13 VPB sky130_fd_pr__pfet_01v8 l=0.15 w=0.84 ad=0.5376 as=0.252 pd=2.96 ps=2.28
XM12 a_31_74##13 A_N#1 VPWR#8 VPB sky130_fd_pr__pfet_01v8 l=0.15 w=0.84 ad=0.252 as=0.406 pd=2.28 ps=3.01
XM1 VPWR#8 a_31_74##8 Y#4 VPB sky130_fd_pr__pfet_01v8 l=0.15 w=1.12 ad=0.406 as=0.7616 pd=3.01 ps=3.6
XM13 Y#4 a_31_74##6 VPWR#7 VPB sky130_fd_pr__pfet_01v8 l=0.15 w=1.12 ad=0.7616 as=1.792 pd=3.6 ps=5.44
XM9 Y#1 B#7 VPWR#7 VPB sky130_fd_pr__pfet_01v8 l=0.15 w=1.12 ad=0.3584 as=1.792 pd=2.88 ps=5.44
XM5 VPWR#1 B#4 Y#1 VPB sky130_fd_pr__pfet_01v8 l=0.15 w=1.12 ad=0.336 as=0.3584 pd=2.84 ps=2.88
*
*
*       RESISTOR AND CAP/DIODE CARDS
*
Rg1	A_N#1	A_N#2	524.651611
Rg2	A_N#2	A_N#3	10.155000
Rg3	A_N#3	A_N#4	337.944641
Rg4	A_N#2	A_N#5	368.391846
Rg5	a_31_74#	a_31_74##2	326.513092
Rg6	a_31_74##2	a_31_74##3	35.926960
Rg7	a_31_74##3	a_31_74##4	77.534370
Rg8	a_31_74##4	a_31_74##5	470.803070
Rg9	a_31_74##2	a_31_74##6	473.299805
Rg10	a_31_74##3	a_31_74##7	308.048096
Rg11	a_31_74##3	a_31_74##8	456.566162
Rg12	a_31_74##4	a_31_74##9	265.435883
Rg13	B#1	B#2	353.941986
Rg14	B#2	B#3	79.767410
Rg15	B#2	B#4	482.001831
Rg16	B#3	B#5	61.857624
Rg17	B#5	B#6	342.058960
Rg18	B#3	B#7	451.334412
Rg19	B#5	B#8	78.434601
Rg20	B#8	B#9	342.058960
Rg21	B#8	B#10	446.227142
Rf1	A_N#6	A_N	1.330131
Rf2	A_N#3	A_N#8	54.741066
Rf3	A_N#6	A_N#8	10.169745
Rf4	A_N#9	A_N	1.330131
Rf5	A_N#8	A_N#9	3.023438
Rf6	a_31_74##3	a_31_74##11	110.482941
Rf7	a_31_74##11	a_31_74##12	131.367554
Rf8	a_31_74##11	a_31_74##13	51.150490
Rf9	Y#1	Y	70.819519
Rf10	Y	Y#2	77.847130
Rf11	Y#2	Y#3	97.323723
Rf12	Y	Y#4	38.144009
Rf13	Y#2	Y#5	25.805576
Rf14	a_243_74#	a_243_74##3	116.809486
Rf15	a_243_74##3	a_243_74##5	67.012756
Rf16	a_243_74##5	a_243_74##6	78.473122
Rf17	a_243_74##6	a_243_74##7	86.225365
Rf18	a_243_74##6	a_243_74##8	16.968842
Rf19	a_243_74##2	a_243_74##3	7.500000
Rf20	a_243_74##4	a_243_74##5	7.500000
Rf21	B	B#11	3.573154
Rf22	B#11	B	9.620030
Rf23	VPWR#1	VPWR#2	157.539505
Rf24	VPWR#2	VPWR#3	72.298676
Rf25	VPWR#3	VPWR#4	69.373436
Rf26	VPWR#4	VPWR#5	86.347176
Rf28	VPWR#2	VPWR#7	7.243760
Rf29	VPWR#4	VPWR#8	37.695530
Rf30	VPWR#5	VPWR#9	23.336641
Rf32	VGND#2	VGND#3	80.167725
Rf33	VGND#3	VGND#4	60.972630
Rf34	VGND#4	VGND#5	157.034042
Rf36	VGND#2	VGND#7	18.326458
Rf37	VGND#3	VGND#8	31.161278
Rf38	VGND#5	VGND#9	34.113823
Rf41	B#3	B#11	32.046562
Re1	VPWR#3	VPWR	0.818510
Re2	VGND	VGND#4	0.818540
*
*       CAPACITOR CARDS
*
*
C1	B#8	B#5	1.84431e-18
C2	A_N#2	a_31_74##5	7.15329e-18
C3	a_243_74#	B#5	2.04493e-18
C4	a_243_74#	B#2	6.3306e-18
C5	A_N#6	A_N#2	1.97826e-17
C6	a_31_74##11	VPWR#4	3.84876e-19
C7	B#5	B#2	2.43455e-18
C8	a_243_74##2	B#8	3.92494e-18
C9	a_243_74##2	B#5	5.81622e-18
C10	a_243_74##6	Y#2	2.11345e-17
C11	a_31_74##4	B#5	1.07771e-19
C12	B#8	VGND#8	9.92091e-19
C13	VGND#3	a_243_74##2	8.40581e-18
C14	a_31_74##4	B#7	4.7898e-20
C15	VGND#3	a_243_74##4	1.05256e-17
C16	a_243_74##4	B#8	3.35884e-19
C17	a_243_74##4	a_31_74##4	3.55969e-19
C18	a_31_74##11	A_N#9	6.47485e-17
C19	a_31_74##4	Y#5	2.08219e-18
C20	A_N#1	a_31_74##4	7.89584e-18
C21	A_N#2	a_31_74##4	9.80116e-19
C22	a_243_74##6	a_243_74##4	3.71616e-18
C23	Y#2	a_243_74##2	5.09177e-18
C24	a_31_74##4	a_243_74##8	1.08624e-18
C25	a_243_74##6	Y#5	4.48482e-17
C26	VGND#3	B#8	4.68111e-20
C27	a_243_74##6	a_243_74##8	6.69048e-19
C28	Y#2	a_243_74##4	5.16939e-17
C29	VGND#3	B#5	1.98947e-20
C30	a_243_74##6	Y#3	4.892e-17
C31	Y#3	a_31_74##4	9.40091e-18
C32	a_243_74##7	a_243_74##6	3.90085e-18
C33	Y#3	A_N#2	1.29553e-20
C34	VPWR#2	VPWR#1	2.87572e-18
C35	a_243_74#	VGND#7	1.05617e-18
C36	a_31_74##11	Y#3	5.41879e-17
C37	a_243_74##2	a_243_74#	2.62669e-18
C38	Y#1	VPWR#2	9.49921e-17
C39	VPWR#3	a_31_74##4	1.1568e-19
C40	a_31_74##11	a_243_74##7	3.12716e-17
C41	a_243_74##2	VGND#7	1.17236e-18
C42	a_243_74##7	A_N#2	1.44641e-18
C43	VPWR#2	VPWR#7	5.02826e-17
C44	Y#4	VPWR#4	9.95838e-18
C45	Y#4	VPWR#2	7.12282e-17
C46	a_243_74##2	VGND#8	4.33844e-17
C47	VGND#4	a_31_74##4	4.02457e-19
C48	A_N#9	VGND#9	3.3352e-18
C49	VPWR#8	VPWR#2	1.35581e-18
C50	a_243_74##4	a_243_74##2	2.53383e-18
C51	VGND#9	A_N#2	1.68032e-18
C52	a_31_74##13	VPWR#4	2.91782e-18
C53	a_243_74##4	VGND#8	4.71622e-17
C54	a_31_74##12	A_N#9	2.12162e-17
C55	Y#5	a_243_74##2	1.19167e-18
C56	B#3	B#5	1.3013e-17
C57	VGND#3	B#9	9.3704e-19
C58	a_243_74##4	Y#5	4.00129e-17
C59	Y#2	Y#4	1.40731e-19
C60	a_31_74##12	A_N#2	1.03252e-17
C61	A_N#6	a_31_74##12	2.97986e-17
C62	B#2	VPWR#1	4.83485e-18
C63	VGND#3	B#10	2.43554e-18
C64	a_31_74##11	VPWR#8	5.58298e-18
C65	Y#3	Y#5	2.51192e-18
C66	a_31_74##3	a_31_74##4	4.26513e-17
C67	a_31_74##11	a_31_74##13	3.32084e-18
C68	B#5	Y#1	1.98781e-18
C69	B#2	Y#1	1.35228e-18
C70	VPWR#2	B#10	1.43445e-18
C71	Y#2	B#1	3.3837e-19
C72	a_243_74##7	Y#3	2.95826e-17
C73	A_N#9	VPWR#9	4.94011e-17
C74	B#8	VPWR#7	1.11974e-19
C75	Y#2	B#6	5.29853e-19
C76	VPWR#2	B#8	2.5107e-18
C77	B#5	VPWR#7	2.40909e-19
C78	A_N#3	A_N#2	1.25584e-17
C79	VPWR#4	a_31_74##4	5.66245e-20
C80	VGND#9	a_243_74##7	3.34926e-17
C81	a_31_74##12	Y#3	1.23352e-18
C82	Y#2	B#9	2.99348e-18
C83	VPWR#2	B#5	2.56433e-18
C84	a_243_74##6	a_31_74#	7.5565e-19
C85	Y#2	B#10	1.20423e-17
C86	VPWR#2	B#2	5.11968e-20
C87	a_31_74##12	VGND#9	6.63779e-17
C88	a_31_74##11	B#10	2.93483e-19
C89	a_243_74##6	a_31_74##7	3.2584e-17
C90	a_243_74#	B#1	4.99053e-17
C91	Y#2	a_31_74#	4.74955e-18
C92	VPWR#4	A_N#2	1.61933e-20
C93	B#1	VGND#7	1.42745e-17
C94	a_243_74##6	a_31_74##9	2.7349e-17
C95	a_243_74#	B#6	1.03624e-18
C96	Y#2	a_31_74##7	4.69449e-18
C97	a_243_74##2	B#1	1.103e-18
C98	B#6	VGND#7	1.78039e-17
C99	Y#4	a_31_74##4	1.18796e-17
C100	a_243_74##6	a_31_74##5	1.82914e-18
C101	VGND#8	B#1	1.24309e-19
C102	a_243_74##2	B#6	6.17678e-17
C103	Y#1	VPWR#1	9.23173e-17
C104	VGND#8	B#6	1.81546e-18
C105	a_243_74##6	A_N#4	1.3339e-19
C106	a_243_74##2	B#9	3.68539e-17
C107	a_243_74##4	B#6	2.01768e-19
C108	VGND#8	B#9	3.24576e-17
C109	a_31_74##11	a_31_74##5	1.34602e-17
C110	Y#1	VPWR#7	1.66665e-18
C111	VPWR#2	B#4	3.60362e-18
C112	a_243_74##2	B#10	1.22969e-18
C113	a_243_74##4	B#9	1.07829e-18
C114	VPWR#8	a_31_74##4	1.88436e-18
C115	B#10	VGND#8	1.99223e-17
C116	A_N#9	a_31_74##5	1.07844e-18
C117	Y#5	B#9	1.30354e-19
C118	a_31_74##11	A_N#4	4.70168e-19
C119	a_243_74##2	a_31_74#	1.25116e-19
C120	a_243_74##4	B#10	4.66189e-17
C121	VPWR#2	B#7	1.67314e-17
C122	VGND#8	a_31_74#	5.13737e-19
C123	Y#5	B#10	2.67261e-19
C124	a_243_74##2	a_31_74##7	8.62458e-20
C125	a_243_74##4	a_31_74#	4.3835e-17
C126	VPWR#2	a_31_74##6	3.08588e-17
C127	VGND#8	a_31_74##7	2.33274e-19
C128	a_31_74#	Y#5	1.73701e-17
C129	VPWR#8	Y#4	1.03536e-16
C130	a_243_74##4	a_31_74##7	7.5565e-19
C131	VPWR#4	a_31_74##8	4.2039e-18
C132	VGND#8	a_31_74##9	5.38947e-20
C133	a_31_74##7	Y#5	2.126e-17
C134	VPWR#2	a_31_74##8	9.10915e-19
C135	Y#3	a_31_74#	1.98384e-19
C136	a_31_74##7	a_243_74##8	1.44708e-17
C137	a_31_74##13	VPWR#8	5.86081e-17
C138	B	B#8	1.57157e-17
C139	B	B#5	1.88895e-17
C140	VGND#8	a_31_74##5	4.09443e-20
C141	Y#5	a_31_74##9	7.69883e-19
C142	B	B#2	3.23854e-17
C143	VPWR#4	A_N#1	4.72424e-18
C144	B	a_31_74##4	1.24862e-19
C145	Y#3	a_31_74##7	4.53521e-19
C146	VPWR#9	VPWR#8	6.39656e-18
C147	A_N#2	a_31_74##13	6.26884e-19
C148	VGND#9	a_31_74#	3.05036e-20
C149	a_31_74##9	a_243_74##8	1.44708e-17
C150	a_31_74##11	a_31_74##6	2.97956e-19
C151	a_243_74##6	a_31_74##4	3.29609e-18
C152	Y#5	a_31_74##5	2.02786e-19
C153	VPWR#9	a_31_74##13	6.77479e-17
C154	Y#3	a_31_74##9	1.77521e-17
C155	VGND#9	a_31_74##7	2.14701e-20
C156	a_243_74##7	a_31_74##9	6.00248e-19
C157	Y#3	a_31_74##5	3.23588e-17
C158	a_31_74##11	a_31_74##8	5.70791e-19
C159	B#10	VPWR#7	4.62499e-19
C160	VGND#9	a_31_74##9	3.75297e-20
C161	a_243_74##7	a_31_74##5	3.37684e-17
C162	Y#3	A_N#4	1.14619e-18
C163	VGND#9	a_31_74##5	1.10445e-18
C164	a_31_74##11	A_N#1	1.43174e-17
C165	a_243_74##7	A_N#4	2.09121e-18
C166	A_N#2	VPWR#9	1.6667e-17
C167	a_31_74##12	a_31_74##5	6.14214e-19
C168	B#6	B#1	5.44727e-18
C169	VGND#4	VGND#3	3.71897e-17
C170	VGND#9	A_N#4	4.32158e-17
C171	VPWR#3	VPWR#4	4.13877e-17
C172	a_31_74##11	A_N#5	8.70584e-19
C173	a_31_74##12	A_N#4	3.37016e-17
C174	VPWR#3	VPWR#2	8.82294e-17
C175	B#9	B#6	3.81541e-17
C176	Y	B#8	1.70984e-17
C177	Y	B#5	6.23202e-18
C178	B#10	B#9	2.87425e-17
C179	Y	a_31_74##4	2.95338e-18
C180	B#4	VPWR#1	3.47905e-17
C181	VGND#4	a_243_74##6	6.38129e-17
C182	Y#2	B#8	5.28375e-18
C183	Y#1	B#4	5.72137e-17
C184	VPWR#1	B#7	1.40122e-18
C185	a_31_74#	B#10	3.62957e-17
C186	Y#1	B#7	6.92095e-17
C187	Y#2	B#5	2.402e-19
C188	a_31_74##3	VPWR#4	2.96547e-19
C189	Y#3	A_N#1	1.64635e-18
C190	B#7	VPWR#7	1.4018e-17
C191	Y#1	a_31_74##6	4.66208e-19
C192	a_243_74##7	A_N#1	5.34181e-19
C193	Y#4	B#7	4.88445e-19
C194	a_31_74##7	a_31_74#	2.03598e-17
C195	a_31_74##6	VPWR#7	3.9027e-17
C196	Y#2	B#2	1.55467e-19
C197	Y#4	a_31_74##6	9.45351e-17
C198	VPWR	a_31_74##4	4.31262e-20
C199	VPWR	A_N#2	1.22246e-20
C200	VPWR#8	a_31_74##6	3.16036e-18
C201	a_31_74##9	a_31_74##7	3.61443e-17
C202	Y#2	a_31_74##3	7.94929e-17
C203	a_31_74##8	Y#4	2.5412e-17
C204	Y#2	a_31_74##4	2.86223e-17
C205	VPWR#8	a_31_74##8	6.5027e-17
C206	a_243_74#	B#3	7.25485e-18
C207	VGND#4	a_243_74##4	3.55932e-17
C208	a_31_74##5	a_31_74##9	3.50136e-17
C209	B#3	VGND#7	5.1522e-18
C210	a_31_74##13	a_31_74##8	1.27426e-18
C211	a_243_74##2	B#3	1.99508e-17
C212	A_N#1	VPWR#8	1.78283e-17
C213	VPWR#9	a_31_74##8	1.53901e-18
C214	a_31_74##13	A_N#1	4.59639e-17
C215	A_N#4	a_31_74##5	3.39378e-18
C216	VPWR#8	A_N#5	1.87475e-18
C217	VPWR#9	A_N#1	1.63956e-18
C218	VPWR#3	VPWR#1	2.86955e-17
C219	a_31_74##13	A_N#5	3.90313e-17
C220	VGND	B#8	1.23712e-19
C221	VGND	B#5	1.10089e-19
C222	Y#2	A_N#2	2.67554e-20
C223	VGND	a_31_74##4	7.68656e-21
C224	A_N#5	VPWR#9	2.81929e-17
C225	B#10	B#8	1.12822e-18
C226	VGND	A_N#2	1.07134e-18
C227	Y#4	VPWR#3	2.25987e-17
C228	a_31_74##11	a_31_74##4	1.01143e-18
C229	Y#3	a_31_74##3	2.73096e-17
C230	B#3	Y#1	2.6845e-17
C231	a_31_74##4	B#10	2.53506e-17
C232	B#7	B#4	4.34376e-17
C233	A_N#3	VGND#9	2.39369e-19
C234	a_31_74##5	A_N#1	1.32862e-17
C235	a_31_74##12	A_N#3	1.95606e-17
C236	a_31_74##3	Y#4	8.79741e-17
C237	B#8	VNB	2.49417e-17
C238	B#5	VNB	5.41979e-17
C239	a_31_74##3	VPWR#8	3.62318e-17
C240	a_31_74##11	A_N#2	2.30019e-17
C241	B#2	VNB	5.58985e-17
C242	Y#2	B	6.2646e-18
C243	a_31_74##4	VNB	7.83477e-17
C244	a_31_74##6	B#7	1.12108e-18
C245	A_N#2	VNB	1.27414e-16
C246	VGND#4	a_31_74#	4.4854e-18
C247	VGND#4	a_31_74##7	4.47052e-18
C248	a_31_74##8	a_31_74##6	1.10477e-17
C249	B	a_243_74#	6.61876e-17
C250	A_N#3	VPWR#9	2.18183e-17
C251	VGND#4	a_31_74##9	4.4153e-18
C252	B	VGND#7	4.9106e-18
C253	B	a_243_74##2	5.97342e-17
C254	a_31_74##3	B#10	5.63984e-18
C255	Y	VPWR#2	1.41234e-16
C256	A_N#1	a_31_74##8	2.71464e-17
C257	Y#2	Y	3.53663e-18
C258	A_N#5	A_N#1	3.67881e-17
C259	VPWR#3	a_31_74##6	1.77808e-18
C260	VPWR	VPWR#4	2.668e-17
C261	VPWR	VPWR#2	1.50048e-16
C262	B	VPWR#1	4.69133e-17
C263	B	Y#1	3.43961e-17
C264	B#3	B#7	3.23237e-18
C265	B	VPWR#7	9.86241e-18
C266	a_243_74##2	Y	2.86971e-18
C267	VPWR	a_31_74##11	1.66091e-18
C268	VGND	VGND#3	1.95523e-17
C269	VPWR	A_N#9	2.22157e-18
C270	A_N#9	a_31_74##4	1.58553e-19
C271	VPWR	A_N#6	6.91892e-18
C272	VGND	a_243_74##6	2.90381e-17
C273	VGND	Y#2	7.74844e-18
C274	VGND	a_31_74##11	8.55636e-18
C275	Y	VPWR#7	2.54573e-17
C276	VGND	A_N#9	3.25458e-18
C277	VGND#3	VNB	2.87403e-17
C278	VGND	A_N#6	4.19741e-18
C279	VGND	a_243_74#	1.80977e-17
C280	VPWR	VPWR#1	3.88026e-17
C281	VGND	a_243_74##2	1.90809e-17
C282	VPWR#4	VNB	3.23188e-17
C283	VPWR	Y#1	1.70419e-17
C284	VPWR#2	VNB	7.4918e-17
C285	VGND	VGND#8	1.5737e-17
C286	VGND	a_243_74##4	2.3239e-17
C287	VPWR	Y#4	2.67069e-17
C288	VGND	Y#5	7.69588e-18
C289	B	B#4	5.84172e-18
C290	a_243_74##6	VNB	5.59625e-18
C291	VPWR	VPWR#8	2.10141e-17
C292	Y	B#10	1.22083e-17
C293	VGND	Y#3	7.16059e-18
C294	VPWR	a_31_74##13	1.3475e-17
C295	Y#2	VNB	4.67187e-18
C296	VGND	a_243_74##7	1.84564e-17
C297	a_31_74##11	VNB	1.11441e-17
C298	B	a_31_74##6	1.66483e-19
C299	A_N#9	VNB	6.86966e-18
C300	VGND	a_31_74##12	1.58806e-17
C301	A_N#9	A_N#2	2.54507e-17
C302	A_N#6	VNB	2.90639e-17
C303	a_243_74#	VNB	4.13472e-17
C304	VGND	Y#4	3.4462e-20
C305	a_243_74##2	VNB	3.13936e-18
C306	VGND#8	VNB	1.16531e-18
C307	a_243_74##4	VNB	3.04689e-18
C308	Y	B#4	8.49545e-19
C309	Y#3	VNB	1.24356e-18
C310	VGND	B#1	8.40565e-19
C311	Y	B#7	3.14046e-18
C312	VPWR	a_31_74##5	1.5938e-19
C313	a_243_74##7	VNB	8.9314e-18
C314	VGND#9	VNB	7.0647e-18
C315	Y	a_31_74##6	2.36408e-18
C316	VGND	B#9	3.66207e-19
C317	a_31_74##12	VNB	4.10427e-17
C318	VPWR#1	VNB	7.64605e-17
C319	VGND	B#10	1.2178e-19
C320	Y	a_31_74##8	5.32155e-19
C321	Y#1	VNB	3.06498e-18
C322	VGND	a_31_74#	1.41854e-18
C323	VPWR	B#4	1.85312e-18
C324	Y	A_N#1	2.69863e-19
C325	VGND	a_31_74##7	1.49053e-18
C326	Y#4	VNB	7.58591e-18
C327	VPWR#8	VNB	5.37361e-18
C328	VGND	a_31_74##9	1.50758e-18
C329	Y	A_N#5	8.52851e-20
C330	a_31_74##13	VNB	3.71616e-18
C331	VPWR	a_31_74##6	1.01031e-18
C332	VGND	a_31_74##5	2.16588e-18
C333	VPWR#9	VNB	5.13779e-17
C334	VGND	A_N#4	1.65485e-18
C335	VPWR	a_31_74##8	2.95212e-18
C336	B#1	VNB	3.3197e-17
C337	B#6	VNB	2.85152e-17
C338	VPWR	A_N#1	6.73436e-18
C339	B#9	VNB	2.43254e-17
C340	B#10	VNB	4.23439e-17
C341	VPWR	A_N#5	7.22581e-18
C342	a_31_74#	VNB	2.59732e-17
C343	a_31_74##7	VNB	2.5978e-17
C344	a_31_74##9	VNB	2.55249e-17
C345	VPWR	VPWR#3	1.23511e-17
C346	a_31_74##5	VNB	4.19101e-17
C347	a_31_74##3	Y	2.33602e-17
C348	A_N#4	VNB	3.67098e-17
C349	VPWR	B#3	1.59047e-18
C350	B#4	VNB	4.09896e-17
C351	B#7	VNB	3.21533e-17
C352	VPWR	a_31_74##3	5.4796e-18
C353	a_31_74##6	VNB	3.20598e-17
C354	VPWR#4	VPWR#2	6.27913e-19
C355	a_31_74##8	VNB	3.67455e-17
C356	VGND	VGND#4	2.60066e-17
C357	VPWR	A_N#3	1.29735e-18
C358	A_N#1	VNB	4.25169e-17
C359	VGND	B#3	1.89575e-18
C360	A_N#5	VNB	3.75603e-17
C361	VGND	a_31_74##3	5.30526e-18
C362	VPWR#3	VNB	2.48202e-16
C363	VGND	A_N#3	1.22297e-18
C364	Y	B	7.42993e-17
C365	VGND#4	VNB	2.77816e-16
C366	B#3	VNB	1.581e-18
C367	VPWR	B	8.39855e-18
C368	a_31_74##3	VNB	2.43971e-18
C369	A_N#3	VNB	1.49178e-18
C370	VGND	B	1.01639e-17
C371	VPWR	Y	9.05704e-18
C372	B	VNB	3.66805e-17
C373	VGND	Y	2.7543e-18
C374	Y	VNB	4.11375e-18
C375	VPWR	VNB	7.04312e-17
C376	VGND	VNB	7.37591e-17
C377	VGND#5	a_243_74##6	8.30907e-18
C378	VGND#2	B#2	9.85882e-19
C379	VPWR#5	A_N#5	3.4521e-18
C380	VGND#2	a_243_74#	9.18035e-17
C381	VPWR#5	A_N#2	6.80498e-19
C382	VPWR#5	VPWR#8	2.75584e-18
C383	VGND#2	VGND#7	1.74688e-17
C384	VPWR#5	VNB	6.84909e-17
C385	VGND#2	a_243_74##2	8.15808e-17
C386	VGND#5	a_31_74##11	3.00793e-18
C387	a_31_74##13	VPWR#5	3.3073e-18
C388	VGND	VGND#2	8.15179e-17
C389	VGND#5	A_N#1	6.96367e-21
C390	VGND#5	a_31_74##4	5.91869e-20
C391	VGND#5	a_243_74##7	3.97825e-17
C392	VGND#8	VGND#2	1.71376e-18
C393	VGND#3	VGND#2	9.91094e-19
C394	VPWR#3	VPWR#5	6.16264e-17
C395	VGND#2	B#1	2.12218e-17
C396	VGND#2	VNB	6.44066e-17
C397	VGND#5	a_31_74#	2.46912e-20
C398	VGND	VGND#5	6.78374e-17
C399	VPWR#5	a_31_74##8	1.45381e-18
C400	VGND#2	B#6	1.78062e-17
C401	VGND#5	A_N#2	9.91412e-19
C402	VGND#5	a_31_74##12	1.78605e-17
C403	VGND#5	a_31_74##7	3.01589e-20
C404	VGND#5	VNB	7.04872e-17
C405	A_N#6	VPWR#5	2.1041e-18
C406	VGND#4	VGND#5	7.81166e-17
C407	VGND#5	A_N#6	6.06509e-19
C408	VGND#5	a_31_74##9	1.2406e-19
C409	VGND#2	B#9	1.17707e-18
C410	VGND#5	a_31_74##5	5.19541e-18
C411	VPWR	VPWR#5	8.39588e-17
C412	VGND#2	B	6.7361e-19
C413	VGND#2	B#5	2.44603e-18
C414	VPWR#5	VPWR#4	9.1939e-19
C415	VGND#4	VGND#2	6.83883e-17
C416	VGND#5	A_N#4	4.04309e-18
*
*
.ENDS sky130_fd_sc_hs__nand2b_4
*
