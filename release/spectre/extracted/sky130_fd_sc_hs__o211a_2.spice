* Extracted by Quantus, converted by sky130cad/quantus.py
*
*
*
*                       LINUX           Wed Nov 18 08:53:48 2026
*
*
*
*  PROGRAM  advgen
*
*  Name           : advgen - Quantus - (64-bit)
*  Version        : 25.1.0-p047
*  Build Date     : Thu Dec 11 23:20:30 PST 2025
*
*  HSPICE LIBRARY
*
*  OPERATING_TEMPERATURE 150
*  QRC_TECH_DIR <path>/tech
*
*
*

*
.SUBCKT sky130_fd_sc_hs__o211a_2 VNB VPB VGND VPWR X C1 B1 A2 A1
*
*
*  caps2d version: 10
*
*
*       TRANSISTOR CARDS
*
*
XM6 a_27_368##13 C1#1 a_117_74# VNB sky130_fd_pr__nfet_01v8_lvt l=0.15 w=0.74 ad=0.2109 as=0.1776 pd=2.05 ps=1.96
XM5 a_117_74# B1#3 a_195_74##2 VNB sky130_fd_pr__nfet_01v8_lvt l=0.15 w=0.74 ad=0.1776 as=0.2664 pd=1.96 ps=2.2
XM0 a_195_74##2 A2#3 VGND#7 VNB sky130_fd_pr__nfet_01v8_lvt l=0.15 w=0.74 ad=0.2664 as=0.3502 pd=2.2 ps=2.66
XM7 VGND#7 A1#1 a_195_74# VNB sky130_fd_pr__nfet_01v8_lvt l=0.15 w=0.74 ad=0.3502 as=0.1998 pd=2.66 ps=2.02
XM1 X#2 a_27_368##7 VGND#6 VNB sky130_fd_pr__nfet_01v8_lvt l=0.15 w=0.74 ad=0.2072 as=0.1998 pd=2.04 ps=2.02
XM2 VGND#1 a_27_368# X#2 VNB sky130_fd_pr__nfet_01v8_lvt l=0.15 w=0.74 ad=0.1998 as=0.2072 pd=2.02 ps=2.04
XM3 a_27_368##11 C1#4 VPWR#7 VPB sky130_fd_pr__pfet_01v8 l=0.15 w=1 ad=0.285 as=0.39 pd=2.57 ps=2.78
XM9 VPWR#7 B1#1 a_27_368##9 VPB sky130_fd_pr__pfet_01v8 l=0.15 w=1 ad=0.39 as=0.31 pd=2.78 ps=2.62
XM11 a_27_368##9 A2#1 a_314_368# VPB sky130_fd_pr__pfet_01v8 l=0.15 w=1 ad=0.31 as=0.32 pd=2.62 ps=2.64
XM8 a_314_368# A1#3 VPWR#6 VPB sky130_fd_pr__pfet_01v8 l=0.15 w=1 ad=0.32 as=0.7518 pd=2.64 ps=3.68
XM4 X#1 a_27_368##8 VPWR#6 VPB sky130_fd_pr__pfet_01v8 l=0.15 w=1.12 ad=0.336 as=0.7518 pd=2.84 ps=3.68
XM10 VPWR#1 a_27_368##6 X#1 VPB sky130_fd_pr__pfet_01v8 l=0.15 w=1.12 ad=0.3864 as=0.336 pd=2.93 ps=2.84
*
*
*       RESISTOR AND CAP/DIODE CARDS
*
Rg1	C1#1	C1#2	322.953644
Rg2	C1#2	C1#3	26.659500
Rg3	C1#2	C1#4	472.643829
Rg4	B1#1	B1#2	400.207520
Rg5	B1#2	B1#3	382.539734
Rg6	A2#1	A2#2	401.956665
Rg7	A2#2	A2#3	515.488770
Rg8	A1#1	A1#2	374.507996
Rg9	A1#2	A1#3	392.175781
Rg10	a_27_368#	a_27_368##2	325.648071
Rg11	a_27_368##2	a_27_368##3	49.989902
Rg12	a_27_368##3	a_27_368##4	23.974180
Rg13	a_27_368##4	a_27_368##5	173.816727
Rg14	a_27_368##2	a_27_368##6	508.786255
Rg15	a_27_368##3	a_27_368##7	315.399963
Rg16	a_27_368##4	a_27_368##8	414.368347
Rf1	C1	C1#3	163.775864
Rf2	B1#4	B1	1.907883
Rf3	B1#2	B1#6	162.140686
Rf4	B1#4	B1#6	7.334466
Rf5	A2#2	A2#5	162.380676
Rf6	A2#6	A2	2.147868
Rf7	A2#5	A2#6	5.500849
Rf8	A1#2	A1	166.137894
Rf9	a_195_74#	a_195_74##2	87.469986
Rf10	a_27_368##9	a_27_368##10	15.058337
Rf11	a_27_368##10	a_27_368##11	83.491539
Rf12	a_27_368##10	a_27_368##5	127.719604
Rf13	a_27_368##5	a_27_368##13	182.610840
Rf14	X#1	X	59.239845
Rf15	X	X#3	9.291110
Rf16	X#3	X	9.291110
Rf17	X#2	X#3	7.500000
Rf18	VGND#1	VGND#2	95.428093
Rf19	VGND#2	VGND#3	55.185940
Rf20	VGND#3	VGND#4	19.756451
Rf22	VGND#2	VGND#6	41.120300
Rf23	VGND#4	VGND#7	27.817997
Rf24	VPWR#1	VPWR#2	121.244644
Rf25	VPWR#2	VPWR#3	33.288174
Rf26	VPWR#3	VPWR#4	83.983536
Rf28	VPWR#2	VPWR#6	17.096312
Rf29	VPWR#4	VPWR#7	35.077789
Re1	VPWR#3	VPWR	1.227783
Re2	VGND	VGND#3	1.227829
*
*       CAPACITOR CARDS
*
*
C1	VGND	VNB	6.75872e-17
C2	VPWR	VNB	6.20541e-17
C3	a_195_74#	a_27_368##13	9.80513e-19
C4	X	VNB	1.71273e-17
C5	C1	VNB	2.09736e-17
C6	B1	VNB	6.16968e-18
C7	A2	VNB	3.55163e-18
C8	A1	VNB	6.81593e-18
C9	C1#3	VNB	5.86969e-17
C10	VGND	X	1.36696e-17
C11	B1#2	VNB	3.34908e-17
C12	A2#2	VNB	3.23183e-17
C13	A1#2	VNB	4.06764e-17
C14	VGND	C1	4.11812e-18
C15	a_27_368##5	VNB	1.03966e-16
C16	VGND#3	VNB	1.84937e-16
C17	VPWR#3	VNB	1.89664e-16
C18	VGND	B1	1.82009e-18
C19	C1#4	VNB	5.21404e-17
C20	B1#1	VNB	3.20141e-17
C21	VPWR	C1	2.63526e-18
C22	VGND	A2	1.64538e-18
C23	A2#1	VNB	2.97735e-17
C24	A1#3	VNB	3.04278e-17
C25	a_27_368##8	VNB	3.37474e-17
C26	VGND	A1	2.5755e-18
C27	a_27_368##6	VNB	4.31193e-17
C28	VPWR	B1	1.75043e-18
C29	C1#1	VNB	3.70578e-17
C30	B1#3	VNB	2.85389e-17
C31	A2#3	VNB	2.8611e-17
C32	VPWR	A2	1.58581e-18
C33	A1#1	VNB	3.05208e-17
C34	a_27_368##7	VNB	2.96961e-17
C35	a_27_368#	VNB	2.42667e-17
C36	a_27_368##11	VNB	5.06611e-17
C37	VPWR	A1	2.49286e-18
C38	VPWR#7	VNB	1.02863e-17
C39	a_27_368##9	VNB	2.65541e-18
C40	VPWR#6	VNB	5.30076e-18
C41	X#1	VNB	3.93283e-18
C42	VPWR#1	VNB	8.46532e-17
C43	C1	B1	3.21187e-17
C44	a_27_368##13	VNB	4.19368e-17
C45	a_195_74##2	VNB	2.64634e-18
C46	VGND	C1#3	6.64159e-19
C47	VGND#7	VNB	2.90954e-18
C48	a_195_74#	VNB	7.57723e-18
C49	VGND#6	VNB	4.85705e-18
C50	VGND	B1#2	1.88665e-18
C51	VGND#1	VNB	6.75231e-17
C52	a_195_74##2	VGND#7	3.35108e-17
C53	A2#5	VNB	1.60161e-18
C54	VGND	a_27_368##5	8.77156e-18
C55	VGND	VGND#3	1.05058e-17
C56	VGND#2	A1#1	1.34187e-18
C57	VGND#2	VNB	3.33512e-17
C58	VPWR	B1#2	1.79485e-18
C59	VPWR#2	VNB	3.90367e-17
C60	A2	A1	3.70867e-17
C61	VPWR	a_27_368##5	6.06839e-18
C62	VGND#1	VPWR#1	1.19263e-17
C63	VPWR	VPWR#3	1.58346e-17
C64	C1	C1#3	2.4304e-17
C65	VGND	C1#1	1.3808e-18
C66	VPWR	C1#4	7.37508e-18
C67	VGND	B1#3	1.55022e-18
C68	X	a_27_368##5	8.85078e-17
C69	VGND	A2#3	3.19842e-19
C70	VPWR	B1#1	5.49988e-18
C71	C1	B1#2	1.90731e-18
C72	a_195_74##2	a_195_74#	2.66601e-18
C73	VGND	A1#1	1.22426e-19
C74	VPWR	A2#1	9.42415e-18
C75	VGND	a_27_368##7	4.83274e-18
C76	C1	A2#2	6.65699e-19
C77	VPWR	A1#3	3.87163e-18
C78	VGND	a_27_368#	4.05212e-18
C79	B1	C1#3	8.89012e-18
C80	VPWR	a_27_368##8	3.88972e-18
C81	VGND	a_27_368##11	2.84256e-18
C82	C1	A1#2	3.21672e-19
C83	B1	B1#2	6.27285e-18
C84	VPWR	a_27_368##6	5.2605e-18
C85	C1	a_27_368##5	7.88057e-19
C86	VGND	X#1	2.39176e-18
C87	VGND#2	a_27_368##7	1.13806e-17
C88	VGND	VPWR#1	3.84604e-18
C89	VGND	a_27_368##13	3.18228e-17
C90	X	A1#3	7.81898e-20
C91	VGND	a_195_74##2	1.71543e-17
C92	A2	A2#2	5.16543e-18
C93	VGND	VGND#7	1.4493e-17
C94	X	a_27_368##6	1.71815e-18
C95	VGND	a_195_74#	1.84805e-17
C96	VPWR	a_27_368##11	1.54497e-17
C97	A2	A1#2	5.21109e-18
C98	a_195_74#	VGND#7	2.3339e-17
C99	VGND	VGND#1	3.50783e-17
C100	a_27_368##5	A2	1.55644e-17
C101	VPWR	a_27_368##9	1.45488e-17
C102	A1	A2#2	2.15755e-18
C103	X	B1#3	2.26589e-19
C104	X	A2#3	2.55173e-19
C105	B1	C1#4	4.3206e-18
C106	A1	A1#2	1.67454e-17
C107	VPWR	X#1	1.87894e-17
C108	VGND	A2#5	1.85506e-18
C109	X	A1#1	9.98633e-19
C110	a_27_368##10	VPWR#7	1.90118e-17
C111	VPWR	VPWR#1	3.8095e-17
C112	X	a_27_368##7	1.80618e-17
C113	A1	a_27_368##5	9.00764e-17
C114	X	a_27_368#	1.23929e-17
C115	VGND#2	a_27_368#	8.80813e-19
C116	VGND	VGND#2	4.14673e-17
C117	VGND#7	VGND#6	1.17193e-18
C118	A2	A1#3	1.15437e-18
C119	C1	a_27_368##11	2.07087e-17
C120	VPWR	A2#5	1.63572e-18
C121	A2#2	a_314_368#	2.74109e-19
C122	A1	A2#1	1.47432e-19
C123	a_27_368##10	a_27_368##9	4.23577e-18
C124	A1	A1#3	2.10691e-18
C125	VPWR	a_27_368##10	8.30393e-18
C126	a_195_74#	VGND#6	4.09741e-17
C127	C1#3	B1#2	3.49238e-17
C128	VGND#6	X	3.37261e-17
C129	X	X#2	1.99488e-18
C130	X	VGND#1	5.88231e-17
C131	B1	a_27_368##11	1.93469e-17
C132	a_27_368##13	C1	3.65217e-17
C133	VPWR	VPWR#2	7.26348e-17
C134	B1#2	A2#2	3.99287e-17
C135	a_27_368##5	C1#3	9.11545e-20
C136	a_27_368##13	B1	2.1674e-17
C137	a_27_368##5	B1#2	8.73357e-20
C138	A2#2	A1#2	2.93782e-17
C139	VGND#2	X	1.39567e-17
C140	a_27_368##5	A2#2	1.79278e-19
C141	A2#1	a_314_368#	2.62002e-17
C142	C1#1	a_117_74#	1.17975e-17
C143	VGND#6	X#2	7.78596e-18
C144	A1#3	a_314_368#	2.62002e-17
C145	B1#3	a_117_74#	1.76798e-18
C146	A1#2	a_27_368##5	4.62454e-17
C147	a_27_368##10	VPWR#6	1.05336e-17
C148	a_27_368##13	A2	8.70543e-18
C149	a_27_368##13	A2#5	2.76592e-17
C150	VPWR#3	A2#2	9.46788e-20
C151	VGND#3	A1#2	1.0088e-19
C152	C1#4	B1#2	2.05259e-18
C153	VGND#3	a_27_368##5	2.25038e-20
C154	VGND#6	VGND#1	1.41696e-18
C155	B1#2	B1#1	2.0236e-18
C156	B1#2	A2#1	5.97502e-19
C157	B1	a_27_368##10	8.39088e-18
C158	X#2	VGND#1	8.11776e-18
C159	a_27_368##5	C1#4	1.34023e-19
C160	a_27_368##5	B1#1	1.29859e-19
C161	C1#3	B1#3	3.50821e-18
C162	A2	a_27_368##10	2.51292e-17
C163	a_27_368##13	a_117_74#	3.30937e-18
C164	a_27_368##5	A2#1	2.52428e-19
C165	A1#3	a_27_368##5	1.30895e-18
C166	a_27_368##5	a_27_368##8	5.83186e-18
C167	a_27_368##13	a_27_368##10	5.85115e-18
C168	VPWR#3	A2#1	4.64955e-18
C169	A1	a_27_368##10	1.95018e-17
C170	a_27_368##5	a_27_368##6	3.17893e-18
C171	a_27_368##11	C1#3	3.92128e-18
C172	VPWR#3	A1#3	4.56087e-18
C173	C1#4	B1#1	2.87296e-17
C174	B1#2	VPWR#7	1.22474e-18
C175	B1#1	A2#1	3.97054e-17
C176	a_27_368##5	A1#1	2.38353e-17
C177	C1#3	a_27_368##13	1.05073e-17
C178	A2#2	a_27_368##9	2.37561e-19
C179	a_27_368##5	a_27_368##7	2.86995e-18
C180	A2#1	A1#3	4.00391e-17
C181	VGND#3	A1#1	5.19575e-18
C182	a_27_368##13	B1#2	3.27254e-17
C183	X#1	VPWR#2	1.50968e-17
C184	A1#3	a_27_368##8	9.75657e-18
C185	a_27_368##5	VPWR#7	6.11026e-21
C186	A1#2	VPWR#6	2.1237e-18
C187	a_195_74##2	B1#2	6.31587e-19
C188	a_27_368##13	A2#2	2.72072e-18
C189	VPWR#2	VPWR#1	8.39891e-19
C190	a_27_368##8	a_27_368##6	4.61117e-17
C191	a_27_368##5	VPWR#6	5.99775e-17
C192	a_195_74##2	A2#2	6.57166e-19
C193	a_27_368##10	a_314_368#	6.60641e-18
C194	a_27_368##5	X#1	3.1977e-17
C195	VGND#7	A2#2	7.08462e-19
C196	a_27_368##9	VPWR#3	1.62716e-18
C197	a_27_368##11	C1#4	5.79629e-17
C198	a_195_74#	A1#2	1.31419e-18
C199	C1#4	VPWR#7	3.6217e-17
C200	a_27_368##11	B1#1	1.52728e-18
C201	a_27_368##5	VGND#7	9.93348e-20
C202	a_27_368##9	C1#4	1.11035e-18
C203	B1#2	A2#5	3.47267e-17
C204	VGND#7	VGND#2	8.99564e-19
C205	VPWR#3	VPWR#1	2.95983e-17
C206	B1#1	VPWR#7	3.01161e-17
C207	a_27_368##5	a_195_74#	5.79964e-17
C208	a_27_368##11	A2#1	2.39699e-19
C209	a_27_368##9	B1#1	4.15564e-17
C210	a_27_368##5	VGND#6	2.69536e-17
C211	VPWR#6	C1#4	5.281e-19
C212	VPWR#7	A2#1	1.58129e-18
C213	C1#1	B1#3	4.63424e-17
C214	a_27_368##5	X#2	9.93736e-19
C215	A2#5	A2#2	1.26853e-17
C216	a_27_368##11	A1#3	2.0401e-19
C217	VGND#3	a_195_74#	1.48125e-17
C218	B1#2	a_27_368##10	3.04093e-17
C219	VGND#2	a_195_74#	4.51012e-18
C220	a_27_368##9	A2#1	4.77151e-17
C221	VPWR#6	B1#1	5.17017e-19
C222	VPWR#7	A1#3	6.66283e-19
C223	a_27_368##9	A1#3	4.45914e-18
C224	B1#3	A2#3	2.84314e-17
C225	VPWR#7	a_27_368##8	3.35188e-19
C226	VGND#3	VGND#1	2.7972e-17
C227	VPWR#6	A2#1	4.90289e-18
C228	a_27_368##10	A2#2	2.52888e-18
C229	X#1	A2#1	1.70102e-19
C230	a_27_368##9	a_27_368##8	2.29725e-19
C231	VPWR#6	A1#3	6.20672e-17
C232	A2#3	A1#1	2.27453e-17
C233	a_27_368##10	A1#2	1.69111e-19
C234	X#1	A1#3	1.61486e-18
C235	a_27_368##8	VPWR#6	2.60598e-17
C236	X#1	a_27_368##8	5.47648e-17
C237	VPWR#6	a_27_368##6	7.94654e-19
C238	a_27_368##5	a_27_368##10	3.4679e-18
C239	A1#1	a_27_368##7	5.59296e-18
C240	VGND#2	VGND#1	1.4097e-18
C241	VGND#2	A1#2	4.14856e-20
C242	VPWR#1	a_27_368##8	1.38618e-18
C243	X#1	a_27_368##6	5.74553e-17
C244	VPWR#1	a_27_368##6	3.47273e-17
C245	a_27_368##7	a_27_368#	3.72314e-17
C246	VGND#2	a_27_368##5	1.71083e-18
C247	A2#5	a_27_368##10	2.84895e-17
C248	a_27_368##10	VPWR#3	2.36075e-18
C249	a_27_368##5	VPWR#2	4.06044e-19
C250	VGND#3	VGND#2	3.87032e-17
C251	a_27_368##13	C1#1	4.6336e-17
C252	A2#5	B1#1	7.07136e-19
C253	a_27_368##11	VPWR#7	6.77452e-17
C254	a_27_368##13	B1#3	3.20365e-17
C255	a_195_74##2	C1#1	3.30483e-18
C256	a_27_368##11	a_27_368##9	3.20182e-18
C257	A2#5	A2#1	1.99526e-18
C258	a_27_368##13	A2#3	1.67011e-17
C259	VGND#7	C1#1	7.49826e-19
C260	VPWR#3	VPWR#2	4.80541e-17
C261	B1#3	a_195_74##2	1.69705e-17
C262	VPWR#7	a_27_368##9	5.20369e-17
C263	a_27_368##10	B1#1	1.71602e-17
C264	a_27_368##13	A1#1	6.50562e-19
C265	VGND#7	B1#3	1.23905e-18
C266	a_195_74##2	A2#3	4.84113e-17
C267	a_27_368##13	a_27_368##7	4.49375e-19
C268	A2#3	VGND#7	2.44031e-17
C269	a_27_368##10	A2#1	1.68017e-17
C270	VPWR#7	VPWR#6	2.91497e-18
C271	a_195_74##2	A1#1	5.33964e-19
C272	a_195_74#	A2#3	8.74992e-19
C273	A1#1	VGND#7	2.28641e-17
C274	a_27_368##9	VPWR#6	1.90281e-17
C275	a_27_368##10	A1#3	2.80991e-17
C276	VGND#6	A2#3	9.69859e-20
C277	a_27_368##13	a_27_368##11	5.24933e-19
C278	a_195_74#	A1#1	5.50834e-17
C279	a_27_368##9	X#1	1.34382e-18
C280	VGND#7	a_27_368##7	7.35103e-19
C281	VGND#6	A1#1	1.45793e-18
C282	a_195_74#	a_27_368##7	9.8994e-19
C283	a_27_368##7	VGND#6	1.77941e-17
C284	VPWR#6	X#1	6.47863e-17
C285	VGND#1	A1#1	1.46867e-19
C286	X#2	a_27_368##7	1.70499e-17
C287	VPWR#6	VPWR#1	2.247e-18
C288	VGND#6	a_27_368#	4.1105e-19
C289	VGND#1	a_27_368##7	3.5622e-18
C290	a_27_368#	X#2	1.56399e-18
C291	X#1	VPWR#1	1.09454e-16
C292	VGND#1	a_27_368#	4.12832e-17
C293	VPWR#2	a_27_368##8	7.93312e-18
C294	VPWR#2	a_27_368##6	7.58205e-19
C295	a_27_368##13	a_195_74##2	8.82317e-17
C296	a_27_368##13	VGND#7	3.01254e-19
C297	VGND#2	A2#3	1.56284e-19
C298	VGND#3	VGND#4	7.65023e-17
C299	VGND#4	B1#2	7.17804e-20
C300	VGND#4	a_195_74##2	2.08658e-17
C301	VPWR#4	VPWR#2	6.94812e-19
C302	VPWR#4	A2#2	2.79793e-20
C303	VPWR#4	C1#4	2.1707e-18
C304	VGND#4	VGND#2	1.6011e-19
C305	a_27_368##9	VPWR#4	9.26735e-18
C306	VGND#4	C1#1	5.36658e-18
C307	VGND#4	VNB	6.511e-17
C308	VPWR#4	C1#3	2.16423e-19
C309	VPWR#3	VPWR#4	5.91896e-17
C310	VPWR#4	B1#1	2.01248e-18
C311	VGND#4	a_27_368##13	3.91139e-17
C312	VPWR#4	a_27_368##8	1.45011e-19
C313	a_27_368##10	VPWR#4	1.70755e-19
C314	VGND#4	C1	9.05704e-19
C315	VPWR#4	VNB	5.53554e-17
C316	VGND#4	B1#3	5.82319e-18
C317	VPWR	VPWR#4	6.11855e-17
C318	a_27_368##11	VPWR#4	1.39365e-17
C319	VGND#4	C1#3	5.73056e-19
C320	VGND	VGND#4	4.31386e-17
C321	VGND#4	A2#3	2.54967e-18
*
*
.ENDS sky130_fd_sc_hs__o211a_2
*
