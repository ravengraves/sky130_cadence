* Extracted by Quantus, converted by sky130cad/quantus.py
*
*
*
*                       LINUX           Wed Nov 18 08:07:35 2026
*
*
*
*  PROGRAM  advgen
*
*  Name           : advgen - Quantus - (64-bit)
*  Version        : 25.1.0-p047
*  Build Date     : Thu Dec 11 23:20:30 PST 2025
*
*  HSPICE LIBRARY
*
*  OPERATING_TEMPERATURE 150
*  QRC_TECH_DIR <path>/tech
*
*
*

*
.SUBCKT sky130_fd_sc_hs__a221oi_4 VPB VNB VGND VPWR Y C1 B1 B2 A2 A1
*
*
*  caps2d version: 10
*
*
*       TRANSISTOR CARDS
*
*
XM38 Y#15 C1#14 VGND#15 VNB sky130_fd_pr__nfet_01v8_lvt l=0.15 w=0.74 ad=0.1961 as=0.2072 pd=2.01 ps=2.04
XM28 VGND#15 C1#12 Y#14 VNB sky130_fd_pr__nfet_01v8_lvt l=0.15 w=0.74 ad=0.2072 as=0.2072 pd=2.04 ps=2.04
XM34 Y#14 C1#10 VGND#14 VNB sky130_fd_pr__nfet_01v8_lvt l=0.15 w=0.74 ad=0.2072 as=0.2072 pd=2.04 ps=2.04
XM22 VGND#14 C1#1 Y#13 VNB sky130_fd_pr__nfet_01v8_lvt l=0.15 w=0.74 ad=0.2072 as=0.1961 pd=2.04 ps=2.01
XM24 a_534_74##6 A2#12 VGND#13 VNB sky130_fd_pr__nfet_01v8_lvt l=0.15 w=0.74 ad=0.1961 as=0.2072 pd=2.01 ps=2.04
XM30 VGND#13 A2#10 a_534_74##8 VNB sky130_fd_pr__nfet_01v8_lvt l=0.15 w=0.74 ad=0.2072 as=0.2072 pd=2.04 ps=2.04
XM35 VGND#9 A2#8 a_534_74##8 VNB sky130_fd_pr__nfet_01v8_lvt l=0.15 w=0.74 ad=0.2072 as=0.2072 pd=2.04 ps=2.04
XM20 a_534_74##3 A2#7 VGND#9 VNB sky130_fd_pr__nfet_01v8_lvt l=0.15 w=0.74 ad=0.2072 as=0.2072 pd=2.04 ps=2.04
XM9 Y#12 A1#13 a_534_74##3 VNB sky130_fd_pr__nfet_01v8_lvt l=0.15 w=0.74 ad=0.2072 as=0.2072 pd=2.04 ps=2.04
XM2 a_534_74##7 A1#10 Y#12 VNB sky130_fd_pr__nfet_01v8_lvt l=0.15 w=0.74 ad=0.2072 as=0.2072 pd=2.04 ps=2.04
XM17 Y#1 A1#8 a_534_74##7 VNB sky130_fd_pr__nfet_01v8_lvt l=0.15 w=0.74 ad=0.2072 as=0.2072 pd=2.04 ps=2.04
XM25 a_534_74# A1#6 Y#1 VNB sky130_fd_pr__nfet_01v8_lvt l=0.15 w=0.74 ad=0.1961 as=0.2072 pd=2.01 ps=2.04
XM31 a_1326_74##7 B1#13 Y#9 VNB sky130_fd_pr__nfet_01v8_lvt l=0.15 w=0.74 ad=0.1961 as=0.2072 pd=2.01 ps=2.04
XM3 Y#9 B1#11 a_1326_74##5 VNB sky130_fd_pr__nfet_01v8_lvt l=0.15 w=0.74 ad=0.2072 as=0.2072 pd=2.04 ps=2.04
XM39 Y#11 B1#9 a_1326_74##5 VNB sky130_fd_pr__nfet_01v8_lvt l=0.15 w=0.74 ad=0.2072 as=0.2072 pd=2.04 ps=2.04
XM10 a_1326_74##3 B1#1 Y#11 VNB sky130_fd_pr__nfet_01v8_lvt l=0.15 w=0.74 ad=0.2072 as=0.2072 pd=2.04 ps=2.04
XM19 VGND#8 B2#10 a_1326_74##3 VNB sky130_fd_pr__nfet_01v8_lvt l=0.15 w=0.74 ad=0.2072 as=0.2072 pd=2.04 ps=2.04
XM14 a_1326_74##8 B2#8 VGND#8 VNB sky130_fd_pr__nfet_01v8_lvt l=0.15 w=0.74 ad=0.2072 as=0.2072 pd=2.04 ps=2.04
XM11 VGND#7 B2#6 a_1326_74##8 VNB sky130_fd_pr__nfet_01v8_lvt l=0.15 w=0.74 ad=0.2072 as=0.2072 pd=2.04 ps=2.04
XM7 a_1326_74# B2#5 VGND#7 VNB sky130_fd_pr__nfet_01v8_lvt l=0.15 w=0.74 ad=0.1961 as=0.2072 pd=2.01 ps=2.04
XM21 Y#7 C1#8 a_114_368##6 VPB sky130_fd_pr__pfet_01v8 l=0.15 w=1.12 ad=0.308 as=0.336 pd=2.79 ps=2.84
XM15 Y#18 C1#13 a_114_368##6 VPB sky130_fd_pr__pfet_01v8 l=0.15 w=1.12 ad=0.336 as=0.336 pd=2.84 ps=2.84
XM0 a_114_368##10 C1#11 Y#18 VPB sky130_fd_pr__pfet_01v8 l=0.15 w=1.12 ad=0.336 as=0.336 pd=2.84 ps=2.84
XM1 a_114_368##10 C1#9 Y#19 VPB sky130_fd_pr__pfet_01v8 l=0.15 w=1.12 ad=0.336 as=0.308 pd=2.84 ps=2.79
XM5 a_531_368##10 A2#6 VPWR#9 VPB sky130_fd_pr__pfet_01v8 l=0.15 w=1.12 ad=0.308 as=0.336 pd=2.79 ps=2.84
XM32 VPWR#9 A2#11 a_531_368##16 VPB sky130_fd_pr__pfet_01v8 l=0.15 w=1.12 ad=0.336 as=0.336 pd=2.84 ps=2.84
XM27 VPWR#8 A2#9 a_531_368##16 VPB sky130_fd_pr__pfet_01v8 l=0.15 w=1.12 ad=0.336 as=0.336 pd=2.84 ps=2.84
XM8 a_531_368##15 A2#1 VPWR#8 VPB sky130_fd_pr__pfet_01v8 l=0.15 w=1.12 ad=0.336 as=0.336 pd=2.84 ps=2.84
XM16 VPWR#7 A1#14 a_531_368##15 VPB sky130_fd_pr__pfet_01v8 l=0.15 w=1.12 ad=0.336 as=0.336 pd=2.84 ps=2.84
XM37 a_531_368##14 A1#11 VPWR#7 VPB sky130_fd_pr__pfet_01v8 l=0.15 w=1.12 ad=0.336 as=0.336 pd=2.84 ps=2.84
XM23 VPWR#6 A1#7 a_531_368##14 VPB sky130_fd_pr__pfet_01v8 l=0.15 w=1.12 ad=0.5936 as=0.336 pd=3.3 ps=2.84
XM13 a_531_368##5 A1#1 VPWR#6 VPB sky130_fd_pr__pfet_01v8 l=0.15 w=1.12 ad=0.336 as=0.5936 pd=2.84 ps=3.3
XM4 a_531_368##5 B1#7 a_114_368##9 VPB sky130_fd_pr__pfet_01v8 l=0.15 w=1.12 ad=0.336 as=0.336 pd=2.84 ps=2.84
XM29 a_114_368##9 B1#12 a_531_368##13 VPB sky130_fd_pr__pfet_01v8 l=0.15 w=1.12 ad=0.336 as=0.336 pd=2.84 ps=2.84
XM6 a_531_368##13 B1#10 a_114_368##8 VPB sky130_fd_pr__pfet_01v8 l=0.15 w=1.12 ad=0.336 as=0.336 pd=2.84 ps=2.84
XM26 a_114_368##8 B1#8 a_531_368##12 VPB sky130_fd_pr__pfet_01v8 l=0.15 w=1.12 ad=0.336 as=0.336 pd=2.84 ps=2.84
XM12 a_531_368##12 B2#12 a_114_368##7 VPB sky130_fd_pr__pfet_01v8 l=0.15 w=1.12 ad=0.336 as=0.336 pd=2.84 ps=2.84
XM18 a_114_368##7 B2#11 a_531_368##11 VPB sky130_fd_pr__pfet_01v8 l=0.15 w=1.12 ad=0.336 as=0.336 pd=2.84 ps=2.84
XM36 a_531_368##11 B2#7 a_114_368# VPB sky130_fd_pr__pfet_01v8 l=0.15 w=1.12 ad=0.336 as=0.336 pd=2.84 ps=2.84
XM33 a_114_368# B2#1 a_531_368# VPB sky130_fd_pr__pfet_01v8 l=0.15 w=1.12 ad=0.336 as=0.308 pd=2.84 ps=2.79
*
*
*       RESISTOR AND CAP/DIODE CARDS
*
Rg1	C1#1	C1#2	395.686340
Rg2	C1#2	C1#3	54.881104
Rg3	C1#3	C1#4	23.896481
Rg4	C1#4	C1#5	25.844448
Rg5	C1#5	C1#6	41.530022
Rg6	C1#6	C1#7	44.418308
Rg7	C1#7	C1#8	451.014282
Rg8	C1#2	C1#9	456.893372
Rg9	C1#3	C1#10	399.678711
Rg10	C1#4	C1#11	414.808441
Rg11	C1#5	C1#12	405.267151
Rg12	C1#6	C1#13	400.745392
Rg13	C1#7	C1#14	363.598511
Rg14	A2#1	A2#2	467.287537
Rg15	A2#2	A2#3	66.369736
Rg16	A2#3	A2#4	51.916321
Rg17	A2#4	A2#5	90.033310
Rg18	A2#5	A2#6	449.655212
Rg19	A2#2	A2#7	418.788055
Rg20	A2#3	A2#8	395.494293
Rg21	A2#3	A2#9	448.603302
Rg22	A2#4	A2#10	372.877838
Rg23	A2#4	A2#11	424.977325
Rg24	A2#5	A2#12	397.555725
Rg25	A1#1	A1#2	460.230957
Rg26	A1#2	A1#3	15.166049
Rg27	A1#3	A1#4	19.362072
Rg28	A1#4	A1#5	30.301437
Rg29	A1#2	A1#6	361.561279
Rg30	A1#3	A1#7	408.550629
Rg31	A1#4	A1#8	372.053619
Rg32	A1#5	A1#9	38.785767
Rg33	A1#9	A1#10	391.759949
Rg34	A1#5	A1#11	426.879181
Rg35	A1#9	A1#12	39.623699
Rg36	A1#12	A1#13	379.219971
Rg37	A1#12	A1#14	454.295563
Rg38	B1#1	B1#2	413.013641
Rg39	B1#2	B1#3	59.578423
Rg40	B1#3	B1#4	26.002787
Rg41	B1#4	B1#5	47.143410
Rg42	B1#5	B1#6	75.704018
Rg43	B1#6	B1#7	450.572052
Rg44	B1#2	B1#8	452.720551
Rg45	B1#3	B1#9	407.781006
Rg46	B1#4	B1#10	409.423920
Rg47	B1#5	B1#11	372.877838
Rg48	B1#5	B1#12	424.977325
Rg49	B1#6	B1#13	377.411346
Rg50	B2#1	B2#2	458.777771
Rg51	B2#2	B2#3	66.369736
Rg52	B2#3	B2#4	57.428749
Rg53	B2#2	B2#5	401.601685
Rg54	B2#3	B2#6	394.561310
Rg55	B2#3	B2#7	446.660797
Rg56	B2#4	B2#8	383.525421
Rg57	B2#4	B2#9	90.033310
Rg58	B2#9	B2#10	411.287628
Rg59	B2#4	B2#11	430.316833
Rg60	B2#9	B2#12	453.701172
Rf3	A2	A2#13	17.494299
Rf4	A2#13	A2	0.372219
Rf5	A1	A1#15	5.024959
Rf6	A1#15	A1	12.841560
Rf7	a_534_74#	a_534_74##2	71.423080
Rf8	a_534_74##2	a_534_74##4	68.854309
Rf9	a_534_74##4	a_534_74##5	68.901634
Rf10	a_534_74##5	a_534_74##6	85.727913
Rf11	a_534_74##2	a_534_74##7	15.197315
Rf12	a_534_74##5	a_534_74##8	24.483221
Rf13	a_534_74##3	a_534_74##4	7.500000
Rf14	B1	B1#14	14.057726
Rf15	B1#14	B1	0.611206
Rf16	Y#1	Y#2	34.390862
Rf17	Y#2	Y#3	62.988514
Rf18	Y#3	Y#4	202.869019
Rf19	Y#4	Y#5	65.914833
Rf20	Y#5	Y#6	60.956360
Rf21	Y#6	Y	10.708293
Rf22	Y	Y#8	18.674389
Rf23	Y#8	Y	0.255814
Rf24	Y#2	Y#10	73.884750
Rf25	Y#10	Y#11	48.270931
Rf26	Y#3	Y#12	34.390862
Rf27	Y#4	Y#13	21.341251
Rf28	Y#5	Y#14	28.306047
Rf29	Y#6	Y	6.061400
Rf30	Y	Y#16	6.209292
Rf31	Y#16	Y	6.209292
Rf32	Y	Y#17	74.003403
Rf33	Y#17	Y#18	19.035625
Rf34	Y#17	Y#19	81.540611
Rf35	Y#7	Y#8	5.000000
Rf36	Y#9	Y#10	15.000000
Rf37	Y#15	Y#16	7.500000
Rf38	a_114_368#	a_114_368##2	77.753891
Rf39	a_114_368##2	a_114_368##3	65.696381
Rf40	a_114_368##3	a_114_368##4	65.696381
Rf41	a_114_368##4	a_114_368##5	397.419525
Rf42	a_114_368##5	a_114_368##6	81.678612
Rf43	a_114_368##2	a_114_368##7	15.689406
Rf44	a_114_368##3	a_114_368##8	15.689406
Rf45	a_114_368##4	a_114_368##9	15.689406
Rf46	a_114_368##5	a_114_368##10	17.622940
Rf47	B2	B2#13	4.278439
Rf48	B2#13	B2	10.390493
Rf49	a_1326_74#	a_1326_74##2	85.866737
Rf50	a_1326_74##2	a_1326_74##4	84.090828
Rf51	a_1326_74##4	a_1326_74##6	56.476780
Rf52	a_1326_74##6	a_1326_74##7	55.107433
Rf53	a_1326_74##2	a_1326_74##8	28.306047
Rf54	a_1326_74##3	a_1326_74##4	7.500000
Rf55	a_1326_74##5	a_1326_74##6	15.000000
Rf56	a_531_368#	a_531_368##2	98.263313
Rf57	a_531_368##2	a_531_368##3	65.844177
Rf58	a_531_368##3	a_531_368##4	65.844177
Rf59	a_531_368##4	a_531_368##6	78.203156
Rf60	a_531_368##6	a_531_368##7	86.551170
Rf61	a_531_368##7	a_531_368##8	65.696381
Rf62	a_531_368##8	a_531_368##9	65.696381
Rf63	a_531_368##9	a_531_368##10	75.832359
Rf64	a_531_368##2	a_531_368##11	22.462164
Rf65	a_531_368##3	a_531_368##12	22.462164
Rf66	a_531_368##4	a_531_368##13	22.462164
Rf67	a_531_368##7	a_531_368##14	13.327370
Rf68	a_531_368##8	a_531_368##15	13.327370
Rf69	a_531_368##9	a_531_368##16	13.327370
Rf70	a_531_368##5	a_531_368##6	7.500000
Rf72	VGND#2	VGND#3	62.774361
Rf73	VGND#3	VGND#4	19.333849
Rf74	VGND#4	VGND#5	332.720490
Rf75	VGND#5	VGND#6	52.937077
Rf76	VGND#2	VGND#7	38.247387
Rf77	VGND#3	VGND#8	38.247387
Rf78	VGND#5	VGND#9	31.161278
Rf79	VGND#6	VGND#10	123.430801
Rf80	VGND#10	VGND#11	62.774361
Rf82	VGND#6	VGND#13	34.659180
Rf83	VGND#10	VGND#14	38.247387
Rf84	VGND#11	VGND#15	38.247387
Rf85	VPWR#1	VPWR#2	189.500687
Rf86	VPWR#2	VPWR#3	74.178955
Rf87	VPWR#3	VPWR#4	65.941528
Rf88	VPWR#4	VPWR#5	56.346924
Rf89	VPWR#2	VPWR#6	27.615677
Rf90	VPWR#3	VPWR#7	48.224632
Rf91	VPWR#4	VPWR#8	48.224632
Rf92	VPWR#5	VPWR#9	53.972439
Rf96	A1#5	A1#15	40.058201
Rf97	B1#5	B1#14	40.058201
Rf94	C1#5	C1	40.058201
Rf98	B2#4	B2#13	40.058201
Rf95	A2#4	A2#13	40.058201
Re1	VPWR#1	VPWR	2.512894
Re2	VPWR	VPWR#5	1.435940
Re3	VGND#4	VGND	2.512894
Re4	VGND	VGND#6	1.435940
*
*       CAPACITOR CARDS
*
*
C1	a_531_368#	B2#1	4.94151e-17
C2	a_114_368##5	A2#6	1.521e-17
C3	a_531_368#	B2#2	6.46695e-20
C4	a_114_368##5	C1#7	3.7142e-18
C5	A2#4	A1#12	2.31809e-18
C6	a_114_368#	B2#1	4.55327e-17
C7	VPWR#3	VPWR#6	4.50075e-19
C8	Y#2	Y#1	8.24921e-18
C9	VGND#5	A2#7	1.2017e-18
C10	B1#1	B2#10	4.09007e-17
C11	a_1326_74##8	VGND#7	4.16102e-17
C12	a_531_368#	B2#7	2.22418e-18
C13	a_531_368##11	B2#1	1.48559e-18
C14	A2#5	VPWR#9	5.17659e-19
C15	A1#11	A1#9	2.31942e-19
C16	A2#2	A1#12	3.4634e-17
C17	A2#4	A2#5	1.98103e-17
C18	a_114_368##5	C1#9	1.76354e-17
C19	a_114_368#	B2#7	5.26343e-17
C20	A2#4	A2#2	1.38549e-17
C21	a_531_368#	B2#11	8.18231e-19
C22	B2#7	a_531_368##11	2.49831e-17
C23	a_531_368##9	a_531_368##8	3.01982e-18
C24	B1#9	B1#1	4.00772e-17
C25	Y#3	Y#12	1.28183e-18
C26	VGND#8	VGND#7	1.66094e-18
C27	VGND#5	A2#8	1.2017e-18
C28	VGND#3	a_1326_74##8	5.24871e-18
C29	a_114_368#	B2#11	1.28708e-18
C30	a_531_368##2	a_114_368#	1.9043e-17
C31	B2#2	a_114_368#	1.39623e-18
C32	a_114_368##5	C1#11	1.37843e-17
C33	B2#11	a_531_368##11	2.83398e-17
C34	a_531_368#	B2#12	3.14338e-19
C35	a_531_368##12	B2#7	3.04727e-19
C36	Y#4	a_114_368##5	1.87259e-18
C37	VGND#8	a_1326_74##8	4.15829e-17
C38	VGND#14	C1#7	9.23408e-19
C39	B2#11	a_114_368##7	2.32435e-17
C40	B1#11	B1#9	4.02646e-17
C41	Y#3	a_534_74##3	4.90393e-17
C42	a_531_368##10	A2#5	2.41167e-19
C43	Y#4	VGND#9	1.84768e-20
C44	a_534_74##2	a_534_74#	3.22697e-18
C45	a_531_368##11	B2#12	7.30993e-19
C46	C1#5	A2#5	1.20157e-18
C47	a_531_368##12	B2#11	7.30993e-19
C48	a_531_368#	B1#8	2.04882e-19
C49	a_531_368#	a_114_368#	7.55818e-17
C50	a_531_368##2	a_531_368##11	2.44554e-18
C51	Y#17	C1#11	2.00969e-17
C52	B2#12	a_114_368##7	2.32435e-17
C53	C1#5	C1#7	6.8178e-17
C54	a_1326_74##3	a_1326_74##8	1.67195e-18
C55	Y#3	a_114_368##5	9.16833e-19
C56	a_531_368##3	a_114_368##7	3.20146e-19
C57	B1#13	B1#11	4.01593e-17
C58	Y#3	VGND#9	9.82984e-20
C59	B2#12	a_531_368##12	2.49647e-17
C60	a_531_368##11	B1#8	3.04727e-19
C61	VGND#10	A2#12	3.44476e-19
C62	a_531_368##11	a_531_368#	3.8026e-18
C63	VGND#10	C1#7	4.68019e-20
C64	a_534_74##2	Y#1	3.71227e-17
C65	a_531_368##8	a_531_368##7	3.01982e-18
C66	Y#17	C1#13	2.01253e-17
C67	a_531_368##2	a_114_368##7	3.15831e-19
C68	a_1326_74##3	VGND#8	5.03166e-17
C69	B1#8	a_531_368##12	2.83398e-17
C70	a_531_368##13	B2#12	3.04727e-19
C71	a_114_368#	a_531_368##11	5.10985e-17
C72	B2#9	a_114_368##7	2.74109e-19
C73	Y#3	a_114_368##4	2.19411e-18
C74	Y#9	B1#6	5.05917e-18
C75	A1#6	B1#13	4.41308e-18
C76	Y#3	a_534_74##8	3.67898e-19
C77	a_531_368##3	a_531_368##12	2.44554e-18
C78	VGND#4	VGND#3	5.89798e-17
C79	B1#8	a_114_368##8	2.32435e-17
C80	a_534_74##2	a_534_74##7	1.04241e-18
C81	Y#4	VGND#13	2.24562e-19
C82	VGND#10	C1#1	5.57693e-18
C83	a_531_368##13	B1#8	7.30993e-19
C84	a_531_368##12	B1#10	7.30993e-19
C85	a_531_368##4	a_114_368##8	3.20146e-19
C86	a_531_368##4	VPWR#1	9.50859e-17
C87	a_531_368#	a_531_368##12	1.24645e-20
C88	a_531_368##3	VPWR#1	8.71826e-17
C89	B1#10	a_114_368##8	2.32435e-17
C90	a_531_368##2	VPWR#1	8.8976e-17
C91	Y#2	a_114_368##4	5.45369e-18
C92	A1#8	A1#6	4.00453e-17
C93	Y#3	VGND#13	7.42286e-21
C94	a_1326_74#	B2#5	3.89342e-17
C95	B1#10	a_531_368##13	2.49647e-17
C96	a_534_74##2	Y#12	4.22648e-17
C97	a_531_368##12	B1#12	3.04727e-19
C98	a_531_368##3	a_114_368##8	3.15831e-19
C99	Y#4	a_534_74##6	5.05482e-17
C100	a_534_74##5	VGND#9	1.59486e-17
C101	VPWR#6	B1#8	4.30509e-20
C102	a_1326_74##3	Y#11	4.95616e-17
C103	VGND#15	C1#7	1.08437e-18
C104	VGND#10	C1#10	5.32154e-18
C105	a_531_368##4	a_531_368##13	2.44554e-18
C106	VGND#7	B2#5	2.95713e-17
C107	Y#19	C1#7	8.05518e-20
C108	a_531_368##3	B2#9	7.81191e-20
C109	a_531_368##5	B1#10	3.25217e-19
C110	a_1326_74##7	B1#6	5.39107e-19
C111	B1#12	a_531_368##13	2.83398e-17
C112	A1#10	A1#8	3.82513e-17
C113	VGND#3	a_1326_74##2	2.91756e-19
C114	a_531_368##12	a_531_368##11	3.9401e-18
C115	a_1326_74#	B2#6	8.48022e-19
C116	a_534_74##3	a_534_74##2	3.1466e-18
C117	B1#12	a_114_368##9	2.32435e-17
C118	VPWR#6	B1#10	7.45982e-20
C119	VGND#10	VGND#6	3.28961e-19
C120	VPWR#1	a_114_368##4	1.05579e-17
C121	a_1326_74##8	B2#5	6.43198e-19
C122	Y#4	Y#13	1.16795e-18
C123	a_531_368##8	A1#12	1.08986e-19
C124	VGND#6	VGND#5	1.14463e-18
C125	VPWR#1	a_114_368##3	1.16859e-17
C126	a_1326_74##5	a_1326_74##3	8.02265e-19
C127	a_534_74##5	a_534_74##8	1.39337e-18
C128	Y#5	VGND#14	1.47503e-17
C129	a_531_368##5	B1#12	7.64206e-19
C130	a_531_368##13	B1#7	7.30993e-19
C131	VGND#7	B2#6	2.83665e-17
C132	VPWR#1	a_114_368##2	1.15533e-17
C133	a_531_368##7	a_531_368##5	2.17337e-18
C134	VGND#4	a_1326_74##2	4.07016e-18
C135	VGND#10	C1#12	9.71076e-19
C136	VPWR#6	B1#12	2.18384e-19
C137	a_531_368##4	a_114_368##9	6.5024e-19
C138	B1#7	a_114_368##9	2.32435e-17
C139	A1#13	A1#10	3.99887e-17
C140	Y#17	C1#7	3.78107e-19
C141	a_1326_74#	B2#8	1.87602e-19
C142	B2#6	a_1326_74##8	1.38198e-17
C143	a_531_368##5	B1#7	3.66142e-17
C144	a_531_368##13	A1#1	3.04727e-19
C145	a_114_368##2	a_114_368#	3.01982e-18
C146	Y#4	VGND#14	1.4702e-17
C147	Y#11	a_1326_74##5	4.33519e-17
C148	a_531_368##4	B1#6	1.26709e-19
C149	a_534_74##5	VGND#13	1.7419e-17
C150	VPWR#6	B1#7	5.33602e-19
C151	Y#5	Y#14	1.53437e-18
C152	VGND#7	B2#8	1.37067e-18
C153	a_531_368##8	A1#9	1.16175e-19
C154	C1#7	a_114_368##10	5.48219e-19
C155	Y#2	B1#13	2.96729e-20
C156	VGND#8	B2#6	1.37067e-18
C157	VGND#3	B2#4	3.62715e-20
C158	C1#7	A2#12	7.14713e-20
C159	a_531_368##7	VPWR#6	6.07929e-17
C160	A2#7	A1#13	3.94692e-17
C161	a_531_368##5	A1#1	5.89335e-17
C162	VPWR#4	VPWR#3	6.93111e-19
C163	B2#8	a_1326_74##8	1.72195e-17
C164	A1#1	VPWR#6	3.59196e-17
C165	Y#3	A1#6	7.18549e-20
C166	a_1326_74##3	a_1326_74##7	2.30928e-20
C167	a_1326_74##3	B2#6	1.67688e-19
C168	a_114_368##2	a_531_368##11	5.30159e-17
C169	a_531_368##5	A1#7	8.71947e-19
C170	Y#5	VGND#15	1.48969e-17
C171	VGND#8	B2#8	3.27157e-17
C172	Y#2	A1#6	1.53186e-17
C173	A2#8	A2#7	3.99434e-17
C174	VPWR#7	A1#1	1.29113e-19
C175	A1#7	VPWR#6	3.90909e-17
C176	a_531_368##13	a_531_368##12	3.9401e-18
C177	VGND#5	a_534_74#	3.8115e-17
C178	a_531_368##7	a_531_368##14	1.06004e-18
C179	a_1326_74##8	B2#10	3.05025e-19
C180	a_1326_74##5	Y#9	3.1479e-17
C181	Y#11	a_1326_74##7	1.40181e-19
C182	A1#7	a_531_368##14	2.32435e-17
C183	a_1326_74##3	B2#8	3.97516e-19
C184	Y#3	A1#8	2.13866e-19
C185	a_114_368##2	a_114_368##7	6.16604e-19
C186	C1#7	Y#18	1.21399e-18
C187	a_531_368##7	A1#9	2.86641e-18
C188	VPWR#7	A1#7	3.24443e-19
C189	VGND#4	Y#2	1.17689e-18
C190	VPWR#6	A1#11	1.08951e-18
C191	a_531_368##8	VPWR#7	3.82893e-17
C192	a_531_368##2	B2#4	1.70544e-19
C193	VGND#8	B2#10	2.82474e-17
C194	A2#10	A2#8	4.11638e-17
C195	Y#2	A1#8	7.88932e-18
C196	a_114_368##3	a_531_368##12	5.33422e-17
C197	A1#11	a_531_368##14	2.32435e-17
C198	a_1326_74##8	B1#1	1.28671e-19
C199	a_1326_74##7	a_1326_74##5	3.75766e-19
C200	a_531_368##2	B2#2	1.88858e-20
C201	a_1326_74##2	B2#4	6.48016e-18
C202	a_1326_74##3	B2#10	2.55407e-17
C203	A1#11	VPWR#7	2.51847e-17
C204	VPWR#6	A1#14	3.11371e-19
C205	a_531_368##7	VPWR#7	3.82336e-17
C206	Y#3	A1#10	7.40153e-18
C207	a_531_368##4	B1#5	1.92421e-19
C208	VPWR#4	A2#4	6.4143e-21
C209	VGND#8	B1#1	1.43332e-18
C210	a_114_368##2	a_531_368##12	5.38512e-17
C211	VPWR#3	VPWR#2	4.9947e-19
C212	a_531_368##3	B1#5	8.46999e-20
C213	A2#12	A2#10	4.00249e-17
C214	Y#11	B2#10	9.9403e-19
C215	a_534_74##2	A1#6	1.35697e-18
C216	Y#2	A1#10	1.07191e-19
C217	VPWR#8	A1#11	1.45657e-19
C218	a_531_368##8	a_531_368##15	1.3641e-18
C219	A1#14	VPWR#7	2.70326e-17
C220	a_114_368##3	a_114_368##8	8.25031e-19
C221	Y#9	a_1326_74##7	5.73234e-17
C222	a_1326_74##2	a_1326_74#	5.2354e-19
C223	a_114_368##2	B2#4	2.71171e-18
C224	Y#5	Y#4	5.2354e-19
C225	a_1326_74##3	B1#1	4.02864e-17
C226	A1#14	a_531_368##15	2.32435e-17
C227	VGND#4	a_1326_74#	1.59883e-17
C228	a_1326_74##5	B2#10	1.99865e-19
C229	VGND#6	Y#4	1.50401e-18
C230	Y#3	A1#13	7.29351e-18
C231	C1#7	a_114_368##6	3.99052e-18
C232	a_114_368##4	a_531_368##13	5.24683e-17
C233	a_531_368##9	VPWR#8	3.82814e-17
C234	VGND#5	A2#4	1.17882e-20
C235	VPWR#8	A1#14	3.25542e-19
C236	VGND#8	B1#9	2.90512e-19
C237	VPWR#7	A2#1	3.25542e-19
C238	C1#1	A2#12	3.97234e-18
C239	C1#7	A2#5	4.38589e-18
C240	Y#11	B1#1	3.49539e-17
C241	VGND#4	a_1326_74##8	1.18512e-17
C242	Y#3	A1#12	8.39704e-18
C243	a_534_74##2	A1#8	2.75154e-17
C244	a_531_368##5	a_531_368##13	4.01585e-18
C245	Y#2	A1#13	4.48308e-20
C246	a_114_368##4	B1#5	1.62771e-18
C247	A2#1	a_531_368##15	2.32435e-17
C248	Y#1	a_1326_74##5	4.58414e-20
C249	Y#4	A2#7	1.80978e-19
C250	a_114_368##3	B1#5	3.2477e-18
C251	a_1326_74##3	B1#9	6.90497e-19
C252	VGND#6	a_534_74##5	4.65462e-19
C253	a_531_368##8	VPWR#8	3.82311e-17
C254	a_114_368##3	a_531_368##13	5.31286e-17
C255	VGND#4	a_1326_74##3	4.14999e-17
C256	A2#1	VPWR#8	2.51867e-17
C257	a_1326_74##5	B1#1	4.88793e-19
C258	a_534_74#	A1#9	2.01249e-18
C259	a_1326_74##2	VGND#7	2.26369e-17
C260	a_531_368##9	A2#4	1.26169e-18
C261	VPWR#7	A2#9	1.45657e-19
C262	VGND#4	Y#11	6.67572e-18
C263	Y#3	A2#7	7.96233e-18
C264	VGND#8	B1#11	1.55626e-19
C265	C1#10	C1#1	3.89219e-17
C266	a_114_368##4	a_114_368##9	6.16604e-19
C267	VGND#4	a_1326_74##5	6.41853e-17
C268	Y#11	B1#9	3.85886e-17
C269	a_531_368##9	a_531_368##16	9.81011e-19
C270	VGND#4	Y#9	8.77518e-18
C271	VPWR#9	A2#1	1.45657e-19
C272	a_534_74#	a_1326_74##7	3.39704e-17
C273	a_534_74##2	A1#10	2.67459e-17
C274	Y#3	A1#9	8.0111e-18
C275	A2#9	VPWR#8	2.70326e-17
C276	VGND#4	a_1326_74##7	4.16932e-17
C277	Y#4	A2#8	2.30868e-19
C278	a_1326_74##3	B1#11	3.74054e-19
C279	a_114_368##5	a_531_368##9	7.01405e-17
C280	A1	A1#12	1.51375e-17
C281	A2#9	a_531_368##16	2.32435e-17
C282	a_1326_74##5	B1#9	3.3667e-17
C283	A1	A1#9	4.98344e-17
C284	C1#12	C1#10	4.01426e-17
C285	a_1326_74##2	a_1326_74##8	1.24483e-18
C286	VPWR#9	A2#9	5.79414e-19
C287	VGND#8	B1#13	1.22928e-19
C288	Y#3	A2#8	7.84603e-18
C289	VPWR#8	A2#11	3.25542e-19
C290	Y#11	B1#11	8.67758e-19
C291	a_114_368##4	a_531_368##5	1.07426e-16
C292	C1#7	C1#9	2.31942e-19
C293	A2#11	a_531_368##16	2.32435e-17
C294	A1	A2#2	8.91915e-18
C295	a_534_74##2	A1#13	1.11331e-18
C296	a_1326_74##2	B2#9	5.34124e-19
C297	a_534_74#	B1#1	2.6257e-19
C298	a_531_368##9	VPWR#9	3.8225e-17
C299	B1#6	a_114_368##9	4.93397e-19
C300	a_1326_74##3	B1#13	2.35254e-19
C301	a_531_368##5	VPWR#6	6.54749e-17
C302	A2#4	a_114_368##5	1.28522e-16
C303	A2#11	VPWR#9	2.52841e-17
C304	Y#4	A2#10	8.12046e-18
C305	a_1326_74##5	B1#11	3.74676e-17
C306	VPWR#8	A2#6	1.45657e-19
C307	VGND#5	a_534_74##3	2.72319e-17
C308	C1#14	C1#12	3.87728e-17
C309	a_114_368##5	a_531_368##8	1.44832e-17
C310	a_531_368##10	A2#11	1.22713e-18
C311	VGND#7	B2#4	3.88415e-19
C312	Y#11	B1#13	4.94164e-19
C313	Y#3	A2#10	7.00987e-20
C314	a_1326_74##2	VGND#8	2.25719e-17
C315	a_534_74#	Y#1	1.70248e-17
C316	Y#9	B1#11	3.69611e-17
C317	Y#19	A2#11	4.34309e-19
C318	Y#5	A2#12	1.2598e-20
C319	A2#6	VPWR#9	2.78118e-17
C320	VGND#8	B2#4	5.9719e-19
C321	a_534_74#	B1#9	3.68596e-19
C322	Y#2	A1#9	2.86056e-17
C323	a_114_368##4	VPWR#6	2.45947e-18
C324	a_534_74##5	A2#8	1.23472e-17
C325	a_114_368##10	A2#11	2.92972e-19
C326	a_531_368##8	A2#2	2.25382e-19
C327	a_531_368##10	A2#6	7.71007e-17
C328	a_1326_74##5	B1#13	7.53501e-19
C329	Y#4	A2#5	5.88765e-18
C330	Y#4	A2#12	1.36481e-17
C331	a_1326_74##7	B1#11	5.16247e-19
C332	C1#5	a_114_368##5	6.86363e-17
C333	a_531_368##10	a_531_368##9	3.01982e-18
C334	Y#19	A2#6	4.67258e-18
C335	Y#1	B1#9	1.60273e-19
C336	a_531_368#	VPWR#1	7.34136e-17
C337	Y#3	Y#2	5.8663e-19
C338	VPWR#9	C1#9	1.94875e-19
C339	Y#11	A1#6	2.64636e-19
C340	a_114_368##4	a_531_368##8	5.75542e-17
C341	Y#9	B1#13	4.0659e-17
C342	a_114_368##10	A2#6	7.24853e-19
C343	VPWR#1	a_114_368#	9.89422e-18
C344	Y#4	A2#4	6.88877e-17
C345	Y#3	A2#12	6.03078e-20
C346	a_531_368##10	C1#9	2.98678e-18
C347	a_534_74#	B1#11	5.85349e-19
C348	Y#3	A2#4	7.43075e-17
C349	a_1326_74##3	a_1326_74##2	5.06977e-19
C350	Y#5	C1#1	1.78765e-19
C351	A2	C1#7	1.28441e-17
C352	a_1326_74##3	B1#5	7.60954e-20
C353	Y#19	C1#9	7.38918e-17
C354	a_534_74##5	A2#10	1.22397e-17
C355	a_114_368##4	a_531_368##14	5.24889e-19
C356	a_1326_74##7	B1#13	4.84473e-17
C357	VPWR#7	VPWR#6	2.04734e-18
C358	Y#11	B1#5	5.49689e-18
C359	VGND#4	a_531_368#	5.7014e-18
C360	VGND#6	a_534_74##8	7.79283e-18
C361	C1#9	a_114_368##10	2.54165e-17
C362	a_1326_74##2	B2#2	1.20631e-18
C363	a_534_74##5	A2#4	1.69833e-18
C364	Y#4	C1#1	1.70647e-17
C365	Y#1	B1#11	2.04292e-19
C366	a_1326_74##5	B1#5	1.43546e-18
C367	A1#9	B1#6	2.31877e-17
C368	Y#9	B1#5	4.51653e-18
C369	Y#18	C1#9	2.17309e-18
C370	a_534_74##5	Y#4	2.78578e-17
C371	Y#5	C1#7	7.6103e-18
C372	Y#5	C1#5	7.20268e-17
C373	VGND#6	a_534_74##6	1.78984e-17
C374	B2	B2#9	1.76405e-17
C375	Y#19	C1#11	1.63225e-18
C376	a_534_74#	B1#13	3.07256e-18
C377	a_1326_74##7	B1#5	1.87866e-19
C378	a_114_368##4	a_531_368##7	8.27563e-17
C379	Y#4	C1#5	2.1254e-17
C380	B2	B2#2	1.74604e-17
C381	a_114_368##6	C1#9	2.619e-19
C382	B2#7	B2#1	4.57897e-17
C383	a_531_368##2	B2#7	1.53578e-17
C384	VGND#5	a_534_74##8	2.55683e-18
C385	C1#11	a_114_368##10	2.79056e-17
C386	Y#5	C1#10	1.59369e-17
C387	a_1326_74##7	A1#6	7.17796e-19
C388	Y#18	C1#11	4.45137e-17
C389	a_531_368##5	VPWR#1	3.79414e-17
C390	Y#1	B1#13	8.36955e-19
C391	a_114_368##4	VPWR#7	1.15912e-18
C392	VGND#10	VGND#13	2.00865e-20
C393	Y#12	Y#1	1.66964e-18
C394	Y#4	C1#10	1.97312e-19
C395	a_114_368##6	C1#11	6.15422e-19
C396	a_114_368##10	C1#13	1.13148e-18
C397	a_534_74##5	Y#3	4.00711e-17
C398	B2#11	B2#7	4.69735e-17
C399	a_534_74#	A1#6	4.32858e-17
C400	Y#18	C1#13	3.93273e-17
C401	a_114_368##6	C1#13	3.55946e-17
C402	VGND#10	Y#5	2.91756e-19
C403	a_531_368##2	B2#11	1.52963e-17
C404	Y#5	C1#12	1.63051e-17
C405	A1#6	Y#1	1.45468e-17
C406	a_114_368##10	C1#8	5.79463e-19
C407	B2#12	B2#11	4.59316e-17
C408	Y#18	C1#8	2.49538e-18
C409	a_114_368##4	a_531_368##15	8.17341e-19
C410	Y#4	C1#7	4.39677e-18
C411	Y#4	C1#12	4.36499e-20
C412	a_534_74#	A1#8	7.38219e-19
C413	a_114_368##6	C1#8	4.5561e-17
C414	B1	B2#9	7.7787e-19
C415	B2#4	a_114_368#	2.04926e-18
C416	C1#8	Y#7	5.54909e-19
C417	a_531_368##3	B2#12	1.5357e-17
C418	a_114_368##5	VPWR#8	1.32291e-18
C419	B1	B1#6	2.00991e-17
C420	VPWR#8	VPWR#7	1.77709e-18
C421	B2#4	a_531_368##11	1.84057e-18
C422	A1#8	Y#1	1.70856e-17
C423	a_114_368##4	a_531_368##4	2.36622e-17
C424	B2#4	a_114_368##7	2.70455e-19
C425	B1#8	B2#12	4.69736e-17
C426	Y#5	C1#14	4.10817e-19
C427	Y#12	A1#6	2.0451e-19
C428	B1	A1#9	1.77455e-17
C429	Y#3	A2#2	8.29858e-18
C430	VGND#10	Y#4	1.19055e-18
C431	a_534_74##3	A2#4	1.90706e-19
C432	a_534_74##3	A1#12	5.71686e-20
C433	a_1326_74#	a_531_368#	9.99116e-18
C434	VGND#9	A2#4	4.58008e-19
C435	C1#8	C1#7	2.31808e-19
C436	A1#8	a_534_74##7	1.44708e-17
C437	a_531_368##5	A1#9	6.26829e-19
C438	a_1326_74##3	a_114_368##3	6.62321e-19
C439	a_534_74##2	Y#3	1.4649e-17
C440	VGND#13	A2#4	2.70237e-19
C441	B1#10	B1#8	4.68413e-17
C442	VPWR#3	A1#1	6.64328e-20
C443	Y#1	A1#10	3.05081e-19
C444	VGND#10	Y#13	1.76065e-17
C445	a_114_368##2	B2#7	1.28708e-18
C446	a_114_368##5	a_531_368##16	5.24889e-19
C447	a_534_74##3	Y#12	3.34724e-17
C448	VPWR#1	B2#9	1.11346e-20
C449	Y#12	A1#8	6.08695e-19
C450	a_531_368##3	B1#8	1.52963e-17
C451	VGND#9	A1#6	1.5481e-19
C452	B1#5	a_114_368##8	5.48219e-19
C453	VPWR#2	A1#1	2.27353e-18
C454	a_114_368##3	a_531_368##4	1.5923e-17
C455	B1#5	a_531_368##13	1.22031e-18
C456	A1#10	a_534_74##7	1.44708e-17
C457	VPWR#1	B2#2	1.1053e-20
C458	B1#5	a_114_368##9	5.11671e-20
C459	B1#12	B1#10	4.78816e-17
C460	VPWR#1	B1#6	1.96441e-20
C461	a_534_74##2	Y#2	1.45492e-17
C462	Y#1	A1#13	1.27595e-19
C463	Y#11	a_114_368##3	3.98785e-18
C464	VGND#4	B2#5	1.49616e-18
C465	A1#10	Y#12	1.44111e-17
C466	a_531_368##4	B1#10	1.5357e-17
C467	VGND#9	A1#8	2.13297e-19
C468	VGND#4	B2#6	6.61976e-19
C469	a_114_368##2	B2#11	3.40623e-17
C470	a_114_368##5	VPWR#9	1.15912e-18
C471	VPWR#3	A1#7	3.03037e-19
C472	VGND#4	B2#8	6.66852e-19
C473	B1#7	B1#12	4.59382e-17
C474	a_114_368##3	a_531_368##3	1.74182e-17
C475	a_534_74##3	A1#10	1.08361e-18
C476	VGND#4	B2#10	4.92659e-18
C477	a_531_368##9	VPWR#4	4.49251e-18
C478	VPWR#2	A1#7	2.54057e-18
C479	VPWR#9	VPWR#8	1.77709e-18
C480	A1#9	VPWR#6	2.50233e-18
C481	VGND#4	B1#1	6.1471e-18
C482	a_534_74##2	A1#12	2.26388e-19
C483	VGND#3	B2#6	9.71076e-19
C484	a_534_74##3	VGND#9	4.34788e-17
C485	A1#13	Y#12	1.67191e-17
C486	a_114_368##3	B2#12	1.28708e-18
C487	VGND#4	B1#9	5.947e-18
C488	VGND#9	A1#10	5.29866e-19
C489	A1#1	B1#7	4.59004e-17
C490	VPWR#3	A1#9	1.63032e-20
C491	VGND#4	B2#9	3.69778e-20
C492	VGND#4	B1#11	6.12894e-18
C493	a_531_368##4	B1#12	1.52963e-17
C494	a_114_368##2	B2#12	2.90739e-17
C495	VPWR#4	A1#11	9.00513e-20
C496	a_534_74##3	A1#13	4.3795e-17
C497	A1	a_114_368##4	1.51124e-16
C498	VGND#4	B1#13	6.1602e-18
C499	a_114_368##5	a_531_368##10	5.84388e-17
C500	VGND#10	Y#14	5.19931e-18
C501	VPWR#3	A1#11	5.16332e-18
C502	A1#7	A1#1	1.97701e-17
C503	a_114_368##2	a_531_368##3	1.71274e-17
C504	a_534_74##8	a_534_74##3	3.45314e-18
C505	Y#12	VGND#13	2.14121e-20
C506	Y#12	A2#7	5.97977e-19
C507	VGND#4	B1#6	7.85813e-20
C508	a_534_74##2	A1#9	1.19969e-18
C509	VGND#9	A1#13	1.66315e-18
C510	a_531_368##8	VPWR#4	9.00904e-18
C511	A2#4	VPWR#8	5.17659e-19
C512	a_534_74##5	A2#5	8.61962e-20
C513	VGND#5	Y#2	3.34344e-20
C514	a_114_368##3	B1#8	4.17345e-17
C515	VGND#3	B2#8	5.49944e-18
C516	A2#4	a_531_368##16	6.9441e-19
C517	a_534_74##3	A2#7	2.71405e-17
C518	a_534_74##8	A1#13	2.57343e-19
C519	A2#4	VPWR#9	4.87566e-19
C520	A1#11	A1#7	4.70639e-17
C521	Y#3	A1	8.41935e-17
C522	A2	a_114_368##5	7.33198e-17
C523	Y#2	A1	6.83478e-17
C524	a_114_368##2	B1#8	1.28708e-18
C525	a_534_74##8	VGND#9	2.12935e-17
C526	a_114_368##5	Y#19	3.75448e-17
C527	a_114_368##4	B1#6	1.90578e-18
C528	a_531_368##10	VPWR#9	3.82814e-17
C529	Y	C1#7	2.61318e-17
C530	Y#12	A2#8	3.32138e-19
C531	A1#9	a_531_368##14	5.48219e-19
C532	VPWR#4	A1#14	3.03786e-19
C533	VGND#9	A2#7	2.57598e-17
C534	VGND#4	A1#9	2.52448e-19
C535	a_114_368##2	a_531_368##2	1.70406e-17
C536	a_114_368##4	B1#10	1.64147e-18
C537	A1#14	A1#11	4.73015e-17
C538	a_531_368##7	A1#1	5.59327e-19
C539	VPWR#3	A1#14	5.16452e-18
C540	VPWR#2	A1#9	2.38469e-20
C541	a_534_74##3	A2#8	6.58799e-19
C542	a_534_74##8	A2#7	6.1005e-19
C543	a_114_368##2	B2#9	1.09988e-18
C544	a_114_368##3	B1#10	2.90739e-17
C545	a_531_368##8	VPWR#3	8.95967e-18
C546	Y#19	VPWR#9	2.19179e-18
C547	Y#4	A2	6.9944e-17
C548	A1#12	A1#9	2.8177e-18
C549	VGND#3	B2#10	4.00236e-18
C550	VGND#13	VGND#9	2.30966e-18
C551	a_1326_74##2	B2	8.74016e-17
C552	Y#12	A2#10	2.02208e-19
C553	VGND#9	A2#8	2.57685e-17
C554	A2#1	A1#14	4.89571e-17
C555	a_114_368##5	a_114_368##10	2.12601e-18
C556	C1#5	a_114_368##6	4.90076e-17
C557	B2	a_114_368##3	1.826e-17
C558	VGND#6	A2#10	1.2017e-18
C559	B2	a_114_368##2	7.79454e-17
C560	Y#19	a_531_368##10	3.84308e-17
C561	A1#12	VPWR#7	2.43612e-19
C562	VPWR#1	B2#1	6.76275e-18
C563	a_534_74##3	A2#10	2.87904e-19
C564	VGND#6	A2#12	1.21593e-18
C565	A1#9	B1#13	9.48082e-20
C566	a_114_368##4	B1#12	3.40623e-17
C567	A2#8	a_534_74##8	1.55172e-17
C568	VPWR#4	A2#1	5.16548e-18
C569	VPWR#1	B2#7	6.09434e-18
C570	A2#9	A2#1	4.72549e-17
C571	a_531_368##7	A1#7	3.75e-17
C572	VGND#13	a_534_74##8	2.12795e-17
C573	VPWR#3	A2#1	3.03786e-19
C574	Y#12	A2#12	1.73965e-19
C575	a_114_368##3	B1#12	1.28708e-18
C576	VPWR#1	B2#11	6.09422e-18
C577	VGND#9	A2#10	1.81383e-18
C578	a_534_74##3	A2#2	1.54246e-19
C579	VGND#13	A2#8	1.92623e-18
C580	a_531_368##7	VPWR#3	8.26862e-18
C581	A1#9	VPWR#7	7.48711e-19
C582	VPWR#1	B2#12	6.09422e-18
C583	VGND#5	a_534_74##5	4.65462e-19
C584	VGND#3	B1#1	1.03294e-18
C585	A2#11	A2#9	4.57726e-17
C586	VPWR#1	B1#8	6.09422e-18
C587	B1	a_114_368##4	1.02336e-16
C588	a_114_368##5	Y#18	1.85734e-17
C589	A2#10	a_534_74##8	1.75336e-17
C590	B1	a_114_368##3	5.06321e-17
C591	a_534_74##6	A2#8	2.87904e-19
C592	VPWR#1	B1#10	6.09223e-18
C593	a_534_74##6	a_534_74##8	3.45314e-18
C594	a_531_368##8	A1#11	1.22713e-18
C595	Y#19	a_114_368##10	5.37453e-17
C596	a_114_368##4	B1#7	2.81913e-17
C597	a_1326_74#	B2	1.47313e-17
C598	VPWR#1	B1#12	6.00945e-18
C599	A2#6	A2#11	4.73862e-17
C600	VGND#13	A2#10	2.81625e-17
C601	VPWR#4	A2#9	5.15927e-18
C602	a_531_368##7	A1#11	3.14787e-17
C603	VPWR#1	B1#7	5.92148e-18
C604	a_1326_74##3	B2	4.71423e-17
C605	Y#2	B1	1.04382e-17
C606	VPWR#3	A2#9	9.00513e-20
C607	a_534_74##8	A2#12	1.17909e-18
C608	Y#18	Y#19	5.01824e-18
C609	a_531_368##7	VPWR#2	9.44928e-18
C610	a_534_74##6	A2#10	6.58799e-19
C611	VGND#7	B2#2	4.53026e-19
C612	C1#9	A2#6	3.57022e-18
C613	a_534_74##6	VGND#13	3.61157e-17
C614	VGND#3	B1#9	5.10498e-19
C615	VGND#13	A2#12	2.61759e-17
C616	Y#17	a_114_368##10	1.21911e-17
C617	a_114_368##4	A1#1	1.90492e-17
C618	a_531_368##8	A1#14	3.50227e-17
C619	Y#18	a_114_368##10	4.05815e-17
C620	C1#11	C1#9	4.77139e-17
C621	VGND#9	A2#2	1.24163e-19
C622	Y#11	B1	5.04371e-17
C623	a_534_74##8	C1#1	8.30933e-20
C624	a_534_74##6	A2#12	3.17294e-17
C625	Y#9	B1	9.80813e-17
C626	B1#5	B1#8	2.31942e-19
C627	a_531_368##7	A1#14	1.46573e-18
C628	VPWR#4	A2#11	3.03786e-19
C629	C1#13	C1#11	4.69149e-17
C630	B2	a_531_368#	1.20082e-18
C631	B1#12	B1#5	2.31942e-19
C632	a_114_368##6	a_114_368##10	3.234e-18
C633	VGND#13	C1#1	5.39956e-19
C634	B2	a_114_368#	5.1494e-17
C635	Y#13	A2#12	2.16335e-18
C636	a_114_368##4	A1#12	3.88994e-19
C637	a_1326_74##2	B2#5	1.95034e-19
C638	B2#9	B2#4	4.0818e-18
C639	VGND#5	a_534_74##2	5.00059e-17
C640	VPWR	VPWR#4	5.35787e-17
C641	VGND#3	B1#11	2.02922e-19
C642	VPWR	VPWR#3	5.89109e-17
C643	a_531_368##9	A2#1	1.22713e-18
C644	Y#17	Y#18	4.35239e-20
C645	VPWR	VPWR#2	6.33584e-17
C646	C1#8	C1#13	4.47907e-17
C647	a_114_368##4	A1#7	1.43835e-17
C648	a_534_74##6	C1#1	2.35253e-18
C649	Y	Y#5	1.15612e-18
C650	VGND#14	A2#12	1.9548e-19
C651	Y	Y#4	1.38042e-18
C652	Y#13	a_534_74##6	3.16349e-17
C653	B2#4	B2#2	4.03823e-18
C654	a_114_368##6	Y#18	5.27802e-17
C655	VGND#14	VGND#13	7.25347e-19
C656	a_531_368##8	A2#1	3.14677e-17
C657	VPWR	a_531_368##9	1.94626e-17
C658	VPWR	a_531_368##8	1.94626e-17
C659	VPWR	a_531_368##7	2.03263e-17
C660	B2#9	VNB	2.55898e-17
C661	C1#1	Y#13	2.46841e-17
C662	VGND#8	B2#9	1.68381e-19
C663	B2#2	VNB	4.18624e-17
C664	B1#6	VNB	3.03015e-17
C665	Y#14	A2#12	4.15467e-20
C666	A1#12	VNB	2.68185e-17
C667	VPWR#4	A2#6	9.00513e-20
C668	A1#9	VNB	1.03887e-16
C669	A2#5	VNB	3.21745e-17
C670	VPWR	a_114_368##5	1.73657e-17
C671	VPWR	a_114_368##4	1.08139e-17
C672	A2#2	VNB	2.22502e-17
C673	C1#7	VNB	1.25308e-16
C674	a_114_368##4	A1#9	1.26223e-17
C675	a_1326_74##2	B2#6	1.70268e-17
C676	VGND#14	C1#1	3.28149e-17
C677	VPWR	Y#17	2.55714e-17
C678	Y#17	a_114_368##6	1.89842e-17
C679	a_114_368##4	a_114_368##3	3.01982e-18
C680	A2#4	A1#14	1.2898e-19
C681	VGND#13	A2#5	3.30043e-19
C682	VGND#3	B1#13	1.46615e-19
C683	a_531_368##9	A2#9	3.50227e-17
C684	a_114_368##4	A1#11	1.26343e-17
C685	A2#4	A2#1	1.26622e-18
C686	Y#13	C1#10	3.294e-19
C687	VGND	VGND#10	9.15485e-17
C688	A2#4	A2#9	2.08662e-18
C689	Y#14	C1#1	5.89544e-19
C690	VGND	VGND#5	1.52017e-16
C691	a_531_368##8	A2#9	1.22713e-18
C692	A2#4	A2#11	2.09836e-18
C693	A2#4	A2#6	2.13222e-18
C694	Y	Y#14	1.81009e-18
C695	VGND#14	C1#10	2.81866e-17
C696	Y	VGND#15	5.80313e-17
C697	VGND#14	Y#13	4.2284e-17
C698	B1#5	B2#9	3.19459e-17
C699	Y	Y#15	7.97654e-18
C700	A1#9	B1#7	2.31942e-19
C701	VGND#5	A1#6	4.89517e-18
C702	VPWR#1	B2#4	5.13283e-20
C703	a_1326_74##2	B2#8	1.69132e-17
C704	C1#5	C1#9	2.45922e-18
C705	VGND#5	A1#12	5.27049e-20
C706	Y#13	C1#12	1.43952e-19
C707	C1#10	Y#14	1.38198e-17
C708	VPWR#1	B1#5	6.28437e-20
C709	a_114_368##5	Y#17	2.75173e-18
C710	VGND	Y#5	2.9427e-18
C711	VGND	Y#4	1.0446e-17
C712	a_114_368##4	A1#14	1.2393e-17
C713	VGND	Y#3	8.06849e-18
C714	B1#6	B1#5	4.0818e-18
C715	VGND	Y#2	6.3769e-18
C716	VGND#4	B1#5	2.11682e-19
C717	a_531_368##9	A2#11	3.14787e-17
C718	VGND	a_534_74##5	4.7512e-18
C719	VGND	a_534_74##2	2.80896e-17
C720	VPWR#4	VNB	2.39092e-17
C721	a_1326_74##3	B2#9	1.55555e-18
C722	VPWR#3	VNB	2.67103e-17
C723	C1#5	C1#8	5.20781e-18
C724	VGND#14	C1#12	1.37067e-18
C725	VPWR#2	VNB	3.36017e-17
C726	VGND#15	C1#10	1.37067e-18
C727	Y#14	Y#13	1.72657e-18
C728	VGND#10	VNB	3.75414e-17
C729	VGND#5	VNB	8.40957e-17
C730	VGND#3	VNB	1.8689e-17
C731	Y	Y#19	1.24645e-20
C732	a_531_368##9	VNB	2.08637e-18
C733	a_531_368##8	VNB	2.08637e-18
C734	a_531_368##7	VNB	2.08637e-18
C735	VGND	Y#9	2.53116e-18
C736	Y	Y#18	4.31681e-18
C737	A1	A1#1	9.57399e-19
C738	a_531_368##4	VNB	5.22706e-18
C739	VGND	a_1326_74##7	4.53091e-18
C740	a_531_368##3	VNB	4.45192e-18
C741	Y	a_114_368##6	7.16758e-17
C742	B2	B2#1	6.19422e-18
C743	VGND	a_534_74#	1.99384e-17
C744	a_531_368##2	VNB	4.62695e-18
C745	C1#12	Y#14	1.72195e-17
C746	VGND	Y#1	6.01009e-18
C747	Y	Y#7	1.57972e-17
C748	A1	A1#7	1.89399e-18
C749	VPWR	a_531_368##5	1.31621e-17
C750	B2	B2#7	2.05282e-18
C751	a_534_74##6	A2#5	2.94882e-19
C752	a_1326_74##2	VNB	1.69371e-18
C753	VGND	Y#12	6.01009e-18
C754	VPWR	VPWR#6	2.74588e-17
C755	a_114_368##5	VNB	1.21652e-17
C756	VGND	a_534_74##3	2.0056e-17
C757	B2	B2#11	2.06454e-18
C758	A1	A1#11	2.16199e-18
C759	VGND#6	A2#4	6.25684e-20
C760	VGND	VGND#9	1.58289e-17
C761	a_114_368##5	A2#1	8.08714e-18
C762	VGND	a_534_74##8	1.13841e-17
C763	B2	B2#12	2.06294e-18
C764	VGND#5	A1#8	4.85004e-18
C765	A1	A1#14	2.97312e-18
C766	Y#17	VNB	4.87116e-18
C767	VGND	VGND#13	1.60421e-17
C768	VGND	a_534_74##6	1.6265e-17
C769	B2	B1#8	1.19264e-18
C770	a_1326_74##2	B2#10	9.24914e-20
C771	VGND	Y#13	1.51451e-17
C772	A1	A2#1	6.4449e-20
C773	a_114_368##3	a_114_368##2	3.01982e-18
C774	Y#5	VNB	6.9338e-19
C775	VGND	Y#14	1.18512e-17
C776	Y#4	VNB	1.30109e-17
C777	VPWR	a_531_368##10	1.83064e-17
C778	Y#3	VNB	2.13866e-18
C779	A1	A2#9	1.29484e-19
C780	VGND#5	A1#9	2.62449e-19
C781	Y#2	VNB	3.41152e-18
C782	VPWR	Y#19	2.43025e-17
C783	VGND#15	C1#12	3.28956e-17
C784	Y#14	VGND#14	4.16102e-17
C785	VPWR	a_114_368##10	7.23312e-18
C786	a_114_368##4	A2#1	1.18304e-17
C787	a_534_74##2	VNB	4.62057e-18
C788	a_114_368##5	A2#5	8.66861e-19
C789	VPWR	a_114_368##6	9.34603e-18
C790	B1	B2#12	1.35677e-19
C791	a_1326_74#	VNB	4.74324e-17
C792	B1	B1#8	1.2193e-18
C793	a_531_368##9	A2#6	1.55259e-18
C794	VGND#7	VNB	1.3093e-18
C795	a_1326_74##8	VNB	4.55126e-18
C796	VGND#8	VNB	3.01253e-20
C797	a_1326_74##3	VNB	4.48138e-18
C798	B2#6	B2#5	3.9603e-17
C799	Y#11	VNB	1.04765e-18
C800	B1	B1#12	2.06454e-18
C801	a_1326_74##5	VNB	4.33881e-18
C802	Y#14	C1#14	6.43198e-19
C803	Y#9	VNB	5.04288e-18
C804	a_1326_74##7	VNB	7.31578e-18
C805	B1	B1#7	2.11545e-18
C806	a_534_74#	VNB	8.70761e-18
C807	Y#1	VNB	8.5161e-20
C808	B1	A1#1	2.84502e-18
C809	Y#12	VNB	1.47208e-19
C810	Y	C1#10	2.63415e-19
C811	A2	C1#9	1.0793e-18
C812	a_534_74##3	VNB	2.65669e-18
C813	B1	A1#7	1.19658e-19
C814	VGND#9	VNB	2.22163e-19
C815	Y	C1#12	1.08641e-18
C816	a_534_74##8	VNB	4.50885e-18
C817	VGND#13	VNB	2.83454e-19
C818	Y	C1#14	3.12366e-17
C819	a_534_74##6	VNB	9.73171e-18
C820	Y#13	VNB	8.30368e-18
C821	VGND#14	VNB	3.01253e-20
C822	Y#14	VNB	4.55126e-18
C823	VGND#15	VNB	1.3093e-18
C824	VGND#15	C1#14	2.90947e-17
C825	a_531_368#	VNB	6.51436e-17
C826	VGND#15	VGND#14	1.66094e-18
C827	a_114_368##5	A2#9	1.2393e-17
C828	a_1326_74##2	B1#1	3.90164e-20
C829	a_531_368##5	VNB	2.40472e-18
C830	VPWR#6	VNB	5.41163e-18
C831	VGND#5	A1#10	4.85004e-18
C832	VGND	A1#6	1.26329e-18
C833	VPWR#7	VNB	2.79388e-18
C834	VGND	A1#8	1.25447e-18
C835	VPWR#8	VNB	2.79388e-18
C836	VGND	A1#10	1.14171e-18
C837	VPWR#1	B2	1.18834e-17
C838	VGND	A1#13	1.06596e-18
C839	VPWR#9	VNB	2.79388e-18
C840	C1#14	Y#15	9.76542e-19
C841	VGND	A2#7	7.62401e-19
C842	a_531_368##10	VNB	1.10111e-17
C843	Y#19	VNB	1.21836e-17
C844	VGND	A2#8	5.59421e-19
C845	VGND#4	B2	9.77847e-18
C846	VGND	A2#10	5.73979e-19
C847	VGND	A2#12	6.43986e-19
C848	VGND	C1#1	1.37049e-18
C849	B2#5	VNB	3.03509e-17
C850	VGND	C1#10	6.62287e-19
C851	VPWR#1	B1	9.03187e-18
C852	B2#6	VNB	2.51793e-17
C853	A2#4	A1	3.44028e-17
C854	VGND	C1#12	6.62287e-19
C855	B2#8	VNB	2.53949e-17
C856	B2#10	VNB	2.71691e-17
C857	VGND	C1#14	1.73991e-18
C858	VGND#4	B1	7.9911e-18
C859	B2#8	B2#6	4.09562e-17
C860	VPWR	A1#1	3.4366e-19
C861	B1#1	VNB	3.02941e-17
C862	B2	B2#4	3.68101e-17
C863	B1#9	VNB	2.97832e-17
C864	VPWR	A1#7	1.14951e-20
C865	B1#11	VNB	2.93523e-17
C866	B1#13	VNB	3.10372e-17
C867	VPWR	A1#11	5.25473e-19
C868	Y	C1#9	5.70256e-19
C869	B2	B1#5	1.75285e-17
C870	A1#6	VNB	3.50892e-17
C871	VPWR	A1#14	6.32153e-19
C872	A1#8	VNB	2.83645e-17
C873	Y	C1#11	6.0441e-19
C874	VGND#15	Y#14	4.15829e-17
C875	A2#2	VPWR#8	4.75604e-19
C876	A1#10	VNB	2.84197e-17
C877	VPWR	A2#1	6.52229e-19
C878	C1#5	A2	4.40428e-17
C879	A1#13	VNB	2.83522e-17
C880	Y	C1#13	2.32409e-18
C881	A2#7	VNB	2.42039e-17
C882	VPWR	A2#9	5.4936e-19
C883	A2#8	VNB	2.40386e-17
C884	Y	C1#8	4.81518e-17
C885	VPWR	A2#11	6.32153e-19
C886	B1	B1#5	4.54124e-17
C887	A2#10	VNB	2.41528e-17
C888	A2#12	VNB	2.9042e-17
C889	VPWR	A2#6	7.64417e-19
C890	C1#1	VNB	2.6816e-17
C891	C1#10	VNB	2.45802e-17
C892	VPWR	C1#9	1.54312e-18
C893	C1#12	VNB	2.44077e-17
C894	VPWR	C1#11	1.65805e-18
C895	C1#14	VNB	3.07438e-17
C896	VPWR	C1#13	1.65818e-18
C897	B2#1	VNB	3.48801e-17
C898	B2#7	VNB	3.16297e-17
C899	VPWR	C1#8	2.42691e-18
C900	a_1326_74#	VGND#7	4.90368e-17
C901	B2#11	VNB	3.21061e-17
C902	B2#12	VNB	3.22067e-17
C903	B1#8	VNB	3.45235e-17
C904	VPWR	VPWR#1	4.54231e-18
C905	a_114_368##5	A2#11	1.2393e-17
C906	B1#10	VNB	3.18949e-17
C907	B1#12	VNB	3.252e-17
C908	B1#7	VNB	3.27657e-17
C909	A1#1	VNB	3.13563e-17
C910	A1#7	VNB	3.27576e-17
C911	A1#11	VNB	3.26641e-17
C912	A1#14	VNB	3.39016e-17
C913	A2#1	VNB	3.3573e-17
C914	Y	C1#5	7.53444e-17
C915	A2#9	VNB	3.25374e-17
C916	A2#11	VNB	3.22942e-17
C917	VGND	VGND#4	1.58781e-17
C918	A2#6	VNB	3.43954e-17
C919	C1#9	VNB	3.59115e-17
C920	VPWR	A2#4	5.73323e-18
C921	VGND#5	A1#13	4.85004e-18
C922	VGND	VGND#6	7.30146e-17
C923	A1	B1	2.64048e-17
C924	C1#11	VNB	3.16712e-17
C925	VPWR	C1#5	9.68319e-18
C926	C1#13	VNB	3.10544e-17
C927	a_114_368##5	A2#2	8.21502e-19
C928	C1#8	VNB	3.92446e-17
C929	A2#7	A1#12	6.16101e-19
C930	VPWR#1	VNB	3.41871e-16
C931	VGND#4	VNB	2.70412e-16
C932	VGND	A2#4	6.99777e-18
C933	B1	B2	3.9754e-17
C934	VGND	C1#5	8.35757e-18
C935	VGND#6	VNB	4.03935e-17
C936	B2#4	VNB	5.64628e-17
C937	Y#2	a_534_74#	2.27197e-17
C938	B2#10	B2#8	3.97309e-17
C939	B1#5	VNB	8.1478e-17
C940	VPWR	A1	6.98008e-18
C941	A2#4	VNB	6.02731e-17
C942	C1#5	VNB	8.29635e-18
C943	VPWR	A2	3.46912e-18
C944	VGND	A1	8.52586e-18
C945	VGND	A2	4.47316e-18
C946	VPWR	B1	1.37543e-18
C947	A1	VNB	8.29628e-18
C948	VGND	B1	1.62587e-18
C949	A2	VNB	1.20609e-17
C950	VPWR	Y	2.41121e-17
C951	B2	VNB	3.37831e-17
C952	B1	VNB	1.65365e-17
C953	VGND	Y	2.3516e-17
C954	a_1326_74##8	a_1326_74#	1.72657e-18
C955	Y	VNB	1.34195e-16
C956	VPWR	VNB	3.07528e-16
C957	a_531_368##5	VPWR#2	1.11095e-17
C958	VGND	VNB	3.03708e-16
C959	VPWR#5	C1#11	4.47672e-18
C960	VGND#3	VGND#2	1.68991e-18
C961	VGND#11	VGND#10	1.69166e-18
C962	a_114_368##5	VPWR#5	2.92368e-18
C963	VGND#2	a_1326_74##8	5.19931e-18
C964	VPWR	VPWR#5	2.24812e-16
C965	VPWR#5	A2#1	9.00513e-20
C966	VGND#11	VNB	5.00503e-17
C967	VPWR#5	A2#4	4.5173e-20
C968	VGND	VGND#11	1.03014e-16
C969	VPWR#5	A2#6	5.42154e-18
C970	VGND#11	Y	2.48434e-17
C971	VGND#2	B2#5	5.36905e-18
C972	a_531_368##10	VPWR#5	1.80306e-17
C973	VPWR#5	C1#13	4.43427e-18
C974	VGND#2	B2#6	5.3368e-18
C975	VGND#2	B2#8	9.71076e-19
C976	VPWR#5	A2#9	5.65677e-19
C977	Y#17	VPWR#5	6.50384e-17
C978	VGND#11	C1#14	5.38189e-18
C979	VPWR#5	C1#9	4.6485e-18
C980	VGND#11	Y#5	2.91756e-19
C981	VGND#11	C1#12	5.48712e-18
C982	VGND#11	C1#10	9.71076e-19
C983	VGND#4	VGND#2	1.01023e-16
C984	Y	VPWR#5	4.76109e-17
C985	VPWR#5	VPWR#4	6.93668e-19
C986	VGND#11	C1#7	1.2519e-19
C987	Y#19	VPWR#5	5.22422e-17
C988	VGND#2	a_1326_74##2	2.91756e-19
C989	VPWR#5	C1#8	4.4526e-18
C990	VGND#2	VNB	4.9867e-17
C991	VPWR#5	VNB	1.27926e-16
C992	VGND#2	B2#4	3.80851e-20
C993	VPWR#5	A2#11	5.32411e-18
C994	a_531_368##9	VPWR#5	1.34303e-17
C995	VPWR#5	C1#7	9.40025e-20
C996	VGND#2	a_1326_74#	1.7841e-17
C997	VGND#11	Y#14	5.24871e-18
*
*
.ENDS sky130_fd_sc_hs__a221oi_4
*
