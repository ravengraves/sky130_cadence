* Extracted by Quantus, converted by sky130cad/quantus.py
*
*
*
*                       LINUX           Wed Nov 18 08:30:18 2026
*
*
*
*  PROGRAM  advgen
*
*  Name           : advgen - Quantus - (64-bit)
*  Version        : 25.1.0-p047
*  Build Date     : Thu Dec 11 23:20:30 PST 2025
*
*  HSPICE LIBRARY
*
*  OPERATING_TEMPERATURE 150
*  QRC_TECH_DIR <path>/tech
*
*
*

*
.SUBCKT sky130_fd_sc_hs__dfxtp_1 VPB VNB VGND VPWR Q D CLK
*
*
*  caps2d version: 10
*
*
*       TRANSISTOR CARDS
*
*
XM23 a_27_74##13 CLK#3 VGND#13 VNB sky130_fd_pr__nfet_01v8_lvt l=0.15 w=0.74 ad=0.2109 as=0.3478 pd=2.05 ps=2.42
XM16 VGND#13 a_27_74# a_206_368##14 VNB sky130_fd_pr__nfet_01v8_lvt l=0.15 w=0.74 ad=0.3478 as=0.2553 pd=2.42 ps=2.17
XM10 VGND#12 D#3 a_454_503# VNB sky130_fd_pr__nfet_01v8_lvt l=0.15 w=0.42 ad=0.23015 as=0.31125 pd=2.1 ps=2.43
XM22 a_454_503# a_27_74##6 a_561_463##7 VNB sky130_fd_pr__nfet_01v8_lvt l=0.15 w=0.42 ad=0.31125 as=0.1575 pd=2.43 ps=1.73
XM9 a_561_463##7 a_206_368# a_731_101# VNB sky130_fd_pr__nfet_01v8_lvt l=0.15 w=0.42 ad=0.1575 as=0.0882 pd=1.73 ps=1.26
XM19 a_731_101# a_713_458# VGND#11 VNB sky130_fd_pr__nfet_01v8_lvt l=0.15 w=0.42 ad=0.0882 as=0.3296 pd=1.26 ps=2.49
XM17 VGND#11 a_561_463# a_713_458##4 VNB sky130_fd_pr__nfet_01v8_lvt l=0.15 w=0.55 ad=0.3296 as=0.218125 pd=2.49 ps=2.05
XM20 a_713_458##4 a_206_368##5 a_1011_424##4 VNB sky130_fd_pr__nfet_01v8_lvt l=0.15 w=0.55 ad=0.218125 as=0.2362 pd=2.05 ps=2.07
XM11 a_1011_424##4 a_27_74##8 a_1168_124# VNB sky130_fd_pr__nfet_01v8_lvt l=0.15 w=0.42 ad=0.2362 as=0.1113 pd=2.07 ps=1.37
XM14 a_1168_124# a_1210_314# VGND#10 VNB sky130_fd_pr__nfet_01v8_lvt l=0.15 w=0.42 ad=0.1113 as=0.1197 pd=1.37 ps=1.41
XM8 a_1210_314##7 a_1011_424# VGND#9 VNB sky130_fd_pr__nfet_01v8_lvt l=0.15 w=0.64 ad=0.1824 as=0.2458 pd=1.85 ps=2.17
XM6 VGND#9 a_1210_314##4 Q#2 VNB sky130_fd_pr__nfet_01v8_lvt l=0.15 w=0.74 ad=0.2458 as=0.2109 pd=2.17 ps=2.05
XM0 a_27_74##16 CLK#1 VPWR#13 VPB sky130_fd_pr__pfet_01v8 l=0.15 w=1.12 ad=0.3304 as=0.336 pd=2.83 ps=2.84
XM15 VPWR#13 a_27_74##3 a_206_368##11 VPB sky130_fd_pr__pfet_01v8 l=0.15 w=1.12 ad=0.336 as=0.3304 pd=2.84 ps=2.83
XM21 VPWR#12 D#1 a_454_503##2 VPB sky130_fd_pr__pfet_01v8 l=0.15 w=0.42 ad=0.2972 as=0.1967 pd=2.41 ps=2.01
XM1 a_454_503##2 a_206_368##3 a_561_463##5 VPB sky130_fd_pr__pfet_01v8 l=0.15 w=0.42 ad=0.1967 as=0.1967 pd=2.01 ps=2.01
XM7 a_561_463##5 a_27_74##4 a_668_503# VPB sky130_fd_pr__pfet_01v8 l=0.15 w=0.42 ad=0.1967 as=0.1008 pd=2.01 ps=1.32
XM13 a_668_503# a_713_458##3 VPWR#11 VPB sky130_fd_pr__pfet_01v8 l=0.15 w=0.42 ad=0.1008 as=0.379725 pd=1.32 ps=3.09
XM3 VPWR#11 a_561_463##3 a_713_458##7 VPB sky130_fd_pr__pfet_01v8 l=0.15 w=0.84 ad=0.379725 as=0.4662 pd=3.09 ps=2.79
XM18 a_713_458##7 a_27_74##7 a_1011_424##6 VPB sky130_fd_pr__pfet_01v8 l=0.15 w=0.84 ad=0.4662 as=0.2856 pd=2.79 ps=2.45
XM12 a_1011_424##6 a_206_368##6 a_1118_508# VPB sky130_fd_pr__pfet_01v8 l=0.15 w=0.42 ad=0.2856 as=0.1995 pd=2.45 ps=1.79
XM2 a_1118_508# a_1210_314##3 VPWR#10 VPB sky130_fd_pr__pfet_01v8 l=0.15 w=0.42 ad=0.1995 as=0.1239 pd=1.79 ps=1.43
XM4 a_1210_314##11 a_1011_424##3 VPWR#9 VPB sky130_fd_pr__pfet_01v8 l=0.15 w=0.84 ad=0.2478 as=0.3724 pd=2.27 ps=2.95
XM5 VPWR#9 a_1210_314##6 Q#1 VPB sky130_fd_pr__pfet_01v8 l=0.15 w=1.12 ad=0.3724 as=0.3304 pd=2.95 ps=2.83
*
*
*       RESISTOR AND CAP/DIODE CARDS
*
Rg1	CLK#1	CLK#2	448.815094
Rg2	CLK#2	CLK#3	345.814911
Rg3	a_27_74#	a_27_74##2	302.507233
Rg4	a_27_74##2	a_27_74##3	486.629089
Rg5	D#1	D#2	226.096359
Rg6	D#3	D#4	288.541687
Rg7	a_27_74##4	a_27_74##5	350.148346
Rg8	a_27_74##5	a_27_74##6	553.429565
Rg9	a_206_368#	a_206_368##2	1990.731567
Rg10	a_206_368##2	a_206_368##3	959.406250
Rg11	a_713_458#	a_713_458##2	234.862106
Rg12	a_713_458##2	a_713_458##3	887.996216
Rg13	a_561_463#	a_561_463##2	687.708191
Rg14	a_561_463##2	a_561_463##3	346.568573
Rg15	a_206_368##4	a_206_368##5	286.896759
Rg16	a_206_368##6	a_206_368##7	226.096359
Rg17	a_27_74##7	a_27_74##8	1288.703613
Rg18	a_27_74##8	a_27_74##9	216.119781
Rg19	a_1210_314#	a_1210_314##2	503.028717
Rg20	a_1210_314##2	a_1210_314##3	345.383423
Rg21	a_1011_424#	a_1011_424##2	311.197021
Rg22	a_1011_424##2	a_1011_424##3	416.670898
Rg23	a_1210_314##4	a_1210_314##5	394.958344
Rg24	a_1210_314##5	a_1210_314##6	442.817719
Rf1	CLK#4	CLK#2	161.607086
Rf2	CLK	CLK#6	1.374290
Rf3	CLK#4	CLK#6	6.881835
Rf4	D#4	D	195.161926
Rf5	D	D#2	165.566223
Rf6	a_454_503#	a_454_503##2	140.290955
Rf7	a_561_463##2	a_561_463##6	270.313049
Rf8	a_561_463##6	a_561_463##7	139.496033
Rf9	a_561_463##5	a_561_463##6	15.000000
Rf10	a_713_458##4	a_713_458##5	60.008812
Rf11	a_713_458##5	a_713_458##2	185.296127
Rf12	a_713_458##5	a_713_458##7	93.133965
Rf13	a_206_368##7	a_206_368##9	258.720001
Rf14	a_206_368##9	a_206_368##10	256.388062
Rf15	a_206_368##10	a_206_368##11	8.185544
Rf16	a_206_368##9	a_206_368##4	277.595825
Rf17	a_206_368##10	a_206_368##13	30.225761
Rf18	a_206_368##13	a_206_368##14	62.823540
Rf19	a_206_368##13	a_206_368##2	164.977570
Rf20	a_27_74##9	a_27_74##11	325.052917
Rf21	a_27_74##11	a_27_74##12	309.856201
Rf22	a_27_74##12	a_27_74##13	54.029877
Rf23	a_27_74##11	a_27_74##5	254.388565
Rf24	a_27_74##12	a_27_74##15	10.340556
Rf25	a_27_74##15	a_27_74##16	90.623344
Rf26	a_1011_424##4	a_1011_424##5	57.898945
Rf27	a_1011_424##5	a_1011_424##6	129.391510
Rf28	a_1011_424##5	a_1011_424##2	244.879089
Rf29	a_1210_314##7	a_1210_314##8	98.818680
Rf30	a_1210_314##8	a_1210_314##9	50.838680
Rf31	a_1210_314##9	a_1210_314##2	120.320610
Rf32	a_1210_314##9	a_1210_314##11	27.992403
Rf33	Q#1	Q	101.238281
Rf34	Q	Q#3	6.703401
Rf35	Q#3	Q	6.703401
Rf36	Q#2	Q#3	7.500000
Rf38	VPWR#2	VPWR#3	80.184914
Rf39	VPWR#3	VPWR#4	175.272125
Rf40	VPWR#4	VPWR#5	44.171017
Rf41	VPWR#5	VPWR#6	118.131752
Rf42	VPWR#6	VPWR#7	74.034248
Rf44	VPWR#2	VPWR#9	46.842815
Rf45	VPWR#3	VPWR#10	34.507496
Rf46	VPWR#4	VPWR#11	22.697315
Rf47	VPWR#6	VPWR#12	22.587963
Rf48	VPWR#7	VPWR#13	53.143215
Rf50	VGND#2	VGND#3	77.920349
Rf51	VGND#3	VGND#4	160.719376
Rf52	VGND#4	VGND#5	61.029980
Rf53	VGND#5	VGND#6	88.366570
Rf54	VGND#6	VGND#7	108.123016
Rf56	VGND#2	VGND#9	36.378891
Rf57	VGND#3	VGND#10	44.349312
Rf58	VGND#4	VGND#11	28.841251
Rf59	VGND#6	VGND#12	30.373932
Rf60	VGND#7	VGND#13	39.841232
Rf73	a_1210_314##5	a_1210_314##8	160.232803
Rf71	a_27_74##2	a_27_74##15	160.232803
Re1	VPWR#2	VPWR	4.549932
Re2	VPWR	VPWR#5	0.974985
Re3	VGND#2	VGND	4.549932
Re4	VGND	VGND#5	0.974985
*
*       CAPACITOR CARDS
*
*
C1	a_1011_424#	a_1210_314##4	2.58596e-17
C2	VGND#4	a_27_74##9	5.71505e-17
C3	Q#1	a_1210_314##6	4.60091e-17
C4	VGND#3	a_1011_424#	1.91391e-18
C5	a_1011_424##4	VGND#10	1.39997e-17
C6	VGND#3	a_27_74##9	6.65427e-17
C7	a_561_463##5	a_206_368#	1.11857e-18
C8	a_1210_314##6	VPWR#9	2.35979e-17
C9	CLK#6	a_27_74##3	3.62338e-19
C10	Q#1	a_1011_424##3	2.30336e-18
C11	a_1210_314##2	VPWR#3	1.06936e-18
C12	a_1210_314##11	a_1210_314##6	6.30924e-19
C13	a_1011_424##5	a_1210_314##5	1.69129e-18
C14	a_713_458##4	VGND#10	2.67083e-18
C15	a_1210_314#	a_1011_424#	3.66482e-18
C16	VPWR#9	a_1011_424##3	4.48528e-17
C17	VGND#3	a_1210_314#	2.27093e-18
C18	a_27_74##12	a_206_368##13	4.75858e-17
C19	a_1011_424##2	a_1210_314##9	5.42727e-17
C20	VGND#5	a_27_74##11	5.77738e-17
C21	CLK#6	CLK#1	3.76208e-18
C22	a_1011_424##5	a_206_368##9	1.08228e-18
C23	VPWR#10	a_1210_314##6	1.68379e-18
C24	Q#1	a_1210_314##3	6.27301e-20
C25	a_1011_424##3	a_1210_314##11	1.43438e-17
C26	VPWR#9	a_1210_314##3	1.27968e-18
C27	VPWR#10	a_1011_424##3	2.154e-18
C28	VGND#3	VGND#9	1.73758e-18
C29	a_1011_424##5	a_1011_424##2	2.55734e-18
C30	a_27_74##8	a_1210_314#	4.01064e-17
C31	a_206_368##9	VPWR#5	1.85169e-17
C32	a_1210_314##11	a_1210_314##3	2.97102e-18
C33	VGND#4	a_206_368##4	7.09846e-21
C34	VGND#3	a_206_368##4	1.98047e-19
C35	a_713_458##4	a_1011_424##4	2.0237e-17
C36	VPWR#10	a_1210_314##3	2.90596e-17
C37	VGND#4	a_206_368##5	3.18921e-18
C38	a_1210_314##11	a_206_368##6	1.45867e-19
C39	a_206_368##7	VPWR#3	3.07207e-17
C40	a_1011_424##5	a_1210_314##2	6.17615e-17
C41	a_206_368##9	a_1011_424##6	8.4714e-17
C42	VGND#3	a_1210_314##7	9.2332e-18
C43	a_206_368##5	a_27_74##8	1.03707e-17
C44	VPWR#10	a_206_368##6	1.8917e-18
C45	VGND#4	a_561_463##2	1.11943e-20
C46	a_454_503#	a_206_368##3	1.12339e-17
C47	VPWR#10	a_27_74##7	2.08082e-20
C48	VGND#4	a_561_463#	4.35922e-18
C49	a_206_368##9	a_713_458##7	8.04166e-17
C50	a_27_74##9	a_1011_424##5	2.87571e-18
C51	a_27_74##11	a_454_503##2	2.47878e-19
C52	a_206_368##6	a_1011_424##6	1.10296e-17
C53	a_561_463#	a_206_368##5	2.36733e-17
C54	a_27_74##12	VPWR#12	5.14747e-19
C55	VGND#3	a_561_463#	3.184e-19
C56	VGND#4	a_713_458##2	7.40041e-22
C57	VPWR#10	a_561_463##3	1.1392e-20
C58	a_1011_424##6	a_27_74##7	3.19208e-17
C59	VPWR#4	a_561_463##2	6.30164e-19
C60	a_206_368##9	VPWR#11	2.65146e-18
C61	a_1011_424##5	a_206_368##7	3.70537e-17
C62	VGND#4	a_713_458#	4.1394e-18
C63	a_27_74##11	a_27_74##9	3.40115e-18
C64	a_27_74##7	a_713_458##7	2.98435e-17
C65	a_713_458#	a_561_463#	1.17262e-17
C66	a_27_74##12	a_206_368##11	2.28418e-17
C67	VGND#6	a_206_368#	1.09106e-17
C68	a_206_368#	a_561_463#	1.33852e-18
C69	a_713_458##7	a_561_463##3	3.00995e-17
C70	VPWR#4	a_713_458##2	3.18669e-19
C71	a_713_458##5	a_713_458##7	3.77667e-19
C72	a_206_368##4	a_1011_424##5	5.65197e-17
C73	Q#2	Q#1	2.38173e-18
C74	a_561_463##3	VPWR#11	1.26257e-17
C75	VGND#4	a_206_368#	5.11185e-19
C76	a_206_368#	a_713_458#	4.25659e-17
C77	a_27_74##12	VPWR#13	4.45838e-18
C78	a_561_463##5	a_27_74##7	1.48103e-19
C79	a_713_458##7	a_713_458##3	6.03247e-19
C80	a_1011_424##5	a_1210_314##4	2.91213e-19
C81	a_206_368##9	a_561_463##5	4.4158e-17
C82	a_713_458##3	VPWR#11	1.13227e-17
C83	a_1011_424##5	a_561_463##2	1.24635e-19
C84	a_561_463##5	a_561_463##3	4.20615e-19
C85	a_1210_314##5	Q#2	6.85011e-17
C86	a_206_368#	a_27_74##6	3.32821e-17
C87	a_27_74##12	a_27_74##16	1.85326e-18
C88	a_27_74##9	a_713_458##5	1.51792e-18
C89	a_1210_314##5	VGND#9	2.22616e-17
C90	a_206_368##9	a_206_368##7	4.12638e-18
C91	a_561_463##5	a_713_458##3	8.11729e-18
C92	a_1011_424##5	a_1011_424#	7.74555e-20
C93	a_206_368##13	a_206_368##11	5.48729e-18
C94	a_206_368#	D#3	1.76158e-17
C95	a_1210_314##7	a_1210_314##5	2.06038e-18
C96	a_27_74##11	a_713_458##5	2.69797e-17
C97	a_27_74##11	a_561_463##2	1.542e-18
C98	VGND#6	D#3	6.93471e-19
C99	Q#2	a_1011_424##2	6.38138e-19
C100	a_561_463##5	a_27_74##4	2.04536e-17
C101	D#3	a_27_74##6	1.12021e-17
C102	a_206_368##4	a_206_368##9	1.84929e-18
C103	a_454_503#	a_561_463##7	2.17153e-17
C104	a_1011_424##2	a_1210_314##7	4.8065e-17
C105	a_1011_424##5	a_1210_314#	1.78376e-17
C106	VGND#6	a_206_368##2	1.32208e-17
C107	a_561_463##5	a_206_368##3	3.24538e-17
C108	VGND#10	a_1011_424##2	2.10734e-17
C109	VPWR#6	D#2	8.7169e-19
C110	a_27_74##11	a_713_458##2	8.19317e-17
C111	a_454_503##2	a_206_368##3	1.96427e-17
C112	a_713_458##5	a_206_368##4	3.54747e-17
C113	a_206_368##11	a_27_74##4	4.29425e-19
C114	a_561_463##2	a_206_368##9	4.58343e-17
C115	a_561_463##5	D#1	6.38801e-19
C116	a_206_368##11	a_206_368##9	2.46366e-18
C117	a_1011_424##5	a_27_74##8	3.75659e-17
C118	VGND#10	a_1210_314##2	8.8721e-19
C119	D#1	a_454_503##2	1.34268e-17
C120	a_27_74##11	a_27_74##5	8.15408e-19
C121	VGND#9	a_27_74##9	1.67886e-19
C122	a_206_368##11	a_206_368##3	1.10699e-17
C123	VPWR#6	a_206_368##2	1.20409e-18
C124	a_206_368##14	a_561_463##7	1.3686e-18
C125	CLK#3	a_27_74#	1.71871e-17
C126	a_713_458##5	a_561_463##2	1.99174e-17
C127	D#1	VPWR#12	1.09331e-17
C128	a_1210_314##7	a_27_74##9	2.59798e-19
C129	a_713_458##2	a_206_368##9	1.33495e-18
C130	a_454_503##2	a_27_74##3	3.57228e-19
C131	a_27_74##9	VGND#10	1.32776e-17
C132	a_206_368##11	D#1	3.17173e-17
C133	a_206_368##13	a_27_74##5	1.10397e-19
C134	a_1011_424##5	a_206_368##5	5.52572e-19
C135	a_27_74##12	D#4	2.2357e-17
C136	a_206_368##14	a_454_503#	2.53024e-18
C137	a_27_74##11	a_1210_314#	2.77164e-20
C138	a_27_74##11	D#4	4.95506e-18
C139	VPWR#13	D#1	4.73752e-19
C140	a_27_74##9	a_1011_424##4	4.34052e-17
C141	a_713_458##2	a_713_458##5	1.57941e-17
C142	a_206_368##11	a_27_74##3	6.4498e-17
C143	a_27_74##9	a_713_458##4	2.5476e-17
C144	a_27_74##3	VPWR#13	2.16417e-17
C145	a_206_368##13	D#4	3.25668e-17
C146	a_27_74##9	VGND#11	1.87651e-17
C147	a_27_74##12	D#2	2.20882e-18
C148	a_1210_314##5	Q#1	3.41827e-17
C149	a_1011_424##5	a_561_463#	1.90184e-19
C150	a_206_368##11	CLK#1	3.54746e-18
C151	a_27_74##11	a_27_74##8	6.35514e-20
C152	CLK#6	a_27_74##12	1.93947e-17
C153	a_27_74##16	a_27_74##3	7.5405e-18
C154	a_27_74##5	a_713_458##5	5.06111e-18
C155	a_1210_314##5	VPWR#9	3.19339e-17
C156	CLK#1	VPWR#13	2.97094e-17
C157	a_27_74##16	CLK#1	6.14081e-17
C158	a_206_368##13	D#2	8.41599e-19
C159	a_206_368##4	a_1011_424##4	3.30513e-17
C160	a_27_74##12	a_206_368##2	5.11755e-17
C161	a_27_74##11	a_206_368##5	1.65145e-18
C162	a_27_74##11	a_206_368##2	1.09453e-18
C163	a_713_458##4	a_206_368##4	3.31196e-17
C164	a_1011_424##3	a_1210_314##6	3.0955e-17
C165	VGND#3	a_1011_424##5	1.4935e-18
C166	Q#1	a_1210_314##2	1.55187e-19
C167	a_713_458##5	a_206_368##9	1.78344e-19
C168	a_1210_314##3	a_1210_314##6	7.04045e-19
C169	VPWR#9	a_1210_314##2	4.42856e-19
C170	a_206_368##13	a_206_368##2	2.413e-17
C171	a_27_74##12	a_27_74##2	2.3429e-17
C172	a_1210_314##2	a_1210_314##11	2.22132e-17
C173	a_206_368#	a_206_368##3	9.08304e-19
C174	a_27_74##11	a_561_463#	1.60409e-17
C175	a_1210_314##3	a_1011_424##3	3.74047e-18
C176	VGND#11	a_561_463##2	3.13631e-19
C177	a_1210_314##2	VPWR#10	2.18561e-17
C178	a_206_368##11	VPWR#5	2.34528e-17
C179	a_27_74##13	VGND#13	3.77155e-17
C180	a_206_368##13	a_27_74##2	6.41787e-18
C181	VGND#6	a_27_74##12	3.15002e-17
C182	a_1011_424##6	a_1210_314##2	3.18123e-18
C183	a_27_74##12	CLK#2	3.79375e-17
C184	a_206_368##6	a_1210_314##3	1.01587e-17
C185	a_713_458##2	VGND#11	1.83056e-18
C186	a_27_74##11	a_713_458#	2.60715e-17
C187	a_206_368##7	a_1210_314##11	5.98246e-18
C188	a_561_463##7	a_713_458##2	4.55831e-18
C189	a_27_74##12	a_206_368#	1.00591e-19
C190	a_206_368##7	VPWR#10	2.67885e-17
C191	a_206_368##13	CLK#2	3.48709e-19
C192	a_1011_424##5	VGND#10	1.24668e-17
C193	a_27_74##7	a_206_368##6	1.65705e-17
C194	VGND#6	a_27_74##11	2.03433e-17
C195	a_27_74##11	a_206_368#	5.46945e-17
C196	a_206_368##7	a_1011_424##6	5.38195e-17
C197	a_1210_314##9	VPWR#3	6.67721e-19
C198	a_561_463##7	a_27_74##5	7.16965e-17
C199	CLK#6	a_27_74##16	3.72726e-17
C200	a_454_503#	a_27_74##5	2.9315e-19
C201	a_1210_314##5	a_1210_314##4	6.82604e-18
C202	VPWR#3	a_1210_314##6	3.41275e-19
C203	a_561_463##3	a_27_74##7	1.34822e-17
C204	a_206_368##4	a_1011_424##6	4.96681e-17
C205	a_1210_314##5	a_1011_424#	7.91278e-19
C206	CLK#6	a_27_74##2	2.11364e-19
C207	VGND#4	a_27_74##11	4.18879e-18
C208	a_561_463##7	D#4	2.39839e-19
C209	a_713_458##5	a_27_74##8	4.67704e-20
C210	a_27_74##11	a_27_74##6	1.30442e-17
C211	a_713_458##7	a_206_368##4	2.28109e-17
C212	a_1011_424##2	a_1210_314##4	4.74365e-18
C213	a_1210_314##5	a_1210_314#	1.94872e-19
C214	a_454_503#	D#4	6.62223e-17
C215	VGND#12	D#4	1.48055e-18
C216	a_1210_314##5	a_27_74##8	1.16266e-19
C217	a_713_458##3	a_561_463##3	2.50895e-17
C218	VPWR#9	Q#1	7.83848e-17
C219	a_27_74##12	D#3	1.01789e-18
C220	a_206_368##14	D#4	1.77281e-18
C221	a_1210_314#	a_1011_424##2	4.37926e-18
C222	a_713_458##7	a_561_463##2	6.76788e-17
C223	a_1011_424##4	a_1011_424##5	2.34984e-18
C224	CLK#6	CLK#2	9.21835e-18
C225	D#2	a_454_503#	2.99714e-18
C226	a_561_463##2	VPWR#11	5.40339e-18
C227	a_1011_424##2	a_27_74##8	7.32058e-20
C228	VGND#4	a_27_74##7	8.94741e-20
C229	a_27_74##11	D#3	3.15482e-17
C230	VGND#5	a_206_368#	1.92903e-17
C231	a_1210_314##11	Q#1	1.38969e-18
C232	a_27_74##4	a_713_458##3	3.82121e-17
C233	VPWR#4	a_1210_314##3	5.55592e-20
C234	a_713_458##2	a_713_458##7	1.68237e-18
C235	VGND#3	a_27_74##7	2.3487e-20
C236	a_561_463##5	a_561_463##2	1.93798e-18
C237	VGND#5	a_27_74##6	1.86864e-18
C238	a_561_463##7	a_206_368##2	2.8003e-19
C239	a_27_74##9	a_1011_424#	1.68781e-18
C240	a_27_74##8	a_1210_314##2	3.84894e-17
C241	a_27_74##12	a_27_74#	2.80549e-17
C242	a_454_503#	a_206_368##2	3.48969e-18
C243	VPWR#3	a_1210_314##3	6.71393e-18
C244	a_713_458##4	a_1011_424##5	3.10154e-18
C245	a_27_74##9	a_1210_314#	1.28932e-17
C246	a_713_458##5	a_561_463#	1.65613e-17
C247	Q#2	a_1210_314##4	2.44104e-17
C248	VGND#12	a_206_368##2	9.78873e-18
C249	a_1210_314##11	VPWR#9	5.15914e-17
C250	a_27_74##11	VGND#10	7.9461e-19
C251	a_206_368##3	a_27_74##4	1.82976e-17
C252	a_27_74##9	a_27_74##8	6.0467e-19
C253	a_206_368##9	a_668_503#	1.16531e-18
C254	a_561_463##5	a_713_458##2	1.2583e-19
C255	a_206_368##9	a_206_368#	5.50229e-19
C256	a_206_368##14	a_206_368##2	9.40566e-18
C257	a_27_74##9	a_206_368##5	2.79951e-17
C258	VPWR#4	a_206_368##6	7.062e-20
C259	a_1210_314##4	VGND#9	1.70623e-17
C260	a_561_463##7	a_561_463##5	2.88927e-18
C261	D#1	a_27_74##4	7.0657e-19
C262	a_27_74##12	CLK#3	1.44367e-17
C263	a_27_74##8	a_206_368##7	2.11626e-17
C264	VPWR#10	VPWR#9	7.26498e-18
C265	a_27_74##9	a_561_463#	1.82554e-17
C266	Q#2	a_1011_424#	1.77675e-18
C267	a_561_463##5	a_27_74##5	9.45535e-17
C268	D#1	a_206_368##3	1.40204e-17
C269	VPWR#3	a_206_368##6	5.125e-18
C270	a_1210_314##9	a_1011_424##3	1.08452e-17
C271	a_27_74##9	a_713_458#	1.71488e-19
C272	a_1210_314##7	a_1210_314##4	7.28536e-19
C273	a_27_74##2	VGND#13	1.18711e-18
C274	a_454_503#	a_561_463##5	5.01077e-17
C275	a_206_368##4	a_27_74##8	3.11599e-17
C276	a_206_368#	a_27_74##9	3.36495e-19
C277	a_27_74##3	a_206_368##3	2.92439e-19
C278	VGND#9	a_1011_424#	2.96067e-17
C279	VPWR#10	a_1210_314##11	1.59964e-17
C280	a_561_463##5	D#4	5.17922e-19
C281	a_206_368##11	a_27_74##5	4.11882e-19
C282	a_1210_314##5	a_1210_314##6	6.37402e-18
C283	a_206_368##13	a_27_74#	1.94239e-19
C284	VPWR#4	a_27_74##7	6.30219e-18
C285	Q#2	a_1210_314#	7.03009e-20
C286	a_27_74##3	D#1	2.46984e-18
C287	a_561_463#	a_206_368##4	8.92482e-18
C288	a_561_463##2	a_27_74##8	7.78907e-19
C289	a_1210_314##5	a_1011_424##3	5.68141e-18
C290	a_1210_314##7	a_1011_424#	2.27569e-17
C291	VPWR#3	a_27_74##7	1.76881e-19
C292	CLK#2	a_27_74##13	3.82131e-17
C293	a_561_463##5	D#2	7.22291e-19
C294	a_206_368##11	D#4	2.03891e-19
C295	D#2	a_454_503##2	6.25212e-17
C296	CLK#1	a_27_74##3	4.86488e-17
C297	VGND#10	a_1011_424#	1.01218e-18
C298	D#2	VPWR#12	2.76631e-18
C299	VPWR#5	a_713_458##3	2.84562e-18
C300	a_561_463##5	a_206_368##2	2.0895e-19
C301	a_206_368##11	D#2	5.98089e-17
C302	VPWR#4	a_561_463##3	1.40046e-17
C303	a_1210_314##7	a_1210_314#	1.09797e-18
C304	a_1210_314##2	a_1011_424##3	8.85135e-18
C305	a_713_458##2	a_561_463#	1.88769e-17
C306	a_454_503##2	a_206_368##2	4.22504e-18
C307	VPWR#5	a_27_74##4	5.18568e-18
C308	a_27_74##11	a_713_458##4	2.65096e-17
C309	VPWR#3	a_561_463##3	3.96625e-20
C310	VPWR#5	a_206_368##3	2.87201e-18
C311	VGND#10	a_1210_314#	3.82339e-17
C312	a_206_368##11	a_206_368##2	1.01108e-17
C313	a_206_368#	a_713_458##2	1.05329e-17
C314	VGND#6	a_206_368##3	1.70535e-19
C315	a_454_503#	a_206_368##11	7.87506e-19
C316	VPWR#6	a_713_458##3	5.42072e-19
C317	a_27_74##6	a_713_458##2	5.45124e-18
C318	VGND#5	a_206_368##3	1.20592e-19
C319	a_27_74##7	a_1210_314##2	1.99585e-18
C320	a_206_368##7	a_1011_424##3	3.75857e-19
C321	a_206_368#	a_27_74##5	2.67937e-18
C322	VPWR#4	a_713_458##3	1.11029e-17
C323	a_206_368##11	a_27_74##2	6.76327e-19
C324	a_206_368##7	a_1210_314##3	2.18506e-17
C325	a_27_74##11	VGND#11	5.23952e-17
C326	a_27_74##9	a_27_74##7	4.81853e-19
C327	VGND#10	a_27_74##8	3.13495e-18
C328	a_27_74##11	a_731_101#	1.30822e-19
C329	a_206_368##7	a_206_368##6	2.10532e-17
C330	a_206_368#	D#4	8.37769e-19
C331	a_1011_424##4	a_1210_314#	3.17444e-18
C332	a_27_74##7	a_206_368##7	2.65303e-17
C333	VPWR#6	a_27_74##4	1.04427e-18
C334	D#4	a_27_74##6	5.26666e-18
C335	CLK#2	a_27_74##16	4.07047e-18
C336	a_206_368##4	a_27_74##7	4.81045e-17
C337	VGND#10	a_206_368##5	4.24249e-19
C338	VPWR#4	a_27_74##4	2.19498e-18
C339	a_713_458##4	a_1210_314#	2.73017e-19
C340	D#4	a_27_74#	3.78022e-19
C341	a_1011_424##4	a_27_74##8	2.87275e-17
C342	a_561_463##2	a_27_74##7	1.6899e-17
C343	a_206_368##2	a_206_368#	2.01263e-19
C344	a_1011_424##5	a_27_74##7	4.31629e-18
C345	a_561_463##2	a_561_463##3	6.012e-18
C346	VPWR#6	a_206_368##3	3.67533e-20
C347	a_1210_314##11	VPWR#3	2.81174e-18
C348	VGND#10	a_561_463#	2.57144e-19
C349	a_713_458##4	a_27_74##8	1.26287e-18
C350	a_206_368##2	D#3	9.50189e-18
C351	a_561_463##2	a_713_458##3	2.22767e-17
C352	a_27_74#	a_206_368##2	2.53771e-17
C353	a_206_368##5	a_1011_424##4	2.06632e-17
C354	a_27_74##11	a_561_463##7	1.07202e-16
C355	a_561_463##2	a_206_368##3	1.21032e-19
C356	a_27_74##5	a_561_463##3	1.96181e-19
C357	a_206_368##5	a_713_458##4	1.45699e-17
C358	a_27_74##5	a_713_458##3	3.61118e-17
C359	CLK#3	a_27_74##2	8.39467e-19
C360	a_1011_424##4	a_561_463#	7.14925e-19
C361	VPWR#6	D#1	1.16143e-17
C362	a_27_74##11	a_454_503#	3.65044e-17
C363	a_1011_424##2	a_1210_314##5	7.81816e-17
C364	a_206_368##3	a_27_74##5	4.58207e-17
C365	VPWR#4	D#1	1.29877e-18
C366	a_27_74##13	a_27_74##16	3.00164e-19
C367	a_27_74##12	VGND#12	5.55297e-17
C368	a_561_463#	a_713_458##4	1.34691e-17
C369	a_1210_314##2	a_1210_314##5	3.72762e-18
C370	D#4	a_206_368##3	4.12654e-18
C371	a_1210_314##2	a_1011_424##2	2.67027e-17
C372	a_561_463#	VGND#11	1.91654e-17
C373	D#2	a_206_368##3	1.54343e-17
C374	VPWR#6	a_27_74##3	2.2765e-18
C375	a_27_74##11	VGND#12	4.0553e-17
C376	a_713_458##4	a_713_458#	1.25133e-19
C377	a_1210_314#	a_1168_124#	1.05553e-17
C378	a_27_74##12	a_206_368##14	9.63007e-17
C379	a_27_74##3	D#2	4.29161e-18
C380	a_27_74##8	a_1168_124#	1.05553e-17
C381	a_206_368##7	a_1210_314##2	4.91345e-17
C382	a_713_458#	VGND#11	1.24709e-17
C383	VGND#5	a_713_458##2	5.05695e-20
C384	a_27_74##3	a_206_368##2	4.20687e-18
C385	a_206_368##9	a_206_368##6	1.05811e-18
C386	VPWR#5	a_27_74##5	1.15238e-19
C387	a_206_368##4	a_1210_314##2	5.18939e-20
C388	a_206_368##6	a_1118_508#	1.13814e-17
C389	VGND#5	a_27_74##5	2.46783e-19
C390	VPWR#6	CLK#1	6.73424e-19
C391	a_27_74##9	a_206_368##4	2.82193e-18
C392	a_1210_314##9	a_1210_314##11	2.4669e-19
C393	a_27_74##12	VGND#13	7.59405e-17
C394	CLK#2	a_27_74##3	1.86491e-18
C395	VGND#11	a_206_368#	3.85267e-18
C396	a_206_368##9	a_27_74##7	4.74168e-17
C397	a_561_463##2	a_206_368##4	1.40122e-17
C398	a_713_458##3	a_668_503#	4.99322e-18
C399	a_27_74##4	a_668_503#	7.48933e-18
C400	a_713_458##5	a_713_458##4	9.68436e-20
C401	a_27_74##13	a_27_74##12	2.74505e-18
C402	a_713_458##2	a_561_463##2	8.36158e-17
C403	a_713_458#	a_731_101#	2.56827e-18
C404	a_206_368#	a_561_463##7	1.18568e-17
C405	a_206_368#	a_731_101#	6.39828e-18
C406	a_206_368##9	a_561_463##3	3.76026e-17
C407	a_454_503##2	a_561_463##5	7.11355e-17
C408	VPWR#4	VPWR#11	6.06645e-18
C409	a_27_74##5	a_561_463##2	4.62317e-17
C410	a_206_368##9	VPWR#4	8.51175e-17
C411	a_27_74##5	a_713_458##2	4.25565e-17
C412	a_713_458##5	a_27_74##7	6.69178e-19
C413	a_454_503#	a_206_368#	3.15805e-18
C414	a_27_74##11	a_206_368##3	1.35523e-18
C415	a_561_463##7	a_27_74##6	2.70435e-17
C416	D#4	a_27_74##5	1.48078e-18
C417	VGND#12	a_206_368#	1.03308e-17
C418	a_206_368##9	a_713_458##3	2.23578e-17
C419	VPWR	VPWR#6	8.97962e-17
C420	VPWR	VPWR#4	1.03292e-16
C421	a_206_368##9	VPWR#3	1.97887e-17
C422	VPWR	VPWR#3	1.10219e-16
C423	a_27_74##6	a_454_503#	1.09921e-17
C424	a_206_368##2	a_27_74##5	5.64311e-19
C425	a_206_368##11	a_561_463##5	3.92987e-17
C426	VPWR	a_1210_314##9	1.29774e-18
C427	a_561_463##7	D#3	2.79427e-18
C428	VPWR	a_1011_424##5	6.86979e-18
C429	D#4	a_206_368##2	7.16833e-17
C430	a_206_368##7	a_1118_508#	3.0984e-18
C431	Q	Q#2	1.0608e-18
C432	VPWR	a_27_74##12	2.68044e-18
C433	VGND#9	Q	2.03288e-17
C434	D#2	a_206_368##2	4.68257e-17
C435	D#4	a_27_74##2	3.99567e-19
C436	VGND#9	Q#2	9.72952e-18
C437	VPWR	a_206_368##13	3.60685e-18
C438	VPWR	a_206_368##9	5.60455e-17
C439	VGND	VGND#6	7.97578e-17
C440	a_206_368##11	a_454_503##2	4.07003e-17
C441	a_206_368##9	a_27_74##4	2.2962e-17
C442	a_454_503#	D#3	1.87078e-17
C443	VGND	VGND#4	8.09673e-17
C444	VGND	VGND#3	1.06186e-16
C445	a_27_74##2	a_206_368##2	2.5092e-17
C446	a_27_74##12	a_27_74##3	2.78808e-18
C447	a_206_368##14	a_27_74##6	1.92927e-19
C448	a_561_463##7	a_27_74#	1.49287e-19
C449	VPWR	CLK#6	3.43457e-18
C450	VGND	a_1210_314##9	6.46799e-19
C451	D#3	VGND#12	9.56911e-18
C452	CLK#2	a_27_74##2	3.83176e-17
C453	VGND	a_1011_424##5	6.4928e-18
C454	a_206_368##11	VPWR#12	5.88375e-18
C455	a_1210_314##7	Q#2	2.5312e-18
C456	VGND	a_27_74##12	4.16835e-17
C457	VGND	a_27_74##11	5.3204e-17
C458	a_454_503#	a_27_74#	2.76107e-19
C459	VGND	a_206_368##13	2.01137e-18
C460	VPWR	a_561_463##7	3.74393e-18
C461	a_206_368##9	a_206_368##3	9.84229e-19
C462	a_206_368##14	D#3	7.58344e-19
C463	VGND	a_713_458##5	3.76738e-18
C464	VGND#6	VNB	3.62882e-17
C465	VGND#4	VNB	4.55926e-17
C466	VGND#3	VNB	5.59277e-17
C467	Q	a_1210_314##4	1.08067e-17
C468	VGND#12	a_27_74#	4.29376e-19
C469	a_27_74##12	CLK#1	3.80988e-18
C470	Q	a_1011_424#	6.57528e-19
C471	VPWR#6	VNB	4.75181e-17
C472	VPWR#4	VNB	5.32556e-17
C473	VPWR	a_1011_424##6	6.56296e-18
C474	VPWR#3	VNB	5.45894e-17
C475	VPWR	a_713_458##7	6.30988e-18
C476	a_1210_314##7	VGND#9	3.79275e-17
C477	VGND	a_1011_424##4	1.00531e-17
C478	a_1210_314##9	VNB	5.96788e-18
C479	VGND	a_713_458##4	5.91277e-18
C480	VPWR	a_561_463##5	1.18828e-17
C481	VGND	VGND#11	1.46502e-17
C482	a_1011_424##5	VNB	9.10578e-18
C483	VPWR	a_454_503##2	6.72836e-18
C484	VGND	a_561_463##7	9.16642e-18
C485	a_27_74##12	VNB	1.75732e-17
C486	VGND	a_454_503#	7.20906e-18
C487	VPWR	a_206_368##11	5.97887e-17
C488	a_27_74##11	VNB	2.08921e-17
C489	VGND	VGND#12	1.67249e-17
C490	a_206_368##13	a_27_74##3	6.17823e-19
C491	a_27_74#	a_206_368##14	1.66021e-17
C492	VGND	a_206_368##14	7.46631e-18
C493	VPWR	a_27_74##16	2.02859e-17
C494	a_206_368##13	VNB	4.38269e-18
C495	VPWR#13	a_206_368##11	5.35288e-17
C496	VGND	a_27_74##13	1.47973e-17
C497	a_206_368##9	VNB	7.01913e-18
C498	a_206_368##9	D#1	3.92506e-19
C499	a_713_458##5	VNB	3.38468e-18
C500	VPWR	a_27_74##8	4.32276e-20
C501	VPWR#6	VPWR#12	5.99924e-18
C502	VGND#12	CLK#3	7.51081e-20
C503	VGND	a_1011_424##6	1.81272e-18
C504	CLK#6	VNB	1.21755e-17
C505	Q#2	VNB	4.52656e-17
C506	VGND	a_561_463##5	1.20856e-18
C507	VGND#9	VNB	9.77978e-19
C508	a_1210_314##7	VNB	1.08478e-17
C509	a_27_74#	VGND#13	2.35554e-17
C510	VGND#10	VNB	9.39047e-18
C511	VGND	a_206_368##11	1.79284e-18
C512	VGND#11	VNB	2.65439e-18
C513	a_27_74##16	a_206_368##11	2.68268e-17
C514	a_561_463##7	VNB	4.29055e-18
C515	a_454_503#	VNB	2.62214e-20
C516	VGND#12	VNB	5.27855e-18
C517	VGND	a_1210_314#	4.33488e-18
C518	a_206_368##14	VNB	1.02349e-18
C519	VPWR	a_1210_314##3	1.06061e-18
C520	VGND#13	VNB	1.81847e-18
C521	a_27_74##13	VNB	4.03291e-17
C522	VPWR	a_206_368##6	1.01691e-18
C523	Q#1	VNB	5.95097e-17
C524	VGND	a_561_463#	5.00585e-18
C525	VPWR	a_27_74##7	6.49571e-18
C526	VPWR#9	VNB	1.49391e-18
C527	VGND	a_713_458#	9.58702e-18
C528	a_1210_314##11	VNB	7.26768e-18
C529	VPWR	a_561_463##3	5.04658e-19
C530	VPWR#10	VNB	7.66801e-18
C531	VGND	a_206_368#	1.33398e-17
C532	VPWR	a_713_458##3	7.981e-18
C533	a_1011_424##6	VNB	2.58864e-18
C534	a_206_368##13	CLK#1	4.37392e-20
C535	a_27_74##13	a_27_74#	6.55322e-19
C536	VGND	D#3	2.63292e-18
C537	VPWR	a_27_74##4	6.30671e-18
C538	a_713_458##7	VNB	4.35019e-18
C539	VGND	a_27_74#	2.97971e-18
C540	VGND	CLK#3	1.60056e-18
C541	a_561_463##5	VNB	7.35453e-18
C542	VPWR	D#1	5.76405e-18
C543	a_454_503##2	VNB	6.84605e-18
C544	VPWR	a_27_74##3	3.35659e-18
C545	a_206_368##11	VNB	2.42179e-17
C546	VPWR	CLK#1	1.7165e-18
C547	VPWR#13	VNB	3.10958e-18
C548	a_27_74##16	VNB	4.83707e-17
C549	VGND#13	CLK#3	2.98039e-17
C550	a_1210_314##4	VNB	3.22649e-17
C551	a_27_74##16	VPWR#13	7.28878e-17
C552	a_1011_424#	VNB	2.60898e-17
C553	a_1210_314#	VNB	3.34255e-17
C554	a_27_74##8	VNB	4.2512e-17
C555	a_206_368##5	VNB	2.88501e-17
C556	VPWR	VPWR#5	5.90428e-17
C557	a_561_463#	VNB	4.129e-17
C558	a_206_368##11	VPWR#6	7.68633e-17
C559	a_713_458#	VNB	2.64544e-17
C560	VGND#10	a_1210_314##7	4.63451e-17
C561	a_206_368#	VNB	1.22893e-16
C562	a_27_74##6	VNB	3.21913e-17
C563	D#3	VNB	2.41668e-17
C564	VPWR	a_1011_424##2	1.17856e-18
C565	a_27_74#	VNB	3.18356e-17
C566	VPWR	a_1210_314##2	5.76244e-18
C567	CLK#3	VNB	3.29054e-17
C568	VGND#3	a_1011_424##2	1.28702e-18
C569	a_1210_314##6	VNB	4.13654e-17
C570	a_1011_424##3	VNB	3.58205e-17
C571	VPWR	a_206_368##7	1.82372e-17
C572	a_1210_314##3	VNB	3.77979e-17
C573	VPWR	a_206_368##4	4.06684e-18
C574	a_206_368##6	VNB	2.20332e-17
C575	a_27_74##7	VNB	6.77293e-17
C576	a_27_74##13	CLK#3	2.0587e-17
C577	VGND	VGND#5	5.64236e-17
C578	VPWR	a_561_463##2	6.75527e-18
C579	a_561_463##3	VNB	3.67825e-17
C580	a_713_458##3	VNB	4.61738e-17
C581	a_27_74##12	a_27_74##11	2.4435e-18
C582	a_27_74##4	VNB	2.68004e-17
C583	VGND	a_1011_424##2	1.58605e-18
C584	VPWR	a_27_74##5	6.54021e-18
C585	a_206_368##3	VNB	6.37739e-17
C586	VGND	a_1210_314##2	3.94262e-18
C587	D#1	VNB	2.59471e-17
C588	VGND	a_27_74##9	5.07491e-17
C589	a_27_74##3	VNB	4.22332e-17
C590	CLK#1	VNB	4.51437e-17
C591	VPWR	D#2	6.56172e-18
C592	VGND	a_206_368##4	6.85285e-18
C593	VPWR	a_206_368##2	1.0464e-19
C594	VGND	a_561_463##2	2.49742e-18
C595	VPWR#5	VNB	3.1698e-17
C596	VGND	a_713_458##2	5.65277e-18
C597	VGND#5	VNB	2.5215e-17
C598	VGND	a_27_74##5	3.61149e-18
C599	a_1210_314##5	VNB	4.77239e-17
C600	VGND	D#4	6.17017e-18
C601	a_1011_424##2	VNB	6.70197e-17
C602	a_1210_314##2	VNB	6.25524e-17
C603	a_27_74##9	VNB	5.6902e-17
C604	VGND	a_206_368##2	3.7681e-18
C605	a_206_368##7	VNB	3.12799e-17
C606	VGND	a_27_74##2	2.43525e-19
C607	a_206_368##4	VNB	2.9475e-17
C608	a_561_463##2	VNB	5.44659e-17
C609	VGND	CLK#2	3.25479e-18
C610	a_1011_424##4	a_27_74##7	8.56232e-19
C611	a_713_458##2	VNB	5.66608e-17
C612	a_27_74##5	VNB	5.41697e-17
C613	D#4	VNB	4.1646e-17
C614	D#2	VNB	3.28406e-17
C615	a_206_368##2	VNB	1.37538e-16
C616	a_27_74##2	VNB	3.28983e-17
C617	CLK#2	VNB	6.5905e-17
C618	VPWR#13	VPWR#6	2.09653e-18
C619	a_713_458##4	a_27_74##7	1.08878e-18
C620	Q	VNB	1.49879e-17
C621	VPWR	VNB	2.98216e-16
C622	VGND	VNB	3.05625e-16
C623	VGND#7	CLK#3	4.98912e-18
C624	VGND#2	a_1011_424##2	5.27184e-18
C625	VGND#2	VGND#3	1.4725e-17
C626	VGND#2	VNB	1.51658e-16
C627	VPWR#7	CLK#1	5.58143e-18
C628	VPWR#7	VNB	4.59959e-17
C629	VPWR#2	a_1210_314##3	1.12109e-18
C630	VPWR#2	VNB	1.54444e-16
C631	VPWR#7	VPWR#6	7.5097e-19
C632	VPWR#2	VPWR#3	1.26187e-17
C633	VGND#2	Q	4.32749e-17
C634	a_1210_314##11	VPWR#2	1.58357e-17
C635	VGND#2	a_1210_314##7	2.45171e-17
C636	VGND#7	a_27_74##13	1.76844e-17
C637	VGND#7	VGND#6	1.71606e-19
C638	a_27_74##12	VPWR#7	2.24962e-19
C639	a_206_368##11	VPWR#7	9.23714e-18
C640	VGND#7	a_206_368##2	8.96009e-19
C641	VPWR#7	a_27_74##2	1.28936e-19
C642	VGND#7	CLK#2	1.55626e-19
C643	VGND#2	a_1210_314##9	2.70674e-18
C644	a_1210_314##5	VPWR#2	5.9953e-18
C645	VGND#7	VNB	5.40127e-17
C646	VPWR#7	a_27_74##3	6.63405e-18
C647	VPWR#10	VPWR#2	3.4819e-18
C648	VGND#7	a_27_74#	6.32611e-18
C649	a_27_74##16	VPWR#7	2.11169e-17
C650	VPWR#2	a_1210_314##6	1.67231e-17
C651	a_1210_314##9	VPWR#2	1.97721e-18
C652	VGND#2	a_27_74##9	7.36457e-20
C653	VPWR#2	Q#1	4.53106e-17
C654	VPWR#2	a_1011_424##2	3.25847e-18
C655	VGND#2	a_1210_314##4	6.51531e-18
C656	VGND#7	VGND#12	1.86643e-19
C657	VGND#2	a_1210_314##5	5.04023e-18
C658	VGND#7	a_27_74##2	1.04364e-19
C659	VPWR#2	a_1011_424##3	5.9852e-18
C660	VPWR	VPWR#7	8.83952e-17
C661	VPWR#7	CLK#2	1.54809e-19
C662	VGND#2	VGND#9	1.52501e-17
C663	VGND#7	a_27_74##12	3.67694e-17
C664	VGND	VGND#7	1.02084e-16
C665	VGND#2	a_1011_424#	1.93254e-18
*
*
.ENDS sky130_fd_sc_hs__dfxtp_1
*
