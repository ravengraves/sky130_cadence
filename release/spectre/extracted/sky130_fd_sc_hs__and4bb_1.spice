* Extracted by Quantus, converted by sky130cad/quantus.py
*
*
*
*                       LINUX           Wed Nov 18 08:19:24 2026
*
*
*
*  PROGRAM  advgen
*
*  Name           : advgen - Quantus - (64-bit)
*  Version        : 25.1.0-p047
*  Build Date     : Thu Dec 11 23:20:30 PST 2025
*
*  HSPICE LIBRARY
*
*  OPERATING_TEMPERATURE 150
*  QRC_TECH_DIR <path>/tech
*
*
*

*
.SUBCKT sky130_fd_sc_hs__and4bb_1 VPB VNB VGND VPWR X C D A_N B_N
*
*
*  caps2d version: 10
*
*
*       TRANSISTOR CARDS
*
*
XM13 a_27_74##7 A_N#4 VGND#7 VNB sky130_fd_pr__nfet_01v8_lvt l=0.15 w=0.55 ad=0.15675 as=0.22625 pd=1.67 ps=2.13
XM1 VGND#7 a_179_48##3 X#2 VNB sky130_fd_pr__nfet_01v8_lvt l=0.15 w=0.74 ad=0.22625 as=0.2109 pd=2.13 ps=2.05
XM11 a_179_48##10 a_27_74# a_455_74# VNB sky130_fd_pr__nfet_01v8_lvt l=0.15 w=0.64 ad=0.1824 as=0.1536 pd=1.85 ps=1.76
XM9 a_455_74# a_503_48##3 a_533_74# VNB sky130_fd_pr__nfet_01v8_lvt l=0.15 w=0.64 ad=0.1536 as=0.2688 pd=1.76 ps=2.12
XM12 a_533_74# C#3 a_647_74# VNB sky130_fd_pr__nfet_01v8_lvt l=0.15 w=0.64 ad=0.2688 as=0.2304 pd=2.12 ps=2
XM4 a_647_74# D#3 VGND#6 VNB sky130_fd_pr__nfet_01v8_lvt l=0.15 w=0.64 ad=0.2304 as=0.30365 pd=2 ps=2.25
XM5 VGND#6 B_N#4 a_503_48##4 VNB sky130_fd_pr__nfet_01v8_lvt l=0.15 w=0.55 ad=0.30365 as=0.15675 pd=2.25 ps=1.67
XM0 a_27_74##8 A_N#1 VPWR#11 VPB sky130_fd_pr__pfet_01v8 l=0.15 w=0.84 ad=0.2478 as=0.406 pd=2.27 ps=3.01
XM7 VPWR#11 a_179_48# X#1 VPB sky130_fd_pr__pfet_01v8 l=0.15 w=1.12 ad=0.406 as=0.4816 pd=3.01 ps=3.1
XM6 VPWR#10 a_27_74##4 a_179_48##9 VPB sky130_fd_pr__pfet_01v8 l=0.15 w=0.84 ad=0.2478 as=0.294 pd=2.27 ps=2.38
XM10 a_179_48##9 a_503_48# VPWR#9 VPB sky130_fd_pr__pfet_01v8 l=0.15 w=0.84 ad=0.294 as=0.336 pd=2.38 ps=2.48
XM8 VPWR#9 C#1 a_179_48##5 VPB sky130_fd_pr__pfet_01v8 l=0.15 w=0.84 ad=0.336 as=0.252 pd=2.48 ps=2.28
XM2 a_179_48##5 D#1 VPWR#8 VPB sky130_fd_pr__pfet_01v8 l=0.15 w=0.84 ad=0.252 as=0.3528 pd=2.28 ps=2.52
XM3 VPWR#8 B_N#3 a_503_48##7 VPB sky130_fd_pr__pfet_01v8 l=0.15 w=0.84 ad=0.3528 as=0.2478 pd=2.52 ps=2.27
*
*
*       RESISTOR AND CAP/DIODE CARDS
*
Rg1	A_N#1	A_N#2	391.522156
Rg2	A_N#2	A_N#3	28.628225
Rg3	A_N#2	A_N#4	423.379517
Rg4	a_179_48#	a_179_48##2	474.414978
Rg5	a_179_48##2	a_179_48##3	380.521820
Rg6	a_179_48##2	a_179_48##4	65.054771
Rg7	a_27_74#	a_27_74##2	441.045807
Rg8	a_27_74##2	a_27_74##3	15.414896
Rg9	a_27_74##2	a_27_74##4	418.543243
Rg10	a_503_48#	a_503_48##2	468.919586
Rg11	a_503_48##2	a_503_48##3	390.954865
Rg12	C#1	C#2	432.136475
Rg13	C#2	C#3	352.883240
Rg14	D#1	D#2	448.493469
Rg15	D#2	D#3	377.720428
Rg16	B_N#1	B_N#2	36.519821
Rg17	B_N#2	B_N#3	517.301331
Rg18	B_N#2	B_N#4	382.733826
Rf1	A_N	A_N#3	168.989502
Rf2	X#1	X	20.117744
Rf3	X	X#2	100.948372
Rf4	a_27_74##3	a_27_74##6	206.810577
Rf5	a_27_74##6	a_27_74##7	126.887398
Rf6	a_27_74##6	a_27_74##8	16.164433
Rf7	C#4	C#2	81.110611
Rf8	C	C#6	0.994210
Rf9	C#4	C#6	5.511418
Rf10	a_179_48##5	a_179_48##6	81.937683
Rf11	a_179_48##6	a_179_48##7	86.044991
Rf12	a_179_48##7	a_179_48##4	214.210541
Rf13	a_179_48##6	a_179_48##9	25.020260
Rf14	a_179_48##7	a_179_48##10	14.052214
Rf15	D#4	D	2.439365
Rf16	D#2	D#6	82.555763
Rf17	D#4	D#6	3.181471
Rf18	a_503_48##4	a_503_48##5	42.560596
Rf19	a_503_48##5	a_503_48##2	202.842224
Rf20	a_503_48##5	a_503_48##7	115.217712
Rf21	B_N	B_N#1	168.989502
Rf23	VPWR#2	VPWR#3	74.462440
Rf24	VPWR#3	VPWR#4	40.883747
Rf25	VPWR#4	VPWR#5	32.117687
Rf26	VPWR#5	VPWR#6	83.593750
Rf28	VPWR#2	VPWR#8	32.814167
Rf29	VPWR#3	VPWR#9	31.141060
Rf30	VPWR#5	VPWR#10	33.326477
Rf31	VPWR#6	VPWR#11	33.326477
Rf33	VGND#2	VGND#3	110.618965
Rf34	VGND#3	VGND#4	123.430809
Rf36	VGND#2	VGND#6	29.449923
Rf37	VGND#4	VGND#7	36.279022
Re1	VPWR#4	VPWR	0.982218
Re2	VGND	VGND#3	0.982254
*
*       CAPACITOR CARDS
*
*
C1	a_179_48##7	VGND#6	6.66964e-18
C2	B_N#1	B_N#2	1.39383e-17
C3	a_179_48##5	VPWR#3	9.16728e-18
C4	VPWR#5	VPWR#9	3.97855e-19
C5	a_503_48##5	B_N#2	8.78566e-18
C6	D#2	B_N#2	5.04653e-17
C7	a_179_48##7	a_179_48##10	3.60722e-18
C8	X#2	a_179_48##7	3.54364e-17
C9	a_503_48##5	VPWR#8	1.65134e-18
C10	a_503_48##5	a_179_48##5	2.80456e-18
C11	VGND#6	a_503_48##4	1.76722e-17
C12	a_503_48##2	B_N#2	4.41597e-20
C13	a_27_74##8	VPWR#5	9.37693e-19
C14	D#4	a_179_48##5	2.04562e-17
C15	a_179_48##6	a_503_48##7	8.17506e-19
C16	a_179_48##6	a_179_48##5	4.78837e-19
C17	a_179_48##2	a_27_74##3	1.01658e-18
C18	C#6	a_179_48##5	3.25285e-17
C19	a_179_48##6	VPWR#9	2.52865e-17
C20	a_179_48##6	a_179_48##9	7.80939e-19
C21	a_179_48##7	VPWR#10	2.11403e-18
C22	a_179_48##4	a_179_48##2	1.62739e-19
C23	a_503_48##5	B_N#4	1.3822e-17
C24	a_503_48##4	a_503_48##7	2.0085e-18
C25	a_503_48##5	D#3	2.11307e-17
C26	a_503_48##5	C#3	2.96391e-19
C27	A_N#3	a_179_48##2	2.12578e-17
C28	a_27_74##8	a_179_48##2	3.76164e-18
C29	VGND#7	X#2	3.81719e-17
C30	a_179_48##7	B_N#4	3.71501e-19
C31	a_503_48##5	a_503_48##3	4.31558e-20
C32	a_179_48##7	a_179_48##2	4.3447e-20
C33	a_27_74##7	X#2	3.25812e-17
C34	a_179_48##7	D#3	1.32237e-18
C35	a_27_74##7	VGND#7	6.98656e-17
C36	a_179_48##7	C#3	2.68746e-18
C37	a_179_48##7	a_503_48##3	1.26803e-17
C38	D#3	B_N#2	6.01391e-19
C39	a_179_48##7	a_27_74#	3.61513e-17
C40	a_503_48##7	VPWR#8	7.66164e-17
C41	VPWR#3	C#1	2.57068e-18
C42	a_503_48##4	B_N#4	3.05999e-17
C43	a_179_48##7	a_179_48##3	5.29271e-18
C44	a_179_48##5	a_503_48##7	8.71072e-18
C45	B_N#4	VGND#6	2.08933e-17
C46	a_503_48##4	D#3	1.74593e-18
C47	a_179_48##5	VPWR#8	5.63649e-17
C48	VPWR#3	a_503_48#	2.45525e-18
C49	VGND#6	D#3	3.97652e-17
C50	VPWR#5	a_27_74##4	1.4169e-19
C51	a_503_48##4	C#3	3.81394e-19
C52	VPWR#9	VPWR#8	1.6e-18
C53	VGND#6	C#3	3.61062e-18
C54	a_179_48##5	VPWR#9	6.321e-17
C55	a_503_48##4	a_503_48##3	2.40731e-19
C56	a_27_74##8	X#2	1.09955e-17
C57	a_179_48##9	a_179_48##5	2.13535e-18
C58	VGND#6	a_503_48##3	1.62131e-18
C59	a_503_48##4	a_27_74#	2.45142e-19
C60	VGND#7	a_27_74##8	1.79166e-18
C61	a_179_48##6	B_N#3	7.78545e-20
C62	a_179_48##9	VPWR#9	5.54243e-17
C63	VGND#6	a_27_74#	8.77659e-19
C64	a_27_74##7	a_27_74##8	1.922e-18
C65	VPWR#5	VPWR#3	8.03217e-19
C66	a_179_48##6	D#1	6.89705e-20
C67	VPWR#10	VPWR#9	1.54433e-18
C68	VPWR#10	a_179_48##9	3.62063e-17
C69	a_179_48##6	C#1	9.51527e-20
C70	a_27_74#	a_179_48##10	2.3018e-17
C71	VPWR#4	VPWR#5	3.3363e-17
C72	a_179_48##6	a_503_48#	2.26999e-17
C73	a_179_48##9	VPWR#11	9.31347e-20
C74	VGND#7	a_503_48##3	1.48952e-19
C75	VPWR#4	VPWR#3	3.32627e-17
C76	X#2	a_27_74#	2.12304e-18
C77	VPWR#11	VPWR#10	6.65577e-18
C78	VGND#7	a_27_74#	7.21861e-19
C79	a_179_48##6	a_27_74##4	7.35128e-18
C80	X#2	a_179_48##3	2.60719e-17
C81	a_27_74##7	a_27_74#	5.88666e-20
C82	a_179_48##3	VGND#7	1.60856e-17
C83	X#2	A_N#4	2.29687e-18
C84	a_179_48##6	a_179_48#	1.66399e-19
C85	a_27_74##8	X#1	6.60747e-18
C86	a_27_74##7	a_179_48##3	5.0756e-18
C87	VGND#7	A_N#4	2.82847e-17
C88	a_27_74##8	VPWR#11	5.03759e-17
C89	a_27_74##7	A_N#4	2.52937e-17
C90	a_503_48##5	B_N#1	1.97753e-17
C91	a_179_48##6	VPWR#4	3.35039e-20
C92	a_503_48##7	B_N#3	5.55973e-17
C93	D#3	B_N#4	1.63737e-17
C94	VGND#3	a_179_48##7	3.63415e-17
C95	B_N#3	VPWR#8	2.88472e-17
C96	a_503_48##7	D#1	4.41713e-18
C97	a_503_48##5	D#2	5.79728e-17
C98	a_179_48##5	B_N#3	2.98087e-18
C99	D#1	VPWR#8	3.07938e-17
C100	a_503_48##4	B_N#2	5.12908e-18
C101	B_N	B_N#2	1.30305e-17
C102	C#3	D#3	2.76392e-17
C103	VPWR#9	B_N#3	3.92203e-19
C104	a_179_48##5	D#1	5.09935e-17
C105	D#4	D#2	1.00109e-17
C106	a_503_48##5	C#2	2.8135e-18
C107	a_27_74##3	VPWR#5	4.30013e-18
C108	VPWR#8	C#1	1.27466e-18
C109	VPWR#9	D#1	7.73066e-19
C110	a_503_48##7	a_503_48#	1.30513e-20
C111	a_179_48##5	C#1	5.94429e-17
C112	a_503_48##3	C#3	2.18967e-17
C113	VPWR#8	a_503_48#	2.74666e-19
C114	C#2	D#4	4.26184e-17
C115	C#1	VPWR#9	2.52921e-17
C116	a_503_48##2	a_503_48##5	2.20618e-18
C117	VPWR#5	a_179_48##4	1.81828e-19
C118	a_179_48##5	a_503_48#	5.19482e-19
C119	C#6	D#2	2.17221e-18
C120	a_179_48##9	C#1	4.24329e-19
C121	a_503_48#	VPWR#9	2.90126e-17
C122	a_27_74#	a_503_48##3	4.17309e-17
C123	a_179_48##6	C#2	3.70475e-19
C124	VPWR#10	C#1	2.8528e-19
C125	a_179_48##9	a_503_48#	4.71098e-17
C126	C#6	C#2	1.04369e-17
C127	a_503_48##4	B_N#1	1.98295e-17
C128	VPWR#9	a_27_74##4	1.18864e-18
C129	a_179_48##7	a_503_48##2	6.57706e-17
C130	VPWR#10	a_503_48#	1.84637e-18
C131	a_27_74##4	a_179_48##9	1.51357e-17
C132	a_179_48##6	a_503_48##2	5.68694e-17
C133	a_179_48##3	a_27_74#	3.39878e-18
C134	a_503_48##2	C#6	2.22374e-17
C135	VPWR#10	a_27_74##4	4.38219e-17
C136	a_179_48##9	a_179_48#	7.5398e-19
C137	a_179_48##7	a_27_74##3	5.60768e-17
C138	D#2	VGND#6	2.52257e-18
C139	a_179_48##6	a_27_74##3	7.50898e-17
C140	VPWR#10	a_179_48#	4.67111e-18
C141	A_N#4	a_179_48##3	2.97309e-17
C142	C#6	a_27_74##3	3.56947e-19
C143	VPWR#11	a_27_74##4	2.71984e-18
C144	a_179_48##9	A_N#1	3.2511e-19
C145	a_179_48#	X#1	1.9405e-17
C146	a_179_48##4	a_179_48##7	6.0397e-18
C147	a_27_74##8	a_27_74##4	8.11452e-19
C148	VPWR#11	a_179_48#	3.73274e-17
C149	a_179_48##6	VPWR#5	5.08679e-19
C150	a_27_74##8	a_179_48#	3.40148e-17
C151	A_N#1	VPWR#11	2.7803e-17
C152	a_179_48##9	VPWR#4	1.75205e-17
C153	a_27_74##8	A_N#1	5.54123e-17
C154	a_179_48##6	VPWR#3	4.74186e-19
C155	D#2	a_503_48##7	3.38844e-17
C156	a_503_48##5	a_647_74#	2.67346e-18
C157	D#2	VPWR#8	1.06874e-17
C158	a_503_48##7	C#2	1.43802e-19
C159	D#1	B_N#3	2.63041e-17
C160	X#2	a_27_74##3	2.72166e-20
C161	a_179_48##5	C#2	1.64956e-18
C162	a_503_48##7	a_503_48##2	5.32297e-20
C163	VPWR#9	C#2	5.72919e-19
C164	C#1	D#1	3.71481e-17
C165	a_503_48##2	a_179_48##5	6.68141e-19
C166	a_179_48##4	X#2	3.6316e-17
C167	a_503_48##7	a_27_74##3	2.63055e-19
C168	a_503_48##5	D#4	2.02213e-17
C169	VPWR#9	a_503_48##2	4.98255e-19
C170	VGND#3	C#3	2.57295e-18
C171	a_503_48#	C#1	2.4842e-17
C172	VGND#3	a_503_48##3	8.87289e-18
C173	X	a_179_48##2	7.28384e-18
C174	X#2	A_N#3	1.88481e-18
C175	VGND#3	a_27_74#	5.30766e-18
C176	a_27_74##3	a_179_48##9	1.51275e-17
C177	a_27_74##7	A_N#3	4.36671e-17
C178	a_27_74##4	a_503_48#	2.84884e-17
C179	a_27_74##3	VPWR#10	3.25458e-17
C180	C#2	D#3	3.4984e-18
C181	a_27_74##3	X#1	2.0005e-18
C182	a_503_48##2	B_N#4	1.90344e-19
C183	a_179_48#	a_27_74##4	4.17334e-18
C184	a_503_48##2	D#3	4.51028e-19
C185	a_27_74##8	a_27_74##3	1.94682e-18
C186	a_179_48##4	X#1	4.66321e-18
C187	a_503_48##2	C#3	2.89383e-17
C188	a_503_48##2	a_503_48##3	1.05501e-17
C189	a_27_74##8	a_179_48##4	9.1994e-19
C190	A_N#1	a_179_48#	2.83389e-17
C191	VPWR#4	a_503_48#	1.6018e-18
C192	a_27_74#	a_503_48##2	6.76413e-18
C193	D#2	B_N#3	8.53778e-19
C194	VPWR#4	a_27_74##4	1.70027e-19
C195	a_27_74##8	A_N#3	2.92166e-17
C196	a_179_48##3	a_27_74##3	2.41578e-19
C197	a_503_48##5	B_N	6.07224e-19
C198	C#2	D#1	4.79718e-18
C199	a_179_48##4	a_27_74#	8.75997e-19
C200	a_179_48##4	a_179_48##3	1.6401e-19
C201	a_503_48#	C#2	1.43513e-18
C202	A_N#3	a_179_48##3	3.43624e-18
C203	VGND	B_N#2	1.13075e-18
C204	D#3	a_647_74#	1.78003e-17
C205	VGND	a_179_48##2	5.24613e-19
C206	C#3	a_647_74#	1.78003e-17
C207	a_27_74##3	a_503_48#	3.53356e-18
C208	C#3	a_533_74#	1.88551e-17
C209	a_27_74##3	a_27_74##4	8.12422e-18
C210	a_503_48##3	a_533_74#	1.88551e-17
C211	a_179_48#	a_27_74##3	6.13104e-18
C212	a_27_74##3	A_N#1	2.97599e-19
C213	X#2	a_179_48##2	1.16524e-17
C214	VPWR#4	a_503_48##2	2.87359e-20
C215	VGND#3	a_503_48##2	6.81219e-18
C216	C#6	D#4	2.26756e-17
C217	a_503_48##7	B_N	5.11988e-17
C218	C#2	D#2	5.64553e-17
C219	VGND#3	a_27_74##3	1.70581e-19
C220	a_27_74#	a_455_74#	1.14208e-17
C221	B_N#2	VNB	8.00795e-17
C222	a_179_48##2	VNB	2.14912e-17
C223	VGND#3	a_179_48##4	1.45416e-19
C224	a_503_48##2	C#2	1.36483e-16
C225	a_27_74##3	a_503_48##2	4.79831e-17
C226	VPWR	VPWR#5	2.47789e-17
C227	VPWR	VPWR#3	1.98838e-17
C228	A_N	a_27_74##8	5.16962e-17
C229	a_179_48##4	a_27_74##3	7.52976e-17
C230	C#2	a_647_74#	8.15892e-19
C231	VPWR	D#4	1.97046e-18
C232	a_503_48##2	a_647_74#	1.5271e-18
C233	VPWR	a_179_48##6	4.09164e-18
C234	VPWR	C#6	2.82867e-18
C235	X#2	X	2.80289e-18
C236	a_179_48##6	C#6	7.10607e-18
C237	a_503_48##2	a_533_74#	5.90769e-18
C238	VGND	a_503_48##5	9.40905e-18
C239	VGND	D#4	1.74637e-18
C240	VGND	a_179_48##7	3.34346e-17
C241	X	X#1	5.13241e-18
C242	X	VPWR#11	1.44558e-18
C243	a_27_74##8	X	1.11944e-16
C244	VPWR	a_503_48##7	1.80694e-17
C245	A_N	A_N#1	2.54077e-18
C246	VPWR	VPWR#8	1.93317e-17
C247	VPWR	a_179_48##5	1.71397e-17
C248	VPWR#5	VNB	2.93358e-17
C249	VGND	a_503_48##4	1.43791e-17
C250	VPWR	VPWR#9	2.23653e-17
C251	VPWR#3	VNB	2.48739e-17
C252	VGND	VGND#6	1.98122e-17
C253	VPWR	a_179_48##9	1.62004e-17
C254	VPWR	VPWR#10	1.51164e-17
C255	a_27_74##7	a_179_48##2	6.9024e-19
C256	VPWR	VPWR#11	1.63339e-17
C257	a_503_48##5	VNB	7.77379e-18
C258	VGND	X#2	1.45306e-17
C259	VPWR	a_27_74##8	2.38154e-17
C260	VGND	a_27_74##7	1.70706e-17
C261	a_503_48##5	VGND#6	4.29632e-17
C262	a_179_48##7	VNB	1.91139e-17
C263	a_179_48##6	VNB	5.83912e-18
C264	C#6	VNB	4.53175e-19
C265	a_503_48##4	VNB	3.35194e-17
C266	X	a_27_74##4	4.05781e-19
C267	VGND#6	VNB	4.93694e-18
C268	X	a_179_48#	1.71277e-17
C269	VPWR	B_N#3	9.6711e-19
C270	VGND	B_N#4	9.86264e-18
C271	X	A_N#1	3.91602e-18
C272	a_503_48##7	B_N#2	1.31594e-17
C273	VPWR	D#1	2.46553e-18
C274	VGND	D#3	5.04908e-19
C275	X#2	VNB	4.09436e-18
C276	A_N	A_N#3	9.72398e-18
C277	VGND	C#3	1.29418e-18
C278	VPWR	C#1	1.34447e-19
C279	VGND#7	VNB	2.43325e-18
C280	a_27_74##7	VNB	4.32199e-17
C281	VGND	a_503_48##3	2.3808e-18
C282	VPWR	a_503_48#	1.11541e-18
C283	a_503_48##7	VNB	5.03896e-17
C284	VGND	a_27_74#	4.79576e-19
C285	VPWR#8	VNB	3.80867e-18
C286	VPWR	a_27_74##4	3.5906e-18
C287	VGND	a_179_48##3	1.67983e-18
C288	a_179_48##5	VNB	6.07012e-18
C289	VPWR	a_179_48#	5.51482e-19
C290	VPWR#9	VNB	4.24011e-18
C291	VGND	A_N#4	1.61734e-18
C292	a_179_48##9	VNB	3.09204e-18
C293	VPWR	A_N#1	6.66191e-18
C294	VPWR#10	VNB	2.00086e-18
C295	VPWR#11	VNB	1.08163e-17
C296	VPWR	VPWR#4	8.29638e-18
C297	a_27_74##8	VNB	4.52449e-17
C298	B_N#4	VNB	4.25864e-17
C299	D#3	VNB	3.47192e-17
C300	C#3	VNB	2.56564e-17
C301	X	a_27_74##3	4.50559e-17
C302	a_503_48##3	VNB	2.59811e-17
C303	VPWR	D#2	2.81446e-18
C304	a_27_74#	VNB	3.37129e-17
C305	X	a_179_48##4	5.09469e-17
C306	a_179_48##3	VNB	2.99817e-17
C307	A_N#4	VNB	3.4383e-17
C308	X	A_N#3	1.65851e-18
C309	VPWR	a_503_48##2	3.09054e-18
C310	B_N#3	VNB	4.35219e-17
C311	VGND	VGND#3	3.6787e-17
C312	VPWR	a_27_74##3	1.09007e-17
C313	D#1	VNB	3.58179e-17
C314	C#1	VNB	2.94893e-17
C315	VGND	B_N#1	4.57547e-18
C316	VPWR	a_179_48##4	3.28122e-18
C317	a_503_48#	VNB	3.25507e-17
C318	VGND	D#2	2.16176e-18
C319	a_27_74##4	VNB	2.51258e-17
C320	VGND	C#2	3.85852e-18
C321	a_179_48#	VNB	5.2352e-17
C322	A_N#1	VNB	4.51137e-17
C323	VGND	a_503_48##2	1.54402e-17
C324	VGND	a_27_74##3	4.09218e-18
C325	VPWR#4	VNB	2.14074e-16
C326	VGND	a_179_48##4	4.86857e-18
C327	VGND#3	VNB	2.5174e-16
C328	B_N#1	VNB	1.22163e-17
C329	VGND	A_N#3	4.94255e-18
C330	D#2	VNB	4.87584e-17
C331	C#2	VNB	5.55143e-17
C332	a_503_48##2	VNB	4.93818e-17
C333	a_27_74##3	VNB	8.83108e-17
C334	a_179_48##4	VNB	4.87181e-17
C335	A_N#3	VNB	8.05698e-17
C336	VPWR	B_N	4.18092e-18
C337	VPWR	A_N	3.71372e-18
C338	B_N	VNB	1.46669e-17
C339	VPWR	X	5.429e-18
C340	A_N	VNB	1.49009e-17
C341	VGND	X	2.27793e-18
C342	X	VNB	3.1054e-18
C343	VPWR	VNB	6.94804e-17
C344	VGND	VNB	7.56733e-17
C345	D#4	VPWR#2	1.88292e-19
C346	VPWR#6	a_179_48##4	1.69601e-19
C347	VGND#2	B_N#1	5.01029e-19
C348	VPWR#2	B_N#3	2.56959e-18
C349	VGND#4	a_179_48##7	2.37548e-18
C350	a_503_48##7	VPWR#2	2.09699e-17
C351	VGND#2	a_503_48##4	1.51049e-17
C352	VGND#3	VGND#4	6.80271e-17
C353	a_179_48##5	VPWR#2	7.94172e-18
C354	VPWR#4	VPWR#2	5.69427e-17
C355	VPWR#3	VPWR#2	7.71943e-19
C356	VPWR#6	VPWR#5	9.26034e-19
C357	VGND#2	a_503_48##2	2.25498e-18
C358	VPWR#6	a_179_48#	3.99024e-18
C359	VGND	VGND#2	5.06464e-17
C360	VGND#4	a_179_48##3	5.5099e-18
C361	VPWR	VPWR#2	3.77024e-17
C362	VPWR#2	B_N#2	5.42601e-19
C363	VGND#4	a_27_74##7	1.78605e-17
C364	VGND#2	C#3	5.74394e-18
C365	VPWR#2	VNB	5.07063e-17
C366	VGND	VGND#4	6.14958e-17
C367	VGND#4	a_179_48##4	1.1527e-18
C368	VPWR#6	A_N#3	4.65037e-19
C369	VGND#4	a_503_48##3	7.70024e-20
C370	VPWR#2	D#1	5.12915e-18
C371	VGND#2	B_N#4	4.85886e-18
C372	VPWR#6	VNB	5.5996e-17
C373	VGND#4	X#2	1.60045e-17
C374	VGND#3	VGND#2	7.2664e-17
C375	VPWR	VPWR#6	4.30073e-17
C376	VPWR#9	VPWR#2	1.29859e-19
C377	VGND#2	a_503_48##5	3.6618e-18
C378	B_N	VPWR#2	7.03103e-19
C379	a_27_74##8	VPWR#6	1.29069e-17
C380	VPWR#4	VPWR#6	5.92899e-17
C381	VGND#4	A_N#4	4.59469e-18
C382	VGND#2	VNB	6.58728e-17
C383	A_N	VPWR#6	4.9518e-19
C384	VPWR#6	A_N#1	3.27804e-18
C385	VGND#4	VNB	6.1575e-17
C386	VGND#4	a_179_48##2	3.78699e-20
C387	D#2	VPWR#2	2.25951e-19
C388	VGND#4	A_N#3	8.12127e-19
C389	VGND#2	C#2	5.04048e-19
C390	VGND#2	B_N#2	3.14872e-19
C391	VGND#4	a_27_74#	2.90234e-19
C392	VGND#2	D#3	3.67167e-18
*
*
.ENDS sky130_fd_sc_hs__and4bb_1
*
