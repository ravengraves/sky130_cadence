* Extracted by Quantus, converted by sky130cad/quantus.py
*
*
*
*                       LINUX           Wed Nov 18 08:40:19 2026
*
*
*
*  PROGRAM  advgen
*
*  Name           : advgen - Quantus - (64-bit)
*  Version        : 25.1.0-p047
*  Build Date     : Thu Dec 11 23:20:30 PST 2025
*
*  HSPICE LIBRARY
*
*  OPERATING_TEMPERATURE 150
*  QRC_TECH_DIR <path>/tech
*
*
*
*
.SUBCKT sky130_fd_sc_hs__fill_diode_2 VPB VNB VGND VPWR
*
*
*  caps2d version: 10
*
*
*       CAPACITOR CARDS
*
*
C1	VGND	VNB	2.11551e-16
C2	VPWR	VNB	2.11551e-16
*
*
.ENDS sky130_fd_sc_hs__fill_diode_2
*
