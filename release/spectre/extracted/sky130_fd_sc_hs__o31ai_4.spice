* Extracted by Quantus, converted by sky130cad/quantus.py
*
*
*
*                       LINUX           Wed Nov 18 09:02:33 2026
*
*
*
*  PROGRAM  advgen
*
*  Name           : advgen - Quantus - (64-bit)
*  Version        : 25.1.0-p047
*  Build Date     : Thu Dec 11 23:20:30 PST 2025
*
*  HSPICE LIBRARY
*
*  OPERATING_TEMPERATURE 150
*  QRC_TECH_DIR <path>/tech
*
*
*

*
.SUBCKT sky130_fd_sc_hs__o31ai_4 VNB VPB VGND VPWR Y A1 A2 A3 B1
*
*
*  caps2d version: 10
*
*
*       TRANSISTOR CARDS
*
*
XM5 a_27_82##17 A1#10 VGND#15 VNB sky130_fd_pr__nfet_01v8_lvt l=0.15 w=0.74 ad=0.2109 as=0.259 pd=2.05 ps=2.18
XM24 VGND#15 A1#8 a_27_82##15 VNB sky130_fd_pr__nfet_01v8_lvt l=0.15 w=0.74 ad=0.259 as=0.2072 pd=2.18 ps=2.04
XM25 VGND#14 A1#6 a_27_82##15 VNB sky130_fd_pr__nfet_01v8_lvt l=0.15 w=0.74 ad=0.259 as=0.2072 pd=2.18 ps=2.04
XM1 a_27_82##14 A1#1 VGND#14 VNB sky130_fd_pr__nfet_01v8_lvt l=0.15 w=0.74 ad=0.2072 as=0.259 pd=2.04 ps=2.18
XM6 a_27_82##14 A2#11 VGND#13 VNB sky130_fd_pr__nfet_01v8_lvt l=0.15 w=0.74 ad=0.2072 as=0.4366 pd=2.04 ps=2.66
XM2 VGND#13 A2#8 a_27_82##12 VNB sky130_fd_pr__nfet_01v8_lvt l=0.15 w=0.74 ad=0.4366 as=0.259 pd=2.66 ps=2.18
XM22 a_27_82##12 A2#6 VGND#12 VNB sky130_fd_pr__nfet_01v8_lvt l=0.15 w=0.74 ad=0.259 as=0.2072 pd=2.18 ps=2.04
XM15 VGND#12 A2#5 a_27_82##8 VNB sky130_fd_pr__nfet_01v8_lvt l=0.15 w=0.74 ad=0.2072 as=0.2072 pd=2.04 ps=2.04
XM26 a_27_82##8 A3#8 VGND#11 VNB sky130_fd_pr__nfet_01v8_lvt l=0.15 w=0.74 ad=0.2072 as=0.7254 pd=2.04 ps=3.5
XM7 VGND#11 A3#13 a_27_82##6 VNB sky130_fd_pr__nfet_01v8_lvt l=0.15 w=0.74 ad=0.7254 as=0.2072 pd=3.5 ps=2.04
XM16 a_27_82##6 A3#11 VGND#10 VNB sky130_fd_pr__nfet_01v8_lvt l=0.15 w=0.74 ad=0.2072 as=0.402 pd=2.04 ps=2.84
XM10 VGND#10 A3#9 a_27_82##4 VNB sky130_fd_pr__nfet_01v8_lvt l=0.15 w=0.74 ad=0.402 as=0.2072 pd=2.84 ps=2.04
XM19 Y#8 B1#9 a_27_82##4 VNB sky130_fd_pr__nfet_01v8_lvt l=0.15 w=0.74 ad=0.2072 as=0.2072 pd=2.04 ps=2.04
XM13 a_27_82##2 B1#7 Y#8 VNB sky130_fd_pr__nfet_01v8_lvt l=0.15 w=0.74 ad=0.2072 as=0.2072 pd=2.04 ps=2.04
XM17 Y#10 B1#6 a_27_82##2 VNB sky130_fd_pr__nfet_01v8_lvt l=0.15 w=0.74 ad=0.2072 as=0.2072 pd=2.04 ps=2.04
XM8 a_27_82# B1#1 Y#10 VNB sky130_fd_pr__nfet_01v8_lvt l=0.15 w=0.74 ad=0.2109 as=0.2072 pd=2.05 ps=2.04
XM11 VPWR#9 A1#12 a_28_368##6 VPB sky130_fd_pr__pfet_01v8 l=0.15 w=1.12 ad=0.336 as=0.3304 pd=2.84 ps=2.83
XM29 a_28_368##8 A1#11 VPWR#9 VPB sky130_fd_pr__pfet_01v8 l=0.15 w=1.12 ad=0.336 as=0.336 pd=2.84 ps=2.84
XM18 VPWR#8 A1#7 a_28_368##8 VPB sky130_fd_pr__pfet_01v8 l=0.15 w=1.12 ad=0.392 as=0.336 pd=2.94 ps=2.84
XM23 a_28_368##7 A1#5 VPWR#8 VPB sky130_fd_pr__pfet_01v8 l=0.15 w=1.12 ad=0.336 as=0.392 pd=2.84 ps=2.94
XM9 a_28_368##7 A2#13 a_487_368##4 VPB sky130_fd_pr__pfet_01v8 l=0.15 w=1.12 ad=0.336 as=0.392 pd=2.84 ps=2.94
XM21 a_28_368##2 A2#12 a_487_368##4 VPB sky130_fd_pr__pfet_01v8 l=0.15 w=1.12 ad=0.6384 as=0.392 pd=3.38 ps=2.94
XM27 a_487_368##6 A2#7 a_28_368##2 VPB sky130_fd_pr__pfet_01v8 l=0.15 w=1.12 ad=0.336 as=0.6384 pd=2.84 ps=3.38
XM12 a_487_368##6 A2#1 a_28_368# VPB sky130_fd_pr__pfet_01v8 l=0.15 w=1.12 ad=0.336 as=0.3864 pd=2.84 ps=2.93
XM0 a_487_368##5 A3#14 Y#7 VPB sky130_fd_pr__pfet_01v8 l=0.15 w=1.12 ad=0.336 as=0.3304 pd=2.84 ps=2.83
XM20 Y#6 A3#12 a_487_368##5 VPB sky130_fd_pr__pfet_01v8 l=0.15 w=1.12 ad=0.336 as=0.336 pd=2.84 ps=2.84
XM3 a_487_368# A3#10 Y#6 VPB sky130_fd_pr__pfet_01v8 l=0.15 w=1.12 ad=0.336 as=0.336 pd=2.84 ps=2.84
XM28 Y#5 A3#1 a_487_368# VPB sky130_fd_pr__pfet_01v8 l=0.15 w=1.12 ad=0.392 as=0.336 pd=2.94 ps=2.84
XM4 VPWR#7 B1#10 Y#5 VPB sky130_fd_pr__pfet_01v8 l=0.15 w=1.12 ad=1.1704 as=0.392 pd=4.33 ps=2.94
XM14 Y#1 B1#5 VPWR#7 VPB sky130_fd_pr__pfet_01v8 l=0.15 w=1.12 ad=0.3304 as=1.1704 pd=2.83 ps=4.33
*
*
*       RESISTOR AND CAP/DIODE CARDS
*
Rg1	A1#1	A1#2	349.177795
Rg2	A1#2	A1#3	233.905685
Rg3	A1#3	A1#4	89.425179
Rg4	A1#2	A1#5	503.403320
Rg5	A1#3	A1#6	371.606812
Rg6	A1#3	A1#7	446.660797
Rg7	A1#4	A1#8	365.365479
Rg8	A1#4	A1#9	64.081955
Rg9	A1#9	A1#10	374.601227
Rg10	A1#4	A1#11	429.126801
Rg11	A1#9	A1#12	449.655212
Rg12	A2#1	A2#2	431.140411
Rg13	A2#2	A2#3	203.726837
Rg14	A2#3	A2#4	79.820198
Rg15	A2#2	A2#5	454.304993
Rg16	A2#3	A2#6	371.606812
Rg17	A2#3	A2#7	446.660797
Rg18	A2#4	A2#8	354.072845
Rg19	A2#4	A2#9	51.378597
Rg20	A2#9	A2#10	173.186829
Rg21	A2#10	A2#11	350.090332
Rg22	A2#9	A2#12	419.554810
Rg23	A2#10	A2#13	504.761536
Rg24	A3#1	A3#2	458.247101
Rg25	A3#2	A3#3	193.287125
Rg26	A3#3	A3#4	49.953510
Rg27	A3#4	A3#5	48.387539
Rg28	A3#5	A3#6	33.180672
Rg29	A3#6	A3#7	40.049488
Rg30	A3#7	A3#8	593.178650
Rg31	A3#2	A3#9	426.610077
Rg32	A3#3	A3#10	409.391785
Rg33	A3#4	A3#11	345.501129
Rg34	A3#5	A3#12	389.159912
Rg35	A3#6	A3#13	360.384613
Rg36	A3#7	A3#14	419.554810
Rg37	B1#1	B1#2	345.523438
Rg38	B1#2	B1#3	195.066742
Rg39	B1#3	B1#4	84.032776
Rg40	B1#2	B1#5	503.217316
Rg41	B1#3	B1#6	344.531250
Rg42	B1#4	B1#7	354.072845
Rg43	B1#4	B1#8	64.097748
Rg44	B1#8	B1#9	490.900543
Rg45	B1#8	B1#10	419.554810
Rf1	A1	A1#13	8.404075
Rf2	A1#13	A1	6.264856
Rf3	A2	A2#14	13.293719
Rf4	A2#14	A2	1.375212
Rf5	a_28_368#	a_28_368##3	92.003334
Rf6	a_28_368##3	a_28_368##4	78.041252
Rf7	a_28_368##4	a_28_368##5	69.363289
Rf8	a_28_368##5	a_28_368##6	90.417343
Rf9	a_28_368##4	a_28_368##7	16.043533
Rf10	a_28_368##5	a_28_368##8	31.284834
Rf11	a_28_368##2	a_28_368##3	7.500000
Rf12	A3	A3#15	5.500849
Rf13	A3#15	A3	9.168082
Rf14	a_487_368#	a_487_368##2	91.645546
Rf15	a_487_368##2	a_487_368##3	107.392517
Rf16	a_487_368##3	a_487_368##4	100.378487
Rf17	a_487_368##2	a_487_368##5	21.341251
Rf18	a_487_368##3	a_487_368##6	18.957424
Rf19	B1	B1#11	4.736843
Rf20	B1#11	B1	9.932090
Rf21	a_27_82#	a_27_82##3	76.428581
Rf22	a_27_82##3	a_27_82##5	57.954136
Rf23	a_27_82##5	a_27_82##7	69.220505
Rf24	a_27_82##7	a_27_82##9	93.473274
Rf26	a_27_82##9	a_27_82##11	86.159767
Rf27	a_27_82##11	a_27_82##12	16.575169
Rf28	a_27_82##11	a_27_82##13	83.786674
Rf29	a_27_82##13	a_27_82##14	13.032116
Rf30	a_27_82##13	a_27_82##16	46.673283
Rf31	a_27_82##16	a_27_82##17	58.576111
Rf32	a_27_82##2	a_27_82##3	15.000000
Rf33	a_27_82##4	a_27_82##5	15.000000
Rf34	a_27_82##6	a_27_82##7	15.000000
Rf35	a_27_82##8	a_27_82##9	7.500000
Rf36	a_27_82##15	a_27_82##16	15.000000
Rf37	Y#1	Y#2	131.749527
Rf38	Y#2	Y#3	69.348907
Rf39	Y#3	Y#4	67.212921
Rf40	Y#4	Y	51.023556
Rf41	Y#2	Y#5	18.602406
Rf42	Y#3	Y#6	16.279915
Rf43	Y#4	Y#7	14.783895
Rf44	Y	Y#9	214.966125
Rf45	Y#9	Y#10	57.411480
Rf46	Y#8	Y#9	15.000000
Rf48	VPWR#2	VPWR#3	320.180298
Rf49	VPWR#3	VPWR#4	125.987572
Rf50	VPWR#4	VPWR#5	65.696381
Rf52	VPWR#2	VPWR#7	12.090981
Rf53	VPWR#4	VPWR#8	31.534731
Rf54	VPWR#5	VPWR#9	31.534731
Rf55	VGND#1	VGND#2	113.563301
Rf56	VGND#2	VGND#3	87.662407
Rf57	VGND#3	VGND#4	81.458801
Rf58	VGND#4	VGND#5	32.848190
Rf59	VGND#5	VGND#6	46.139027
Rf60	VGND#6	VGND#7	79.352470
Rf61	VGND#7	VGND#8	62.774361
Rf63	VGND#2	VGND#10	24.203579
Rf64	VGND#3	VGND#11	12.409773
Rf65	VGND#4	VGND#12	37.460041
Rf66	VGND#6	VGND#13	31.594273
Rf67	VGND#7	VGND#14	34.113823
Rf68	VGND#8	VGND#15	34.113823
Rf72	B1#4	B1#11	53.410934
Rf69	A1#4	A1#13	53.410934
Rf70	A2#4	A2#14	53.410934
Rf71	A3#6	A3#15	53.410934
Re1	VPWR#2	VPWR	3.735117
Re2	VPWR	VPWR#3	1.067176
Re3	VGND#1	VGND	3.735117
Re4	VGND	VGND#5	1.067176
*
*       CAPACITOR CARDS
*
*
C1	Y#8	A3#2	1.63477e-18
C2	Y#2	A3#2	1.00787e-18
C3	a_27_82##4	A3#11	7.68947e-19
C4	a_27_82##4	A3#4	2.5418e-19
C5	a_27_82##6	A3#9	1.84251e-18
C6	Y#8	A3#13	3.08567e-19
C7	A3#11	VGND#10	1.84488e-17
C8	a_27_82##13	A1#10	2.72722e-19
C9	VPWR#3	A3#7	6.20553e-20
C10	a_27_82##6	A3#11	4.35209e-17
C11	a_27_82##11	a_27_82##8	2.37845e-18
C12	VGND#7	a_27_82##13	6.86335e-18
C13	a_27_82##8	A3#9	8.29784e-20
C14	a_28_368#	a_487_368##6	4.05546e-19
C15	a_27_82##17	a_28_368##6	1.77372e-19
C16	a_28_368#	A2#3	9.91218e-19
C17	a_27_82##6	A3#13	4.33669e-17
C18	a_27_82##4	A3#2	2.11341e-19
C19	Y#2	B1#5	1.22907e-19
C20	A2#3	A2#2	8.17614e-18
C21	VPWR#3	A2#10	2.2098e-20
C22	a_27_82##8	A3#11	7.47167e-20
C23	VPWR#3	A2#9	1.18342e-19
C24	a_27_82##11	VGND#12	6.245e-17
C25	VGND#6	a_27_82##13	7.19175e-18
C26	a_28_368##2	a_28_368#	2.04128e-18
C27	VPWR#3	A2#3	1.55992e-20
C28	A3#13	VGND#11	2.16479e-17
C29	a_28_368#	A2#2	9.64785e-19
C30	a_27_82##6	A3#7	1.79262e-18
C31	VPWR#3	A2#2	1.03866e-20
C32	a_27_82##6	A3#8	4.51619e-19
C33	a_27_82##8	A3#13	4.73346e-19
C34	Y#2	B1#10	2.41408e-17
C35	A3#8	VGND#11	2.25739e-17
C36	a_27_82##11	a_27_82##12	3.63898e-18
C37	VGND#12	A3#13	7.47067e-20
C38	VGND#6	a_27_82##11	5.98709e-19
C39	a_27_82##13	VGND#13	5.46312e-17
C40	a_27_82##6	A2#5	1.27488e-19
C41	a_27_82##8	A3#8	2.78453e-17
C42	A1#2	A2#10	2.45378e-17
C43	Y#2	A3#1	1.3732e-17
C44	VGND#5	A2#9	7.50206e-20
C45	VGND#12	A3#8	1.75339e-18
C46	a_28_368##2	a_487_368##4	7.83732e-17
C47	a_27_82##6	A3#4	4.79412e-19
C48	a_27_82##11	VGND#13	5.58988e-17
C49	VGND#5	A2#3	2.84858e-20
C50	B1#8	B1#4	2.11554e-18
C51	a_27_82##8	A2#5	3.47539e-17
C52	VGND#4	a_27_82##11	2.07374e-19
C53	a_27_82##13	a_27_82##14	4.68449e-19
C54	B1#4	B1#3	2.11554e-18
C55	a_28_368##7	a_28_368##2	2.85825e-18
C56	VGND#12	A2#5	3.09679e-17
C57	a_27_82##13	A2#10	3.26992e-18
C58	A2#9	a_28_368##2	8.32731e-18
C59	Y#2	A3#10	1.65376e-19
C60	a_27_82##8	A2#6	8.13698e-19
C61	a_28_368##7	a_487_368##4	6.34482e-17
C62	Y#4	A3#12	1.09321e-18
C63	a_27_82##13	VGND#14	4.9622e-17
C64	A2#3	a_28_368##2	4.521e-19
C65	VGND#12	A2#6	2.85207e-17
C66	a_27_82##13	A2#9	1.474e-18
C67	VPWR#8	a_487_368##4	3.28206e-18
C68	a_27_82##8	A2#8	2.52345e-19
C69	A2#6	a_27_82##12	3.25017e-18
C70	a_487_368##4	A2#10	3.61536e-19
C71	VGND#12	A2#8	1.53855e-18
C72	Y#4	A3#14	2.96995e-17
C73	a_27_82##8	A3#7	6.537e-19
C74	VPWR#8	a_28_368##7	6.22435e-17
C75	VGND#13	A2#6	3.47926e-19
C76	A2#8	a_27_82##12	1.72002e-17
C77	a_27_82#	Y#10	2.7725e-17
C78	A2#9	a_487_368##4	1.85793e-18
C79	B1#8	B1#5	7.91984e-20
C80	a_28_368##8	a_28_368##7	9.19873e-19
C81	VGND#12	A2#11	1.75385e-19
C82	A2#8	VGND#13	2.41886e-17
C83	B1#3	B1#5	4.42552e-18
C84	Y#4	A2#1	1.52937e-18
C85	B1#3	B1#2	7.7661e-18
C86	a_28_368##8	VPWR#8	5.05943e-17
C87	a_27_82##2	a_27_82#	3.93519e-18
C88	a_27_82##11	A2#9	6.53212e-18
C89	A2#11	VGND#13	2.72428e-17
C90	VGND#14	A2#8	3.18308e-19
C91	Y#2	Y#1	2.58237e-19
C92	VPWR#9	VPWR#8	2.06271e-18
C93	A2#11	a_27_82##14	1.49295e-17
C94	a_27_82##17	a_27_82##13	1.04688e-18
C95	Y#10	a_27_82##2	2.96399e-17
C96	Y#4	A2#7	1.52874e-19
C97	VGND#13	A1#1	3.65832e-19
C98	VPWR#9	a_28_368##8	5.05407e-17
C99	a_27_82##11	A2#3	2.84671e-18
C100	VGND#14	A2#11	1.42298e-18
C101	A1#1	a_27_82##14	1.49295e-17
C102	Y#2	VPWR#7	5.51932e-17
C103	a_28_368##6	a_28_368##8	8.39315e-19
C104	a_27_82#	a_27_82##4	2.97667e-20
C105	VGND#13	A1#6	1.80029e-19
C106	VPWR#4	A2#13	5.69958e-18
C107	A1#1	VGND#14	2.03234e-17
C108	Y#4	A2#12	9.63518e-20
C109	a_487_368##2	A3#12	1.58461e-17
C110	a_27_82##11	A2#2	1.28045e-18
C111	a_28_368##6	VPWR#9	5.53668e-17
C112	a_27_82##13	A1#3	3.39859e-19
C113	Y#2	Y#5	2.10563e-18
C114	a_27_82##2	Y#8	2.90443e-17
C115	a_487_368##3	A3#14	8.29162e-19
C116	VGND#14	A1#6	3.64498e-17
C117	a_487_368##2	A3#14	2.17957e-17
C118	VPWR#4	A1#5	2.5859e-18
C119	a_27_82##15	A1#6	4.2312e-17
C120	a_27_82##17	A1#1	1.34736e-19
C121	A3#1	B1#8	8.01328e-19
C122	a_27_82##13	A1#2	2.67066e-18
C123	Y#4	Y#6	3.68763e-18
C124	a_28_368#	A3#8	6.68491e-19
C125	VGND#14	A1#8	3.35294e-18
C126	a_27_82##4	a_27_82##2	6.60859e-18
C127	VGND#15	A1#6	3.35294e-18
C128	a_487_368##3	A2#1	2.54574e-17
C129	Y#2	a_487_368#	1.19195e-17
C130	a_27_82##15	A1#8	4.22194e-17
C131	a_27_82##17	A1#6	2.19728e-19
C132	VPWR#4	A1#7	1.83922e-18
C133	VGND#15	A1#8	3.83125e-17
C134	Y#8	a_27_82##4	5.25851e-17
C135	B1#6	B1#1	3.80342e-17
C136	Y#4	a_487_368##5	5.11172e-17
C137	A1#9	A1#4	2.55807e-18
C138	a_487_368##3	A2#7	2.2862e-17
C139	a_27_82##17	A1#8	1.90585e-18
C140	A1#4	A1#3	2.99691e-18
C141	Y#6	Y#2	5.72085e-19
C142	a_28_368##4	A2#1	1.35754e-19
C143	A1#10	VGND#15	2.24924e-17
C144	A3#4	A3#1	1.07889e-18
C145	a_27_82##8	A2#2	6.17362e-19
C146	Y#8	VGND#10	7.94714e-19
C147	a_27_82##17	A1#10	5.08606e-17
C148	VPWR#8	A1#3	4.16707e-19
C149	B1#7	B1#6	3.95133e-17
C150	a_487_368##3	A2#12	1.01023e-18
C151	Y#4	Y#7	9.27405e-18
C152	A1#3	A1#2	5.8094e-18
C153	a_28_368##4	A2#7	1.22363e-19
C154	a_27_82##4	VGND#10	1.43451e-18
C155	VPWR#8	A1#2	3.96772e-19
C156	Y#8	a_27_82##6	3.7231e-17
C157	VGND#12	A2#3	3.32498e-19
C158	A3#7	A3#10	2.31942e-19
C159	B1#9	B1#7	3.72138e-17
C160	a_28_368#	Y#4	2.81047e-17
C161	a_28_368##4	A2#12	6.24217e-19
C162	a_27_82##6	a_27_82##4	4.69947e-18
C163	VGND#12	A2#2	3.43516e-19
C164	Y#1	B1#5	6.64039e-17
C165	A1#3	a_28_368##8	2.70455e-19
C166	a_487_368##4	VPWR#4	6.78362e-18
C167	B1#5	VPWR#7	4.66632e-17
C168	A3#9	B1#9	3.99215e-17
C169	a_28_368##4	A2#13	2.66476e-17
C170	a_27_82##6	VGND#10	1.45453e-18
C171	Y#1	B1#10	9.37567e-19
C172	Y#5	B1#5	4.68218e-19
C173	A3#2	B1#8	2.13275e-17
C174	a_28_368##5	A1#5	2.58796e-19
C175	B1#10	VPWR#7	4.77046e-17
C176	a_487_368#	B1#5	2.85278e-19
C177	a_28_368##4	A1#5	2.63541e-17
C178	Y#1	A3#1	1.32282e-19
C179	A3#11	A3#9	1.98747e-17
C180	a_28_368##7	VPWR#4	1.66734e-17
C181	Y#5	B1#10	5.62607e-17
C182	VGND#13	A2#10	9.81044e-19
C183	A1#9	VPWR#9	2.86194e-19
C184	a_28_368##2	Y#4	9.90097e-19
C185	VPWR#7	A3#1	5.30463e-18
C186	a_487_368#	B1#10	2.30968e-18
C187	a_28_368##5	A1#7	1.49997e-17
C188	VGND#3	A3#7	2.13051e-18
C189	a_487_368##2	VPWR#7	3.67322e-17
C190	a_27_82##6	VGND#11	3.79509e-18
C191	A3#1	Y#5	2.04212e-17
C192	a_27_82##8	VGND#10	1.20303e-20
C193	Y#6	B1#10	2.07981e-19
C194	VGND#13	A2#9	2.09352e-18
C195	a_28_368##4	A1#7	4.96047e-19
C196	A3#13	A3#11	3.82771e-17
C197	VPWR#7	A3#10	4.65791e-18
C198	a_487_368#	A3#1	5.38072e-17
C199	a_27_82##11	a_28_368#	1.93694e-18
C200	A3#7	A3#4	2.99691e-18
C201	Y#5	A3#10	6.30005e-19
C202	a_487_368##2	A3#7	3.26619e-19
C203	Y#6	A3#1	1.38551e-18
C204	a_27_82##13	a_27_82##11	2.96818e-18
C205	a_27_82##8	a_27_82##6	1.03023e-18
C206	a_28_368##5	A1#11	1.42443e-17
C207	a_487_368#	A3#10	3.70225e-17
C208	VPWR#7	A3#12	4.49909e-18
C209	a_28_368##4	A1#11	2.51527e-19
C210	a_487_368##5	A3#1	3.00902e-19
C211	A3#14	A3#7	2.31942e-19
C212	A3#8	A3#13	4.40258e-18
C213	Y#6	A3#10	5.67789e-17
C214	a_28_368##8	VPWR#4	5.20514e-18
C215	a_27_82##8	VGND#11	2.30439e-18
C216	a_487_368#	A3#12	6.72697e-19
C217	a_487_368##5	A3#10	1.30694e-18
C218	a_28_368##5	A1#12	4.70377e-19
C219	VPWR#7	A3#14	4.96402e-20
C220	VGND#2	A3#7	3.24107e-20
C221	a_28_368##4	A1#12	2.46536e-19
C222	Y#6	A3#12	5.30448e-17
C223	A2#5	A3#8	4.56741e-17
C224	A3#12	a_487_368##5	2.16867e-17
C225	a_487_368#	A3#14	3.00902e-19
C226	a_27_82##11	a_28_368##2	6.86916e-20
C227	a_487_368##2	A3#4	4.68382e-19
C228	Y#6	A3#14	2.00565e-18
C229	a_487_368##2	Y#6	1.6243e-17
C230	a_487_368##5	A3#14	4.00614e-17
C231	a_487_368##3	a_487_368##5	2.26641e-18
C232	A2#6	A2#5	3.90542e-17
C233	a_27_82##8	VGND#12	3.74211e-17
C234	VGND#2	B1#1	5.0956e-19
C235	A3#14	Y#7	1.72842e-17
C236	Y#6	A2#1	9.16843e-20
C237	B1	B1#8	1.77865e-17
C238	a_28_368#	A3#14	7.78396e-19
C239	a_487_368##5	A2#1	9.70936e-19
C240	a_28_368##5	VPWR#4	3.13618e-19
C241	a_487_368##2	a_487_368##5	5.24145e-20
C242	B1	B1#3	2.03006e-17
C243	B1	B1#2	2.80456e-18
C244	a_27_82#	Y#1	1.18684e-17
C245	A2#8	A2#6	2.69138e-17
C246	B1	A3#4	2.95339e-18
C247	VGND#2	A3#4	5.77612e-19
C248	a_28_368#	A2#1	5.52344e-17
C249	a_28_368##2	A3#14	2.13457e-19
C250	B1	A3#2	1.55896e-17
C251	VGND#2	B1#6	5.26823e-19
C252	a_487_368##3	A2#9	1.41114e-19
C253	VGND#5	a_27_82##11	1.51799e-17
C254	A2#1	a_487_368##6	2.62827e-17
C255	Y#10	Y#1	8.18113e-18
C256	a_487_368##2	Y#7	9.99685e-19
C257	a_28_368##4	VPWR#4	4.94929e-19
C258	A3#9	B1#8	3.47165e-18
C259	a_487_368##3	VPWR#3	9.45306e-17
C260	A2#11	A2#8	1.16938e-17
C261	a_28_368##2	A2#1	1.82234e-18
C262	Y#2	B1#4	8.81102e-18
C263	a_28_368#	A2#7	4.73258e-19
C264	a_487_368##3	a_28_368#	6.85206e-17
C265	a_487_368##2	VPWR#3	4.83486e-17
C266	Y#4	a_487_368##2	3.34079e-17
C267	A2#7	a_487_368##6	2.62827e-17
C268	a_487_368##3	A2#3	2.02699e-19
C269	a_28_368##2	A2#7	4.53797e-17
C270	VGND#2	B1#7	8.47792e-19
C271	VGND#13	VGND#12	2.06601e-18
C272	VGND#1	a_27_82#	4.06529e-17
C273	a_28_368#	A2#12	1.77071e-19
C274	VGND#7	A1#3	8.95991e-20
C275	VGND#1	Y#10	6.17692e-18
C276	A1#1	A2#11	3.74324e-17
C277	a_487_368##4	A2#7	9.00816e-19
C278	a_487_368##3	a_487_368##6	1.30135e-18
C279	A3	A3#7	3.71666e-17
C280	VGND#1	a_27_82##2	5.94012e-17
C281	A3	A3#4	2.04981e-17
C282	Y#1	B1#3	7.88555e-18
C283	a_28_368##7	A2#7	1.8901e-19
C284	a_28_368##2	A2#12	5.08278e-17
C285	VGND#1	Y#8	6.19376e-18
C286	A3	A3#2	1.81073e-18
C287	a_487_368##3	A2#2	1.39069e-19
C288	VGND#1	a_27_82##4	2.80748e-17
C289	a_487_368##4	A2#12	6.41244e-17
C290	VPWR#8	A2#7	7.10498e-20
C291	VGND#2	A3#2	1.67898e-19
C292	A1#6	A1#1	2.88855e-17
C293	A3	A2#2	4.74609e-19
C294	VGND#2	B1#9	1.48864e-18
C295	a_28_368##7	A2#12	1.88379e-18
C296	a_28_368##2	A2#13	8.30726e-19
C297	Y#1	B1#2	1.16859e-18
C298	a_487_368##3	a_28_368##2	2.8728e-17
C299	VGND#14	A1#3	4.46807e-19
C300	VPWR#8	A2#12	4.37986e-19
C301	A2#13	a_487_368##4	2.58759e-17
C302	A3#4	A3#9	2.1838e-18
C303	a_28_368##7	A2#13	5.25481e-17
C304	VGND#3	A3#9	4.88061e-19
C305	VPWR#7	B1#8	2.23075e-20
C306	A1#8	A1#6	4.04157e-17
C307	VPWR#8	A2#13	9.50002e-19
C308	a_487_368##4	A1#5	7.79389e-19
C309	VGND#14	A1#2	9.67218e-19
C310	VGND#2	A3#9	8.96255e-18
C311	a_487_368##4	a_487_368##3	2.10342e-18
C312	a_28_368##7	A1#5	4.65193e-17
C313	B1#3	VPWR#7	3.64103e-18
C314	A1#5	VPWR#8	2.65431e-17
C315	a_487_368##4	A1#7	4.38492e-19
C316	A1#10	A1#8	2.87127e-17
C317	A2	A2#10	6.31544e-18
C318	Y#10	B1#4	4.71935e-19
C319	A2	A2#9	3.19676e-17
C320	a_28_368##8	A1#5	1.44781e-19
C321	VGND#3	A3#11	9.60242e-19
C322	A2	A2#3	1.54383e-17
C323	a_28_368##7	A1#7	1.57066e-18
C324	a_27_82##2	B1#4	5.88682e-19
C325	A2	A2#2	2.57045e-18
C326	VGND#14	VGND#13	2.0166e-18
C327	A3#4	A3#2	5.3381e-18
C328	A2	A1#3	8.58256e-19
C329	Y#8	B1#4	2.14305e-18
C330	VGND#7	VGND#6	1.33001e-18
C331	VPWR#8	A1#7	4.96042e-17
C332	A2	A1#2	2.95701e-18
C333	VPWR#7	B1#2	2.88613e-19
C334	a_27_82##15	A1#3	2.79838e-18
C335	VGND#2	A3#11	8.97107e-18
C336	A1#7	a_28_368##8	2.10606e-17
C337	a_28_368##7	A1#11	2.18875e-19
C338	VGND#1	Y#1	4.56508e-18
C339	VGND#4	A3#13	5.94009e-20
C340	VPWR#9	A1#7	2.64683e-18
C341	VPWR#8	A1#11	2.52395e-18
C342	Y#8	Y#6	2.62284e-18
C343	B1#8	Y#5	2.37561e-19
C344	VPWR#7	A3#7	2.10073e-20
C345	a_28_368##6	A1#7	1.8144e-19
C346	A1#11	a_28_368##8	2.57546e-17
C347	VGND#3	A3#13	1.18946e-17
C348	VPWR#9	A1#11	5.19089e-17
C349	VGND#15	A1#9	3.02286e-19
C350	a_28_368##5	A1#4	2.63947e-18
C351	a_28_368##6	A1#11	7.88066e-19
C352	VGND#2	A3#13	1.54604e-18
C353	a_28_368##8	A1#12	3.08444e-19
C354	a_28_368##4	a_487_368##4	2.11073e-17
C355	A1	A2#10	4.31e-18
C356	VGND#4	A3#8	7.01616e-19
C357	A1	A2#9	4.16692e-20
C358	VPWR#9	A1#12	4.69217e-17
C359	B1#10	B1#5	3.47143e-18
C360	A1	A1#9	2.09906e-17
C361	a_28_368##5	a_28_368##7	1.64427e-18
C362	A1	A1#3	1.93028e-17
C363	a_28_368##6	A1#12	3.75684e-17
C364	A1	A1#2	8.63538e-18
C365	VGND#3	A3#8	1.25144e-17
C366	A2#13	A2#9	6.16523e-18
C367	a_27_82##15	VGND#14	1.98555e-17
C368	VPWR#7	A3#4	8.92042e-20
C369	VGND#6	VGND#4	1.52578e-18
C370	a_28_368##4	a_28_368##7	2.68731e-19
C371	VGND#2	a_27_82##4	2.83109e-17
C372	A3#1	B1#10	3.9605e-17
C373	VGND#2	A3#8	1.87423e-19
C374	a_28_368##4	A2#10	5.81894e-19
C375	B1#4	VPWR#7	4.24227e-18
C376	VGND#4	A2#5	4.65134e-18
C377	a_28_368##5	VPWR#8	1.49499e-17
C378	VGND#15	VGND#14	1.50065e-17
C379	a_487_368##4	VPWR#3	4.87227e-17
C380	Y	A3#7	1.3017e-17
C381	a_27_82##17	A1#9	1.04309e-18
C382	VGND#3	A2#5	1.70865e-18
C383	A3#10	A3#1	4.42796e-17
C384	Y	A3#4	1.196e-19
C385	a_28_368##4	VPWR#8	2.03044e-17
C386	a_27_82##13	a_28_368##4	1.85673e-17
C387	Y	A3#2	6.5811e-20
C388	a_28_368##4	A2#9	1.08069e-18
C389	VGND#6	A2#6	4.47955e-19
C390	Y	A2#10	1.08332e-19
C391	Y	A2#9	1.32104e-19
C392	VPWR#7	A3#2	2.52783e-20
C393	a_27_82##15	VGND#15	1.97962e-17
C394	A3#8	A3#7	3.12581e-19
C395	Y	A2#3	1.47959e-18
C396	VGND#2	VGND#10	7.12002e-18
C397	Y	A2#2	1.64996e-17
C398	a_28_368##5	a_28_368##8	4.53535e-18
C399	VGND#1	B1#1	1.55626e-17
C400	A3#12	A3#10	4.69677e-17
C401	VGND#4	A2#6	4.30087e-18
C402	A2#2	A3#7	1.43921e-18
C403	VGND#3	a_27_82##6	5.58177e-17
C404	VGND#1	B1#6	1.66725e-17
C405	a_27_82##15	A1#4	2.30659e-18
C406	VGND#1	B1#7	1.66725e-17
C407	a_28_368##5	A1#9	4.16739e-19
C408	VGND#15	A1#4	7.82407e-19
C409	VGND#1	B1#9	1.73996e-17
C410	a_27_82##17	A1#4	1.44739e-18
C411	A3#14	A3#12	4.50591e-17
C412	a_28_368##5	VPWR#9	2.78153e-17
C413	B1	Y#2	1.08493e-16
C414	VGND#6	A2#8	5.05291e-18
C415	VGND#4	VGND#3	1.85978e-18
C416	VPWR#4	A2#10	8.49923e-21
C417	VGND#2	a_27_82##6	3.01408e-17
C418	a_27_82##17	VGND#15	5.13274e-17
C419	VGND#4	A2#8	6.65666e-19
C420	A1#3	A1#5	3.31513e-18
C421	VGND#3	VGND#11	1.62465e-17
C422	a_28_368##5	A1#3	1.46944e-18
C423	A2#1	A3#14	4.84781e-18
C424	VGND#4	a_27_82##8	2.94337e-19
C425	A3	Y#4	3.96016e-17
C426	a_28_368##6	a_28_368##5	1.27996e-18
C427	VPWR#3	A3#8	1.10954e-19
C428	VGND#6	A2#11	5.82198e-18
C429	A2#7	A2#1	4.7229e-17
C430	VGND#6	VGND#12	5.5524e-19
C431	a_487_368#	A3#4	6.97838e-19
C432	Y#10	B1#3	2.68104e-18
C433	VGND#4	A2#11	1.40826e-19
C434	VGND#3	a_27_82##8	3.08768e-17
C435	a_27_82##8	a_28_368#	1.337e-18
C436	A2#12	A2#7	1.71732e-17
C437	Y#10	B1	3.17248e-17
C438	VGND#7	A1#1	2.61619e-18
C439	A1#4	a_28_368##8	2.74109e-19
C440	VGND#5	A2#6	5.29021e-20
C441	B1	a_27_82##2	2.51339e-18
C442	B1	Y#8	1.03785e-16
C443	A1#4	VPWR#9	9.49831e-19
C444	Y#6	A3#7	1.20875e-18
C445	VGND#5	A2#8	1.71936e-18
C446	a_27_82##13	A2	2.37989e-17
C447	a_27_82##11	A2	8.49133e-17
C448	VGND#6	A1#1	4.75582e-19
C449	VGND#3	VGND#2	4.30479e-18
C450	A2#13	A2#12	3.69364e-17
C451	Y#10	B1#2	2.989e-18
C452	a_28_368##4	A1#3	1.41136e-19
C453	Y#4	A3#7	4.96071e-18
C454	VGND	A3#2	6.27768e-19
C455	A2#2	A3#8	1.32937e-17
C456	VGND	A2#10	4.71385e-19
C457	a_27_82##2	B1#8	5.64932e-20
C458	VGND#12	VGND#3	3.06891e-18
C459	a_487_368#	A3#2	2.91178e-19
C460	VGND	A2#2	1.61907e-20
C461	Y#8	A3	5.05773e-17
C462	A1#5	A2#13	5.03876e-17
C463	VGND	A1#2	1.57128e-19
C464	VGND#7	A1#6	3.46638e-18
C465	Y#1	VPWR#7	1.14868e-16
C466	A3	a_27_82##6	2.51339e-18
C467	A2	a_28_368##4	2.07381e-17
C468	a_27_82##13	A1	2.08164e-17
C469	A3	VGND#11	6.74241e-18
C470	Y#2	B1#8	1.32352e-18
C471	a_28_368##4	A1#2	3.58268e-19
C472	A3#4	Y#6	5.08179e-18
C473	A1#7	A1#5	3.73238e-17
C474	B1	Y#1	2.42597e-17
C475	VGND#6	A1#6	2.34037e-19
C476	a_27_82##11	A3#8	2.02452e-19
C477	a_27_82##2	B1#3	3.70265e-19
C478	Y#5	Y#1	9.83759e-19
C479	A1#11	A1#7	4.77552e-17
C480	A1	a_28_368##5	8.36692e-17
C481	Y	Y#4	3.69112e-18
C482	VPWR#3	A3#14	4.4526e-18
C483	A3#7	a_487_368##5	1.15953e-18
C484	A1	a_28_368##4	2.25206e-17
C485	A2#3	A2#5	4.82776e-18
C486	Y#8	Y#2	2.56556e-18
C487	VPWR#3	A2#1	4.46713e-18
C488	A2	a_27_82##12	3.62846e-18
C489	Y#2	B1#3	1.59079e-18
C490	A2	VGND#13	6.91091e-18
C491	a_27_82##2	B1#2	3.04232e-19
C492	VPWR#3	A2#7	4.4526e-18
C493	A1#12	A1#11	4.63777e-17
C494	a_27_82#	B1#1	3.13325e-17
C495	A3	Y#6	7.79365e-17
C496	a_27_82##11	A2#5	7.73532e-19
C497	Y#5	VPWR#7	8.33707e-17
C498	VPWR#3	A2#12	4.4526e-18
C499	Y#6	A3#2	4.9365e-19
C500	Y#8	B1#8	1.4529e-18
C501	Y	a_487_368##3	2.46078e-18
C502	Y	a_487_368##2	3.24397e-18
C503	VPWR	VPWR#4	7.96501e-17
C504	A2#10	A2#9	9.91554e-18
C505	a_28_368##4	Y	6.57044e-19
C506	Y#10	B1#1	3.15095e-17
C507	VPWR	Y#4	9.2635e-18
C508	VPWR	Y#2	2.09847e-18
C509	a_487_368#	VPWR#7	4.90876e-17
C510	A1	VGND#14	3.72411e-18
C511	a_27_82#	B1#6	1.77405e-18
C512	A1	a_27_82##15	7.46846e-17
C513	A1	VGND#15	3.77799e-18
C514	a_27_82##17	A1	5.85434e-17
C515	a_27_82##11	A2#6	2.48588e-17
C516	a_27_82##2	B1#1	2.11598e-18
C517	A2	a_28_368##2	6.4313e-17
C518	Y	a_27_82##6	5.29586e-17
C519	VPWR#4	A1#3	2.01982e-20
C520	Y	VGND#11	3.3341e-18
C521	VPWR	a_487_368##3	3.54053e-17
C522	a_27_82##8	Y	7.73183e-17
C523	VGND	VGND#7	7.7091e-17
C524	VPWR	a_487_368##2	3.71979e-17
C525	VGND	VGND#6	8.96456e-17
C526	VGND	VGND#4	6.69126e-17
C527	VGND	VGND#3	1.06735e-16
C528	VPWR	a_28_368##5	3.60101e-18
C529	VGND#14	VGND#6	1.91353e-18
C530	Y#10	B1#6	3.27011e-17
C531	a_487_368#	Y#5	6.25843e-17
C532	VGND	VGND#2	6.87583e-17
C533	VPWR	a_28_368##4	3.97719e-18
C534	A3#7	Y#7	5.84767e-19
C535	a_27_82##13	A2#8	1.14212e-18
C536	a_27_82#	B1#7	4.49467e-19
C537	VGND#7	a_27_82##15	1.68193e-18
C538	VGND	a_27_82##13	2.02787e-17
C539	VGND	a_27_82##11	2.10342e-17
C540	a_27_82##2	B1#6	3.61967e-17
C541	B1#8	VNB	2.49742e-17
C542	B1#3	VNB	2.06286e-17
C543	B1#2	VNB	3.58436e-17
C544	A3#7	VNB	6.63301e-17
C545	A3#4	VNB	2.73458e-17
C546	A3#2	VNB	1.93891e-17
C547	a_27_82##11	A2#8	4.3902e-17
C548	Y#6	Y#5	2.17937e-18
C549	A2#10	VNB	2.47361e-17
C550	A2#9	VNB	5.11436e-17
C551	A1	a_28_368##6	4.09326e-17
C552	A2#3	VNB	2.45351e-17
C553	A2#2	VNB	1.95986e-17
C554	A1#9	VNB	3.47791e-17
C555	A1#3	VNB	2.90499e-17
C556	Y	a_28_368#	4.31403e-17
C557	VGND#1	B1#4	7.70605e-20
C558	A1#2	VNB	2.40977e-17
C559	A2	A3#8	1.87021e-18
C560	a_27_82##4	B1#8	2.44295e-19
C561	B1	B1#5	3.30204e-18
C562	a_28_368##2	Y	9.20436e-18
C563	a_487_368##3	A3#8	4.55907e-19
C564	VGND	a_28_368##4	4.07821e-18
C565	B1	B1#10	3.1408e-18
C566	B1	A3#1	4.58163e-18
C567	VPWR	VPWR#7	7.59699e-17
C568	VPWR	Y#5	7.188e-18
C569	B1	A3#10	8.53765e-19
C570	a_27_82#	B1#9	2.69604e-19
C571	VGND	Y#8	7.23324e-18
C572	VPWR	a_487_368#	2.27593e-17
C573	VGND	a_27_82##4	1.02815e-17
C574	VPWR	Y#6	1.08992e-17
C575	a_27_82##13	A2#11	4.91377e-17
C576	VGND	a_27_82##6	2.16526e-17
C577	a_487_368#	Y#6	6.17295e-17
C578	a_27_82##2	B1#7	3.66725e-17
C579	Y#8	A3#7	1.33731e-18
C580	a_487_368##2	A3#8	3.7335e-19
C581	VGND	a_27_82##8	6.98442e-18
C582	VPWR	a_28_368#	1.19773e-17
C583	A3	A3#1	8.18064e-19
C584	A3	A3#10	2.02694e-18
C585	VPWR	a_28_368##2	1.34304e-17
C586	VPWR	a_487_368##4	2.77769e-17
C587	Y	A3#9	1.27751e-19
C588	VPWR	a_28_368##7	1.67949e-17
C589	Y	A3#11	6.13336e-21
C590	VGND	a_27_82##15	8.35123e-18
C591	VPWR	VPWR#8	2.21423e-17
C592	Y	A3#13	1.78812e-17
C593	A3	A3#14	3.06857e-18
C594	a_27_82##11	A2#11	7.56872e-19
C595	VPWR	a_28_368##8	1.22396e-17
C596	VGND	a_27_82##17	1.8129e-17
C597	Y	A3#8	2.64768e-17
C598	VPWR	VPWR#9	2.19929e-17
C599	A3	A2#1	4.06119e-21
C600	Y	A2#5	1.79598e-18
C601	VPWR	a_28_368##6	1.59555e-17
C602	Y	A2#6	3.25983e-19
C603	Y#8	B1#7	3.52177e-17
C604	Y	A2#8	2.37109e-19
C605	Y	A2#11	1.94442e-19
C606	a_487_368##5	a_487_368#	3.6274e-18
C607	a_27_82#	A3#9	1.66929e-19
C608	A2	A2#1	7.0135e-19
C609	A2	A2#7	4.37941e-18
C610	VGND#7	VNB	3.11053e-17
C611	a_27_82##2	B1#9	1.35714e-18
C612	VGND#6	VNB	3.35341e-17
C613	VGND#4	VNB	2.42464e-17
C614	A2	A2#12	2.13354e-18
C615	VGND#3	VNB	4.25792e-17
C616	VGND#2	VNB	3.58075e-17
C617	a_27_82##13	A1#1	4.13529e-17
C618	A2	A2#13	2.03573e-18
C619	VPWR#4	VNB	4.09901e-17
C620	a_27_82##4	B1#7	1.80029e-18
C621	A2	A1#5	5.79236e-19
C622	Y#4	VNB	3.14525e-18
C623	Y	A3#1	1.50803e-19
C624	VGND#1	B1	6.09116e-18
C625	A2	A1#7	1.65974e-19
C626	a_27_82##13	VNB	6.00634e-18
C627	a_27_82##11	VNB	4.67352e-18
C628	Y	A3#10	2.92766e-19
C629	A1	A2#12	1.75449e-19
C630	VGND	A3#9	9.88862e-18
C631	Y	A3#12	5.3176e-19
C632	VGND	A3#11	9.2755e-18
C633	A1	A2#13	1.10836e-18
C634	a_27_82##6	B1#6	2.09219e-19
C635	VGND	A3#13	9.88862e-18
C636	Y	A3#14	1.62488e-18
C637	Y#6	a_487_368##5	4.71322e-17
C638	a_487_368##3	VNB	9.06141e-18
C639	A1	A1#5	3.50934e-18
C640	a_487_368##2	VNB	8.55363e-18
C641	VGND	A3#8	9.39734e-18
C642	Y	A2#1	2.12562e-17
C643	Y#8	B1#9	3.34254e-17
C644	VGND	A2#5	5.03733e-18
C645	a_28_368##4	VNB	2.07489e-18
C646	A1	A1#7	2.10765e-18
C647	VGND	A2#6	4.82291e-18
C648	Y	A2#7	3.80154e-18
C649	B1	B1#4	1.87076e-17
C650	VGND	A2#8	9.2755e-18
C651	VPWR	A3#1	1.95016e-18
C652	A1	A1#11	2.10322e-18
C653	a_27_82#	VNB	4.40667e-17
C654	Y	A2#12	1.23047e-18
C655	Y#10	VNB	3.14366e-18
C656	VGND	A2#11	9.88862e-18
C657	a_27_82##2	VNB	4.99354e-18
C658	VPWR	A3#10	1.55967e-18
C659	Y#8	VNB	1.96363e-18
C660	VGND	A1#1	9.46466e-18
C661	Y	A2#13	1.68675e-19
C662	A1	A1#12	3.3974e-18
C663	a_27_82##4	VNB	3.13613e-18
C664	VPWR	A3#12	1.6494e-18
C665	A2#9	A2#3	2.02121e-18
C666	VGND	A1#6	4.82291e-18
C667	a_27_82##6	VNB	2.08289e-18
C668	VGND	A1#8	4.72725e-18
C669	VPWR	A3#14	1.60945e-18
C670	a_27_82##8	VNB	2.39234e-18
C671	VGND#12	VNB	5.09012e-20
C672	VGND	A1#10	9.88862e-18
C673	VPWR	A2#1	1.64491e-18
C674	VGND#13	VNB	3.2402e-18
C675	Y#8	A3#4	3.81281e-18
C676	VPWR	A2#7	1.6094e-18
C677	VGND#14	VNB	1.47622e-18
C678	a_27_82##15	VNB	6.76344e-19
C679	VPWR	A2#12	1.50439e-18
C680	VGND#15	VNB	3.39895e-18
C681	VGND#1	B1#8	4.31943e-20
C682	a_27_82##17	VNB	4.60343e-17
C683	Y#1	VNB	5.59712e-17
C684	VPWR	A2#13	4.25482e-19
C685	VPWR#7	VNB	1.01781e-16
C686	Y#5	VNB	2.78027e-18
C687	a_487_368#	VNB	3.14712e-18
C688	a_27_82##4	B1#9	3.74668e-17
C689	VPWR	A1#7	1.08154e-18
C690	a_28_368#	VNB	3.3703e-18
C691	VPWR	A1#11	1.09837e-18
C692	a_27_82##13	A1#6	1.11758e-18
C693	VGND#1	B1#3	1.38679e-18
C694	a_487_368##4	VNB	4.96285e-18
C695	VPWR	A1#12	2.08506e-18
C696	a_28_368##7	VNB	2.11065e-18
C697	VPWR#8	VNB	1.19236e-18
C698	a_28_368##8	VNB	4.61348e-18
C699	a_27_82##6	B1#7	2.62533e-19
C700	VPWR#9	VNB	2.49533e-18
C701	a_28_368##6	VNB	4.98572e-17
C702	B1#1	VNB	4.16828e-17
C703	B1#6	VNB	3.04587e-17
C704	A1	A1#4	1.97794e-17
C705	B1#7	VNB	2.97678e-17
C706	B1#9	VNB	2.97639e-17
C707	VGND#1	B1#2	1.36669e-18
C708	Y#8	A3#9	1.94937e-17
C709	A3#9	VNB	3.37583e-17
C710	VPWR	VPWR#3	1.41299e-16
C711	A3#11	VNB	3.27715e-17
C712	A3#13	VNB	3.0405e-17
C713	A3#8	VNB	5.05957e-17
C714	A2#5	VNB	3.03468e-17
C715	A2#6	VNB	2.7581e-17
C716	A3	B1	3.13882e-17
C717	A2#8	VNB	3.30057e-17
C718	A2#11	VNB	3.34581e-17
C719	A1#1	VNB	3.10894e-17
C720	VGND	VGND#1	4.59021e-18
C721	A1#6	VNB	2.57328e-17
C722	A1#8	VNB	2.55489e-17
C723	A1#10	VNB	4.18668e-17
C724	VGND	VGND#5	2.31442e-17
C725	B1#5	VNB	4.79311e-17
C726	B1#10	VNB	3.38593e-17
C727	A3#1	VNB	3.21037e-17
C728	A3#10	VNB	3.19734e-17
C729	A3#12	VNB	3.15398e-17
C730	A3#14	VNB	3.55473e-17
C731	A2#1	VNB	3.59062e-17
C732	A2#7	VNB	3.14937e-17
C733	A2#12	VNB	3.24163e-17
C734	A2#13	VNB	3.59328e-17
C735	A1	A2	1.39484e-17
C736	A1#5	VNB	3.59094e-17
C737	Y	A3	1.05637e-16
C738	A1#7	VNB	2.8455e-17
C739	a_27_82##4	A3#9	4.05079e-17
C740	A1#11	VNB	2.84351e-17
C741	VPWR	B1	2.10665e-18
C742	A1#12	VNB	3.8727e-17
C743	A2	Y	2.10856e-17
C744	VPWR	A3	8.76855e-18
C745	VGND#1	VNB	2.1036e-16
C746	VPWR#3	VNB	8.4475e-17
C747	VGND	B1	1.91964e-18
C748	VPWR	A2	9.46186e-18
C749	VGND#5	VNB	1.35562e-17
C750	B1#4	VNB	2.40925e-17
C751	VGND	A3	7.7383e-18
C752	VPWR	A1	1.12957e-17
C753	VGND	A2	8.19733e-18
C754	a_27_82##6	B1#9	4.50966e-19
C755	A1#4	VNB	3.00145e-17
C756	VPWR	Y	9.12759e-18
C757	VGND	A1	9.73615e-18
C758	VGND	Y	1.25997e-17
C759	a_27_82##13	A1#8	2.19728e-19
C760	B1	VNB	2.28653e-17
C761	A3	VNB	8.79642e-18
C762	Y#8	A3#11	1.62393e-17
C763	A2	VNB	9.12322e-18
C764	A1	VNB	3.62501e-17
C765	Y	VNB	1.32246e-17
C766	VPWR	VNB	3.13294e-16
C767	VGND	VNB	2.92023e-16
C768	A3#9	VGND#10	1.84488e-17
C769	VGND#4	a_27_82##9	6.29591e-18
C770	Y#1	VPWR#2	3.49964e-17
C771	VPWR#2	B1	7.75762e-18
C772	VGND#3	a_27_82##9	1.06306e-17
C773	VPWR#5	VNB	4.58683e-17
C774	VPWR#2	Y#5	1.03654e-17
C775	a_28_368##6	VPWR#5	1.78825e-17
C776	VPWR#2	B1#5	7.02608e-19
C777	VGND#8	A1#3	2.722e-20
C778	a_27_82##9	a_27_82##6	4.14125e-19
C779	a_28_368##5	VPWR#5	3.13618e-19
C780	VGND#8	a_27_82##17	1.82878e-17
C781	a_28_368##8	VPWR#5	5.25459e-18
C782	a_27_82##9	A3#13	2.40948e-19
C783	VGND#8	VNB	4.99716e-17
C784	a_27_82##9	a_27_82##8	3.55051e-18
C785	VPWR#5	VPWR#4	1.22166e-18
C786	a_27_82##9	A3#8	3.35063e-18
C787	VGND#8	A1#10	2.59122e-18
C788	VPWR	VPWR#5	7.76907e-17
C789	VPWR#2	Y#2	2.94265e-18
C790	VGND	a_27_82##9	1.18214e-17
C791	VPWR#2	VPWR#7	1.67174e-16
C792	VGND#12	a_27_82##9	1.2631e-17
C793	a_27_82##9	A2#5	2.85192e-18
C794	VGND#8	A1#4	6.30508e-20
C795	VPWR#5	A1#4	2.04712e-20
C796	VPWR#5	A1#12	1.84214e-18
C797	a_27_82##9	VNB	4.71232e-18
C798	VGND#8	A1#8	3.45915e-18
C799	VPWR#2	VNB	1.32353e-16
C800	VPWR#5	A1#11	1.83922e-18
C801	VGND#8	a_27_82##15	1.69367e-18
C802	VPWR#2	B1#10	6.76869e-20
C803	VGND#8	VGND#7	1.94695e-18
C804	VGND	VGND#8	1.00182e-16
*
*
.ENDS sky130_fd_sc_hs__o31ai_4
*
