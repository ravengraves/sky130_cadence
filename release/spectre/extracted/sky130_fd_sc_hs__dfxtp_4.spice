* Extracted by Quantus, converted by sky130cad/quantus.py
*
*
*
*                       LINUX           Wed Nov 18 08:29:34 2026
*
*
*
*  PROGRAM  advgen
*
*  Name           : advgen - Quantus - (64-bit)
*  Version        : 25.1.0-p047
*  Build Date     : Thu Dec 11 23:20:30 PST 2025
*
*  HSPICE LIBRARY
*
*  OPERATING_TEMPERATURE 150
*  QRC_TECH_DIR <path>/tech
*
*
*

*
.SUBCKT sky130_fd_sc_hs__dfxtp_4 VPB VNB VGND VPWR Q D CLK
*
*
*  caps2d version: 10
*
*
*       TRANSISTOR CARDS
*
*
XM29 a_27_74##13 CLK#3 VGND#16 VNB sky130_fd_pr__nfet_01v8_lvt l=0.15 w=0.74 ad=0.2109 as=0.3515 pd=2.05 ps=2.43
XM14 VGND#16 a_27_74# a_206_368##14 VNB sky130_fd_pr__nfet_01v8_lvt l=0.15 w=0.74 ad=0.3515 as=0.2516 pd=2.43 ps=2.16
XM19 VGND#15 D#3 a_437_503# VNB sky130_fd_pr__nfet_01v8_lvt l=0.15 w=0.42 ad=0.355025 as=0.1176 pd=2.6 ps=1.4
XM27 a_437_503# a_27_74##5 a_544_485##8 VNB sky130_fd_pr__nfet_01v8_lvt l=0.15 w=0.42 ad=0.1176 as=0.151375 pd=1.4 ps=1.66
XM8 a_544_485##8 a_206_368# a_735_102# VNB sky130_fd_pr__nfet_01v8_lvt l=0.15 w=0.42 ad=0.151375 as=0.0882 pd=1.66 ps=1.26
XM20 a_735_102# a_696_458# VGND#14 VNB sky130_fd_pr__nfet_01v8_lvt l=0.15 w=0.42 ad=0.0882 as=0.3943 pd=1.26 ps=2.73
XM3 VGND#14 a_544_485# a_696_458##5 VNB sky130_fd_pr__nfet_01v8_lvt l=0.15 w=0.55 ad=0.3943 as=0.198 pd=2.73 ps=1.97
XM24 a_696_458##5 a_206_368##5 a_1034_424##6 VNB sky130_fd_pr__nfet_01v8_lvt l=0.15 w=0.55 ad=0.198 as=0.2152 pd=1.97 ps=1.97
XM4 a_1034_424##6 a_27_74##8 a_1178_124# VNB sky130_fd_pr__nfet_01v8_lvt l=0.15 w=0.42 ad=0.2152 as=0.1323 pd=1.97 ps=1.47
XM30 a_1178_124# a_1226_296# VGND#13 VNB sky130_fd_pr__nfet_01v8_lvt l=0.15 w=0.42 ad=0.1323 as=0.1197 pd=1.47 ps=1.41
XM10 a_1226_296##20 a_1034_424# VGND#12 VNB sky130_fd_pr__nfet_01v8_lvt l=0.15 w=0.74 ad=0.2109 as=0.2294 pd=2.05 ps=2.1
XM11 Q#1 a_1226_296##9 VGND#12 VNB sky130_fd_pr__nfet_01v8_lvt l=0.15 w=0.74 ad=0.2368 as=0.2294 pd=2.12 ps=2.1
XM9 Q#1 a_1226_296##13 VGND#11 VNB sky130_fd_pr__nfet_01v8_lvt l=0.15 w=0.74 ad=0.2368 as=0.222 pd=2.12 ps=2.08
XM5 VGND#11 a_1226_296##11 Q#5 VNB sky130_fd_pr__nfet_01v8_lvt l=0.15 w=0.74 ad=0.222 as=0.2072 pd=2.08 ps=2.04
XM2 VGND#1 a_1226_296##10 Q#5 VNB sky130_fd_pr__nfet_01v8_lvt l=0.15 w=0.74 ad=0.2109 as=0.2072 pd=2.05 ps=2.04
XM0 a_27_74##16 CLK#1 VPWR#16 VPB sky130_fd_pr__pfet_01v8 l=0.15 w=1.12 ad=0.3304 as=0.336 pd=2.83 ps=2.84
XM17 VPWR#16 a_27_74##3 a_206_368##11 VPB sky130_fd_pr__pfet_01v8 l=0.15 w=1.12 ad=0.336 as=0.3304 pd=2.84 ps=2.83
XM26 VPWR#15 D#1 a_437_503##2 VPB sky130_fd_pr__pfet_01v8 l=0.15 w=0.42 ad=0.2544 as=0.17745 pd=2.2 ps=1.79
XM15 a_437_503##2 a_206_368##3 a_544_485##7 VPB sky130_fd_pr__pfet_01v8 l=0.15 w=0.42 ad=0.17745 as=0.17745 pd=1.79 ps=1.79
XM22 a_544_485##7 a_27_74##6 a_651_503# VPB sky130_fd_pr__pfet_01v8 l=0.15 w=0.42 ad=0.17745 as=0.1008 pd=1.79 ps=1.32
XM1 a_651_503# a_696_458##3 VPWR#14 VPB sky130_fd_pr__pfet_01v8 l=0.15 w=0.42 ad=0.1008 as=0.4797 pd=1.32 ps=3.47
XM25 VPWR#14 a_544_485##4 a_696_458##8 VPB sky130_fd_pr__pfet_01v8 l=0.15 w=0.84 ad=0.4797 as=0.4452 pd=3.47 ps=2.74
XM16 a_696_458##8 a_27_74##7 a_1034_424##8 VPB sky130_fd_pr__pfet_01v8 l=0.15 w=0.84 ad=0.4452 as=0.2856 pd=2.74 ps=2.45
XM6 a_1034_424##8 a_206_368##6 a_1141_508# VPB sky130_fd_pr__pfet_01v8 l=0.15 w=0.42 ad=0.2856 as=0.1995 pd=2.45 ps=1.79
XM21 a_1141_508# a_1226_296##3 VPWR#13 VPB sky130_fd_pr__pfet_01v8 l=0.15 w=0.42 ad=0.1995 as=0.2604 pd=1.79 ps=2.39
XM18 VPWR#13 a_1034_424##4 a_1226_296##21 VPB sky130_fd_pr__pfet_01v8 l=0.15 w=0.84 ad=0.2604 as=0.252 pd=2.39 ps=2.28
XM7 a_1226_296##21 a_1034_424##5 VPWR#12 VPB sky130_fd_pr__pfet_01v8 l=0.15 w=0.84 ad=0.252 as=0.406 pd=2.28 ps=3.01
XM13 Q#4 a_1226_296##15 VPWR#12 VPB sky130_fd_pr__pfet_01v8 l=0.15 w=1.12 ad=0.336 as=0.406 pd=2.84 ps=3.01
XM12 Q#4 a_1226_296##14 VPWR#11 VPB sky130_fd_pr__pfet_01v8 l=0.15 w=1.12 ad=0.336 as=0.336 pd=2.84 ps=2.84
XM23 VPWR#11 a_1226_296##12 Q#6 VPB sky130_fd_pr__pfet_01v8 l=0.15 w=1.12 ad=0.336 as=0.336 pd=2.84 ps=2.84
XM28 VPWR#1 a_1226_296##4 Q#6 VPB sky130_fd_pr__pfet_01v8 l=0.15 w=1.12 ad=0.3304 as=0.336 pd=2.83 ps=2.84
*
*
*       RESISTOR AND CAP/DIODE CARDS
*
Rg1	CLK#1	CLK#2	448.815094
Rg2	CLK#2	CLK#3	345.814911
Rg3	a_27_74#	a_27_74##2	302.102234
Rg4	a_27_74##2	a_27_74##3	486.224121
Rg5	D#1	D#2	226.096359
Rg6	D#3	D#4	429.137878
Rg7	a_27_74##4	a_27_74##5	550.548706
Rg8	a_27_74##4	a_27_74##6	348.057922
Rg9	a_206_368#	a_206_368##2	1927.606812
Rg10	a_206_368##2	a_206_368##3	985.588562
Rg11	a_696_458#	a_696_458##2	202.035629
Rg12	a_696_458##2	a_696_458##3	853.652649
Rg13	a_696_458##2	a_696_458##4	49.250992
Rg14	a_544_485#	a_544_485##2	605.973083
Rg15	a_544_485##2	a_544_485##3	34.566891
Rg16	a_544_485##2	a_544_485##4	339.214142
Rg17	a_206_368##4	a_206_368##5	249.741394
Rg18	a_206_368##6	a_206_368##7	226.096359
Rg19	a_27_74##7	a_27_74##8	1251.402588
Rg20	a_27_74##8	a_27_74##9	216.119781
Rg21	a_1226_296#	a_1226_296##2	405.494232
Rg22	a_1226_296##2	a_1226_296##3	482.618622
Rg23	a_1034_424#	a_1034_424##2	371.977844
Rg24	a_1034_424##2	a_1034_424##3	232.287354
Rg25	a_1034_424##3	a_1034_424##4	351.296814
Rg26	a_1034_424##3	a_1034_424##5	446.265228
Rg27	a_1226_296##4	a_1226_296##5	528.662170
Rg28	a_1226_296##5	a_1226_296##6	69.824287
Rg29	a_1226_296##6	a_1226_296##7	84.263916
Rg30	a_1226_296##7	a_1226_296##8	58.569523
Rg31	a_1226_296##8	a_1226_296##9	368.862610
Rg32	a_1226_296##5	a_1226_296##10	412.337402
Rg33	a_1226_296##6	a_1226_296##11	394.814545
Rg34	a_1226_296##6	a_1226_296##12	437.854187
Rg35	a_1226_296##7	a_1226_296##13	352.054443
Rg36	a_1226_296##7	a_1226_296##14	455.054626
Rg37	a_1226_296##8	a_1226_296##15	471.862823
Rf1	CLK#4	CLK#2	161.607086
Rf2	CLK	CLK#6	1.374290
Rf3	CLK#4	CLK#6	6.881835
Rf4	D	D#2	192.262924
Rf5	D	D#4	160.413971
Rf6	a_437_503#	a_437_503##2	171.650665
Rf7	a_544_485##3	a_544_485##6	262.965851
Rf8	a_544_485##6	a_544_485##7	30.558464
Rf9	a_544_485##6	a_544_485##8	138.031738
Rf10	a_696_458##5	a_696_458##6	54.546608
Rf11	a_696_458##6	a_696_458##4	177.295532
Rf12	a_696_458##6	a_696_458##8	98.011345
Rf13	a_206_368##7	a_206_368##9	243.029419
Rf14	a_206_368##9	a_206_368##10	309.056885
Rf15	a_206_368##10	a_206_368##11	7.811945
Rf16	a_206_368##9	a_206_368##4	283.353485
Rf17	a_206_368##10	a_206_368##13	39.909122
Rf18	a_206_368##13	a_206_368##14	53.326977
Rf19	a_206_368##13	a_206_368##2	165.174408
Rf20	a_27_74##9	a_27_74##11	323.957184
Rf21	a_27_74##11	a_27_74##12	321.179047
Rf22	a_27_74##12	a_27_74##13	46.316921
Rf23	a_27_74##11	a_27_74##4	255.569580
Rf24	a_27_74##12	a_27_74##15	10.340556
Rf25	a_27_74##15	a_27_74##16	90.623344
Rf26	a_1034_424##6	a_1034_424##7	48.473515
Rf27	a_1034_424##7	a_1034_424##8	129.026245
Rf28	a_1034_424##7	a_1034_424##2	234.843811
Rf29	a_1226_296##7	a_1226_296##17	80.594032
Rf30	a_1226_296##17	a_1226_296##18	49.244732
Rf31	a_1226_296##18	a_1226_296##2	211.818451
Rf32	a_1226_296##17	a_1226_296##20	74.475830
Rf33	a_1226_296##18	a_1226_296##21	33.109421
Rf34	Q#1	Q#2	68.094818
Rf35	Q#2	Q#3	59.778580
Rf36	Q#3	Q#4	75.707176
Rf37	Q#2	Q#5	19.939056
Rf38	Q#3	Q	6.507679
Rf39	Q	Q#7	14.369054
Rf40	Q#7	Q	0.196836
Rf41	Q#6	Q#7	5.000000
Rf42	VPWR#1	VPWR#2	115.707314
Rf43	VPWR#2	VPWR#3	19.091171
Rf44	VPWR#3	VPWR#4	49.707153
Rf45	VPWR#4	VPWR#5	72.873260
Rf46	VPWR#5	VPWR#6	190.061951
Rf47	VPWR#6	VPWR#7	37.961727
Rf48	VPWR#7	VPWR#8	118.439842
Rf49	VPWR#8	VPWR#9	73.977089
Rf51	VPWR#2	VPWR#11	58.622005
Rf52	VPWR#4	VPWR#12	44.620285
Rf53	VPWR#5	VPWR#13	37.529072
Rf54	VPWR#6	VPWR#14	24.075169
Rf55	VPWR#8	VPWR#15	31.788271
Rf56	VPWR#9	VPWR#16	53.143215
Rf57	VGND#1	VGND#2	107.025391
Rf58	VGND#2	VGND#3	18.725920
Rf59	VGND#3	VGND#4	49.284554
Rf60	VGND#4	VGND#5	69.406258
Rf61	VGND#5	VGND#6	169.542786
Rf62	VGND#6	VGND#7	62.490990
Rf63	VGND#7	VGND#8	88.366570
Rf64	VGND#8	VGND#9	105.266228
Rf66	VGND#2	VGND#11	51.511902
Rf67	VGND#4	VGND#12	32.539131
Rf68	VGND#5	VGND#13	50.841217
Rf69	VGND#6	VGND#14	28.841251
Rf70	VGND#8	VGND#15	30.373932
Rf71	VGND#9	VGND#16	51.511902
Rf82	a_27_74##2	a_27_74##15	160.232803
Re1	VPWR#3	VPWR	2.920302
Re2	VPWR	VPWR#7	1.251558
Re3	VGND#3	VGND	2.920302
Re4	VGND	VGND#7	1.251558
*
*       CAPACITOR CARDS
*
*
C1	a_1034_424##7	a_1226_296##2	5.59263e-17
C2	a_1034_424##7	a_206_368##5	8.03742e-19
C3	a_27_74##13	VGND#16	3.76784e-17
C4	a_27_74##11	a_1226_296#	7.41137e-20
C5	VPWR#2	VPWR#1	7.0017e-19
C6	VPWR#13	a_1226_296##3	3.00078e-17
C7	a_206_368##9	a_696_458##2	1.11032e-18
C8	a_437_503#	a_206_368##3	4.60932e-18
C9	a_544_485#	a_206_368##5	2.7864e-17
C10	Q#3	a_1226_296##6	4.96527e-18
C11	VPWR#3	a_1226_296##8	1.21897e-20
C12	VPWR#13	a_206_368##6	1.96619e-18
C13	a_27_74##9	a_1034_424##7	5.22366e-18
C14	a_1034_424##7	a_544_485#	3.14073e-19
C15	a_27_74##11	a_27_74##8	1.29437e-19
C16	VGND#3	VGND#1	5.54468e-17
C17	a_27_74##11	a_696_458##5	2.72353e-17
C18	Q#2	a_1226_296##8	4.10615e-20
C19	VPWR#6	a_544_485##3	9.15361e-20
C20	a_1226_296##21	a_27_74##7	2.6023e-19
C21	a_696_458#	a_544_485#	7.65877e-18
C22	Q#3	a_1226_296##5	1.1412e-17
C23	a_206_368##6	a_1034_424##8	1.10296e-17
C24	VPWR#3	a_1034_424##3	1.2953e-22
C25	VGND#3	Q#1	3.30244e-17
C26	a_27_74##11	a_27_74##9	1.84071e-18
C27	a_206_368#	a_544_485#	1.08004e-18
C28	a_1034_424##7	a_206_368##7	3.70007e-17
C29	a_27_74##11	a_206_368##5	1.24487e-18
C30	a_27_74##11	VGND#14	8.83745e-17
C31	CLK#6	a_27_74##16	3.64453e-17
C32	Q#3	VPWR#1	2.63057e-17
C33	Q#2	a_1226_296##6	2.12787e-18
C34	VGND#3	VGND#12	1.80902e-17
C35	a_1034_424##8	a_27_74##7	3.28297e-17
C36	VGND#3	a_1226_296##8	5.89299e-20
C37	a_206_368#	a_696_458#	4.09398e-17
C38	a_696_458##2	VGND#14	3.14592e-18
C39	VGND#3	a_1226_296##20	1.55422e-17
C40	a_27_74##7	a_696_458##8	2.86265e-17
C41	Q#3	a_1034_424##3	9.87697e-21
C42	Q#4	VPWR#4	2.06112e-18
C43	VGND#3	a_1226_296##6	1.60142e-18
C44	a_1226_296##6	a_1226_296##5	5.7111e-18
C45	a_1034_424##3	a_1226_296##8	1.09546e-19
C46	Q#6	VPWR#1	3.64419e-17
C47	VGND#8	D#4	1.57328e-19
C48	a_27_74##11	a_544_485#	1.78491e-17
C49	a_206_368##4	a_1034_424##7	4.79932e-17
C50	VGND#3	a_1226_296##5	1.8602e-20
C51	VPWR#5	VPWR#12	1.12329e-18
C52	Q#3	Q#6	2.46769e-19
C53	Q#2	a_1226_296##5	1.10442e-17
C54	a_544_485##4	a_696_458##8	1.33853e-17
C55	a_206_368#	a_27_74##5	3.96345e-17
C56	VPWR#11	VPWR#1	1.94092e-18
C57	a_544_485##4	VPWR#14	1.97959e-17
C58	a_544_485##7	a_27_74##7	1.40102e-19
C59	a_696_458##8	a_696_458##3	3.58469e-19
C60	a_206_368#	D#3	1.94906e-17
C61	a_27_74##11	a_696_458#	2.40939e-17
C62	a_1034_424##7	a_544_485##3	1.14522e-19
C63	a_27_74##11	a_544_485##8	7.96513e-17
C64	a_1226_296##7	VGND#11	3.45243e-18
C65	a_27_74##9	a_696_458##6	1.45823e-18
C66	a_1226_296##21	VPWR#5	9.36578e-18
C67	VPWR#11	Q#6	3.58517e-17
C68	a_696_458##3	VPWR#14	7.81128e-18
C69	Q#3	VPWR#11	2.0989e-17
C70	a_544_485##7	a_544_485##4	1.64944e-19
C71	a_206_368##9	a_206_368##7	3.39378e-18
C72	D#3	a_27_74##5	3.72718e-17
C73	a_1226_296##7	Q#1	5.97785e-17
C74	a_27_74##12	a_206_368#	9.9434e-20
C75	a_696_458##8	a_27_74##6	9.36674e-20
C76	VGND#12	a_1226_296##7	4.30094e-18
C77	VGND#1	a_1226_296##10	2.70131e-17
C78	VPWR#2	a_1226_296##4	2.39391e-18
C79	a_1226_296##21	VPWR#4	7.58311e-18
C80	a_27_74##11	a_544_485##3	1.56827e-18
C81	a_544_485##7	a_696_458##3	3.74806e-19
C82	a_27_74##11	a_206_368#	5.11948e-17
C83	a_1226_296##6	a_1226_296##4	2.05486e-18
C84	a_27_74##11	a_437_503#	7.53111e-17
C85	a_696_458##8	a_206_368##3	7.0749e-20
C86	VGND#8	a_206_368##2	1.49564e-17
C87	a_27_74##12	VGND#15	6.32651e-17
C88	a_1226_296##10	Q#5	1.5442e-17
C89	a_696_458##6	a_696_458##2	7.20569e-19
C90	a_206_368##4	a_206_368##9	1.9964e-18
C91	Q#4	Q#3	3.01982e-18
C92	VPWR#8	D#2	1.56369e-19
C93	VPWR#4	a_1226_296##12	8.74044e-20
C94	VGND#1	a_1226_296##11	1.34665e-18
C95	a_27_74##6	a_544_485##7	1.00124e-17
C96	Q#4	VPWR#11	6.23134e-17
C97	VPWR#3	VPWR#1	5.43158e-17
C98	a_696_458##6	a_27_74##8	5.66607e-20
C99	a_1034_424##2	a_1226_296##20	3.75761e-17
C100	a_544_485##8	a_696_458##2	5.35075e-18
C101	VGND#11	a_1226_296##10	4.84709e-19
C102	VPWR#2	a_1226_296##12	5.09857e-18
C103	a_27_74##11	a_696_458##4	7.44119e-17
C104	a_437_503##2	a_27_74##6	4.76106e-19
C105	a_27_74##11	a_27_74##5	7.91005e-18
C106	a_696_458##6	a_206_368##4	4.43858e-17
C107	a_27_74##11	VGND#15	3.9322e-17
C108	VGND#13	a_1034_424##2	3.40919e-17
C109	Q#3	a_1226_296##4	1.03467e-17
C110	a_1226_296##11	Q#5	1.4935e-17
C111	a_544_485##7	a_206_368##3	2.21128e-17
C112	a_1226_296##17	a_1226_296##8	1.18056e-18
C113	CLK#3	a_27_74#	1.7109e-17
C114	a_544_485##3	a_206_368##9	5.99167e-17
C115	a_27_74##12	a_206_368##14	9.06695e-17
C116	VPWR#12	VPWR#11	1.94092e-18
C117	VGND#3	VPWR#1	3.64537e-18
C118	VGND#1	a_1226_296##13	2.73182e-19
C119	a_27_74##12	D#3	5.96873e-19
C120	Q#4	VPWR#3	3.35588e-17
C121	a_437_503##2	a_206_368##3	3.75422e-17
C122	VPWR#4	a_1226_296##14	3.00302e-19
C123	VPWR#8	a_206_368##2	1.01598e-19
C124	a_206_368##11	a_27_74##6	9.57212e-18
C125	a_1226_296##11	VGND#11	1.67538e-17
C126	a_544_485##7	D#1	4.19929e-19
C127	VGND#13	a_1226_296##2	6.39537e-19
C128	a_27_74##11	a_27_74##4	1.57817e-18
C129	a_696_458##6	a_544_485##3	3.95243e-17
C130	VGND#2	VGND#1	1.18415e-18
C131	a_544_485##6	a_696_458##2	3.4222e-19
C132	a_27_74##11	D#3	1.99637e-17
C133	VPWR#2	a_1226_296##14	1.66037e-18
C134	VPWR#12	Q#4	6.96936e-17
C135	a_27_74##12	a_27_74##11	2.78922e-18
C136	VGND#12	a_27_74##9	1.20462e-19
C137	a_544_485##6	a_544_485##3	1.4666e-18
C138	VPWR#3	a_1226_296##21	1.76699e-17
C139	D#1	a_437_503##2	1.23635e-17
C140	Q#3	a_1226_296##12	1.70861e-17
C141	VGND#3	Q#4	3.03303e-18
C142	a_206_368##11	a_206_368##3	9.15233e-18
C143	VGND#7	a_696_458##2	7.26321e-20
C144	VPWR#5	a_1226_296##15	1.95348e-19
C145	Q#1	a_1226_296##11	1.351e-18
C146	a_1226_296##17	a_1226_296##6	9.08042e-20
C147	a_27_74##12	VGND#16	7.04008e-17
C148	a_206_368##13	a_437_503#	7.69757e-19
C149	a_1226_296##20	a_27_74##9	2.59798e-19
C150	a_1226_296##18	Q#4	9.95856e-19
C151	a_27_74##12	a_27_74#	2.80121e-17
C152	D#1	VPWR#15	1.66037e-17
C153	a_206_368##13	a_27_74##4	1.24052e-19
C154	a_696_458##6	a_544_485#	1.94431e-17
C155	a_1226_296##13	VGND#11	1.92274e-17
C156	a_1226_296##7	a_1226_296##8	1.89502e-17
C157	a_437_503#	a_544_485##7	1.43778e-18
C158	a_27_74##9	VGND#13	1.00283e-17
C159	VPWR#4	a_1226_296##15	7.45556e-18
C160	a_1226_296##18	a_1034_424##3	9.54221e-18
C161	a_27_74##12	D#4	5.0321e-18
C162	a_1226_296##21	Q#4	1.70916e-18
C163	a_437_503##2	a_27_74##3	1.5423e-19
C164	VGND#12	a_1226_296##11	2.88793e-19
C165	a_1226_296##7	a_1226_296##6	1.86167e-17
C166	a_206_368##11	D#1	2.83833e-17
C167	a_1226_296##17	a_1226_296##4	1.5646e-20
C168	a_27_74##11	D#4	2.49915e-18
C169	VPWR#2	a_1226_296##15	2.85183e-19
C170	Q#1	a_1226_296##13	5.65279e-17
C171	VPWR#15	a_27_74##3	1.96858e-18
C172	a_27_74##9	a_1034_424##6	3.81851e-17
C173	a_206_368##9	a_27_74##4	5.59799e-19
C174	a_1226_296##17	Q#4	7.71803e-18
C175	VPWR#16	D#1	5.79761e-19
C176	VPWR#5	VPWR#4	7.44738e-19
C177	Q#3	a_1226_296##14	5.36111e-19
C178	a_27_74##13	a_27_74##12	3.21098e-18
C179	a_1226_296##17	a_1226_296##5	7.49148e-20
C180	VPWR#5	a_1034_424##5	8.3602e-19
C181	VGND#11	a_1226_296##9	2.41036e-19
C182	a_1226_296##21	VPWR#12	6.80936e-17
C183	a_27_74##9	a_696_458##5	3.56914e-17
C184	a_1226_296##14	a_1226_296##6	1.71475e-18
C185	VGND#11	VGND#1	1.40592e-18
C186	a_206_368##11	a_27_74##3	6.36471e-17
C187	VGND#2	Q#2	1.62799e-17
C188	a_27_74##12	CLK#3	1.38662e-17
C189	a_206_368##13	D#4	3.81124e-18
C190	VGND#12	a_1226_296##13	1.41173e-18
C191	VGND#14	a_27_74##9	4.90718e-19
C192	a_27_74##12	D#2	3.80705e-18
C193	VPWR#15	CLK#1	4.87695e-19
C194	a_27_74##3	VPWR#16	2.16623e-17
C195	a_27_74##4	a_696_458##6	4.68203e-18
C196	VPWR#4	a_1034_424##5	7.5956e-18
C197	a_1226_296##9	Q#1	3.19615e-17
C198	a_1226_296##12	a_1226_296##4	4.70054e-17
C199	a_544_485##6	a_27_74##4	9.86812e-17
C200	a_206_368##11	CLK#1	3.22839e-18
C201	a_1226_296##7	VPWR#11	2.80148e-18
C202	VPWR#13	VPWR#12	9.95907e-19
C203	a_27_74##16	a_27_74##3	7.5405e-18
C204	VPWR#6	VPWR#14	6.87018e-18
C205	VPWR#2	a_1034_424##5	7.90815e-20
C206	a_1226_296##20	a_1226_296##13	1.81066e-19
C207	a_1226_296##17	VPWR#12	1.6566e-17
C208	VGND#11	a_1034_424#	1.0539e-19
C209	a_206_368##13	a_206_368##14	1.51404e-18
C210	a_1034_424##2	a_1226_296##8	1.41248e-17
C211	a_1226_296##7	Q#4	4.91252e-17
C212	CLK#1	VPWR#16	2.97094e-17
C213	a_206_368##13	a_27_74#	1.05251e-18
C214	a_1226_296##9	VGND#12	1.57379e-17
C215	VPWR#5	a_1034_424##4	5.79717e-18
C216	a_1226_296##7	VPWR#12	3.27674e-18
C217	VGND#4	Q#1	3.14834e-18
C218	a_27_74##16	CLK#1	6.1354e-17
C219	a_27_74##12	a_206_368##2	5.1541e-17
C220	VPWR#13	a_1226_296##21	4.86955e-17
C221	a_206_368##4	a_1034_424##6	2.27709e-17
C222	Q#1	a_1034_424#	3.0248e-18
C223	a_1226_296##14	a_1226_296##12	4.78909e-17
C224	VGND#6	a_27_74##7	1.75104e-19
C225	a_544_485##6	a_206_368#	9.02484e-19
C226	a_27_74##11	a_206_368##2	9.65261e-19
C227	VPWR#4	a_1034_424##4	2.93367e-19
C228	VGND#5	VGND#12	1.67281e-18
C229	a_696_458##5	a_206_368##4	2.88606e-17
C230	a_1226_296##20	a_1226_296##9	4.1441e-19
C231	a_1034_424##2	a_1034_424##3	4.15782e-18
C232	a_27_74##12	a_206_368##13	5.37671e-17
C233	VGND#5	a_27_74##7	3.53703e-20
C234	a_1034_424##7	a_206_368##9	1.6846e-18
C235	VGND#12	a_1034_424#	3.19925e-17
C236	VPWR#4	VPWR#2	6.99578e-19
C237	a_206_368##13	a_206_368##2	2.77589e-17
C238	a_1226_296##18	a_1226_296##15	2.62204e-19
C239	Q#1	a_1226_296#	6.78987e-20
C240	VPWR#5	a_1226_296##3	7.48601e-18
C241	a_1226_296##18	VPWR#13	1.21322e-18
C242	a_1226_296##15	a_1226_296##14	4.70289e-17
C243	a_27_74##12	a_27_74##2	2.4089e-17
C244	a_206_368#	a_696_458##3	9.96889e-19
C245	a_544_485##6	D#2	1.18161e-18
C246	a_1226_296##20	a_1034_424#	2.75778e-17
C247	a_1034_424##3	a_1226_296##15	1.0904e-18
C248	Q#1	VGND#11	4.52137e-17
C249	a_1226_296##2	a_1226_296##8	1.61555e-19
C250	a_1226_296##17	a_1226_296##15	1.35927e-19
C251	VPWR#4	a_1226_296##3	8.24612e-20
C252	a_1034_424##8	a_1226_296##21	5.71929e-19
C253	VGND#5	a_1226_296##20	1.03923e-17
C254	a_1226_296##21	a_1226_296##2	9.78472e-19
C255	VPWR#6	a_206_368##6	6.38046e-20
C256	VGND#13	a_1034_424#	9.91409e-19
C257	a_206_368##11	VPWR#7	4.29302e-17
C258	a_206_368##13	a_27_74##2	6.59562e-18
C259	a_1226_296##2	VPWR#13	1.27741e-17
C260	a_1034_424##5	a_1226_296##15	3.35027e-17
C261	VGND#12	VGND#2	2.54376e-19
C262	a_1226_296##18	a_1034_424##5	3.2922e-18
C263	a_1226_296##20	a_1226_296#	2.04825e-18
C264	a_544_485##8	a_544_485##6	1.95856e-18
C265	VGND#3	a_1226_296##10	4.5953e-18
C266	CLK#2	a_27_74##12	3.2092e-17
C267	a_544_485##6	a_206_368##2	7.41383e-21
C268	a_1226_296##2	a_1034_424##3	2.11414e-17
C269	VPWR#5	a_206_368##6	5.33826e-18
C270	VGND#12	VGND#11	1.51135e-18
C271	VGND#4	a_1226_296##20	9.0993e-18
C272	a_1034_424##8	a_1226_296##2	6.18708e-19
C273	a_1226_296##17	a_1034_424##5	4.44431e-19
C274	a_1226_296#	VGND#13	2.10324e-17
C275	VGND#3	a_1226_296##13	5.5988e-18
C276	a_1034_424##4	a_1034_424##5	3.60686e-17
C277	a_206_368##13	CLK#2	2.76008e-19
C278	D#3	a_206_368##3	5.32144e-18
C279	a_1034_424##6	a_1034_424#	2.83915e-19
C280	a_1226_296##20	a_27_74##8	2.19255e-19
C281	VPWR#6	a_27_74##7	4.81693e-18
C282	a_206_368##7	a_1226_296##21	1.10667e-17
C283	a_437_503#	a_544_485##6	8.21185e-18
C284	VGND#3	a_1226_296##9	5.67956e-19
C285	VGND#12	Q#1	3.41929e-17
C286	a_1034_424##8	a_1226_296##18	4.11965e-19
C287	a_206_368##7	VPWR#13	2.80742e-17
C288	VPWR#5	a_27_74##7	2.07284e-19
C289	VGND#3	a_1034_424#	2.75839e-18
C290	a_544_485##8	a_27_74##4	4.9701e-17
C291	a_696_458##5	a_1034_424#	2.59639e-19
C292	VGND#13	a_27_74##8	1.92889e-18
C293	a_1226_296##3	a_1034_424##4	2.96173e-17
C294	a_437_503#	a_27_74##4	2.8894e-19
C295	a_1034_424##6	a_1226_296#	2.63444e-18
C296	a_1034_424##8	a_206_368##7	5.42226e-17
C297	VGND#5	a_1034_424##7	2.09243e-18
C298	CLK#6	a_27_74##2	2.24511e-19
C299	a_1226_296##20	Q#1	2.4458e-18
C300	VPWR#6	a_544_485##4	7.42904e-18
C301	a_27_74##13	a_27_74##16	7.74324e-19
C302	a_544_485##8	D#4	4.63075e-19
C303	a_696_458##5	a_1226_296#	4.00063e-19
C304	VGND#13	a_206_368##5	3.75532e-19
C305	a_206_368##6	a_1226_296##3	1.01587e-17
C306	a_437_503#	D#4	8.13571e-18
C307	a_206_368##4	a_1034_424##8	6.56014e-17
C308	VPWR#5	a_544_485##4	5.79471e-20
C309	a_1034_424##6	a_27_74##8	2.71674e-17
C310	VGND#15	D#4	1.78439e-18
C311	a_206_368##4	a_696_458##8	2.14977e-17
C312	a_206_368##11	VPWR#8	5.70271e-17
C313	CLK#6	CLK#2	9.21835e-18
C314	a_1226_296##20	VGND#12	3.19926e-17
C315	a_696_458##5	a_27_74##8	1.80344e-18
C316	VGND#13	a_544_485#	2.20897e-19
C317	a_27_74##7	a_206_368##6	1.66088e-17
C318	VPWR#6	a_696_458##3	1.15585e-17
C319	a_1034_424##2	a_1226_296##9	2.92505e-19
C320	a_696_458##8	a_544_485##3	6.33249e-17
C321	a_206_368##5	a_1034_424##6	9.79522e-18
C322	Q#3	VPWR#2	2.5317e-19
C323	VGND#8	a_27_74##12	3.14901e-17
C324	a_544_485##3	VPWR#14	2.25802e-18
C325	a_1034_424##2	a_1034_424#	1.05519e-18
C326	a_544_485##8	a_206_368##2	1.41207e-19
C327	a_1034_424##2	a_1226_296#	1.1464e-17
C328	VGND#5	a_1034_424##3	2.37673e-20
C329	a_696_458##5	a_206_368##5	3.33941e-17
C330	a_437_503#	a_206_368##2	4.88285e-19
C331	a_544_485##4	a_27_74##7	1.48504e-17
C332	a_1034_424##2	a_27_74##8	3.01792e-19
C333	VGND#15	a_206_368##2	1.13847e-17
C334	VGND#7	a_206_368#	2.05088e-17
C335	a_206_368##9	a_651_503#	1.6197e-18
C336	VPWR#7	D#3	2.54283e-20
C337	a_206_368##2	a_206_368##14	7.55154e-18
C338	VPWR#6	a_27_74##6	1.02435e-18
C339	a_1226_296##18	a_27_74##7	7.49462e-20
C340	VGND#13	a_1226_296##20	4.01647e-17
C341	VGND#7	a_27_74##5	8.06442e-19
C342	VGND#2	a_1226_296##10	2.48482e-18
C343	VGND#6	a_696_458##2	2.78218e-20
C344	VPWR#3	a_1226_296##4	5.22106e-18
C345	a_1226_296##18	VPWR#5	1.20376e-19
C346	VGND#8	a_27_74##11	2.29625e-17
C347	a_27_74##8	a_1226_296##2	3.824e-17
C348	a_27_74##9	a_1034_424#	1.81624e-18
C349	a_544_485#	a_696_458##5	1.1087e-17
C350	a_696_458##3	a_544_485##4	1.41041e-17
C351	a_544_485##7	a_696_458##8	1.24247e-18
C352	VPWR#3	a_1226_296##12	8.38093e-19
C353	VPWR#11	a_1226_296##6	3.35931e-19
C354	VGND#2	a_1226_296##6	4.54969e-20
C355	a_27_74##9	a_1226_296#	1.31043e-17
C356	VGND#1	Q#2	7.48944e-17
C357	a_27_74##9	a_27_74##8	3.89359e-19
C358	VPWR#3	a_1226_296##14	6.09997e-18
C359	a_544_485#	VGND#14	9.86662e-18
C360	VPWR#8	a_206_368##3	1.93919e-20
C361	a_27_74##2	VGND#16	1.21159e-18
C362	a_27_74##9	a_206_368##5	2.51629e-17
C363	a_27_74##6	a_696_458##3	3.6889e-17
C364	a_696_458##5	a_696_458#	4.34597e-19
C365	a_437_503##2	a_27_74##4	1.12511e-18
C366	VPWR#3	a_1226_296##15	2.54668e-18
C367	a_27_74##11	a_696_458##6	2.47679e-17
C368	VGND#6	a_27_74##11	3.03261e-17
C369	a_27_74##9	a_544_485#	1.27681e-17
C370	a_1226_296##18	VPWR#4	1.84105e-19
C371	VGND#2	a_1226_296##11	7.68453e-18
C372	a_27_74##8	a_206_368##7	1.95322e-17
C373	VPWR#3	a_1034_424##5	7.36105e-19
C374	Q#4	a_1226_296##8	3.8762e-19
C375	a_27_74##9	a_696_458#	1.26094e-19
C376	a_1034_424##7	a_27_74##7	3.59717e-18
C377	a_696_458#	VGND#14	1.59941e-17
C378	Q#2	Q#5	4.68449e-19
C379	VGND#2	a_1226_296##5	4.78451e-20
C380	a_437_503##2	D#4	1.70491e-19
C381	VPWR#3	a_1034_424##4	7.97311e-20
C382	a_206_368##3	a_27_74##6	2.18978e-17
C383	a_206_368#	a_27_74##9	1.40495e-19
C384	CLK#2	a_27_74##13	4.34745e-17
C385	VGND#3	a_1034_424##5	3.62162e-19
C386	a_206_368##4	a_27_74##8	2.95091e-17
C387	a_696_458##5	a_206_368#	4.23769e-20
C388	a_1226_296##5	Q#5	1.79197e-19
C389	VPWR#8	D#1	3.97716e-18
C390	D#1	a_27_74##6	4.49252e-19
C391	a_544_485#	a_206_368##4	9.90827e-18
C392	D#2	a_437_503##2	4.4063e-17
C393	a_544_485##3	a_27_74##8	8.61688e-19
C394	VGND#14	a_206_368#	3.56503e-18
C395	a_1226_296##17	VPWR#4	5.81576e-20
C396	VGND#2	a_1226_296##13	2.20772e-18
C397	D#1	a_206_368##3	1.72602e-17
C398	a_1034_424##6	VGND#13	9.13355e-18
C399	D#2	VPWR#15	3.52069e-18
C400	a_544_485##8	a_696_458#	9.14085e-19
C401	a_206_368##11	D#2	7.21676e-17
C402	Q#2	VGND#11	4.45088e-17
C403	VGND#11	a_1226_296##6	1.02947e-18
C404	a_27_74##3	a_206_368##3	2.66829e-19
C405	a_437_503##2	a_544_485##7	2.383e-17
C406	a_437_503##2	a_206_368##2	4.05088e-18
C407	VGND#4	a_1226_296##9	4.64996e-18
C408	a_696_458##2	a_544_485##3	5.14216e-17
C409	VPWR#15	a_206_368##2	7.90372e-19
C410	a_27_74##3	D#1	2.78448e-18
C411	a_206_368##11	a_206_368##2	8.73309e-18
C412	a_696_458##5	VGND#13	2.64209e-18
C413	a_544_485##8	a_206_368#	3.00569e-17
C414	Q#2	Q#3	3.80754e-18
C415	a_1034_424##2	a_1034_424##5	5.19589e-18
C416	Q#4	a_1034_424##3	1.11776e-20
C417	VGND#2	a_1226_296##9	3.87649e-19
C418	Q#1	a_1226_296##8	9.41491e-19
C419	VGND#5	a_1034_424#	1.9474e-18
C420	a_696_458##4	a_206_368#	3.272e-19
C421	CLK#1	a_27_74##3	4.86488e-17
C422	Q#1	Q#2	3.13082e-18
C423	a_437_503#	a_206_368#	2.95556e-18
C424	a_206_368##11	a_27_74##2	7.85811e-19
C425	VPWR#7	a_696_458##3	3.97948e-18
C426	a_27_74##11	a_735_102#	6.57849e-18
C427	a_544_485##8	a_27_74##5	2.87109e-17
C428	a_1226_296##2	a_1034_424##4	3.68879e-18
C429	a_206_368##11	a_544_485##7	3.72e-17
C430	a_206_368#	a_27_74##4	4.10939e-18
C431	VPWR#7	a_27_74##6	3.97631e-18
C432	VGND#4	a_1034_424#	2.50066e-18
C433	VGND#15	a_206_368#	3.79514e-18
C434	a_206_368##9	a_206_368##6	4.46323e-18
C435	a_206_368##11	CLK#2	1.93404e-19
C436	VPWR#7	a_206_368##3	3.24379e-18
C437	a_27_74##5	a_437_503#	1.26521e-17
C438	a_206_368##11	a_437_503##2	5.11985e-17
C439	a_206_368#	D#4	1.18207e-18
C440	a_696_458##4	a_696_458##2	2.22191e-17
C441	VGND#2	a_1034_424#	1.22331e-19
C442	CLK#2	a_27_74##16	4.07047e-18
C443	a_544_485##8	D#3	1.16937e-18
C444	a_27_74##7	a_1226_296##2	1.26281e-18
C445	VGND#5	a_1226_296#	3.59565e-18
C446	a_696_458##5	a_1034_424##6	2.17866e-17
C447	D#4	a_27_74##5	3.80371e-19
C448	a_206_368##7	a_1034_424##4	1.04896e-18
C449	a_27_74##11	a_696_458##3	2.71853e-19
C450	a_206_368##7	a_1226_296##3	3.06221e-17
C451	a_27_74##9	a_27_74##7	1.16208e-18
C452	CLK#6	a_27_74##12	1.93947e-17
C453	a_206_368##11	VPWR#15	5.80804e-17
C454	a_206_368##9	a_27_74##7	3.73879e-17
C455	a_437_503#	D#3	2.82963e-17
C456	a_206_368##7	a_206_368##6	1.73848e-17
C457	a_206_368##14	a_27_74##5	8.47978e-20
C458	a_27_74##7	a_206_368##7	2.4255e-17
C459	a_206_368##2	a_206_368#	1.94442e-19
C460	D#3	VGND#15	9.70899e-18
C461	VPWR#16	VPWR#15	1.79986e-18
C462	a_206_368##4	a_27_74##7	5.26192e-17
C463	a_206_368##9	a_1034_424##8	6.82711e-17
C464	a_206_368##2	D#3	4.5757e-18
C465	VGND#5	a_27_74##8	4.89312e-21
C466	a_437_503#	a_27_74#	3.49319e-19
C467	VGND#3	VGND#5	1.69731e-17
C468	a_27_74#	a_206_368##2	2.44927e-17
C469	a_206_368##4	a_544_485##4	2.22537e-19
C470	a_206_368##9	a_544_485##4	3.45016e-17
C471	a_206_368##14	D#3	2.69263e-19
C472	a_1226_296##17	Q#1	1.46758e-17
C473	VGND#1	VPWR#1	9.30091e-18
C474	a_544_485##3	a_27_74##7	2.19228e-17
C475	Q#2	a_1226_296##10	2.4844e-17
C476	a_27_74##4	a_696_458##2	4.16158e-17
C477	a_696_458##6	a_27_74##7	1.75055e-18
C478	VGND#3	VGND#4	5.51817e-17
C479	VPWR#16	a_206_368##11	5.37178e-17
C480	VGND#15	a_27_74#	4.33074e-19
C481	VPWR#3	a_1226_296##7	7.0926e-18
C482	a_1226_296##17	Q#3	3.72289e-19
C483	a_544_485##3	a_544_485##4	1.47672e-17
C484	VGND#6	a_206_368##5	3.18921e-18
C485	a_696_458##6	a_206_368##9	2.97527e-19
C486	VGND#3	VGND#2	5.63e-17
C487	a_544_485##3	a_696_458##3	2.4234e-17
C488	VGND#3	a_1226_296##7	7.45322e-18
C489	CLK#3	a_27_74##2	8.24933e-19
C490	VPWR#3	a_1034_424##2	2.77884e-18
C491	a_1226_296##21	a_1034_424##3	7.84022e-18
C492	a_206_368##9	a_696_458##8	1.00689e-16
C493	a_27_74#	a_206_368##14	1.57306e-17
C494	a_27_74##11	a_206_368##3	9.38062e-20
C495	a_27_74##16	a_206_368##11	2.68268e-17
C496	a_27_74##11	a_437_503##2	2.76472e-18
C497	VPWR#3	VPWR#5	1.77711e-17
C498	VGND#3	a_1034_424##2	8.26343e-18
C499	a_206_368##9	a_696_458##3	3.6454e-17
C500	a_544_485##3	a_206_368##3	1.62747e-19
C501	VGND#15	CLK#3	7.51858e-20
C502	a_27_74##11	a_696_458##2	1.46991e-17
C503	a_1226_296##17	VGND#12	1.38963e-17
C504	a_27_74##4	a_544_485##4	1.76937e-19
C505	VPWR#3	VPWR#4	6.35589e-17
C506	Q#2	a_1226_296##11	3.74035e-17
C507	a_27_74#	VGND#16	2.33353e-17
C508	a_27_74##4	a_696_458##3	3.33831e-17
C509	a_1226_296##20	a_1226_296##18	3.35972e-18
C510	a_1226_296##17	Q#2	3.31659e-19
C511	a_27_74##16	VPWR#16	7.28878e-17
C512	a_544_485##6	a_206_368##9	4.07874e-17
C513	VPWR#3	VPWR#2	5.30532e-17
C514	a_544_485##6	a_544_485##4	9.60149e-20
C515	VGND#6	a_544_485#	4.29092e-18
C516	a_206_368##9	VPWR#14	4.46858e-18
C517	a_27_74##13	a_27_74#	6.63358e-19
C518	a_206_368##3	a_27_74##4	2.17887e-17
C519	a_1226_296##20	a_1034_424##5	6.52152e-19
C520	a_1226_296##17	a_1226_296##10	6.32633e-21
C521	a_206_368##9	a_27_74##6	1.26897e-17
C522	CLK#3	VGND#16	1.43333e-17
C523	D#4	a_206_368##3	3.37059e-18
C524	a_1226_296##20	a_1226_296##17	6.01359e-19
C525	VGND#5	a_544_485#	2.98027e-19
C526	a_1226_296#	a_1178_124#	1.15914e-17
C527	a_1034_424##2	a_1226_296##2	5.03659e-17
C528	a_27_74##12	a_206_368##11	2.52206e-17
C529	Q#2	a_1226_296##13	1.46812e-18
C530	a_27_74##8	a_1178_124#	1.15914e-17
C531	D#2	a_206_368##3	1.71802e-17
C532	Q#3	VPWR#3	1.48271e-18
C533	a_544_485##6	a_696_458##3	8.27086e-18
C534	a_27_74##13	CLK#3	3.50175e-17
C535	a_27_74##12	a_27_74##3	2.89857e-18
C536	a_696_458##6	a_696_458##8	7.64541e-19
C537	a_27_74##3	D#2	5.11783e-18
C538	VGND#6	a_696_458#	1.51636e-18
C539	a_206_368##9	a_206_368##3	1.08706e-18
C540	a_1226_296##17	a_1226_296##11	1.02877e-20
C541	VGND#5	VGND#4	1.07681e-18
C542	a_206_368##7	a_1226_296##2	1.5843e-17
C543	a_27_74##3	a_206_368##2	2.35061e-18
C544	VPWR#7	a_27_74##4	5.90906e-20
C545	a_27_74##9	a_206_368##7	5.39077e-19
C546	a_206_368##4	a_1226_296##2	7.92882e-20
C547	a_27_74##12	VPWR#16	4.45838e-18
C548	VPWR#3	a_1226_296##18	1.02168e-18
C549	a_544_485##6	a_27_74##6	8.46268e-18
C550	Q#2	a_1226_296##9	1.1055e-20
C551	a_206_368##6	a_1141_508#	1.13814e-17
C552	VGND#7	a_27_74##4	3.06152e-19
C553	a_27_74##12	CLK#1	3.80988e-18
C554	a_27_74##9	a_206_368##4	4.45667e-18
C555	VGND#3	Q#3	2.43143e-18
C556	VGND#8	a_206_368#	9.55345e-18
C557	a_544_485##7	a_206_368##9	1.70378e-17
C558	VPWR#3	a_1226_296##17	1.05142e-18
C559	a_27_74##12	D	2.40856e-17
C560	a_1226_296##11	a_1226_296##10	3.84505e-17
C561	a_206_368##4	a_206_368##7	2.8175e-19
C562	a_27_74##11	D	2.73055e-18
C563	VGND#4	a_1226_296##7	4.55813e-19
C564	CLK#2	a_27_74##3	1.86491e-18
C565	VGND#3	Q#2	2.20529e-17
C566	a_206_368##9	D#1	2.914e-19
C567	a_206_368##13	D	3.94592e-17
C568	a_1226_296##17	a_1226_296##13	9.69638e-19
C569	VGND	a_696_458##2	3.84748e-19
C570	VGND#6	a_206_368#	5.11182e-19
C571	Q	VPWR#2	1.67706e-17
C572	a_544_485##3	a_206_368##4	1.71196e-17
C573	a_696_458##3	a_651_503#	4.3587e-18
C574	a_696_458##2	a_544_485#	1.81661e-17
C575	a_696_458#	a_735_102#	1.64846e-18
C576	a_544_485##6	a_206_368##3	1.26857e-17
C577	a_27_74##12	a_27_74##16	1.36185e-18
C578	VPWR#1	a_1226_296##4	3.28401e-17
C579	a_206_368#	a_735_102#	3.36712e-18
C580	a_27_74##6	a_651_503#	7.47884e-18
C581	VGND#3	a_1226_296##18	3.49081e-18
C582	a_1034_424##7	a_1226_296##20	1.69533e-18
C583	a_696_458##4	a_544_485##3	2.64356e-17
C584	a_206_368##13	a_206_368##11	5.8334e-18
C585	VGND#5	a_1034_424##2	1.67934e-18
C586	VGND#3	a_1226_296##17	2.48934e-18
C587	Q#6	a_1226_296##4	3.64834e-17
C588	a_437_503#	a_544_485##8	9.05058e-17
C589	a_1226_296##13	a_1226_296##11	3.61057e-17
C590	a_27_74##4	a_544_485##3	6.35753e-17
C591	VGND#4	a_1034_424##2	1.10083e-19
C592	VPWR	VPWR#8	6.73417e-17
C593	a_1226_296##17	a_1226_296##9	4.46582e-18
C594	VPWR#5	a_1034_424##3	5.82807e-20
C595	VPWR#1	a_1226_296##12	1.23306e-18
C596	VPWR	VPWR#6	1.0178e-16
C597	VPWR	VPWR#5	1.05317e-16
C598	a_544_485##6	D#1	3.24678e-19
C599	VPWR#11	a_1226_296##4	6.79311e-19
C600	VGND#4	VGND#2	1.00742e-18
C601	VPWR	a_1226_296##18	5.74294e-20
C602	D	a_437_503#	4.7827e-17
C603	Q#6	a_1226_296##12	3.54e-17
C604	D#4	a_27_74##4	1.17315e-18
C605	VPWR	a_1034_424##7	3.51559e-18
C606	a_1226_296##8	VNB	2.25846e-17
C607	a_1226_296##6	VNB	2.78264e-17
C608	VPWR#6	a_696_458##2	4.52722e-19
C609	a_1226_296##5	VNB	3.95314e-17
C610	a_1034_424##3	VNB	1.99918e-17
C611	a_1226_296##7	VPWR#4	3.25952e-19
C612	VPWR	a_27_74##12	2.68044e-18
C613	a_696_458##2	VNB	6.64151e-17
C614	VPWR#1	a_1226_296##14	2.59902e-19
C615	a_1034_424##8	a_1034_424##3	3.22251e-19
C616	VPWR	a_206_368##13	3.3633e-18
C617	VGND#5	a_1226_296##2	1.26498e-19
C618	a_1226_296##12	VPWR#11	2.42018e-17
C619	a_206_368##2	a_27_74##4	4.49163e-19
C620	VGND	VGND#8	7.9413e-17
C621	VGND#8	D#3	7.74234e-19
C622	a_1226_296##9	a_1226_296##13	3.21699e-17
C623	VGND	VGND#6	8.45789e-17
C624	VPWR	a_206_368##9	6.4899e-17
C625	VGND	VGND#5	9.60477e-17
C626	a_544_485##6	a_544_485##7	3.90118e-19
C627	a_1226_296##17	a_1034_424#	5.70521e-18
C628	a_206_368##2	D#4	5.76136e-17
C629	VPWR	a_544_485##6	3.45177e-18
C630	a_206_368##7	a_1141_508#	3.10474e-18
C631	Q#6	a_1226_296##14	8.13432e-19
C632	VPWR#2	a_1226_296##6	3.99596e-20
C633	a_1034_424##6	a_27_74##7	1.02944e-18
C634	a_206_368##2	D#2	3.58608e-17
C635	VPWR	CLK#6	3.43457e-18
C636	Q#4	a_1226_296##12	2.01797e-18
C637	a_437_503##2	a_206_368#	5.08953e-19
C638	Q	VPWR#1	2.50357e-17
C639	a_206_368##11	a_206_368##9	1.57937e-18
C640	D	a_437_503##2	1.42222e-17
C641	VGND	a_1226_296##18	1.66591e-19
C642	Q	Q#6	2.43574e-19
C643	VPWR#11	Q	2.46303e-17
C644	a_206_368##11	D	7.81062e-18
C645	VGND	a_1034_424##7	7.50836e-18
C646	a_1226_296##14	VPWR#11	2.88136e-17
C647	a_696_458##5	a_27_74##7	7.05185e-19
C648	a_27_74##2	a_206_368##2	2.38042e-17
C649	VGND	a_27_74##12	4.1945e-17
C650	VPWR#4	a_1034_424##3	4.0932e-20
C651	VGND	a_27_74##11	6.21519e-17
C652	a_1226_296##7	Q#3	4.66003e-17
C653	VPWR#12	a_1226_296##12	1.72497e-19
C654	VGND#6	a_27_74##9	4.35838e-17
C655	VPWR#4	a_1034_424##2	3.89452e-19
C656	VGND	a_206_368##13	1.89811e-18
C657	VPWR	a_544_485##8	2.65757e-18
C658	a_437_503##2	a_544_485##6	4.98713e-17
C659	CLK#2	a_27_74##2	3.83258e-17
C660	VGND	a_696_458##6	3.86349e-18
C661	Q#4	a_1226_296##14	7.44337e-17
C662	VGND#5	a_27_74##9	6.59326e-17
C663	Q#2	a_1226_296##7	3.6826e-17
C664	a_1034_424#	a_1226_296##9	3.4526e-17
C665	a_206_368##14	a_437_503#	2.8193e-18
C666	a_1226_296##17	a_1226_296#	6.26549e-20
C667	VGND#8	VNB	3.62111e-17
C668	VGND#6	VNB	4.86947e-17
C669	a_544_485##7	D#3	2.62416e-19
C670	VGND#5	VNB	5.48474e-17
C671	VGND#4	VNB	2.72551e-17
C672	VGND#2	VNB	2.52733e-17
C673	D	a_206_368#	2.66332e-19
C674	VGND#4	a_27_74##9	6.38099e-20
C675	VPWR#8	VNB	3.9495e-17
C676	VPWR#2	a_1226_296##5	4.82475e-20
C677	VPWR#11	a_1226_296##15	3.44144e-19
C678	VPWR#6	VNB	4.93414e-17
C679	VPWR#5	VNB	5.60073e-17
C680	D	a_27_74##5	4.67558e-20
C681	VPWR#4	VNB	2.43972e-17
C682	VPWR#2	VNB	2.26894e-17
C683	CLK#6	a_27_74##3	3.84876e-19
C684	D	a_27_74#	3.69998e-19
C685	VPWR#12	a_1226_296##14	3.71489e-19
C686	Q#3	VNB	8.85739e-18
C687	VPWR	a_1034_424##8	6.74298e-18
C688	Q#2	VNB	1.05369e-17
C689	VPWR	a_696_458##8	7.41671e-18
C690	a_1226_296##18	VNB	3.30103e-18
C691	VGND	a_1034_424##6	9.66171e-18
C692	a_1226_296##17	VNB	4.75617e-18
C693	VGND	a_696_458##5	7.95485e-18
C694	a_206_368#	a_696_458##2	9.54989e-18
C695	VGND	VGND#14	1.46954e-17
C696	VPWR	a_544_485##7	8.58325e-18
C697	a_1034_424##7	VNB	1.12801e-17
C698	a_1226_296##2	VPWR#5	6.68646e-19
C699	VGND	a_544_485##8	1.28818e-17
C700	VPWR	a_437_503##2	8.64524e-18
C701	a_1034_424##7	a_1034_424#	3.21154e-20
C702	VGND	a_437_503#	9.6477e-18
C703	a_27_74##12	VNB	1.79005e-17
C704	VPWR	VPWR#15	9.5654e-18
C705	a_1034_424##7	a_1034_424##6	2.30579e-18
C706	Q#4	a_1226_296##15	5.57205e-17
C707	a_27_74##11	VNB	2.69482e-17
C708	VGND	VGND#15	1.67249e-17
C709	VPWR	a_206_368##11	6.14722e-17
C710	VGND	a_206_368##14	7.41413e-18
C711	a_206_368##13	VNB	4.50412e-18
C712	VGND	a_27_74##13	1.72357e-17
C713	VPWR	a_27_74##16	2.00979e-17
C714	Q#3	a_1034_424##2	2.44325e-20
C715	a_1226_296##17	a_1226_296##7	1.64415e-19
C716	a_206_368##9	VNB	1.10467e-17
C717	a_696_458##6	VNB	4.27945e-18
C718	a_544_485##6	VNB	1.40445e-17
C719	VPWR#11	a_1034_424##5	1.55776e-19
C720	CLK#6	VNB	1.16636e-17
C721	Q	a_1226_296##4	1.2015e-17
C722	VPWR	a_27_74##8	2.62453e-20
C723	VGND	a_1034_424##8	1.48588e-18
C724	Q	a_1226_296##12	1.16063e-17
C725	Q#2	a_1034_424##2	5.78723e-20
C726	a_1226_296#	a_1034_424#	3.99568e-18
C727	VGND#1	VNB	6.91367e-17
C728	a_1226_296##15	VPWR#12	2.26352e-17
C729	Q	a_1226_296##14	6.65195e-19
C730	VGND#11	VNB	2.20912e-18
C731	Q#1	VNB	2.82263e-18
C732	VGND#12	VNB	7.67548e-19
C733	a_1226_296##20	VNB	9.41453e-18
C734	VGND#13	VNB	9.35511e-18
C735	CLK#6	CLK#1	3.73134e-18
C736	VGND	a_206_368##11	1.79284e-18
C737	VPWR	D#3	8.89278e-20
C738	a_696_458##5	VNB	6.4426e-19
C739	VGND#14	VNB	2.53135e-18
C740	D	a_27_74##3	4.50298e-19
C741	Q#4	a_1034_424##5	2.33976e-18
C742	a_544_485##8	VNB	4.76491e-18
C743	a_437_503#	VNB	6.74312e-18
C744	VGND#15	VNB	2.86583e-18
C745	VGND#16	VNB	1.46558e-18
C746	a_27_74##13	VNB	3.99063e-17
C747	a_1226_296##21	a_1226_296##15	1.64428e-18
C748	VPWR#1	VNB	8.01525e-17
C749	a_206_368##11	D#3	5.73679e-20
C750	VGND	a_1226_296#	8.03386e-18
C751	VPWR#11	VNB	2.92383e-18
C752	Q#4	VNB	2.49226e-18
C753	a_1226_296##18	a_1034_424##2	4.72671e-17
C754	VPWR#12	VNB	3.6172e-18
C755	a_1226_296##21	VNB	2.62295e-18
C756	VGND	a_544_485#	5.28171e-18
C757	a_1034_424##7	a_1226_296#	1.01727e-17
C758	VPWR#13	VNB	1.03176e-18
C759	VGND	a_696_458#	6.70776e-18
C760	a_696_458##5	a_1034_424##7	3.46141e-18
C761	VPWR	a_1226_296##3	5.23931e-19
C762	VGND	a_206_368#	1.82222e-17
C763	a_1034_424##8	VNB	3.46442e-18
C764	a_206_368##9	VPWR#6	1.31859e-16
C765	VGND#7	a_27_74##11	6.55887e-17
C766	a_696_458##8	VNB	1.72893e-18
C767	VPWR	a_206_368##6	1.00028e-18
C768	a_544_485##6	a_206_368##11	1.01545e-18
C769	VGND	D#3	9.63564e-19
C770	a_1034_424##5	VPWR#12	2.56087e-17
C771	VPWR	a_27_74##7	6.55392e-18
C772	VGND	a_27_74#	3.18737e-18
C773	a_544_485##7	VNB	1.53422e-20
C774	VPWR	a_544_485##4	1.42476e-18
C775	a_437_503##2	VNB	6.52753e-18
C776	VGND	CLK#3	1.3756e-18
C777	VPWR#3	Q	2.05824e-17
C778	VPWR	a_696_458##3	8.60906e-18
C779	a_1226_296##17	a_1034_424##2	4.89502e-17
C780	a_206_368##11	VNB	2.80946e-17
C781	VPWR	a_27_74##6	6.12717e-20
C782	VPWR#16	VNB	3.10958e-18
C783	VPWR#13	a_1226_296##15	8.90968e-20
C784	a_27_74##16	VNB	4.83579e-17
C785	VPWR	a_206_368##3	2.39343e-18
C786	a_1226_296##10	VNB	3.3842e-17
C787	a_1226_296##11	VNB	2.97614e-17
C788	a_1226_296##13	VNB	3.14591e-17
C789	VPWR	a_27_74##3	3.48752e-18
C790	a_1226_296##9	VNB	2.79497e-17
C791	a_1034_424#	VNB	2.85594e-17
C792	VPWR	CLK#1	1.7165e-18
C793	a_1226_296#	VNB	3.11053e-17
C794	a_27_74##8	VNB	4.16697e-17
C795	VGND#6	a_206_368##4	7.09846e-21
C796	a_206_368##5	VNB	2.75536e-17
C797	a_27_74##8	a_1226_296#	2.63826e-17
C798	a_544_485#	VNB	4.14913e-17
C799	a_696_458#	VNB	2.24409e-17
C800	a_1226_296##21	a_1034_424##5	5.22593e-17
C801	a_206_368#	VNB	1.19002e-16
C802	a_27_74##5	a_696_458##2	7.26241e-18
C803	D	a_27_74##4	2.2752e-19
C804	a_27_74##5	VNB	3.37332e-17
C805	VGND	a_696_458##3	6.00315e-19
C806	VPWR	VPWR#7	5.35049e-17
C807	D#3	VNB	2.89565e-17
C808	a_544_485##8	a_696_458##3	3.1607e-19
C809	D	D#4	1.83492e-17
C810	a_27_74#	VNB	3.18466e-17
C811	VGND	a_206_368##3	8.15117e-19
C812	CLK#3	VNB	3.49587e-17
C813	a_1226_296##4	VNB	4.25284e-17
C814	VPWR	a_1034_424##2	7.07363e-19
C815	VGND#5	a_206_368##4	1.55456e-19
C816	a_1226_296##12	VNB	3.17886e-17
C817	D	a_206_368##2	3.51684e-17
C818	VPWR	a_1226_296##2	4.67912e-18
C819	a_1226_296##14	VNB	3.65464e-17
C820	a_1226_296##15	VNB	3.56384e-17
C821	D	a_27_74##2	2.32913e-19
C822	a_1034_424##5	VNB	4.28022e-17
C823	VPWR#12	a_1034_424##4	3.60384e-19
C824	a_1034_424##4	VNB	2.56188e-17
C825	VPWR	a_206_368##7	1.73198e-17
C826	a_206_368##9	VPWR#7	2.09766e-17
C827	a_1226_296##3	VNB	3.7152e-17
C828	VPWR	a_206_368##4	3.68789e-18
C829	a_206_368##6	VNB	2.21116e-17
C830	a_27_74##7	VNB	6.64141e-17
C831	VGND	VGND#7	5.62438e-17
C832	VPWR	a_544_485##3	7.72268e-18
C833	a_544_485##4	VNB	3.23815e-17
C834	a_696_458##3	VNB	5.44527e-17
C835	VPWR#13	a_1034_424##5	1.97227e-19
C836	a_27_74##6	VNB	2.71793e-17
C837	VGND	a_1034_424##2	1.41715e-18
C838	VPWR	a_27_74##4	6.46531e-18
C839	a_206_368##3	VNB	7.95862e-17
C840	VGND	a_1226_296##2	2.97851e-18
C841	D#1	VNB	2.73487e-17
C842	a_1226_296##18	a_1226_296##2	3.51809e-19
C843	a_1034_424##7	a_1034_424##2	2.63251e-18
C844	VGND	a_27_74##9	4.17434e-17
C845	a_206_368##9	VPWR#5	3.02012e-17
C846	a_27_74##3	VNB	3.78142e-17
C847	a_1034_424##7	a_27_74##8	3.57438e-17
C848	CLK#1	VNB	4.51437e-17
C849	VPWR	D#2	5.96664e-18
C850	VGND	a_206_368##4	7.4497e-18
C851	VPWR	a_206_368##2	2.04712e-19
C852	VPWR#3	VNB	1.69517e-16
C853	VGND	a_544_485##3	3.88792e-18
C854	VGND#3	VNB	1.68634e-16
C855	VPWR#7	VNB	3.11178e-17
C856	VGND	a_696_458##4	4.74868e-18
C857	VGND#7	VNB	2.54291e-17
C858	VGND	a_27_74##4	3.81857e-18
C859	a_1226_296##7	VNB	4.31725e-17
C860	a_206_368##7	VPWR#5	3.0908e-17
C861	a_1226_296##21	a_1034_424##4	4.13106e-17
C862	VGND	D#4	2.26878e-18
C863	a_1034_424##2	VNB	4.89766e-17
C864	a_1226_296##2	VNB	6.14178e-17
C865	a_27_74##9	VNB	5.93129e-17
C866	a_1226_296##2	a_1226_296##17	2.99221e-18
C867	VGND	a_206_368##2	3.829e-18
C868	a_206_368##7	VNB	3.55678e-17
C869	VGND	a_27_74##2	2.43525e-19
C870	a_206_368##4	VNB	2.5988e-17
C871	a_544_485##3	VNB	5.44644e-17
C872	VGND	CLK#2	3.06142e-18
C873	a_696_458##4	VNB	3.42818e-18
C874	a_27_74##4	VNB	6.50077e-17
C875	D#4	VNB	2.86215e-17
C876	D#2	VNB	3.34616e-17
C877	a_206_368##2	VNB	1.34486e-16
C878	a_27_74##2	VNB	3.26137e-17
C879	VPWR#12	a_1226_296##3	1.6883e-19
C880	CLK#2	VNB	6.58993e-17
C881	Q#3	a_1226_296##8	1.14505e-19
C882	a_206_368##5	a_27_74##8	1.21024e-17
C883	a_1034_424##4	VPWR#13	1.57351e-17
C884	VGND#6	a_544_485##3	1.83709e-20
C885	VPWR	D	2.44389e-18
C886	VGND	D	5.44823e-18
C887	D	VNB	5.86518e-19
C888	Q	VNB	2.35971e-18
C889	a_1226_296##21	a_1226_296##3	2.27845e-18
C890	VPWR	VNB	3.09998e-16
C891	VGND	VNB	3.06716e-16
C892	VGND#9	a_27_74#	6.23348e-18
C893	VGND#9	VGND#15	1.85444e-19
C894	a_27_74##16	VPWR#9	2.11169e-17
C895	VPWR#9	a_27_74##3	6.64401e-18
C896	VPWR#9	CLK#1	5.58143e-18
C897	a_27_74##12	VPWR#9	2.24962e-19
C898	VPWR#9	a_27_74##2	1.32965e-19
C899	VGND#9	VNB	5.40829e-17
C900	VGND#9	a_27_74##13	2.09175e-17
C901	VGND#9	a_27_74##12	3.66719e-17
C902	VPWR#9	CLK#2	1.54809e-19
C903	VGND#9	CLK#2	1.85101e-19
C904	VPWR	VPWR#9	9.06561e-17
C905	VGND	VGND#9	9.68317e-17
C906	VGND#9	VGND#8	1.70531e-19
C907	VPWR#9	VNB	4.72598e-17
C908	VGND#9	a_27_74##2	1.07372e-19
C909	VGND#9	CLK#3	6.18493e-18
C910	VPWR#9	VPWR#15	6.64501e-19
C911	a_206_368##11	VPWR#9	1.12168e-17
C912	VGND#9	a_206_368##2	8.64303e-19
*
*
.ENDS sky130_fd_sc_hs__dfxtp_4
*
