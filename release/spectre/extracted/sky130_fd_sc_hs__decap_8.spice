* Extracted by Quantus, converted by sky130cad/quantus.py
*
*
*
*                       LINUX           Wed Nov 18 08:25:44 2026
*
*
*
*  PROGRAM  advgen
*
*  Name           : advgen - Quantus - (64-bit)
*  Version        : 25.1.0-p047
*  Build Date     : Thu Dec 11 23:20:30 PST 2025
*
*  HSPICE LIBRARY
*
*  OPERATING_TEMPERATURE 150
*  QRC_TECH_DIR <path>/tech
*
*
*

*
.SUBCKT sky130_fd_sc_hs__decap_8 VPB VNB VGND VPWR
*
*
*  caps2d version: 10
*
*
*       TRANSISTOR CARDS
*
*
XM1 VGND#9 VPWR#4 VGND#14 VNB sky130_fd_pr__nfet_01v8_lvt l=1 w=0.42 ad=0.1113 as=0.1155 pd=1.37 ps=1.39
XM2 VGND#14 VPWR#1 VGND#11 VNB sky130_fd_pr__nfet_01v8_lvt l=1 w=0.42 ad=0.1155 as=0.1197 pd=1.39 ps=1.41
XM0 VPWR#8 VGND#2 VPWR#10 VPB sky130_fd_pr__pfet_01v8 l=1 w=1 ad=0.275 as=0.275 pd=2.55 ps=2.55
XM3 VPWR#10 VGND#4 VPWR#9 VPB sky130_fd_pr__pfet_01v8 l=1 w=1 ad=0.275 as=0.285 pd=2.55 ps=2.57
*
*
*       RESISTOR AND CAP/DIODE CARDS
*
Rg1	VGND#1	VGND#2	146.904678
Rg2	VGND#3	VGND#4	146.904678
Rg3	VPWR#1	VPWR#2	113.205864
Rg4	VPWR#2	VPWR#3	90.058266
Rg5	VPWR#3	VPWR#4	113.205864
Rf2	VGND#6	VGND#7	57.394836
Rf3	VGND#7	VGND#8	22.255869
Rf4	VGND#8	VGND#10	89.362061
Rf5	VGND#6	VGND#12	10.583740
Rf6	VGND#12	VGND#3	175.093536
Rf7	VGND#8	VGND#14	36.869534
Rf8	VGND#10	VGND#1	178.384674
Rf9	VGND#9	VGND#10	15.000000
Rf10	VGND#11	VGND#12	15.000000
Rf12	VPWR#6	VPWR#7	67.254974
Rf13	VPWR#7	VPWR#8	160.556686
Rf14	VPWR#6	VPWR#9	35.924004
Rf15	VPWR#7	VPWR#11	12.505984
Rf16	VPWR#11	VPWR#12	14.994919
Rf17	VPWR#12	VPWR#3	160.232803
Rf18	VPWR#10	VPWR#11	5.000000
Rf21	VPWR#2	VPWR#12	160.232803
Re1	VPWR#7	VPWR	1.227783
Re2	VGND	VGND#7	1.227829
*
*       CAPACITOR CARDS
*
*
C1	VGND	VNB	7.51252e-17
C2	VPWR	VNB	7.17494e-17
C3	VGND#1	VNB	8.48421e-17
C4	VPWR#3	VNB	6.14814e-17
C5	VPWR#2	VNB	5.77613e-17
C6	VGND#3	VNB	8.34675e-17
C7	VGND	VGND#1	3.31065e-19
C8	VGND#7	VNB	1.78286e-16
C9	VGND	VPWR#3	1.56704e-17
C10	VPWR#7	VNB	1.68586e-16
C11	VPWR	VGND#1	7.1379e-18
C12	VGND#2	VNB	1.92109e-16
C13	VGND	VGND#3	3.59035e-19
C14	VGND#4	VNB	1.85947e-16
C15	VPWR	VPWR#3	3.5493e-19
C16	VGND	VGND#7	1.09113e-17
C17	VPWR#4	VNB	1.26866e-16
C18	VPWR	VPWR#2	6.11651e-19
C19	VPWR#1	VNB	1.18256e-16
C20	VPWR#8	VNB	7.82309e-17
C21	VPWR	VGND#3	6.88639e-18
C22	VPWR#10	VNB	5.07393e-17
C23	VGND	VGND#2	1.67211e-18
C24	VPWR#9	VNB	4.69498e-17
C25	VGND#9	VNB	6.53017e-17
C26	VGND#1	VPWR#3	8.7773e-17
C27	VGND	VGND#4	9.09391e-19
C28	VGND#14	VNB	3.49723e-20
C29	VGND	VPWR#4	1.46528e-17
C30	VGND#1	VPWR#2	7.97257e-19
C31	VGND	VPWR#1	1.27042e-17
C32	VPWR	VGND#2	2.17881e-17
C33	VGND#8	VNB	2.62745e-17
C34	VGND#1	VGND#3	3.13531e-18
C35	VGND	VPWR#8	4.33004e-18
C36	VPWR#3	VPWR#2	3.63099e-17
C37	VPWR	VGND#4	1.67297e-17
C38	VGND#7	VGND#1	1.4522e-20
C39	VGND	VPWR#9	3.82722e-18
C40	VGND	VGND#9	6.01909e-17
C41	VPWR#3	VGND#3	4.45348e-17
C42	VGND#7	VPWR#3	1.68332e-18
C43	VPWR	VPWR#8	4.18307e-17
C44	VGND#3	VPWR#2	6.54304e-17
C45	VPWR	VPWR#10	9.93326e-17
C46	VGND	VGND#8	4.50898e-17
C47	VPWR	VPWR#9	2.04881e-17
C48	VPWR#3	VGND#2	2.4486e-17
C49	VGND#1	VPWR#8	2.68522e-17
C50	VPWR#2	VGND#4	2.96305e-17
C51	VGND#1	VPWR#10	7.31687e-19
C52	VGND#7	VGND#4	2.7949e-19
C53	VGND#9	VPWR#3	9.34422e-19
C54	VGND#14	VPWR#3	2.54209e-17
C55	VPWR#9	VPWR#2	7.97607e-19
C56	VGND#9	VPWR#2	9.89037e-20
C57	VGND#7	VPWR#1	8.86792e-18
C58	VGND#3	VPWR#10	6.23361e-19
C59	VGND#14	VPWR#2	1.37257e-18
C60	VGND#3	VPWR#9	2.61058e-17
C61	VGND#2	VGND#4	5.4131e-17
C62	VGND#8	VPWR#3	1.521e-18
C63	VPWR#7	VPWR#8	2.9839e-17
C64	VPWR#7	VPWR#10	6.97503e-17
C65	VGND#7	VGND#9	3.94336e-17
C66	VPWR#8	VGND#2	7.52863e-17
C67	VPWR#10	VGND#2	1.31633e-16
C68	VGND#7	VGND#8	3.71696e-17
C69	VPWR#10	VGND#4	1.39803e-16
C70	VPWR#4	VPWR#1	3.686e-17
C71	VGND#9	VGND#2	6.76889e-19
C72	VPWR#9	VGND#4	6.47684e-17
C73	VGND#9	VPWR#4	7.44957e-17
C74	VGND#8	VGND#2	1.66384e-18
C75	VPWR#8	VPWR#10	2.53812e-17
C76	VGND#14	VPWR#4	3.80853e-17
C77	VGND#9	VPWR#1	2.01104e-18
C78	VGND#14	VPWR#1	3.60238e-17
C79	VPWR#10	VPWR#9	3.0968e-17
C80	VPWR#1	VGND#11	4.39912e-18
C81	VGND#8	VPWR#4	1.81555e-17
C82	VGND#8	VPWR#1	5.04183e-18
C83	VGND#9	VGND#14	1.45447e-17
C84	VGND#9	VGND#8	4.6253e-19
C85	VPWR#6	VGND#4	6.53176e-18
C86	VGND#6	VPWR#2	1.16307e-18
C87	VGND#6	VPWR#1	7.94776e-17
C88	VGND#6	VPWR#3	1.15138e-19
C89	VGND#8	VGND#6	9.63402e-19
C90	VGND#6	VPWR#4	2.34115e-18
C91	VGND#3	VPWR#6	5.11518e-19
C92	VPWR#6	VNB	6.35566e-17
C93	VGND#6	VGND#4	9.25809e-19
C94	VGND#6	VGND#11	2.14142e-18
C95	VGND	VGND#6	9.59785e-17
C96	VGND#14	VGND#6	1.83152e-17
C97	VPWR#7	VPWR#6	6.256e-17
C98	VPWR	VPWR#6	4.97585e-17
C99	VGND#6	VNB	1.00925e-16
C100	VGND#9	VGND#6	1.99912e-18
C101	VPWR#10	VPWR#6	1.25187e-18
C102	VGND#7	VGND#6	7.14628e-17
*
*
.ENDS sky130_fd_sc_hs__decap_8
*
