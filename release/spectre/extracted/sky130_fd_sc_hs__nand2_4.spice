* Extracted by Quantus, converted by sky130cad/quantus.py
*
*
*
*                       LINUX           Wed Nov 18 08:44:59 2026
*
*
*
*  PROGRAM  advgen
*
*  Name           : advgen - Quantus - (64-bit)
*  Version        : 25.1.0-p047
*  Build Date     : Thu Dec 11 23:20:30 PST 2025
*
*  HSPICE LIBRARY
*
*  OPERATING_TEMPERATURE 150
*  QRC_TECH_DIR <path>/tech
*
*
*

*
.SUBCKT sky130_fd_sc_hs__nand2_4 VPB VNB VGND VPWR Y B A
*
*
*  caps2d version: 10
*
*
*       TRANSISTOR CARDS
*
*
XM4 VGND#6 B#7 a_27_74##6 VNB sky130_fd_pr__nfet_01v8_lvt l=0.15 w=0.74 ad=0.2072 as=0.2109 pd=2.04 ps=2.05
XM2 a_27_74##8 B#10 VGND#6 VNB sky130_fd_pr__nfet_01v8_lvt l=0.15 w=0.74 ad=0.2072 as=0.2072 pd=2.04 ps=2.04
XM3 VGND#5 B#9 a_27_74##8 VNB sky130_fd_pr__nfet_01v8_lvt l=0.15 w=0.74 ad=0.2072 as=0.2072 pd=2.04 ps=2.04
XM11 a_27_74##3 B#1 VGND#5 VNB sky130_fd_pr__nfet_01v8_lvt l=0.15 w=0.74 ad=0.2368 as=0.2072 pd=2.12 ps=2.04
XM1 Y#6 A#9 a_27_74##3 VNB sky130_fd_pr__nfet_01v8_lvt l=0.15 w=0.74 ad=0.2294 as=0.2368 pd=2.1 ps=2.12
XM5 a_27_74##7 A#7 Y#6 VNB sky130_fd_pr__nfet_01v8_lvt l=0.15 w=0.74 ad=0.259 as=0.2294 pd=2.18 ps=2.1
XM6 Y#1 A#5 a_27_74##7 VNB sky130_fd_pr__nfet_01v8_lvt l=0.15 w=0.74 ad=0.3071 as=0.259 pd=2.31 ps=2.18
XM9 a_27_74# A#1 Y#1 VNB sky130_fd_pr__nfet_01v8_lvt l=0.15 w=0.74 ad=0.2442 as=0.3071 pd=2.14 ps=2.31
XM7 VPWR#4 B#11 Y#5 VPB sky130_fd_pr__pfet_01v8 l=0.15 w=1.12 ad=0.336 as=1.2432 pd=2.84 ps=4.46
XM8 Y#5 B#8 VPWR#3 VPB sky130_fd_pr__pfet_01v8 l=0.15 w=1.12 ad=1.2432 as=0.392 pd=4.46 ps=2.94
XM0 VPWR#3 A#10 Y#3 VPB sky130_fd_pr__pfet_01v8 l=0.15 w=1.12 ad=0.392 as=1.5064 pd=2.94 ps=4.93
XM10 Y#3 A#4 VPWR#1 VPB sky130_fd_pr__pfet_01v8 l=0.15 w=1.12 ad=1.5064 as=0.3864 pd=4.93 ps=2.93
*
*
*       RESISTOR AND CAP/DIODE CARDS
*
Rg1	B#1	B#2	397.555725
Rg2	B#2	B#3	60.954994
Rg3	B#3	B#4	30.358044
Rg4	B#4	B#5	48.076557
Rg5	B#5	B#6	60.971695
Rg6	B#6	B#7	397.555725
Rg7	B#2	B#8	449.655212
Rg8	B#3	B#9	370.752045
Rg9	B#5	B#10	370.752045
Rg10	B#6	B#11	449.655212
Rg11	A#1	A#2	397.555725
Rg12	A#2	A#3	103.666420
Rg13	A#2	A#4	449.655212
Rg14	A#3	A#5	377.027313
Rg15	A#3	A#6	76.623055
Rg16	A#6	A#7	370.752045
Rg17	A#6	A#8	66.877869
Rg18	A#8	A#9	397.555725
Rg19	A#8	A#10	449.655212
Rf1	B	B#4	40.679131
Rf4	Y#1	Y#2	22.959766
Rf5	Y#2	Y	46.798626
Rf6	Y	Y#4	51.463661
Rf7	Y#4	Y#5	66.365021
Rf8	Y#2	Y#6	95.129036
Rf9	Y#3	Y#4	1.250000
Rf10	a_27_74#	a_27_74##2	95.185699
Rf11	a_27_74##2	a_27_74##4	85.220901
Rf12	a_27_74##4	a_27_74##5	78.366737
Rf13	a_27_74##5	a_27_74##6	86.158134
Rf14	a_27_74##2	a_27_74##7	22.894152
Rf15	a_27_74##5	a_27_74##8	28.306047
Rf16	a_27_74##3	a_27_74##4	7.500000
Rf17	VPWR#1	VPWR#2	165.902161
Rf18	VPWR#2	VPWR#3	35.721558
Rf19	VPWR#2	VPWR#4	175.341354
Rf20	VGND#1	VGND#2	43.075260
Rf21	VGND#2	VGND#3	62.774361
Rf23	VGND#2	VGND#5	36.279022
Rf24	VGND#3	VGND#6	36.279022
Rf26	A#3	A	40.058201
Re1	VPWR#2	VPWR	1.091357
Re2	VGND	VGND#1	1.091398
*
*       CAPACITOR CARDS
*
*
C1	a_27_74##5	B#6	1.44976e-18
C2	a_27_74##5	B#5	9.76684e-19
C3	a_27_74##5	B#2	1.38028e-18
C4	a_27_74##2	A#8	2.30261e-19
C5	a_27_74##2	A#6	3.38053e-19
C6	a_27_74##2	A#2	1.13037e-19
C7	Y#2	A#2	3.49881e-18
C8	VGND#2	a_27_74##5	2.91756e-19
C9	a_27_74##2	Y#2	5.33026e-17
C10	VPWR#2	A#8	2.18359e-20
C11	a_27_74#	A#2	2.85733e-19
C12	VPWR#2	A#6	1.03631e-19
C13	VPWR#2	B#5	1.05601e-21
C14	VPWR#2	B#2	1.74687e-20
C15	a_27_74##2	a_27_74#	2.80188e-18
C16	VGND#2	a_27_74##3	3.82347e-18
C17	VGND#1	A#8	2.24609e-20
C18	a_27_74##2	Y#1	1.10844e-18
C19	VGND#1	A#6	2.36861e-20
C20	VGND#1	A#2	3.88983e-20
C21	Y#2	a_27_74#	3.83214e-17
C22	a_27_74##2	a_27_74##7	3.62108e-18
C23	a_27_74##5	a_27_74##3	5.2354e-19
C24	Y#2	Y#1	1.07646e-17
C25	VGND#2	a_27_74##8	5.19931e-18
C26	a_27_74##2	Y#6	5.57684e-17
C27	a_27_74##5	VGND#5	2.00132e-17
C28	Y#2	a_27_74##7	1.3334e-20
C29	a_27_74##3	a_27_74##2	2.84178e-18
C30	A#6	A#3	2.58024e-18
C31	A#3	A#2	2.14801e-18
C32	a_27_74##5	a_27_74##8	1.24483e-18
C33	Y#6	Y#2	3.52464e-18
C34	a_27_74#	Y#1	7.48e-19
C35	a_27_74##5	VGND#6	1.99802e-17
C36	Y#6	A#8	3.02142e-18
C37	Y#6	A#6	1.97434e-18
C38	a_27_74##6	a_27_74##5	5.2354e-19
C39	B#4	A#8	1.73133e-17
C40	B#4	B#6	1.39405e-17
C41	B#4	B#5	1.21939e-17
C42	B#4	B#2	1.64908e-17
C43	Y#6	a_27_74##7	4.07878e-19
C44	A#8	A#6	2.90033e-18
C45	a_27_74##3	Y#6	5.84697e-17
C46	Y#2	Y#3	1.50797e-18
C47	VGND#2	A#1	5.50486e-20
C48	A#8	A#2	4.48582e-20
C49	a_27_74##3	VGND#5	5.12147e-17
C50	a_27_74#	VPWR#1	1.60868e-19
C51	VGND#2	A#5	7.05125e-20
C52	a_27_74##8	a_27_74##3	2.50631e-18
C53	a_27_74##8	VGND#5	3.88753e-17
C54	VGND#2	A#7	2.59159e-19
C55	a_27_74##2	A#1	1.01379e-18
C56	VGND#6	VGND#5	2.45187e-18
C57	VGND#2	A#9	6.39262e-19
C58	a_27_74##2	A#5	3.15172e-17
C59	Y#2	A#1	3.38042e-17
C60	VGND#6	a_27_74##8	3.88497e-17
C61	Y#6	Y#3	2.98082e-18
C62	a_27_74##5	A#9	3.90408e-20
C63	VGND#2	B#1	6.87507e-18
C64	a_27_74##6	a_27_74##8	2.50631e-18
C65	a_27_74##2	A#7	2.18728e-17
C66	a_27_74##3	Y#3	4.3822e-19
C67	Y#2	A#5	2.53883e-17
C68	A	A#8	6.07162e-18
C69	VGND#5	B#2	5.18819e-19
C70	a_27_74##6	VGND#6	4.39184e-17
C71	A	A#6	1.67137e-17
C72	A	A#2	1.51203e-17
C73	a_27_74##5	B#1	9.24914e-20
C74	a_27_74#	A#1	2.87649e-17
C75	a_27_74##2	A#9	5.05614e-19
C76	VGND#2	B#9	4.70981e-18
C77	Y#2	A#7	1.00626e-18
C78	A#1	Y#1	1.13601e-17
C79	a_27_74#	A#5	9.41218e-19
C80	a_27_74##2	B#1	2.21746e-19
C81	a_27_74##5	B#9	1.73542e-17
C82	VGND#2	B#10	7.64954e-19
C83	A#5	Y#1	1.38816e-17
C84	Y#6	A#1	2.74306e-19
C85	A#5	a_27_74##7	1.64928e-17
C86	a_27_74##5	B#10	1.72533e-17
C87	Y#3	VPWR#1	1.28388e-16
C88	Y#6	A#5	1.08938e-18
C89	B	A#8	3.97536e-18
C90	A#7	a_27_74##7	8.33433e-18
C91	a_27_74##5	B#7	1.95034e-19
C92	a_27_74##3	A#5	2.19508e-19
C93	B	B#6	6.87358e-18
C94	B	B#5	1.84184e-18
C95	Y#6	A#7	4.49767e-17
C96	VGND#6	B#6	4.8818e-19
C97	B	B#2	5.32134e-18
C98	Y#3	VPWR#3	8.55949e-17
C99	a_27_74##3	A#7	1.36898e-18
C100	a_27_74##6	VPWR#4	1.49678e-17
C101	VGND#6	B#5	3.28879e-19
C102	A#9	Y#6	2.82334e-17
C103	Y#5	Y#3	3.42185e-18
C104	a_27_74##3	A#9	5.55173e-17
C105	Y#6	B#1	9.68977e-19
C106	Y#5	VPWR#3	8.25238e-17
C107	VGND#5	A#9	9.11196e-19
C108	a_27_74##3	B#1	3.07215e-17
C109	a_27_74##8	A#9	1.86898e-19
C110	VPWR#4	VPWR#3	4.12115e-19
C111	Y	A#8	7.7095e-20
C112	Y	A#6	1.27488e-19
C113	VGND#5	B#1	3.04083e-17
C114	Y	A#2	1.61012e-17
C115	a_27_74##3	B#9	5.78043e-19
C116	VPWR#4	Y#5	1.18385e-16
C117	a_27_74##8	B#1	4.42778e-19
C118	VGND#5	B#9	2.81854e-17
C119	a_27_74##3	B#10	2.52612e-19
C120	B#9	a_27_74##8	1.4044e-17
C121	VGND#5	B#10	1.29323e-18
C122	B#2	A#8	2.10773e-17
C123	VGND#6	B#9	1.51975e-18
C124	B#10	a_27_74##8	1.74437e-17
C125	a_27_74##6	B#9	2.52612e-19
C126	VGND#6	B#10	3.27256e-17
C127	a_27_74##8	B#7	9.33674e-19
C128	A#5	A#1	2.19458e-17
C129	VPWR#1	A#2	3.58928e-20
C130	a_27_74##6	B#10	1.14189e-18
C131	VGND#6	B#7	2.92518e-17
C132	a_27_74##6	B#7	3.68025e-17
C133	A#7	A#5	2.51927e-17
C134	B#6	B#5	3.15868e-18
C135	A#8	Y#3	1.84783e-18
C136	VGND#1	VGND#2	3.08334e-17
C137	A#9	A#7	3.44587e-17
C138	A#6	Y#3	7.37206e-18
C139	A#4	VPWR#1	3.19003e-17
C140	VGND#1	a_27_74##2	8.1437e-17
C141	Y#3	A#4	9.54271e-17
C142	A#2	Y#3	2.57608e-18
C143	B#1	A#9	3.33837e-17
C144	VPWR#1	A#10	6.30888e-19
C145	VPWR#3	A#4	8.63707e-19
C146	Y#3	A#10	9.45349e-17
C147	a_27_74##2	A#3	1.16878e-18
C148	VGND#2	B#4	3.58181e-20
C149	VPWR#1	B#8	3.22324e-19
C150	A#10	VPWR#3	2.84541e-17
C151	B#9	B#1	3.97683e-17
C152	VGND#1	a_27_74#	5.44464e-17
C153	Y#3	B#8	1.81107e-18
C154	Y#2	A#3	3.88583e-18
C155	Y#5	A#10	6.13349e-19
C156	a_27_74##5	B#4	9.08087e-17
C157	VPWR#3	B#8	4.9682e-17
C158	VPWR#4	A#10	4.86446e-19
C159	Y#3	B#11	1.36032e-19
C160	Y#5	B#8	8.68347e-17
C161	B#10	B#9	4.09579e-17
C162	VPWR#3	B#11	7.91974e-19
C163	VGND#1	a_27_74##3	3.51469e-17
C164	VPWR#4	B#8	1.67948e-18
C165	B#11	Y#5	6.51495e-17
C166	Y#6	A#3	1.17674e-18
C167	VPWR#4	B#11	5.4076e-17
C168	VPWR#2	VPWR#1	4.78345e-17
C169	B#7	B#10	3.96938e-17
C170	Y#3	VPWR#2	4.36846e-17
C171	A#8	VNB	2.83991e-17
C172	A#6	VNB	2.15832e-17
C173	A#2	VNB	4.05389e-17
C174	B#6	VNB	4.06097e-17
C175	B#5	VNB	1.61887e-17
C176	B#2	VNB	2.71804e-17
C177	Y#5	VPWR#2	3.35611e-17
C178	a_27_74##3	B#4	5.36417e-17
C179	VGND#5	B#4	3.5866e-19
C180	VPWR#2	VPWR#4	4.42752e-17
C181	VPWR#1	A#3	8.12594e-20
C182	A#3	Y#3	1.22122e-17
C183	B#6	B#2	7.0139e-20
C184	a_27_74##6	B#4	1.55505e-17
C185	VGND#1	A#1	4.48038e-18
C186	Y#2	A	7.19313e-17
C187	VGND#1	A#5	4.47052e-18
C188	A#10	A#4	1.72503e-18
C189	VGND#1	A#7	4.47052e-18
C190	B#4	Y#5	8.99901e-18
C191	VGND#1	A#9	4.43427e-18
C192	Y#6	A	5.22078e-17
C193	B#8	A#10	3.74079e-17
C194	Y#5	B#6	1.00948e-18
C195	B#11	B#8	3.96889e-18
C196	A	Y#3	1.31101e-16
C197	Y	a_27_74#	2.69491e-17
C198	VPWR#2	A#10	2.58378e-18
C199	Y#5	B#5	4.84225e-18
C200	VPWR#2	B#8	9.77087e-19
C201	B	Y#3	3.07281e-17
C202	B	Y#5	1.19916e-16
C203	VGND	VGND#2	3.91097e-17
C204	B	VPWR#4	5.2636e-19
C205	Y	VPWR#1	2.24369e-18
C206	VGND	a_27_74##5	4.1224e-18
C207	Y	Y#3	1.07092e-19
C208	B#2	Y#5	1.25376e-18
C209	VGND	a_27_74##2	3.10301e-17
C210	VGND	Y#2	1.00439e-17
C211	VGND	a_27_74#	2.19201e-17
C212	VPWR#2	A#3	1.00331e-19
C213	VPWR	VPWR#1	5.21053e-17
C214	VPWR	Y#3	5.4724e-17
C215	VGND	Y#6	8.69445e-18
C216	VGND#1	A#3	6.62598e-20
C217	VPWR	VPWR#3	2.23244e-17
C218	VPWR#2	B#4	1.46024e-19
C219	VGND#2	VNB	2.3362e-17
C220	VGND	a_27_74##3	1.98979e-17
C221	A	A#4	1.84376e-18
C222	VPWR	Y#5	4.16484e-17
C223	a_27_74##5	VNB	1.82376e-18
C224	VPWR	VPWR#4	4.97895e-17
C225	VGND	a_27_74##8	1.09176e-17
C226	A	A#10	1.17455e-18
C227	a_27_74##2	VNB	6.55723e-18
C228	VGND	a_27_74##6	1.47341e-17
C229	Y#2	VNB	3.88863e-18
C230	VPWR#4	B#6	1.77417e-20
C231	a_27_74#	VNB	3.32293e-17
C232	B	A#10	3.02748e-18
C233	B	B#8	2.60946e-18
C234	Y#6	VNB	5.73239e-19
C235	VGND	VPWR#4	4.48213e-18
C236	a_27_74##3	VNB	4.91013e-18
C237	Y	A#4	5.17629e-18
C238	VGND	A#1	2.32341e-18
C239	B	B#11	1.65651e-18
C240	VGND#5	VNB	4.05133e-20
C241	a_27_74##8	VNB	4.55126e-18
C242	VGND	A#5	1.59894e-18
C243	Y	A#10	4.92107e-19
C244	VPWR#4	B#5	7.36565e-20
C245	VGND#6	VNB	1.90168e-18
C246	VGND	A#7	1.57561e-18
C247	a_27_74##6	VNB	4.54187e-17
C248	VGND	A#9	1.49728e-18
C249	VPWR#1	VNB	8.04042e-17
C250	Y#3	VNB	2.45763e-17
C251	VGND	B#1	5.1167e-19
C252	A	A#3	2.46426e-17
C253	VPWR#3	VNB	1.35907e-18
C254	VGND	B#9	6.66852e-19
C255	Y#5	VNB	9.14507e-18
C256	VGND	B#10	6.66852e-19
C257	B#4	A	2.79615e-17
C258	VPWR#4	VNB	8.89589e-17
C259	VPWR	B#8	6.90431e-19
C260	A#1	VNB	3.60634e-17
C261	VGND	B#7	1.6266e-18
C262	A#5	VNB	3.00011e-17
C263	VPWR	B#11	3.06512e-18
C264	A#7	VNB	2.94353e-17
C265	B	B#4	6.43921e-18
C266	A#9	VNB	3.15324e-17
C267	B#1	VNB	2.786e-17
C268	Y	A#3	2.99217e-19
C269	VPWR	VPWR#2	5.10769e-17
C270	B#9	VNB	2.51238e-17
C271	B#10	VNB	2.50796e-17
C272	B#7	VNB	3.35148e-17
C273	A#4	VNB	4.30523e-17
C274	B	A	1.43285e-17
C275	A#10	VNB	3.39673e-17
C276	VGND	VGND#1	4.65105e-17
C277	B#8	VNB	3.0065e-17
C278	B#11	VNB	4.4528e-17
C279	A	Y	4.24535e-17
C280	VGND	B#4	1.07014e-17
C281	VPWR#2	VNB	2.55e-16
C282	VPWR	A	7.9457e-18
C283	VGND#1	VNB	2.70109e-16
C284	A#3	VNB	3.60672e-17
C285	VPWR	B	1.00923e-17
C286	B#4	VNB	5.26682e-17
C287	VGND	A	7.85531e-18
C288	A	VNB	2.63592e-17
C289	VGND	Y	3.91493e-18
C290	B	VNB	1.4395e-17
C291	Y	VNB	4.77208e-17
C292	VPWR	VNB	6.99936e-17
C293	VGND	VNB	7.18623e-17
C294	VGND#3	VNB	4.40185e-17
C295	VGND	VGND#3	4.92847e-17
C296	VGND#3	B#4	3.85385e-20
C297	VGND#1	VGND#3	4.96643e-17
C298	VGND#3	B#7	4.57367e-18
C299	VGND#3	B#10	4.79501e-18
C300	VGND#3	B#9	7.64954e-19
C301	VGND#3	a_27_74##6	1.7841e-17
C302	VGND#3	a_27_74##8	5.24871e-18
C303	VGND#3	a_27_74##5	2.91756e-19
C304	VGND#3	VGND#2	1.14921e-18
*
*
.ENDS sky130_fd_sc_hs__nand2_4
*
