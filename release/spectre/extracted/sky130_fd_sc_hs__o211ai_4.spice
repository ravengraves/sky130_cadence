* Extracted by Quantus, converted by sky130cad/quantus.py
*
*
*
*                       LINUX           Wed Nov 18 08:54:29 2026
*
*
*
*  PROGRAM  advgen
*
*  Name           : advgen - Quantus - (64-bit)
*  Version        : 25.1.0-p047
*  Build Date     : Thu Dec 11 23:20:30 PST 2025
*
*  HSPICE LIBRARY
*
*  OPERATING_TEMPERATURE 150
*  QRC_TECH_DIR <path>/tech
*
*
*

*
.SUBCKT sky130_fd_sc_hs__o211ai_4 VNB VPB VGND VPWR Y A1 A2 B1 C1
*
*
*  caps2d version: 10
*
*
*       TRANSISTOR CARDS
*
*
XM18 VGND#10 A1#6 a_27_74##12 VNB sky130_fd_pr__nfet_01v8_lvt l=0.15 w=0.74 ad=0.259 as=0.2109 pd=2.18 ps=2.05
XM19 VGND#10 A1#10 a_27_74##11 VNB sky130_fd_pr__nfet_01v8_lvt l=0.15 w=0.74 ad=0.259 as=0.2072 pd=2.18 ps=2.04
XM26 a_27_74##11 A1#8 VGND#9 VNB sky130_fd_pr__nfet_01v8_lvt l=0.15 w=0.74 ad=0.2072 as=0.259 pd=2.04 ps=2.18
XM0 a_27_74##9 A1#1 VGND#9 VNB sky130_fd_pr__nfet_01v8_lvt l=0.15 w=0.74 ad=0.2072 as=0.259 pd=2.04 ps=2.18
XM27 VGND#8 A2#11 a_27_74##9 VNB sky130_fd_pr__nfet_01v8_lvt l=0.15 w=0.74 ad=0.2072 as=0.2072 pd=2.04 ps=2.04
XM15 a_27_74##7 A2#9 VGND#8 VNB sky130_fd_pr__nfet_01v8_lvt l=0.15 w=0.74 ad=0.2072 as=0.2072 pd=2.04 ps=2.04
XM22 a_27_74##7 A2#6 VGND#7 VNB sky130_fd_pr__nfet_01v8_lvt l=0.15 w=0.74 ad=0.2072 as=0.222 pd=2.04 ps=2.08
XM9 VGND#7 A2#5 a_27_74##4 VNB sky130_fd_pr__nfet_01v8_lvt l=0.15 w=0.74 ad=0.222 as=0.2072 pd=2.08 ps=2.04
XM13 a_27_74##4 B1#9 a_834_74##6 VNB sky130_fd_pr__nfet_01v8_lvt l=0.15 w=0.74 ad=0.2072 as=0.2072 pd=2.04 ps=2.04
XM20 a_27_74##2 B1#7 a_834_74##6 VNB sky130_fd_pr__nfet_01v8_lvt l=0.15 w=0.74 ad=0.2072 as=0.2072 pd=2.04 ps=2.04
XM5 a_834_74##4 B1#5 a_27_74##2 VNB sky130_fd_pr__nfet_01v8_lvt l=0.15 w=0.74 ad=0.2072 as=0.2072 pd=2.04 ps=2.04
XM16 a_834_74##4 B1#1 a_27_74# VNB sky130_fd_pr__nfet_01v8_lvt l=0.15 w=0.74 ad=0.2072 as=0.2109 pd=2.04 ps=2.05
XM21 Y#10 C1#7 a_834_74##8 VNB sky130_fd_pr__nfet_01v8_lvt l=0.15 w=0.74 ad=0.2072 as=0.2109 pd=2.04 ps=2.05
XM17 a_834_74##7 C1#6 Y#10 VNB sky130_fd_pr__nfet_01v8_lvt l=0.15 w=0.74 ad=0.2072 as=0.2072 pd=2.04 ps=2.04
XM23 a_834_74##7 C1#5 Y#6 VNB sky130_fd_pr__nfet_01v8_lvt l=0.15 w=0.74 ad=0.2072 as=0.2072 pd=2.04 ps=2.04
XM14 Y#6 C1#1 a_834_74# VNB sky130_fd_pr__nfet_01v8_lvt l=0.15 w=0.74 ad=0.2072 as=0.2109 pd=2.04 ps=2.05
XM1 VPWR#13 A1#12 a_30_368##6 VPB sky130_fd_pr__pfet_01v8 l=0.15 w=1.12 ad=0.336 as=0.3304 pd=2.84 ps=2.83
XM7 a_30_368##8 A1#11 VPWR#13 VPB sky130_fd_pr__pfet_01v8 l=0.15 w=1.12 ad=0.336 as=0.336 pd=2.84 ps=2.84
XM3 VPWR#12 A1#9 a_30_368##8 VPB sky130_fd_pr__pfet_01v8 l=0.15 w=1.12 ad=0.336 as=0.336 pd=2.84 ps=2.84
XM11 a_30_368##3 A1#7 VPWR#12 VPB sky130_fd_pr__pfet_01v8 l=0.15 w=1.12 ad=0.392 as=0.336 pd=2.94 ps=2.84
XM12 Y#4 A2#13 a_30_368##3 VPB sky130_fd_pr__pfet_01v8 l=0.15 w=1.12 ad=0.336 as=0.392 pd=2.84 ps=2.94
XM6 a_30_368##7 A2#12 Y#4 VPB sky130_fd_pr__pfet_01v8 l=0.15 w=1.12 ad=0.336 as=0.336 pd=2.84 ps=2.84
XM24 Y#9 A2#7 a_30_368##7 VPB sky130_fd_pr__pfet_01v8 l=0.15 w=1.12 ad=0.392 as=0.336 pd=2.94 ps=2.84
XM8 a_30_368# A2#1 Y#9 VPB sky130_fd_pr__pfet_01v8 l=0.15 w=1.12 ad=0.3864 as=0.392 pd=2.93 ps=2.94
XM4 Y#8 B1#8 VPWR#11 VPB sky130_fd_pr__pfet_01v8 l=0.15 w=1.12 ad=0.4368 as=0.3304 pd=3.02 ps=2.83
XM25 VPWR#10 B1#4 Y#8 VPB sky130_fd_pr__pfet_01v8 l=0.15 w=1.12 ad=0.4032 as=0.4368 pd=2.96 ps=3.02
XM2 Y#7 C1#8 VPWR#10 VPB sky130_fd_pr__pfet_01v8 l=0.15 w=1.12 ad=0.336 as=0.4032 pd=2.84 ps=2.96
XM10 VPWR#9 C1#9 Y#7 VPB sky130_fd_pr__pfet_01v8 l=0.15 w=1.12 ad=0.9688 as=0.336 pd=3.97 ps=2.84
*
*
*       RESISTOR AND CAP/DIODE CARDS
*
Rg1	A1#1	A1#2	394.232941
Rg2	A1#2	A1#3	64.267426
Rg3	A1#3	A1#4	52.572067
Rg4	A1#4	A1#5	88.398666
Rg5	A1#5	A1#6	396.743866
Rg6	A1#2	A1#7	449.668243
Rg7	A1#3	A1#8	415.274414
Rg8	A1#3	A1#9	429.620972
Rg9	A1#4	A1#10	373.478424
Rg10	A1#4	A1#11	425.577911
Rg11	A1#5	A1#12	449.230865
Rg12	A2#1	A2#2	453.403839
Rg13	A2#2	A2#3	61.631439
Rg14	A2#3	A2#4	46.141594
Rg15	A2#2	A2#5	398.006165
Rg16	A2#3	A2#6	442.592041
Rg17	A2#3	A2#7	456.938599
Rg18	A2#4	A2#8	21.238852
Rg19	A2#8	A2#9	427.444397
Rg20	A2#8	A2#10	54.988647
Rg21	A2#10	A2#11	403.957642
Rg22	A2#8	A2#12	441.790924
Rg23	A2#10	A2#13	436.070282
Rg24	B1#1	B1#2	397.555725
Rg25	B1#2	B1#3	64.065247
Rg26	B1#2	B1#4	449.655212
Rg27	B1#3	B1#5	396.960083
Rg28	B1#3	B1#6	140.525421
Rg29	B1#6	B1#7	280.275299
Rg30	B1#3	B1#8	440.981964
Rg31	B1#6	B1#9	455.634949
Rg32	C1#1	C1#2	539.202332
Rg33	C1#2	C1#3	224.568359
Rg34	C1#3	C1#4	84.032776
Rg35	C1#2	C1#5	328.696167
Rg36	C1#3	C1#6	338.792633
Rg37	C1#4	C1#7	356.465179
Rg38	C1#4	C1#8	516.401367
Rg39	C1#4	C1#9	431.330811
Rf1	A1	A1#13	3.208829
Rf2	A1#13	A1	11.460103
Rf3	A2	A2#14	9.626486
Rf4	A2#14	A2	5.042445
Rf5	a_30_368#	a_30_368##2	86.229408
Rf6	a_30_368##2	a_30_368##4	86.479172
Rf7	a_30_368##4	a_30_368##5	75.666893
Rf8	a_30_368##5	a_30_368##6	81.107391
Rf9	a_30_368##2	a_30_368##7	21.341251
Rf10	a_30_368##5	a_30_368##8	18.602406
Rf11	a_30_368##3	a_30_368##4	5.000000
Rf12	B1	B1#10	2.597623
Rf13	B1#10	B1	12.071308
Rf14	a_27_74#	a_27_74##3	77.488335
Rf15	a_27_74##3	a_27_74##5	31.307194
Rf16	a_27_74##5	a_27_74##6	64.868744
Rf17	a_27_74##6	a_27_74##7	28.306047
Rf18	a_27_74##6	a_27_74##8	63.019512
Rf19	a_27_74##8	a_27_74##9	28.306047
Rf20	a_27_74##8	a_27_74##10	65.145798
Rf21	a_27_74##10	a_27_74##11	21.341251
Rf22	a_27_74##10	a_27_74##12	85.825729
Rf23	a_27_74##2	a_27_74##3	15.000000
Rf24	a_27_74##4	a_27_74##5	7.500000
Rf25	C1	C1#10	3.208829
Rf26	C1#10	C1	11.460103
Rf27	Y	Y#1	103.334831
Rf28	Y#1	Y#2	73.001427
Rf29	Y#2	Y#3	113.909706
Rf30	Y#3	Y#4	82.437431
Rf31	Y	Y#5	38.535805
Rf32	Y#5	Y#6	29.636944
Rf33	Y#1	Y#7	18.602406
Rf34	Y#2	Y#8	18.602406
Rf35	Y#3	Y#9	16.279915
Rf36	Y#5	Y#10	83.535629
Rf37	a_834_74#	a_834_74##2	81.032211
Rf38	a_834_74##2	a_834_74##3	62.774361
Rf39	a_834_74##3	a_834_74##5	68.014969
Rf40	a_834_74##5	a_834_74##6	42.625023
Rf41	a_834_74##2	a_834_74##7	24.272007
Rf42	a_834_74##3	a_834_74##8	21.889751
Rf43	a_834_74##4	a_834_74##5	15.000000
Rf44	VPWR#1	VPWR#2	42.231262
Rf45	VPWR#2	VPWR#3	92.246315
Rf46	VPWR#3	VPWR#4	73.001427
Rf47	VPWR#4	VPWR#5	90.923332
Rf48	VPWR#5	VPWR#6	125.379646
Rf49	VPWR#6	VPWR#7	65.941528
Rf51	VPWR#2	VPWR#9	13.369189
Rf52	VPWR#3	VPWR#10	33.109421
Rf53	VPWR#4	VPWR#11	33.109421
Rf54	VPWR#6	VPWR#12	53.143215
Rf55	VPWR#7	VPWR#13	53.143215
Rf56	VGND#1	VGND#2	299.762726
Rf57	VGND#2	VGND#3	58.379341
Rf58	VGND#3	VGND#4	62.774361
Rf59	VGND#4	VGND#5	67.887894
Rf61	VGND#2	VGND#7	40.170597
Rf62	VGND#3	VGND#8	36.672695
Rf63	VGND#4	VGND#9	36.672695
Rf64	VGND#5	VGND#10	35.098007
Rf66	A2#4	A2#14	40.058201
Rf67	B1#3	B1#10	53.410934
Rf68	C1#4	C1#10	53.410934
Rf65	A1#4	A1#13	40.058201
Re1	VPWR#1	VPWR	4.549932
Re2	VPWR	VPWR#5	0.974985
Re3	VGND#1	VGND	4.549932
Re4	VGND	VGND#2	0.974985
*
*       CAPACITOR CARDS
*
*
C1	VGND#1	C1#3	2.6234e-20
C2	Y#8	Y#7	2.03058e-18
C3	a_27_74##6	A2#5	9.02533e-20
C4	a_834_74##2	Y#10	4.52497e-17
C5	VPWR#2	C1#3	2.54471e-18
C6	VGND#1	C1#2	1.52373e-18
C7	Y#6	C1#7	2.52738e-19
C8	a_834_74##3	a_834_74##8	3.87518e-21
C9	a_30_368##2	A2#2	1.49887e-19
C10	Y#10	C1#6	2.47858e-17
C11	a_27_74##8	A2#6	3.90164e-20
C12	VGND#1	B1#2	2.7831e-21
C13	Y#8	VPWR#10	6.22318e-17
C14	VGND#3	a_27_74##7	5.24871e-18
C15	a_834_74##8	C1#6	2.37967e-18
C16	a_27_74##6	A2#6	1.72271e-17
C17	a_834_74#	C1#2	1.61231e-19
C18	a_834_74##8	a_834_74##2	5.36247e-18
C19	VPWR#2	C1#2	2.04917e-18
C20	C1#7	Y#10	1.95282e-17
C21	VPWR#11	VPWR#10	1.58651e-18
C22	a_834_74##3	a_27_74#	1.46869e-17
C23	VPWR#3	B1#2	9.14379e-21
C24	a_27_74##8	A2#9	9.24914e-20
C25	a_834_74##8	C1#7	4.89666e-17
C26	a_27_74##6	A2#9	1.69132e-17
C27	VPWR#11	Y#8	6.22197e-17
C28	B1#2	Y#8	1.22436e-19
C29	a_27_74##10	A2#11	4.41656e-20
C30	a_27_74#	C1#7	1.1227e-18
C31	a_27_74##8	A2#11	1.45258e-17
C32	VGND#4	a_27_74##9	5.24871e-18
C33	a_834_74##8	B1#1	2.86591e-18
C34	a_834_74##4	C1#7	5.40049e-19
C35	VPWR#5	A2#10	1.29233e-20
C36	a_27_74##6	A2#11	9.24914e-20
C37	C1#2	Y#6	4.06878e-19
C38	VPWR#5	A2#8	4.01799e-20
C39	a_27_74##10	A1#1	1.20285e-19
C40	a_27_74#	B1#1	4.78763e-17
C41	VGND#3	a_27_74##9	5.19931e-18
C42	a_30_368#	VPWR#11	5.68375e-17
C43	B1#6	VPWR#11	1.97838e-18
C44	VPWR#5	A2#2	2.73353e-20
C45	a_27_74##8	A1#1	2.0573e-17
C46	a_834_74##8	B1#5	3.15065e-19
C47	a_834_74##4	B1#1	3.50498e-17
C48	a_27_74##6	A1#1	3.90164e-20
C49	a_27_74#	B1#5	1.0807e-18
C50	a_27_74##10	A1#8	2.15224e-17
C51	a_27_74##2	B1#1	8.46252e-19
C52	VPWR#2	C1#9	2.29913e-17
C53	VGND#2	B1#6	7.58686e-20
C54	a_27_74##8	A1#8	8.67344e-20
C55	a_834_74##4	B1#5	3.76828e-17
C56	a_30_368#	Y#9	2.69038e-19
C57	VGND#2	B1#2	9.64147e-21
C58	VGND#4	a_27_74##11	6.70407e-18
C59	a_27_74##2	B1#5	3.65199e-17
C60	VGND#2	A2#8	3.56886e-20
C61	a_27_74##10	A1#10	1.76068e-17
C62	VPWR#3	C1#8	2.56446e-18
C63	a_27_74##4	B1#1	3.33096e-20
C64	a_30_368##7	a_30_368#	4.13726e-18
C65	a_834_74##4	B1#7	1.24393e-19
C66	VGND#2	A2#2	3.51727e-20
C67	VPWR#2	C1#8	1.2077e-18
C68	a_27_74#	Y#1	5.15481e-18
C69	a_27_74##2	B1#7	2.96407e-17
C70	a_27_74##4	B1#5	5.81345e-20
C71	a_27_74##2	Y#3	8.23823e-19
C72	VGND#10	VGND#4	5.34212e-19
C73	a_27_74##10	A1#6	1.7522e-19
C74	C1#4	C1#3	1.84431e-18
C75	a_834_74##4	B1#9	5.81345e-20
C76	VPWR#3	B1#4	9.77087e-19
C77	A2#10	A2#8	3.20043e-18
C78	Y#10	C1#3	1.70456e-18
C79	a_834_74##6	B1#7	3.77272e-17
C80	A2#2	B1#6	6.33069e-18
C81	a_834_74##3	C1#8	3.06317e-18
C82	VPWR#2	B1#4	3.52974e-19
C83	B1#2	C1#4	4.73716e-19
C84	a_27_74##4	B1#7	1.24393e-19
C85	a_27_74##2	Y#2	2.68589e-18
C86	a_834_74##4	A2#5	3.33096e-20
C87	VPWR#4	B1#8	9.77087e-19
C88	Y#4	a_30_368##7	4.3893e-17
C89	a_834_74##6	B1#9	2.86383e-17
C90	Y#1	C1#9	2.62698e-17
C91	a_27_74##4	B1#9	3.36432e-17
C92	a_30_368##3	a_30_368##7	3.90094e-18
C93	VPWR#6	A2#1	4.05989e-20
C94	a_834_74##6	A2#5	1.58975e-18
C95	Y#2	C1#8	1.58608e-19
C96	VGND#7	B1#9	1.31308e-18
C97	a_27_74##4	Y#3	2.09059e-18
C98	a_30_368##3	Y#4	7.49912e-17
C99	a_27_74##4	A2#5	3.51138e-17
C100	a_834_74##2	C1#3	3.99345e-19
C101	Y#1	C1#8	2.11431e-17
C102	a_27_74##7	B1#9	1.25529e-19
C103	B1#6	B1#3	5.74126e-18
C104	a_30_368#	A2#2	1.06651e-19
C105	Y#3	B1#4	1.12719e-19
C106	B1#3	B1#2	3.80039e-18
C107	VGND#7	A2#5	3.36889e-17
C108	VPWR#6	A2#7	6.17969e-20
C109	Y#2	B1#4	1.30708e-17
C110	a_27_74##4	A2#6	3.60104e-19
C111	a_27_74##7	A2#5	2.97644e-19
C112	A2#8	Y#9	1.07622e-19
C113	Y#1	B1#4	1.83069e-19
C114	a_834_74##2	C1#2	4.36162e-19
C115	A2#2	B1#3	2.00218e-19
C116	a_30_368##3	VPWR#12	5.93552e-17
C117	VGND#7	A2#6	2.97758e-17
C118	Y#3	B1#8	3.84906e-19
C119	a_27_74##4	A2#9	1.86883e-19
C120	VPWR#4	VPWR#3	9.5684e-19
C121	A2#6	a_27_74##7	1.38208e-17
C122	Y#2	B1#8	1.53999e-17
C123	a_30_368##8	a_30_368##3	2.36849e-18
C124	VPWR#6	A2#12	1.67739e-19
C125	VGND#7	A2#9	1.32366e-18
C126	Y#1	B1#8	5.51194e-20
C127	Y#5	C1#3	4.79924e-19
C128	VGND#8	A2#6	1.32366e-18
C129	A2#2	Y#9	9.63213e-19
C130	a_30_368##8	VPWR#12	5.20507e-17
C131	Y#3	A2#1	4.08902e-17
C132	A2#9	a_27_74##7	1.72195e-17
C133	a_27_74##9	A2#6	1.28671e-19
C134	Y#2	A2#1	7.2557e-20
C135	VPWR#6	A2#13	4.84638e-18
C136	VGND#8	A2#9	3.32863e-17
C137	VPWR#13	VPWR#12	1.87864e-18
C138	A2#8	a_30_368##7	1.66984e-18
C139	Y#5	C1#2	8.80242e-18
C140	a_27_74##7	A2#11	3.05025e-19
C141	a_27_74##9	A2#9	3.05025e-19
C142	Y#3	A2#7	2.26248e-17
C143	VPWR#13	a_30_368##8	5.21059e-17
C144	VGND#8	A2#11	2.86802e-17
C145	VPWR#3	VPWR#2	1.00343e-18
C146	A2#8	A2#2	2.9937e-18
C147	a_27_74##7	A1#1	1.28671e-19
C148	VPWR#6	A1#7	7.11348e-18
C149	a_30_368##6	a_30_368##8	2.36849e-18
C150	A2#11	a_27_74##9	1.38198e-17
C151	VGND#8	A1#1	1.32366e-18
C152	A2#10	Y#4	1.8395e-18
C153	a_27_74##6	a_27_74##4	6.07382e-19
C154	a_834_74#	Y#6	4.46238e-17
C155	Y#3	A2#12	8.03256e-19
C156	a_27_74#	B1#2	9.32422e-19
C157	VGND#9	A2#11	1.32366e-18
C158	a_30_368##6	VPWR#13	5.2514e-17
C159	A1#1	a_27_74##9	1.7219e-17
C160	VPWR#2	VPWR#9	3.08634e-17
C161	a_27_74##11	A2#11	1.45653e-19
C162	A2#8	Y#4	2.40834e-18
C163	VPWR#6	A1#9	5.23407e-18
C164	A1#5	A1#4	3.41818e-18
C165	Y#5	B1#2	9.826e-20
C166	VGND#9	A1#1	3.76237e-17
C167	Y#7	VPWR#3	8.48902e-18
C168	a_27_74##6	VGND#7	1.55765e-17
C169	A1#4	A1#2	3.46161e-18
C170	a_27_74##9	A1#8	2.86039e-19
C171	a_27_74##11	A1#1	1.12083e-18
C172	a_30_368#	B1#9	1.13017e-18
C173	A1#8	VGND#9	1.65663e-17
C174	Y#7	VPWR#2	7.37235e-17
C175	a_834_74##8	C1#8	2.19308e-18
C176	VGND#10	A1#1	2.01831e-19
C177	Y#3	B1#6	6.75886e-19
C178	VPWR#6	A1#11	5.30308e-19
C179	a_27_74##11	A1#8	3.62995e-17
C180	a_27_74##6	a_27_74##7	1.24483e-18
C181	a_834_74##4	B1#2	2.78688e-19
C182	a_27_74##8	VGND#8	1.4765e-17
C183	VGND#9	A1#10	3.14381e-19
C184	VGND#10	A1#8	1.76534e-18
C185	C1#5	C1#1	3.99116e-17
C186	Y#8	VPWR#4	9.23125e-18
C187	Y#10	Y#6	3.24924e-18
C188	A1#10	a_27_74##11	1.12761e-17
C189	VPWR#10	VPWR#2	1.99819e-18
C190	a_27_74##12	A1#8	2.00467e-19
C191	a_30_368##2	A2#7	1.62924e-17
C192	a_27_74##6	VGND#8	1.4726e-17
C193	VPWR#6	A1#12	2.31528e-19
C194	VGND#10	A1#10	3.84009e-17
C195	Y#8	VPWR#3	9.16153e-18
C196	a_27_74##8	a_27_74##9	1.24483e-18
C197	a_27_74##2	B1#6	9.24671e-18
C198	a_27_74##11	A1#6	5.77854e-19
C199	a_27_74##10	VGND#9	1.63635e-17
C200	C1#6	C1#5	3.88268e-17
C201	a_27_74##12	A1#10	1.69609e-18
C202	A1#2	A2#10	2.60256e-17
C203	a_30_368##2	A2#12	1.57323e-17
C204	Y#1	C1#3	4.8651e-18
C205	Y#2	B1#6	4.1085e-18
C206	A1#6	VGND#10	1.90897e-17
C207	a_27_74##8	VGND#9	1.40656e-17
C208	a_27_74##12	A1#6	5.12999e-17
C209	a_27_74##10	a_27_74##11	5.26243e-19
C210	C1#7	C1#6	4.00365e-17
C211	VGND#4	a_27_74##10	2.25448e-19
C212	B1#2	C1#8	1.77993e-17
C213	a_30_368#	VPWR#4	2.19942e-17
C214	Y#2	B1#2	5.61181e-19
C215	Y#3	A2#8	1.60049e-18
C216	a_30_368##5	A1#7	1.07385e-19
C217	Y#3	VPWR#4	8.84799e-19
C218	a_834_74##8	Y#10	4.86398e-17
C219	a_834_74##6	B1#6	3.88656e-19
C220	a_27_74##10	VGND#10	1.86309e-17
C221	B1#1	C1#7	4.63958e-18
C222	VGND#4	a_27_74##8	2.91756e-19
C223	a_30_368##5	A1#9	1.75321e-17
C224	VPWR#1	VPWR#2	8.4342e-17
C225	C1#9	VPWR#9	4.02409e-18
C226	Y#1	VPWR#9	1.32004e-18
C227	Y#2	VPWR#4	5.20529e-19
C228	Y#7	C1#9	5.29283e-17
C229	a_27_74##12	a_27_74##10	5.74436e-19
C230	B1#5	B1#1	4.01364e-17
C231	VPWR#10	C1#9	1.4381e-18
C232	VGND#3	a_27_74##8	2.91756e-19
C233	a_30_368##5	A1#11	1.75424e-17
C234	a_27_74#	a_834_74##8	4.54089e-17
C235	Y#3	A2#2	2.92867e-18
C236	Y#7	C1#8	4.57647e-17
C237	Y#1	Y#7	1.36226e-18
C238	Y#2	VPWR#3	1.6661e-19
C239	a_27_74##4	B1#6	5.15808e-19
C240	C1#8	VPWR#10	2.68596e-17
C241	Y#2	VPWR#10	1.66354e-17
C242	A1#2	VPWR#12	6.76081e-19
C243	B1#7	B1#5	3.63456e-17
C244	Y#7	B1#4	1.68153e-18
C245	VGND#1	a_834_74##3	7.14488e-17
C246	Y#8	C1#8	6.04221e-19
C247	a_834_74##4	a_834_74##8	4.76894e-18
C248	Y#3	Y#8	1.03621e-18
C249	a_30_368##5	A1#12	1.94029e-19
C250	VPWR#1	Y#1	6.9954e-19
C251	VGND#3	a_27_74##6	2.91756e-19
C252	VGND#1	a_834_74##2	8.91507e-17
C253	VPWR#10	B1#4	4.97004e-17
C254	Y#1	VPWR#10	2.03951e-17
C255	VGND#3	VGND#2	1.15097e-18
C256	VGND#1	Y#5	1.81763e-18
C257	Y#1	VPWR#3	1.6661e-19
C258	Y#7	B1#8	2.09979e-19
C259	B1#4	Y#8	2.66968e-17
C260	Y#2	Y#8	4.17428e-18
C261	B1#9	B1#7	3.63456e-17
C262	a_27_74#	a_834_74##4	5.10893e-17
C263	a_30_368##3	VPWR#6	4.20758e-17
C264	VPWR#10	B1#8	1.22878e-18
C265	VPWR#11	B1#4	8.70929e-19
C266	B1#8	Y#8	3.24473e-17
C267	Y#1	VPWR#2	3.32984e-17
C268	a_27_74##2	a_27_74#	3.63108e-18
C269	VPWR#11	B1#8	7.04098e-17
C270	A2#5	B1#9	4.17846e-17
C271	Y#2	VPWR#11	3.64912e-17
C272	Y#8	A2#1	2.76408e-19
C273	a_30_368#	B1#8	1.42069e-18
C274	C1	C1#3	1.58614e-17
C275	Y#3	a_30_368#	9.639e-17
C276	C1	C1#2	4.56938e-18
C277	VPWR#11	A2#1	2.10939e-18
C278	C1	B1#2	4.18748e-18
C279	A2#2	B1#8	2.94438e-20
C280	VPWR#3	C1#4	2.1563e-20
C281	a_834_74##4	a_27_74##2	2.78424e-17
C282	a_834_74##2	Y#5	1.63559e-17
C283	A1#5	VPWR#13	6.2216e-19
C284	A2#6	A2#5	3.6007e-17
C285	a_30_368#	A2#1	4.64687e-17
C286	C1#2	C1#1	1.50442e-18
C287	VPWR#2	C1#4	8.69272e-19
C288	a_30_368##7	B1#8	1.01221e-19
C289	VPWR#11	A2#7	1.57335e-19
C290	A2#1	Y#9	2.54251e-17
C291	a_30_368##8	VPWR#6	8.43957e-18
C292	Y#3	Y#9	4.42787e-18
C293	a_834_74##3	C1#4	1.65611e-19
C294	a_30_368#	A2#7	7.15063e-19
C295	a_30_368##7	A2#1	1.93031e-18
C296	VPWR#4	B1#3	4.06942e-20
C297	a_834_74##2	C1#4	6.10691e-20
C298	A2#9	A2#6	4.09614e-17
C299	a_27_74##4	A2#2	2.10464e-18
C300	VPWR#3	B1#3	2.16994e-20
C301	Y#5	C1#4	1.74494e-19
C302	A2#7	Y#9	1.16921e-17
C303	VPWR#11	A2#12	5.15423e-20
C304	Y#4	A2#1	2.1004e-19
C305	A2#8	A2#1	3.75454e-19
C306	a_30_368##7	A2#7	4.47399e-17
C307	VGND#2	a_27_74##6	2.91756e-19
C308	VGND#1	a_834_74#	7.53862e-17
C309	VGND#7	A2#8	4.76309e-19
C310	a_27_74##2	a_834_74##6	4.1371e-17
C311	a_27_74##4	a_834_74##4	4.20094e-19
C312	Y#1	C1#4	4.5446e-18
C313	VGND#1	Y#6	7.57464e-18
C314	Y#3	a_30_368##7	5.52414e-17
C315	a_30_368##2	VPWR#5	7.3341e-17
C316	Y#4	A2#7	1.39076e-18
C317	B1	B1#6	1.32999e-17
C318	VPWR#11	A2#13	4.37554e-20
C319	B1	B1#2	1.56071e-17
C320	A2#11	A2#9	3.97309e-17
C321	A2#12	a_30_368##7	2.14275e-17
C322	a_30_368##3	A2#7	3.28804e-19
C323	VGND#1	Y#10	2.79706e-18
C324	a_834_74##3	Y#1	1.02508e-18
C325	B1	A2#2	1.65407e-18
C326	Y#4	A2#12	5.67964e-17
C327	VGND#4	A1#4	3.80851e-20
C328	Y#2	B1#3	3.80443e-18
C329	a_30_368##3	A2#12	7.65936e-19
C330	a_30_368##7	A2#13	6.70331e-19
C331	Y#4	Y#3	2.7787e-18
C332	A1#1	A2#11	4.09092e-17
C333	VGND#1	a_834_74##4	2.6781e-17
C334	Y#4	A2#13	4.41183e-17
C335	VPWR#6	A1#4	2.01982e-20
C336	VGND#7	A2#2	4.38266e-19
C337	a_27_74##4	a_834_74##6	4.22088e-17
C338	a_30_368##3	A2#13	3.99751e-17
C339	a_30_368##7	A1#7	2.99099e-19
C340	Y#4	A1#7	1.29194e-18
C341	A1#8	A1#1	2.4797e-17
C342	a_27_74##8	A2#10	1.14851e-18
C343	A2	B1#6	6.94184e-18
C344	a_30_368##3	A1#7	7.24507e-17
C345	A2	A2#10	2.32988e-17
C346	VGND#7	a_834_74##6	2.9219e-18
C347	A2	A2#8	3.91389e-17
C348	A1#7	VPWR#12	2.42121e-17
C349	Y#3	Y#2	2.72006e-19
C350	A2	A2#2	2.44378e-17
C351	a_30_368##8	A1#7	1.66337e-18
C352	VGND#2	a_834_74##4	3.37269e-17
C353	a_30_368##3	A1#9	2.00241e-18
C354	A1#10	A1#8	4.00376e-17
C355	A2	A1#2	1.53544e-17
C356	Y#10	C1#4	2.02769e-18
C357	VPWR#13	A1#7	1.53981e-19
C358	A1#9	VPWR#12	2.83688e-17
C359	VGND#8	A2#10	5.78502e-19
C360	a_27_74##4	VGND#7	5.19413e-17
C361	VGND#2	a_834_74##6	4.74057e-17
C362	a_834_74##8	C1#4	4.08103e-18
C363	a_30_368##8	A1#9	5.23881e-17
C364	a_27_74##10	A1#4	6.66435e-18
C365	VGND#2	a_27_74##4	1.19543e-17
C366	a_30_368##5	VPWR#6	3.13618e-19
C367	A1#6	A1#10	2.46576e-17
C368	VPWR#13	A1#9	6.54315e-19
C369	VPWR#12	A1#11	3.44144e-19
C370	VGND#2	a_27_74##7	5.19931e-18
C371	VGND#8	A2#8	2.28982e-19
C372	a_27_74##7	a_27_74##4	2.00307e-18
C373	a_30_368##8	A1#11	4.59447e-17
C374	a_27_74##10	A1#5	1.75498e-19
C375	a_27_74##6	A2#10	4.82116e-19
C376	A1#11	VPWR#13	2.52415e-17
C377	VPWR#12	A1#12	1.53981e-19
C378	a_27_74#	B1#3	4.59215e-19
C379	A1	A2#10	5.44083e-18
C380	a_30_368##5	A1#4	5.05957e-18
C381	a_834_74##4	B1#3	5.87624e-19
C382	a_30_368##6	A1#11	2.12167e-18
C383	a_30_368##8	A1#12	1.99344e-18
C384	A1	A1#5	2.27208e-17
C385	a_27_74##2	B1#3	3.36784e-18
C386	Y#2	Y#1	5.33026e-19
C387	a_27_74##7	VGND#7	4.16102e-17
C388	A1#12	VPWR#13	3.08474e-17
C389	A1	A1#2	1.0929e-17
C390	a_834_74##6	B1#3	3.25721e-19
C391	a_27_74##6	A2#8	5.27496e-18
C392	a_30_368##6	A1#12	5.81998e-17
C393	a_27_74##8	a_30_368##3	5.01114e-18
C394	VGND#8	VGND#7	2.29368e-18
C395	A2#13	A2#8	9.64071e-19
C396	a_30_368#	VPWR#5	2.74877e-17
C397	B1#2	C1#7	3.4832e-19
C398	a_30_368##2	VPWR#6	2.11371e-18
C399	C1#8	C1#9	4.5654e-17
C400	C1#4	VPWR#9	6.19487e-19
C401	a_27_74##10	A1#2	1.12331e-18
C402	Y	C1#3	6.58471e-18
C403	C1#4	Y#7	5.62838e-19
C404	Y	C1#2	1.73055e-17
C405	VGND#8	a_27_74##7	4.15829e-17
C406	a_834_74##2	C1#1	1.489e-18
C407	VPWR#1	C1#1	1.65333e-19
C408	B1#4	C1#8	3.57085e-17
C409	a_30_368##2	Y#9	7.06526e-19
C410	Y#5	C1#1	5.67517e-18
C411	VGND#1	C1#1	3.90592e-18
C412	a_27_74##9	a_27_74##7	1.67195e-18
C413	B1#3	Y#8	7.47405e-19
C414	VGND#1	C1#5	5.44298e-18
C415	A1#7	A2#10	1.85669e-19
C416	B1#8	B1#4	3.22246e-17
C417	B1#3	VPWR#11	1.36875e-19
C418	a_834_74##2	C1#5	2.11101e-17
C419	VGND#9	A1#4	4.01363e-19
C420	VGND#1	C1#6	3.89644e-18
C421	a_30_368##2	a_30_368##7	5.24145e-20
C422	VGND#1	C1#7	3.89644e-18
C423	a_834_74##3	C1	1.20815e-17
C424	VGND#10	A1#4	5.4903e-19
C425	a_27_74##9	VGND#8	4.16102e-17
C426	VGND#1	B1#1	4.48038e-18
C427	Y#5	C1#5	1.64588e-17
C428	Y#5	C1	1.31122e-17
C429	a_27_74##8	A1#2	1.02537e-18
C430	A2#1	B1#8	5.13368e-18
C431	a_30_368##5	a_30_368##3	6.21728e-19
C432	C1	Y#1	8.90337e-17
C433	a_834_74##2	C1#6	1.92735e-17
C434	a_30_368##2	Y#4	2.68325e-17
C435	VGND#9	VGND#8	2.29368e-18
C436	C1#3	C1#2	1.84431e-18
C437	A2#7	A2#1	3.44556e-17
C438	VGND#2	B1#1	4.86394e-20
C439	Y#5	C1#6	4.82294e-20
C440	a_834_74##3	C1#7	1.95528e-17
C441	VGND#2	B1#5	4.54614e-18
C442	a_30_368##5	VPWR#12	1.74636e-17
C443	B1	Y#2	1.04733e-16
C444	VGND#2	B1#7	4.70661e-18
C445	B1	Y#1	9.91255e-18
C446	B1#6	B1#5	3.87043e-18
C447	VGND#9	a_27_74##9	4.15829e-17
C448	A2#12	A2#7	4.51464e-17
C449	VGND#2	B1#9	5.36367e-18
C450	a_834_74##2	C1#7	1.84484e-18
C451	A1#4	VPWR#12	5.59944e-19
C452	VGND#2	A2#5	5.22847e-18
C453	A1#4	a_30_368##8	7.30958e-19
C454	C1	a_834_74##7	2.13261e-18
C455	VGND#2	A2#6	4.84539e-18
C456	A2#13	A2#12	4.69209e-17
C457	C1	Y#10	5.19964e-17
C458	A1#4	VPWR#13	6.13865e-19
C459	Y#5	C1#7	3.59252e-20
C460	a_27_74##11	a_27_74##9	1.78332e-18
C461	C1	a_834_74##8	4.90967e-17
C462	VGND#2	A2#9	8.06178e-19
C463	a_30_368##5	a_30_368##8	1.36226e-18
C464	A2	Y#3	1.03942e-16
C465	VGND	B1#6	1.60275e-18
C466	A1#7	A2#13	3.94387e-17
C467	a_27_74##8	A2	5.25291e-17
C468	a_27_74##6	A2	7.29043e-17
C469	a_27_74##10	a_27_74##8	5.40749e-19
C470	a_27_74##11	VGND#9	4.45083e-17
C471	VPWR#4	B1#9	1.83141e-19
C472	VGND#1	C1#8	6.3299e-20
C473	a_27_74#	B1	4.93185e-17
C474	a_30_368##5	VPWR#13	1.74539e-17
C475	A1#9	A1#7	4.844e-17
C476	a_27_74##2	B1	6.73882e-17
C477	VGND#3	A2#6	5.30118e-19
C478	a_27_74##10	A1	8.28905e-17
C479	VGND#10	VGND#9	2.03844e-18
C480	a_27_74##8	A1	1.3743e-17
C481	VGND#9	A1#2	7.52966e-19
C482	A1#11	A1#9	4.67636e-17
C483	Y	VPWR#2	9.06238e-17
C484	A1	a_30_368##5	9.20111e-17
C485	VPWR#5	A2#1	4.49144e-18
C486	a_30_368##6	a_30_368##5	6.21728e-19
C487	C1#8	C1#4	8.80869e-19
C488	Y#5	Y	4.50242e-18
C489	a_27_74##4	A2	7.0272e-17
C490	VPWR#5	A2#7	4.42929e-18
C491	A1#12	A1#11	4.73903e-17
C492	VGND#3	A2#8	3.83992e-20
C493	VGND#10	a_27_74##11	4.2284e-17
C494	Y#1	Y	3.1054e-19
C495	VPWR#5	A2#12	4.42929e-18
C496	C1#3	VPWR#9	1.1457e-18
C497	VGND#3	A2#9	4.9225e-18
C498	a_27_74##8	a_27_74##6	5.06977e-19
C499	VPWR	VPWR#6	8.56455e-17
C500	VPWR	VPWR#4	6.87357e-17
C501	VPWR	VPWR#3	5.90505e-17
C502	VPWR	VPWR#2	4.76767e-17
C503	a_27_74##12	a_27_74##11	1.89442e-18
C504	a_834_74#	Y	2.04521e-17
C505	VPWR	Y#3	1.39407e-17
C506	VGND#4	A2#11	5.30118e-19
C507	VPWR	Y#2	4.02421e-18
C508	VPWR	Y#1	2.99603e-18
C509	a_27_74##12	A1	5.33716e-17
C510	A2	Y#4	6.07333e-17
C511	a_27_74##12	VGND#10	5.70296e-17
C512	A2	a_30_368##3	3.04094e-17
C513	VGND#3	A2#11	4.82147e-18
C514	VGND	VGND#4	7.4619e-17
C515	VPWR	a_30_368##5	3.14808e-18
C516	VGND	VGND#3	7.20351e-17
C517	VPWR	a_30_368##2	3.29399e-17
C518	VGND#10	A1#5	5.8616e-19
C519	Y#3	a_30_368##2	1.66762e-17
C520	VGND	a_834_74##3	3.27481e-17
C521	A1#4	A1#7	2.31942e-19
C522	VGND	a_834_74##2	2.20488e-18
C523	A1	a_30_368##3	1.25211e-17
C524	Y	VPWR#9	5.25529e-18
C525	C1#3	VNB	2.47585e-17
C526	Y#7	Y	1.16822e-18
C527	C1#2	VNB	2.06835e-17
C528	B1#6	VNB	3.5349e-17
C529	B1#2	VNB	2.4758e-17
C530	Y	VPWR#10	5.83366e-21
C531	A2#10	VNB	2.79313e-17
C532	VGND#4	A1#1	4.96448e-18
C533	A2#8	VNB	5.52616e-17
C534	VGND	a_27_74##10	3.17911e-18
C535	VGND#1	C1#4	6.60556e-20
C536	A2#2	VNB	3.43737e-17
C537	VGND	a_27_74##8	3.30082e-18
C538	A1#11	A1#4	2.31942e-19
C539	A1#5	VNB	3.97686e-17
C540	VGND	a_27_74##6	3.00365e-18
C541	A1	a_30_368##6	4.52515e-17
C542	A1#2	VNB	2.89785e-17
C543	A2	B1#9	8.77305e-18
C544	Y#3	B1#9	1.72503e-18
C545	C1	C1#9	2.95044e-18
C546	VGND#3	A1#1	5.30118e-19
C547	C1	C1#8	1.15622e-17
C548	C1	B1#4	3.50709e-19
C549	VPWR	Y#7	1.72175e-17
C550	VGND	Y#10	4.23194e-18
C551	VGND#2	B1#3	4.96795e-20
C552	VPWR	VPWR#10	2.13753e-17
C553	VGND	a_27_74#	9.50181e-18
C554	VPWR	Y#8	1.81434e-17
C555	VGND	a_834_74##4	2.5186e-17
C556	Y	C1#1	4.4149e-18
C557	VPWR	VPWR#11	2.22062e-17
C558	VGND	a_27_74##2	7.84367e-18
C559	B1	C1#8	8.90704e-18
C560	VPWR	a_30_368#	2.52422e-17
C561	VGND	a_834_74##6	2.16714e-17
C562	VGND	a_27_74##4	1.70555e-17
C563	B1	B1#4	2.10392e-18
C564	VGND	a_27_74##7	1.18512e-17
C565	VPWR	Y#4	9.45917e-18
C566	B1	B1#8	2.2998e-18
C567	a_834_74##2	a_834_74#	3.22697e-18
C568	VPWR	a_30_368##3	2.45684e-17
C569	VGND	a_27_74##9	1.18512e-17
C570	B1	A2#1	1.26221e-19
C571	VGND	a_27_74##11	1.43086e-17
C572	VPWR	a_30_368##8	1.72175e-17
C573	VGND#4	A1#8	5.08708e-18
C574	a_834_74#	C1#1	4.49466e-17
C575	VGND	a_27_74##12	1.82067e-17
C576	VPWR	a_30_368##6	1.92756e-17
C577	A2#2	B1#9	1.05689e-17
C578	A2	B1#8	2.59831e-19
C579	A2	A2#1	2.1514e-18
C580	a_30_368##5	A1#5	9.05954e-19
C581	a_27_74##12	A1#5	1.47092e-18
C582	VGND#4	VNB	2.77948e-17
C583	VGND#3	VNB	2.61381e-17
C584	a_30_368##2	A2#10	1.26838e-19
C585	VPWR#1	C1	3.28506e-18
C586	C1#1	Y#6	1.31129e-17
C587	VPWR#6	VNB	4.0138e-17
C588	A2	A1#7	1.14433e-18
C589	VPWR#4	VNB	3.73456e-17
C590	VPWR#3	VNB	3.06513e-17
C591	VPWR#2	VNB	5.82319e-17
C592	Y	C1#9	3.29617e-18
C593	VGND#1	C1	2.55152e-18
C594	a_834_74##3	VNB	1.07698e-17
C595	Y	C1#8	1.91741e-19
C596	a_834_74##2	VNB	6.14816e-18
C597	Y#5	a_834_74#	1.85381e-17
C598	Y#5	VNB	6.53797e-18
C599	Y#3	VNB	3.75402e-18
C600	Y	B1#4	1.29462e-19
C601	Y#2	VNB	1.90559e-18
C602	VGND	B1#1	2.57217e-18
C603	a_27_74##10	VNB	1.2546e-18
C604	A1	A1#7	1.20494e-19
C605	a_27_74##8	VNB	1.93615e-18
C606	VGND	B1#5	1.30359e-18
C607	a_27_74##6	VNB	7.66989e-19
C608	a_834_74##2	Y#6	3.20017e-17
C609	a_834_74#	C1#5	2.12453e-18
C610	VGND	B1#7	1.20968e-18
C611	VGND	B1#9	2.42003e-18
C612	C1	C1#4	2.71863e-17
C613	VGND	A2#5	1.15267e-18
C614	A1	A1#11	2.05823e-18
C615	a_30_368##2	VNB	6.09424e-18
C616	VGND	A2#6	6.99989e-19
C617	VPWR	C1#8	1.22376e-19
C618	VPWR#1	C1#2	3.21785e-19
C619	a_834_74#	VNB	5.3036e-17
C620	VGND	A2#9	6.36564e-19
C621	A1	A1#12	3.35845e-18
C622	VPWR	B1#4	5.65877e-19
C623	VGND	A2#11	6.99989e-19
C624	Y#10	VNB	2.61159e-19
C625	a_834_74##8	VNB	5.6258e-18
C626	VGND	A1#1	7.30277e-19
C627	VPWR	B1#8	5.25086e-19
C628	a_27_74#	VNB	1.07068e-17
C629	VGND#4	A1#10	4.07817e-19
C630	a_834_74##4	VNB	3.01476e-18
C631	VGND	A1#8	5.94404e-20
C632	VPWR#4	B1#6	1.75299e-19
C633	VPWR	A2#1	2.12824e-18
C634	a_27_74##2	VNB	8.76529e-19
C635	B1	B1#3	2.13169e-17
C636	a_834_74##6	VNB	3.25583e-18
C637	VGND	A1#10	7.51004e-19
C638	a_27_74##4	VNB	6.46006e-18
C639	VPWR	A2#7	1.52941e-18
C640	VGND#7	VNB	4.87279e-20
C641	VGND	A1#6	7.48256e-19
C642	a_27_74##7	VNB	4.55126e-18
C643	VPWR	A2#12	1.58411e-18
C644	VGND#8	VNB	3.84357e-20
C645	a_27_74##9	VNB	4.55126e-18
C646	VGND#9	VNB	4.33049e-19
C647	VPWR	A2#13	1.505e-18
C648	a_27_74##11	VNB	2.12109e-18
C649	VGND#10	VNB	1.46972e-18
C650	A2	B1#3	5.34243e-20
C651	VPWR	A1#7	6.21117e-19
C652	VGND#4	VGND#3	1.14921e-18
C653	a_27_74##12	VNB	4.64558e-17
C654	a_30_368##2	A2#8	1.32988e-19
C655	C1#5	Y#6	1.79421e-17
C656	Y	VPWR#1	5.18431e-17
C657	Y#7	VNB	2.20229e-18
C658	VPWR	A1#9	7.83421e-19
C659	VPWR#10	VNB	1.03276e-18
C660	Y#8	VNB	5.43418e-18
C661	VGND#1	Y	4.66904e-18
C662	VPWR	A1#11	7.49657e-19
C663	VPWR#11	VNB	8.54622e-18
C664	a_30_368#	VNB	1.27353e-17
C665	VPWR	A1#12	1.15871e-18
C666	a_30_368##3	VNB	2.33653e-18
C667	Y#10	C1#1	2.49041e-19
C668	VPWR#12	VNB	2.92383e-18
C669	a_30_368##8	VNB	2.1429e-18
C670	VPWR#13	VNB	2.82484e-18
C671	Y	C1#4	5.70111e-20
C672	a_30_368##6	VNB	4.97112e-17
C673	A1	A1#4	3.86566e-17
C674	C1#1	VNB	5.2976e-17
C675	C1#5	VNB	2.54966e-17
C676	Y#5	Y#6	2.99255e-19
C677	C1#6	VNB	2.55944e-17
C678	VPWR	VPWR#5	7.58701e-17
C679	C1#7	VNB	3.11176e-17
C680	B1#1	VNB	3.7585e-17
C681	B1#5	VNB	2.93737e-17
C682	B1#7	VNB	2.60621e-17
C683	B1#9	VNB	4.64593e-17
C684	B1	C1	3.23594e-17
C685	A2#5	VNB	2.54654e-17
C686	A2#6	VNB	2.56629e-17
C687	a_27_74##6	B1#9	3.80638e-20
C688	A2#9	VNB	2.54098e-17
C689	VGND	VGND#1	7.34856e-17
C690	a_834_74##2	a_834_74##7	1.04798e-18
C691	C1#5	a_834_74##7	1.44708e-17
C692	A2#11	VNB	2.5483e-17
C693	A1#1	VNB	2.58804e-17
C694	A1#8	VNB	2.69335e-17
C695	A1#10	VNB	2.55235e-17
C696	VGND	VGND#2	1.46095e-16
C697	A1#6	VNB	3.57237e-17
C698	A2	B1	3.64618e-17
C699	C1#9	VNB	3.41515e-17
C700	a_30_368##5	A1#2	9.8447e-19
C701	C1#8	VNB	5.79731e-17
C702	B1#4	VNB	2.79555e-17
C703	B1#8	VNB	3.05455e-17
C704	a_834_74##3	Y#10	9.5607e-18
C705	A2#1	VNB	3.74308e-17
C706	VPWR#10	Y#7	6.22435e-17
C707	A2#7	VNB	3.21719e-17
C708	C1	Y	4.59546e-17
C709	A2#12	VNB	3.18316e-17
C710	A2#13	VNB	3.32891e-17
C711	A1	A2	3.28972e-17
C712	A1#7	VNB	3.58888e-17
C713	A1#9	VNB	3.22623e-17
C714	Y#6	C1#6	5.96268e-19
C715	A1#11	VNB	3.24358e-17
C716	VPWR	C1	4.90301e-18
C717	A1#12	VNB	4.40377e-17
C718	VPWR	B1	8.46802e-18
C719	VPWR#1	VNB	1.38762e-16
C720	VGND#1	VNB	2.10684e-16
C721	VPWR#5	VNB	4.42458e-17
C722	VGND	C1	7.95291e-18
C723	VPWR	A2	1.54692e-17
C724	VGND#2	VNB	6.84458e-17
C725	C1#4	VNB	3.72341e-17
C726	VGND	B1	7.17755e-18
C727	VPWR	A1	1.25535e-17
C728	B1#3	VNB	3.31837e-17
C729	VGND	A2	1.24116e-17
C730	Y#10	C1#5	5.90371e-19
C731	A1#4	VNB	5.74284e-17
C732	VGND	A1	1.02761e-17
C733	C1	VNB	1.72394e-17
C734	B1	VNB	1.25436e-17
C735	A2	VNB	2.01554e-17
C736	A1	VNB	4.51098e-17
C737	Y	VNB	1.06545e-16
C738	VPWR	VNB	2.9917e-16
C739	VGND	VNB	3.00729e-16
C740	C1#6	a_834_74##7	1.44708e-17
C741	VGND#5	A1#10	4.38987e-18
C742	VGND#5	a_27_74##12	2.10084e-17
C743	VGND#5	A1#6	4.94812e-18
C744	VGND#5	a_27_74##10	2.91756e-19
C745	a_30_368##6	VPWR#7	2.11316e-17
C746	VPWR#7	A1#12	7.70872e-18
C747	A1	VPWR#7	4.67611e-19
C748	VPWR#7	A1#4	3.41186e-20
C749	VGND#5	VGND#4	1.22239e-18
C750	VGND#5	A1#4	5.21403e-20
C751	VPWR#7	A1#7	8.1728e-20
C752	VPWR#7	VNB	4.68322e-17
C753	a_30_368##5	VPWR#7	3.13618e-19
C754	VGND	VGND#5	1.01527e-16
C755	a_30_368##8	VPWR#7	8.03471e-18
C756	VPWR#7	A1#9	5.30308e-19
C757	VGND#5	VNB	4.8637e-17
C758	VPWR	VPWR#7	8.87562e-17
C759	VGND#5	A1#1	1.12033e-19
C760	VGND#5	a_27_74##11	6.9777e-18
C761	VPWR#7	VPWR#6	6.93111e-19
C762	VGND#5	A1#8	7.07305e-19
C763	VPWR#7	A1#11	5.25568e-18
*
*
.ENDS sky130_fd_sc_hs__o211ai_4
*
