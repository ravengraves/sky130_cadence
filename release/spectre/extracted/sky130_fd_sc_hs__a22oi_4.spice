* Extracted by Quantus, converted by sky130cad/quantus.py
*
*
*
*                       LINUX           Wed Nov 18 08:09:29 2026
*
*
*
*  PROGRAM  advgen
*
*  Name           : advgen - Quantus - (64-bit)
*  Version        : 25.1.0-p047
*  Build Date     : Thu Dec 11 23:20:30 PST 2025
*
*  HSPICE LIBRARY
*
*  OPERATING_TEMPERATURE 150
*  QRC_TECH_DIR <path>/tech
*
*
*

*
.SUBCKT sky130_fd_sc_hs__a22oi_4 VPB VNB VGND VPWR Y B2 B1 A1 A2
*
*
*  caps2d version: 10
*
*
*       TRANSISTOR CARDS
*
*
XM20 VGND#10 B2#13 a_48_74##3 VNB sky130_fd_pr__nfet_01v8_lvt l=0.15 w=0.74 ad=0.2072 as=0.1961 pd=2.04 ps=2.01
XM17 VGND#10 B2#11 a_48_74# VNB sky130_fd_pr__nfet_01v8_lvt l=0.15 w=0.74 ad=0.2072 as=0.2072 pd=2.04 ps=2.04
XM22 a_48_74# B2#9 VGND#9 VNB sky130_fd_pr__nfet_01v8_lvt l=0.15 w=0.74 ad=0.2072 as=0.2072 pd=2.04 ps=2.04
XM28 a_48_74##4 B2#8 VGND#9 VNB sky130_fd_pr__nfet_01v8_lvt l=0.15 w=0.74 ad=0.2072 as=0.2072 pd=2.04 ps=2.04
XM31 a_48_74##4 B1#7 Y#9 VNB sky130_fd_pr__nfet_01v8_lvt l=0.15 w=0.74 ad=0.2072 as=0.2072 pd=2.04 ps=2.04
XM7 Y#9 B1#11 a_48_74##8 VNB sky130_fd_pr__nfet_01v8_lvt l=0.15 w=0.74 ad=0.2072 as=0.2072 pd=2.04 ps=2.04
XM0 Y#4 B1#10 a_48_74##8 VNB sky130_fd_pr__nfet_01v8_lvt l=0.15 w=0.74 ad=0.2072 as=0.2072 pd=2.04 ps=2.04
XM26 a_48_74##6 B1#8 Y#4 VNB sky130_fd_pr__nfet_01v8_lvt l=0.15 w=0.74 ad=0.1961 as=0.2072 pd=2.01 ps=2.04
XM30 a_840_74##7 A1#14 Y#10 VNB sky130_fd_pr__nfet_01v8_lvt l=0.15 w=0.74 ad=0.1961 as=0.2072 pd=2.01 ps=2.04
XM12 Y#10 A1#12 a_840_74##5 VNB sky130_fd_pr__nfet_01v8_lvt l=0.15 w=0.74 ad=0.2072 as=0.2072 pd=2.04 ps=2.04
XM16 a_840_74##5 A1#10 Y#12 VNB sky130_fd_pr__nfet_01v8_lvt l=0.15 w=0.74 ad=0.2072 as=0.2072 pd=2.04 ps=2.04
XM5 Y#12 A1#1 a_840_74##3 VNB sky130_fd_pr__nfet_01v8_lvt l=0.15 w=0.74 ad=0.2072 as=0.2072 pd=2.04 ps=2.04
XM8 a_840_74##3 A2#10 VGND#8 VNB sky130_fd_pr__nfet_01v8_lvt l=0.15 w=0.74 ad=0.2072 as=0.2072 pd=2.04 ps=2.04
XM1 a_840_74##8 A2#8 VGND#8 VNB sky130_fd_pr__nfet_01v8_lvt l=0.15 w=0.74 ad=0.2072 as=0.2072 pd=2.04 ps=2.04
XM13 VGND#1 A2#6 a_840_74##8 VNB sky130_fd_pr__nfet_01v8_lvt l=0.15 w=0.74 ad=0.2072 as=0.2072 pd=2.04 ps=2.04
XM6 VGND#1 A2#5 a_840_74# VNB sky130_fd_pr__nfet_01v8_lvt l=0.15 w=0.74 ad=0.2072 as=0.1961 pd=2.04 ps=2.01
XM3 Y#7 B2#7 a_45_368##10 VPB sky130_fd_pr__pfet_01v8 l=0.15 w=1.12 ad=0.336 as=0.308 pd=2.84 ps=2.79
XM9 Y#7 B2#12 a_45_368##16 VPB sky130_fd_pr__pfet_01v8 l=0.15 w=1.12 ad=0.336 as=0.336 pd=2.84 ps=2.84
XM23 a_45_368##16 B2#10 Y#13 VPB sky130_fd_pr__pfet_01v8 l=0.15 w=1.12 ad=0.336 as=0.336 pd=2.84 ps=2.84
XM2 a_45_368##15 B2#1 Y#13 VPB sky130_fd_pr__pfet_01v8 l=0.15 w=1.12 ad=0.336 as=0.336 pd=2.84 ps=2.84
XM15 Y#1 B1#13 a_45_368##15 VPB sky130_fd_pr__pfet_01v8 l=0.15 w=1.12 ad=0.336 as=0.336 pd=2.84 ps=2.84
XM27 a_45_368##14 B1#12 Y#1 VPB sky130_fd_pr__pfet_01v8 l=0.15 w=1.12 ad=0.336 as=0.336 pd=2.84 ps=2.84
XM25 a_45_368##14 B1#9 Y#8 VPB sky130_fd_pr__pfet_01v8 l=0.15 w=1.12 ad=0.336 as=0.336 pd=2.84 ps=2.84
XM11 Y#8 B1#1 a_45_368##5 VPB sky130_fd_pr__pfet_01v8 l=0.15 w=1.12 ad=0.336 as=0.336 pd=2.84 ps=2.84
XM29 a_45_368##5 A1#8 VPWR#8 VPB sky130_fd_pr__pfet_01v8 l=0.15 w=1.12 ad=0.336 as=0.336 pd=2.84 ps=2.84
XM18 VPWR#8 A1#13 a_45_368##13 VPB sky130_fd_pr__pfet_01v8 l=0.15 w=1.12 ad=0.336 as=0.336 pd=2.84 ps=2.84
XM21 VPWR#6 A1#11 a_45_368##13 VPB sky130_fd_pr__pfet_01v8 l=0.15 w=1.12 ad=0.5936 as=0.336 pd=3.3 ps=2.84
XM19 a_45_368##12 A1#9 VPWR#6 VPB sky130_fd_pr__pfet_01v8 l=0.15 w=1.12 ad=0.336 as=0.5936 pd=2.84 ps=3.3
XM14 VPWR#4 A2#12 a_45_368##12 VPB sky130_fd_pr__pfet_01v8 l=0.15 w=1.12 ad=0.336 as=0.336 pd=2.84 ps=2.84
XM4 a_45_368##11 A2#11 VPWR#4 VPB sky130_fd_pr__pfet_01v8 l=0.15 w=1.12 ad=0.336 as=0.336 pd=2.84 ps=2.84
XM10 a_45_368##11 A2#7 VPWR#1 VPB sky130_fd_pr__pfet_01v8 l=0.15 w=1.12 ad=0.336 as=0.336 pd=2.84 ps=2.84
XM24 VPWR#1 A2#1 a_45_368# VPB sky130_fd_pr__pfet_01v8 l=0.15 w=1.12 ad=0.336 as=0.308 pd=2.84 ps=2.79
*
*
*       RESISTOR AND CAP/DIODE CARDS
*
Rg1	B2#1	B2#2	453.701172
Rg2	B2#2	B2#3	66.369736
Rg3	B2#3	B2#4	33.804066
Rg4	B2#4	B2#5	45.616405
Rg5	B2#5	B2#6	66.386436
Rg6	B2#6	B2#7	458.777771
Rg7	B2#2	B2#8	411.287628
Rg8	B2#3	B2#9	395.494293
Rg9	B2#3	B2#10	448.603302
Rg10	B2#5	B2#11	394.561310
Rg11	B2#5	B2#12	446.660797
Rg12	B2#6	B2#13	401.601685
Rg13	B1#1	B1#2	445.675507
Rg14	B1#2	B1#3	44.165844
Rg15	B1#3	B1#4	23.632120
Rg16	B1#4	B1#5	59.126259
Rg17	B1#5	B1#6	51.034912
Rg18	B1#6	B1#7	396.493347
Rg19	B1#2	B1#8	361.512299
Rg20	B1#3	B1#9	398.356903
Rg21	B1#4	B1#10	372.053619
Rg22	B1#5	B1#11	377.887207
Rg23	B1#5	B1#12	435.115021
Rg24	B1#6	B1#13	457.312805
Rg25	A1#1	A1#2	392.634735
Rg26	A1#2	A1#3	49.142651
Rg27	A1#3	A1#4	58.683800
Rg28	A1#4	A1#5	21.000185
Rg29	A1#5	A1#6	50.285873
Rg30	A1#6	A1#7	30.253599
Rg31	A1#7	A1#8	589.252686
Rg32	A1#2	A1#9	450.494476
Rg33	A1#3	A1#10	370.752045
Rg34	A1#4	A1#11	451.603058
Rg35	A1#5	A1#12	396.201660
Rg36	A1#6	A1#13	419.000305
Rg37	A1#7	A1#14	422.572784
Rg38	A2#1	A2#2	449.655212
Rg39	A2#2	A2#3	66.369736
Rg40	A2#3	A2#4	57.428749
Rg41	A2#2	A2#5	397.555725
Rg42	A2#3	A2#6	394.561310
Rg43	A2#3	A2#7	446.660797
Rg44	A2#4	A2#8	383.525421
Rg45	A2#4	A2#9	90.033310
Rg46	A2#9	A2#10	411.287628
Rg47	A2#4	A2#11	430.316833
Rg48	A2#9	A2#12	453.701172
Rf1	B2	B2#14	12.224110
Rf2	B2#14	B2	2.444822
Rf3	B1#14	B1	0.997598
Rf4	B1#5	B1#16	54.408531
Rf5	B1#14	B1#16	3.972836
Rf6	B1#17	B1	0.997598
Rf7	B1#16	B1#17	10.696096
Rf8	a_48_74#	a_48_74##2	21.339512
Rf9	a_48_74##2	a_48_74##3	83.170883
Rf10	a_48_74##2	a_48_74##5	86.947624
Rf11	a_48_74##5	a_48_74##7	97.246605
Rf12	a_48_74##7	a_48_74##8	15.969686
Rf13	a_48_74##4	a_48_74##5	7.500000
Rf14	a_48_74##6	a_48_74##7	15.000000
Rf15	A1	A1#15	13.752123
Rf16	A1#15	A1	0.916808
Rf17	Y#1	Y#2	21.914129
Rf18	Y#2	Y#3	61.225365
Rf19	Y#3	Y	45.205070
Rf20	Y	Y#5	3.123488
Rf21	Y#2	Y#6	65.941528
Rf22	Y#6	Y#7	84.603409
Rf23	Y#3	Y#8	27.172836
Rf24	Y#5	Y#9	80.210579
Rf25	Y#5	Y#11	53.717983
Rf26	Y#11	Y#12	52.945065
Rf27	Y#6	Y#13	21.914129
Rf28	Y#4	Y#5	15.000000
Rf29	Y#10	Y#11	15.000000
Rf30	A2	A2#13	5.195247
Rf31	A2#13	A2	9.473685
Rf32	a_840_74#	a_840_74##2	80.271690
Rf33	a_840_74##2	a_840_74##4	81.103577
Rf34	a_840_74##4	a_840_74##6	58.010189
Rf35	a_840_74##6	a_840_74##7	57.053680
Rf36	a_840_74##2	a_840_74##8	21.341251
Rf37	a_840_74##3	a_840_74##4	7.500000
Rf38	a_840_74##5	a_840_74##6	15.000000
Rf39	a_45_368#	a_45_368##2	86.731674
Rf40	a_45_368##2	a_45_368##3	68.798325
Rf41	a_45_368##3	a_45_368##4	76.768654
Rf42	a_45_368##4	a_45_368##6	84.948563
Rf43	a_45_368##6	a_45_368##7	87.345375
Rf44	a_45_368##7	a_45_368##8	65.696381
Rf45	a_45_368##8	a_45_368##9	65.696381
Rf46	a_45_368##9	a_45_368##10	98.480812
Rf47	a_45_368##2	a_45_368##11	28.362816
Rf48	a_45_368##3	a_45_368##12	20.631947
Rf49	a_45_368##4	a_45_368##13	20.631947
Rf50	a_45_368##7	a_45_368##14	19.724552
Rf51	a_45_368##8	a_45_368##15	19.724552
Rf52	a_45_368##9	a_45_368##16	19.724552
Rf53	a_45_368##5	a_45_368##6	5.000000
Rf54	VPWR#1	VPWR#2	36.607323
Rf55	VPWR#2	VPWR#3	75.765358
Rf56	VPWR#3	VPWR#4	33.109421
Rf57	VPWR#3	VPWR#5	74.056381
Rf58	VPWR#5	VPWR#6	26.129707
Rf59	VPWR#5	VPWR#7	74.056381
Rf60	VPWR#7	VPWR#8	33.109421
Rf61	VPWR#7	VPWR#9	75.947983
Rf62	VGND#1	VGND#2	45.737534
Rf63	VGND#2	VGND#3	75.420929
Rf64	VGND#3	VGND#4	224.663086
Rf65	VGND#4	VGND#5	124.526566
Rf66	VGND#5	VGND#6	65.753731
Rf68	VGND#3	VGND#8	41.120300
Rf69	VGND#5	VGND#9	38.247387
Rf70	VGND#6	VGND#10	45.213318
Rf73	A1#4	A1#15	53.410934
Rf74	A2#4	A2#13	40.058201
Rf71	B2#4	B2#14	40.058201
Re1	VPWR#2	VPWR	4.549932
Re2	VPWR	VPWR#9	0.974985
Re3	VGND#2	VGND	4.549932
Re4	VGND	VGND#4	0.974985
*
*       CAPACITOR CARDS
*
*
C1	a_45_368##14	a_45_368##5	4.88921e-18
C2	a_840_74#	VGND#1	5.02057e-17
C3	a_48_74##8	A1#10	4.88731e-19
C4	a_48_74##2	B2#11	2.06291e-17
C5	a_45_368##2	A2#11	1.38757e-17
C6	a_840_74##7	A1#14	4.85213e-17
C7	Y#4	A1#12	6.14859e-19
C8	a_45_368##12	VPWR#5	7.25265e-18
C9	a_45_368##14	Y#8	3.48691e-17
C10	a_48_74##4	Y#6	4.96829e-18
C11	a_45_368##3	a_45_368##2	8.60298e-19
C12	VPWR#5	A1#11	2.58799e-18
C13	a_840_74##8	a_840_74#	2.09171e-18
C14	a_48_74##8	A1#12	9.12362e-19
C15	a_45_368##3	A2#12	1.41089e-17
C16	VPWR#7	VPWR#6	5.4365e-19
C17	a_840_74##7	B1#8	1.78602e-18
C18	VPWR#9	B1#6	5.25226e-21
C19	a_48_74##2	B2#13	2.45275e-19
C20	a_45_368##12	VPWR#3	6.44151e-18
C21	Y#4	A1#14	2.5221e-18
C22	Y#1	Y#8	2.08705e-18
C23	VPWR#9	B1#4	4.00357e-20
C24	a_45_368##2	A2#12	1.5254e-19
C25	B1#4	a_48_74##6	2.34333e-19
C26	B1#8	a_48_74##6	2.19699e-17
C27	a_45_368##2	a_45_368#	8.60298e-19
C28	VPWR#7	A1#13	1.84438e-18
C29	a_45_368##4	A1#9	2.19146e-19
C30	a_48_74##8	A1#14	3.97849e-18
C31	a_840_74##8	VGND#1	4.16239e-17
C32	A1#7	A1#2	3.5619e-18
C33	Y#1	a_45_368##14	3.4678e-17
C34	Y#4	A1#2	1.65347e-19
C35	a_840_74##7	B1#10	3.54682e-19
C36	VPWR#9	B2#6	1.12044e-20
C37	Y#4	B1#8	3.9283e-17
C38	a_45_368##3	A1#9	2.66094e-17
C39	VPWR#9	B2#5	5.13283e-20
C40	VGND#4	A1#7	1.11749e-19
C41	a_45_368##13	VPWR#7	6.49096e-18
C42	Y#6	a_45_368##9	3.19319e-18
C43	VPWR#6	VPWR#3	5.42588e-19
C44	a_45_368##2	A1#9	6.57987e-20
C45	a_45_368##15	a_45_368##14	5.01824e-18
C46	VPWR#9	B2#2	1.09861e-20
C47	a_48_74##8	B1#8	2.45986e-17
C48	Y#4	B1#6	5.5239e-20
C49	a_45_368##2	VPWR#1	2.46367e-17
C50	VGND#8	VGND#1	1.35203e-18
C51	a_840_74##7	B1#11	1.18306e-19
C52	VPWR#7	A1#8	1.85197e-18
C53	a_45_368##4	A1#11	2.02059e-17
C54	a_45_368##13	VPWR#5	7.20319e-18
C55	Y#4	B1#10	3.47067e-17
C56	Y#3	B1#4	8.17758e-18
C57	VGND#5	B1#6	2.61303e-20
C58	a_45_368##15	Y#1	3.46413e-17
C59	VPWR#7	A1#7	2.72949e-20
C60	VGND#4	B1#6	2.6711e-21
C61	Y#6	B2#5	3.14783e-18
C62	a_48_74##4	Y#2	2.76669e-18
C63	a_45_368##3	A1#11	2.19146e-19
C64	VGND#4	B1#4	8.04014e-20
C65	Y#6	a_45_368##8	3.19319e-18
C66	a_48_74##8	B1#10	4.16537e-17
C67	Y#4	B1#4	3.34893e-17
C68	VGND#8	a_840_74##8	4.16239e-17
C69	A2#9	A2#4	4.0818e-18
C70	Y#4	B1#11	8.93948e-19
C71	Y#13	Y#1	2.43716e-18
C72	Y#9	B1#10	1.0807e-18
C73	a_45_368##2	a_45_368##11	3.80666e-18
C74	VGND#3	A1#2	5.50469e-20
C75	Y#2	B1#6	5.59772e-19
C76	a_45_368##4	A1#13	1.39774e-17
C77	A2#4	A2#2	4.03955e-18
C78	a_48_74##8	B1#11	2.73647e-17
C79	a_45_368##3	VPWR#4	1.56403e-17
C80	a_48_74##4	B1#10	1.69348e-19
C81	Y#13	a_45_368##15	3.4678e-17
C82	a_840_74##3	a_840_74##8	1.97519e-18
C83	a_45_368##5	VPWR#7	1.67994e-17
C84	VGND#5	a_48_74##2	2.91756e-19
C85	Y#9	B1#11	4.32912e-17
C86	a_48_74##8	B1#6	2.38697e-19
C87	Y#2	B1#4	4.99004e-19
C88	a_45_368##2	VPWR#4	1.55915e-17
C89	a_48_74##8	B1#7	3.70302e-19
C90	a_45_368##16	a_45_368##15	5.01824e-18
C91	a_48_74##4	B1#11	4.01452e-19
C92	a_45_368##4	A1#8	2.86165e-19
C93	VPWR#5	A1#7	1.30742e-20
C94	Y#6	B2#2	1.12856e-18
C95	a_45_368##3	a_45_368##12	2.03959e-18
C96	a_840_74##3	VGND#8	4.74674e-17
C97	Y#9	B1#7	3.24737e-17
C98	a_48_74##8	B1#4	1.13796e-18
C99	a_45_368##16	Y#13	3.46413e-17
C100	a_45_368##7	B1#1	1.27047e-17
C101	a_48_74##8	B2#8	1.92178e-19
C102	a_45_368##4	VPWR#6	2.24397e-17
C103	a_48_74##4	B1#7	4.64741e-17
C104	B1#4	A1#7	2.8842e-18
C105	Y#7	Y#13	2.54942e-18
C106	a_45_368##10	a_45_368##15	2.85759e-20
C107	Y#9	B2#8	1.31109e-18
C108	a_45_368##4	B1#1	7.36537e-20
C109	Y#3	A1#11	3.84883e-20
C110	a_48_74##2	a_48_74##4	5.45819e-19
C111	VGND#9	B1#7	1.02509e-18
C112	a_45_368##3	VPWR#6	2.26575e-17
C113	B2#5	Y#13	2.74109e-19
C114	a_48_74##4	B2#8	2.5783e-17
C115	Y#3	a_45_368##7	3.54799e-18
C116	Y#9	B1#6	2.62064e-18
C117	Y#7	a_45_368##16	4.56795e-17
C118	a_45_368##7	B1#9	2.10037e-17
C119	a_48_74#	B1#7	1.42094e-19
C120	Y#4	B2#5	1.00915e-19
C121	Y#2	a_45_368##8	3.19319e-18
C122	a_45_368##4	a_45_368##13	1.68352e-18
C123	VGND#9	B2#8	3.09993e-17
C124	a_840_74##3	Y#12	4.79355e-17
C125	a_48_74##2	VGND#9	2.25092e-17
C126	Y#3	A1#13	6.52923e-20
C127	a_45_368##10	a_45_368##16	4.31681e-18
C128	a_48_74##4	B2#9	3.97516e-19
C129	a_48_74#	B2#8	3.25149e-19
C130	B2#2	Y#13	2.70455e-19
C131	Y#2	a_45_368##7	3.19319e-18
C132	VGND#9	B2#9	2.82092e-17
C133	a_45_368##7	B1#12	2.10313e-17
C134	a_45_368##10	Y#7	7.26672e-17
C135	a_45_368##4	VPWR#8	2.37692e-17
C136	a_48_74##4	B2#11	1.67688e-19
C137	a_48_74##2	a_48_74#	5.30077e-19
C138	B2#9	a_48_74#	1.12564e-17
C139	Y#3	A1#8	1.00932e-18
C140	Y#4	B2#2	2.07716e-19
C141	B2#5	a_45_368##16	1.46371e-18
C142	VGND#9	B2#11	1.22366e-18
C143	VGND#10	B2#9	9.10358e-20
C144	a_45_368##8	B1#13	2.10037e-17
C145	Y#12	a_840_74##5	3.83471e-17
C146	a_45_368##7	Y#8	2.17691e-17
C147	a_48_74#	B2#11	3.13683e-17
C148	B1#6	B1#5	3.26814e-18
C149	a_45_368##5	a_45_368##4	8.87901e-19
C150	a_48_74##2	VGND#10	2.0926e-17
C151	VGND#5	B2#5	5.39539e-20
C152	B1#5	B1#4	3.26814e-18
C153	Y#3	B1#1	7.29328e-18
C154	VGND#9	B2#13	1.13166e-19
C155	B2#11	VGND#10	1.36148e-17
C156	a_840_74##7	a_840_74##3	9.68848e-19
C157	a_48_74#	B2#13	1.66262e-18
C158	B2#6	Y#7	1.4151e-18
C159	a_48_74##3	B2#11	7.72348e-19
C160	a_45_368##8	B2#1	2.10313e-17
C161	a_45_368##7	a_45_368##14	4.35239e-20
C162	A2#6	A2#5	3.67895e-17
C163	a_48_74##3	a_48_74##2	6.43198e-19
C164	VGND#10	B2#13	2.84496e-17
C165	Y#3	B1#9	1.79445e-17
C166	B2#5	Y#7	1.71633e-18
C167	a_840_74##5	Y#10	2.01186e-17
C168	a_48_74##3	B2#13	3.96438e-17
C169	a_45_368##8	Y#1	9.56665e-18
C170	a_45_368##9	B2#10	2.10037e-17
C171	A2#8	A2#6	4.00265e-17
C172	a_45_368##7	Y#1	1.01425e-17
C173	Y#3	B1#12	5.59212e-19
C174	Y#2	B1#12	1.53146e-17
C175	VGND#5	B2#2	1.6096e-20
C176	a_45_368##10	B2#6	3.71993e-20
C177	a_45_368##8	a_45_368##15	4.35239e-20
C178	a_45_368##9	B2#12	2.10321e-17
C179	Y#10	a_840_74##7	2.37205e-17
C180	Y#4	Y#12	1.53961e-19
C181	A2#10	A2#8	3.68712e-17
C182	a_45_368##9	Y#13	9.56665e-18
C183	Y#3	B1#13	2.35137e-19
C184	a_45_368#	A2#1	4.16983e-17
C185	A1#7	A1#11	2.31942e-19
C186	Y#2	B1#13	1.5214e-17
C187	Y#6	B2#1	1.8584e-17
C188	VPWR#1	A2#1	4.75535e-17
C189	a_45_368##8	Y#13	1.01425e-17
C190	a_45_368#	A2#7	1.20191e-18
C191	a_45_368##11	A2#1	4.62666e-19
C192	A1#1	A2#10	4.09007e-17
C193	Y#3	B2#1	1.26062e-19
C194	a_45_368##9	a_45_368##16	4.35239e-20
C195	VPWR#1	A2#7	4.60423e-17
C196	Y#6	B2#10	1.5214e-17
C197	a_45_368#	A2#11	4.14908e-19
C198	A2#7	a_45_368##11	2.14335e-17
C199	a_48_74##4	B2#2	2.98499e-18
C200	VPWR#1	A2#11	2.64683e-18
C201	VPWR#4	A2#7	2.13205e-18
C202	a_840_74##7	A1#8	5.27696e-19
C203	Y#3	B2#10	8.45173e-20
C204	A1#10	A1#1	4.062e-17
C205	VGND#9	B2#5	6.20643e-19
C206	a_45_368##9	Y#7	1.66154e-17
C207	a_45_368#	A2#12	1.42355e-19
C208	A2#11	a_45_368##11	2.61267e-17
C209	Y#4	a_840_74##7	3.47717e-17
C210	a_45_368##12	A2#7	1.07786e-19
C211	a_48_74##8	Y#10	4.82498e-20
C212	Y#4	A1#8	1.45208e-17
C213	VPWR#4	A2#11	5.19665e-17
C214	VPWR#2	VPWR#3	1.31059e-17
C215	VGND#3	a_840_74##8	6.50647e-18
C216	a_45_368##11	A2#12	2.23229e-19
C217	VGND#3	A2#6	8.33006e-19
C218	a_45_368#	A1#9	9.41412e-20
C219	a_45_368##12	A2#11	4.18778e-19
C220	A1#12	A1#10	4.10001e-17
C221	a_840_74#	a_45_368#	1.64816e-17
C222	VGND#2	VGND#3	1.17221e-17
C223	a_48_74##8	a_840_74##7	3.12855e-17
C224	Y#3	a_45_368##5	3.65027e-17
C225	VPWR#4	A2#12	4.59907e-17
C226	a_48_74##2	B2#6	1.29716e-18
C227	VGND#9	B2#2	1.76082e-19
C228	a_45_368##11	A1#9	9.62907e-20
C229	A2#12	a_45_368##12	1.78745e-17
C230	a_45_368##3	A2#9	8.71697e-19
C231	A2#2	VPWR#1	6.38968e-19
C232	a_48_74##8	a_48_74##6	1.37413e-18
C233	VPWR#4	A1#9	2.15582e-18
C234	A1#14	A1#12	4.09983e-17
C235	VPWR#6	A2#12	7.82013e-19
C236	VGND#3	A2#8	5.7664e-18
C237	A1#8	A1#7	3.98147e-18
C238	Y#3	Y#8	4.61996e-18
C239	a_48_74##2	B2#5	6.56323e-18
C240	a_45_368##2	VPWR#2	3.04522e-18
C241	a_45_368##12	A1#9	4.38315e-17
C242	a_45_368##8	B1#6	3.75908e-20
C243	Y#4	a_48_74##8	9.07471e-17
C244	VPWR#4	A1#11	2.86497e-19
C245	A1#9	VPWR#6	3.57786e-17
C246	a_45_368##4	A1#7	8.00154e-18
C247	B1#8	A1#14	4.83663e-18
C248	a_45_368##12	A1#11	3.20702e-19
C249	a_45_368##13	A1#9	3.20702e-19
C250	VGND#3	a_840_74##3	2.30246e-17
C251	VGND#10	B2#6	4.08925e-19
C252	Y#3	a_45_368##14	1.55836e-17
C253	a_45_368##9	VPWR#9	6.51113e-17
C254	VGND#3	A2#10	5.14573e-18
C255	A1#11	VPWR#6	4.07308e-17
C256	VPWR#8	A1#9	2.86497e-19
C257	Y#9	Y#4	4.1599e-18
C258	a_45_368##8	VPWR#9	6.20136e-17
C259	a_45_368##7	VPWR#9	7.63488e-17
C260	a_45_368##13	A1#11	5.109e-17
C261	a_45_368##5	A1#9	1.31446e-19
C262	Y#2	a_45_368##14	1.46648e-17
C263	a_840_74#	A2#2	1.02005e-18
C264	B1#10	B1#8	3.93395e-17
C265	VGND#10	B2#5	3.56005e-19
C266	VGND#2	a_840_74##2	1.90466e-18
C267	Y#6	a_45_368##15	1.64904e-17
C268	VPWR#6	A1#13	7.82013e-19
C269	VPWR#8	A1#11	2.15582e-18
C270	B1#4	A1#8	1.92489e-17
C271	a_48_74##2	B2#2	4.87916e-19
C272	Y#1	Y#3	3.59837e-19
C273	a_48_74##8	Y#9	5.53587e-17
C274	A1#13	a_45_368##13	1.78745e-17
C275	a_45_368##5	A1#11	7.70443e-19
C276	A2#9	VPWR#4	6.32316e-19
C277	VGND#3	A1#1	6.37447e-18
C278	VGND#3	A2#4	1.81358e-20
C279	VPWR#8	A1#13	5.19794e-17
C280	Y#2	Y#1	2.52912e-18
C281	B1#11	B1#10	3.61689e-17
C282	a_45_368##3	A1#7	1.63927e-18
C283	a_45_368##5	A1#13	1.44969e-18
C284	a_45_368##13	A1#8	4.18778e-19
C285	Y#6	Y#13	2.47687e-18
C286	a_48_74##4	a_48_74##8	2.71565e-18
C287	a_45_368##9	B2#6	4.75006e-20
C288	VPWR#8	A1#8	4.42933e-17
C289	VPWR#3	A2#4	2.32007e-20
C290	VGND#3	a_840_74##5	3.2477e-17
C291	a_45_368##5	A1#8	3.4567e-17
C292	a_45_368##7	B1#4	1.4863e-19
C293	a_45_368##13	B1#1	1.07786e-19
C294	VGND#3	A1#10	5.85868e-18
C295	A2	A2#9	1.71506e-17
C296	B1#7	B1#11	3.76366e-17
C297	a_48_74##4	Y#9	5.48512e-17
C298	Y#2	a_45_368##15	1.59913e-17
C299	a_45_368##2	A2#2	8.93875e-19
C300	VGND#1	A2#2	4.23162e-19
C301	A2	A2#2	1.37241e-17
C302	VPWR#8	B1#1	2.01865e-18
C303	A2	A1#7	3.00437e-20
C304	B1#4	B1#1	1.86559e-19
C305	Y#6	a_45_368##16	1.95403e-17
C306	Y#3	Y#13	2.78554e-21
C307	a_45_368##5	B1#1	5.42113e-17
C308	a_45_368##9	B2#5	1.70544e-19
C309	A2	A1#2	1.75912e-17
C310	B1#1	Y#8	1.72193e-17
C311	a_45_368##2	A2#4	4.84248e-18
C312	VPWR#8	B1#9	2.65252e-19
C313	B2#8	B1#7	3.9493e-17
C314	a_45_368##14	B1#1	1.72215e-18
C315	VGND#3	A1#12	5.51037e-18
C316	a_45_368##5	B1#9	2.45336e-18
C317	a_840_74##2	A2#4	6.48016e-18
C318	Y#1	B1#1	1.90977e-19
C319	B1#9	Y#8	2.52611e-17
C320	VPWR#8	B1#12	7.33399e-20
C321	VGND#2	a_840_74#	3.94516e-17
C322	a_48_74##4	VGND#9	5.23335e-17
C323	a_840_74##2	A2#5	1.8692e-19
C324	B2#9	B2#8	3.97368e-17
C325	a_45_368##14	B1#9	4.40815e-17
C326	VGND#2	a_840_74##8	2.14839e-17
C327	A1	A2#9	7.04976e-20
C328	Y#1	B1#9	4.42737e-19
C329	Y#8	B1#12	3.88881e-19
C330	VPWR#8	B1#13	4.23817e-20
C331	a_45_368##8	B1#5	3.86439e-20
C332	A1	A1#7	5.43872e-17
C333	VGND#3	A1#14	1.40755e-19
C334	a_48_74#	a_48_74##4	1.70429e-18
C335	a_45_368##14	B1#12	3.948e-17
C336	a_45_368##7	B1#5	7.33242e-20
C337	VGND#8	A2#9	1.68381e-19
C338	B2#11	B2#9	4.00399e-17
C339	A1	A1#2	7.72523e-18
C340	B1#12	Y#1	2.30011e-17
C341	Y#8	B1#13	1.70184e-19
C342	a_840_74##2	A2#6	1.70515e-17
C343	A1	B1#4	2.10724e-18
C344	a_45_368##15	B1#12	1.72215e-18
C345	a_45_368##14	B1#13	1.72215e-18
C346	VGND#5	B1#8	4.94437e-20
C347	a_48_74#	VGND#9	4.23256e-17
C348	VPWR#7	VPWR#5	5.35021e-19
C349	Y#13	B1#12	1.92581e-19
C350	B1#13	Y#1	2.64543e-17
C351	B2#13	B2#11	3.6907e-17
C352	a_45_368##15	B1#13	4.40815e-17
C353	a_45_368##3	A1#2	3.92977e-19
C354	Y#13	B1#13	4.46457e-19
C355	a_840_74##2	A2#8	2.0605e-17
C356	VGND#10	VGND#9	3.37372e-19
C357	Y#1	B2#1	4.46457e-19
C358	a_840_74##2	A2#9	5.34124e-19
C359	a_45_368##15	B2#1	3.948e-17
C360	B1#12	B1#4	2.31942e-19
C361	VGND#5	B1#10	7.99039e-20
C362	VGND#1	A2#4	3.88416e-19
C363	B2#1	Y#13	2.30197e-17
C364	B1#5	Y#2	1.96609e-17
C365	VGND#4	a_840_74##5	3.84679e-18
C366	a_840_74##3	A2#9	1.55555e-18
C367	Y#1	B2#10	1.92581e-19
C368	a_45_368#	VPWR#2	3.47839e-17
C369	VGND#10	a_48_74#	3.99628e-17
C370	a_45_368##10	B1#13	9.69326e-20
C371	a_45_368##16	B2#1	1.72215e-18
C372	B1	B1#6	1.7518e-17
C373	a_45_368##15	B2#10	1.72215e-18
C374	a_45_368##8	B2#2	7.70775e-20
C375	B1	B1#4	1.87517e-17
C376	VGND#8	A2#4	5.9719e-19
C377	VPWR#2	VPWR#1	2.19118e-17
C378	VGND#4	a_840_74##7	2.94322e-17
C379	A1#7	VPWR#6	2.82221e-18
C380	a_840_74##2	A2#10	1.26526e-19
C381	Y#7	B2#1	2.18267e-19
C382	VGND#5	a_48_74##8	1.07508e-17
C383	a_45_368##11	VPWR#2	1.73584e-17
C384	B2#10	Y#13	2.64822e-17
C385	a_840_74##2	a_840_74#	6.3426e-19
C386	VGND#4	Y#4	3.03925e-18
C387	a_45_368##10	B2#1	1.42355e-19
C388	B1	B2#2	4.62315e-18
C389	a_45_368##16	B2#10	4.40815e-17
C390	VGND#2	a_45_368#	5.62596e-18
C391	a_48_74##3	a_48_74#	2.00835e-18
C392	VGND#4	a_48_74##8	1.07493e-16
C393	VGND#5	B1#11	2.80855e-19
C394	VPWR#5	VPWR#3	5.33975e-19
C395	Y#7	B2#10	4.87956e-19
C396	B1#4	A1#14	9.48082e-20
C397	Y#13	B2#12	4.52038e-19
C398	a_45_368##10	B2#10	2.33468e-19
C399	A2#7	A2#1	4.63314e-17
C400	a_45_368##16	B2#12	3.95746e-17
C401	a_840_74##2	A1#1	4.7366e-20
C402	a_840_74##3	a_45_368##3	1.13538e-18
C403	a_48_74##3	VGND#10	4.34066e-17
C404	Y#7	B2#12	3.60398e-17
C405	a_840_74##2	A2#2	2.36953e-19
C406	Y#13	B2#7	3.09986e-19
C407	a_840_74##2	VGND#1	1.58219e-17
C408	a_45_368##10	B2#12	1.66656e-18
C409	a_45_368##16	B2#7	2.58528e-18
C410	A2#11	A2#7	4.77552e-17
C411	B2	B1#6	8.34096e-18
C412	Y#7	B2#7	4.49234e-17
C413	VGND#5	B1#7	5.14451e-18
C414	A1#7	a_45_368##13	5.48219e-19
C415	a_45_368##10	B2#7	4.82868e-17
C416	B2	B2#6	1.73868e-17
C417	B2	B2#5	3.67867e-17
C418	Y#12	a_45_368##3	2.81685e-18
C419	B2	B2#2	1.28049e-17
C420	A2#12	A2#11	4.65914e-17
C421	a_840_74##2	a_840_74##8	5.26243e-19
C422	VGND#5	a_48_74##4	3.55951e-17
C423	B2#2	B1#6	3.76353e-17
C424	A1#2	VPWR#6	2.82046e-19
C425	a_45_368##5	VPWR#9	8.60101e-18
C426	Y#4	B1#5	3.61583e-18
C427	A2#4	VPWR#1	6.47602e-19
C428	a_48_74##8	B1#5	7.41867e-19
C429	A2#4	a_45_368##11	6.9441e-19
C430	VGND#5	B2#8	4.80077e-18
C431	Y#9	B1#5	1.89111e-17
C432	A2#4	VPWR#4	6.13865e-19
C433	A1#9	A2#12	4.67786e-17
C434	a_840_74##2	VGND#8	2.09886e-17
C435	Y#10	a_45_368##4	4.16827e-19
C436	A1#11	A1#9	1.91905e-17
C437	VGND#2	A2#5	6.72216e-18
C438	A1#7	VPWR#8	9.8946e-19
C439	Y#4	a_45_368##5	2.85902e-17
C440	a_45_368#	VPWR#1	5.94761e-17
C441	VGND#2	A2#6	5.95539e-18
C442	Y#12	A1#7	2.15072e-18
C443	VGND#5	B2#9	5.35279e-18
C444	a_45_368##10	VPWR#9	4.76325e-17
C445	VGND#2	A2#8	8.72303e-19
C446	A1#13	A1#11	4.76878e-17
C447	VGND#2	A2#10	1.95691e-19
C448	a_840_74##3	a_840_74##2	5.98929e-19
C449	A2	a_45_368##3	5.41678e-17
C450	A2	a_45_368##2	8.23775e-17
C451	a_45_368##11	a_45_368#	1.25897e-18
C452	VGND#5	a_48_74#	7.1753e-18
C453	a_840_74##2	A2	8.47759e-17
C454	A1#8	A1#13	4.75062e-17
C455	Y#4	a_45_368##7	2.37277e-19
C456	a_45_368##4	VPWR#7	3.13618e-19
C457	VGND#5	B2#11	1.00225e-18
C458	a_45_368##11	VPWR#1	5.21059e-17
C459	A1	a_45_368##4	8.1693e-17
C460	B1#5	a_45_368##14	1.98989e-19
C461	a_840_74##3	A1#2	1.51323e-19
C462	A1	a_45_368##3	2.64335e-17
C463	a_840_74#	A2#5	4.86345e-17
C464	B1#5	Y#1	4.16646e-19
C465	B1#1	A1#8	4.63259e-17
C466	a_45_368##5	A1#7	6.98253e-19
C467	a_840_74##5	A1#7	6.96058e-19
C468	A2#5	VGND#1	1.5686e-17
C469	VPWR#4	VPWR#1	2.06271e-18
C470	B2#6	B2#5	4.03823e-18
C471	a_45_368#	a_45_368##12	4.75919e-21
C472	VGND#4	A1#14	5.31202e-18
C473	B1#9	B1#1	4.70758e-17
C474	a_45_368##4	VPWR#5	1.6661e-19
C475	Y#3	A1	4.00541e-18
C476	VGND#4	B1#8	4.43427e-18
C477	a_840_74#	A2	1.68855e-17
C478	a_840_74#	A2#6	1.91181e-18
C479	VGND#5	B2#13	4.67604e-19
C480	VGND#4	B1#10	4.43427e-18
C481	a_840_74##8	A2#5	6.16437e-19
C482	VGND#4	B1#11	4.43427e-18
C483	Y#4	a_45_368##4	2.51138e-18
C484	VPWR#4	a_45_368##11	5.20507e-17
C485	a_840_74##3	A2	4.34434e-17
C486	B1#12	B1#9	4.7042e-17
C487	VPWR#2	A2#1	3.79312e-18
C488	VGND#1	A2#6	2.89103e-17
C489	VPWR#2	A2#7	2.99041e-18
C490	B1	Y#3	3.48046e-17
C491	a_840_74#	A2#8	2.14555e-19
C492	VPWR#2	A2#11	9.99263e-19
C493	B1#13	B1#12	4.67518e-17
C494	B1	Y#2	5.33897e-17
C495	Y#12	A1#2	2.95749e-18
C496	a_45_368##3	VPWR#5	1.6661e-19
C497	a_45_368##12	a_45_368##11	1.25897e-18
C498	A2#6	a_840_74##8	1.12206e-17
C499	Y#12	A1	3.91897e-17
C500	VGND#1	A2#8	1.3657e-18
C501	Y#10	A1	4.73522e-17
C502	B2#1	B1#13	4.60836e-17
C503	VGND#8	A2#6	3.75068e-19
C504	Y#10	A1#7	2.99165e-18
C505	a_45_368##12	VPWR#4	5.30395e-17
C506	A2	a_45_368#	1.05647e-17
C507	Y#4	A1	1.59258e-17
C508	B2	Y#6	6.9256e-17
C509	a_840_74##8	A2#8	3.15673e-17
C510	B2#10	B2#1	4.67054e-17
C511	a_45_368##3	VPWR#3	3.13618e-19
C512	a_48_74##2	B2	9.13961e-17
C513	VGND#1	A2#10	1.07414e-19
C514	VPWR#6	VPWR#4	2.12942e-18
C515	A2#8	VGND#8	1.42468e-17
C516	B2#12	B2#10	4.61297e-17
C517	VGND#3	a_840_74##2	2.85126e-19
C518	Y#4	B1	5.5295e-17
C519	Y#9	B1	3.88159e-17
C520	a_48_74##4	B1	2.25934e-18
C521	A2#9	VNB	2.49763e-17
C522	VPWR#9	B1#1	4.4376e-18
C523	a_840_74##8	A2#10	1.31403e-18
C524	A2#2	VNB	4.38026e-17
C525	A1#7	VNB	7.88047e-17
C526	VGND#4	A1#8	1.85217e-19
C527	a_840_74##5	A1#2	2.10089e-19
C528	A1#2	VNB	2.57747e-17
C529	VPWR#9	B1#9	4.47322e-18
C530	B2#7	B2#12	4.39457e-17
C531	a_840_74##3	A2#8	3.80285e-19
C532	B1#6	VNB	2.60529e-17
C533	VPWR	VPWR#7	6.11456e-17
C534	B1#4	VNB	5.71961e-17
C535	VPWR#6	a_45_368##12	6.22058e-17
C536	VPWR	VPWR#5	6.18654e-17
C537	B2#6	VNB	4.1872e-17
C538	VPWR	VPWR#3	4.34502e-17
C539	B2#5	VNB	5.64007e-17
C540	VPWR	a_45_368##9	2.57937e-17
C541	VPWR#9	B1#12	4.47374e-18
C542	B2#2	VNB	2.53803e-17
C543	VPWR	a_45_368##8	2.50171e-17
C544	a_45_368##2	VPWR#3	3.08718e-19
C545	VPWR	a_45_368##7	3.19505e-17
C546	VGND#8	A2#10	2.87672e-17
C547	VPWR	a_45_368##4	3.87948e-18
C548	VPWR#9	B1#13	4.47374e-18
C549	B2#8	B1#6	7.59423e-19
C550	VPWR	a_45_368##3	3.10719e-18
C551	VPWR	a_45_368##2	7.76053e-19
C552	a_48_74##4	B2	2.39799e-17
C553	VPWR#9	B2#1	4.464e-18
C554	a_840_74##7	A1#7	7.18566e-19
C555	a_840_74##8	A1#1	1.56207e-19
C556	a_45_368##13	a_45_368##12	1.22606e-18
C557	VPWR	Y#6	4.3042e-18
C558	VPWR#9	B2#10	4.46413e-18
C559	a_48_74##3	B2	1.14632e-17
C560	a_840_74##3	A2#10	2.38473e-17
C561	VPWR	Y#3	2.049e-18
C562	VPWR	Y#2	4.07272e-18
C563	VPWR#9	B2#12	4.46413e-18
C564	VGND	VGND#5	9.82768e-17
C565	VGND	VGND#3	1.21957e-16
C566	VPWR#9	B2#7	4.4526e-18
C567	VGND#8	A1#1	1.38006e-18
C568	B1#5	B1#12	2.1032e-18
C569	Y#12	A2#10	1.06106e-18
C570	a_45_368##13	VPWR#6	6.21776e-17
C571	VGND#3	A2#9	3.69778e-20
C572	VGND	a_840_74##2	1.74437e-18
C573	a_840_74##3	A1#1	3.82058e-17
C574	A1#2	A2#9	3.51111e-17
C575	B2	Y#7	4.75178e-17
C576	VPWR	Y#4	3.17372e-18
C577	B2	a_45_368##10	1.20082e-18
C578	VPWR#2	A2#4	2.01982e-20
C579	A2	A2#1	2.46918e-18
C580	VGND#8	A1#10	2.8404e-19
C581	VPWR#8	VPWR#6	1.86588e-18
C582	VGND	a_48_74##2	3.85007e-18
C583	A2	A2#7	2.09148e-18
C584	VGND#2	A2#4	5.62208e-20
C585	B1#4	Y#8	4.20161e-19
C586	Y#12	A1#1	2.8992e-17
C587	A2	A2#11	2.1032e-18
C588	VGND#5	VNB	4.19897e-17
C589	VGND#3	VNB	6.1409e-17
C590	A2	A2#12	2.0968e-18
C591	VPWR#7	VNB	3.10874e-17
C592	B2#5	B2#2	4.0818e-18
C593	VPWR#5	VNB	3.21801e-17
C594	VPWR#3	VNB	2.78098e-17
C595	VPWR	VPWR#4	2.15485e-17
C596	A2	A1#9	1.27576e-18
C597	a_45_368##9	VNB	4.87692e-18
C598	VGND	a_840_74##3	1.88979e-17
C599	a_45_368##8	VNB	4.45184e-18
C600	VPWR	a_45_368##12	1.48755e-17
C601	VGND	Y#12	7.50129e-18
C602	a_45_368##7	VNB	5.52312e-18
C603	VGND	a_840_74##5	2.23829e-17
C604	VPWR	VPWR#6	3.30017e-17
C605	A2	A1#11	1.265e-19
C606	a_840_74##3	A1#10	6.89186e-19
C607	VGND	Y#10	6.43697e-18
C608	VPWR	a_45_368##13	1.46854e-17
C609	VGND	a_840_74##7	1.97295e-17
C610	VPWR	VPWR#8	2.17635e-17
C611	VPWR	a_45_368##5	1.69541e-17
C612	VGND	Y#4	2.03351e-17
C613	A1	A2#12	2.96832e-19
C614	VPWR#8	a_45_368##13	5.29637e-17
C615	a_840_74##2	VNB	1.46345e-18
C616	VGND	a_48_74##8	4.97619e-17
C617	VPWR	Y#8	8.05621e-18
C618	VPWR#9	B1#5	2.04017e-20
C619	VGND	Y#9	8.77513e-18
C620	A1	A1#9	1.40828e-18
C621	Y#3	A1#7	2.69792e-19
C622	VGND	a_48_74##4	1.79757e-17
C623	VPWR	Y#1	6.14543e-18
C624	Y#3	VNB	2.28878e-18
C625	A1	A1#11	2.06243e-18
C626	VGND	a_48_74#	1.43086e-17
C627	VGND#4	B1#5	3.94064e-20
C628	VGND#8	A1#12	1.51388e-19
C629	VPWR	Y#13	6.14543e-18
C630	a_840_74##7	A2#10	9.18835e-20
C631	VGND	a_48_74##3	1.57506e-17
C632	a_48_74##2	VNB	1.80434e-18
C633	VPWR	Y#7	8.98723e-18
C634	A1	A1#8	2.21701e-18
C635	Y#12	A1#10	3.87644e-17
C636	VPWR	a_45_368##10	2.33787e-17
C637	A1	B1#1	2.27225e-19
C638	a_840_74#	VNB	4.60376e-17
C639	VGND#1	VNB	7.66364e-19
C640	a_840_74##8	VNB	2.12109e-18
C641	a_48_74##2	B1#7	4.55074e-20
C642	VGND#8	VNB	2.88534e-19
C643	a_840_74##3	VNB	4.82495e-18
C644	VGND	a_45_368##5	3.11373e-18
C645	Y#12	VNB	5.79475e-19
C646	a_45_368##5	a_45_368##13	1.29937e-18
C647	a_840_74##5	VNB	3.86267e-18
C648	Y#10	VNB	2.82448e-19
C649	a_840_74##3	A1#12	3.75872e-19
C650	a_840_74##7	VNB	7.10449e-18
C651	B1	B1#1	2.04696e-19
C652	Y#4	VNB	1.14489e-17
C653	a_48_74##8	VNB	1.43172e-17
C654	Y#9	VNB	2.56805e-19
C655	a_840_74##5	A1#10	3.35064e-17
C656	a_48_74##4	VNB	6.17925e-18
C657	VGND#9	VNB	3.01253e-20
C658	VPWR#3	A2#11	1.85466e-18
C659	a_48_74#	VNB	2.12109e-18
C660	VGND	a_45_368##10	5.7014e-18
C661	VGND#10	VNB	4.60233e-19
C662	B1	B1#13	2.05946e-18
C663	a_48_74##3	VNB	4.6976e-17
C664	VPWR#2	A2	5.46424e-18
C665	a_45_368#	VNB	6.03704e-17
C666	a_840_74##7	A1#1	1.34733e-19
C667	VPWR#1	VNB	2.45571e-18
C668	VGND	A2#8	4.79243e-19
C669	B1	B2#1	7.80354e-19
C670	a_45_368##11	VNB	4.61348e-18
C671	VGND#8	A1#14	1.17352e-19
C672	VGND	A2#10	8.69858e-19
C673	VPWR#4	VNB	1.11485e-19
C674	VGND#2	A2	5.12983e-18
C675	VGND	A1#1	6.01082e-19
C676	a_45_368##12	VNB	2.24265e-18
C677	VPWR#6	VNB	5.63487e-18
C678	VGND	A1#10	6.75927e-19
C679	a_45_368##13	VNB	2.24265e-18
C680	Y#12	A1#12	5.3142e-19
C681	VGND	A1#12	8.98877e-19
C682	VPWR#8	VNB	2.52594e-19
C683	VGND	A1#14	9.14773e-19
C684	B2	B1#13	5.85071e-19
C685	a_45_368##5	VNB	4.4542e-18
C686	VGND	B1#8	1.40915e-18
C687	a_45_368##2	A2#1	3.16155e-19
C688	a_45_368##5	VPWR#8	6.66387e-17
C689	B2	B2#1	2.44848e-18
C690	VGND	B1#10	1.37789e-18
C691	VPWR	A2#11	6.31267e-20
C692	VGND	B1#11	1.54144e-18
C693	B2	B2#10	2.09146e-18
C694	VGND	B1#7	2.54229e-18
C695	VPWR	A2#12	1.06726e-18
C696	A2	A2#4	3.67841e-17
C697	B1#4	a_45_368##14	9.22808e-19
C698	VGND	B2#8	8.39544e-19
C699	VPWR	A1#9	5.14791e-20
C700	B2	B2#12	2.10322e-18
C701	VGND	B2#9	6.48986e-19
C702	a_45_368##10	VNB	6.4062e-17
C703	VPWR	A1#11	5.14791e-20
C704	a_48_74##2	B2#8	1.04133e-19
C705	A2#5	VNB	3.14746e-17
C706	VGND	B2#11	3.079e-19
C707	B2	B2#7	6.21269e-18
C708	A2#6	VNB	2.5032e-17
C709	VPWR	A1#13	1.16611e-18
C710	VGND	B2#13	1.70714e-18
C711	a_840_74##3	A1#14	2.4779e-19
C712	A2#8	VNB	2.68219e-17
C713	VPWR	A1#8	1.30683e-18
C714	A2#10	VNB	2.53276e-17
C715	A1#1	VNB	3.0056e-17
C716	VPWR	B1#1	1.40059e-18
C717	A1#10	VNB	3.00502e-17
C718	a_840_74##5	A1#12	3.50109e-17
C719	A1#12	VNB	2.94948e-17
C720	VPWR	B1#9	1.53571e-18
C721	A1#14	VNB	3.2517e-17
C722	VPWR	B1#12	1.64171e-18
C723	B1#8	VNB	3.20099e-17
C724	B1#10	VNB	2.80275e-17
C725	VPWR	B1#13	1.64171e-18
C726	B1#11	VNB	2.84124e-17
C727	B1#7	VNB	2.88245e-17
C728	VPWR	B2#1	1.64169e-18
C729	a_45_368##4	a_45_368##3	8.37809e-19
C730	a_840_74##7	A1#10	2.24832e-19
C731	B2#8	VNB	2.53096e-17
C732	VPWR	B2#10	1.64171e-18
C733	B2#9	VNB	2.52505e-17
C734	B1	B1#5	7.84972e-18
C735	Y#4	A1#7	6.68701e-18
C736	B2#11	VNB	2.68224e-17
C737	VPWR	B2#12	1.64183e-18
C738	B2#13	VNB	3.39532e-17
C739	VPWR	B2#7	2.47886e-18
C740	a_45_368##3	A2#7	7.36537e-20
C741	a_48_74##3	a_45_368##10	9.99116e-18
C742	A2#1	VNB	3.85478e-17
C743	Y#12	A1#14	2.24588e-19
C744	A2#7	VNB	2.84837e-17
C745	VPWR#3	A2#12	1.83922e-18
C746	Y#4	A1#1	1.37322e-19
C747	A2#11	VNB	2.84122e-17
C748	a_45_368##11	VPWR#3	5.25459e-18
C749	A2#12	VNB	2.86841e-17
C750	A1#9	VNB	3.37873e-17
C751	A1#11	VNB	3.21828e-17
C752	Y#10	A1#12	3.77554e-17
C753	VPWR	VPWR#9	2.11016e-16
C754	A1#13	VNB	2.79898e-17
C755	A1#8	VNB	4.57619e-17
C756	B1#1	VNB	3.44854e-17
C757	B1#9	VNB	3.25311e-17
C758	A1	A2	3.10837e-17
C759	VGND#3	A1#7	8.73101e-20
C760	B1#12	VNB	3.26398e-17
C761	B1#13	VNB	3.24604e-17
C762	B2#1	VNB	3.31599e-17
C763	a_45_368##2	A2#7	1.40036e-17
C764	VPWR	B1#5	1.29755e-18
C765	B2#10	VNB	3.21402e-17
C766	VGND	VGND#4	1.26385e-16
C767	B2#12	VNB	3.19568e-17
C768	B2#7	VNB	3.9472e-17
C769	a_48_74##2	B2#9	1.7088e-17
C770	VPWR#2	VNB	1.52553e-16
C771	VGND	B1#5	1.19806e-18
C772	Y#4	Y#3	2.93057e-18
C773	VGND#2	VNB	1.57946e-16
C774	a_48_74##8	A1#1	3.48149e-19
C775	Y#8	a_45_368##5	4.62151e-17
C776	VPWR#9	VNB	1.28988e-16
C777	VGND#4	VNB	7.36393e-17
C778	B2	B1	2.64009e-17
C779	A2#4	VNB	5.64628e-17
C780	a_840_74##7	A1#12	9.78756e-19
C781	VPWR	A2	5.30067e-18
C782	B1#5	VNB	2.78543e-17
C783	VPWR	A1	8.46684e-18
C784	B1#6	Y#1	1.27918e-19
C785	VGND	A2	4.63674e-18
C786	VPWR	B1	5.64361e-18
C787	VGND	A1	7.00029e-18
C788	VPWR	B2	9.68319e-18
C789	VGND	B1	6.38682e-18
C790	Y#4	A1#10	4.09187e-19
C791	VPWR#5	A1#9	2.57874e-18
C792	A2	VNB	3.27345e-17
C793	Y#12	B1#8	1.42974e-19
C794	VGND	B2	8.74192e-18
C795	A1	VNB	1.39487e-17
C796	B1	VNB	5.36303e-18
C797	B2	VNB	3.11249e-17
C798	Y#10	A1#14	4.14199e-17
C799	VPWR	VNB	3.07055e-16
C800	VGND	VNB	3.10125e-16
C801	a_45_368##3	A2#11	2.86165e-19
C802	VGND#6	a_48_74#	6.12788e-18
C803	VGND#6	a_48_74##3	1.7841e-17
C804	VGND#6	VGND#5	1.40786e-18
C805	VGND#6	VNB	5.03905e-17
C806	VGND#6	B2#11	6.55779e-18
C807	VGND#6	VGND#9	1.0526e-18
C808	VGND#6	B2#5	3.17376e-20
C809	VGND#6	a_48_74##2	2.91756e-19
C810	VGND	VGND#6	9.38488e-17
C811	VGND#6	B2#9	1.11704e-18
C812	VGND#6	B2#13	6.47279e-18
*
*
.ENDS sky130_fd_sc_hs__a22oi_4
*
