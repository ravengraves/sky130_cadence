* Extracted by Quantus, converted by sky130cad/quantus.py
*
*
*
*                       LINUX           Wed Nov 18 08:15:21 2026
*
*
*
*  PROGRAM  advgen
*
*  Name           : advgen - Quantus - (64-bit)
*  Version        : 25.1.0-p047
*  Build Date     : Thu Dec 11 23:20:30 PST 2025
*
*  HSPICE LIBRARY
*
*  OPERATING_TEMPERATURE 150
*  QRC_TECH_DIR <path>/tech
*
*
*

*
.SUBCKT sky130_fd_sc_hs__a41o_4 VPB VNB VGND VPWR X B1 A1 A2 A3 A4
*
*
*  caps2d version: 10
*
*
*       TRANSISTOR CARDS
*
*
XM16 a_113_98##13 B1#5 VGND#7 VNB sky130_fd_pr__nfet_01v8_lvt l=0.15 w=0.74 ad=0.2072 as=0.2072 pd=2.04 ps=2.04
XM19 VGND#10 B1#4 a_113_98##13 VNB sky130_fd_pr__nfet_01v8_lvt l=0.15 w=0.74 ad=0.391 as=0.2072 pd=2.86 ps=2.04
XM0 VGND#10 a_113_98##10 X#6 VNB sky130_fd_pr__nfet_01v8_lvt l=0.15 w=0.74 ad=0.391 as=0.2072 pd=2.86 ps=2.04
XM4 X#6 a_113_98##9 VGND#9 VNB sky130_fd_pr__nfet_01v8_lvt l=0.15 w=0.74 ad=0.2072 as=0.386 pd=2.04 ps=2.85
XM11 VGND#9 a_113_98##7 X#4 VNB sky130_fd_pr__nfet_01v8_lvt l=0.15 w=0.74 ad=0.386 as=0.2072 pd=2.85 ps=2.04
XM17 X#4 a_113_98##5 VGND#8 VNB sky130_fd_pr__nfet_01v8_lvt l=0.15 w=0.74 ad=0.2072 as=0.3495 pd=2.04 ps=2.81
XM5 a_751_74##4 A1#5 a_113_98##12 VNB sky130_fd_pr__nfet_01v8_lvt l=0.15 w=0.74 ad=0.2109 as=0.2072 pd=2.05 ps=2.04
XM3 a_113_98##12 A1#1 a_751_74##2 VNB sky130_fd_pr__nfet_01v8_lvt l=0.15 w=0.74 ad=0.2072 as=0.2072 pd=2.04 ps=2.04
XM21 a_1010_74##2 A2#6 a_751_74##2 VNB sky130_fd_pr__nfet_01v8_lvt l=0.15 w=0.74 ad=0.2072 as=0.2072 pd=2.04 ps=2.04
XM13 a_751_74# A2#4 a_1010_74##2 VNB sky130_fd_pr__nfet_01v8_lvt l=0.15 w=0.74 ad=0.2035 as=0.2072 pd=2.03 ps=2.04
XM22 a_1010_74# A3#5 a_1205_74##4 VNB sky130_fd_pr__nfet_01v8_lvt l=0.15 w=0.74 ad=0.2072 as=0.2072 pd=2.04 ps=2.04
XM25 a_1205_74##2 A3#1 a_1010_74# VNB sky130_fd_pr__nfet_01v8_lvt l=0.15 w=0.74 ad=0.2072 as=0.2072 pd=2.04 ps=2.04
XM2 a_1205_74##2 A4#6 VGND#4 VNB sky130_fd_pr__nfet_01v8_lvt l=0.15 w=0.74 ad=0.2072 as=0.2072 pd=2.04 ps=2.04
XM27 VGND#4 A4#1 a_1205_74# VNB sky130_fd_pr__nfet_01v8_lvt l=0.15 w=0.74 ad=0.2072 as=0.2072 pd=2.04 ps=2.04
XM7 a_27_392##10 B1#6 a_113_98##16 VPB sky130_fd_pr__pfet_01v8 l=0.15 w=1 ad=0.295 as=0.35 pd=2.59 ps=2.7
XM15 a_113_98##16 B1#1 a_27_392##6 VPB sky130_fd_pr__pfet_01v8 l=0.15 w=1 ad=0.35 as=0.295 pd=2.7 ps=2.59
XM8 VPWR#14 a_113_98##11 X#1 VPB sky130_fd_pr__pfet_01v8 l=0.15 w=1.12 ad=0.3304 as=0.336 pd=2.83 ps=2.84
XM9 VPWR#12 a_113_98##8 X#1 VPB sky130_fd_pr__pfet_01v8 l=0.15 w=1.12 ad=0.336 as=0.336 pd=2.84 ps=2.84
XM23 X#2 a_113_98##6 VPWR#12 VPB sky130_fd_pr__pfet_01v8 l=0.15 w=1.12 ad=0.336 as=0.336 pd=2.84 ps=2.84
XM26 X#2 a_113_98# VPWR#10 VPB sky130_fd_pr__pfet_01v8 l=0.15 w=1.12 ad=0.336 as=0.4018 pd=2.84 ps=2.98
XM6 VPWR#10 A1#6 a_27_392##4 VPB sky130_fd_pr__pfet_01v8 l=0.15 w=1 ad=0.4018 as=0.495 pd=2.98 ps=2.99
XM20 a_27_392##4 A1#4 VPWR#9 VPB sky130_fd_pr__pfet_01v8 l=0.15 w=1 ad=0.495 as=0.525 pd=2.99 ps=3.05
XM1 VPWR#9 A2#5 a_27_392##9 VPB sky130_fd_pr__pfet_01v8 l=0.15 w=1 ad=0.525 as=0.3 pd=3.05 ps=2.6
XM14 a_27_392##9 A2#1 VPWR#8 VPB sky130_fd_pr__pfet_01v8 l=0.15 w=1 ad=0.3 as=0.4 pd=2.6 ps=2.8
XM18 a_27_392##8 A3#6 VPWR#8 VPB sky130_fd_pr__pfet_01v8 l=0.15 w=1 ad=0.35 as=0.4 pd=2.7 ps=2.8
XM12 VPWR#7 A3#4 a_27_392##8 VPB sky130_fd_pr__pfet_01v8 l=0.15 w=1 ad=0.35 as=0.35 pd=2.7 ps=2.7
XM24 VPWR#7 A4#4 a_27_392# VPB sky130_fd_pr__pfet_01v8 l=0.15 w=1 ad=0.35 as=0.3 pd=2.7 ps=2.6
XM10 a_27_392# A4#5 VPWR#1 VPB sky130_fd_pr__pfet_01v8 l=0.15 w=1 ad=0.3 as=0.295 pd=2.6 ps=2.59
*
*
*       RESISTOR AND CAP/DIODE CARDS
*
Rg1	B1#1	B1#2	426.334839
Rg2	B1#2	B1#3	90.374443
Rg3	B1#2	B1#4	413.664001
Rg4	B1#3	B1#5	377.162689
Rg5	B1#3	B1#6	402.368896
Rg6	a_113_98#	a_113_98##2	506.504517
Rg7	a_113_98##2	a_113_98##3	79.420471
Rg8	a_113_98##3	a_113_98##4	103.067337
Rg9	a_113_98##2	a_113_98##5	319.775085
Rg10	a_113_98##2	a_113_98##6	451.639893
Rg11	a_113_98##3	a_113_98##7	321.855652
Rg12	a_113_98##3	a_113_98##8	453.484222
Rg13	a_113_98##4	a_113_98##9	316.797119
Rg14	a_113_98##4	a_113_98##10	372.110962
Rg15	a_113_98##4	a_113_98##11	440.567688
Rg16	A1#1	A1#2	454.941925
Rg17	A1#2	A1#3	75.454018
Rg18	A1#2	A1#4	424.106537
Rg19	A1#3	A1#5	434.413513
Rg20	A1#3	A1#6	426.054413
Rg21	A2#1	A2#2	496.616791
Rg22	A2#2	A2#3	58.630272
Rg23	A2#2	A2#4	424.871948
Rg24	A2#3	A2#5	403.578156
Rg25	A2#3	A2#6	466.779327
Rg26	A3#1	A3#2	478.131866
Rg27	A3#2	A3#3	46.379234
Rg28	A3#2	A3#4	394.006165
Rg29	A3#3	A3#5	434.413513
Rg30	A3#3	A3#6	441.300537
Rg31	A4#1	A4#2	428.633911
Rg32	A4#2	A4#3	32.976120
Rg33	A4#3	A4#4	426.119202
Rg34	A4#2	A4#5	397.798523
Rg35	A4#3	A4#6	459.546112
Rf1	B1#7	B1	0.772649
Rf2	B1#3	B1#9	161.005447
Rf3	B1#7	B1#9	5.708254
Rf4	X#1	X	57.053169
Rf5	X	X#3	0.975746
Rf6	X#3	X	6.213156
Rf7	X	X#5	3.774462
Rf8	X#5	X#6	89.621078
Rf9	X#2	X#3	15.000000
Rf10	X#4	X#5	15.000000
Rf11	A1	A1#7	1.968364
Rf12	A1#7	A1	16.927925
Rf13	a_113_98##12	a_113_98##14	275.106384
Rf14	a_113_98##14	a_113_98##15	19.241423
Rf15	a_113_98##15	a_113_98##16	59.352119
Rf16	a_113_98##15	a_113_98##4	81.156433
Rf17	a_113_98##13	a_113_98##14	7.500000
Rf18	A2	A2#7	17.912109
Rf19	A2#7	A2	0.984182
Rf20	a_751_74#	a_751_74##3	65.753036
Rf21	a_751_74##3	a_751_74##4	44.415077
Rf22	a_751_74##2	a_751_74##3	7.500000
Rf23	a_1010_74#	a_1010_74##2	167.729019
Rf24	A3	A3#7	1.181018
Rf25	A3#7	A3	17.715271
Rf26	a_27_392#	a_27_392##2	87.971939
Rf27	a_27_392##2	a_27_392##3	73.001427
Rf28	a_27_392##3	a_27_392##5	99.838455
Rf29	a_27_392##5	a_27_392##7	207.355377
Rf30	a_27_392##2	a_27_392##8	18.602406
Rf31	a_27_392##3	a_27_392##9	18.602406
Rf32	a_27_392##7	a_27_392##10	102.407043
Rf33	a_27_392##4	a_27_392##5	5.000000
Rf34	a_27_392##6	a_27_392##7	5.000000
Rf35	A4	A4#7	16.927925
Rf36	A4#7	A4	1.968364
Rf37	a_1205_74#	a_1205_74##3	110.383614
Rf38	a_1205_74##3	a_1205_74##4	89.267242
Rf39	a_1205_74##2	a_1205_74##3	7.500000
Rf40	VPWR#1	VPWR#2	78.680466
Rf41	VPWR#2	VPWR#3	37.231220
Rf42	VPWR#3	VPWR#4	73.001427
Rf43	VPWR#4	VPWR#5	77.708900
Rf44	VPWR#5	VPWR#6	112.907249
Rf45	VPWR#3	VPWR#7	32.322075
Rf46	VPWR#4	VPWR#8	32.322075
Rf47	VPWR#5	VPWR#9	26.129707
Rf48	VPWR#6	VPWR#10	36.184055
Rf49	VPWR#6	VPWR#11	48.919300
Rf50	VPWR#11	VPWR#12	34.310661
Rf51	VPWR#11	VPWR#13	65.696381
Rf52	VPWR#13	VPWR#14	34.310661
Rf55	VGND#2	VGND#3	299.141785
Rf56	VGND#2	VGND#4	33.851616
Rf57	VGND#3	VGND#5	85.481071
Rf58	VGND#5	VGND#6	73.731934
Rf59	VGND#6	VGND#7	118.368164
Rf60	VGND#3	VGND#8	31.923599
Rf61	VGND#5	VGND#9	26.437206
Rf62	VGND#6	VGND#10	26.437206
Rf64	A1#3	A1#7	160.232803
Rf66	A2#3	A2#7	160.232803
Rf67	A3#3	A3#7	80.116402
Rf68	A4#2	A4#7	160.232803
Re1	VPWR#2	VPWR	4.549932
Re2	VPWR	VPWR#6	0.974985
Re3	VGND#2	VGND	4.549932
Re4	VGND	VGND#3	0.974985
*
*       CAPACITOR CARDS
*
*
C1	A2#3	A2#2	5.91265e-18
C2	VPWR#12	VPWR#10	1.28711e-17
C3	a_27_392##4	X#1	2.63373e-21
C4	a_113_98##2	X#2	6.59527e-19
C5	a_1010_74##2	A2#2	4.18873e-18
C6	VGND#8	A1#1	1.16352e-19
C7	A1#2	A2#3	2.92174e-17
C8	a_751_74##2	a_113_98##5	1.62619e-19
C9	a_27_392##3	A3#6	1.58753e-19
C10	a_751_74##4	A1#5	4.68075e-17
C11	VPWR#5	A1#4	5.35533e-18
C12	X#4	A1#1	5.16237e-19
C13	a_113_98##12	a_113_98##5	1.23494e-17
C14	a_27_392##2	A3#6	1.96888e-17
C15	VPWR#4	VPWR#3	9.53351e-19
C16	VGND#8	A1#5	1.43626e-18
C17	a_751_74##4	a_113_98##5	2.23603e-18
C18	a_113_98##3	VPWR#12	4.59691e-19
C19	a_27_392##3	A2#1	2.05013e-17
C20	X#4	A1#5	2.7387e-18
C21	a_113_98##12	a_113_98##7	4.46455e-19
C22	VPWR#3	VPWR#1	1.29308e-18
C23	a_113_98##5	VGND#8	2.2832e-17
C24	a_27_392##2	A2#1	1.08011e-19
C25	VGND#4	a_1205_74#	7.01205e-17
C26	VGND#9	A1#5	3.31582e-19
C27	a_113_98##2	VPWR#12	4.4847e-19
C28	a_751_74##4	a_113_98##7	3.2123e-19
C29	a_27_392##3	A2#2	2.06811e-18
C30	A1#3	A1#2	6.88905e-18
C31	X#4	a_113_98##5	2.98772e-17
C32	a_113_98##12	a_113_98##9	2.59147e-19
C33	a_27_392##3	A2#5	2.08167e-17
C34	VPWR#14	VPWR#12	1.33968e-17
C35	VPWR#11	a_113_98#	3.51318e-19
C36	VGND#8	a_113_98##7	1.26529e-18
C37	a_27_392##6	X#2	9.15039e-20
C38	VGND#9	a_113_98##5	2.30193e-18
C39	a_27_392#	VPWR#3	3.03818e-19
C40	a_1205_74##2	a_1205_74#	2.38898e-18
C41	a_751_74##4	a_113_98##9	2.3718e-19
C42	a_751_74##2	A1#2	2.27533e-18
C43	X#4	a_113_98##7	3.1683e-17
C44	a_27_392##6	VPWR#12	2.46234e-17
C45	a_113_98##12	a_113_98##10	1.72014e-19
C46	X#1	a_113_98##3	1.17243e-18
C47	VGND#8	a_113_98##9	5.72131e-19
C48	a_27_392##3	A1#4	1.16117e-19
C49	a_113_98##7	VGND#9	2.4859e-17
C50	a_1205_74##2	VGND#4	7.43269e-17
C51	VPWR#11	a_113_98##6	6.80374e-18
C52	a_27_392##6	X#1	4.32237e-17
C53	X#4	a_113_98##9	3.45733e-19
C54	a_113_98##13	a_113_98##5	5.48969e-19
C55	a_27_392##8	VPWR#4	8.48902e-18
C56	a_113_98##4	a_113_98##3	1.0527e-17
C57	a_113_98##9	VGND#9	2.4847e-17
C58	a_27_392##6	VPWR#14	7.41854e-17
C59	VGND#10	a_113_98##7	5.98203e-19
C60	X#1	B1#2	4.43548e-19
C61	a_27_392##3	A1#6	3.01115e-20
C62	X#4	a_113_98##10	9.24907e-20
C63	B1#2	a_113_98##4	4.38299e-19
C64	X#6	a_113_98##9	3.24929e-17
C65	VPWR#11	a_113_98##8	6.79883e-18
C66	a_113_98##12	A1#2	2.73383e-19
C67	a_27_392##8	VPWR#3	9.16153e-18
C68	a_113_98##13	a_113_98##7	1.1223e-17
C69	VGND#9	a_113_98##10	1.29501e-18
C70	VGND#10	a_113_98##9	1.29501e-18
C71	a_1205_74##2	a_1010_74#	6.63982e-17
C72	X#4	B1#4	6.43798e-20
C73	X#6	a_113_98##10	2.31224e-17
C74	a_27_392##6	a_113_98##16	6.77704e-17
C75	a_113_98##13	a_113_98##9	1.19972e-17
C76	a_27_392##9	VPWR#5	8.48902e-18
C77	VGND#9	B1#4	5.97267e-19
C78	VPWR#11	a_113_98##11	5.09286e-19
C79	a_113_98##10	VGND#10	1.54375e-17
C80	a_27_392##10	a_27_392##6	2.84152e-18
C81	a_1205_74##4	a_1205_74##2	3.1466e-18
C82	X#6	B1#4	1.0942e-18
C83	a_113_98##13	a_113_98##10	1.81259e-17
C84	a_27_392##3	VPWR#5	1.6661e-19
C85	a_27_392##9	VPWR#4	8.43957e-18
C86	a_113_98##12	a_113_98##2	7.93692e-19
C87	B1#3	B1#2	5.04589e-18
C88	a_27_392##10	a_113_98##16	9.46208e-17
C89	B1#4	VGND#10	2.49533e-17
C90	a_751_74##4	A1#2	3.98326e-19
C91	VGND#7	a_113_98##10	3.59159e-19
C92	a_1205_74##4	a_1010_74#	7.01723e-17
C93	a_27_392##6	a_113_98##3	4.62916e-19
C94	a_113_98##13	B1#4	5.53445e-17
C95	a_27_392##4	VPWR#11	1.10387e-18
C96	a_27_392##3	VPWR#4	1.6661e-19
C97	VGND#10	B1#5	1.61342e-18
C98	VPWR#9	VPWR#4	4.80587e-19
C99	VGND#7	B1#4	1.4773e-18
C100	a_27_392##6	a_113_98##2	8.76653e-20
C101	a_27_392##2	a_27_392#	5.3354e-19
C102	a_113_98##13	B1#5	4.02733e-17
C103	a_27_392##4	VPWR#5	9.95764e-18
C104	VGND#7	B1#5	2.48115e-17
C105	VPWR#11	VPWR#10	6.6792e-20
C106	a_27_392##2	VPWR#4	1.6661e-19
C107	a_27_392##2	VPWR#7	2.38941e-17
C108	a_751_74#	a_1205_74##4	5.05155e-17
C109	a_1010_74##2	a_1010_74#	1.17722e-18
C110	A4#6	A4#1	4.22464e-17
C111	a_27_392##2	VPWR#3	1.61709e-19
C112	a_27_392##2	a_27_392##8	8.92871e-19
C113	A3#1	A4#6	4.24057e-17
C114	a_27_392##3	VPWR#8	1.77187e-17
C115	B1#2	a_113_98##16	2.31346e-19
C116	VPWR#1	A4#5	2.89103e-17
C117	a_113_98##2	VGND#8	1.3295e-18
C118	a_751_74#	a_1010_74##2	7.41758e-17
C119	X#4	A1#2	4.75109e-19
C120	a_27_392#	A4#5	5.30732e-17
C121	a_27_392##2	VPWR#8	1.77926e-17
C122	VPWR#1	A4#4	1.23062e-18
C123	VPWR#7	A4#5	1.46384e-18
C124	a_27_392##3	a_27_392##9	1.98852e-19
C125	VPWR#2	VPWR#3	3.7245e-17
C126	A3#5	A3#1	4.28341e-17
C127	a_751_74##2	a_751_74#	2.67476e-18
C128	a_113_98##12	a_1205_74##4	1.1514e-18
C129	a_27_392#	A4#4	6.42687e-17
C130	X#4	a_113_98##3	5.73705e-18
C131	VPWR#1	A3#4	2.56585e-19
C132	A4#4	VPWR#7	2.38713e-17
C133	a_27_392#	A3#4	1.51364e-18
C134	a_27_392##10	B1#2	2.01473e-19
C135	a_751_74##2	a_1010_74##2	4.55569e-17
C136	X#4	a_113_98##2	1.17631e-17
C137	a_27_392##8	A4#4	3.41523e-19
C138	a_27_392##3	VPWR#9	3.38874e-17
C139	A2#4	A3#5	4.31411e-18
C140	VPWR#7	A3#4	4.69467e-17
C141	VPWR#11	VPWR#6	1.61134e-18
C142	a_27_392#	A3#6	1.97004e-19
C143	VPWR#6	VPWR#5	3.32647e-19
C144	A3#4	a_27_392##8	1.76151e-17
C145	a_113_98##12	a_113_98#	4.82736e-18
C146	VPWR#2	a_27_392##2	1.54171e-18
C147	VPWR#7	A3#6	1.86694e-18
C148	a_27_392##4	a_27_392##3	3.97286e-19
C149	VPWR#8	A3#4	7.17622e-19
C150	a_27_392##6	a_113_98##10	4.24508e-18
C151	VGND#9	a_113_98##3	4.31461e-19
C152	A2#6	A2#4	4.12177e-17
C153	a_27_392##8	A3#6	4.58104e-17
C154	a_113_98#	VGND#8	9.60257e-19
C155	a_751_74##2	a_113_98##12	4.48035e-17
C156	VPWR#7	A2#1	2.8528e-19
C157	A3#6	VPWR#8	2.90425e-17
C158	X#4	a_113_98#	7.76264e-18
C159	a_27_392##6	VPWR#11	2.0285e-18
C160	a_27_392##8	A2#1	4.11471e-19
C161	a_27_392##9	A3#6	6.04773e-19
C162	A1#1	A2#6	4.40543e-17
C163	A2#1	VPWR#8	3.329e-17
C164	VPWR#9	A3#6	3.10682e-19
C165	a_27_392##9	A2#1	5.05112e-17
C166	VPWR#8	A2#5	7.67963e-19
C167	A1#5	A1#1	4.24043e-17
C168	VPWR#9	A2#1	1.2891e-18
C169	a_113_98##12	a_751_74##4	4.9625e-17
C170	a_27_392##9	A2#5	4.31775e-17
C171	a_27_392##3	a_27_392##2	5.43544e-19
C172	VPWR#8	A1#4	2.52282e-19
C173	A2#5	VPWR#9	3.24107e-17
C174	a_113_98##13	a_113_98##6	6.13539e-20
C175	a_1205_74#	VPWR#1	4.24648e-19
C176	a_113_98##12	VGND#8	5.9295e-17
C177	a_113_98##5	A1#5	3.80354e-18
C178	a_27_392##9	A1#4	4.42351e-19
C179	VPWR#4	A3#3	3.31577e-20
C180	a_27_392##4	A2#5	1.66584e-18
C181	a_113_98##2	a_113_98#	1.06693e-18
C182	VPWR#3	A3#3	4.04436e-20
C183	A1#4	VPWR#9	3.96529e-17
C184	VPWR#10	A2#5	1.76565e-19
C185	a_113_98##13	a_113_98##8	8.44996e-20
C186	a_27_392##9	A1#6	1.14711e-19
C187	a_113_98##12	X#4	4.99126e-17
C188	a_27_392##4	A1#4	5.63482e-17
C189	a_113_98##7	a_113_98##5	3.91596e-17
C190	VPWR#9	A1#6	1.9112e-18
C191	VPWR#10	A1#4	1.34318e-18
C192	a_113_98##13	a_113_98##11	7.12283e-19
C193	a_27_392##4	A1#6	5.57137e-17
C194	X#4	a_751_74##4	9.78465e-18
C195	VPWR#9	a_113_98#	2.30243e-19
C196	A1#6	VPWR#10	2.81442e-17
C197	VPWR#12	A1#4	1.30484e-19
C198	a_27_392##2	A3#3	9.41774e-18
C199	a_113_98##9	a_113_98##7	2.11823e-17
C200	a_113_98##13	B1#1	2.73432e-18
C201	a_27_392##4	a_113_98#	2.73605e-17
C202	VPWR#5	A1#3	3.19749e-20
C203	a_1205_74##2	a_27_392#	6.26256e-18
C204	VGND#6	a_113_98##4	5.8672e-20
C205	X#4	VGND#8	2.62678e-18
C206	VGND#10	B1#2	3.29118e-19
C207	a_751_74##4	VGND#9	7.99884e-20
C208	a_113_98##12	X#6	3.91985e-21
C209	VPWR#10	a_113_98#	4.2145e-17
C210	VPWR#12	A1#6	2.35721e-19
C211	VGND#5	a_113_98##4	4.23296e-20
C212	a_27_392##3	A2#3	3.25007e-18
C213	a_113_98##13	a_113_98##3	6.32046e-19
C214	a_27_392##4	a_113_98##6	1.63119e-17
C215	a_113_98#	X#2	2.611e-17
C216	a_113_98##13	B1#6	2.69887e-18
C217	A4	A4#3	2.76913e-17
C218	a_113_98##10	a_113_98##9	3.92947e-17
C219	VPWR#10	a_113_98##6	3.17265e-18
C220	VPWR#12	a_113_98#	2.74951e-18
C221	VGND#9	VGND#8	5.86857e-18
C222	a_27_392##4	a_113_98##8	4.97486e-19
C223	a_113_98##6	X#2	2.611e-17
C224	VGND#6	B1#3	2.85778e-19
C225	a_113_98##13	a_113_98##2	1.35245e-19
C226	VPWR#12	a_113_98##6	4.00512e-17
C227	B1#4	a_113_98##10	2.04576e-17
C228	X#4	VGND#9	5.97651e-19
C229	a_27_392##4	a_113_98##11	5.33927e-19
C230	VGND#3	a_751_74#	1.30687e-17
C231	a_27_392##6	a_113_98#	3.64846e-19
C232	a_113_98##13	B1#2	2.88642e-17
C233	VPWR#12	a_113_98##8	3.69432e-17
C234	VGND#3	a_751_74##2	2.39051e-17
C235	X#1	a_113_98##8	3.43124e-17
C236	a_27_392##6	a_113_98##6	5.34689e-19
C237	B1#5	B1#4	3.90186e-17
C238	VPWR#2	VPWR#1	2.35443e-17
C239	A3	A4#3	1.00267e-17
C240	VGND#3	a_113_98##12	8.50204e-17
C241	VPWR#12	a_113_98##11	4.07484e-18
C242	VPWR#14	a_113_98##8	2.74855e-18
C243	A3	A2#2	8.35868e-18
C244	a_27_392#	VPWR#2	3.51691e-17
C245	a_1205_74##2	A3#3	7.92056e-19
C246	X#1	a_113_98##11	3.79969e-17
C247	a_27_392##6	a_113_98##8	1.71244e-17
C248	VPWR#2	VPWR#7	2.11156e-17
C249	a_1010_74#	A3#3	6.48642e-18
C250	X#6	VGND#9	1.21003e-19
C251	VGND#5	a_113_98##3	2.67909e-20
C252	a_1205_74##4	A3#3	1.23992e-18
C253	VPWR#14	a_113_98##11	3.63667e-17
C254	a_27_392#	A4#3	3.82851e-18
C255	VGND#9	VGND#3	2.07315e-19
C256	X#1	B1#1	1.31287e-18
C257	a_27_392##6	a_113_98##11	3.21898e-17
C258	VGND#6	B1#2	2.5575e-20
C259	VPWR#14	B1#1	9.1074e-19
C260	VGND#10	VGND#9	7.00175e-18
C261	a_113_98##13	X#4	4.58565e-17
C262	B1#2	a_113_98##11	1.60116e-18
C263	VGND#3	a_113_98##13	1.20937e-19
C264	a_27_392##6	B1#1	8.23806e-17
C265	X#1	B1#6	2.57494e-19
C266	a_751_74#	A2#3	4.02028e-19
C267	VGND#5	a_113_98##2	1.5376e-20
C268	B1#1	a_113_98##16	2.40074e-17
C269	VPWR#14	B1#6	4.38375e-20
C270	a_1010_74##2	A2#3	3.30493e-18
C271	A2	A2#2	1.3714e-17
C272	a_113_98##13	VGND#9	4.74742e-17
C273	A2	A1#2	8.98462e-18
C274	a_751_74##2	A2#3	3.24279e-20
C275	a_27_392##6	B1#6	2.50205e-18
C276	a_27_392##10	B1#1	3.00842e-18
C277	A4#4	A4#5	4.1513e-17
C278	B1#6	a_113_98##16	3.14397e-17
C279	a_27_392##10	B1#6	6.05565e-17
C280	a_113_98##13	X#6	6.67666e-17
C281	VPWR#6	VPWR#9	5.52624e-19
C282	X#4	A2#3	4.98185e-19
C283	a_27_392##4	VPWR#6	1.28529e-17
C284	a_113_98##12	A1#3	1.04663e-18
C285	A3#4	A4#4	3.38476e-17
C286	a_751_74##4	A1#3	5.64517e-18
C287	a_113_98##13	VGND#10	5.18489e-17
C288	X#4	A1#3	8.76349e-19
C289	VPWR#7	A3#3	7.55744e-19
C290	A3#6	A3#4	3.34181e-17
C291	VGND#7	VGND#10	6.14972e-18
C292	X#4	a_113_98##4	3.48879e-17
C293	a_113_98##4	VGND#9	5.38023e-18
C294	A2#1	A3#6	2.81022e-17
C295	VGND#5	a_113_98##7	3.96272e-18
C296	a_113_98##4	X#6	6.03457e-17
C297	VGND#7	a_113_98##13	6.72182e-17
C298	a_113_98##13	a_113_98##4	9.04452e-18
C299	VPWR#9	A2#3	1.06576e-18
C300	A2#5	A2#1	4.15333e-17
C301	a_751_74##2	a_27_392##4	8.08743e-18
C302	VGND#5	a_113_98##9	4.03993e-18
C303	a_113_98##13	B1#3	5.38154e-17
C304	VPWR#5	A2#2	3.09218e-20
C305	a_1205_74#	A4#3	8.60769e-18
C306	VGND#7	B1#3	1.71596e-17
C307	A1#4	A2#5	1.78935e-17
C308	a_27_392##4	A1#3	8.87945e-18
C309	VPWR#11	a_113_98##3	2.80436e-20
C310	a_113_98##12	a_27_392##4	1.71134e-18
C311	VGND#6	a_113_98##10	4.07947e-18
C312	VGND#3	A2#4	2.38284e-18
C313	A1#6	A1#4	2.03266e-17
C314	VGND#3	A2#6	5.18009e-18
C315	a_751_74##4	a_27_392##4	3.39731e-18
C316	VPWR#5	A1#2	1.76016e-20
C317	VGND#3	A1#1	4.63203e-18
C318	VPWR#2	A4#3	5.6683e-20
C319	VPWR#11	a_113_98##2	2.08432e-20
C320	VGND#3	A1#5	4.48044e-18
C321	a_113_98#	A1#6	3.62327e-17
C322	a_113_98##4	X#1	3.86792e-17
C323	VGND#3	a_113_98##5	3.96272e-18
C324	VGND#6	B1#4	3.2425e-18
C325	X	A1#2	1.39005e-19
C326	a_113_98##4	VPWR#14	4.44474e-18
C327	X	a_113_98##3	5.34868e-18
C328	a_27_392#	VPWR#1	7.81108e-17
C329	X	a_113_98##2	1.55646e-17
C330	VPWR#4	A2#2	1.96413e-20
C331	X	B1#2	1.39142e-19
C332	a_113_98##4	a_27_392##6	2.61175e-17
C333	VGND#4	A4#3	9.58019e-19
C334	VPWR#2	A4#5	8.02593e-18
C335	a_113_98##6	a_113_98#	4.90112e-17
C336	X#1	B1#3	2.57494e-19
C337	VPWR#2	A4#4	2.23619e-18
C338	VPWR#7	VPWR#1	1.47906e-18
C339	VPWR#2	A3#4	5.18404e-19
C340	a_113_98##8	a_113_98##6	4.65663e-17
C341	VGND#6	B1#5	3.14998e-18
C342	B1#3	a_27_392##10	1.99254e-17
C343	A3	a_27_392##3	1.1548e-17
C344	a_1205_74#	A4#1	2.6831e-17
C345	A3	a_27_392##2	9.42239e-17
C346	a_27_392#	VPWR#7	7.0973e-17
C347	a_113_98##11	a_113_98##8	4.84776e-17
C348	a_1205_74#	A4	5.04848e-17
C349	a_113_98##5	A1#3	1.83835e-20
C350	VGND#4	A4#1	3.59024e-17
C351	a_1205_74##2	A4	1.69493e-17
C352	a_1205_74#	A4#6	8.85809e-19
C353	a_27_392##8	a_27_392#	2.03253e-18
C354	a_1205_74##2	A4#3	9.40818e-19
C355	A2	a_27_392##3	7.80124e-17
C356	B1#1	a_113_98##11	6.308e-18
C357	a_1205_74##2	A4#1	8.60291e-19
C358	VGND#4	A4#6	3.36563e-17
C359	a_1205_74##2	A3	2.21399e-17
C360	VPWR#6	A1#6	5.37359e-18
C361	a_113_98##4	a_113_98##10	1.70655e-17
C362	a_27_392##8	VPWR#7	6.22435e-17
C363	a_1010_74#	A3	6.62053e-17
C364	B1#6	B1#1	3.40498e-17
C365	A3#6	A3#3	1.94229e-19
C366	a_1205_74#	A3#1	1.94223e-19
C367	VPWR#6	a_113_98#	3.9562e-18
C368	a_1010_74##2	A3	1.57675e-17
C369	A2#1	A3#3	1.50097e-18
C370	a_1205_74##2	A4#6	3.1247e-17
C371	VGND#3	a_113_98#	2.19888e-20
C372	A4	VPWR#1	3.26751e-17
C373	VPWR#8	VPWR#7	1.76627e-18
C374	X#4	X#1	1.36219e-18
C375	A2#3	A2#1	2.31491e-18
C376	VGND#4	A3#1	1.88845e-18
C377	A4	a_27_392#	4.23449e-17
C378	a_1010_74##2	A2	6.59175e-17
C379	a_751_74##2	A2	3.11819e-18
C380	a_1205_74##2	A3#1	5.38066e-17
C381	VPWR#8	a_27_392##8	6.22435e-17
C382	A3	a_27_392#	1.23475e-17
C383	A3	VPWR#7	5.03046e-19
C384	VGND#4	A3#5	3.07356e-19
C385	VPWR#6	a_113_98##2	6.02558e-20
C386	A3	a_27_392##8	3.31539e-18
C387	A3#1	a_1010_74#	1.73654e-17
C388	a_113_98#	A1#3	2.35532e-17
C389	a_27_392##9	a_27_392##8	2.07064e-18
C390	a_113_98##12	A1	7.39706e-18
C391	a_1205_74##2	A3#5	1.6054e-18
C392	a_751_74##4	A1	2.60475e-17
C393	X#4	A1	4.50014e-18
C394	a_1205_74##4	A3#1	1.24369e-18
C395	VGND#4	A2#4	8.51574e-20
C396	A2	a_27_392##9	3.04772e-18
C397	A2	VPWR#9	2.45016e-18
C398	a_1010_74#	A3#5	3.26861e-17
C399	a_27_392##9	VPWR#8	6.22197e-17
C400	A4#3	VNB	7.9082e-17
C401	B1#2	a_113_98##10	1.81939e-17
C402	A2#2	VNB	3.79362e-17
C403	A1#2	VNB	3.27634e-17
C404	a_113_98##3	VNB	1.92039e-17
C405	VGND#6	a_113_98##13	1.6357e-17
C406	a_113_98##2	VNB	2.17723e-17
C407	B1#2	VNB	2.49925e-17
C408	VPWR	VPWR#11	7.11512e-17
C409	VPWR	VPWR#5	7.12201e-17
C410	VGND#3	A1#2	1.64681e-20
C411	VPWR	VPWR#4	5.90867e-17
C412	a_113_98##13	X#1	2.86739e-18
C413	VPWR	VPWR#3	1.22905e-17
C414	a_1205_74##4	A3#5	5.97998e-17
C415	a_1010_74##2	a_27_392##3	6.76849e-18
C416	A1	a_27_392##4	4.35549e-17
C417	VPWR#9	VPWR#8	1.78545e-18
C418	a_1010_74##2	A3#1	1.09588e-19
C419	VPWR	a_27_392##3	4.17085e-18
C420	VGND#7	B1	1.58152e-17
C421	VPWR	a_27_392##2	1.2083e-18
C422	a_1010_74#	A2#4	3.32574e-19
C423	VGND#3	a_113_98##2	4.13561e-20
C424	a_27_392##4	A1#2	2.34518e-18
C425	VGND#3	A2#3	6.29329e-20
C426	VGND#5	a_113_98##13	8.0776e-18
C427	VPWR#6	A1#3	4.69357e-20
C428	a_751_74#	A3#5	1.15637e-18
C429	VGND#3	A1#3	5.49768e-20
C430	X#4	X	2.88033e-19
C431	VGND	VGND#6	6.97243e-17
C432	VGND	VGND#5	5.58732e-17
C433	a_1205_74##4	A2#4	2.93484e-18
C434	VPWR#9	a_27_392##9	6.32009e-17
C435	a_113_98##13	X	3.10133e-19
C436	a_1010_74##2	A3#5	3.7085e-19
C437	a_751_74##2	a_27_392##3	3.11288e-18
C438	a_1010_74#	A2#6	9.17723e-20
C439	VPWR#3	A4#4	1.77556e-18
C440	B1	a_27_392##10	1.83466e-17
C441	a_751_74#	A2#4	5.60134e-17
C442	a_113_98##13	a_27_392##6	2.11695e-17
C443	X	a_27_392##4	5.65206e-17
C444	a_27_392##4	a_27_392##9	1.51347e-18
C445	X	VPWR#12	4.18106e-19
C446	VPWR	a_113_98##13	2.78893e-18
C447	a_27_392##4	a_113_98##2	8.27006e-19
C448	a_1205_74##4	A2#6	3.01268e-19
C449	X	a_27_392##6	2.18301e-17
C450	a_1010_74##2	A2#4	2.97689e-17
C451	VGND	a_1205_74##2	2.1105e-18
C452	VGND#6	VNB	3.76774e-17
C453	VPWR	a_27_392##8	1.75534e-17
C454	VGND#5	VNB	3.01581e-17
C455	VGND	a_1010_74#	6.53451e-18
C456	VPWR	VPWR#8	2.09048e-17
C457	VGND	a_1205_74##4	2.30486e-17
C458	VGND	a_751_74#	2.35641e-17
C459	VPWR	a_27_392##9	1.72175e-17
C460	VPWR#11	VNB	2.6821e-17
C461	VPWR#5	VNB	3.6378e-17
C462	VGND	a_1010_74##2	1.11668e-17
C463	VPWR	VPWR#9	3.31454e-17
C464	VPWR#4	VNB	3.05685e-17
C465	VGND	a_751_74##2	2.23356e-17
C466	VPWR#3	VNB	2.46883e-17
C467	VPWR	a_27_392##4	3.46101e-17
C468	a_113_98##12	A3#5	2.37216e-19
C469	VGND	a_113_98##12	4.57691e-17
C470	a_113_98##13	a_113_98##16	1.72257e-18
C471	VPWR	VPWR#10	1.7137e-17
C472	VGND	a_751_74##4	7.41889e-18
C473	a_27_392##4	VPWR#9	5.72292e-17
C474	a_751_74#	A2#6	9.64683e-19
C475	VGND	VGND#8	1.4537e-17
C476	VGND	X#4	1.27694e-17
C477	a_27_392##3	VNB	4.75867e-18
C478	VGND	VGND#9	1.91556e-17
C479	VPWR	X#1	2.28128e-18
C480	a_27_392##2	VNB	2.27286e-18
C481	VGND	X#6	4.05338e-18
C482	VGND	VGND#10	1.92053e-17
C483	VPWR#3	A3#4	9.88103e-19
C484	VGND	a_113_98##13	4.32249e-17
C485	VPWR	a_27_392##6	3.38493e-17
C486	a_751_74##2	A2#4	7.02445e-19
C487	A4	VPWR#2	4.52041e-18
C488	VGND	VGND#7	5.28631e-17
C489	VPWR	a_113_98##16	9.80696e-18
C490	VPWR	a_27_392##10	2.93755e-17
C491	a_1205_74##4	A1#1	2.20925e-19
C492	A1	a_113_98#	1.14156e-17
C493	a_1205_74#	VNB	4.86233e-17
C494	VPWR#2	A3	2.08839e-18
C495	a_1010_74##2	A2#6	3.44259e-17
C496	VGND#4	VNB	2.6051e-18
C497	a_1205_74##2	VNB	5.16501e-18
C498	a_1010_74#	VNB	2.39346e-18
C499	a_1205_74##4	VNB	8.41885e-18
C500	VPWR#10	VPWR#9	1.22756e-18
C501	a_751_74#	VNB	1.02044e-17
C502	a_1010_74##2	VNB	7.79643e-18
C503	a_113_98##13	a_27_392##10	5.9813e-19
C504	a_751_74##2	VNB	6.52031e-18
C505	VGND	X#1	3.86207e-19
C506	a_113_98##12	A2#4	3.33534e-19
C507	a_113_98##12	VNB	2.04779e-17
C508	a_751_74##4	VNB	1.88245e-18
C509	A4	A3#3	2.76932e-18
C510	VGND#8	VNB	3.13538e-18
C511	X#4	VNB	1.67517e-18
C512	a_751_74#	A1#1	2.16679e-19
C513	A3#3	A4#3	3.53282e-17
C514	VGND#9	VNB	8.94675e-18
C515	VPWR#4	A3#6	2.57039e-18
C516	VGND#10	VNB	9.16415e-18
C517	a_113_98##13	VNB	1.19839e-17
C518	VGND#7	VNB	7.46443e-17
C519	X	A2#5	2.43998e-19
C520	A3	A3#3	4.04327e-17
C521	VPWR#1	VNB	5.43165e-17
C522	a_751_74##2	A2#6	3.90591e-17
C523	a_27_392#	VNB	3.16567e-18
C524	VGND	A3#5	1.45291e-18
C525	X	A1#4	9.4681e-19
C526	VPWR#7	VNB	7.62104e-19
C527	VGND	A2#4	8.66911e-19
C528	a_27_392##8	VNB	2.77013e-18
C529	X	A1#6	2.02026e-18
C530	VGND	A2#6	9.10619e-19
C531	VPWR#8	VNB	3.74405e-18
C532	a_27_392##9	VNB	2.1429e-18
C533	VGND	A1#1	1.77361e-18
C534	X	a_113_98#	1.67305e-17
C535	VPWR#9	VNB	5.68236e-18
C536	VGND	A1#5	2.15707e-18
C537	a_27_392##4	VNB	7.53661e-18
C538	X	a_113_98##6	1.58042e-17
C539	A2	A3#3	2.41583e-18
C540	VGND	a_113_98##5	8.71688e-18
C541	VPWR#10	VNB	8.774e-19
C542	VPWR	A3#6	1.37615e-19
C543	VGND#7	a_27_392##10	4.04218e-19
C544	VGND	a_113_98##7	8.71688e-18
C545	X	a_113_98##8	1.13816e-17
C546	A2#2	A3#3	1.32129e-17
C547	a_27_392##4	VPWR#10	5.69342e-17
C548	VPWR	A2#1	7.63666e-20
C549	VPWR#12	VNB	6.45316e-20
C550	A2	A2#3	2.26735e-17
C551	VGND	a_113_98##9	9.47289e-18
C552	X	a_113_98##11	9.74973e-19
C553	VPWR	A2#5	8.85411e-20
C554	a_1010_74##2	A1#1	1.89544e-18
C555	VGND	a_113_98##10	9.13247e-18
C556	VPWR#14	VNB	4.0794e-18
C557	a_27_392##6	VNB	1.688e-17
C558	VGND	B1#4	9.47289e-18
C559	VPWR	A1#4	1.21926e-18
C560	a_751_74#	A2#2	8.48881e-19
C561	a_113_98##16	VNB	9.45145e-19
C562	VGND	B1#5	9.47289e-18
C563	VPWR	A1#6	9.70954e-19
C564	a_27_392##10	VNB	5.60327e-17
C565	A4#1	VNB	2.9914e-17
C566	VPWR	a_113_98#	3.98075e-19
C567	A4#6	VNB	2.59432e-17
C568	A1	A2#3	2.15825e-18
C569	A3#1	VNB	3.06942e-17
C570	VPWR	a_113_98##6	3.5589e-19
C571	a_113_98##3	a_113_98##2	1.06693e-18
C572	a_113_98##12	A2#6	1.47879e-18
C573	A3#5	VNB	3.3218e-17
C574	VPWR	a_113_98##8	3.39359e-19
C575	A1	A1#3	3.1006e-17
C576	A2#4	VNB	3.33874e-17
C577	A2#6	VNB	3.19285e-17
C578	VPWR	a_113_98##11	3.53312e-19
C579	A1#1	VNB	2.9179e-17
C580	A1#5	VNB	3.98655e-17
C581	VPWR	B1#1	1.99971e-18
C582	a_113_98##5	VNB	3.34475e-17
C583	VPWR	B1#6	2.27122e-18
C584	a_113_98##7	VNB	2.95686e-17
C585	a_113_98##9	VNB	2.99176e-17
C586	a_113_98##10	VNB	5.40328e-17
C587	B1#4	VNB	3.26297e-17
C588	VPWR#5	VPWR#4	4.72958e-19
C589	a_751_74##2	A1#1	4.53734e-17
C590	B1#5	VNB	3.61911e-17
C591	A4#5	VNB	3.89894e-17
C592	X	A2#3	7.4856e-20
C593	B1	B1#3	9.9201e-18
C594	VPWR	VPWR#6	7.26443e-17
C595	a_27_392##4	X#2	3.5731e-18
C596	a_27_392##2	A4#4	8.96497e-20
C597	A4#4	VNB	2.9656e-17
C598	A3#4	VNB	2.69265e-17
C599	X	A1#3	1.72901e-18
C600	VPWR#4	A2#1	2.57007e-18
C601	A3#6	VNB	3.06392e-17
C602	A2#1	VNB	3.27909e-17
C603	a_113_98##4	X	1.96886e-17
C604	a_751_74##4	A2#6	1.44444e-19
C605	A2#5	VNB	3.02823e-17
C606	A3	A4	2.27857e-17
C607	A1#4	VNB	3.41124e-17
C608	A1#6	VNB	3.32518e-17
C609	a_113_98#	VNB	5.25979e-17
C610	a_1010_74##2	A1#5	8.66246e-19
C611	a_113_98##6	VNB	2.88387e-17
C612	a_113_98##8	VNB	3.03898e-17
C613	VGND	VGND#3	1.4548e-16
C614	VPWR	a_113_98##4	8.34257e-18
C615	a_113_98##11	VNB	4.18033e-17
C616	B1#1	VNB	4.01764e-17
C617	VPWR	B1#3	2.05284e-18
C618	A2	A3	2.40285e-17
C619	X#4	A2#4	3.81742e-19
C620	B1#6	VNB	4.25146e-17
C621	a_113_98##12	A1#1	2.72426e-17
C622	VPWR#2	VNB	1.30319e-16
C623	VGND	a_113_98##4	7.68289e-18
C624	VPWR#6	VNB	3.68762e-17
C625	VGND#3	VNB	8.25986e-17
C626	VGND	B1#3	2.31728e-18
C627	A1	A2	9.3613e-18
C628	A3#3	VNB	8.31325e-17
C629	A2#3	VNB	4.40893e-17
C630	VGND#8	A2#6	4.863e-20
C631	A1#3	VNB	4.9483e-17
C632	a_27_392##4	VPWR#12	1.98876e-17
C633	a_113_98##4	VNB	3.13408e-17
C634	B1#3	VNB	5.78022e-17
C635	a_751_74##2	A1#5	8.02103e-19
C636	VPWR	A3	3.23637e-18
C637	X	A1	2.80326e-17
C638	VPWR	A2	3.73963e-18
C639	VPWR#5	A2#5	2.56999e-18
C640	VGND	A3	4.19822e-18
C641	VPWR	A1	5.45523e-18
C642	VGND	A2	5.27097e-18
C643	VPWR	B1	1.07083e-18
C644	A4	VNB	2.31825e-17
C645	VGND	A1	6.73725e-18
C646	a_751_74##4	A1#1	3.42415e-19
C647	A3	VNB	8.8492e-18
C648	VPWR	X	8.52736e-18
C649	VGND	B1	1.36488e-18
C650	A2	VNB	5.27574e-18
C651	A1	VNB	8.69311e-18
C652	VGND	X	2.48052e-19
C653	B1	VNB	1.7532e-17
C654	a_27_392##2	A3#4	1.40122e-17
C655	X	VNB	2.92681e-18
C656	a_1010_74##2	a_113_98##5	8.40136e-19
C657	VPWR	VNB	2.88999e-16
C658	VGND	VNB	3.06013e-16
C659	X#4	A2#6	3.43371e-19
C660	a_113_98##12	A1#5	4.25128e-17
C661	VGND#2	a_1010_74#	1.93422e-18
C662	a_27_392##10	VPWR#13	6.31782e-17
C663	VPWR#13	B1#6	4.62985e-18
C664	VGND#2	A4#1	2.31653e-18
C665	VGND#2	a_1205_74##4	4.93773e-17
C666	VPWR#13	VPWR#11	9.56424e-19
C667	VGND#2	A4#6	2.16162e-18
C668	VGND#2	a_751_74#	2.06889e-17
C669	VGND#2	A3#1	5.80724e-18
C670	VGND#2	a_1010_74##2	1.69189e-18
C671	VGND#2	A3#5	4.48044e-18
C672	VGND#2	A2#4	2.77998e-18
C673	VGND	VGND#2	7.02891e-17
C674	VPWR	VPWR#13	1.50351e-16
C675	VGND#2	VNB	1.96126e-16
C676	VPWR#13	a_113_98##4	2.84226e-20
C677	VGND#2	a_1205_74#	3.47308e-17
C678	VGND#2	A3#3	7.12324e-20
C679	VPWR#13	B1#3	4.52679e-20
C680	VPWR#13	VNB	7.84237e-17
C681	VGND#2	VGND#4	2.28606e-17
C682	VPWR#13	a_113_98##8	5.48833e-19
C683	VGND#2	A2#2	7.19848e-20
C684	VPWR#13	a_113_98##10	5.89318e-20
C685	VPWR#13	B1#2	2.10793e-20
C686	VGND#2	A4	4.02457e-18
C687	a_27_392##6	VPWR#13	3.94497e-17
C688	VPWR#13	a_113_98##11	6.86135e-18
C689	VGND#2	a_1205_74##2	5.84195e-17
C690	VPWR#13	B1#1	5.27184e-18
C691	VGND#2	A3	3.09298e-18
*
*
.ENDS sky130_fd_sc_hs__a41o_4
*
