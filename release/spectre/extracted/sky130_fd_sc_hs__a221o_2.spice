* Extracted by Quantus, converted by sky130cad/quantus.py
*
*
*
*                       LINUX           Wed Nov 18 08:06:45 2026
*
*
*
*  PROGRAM  advgen
*
*  Name           : advgen - Quantus - (64-bit)
*  Version        : 25.1.0-p047
*  Build Date     : Thu Dec 11 23:20:30 PST 2025
*
*  HSPICE LIBRARY
*
*  OPERATING_TEMPERATURE 150
*  QRC_TECH_DIR <path>/tech
*
*
*

*
.SUBCKT sky130_fd_sc_hs__a221o_2 VPB VNB VGND VPWR X B2 C1 A2 A1 B1
*
*
*  caps2d version: 10
*
*
*       TRANSISTOR CARDS
*
*
XM1 X#3 a_89_260##7 VGND#5 VNB sky130_fd_pr__nfet_01v8_lvt l=0.15 w=0.74 ad=0.2072 as=0.1961 pd=2.04 ps=2.01
XM9 VGND#7 a_89_260##6 X#3 VNB sky130_fd_pr__nfet_01v8_lvt l=0.15 w=0.74 ad=0.3515 as=0.2072 pd=2.43 ps=2.04
XM7 VGND#7 A2#1 a_337_74# VNB sky130_fd_pr__nfet_01v8_lvt l=0.15 w=0.74 ad=0.3515 as=0.1554 pd=2.43 ps=1.9
XM8 a_337_74# A1#1 a_89_260##10 VNB sky130_fd_pr__nfet_01v8_lvt l=0.15 w=0.74 ad=0.1554 as=0.6068 pd=1.9 ps=3.12
XM13 a_89_260##10 B1#1 a_603_74# VNB sky130_fd_pr__nfet_01v8_lvt l=0.15 w=0.74 ad=0.6068 as=0.1554 pd=3.12 ps=1.9
XM3 a_603_74# B2#3 VGND#6 VNB sky130_fd_pr__nfet_01v8_lvt l=0.15 w=0.74 ad=0.1554 as=0.2886 pd=1.9 ps=2.26
XM5 VGND#6 C1#4 a_89_260##8 VNB sky130_fd_pr__nfet_01v8_lvt l=0.15 w=0.74 ad=0.2886 as=0.1961 pd=2.26 ps=2.01
XM2 VPWR#4 a_89_260##5 X#1 VPB sky130_fd_pr__pfet_01v8 l=0.15 w=1.12 ad=0.308 as=0.336 pd=2.79 ps=2.84
XM11 X#1 a_89_260# VPWR#6 VPB sky130_fd_pr__pfet_01v8 l=0.15 w=1.12 ad=0.336 as=0.398 pd=2.84 ps=2.97
XM10 VPWR#6 A2#3 a_316_392##2 VPB sky130_fd_pr__pfet_01v8 l=0.15 w=1 ad=0.398 as=0.3 pd=2.97 ps=2.6
XM4 a_316_392##2 A1#3 VPWR#5 VPB sky130_fd_pr__pfet_01v8 l=0.15 w=1 ad=0.3 as=0.275 pd=2.6 ps=2.55
XM12 a_515_392##2 B1#4 a_316_392# VPB sky130_fd_pr__pfet_01v8 l=0.15 w=1 ad=0.275 as=0.3 pd=2.55 ps=2.6
XM6 a_316_392# B2#1 a_515_392# VPB sky130_fd_pr__pfet_01v8 l=0.15 w=1 ad=0.3 as=0.3 pd=2.6 ps=2.6
XM0 a_515_392# C1#3 a_89_260##13 VPB sky130_fd_pr__pfet_01v8 l=0.15 w=1 ad=0.3 as=0.275 pd=2.6 ps=2.55
*
*
*       RESISTOR AND CAP/DIODE CARDS
*
Rg1	a_89_260#	a_89_260##2	471.657928
Rg2	a_89_260##2	a_89_260##3	23.706415
Rg3	a_89_260##3	a_89_260##4	29.629290
Rg4	a_89_260##4	a_89_260##5	471.571991
Rg5	a_89_260##2	a_89_260##6	365.898590
Rg6	a_89_260##4	a_89_260##7	368.453094
Rg7	A2#1	A2#2	330.892151
Rg8	A2#2	A2#3	492.429810
Rg9	A1#1	A1#2	459.376526
Rg10	A1#2	A1#3	408.924988
Rg11	B1#1	B1#2	454.941925
Rg12	B1#2	B1#3	42.409290
Rg13	B1#2	B1#4	424.106537
Rg14	B2#1	B2#2	509.830780
Rg15	B2#2	B2#3	307.937683
Rg16	C1#1	C1#2	22.738758
Rg17	C1#2	C1#3	569.818970
Rg18	C1#2	C1#4	329.212952
Rf1	X	X#2	0.196836
Rf2	X#2	X	14.369054
Rf3	X	X#3	128.934143
Rf4	X#1	X#2	5.000000
Rf5	A2#2	A2#5	162.267883
Rf6	A2#6	A2	2.035075
Rf7	A2#5	A2#6	7.862125
Rf8	A1#2	A1#5	161.189423
Rf9	A1#6	A1	0.956614
Rf10	A1#5	A1#6	3.149382
Rf11	B1#3	B1	162.353989
Rf12	a_316_392#	a_316_392##2	136.154053
Rf13	a_515_392#	a_515_392##2	137.133667
Rf14	B2#4	B2#2	161.623566
Rf15	B2	B2#6	1.390769
Rf16	B2#4	B2#6	7.412643
Rf17	C1#5	C1	0.882458
Rf18	C1#1	C1#7	161.115265
Rf19	C1#5	C1#7	3.543054
Rf20	a_89_260##8	a_89_260##9	84.774704
Rf21	a_89_260##9	a_89_260##11	13.586550
Rf22	a_89_260##11	a_89_260##3	189.337585
Rf23	a_89_260##9	a_89_260##13	147.227768
Rf24	a_89_260##10	a_89_260##11	3.750000
Rf26	VGND#2	VGND#3	100.399551
Rf27	VGND#3	VGND#4	62.948483
Rf28	VGND#4	VGND#5	116.088333
Rf29	VGND#2	VGND#6	31.432171
Rf30	VGND#4	VGND#7	28.244987
Rf32	VPWR#2	VPWR#3	67.202744
Rf33	VPWR#3	VPWR#4	114.576180
Rf34	VPWR#2	VPWR#5	36.607323
Rf35	VPWR#3	VPWR#6	44.934231
Re1	VPWR#2	VPWR	1.091357
Re2	VGND	VGND#3	1.091398
*
*       CAPACITOR CARDS
*
*
C1	VGND#4	X#3	1.26794e-17
C2	a_89_260##8	B2#6	2.46549e-17
C3	a_89_260##13	C1#2	1.32033e-17
C4	VGND#5	VGND#4	1.1909e-18
C5	A2#5	A1#5	1.00312e-17
C6	C1#1	C1#2	1.00229e-17
C7	VPWR#3	VPWR#5	3.00346e-19
C8	a_89_260##9	a_89_260##13	9.20488e-19
C9	a_89_260##9	C1#2	2.81872e-19
C10	a_316_392##2	VPWR#3	6.88174e-18
C11	B2#2	C1#2	3.7201e-17
C12	C1#7	a_89_260##13	3.70794e-17
C13	a_89_260##9	a_316_392#	3.07655e-17
C14	a_89_260##10	A1#5	1.11602e-17
C15	B2#6	a_89_260##13	2.38984e-17
C16	VPWR#4	VPWR#3	7.06672e-19
C17	a_89_260##8	VGND#6	5.45589e-17
C18	C1#7	C1#2	1.23876e-17
C19	a_89_260##10	A2#5	3.14312e-17
C20	a_89_260##9	VPWR#6	2.71437e-22
C21	a_89_260##10	a_89_260##8	1.95581e-18
C22	A2#5	VGND#7	1.7891e-18
C23	a_89_260##10	VGND#6	1.42484e-17
C24	VGND#4	B2#3	8.91295e-20
C25	VGND#4	B1#1	2.18402e-19
C26	a_89_260##4	A2#2	2.60761e-17
C27	a_89_260##9	C1#4	8.29687e-19
C28	B2#6	C1#2	6.76511e-18
C29	VGND#4	A1#1	9.75387e-19
C30	a_89_260##9	B2#3	1.89616e-17
C31	a_89_260##10	VGND#7	2.62376e-17
C32	a_89_260##8	a_89_260##13	3.63613e-18
C33	A1#5	VPWR#5	2.37112e-19
C34	VGND#4	A2#1	7.4096e-18
C35	a_89_260##3	a_89_260##4	2.87721e-17
C36	X#3	a_89_260##10	1.60321e-18
C37	a_89_260##9	B1#1	1.35257e-17
C38	A1#5	a_316_392##2	2.21372e-17
C39	VGND#4	a_89_260##6	7.34345e-18
C40	a_89_260##9	A1#1	6.83968e-19
C41	X#3	VGND#7	3.60118e-17
C42	VGND#4	a_89_260##7	3.76333e-18
C43	VGND#5	VGND#7	1.99285e-18
C44	X#3	VGND#5	7.54681e-17
C45	a_89_260##10	a_316_392#	7.41276e-18
C46	a_89_260##9	a_89_260##6	1.37204e-20
C47	a_89_260##10	a_316_392##2	3.6636e-18
C48	a_89_260##13	a_515_392#	9.49201e-17
C49	VPWR#3	A1#3	5.07292e-19
C50	a_89_260##13	a_316_392#	1.59181e-17
C51	a_89_260##8	C1#4	4.65053e-17
C52	a_515_392#	a_316_392#	7.67316e-17
C53	A2#5	B1#1	3.38787e-19
C54	C1#4	VGND#6	2.38781e-17
C55	VPWR#3	A2#3	6.94289e-18
C56	a_89_260##8	B2#3	1.73963e-18
C57	a_515_392##2	a_515_392#	2.14025e-18
C58	A2#5	A1#1	2.64822e-18
C59	VGND#6	B2#3	3.57064e-17
C60	a_89_260##9	B1#4	3.90713e-18
C61	a_89_260##8	B1#1	3.54848e-19
C62	a_316_392#	a_515_392##2	5.4263e-17
C63	a_89_260##10	C1#4	6.43123e-19
C64	VPWR#3	a_89_260#	7.43029e-18
C65	VGND#6	B1#1	4.01028e-18
C66	a_316_392#	VPWR#5	1.28425e-17
C67	a_89_260##10	B2#3	3.40783e-18
C68	a_89_260##9	A1#3	9.87084e-19
C69	VGND#6	A1#1	5.02408e-19
C70	VPWR#5	a_515_392##2	5.80759e-17
C71	VPWR#3	a_89_260##5	2.16586e-18
C72	a_316_392##2	a_316_392#	1.69028e-18
C73	a_89_260##10	B1#1	6.22782e-17
C74	VGND#7	B2#3	1.49229e-19
C75	a_89_260##9	A2#3	4.80544e-19
C76	VGND#6	A2#1	1.90939e-19
C77	a_89_260##10	A1#1	7.55924e-17
C78	a_316_392##2	VPWR#5	7.53194e-17
C79	VGND#7	B1#1	2.94323e-19
C80	a_89_260##9	a_89_260#	1.58734e-19
C81	a_89_260##10	A2#1	2.02085e-17
C82	VPWR#6	VPWR#5	2.40284e-18
C83	VGND#7	A1#1	3.60853e-18
C84	a_89_260##10	a_89_260##6	3.43751e-19
C85	VPWR#6	a_316_392##2	8.14836e-17
C86	X#3	A1#1	1.59788e-19
C87	VGND#7	A2#1	3.67571e-17
C88	a_89_260##10	a_89_260##7	3.1466e-19
C89	X#3	A2#1	7.32197e-19
C90	VGND#7	a_89_260##6	3.36645e-17
C91	VGND#3	VGND#4	5.38007e-17
C92	X#3	a_89_260##6	1.32058e-17
C93	VGND#7	a_89_260##7	1.91782e-18
C94	VPWR#4	VPWR#6	2.00319e-18
C95	VGND#5	a_89_260##6	1.21536e-18
C96	A1#5	A2#3	1.90091e-19
C97	X#3	a_89_260##7	5.13275e-17
C98	a_89_260##7	VGND#5	1.95224e-17
C99	a_89_260##13	C1#3	5.53566e-17
C100	B2#3	C1#4	2.37594e-17
C101	C1#3	a_515_392#	2.66834e-17
C102	a_89_260##9	B2#2	6.04519e-17
C103	a_89_260##13	B2#1	1.6026e-17
C104	B2#6	C1#1	1.37693e-17
C105	a_316_392#	C1#3	1.96947e-18
C106	a_515_392#	B2#1	4.25839e-17
C107	C1#7	B2#2	1.44336e-18
C108	B1#1	B2#3	5.62806e-17
C109	a_515_392##2	C1#3	1.83236e-19
C110	a_89_260##13	B1#4	1.69694e-19
C111	a_316_392#	B2#1	4.57653e-17
C112	a_89_260##9	B1#3	4.60652e-17
C113	VPWR#3	A2#2	8.77929e-20
C114	a_515_392#	B1#4	3.79489e-19
C115	B2#6	B2#2	5.4802e-18
C116	VPWR#5	C1#3	8.49416e-20
C117	a_515_392##2	B2#1	4.09642e-19
C118	a_89_260##13	A1#3	5.48035e-20
C119	a_316_392#	B1#4	5.39482e-17
C120	A1#1	B1#1	3.30238e-18
C121	VPWR#5	B2#1	2.03279e-19
C122	a_515_392#	A1#3	5.97228e-20
C123	a_89_260##9	A1#2	4.12624e-19
C124	a_515_392##2	B1#4	3.47294e-17
C125	A2	a_89_260##4	1.26479e-18
C126	a_89_260##3	VPWR#3	3.26219e-19
C127	a_316_392#	A1#3	1.89813e-18
C128	VPWR#5	B1#4	4.13837e-18
C129	a_515_392##2	A1#3	1.20313e-18
C130	A2#1	A1#1	5.77032e-17
C131	VGND#4	a_89_260##3	4.93138e-19
C132	A2#5	a_89_260##4	3.49251e-18
C133	a_316_392##2	B1#4	1.26886e-19
C134	a_316_392#	A2#3	3.15301e-19
C135	a_89_260##9	A2#2	4.09394e-19
C136	VPWR#5	A1#3	5.84986e-17
C137	a_316_392##2	A1#3	3.31923e-17
C138	a_89_260##8	C1#1	3.58071e-17
C139	VPWR#5	A2#3	2.42979e-18
C140	a_89_260##6	A2#1	1.67812e-17
C141	VGND#3	a_89_260##10	3.91378e-17
C142	VPWR#6	A1#3	6.22665e-19
C143	a_316_392##2	A2#3	4.96946e-17
C144	VPWR#5	a_89_260#	3.06908e-19
C145	a_89_260##8	B2#2	1.6861e-18
C146	A2#3	VPWR#6	2.48116e-17
C147	A1#5	A1#2	9.67043e-18
C148	A2#5	B1#3	3.55075e-19
C149	a_316_392##2	a_89_260#	1.51036e-18
C150	a_89_260##7	a_89_260##6	3.91526e-17
C151	B2#2	VGND#6	1.80052e-18
C152	a_89_260#	VPWR#6	3.1527e-17
C153	VGND#3	VGND#5	2.39765e-17
C154	VPWR#4	A2#3	2.57851e-19
C155	a_89_260#	X#1	2.37354e-17
C156	A2#5	A1#2	4.10796e-18
C157	C1#2	a_89_260##8	6.16695e-18
C158	A1#5	A2#2	2.00734e-18
C159	VPWR#6	a_89_260##5	7.14071e-19
C160	VPWR#4	a_89_260#	1.23306e-18
C161	a_89_260##5	X#1	2.44089e-17
C162	a_89_260##10	B1#3	3.01956e-17
C163	A2#5	A2#2	1.06293e-17
C164	a_89_260##5	VPWR#4	3.13013e-17
C165	a_89_260##10	A1#2	3.25751e-18
C166	a_89_260##13	B2#2	2.89705e-17
C167	a_89_260##3	A2#5	3.7173e-17
C168	a_515_392#	B2#2	5.1697e-19
C169	B2#1	C1#3	5.35767e-17
C170	a_89_260##10	A2#2	1.73723e-19
C171	a_89_260##9	a_603_74#	3.74243e-18
C172	B1#3	a_316_392#	3.73794e-17
C173	VGND#7	A2#2	1.06734e-18
C174	B1#4	B2#1	4.22058e-17
C175	B1#3	a_515_392##2	3.89241e-18
C176	X	a_89_260##4	1.07787e-17
C177	a_89_260##3	VGND#7	4.03542e-17
C178	a_89_260##3	X#3	7.234e-17
C179	A1#3	B1#4	5.56564e-18
C180	VPWR#5	A1#2	1.16327e-18
C181	VGND#3	A1#1	5.52476e-18
C182	a_316_392##2	A1#2	2.88987e-18
C183	A2#3	A1#3	4.40234e-17
C184	B1#1	B2#2	8.16489e-18
C185	a_316_392##2	A2#2	9.06572e-19
C186	a_89_260#	A2#3	3.93695e-17
C187	B2#6	C1#7	1.79861e-17
C188	A1#1	B1#3	1.9783e-19
C189	a_89_260##3	VPWR#6	9.82543e-18
C190	a_89_260##3	X#1	2.37113e-18
C191	a_89_260##5	a_89_260#	4.76972e-17
C192	A2#2	A1#1	8.20443e-18
C193	A2	VPWR#3	3.57517e-19
C194	a_89_260##10	a_337_74#	4.31855e-18
C195	a_89_260##3	B1#1	1.7049e-19
C196	a_89_260##3	A1#1	3.13543e-19
C197	a_89_260##6	A2#2	4.19509e-19
C198	B1#3	B2#1	5.25737e-18
C199	VGND	C1#2	6.19882e-19
C200	a_89_260##3	a_89_260##6	7.00622e-18
C201	VGND	a_89_260##4	6.0141e-19
C202	a_89_260##3	a_89_260##7	8.56982e-19
C203	A1#3	B1#3	3.68652e-19
C204	A2#3	A1#2	3.89428e-18
C205	A2	A1#5	2.01828e-17
C206	B2#3	a_603_74#	1.2467e-17
C207	a_89_260##10	A1	1.2831e-17
C208	B1#1	a_603_74#	1.40031e-17
C209	a_89_260#	A2#2	3.70805e-18
C210	C1#1	B2#2	1.34668e-18
C211	VGND#3	B1#3	1.35151e-19
C212	VPWR#3	a_89_260##4	9.14229e-20
C213	A1#1	a_337_74#	1.44693e-17
C214	C1#2	VNB	5.88559e-17
C215	A2#1	a_337_74#	1.44693e-17
C216	a_89_260##4	VNB	6.69769e-17
C217	X	VPWR#3	1.67068e-17
C218	A1	a_316_392#	7.77273e-18
C219	VGND#3	A1#2	6.95986e-20
C220	B1#3	B2#2	3.1431e-17
C221	A1	VPWR#5	1.96013e-18
C222	A1	a_316_392##2	1.20673e-17
C223	A1#2	B1#3	2.48677e-17
C224	A2	a_316_392##2	3.45599e-17
C225	VPWR	VPWR#3	4.26157e-17
C226	A2	VPWR#6	1.91657e-17
C227	A2#2	A1#2	2.9687e-17
C228	VPWR	a_89_260##9	1.64002e-18
C229	VPWR	C1#7	1.98054e-18
C230	VPWR	B2#6	1.15921e-18
C231	a_89_260##3	A2#2	7.99436e-18
C232	VPWR	A1#5	8.66076e-19
C233	VGND	VGND#4	6.331e-17
C234	X#3	X	3.04459e-18
C235	VGND	a_89_260##9	7.19484e-18
C236	A2#5	a_89_260##9	3.7196e-18
C237	VGND	B2#6	1.65265e-18
C238	X	VPWR#6	7.75631e-17
C239	A2	A2#3	4.01515e-18
C240	X	X#1	8.9284e-19
C241	VGND	A1#5	1.03532e-18
C242	X	VPWR#4	1.01914e-16
C243	A2	a_89_260#	2.86276e-18
C244	VPWR	a_89_260##13	2.00374e-17
C245	VPWR	a_515_392#	2.15397e-17
C246	A2	a_89_260##5	2.83879e-19
C247	VPWR#3	VNB	3.31374e-17
C248	VGND	A2#5	3.74803e-18
C249	VPWR	a_316_392#	1.21763e-17
C250	VPWR	a_515_392##2	1.75418e-17
C251	VGND#4	VNB	4.23972e-17
C252	VGND	a_89_260##8	1.75866e-17
C253	VPWR	VPWR#5	2.19381e-17
C254	VGND	VGND#6	1.90743e-17
C255	VPWR	a_316_392##2	1.54878e-17
C256	VGND	a_89_260##10	3.82242e-17
C257	a_89_260##9	VNB	4.33651e-18
C258	C1#7	VNB	1.02546e-17
C259	VPWR	VPWR#4	3.6097e-17
C260	A1	B1#3	3.02438e-17
C261	VGND	X#3	1.76423e-17
C262	B2#6	VNB	1.54805e-18
C263	VGND	VGND#5	3.35425e-17
C264	VGND	a_89_260##13	5.42097e-18
C265	A1	A1#2	4.59395e-18
C266	VGND#4	a_89_260##10	1.57538e-18
C267	A1#5	VNB	3.23358e-19
C268	X	B1#4	3.21472e-19
C269	VGND#4	a_89_260##4	1.84256e-19
C270	X	A1#3	7.72288e-19
C271	A2	A1#2	3.99346e-18
C272	a_89_260##8	VNB	3.90643e-17
C273	X	A2#3	4.01883e-18
C274	VGND#6	VNB	1.95259e-18
C275	A2	A2#2	6.74564e-18
C276	X	a_89_260#	4.24413e-17
C277	a_89_260##10	VNB	1.0737e-17
C278	VPWR	C1#3	1.42997e-18
C279	VGND	C1#4	5.7079e-19
C280	X	a_89_260##5	5.15983e-17
C281	a_89_260##3	A2	9.32516e-18
C282	VGND	B2#3	1.15208e-18
C283	VPWR	B2#1	1.59745e-18
C284	VGND#7	VNB	2.10554e-19
C285	X#3	VNB	3.13124e-17
C286	VGND	B1#1	8.29261e-19
C287	VPWR	B1#4	2.03255e-18
C288	VGND#5	VNB	5.27488e-17
C289	VGND	A1#1	1.88318e-19
C290	a_89_260##13	VNB	6.12437e-17
C291	VPWR	A1#3	1.12699e-18
C292	VGND	A2#1	4.21525e-19
C293	a_515_392#	VNB	5.3617e-18
C294	VPWR	A2#3	2.17137e-18
C295	a_316_392#	VNB	6.2682e-18
C296	VGND	a_89_260##6	6.68867e-20
C297	a_515_392##2	VNB	1.00001e-17
C298	VGND	a_89_260##7	3.24583e-19
C299	VPWR	a_89_260#	2.52409e-18
C300	VPWR#5	VNB	7.66075e-18
C301	a_316_392##2	VNB	5.39612e-18
C302	VPWR	a_89_260##5	2.11767e-18
C303	VPWR#6	VNB	4.85989e-18
C304	VPWR#4	VNB	6.91027e-17
C305	X	B1#3	1.00013e-19
C306	C1#4	VNB	3.16345e-17
C307	X#3	a_89_260##4	1.01372e-17
C308	B2#3	VNB	2.32844e-17
C309	X	A1#2	8.66306e-19
C310	B1#1	VNB	3.22041e-17
C311	A1#1	VNB	3.25564e-17
C312	X	A2#2	1.27568e-19
C313	A2#1	VNB	2.26248e-17
C314	VPWR	B2#2	1.18491e-18
C315	a_89_260##6	VNB	2.79589e-17
C316	X	a_89_260##3	6.2858e-17
C317	a_89_260##7	VNB	3.44651e-17
C318	VPWR	B1#3	1.36944e-18
C319	VPWR	A1#2	9.57191e-20
C320	C1#3	VNB	4.42898e-17
C321	B2#1	VNB	3.7088e-17
C322	VGND	VGND#3	2.18518e-17
C323	B1#4	VNB	3.73031e-17
C324	VGND	C1#1	2.84228e-18
C325	A1#3	VNB	3.06613e-17
C326	VPWR	a_89_260##3	4.8155e-18
C327	VGND	B2#2	1.63685e-18
C328	A2#3	VNB	3.85571e-17
C329	a_89_260#	VNB	3.82656e-17
C330	VGND	B1#3	2.75797e-18
C331	a_89_260##5	VNB	4.50634e-17
C332	VGND#3	VNB	2.17844e-16
C333	VGND	a_89_260##3	7.18672e-18
C334	C1#1	VNB	6.99372e-18
C335	B2#2	VNB	3.34282e-17
C336	B1#3	VNB	7.01582e-17
C337	a_89_260##9	VGND#6	1.17412e-17
C338	A1#2	VNB	4.3069e-17
C339	A2#2	VNB	2.87841e-17
C340	a_89_260##3	VNB	2.26421e-18
C341	X	A2	3.81583e-18
C342	VPWR	A1	9.27037e-19
C343	VPWR	A2	3.7075e-18
C344	VGND	A1	1.41595e-18
C345	A1	VNB	3.23638e-18
C346	VPWR	X	1.95177e-17
C347	VGND	X	2.91286e-18
C348	X	VNB	3.44548e-17
C349	VPWR	VNB	6.81069e-17
C350	VGND	VNB	6.2074e-17
C351	VGND#2	a_89_260##8	1.98989e-17
C352	VGND#2	a_89_260##10	4.85048e-18
C353	VPWR#2	B1#3	2.53758e-19
C354	a_89_260##13	VPWR#2	2.10058e-17
C355	VGND#2	C1#2	2.37332e-19
C356	VPWR#2	VPWR#4	2.74316e-17
C357	VGND#2	B2#3	3.66907e-18
C358	a_515_392#	VPWR#2	5.33585e-17
C359	VPWR	VPWR#2	6.14557e-17
C360	a_316_392#	VPWR#2	9.38656e-19
C361	VPWR#2	C1#3	5.74096e-18
C362	a_515_392##2	VPWR#2	3.65791e-17
C363	VGND#2	B1#1	6.82974e-18
C364	VPWR#2	VNB	2.76829e-16
C365	VPWR#2	B2#1	4.45925e-18
C366	VGND	VGND#2	4.35418e-17
C367	VPWR#2	C1#2	1.69289e-19
C368	VPWR#2	B1#4	4.43469e-18
C369	VGND#3	VGND#2	6.50608e-17
C370	VGND#2	B1#3	1.18156e-20
C371	a_316_392##2	VPWR#2	7.12604e-18
C372	VGND#2	a_89_260##9	3.41619e-18
C373	VPWR#2	A1#3	1.83429e-18
C374	VGND#2	C1#4	2.74781e-18
C375	VGND#2	VNB	5.87363e-17
C376	VPWR#2	B2#2	3.69145e-20
C377	VPWR#2	VPWR#3	4.53198e-17
*
*
.ENDS sky130_fd_sc_hs__a221o_2
*
