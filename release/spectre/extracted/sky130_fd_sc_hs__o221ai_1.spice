* Extracted by Quantus, converted by sky130cad/quantus.py
*
*
*
*                       LINUX           Wed Nov 18 08:57:40 2026
*
*
*
*  PROGRAM  advgen
*
*  Name           : advgen - Quantus - (64-bit)
*  Version        : 25.1.0-p047
*  Build Date     : Thu Dec 11 23:20:30 PST 2025
*
*  HSPICE LIBRARY
*
*  OPERATING_TEMPERATURE 150
*  QRC_TECH_DIR <path>/tech
*
*
*

*
.SUBCKT sky130_fd_sc_hs__o221ai_1 VNB VPB VGND VPWR Y C1 A1 B1 B2 A2
*
*
*  caps2d version: 10
*
*
*       TRANSISTOR CARDS
*
*
XM8 Y#3 C1#4 a_114_74##2 VNB sky130_fd_pr__nfet_01v8_lvt l=0.15 w=0.74 ad=0.2109 as=0.2627 pd=2.05 ps=2.19
XM2 a_239_74##3 B1#1 a_114_74# VNB sky130_fd_pr__nfet_01v8_lvt l=0.15 w=0.74 ad=0.2109 as=0.259 pd=2.05 ps=2.18
XM0 a_114_74# B2#1 a_239_74##4 VNB sky130_fd_pr__nfet_01v8_lvt l=0.15 w=0.74 ad=0.259 as=0.259 pd=2.18 ps=2.18
XM7 a_239_74##4 A2#1 VGND#4 VNB sky130_fd_pr__nfet_01v8_lvt l=0.15 w=0.74 ad=0.259 as=0.4736 pd=2.18 ps=2.76
XM4 VGND#4 A1#1 a_239_74# VNB sky130_fd_pr__nfet_01v8_lvt l=0.15 w=0.74 ad=0.4736 as=0.2109 pd=2.76 ps=2.05
XM1 Y#5 C1#1 VPWR#7 VPB sky130_fd_pr__pfet_01v8 l=0.15 w=1.12 ad=0.3304 as=0.8512 pd=2.83 ps=3.76
XM5 VPWR#7 B1#4 a_324_368# VPB sky130_fd_pr__pfet_01v8 l=0.15 w=1.12 ad=0.8512 as=0.3024 pd=3.76 ps=2.78
XM6 a_324_368# B2#3 Y#1 VPB sky130_fd_pr__pfet_01v8 l=0.15 w=1.12 ad=0.3024 as=0.4704 pd=2.78 ps=3.08
XM3 Y#1 A2#3 a_522_368# VPB sky130_fd_pr__pfet_01v8 l=0.15 w=1.12 ad=0.4704 as=0.4704 pd=3.08 ps=3.08
XM9 a_522_368# A1#3 VPWR#6 VPB sky130_fd_pr__pfet_01v8 l=0.15 w=1.12 ad=0.4704 as=0.3304 pd=3.08 ps=2.83
*
*
*       RESISTOR AND CAP/DIODE CARDS
*
Rg1	C1#1	C1#2	467.755005
Rg2	C1#2	C1#3	39.303265
Rg3	C1#2	C1#4	346.919952
Rg4	B1#1	B1#2	397.555725
Rg5	B1#2	B1#3	30.596949
Rg6	B1#2	B1#4	449.655212
Rg7	B2#1	B2#2	382.539734
Rg8	B2#2	B2#3	434.639221
Rg9	A2#1	A2#2	382.539734
Rg10	A2#2	A2#3	434.639221
Rg11	A1#1	A1#2	376.352570
Rg12	A1#2	A1#3	493.901062
Rf1	C1	C1#3	168.106262
Rf2	B1#5	B1#3	81.644417
Rf3	B1	B1#7	1.528014
Rf4	B1#5	B1#7	2.982629
Rf5	a_114_74#	a_114_74##2	108.279182
Rf6	B2#2	B2#5	162.066422
Rf7	B2#6	B2	1.833616
Rf8	B2#5	B2#6	4.913828
Rf9	Y#1	Y#2	124.619759
Rf10	Y#2	Y	90.562889
Rf11	Y	Y#4	7.282945
Rf12	Y#2	Y#5	39.282005
Rf13	Y#4	Y	7.282945
Rf14	Y#3	Y#4	7.500000
Rf15	A2	A2#2	166.137894
Rf16	A1#4	A1	1.879015
Rf17	A1#2	A1#6	81.995415
Rf18	A1#4	A1#6	6.321734
Rf19	A1#7	A1	1.879015
Rf20	A1#6	A1#7	6.871449
Rf21	a_239_74#	a_239_74##2	106.241997
Rf22	a_239_74##2	a_239_74##3	80.602478
Rf23	a_239_74##2	a_239_74##4	18.149860
Rf25	VPWR#2	VPWR#3	102.976662
Rf26	VPWR#3	VPWR#4	56.246181
Rf28	VPWR#2	VPWR#6	35.727165
Rf29	VPWR#4	VPWR#7	16.729233
Rf31	VGND#2	VGND#3	75.192337
Rf32	VGND#2	VGND#4	20.522366
Re1	VPWR#3	VPWR	1.227783
Re2	VGND	VGND#3	1.227829
*
*       CAPACITOR CARDS
*
*
C1	VGND	VNB	7.28841e-17
C2	VPWR	VNB	7.16664e-17
C3	Y	VNB	4.38327e-17
C4	C1	VNB	1.69448e-17
C5	A1	VNB	2.97441e-17
C6	B1	VNB	5.23416e-18
C7	A2	VNB	2.30909e-18
C8	VGND	Y	2.10805e-17
C9	C1#3	VNB	7.60362e-17
C10	B2#2	VNB	3.455e-17
C11	A2#2	VNB	2.41032e-17
C12	A1#2	VNB	7.92904e-17
C13	VGND#3	VNB	2.53272e-16
C14	VGND	A1	4.52005e-18
C15	VPWR#3	VNB	1.97156e-16
C16	C1#1	VNB	4.48782e-17
C17	VPWR	C1	6.28131e-18
C18	B1#4	VNB	2.71967e-17
C19	B2#3	VNB	2.77548e-17
C20	A2#3	VNB	3.08286e-17
C21	A1#3	VNB	3.74703e-17
C22	VPWR	A1	7.18219e-18
C23	C1#4	VNB	3.94074e-17
C24	B1#1	VNB	3.81494e-17
C25	B2#1	VNB	2.79207e-17
C26	VPWR	B1	4.37538e-18
C27	A2#1	VNB	3.05989e-17
C28	A1#1	VNB	3.30133e-17
C29	Y#5	VNB	2.7896e-17
C30	Y#1	VNB	2.82551e-18
C31	VPWR#6	VNB	4.65687e-17
C32	VPWR	A2	1.43138e-17
C33	a_114_74##2	VNB	1.1207e-17
C34	a_239_74##3	VNB	7.1306e-18
C35	a_114_74#	VNB	3.49882e-18
C36	a_239_74##4	VNB	2.63465e-18
C37	VGND#4	VNB	2.64603e-18
C38	a_239_74#	VNB	4.43785e-17
C39	VGND	C1#3	5.15785e-18
C40	B1#5	VNB	9.71085e-18
C41	B2#5	VNB	9.84628e-19
C42	a_239_74##2	A2#1	2.46914e-17
C43	B2#6	VNB	1.75025e-18
C44	Y#2	VNB	1.59974e-17
C45	VGND	A2#2	3.35036e-18
C46	B2#6	Y#1	4.42244e-17
C47	VGND	A1#2	1.24825e-18
C48	a_239_74##2	VNB	1.45887e-17
C49	VGND	VGND#3	5.69726e-17
C50	a_114_74##2	B1#5	4.83981e-18
C51	A2	A1	2.31678e-17
C52	B2#6	B1#2	1.5055e-18
C53	a_239_74##4	VGND#4	4.20209e-17
C54	VPWR	A1#2	1.34923e-18
C55	Y	C1#3	5.35727e-17
C56	VPWR	VPWR#3	2.09832e-17
C57	VGND	C1#4	2.53653e-18
C58	Y	B2#2	1.60942e-19
C59	VGND	B1#1	1.10089e-18
C60	Y	A2#2	1.12909e-19
C61	C1	C1#3	9.97328e-18
C62	VPWR	C1#1	7.56764e-19
C63	VGND	B2#1	1.71596e-18
C64	Y#2	Y#1	4.8535e-19
C65	VGND	A2#1	2.44942e-19
C66	VPWR	B1#4	1.73514e-19
C67	VGND	A1#1	8.71633e-19
C68	VPWR	B2#3	3.46962e-19
C69	VGND#3	Y	2.39113e-17
C70	VPWR	A2#3	3.09176e-18
C71	VPWR	A1#3	1.09924e-18
C72	a_239_74##3	B1#5	4.75444e-17
C73	a_239_74##4	a_239_74#	3.24723e-18
C74	VGND	a_114_74##2	2.18309e-17
C75	B1	C1#3	9.24516e-19
C76	VGND	a_239_74##3	7.46317e-18
C77	VGND	a_114_74#	2.05991e-17
C78	A2#2	A1	2.00463e-17
C79	VGND	a_239_74##4	1.66604e-17
C80	A2	a_522_368#	4.39607e-18
C81	A1	A1#2	2.29513e-17
C82	VPWR	Y#5	1.3444e-17
C83	VGND	a_239_74#	1.74511e-17
C84	C1	C1#1	1.97542e-18
C85	B1	B2#2	1.49134e-18
C86	VGND	B1#5	6.22889e-18
C87	B1#2	VNB	5.6723e-17
C88	Y	C1#4	3.86473e-17
C89	VPWR	Y#1	2.10657e-17
C90	Y	B1#1	3.77202e-18
C91	VGND	B2#5	3.30455e-18
C92	VPWR	VPWR#6	2.23896e-17
C93	Y	B2#1	1.89546e-19
C94	Y	A2#1	1.51506e-19
C95	a_239_74#	VGND#4	6.1932e-17
C96	A2	B2#2	8.94208e-19
C97	VGND	a_239_74##2	4.81145e-18
C98	A1	A2#3	4.56911e-19
C99	A2	A2#2	1.04474e-17
C100	B1	C1#1	1.58249e-18
C101	A1	A1#3	5.6073e-18
C102	B1	B1#4	2.07078e-18
C103	A2	A1#2	1.34077e-18
C104	Y	Y#3	3.85214e-18
C105	B1	B2#3	6.65664e-19
C106	Y	a_114_74##2	5.9805e-17
C107	Y	a_239_74##3	1.74469e-17
C108	VPWR	B2#6	2.89778e-18
C109	Y	a_114_74#	1.42869e-18
C110	A2	VPWR#3	2.73568e-18
C111	VPWR	Y#2	4.11768e-18
C112	Y#2	B1#2	8.28195e-18
C113	A2	C1#1	2.41679e-19
C114	Y	B1#5	1.39277e-17
C115	A2	B1#4	3.17747e-19
C116	A2	B2#3	2.1696e-18
C117	A2#2	a_522_368#	4.65238e-19
C118	A2	A2#3	3.1373e-17
C119	Y	Y#2	2.99192e-18
C120	a_114_74##2	B1#2	2.58045e-18
C121	A1	VPWR#6	1.65897e-17
C122	A2	A1#3	1.69434e-17
C123	B1	Y#1	1.76632e-17
C124	a_114_74##2	Y#2	2.72428e-18
C125	A1	VGND#4	3.12094e-18
C126	B1#4	a_324_368#	2.6874e-17
C127	A1	a_239_74#	4.3545e-17
C128	C1	Y#2	4.45e-17
C129	VGND#3	C1#3	9.00359e-19
C130	B2#3	a_324_368#	2.6874e-17
C131	B2#2	A2#2	2.69502e-17
C132	a_239_74##2	Y#1	4.34154e-18
C133	A2#3	a_522_368#	2.83479e-17
C134	VGND#3	B2#2	9.30094e-20
C135	A2#2	A1#2	2.99864e-17
C136	Y#1	A2	8.39828e-17
C137	C1#3	B1#2	2.45421e-17
C138	A1#3	a_522_368#	2.3229e-18
C139	VPWR#3	B2#2	4.42985e-20
C140	A2	VPWR#6	4.05228e-17
C141	a_239_74##3	B1#2	6.19466e-18
C142	B1	B2#6	1.16962e-17
C143	Y#2	B1	6.0082e-17
C144	Y#1	a_324_368#	8.09257e-18
C145	C1#3	B1#1	1.4724e-19
C146	B2#5	A2	3.54621e-18
C147	A2#2	A1#3	9.63572e-19
C148	B2#6	A2	1.82278e-17
C149	B1#5	B2#5	1.62259e-17
C150	C1#3	Y#5	2.8983e-19
C151	VPWR#3	B2#3	5.68243e-18
C152	a_114_74#	B1#2	4.42148e-19
C153	VPWR#3	A2#3	1.22817e-18
C154	C1#1	B1#4	7.55443e-18
C155	VGND#3	C1#4	5.47099e-18
C156	B1#4	B2#3	5.65306e-17
C157	VGND#3	B1#1	5.36658e-18
C158	C1#3	Y#3	3.55669e-18
C159	A2#1	A1#2	5.434e-19
C160	a_114_74##2	C1#3	4.84415e-19
C161	VGND#3	B2#1	4.68564e-18
C162	B2#2	Y#1	3.06881e-18
C163	B1#2	B2#2	2.52876e-17
C164	B2#3	A2#3	2.87346e-17
C165	Y#2	B1#5	1.14238e-17
C166	a_239_74##2	a_114_74#	1.17297e-17
C167	Y	B1#2	2.47706e-18
C168	A2#3	A1#3	2.87221e-17
C169	B1#5	C1#3	2.62029e-18
C170	a_114_74#	B2#2	4.86796e-19
C171	a_239_74##2	a_239_74##4	5.33767e-19
C172	A1#2	VPWR#6	3.08487e-17
C173	Y#1	VPWR#3	2.21113e-17
C174	Y#5	C1#1	3.34711e-17
C175	a_239_74##2	VGND#4	3.19015e-17
C176	C1#1	VPWR#7	5.08439e-17
C177	VGND#4	A2#2	7.75888e-19
C178	Y#5	B1#4	1.62292e-18
C179	Y#2	C1#3	1.95356e-17
C180	VGND#3	a_114_74##2	3.70207e-17
C181	B1#5	B2#2	2.24899e-18
C182	VPWR#7	B1#4	5.90148e-17
C183	Y#5	B2#3	1.40603e-19
C184	Y#1	C1#1	3.88173e-19
C185	VGND#4	A1#2	1.24825e-18
C186	VGND#3	a_114_74#	3.41644e-17
C187	C1#4	B1#1	4.46001e-18
C188	B2#5	B2#2	1.0356e-17
C189	VPWR#7	B2#3	4.61726e-18
C190	a_239_74#	A1#2	2.92645e-17
C191	VGND#3	a_239_74##4	1.23758e-17
C192	Y#1	B1#4	1.52384e-17
C193	B2#6	B2#2	6.61685e-18
C194	Y#1	B2#3	7.4574e-17
C195	B2#5	A2#2	1.96422e-17
C196	B1#1	B2#1	2.58182e-17
C197	VPWR#6	B1#4	2.77119e-19
C198	A2#3	Y#1	2.08305e-17
C199	B2#6	A2#2	1.08373e-18
C200	VPWR#6	B2#3	4.31057e-19
C201	B2#1	A2#1	2.92352e-17
C202	Y#1	A1#3	1.33459e-18
C203	VPWR#6	A2#3	7.50062e-18
C204	a_239_74##2	B2#2	3.40455e-18
C205	VPWR#6	A1#3	4.79595e-17
C206	A2#1	A1#1	9.05189e-18
C207	VGND#3	B1#2	2.55714e-19
C208	a_239_74##2	A2#2	3.85447e-17
C209	B1	B1#2	1.2136e-17
C210	C1#4	Y#3	7.72986e-18
C211	a_239_74##2	B2#5	4.19702e-17
C212	C1#4	a_114_74##2	1.81746e-17
C213	Y#5	VPWR#7	5.10928e-17
C214	a_239_74##3	C1#4	4.13925e-18
C215	VGND#3	a_239_74##2	6.76344e-19
C216	a_114_74##2	B1#1	2.84828e-18
C217	Y#2	C1#1	2.87894e-17
C218	a_114_74#	C1#4	1.54721e-18
C219	B1#5	B1#2	1.87834e-17
C220	Y#5	Y#1	5.8031e-19
C221	a_239_74##3	B1#1	5.12372e-17
C222	a_114_74##2	B2#1	4.93151e-19
C223	a_239_74##4	C1#4	2.68658e-20
C224	B2#6	B1#4	6.37434e-19
C225	a_114_74#	B1#1	4.45522e-17
C226	Y#1	VPWR#7	3.05576e-17
C227	Y#2	B1#4	1.01723e-17
C228	a_239_74##3	B2#1	1.27158e-18
C229	B1#2	VPWR#7	4.31495e-18
C230	a_239_74##4	B1#1	1.19141e-18
C231	B2#6	B2#3	2.01358e-18
C232	a_114_74#	B2#1	3.90747e-17
C233	a_239_74##3	A2#1	4.79456e-19
C234	VGND#4	B1#1	2.61678e-19
C235	Y#2	B2#3	2.87493e-19
C236	B2#1	a_239_74##4	1.40967e-17
C237	a_114_74#	A2#1	8.14248e-19
C238	B2#6	A2#3	1.06608e-18
C239	VGND#4	B2#1	3.41092e-19
C240	a_239_74##4	A2#1	4.18514e-17
C241	Y#2	A2#3	1.11813e-19
C242	A2#1	VGND#4	2.77937e-17
C243	Y#1	VPWR#6	3.68254e-18
C244	a_239_74##4	A1#1	1.5188e-18
C245	a_239_74#	A2#1	1.41375e-18
C246	A1#1	VGND#4	2.63391e-17
C247	C1#1	B1#2	2.11192e-19
C248	a_239_74#	A1#1	4.95207e-17
C249	a_239_74##3	Y#1	4.87864e-18
C250	B2#5	B1#2	2.36235e-18
C251	a_114_74##2	a_239_74##3	1.05417e-17
C252	a_114_74##2	a_114_74#	4.52643e-18
C253	a_114_74#	a_239_74##3	2.72921e-17
C254	Y#2	Y#5	3.95564e-18
C255	a_239_74##3	a_239_74##4	4.55041e-18
C256	Y#2	VPWR#7	7.19524e-17
C257	a_114_74#	a_239_74##4	4.07525e-17
C258	a_239_74##2	B2#1	1.93671e-17
C259	VPWR#4	VPWR#7	2.20255e-18
C260	VPWR#3	VPWR#2	5.39334e-17
C261	VGND#3	VGND#2	6.49856e-17
C262	VPWR	VPWR#4	9.9587e-17
C263	VPWR#4	B1#4	1.20569e-17
C264	VGND#2	A1#2	1.64469e-19
C265	Y#5	VPWR#4	2.98336e-17
C266	VPWR#4	VPWR#6	4.83384e-19
C267	VPWR#4	C1#1	1.19787e-17
C268	A1	VPWR#2	1.70376e-18
C269	VGND#2	A1#1	7.73332e-18
C270	Y#2	VPWR#4	1.69475e-19
C271	VGND#2	A2#1	6.73664e-18
C272	VPWR#2	A1#2	5.985e-19
C273	VGND	VGND#2	7.2441e-17
C274	VGND#2	a_239_74##2	2.44313e-19
C275	VPWR#4	A1#3	4.39192e-19
C276	VGND#2	a_239_74#	2.10217e-17
C277	VPWR#4	VPWR#2	2.1853e-19
C278	VGND#2	B2#1	8.88104e-19
C279	VPWR#2	VNB	5.0978e-17
C280	A2	VPWR#2	6.64765e-18
C281	Y#1	VPWR#4	6.28958e-18
C282	VPWR#4	VNB	6.79092e-17
C283	VPWR#3	VPWR#4	7.3037e-17
C284	VPWR#2	A2#2	5.47507e-20
C285	C1	VPWR#4	1.56418e-18
C286	VGND#2	B1#1	5.51619e-19
C287	VPWR#4	A2#3	4.60414e-19
C288	VPWR#2	A1#3	4.17759e-18
C289	VGND#2	VNB	6.01304e-17
C290	VGND#2	a_239_74##4	8.44746e-18
C291	VPWR#4	C1#3	9.64469e-19
C292	VPWR#4	B2#3	2.91413e-18
C293	VPWR	VPWR#2	3.96345e-17
C294	VPWR#2	A2#3	2.02648e-18
*
*
.ENDS sky130_fd_sc_hs__o221ai_1
*
