* Extracted by Quantus, converted by sky130cad/quantus.py
*
*
*
*                       LINUX           Wed Nov 18 08:13:55 2026
*
*
*
*  PROGRAM  advgen
*
*  Name           : advgen - Quantus - (64-bit)
*  Version        : 25.1.0-p047
*  Build Date     : Thu Dec 11 23:20:30 PST 2025
*
*  HSPICE LIBRARY
*
*  OPERATING_TEMPERATURE 150
*  QRC_TECH_DIR <path>/tech
*
*
*

*
.SUBCKT sky130_fd_sc_hs__a32o_2 VPB VNB VGND VPWR X B2 A3 A2 A1 B1
*
*
*  caps2d version: 10
*
*
*       TRANSISTOR CARDS
*
*
XM9 VGND#4 a_45_264##5 X#3 VNB sky130_fd_pr__nfet_01v8_lvt l=0.15 w=0.74 ad=0.259 as=0.2146 pd=2.18 ps=2.06
XM10 X#3 a_45_264# VGND#5 VNB sky130_fd_pr__nfet_01v8_lvt l=0.15 w=0.74 ad=0.2146 as=0.407 pd=2.06 ps=2.58
XM13 VGND#5 A3#1 a_355_74# VNB sky130_fd_pr__nfet_01v8_lvt l=0.15 w=0.74 ad=0.407 as=0.1776 pd=2.58 ps=1.96
XM12 a_355_74# A2#3 a_433_74# VNB sky130_fd_pr__nfet_01v8_lvt l=0.15 w=0.74 ad=0.1776 as=0.3108 pd=1.96 ps=2.32
XM4 a_433_74# A1#3 a_45_264##10 VNB sky130_fd_pr__nfet_01v8_lvt l=0.15 w=0.74 ad=0.3108 as=0.3108 pd=2.32 ps=2.32
XM11 a_45_264##10 B1#3 a_661_74# VNB sky130_fd_pr__nfet_01v8_lvt l=0.15 w=0.74 ad=0.3108 as=0.3108 pd=2.32 ps=2.32
XM3 a_661_74# B2#3 VGND#1 VNB sky130_fd_pr__nfet_01v8_lvt l=0.15 w=0.74 ad=0.3108 as=0.2109 pd=2.32 ps=2.05
XM0 VPWR#5 a_45_264##6 X#1 VPB sky130_fd_pr__pfet_01v8 l=0.15 w=1.12 ad=0.3304 as=0.336 pd=2.83 ps=2.84
XM7 X#1 a_45_264##4 VPWR#7 VPB sky130_fd_pr__pfet_01v8 l=0.15 w=1.12 ad=0.336 as=0.6052 pd=2.84 ps=3.34
XM1 VPWR#7 A3#3 a_346_368##5 VPB sky130_fd_pr__pfet_01v8 l=0.15 w=1 ad=0.6052 as=0.3 pd=3.34 ps=2.6
XM6 a_346_368##5 A2#1 VPWR#6 VPB sky130_fd_pr__pfet_01v8 l=0.15 w=1 ad=0.3 as=0.56 pd=2.6 ps=3.12
XM2 VPWR#6 A1#1 a_346_368##3 VPB sky130_fd_pr__pfet_01v8 l=0.15 w=1 ad=0.56 as=0.3 pd=3.12 ps=2.6
XM8 a_346_368##3 B1#1 a_45_264##7 VPB sky130_fd_pr__pfet_01v8 l=0.15 w=1 ad=0.3 as=0.4 pd=2.6 ps=2.8
XM5 a_45_264##7 B2#4 a_346_368# VPB sky130_fd_pr__pfet_01v8 l=0.15 w=1 ad=0.4 as=0.295 pd=2.8 ps=2.59
*
*
*       RESISTOR AND CAP/DIODE CARDS
*
Rg1	a_45_264#	a_45_264##2	380.374634
Rg2	a_45_264##2	a_45_264##3	102.502281
Rg3	a_45_264##2	a_45_264##4	462.815369
Rg4	a_45_264##3	a_45_264##5	364.234680
Rg5	a_45_264##3	a_45_264##6	439.535522
Rg6	A3#1	A3#2	382.539734
Rg7	A3#2	A3#3	400.207520
Rg8	A2#1	A2#2	400.207520
Rg9	A2#2	A2#3	382.539734
Rg10	A1#1	A1#2	400.207520
Rg11	A1#2	A1#3	382.539734
Rg12	B1#1	B1#2	400.207520
Rg13	B1#2	B1#3	382.539734
Rg14	B2#1	B2#2	28.644930
Rg15	B2#2	B2#3	368.862610
Rg16	B2#2	B2#4	437.431122
Rf1	X	X#2	1.764915
Rf2	X#2	X#3	73.789856
Rf3	X#1	X#2	15.000000
Rf4	A3#2	A3#5	161.302414
Rf5	A3#6	A3	1.069610
Rf6	A3#5	A3#6	5.905091
Rf7	A2	A2#2	166.137894
Rf8	A1#4	A1#2	161.913620
Rf9	A1	A1#6	1.680815
Rf10	A1#4	A1#6	5.034561
Rf11	a_45_264##7	a_45_264##8	178.968430
Rf12	a_45_264##8	a_45_264##3	303.765564
Rf13	a_45_264##8	a_45_264##10	206.774231
Rf14	B1#2	B1#5	162.008423
Rf15	B1#6	B1	1.775621
Rf16	B1#5	B1#6	8.556877
Rf17	a_346_368##2	a_346_368##4	88.658882
Rf18	a_346_368##4	a_346_368##5	92.100052
Rf19	a_346_368##2	a_346_368#	39.801380
Rf20	a_346_368#	a_346_368##2	15.000000
Rf21	a_346_368##3	a_346_368##4	7.500000
Rf22	B2	B2#1	168.106262
Rf23	VGND#1	VGND#2	165.158493
Rf24	VGND#2	VGND#3	59.146370
Rf25	VGND#3	VGND#4	109.345985
Rf26	VGND#3	VGND#5	38.247387
Rf28	VPWR#2	VPWR#3	21.500971
Rf29	VPWR#3	VPWR#4	62.399734
Rf30	VPWR#4	VPWR#5	106.045029
Rf31	VPWR#2	VPWR#6	33.254837
Rf32	VPWR#4	VPWR#7	28.453159
Re1	VPWR#3	VPWR	1.091357
Re2	VGND	VGND#2	1.091398
*
*       CAPACITOR CARDS
*
*
C1	a_346_368##3	VPWR#6	4.84789e-17
C2	VGND#1	A2#3	2.68191e-19
C3	VGND	VNB	6.3017e-17
C4	VPWR	VNB	6.89216e-17
C5	B1#5	B1#1	2.04207e-18
C6	X	VNB	7.18952e-19
C7	B2	VNB	1.36172e-17
C8	A3	VNB	1.98015e-18
C9	VGND	X	1.84628e-18
C10	A2	VNB	1.7541e-18
C11	A1#4	B1#5	1.6031e-17
C12	B1	VNB	6.08311e-18
C13	VPWR	X	4.08654e-18
C14	VPWR	B2	3.77091e-18
C15	VPWR	A3	2.51368e-18
C16	VGND	B1	5.50418e-18
C17	VPWR	A2	2.51368e-18
C18	a_45_264##3	VNB	9.25988e-17
C19	A3#2	VNB	3.41447e-17
C20	B1#3	a_45_264##10	2.83818e-17
C21	A2#2	VNB	3.11069e-17
C22	A1#2	VNB	3.3775e-17
C23	VPWR	B1	2.45937e-18
C24	B1#2	VNB	3.30328e-17
C25	B2#1	VNB	9.3392e-18
C26	VGND#2	VNB	2.32276e-16
C27	a_45_264##7	VPWR#6	5.43179e-18
C28	VPWR#3	VNB	2.00296e-16
C29	VGND	a_45_264##3	3.22679e-18
C30	a_45_264##6	VNB	3.7352e-17
C31	a_45_264##4	VNB	3.63166e-17
C32	A3#3	VNB	3.5157e-17
C33	A3	A2	1.1604e-17
C34	VGND	A2#2	2.49498e-18
C35	A2#1	VNB	3.61978e-17
C36	VPWR#4	A3#3	6.18075e-18
C37	VGND#1	A1#3	2.15691e-18
C38	A1#1	VNB	3.09336e-17
C39	B1	B2	2.22332e-17
C40	B1#1	VNB	3.12871e-17
C41	VGND	B1#2	1.75107e-18
C42	B2#4	VNB	3.87755e-17
C43	VGND	B2#1	2.23375e-18
C44	a_45_264##5	VNB	3.3348e-17
C45	VPWR	a_45_264##3	3.41364e-18
C46	VGND	VGND#2	3.73026e-17
C47	a_45_264#	VNB	3.11622e-17
C48	A3#1	VNB	3.19097e-17
C49	A2#3	VNB	2.59689e-17
C50	A1#3	VNB	2.8479e-17
C51	B1#3	VNB	2.93881e-17
C52	B2#3	VNB	2.34557e-17
C53	VPWR#5	VNB	4.82972e-17
C54	X	a_45_264##3	7.05717e-17
C55	VPWR#7	VNB	6.72513e-18
C56	a_346_368##5	VNB	2.52315e-18
C57	VPWR#6	VNB	5.75475e-18
C58	X	A3#2	4.80685e-19
C59	a_45_264##10	B2#3	8.78416e-18
C60	a_346_368##3	VNB	7.26619e-18
C61	a_45_264##7	a_346_368##3	1.19466e-16
C62	VPWR	VPWR#3	1.09634e-17
C63	a_346_368#	VNB	5.89079e-17
C64	VGND#4	VNB	7.35309e-17
C65	X#3	VNB	6.88443e-18
C66	VGND	a_45_264##5	1.37351e-18
C67	VGND#5	VNB	2.11739e-18
C68	VPWR	a_45_264##6	3.66593e-19
C69	VGND	a_45_264#	5.41357e-18
C70	VPWR	a_45_264##4	7.13646e-19
C71	VGND	A3#1	1.3609e-18
C72	a_45_264##10	VNB	2.1362e-17
C73	VGND	A2#3	1.24972e-18
C74	VGND#1	VNB	8.55546e-17
C75	VPWR	A3#3	7.25174e-18
C76	VGND	A1#3	1.53878e-18
C77	VGND#1	B1#3	1.44423e-17
C78	A3#5	VNB	1.96633e-18
C79	VPWR	A2#1	9.23126e-18
C80	VGND	B1#3	1.15414e-18
C81	VGND	B2#3	4.2017e-18
C82	VPWR	A1#1	3.84991e-18
C83	A1#4	VNB	2.05833e-18
C84	A3	A3#2	5.84047e-18
C85	B2	B1#2	4.6127e-19
C86	A1#6	VNB	2.80043e-18
C87	X	a_45_264##6	9.87864e-18
C88	a_45_264##8	VNB	1.08228e-17
C89	A3	A2#2	9.05335e-19
C90	B1#5	VNB	2.87824e-18
C91	X	a_45_264##4	1.05119e-17
C92	a_346_368##3	a_346_368#	2.64007e-18
C93	X	A3#3	2.58143e-19
C94	A2	A3#2	1.86513e-18
C95	VGND#3	VNB	3.73339e-17
C96	VGND	VGND#4	4.19087e-17
C97	VGND	X#3	1.68229e-17
C98	A1#6	B1#5	1.22125e-17
C99	VPWR#4	VNB	3.6409e-17
C100	A2	A2#2	7.42074e-18
C101	A2	A1#2	1.4493e-18
C102	VGND	a_45_264##10	2.83948e-17
C103	VPWR	VPWR#5	3.65222e-17
C104	VGND	VGND#1	5.58133e-17
C105	VGND#1	B2#3	4.43908e-17
C106	VPWR	VPWR#7	2.44323e-17
C107	VGND	A3#5	2.4906e-18
C108	VPWR	a_346_368##5	1.6712e-17
C109	VPWR	a_346_368##3	2.38354e-17
C110	VGND	A1#4	2.96021e-18
C111	a_45_264##7	a_346_368#	9.33979e-17
C112	VPWR	a_45_264##7	1.26502e-17
C113	A3	a_45_264##4	1.77709e-19
C114	B2	B2#4	2.52048e-18
C115	VPWR	a_346_368#	2.569e-17
C116	VGND	a_45_264##8	5.6196e-18
C117	A3	A3#3	2.05234e-18
C118	VGND	B1#5	5.41512e-18
C119	A3	A2#1	6.33585e-19
C120	a_45_264##8	a_45_264#	4.12775e-18
C121	X	X#1	1.54882e-19
C122	B1	B1#2	6.31586e-18
C123	VGND	VGND#3	5.03531e-17
C124	B1	B2#1	2.24945e-17
C125	A2	A3#3	5.43831e-19
C126	A2	A2#1	2.0298e-18
C127	A2	A1#1	1.81103e-19
C128	X#3	X	3.4878e-18
C129	VPWR	A1#6	2.84291e-18
C130	VPWR	a_45_264##8	1.76454e-17
C131	VPWR	B1#5	1.91008e-18
C132	a_45_264##8	A3#1	1.67127e-17
C133	B2	a_346_368#	2.91964e-17
C134	VPWR	VPWR#4	2.94513e-17
C135	a_45_264##2	VNB	2.41391e-17
C136	B2#2	VNB	5.93382e-17
C137	B1	B2#4	2.22363e-18
C138	X	a_45_264##8	1.03833e-16
C139	A3#2	A2#2	3.33449e-17
C140	A2#2	A1#2	2.69561e-17
C141	VGND#4	X#3	7.37087e-17
C142	a_45_264##2	X#1	1.73121e-19
C143	VGND#3	a_45_264##5	8.21028e-19
C144	A1#2	B1#2	2.56661e-17
C145	VGND#4	VGND#5	7.37102e-19
C146	A3#1	a_355_74#	1.68123e-17
C147	VGND#2	A2#2	2.39162e-19
C148	a_45_264##3	a_45_264##6	1.46492e-17
C149	A2#3	a_355_74#	1.68123e-17
C150	a_45_264##8	A3	5.39147e-17
C151	a_45_264##3	a_45_264##4	8.94315e-19
C152	VGND#2	A1#2	8.63921e-20
C153	B2#1	B1#2	4.95216e-19
C154	A3#5	A2	2.62395e-18
C155	a_45_264##10	a_45_264##7	1.09413e-17
C156	B1	a_45_264##7	2.4005e-17
C157	VGND	B2#2	8.27031e-19
C158	a_45_264##3	A3#3	1.51481e-19
C159	B1	a_346_368#	1.57084e-18
C160	A2#3	a_433_74#	2.22793e-17
C161	X#3	VGND#5	3.21424e-17
C162	a_45_264##4	A3#2	2.61093e-19
C163	VGND#3	a_45_264#	7.80026e-18
C164	A1#3	a_433_74#	2.22793e-17
C165	A2	A1#4	3.37135e-18
C166	A2	A1#6	1.57384e-17
C167	A2	a_45_264##8	3.43947e-17
C168	B1#3	a_661_74#	2.32378e-17
C169	VGND#3	A3#1	1.16831e-17
C170	B2#3	a_661_74#	2.35472e-17
C171	VGND#1	B1	1.83515e-18
C172	VGND#1	B2#2	1.00746e-17
C173	a_45_264##8	VPWR#5	7.2803e-19
C174	a_45_264##3	a_45_264##2	3.56607e-18
C175	VGND#3	a_45_264##8	1.49725e-18
C176	VGND#1	a_346_368#	2.65438e-19
C177	VGND#3	A2#3	7.78188e-19
C178	a_45_264##10	a_355_74#	3.18215e-18
C179	a_45_264##8	X#1	3.79823e-18
C180	B1#2	B2#4	7.5942e-19
C181	VGND#5	a_45_264##10	8.20108e-18
C182	VPWR#3	A2#1	4.53642e-18
C183	a_45_264##3	VPWR#5	4.50001e-17
C184	a_45_264##10	a_433_74#	5.71822e-18
C185	a_45_264##6	a_45_264##4	5.04191e-17
C186	VGND#3	A1#3	4.33519e-19
C187	a_45_264##3	X#1	1.16974e-20
C188	a_45_264##8	VPWR#7	4.87276e-17
C189	a_45_264##4	A3#3	1.85065e-17
C190	a_45_264##2	A3#2	1.66775e-17
C191	A3#2	VPWR#7	1.57522e-18
C192	VGND#3	B1#3	1.75749e-19
C193	X	a_45_264##2	1.3433e-17
C194	a_45_264##8	a_346_368##5	6.82638e-17
C195	a_45_264##8	VPWR#4	4.91722e-18
C196	A3#3	A2#1	4.13332e-17
C197	A3#5	a_45_264##2	9.92328e-19
C198	a_45_264##3	VGND#4	4.01793e-17
C199	a_346_368##5	A2#2	5.30567e-19
C200	X#3	a_45_264##3	1.26183e-17
C201	VGND#2	A2#3	8.4394e-18
C202	A2#2	VPWR#6	1.3093e-18
C203	a_45_264##8	VPWR#6	4.52875e-19
C204	A2#1	A1#1	1.56007e-17
C205	VGND#2	A1#3	5.60191e-18
C206	VGND#2	B1#3	2.88021e-18
C207	A1#2	VPWR#6	1.10377e-18
C208	X#3	A3#2	3.31667e-19
C209	VGND#5	A3#2	1.10769e-18
C210	a_346_368##3	A1#2	4.43087e-19
C211	a_45_264##8	a_346_368##3	2.20412e-20
C212	A1#1	B1#1	4.24578e-17
C213	A1#6	a_45_264##7	4.7562e-17
C214	a_45_264##7	A1#2	1.62404e-18
C215	B2	B2#2	1.0857e-17
C216	a_45_264##10	VGND#1	2.14892e-17
C217	a_346_368##3	B1#2	6.20957e-20
C218	VPWR#3	VPWR#5	2.86353e-17
C219	B1#2	a_45_264##7	2.64389e-18
C220	B1#1	B2#4	2.82303e-17
C221	a_346_368#	B1#2	1.1674e-19
C222	a_45_264##10	A2#2	4.40429e-17
C223	A3#5	A3#2	1.10923e-17
C224	VPWR#5	VPWR#4	6.07128e-19
C225	a_346_368##5	VPWR#3	9.38914e-18
C226	a_45_264##10	A3#5	1.3443e-17
C227	VPWR#5	a_45_264##6	3.29776e-17
C228	a_45_264##10	A1#2	3.62122e-18
C229	B1#5	a_45_264##7	3.17224e-17
C230	a_45_264##6	X#1	2.68567e-17
C231	A3	a_45_264##2	2.27631e-19
C232	A3#5	A2#2	1.54128e-17
C233	a_45_264##3	a_45_264##8	3.74622e-18
C234	VPWR#5	a_45_264##4	5.62198e-18
C235	VGND#3	a_45_264##2	5.81762e-20
C236	VPWR#7	a_45_264##6	4.50967e-18
C237	VGND#2	VGND#4	3.1241e-17
C238	a_45_264##4	X#1	2.61416e-17
C239	a_346_368##5	a_45_264##6	8.30971e-19
C240	VPWR#5	A3#3	9.20152e-19
C241	a_45_264##4	VPWR#7	3.57352e-17
C242	a_45_264##8	A3#2	1.09346e-17
C243	VGND#1	B1#2	2.60638e-19
C244	A2#2	A1#4	1.87039e-17
C245	X#3	a_45_264##8	3.84185e-17
C246	a_346_368##5	a_45_264##4	3.06173e-18
C247	a_45_264##5	a_45_264#	3.67664e-17
C248	A3#3	VPWR#7	2.1029e-17
C249	VPWR#6	a_45_264##4	3.98178e-19
C250	A1#6	A2#2	1.76987e-18
C251	a_346_368##5	A3#3	3.94294e-17
C252	B2#1	VGND#1	3.24732e-17
C253	a_45_264##8	A2#2	2.34412e-18
C254	A1#4	A1#2	1.0272e-17
C255	VGND#3	a_45_264##3	1.53478e-20
C256	VGND#2	a_45_264##10	2.78475e-17
C257	a_346_368##3	a_45_264##4	3.58932e-19
C258	a_45_264##8	VGND#5	4.21394e-17
C259	VPWR#7	A2#1	7.93072e-19
C260	B1#2	B2#2	2.88728e-17
C261	a_45_264#	A3#1	1.50803e-17
C262	VPWR#6	A3#3	7.44676e-19
C263	a_346_368##5	VPWR#4	2.61572e-18
C264	a_346_368##5	A2#1	5.38094e-17
C265	a_45_264##10	A1#4	4.74026e-17
C266	A1#6	A1#2	6.04819e-18
C267	VGND#2	VGND#1	4.96643e-17
C268	VPWR#7	A1#1	3.34729e-19
C269	VPWR#4	a_45_264##3	2.6816e-20
C270	a_45_264##8	A1#2	9.82004e-20
C271	A1#4	B1#2	2.81771e-18
C272	A2#1	VPWR#6	3.56964e-17
C273	a_45_264##7	A3#3	2.11282e-19
C274	a_346_368##5	A1#1	8.58261e-19
C275	A3#1	A2#3	5.3433e-17
C276	a_346_368##3	A2#1	7.13731e-19
C277	B1#5	A1#2	3.89991e-18
C278	A1#6	B1#2	1.56445e-18
C279	A1#1	VPWR#6	3.296e-17
C280	a_45_264##7	A2#1	4.18378e-19
C281	a_45_264##8	B1#2	7.19015e-20
C282	B2#2	a_346_368#	5.39471e-18
C283	a_346_368##3	A1#1	5.28197e-17
C284	A2#3	A1#3	2.59679e-17
C285	B1#5	B1#2	1.62505e-17
C286	B2#1	B2#2	1.41423e-17
C287	a_45_264##7	A1#1	1.47454e-17
C288	a_346_368##3	B1#1	4.8549e-17
C289	a_45_264##10	a_45_264##8	5.86627e-18
C290	a_45_264##7	B1#1	4.27553e-17
C291	a_346_368##3	B2#4	8.39115e-19
C292	A1#3	B1#3	2.34869e-17
C293	a_346_368#	B1#1	1.36235e-18
C294	B2#4	a_45_264##7	2.92426e-17
C295	VGND#4	VGND#3	1.17457e-18
C296	a_45_264##2	A3#1	2.37135e-19
C297	a_346_368#	B2#4	4.93588e-17
C298	VGND#2	B1#5	4.4452e-19
C299	B1#3	B2#3	2.73863e-17
C300	B1	B2#2	8.68289e-18
C301	VGND#3	X#3	1.3994e-17
C302	VPWR#4	a_45_264##2	2.76101e-20
C303	X#3	a_45_264##2	5.5754e-18
C304	VGND#4	a_45_264##5	2.85268e-17
C305	VGND#2	VGND#3	4.48577e-17
C306	VGND#1	B1#5	1.26798e-18
C307	a_45_264##8	a_45_264##6	7.01892e-18
C308	X#3	a_45_264##5	4.25154e-17
C309	a_45_264##8	A3#5	4.38016e-17
C310	VGND#4	a_45_264#	1.2237e-18
C311	VGND#5	a_45_264##5	2.49316e-19
C312	X#3	a_45_264#	4.1567e-17
C313	a_45_264##8	a_45_264##4	2.31117e-17
C314	VPWR#5	VPWR#7	1.05244e-17
C315	VGND#4	A3#1	2.08144e-19
C316	a_45_264#	VGND#5	2.46472e-17
C317	X#3	A3#1	1.72762e-18
C318	a_45_264##8	A3#3	2.5542e-17
C319	VPWR#3	VPWR#4	4.74683e-17
C320	A3#1	VGND#5	2.58213e-17
C321	X#3	A2#3	3.68594e-19
C322	A1#6	A2#1	4.24131e-19
C323	VGND#3	a_45_264##10	5.47043e-19
C324	a_45_264##8	A2#1	1.47643e-17
C325	VGND#5	A2#3	2.48721e-18
C326	a_45_264##10	a_45_264#	9.84356e-19
C327	VPWR#7	a_346_368##5	1.76727e-17
C328	X#3	A1#3	2.4401e-19
C329	A1#6	A1#1	2.02967e-18
C330	a_45_264##8	a_45_264##2	7.924e-18
C331	VPWR#7	VPWR#6	3.76125e-18
C332	VGND#5	A1#3	1.53812e-18
C333	a_45_264##10	A3#1	1.34711e-17
C334	a_45_264##8	A1#1	4.40851e-19
C335	a_346_368##5	VPWR#6	4.09615e-17
C336	A1#6	B1#1	5.63238e-19
C337	VGND#5	B1#3	8.21306e-19
C338	a_45_264##10	A2#3	2.9942e-17
C339	VGND#4	VPWR#5	1.89666e-18
C340	B1#5	A1#1	6.2109e-19
C341	a_45_264##8	B1#1	2.53378e-19
C342	VGND#1	A3#1	2.50987e-19
C343	a_346_368##5	a_346_368##3	2.12957e-18
C344	B1#3	B2#2	8.63616e-19
C345	a_45_264##10	A1#3	4.66837e-17
C346	VPWR#4	a_45_264##4	8.40584e-18
C347	a_45_264##7	a_346_368##5	9.16566e-18
C348	VPWR#2	B1#1	3.19935e-18
C349	VPWR#3	VPWR#2	8.69692e-17
C350	VPWR#4	VPWR#2	4.98765e-19
C351	VPWR#7	VPWR#2	8.93232e-19
C352	VPWR	VPWR#2	6.71006e-17
C353	VPWR#2	A1#1	4.09052e-18
C354	a_346_368#	VPWR#2	6.15045e-17
C355	VPWR#2	B2#2	3.49177e-19
C356	VPWR#2	VNB	7.51758e-17
C357	VPWR#2	B1#2	2.16518e-20
C358	VPWR#2	a_45_264##4	3.9645e-19
C359	a_346_368##3	VPWR#2	5.22746e-17
C360	B2	VPWR#2	4.94776e-19
C361	VPWR#2	B2#4	3.20163e-18
*
*
.ENDS sky130_fd_sc_hs__a32o_2
*
