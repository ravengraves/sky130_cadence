* Extracted by Quantus, converted by sky130cad/quantus.py
*
*
*
*                       LINUX           Wed Nov 18 08:08:36 2026
*
*
*
*  PROGRAM  advgen
*
*  Name           : advgen - Quantus - (64-bit)
*  Version        : 25.1.0-p047
*  Build Date     : Thu Dec 11 23:20:30 PST 2025
*
*  HSPICE LIBRARY
*
*  OPERATING_TEMPERATURE 150
*  QRC_TECH_DIR <path>/tech
*
*
*

*
.SUBCKT sky130_fd_sc_hs__a22o_1 VPB VNB VGND VPWR X A2 A1 B2 B1
*
*
*  caps2d version: 10
*
*
*       TRANSISTOR CARDS
*
*
XM2 a_52_123##2 A2#2 VGND#7 VNB sky130_fd_pr__nfet_01v8_lvt l=0.15 w=0.64 ad=0.1696 as=0.2465 pd=1.81 ps=2.37
XM7 VGND#7 B2#1 a_230_79# VNB sky130_fd_pr__nfet_01v8_lvt l=0.15 w=0.64 ad=0.2465 as=0.1344 pd=2.37 ps=1.7
XM9 a_230_79# B1#3 a_222_392##4 VNB sky130_fd_pr__nfet_01v8_lvt l=0.15 w=0.64 ad=0.1344 as=0.1792 pd=1.7 ps=1.84
XM8 a_222_392##4 A1#3 a_52_123# VNB sky130_fd_pr__nfet_01v8_lvt l=0.15 w=0.64 ad=0.1792 as=0.1824 pd=1.84 ps=1.85
XM4 VGND#6 a_222_392# X#3 VNB sky130_fd_pr__nfet_01v8_lvt l=0.15 w=0.74 ad=0.1961 as=0.1961 pd=2.01 ps=2.01
XM0 VPWR#4 A2#1 a_132_392##2 VPB sky130_fd_pr__pfet_01v8 l=0.15 w=1 ad=0.275 as=0.3 pd=2.55 ps=2.6
XM1 a_132_392##2 B2#3 a_222_392##6 VPB sky130_fd_pr__pfet_01v8 l=0.15 w=1 ad=0.3 as=0.33 pd=2.6 ps=2.66
XM5 a_222_392##6 B1#1 a_132_392# VPB sky130_fd_pr__pfet_01v8 l=0.15 w=1 ad=0.33 as=0.39 pd=2.66 ps=2.78
XM6 a_132_392# A1#1 VPWR#5 VPB sky130_fd_pr__pfet_01v8 l=0.15 w=1 ad=0.39 as=0.613 pd=2.78 ps=3.4
XM3 VPWR#5 a_222_392##3 X#1 VPB sky130_fd_pr__pfet_01v8 l=0.15 w=1.12 ad=0.613 as=0.308 pd=3.4 ps=2.79
*
*
*       RESISTOR AND CAP/DIODE CARDS
*
Rg1	A2#1	A2#2	803.013733
Rg2	A2#2	A2#3	305.973755
Rg3	B2#1	B2#2	478.168365
Rg4	B2#2	B2#3	408.386017
Rg5	B1#1	B1#2	400.207520
Rg6	B1#2	B1#3	443.036499
Rg7	A1#1	A1#2	453.277618
Rg8	A1#2	A1#3	389.656677
Rg9	a_222_392#	a_222_392##2	429.234741
Rg10	a_222_392##2	a_222_392##3	448.418579
Rf1	A2#3	A2	169.588104
Rf2	B2#2	B2	173.223999
Rf3	B1#2	B1	163.775864
Rf4	a_132_392#	a_132_392##2	111.303413
Rf5	a_52_123#	a_52_123##2	169.059341
Rf6	A1#2	A1	166.137894
Rf7	a_222_392##4	a_222_392##5	101.456741
Rf8	a_222_392##5	a_222_392##6	137.295975
Rf9	X	X#2	0.196836
Rf10	X#2	X	14.369054
Rf11	X	X#4	7.282945
Rf12	X#4	X	7.282945
Rf13	X#1	X#2	5.000000
Rf14	X#3	X#4	7.500000
Rf16	VGND#2	VGND#3	68.700279
Rf17	VGND#3	VGND#4	61.606976
Rf19	VGND#2	VGND#6	45.213318
Rf20	VGND#4	VGND#7	55.640255
Rf22	VPWR#2	VPWR#3	55.837856
Rf23	VPWR#3	VPWR#4	144.586899
Rf24	VPWR#2	VPWR#5	26.807276
Rf29	a_222_392##2	a_222_392##5	160.232803
Re1	VPWR#3	VPWR	1.403190
Re2	VGND	VGND#3	1.403242
*
*       CAPACITOR CARDS
*
*
C1	a_52_123#	VGND#6	1.96873e-17
C2	a_222_392##4	VGND#6	2.26653e-18
C3	a_52_123#	a_222_392##4	4.87882e-17
C4	VGND#7	a_52_123#	3.63022e-17
C5	a_52_123##2	a_222_392##4	2.9868e-17
C6	a_52_123##2	VGND#7	5.05517e-17
C7	a_52_123#	a_222_392##6	8.42252e-19
C8	a_222_392##4	a_222_392##6	3.52499e-18
C9	a_222_392#	X#3	7.22397e-18
C10	a_222_392#	VGND#6	2.09742e-17
C11	a_52_123#	a_222_392#	8.57329e-19
C12	VGND#6	A1#3	3.19181e-18
C13	a_52_123##2	a_222_392##6	5.5669e-18
C14	a_222_392##4	a_222_392#	1.53351e-18
C15	a_52_123#	A1#3	4.2189e-17
C16	a_132_392#	VPWR#5	4.65532e-17
C17	VGND#6	B1#3	2.53414e-19
C18	a_222_392##4	A1#3	3.16915e-17
C19	a_52_123#	B1#3	2.32117e-17
C20	VGND#6	B2#1	4.07594e-20
C21	a_222_392##4	B1#3	2.95602e-17
C22	a_132_392#	a_222_392##6	9.952e-17
C23	a_52_123#	B2#1	1.16168e-17
C24	a_132_392##2	a_132_392#	2.41514e-18
C25	a_222_392##4	B2#1	2.55752e-18
C26	a_52_123##2	A1#3	5.01559e-19
C27	a_52_123#	A2#2	4.88137e-19
C28	a_132_392##2	a_222_392##6	7.16918e-17
C29	a_52_123##2	B1#3	4.45089e-18
C30	B2#1	VGND#7	1.40874e-17
C31	a_52_123##2	B2#1	1.64422e-17
C32	A2#2	VGND#7	1.89694e-17
C33	VPWR#4	a_132_392##2	9.75221e-17
C34	a_132_392#	A1#3	6.97804e-19
C35	a_52_123##2	A2#2	3.54158e-17
C36	a_222_392##6	A1#3	2.07979e-18
C37	A1#3	a_222_392#	4.74734e-18
C38	VPWR#5	a_222_392##3	4.91235e-17
C39	a_132_392#	a_222_392##3	5.91328e-19
C40	B1#3	A1#3	4.55002e-17
C41	A1#1	VPWR#5	2.16078e-17
C42	a_222_392##6	a_222_392##3	1.82011e-19
C43	a_132_392#	A1#1	5.60095e-17
C44	a_222_392##6	A1#1	2.43153e-17
C45	B2#1	B1#3	5.9421e-17
C46	a_132_392#	B1#1	5.245e-17
C47	a_132_392##2	A1#1	1.75057e-19
C48	a_222_392##6	B1#1	3.61267e-17
C49	a_132_392#	B2#3	1.19986e-18
C50	VGND#3	a_52_123#	3.34601e-17
C51	VPWR#4	A1#1	7.49867e-20
C52	a_132_392##2	B1#1	3.90967e-19
C53	A2#2	B2#1	2.27837e-17
C54	a_222_392##6	B2#3	4.5628e-17
C55	a_222_392##2	VGND#6	2.62479e-17
C56	a_132_392#	A2#1	2.13375e-19
C57	VPWR#4	B1#1	1.85531e-19
C58	a_132_392##2	B2#3	3.35991e-17
C59	a_222_392##6	A2#1	1.83309e-18
C60	VPWR#4	B2#3	4.4454e-19
C61	a_132_392##2	A2#1	4.9797e-17
C62	A1#2	a_52_123#	4.55843e-18
C63	A2#1	VPWR#4	3.31153e-17
C64	a_222_392##4	A1#2	1.06892e-17
C65	a_132_392#	VPWR#3	5.22788e-17
C66	a_52_123##2	a_222_392##2	2.17321e-18
C67	a_52_123#	B1#2	5.29989e-19
C68	a_222_392##4	B1#2	2.74637e-18
C69	a_132_392##2	VPWR#3	2.72536e-17
C70	a_222_392##2	VPWR#5	5.96106e-17
C71	VPWR#3	VPWR#4	3.76632e-17
C72	A1#1	a_222_392##3	1.60881e-17
C73	VPWR#5	A1#2	8.07958e-19
C74	a_52_123##2	B1#2	2.22598e-18
C75	VGND#6	A2#3	9.28638e-20
C76	VPWR#3	A1#3	6.06975e-20
C77	a_52_123#	A2#3	7.10283e-19
C78	VGND#7	B2#2	6.4561e-19
C79	B1#1	A1#1	2.49826e-17
C80	a_52_123##2	B2#2	9.63545e-18
C81	VGND#3	A1#3	5.2079e-18
C82	a_132_392#	B1#2	8.00656e-19
C83	a_222_392##2	a_222_392#	4.05111e-18
C84	VGND#7	A2#3	2.18712e-18
C85	VGND#3	B1#3	5.25706e-18
C86	a_222_392##6	B1#2	3.01894e-18
C87	a_52_123##2	A2#3	3.41484e-18
C88	B2#3	B1#1	3.35644e-17
C89	A1#2	a_222_392#	1.76656e-18
C90	a_222_392##2	B1#3	7.64534e-21
C91	a_222_392##6	B2#2	1.91557e-18
C92	a_132_392##2	B2#2	1.69936e-19
C93	a_222_392##2	A2#2	1.17096e-19
C94	A2#1	B2#3	4.18067e-17
C95	B1#2	A1#3	6.03913e-18
C96	VPWR#3	B1#1	4.44829e-18
C97	VPWR#4	A2#3	9.36442e-19
C98	a_222_392##2	a_222_392##3	1.12842e-17
C99	VPWR#3	B2#3	4.43306e-18
C100	a_52_123#	a_230_79#	8.75701e-20
C101	a_222_392##2	A1#1	2.11696e-18
C102	A1#2	a_222_392##3	1.74259e-18
C103	a_222_392##2	B1#1	4.10804e-19
C104	A2#2	B2#2	1.94912e-17
C105	a_222_392##2	B2#3	2.00919e-19
C106	A2#3	B2#1	1.36775e-17
C107	B1#2	A1#1	2.56041e-18
C108	a_222_392##2	A2#1	2.30782e-19
C109	a_52_123#	B1	2.1516e-18
C110	a_222_392##4	B1	1.7365e-17
C111	A2#1	B2#2	1.81403e-17
C112	VGND#3	A1#2	2.2393e-19
C113	VPWR#3	B1#2	5.03853e-20
C114	B1#3	a_230_79#	3.49377e-18
C115	B1	a_132_392#	1.42267e-18
C116	A1#2	a_222_392##2	3.56176e-17
C117	VGND#3	B1#2	7.62152e-20
C118	VPWR#3	B2#2	1.73177e-20
C119	B2#1	a_230_79#	9.72937e-18
C120	B1	a_222_392##6	3.20264e-17
C121	a_52_123##2	B2	1.01577e-16
C122	a_222_392##2	B1#2	4.70571e-19
C123	a_222_392##4	A1	3.09274e-17
C124	B1#2	A1#2	3.42657e-17
C125	a_222_392##2	B2#2	1.2204e-19
C126	B2	a_222_392##6	2.60542e-17
C127	B1	A1#3	2.944e-18
C128	B2	a_132_392##2	3.87401e-17
C129	B2	VPWR#4	4.25977e-17
C130	B2#2	B1#2	4.24668e-17
C131	A1	a_222_392##6	1.47432e-17
C132	A2	VGND#7	1.73906e-17
C133	A2	a_52_123##2	2.91616e-17
C134	X	X#3	3.62139e-18
C135	VGND#6	X	4.06366e-17
C136	B2	A2#2	1.42853e-17
C137	a_222_392##4	X	1.5361e-18
C138	X	X#1	1.38745e-17
C139	A1	A2#2	5.43654e-19
C140	VPWR#5	X	4.16772e-17
C141	A1	a_222_392##3	9.26357e-19
C142	a_222_392##6	X	1.01527e-18
C143	A2	B2#1	1.46594e-18
C144	B2	A2#1	1.91426e-17
C145	A2	A2#2	3.8456e-18
C146	X	a_222_392#	2.59343e-17
C147	B1	a_222_392##2	1.02265e-18
C148	X	A1#3	1.58294e-18
C149	VPWR	a_132_392#	2.56391e-17
C150	B1	A1#2	5.63578e-18
C151	VPWR	a_222_392##6	1.24655e-17
C152	VGND	a_52_123#	3.59645e-17
C153	VPWR	a_132_392##2	2.07546e-17
C154	B1	B1#2	1.96602e-17
C155	VGND	a_222_392##4	7.66494e-18
C156	VPWR	VPWR#4	4.42374e-17
C157	B1	B2#2	2.87221e-18
C158	X	a_222_392##3	2.95829e-17
C159	VGND	a_52_123##2	7.23688e-18
C160	X	A1#1	9.14449e-19
C161	B2	B1#2	6.22988e-18
C162	a_222_392##2	A1	5.59447e-17
C163	X	B1#1	2.84577e-19
C164	B2	B2#2	2.08141e-17
C165	A1	A1#2	1.92463e-17
C166	X	B2#3	9.65246e-20
C167	A1	B1#2	5.27543e-18
C168	B2	A2#3	8.98605e-19
C169	VPWR	a_222_392##3	4.74214e-18
C170	VGND#6	VNB	3.51849e-18
C171	VGND	a_222_392#	4.70581e-18
C172	A1	B2#2	7.70765e-19
C173	a_52_123#	VNB	8.60326e-18
C174	VPWR	A1#1	1.43276e-18
C175	a_222_392##4	VNB	2.52559e-18
C176	VGND	A1#3	1.10225e-17
C177	VPWR	B1#1	1.41805e-18
C178	VGND	B1#3	1.00255e-17
C179	VGND#7	VNB	1.24046e-18
C180	VPWR	B2#3	1.45831e-18
C181	VGND	B2#1	8.22114e-18
C182	a_52_123##2	VNB	3.00386e-17
C183	VPWR	A2#1	2.63809e-18
C184	X	a_222_392##2	1.30233e-16
C185	a_132_392#	VNB	4.16751e-18
C186	X	A1#2	1.69592e-19
C187	A2	A2#3	2.17939e-17
C188	VPWR	VPWR#3	2.04803e-17
C189	a_132_392##2	VNB	3.25821e-18
C190	VPWR#4	VNB	8.42791e-17
C191	a_222_392#	VNB	3.57976e-17
C192	VPWR	a_222_392##2	2.59783e-18
C193	A1#3	VNB	4.44753e-17
C194	B1#3	VNB	3.22565e-17
C195	B2#1	VNB	3.56224e-17
C196	A2#2	VNB	4.52231e-17
C197	B2	B1	2.54321e-17
C198	a_222_392##3	VNB	4.29442e-17
C199	VGND	VGND#3	2.02068e-17
C200	A1#1	VNB	3.53038e-17
C201	VGND	a_222_392##2	4.82323e-18
C202	B1	A1	2.85396e-17
C203	B1#1	VNB	3.05426e-17
C204	VGND	A1#2	4.14389e-20
C205	B2#3	VNB	3.05831e-17
C206	A2#1	VNB	5.44547e-17
C207	VPWR#3	VNB	1.87564e-16
C208	VGND	A2#3	4.56295e-18
C209	VGND#3	VNB	1.80534e-16
C210	A2	B2	2.47596e-18
C211	a_222_392##2	VNB	5.45314e-17
C212	A1#2	VNB	3.7312e-17
C213	B1#2	VNB	3.84552e-17
C214	B2#2	VNB	3.82201e-17
C215	VPWR	B1	1.88255e-18
C216	A2#3	VNB	6.03255e-17
C217	VPWR	B2	6.63575e-18
C218	VGND	B1	3.16939e-18
C219	VPWR	A1	2.727e-18
C220	VGND	B2	6.24495e-18
C221	VGND	A1	2.48945e-18
C222	B1	VNB	2.34063e-18
C223	VPWR	X	2.08652e-17
C224	VGND	A2	1.77606e-17
C225	B2	VNB	2.55308e-17
C226	A1	VNB	5.2072e-18
C227	VGND	X	2.04417e-17
C228	A2	VNB	2.50268e-17
C229	X	VNB	1.22634e-16
C230	VPWR	VNB	5.87084e-17
C231	VGND	VNB	6.87887e-17
C232	a_222_392##6	VPWR#2	6.8113e-19
C233	VGND#4	A2#3	1.89453e-17
C234	VPWR	VPWR#2	7.81803e-17
C235	VGND#4	VGND#6	3.53666e-19
C236	VGND	VGND#2	5.30194e-17
C237	VPWR#2	B1#1	5.29313e-19
C238	VGND#4	B1#3	1.48278e-18
C239	VGND#2	X	2.08972e-17
C240	VPWR#2	VPWR#5	1.82136e-18
C241	VGND	VGND#4	5.0432e-17
C242	VGND#2	A1#2	2.19429e-19
C243	VGND#4	a_52_123##2	7.43137e-19
C244	VGND#2	B1#3	5.83592e-19
C245	VGND#4	a_222_392#	4.20555e-19
C246	VGND#2	a_52_123#	5.82413e-18
C247	VGND#3	VGND#2	5.32562e-17
C248	VGND#4	VGND#2	9.92457e-19
C249	VGND#2	a_222_392#	1.43094e-17
C250	VPWR#2	a_222_392##3	1.60573e-17
C251	VPWR#2	a_222_392##2	6.5697e-20
C252	VPWR#2	B2#3	1.76209e-19
C253	VGND#4	a_52_123#	9.21334e-18
C254	VGND#4	B2#1	7.09288e-18
C255	VGND#2	VNB	5.40682e-17
C256	a_132_392#	VPWR#2	2.67056e-17
C257	VGND#2	A2#3	5.58227e-19
C258	VGND#4	B2#2	3.12678e-20
C259	VPWR#3	VPWR#2	6.05218e-17
C260	VGND#4	VNB	4.90782e-17
C261	VPWR#2	X	3.3784e-17
C262	VGND#4	A1#3	3.85103e-19
C263	VGND#2	B2#1	1.59233e-19
C264	VPWR#2	A1#1	1.41313e-17
C265	VGND#2	a_222_392##4	1.41543e-19
C266	VGND#2	a_222_392##2	1.6884e-18
C267	VGND#2	A1#3	1.95612e-18
C268	VPWR#2	VNB	5.81818e-17
C269	VGND#3	VGND#4	5.49108e-17
C270	VPWR#2	A2#1	7.6205e-20
C271	VGND#4	A2	4.98462e-17
*
*
.ENDS sky130_fd_sc_hs__a22o_1
*
