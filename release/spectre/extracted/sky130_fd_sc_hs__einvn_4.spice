* Extracted by Quantus, converted by sky130cad/quantus.py
*
*
*
*                       LINUX           Wed Nov 18 08:37:05 2026
*
*
*
*  PROGRAM  advgen
*
*  Name           : advgen - Quantus - (64-bit)
*  Version        : 25.1.0-p047
*  Build Date     : Thu Dec 11 23:20:30 PST 2025
*
*  HSPICE LIBRARY
*
*  OPERATING_TEMPERATURE 150
*  QRC_TECH_DIR <path>/tech
*
*
*

*
.SUBCKT sky130_fd_sc_hs__einvn_4 VPB VNB VGND VPWR Z A TE_B
*
*
*  caps2d version: 10
*
*
*       TRANSISTOR CARDS
*
*
XM17 VGND#4 TE_B#10 a_114_74##10 VNB sky130_fd_pr__nfet_01v8_lvt l=0.15 w=0.74 ad=0.2109 as=0.2109 pd=2.05 ps=2.05
XM11 VGND#6 a_114_74##8 a_281_74##7 VNB sky130_fd_pr__nfet_01v8_lvt l=0.15 w=0.74 ad=0.2072 as=0.2109 pd=2.04 ps=2.05
XM1 a_281_74##8 a_114_74##7 VGND#6 VNB sky130_fd_pr__nfet_01v8_lvt l=0.15 w=0.74 ad=0.2072 as=0.2072 pd=2.04 ps=2.04
XM9 a_281_74##8 a_114_74##6 VGND#5 VNB sky130_fd_pr__nfet_01v8_lvt l=0.15 w=0.74 ad=0.2072 as=0.2072 pd=2.04 ps=2.04
XM10 VGND#5 a_114_74# a_281_74##4 VNB sky130_fd_pr__nfet_01v8_lvt l=0.15 w=0.74 ad=0.2072 as=0.2072 pd=2.04 ps=2.04
XM0 Z#2 A#13 a_281_74##4 VNB sky130_fd_pr__nfet_01v8_lvt l=0.15 w=0.74 ad=0.2072 as=0.2072 pd=2.04 ps=2.04
XM12 Z#2 A#11 a_281_74##2 VNB sky130_fd_pr__nfet_01v8_lvt l=0.15 w=0.74 ad=0.2072 as=0.2146 pd=2.04 ps=2.06
XM13 a_281_74##2 A#9 Z#1 VNB sky130_fd_pr__nfet_01v8_lvt l=0.15 w=0.74 ad=0.2146 as=0.2072 pd=2.06 ps=2.04
XM16 a_281_74# A#1 Z#1 VNB sky130_fd_pr__nfet_01v8_lvt l=0.15 w=0.74 ad=0.2109 as=0.2072 pd=2.05 ps=2.04
XM4 VPWR#4 TE_B#11 a_114_74##9 VPB sky130_fd_pr__pfet_01v8 l=0.15 w=1.12 ad=0.3304 as=0.3304 pd=2.83 ps=2.83
XM2 a_241_368##6 TE_B#9 VPWR#6 VPB sky130_fd_pr__pfet_01v8 l=0.15 w=1.12 ad=0.3304 as=0.336 pd=2.83 ps=2.84
XM3 VPWR#6 TE_B#8 a_241_368##8 VPB sky130_fd_pr__pfet_01v8 l=0.15 w=1.12 ad=0.336 as=0.336 pd=2.84 ps=2.84
XM7 a_241_368##8 TE_B#7 VPWR#5 VPB sky130_fd_pr__pfet_01v8 l=0.15 w=1.12 ad=0.336 as=0.392 pd=2.84 ps=2.94
XM8 VPWR#5 TE_B#1 a_241_368##3 VPB sky130_fd_pr__pfet_01v8 l=0.15 w=1.12 ad=0.392 as=0.336 pd=2.94 ps=2.84
XM6 Z#5 A#7 a_241_368##3 VPB sky130_fd_pr__pfet_01v8 l=0.15 w=1.12 ad=0.336 as=0.336 pd=2.84 ps=2.84
XM14 a_241_368##7 A#12 Z#5 VPB sky130_fd_pr__pfet_01v8 l=0.15 w=1.12 ad=0.336 as=0.336 pd=2.84 ps=2.84
XM15 a_241_368##7 A#10 Z#6 VPB sky130_fd_pr__pfet_01v8 l=0.15 w=1.12 ad=0.336 as=0.336 pd=2.84 ps=2.84
XM5 Z#6 A#8 a_241_368# VPB sky130_fd_pr__pfet_01v8 l=0.15 w=1.12 ad=0.336 as=0.3304 pd=2.84 ps=2.83
*
*
*       RESISTOR AND CAP/DIODE CARDS
*
Rg1	TE_B#1	TE_B#2	627.760071
Rg2	TE_B#2	TE_B#3	214.351181
Rg3	TE_B#3	TE_B#4	214.351181
Rg4	TE_B#4	TE_B#5	525.103149
Rg5	TE_B#5	TE_B#6	33.467823
Rg6	TE_B#2	TE_B#7	385.612793
Rg7	TE_B#3	TE_B#8	385.612793
Rg8	TE_B#4	TE_B#9	385.612793
Rg9	TE_B#5	TE_B#10	442.169952
Rg10	TE_B#5	TE_B#11	485.209564
Rg11	a_114_74#	a_114_74##2	473.208221
Rg12	a_114_74##2	a_114_74##3	210.494781
Rg13	a_114_74##3	a_114_74##4	210.494781
Rg14	a_114_74##4	a_114_74##5	360.013336
Rg15	a_114_74##2	a_114_74##6	262.702026
Rg16	a_114_74##3	a_114_74##7	262.702026
Rg17	a_114_74##4	a_114_74##8	262.702026
Rg18	A#1	A#2	329.107544
Rg19	A#2	A#3	17.473763
Rg20	A#3	A#4	22.285097
Rg21	A#4	A#5	49.862019
Rg22	A#5	A#6	43.766056
Rg23	A#6	A#7	567.488586
Rg24	A#2	A#8	455.289612
Rg25	A#4	A#9	372.836365
Rg26	A#4	A#10	461.784973
Rg27	A#5	A#11	379.494690
Rg28	A#5	A#12	468.443298
Rg29	A#6	A#13	473.082947
Rf1	TE_B#12	TE_B#6	160.919952
Rf2	TE_B	TE_B#14	0.687145
Rf3	TE_B#12	TE_B#14	7.873454
Rf4	a_114_74##9	a_114_74##11	67.421341
Rf5	a_114_74##11	a_114_74##5	59.052334
Rf6	a_114_74##10	a_114_74##11	7.500000
Rf7	Z#1	Z#3	57.011925
Rf8	Z#3	Z	44.243561
Rf9	Z	Z#4	5.495449
Rf10	Z#4	Z#5	24.864502
Rf11	Z#4	Z#6	76.103218
Rf12	Z#2	Z#3	15.000000
Rf13	A	A#3	54.116901
Rf14	a_241_368#	a_241_368##2	98.311989
Rf15	a_241_368##2	a_241_368##4	93.603386
Rf16	a_241_368##4	a_241_368##5	106.512131
Rf17	a_241_368##5	a_241_368##6	108.151001
Rf18	a_241_368##2	a_241_368##7	36.706856
Rf19	a_241_368##5	a_241_368##8	43.399349
Rf20	a_241_368##3	a_241_368##4	5.000000
Rf21	a_281_74#	a_281_74##3	81.769051
Rf22	a_281_74##3	a_281_74##5	41.372849
Rf23	a_281_74##5	a_281_74##6	85.017883
Rf24	a_281_74##6	a_281_74##7	101.087387
Rf25	a_281_74##6	a_281_74##8	37.802612
Rf26	a_281_74##2	a_281_74##3	15.000000
Rf27	a_281_74##4	a_281_74##5	7.500000
Rf29	VGND#2	VGND#3	48.188797
Rf30	VGND#3	VGND#4	168.160995
Rf31	VGND#2	VGND#5	35.131050
Rf32	VGND#3	VGND#6	31.633150
Rf34	VPWR#2	VPWR#3	65.084282
Rf35	VPWR#3	VPWR#4	152.243622
Rf36	VPWR#2	VPWR#5	41.783939
Rf37	VPWR#3	VPWR#6	48.259808
Re1	VPWR#2	VPWR	0.892922
Re2	VGND	VGND#2	0.892955
*
*       CAPACITOR CARDS
*
*
C1	a_114_74##4	TE_B#4	2.23135e-17
C2	A#5	a_281_74#	6.06644e-18
C3	a_114_74##4	TE_B#3	9.77546e-18
C4	A#5	Z#1	6.07043e-18
C5	a_281_74##6	TE_B#1	1.36746e-18
C6	a_114_74##3	TE_B#3	1.47086e-17
C7	A#5	a_281_74##2	2.26722e-18
C8	Z#2	A#6	2.83639e-18
C9	a_241_368##5	TE_B#1	3.77477e-19
C10	a_114_74##3	TE_B#2	8.68323e-18
C11	VPWR#3	TE_B#7	5.16438e-19
C12	Z#2	A#5	6.96079e-18
C13	a_281_74##4	A#6	1.38522e-17
C14	a_114_74##2	TE_B#2	2.02387e-17
C15	a_241_368##2	Z#6	1.60192e-17
C16	a_281_74##4	A#5	3.56998e-19
C17	VPWR#3	TE_B#8	5.41536e-18
C18	a_241_368##2	a_241_368##7	3.2067e-19
C19	a_241_368##2	A#6	4.6068e-20
C20	VPWR#3	TE_B#9	5.87382e-18
C21	a_281_74##6	a_241_368##3	1.47679e-17
C22	VPWR#3	VPWR#5	2.85251e-19
C23	a_241_368##2	Z#5	1.52137e-17
C24	a_114_74##2	VGND#5	2.51544e-18
C25	a_114_74##3	a_281_74##8	4.96868e-19
C26	a_114_74##4	VGND#6	1.65461e-18
C27	a_281_74#	Z#1	4.5647e-17
C28	a_241_368##2	A#5	2.84956e-19
C29	a_114_74##2	a_281_74##8	4.90657e-19
C30	a_241_368##5	a_241_368##3	1.23342e-18
C31	a_114_74##3	VGND#6	1.62547e-18
C32	a_281_74##7	a_114_74##4	1.5817e-17
C33	VPWR#3	TE_B#11	4.17846e-19
C34	a_281_74##2	a_281_74#	2.99834e-18
C35	VGND#3	a_114_74##4	4.84251e-19
C36	a_241_368##8	VPWR#3	6.52642e-18
C37	a_241_368#	A#5	7.05074e-18
C38	Z#1	a_281_74##2	3.00014e-17
C39	Z#6	A#5	1.56156e-17
C40	a_281_74##6	a_114_74##4	9.25921e-19
C41	a_241_368##5	VPWR#5	2.65822e-17
C42	a_281_74##2	Z#2	3.66391e-17
C43	a_281_74##4	Z#1	4.81547e-19
C44	VGND#3	a_114_74##3	1.55203e-20
C45	A#5	a_241_368##7	4.68201e-18
C46	a_281_74##7	TE_B#4	2.97671e-18
C47	A#6	Z#5	4.83974e-19
C48	a_281_74##7	TE_B#3	1.97546e-18
C49	A#5	Z#5	2.19559e-19
C50	a_114_74##10	TE_B#4	3.7353e-18
C51	a_241_368##3	A#6	1.15363e-17
C52	a_281_74##4	Z#2	6.42123e-17
C53	a_281_74##6	a_114_74##3	8.06724e-18
C54	a_241_368##5	a_114_74##4	4.05548e-18
C55	a_241_368##6	VPWR#3	1.78266e-17
C56	VGND#5	a_281_74##4	6.37875e-17
C57	a_281_74##8	a_281_74##4	2.78479e-18
C58	VGND#3	a_241_368##6	7.04853e-19
C59	a_281_74##6	a_114_74##2	9.25002e-18
C60	a_241_368##5	VPWR#6	2.4269e-17
C61	a_281_74##8	VGND#5	5.17686e-17
C62	a_241_368##5	a_114_74##3	6.88078e-18
C63	a_281_74#	a_241_368#	3.09618e-19
C64	a_241_368##3	a_114_74##2	7.18025e-19
C65	VGND#6	VGND#5	2.30962e-18
C66	a_114_74##9	VPWR#3	9.01537e-18
C67	VPWR#3	TE_B#4	4.37785e-19
C68	VGND#6	a_281_74##8	5.17346e-17
C69	a_281_74##7	a_281_74##8	2.69669e-18
C70	a_241_368##6	a_241_368##5	1.33113e-18
C71	a_241_368##5	a_114_74##2	5.64198e-18
C72	VGND#3	TE_B#4	3.83447e-19
C73	a_281_74##7	VGND#6	6.3497e-17
C74	a_241_368##6	a_114_74##4	3.45421e-18
C75	VPWR#4	VPWR#3	3.58923e-19
C76	a_114_74##10	VGND#6	2.54876e-18
C77	VPWR#3	TE_B#3	8.54626e-21
C78	VPWR#5	TE_B#2	3.22693e-18
C79	a_241_368##8	TE_B#3	4.4937e-19
C80	a_114_74##10	a_281_74##7	8.67112e-17
C81	VGND#4	VGND#6	1.36869e-20
C82	VPWR#6	TE_B#4	1.47477e-18
C83	TE_B#2	a_241_368##8	3.45404e-19
C84	VPWR#6	TE_B#3	1.62329e-18
C85	a_241_368##6	TE_B#4	2.24216e-17
C86	VPWR#3	a_114_74##5	8.49977e-19
C87	VGND#3	a_114_74##5	6.7239e-18
C88	VGND#4	a_114_74##10	9.29621e-17
C89	a_281_74##4	a_241_368##3	3.02748e-17
C90	a_281_74##6	TE_B#3	2.50079e-18
C91	a_241_368##5	TE_B#4	2.34587e-18
C92	a_114_74#	A#6	1.28416e-17
C93	VPWR#3	TE_B#6	3.69308e-20
C94	VGND#3	TE_B#6	1.29349e-20
C95	a_241_368#	Z#6	8.4508e-17
C96	TE_B#14	a_114_74##9	2.53028e-17
C97	a_241_368##7	a_241_368#	3.51463e-18
C98	a_281_74#	A#1	4.19093e-17
C99	a_281_74##6	TE_B#2	4.83429e-18
C100	a_241_368##5	TE_B#3	1.10288e-17
C101	Z#6	a_241_368##7	5.09609e-17
C102	A#1	Z#1	1.73423e-17
C103	a_281_74#	A#9	1.81312e-18
C104	Z#5	Z#6	1.25826e-18
C105	a_281_74##2	A#1	9.9499e-19
C106	TE_B#14	TE_B#6	1.13624e-17
C107	Z#1	A#9	3.10134e-17
C108	Z#2	A#1	7.54825e-19
C109	Z#5	a_241_368##7	5.09848e-17
C110	TE_B#14	VPWR#4	3.27699e-17
C111	a_281_74##2	A#9	3.47316e-17
C112	a_281_74##7	a_241_368##6	1.48548e-17
C113	a_281_74##4	A#1	4.08879e-20
C114	Z#1	A#11	1.22559e-19
C115	a_241_368##3	a_241_368##7	3.51463e-18
C116	Z#2	A#9	1.20886e-18
C117	a_241_368##5	TE_B#2	1.05673e-17
C118	a_114_74##10	a_241_368##6	2.93486e-17
C119	VGND#5	A#1	5.64812e-20
C120	a_281_74##2	A#11	3.63656e-17
C121	a_281_74##4	A#9	7.14638e-20
C122	a_241_368##3	Z#5	6.8392e-17
C123	Z#1	A#13	5.69039e-20
C124	Z#2	A#11	3.61114e-17
C125	VGND#5	A#9	7.61573e-20
C126	a_281_74##4	A#11	7.94311e-19
C127	A#13	Z#2	1.43306e-17
C128	a_241_368##3	VPWR#5	1.15325e-16
C129	VGND#5	A#11	2.80855e-19
C130	a_281_74##4	A#13	4.96774e-17
C131	A#5	A#8	7.63942e-19
C132	a_241_368##8	a_241_368##3	1.03752e-18
C133	VGND#5	A#13	1.94888e-18
C134	a_281_74##4	a_114_74#	2.18494e-17
C135	a_241_368##8	VPWR#5	8.70717e-17
C136	a_281_74##8	A#13	2.07534e-19
C137	VGND#5	a_114_74#	3.98934e-17
C138	VPWR#6	VPWR#5	2.35578e-18
C139	a_281_74##4	a_114_74##6	5.3129e-19
C140	a_281_74##8	a_114_74#	4.91976e-19
C141	VGND#5	a_114_74##6	3.54423e-17
C142	VPWR#6	a_241_368##8	8.55715e-17
C143	a_281_74##4	a_114_74##7	2.3218e-19
C144	a_114_74##6	a_281_74##8	1.47809e-17
C145	a_241_368##6	a_241_368##8	1.08906e-18
C146	VGND#5	a_114_74##7	2.07098e-18
C147	VGND#6	a_114_74##6	2.44947e-18
C148	A#7	A#5	7.64197e-19
C149	a_114_74##7	a_281_74##8	1.87126e-17
C150	a_241_368##6	VPWR#6	9.01081e-17
C151	a_281_74##7	a_114_74##6	2.07534e-19
C152	VGND#6	a_114_74##7	4.1241e-17
C153	a_281_74##6	a_114_74#	2.87781e-18
C154	TE_B#1	A#6	8.97753e-18
C155	a_281_74##8	a_114_74##8	4.91976e-19
C156	VGND#3	a_281_74##6	2.39011e-19
C157	a_281_74##7	a_114_74##7	4.91976e-19
C158	VGND#6	a_114_74##8	3.53586e-17
C159	a_114_74##9	a_241_368##6	9.46273e-17
C160	VPWR#4	VPWR#6	1.1469e-18
C161	a_281_74##7	a_114_74##8	1.53417e-17
C162	VGND#6	TE_B#10	4.08215e-19
C163	a_114_74##10	a_114_74##8	3.11154e-18
C164	VPWR#4	a_114_74##9	8.9539e-17
C165	a_114_74##2	TE_B#1	5.0026e-18
C166	VGND#4	a_114_74##8	3.50443e-19
C167	a_241_368##3	a_114_74#	4.88942e-18
C168	a_114_74##10	TE_B#10	4.12314e-17
C169	a_281_74##6	a_114_74##6	3.44948e-18
C170	VGND#4	TE_B#10	2.85098e-17
C171	a_241_368##5	VPWR#3	1.61954e-19
C172	A#9	A#1	3.8592e-17
C173	VGND#3	a_114_74##7	1.25842e-18
C174	a_241_368#	A#8	4.60747e-17
C175	Z#6	A#8	4.85217e-17
C176	a_281_74##4	TE_B#1	1.01866e-18
C177	a_281_74##6	a_114_74##7	3.33471e-18
C178	A#11	A#9	3.60101e-17
C179	a_241_368#	A#10	1.30694e-18
C180	a_241_368##7	A#8	1.29161e-18
C181	Z#6	A#10	5.24499e-17
C182	a_241_368#	A#12	3.00902e-19
C183	A#10	a_241_368##7	2.31681e-17
C184	A#13	A#11	3.76022e-17
C185	Z#6	A#12	1.74308e-18
C186	Z#5	A#10	1.44393e-18
C187	VPWR#5	A#8	5.08752e-20
C188	VGND#3	a_114_74##8	1.25541e-18
C189	A#12	a_241_368##7	2.78893e-17
C190	VGND#5	a_281_74##6	3.04964e-17
C191	a_241_368##3	A#10	3.00902e-19
C192	Z#5	A#12	4.73736e-17
C193	a_114_74#	A#13	3.73931e-17
C194	VPWR#5	A#10	7.09397e-20
C195	a_241_368##7	A#7	6.2318e-19
C196	a_241_368##3	A#12	6.72697e-19
C197	Z#5	A#7	4.11502e-17
C198	VGND#3	a_281_74##8	2.2864e-18
C199	VPWR#5	A#12	2.11221e-19
C200	a_241_368##7	TE_B#1	2.68812e-19
C201	a_241_368##3	A#7	3.38684e-17
C202	a_114_74##6	a_114_74#	3.65142e-17
C203	A#3	A#5	3.15284e-17
C204	Z#5	TE_B#1	1.2952e-18
C205	VPWR#5	A#7	5.18866e-19
C206	a_241_368##3	TE_B#1	6.2394e-17
C207	Z	a_241_368##2	7.6365e-19
C208	a_114_74##7	a_114_74##6	3.77796e-17
C209	VPWR#5	TE_B#1	2.36408e-17
C210	a_241_368##3	TE_B#7	1.83869e-18
C211	a_241_368##8	TE_B#1	1.45964e-19
C212	VPWR#5	TE_B#7	5.95542e-17
C213	a_114_74##8	a_114_74##7	3.65069e-17
C214	a_241_368##3	TE_B#8	7.22861e-20
C215	a_241_368##8	TE_B#7	1.78536e-17
C216	VPWR#5	TE_B#8	3.20906e-18
C217	VPWR#6	TE_B#7	6.51081e-19
C218	VPWR	VPWR#3	4.67272e-17
C219	a_241_368##8	TE_B#8	5.34884e-17
C220	Z#1	A#3	3.59395e-17
C221	TE_B#10	a_114_74##8	5.08395e-19
C222	a_114_74##5	TE_B#4	2.1361e-17
C223	VPWR#6	TE_B#8	1.91043e-17
C224	VPWR#5	TE_B#9	3.75171e-19
C225	VPWR	a_241_368##5	2.56482e-18
C226	VPWR	a_241_368##2	2.52286e-17
C227	Z#2	A#3	2.92339e-17
C228	a_241_368##8	TE_B#9	2.23084e-18
C229	a_241_368##6	TE_B#8	1.47062e-19
C230	VPWR#6	TE_B#9	5.17067e-17
C231	VPWR	TE_B#14	1.41012e-18
C232	a_241_368##6	TE_B#9	2.16713e-17
C233	VGND#6	a_281_74##6	2.03442e-17
C234	a_241_368##8	TE_B#11	1.62322e-20
C235	a_114_74##9	TE_B#9	1.96093e-18
C236	VPWR#6	TE_B#11	6.49823e-19
C237	a_241_368##6	TE_B#11	1.84315e-18
C238	VPWR#4	TE_B#9	8.88262e-19
C239	a_114_74#	TE_B#1	1.40665e-17
C240	a_281_74##8	a_114_74##5	2.63883e-19
C241	a_114_74##9	TE_B#11	7.28767e-17
C242	VGND#6	a_114_74##5	1.85185e-18
C243	VGND#3	a_281_74##7	1.07441e-17
C244	TE_B#11	VPWR#4	3.80138e-17
C245	a_281_74##6	a_241_368##5	7.33558e-17
C246	a_281_74##7	a_114_74##5	1.06321e-17
C247	A#3	Z#6	2.93653e-17
C248	A#10	A#8	4.62837e-17
C249	VGND	VGND#3	3.17543e-17
C250	a_114_74##10	a_114_74##5	5.62793e-17
C251	VGND	a_281_74##6	3.57865e-18
C252	VGND	a_241_368##5	5.21238e-18
C253	a_114_74##10	TE_B#6	4.20223e-17
C254	A#12	A#10	4.74852e-17
C255	TE_B#6	VGND#4	4.46729e-17
C256	A#7	A#12	4.63327e-17
C257	a_241_368##6	a_114_74##5	5.17339e-18
C258	VGND#3	a_114_74##10	2.11865e-17
C259	TE_B#1	A#7	4.78889e-17
C260	a_241_368##8	TE_B#6	1.76236e-20
C261	VPWR#3	VNB	4.14379e-17
C262	VGND#3	VNB	4.34654e-17
C263	a_241_368##6	TE_B#6	9.30425e-19
C264	a_281_74##6	VNB	1.93834e-18
C265	a_114_74##9	TE_B#6	2.74984e-17
C266	TE_B#7	TE_B#1	3.76608e-17
C267	a_241_368##2	VNB	4.52537e-18
C268	TE_B#6	VPWR#4	7.95363e-18
C269	TE_B#14	VNB	9.27403e-18
C270	A	A#5	3.43448e-17
C271	a_281_74##7	a_241_368##5	2.38038e-17
C272	TE_B#8	TE_B#7	4.80332e-17
C273	Z	A#6	1.46817e-17
C274	a_114_74##5	a_114_74##8	2.9282e-17
C275	TE_B#9	TE_B#8	4.75779e-17
C276	Z	A#5	1.82329e-17
C277	a_281_74#	A	3.73221e-17
C278	Z#1	A	1.52393e-17
C279	TE_B#10	a_114_74##5	2.73312e-17
C280	TE_B#11	TE_B#9	6.30999e-18
C281	VGND#4	VGND#3	2.61458e-19
C282	Z#2	Z	2.03973e-18
C283	A	a_241_368#	1.57223e-17
C284	a_281_74##4	Z	2.58967e-18
C285	A	Z#6	1.91717e-17
C286	VPWR	TE_B#4	1.49659e-18
C287	VPWR	TE_B#3	1.92775e-19
C288	VPWR	TE_B#2	5.3337e-19
C289	Z	Z#6	1.73196e-18
C290	Z	a_241_368##7	1.38421e-17
C291	Z	Z#5	1.40954e-19
C292	a_241_368##2	A#10	1.62137e-17
C293	VGND	a_114_74##4	5.27529e-19
C294	a_241_368##3	Z	4.23558e-17
C295	TE_B#6	TE_B#9	1.24222e-19
C296	VGND	TE_B#4	3.89853e-19
C297	VPWR	a_241_368#	2.22316e-17
C298	VGND	a_281_74#	2.10114e-17
C299	VPWR	Z#6	8.60674e-18
C300	VGND	Z#1	6.66613e-18
C301	VGND	a_281_74##2	2.40023e-17
C302	VPWR	Z#5	8.54488e-18
C303	VGND	Z#2	7.32931e-18
C304	VGND	a_281_74##4	2.14959e-17
C305	VPWR	a_241_368##3	2.23186e-17
C306	VGND	VGND#5	2.1796e-17
C307	VPWR	VPWR#5	2.0955e-17
C308	VGND	a_281_74##8	1.12244e-17
C309	A#6	VNB	2.97442e-17
C310	VPWR	a_241_368##8	1.4404e-17
C311	VGND	VGND#6	2.1892e-17
C312	A#5	VNB	1.14053e-16
C313	VGND	a_281_74##7	1.22468e-17
C314	VGND	a_114_74##10	3.39407e-17
C315	VPWR	a_241_368##6	1.55208e-17
C316	a_114_74##4	VNB	1.70394e-17
C317	VGND	VGND#4	4.24707e-17
C318	a_114_74##3	VNB	1.1918e-17
C319	VPWR	a_114_74##9	2.04802e-17
C320	a_114_74##2	VNB	1.2798e-17
C321	VGND	a_241_368#	2.72101e-18
C322	VPWR	VPWR#4	3.79709e-17
C323	VGND	Z#6	2.22042e-18
C324	TE_B#4	VNB	2.75132e-17
C325	TE_B#3	VNB	1.55869e-17
C326	TE_B#6	a_114_74##5	1.17379e-17
C327	TE_B#2	VNB	1.9844e-17
C328	a_281_74#	VNB	4.04058e-17
C329	VGND	a_241_368##3	3.47338e-18
C330	a_281_74##2	VNB	4.14166e-18
C331	Z#2	VNB	1.33094e-18
C332	a_281_74##4	VNB	4.44005e-18
C333	VGND	a_241_368##6	4.73466e-18
C334	a_281_74##8	VNB	4.57648e-18
C335	VGND#6	VNB	5.1183e-20
C336	Z	A#10	2.99145e-19
C337	a_281_74##7	VNB	4.6167e-18
C338	a_114_74##10	VNB	1.42858e-17
C339	Z	A#12	1.10151e-17
C340	VGND	A#1	2.1931e-18
C341	VGND#4	VNB	8.06031e-17
C342	a_241_368#	VNB	5.81064e-17
C343	VGND	A#9	1.62023e-18
C344	Z	A#7	5.3212e-18
C345	Z#6	VNB	5.05054e-18
C346	VGND	A#11	1.28275e-18
C347	Z	TE_B#1	2.39332e-18
C348	VGND	A#13	1.12139e-18
C349	VPWR	A#8	2.31477e-18
C350	a_241_368##3	VNB	4.0038e-18
C351	VGND	a_114_74#	9.28604e-19
C352	VPWR	A#10	1.68653e-18
C353	VPWR#5	VNB	1.52805e-18
C354	VGND	a_114_74##6	7.40182e-19
C355	a_241_368##8	VNB	2.61552e-18
C356	VPWR	A#12	1.60341e-18
C357	VGND	a_114_74##7	7.89049e-19
C358	VPWR#6	VNB	5.50593e-19
C359	a_241_368##6	VNB	1.61787e-17
C360	VGND	a_114_74##8	9.12823e-19
C361	VPWR	A#7	1.51743e-18
C362	a_114_74##9	VNB	1.73925e-17
C363	VGND	TE_B#10	4.04827e-18
C364	VPWR	TE_B#1	5.08871e-18
C365	VPWR#4	VNB	8.26742e-17
C366	A#1	VNB	2.98687e-17
C367	VPWR	TE_B#7	2.97779e-18
C368	A#9	VNB	2.62036e-17
C369	A#11	VNB	2.68174e-17
C370	VPWR	TE_B#8	3.94784e-18
C371	A#13	VNB	2.69865e-17
C372	a_241_368##2	A#12	1.60115e-17
C373	VPWR	TE_B#9	2.94211e-18
C374	a_114_74#	VNB	3.54618e-17
C375	a_114_74##6	VNB	2.14996e-17
C376	VPWR	TE_B#11	5.15485e-18
C377	a_114_74##7	VNB	2.19241e-17
C378	VGND	TE_B#1	4.03412e-21
C379	a_114_74##8	VNB	2.31591e-17
C380	Z	A#3	2.92648e-17
C381	TE_B#10	VNB	3.46376e-17
C382	A#8	VNB	3.41524e-17
C383	A#10	VNB	3.15955e-17
C384	A#12	VNB	3.183e-17
C385	VPWR	A#3	2.27952e-18
C386	A#7	VNB	3.28129e-17
C387	TE_B#1	VNB	4.34134e-17
C388	TE_B#7	VNB	2.96593e-17
C389	VPWR	TE_B#6	4.89287e-19
C390	TE_B#8	VNB	3.13894e-17
C391	TE_B#9	VNB	3.16993e-17
C392	VGND	A#3	3.47256e-18
C393	TE_B#11	VNB	4.08688e-17
C394	VGND	a_114_74##5	6.01078e-18
C395	VGND	TE_B#6	3.72067e-18
C396	A#3	VNB	2.68714e-18
C397	a_114_74##5	VNB	8.51054e-17
C398	TE_B#6	VNB	9.41725e-17
C399	VPWR	A	3.24311e-18
C400	VPWR	Z	1.05149e-18
C401	VGND	A	4.13609e-18
C402	VGND	Z	2.3626e-18
C403	A	VNB	2.21309e-17
C404	Z	VNB	3.83413e-18
C405	VPWR	VNB	7.71801e-17
C406	VGND	VNB	6.62096e-17
C407	VGND#2	VGND#4	4.07251e-17
C408	VPWR#2	A#6	1.56946e-20
C409	VPWR#2	A#7	4.43427e-18
C410	VGND#2	A#5	4.87369e-19
C411	a_241_368#	VPWR#2	5.03722e-17
C412	VGND#2	TE_B#6	1.06778e-19
C413	VPWR#2	TE_B#2	1.80692e-20
C414	VGND#2	a_114_74#	1.2524e-18
C415	VGND	VGND#2	6.28961e-17
C416	VPWR#2	A#10	4.43427e-18
C417	VGND#2	a_281_74##8	8.16923e-18
C418	VPWR#2	VPWR#4	3.80644e-17
C419	VGND#2	A#11	4.47785e-18
C420	VGND#2	a_114_74##2	7.24163e-20
C421	VPWR#2	a_114_74#	3.73876e-20
C422	VGND#2	a_281_74##4	4.02714e-17
C423	VGND#2	A#1	4.48038e-18
C424	VGND#2	a_281_74##2	6.04157e-17
C425	VGND#2	a_281_74##6	2.39011e-19
C426	VPWR#2	A#5	9.86802e-20
C427	VPWR#2	TE_B#1	2.35934e-18
C428	a_241_368##2	VPWR#2	6.31618e-17
C429	VGND#2	a_281_74#	4.8949e-17
C430	VGND#2	VGND#3	5.91308e-17
C431	a_241_368##8	VPWR#2	7.20223e-18
C432	VGND#2	A#6	7.53979e-20
C433	VPWR#2	A#12	4.43427e-18
C434	VGND#2	a_114_74##6	1.2494e-18
C435	VGND#2	VNB	3.18679e-16
C436	a_241_368##5	VPWR#2	1.61954e-19
C437	VPWR#2	VNB	3.21055e-16
C438	VGND#2	A#13	4.47785e-18
C439	VPWR#2	TE_B#3	9.52297e-21
C440	VPWR#2	VPWR#3	5.52139e-17
C441	a_241_368##3	VPWR#2	4.48882e-17
C442	VPWR#2	A#8	4.43427e-18
C443	VGND#2	a_114_74##3	5.70367e-20
C444	VGND#2	A#9	4.39559e-18
C445	VPWR#2	TE_B#7	1.91103e-18
C446	VPWR	VPWR#2	6.63185e-17
*
*
.ENDS sky130_fd_sc_hs__einvn_4
*
