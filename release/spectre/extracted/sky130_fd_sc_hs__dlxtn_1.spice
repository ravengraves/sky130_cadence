* Extracted by Quantus, converted by sky130cad/quantus.py
*
*
*
*                       LINUX           Wed Nov 18 08:33:33 2026
*
*
*
*  PROGRAM  advgen
*
*  Name           : advgen - Quantus - (64-bit)
*  Version        : 25.1.0-p047
*  Build Date     : Thu Dec 11 23:20:30 PST 2025
*
*  HSPICE LIBRARY
*
*  OPERATING_TEMPERATURE 150
*  QRC_TECH_DIR <path>/tech
*
*
*

*
.SUBCKT sky130_fd_sc_hs__dlxtn_1 VPB VNB VGND VPWR Q D GATE_N
*
*
*  caps2d version: 10
*
*
*       TRANSISTOR CARDS
*
*
XM0 a_27_115##6 D#4 VGND#11 VNB sky130_fd_pr__nfet_01v8_lvt l=0.15 w=0.55 ad=0.15675 as=0.403175 pd=1.67 ps=3.14
XM6 VGND#11 GATE_N#1 a_217_419##12 VNB sky130_fd_pr__nfet_01v8_lvt l=0.15 w=0.74 ad=0.403175 as=0.2109 pd=3.14 ps=2.05
XM13 a_369_392##9 a_217_419# VGND#10 VNB sky130_fd_pr__nfet_01v8_lvt l=0.15 w=0.74 ad=0.2109 as=0.4698 pd=2.05 ps=2.87
XM7 VGND#10 a_27_115# a_655_79# VNB sky130_fd_pr__nfet_01v8_lvt l=0.15 w=0.64 ad=0.4698 as=0.1536 pd=2.87 ps=1.76
XM3 a_655_79# a_217_419##7 a_669_392##5 VNB sky130_fd_pr__nfet_01v8_lvt l=0.15 w=0.64 ad=0.1536 as=0.2786 pd=1.76 ps=2.52
XM2 a_669_392##5 a_369_392##3 a_871_139# VNB sky130_fd_pr__nfet_01v8_lvt l=0.15 w=0.42 ad=0.2786 as=0.1008 pd=2.52 ps=1.32
XM8 a_871_139# a_863_441# VGND#9 VNB sky130_fd_pr__nfet_01v8_lvt l=0.15 w=0.42 ad=0.1008 as=0.2349 pd=1.32 ps=2.1
XM10 VGND#9 a_669_392# a_863_441##8 VNB sky130_fd_pr__nfet_01v8_lvt l=0.15 w=0.64 ad=0.2349 as=0.1824 pd=2.1 ps=1.85
XM14 VGND#8 a_863_441##4 Q#3 VNB sky130_fd_pr__nfet_01v8_lvt l=0.15 w=0.74 ad=0.2109 as=0.2146 pd=2.05 ps=2.06
XM4 a_27_115##7 D#1 VPWR#11 VPB sky130_fd_pr__pfet_01v8 l=0.15 w=0.84 ad=0.2478 as=0.294 pd=2.27 ps=2.38
XM11 VPWR#11 GATE_N#3 a_217_419##13 VPB sky130_fd_pr__pfet_01v8 l=0.15 w=0.84 ad=0.294 as=0.3192 pd=2.38 ps=2.44
XM17 a_369_392##8 a_217_419##4 VPWR#10 VPB sky130_fd_pr__pfet_01v8 l=0.15 w=0.84 ad=0.2478 as=0.51025 pd=2.27 ps=3.23
XM12 VPWR#10 a_27_115##3 a_585_392# VPB sky130_fd_pr__pfet_01v8 l=0.15 w=1 ad=0.51025 as=0.27 pd=3.23 ps=2.54
XM15 a_585_392# a_369_392# a_669_392##7 VPB sky130_fd_pr__pfet_01v8 l=0.15 w=1 ad=0.27 as=0.5128 pd=2.54 ps=3.13
XM5 a_669_392##7 a_217_419##8 a_812_508# VPB sky130_fd_pr__pfet_01v8 l=0.15 w=0.42 ad=0.5128 as=0.1134 pd=3.13 ps=1.38
XM9 a_812_508# a_863_441##3 VPWR#9 VPB sky130_fd_pr__pfet_01v8 l=0.15 w=0.42 ad=0.1134 as=0.4441 pd=1.38 ps=3.3
XM1 VPWR#9 a_669_392##3 a_863_441##12 VPB sky130_fd_pr__pfet_01v8 l=0.15 w=1 ad=0.4441 as=0.295 pd=3.3 ps=2.59
XM16 VPWR#8 a_863_441##7 Q#1 VPB sky130_fd_pr__pfet_01v8 l=0.15 w=1.12 ad=0.3304 as=0.3304 pd=2.83 ps=2.83
*
*
*       RESISTOR AND CAP/DIODE CARDS
*
Rg1	D#1	D#2	585.423889
Rg2	D#2	D#3	29.612585
Rg3	D#2	D#4	322.719971
Rg4	GATE_N#1	GATE_N#2	351.130615
Rg5	GATE_N#2	GATE_N#3	398.127228
Rg6	a_217_419#	a_217_419##2	343.856415
Rg7	a_217_419##2	a_217_419##3	104.359573
Rg8	a_217_419##2	a_217_419##4	394.604614
Rg9	a_27_115#	a_27_115##2	407.088776
Rg10	a_27_115##2	a_27_115##3	514.966736
Rg11	a_369_392#	a_369_392##2	560.440308
Rg12	a_217_419##5	a_217_419##6	33.582527
Rg13	a_217_419##6	a_217_419##7	501.535065
Rg14	a_217_419##6	a_217_419##8	478.409821
Rg15	a_369_392##3	a_369_392##4	216.119781
Rg16	a_863_441#	a_863_441##2	683.065796
Rg17	a_863_441##2	a_863_441##3	245.247192
Rg18	a_669_392#	a_669_392##2	325.153564
Rg19	a_669_392##2	a_669_392##3	472.853699
Rg20	a_863_441##4	a_863_441##5	423.145813
Rg21	a_863_441##5	a_863_441##6	240.047852
Rg22	a_863_441##5	a_863_441##7	526.145996
Rf1	D	D#3	164.366364
Rf2	GATE_N	GATE_N#2	163.775864
Rf3	a_27_115##2	a_27_115##5	392.338440
Rf4	a_27_115##5	a_27_115##6	29.502554
Rf5	a_27_115##5	a_27_115##7	115.807121
Rf6	a_217_419##5	a_217_419##10	459.622559
Rf7	a_217_419##10	a_217_419##3	49.927326
Rf8	a_217_419##3	a_217_419##12	28.809029
Rf9	a_217_419##10	a_217_419##13	11.758680
Rf10	a_369_392##4	a_369_392##2	268.812347
Rf11	a_369_392##2	a_369_392##7	78.220314
Rf12	a_369_392##7	a_369_392##8	29.791061
Rf13	a_369_392##7	a_369_392##9	64.112381
Rf14	a_669_392##2	a_669_392##6	242.710403
Rf15	a_669_392##6	a_669_392##7	107.821854
Rf16	a_669_392##5	a_669_392##6	15.000000
Rf17	a_863_441##8	a_863_441##6	40.559998
Rf18	a_863_441##6	a_863_441##10	37.151623
Rf19	a_863_441##10	a_863_441##2	191.880219
Rf20	a_863_441##10	a_863_441##12	13.893780
Rf21	Q	Q#2	0.194040
Rf22	Q#2	Q	14.164948
Rf23	Q	Q#3	16.552322
Rf24	Q#1	Q#2	5.000000
Rf26	VGND#2	VGND#3	72.385628
Rf27	VGND#3	VGND#4	118.009369
Rf28	VGND#4	VGND#5	27.734655
Rf29	VGND#5	VGND#6	159.931519
Rf31	VGND#2	VGND#8	41.038895
Rf32	VGND#3	VGND#9	43.852844
Rf33	VGND#5	VGND#10	32.322075
Rf34	VGND#6	VGND#11	24.468842
Rf36	VPWR#2	VPWR#3	86.386154
Rf37	VPWR#3	VPWR#4	102.789696
Rf38	VPWR#4	VPWR#5	60.416367
Rf39	VPWR#5	VPWR#6	127.598289
Rf41	VPWR#2	VPWR#8	48.259808
Rf42	VPWR#3	VPWR#9	18.560368
Rf43	VPWR#5	VPWR#10	26.340607
Rf44	VPWR#6	VPWR#11	36.258804
Re1	VPWR#4	VPWR	0.701577
Re2	VGND	VGND#4	0.701602
*
*       CAPACITOR CARDS
*
*
C1	a_369_392##2	a_217_419##6	3.45144e-17
C2	a_27_115##5	VPWR#11	1.76694e-18
C3	a_669_392##5	a_217_419##6	1.07447e-17
C4	VPWR#3	a_863_441##7	8.51869e-19
C5	a_27_115##5	a_27_115##7	2.22736e-19
C6	a_669_392##5	a_669_392##7	1.49339e-21
C7	VPWR#3	a_669_392##3	1.93271e-17
C8	a_27_115##2	a_217_419##6	1.82367e-18
C9	VPWR#3	a_863_441##3	2.3995e-17
C10	VPWR#3	a_217_419##8	6.44549e-18
C11	a_863_441##4	Q#3	7.84931e-18
C12	a_863_441##4	VGND#8	2.01832e-17
C13	VPWR#3	a_369_392#	2.42246e-19
C14	a_863_441##8	a_863_441##4	1.21746e-18
C15	VGND#8	a_669_392#	2.98314e-18
C16	VGND#9	a_863_441##4	8.43923e-19
C17	VPWR#5	a_27_115##3	4.73264e-18
C18	a_863_441##8	a_669_392#	4.25658e-17
C19	a_863_441##10	a_863_441##7	3.49162e-18
C20	a_27_115##5	a_27_115#	1.00625e-19
C21	VPWR#3	a_27_115##3	6.41037e-20
C22	a_669_392#	VGND#9	2.08698e-17
C23	a_863_441##8	a_863_441#	7.9713e-19
C24	a_217_419##12	a_217_419##13	4.98232e-18
C25	VPWR#5	a_217_419##4	5.66854e-18
C26	a_863_441##10	a_669_392##3	5.37223e-17
C27	a_27_115##5	a_217_419#	1.42619e-18
C28	a_863_441#	VGND#9	1.60443e-17
C29	a_669_392##5	a_669_392#	4.74736e-19
C30	a_27_115##5	GATE_N#1	3.32681e-17
C31	a_863_441##10	a_863_441##3	6.02015e-19
C32	VGND#9	a_369_392##3	5.42916e-19
C33	a_669_392##5	a_863_441#	1.38759e-17
C34	VGND#5	a_27_115##5	7.76242e-18
C35	a_863_441##10	a_217_419##6	2.52209e-19
C36	a_27_115##5	D#4	1.54482e-17
C37	VGND#9	a_217_419##7	2.99643e-19
C38	a_863_441##10	a_217_419##8	1.82548e-19
C39	a_669_392##5	a_369_392##3	3.97342e-17
C40	a_27_115##6	a_27_115##7	1.8835e-18
C41	VGND#9	a_27_115#	1.37632e-19
C42	a_669_392##5	a_217_419##7	3.63791e-17
C43	a_669_392##5	a_27_115#	1.10991e-18
C44	VGND#10	a_217_419##7	1.6262e-18
C45	a_369_392##8	a_669_392##7	6.98413e-18
C46	VPWR#4	VPWR#5	5.35252e-17
C47	a_217_419##13	a_669_392##7	2.46815e-17
C48	VGND#10	a_27_115#	5.33841e-17
C49	VPWR#4	VPWR#3	6.05554e-17
C50	a_217_419#	VGND#10	4.86859e-18
C51	a_369_392##7	a_27_115##3	6.71016e-18
C52	a_217_419##13	VPWR#10	7.56227e-17
C53	a_369_392##9	a_217_419#	2.97223e-17
C54	a_217_419##13	a_369_392##8	9.406e-17
C55	VPWR#11	VPWR#10	1.46256e-18
C56	a_369_392##7	a_217_419##4	5.66803e-18
C57	a_369_392##9	GATE_N#1	1.03962e-18
C58	a_217_419##12	GATE_N#1	2.69964e-17
C59	VGND#3	VGND#8	1.46107e-18
C60	VPWR#11	a_217_419##13	6.74381e-17
C61	VGND#4	VGND#5	5.34338e-17
C62	GATE_N#1	VGND#11	8.45775e-18
C63	a_217_419##12	D#4	1.51759e-18
C64	VGND#4	VGND#3	5.33329e-17
C65	a_27_115##6	GATE_N#1	1.03243e-18
C66	a_27_115##7	a_217_419##13	3.00793e-18
C67	VPWR#3	a_669_392##2	5.07165e-19
C68	D#4	VGND#11	1.30333e-17
C69	VGND#3	a_863_441##8	6.65589e-18
C70	VPWR#8	a_863_441##5	2.25173e-18
C71	a_27_115##7	VPWR#11	9.94945e-17
C72	a_27_115##6	D#4	2.77135e-17
C73	a_669_392##7	a_217_419##7	3.30337e-18
C74	a_863_441##2	VPWR#3	5.88088e-17
C75	VGND#3	a_669_392##2	7.29238e-19
C76	a_863_441##7	Q#1	1.206e-17
C77	a_863_441##6	a_863_441##10	2.62903e-18
C78	a_669_392#	a_863_441##4	5.13585e-18
C79	VGND#3	a_863_441##2	1.13875e-19
C80	a_863_441##7	VPWR#8	2.59635e-17
C81	a_217_419##5	VPWR#3	5.1369e-17
C82	VGND#3	a_669_392##5	4.15091e-18
C83	a_217_419##13	a_27_115#	5.0451e-19
C84	VPWR#8	a_669_392##3	2.68031e-18
C85	a_669_392##2	a_863_441##10	1.95065e-17
C86	a_863_441#	a_669_392#	1.81671e-17
C87	VGND#3	a_369_392##4	2.40941e-17
C88	a_669_392##3	a_863_441##12	3.41057e-17
C89	VPWR#8	a_863_441##3	1.7133e-19
C90	a_669_392##3	VPWR#9	7.9613e-18
C91	a_863_441##10	a_863_441##2	2.37853e-19
C92	a_369_392#	a_217_419##6	4.98734e-18
C93	a_369_392##3	a_863_441#	3.51938e-17
C94	a_863_441##3	VPWR#9	1.29842e-17
C95	a_217_419##7	a_863_441#	5.15956e-19
C96	VGND#5	a_369_392##2	7.78941e-19
C97	a_217_419##7	a_369_392##3	1.53964e-17
C98	VPWR#5	a_217_419##3	1.72107e-19
C99	a_217_419##5	a_863_441##10	3.51975e-18
C100	a_217_419##8	a_669_392##7	1.8757e-17
C101	VGND#5	a_27_115##2	4.83593e-17
C102	VPWR#10	a_863_441##3	5.70819e-20
C103	a_27_115#	a_217_419##7	5.08842e-17
C104	a_669_392##7	a_369_392#	5.16088e-17
C105	a_863_441##6	VGND#8	2.02085e-17
C106	VPWR#10	a_217_419##8	1.54918e-19
C107	a_863_441##6	a_863_441##8	1.25949e-19
C108	VPWR#3	VPWR#8	2.31353e-18
C109	VGND#5	a_217_419##3	1.88048e-19
C110	a_669_392##7	a_27_115##3	4.22845e-18
C111	VGND#9	a_863_441##6	1.55947e-18
C112	VPWR#10	a_369_392#	4.77166e-19
C113	a_217_419#	a_27_115#	7.54801e-18
C114	a_217_419##13	a_217_419##8	3.54283e-19
C115	a_369_392##8	a_369_392#	6.95361e-19
C116	a_669_392##7	a_217_419##4	1.17573e-18
C117	a_369_392##7	a_369_392##2	2.13402e-18
C118	a_27_115##3	VPWR#10	3.56703e-17
C119	a_669_392##2	VGND#9	4.44515e-17
C120	a_217_419##13	a_369_392#	1.98885e-17
C121	GATE_N#1	a_217_419#	1.47526e-18
C122	a_669_392##7	a_217_419##6	1.29169e-17
C123	a_369_392##8	a_27_115##3	2.32864e-18
C124	a_217_419##4	VPWR#10	3.37951e-17
C125	a_669_392##5	a_669_392##2	9.19778e-18
C126	a_217_419##13	a_27_115##3	3.65266e-17
C127	a_27_115##2	a_369_392##7	5.24507e-17
C128	a_369_392##8	a_217_419##4	5.35441e-17
C129	VGND#8	a_369_392##4	2.32139e-19
C130	VPWR#11	a_27_115##3	5.8594e-19
C131	VPWR#10	GATE_N#3	1.33466e-18
C132	D#4	GATE_N#1	1.73501e-17
C133	a_217_419##13	a_217_419##4	1.54065e-17
C134	VPWR#3	VPWR#9	9.16282e-18
C135	a_863_441##8	a_369_392##4	2.23319e-19
C136	a_669_392##5	a_863_441##2	5.38759e-18
C137	a_369_392##8	GATE_N#3	7.28092e-19
C138	a_369_392##4	VGND#9	1.58234e-17
C139	VPWR#11	a_217_419##4	5.13524e-19
C140	a_369_392##7	a_217_419##3	5.48907e-17
C141	GATE_N#3	a_217_419##13	1.85693e-17
C142	a_27_115##7	a_217_419##4	1.00138e-19
C143	a_369_392##4	a_669_392##5	6.05524e-17
C144	a_27_115##5	a_27_115##2	1.43754e-18
C145	VPWR#11	GATE_N#3	5.53785e-17
C146	a_863_441##6	VPWR#8	2.10382e-17
C147	a_217_419##13	D#1	4.88896e-19
C148	a_27_115##7	GATE_N#3	2.27859e-18
C149	VGND#10	a_369_392##4	5.02463e-17
C150	VPWR#11	D#1	2.09529e-17
C151	a_669_392##5	a_217_419##5	2.49475e-17
C152	a_27_115##5	a_217_419##3	4.62855e-17
C153	a_27_115##7	D#1	5.00935e-17
C154	a_217_419##13	VPWR#4	2.37241e-17
C155	a_369_392##2	a_669_392##5	6.23319e-17
C156	a_27_115##5	GATE_N#2	1.32567e-17
C157	a_669_392##3	a_863_441##7	6.57991e-18
C158	VGND#10	a_369_392##2	2.45509e-17
C159	a_863_441##2	VPWR#9	6.87809e-18
C160	a_669_392##5	a_27_115##2	1.23806e-19
C161	a_27_115##5	D#3	6.98523e-18
C162	a_863_441##3	a_669_392##3	7.75999e-18
C163	a_27_115##2	VGND#10	1.10141e-16
C164	a_27_115##2	a_369_392##9	8.73835e-17
C165	a_369_392##4	a_669_392##7	1.78978e-18
C166	a_217_419##8	a_863_441##3	2.58177e-17
C167	a_863_441##6	a_863_441##4	9.71344e-19
C168	a_369_392##9	a_217_419##3	7.10756e-17
C169	VPWR#4	a_217_419##7	5.69813e-20
C170	a_863_441##6	a_669_392#	3.17399e-18
C171	a_217_419##5	a_669_392##7	1.47445e-16
C172	a_369_392##8	a_217_419##6	7.50175e-20
C173	a_669_392##2	a_863_441##4	2.34541e-21
C174	VPWR#4	a_27_115#	3.92675e-20
C175	a_863_441##6	a_863_441#	3.20259e-19
C176	VGND#4	a_217_419##7	4.32493e-18
C177	a_369_392#	a_217_419##8	1.32978e-17
C178	a_669_392##2	a_669_392#	1.0375e-19
C179	a_369_392##2	a_669_392##7	6.1994e-17
C180	VGND#4	a_27_115#	1.02899e-18
C181	VPWR#3	a_217_419##6	3.59332e-19
C182	GATE_N#2	a_217_419##12	2.19634e-17
C183	a_669_392##2	a_863_441#	3.92114e-17
C184	GATE_N#2	VGND#11	8.05417e-20
C185	a_217_419##13	a_217_419##5	1.56568e-18
C186	a_863_441##10	VPWR#8	1.05197e-16
C187	a_669_392##2	a_369_392##3	3.54228e-18
C188	a_27_115##3	a_369_392#	5.16674e-17
C189	a_217_419##13	VPWR#5	1.90351e-17
C190	a_369_392##4	a_863_441##4	5.61356e-19
C191	a_669_392##2	a_217_419##7	1.11792e-18
C192	a_217_419##12	D#3	1.59044e-18
C193	a_369_392##4	a_669_392#	4.37759e-18
C194	a_369_392##3	a_863_441##2	3.83697e-18
C195	a_369_392##2	a_217_419##13	1.08123e-17
C196	VPWR#4	a_217_419##6	2.80782e-20
C197	VPWR#10	a_27_115##2	2.29405e-19
C198	a_369_392##4	a_863_441#	1.09287e-17
C199	D#3	a_27_115##6	6.47681e-18
C200	a_217_419##4	a_27_115##3	2.19713e-17
C201	a_863_441##10	a_863_441##12	2.70388e-18
C202	a_369_392##4	a_369_392##3	7.22459e-19
C203	a_217_419##13	a_27_115##2	1.018e-18
C204	a_863_441##8	VGND#8	5.6471e-17
C205	VPWR#10	a_217_419##3	3.19646e-19
C206	GATE_N#3	a_27_115##3	3.55592e-19
C207	a_217_419##5	a_863_441#	1.10154e-18
C208	a_369_392##4	a_217_419##7	3.94881e-17
C209	a_369_392##8	a_217_419##3	5.32676e-18
C210	a_217_419##5	a_369_392##3	4.5543e-18
C211	a_369_392##4	a_27_115#	8.63184e-18
C212	GATE_N#3	a_217_419##4	4.04939e-18
C213	a_863_441##6	a_863_441##7	1.77284e-18
C214	a_217_419##13	a_217_419##3	8.89965e-18
C215	VPWR#4	a_217_419##8	1.78843e-18
C216	a_217_419##5	a_217_419##7	1.62839e-19
C217	a_217_419#	a_369_392##4	3.39067e-19
C218	a_863_441##10	VPWR#9	4.50245e-19
C219	VGND#9	VGND#8	3.4731e-18
C220	a_369_392##8	GATE_N#2	5.24024e-20
C221	a_669_392##2	a_863_441##7	7.84121e-19
C222	VPWR#4	a_369_392#	4.41812e-18
C223	Q	a_863_441##5	2.1076e-17
C224	GATE_N#2	a_217_419##13	3.05579e-17
C225	a_369_392##2	a_217_419##7	5.83659e-18
C226	D#1	GATE_N#3	3.16299e-17
C227	a_27_115##5	a_369_392##9	4.98707e-18
C228	GATE_N#2	VPWR#11	7.52436e-18
C229	a_27_115#	a_369_392##2	2.39598e-17
C230	VGND#4	a_217_419##6	6.26595e-20
C231	a_27_115##7	GATE_N#2	3.47842e-17
C232	a_863_441##2	a_669_392##3	2.20381e-17
C233	VGND#9	a_863_441##8	5.44416e-17
C234	a_27_115##2	a_217_419##7	9.64821e-19
C235	a_369_392##2	a_217_419#	8.12499e-20
C236	a_27_115##2	a_27_115#	1.10163e-18
C237	a_27_115##5	a_217_419##12	4.33772e-17
C238	a_27_115##7	D#3	1.70749e-17
C239	a_27_115##2	a_217_419#	3.35585e-17
C240	a_669_392##5	a_871_139#	2.32129e-18
C241	a_217_419##8	a_863_441##2	1.45965e-17
C242	a_217_419##5	a_863_441##7	2.16377e-19
C243	a_27_115##2	GATE_N#1	2.4912e-19
C244	a_217_419##5	a_669_392##3	2.50513e-19
C245	a_217_419##3	a_217_419#	1.4003e-17
C246	a_217_419##5	a_863_441##3	9.57463e-18
C247	GATE_N#1	a_217_419##3	2.14809e-17
C248	a_27_115##5	VGND#11	9.66529e-18
C249	a_217_419##5	a_217_419##8	2.25767e-17
C250	a_863_441##6	a_863_441##5	8.24979e-19
C251	VPWR	a_217_419##6	8.9273e-19
C252	a_217_419##3	D#4	1.24032e-19
C253	a_217_419##5	a_369_392#	7.95755e-18
C254	a_863_441##6	a_217_419##6	4.23328e-19
C255	a_217_419##13	a_585_392#	1.48499e-18
C256	a_217_419##5	a_27_115##3	1.23121e-19
C257	a_369_392##2	a_369_392#	6.29885e-18
C258	D#3	GATE_N#1	5.42217e-18
C259	a_27_115##6	a_27_115##5	2.86291e-18
C260	VGND#4	a_863_441##6	7.00081e-20
C261	a_369_392##2	a_27_115##3	2.3165e-17
C262	a_669_392##5	VGND#9	2.69664e-17
C263	a_669_392##2	a_863_441##6	8.63651e-17
C264	a_217_419##3	a_27_115##3	3.37886e-18
C265	a_863_441##6	a_863_441##2	2.4228e-19
C266	VGND#4	a_369_392##4	6.55469e-17
C267	a_217_419##5	VPWR#4	4.37629e-17
C268	VGND	a_863_441##5	1.06187e-18
C269	VGND	a_217_419##6	5.93932e-19
C270	a_669_392##2	a_863_441##5	5.87258e-19
C271	a_669_392##2	a_863_441##2	4.29545e-17
C272	VGND#8	a_863_441##5	2.78914e-18
C273	VPWR#4	a_369_392##2	2.77928e-20
C274	a_669_392##2	a_217_419##6	5.39289e-18
C275	GATE_N#2	a_217_419##4	7.93428e-19
C276	a_863_441#	a_871_139#	7.47523e-18
C277	a_217_419##5	a_863_441##6	2.0627e-18
C278	VGND#4	a_369_392##2	3.4668e-19
C279	a_369_392##3	a_871_139#	6.42628e-18
C280	a_217_419##5	a_669_392##2	2.05164e-17
C281	D#1	GATE_N#2	5.00181e-18
C282	a_217_419##8	a_812_508#	7.28011e-18
C283	a_217_419##5	a_863_441##2	5.5292e-17
C284	a_863_441##10	VPWR#3	5.89741e-17
C285	VPWR#3	a_369_392##3	3.26353e-20
C286	VGND#3	a_863_441##4	7.96256e-19
C287	a_217_419##5	a_369_392##4	4.40961e-19
C288	a_369_392#	a_585_392#	1.328e-17
C289	a_369_392##4	a_369_392##2	1.18022e-18
C290	a_27_115##3	a_585_392#	2.24869e-17
C291	a_217_419##7	a_655_79#	8.7769e-18
C292	a_217_419##5	a_369_392##2	3.2367e-19
C293	a_27_115##2	a_369_392##4	1.65429e-20
C294	D	a_27_115##5	3.08552e-17
C295	a_27_115#	a_655_79#	1.84386e-18
C296	a_863_441##5	VNB	3.81228e-17
C297	a_217_419##6	VNB	6.29175e-17
C298	a_669_392#	a_863_441##5	2.88358e-20
C299	VGND#3	a_669_392#	4.24917e-18
C300	a_27_115##2	a_369_392##2	6.34965e-17
C301	VPWR	VPWR#5	2.90842e-17
C302	a_217_419##6	a_863_441##2	2.69918e-17
C303	VPWR	VPWR#3	6.90025e-17
C304	a_369_392##2	a_217_419##3	2.07159e-19
C305	a_217_419##3	a_27_115##2	3.60624e-17
C306	Q	Q#3	3.88838e-18
C307	a_27_115##6	D	2.87902e-17
C308	VPWR	a_863_441##10	1.98194e-17
C309	VGND#8	Q	7.03548e-17
C310	VPWR	a_369_392##7	3.45085e-18
C311	GATE_N#2	a_217_419##3	5.1381e-17
C312	VGND#3	a_863_441#	2.12494e-18
C313	a_217_419##3	D#3	4.04389e-19
C314	VGND	VGND#5	2.99779e-17
C315	D#3	GATE_N#2	1.97139e-17
C316	VGND	VGND#3	5.06846e-17
C317	Q	Q#1	5.94628e-18
C318	VPWR#8	Q	8.91357e-17
C319	D	a_27_115##7	3.32806e-17
C320	VGND#8	VPWR#8	6.53442e-18
C321	a_217_419##13	a_369_392##7	2.38003e-17
C322	VGND	a_863_441##10	1.59938e-18
C323	VGND	a_369_392##7	1.21425e-18
C324	a_369_392##4	a_217_419##6	2.13234e-18
C325	VGND	a_27_115##5	3.50342e-17
C326	VPWR#5	VNB	4.17385e-17
C327	D	GATE_N#1	4.41296e-19
C328	VPWR#3	VNB	4.83227e-17
C329	Q	a_863_441##4	2.63034e-17
C330	a_369_392##4	a_655_79#	6.24591e-18
C331	a_217_419##6	a_863_441#	8.50872e-18
C332	Q	a_669_392#	4.59621e-19
C333	VGND	a_863_441##8	1.82153e-17
C334	VGND#5	VNB	4.29841e-17
C335	VPWR	a_669_392##7	1.04802e-17
C336	VGND#3	VNB	4.45503e-17
C337	VGND	a_669_392##5	1.78433e-17
C338	a_369_392##2	a_655_79#	5.66301e-18
C339	VPWR	VPWR#10	2.09562e-17
C340	VPWR	a_369_392##8	5.17763e-18
C341	VGND	VGND#10	1.78622e-17
C342	VPWR	a_217_419##13	5.64534e-17
C343	a_863_441##10	VNB	1.66812e-17
C344	VGND	a_369_392##9	7.30438e-18
C345	VGND	a_217_419##12	2.77646e-18
C346	VPWR	VPWR#11	1.98126e-17
C347	VPWR	a_27_115##7	1.84693e-17
C348	a_369_392##7	VNB	6.26083e-18
C349	VGND	a_27_115##6	1.2587e-17
C350	VGND	VPWR#8	2.95211e-18
C351	Q	a_863_441##7	3.65924e-17
C352	VPWR	a_369_392##3	1.11321e-20
C353	a_27_115##5	VNB	1.95735e-17
C354	Q	a_669_392##3	1.38271e-19
C355	VGND#8	VNB	1.0513e-17
C356	a_863_441##8	VNB	1.1413e-17
C357	VGND	a_369_392##8	7.05187e-19
C358	VGND#9	VNB	6.88298e-18
C359	a_669_392##5	VNB	1.57752e-18
C360	VGND	a_27_115##7	2.89756e-18
C361	VGND#10	VNB	1.54385e-18
C362	VGND	a_863_441##4	5.3108e-18
C363	VPWR	a_863_441##7	5.84627e-18
C364	a_369_392##9	VNB	4.12159e-19
C365	VGND	a_669_392#	7.45161e-18
C366	a_217_419##12	VNB	3.15566e-18
C367	VPWR	a_669_392##3	5.93202e-19
C368	VGND	a_863_441#	9.12537e-18
C369	VPWR	a_863_441##3	2.0428e-18
C370	a_27_115##6	VNB	2.79078e-17
C371	VGND	a_369_392##3	1.64322e-19
C372	VPWR	a_217_419##8	1.10326e-18
C373	VGND	a_217_419##7	2.95637e-18
C374	VPWR#8	VNB	1.1223e-17
C375	VGND	a_27_115#	3.9495e-18
C376	VPWR	a_369_392#	1.42919e-18
C377	VGND	a_217_419#	5.9844e-18
C378	VGND#5	a_27_115#	8.33158e-19
C379	a_217_419##5	a_863_441##5	6.16234e-20
C380	VGND	GATE_N#1	2.64125e-18
C381	a_669_392##7	VNB	1.41853e-18
C382	VPWR	a_217_419##4	6.94036e-18
C383	VGND	D#4	7.73441e-18
C384	a_863_441##6	Q	2.14809e-17
C385	VPWR#10	VNB	8.66285e-18
C386	VPWR	GATE_N#3	4.0811e-18
C387	a_369_392##8	VNB	2.06082e-18
C388	Q	a_669_392##2	5.25951e-19
C389	VPWR	D#1	7.78729e-18
C390	a_217_419##13	VNB	3.18359e-17
C391	VPWR#11	VNB	6.55846e-18
C392	a_27_115##7	VNB	5.83137e-17
C393	a_863_441##4	VNB	3.40548e-17
C394	VPWR	VPWR#4	1.73256e-17
C395	a_217_419##5	a_217_419##6	2.64171e-17
C396	a_669_392#	VNB	3.76314e-17
C397	a_863_441#	VNB	4.60958e-17
C398	a_369_392##3	VNB	2.03995e-17
C399	VPWR	a_863_441##6	2.50243e-18
C400	D	GATE_N#2	4.83973e-19
C401	a_217_419##7	VNB	3.85383e-17
C402	a_27_115#	VNB	4.30103e-17
C403	VPWR	a_669_392##2	5.72608e-18
C404	D	D#3	2.26617e-17
C405	a_217_419#	VNB	3.61562e-17
C406	VPWR	a_863_441##2	5.60144e-18
C407	GATE_N#1	VNB	3.00082e-17
C408	D#4	VNB	3.96462e-17
C409	a_369_392##3	a_217_419##6	1.14063e-17
C410	a_863_441##7	VNB	4.48615e-17
C411	VPWR	a_217_419##5	2.97472e-17
C412	a_669_392##3	VNB	4.32354e-17
C413	VGND	VGND#4	1.65611e-17
C414	VPWR	a_369_392##2	5.24063e-18
C415	a_863_441##3	VNB	2.5711e-17
C416	a_27_115##5	a_369_392##8	1.13969e-18
C417	VGND	a_863_441##6	4.94155e-18
C418	a_217_419##8	VNB	3.57098e-17
C419	VPWR	a_27_115##2	2.73194e-18
C420	a_369_392#	VNB	3.24576e-17
C421	VGND	a_669_392##2	3.89843e-18
C422	a_27_115##3	VNB	3.88153e-17
C423	VGND	a_863_441##2	2.60404e-19
C424	a_217_419##4	VNB	4.81583e-17
C425	VGND	a_369_392##4	4.41225e-17
C426	VPWR	GATE_N#2	3.30411e-18
C427	GATE_N#3	VNB	3.84913e-17
C428	D#1	VNB	5.37259e-17
C429	VGND	a_217_419##5	2.94209e-18
C430	VPWR	D#3	6.58727e-19
C431	VGND	a_369_392##2	4.0152e-18
C432	VPWR#4	VNB	2.96177e-16
C433	VGND	a_27_115##2	2.5234e-17
C434	VGND#4	VNB	2.94914e-16
C435	a_863_441##6	VNB	5.4913e-17
C436	VGND	a_217_419##3	9.48622e-18
C437	a_669_392##2	VNB	3.71342e-17
C438	VGND#5	a_217_419#	4.41432e-18
C439	VGND	GATE_N#2	3.29855e-18
C440	a_863_441##2	VNB	6.15485e-17
C441	VGND	D#3	5.93126e-19
C442	a_369_392##4	VNB	4.53926e-17
C443	a_217_419##5	VNB	6.97147e-18
C444	a_369_392##2	VNB	3.36558e-17
C445	a_27_115##2	VNB	4.80207e-17
C446	a_217_419##3	VNB	1.28282e-16
C447	GATE_N#2	VNB	5.06235e-17
C448	D#3	VNB	7.25881e-17
C449	VPWR	D	3.37833e-18
C450	VPWR	Q	2.067e-17
C451	VGND	D	4.10137e-18
C452	VGND	Q	2.06507e-17
C453	D	VNB	2.32747e-17
C454	Q	VNB	1.12447e-16
C455	VPWR	VNB	8.42899e-17
C456	VGND	VNB	8.65215e-17
C457	a_217_419##13	VPWR#6	2.45631e-17
C458	VGND	VGND#2	4.83553e-17
C459	VGND#6	a_217_419##3	1.04783e-18
C460	VPWR#4	VPWR#2	5.47358e-17
C461	VGND#6	D#4	8.21367e-18
C462	VGND#6	a_27_115##6	1.17822e-17
C463	VGND#2	a_863_441##6	4.62635e-19
C464	a_27_115##7	VPWR#6	1.91372e-17
C465	Q	VPWR#2	2.1107e-17
C466	VGND#6	GATE_N#2	3.27552e-19
C467	VGND	VGND#6	5.73332e-17
C468	VGND#2	VNB	5.09852e-17
C469	VGND#6	a_27_115##5	1.23226e-16
C470	a_863_441##6	VPWR#2	3.75925e-19
C471	VPWR	VPWR#2	4.85317e-17
C472	VGND#2	a_863_441##8	7.22741e-18
C473	a_863_441##10	VPWR#2	1.13936e-17
C474	VPWR#6	VPWR#5	5.7796e-20
C475	VGND#6	D#3	5.48224e-19
C476	VPWR#6	a_217_419##3	7.67552e-20
C477	VGND#6	VNB	8.16518e-17
C478	D	VPWR#6	2.99681e-19
C479	GATE_N#2	VPWR#6	5.77203e-19
C480	VPWR#6	GATE_N#3	3.95103e-18
C481	VGND#2	Q	2.11455e-17
C482	VGND#4	VGND#6	7.97309e-17
C483	VPWR#6	D#3	5.57974e-19
C484	VPWR#6	D#1	3.46225e-18
C485	VPWR#2	VNB	4.97107e-17
C486	VPWR	VPWR#6	4.51119e-17
C487	VGND#6	D	7.82933e-19
C488	VGND#6	a_217_419#	6.27871e-19
C489	VPWR#2	a_863_441##7	8.12003e-18
C490	VGND#2	a_863_441##4	8.50056e-18
C491	VPWR#4	VPWR#6	7.0023e-17
C492	VPWR#6	VNB	6.17606e-17
C493	VPWR#3	VPWR#2	7.73697e-19
C494	VPWR#6	VPWR#10	2.75643e-19
C495	VPWR#2	a_669_392##3	8.55497e-19
C496	VGND#2	a_369_392##4	1.69338e-19
C497	VGND#6	GATE_N#1	5.63803e-18
C498	VGND#4	VGND#2	5.40633e-17
C499	VGND#6	VGND#11	6.4744e-18
C500	VGND#3	VGND#2	1.16305e-18
C501	VPWR#2	a_863_441##3	4.74701e-20
*
*
.ENDS sky130_fd_sc_hs__dlxtn_1
*
