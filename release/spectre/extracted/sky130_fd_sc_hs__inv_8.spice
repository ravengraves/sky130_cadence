* Extracted by Quantus, converted by sky130cad/quantus.py
*
*
*
*                       LINUX           Wed Nov 18 08:42:09 2026
*
*
*
*  PROGRAM  advgen
*
*  Name           : advgen - Quantus - (64-bit)
*  Version        : 25.1.0-p047
*  Build Date     : Thu Dec 11 23:20:30 PST 2025
*
*  HSPICE LIBRARY
*
*  OPERATING_TEMPERATURE 150
*  QRC_TECH_DIR <path>/tech
*
*
*

*
.SUBCKT sky130_fd_sc_hs__inv_8 VPB VNB VGND VPWR Y A
*
*
*  caps2d version: 10
*
*
*       TRANSISTOR CARDS
*
*
XM4 VGND#6 A#25 Y#5 VNB sky130_fd_pr__nfet_01v8_lvt l=0.15 w=0.74 ad=0.2109 as=0.2072 pd=2.05 ps=2.04
XM1 Y#5 A#23 VGND#8 VNB sky130_fd_pr__nfet_01v8_lvt l=0.15 w=0.74 ad=0.2072 as=0.2072 pd=2.04 ps=2.04
XM2 Y#11 A#21 VGND#8 VNB sky130_fd_pr__nfet_01v8_lvt l=0.15 w=0.74 ad=0.2072 as=0.2072 pd=2.04 ps=2.04
XM7 VGND#7 A#20 Y#11 VNB sky130_fd_pr__nfet_01v8_lvt l=0.15 w=0.74 ad=0.259 as=0.2072 pd=2.18 ps=2.04
XM8 Y#8 A#17 VGND#7 VNB sky130_fd_pr__nfet_01v8_lvt l=0.15 w=0.74 ad=0.2072 as=0.259 pd=2.04 ps=2.18
XM11 VGND#4 A#15 Y#8 VNB sky130_fd_pr__nfet_01v8_lvt l=0.15 w=0.74 ad=0.3108 as=0.2072 pd=2.32 ps=2.04
XM12 VGND#4 A#13 Y#10 VNB sky130_fd_pr__nfet_01v8_lvt l=0.15 w=0.74 ad=0.3108 as=0.2072 pd=2.32 ps=2.04
XM14 Y#10 A#12 VGND#1 VNB sky130_fd_pr__nfet_01v8_lvt l=0.15 w=0.74 ad=0.2072 as=0.2146 pd=2.04 ps=2.06
XM0 VPWR#5 A#11 Y#7 VPB sky130_fd_pr__pfet_01v8 l=0.15 w=1.12 ad=0.3304 as=0.336 pd=2.83 ps=2.84
XM6 Y#7 A#24 VPWR#8 VPB sky130_fd_pr__pfet_01v8 l=0.15 w=1.12 ad=0.336 as=0.392 pd=2.84 ps=2.94
XM9 Y#12 A#22 VPWR#8 VPB sky130_fd_pr__pfet_01v8 l=0.15 w=1.12 ad=0.336 as=0.392 pd=2.84 ps=2.94
XM3 Y#12 A#19 VPWR#7 VPB sky130_fd_pr__pfet_01v8 l=0.15 w=1.12 ad=0.336 as=0.336 pd=2.84 ps=2.84
XM5 Y#1 A#18 VPWR#7 VPB sky130_fd_pr__pfet_01v8 l=0.15 w=1.12 ad=0.336 as=0.336 pd=2.84 ps=2.84
XM10 VPWR#6 A#16 Y#1 VPB sky130_fd_pr__pfet_01v8 l=0.15 w=1.12 ad=0.392 as=0.336 pd=2.94 ps=2.84
XM13 VPWR#6 A#14 Y#13 VPB sky130_fd_pr__pfet_01v8 l=0.15 w=1.12 ad=0.392 as=0.336 pd=2.94 ps=2.84
XM15 VPWR#1 A#1 Y#13 VPB sky130_fd_pr__pfet_01v8 l=0.15 w=1.12 ad=0.3864 as=0.336 pd=2.93 ps=2.84
*
*
*       RESISTOR AND CAP/DIODE CARDS
*
Rg1	A#1	A#2	450.639984
Rg2	A#2	A#3	65.056755
Rg3	A#3	A#4	92.875465
Rg4	A#4	A#5	77.023613
Rg5	A#5	A#6	70.308174
Rg6	A#6	A#7	25.883810
Rg7	A#7	A#8	65.427719
Rg8	A#8	A#9	120.843338
Rg9	A#9	A#10	72.630096
Rg10	A#10	A#11	478.310150
Rg11	A#2	A#12	399.275177
Rg12	A#3	A#13	415.274414
Rg13	A#3	A#14	429.620972
Rg14	A#4	A#15	469.786224
Rg15	A#4	A#16	484.132751
Rg16	A#5	A#17	442.592041
Rg17	A#5	A#18	456.938599
Rg18	A#6	A#19	402.474609
Rg19	A#7	A#20	396.201660
Rg20	A#8	A#21	385.658203
Rg21	A#8	A#22	437.757690
Rg22	A#9	A#23	357.016968
Rg23	A#9	A#24	522.776123
Rg24	A#10	A#25	340.131378
Rf1	A	A#26	8.404075
Rf2	A#26	A	6.264856
Rf3	Y#1	Y#2	31.761475
Rf4	Y#2	Y#3	60.986694
Rf5	Y#3	Y#4	71.791039
Rf6	Y#4	Y#5	86.158134
Rf7	Y#2	Y#6	60.594036
Rf8	Y#6	Y#7	93.947296
Rf9	Y#3	Y#8	47.259083
Rf10	Y#3	Y#9	31.731333
Rf11	Y#9	Y#10	36.167645
Rf12	Y#4	Y#11	28.306047
Rf13	Y#6	Y#12	18.602406
Rf14	Y#9	Y#13	44.681767
Rf15	Y#9	Y	14.884869
Rf16	VPWR#1	VPWR#2	107.655571
Rf17	VPWR#2	VPWR#3	64.515579
Rf18	VPWR#3	VPWR#4	72.405029
Rf19	VPWR#4	VPWR#5	116.941498
Rf20	VPWR#2	VPWR#6	38.286041
Rf21	VPWR#3	VPWR#7	43.353802
Rf22	VPWR#4	VPWR#8	31.534731
Rf23	VGND#1	VGND#2	95.987572
Rf24	VGND#2	VGND#3	62.433640
Rf25	VGND#2	VGND#4	31.141060
Rf26	VGND#3	VGND#5	75.655785
Rf27	VGND#5	VGND#6	106.944885
Rf28	VGND#3	VGND#7	41.745289
Rf29	VGND#5	VGND#8	38.247387
Rf30	A#8	A#26	32.046562
Re1	VPWR#3	VPWR	1.091357
Re2	VGND	VGND#3	1.091398
*
*       CAPACITOR CARDS
*
*
C1	VPWR#2	A#4	1.98672e-20
C2	Y#6	A#10	7.8516e-19
C3	VPWR#2	A#3	1.77417e-20
C4	Y#9	A#5	2.16815e-19
C5	VPWR#2	A#2	2.29277e-20
C6	Y#6	A#7	2.80805e-18
C7	Y#9	A#4	1.0135e-18
C8	Y#4	A#10	1.44976e-18
C9	Y#9	A#3	2.76186e-17
C10	Y#6	A#5	4.73611e-19
C11	Y#9	A#2	2.99672e-17
C12	A#10	A#21	2.96748e-18
C13	Y#4	A#7	1.62495e-18
C14	Y#3	A#10	2.94215e-19
C15	Y#3	A#7	2.25195e-18
C16	Y#3	A#5	1.27094e-17
C17	Y#3	A#4	2.40909e-17
C18	Y#3	A#3	3.56339e-19
C19	Y#2	A#5	3.77447e-19
C20	A#3	A#1	1.85446e-19
C21	VGND#2	Y#9	1.86437e-19
C22	VGND#5	Y#4	2.91756e-19
C23	Y#9	VPWR#2	2.12064e-19
C24	Y#6	VPWR#4	1.6661e-19
C25	VGND#2	Y#3	1.86437e-19
C26	Y#3	VPWR#2	3.21052e-19
C27	VGND#4	A#4	1.05452e-18
C28	Y#3	Y#9	2.16673e-18
C29	VGND#2	VGND#1	9.55651e-19
C30	A#7	A#5	3.74089e-18
C31	VGND#4	A#3	1.62216e-18
C32	Y#2	Y#9	7.58895e-19
C33	VGND#2	Y#10	1.4265e-17
C34	Y#6	Y#2	5.1918e-19
C35	VGND#1	Y#9	1.13543e-17
C36	VGND#7	A#7	9.60911e-19
C37	VGND#2	Y#8	5.56788e-18
C38	Y#3	Y#2	4.1088e-18
C39	Y#9	Y#10	5.31531e-20
C40	VGND#5	Y#11	5.24871e-18
C41	VGND#7	A#5	1.6357e-19
C42	VGND#4	Y#9	1.88174e-17
C43	Y#3	Y#10	3.90306e-18
C44	A#22	A#7	2.31942e-19
C45	VGND#5	Y#5	1.2734e-17
C46	VGND#8	A#10	4.57034e-19
C47	Y#3	VGND#4	2.13711e-17
C48	Y#4	Y#8	9.24828e-19
C49	VGND#6	VGND#5	1.4097e-18
C50	Y#3	Y#8	9.59055e-20
C51	Y#4	VGND#7	1.42084e-17
C52	Y#10	VGND#1	5.55233e-17
C53	A#5	A#4	3.76918e-18
C54	Y#3	VGND#7	1.61655e-17
C55	Y#4	Y#11	1.41744e-18
C56	VGND#4	VGND#1	2.07044e-18
C57	Y#5	A#10	1.51012e-17
C58	Y#4	VGND#8	2.25094e-17
C59	VGND#4	Y#10	5.55233e-17
C60	VPWR#2	VPWR#1	9.5684e-19
C61	Y#5	Y#4	5.2354e-19
C62	Y#9	VPWR#1	1.47928e-17
C63	Y#13	VPWR#2	1.49889e-17
C64	Y#8	VGND#4	5.3407e-17
C65	Y#9	Y#13	6.90794e-20
C66	VGND#7	VGND#4	1.31479e-18
C67	Y#9	VPWR#6	2.74704e-17
C68	VGND#7	Y#8	4.526e-17
C69	Y#1	VPWR#2	5.22792e-18
C70	A#4	A#3	2.27623e-18
C71	Y#11	Y#8	1.8378e-18
C72	Y#12	VPWR#4	9.23085e-18
C73	Y#11	VGND#7	4.16102e-17
C74	Y#3	VPWR#6	1.40681e-17
C75	Y#6	VPWR#7	1.32159e-17
C76	Y#2	VPWR#6	2.82759e-17
C77	VGND#8	VGND#7	1.66094e-18
C78	VGND#8	Y#11	4.15829e-17
C79	Y#6	Y#12	1.36226e-18
C80	Y#2	Y#1	7.40327e-18
C81	Y#7	VPWR#4	1.40113e-17
C82	VPWR#3	A#7	1.55761e-20
C83	Y#5	Y#11	1.72657e-18
C84	Y#2	VPWR#7	1.20706e-17
C85	Y#6	VPWR#8	3.08916e-17
C86	VPWR#3	A#5	1.29651e-20
C87	VPWR#3	A#4	7.1146e-21
C88	VPWR#5	VPWR#4	9.86498e-19
C89	Y#5	VGND#8	4.91213e-17
C90	Y#12	Y#2	1.85422e-19
C91	Y#7	Y#6	4.97913e-19
C92	VGND#6	VGND#8	1.41696e-18
C93	VGND#2	A#13	2.73586e-18
C94	VGND#6	Y#5	7.14364e-17
C95	A#3	A#2	3.52237e-18
C96	Y#9	A#12	9.04656e-18
C97	VGND#3	A#7	1.31484e-20
C98	Y#2	Y#7	1.82253e-21
C99	VGND#2	A#15	2.73586e-18
C100	VGND#3	A#5	6.4646e-20
C101	VGND#3	A#4	1.70489e-20
C102	VGND#3	A#3	1.6811e-20
C103	Y#9	A#13	1.12806e-17
C104	VGND#3	A#2	1.46355e-20
C105	VGND#5	A#20	6.3656e-19
C106	A#3	Y#13	2.07781e-19
C107	Y#13	VPWR#1	9.30981e-17
C108	Y#3	A#13	6.57111e-19
C109	A#10	A#8	4.15738e-18
C110	A#8	A#7	4.0818e-18
C111	A#2	Y#13	2.68517e-19
C112	VGND#5	A#21	5.48621e-18
C113	VPWR#6	VPWR#1	1.69608e-18
C114	VGND#1	A#12	3.66837e-17
C115	Y#3	A#15	1.5489e-17
C116	A#12	Y#10	1.38616e-17
C117	VPWR#6	Y#13	9.12409e-17
C118	Y#4	A#17	1.43942e-19
C119	VGND#1	A#13	2.65541e-18
C120	VGND#5	A#23	5.35279e-18
C121	VGND#4	A#12	1.33422e-18
C122	VPWR#6	A#4	1.62956e-18
C123	Y#3	A#17	2.02865e-17
C124	Y#10	A#13	3.58425e-17
C125	Y#4	A#20	1.79384e-17
C126	VGND#1	A#15	3.31733e-19
C127	VPWR#6	A#3	3.50806e-18
C128	A#13	VGND#4	2.33681e-17
C129	Y#1	VPWR#6	5.56804e-17
C130	VGND#5	A#25	4.43694e-18
C131	Y#10	A#15	1.07569e-18
C132	Y#4	A#21	1.69614e-17
C133	VPWR#7	VPWR#6	2.66815e-18
C134	A#15	VGND#4	2.73537e-17
C135	VGND#7	A#13	1.09125e-19
C136	VPWR#7	Y#1	5.11378e-17
C137	Y#8	A#15	3.83918e-17
C138	A#5	Y#1	1.5184e-19
C139	Y#4	A#23	9.24914e-20
C140	VGND#4	A#17	7.57597e-19
C141	VGND#6	VPWR#5	9.71428e-18
C142	VGND#7	A#15	2.36947e-19
C143	Y#12	Y#1	1.76769e-18
C144	A#4	Y#1	3.24488e-19
C145	Y#8	A#17	3.33527e-17
C146	VGND#4	A#20	2.84905e-19
C147	Y#4	A#25	6.33843e-20
C148	Y#12	VPWR#7	5.29637e-17
C149	A#17	VGND#7	1.61713e-17
C150	A#7	VPWR#7	6.47602e-19
C151	Y#8	A#20	1.37912e-18
C152	Y#11	A#17	2.86039e-19
C153	VPWR#8	VPWR#7	2.15425e-18
C154	A	A#10	3.69665e-17
C155	VGND#7	A#20	3.23452e-17
C156	A	A#7	2.20386e-17
C157	Y#9	A#1	3.85688e-18
C158	A	A#5	1.26375e-17
C159	Y#8	A#21	2.31232e-19
C160	VPWR#8	Y#12	6.22435e-17
C161	A	A#4	4.33703e-19
C162	A#20	Y#11	1.38193e-17
C163	A#5	VPWR#7	6.075e-19
C164	VGND#7	A#21	1.21722e-18
C165	VPWR#2	A#14	4.15788e-18
C166	VGND#8	A#20	1.21722e-18
C167	Y#7	Y#12	1.89681e-18
C168	VPWR#5	VPWR#7	8.97529e-21
C169	A#21	Y#11	1.72195e-17
C170	Y#9	A#14	2.81446e-18
C171	Y#5	A#20	1.87602e-19
C172	Y#7	VPWR#8	5.50838e-17
C173	VGND#8	A#21	3.27157e-17
C174	VPWR#2	A#16	4.18856e-18
C175	Y#11	A#23	3.05025e-19
C176	Y#5	A#21	4.29282e-19
C177	VPWR#5	VPWR#8	1.7987e-18
C178	Y#9	A#16	2.87415e-19
C179	A#7	Y#12	4.3492e-19
C180	VGND#8	A#23	2.82226e-17
C181	Y#6	A#16	4.34608e-20
C182	Y#2	A#14	1.14703e-19
C183	VPWR#5	Y#7	7.82685e-17
C184	Y#11	A#25	2.09033e-19
C185	Y#5	A#23	2.00517e-17
C186	VGND#8	A#25	1.45533e-18
C187	Y#9	A#18	3.5608e-20
C188	VGND#6	A#23	1.21536e-18
C189	Y#6	A#18	1.11924e-19
C190	Y#2	A#16	6.01581e-18
C191	Y#5	A#25	3.69439e-17
C192	A#10	VPWR#8	5.39205e-19
C193	VGND#6	A#25	2.55349e-17
C194	Y#2	A#18	1.82145e-17
C195	Y#6	A#19	1.75361e-17
C196	VPWR#4	A#22	2.58799e-18
C197	A#13	A#12	4.04193e-17
C198	Y#2	A#19	6.38569e-19
C199	Y#6	A#22	1.76035e-17
C200	VPWR#4	A#24	1.84214e-18
C201	VPWR#1	A#1	3.27933e-17
C202	A#15	A#13	2.20885e-17
C203	VPWR	A#4	3.44589e-20
C204	Y#13	A#1	5.37665e-17
C205	Y#2	A#22	2.99981e-19
C206	Y#6	A#24	1.07078e-19
C207	VPWR#1	A#14	1.34947e-18
C208	VPWR#6	A#1	1.4381e-18
C209	VPWR#4	A#11	3.09628e-18
C210	A#10	Y#7	3.08438e-18
C211	Y#13	A#14	5.16178e-17
C212	A#17	A#15	3.95418e-17
C213	Y#2	A#24	1.27002e-19
C214	VPWR#1	A#16	2.81672e-19
C215	VPWR#6	A#14	2.35175e-17
C216	Y#6	A#11	6.37174e-20
C217	Y#13	A#16	1.46927e-18
C218	A#20	A#17	2.47825e-17
C219	VPWR#6	A#16	5.913e-17
C220	Y#2	A#11	1.17967e-19
C221	VGND#5	A#10	1.82292e-19
C222	A#16	Y#1	1.5858e-17
C223	VPWR#6	A#18	2.88735e-18
C224	VPWR#7	A#16	1.65292e-18
C225	VPWR#3	VPWR#4	4.80864e-17
C226	VGND	A#4	1.30859e-20
C227	A#21	A#20	4.09634e-17
C228	A#18	Y#1	2.51418e-17
C229	VPWR#3	VPWR#2	4.45969e-17
C230	Y#12	A#16	1.63495e-19
C231	VPWR#7	A#18	4.91311e-17
C232	Y#6	VPWR#3	3.13618e-19
C233	VGND#3	VGND#5	4.49333e-17
C234	Y#12	A#18	1.67533e-18
C235	VGND#3	VGND#2	4.27148e-17
C236	Y#1	A#19	2.59603e-19
C237	A#23	A#21	3.68532e-17
C238	A#19	VPWR#7	2.21029e-17
C239	VPWR#8	A#18	2.84892e-19
C240	Y#2	VPWR#3	3.13618e-19
C241	Y#12	A#19	5.23858e-17
C242	VGND#5	A#8	3.56411e-20
C243	VPWR#8	A#19	7.692e-19
C244	VGND#3	Y#4	2.91756e-19
C245	VPWR#7	A#22	3.70183e-19
C246	VPWR#5	A#18	2.36864e-19
C247	A#25	A#23	3.71641e-17
C248	VGND#3	Y#3	2.25448e-19
C249	VPWR#4	A#8	8.18847e-21
C250	Y#12	A#22	4.56401e-17
C251	A#22	VPWR#8	2.66217e-17
C252	VPWR#5	A#19	3.50139e-19
C253	VPWR#7	A#24	1.71283e-19
C254	VGND#3	VGND#1	3.22095e-17
C255	Y#6	A#8	2.05998e-18
C256	A#10	VNB	8.38379e-17
C257	Y#7	A#22	3.93128e-19
C258	Y#12	A#24	1.41004e-18
C259	A#7	VNB	3.17018e-17
C260	Y#4	A#8	3.38033e-18
C261	A#5	VNB	2.56322e-17
C262	A#4	VNB	2.825e-17
C263	Y#3	A#8	1.73574e-19
C264	VGND#3	VGND#4	6.49329e-19
C265	VPWR#5	A#22	2.57188e-19
C266	VPWR#8	A#24	4.99268e-17
C267	A#3	VNB	3.07037e-17
C268	A#2	VNB	3.51687e-17
C269	VGND#3	Y#8	1.14018e-17
C270	Y#7	A#24	3.23671e-17
C271	Y#12	A#11	2.42733e-19
C272	VGND#3	Y#11	5.19931e-18
C273	VPWR#5	A#24	1.5884e-18
C274	VPWR#3	VPWR#1	2.99995e-17
C275	VPWR#8	A#11	2.90342e-18
C276	Y#7	A#11	5.19407e-17
C277	VPWR#3	VPWR#6	6.61283e-20
C278	VGND#3	VGND#6	2.43801e-17
C279	VPWR#5	A#11	3.0995e-17
C280	A	VPWR#4	2.74763e-19
C281	Y#1	VPWR#3	5.27759e-18
C282	A#14	A#1	4.60437e-17
C283	VGND#8	A#8	3.07897e-19
C284	A	Y#6	9.64687e-17
C285	Y#12	VPWR#3	7.69774e-18
C286	Y#4	A	7.93077e-17
C287	VPWR#8	VPWR#3	2.24131e-19
C288	Y#3	A	5.43294e-17
C289	A	Y#2	8.71695e-18
C290	A#16	A#14	3.70993e-17
C291	VPWR#3	VPWR#5	2.44223e-17
C292	VPWR#4	A#10	4.13675e-20
C293	A#18	A#16	4.70364e-17
C294	A#8	Y#12	1.09644e-19
C295	A#8	VPWR#8	1.08428e-18
C296	VGND#1	Y	3.17992e-17
C297	Y#5	A	4.30973e-17
C298	VGND#3	A#13	1.78955e-19
C299	VPWR	VPWR#4	2.74595e-17
C300	A#19	A#18	4.79261e-17
C301	VPWR	VPWR#2	2.68058e-17
C302	VGND#3	A#15	5.2065e-19
C303	VPWR	Y#9	2.40047e-18
C304	VPWR	Y#6	3.11655e-18
C305	VGND#3	A#17	5.60583e-18
C306	VPWR	Y#3	2.25278e-18
C307	VGND#3	A#20	5.36554e-18
C308	VPWR	Y#2	1.39203e-18
C309	VGND#3	A#21	6.3656e-19
C310	A#22	A#19	4.67508e-17
C311	VGND	VGND#5	4.53247e-17
C312	Y	VPWR#1	2.81294e-17
C313	VGND	VGND#2	2.25553e-17
C314	A	Y#7	3.9322e-17
C315	VPWR#4	A#7	1.55761e-20
C316	VGND	Y#9	4.21995e-18
C317	A#24	A#22	3.7388e-17
C318	VGND	Y#4	3.34243e-18
C319	VGND#2	A#4	9.52127e-21
C320	VGND	Y#3	2.96099e-18
C321	VPWR#3	A#16	3.95329e-19
C322	VPWR	VPWR#1	4.02714e-17
C323	VGND	VGND#1	4.32431e-17
C324	VPWR#3	A#18	4.89479e-18
C325	VPWR	Y#13	1.73874e-17
C326	VGND	Y#10	1.75565e-17
C327	A#11	A#24	4.67195e-17
C328	VGND	VGND#4	2.29529e-17
C329	VPWR	VPWR#6	2.0451e-17
C330	VGND	Y#8	1.66924e-17
C331	VPWR#3	A#19	5.22773e-18
C332	VPWR	Y#1	1.4175e-17
C333	VGND#5	VNB	3.29873e-17
C334	VGND#2	VNB	3.2274e-17
C335	VGND	Y#11	1.09176e-17
C336	VPWR#4	VNB	3.58016e-17
C337	VPWR	Y#12	1.5835e-17
C338	VPWR#3	A#22	2.99535e-19
C339	VPWR#2	VNB	3.2779e-17
C340	VGND	Y#5	1.41394e-17
C341	VPWR	VPWR#8	2.11119e-17
C342	Y#9	VNB	1.32353e-18
C343	VGND	VGND#6	3.0559e-17
C344	VPWR	Y#7	1.42771e-17
C345	VPWR#3	A#24	8.34499e-20
C346	Y#4	VNB	1.172e-18
C347	VGND	VPWR#1	3.3598e-18
C348	Y#3	VNB	3.68547e-18
C349	VPWR	VPWR#5	3.22914e-17
C350	Y#2	VNB	1.13073e-18
C351	VGND#2	A#3	3.85385e-20
C352	VGND	VPWR#6	3.04489e-18
C353	VGND#1	VNB	6.31798e-17
C354	Y#10	VNB	2.73959e-18
C355	VGND#4	VNB	4.47979e-18
C356	Y#8	VNB	2.10494e-18
C357	VGND#7	VNB	3.39417e-19
C358	Y#11	VNB	4.55126e-18
C359	VGND#8	VNB	3.01253e-20
C360	Y#5	VNB	6.011e-18
C361	VGND	VPWR#5	3.12218e-18
C362	VGND#6	VNB	6.75692e-17
C363	VGND	A#12	2.22223e-19
C364	VPWR#1	VNB	8.43777e-17
C365	VGND	A#13	1.05162e-19
C366	Y#13	VNB	2.34549e-18
C367	VPWR#6	VNB	1.09433e-18
C368	VGND	A#15	2.80511e-19
C369	Y#1	VNB	4.7969e-18
C370	A	A#22	2.06618e-18
C371	VGND	A#17	1.91078e-19
C372	VPWR#7	VNB	4.09278e-19
C373	VGND	A#20	6.99989e-19
C374	VPWR	A#1	4.83186e-18
C375	Y#12	VNB	2.1429e-18
C376	A	A#24	2.11121e-18
C377	VPWR#8	VNB	7.6585e-19
C378	VGND	A#21	6.99989e-19
C379	VPWR	A#14	3.16706e-18
C380	Y#7	VNB	2.29714e-18
C381	VGND	A#23	6.49129e-19
C382	A	A#11	4.81432e-18
C383	VPWR#5	VNB	8.03052e-17
C384	VPWR	A#16	2.34434e-18
C385	VGND#3	A#8	2.18302e-20
C386	VGND#2	A#2	3.35512e-20
C387	VGND	A#25	4.85358e-18
C388	A#12	VNB	3.12247e-17
C389	VPWR	A#18	1.13552e-18
C390	A#13	VNB	2.8839e-17
C391	A#15	VNB	2.92455e-17
C392	VPWR	A#19	8.70233e-19
C393	A#17	VNB	2.67353e-17
C394	A#20	VNB	2.59402e-17
C395	VPWR	A#22	2.24528e-19
C396	A#21	VNB	2.56588e-17
C397	VPWR	A#24	1.00571e-18
C398	A#23	VNB	2.22399e-17
C399	A#25	VNB	2.96502e-17
C400	VPWR	A#11	5.13261e-18
C401	A	A#8	1.88389e-17
C402	A#1	VNB	3.72601e-17
C403	A#14	VNB	3.14226e-17
C404	VPWR	VPWR#3	3.72937e-17
C405	A#16	VNB	2.99798e-17
C406	A#18	VNB	2.73711e-17
C407	A#19	VNB	3.04035e-17
C408	A#22	VNB	3.04062e-17
C409	A#24	VNB	2.8537e-17
C410	VGND	VGND#3	4.39127e-17
C411	A#11	VNB	3.9162e-17
C412	VPWR	A	1.01173e-17
C413	VPWR#3	VNB	2.11629e-16
C414	VGND#3	VNB	2.16141e-16
C415	VPWR	Y	2.02697e-18
C416	VGND	A	9.18381e-18
C417	A#8	VNB	2.82322e-17
C418	VGND	Y	3.24547e-18
C419	A	VNB	3.38268e-17
C420	Y	VNB	3.7104e-17
C421	VPWR	VNB	5.90407e-17
C422	VGND	VNB	5.80039e-17
*
*
.ENDS sky130_fd_sc_hs__inv_8
*
