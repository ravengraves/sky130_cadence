* Extracted by Quantus, converted by sky130cad/quantus.py
*
*
*
*                       LINUX           Wed Nov 18 09:04:54 2026
*
*
*
*  PROGRAM  advgen
*
*  Name           : advgen - Quantus - (64-bit)
*  Version        : 25.1.0-p047
*  Build Date     : Thu Dec 11 23:20:30 PST 2025
*
*  HSPICE LIBRARY
*
*  OPERATING_TEMPERATURE 150
*  QRC_TECH_DIR <path>/tech
*
*
*

*
.SUBCKT sky130_fd_sc_hs__or2_1 VNB VPB VGND VPWR X B A
*
*
*  caps2d version: 10
*
*
*       TRANSISTOR CARDS
*
*
XM1 VGND#7 B#1 a_63_368##4 VNB sky130_fd_pr__nfet_01v8_lvt l=0.15 w=0.55 ad=0.2695 as=0.26125 pd=2.08 ps=2.05
XM3 a_63_368##4 A#1 VGND#6 VNB sky130_fd_pr__nfet_01v8_lvt l=0.15 w=0.55 ad=0.26125 as=0.30395 pd=2.05 ps=2.34
XM5 VGND#6 a_63_368# X#3 VNB sky130_fd_pr__nfet_01v8_lvt l=0.15 w=0.74 ad=0.30395 as=0.2109 pd=2.34 ps=2.05
XM0 a_63_368##6 B#4 a_152_368# VPB sky130_fd_pr__pfet_01v8 l=0.15 w=0.84 ad=0.2478 as=0.2268 pd=2.27 ps=2.22
XM2 a_152_368# A#3 VPWR#3 VPB sky130_fd_pr__pfet_01v8 l=0.15 w=0.84 ad=0.2268 as=0.6692 pd=2.22 ps=3.52
XM4 VPWR#3 a_63_368##3 X#1 VPB sky130_fd_pr__pfet_01v8 l=0.15 w=1.12 ad=0.6692 as=0.3304 pd=3.52 ps=2.83
*
*
*       RESISTOR AND CAP/DIODE CARDS
*
Rg1	B#1	B#2	268.436768
Rg2	B#2	B#3	30.596949
Rg3	B#2	B#4	426.734863
Rg4	A#1	A#2	339.308746
Rg5	A#2	A#3	357.398132
Rg6	a_63_368#	a_63_368##2	352.160645
Rg7	a_63_368##2	a_63_368##3	455.160828
Rf1	B	B#5	0.894789
Rf2	B#6	B#3	81.011192
Rf3	B#5	B#6	7.059660
Rf4	A	A#2	166.137894
Rf5	a_63_368##4	a_63_368##5	81.334656
Rf6	a_63_368##5	a_63_368##6	131.279755
Rf7	X	X#2	0.183608
Rf8	X#2	X	13.403392
Rf9	X	X#3	86.870316
Rf10	X#1	X#2	5.000000
Rf12	VPWR#2	VPWR#3	23.814323
Rf14	VGND#2	VGND#3	30.656675
Rf15	VGND#3	VGND#4	53.106220
Rf17	VGND#2	VGND#6	38.247387
Rf18	VGND#4	VGND#7	42.376846
Rf21	a_63_368##2	a_63_368##5	160.232803
Re1	VPWR#2	VPWR	1.964508
Re2	VGND	VGND#3	1.964582
*
*       CAPACITOR CARDS
*
*
C1	VGND	VNB	6.2828e-17
C2	VPWR	VNB	5.67127e-17
C3	X	VNB	6.87134e-17
C4	A	VNB	4.52646e-18
C5	B#3	VNB	7.46904e-17
C6	A#2	VNB	3.58089e-17
C7	a_63_368##2	VNB	4.39219e-17
C8	VGND#3	VNB	1.37661e-16
C9	VGND	X	1.42469e-18
C10	B#4	VNB	4.21618e-17
C11	A#3	VNB	2.57673e-17
C12	a_63_368##3	VNB	3.89301e-17
C13	VPWR	X	1.98452e-17
C14	B#1	VNB	3.30497e-17
C15	VGND	A	2.52374e-18
C16	A#1	VNB	3.12477e-17
C17	a_63_368#	VNB	3.32628e-17
C18	a_63_368##6	VNB	4.47937e-17
C19	VPWR#3	VNB	7.79679e-19
C20	VGND#7	VNB	2.23074e-17
C21	VPWR	A	2.40088e-18
C22	a_63_368##4	VNB	1.19225e-17
C23	VGND#6	VNB	5.0258e-18
C24	X#3	VNB	5.22799e-17
C25	B#5	VNB	2.72239e-17
C26	B#6	VNB	3.97943e-18
C27	VGND	B#3	4.35781e-19
C28	VGND	a_63_368##2	4.76548e-18
C29	VGND	VGND#3	1.19284e-17
C30	VPWR	B#3	3.13985e-18
C31	VPWR	a_63_368##2	5.45078e-18
C32	X	A#2	1.30155e-20
C33	VGND	B#1	3.65975e-18
C34	a_63_368##2	X	5.4802e-17
C35	VGND	A#1	7.08597e-18
C36	VPWR	B#4	8.11898e-18
C37	VGND	a_63_368#	1.82039e-18
C38	VPWR	A#3	3.44758e-18
C39	VGND	a_63_368##6	2.88967e-18
C40	VPWR	a_63_368##3	3.62664e-18
C41	A	B#3	4.45716e-18
C42	A	A#2	1.70993e-17
C43	X	B#4	5.72203e-19
C44	VGND	a_63_368##4	1.34052e-17
C45	X	A#3	3.07117e-18
C46	A	a_63_368##2	4.43208e-17
C47	VGND	X#3	1.91921e-17
C48	X	a_63_368##3	3.46651e-17
C49	VGND	B#5	4.21983e-18
C50	VPWR	a_63_368##6	1.9287e-17
C51	VGND	B#6	3.65739e-18
C52	A	B#4	2.00971e-18
C53	a_63_368##6	X	1.7009e-18
C54	A	A#3	3.8279e-18
C55	VPWR	B#5	4.17733e-18
C56	VPWR#3	X	5.6916e-17
C57	B#3	A#2	2.54443e-17
C58	VPWR	B#6	2.26976e-18
C59	A	a_63_368##3	1.02248e-18
C60	X	X#1	5.78548e-18
C61	a_63_368##2	B#3	2.70732e-19
C62	B#4	a_152_368#	2.04841e-17
C63	VGND#3	B#3	1.86111e-22
C64	X#3	X	3.90241e-18
C65	A#2	a_63_368##2	3.57033e-17
C66	A#3	a_152_368#	1.98132e-17
C67	A	a_63_368##6	2.52737e-17
C68	VGND#3	A#2	1.20224e-19
C69	a_63_368##4	A	3.20503e-17
C70	B#4	A#2	3.13591e-18
C71	a_63_368##6	a_152_368#	9.93878e-18
C72	a_63_368##2	B#4	1.98509e-19
C73	A#2	a_63_368##3	1.34523e-19
C74	B#6	A	1.47812e-17
C75	a_63_368##2	A#3	1.07444e-18
C76	B#3	A#1	1.86438e-18
C77	a_63_368##2	a_63_368##3	7.45051e-18
C78	a_63_368##6	B#3	5.29612e-18
C79	A#1	a_63_368##2	9.57165e-19
C80	a_63_368##6	A#2	5.95559e-19
C81	VGND#3	B#1	3.30586e-20
C82	a_63_368##2	a_63_368#	4.38527e-18
C83	B#4	A#3	4.68211e-17
C84	B#3	VGND#7	9.49293e-18
C85	VGND#3	A#1	1.18034e-18
C86	A#2	VPWR#3	1.84102e-18
C87	a_63_368##6	a_63_368##2	2.44337e-18
C88	a_63_368##4	B#3	2.55718e-18
C89	a_63_368##2	VPWR#3	5.38848e-17
C90	A#3	a_63_368##3	1.13285e-17
C91	a_63_368##4	A#2	3.84828e-18
C92	B#5	B#3	1.51122e-17
C93	B#6	B#3	2.41425e-17
C94	a_63_368##4	a_63_368##2	1.25003e-18
C95	a_63_368##2	VGND#6	2.96461e-17
C96	B#6	A#2	6.06225e-18
C97	a_63_368##2	X#3	4.63567e-17
C98	VGND#3	a_63_368##4	9.44111e-18
C99	a_63_368##6	B#4	5.69192e-17
C100	B#6	a_63_368##2	4.9436e-18
C101	a_63_368##6	A#3	2.98822e-17
C102	VPWR#3	B#4	7.11703e-18
C103	a_63_368##6	a_63_368##3	9.40539e-19
C104	B#1	A#1	1.40392e-17
C105	VPWR#3	A#3	5.00616e-17
C106	a_63_368##3	VPWR#3	2.22952e-17
C107	A#1	a_63_368#	1.93633e-17
C108	a_63_368##3	X#1	1.20142e-17
C109	VGND#7	B#1	3.43592e-17
C110	B#1	a_63_368##4	2.10098e-17
C111	VGND#7	A#1	2.36382e-18
C112	a_63_368##6	VPWR#3	2.86339e-17
C113	VGND#6	B#1	1.42905e-18
C114	a_63_368##4	A#1	3.1306e-17
C115	VGND#7	a_63_368#	6.60248e-19
C116	X#3	B#1	3.36055e-19
C117	A#1	VGND#6	2.136e-17
C118	a_63_368##4	a_63_368#	1.30652e-18
C119	X#3	A#1	2.37012e-18
C120	a_63_368#	VGND#6	2.12502e-17
C121	a_63_368##4	a_63_368##6	4.91282e-18
C122	X#3	a_63_368#	3.47051e-17
C123	B#5	a_63_368##6	8.09743e-18
C124	B#6	a_63_368##6	2.6445e-17
C125	VGND#7	a_63_368##4	2.63946e-17
C126	VGND#7	VGND#6	2.77201e-18
C127	a_63_368##4	VGND#6	2.55713e-17
C128	B#5	VGND#7	1.20732e-17
C129	a_63_368##4	X#3	2.41072e-18
C130	VGND#7	B#6	2.89073e-17
C131	VGND#6	X#3	5.08626e-17
C132	VGND#4	VGND#6	2.43171e-18
C133	VGND#3	VGND#2	4.51846e-17
C134	VGND#2	a_63_368##4	1.10552e-19
C135	a_63_368##2	VPWR#2	2.51872e-19
C136	VGND#2	A#1	3.04605e-19
C137	VPWR	VPWR#2	1.11767e-16
C138	VPWR#2	B#3	1.39938e-18
C139	VPWR#2	A#3	2.26315e-18
C140	VGND#2	a_63_368#	9.51663e-18
C141	B#5	VPWR#2	8.09609e-19
C142	VGND#2	VNB	4.43556e-17
C143	VGND#2	X#3	2.20849e-17
C144	VGND#4	VNB	4.85081e-17
C145	VGND#4	B#5	1.69614e-18
C146	VGND#3	VGND#4	3.92722e-17
C147	VGND#4	B#6	7.61217e-19
C148	VGND	VGND#2	5.31867e-17
C149	VGND#4	B#1	2.5697e-18
C150	VPWR#2	X	3.51713e-17
C151	VPWR#2	a_63_368##3	1.59067e-17
C152	VGND	VGND#4	5.19907e-17
C153	VPWR#2	VPWR#3	2.45368e-18
C154	VPWR#2	B#4	3.39651e-18
C155	VGND#4	VGND#2	1.05487e-18
C156	a_63_368##6	VPWR#2	1.13577e-17
C157	VPWR#2	VNB	2.32609e-16
C158	VGND#4	a_63_368#	1.14449e-18
C159	VGND#2	a_63_368##2	4.41816e-19
C160	VGND#4	B#3	6.88081e-19
*
*
.ENDS sky130_fd_sc_hs__or2_1
*
