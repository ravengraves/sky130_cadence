* SkyWater sky130 digital transistor subset (nfet_01v8, nfet_01v8_lvt, pfet_01v8, pfet_01v8_hvt) for Spectre.
* Generated by sky130cad/spectre_models.py from sky130_fd_pr models, .lib ff.
* Includes are relative to this file (Spectre resolves them from here).
simulator lang=spice
.option scale=1.0u
.include "fd_pr/lod.spice"
.param
+ lv_dlc_rotweak = .00e-9
+ lvhvt_dlc_rotweak = .00e-9
+ lvt_dlc_rotweak = .00e-9
+ hv_dlc_rotweak = .00e-9
+ sky130_fd_pr__nfet_01v8__dlc_rotweak = lv_dlc_rotweak
+ sky130_fd_pr__nfet_01v8_lvt__dlc_rotweak = lvt_dlc_rotweak
+ sky130_fd_pr__pfet_01v8__dlc_rotweak = lv_dlc_rotweak
+ sky130_fd_pr__pfet_01v8_hvt__dlc_rotweak = lvhvt_dlc_rotweak
+ sonos_eeol_dlc_rotweak = hv_dlc_rotweak
+ sonos_peol_dlc_rotweak = hv_dlc_rotweak
.include "fd_pr/sky130_fd_pr__nfet_01v8__ff.corner.spice"
.include "fd_pr/sky130_fd_pr__nfet_01v8_lvt__ff.corner.spice"
.include "fd_pr/sky130_fd_pr__pfet_01v8__ff.corner.spice"
.include "fd_pr/sky130_fd_pr__pfet_01v8_hvt__ff.corner.spice"
.include "fd_pr/sky130_fd_pr__nfet_01v8__mismatch.corner.spice"
.include "fd_pr/sky130_fd_pr__pfet_01v8__mismatch.corner.spice"
.include "fd_pr/sky130_fd_pr__nfet_01v8_lvt__mismatch.corner.spice"
.include "fd_pr/sky130_fd_pr__pfet_01v8_hvt__mismatch.corner.spice"
