.subckt nfet_01v8_lvt_w0p65_l0p15_nf1 D G S B
X0 D G S B sky130_fd_pr__nfet_01v8_lvt w=0.65 l=0.15
.ends
