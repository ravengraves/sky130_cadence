.SUBCKT nfet_01v8_lvt_w0p65_l0p15_nf1 D G S B
M0 D G S B nfet_01v8_lvt w=0.65 l=0.15
.ENDS
