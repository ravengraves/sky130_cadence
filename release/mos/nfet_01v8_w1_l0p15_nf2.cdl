.SUBCKT nfet_01v8_w1_l0p15_nf2 D G S B
M0 D G S B nfet_01v8 w=1 l=0.15
M1 D G S B nfet_01v8 w=1 l=0.15
.ENDS
