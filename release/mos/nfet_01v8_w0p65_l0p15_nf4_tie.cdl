.SUBCKT nfet_01v8_w0p65_l0p15_nf4_tie D G S
M0 D G S S nfet_01v8 w=0.65 l=0.15
M1 D G S S nfet_01v8 w=0.65 l=0.15
M2 D G S S nfet_01v8 w=0.65 l=0.15
M3 D G S S nfet_01v8 w=0.65 l=0.15
.ENDS
