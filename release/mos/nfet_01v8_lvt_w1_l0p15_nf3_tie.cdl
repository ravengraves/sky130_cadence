.SUBCKT nfet_01v8_lvt_w1_l0p15_nf3_tie D G S
M0 D G S S nfet_01v8_lvt w=1 l=0.15
M1 D G S S nfet_01v8_lvt w=1 l=0.15
M2 D G S S nfet_01v8_lvt w=1 l=0.15
.ENDS
