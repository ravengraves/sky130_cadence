.subckt pfet_01v8_w0p55_l0p15_nf1 D G S B
X0 D G S B sky130_fd_pr__pfet_01v8 w=0.55 l=0.15
.ends
