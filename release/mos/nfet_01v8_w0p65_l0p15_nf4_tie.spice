.subckt nfet_01v8_w0p65_l0p15_nf4_tie D G S
X0 D G S S sky130_fd_pr__nfet_01v8 w=0.65 l=0.15
X1 D G S S sky130_fd_pr__nfet_01v8 w=0.65 l=0.15
X2 D G S S sky130_fd_pr__nfet_01v8 w=0.65 l=0.15
X3 D G S S sky130_fd_pr__nfet_01v8 w=0.65 l=0.15
.ends
