.SUBCKT pfet_01v8_w1_l0p15_nf2_tie D G S
M0 D G S S pfet_01v8 w=1 l=0.15
M1 D G S S pfet_01v8 w=1 l=0.15
.ENDS
