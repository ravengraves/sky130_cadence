.SUBCKT pfet_01v8_hvt_w0p42_l0p15_nf1 D G S B
M0 D G S B pfet_01v8_hvt w=0.42 l=0.15
.ENDS
